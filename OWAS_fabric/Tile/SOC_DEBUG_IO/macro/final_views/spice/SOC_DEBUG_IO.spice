* NGSPICE file created from SOC_DEBUG_IO.ext - technology: ihp-sg13cmos5l

* Black-box entry subcircuit for sg13cmos5l_decap_8 abstract view
.subckt sg13cmos5l_decap_8 VDD VSS
.ends

* Black-box entry subcircuit for sg13cmos5l_fill_2 abstract view
.subckt sg13cmos5l_fill_2 VDD VSS
.ends

* Black-box entry subcircuit for sg13cmos5l_antennanp abstract view
.subckt sg13cmos5l_antennanp A VDD VSS
.ends

* Black-box entry subcircuit for sg13cmos5l_mux4_1 abstract view
.subckt sg13cmos5l_mux4_1 X A0 A1 A2 A3 S0 S1 VDD VSS
.ends

* Black-box entry subcircuit for sg13cmos5l_fill_1 abstract view
.subckt sg13cmos5l_fill_1 VDD VSS
.ends

* Black-box entry subcircuit for sg13cmos5l_buf_1 abstract view
.subckt sg13cmos5l_buf_1 X A VDD VSS
.ends

* Black-box entry subcircuit for latch abstract view
.subckt latch Q D VSS VDD GATE
.ends

* Black-box entry subcircuit for sg13cmos5l_decap_4 abstract view
.subckt sg13cmos5l_decap_4 VDD VSS
.ends

* Black-box entry subcircuit for sg13cmos5l_buf_8 abstract view
.subckt sg13cmos5l_buf_8 X A VDD VSS
.ends

* Black-box entry subcircuit for sg13cmos5l_inv_1 abstract view
.subckt sg13cmos5l_inv_1 Y A VDD VSS
.ends

* Black-box entry subcircuit for sg13cmos5l_tiehi abstract view
.subckt sg13cmos5l_tiehi L_HI VDD VSS
.ends

* Black-box entry subcircuit for sg13cmos5l_mux2_1 abstract view
.subckt sg13cmos5l_mux2_1 X A0 A1 S VDD VSS
.ends

* Black-box entry subcircuit for sg13cmos5l_xor2_1 abstract view
.subckt sg13cmos5l_xor2_1 X A B VDD VSS
.ends

* Black-box entry subcircuit for sg13cmos5l_dfrbpq_1 abstract view
.subckt sg13cmos5l_dfrbpq_1 Q CLK D RESET_B VDD VSS
.ends

* Black-box entry subcircuit for sg13cmos5l_tielo abstract view
.subckt sg13cmos5l_tielo L_LO VDD VSS
.ends

.subckt SOC_DEBUG_IO Co DEBUG_IN0 DEBUG_IN1 DEBUG_IN2 DEBUG_IN3 DEBUG_IN4 DEBUG_IN5
+ DEBUG_IN6 DEBUG_IN7 DEBUG_OUT0 DEBUG_OUT1 DEBUG_OUT2 DEBUG_OUT3 DEBUG_OUT4 DEBUG_OUT5
+ DEBUG_OUT6 DEBUG_OUT7 FrameData[0] FrameData[10] FrameData[11] FrameData[12] FrameData[13]
+ FrameData[14] FrameData[15] FrameData[16] FrameData[17] FrameData[18] FrameData[19]
+ FrameData[1] FrameData[20] FrameData[21] FrameData[22] FrameData[23] FrameData[24]
+ FrameData[25] FrameData[26] FrameData[27] FrameData[28] FrameData[29] FrameData[2]
+ FrameData[30] FrameData[31] FrameData[3] FrameData[4] FrameData[5] FrameData[6]
+ FrameData[7] FrameData[8] FrameData[9] FrameData_O[0] FrameData_O[10] FrameData_O[11]
+ FrameData_O[12] FrameData_O[13] FrameData_O[14] FrameData_O[15] FrameData_O[16]
+ FrameData_O[17] FrameData_O[18] FrameData_O[19] FrameData_O[1] FrameData_O[20] FrameData_O[21]
+ FrameData_O[22] FrameData_O[23] FrameData_O[24] FrameData_O[25] FrameData_O[26]
+ FrameData_O[27] FrameData_O[28] FrameData_O[29] FrameData_O[2] FrameData_O[30] FrameData_O[31]
+ FrameData_O[3] FrameData_O[4] FrameData_O[5] FrameData_O[6] FrameData_O[7] FrameData_O[8]
+ FrameData_O[9] FrameStrobe[0] FrameStrobe[10] FrameStrobe[11] FrameStrobe[12] FrameStrobe[13]
+ FrameStrobe[14] FrameStrobe[15] FrameStrobe[16] FrameStrobe[17] FrameStrobe[18]
+ FrameStrobe[19] FrameStrobe[1] FrameStrobe[2] FrameStrobe[3] FrameStrobe[4] FrameStrobe[5]
+ FrameStrobe[6] FrameStrobe[7] FrameStrobe[8] FrameStrobe[9] FrameStrobe_O[0] FrameStrobe_O[10]
+ FrameStrobe_O[11] FrameStrobe_O[12] FrameStrobe_O[13] FrameStrobe_O[14] FrameStrobe_O[15]
+ FrameStrobe_O[16] FrameStrobe_O[17] FrameStrobe_O[18] FrameStrobe_O[19] FrameStrobe_O[1]
+ FrameStrobe_O[2] FrameStrobe_O[3] FrameStrobe_O[4] FrameStrobe_O[5] FrameStrobe_O[6]
+ FrameStrobe_O[7] FrameStrobe_O[8] FrameStrobe_O[9] N1BEG[0] N1BEG[1] N1BEG[2] N1BEG[3]
+ N2BEG[0] N2BEG[1] N2BEG[2] N2BEG[3] N2BEG[4] N2BEG[5] N2BEG[6] N2BEG[7] N2BEGb[0]
+ N2BEGb[1] N2BEGb[2] N2BEGb[3] N2BEGb[4] N2BEGb[5] N2BEGb[6] N2BEGb[7] N4BEG[0] N4BEG[10]
+ N4BEG[11] N4BEG[12] N4BEG[13] N4BEG[14] N4BEG[15] N4BEG[1] N4BEG[2] N4BEG[3] N4BEG[4]
+ N4BEG[5] N4BEG[6] N4BEG[7] N4BEG[8] N4BEG[9] NN4BEG[0] NN4BEG[10] NN4BEG[11] NN4BEG[12]
+ NN4BEG[13] NN4BEG[14] NN4BEG[15] NN4BEG[1] NN4BEG[2] NN4BEG[3] NN4BEG[4] NN4BEG[5]
+ NN4BEG[6] NN4BEG[7] NN4BEG[8] NN4BEG[9] S1END[0] S1END[1] S1END[2] S1END[3] S2END[0]
+ S2END[1] S2END[2] S2END[3] S2END[4] S2END[5] S2END[6] S2END[7] S2MID[0] S2MID[1]
+ S2MID[2] S2MID[3] S2MID[4] S2MID[5] S2MID[6] S2MID[7] S4END[0] S4END[10] S4END[11]
+ S4END[12] S4END[13] S4END[14] S4END[15] S4END[1] S4END[2] S4END[3] S4END[4] S4END[5]
+ S4END[6] S4END[7] S4END[8] S4END[9] SLOT_SOFT_RST_N SS4END[0] SS4END[10] SS4END[11]
+ SS4END[12] SS4END[13] SS4END[14] SS4END[15] SS4END[1] SS4END[2] SS4END[3] SS4END[4]
+ SS4END[5] SS4END[6] SS4END[7] SS4END[8] SS4END[9] USR_IRQ UserCLK UserCLKo VGND
+ VPWR
XFILLER_7_7 VPWR VGND sg13cmos5l_decap_8
XFILLER_2_516 VPWR VGND sg13cmos5l_decap_8
XFILLER_2_549 VPWR VGND sg13cmos5l_fill_2
XANTENNA__218__X NN4BEG[13] VPWR VGND sg13cmos5l_antennanp
X_294_ _294_/X S2END[4] S4END[12] SS4END[3] _153_/Q _114_/Q _115_/Q VPWR VGND sg13cmos5l_mux4_1
XFILLER_3_56 VPWR VGND sg13cmos5l_decap_8
XFILLER_12_43 VPWR VGND sg13cmos5l_decap_8
XFILLER_2_357 VPWR VGND sg13cmos5l_fill_1
XFILLER_14_486 VPWR VGND sg13cmos5l_decap_8
X_277_ N1BEG[3] _335_/X VPWR VGND sg13cmos5l_buf_1
X_200_ N4BEG[11] _311_/X VPWR VGND sg13cmos5l_buf_1
X_062_ _062_/Q FrameData[18] VGND VPWR FrameStrobe[2] latch
X_131_ _131_/Q FrameData[23] VGND VPWR FrameStrobe[0] latch
XFILLER_7_449 VPWR VGND sg13cmos5l_fill_1
XFILLER_11_467 VPWR VGND sg13cmos5l_decap_8
XFILLER_11_434 VPWR VGND sg13cmos5l_decap_8
XFILLER_2_154 VPWR VGND sg13cmos5l_decap_8
XANTENNA__231__X FrameData_O[9] VPWR VGND sg13cmos5l_antennanp
XFILLER_0_35 VPWR VGND sg13cmos5l_decap_8
X_329_ _329_/X S1END[1] S2MID[1] S2END[6] _151_/Q _044_/Q _045_/Q VPWR VGND sg13cmos5l_mux4_1
XFILLER_6_460 VPWR VGND sg13cmos5l_fill_2
XANTENNA__176__L_LO Co VPWR VGND sg13cmos5l_antennanp
XFILLER_16_537 VPWR VGND sg13cmos5l_decap_8
XFILLER_11_242 VPWR VGND sg13cmos5l_decap_8
XANTENNA__226__X FrameData_O[4] VPWR VGND sg13cmos5l_antennanp
X_045_ _045_/Q FrameData[1] VGND VPWR FrameStrobe[2] latch
X_114_ _114_/Q FrameData[6] VGND VPWR FrameStrobe[0] latch
XFILLER_7_257 VPWR VGND sg13cmos5l_fill_2
XFILLER_3_430 VPWR VGND sg13cmos5l_decap_8
XFILLER_0_466 VPWR VGND sg13cmos5l_fill_2
XFILLER_16_356 VPWR VGND sg13cmos5l_decap_4
XANTENNA_5 FrameData[10] VPWR VGND sg13cmos5l_antennanp
X_028_ _028_/Q FrameData[16] VGND VPWR FrameStrobe[3] latch
XFILLER_6_56 VPWR VGND sg13cmos5l_decap_8
XFILLER_15_21 VPWR VGND sg13cmos5l_decap_8
XFILLER_5_503 VPWR VGND sg13cmos5l_decap_8
XFILLER_13_337 VPWR VGND sg13cmos5l_fill_2
XFILLER_12_392 VPWR VGND sg13cmos5l_decap_4
XFILLER_11_0 VPWR VGND sg13cmos5l_decap_8
XFILLER_13_167 VPWR VGND sg13cmos5l_decap_8
XFILLER_13_101 VPWR VGND sg13cmos5l_fill_2
X_293_ _293_/X S2END[5] S4END[13] SS4END[2] _152_/Q _116_/Q _117_/Q VPWR VGND sg13cmos5l_mux4_1
XFILLER_5_333 VPWR VGND sg13cmos5l_fill_1
XFILLER_5_300 VPWR VGND sg13cmos5l_decap_8
XANTENNA__234__X FrameData_O[12] VPWR VGND sg13cmos5l_antennanp
XFILLER_3_35 VPWR VGND sg13cmos5l_decap_8
XFILLER_8_171 VPWR VGND sg13cmos5l_fill_1
XFILLER_2_336 VPWR VGND sg13cmos5l_decap_8
XANTENNA__229__X FrameData_O[7] VPWR VGND sg13cmos5l_antennanp
X_276_ N1BEG[2] _336_/X VPWR VGND sg13cmos5l_buf_1
XFILLER_14_465 VPWR VGND sg13cmos5l_decap_8
XFILLER_5_163 VPWR VGND sg13cmos5l_decap_8
XFILLER_5_141 VPWR VGND sg13cmos5l_fill_2
X_130_ _130_/Q FrameData[22] VGND VPWR FrameStrobe[0] latch
XFILLER_11_413 VPWR VGND sg13cmos5l_decap_8
X_061_ _061_/Q FrameData[17] VGND VPWR FrameStrobe[2] latch
XFILLER_2_133 VPWR VGND sg13cmos5l_decap_8
XFILLER_0_14 VPWR VGND sg13cmos5l_decap_8
XFILLER_9_56 VPWR VGND sg13cmos5l_decap_4
X_328_ _328_/X S1END[2] S2MID[2] S2END[5] _152_/Q _046_/Q _047_/Q VPWR VGND sg13cmos5l_mux4_1
X_259_ FrameStrobe_O[5] FrameStrobe[5] VPWR VGND sg13cmos5l_buf_1
XFILLER_14_284 VPWR VGND sg13cmos5l_decap_4
XFILLER_14_273 VPWR VGND sg13cmos5l_decap_4
XFILLER_6_483 VPWR VGND sg13cmos5l_decap_8
XFILLER_6_450 VPWR VGND sg13cmos5l_decap_4
XFILLER_16_516 VPWR VGND sg13cmos5l_decap_8
X_113_ _113_/Q FrameData[5] VGND VPWR FrameStrobe[0] latch
XFILLER_11_298 VPWR VGND sg13cmos5l_decap_4
XFILLER_11_210 VPWR VGND sg13cmos5l_decap_8
X_044_ _044_/Q FrameData[0] VGND VPWR FrameStrobe[2] latch
XFILLER_3_497 VPWR VGND sg13cmos5l_decap_8
XANTENNA__242__X FrameData_O[20] VPWR VGND sg13cmos5l_antennanp
XFILLER_15_7 VPWR VGND sg13cmos5l_decap_8
XFILLER_16_335 VPWR VGND sg13cmos5l_decap_8
XFILLER_16_313 VPWR VGND sg13cmos5l_fill_1
XANTENNA__237__X FrameData_O[15] VPWR VGND sg13cmos5l_antennanp
XANTENNA_6 FrameData[10] VPWR VGND sg13cmos5l_antennanp
XFILLER_6_35 VPWR VGND sg13cmos5l_decap_8
X_027_ _027_/Q FrameData[15] VGND VPWR FrameStrobe[3] latch
XFILLER_13_316 VPWR VGND sg13cmos5l_decap_8
XFILLER_15_99 VPWR VGND sg13cmos5l_fill_2
XFILLER_0_264 VPWR VGND sg13cmos5l_fill_2
XFILLER_16_132 VPWR VGND sg13cmos5l_fill_2
XFILLER_16_121 VPWR VGND sg13cmos5l_fill_1
XFILLER_8_375 VPWR VGND sg13cmos5l_fill_2
X_292_ _292_/X S2END[6] S4END[14] SS4END[1] _151_/Q _118_/Q _119_/Q VPWR VGND sg13cmos5l_mux4_1
XFILLER_13_146 VPWR VGND sg13cmos5l_decap_8
XFILLER_3_14 VPWR VGND sg13cmos5l_decap_8
XFILLER_1_540 VPWR VGND sg13cmos5l_fill_1
XANTENNA__250__X FrameData_O[28] VPWR VGND sg13cmos5l_antennanp
XFILLER_12_190 VPWR VGND sg13cmos5l_decap_8
XFILLER_10_116 VPWR VGND sg13cmos5l_decap_4
XFILLER_10_149 VPWR VGND sg13cmos5l_decap_8
XFILLER_2_315 VPWR VGND sg13cmos5l_decap_8
X_275_ N1BEG[1] _337_/X VPWR VGND sg13cmos5l_buf_1
XFILLER_14_444 VPWR VGND sg13cmos5l_decap_8
XANTENNA__245__X FrameData_O[23] VPWR VGND sg13cmos5l_antennanp
XFILLER_5_186 VPWR VGND sg13cmos5l_decap_4
XFILLER_5_120 VPWR VGND sg13cmos5l_decap_8
XFILLER_9_492 VPWR VGND sg13cmos5l_decap_8
XFILLER_15_219 VPWR VGND sg13cmos5l_decap_4
XFILLER_7_418 VPWR VGND sg13cmos5l_decap_8
X_060_ _060_/Q FrameData[16] VGND VPWR FrameStrobe[2] latch
XFILLER_2_112 VPWR VGND sg13cmos5l_decap_8
XFILLER_2_189 VPWR VGND sg13cmos5l_decap_8
XFILLER_9_35 VPWR VGND sg13cmos5l_decap_8
XFILLER_14_252 VPWR VGND sg13cmos5l_decap_8
XFILLER_14_230 VPWR VGND sg13cmos5l_fill_1
XFILLER_9_68 VPWR VGND sg13cmos5l_decap_4
X_189_ N4BEG[0] _322_/X VPWR VGND sg13cmos5l_buf_1
X_327_ _327_/X S1END[3] S2MID[3] S2END[4] _153_/Q _048_/Q _049_/Q VPWR VGND sg13cmos5l_mux4_1
X_258_ FrameStrobe_O[4] FrameStrobe[4] VPWR VGND sg13cmos5l_buf_1
XFILLER_14_296 VPWR VGND sg13cmos5l_decap_8
XFILLER_6_473 VPWR VGND sg13cmos5l_fill_2
Xclkbuf_2_2__f_UserCLK_regs _148_/CLK clkbuf_0_UserCLK_regs/X VPWR VGND sg13cmos5l_buf_8
X_043_ _043_/Q FrameData[31] VGND VPWR FrameStrobe[3] latch
X_112_ _112_/Q FrameData[4] VGND VPWR FrameStrobe[0] latch
XFILLER_11_277 VPWR VGND sg13cmos5l_decap_8
XFILLER_3_476 VPWR VGND sg13cmos5l_decap_8
XFILLER_1_0 VPWR VGND sg13cmos5l_decap_8
XFILLER_15_550 VPWR VGND sg13cmos5l_fill_1
XFILLER_1_91 VPWR VGND sg13cmos5l_decap_8
XFILLER_13_509 VPWR VGND sg13cmos5l_decap_8
XFILLER_8_513 VPWR VGND sg13cmos5l_decap_8
XFILLER_12_542 VPWR VGND sg13cmos5l_fill_1
XANTENNA_7 FrameData[10] VPWR VGND sg13cmos5l_antennanp
X_026_ _026_/Q FrameData[14] VGND VPWR FrameStrobe[3] latch
XFILLER_6_14 VPWR VGND sg13cmos5l_decap_8
XANTENNA__253__X FrameData_O[31] VPWR VGND sg13cmos5l_antennanp
XFILLER_15_391 VPWR VGND sg13cmos5l_decap_8
XFILLER_15_67 VPWR VGND sg13cmos5l_decap_4
XFILLER_15_45 VPWR VGND sg13cmos5l_decap_8
XFILLER_13_339 VPWR VGND sg13cmos5l_fill_1
XFILLER_5_549 VPWR VGND sg13cmos5l_fill_2
XFILLER_16_166 VPWR VGND sg13cmos5l_fill_1
XFILLER_0_298 VPWR VGND sg13cmos5l_fill_1
XANTENNA__248__X FrameData_O[26] VPWR VGND sg13cmos5l_antennanp
XFILLER_16_199 VPWR VGND sg13cmos5l_fill_1
XFILLER_16_177 VPWR VGND sg13cmos5l_fill_2
XFILLER_8_398 VPWR VGND sg13cmos5l_decap_8
X_291_ _291_/X S2END[7] S4END[15] SS4END[0] _150_/Q _120_/Q _121_/Q VPWR VGND sg13cmos5l_mux4_1
XFILLER_13_125 VPWR VGND sg13cmos5l_decap_8
XFILLER_13_103 VPWR VGND sg13cmos5l_fill_1
XFILLER_8_140 VPWR VGND sg13cmos5l_decap_8
XFILLER_10_128 VPWR VGND sg13cmos5l_decap_8
XFILLER_5_7 VPWR VGND sg13cmos5l_decap_8
XFILLER_12_57 VPWR VGND sg13cmos5l_decap_8
XFILLER_14_423 VPWR VGND sg13cmos5l_decap_8
X_274_ N1BEG[0] _338_/X VPWR VGND sg13cmos5l_buf_1
XFILLER_5_154 VPWR VGND sg13cmos5l_fill_2
XANTENNA__261__X FrameStrobe_O[7] VPWR VGND sg13cmos5l_antennanp
XFILLER_9_471 VPWR VGND sg13cmos5l_decap_8
XFILLER_11_448 VPWR VGND sg13cmos5l_decap_8
XFILLER_2_168 VPWR VGND sg13cmos5l_decap_8
XFILLER_0_49 VPWR VGND sg13cmos5l_decap_8
X_326_ _326_/X S1END[0] S2MID[4] S2END[3] _154_/Q _050_/Q _051_/Q VPWR VGND sg13cmos5l_mux4_1
XFILLER_9_14 VPWR VGND sg13cmos5l_decap_8
XANTENNA__256__X FrameStrobe_O[2] VPWR VGND sg13cmos5l_antennanp
X_188_ N2BEGb[7] _323_/X VPWR VGND sg13cmos5l_buf_1
X_257_ FrameStrobe_O[3] FrameStrobe[3] VPWR VGND sg13cmos5l_buf_1
XFILLER_9_290 VPWR VGND sg13cmos5l_fill_2
X_042_ _042_/Q FrameData[30] VGND VPWR FrameStrobe[3] latch
X_111_ _111_/Q FrameData[3] VGND VPWR FrameStrobe[0] latch
XFILLER_7_238 VPWR VGND sg13cmos5l_decap_8
XFILLER_11_256 VPWR VGND sg13cmos5l_decap_8
XFILLER_3_444 VPWR VGND sg13cmos5l_decap_8
X_309_ _309_/X S2MID[5] S4END[2] SS4END[13] _155_/Q _084_/Q _085_/Q VPWR VGND sg13cmos5l_mux4_1
XFILLER_1_70 VPWR VGND sg13cmos5l_decap_8
XFILLER_4_208 VPWR VGND sg13cmos5l_decap_8
XFILLER_16_304 VPWR VGND sg13cmos5l_decap_8
XFILLER_12_532 VPWR VGND sg13cmos5l_fill_2
XANTENNA_8 FrameData[10] VPWR VGND sg13cmos5l_antennanp
X_025_ _025_/Q FrameData[13] VGND VPWR FrameStrobe[3] latch
XFILLER_3_285 VPWR VGND sg13cmos5l_decap_8
XFILLER_15_35 VPWR VGND sg13cmos5l_decap_8
XFILLER_5_517 VPWR VGND sg13cmos5l_decap_8
XFILLER_0_277 VPWR VGND sg13cmos5l_fill_2
XFILLER_0_200 VPWR VGND sg13cmos5l_decap_8
XFILLER_16_189 VPWR VGND sg13cmos5l_fill_1
XFILLER_16_156 VPWR VGND sg13cmos5l_fill_2
XANTENNA__264__X FrameStrobe_O[10] VPWR VGND sg13cmos5l_antennanp
XFILLER_2_509 VPWR VGND sg13cmos5l_decap_8
X_290_ _290_/X S1END[0] S1END[1] S4END[4] SS4END[4] _138_/Q _139_/Q VPWR VGND sg13cmos5l_mux4_1
XFILLER_5_369 VPWR VGND sg13cmos5l_decap_4
XFILLER_1_520 VPWR VGND sg13cmos5l_fill_1
XFILLER_3_49 VPWR VGND sg13cmos5l_decap_8
XANTENNA__259__X FrameStrobe_O[5] VPWR VGND sg13cmos5l_antennanp
XFILLER_12_36 VPWR VGND sg13cmos5l_decap_8
XFILLER_14_479 VPWR VGND sg13cmos5l_decap_8
XFILLER_14_402 VPWR VGND sg13cmos5l_decap_8
X_273_ FrameStrobe_O[19] FrameStrobe[19] VPWR VGND sg13cmos5l_buf_1
XFILLER_1_361 VPWR VGND sg13cmos5l_decap_4
XFILLER_9_450 VPWR VGND sg13cmos5l_decap_8
XFILLER_4_70 VPWR VGND sg13cmos5l_fill_1
XFILLER_11_427 VPWR VGND sg13cmos5l_decap_8
XFILLER_2_147 VPWR VGND sg13cmos5l_decap_8
XFILLER_0_28 VPWR VGND sg13cmos5l_decap_8
X_325_ _325_/X S1END[1] S2MID[5] S2END[2] _155_/Q _052_/Q _053_/Q VPWR VGND sg13cmos5l_mux4_1
X_187_ N2BEGb[6] _324_/X VPWR VGND sg13cmos5l_buf_1
X_256_ FrameStrobe_O[2] FrameStrobe[2] VPWR VGND sg13cmos5l_buf_1
XFILLER_6_497 VPWR VGND sg13cmos5l_decap_8
XFILLER_6_475 VPWR VGND sg13cmos5l_fill_1
XFILLER_6_442 VPWR VGND sg13cmos5l_fill_1
XFILLER_6_431 VPWR VGND sg13cmos5l_decap_8
XFILLER_10_482 VPWR VGND sg13cmos5l_decap_8
XANTENNA__272__X FrameStrobe_O[18] VPWR VGND sg13cmos5l_antennanp
XANTENNA__182__X N2BEGb[1] VPWR VGND sg13cmos5l_antennanp
X_110_ _110_/Q FrameData[2] VGND VPWR FrameStrobe[0] latch
X_041_ _041_/Q FrameData[29] VGND VPWR FrameStrobe[3] latch
Xclkload0 clkload0/Y _157_/CLK VPWR VGND sg13cmos5l_inv_1
XFILLER_3_423 VPWR VGND sg13cmos5l_decap_8
XANTENNA__267__X FrameStrobe_O[13] VPWR VGND sg13cmos5l_antennanp
X_239_ FrameData_O[17] FrameData[17] VPWR VGND sg13cmos5l_buf_1
X_308_ _308_/X S2MID[6] S4END[1] SS4END[14] _156_/Q _086_/Q _087_/Q VPWR VGND sg13cmos5l_mux4_1
XANTENNA__177__X N2BEG[4] VPWR VGND sg13cmos5l_antennanp
XFILLER_0_459 VPWR VGND sg13cmos5l_decap_8
XFILLER_0_426 VPWR VGND sg13cmos5l_fill_2
XFILLER_16_349 VPWR VGND sg13cmos5l_decap_8
XFILLER_12_511 VPWR VGND sg13cmos5l_decap_8
X_024_ _024_/Q FrameData[12] VGND VPWR FrameStrobe[3] latch
XFILLER_6_49 VPWR VGND sg13cmos5l_decap_8
XFILLER_3_231 VPWR VGND sg13cmos5l_decap_8
XFILLER_10_80 VPWR VGND sg13cmos5l_decap_8
XANTENNA_9 FrameData[10] VPWR VGND sg13cmos5l_antennanp
XFILLER_13_7 VPWR VGND sg13cmos5l_fill_2
XFILLER_15_14 VPWR VGND sg13cmos5l_decap_8
XFILLER_16_113 VPWR VGND sg13cmos5l_fill_2
XFILLER_12_396 VPWR VGND sg13cmos5l_fill_1
XFILLER_12_385 VPWR VGND sg13cmos5l_decap_8
XANTENNA__280__X N2BEG[2] VPWR VGND sg13cmos5l_antennanp
XANTENNA__190__X N4BEG[1] VPWR VGND sg13cmos5l_antennanp
XFILLER_3_28 VPWR VGND sg13cmos5l_decap_8
XFILLER_1_532 VPWR VGND sg13cmos5l_fill_1
XFILLER_16_90 VPWR VGND sg13cmos5l_fill_2
XFILLER_12_171 VPWR VGND sg13cmos5l_fill_1
XANTENNA__275__X N1BEG[1] VPWR VGND sg13cmos5l_antennanp
XFILLER_8_164 VPWR VGND sg13cmos5l_decap_8
XANTENNA__185__X N2BEGb[4] VPWR VGND sg13cmos5l_antennanp
XFILLER_12_26 VPWR VGND sg13cmos5l_decap_4
XFILLER_2_329 VPWR VGND sg13cmos5l_decap_8
X_272_ FrameStrobe_O[18] FrameStrobe[18] VPWR VGND sg13cmos5l_buf_1
XFILLER_14_458 VPWR VGND sg13cmos5l_decap_8
XFILLER_5_134 VPWR VGND sg13cmos5l_decap_8
XFILLER_1_340 VPWR VGND sg13cmos5l_decap_8
XFILLER_4_82 VPWR VGND sg13cmos5l_decap_8
XFILLER_11_406 VPWR VGND sg13cmos5l_decap_8
XFILLER_2_126 VPWR VGND sg13cmos5l_decap_8
XFILLER_9_49 VPWR VGND sg13cmos5l_decap_8
X_324_ _324_/X S1END[2] S2MID[6] S2END[1] _156_/Q _054_/Q _055_/Q VPWR VGND sg13cmos5l_mux4_1
X_255_ FrameStrobe_O[1] FrameStrobe[1] VPWR VGND sg13cmos5l_buf_1
XFILLER_14_288 VPWR VGND sg13cmos5l_fill_1
XFILLER_14_266 VPWR VGND sg13cmos5l_decap_8
XFILLER_10_461 VPWR VGND sg13cmos5l_decap_8
X_186_ N2BEGb[5] _325_/X VPWR VGND sg13cmos5l_buf_1
XFILLER_6_454 VPWR VGND sg13cmos5l_fill_2
XFILLER_16_509 VPWR VGND sg13cmos5l_decap_8
Xclkload1 clkload1/Y _156_/CLK VPWR VGND sg13cmos5l_inv_1
XFILLER_11_203 VPWR VGND sg13cmos5l_decap_8
X_040_ _040_/Q FrameData[28] VGND VPWR FrameStrobe[3] latch
XFILLER_3_402 VPWR VGND sg13cmos5l_decap_8
XFILLER_15_542 VPWR VGND sg13cmos5l_fill_1
X_169_ _169_/L_HI VPWR VGND sg13cmos5l_tiehi
X_238_ FrameData_O[16] FrameData[16] VPWR VGND sg13cmos5l_buf_1
X_307_ _307_/X S2MID[7] S4END[0] SS4END[15] _157_/Q _088_/Q _089_/Q VPWR VGND sg13cmos5l_mux4_1
XFILLER_6_262 VPWR VGND sg13cmos5l_decap_8
XFILLER_6_273 VPWR VGND sg13cmos5l_fill_2
XANTENNA__193__X N4BEG[4] VPWR VGND sg13cmos5l_antennanp
XANTENNA__142__Q DEBUG_IN1 VPWR VGND sg13cmos5l_antennanp
X_023_ _023_/Q FrameData[11] VGND VPWR FrameStrobe[3] latch
XFILLER_8_549 VPWR VGND sg13cmos5l_fill_2
XFILLER_8_527 VPWR VGND sg13cmos5l_decap_4
XFILLER_6_28 VPWR VGND sg13cmos5l_decap_8
XFILLER_3_210 VPWR VGND sg13cmos5l_decap_8
XANTENNA__278__X N2BEG[0] VPWR VGND sg13cmos5l_antennanp
XFILLER_15_361 VPWR VGND sg13cmos5l_decap_8
XFILLER_13_309 VPWR VGND sg13cmos5l_decap_8
XANTENNA__188__X N2BEGb[7] VPWR VGND sg13cmos5l_antennanp
XFILLER_0_279 VPWR VGND sg13cmos5l_fill_1
XFILLER_0_257 VPWR VGND sg13cmos5l_decap_8
XFILLER_8_335 VPWR VGND sg13cmos5l_fill_1
XFILLER_7_82 VPWR VGND sg13cmos5l_decap_8
XFILLER_13_139 VPWR VGND sg13cmos5l_decap_8
XFILLER_8_154 VPWR VGND sg13cmos5l_fill_2
XFILLER_12_183 VPWR VGND sg13cmos5l_decap_8
XFILLER_4_393 VPWR VGND sg13cmos5l_fill_1
XFILLER_4_382 VPWR VGND sg13cmos5l_decap_8
XFILLER_10_109 VPWR VGND sg13cmos5l_decap_8
XFILLER_2_308 VPWR VGND sg13cmos5l_decap_8
X_271_ FrameStrobe_O[17] FrameStrobe[17] VPWR VGND sg13cmos5l_buf_1
XFILLER_14_437 VPWR VGND sg13cmos5l_decap_8
XFILLER_5_179 VPWR VGND sg13cmos5l_decap_8
XFILLER_5_102 VPWR VGND sg13cmos5l_decap_8
XFILLER_9_485 VPWR VGND sg13cmos5l_decap_8
XFILLER_13_481 VPWR VGND sg13cmos5l_decap_8
XANTENNA__196__X N4BEG[7] VPWR VGND sg13cmos5l_antennanp
XANTENNA__145__Q DEBUG_IN4 VPWR VGND sg13cmos5l_antennanp
XFILLER_3_7 VPWR VGND sg13cmos5l_decap_8
XFILLER_2_105 VPWR VGND sg13cmos5l_decap_8
XFILLER_14_212 VPWR VGND sg13cmos5l_decap_8
XFILLER_9_28 VPWR VGND sg13cmos5l_decap_8
X_185_ N2BEGb[4] _326_/X VPWR VGND sg13cmos5l_buf_1
X_323_ _323_/X S1END[3] S2MID[7] S2END[0] _157_/Q _056_/Q _057_/Q VPWR VGND sg13cmos5l_mux4_1
X_254_ FrameStrobe_O[0] FrameStrobe[0] VPWR VGND sg13cmos5l_buf_1
XFILLER_10_440 VPWR VGND sg13cmos5l_decap_8
XFILLER_6_466 VPWR VGND sg13cmos5l_decap_8
XFILLER_1_182 VPWR VGND sg13cmos5l_decap_8
XFILLER_3_458 VPWR VGND sg13cmos5l_decap_4
X_306_ _306_/X S2END[0] S4END[0] SS4END[15] _157_/Q _090_/Q _091_/Q VPWR VGND sg13cmos5l_mux4_1
XFILLER_15_532 VPWR VGND sg13cmos5l_decap_4
X_168_ _168_/L_HI VPWR VGND sg13cmos5l_tiehi
X_237_ FrameData_O[15] FrameData[15] VPWR VGND sg13cmos5l_buf_1
X_099_ _099_/Q FrameData[23] VGND VPWR FrameStrobe[1] latch
XFILLER_1_84 VPWR VGND sg13cmos5l_decap_8
X_022_ _022_/Q FrameData[10] VGND VPWR FrameStrobe[3] latch
XFILLER_8_506 VPWR VGND sg13cmos5l_decap_8
XFILLER_3_299 VPWR VGND sg13cmos5l_decap_8
XFILLER_13_9 VPWR VGND sg13cmos5l_fill_1
XFILLER_7_550 VPWR VGND sg13cmos5l_fill_1
XFILLER_16_148 VPWR VGND sg13cmos5l_decap_4
XFILLER_16_137 VPWR VGND sg13cmos5l_fill_2
XFILLER_12_310 VPWR VGND sg13cmos5l_fill_1
XFILLER_4_531 VPWR VGND sg13cmos5l_decap_4
XFILLER_15_170 VPWR VGND sg13cmos5l_decap_8
XANTENNA__199__X N4BEG[10] VPWR VGND sg13cmos5l_antennanp
XANTENNA__148__Q DEBUG_IN7 VPWR VGND sg13cmos5l_antennanp
XFILLER_1_512 VPWR VGND sg13cmos5l_fill_1
XFILLER_16_70 VPWR VGND sg13cmos5l_fill_1
XFILLER_8_133 VPWR VGND sg13cmos5l_decap_8
XFILLER_16_92 VPWR VGND sg13cmos5l_fill_1
XFILLER_8_199 VPWR VGND sg13cmos5l_decap_8
XFILLER_14_416 VPWR VGND sg13cmos5l_decap_8
X_270_ FrameStrobe_O[16] FrameStrobe[16] VPWR VGND sg13cmos5l_buf_1
XFILLER_5_147 VPWR VGND sg13cmos5l_decap_8
XFILLER_13_460 VPWR VGND sg13cmos5l_decap_8
XFILLER_9_464 VPWR VGND sg13cmos5l_decap_8
XFILLER_4_191 VPWR VGND sg13cmos5l_decap_8
XFILLER_4_180 VPWR VGND sg13cmos5l_decap_4
X_322_ _322_/X S2MID[0] S4END[15] SS4END[0] _150_/Q _058_/Q _059_/Q VPWR VGND sg13cmos5l_mux4_1
X_184_ N2BEGb[3] _327_/X VPWR VGND sg13cmos5l_buf_1
X_253_ FrameData_O[31] FrameData[31] VPWR VGND sg13cmos5l_buf_1
XFILLER_10_496 VPWR VGND sg13cmos5l_decap_8
XFILLER_1_161 VPWR VGND sg13cmos5l_decap_8
XFILLER_9_261 VPWR VGND sg13cmos5l_decap_8
XFILLER_9_283 VPWR VGND sg13cmos5l_decap_8
XFILLER_11_249 VPWR VGND sg13cmos5l_decap_8
XFILLER_3_437 VPWR VGND sg13cmos5l_decap_8
XFILLER_15_511 VPWR VGND sg13cmos5l_decap_8
X_305_ _305_/X S2END[1] S4END[1] SS4END[14] _156_/Q _092_/Q _093_/Q VPWR VGND sg13cmos5l_mux4_1
X_098_ _098_/Q FrameData[22] VGND VPWR FrameStrobe[1] latch
X_167_ _167_/L_HI VPWR VGND sg13cmos5l_tiehi
X_236_ FrameData_O[14] FrameData[14] VPWR VGND sg13cmos5l_buf_1
XFILLER_1_63 VPWR VGND sg13cmos5l_decap_8
XFILLER_12_525 VPWR VGND sg13cmos5l_decap_8
X_021_ USR_IRQ _140_/Q _140_/D _025_/Q VPWR VGND sg13cmos5l_mux2_1
XFILLER_10_94 VPWR VGND sg13cmos5l_decap_4
X_219_ NN4BEG[14] _292_/X VPWR VGND sg13cmos5l_buf_1
XFILLER_15_28 VPWR VGND sg13cmos5l_decap_4
XFILLER_0_215 VPWR VGND sg13cmos5l_fill_2
XFILLER_4_510 VPWR VGND sg13cmos5l_decap_8
XFILLER_11_7 VPWR VGND sg13cmos5l_fill_2
XFILLER_7_73 VPWR VGND sg13cmos5l_decap_4
XFILLER_5_307 VPWR VGND sg13cmos5l_fill_2
XFILLER_1_524 VPWR VGND sg13cmos5l_fill_1
XFILLER_16_82 VPWR VGND sg13cmos5l_fill_1
XFILLER_8_156 VPWR VGND sg13cmos5l_fill_1
XFILLER_8_101 VPWR VGND sg13cmos5l_fill_1
XFILLER_12_18 VPWR VGND sg13cmos5l_decap_4
XFILLER_1_365 VPWR VGND sg13cmos5l_fill_1
XFILLER_1_354 VPWR VGND sg13cmos5l_decap_8
XFILLER_9_443 VPWR VGND sg13cmos5l_decap_8
XFILLER_4_96 VPWR VGND sg13cmos5l_decap_8
XFILLER_4_63 VPWR VGND sg13cmos5l_decap_8
X_252_ FrameData_O[30] FrameData[30] VPWR VGND sg13cmos5l_buf_1
X_321_ _321_/X S2MID[1] S4END[14] SS4END[1] _151_/Q _060_/Q _061_/Q VPWR VGND sg13cmos5l_mux4_1
X_183_ N2BEGb[2] _328_/X VPWR VGND sg13cmos5l_buf_1
XFILLER_6_424 VPWR VGND sg13cmos5l_decap_8
XFILLER_13_94 VPWR VGND sg13cmos5l_decap_8
XFILLER_10_475 VPWR VGND sg13cmos5l_decap_8
XFILLER_1_140 VPWR VGND sg13cmos5l_decap_8
XFILLER_13_291 VPWR VGND sg13cmos5l_decap_8
XFILLER_11_217 VPWR VGND sg13cmos5l_decap_4
XFILLER_3_416 VPWR VGND sg13cmos5l_decap_8
X_235_ FrameData_O[13] FrameData[13] VPWR VGND sg13cmos5l_buf_1
X_304_ _304_/X S2END[2] S4END[2] SS4END[13] _155_/Q _094_/Q _095_/Q VPWR VGND sg13cmos5l_mux4_1
X_097_ _097_/Q FrameData[21] VGND VPWR FrameStrobe[1] latch
X_166_ _166_/L_HI VPWR VGND sg13cmos5l_tiehi
XFILLER_6_221 VPWR VGND sg13cmos5l_fill_1
XFILLER_1_42 VPWR VGND sg13cmos5l_decap_8
XFILLER_12_504 VPWR VGND sg13cmos5l_decap_8
X_020_ _140_/D _290_/X _023_/Q VPWR VGND sg13cmos5l_xor2_1
XFILLER_3_224 VPWR VGND sg13cmos5l_decap_8
XFILLER_10_73 VPWR VGND sg13cmos5l_decap_8
XFILLER_10_40 VPWR VGND sg13cmos5l_fill_1
XFILLER_15_386 VPWR VGND sg13cmos5l_fill_1
XFILLER_15_353 VPWR VGND sg13cmos5l_fill_1
XFILLER_15_331 VPWR VGND sg13cmos5l_decap_8
X_149_ _149_/Q _156_/CLK _149_/D _163_/L_HI VPWR VGND sg13cmos5l_dfrbpq_1
X_218_ NN4BEG[13] _293_/X VPWR VGND sg13cmos5l_buf_1
XFILLER_7_530 VPWR VGND sg13cmos5l_fill_1
XFILLER_0_249 VPWR VGND sg13cmos5l_decap_4
XFILLER_16_128 VPWR VGND sg13cmos5l_fill_1
XANTENNA_90 SS4END[3] VPWR VGND sg13cmos5l_antennanp
XFILLER_7_96 VPWR VGND sg13cmos5l_decap_4
XFILLER_7_63 VPWR VGND sg13cmos5l_decap_4
XFILLER_1_547 VPWR VGND sg13cmos5l_decap_4
XFILLER_1_536 VPWR VGND sg13cmos5l_fill_1
XFILLER_12_142 VPWR VGND sg13cmos5l_fill_1
XFILLER_12_131 VPWR VGND sg13cmos5l_decap_8
XFILLER_12_197 VPWR VGND sg13cmos5l_fill_2
XFILLER_12_164 VPWR VGND sg13cmos5l_decap_8
XFILLER_5_127 VPWR VGND sg13cmos5l_decap_8
XFILLER_1_333 VPWR VGND sg13cmos5l_decap_8
XFILLER_9_422 VPWR VGND sg13cmos5l_decap_8
XFILLER_13_495 VPWR VGND sg13cmos5l_decap_8
XFILLER_9_499 VPWR VGND sg13cmos5l_decap_8
XFILLER_4_42 VPWR VGND sg13cmos5l_decap_8
Xclkbuf_2_3__f_UserCLK_regs _156_/CLK clkbuf_0_UserCLK_regs/X VPWR VGND sg13cmos5l_buf_8
XFILLER_4_75 VPWR VGND sg13cmos5l_decap_8
XFILLER_2_119 VPWR VGND sg13cmos5l_decap_8
X_182_ N2BEGb[1] _329_/X VPWR VGND sg13cmos5l_buf_1
X_251_ FrameData_O[29] FrameData[29] VPWR VGND sg13cmos5l_buf_1
X_320_ _320_/X S2MID[2] S4END[13] SS4END[2] _152_/Q _062_/Q _063_/Q VPWR VGND sg13cmos5l_mux4_1
XFILLER_14_226 VPWR VGND sg13cmos5l_decap_4
XFILLER_8_0 VPWR VGND sg13cmos5l_decap_8
XFILLER_10_454 VPWR VGND sg13cmos5l_decap_8
XFILLER_9_252 VPWR VGND sg13cmos5l_fill_2
XFILLER_1_7 VPWR VGND sg13cmos5l_decap_8
XFILLER_15_546 VPWR VGND sg13cmos5l_decap_4
X_165_ _165_/L_HI VPWR VGND sg13cmos5l_tiehi
X_234_ FrameData_O[12] FrameData[12] VPWR VGND sg13cmos5l_buf_1
X_303_ _303_/X S2END[3] S4END[3] SS4END[12] _154_/Q _096_/Q _097_/Q VPWR VGND sg13cmos5l_mux4_1
XFILLER_6_233 VPWR VGND sg13cmos5l_fill_1
XFILLER_10_240 VPWR VGND sg13cmos5l_decap_8
X_096_ _096_/Q FrameData[20] VGND VPWR FrameStrobe[1] latch
XFILLER_2_483 VPWR VGND sg13cmos5l_fill_2
XFILLER_2_472 VPWR VGND sg13cmos5l_decap_8
XFILLER_1_98 VPWR VGND sg13cmos5l_decap_8
XFILLER_1_21 VPWR VGND sg13cmos5l_decap_8
XFILLER_12_549 VPWR VGND sg13cmos5l_fill_2
XFILLER_12_538 VPWR VGND sg13cmos5l_decap_4
XFILLER_3_247 VPWR VGND sg13cmos5l_decap_8
XFILLER_3_203 VPWR VGND sg13cmos5l_decap_8
XFILLER_10_52 VPWR VGND sg13cmos5l_decap_8
XANTENNA__202__X N4BEG[13] VPWR VGND sg13cmos5l_antennanp
X_148_ DEBUG_IN7 _148_/CLK _289_/X _162_/L_HI VPWR VGND sg13cmos5l_dfrbpq_1
X_217_ NN4BEG[12] _294_/X VPWR VGND sg13cmos5l_buf_1
X_079_ _079_/Q FrameData[3] VGND VPWR FrameStrobe[1] latch
XFILLER_2_280 VPWR VGND sg13cmos5l_decap_8
XFILLER_0_217 VPWR VGND sg13cmos5l_fill_1
XFILLER_12_324 VPWR VGND sg13cmos5l_fill_1
XFILLER_8_328 VPWR VGND sg13cmos5l_decap_8
XFILLER_8_317 VPWR VGND sg13cmos5l_decap_8
XFILLER_12_346 VPWR VGND sg13cmos5l_decap_8
XANTENNA_80 FrameData[8] VPWR VGND sg13cmos5l_antennanp
XFILLER_7_42 VPWR VGND sg13cmos5l_decap_8
XFILLER_7_350 VPWR VGND sg13cmos5l_fill_2
XFILLER_5_309 VPWR VGND sg13cmos5l_fill_1
XFILLER_8_147 VPWR VGND sg13cmos5l_decap_8
XFILLER_4_375 VPWR VGND sg13cmos5l_decap_8
XFILLER_4_397 VPWR VGND sg13cmos5l_decap_8
XFILLER_1_312 VPWR VGND sg13cmos5l_decap_8
XANTENNA__210__X NN4BEG[5] VPWR VGND sg13cmos5l_antennanp
XFILLER_9_478 VPWR VGND sg13cmos5l_decap_8
XFILLER_13_474 VPWR VGND sg13cmos5l_decap_8
XFILLER_4_21 VPWR VGND sg13cmos5l_decap_8
XFILLER_16_290 VPWR VGND sg13cmos5l_decap_8
XFILLER_14_205 VPWR VGND sg13cmos5l_decap_8
X_181_ N2BEGb[0] _330_/X VPWR VGND sg13cmos5l_buf_1
X_250_ FrameData_O[28] FrameData[28] VPWR VGND sg13cmos5l_buf_1
XFILLER_6_404 VPWR VGND sg13cmos5l_fill_2
XFILLER_13_52 VPWR VGND sg13cmos5l_fill_2
XFILLER_10_433 VPWR VGND sg13cmos5l_decap_8
XANTENNA__205__X NN4BEG[0] VPWR VGND sg13cmos5l_antennanp
XFILLER_1_175 VPWR VGND sg13cmos5l_decap_8
X_302_ _302_/X S2END[4] S4END[4] SS4END[11] _153_/Q _098_/Q _099_/Q VPWR VGND sg13cmos5l_mux4_1
XFILLER_15_536 VPWR VGND sg13cmos5l_fill_2
XFILLER_15_525 VPWR VGND sg13cmos5l_decap_8
X_095_ _095_/Q FrameData[19] VGND VPWR FrameStrobe[1] latch
X_164_ _164_/L_HI VPWR VGND sg13cmos5l_tiehi
X_233_ FrameData_O[11] FrameData[11] VPWR VGND sg13cmos5l_buf_1
XFILLER_6_212 VPWR VGND sg13cmos5l_decap_8
XFILLER_6_201 VPWR VGND sg13cmos5l_decap_8
XFILLER_2_495 VPWR VGND sg13cmos5l_decap_8
XFILLER_1_77 VPWR VGND sg13cmos5l_decap_8
XFILLER_15_322 VPWR VGND sg13cmos5l_decap_4
XFILLER_11_550 VPWR VGND sg13cmos5l_fill_1
X_078_ _078_/Q FrameData[2] VGND VPWR FrameStrobe[1] latch
X_147_ DEBUG_IN6 _148_/CLK _288_/X _158_/L_HI VPWR VGND sg13cmos5l_dfrbpq_1
X_216_ NN4BEG[11] _295_/X VPWR VGND sg13cmos5l_buf_1
XFILLER_16_108 VPWR VGND sg13cmos5l_fill_2
XFILLER_12_314 VPWR VGND sg13cmos5l_fill_2
XANTENNA_70 FrameData[8] VPWR VGND sg13cmos5l_antennanp
XFILLER_4_524 VPWR VGND sg13cmos5l_decap_8
XANTENNA__213__X NN4BEG[8] VPWR VGND sg13cmos5l_antennanp
XANTENNA_81 FrameData[8] VPWR VGND sg13cmos5l_antennanp
XFILLER_15_141 VPWR VGND sg13cmos5l_fill_1
XFILLER_7_21 VPWR VGND sg13cmos5l_decap_8
XFILLER_15_163 VPWR VGND sg13cmos5l_decap_8
XFILLER_7_384 VPWR VGND sg13cmos5l_fill_2
XFILLER_16_0 VPWR VGND sg13cmos5l_decap_4
XFILLER_1_516 VPWR VGND sg13cmos5l_fill_1
XFILLER_16_74 VPWR VGND sg13cmos5l_fill_1
XFILLER_12_199 VPWR VGND sg13cmos5l_fill_1
XANTENNA__208__X NN4BEG[3] VPWR VGND sg13cmos5l_antennanp
XFILLER_14_409 VPWR VGND sg13cmos5l_decap_8
XFILLER_9_457 VPWR VGND sg13cmos5l_decap_8
XFILLER_13_453 VPWR VGND sg13cmos5l_decap_8
XFILLER_4_173 VPWR VGND sg13cmos5l_decap_8
X_180_ N2BEG[7] S2MID[0] VPWR VGND sg13cmos5l_buf_1
XFILLER_6_438 VPWR VGND sg13cmos5l_decap_4
XFILLER_13_31 VPWR VGND sg13cmos5l_decap_8
XFILLER_10_489 VPWR VGND sg13cmos5l_decap_8
XFILLER_1_154 VPWR VGND sg13cmos5l_decap_8
XANTENNA__221__X UserCLKo VPWR VGND sg13cmos5l_antennanp
XFILLER_13_261 VPWR VGND sg13cmos5l_fill_2
XFILLER_13_250 VPWR VGND sg13cmos5l_decap_8
XFILLER_9_276 VPWR VGND sg13cmos5l_decap_8
XFILLER_5_482 VPWR VGND sg13cmos5l_decap_8
X_232_ FrameData_O[10] FrameData[10] VPWR VGND sg13cmos5l_buf_1
X_301_ _301_/X S2END[5] S4END[5] SS4END[10] _152_/Q _100_/Q _101_/Q VPWR VGND sg13cmos5l_mux4_1
XFILLER_15_504 VPWR VGND sg13cmos5l_decap_8
X_094_ _094_/Q FrameData[18] VGND VPWR FrameStrobe[1] latch
X_163_ _163_/L_HI VPWR VGND sg13cmos5l_tiehi
XFILLER_10_231 VPWR VGND sg13cmos5l_fill_2
XFILLER_10_220 VPWR VGND sg13cmos5l_decap_8
XANTENNA__216__X NN4BEG[11] VPWR VGND sg13cmos5l_antennanp
XFILLER_1_56 VPWR VGND sg13cmos5l_decap_8
XFILLER_12_518 VPWR VGND sg13cmos5l_decap_8
XFILLER_3_238 VPWR VGND sg13cmos5l_fill_2
XFILLER_10_87 VPWR VGND sg13cmos5l_decap_8
X_215_ NN4BEG[10] _296_/X VPWR VGND sg13cmos5l_buf_1
X_077_ _077_/Q FrameData[1] VGND VPWR FrameStrobe[1] latch
X_146_ DEBUG_IN5 _148_/CLK _287_/X _159_/L_HI VPWR VGND sg13cmos5l_dfrbpq_1
XANTENNA_60 FrameData[24] VPWR VGND sg13cmos5l_antennanp
XANTENNA_71 FrameData[8] VPWR VGND sg13cmos5l_antennanp
XFILLER_4_503 VPWR VGND sg13cmos5l_decap_8
XANTENNA_82 FrameData[8] VPWR VGND sg13cmos5l_antennanp
XFILLER_7_77 VPWR VGND sg13cmos5l_fill_1
XFILLER_7_330 VPWR VGND sg13cmos5l_decap_8
X_129_ _129_/Q FrameData[21] VGND VPWR FrameStrobe[0] latch
XFILLER_1_528 VPWR VGND sg13cmos5l_fill_1
XFILLER_16_31 VPWR VGND sg13cmos5l_fill_2
XFILLER_12_101 VPWR VGND sg13cmos5l_decap_8
XFILLER_8_127 VPWR VGND sg13cmos5l_fill_2
XANTENNA__224__X FrameData_O[2] VPWR VGND sg13cmos5l_antennanp
XFILLER_0_550 VPWR VGND sg13cmos5l_fill_1
XFILLER_16_495 VPWR VGND sg13cmos5l_decap_8
XFILLER_16_451 VPWR VGND sg13cmos5l_decap_8
XFILLER_16_440 VPWR VGND sg13cmos5l_fill_2
XFILLER_1_347 VPWR VGND sg13cmos5l_decap_8
XANTENNA__219__X NN4BEG[14] VPWR VGND sg13cmos5l_antennanp
XFILLER_9_436 VPWR VGND sg13cmos5l_decap_8
XFILLER_4_89 VPWR VGND sg13cmos5l_decap_8
XFILLER_4_56 VPWR VGND sg13cmos5l_decap_8
XFILLER_4_152 VPWR VGND sg13cmos5l_decap_8
XFILLER_13_87 VPWR VGND sg13cmos5l_decap_8
XFILLER_13_54 VPWR VGND sg13cmos5l_fill_1
XFILLER_13_21 VPWR VGND sg13cmos5l_decap_8
XFILLER_10_468 VPWR VGND sg13cmos5l_decap_8
XFILLER_1_133 VPWR VGND sg13cmos5l_decap_8
XFILLER_13_284 VPWR VGND sg13cmos5l_decap_8
XFILLER_3_409 VPWR VGND sg13cmos5l_decap_8
X_162_ _162_/L_HI VPWR VGND sg13cmos5l_tiehi
X_231_ FrameData_O[9] FrameData[9] VPWR VGND sg13cmos5l_buf_1
X_300_ _300_/X S2END[6] S4END[6] SS4END[9] _151_/Q _102_/Q _103_/Q VPWR VGND sg13cmos5l_mux4_1
X_093_ _093_/Q FrameData[17] VGND VPWR FrameStrobe[1] latch
XFILLER_6_269 VPWR VGND sg13cmos5l_decap_4
XFILLER_6_0 VPWR VGND sg13cmos5l_decap_8
XFILLER_10_298 VPWR VGND sg13cmos5l_decap_8
XFILLER_10_254 VPWR VGND sg13cmos5l_decap_4
XANTENNA__232__X FrameData_O[10] VPWR VGND sg13cmos5l_antennanp
XFILLER_2_442 VPWR VGND sg13cmos5l_fill_2
XFILLER_1_35 VPWR VGND sg13cmos5l_decap_8
XFILLER_3_217 VPWR VGND sg13cmos5l_decap_8
XFILLER_10_22 VPWR VGND sg13cmos5l_decap_8
XFILLER_10_66 VPWR VGND sg13cmos5l_decap_8
XFILLER_15_368 VPWR VGND sg13cmos5l_decap_4
X_145_ DEBUG_IN4 _148_/CLK _286_/X _175_/L_HI VPWR VGND sg13cmos5l_dfrbpq_1
X_214_ NN4BEG[9] _297_/X VPWR VGND sg13cmos5l_buf_1
XFILLER_7_512 VPWR VGND sg13cmos5l_decap_8
XFILLER_15_379 VPWR VGND sg13cmos5l_decap_8
XFILLER_11_530 VPWR VGND sg13cmos5l_decap_8
XANTENNA__227__X FrameData_O[5] VPWR VGND sg13cmos5l_antennanp
X_076_ _076_/Q FrameData[0] VGND VPWR FrameStrobe[1] latch
XFILLER_2_294 VPWR VGND sg13cmos5l_decap_8
XANTENNA_50 FrameData[24] VPWR VGND sg13cmos5l_antennanp
XANTENNA_61 FrameData[24] VPWR VGND sg13cmos5l_antennanp
XANTENNA_72 FrameData[8] VPWR VGND sg13cmos5l_antennanp
XFILLER_12_316 VPWR VGND sg13cmos5l_fill_1
XANTENNA_83 SS4END[1] VPWR VGND sg13cmos5l_antennanp
Xclkbuf_1_0__f_UserCLK _221_/A clkbuf_0_UserCLK/X VPWR VGND sg13cmos5l_buf_8
X_128_ _128_/Q FrameData[20] VGND VPWR FrameStrobe[0] latch
XFILLER_7_89 VPWR VGND sg13cmos5l_decap_8
XFILLER_7_67 VPWR VGND sg13cmos5l_fill_2
XFILLER_7_56 VPWR VGND sg13cmos5l_decap_8
XFILLER_7_386 VPWR VGND sg13cmos5l_fill_1
X_059_ _059_/Q FrameData[15] VGND VPWR FrameStrobe[2] latch
XFILLER_16_65 VPWR VGND sg13cmos5l_fill_2
XFILLER_16_21 VPWR VGND sg13cmos5l_fill_2
XFILLER_12_124 VPWR VGND sg13cmos5l_decap_8
XFILLER_4_389 VPWR VGND sg13cmos5l_decap_4
XFILLER_0_540 VPWR VGND sg13cmos5l_fill_2
XANTENNA__240__X FrameData_O[18] VPWR VGND sg13cmos5l_antennanp
XFILLER_7_183 VPWR VGND sg13cmos5l_decap_4
XFILLER_5_109 VPWR VGND sg13cmos5l_decap_4
XFILLER_1_326 VPWR VGND sg13cmos5l_decap_8
XFILLER_9_404 VPWR VGND sg13cmos5l_fill_1
XFILLER_9_415 VPWR VGND sg13cmos5l_decap_8
XFILLER_13_488 VPWR VGND sg13cmos5l_decap_8
XANTENNA__235__X FrameData_O[13] VPWR VGND sg13cmos5l_antennanp
XFILLER_4_131 VPWR VGND sg13cmos5l_decap_8
XFILLER_4_35 VPWR VGND sg13cmos5l_decap_8
XFILLER_8_492 VPWR VGND sg13cmos5l_decap_8
XFILLER_14_219 VPWR VGND sg13cmos5l_decap_8
XFILLER_10_447 VPWR VGND sg13cmos5l_decap_8
XFILLER_1_112 VPWR VGND sg13cmos5l_decap_8
XFILLER_9_223 VPWR VGND sg13cmos5l_fill_1
XFILLER_9_245 VPWR VGND sg13cmos5l_decap_8
X_161_ _161_/L_HI VPWR VGND sg13cmos5l_tiehi
X_230_ FrameData_O[8] FrameData[8] VPWR VGND sg13cmos5l_buf_1
X_092_ _092_/Q FrameData[16] VGND VPWR FrameStrobe[1] latch
XFILLER_2_465 VPWR VGND sg13cmos5l_decap_8
XFILLER_1_14 VPWR VGND sg13cmos5l_decap_8
XFILLER_10_45 VPWR VGND sg13cmos5l_decap_8
XFILLER_15_314 VPWR VGND sg13cmos5l_decap_4
X_075_ _075_/Q FrameData[31] VGND VPWR FrameStrobe[2] latch
X_144_ DEBUG_IN3 _156_/CLK _285_/X _174_/L_HI VPWR VGND sg13cmos5l_dfrbpq_1
X_213_ NN4BEG[8] _298_/X VPWR VGND sg13cmos5l_buf_1
XANTENNA__243__X FrameData_O[21] VPWR VGND sg13cmos5l_antennanp
XFILLER_2_273 VPWR VGND sg13cmos5l_decap_8
XFILLER_12_306 VPWR VGND sg13cmos5l_decap_4
XANTENNA_40 FrameData[1] VPWR VGND sg13cmos5l_antennanp
XANTENNA_51 FrameData[24] VPWR VGND sg13cmos5l_antennanp
XANTENNA_62 FrameData[24] VPWR VGND sg13cmos5l_antennanp
XANTENNA_73 FrameData[8] VPWR VGND sg13cmos5l_antennanp
XANTENNA_84 SS4END[1] VPWR VGND sg13cmos5l_antennanp
XFILLER_4_549 VPWR VGND sg13cmos5l_fill_2
XANTENNA__238__X FrameData_O[16] VPWR VGND sg13cmos5l_antennanp
X_058_ _058_/Q FrameData[14] VGND VPWR FrameStrobe[2] latch
X_127_ _127_/Q FrameData[19] VGND VPWR FrameStrobe[0] latch
XFILLER_7_35 VPWR VGND sg13cmos5l_decap_8
XFILLER_1_508 VPWR VGND sg13cmos5l_fill_1
XFILLER_4_368 VPWR VGND sg13cmos5l_decap_8
XFILLER_14_0 VPWR VGND sg13cmos5l_decap_4
XFILLER_1_305 VPWR VGND sg13cmos5l_decap_8
XFILLER_13_467 VPWR VGND sg13cmos5l_decap_8
XFILLER_4_198 VPWR VGND sg13cmos5l_fill_2
XFILLER_4_14 VPWR VGND sg13cmos5l_decap_8
XFILLER_4_110 VPWR VGND sg13cmos5l_decap_8
XANTENNA__251__X FrameData_O[29] VPWR VGND sg13cmos5l_antennanp
XFILLER_8_471 VPWR VGND sg13cmos5l_decap_8
XFILLER_13_45 VPWR VGND sg13cmos5l_decap_8
XFILLER_1_168 VPWR VGND sg13cmos5l_decap_8
XANTENNA__246__X FrameData_O[24] VPWR VGND sg13cmos5l_antennanp
XFILLER_9_268 VPWR VGND sg13cmos5l_fill_1
XFILLER_5_496 VPWR VGND sg13cmos5l_decap_8
XFILLER_15_518 VPWR VGND sg13cmos5l_decap_8
X_091_ _091_/Q FrameData[15] VGND VPWR FrameStrobe[1] latch
X_160_ _160_/L_HI VPWR VGND sg13cmos5l_tiehi
XFILLER_10_212 VPWR VGND sg13cmos5l_fill_1
XFILLER_10_201 VPWR VGND sg13cmos5l_decap_8
XFILLER_2_488 VPWR VGND sg13cmos5l_decap_8
XFILLER_2_444 VPWR VGND sg13cmos5l_fill_1
XFILLER_2_422 VPWR VGND sg13cmos5l_decap_8
Xclkbuf_regs_0_UserCLK clkbuf_regs_0_UserCLK/X UserCLK VPWR VGND sg13cmos5l_buf_8
X_289_ _289_/X S2MID[7] S2END[0] S4END[15] SS4END[15] _136_/Q _137_/Q VPWR VGND sg13cmos5l_mux4_1
X_212_ NN4BEG[7] _299_/X VPWR VGND sg13cmos5l_buf_1
XFILLER_15_326 VPWR VGND sg13cmos5l_fill_1
X_074_ _074_/Q FrameData[30] VGND VPWR FrameStrobe[2] latch
X_143_ DEBUG_IN2 _148_/CLK _284_/X _173_/L_HI VPWR VGND sg13cmos5l_dfrbpq_1
XFILLER_2_252 VPWR VGND sg13cmos5l_decap_8
XFILLER_2_91 VPWR VGND sg13cmos5l_decap_8
XANTENNA_30 FrameData[1] VPWR VGND sg13cmos5l_antennanp
XANTENNA_41 FrameData[1] VPWR VGND sg13cmos5l_antennanp
XANTENNA_52 FrameData[24] VPWR VGND sg13cmos5l_antennanp
XANTENNA_63 FrameData[24] VPWR VGND sg13cmos5l_antennanp
XANTENNA_74 FrameData[8] VPWR VGND sg13cmos5l_antennanp
XFILLER_4_517 VPWR VGND sg13cmos5l_decap_8
XANTENNA_85 SS4END[1] VPWR VGND sg13cmos5l_antennanp
XFILLER_15_134 VPWR VGND sg13cmos5l_decap_8
XFILLER_7_322 VPWR VGND sg13cmos5l_fill_1
XFILLER_7_14 VPWR VGND sg13cmos5l_decap_8
XANTENNA__254__X FrameStrobe_O[0] VPWR VGND sg13cmos5l_antennanp
X_057_ _057_/Q FrameData[13] VGND VPWR FrameStrobe[2] latch
X_126_ _126_/Q FrameData[18] VGND VPWR FrameStrobe[0] latch
XFILLER_16_4 VPWR VGND sg13cmos5l_fill_1
XFILLER_16_12 VPWR VGND sg13cmos5l_fill_2
XFILLER_16_78 VPWR VGND sg13cmos5l_decap_4
XFILLER_12_115 VPWR VGND sg13cmos5l_fill_2
XFILLER_4_303 VPWR VGND sg13cmos5l_fill_1
XFILLER_0_542 VPWR VGND sg13cmos5l_fill_1
XFILLER_16_432 VPWR VGND sg13cmos5l_fill_1
XANTENNA__249__X FrameData_O[27] VPWR VGND sg13cmos5l_antennanp
X_109_ _109_/Q FrameData[1] VGND VPWR FrameStrobe[0] latch
XFILLER_13_446 VPWR VGND sg13cmos5l_decap_8
XFILLER_4_166 VPWR VGND sg13cmos5l_decap_8
XFILLER_0_394 VPWR VGND sg13cmos5l_fill_1
XFILLER_8_450 VPWR VGND sg13cmos5l_decap_8
XFILLER_12_490 VPWR VGND sg13cmos5l_decap_8
XFILLER_13_13 VPWR VGND sg13cmos5l_decap_4
XFILLER_1_147 VPWR VGND sg13cmos5l_decap_8
XFILLER_13_298 VPWR VGND sg13cmos5l_decap_4
XANTENNA__262__X FrameStrobe_O[8] VPWR VGND sg13cmos5l_antennanp
XFILLER_5_475 VPWR VGND sg13cmos5l_decap_8
X_090_ _090_/Q FrameData[14] VGND VPWR FrameStrobe[1] latch
Xclkbuf_0_UserCLK_regs clkbuf_0_UserCLK_regs/X clkbuf_regs_0_UserCLK/X VPWR VGND sg13cmos5l_buf_8
XFILLER_2_401 VPWR VGND sg13cmos5l_decap_8
XFILLER_1_49 VPWR VGND sg13cmos5l_decap_8
XANTENNA__257__X FrameStrobe_O[3] VPWR VGND sg13cmos5l_antennanp
X_288_ _288_/X S2MID[6] S2END[1] S4END[14] SS4END[14] _134_/Q _135_/Q VPWR VGND sg13cmos5l_mux4_1
XFILLER_5_272 VPWR VGND sg13cmos5l_decap_8
XFILLER_10_36 VPWR VGND sg13cmos5l_decap_4
XFILLER_10_14 VPWR VGND sg13cmos5l_decap_4
X_142_ DEBUG_IN1 _157_/CLK _283_/X _172_/L_HI VPWR VGND sg13cmos5l_dfrbpq_1
X_211_ NN4BEG[6] _300_/X VPWR VGND sg13cmos5l_buf_1
XFILLER_15_349 VPWR VGND sg13cmos5l_decap_4
XFILLER_15_338 VPWR VGND sg13cmos5l_decap_4
X_073_ _073_/Q FrameData[29] VGND VPWR FrameStrobe[2] latch
XFILLER_7_526 VPWR VGND sg13cmos5l_decap_4
XFILLER_4_0 VPWR VGND sg13cmos5l_decap_8
XFILLER_2_231 VPWR VGND sg13cmos5l_decap_8
XFILLER_2_70 VPWR VGND sg13cmos5l_decap_8
XANTENNA_20 FrameData[10] VPWR VGND sg13cmos5l_antennanp
XANTENNA_31 FrameData[1] VPWR VGND sg13cmos5l_antennanp
XANTENNA_42 FrameData[24] VPWR VGND sg13cmos5l_antennanp
XANTENNA_53 FrameData[24] VPWR VGND sg13cmos5l_antennanp
XANTENNA_64 FrameData[24] VPWR VGND sg13cmos5l_antennanp
XANTENNA_75 FrameData[8] VPWR VGND sg13cmos5l_antennanp
XANTENNA_86 SS4END[1] VPWR VGND sg13cmos5l_antennanp
X_125_ _125_/Q FrameData[17] VGND VPWR FrameStrobe[0] latch
XFILLER_7_301 VPWR VGND sg13cmos5l_decap_8
XFILLER_11_352 VPWR VGND sg13cmos5l_decap_8
X_056_ _056_/Q FrameData[12] VGND VPWR FrameStrobe[2] latch
XANTENNA__270__X FrameStrobe_O[16] VPWR VGND sg13cmos5l_antennanp
XANTENNA__180__X N2BEG[7] VPWR VGND sg13cmos5l_antennanp
XFILLER_16_46 VPWR VGND sg13cmos5l_fill_2
XFILLER_12_138 VPWR VGND sg13cmos5l_decap_4
XFILLER_4_315 VPWR VGND sg13cmos5l_fill_2
XFILLER_16_400 VPWR VGND sg13cmos5l_decap_8
XFILLER_16_488 VPWR VGND sg13cmos5l_decap_8
XANTENNA__265__X FrameStrobe_O[11] VPWR VGND sg13cmos5l_antennanp
X_108_ _108_/Q FrameData[0] VGND VPWR FrameStrobe[0] latch
X_039_ _039_/Q FrameData[27] VGND VPWR FrameStrobe[3] latch
XFILLER_9_429 VPWR VGND sg13cmos5l_decap_8
XFILLER_4_49 VPWR VGND sg13cmos5l_decap_8
XFILLER_4_145 VPWR VGND sg13cmos5l_decap_8
XFILLER_16_263 VPWR VGND sg13cmos5l_fill_2
XFILLER_8_7 VPWR VGND sg13cmos5l_decap_8
XFILLER_1_126 VPWR VGND sg13cmos5l_decap_8
XFILLER_9_204 VPWR VGND sg13cmos5l_fill_1
XFILLER_0_181 VPWR VGND sg13cmos5l_fill_1
XFILLER_6_229 VPWR VGND sg13cmos5l_decap_4
XFILLER_10_247 VPWR VGND sg13cmos5l_decap_8
XFILLER_2_479 VPWR VGND sg13cmos5l_decap_4
XFILLER_1_28 VPWR VGND sg13cmos5l_decap_8
X_287_ _287_/X S2MID[5] S2END[2] S4END[13] SS4END[13] _132_/Q _133_/Q VPWR VGND sg13cmos5l_mux4_1
XFILLER_14_90 VPWR VGND sg13cmos5l_decap_4
XANTENNA__273__X FrameStrobe_O[19] VPWR VGND sg13cmos5l_antennanp
XANTENNA__183__X N2BEGb[2] VPWR VGND sg13cmos5l_antennanp
XFILLER_10_59 VPWR VGND sg13cmos5l_decap_8
X_141_ DEBUG_IN0 _157_/CLK _282_/X _160_/L_HI VPWR VGND sg13cmos5l_dfrbpq_1
X_210_ NN4BEG[5] _301_/X VPWR VGND sg13cmos5l_buf_1
XFILLER_7_505 VPWR VGND sg13cmos5l_decap_8
XFILLER_11_523 VPWR VGND sg13cmos5l_decap_8
X_072_ _072_/Q FrameData[28] VGND VPWR FrameStrobe[2] latch
XFILLER_2_210 VPWR VGND sg13cmos5l_decap_8
XFILLER_2_287 VPWR VGND sg13cmos5l_decap_8
XANTENNA__268__X FrameStrobe_O[14] VPWR VGND sg13cmos5l_antennanp
XFILLER_14_372 VPWR VGND sg13cmos5l_fill_2
XANTENNA__178__X N2BEG[5] VPWR VGND sg13cmos5l_antennanp
XANTENNA_10 FrameData[10] VPWR VGND sg13cmos5l_antennanp
XANTENNA_21 FrameData[10] VPWR VGND sg13cmos5l_antennanp
XANTENNA_32 FrameData[1] VPWR VGND sg13cmos5l_antennanp
XANTENNA_43 FrameData[24] VPWR VGND sg13cmos5l_antennanp
XANTENNA_54 FrameData[24] VPWR VGND sg13cmos5l_antennanp
XANTENNA_65 FrameData[24] VPWR VGND sg13cmos5l_antennanp
XANTENNA_76 FrameData[8] VPWR VGND sg13cmos5l_antennanp
XANTENNA_87 SS4END[3] VPWR VGND sg13cmos5l_antennanp
X_055_ _055_/Q FrameData[11] VGND VPWR FrameStrobe[2] latch
X_124_ _124_/Q FrameData[16] VGND VPWR FrameStrobe[0] latch
XFILLER_7_49 VPWR VGND sg13cmos5l_decap_8
XFILLER_7_346 VPWR VGND sg13cmos5l_decap_4
XFILLER_11_342 VPWR VGND sg13cmos5l_fill_2
XFILLER_0_533 VPWR VGND sg13cmos5l_decap_8
XFILLER_11_150 VPWR VGND sg13cmos5l_decap_4
X_038_ _038_/Q FrameData[26] VGND VPWR FrameStrobe[3] latch
X_107_ _107_/Q FrameData[31] VGND VPWR FrameStrobe[1] latch
XFILLER_7_187 VPWR VGND sg13cmos5l_fill_1
XFILLER_11_183 VPWR VGND sg13cmos5l_fill_1
XANTENNA__281__X N2BEG[3] VPWR VGND sg13cmos5l_antennanp
XFILLER_8_92 VPWR VGND sg13cmos5l_decap_8
XFILLER_8_70 VPWR VGND sg13cmos5l_decap_8
XANTENNA__191__X N4BEG[2] VPWR VGND sg13cmos5l_antennanp
XFILLER_1_319 VPWR VGND sg13cmos5l_decap_8
XFILLER_9_408 VPWR VGND sg13cmos5l_decap_8
XFILLER_4_124 VPWR VGND sg13cmos5l_decap_8
XFILLER_4_28 VPWR VGND sg13cmos5l_decap_8
XFILLER_0_330 VPWR VGND sg13cmos5l_fill_2
XANTENNA__276__X N1BEG[2] VPWR VGND sg13cmos5l_antennanp
XFILLER_16_297 VPWR VGND sg13cmos5l_decap_8
XFILLER_8_485 VPWR VGND sg13cmos5l_decap_8
XFILLER_12_0 VPWR VGND sg13cmos5l_decap_8
XANTENNA__186__X N2BEGb[5] VPWR VGND sg13cmos5l_antennanp
XFILLER_1_105 VPWR VGND sg13cmos5l_decap_8
XFILLER_9_216 VPWR VGND sg13cmos5l_decap_8
XFILLER_0_193 VPWR VGND sg13cmos5l_fill_2
XFILLER_8_260 VPWR VGND sg13cmos5l_decap_8
XFILLER_6_208 VPWR VGND sg13cmos5l_fill_1
XFILLER_6_219 VPWR VGND sg13cmos5l_fill_2
XFILLER_2_458 VPWR VGND sg13cmos5l_decap_8
XFILLER_14_532 VPWR VGND sg13cmos5l_fill_2
XFILLER_14_521 VPWR VGND sg13cmos5l_decap_8
X_286_ _286_/X S2MID[4] S2END[3] S4END[12] SS4END[12] _130_/Q _131_/Q VPWR VGND sg13cmos5l_mux4_1
XFILLER_15_307 VPWR VGND sg13cmos5l_decap_8
X_071_ _071_/Q FrameData[27] VGND VPWR FrameStrobe[2] latch
X_140_ _140_/Q _156_/CLK _140_/D _161_/L_HI VPWR VGND sg13cmos5l_dfrbpq_1
XFILLER_11_546 VPWR VGND sg13cmos5l_decap_4
XFILLER_11_502 VPWR VGND sg13cmos5l_decap_8
XFILLER_2_266 VPWR VGND sg13cmos5l_decap_8
X_338_ _338_/X S1END[3] S2MID[0] S4END[12] _019_/X _026_/Q _027_/Q VPWR VGND sg13cmos5l_mux4_1
XFILLER_14_395 VPWR VGND sg13cmos5l_decap_8
X_269_ FrameStrobe_O[15] FrameStrobe[15] VPWR VGND sg13cmos5l_buf_1
XFILLER_6_550 VPWR VGND sg13cmos5l_fill_1
XANTENNA_11 FrameData[10] VPWR VGND sg13cmos5l_antennanp
XANTENNA_22 FrameData[10] VPWR VGND sg13cmos5l_antennanp
XANTENNA_33 FrameData[1] VPWR VGND sg13cmos5l_antennanp
XANTENNA_44 FrameData[24] VPWR VGND sg13cmos5l_antennanp
XANTENNA_55 FrameData[24] VPWR VGND sg13cmos5l_antennanp
XANTENNA_66 FrameData[24] VPWR VGND sg13cmos5l_antennanp
XANTENNA_77 FrameData[8] VPWR VGND sg13cmos5l_antennanp
XANTENNA__194__X N4BEG[5] VPWR VGND sg13cmos5l_antennanp
XANTENNA_88 SS4END[3] VPWR VGND sg13cmos5l_antennanp
XANTENNA__143__Q DEBUG_IN2 VPWR VGND sg13cmos5l_antennanp
XFILLER_15_126 VPWR VGND sg13cmos5l_fill_1
XFILLER_11_321 VPWR VGND sg13cmos5l_decap_8
X_054_ _054_/Q FrameData[10] VGND VPWR FrameStrobe[2] latch
X_123_ _123_/Q FrameData[15] VGND VPWR FrameStrobe[0] latch
XFILLER_7_28 VPWR VGND sg13cmos5l_decap_8
XANTENNA__279__X N2BEG[1] VPWR VGND sg13cmos5l_antennanp
XFILLER_14_181 VPWR VGND sg13cmos5l_fill_1
XANTENNA__189__X N4BEG[0] VPWR VGND sg13cmos5l_antennanp
XFILLER_16_26 VPWR VGND sg13cmos5l_fill_1
XFILLER_16_446 VPWR VGND sg13cmos5l_fill_2
XFILLER_11_162 VPWR VGND sg13cmos5l_decap_8
XFILLER_11_140 VPWR VGND sg13cmos5l_decap_4
X_037_ _037_/Q FrameData[25] VGND VPWR FrameStrobe[3] latch
X_106_ _106_/Q FrameData[30] VGND VPWR FrameStrobe[1] latch
XFILLER_3_361 VPWR VGND sg13cmos5l_decap_8
XFILLER_14_4 VPWR VGND sg13cmos5l_fill_1
XFILLER_15_490 VPWR VGND sg13cmos5l_decap_8
XFILLER_4_103 VPWR VGND sg13cmos5l_decap_8
XFILLER_16_221 VPWR VGND sg13cmos5l_fill_2
XFILLER_8_464 VPWR VGND sg13cmos5l_decap_8
XFILLER_13_38 VPWR VGND sg13cmos5l_decap_8
XFILLER_13_257 VPWR VGND sg13cmos5l_decap_4
XFILLER_5_489 VPWR VGND sg13cmos5l_decap_8
XFILLER_5_434 VPWR VGND sg13cmos5l_decap_8
XFILLER_0_172 VPWR VGND sg13cmos5l_decap_8
XFILLER_8_283 VPWR VGND sg13cmos5l_decap_4
XFILLER_5_72 VPWR VGND sg13cmos5l_decap_8
XANTENNA__197__X N4BEG[8] VPWR VGND sg13cmos5l_antennanp
XFILLER_10_227 VPWR VGND sg13cmos5l_decap_4
XANTENNA__146__Q DEBUG_IN5 VPWR VGND sg13cmos5l_antennanp
XFILLER_2_437 VPWR VGND sg13cmos5l_fill_2
XFILLER_2_415 VPWR VGND sg13cmos5l_decap_8
XFILLER_14_500 VPWR VGND sg13cmos5l_decap_8
X_285_ _285_/X S2MID[3] S2END[4] S4END[11] SS4END[11] _128_/Q _129_/Q VPWR VGND sg13cmos5l_mux4_1
XFILLER_5_253 VPWR VGND sg13cmos5l_decap_4
XFILLER_5_286 VPWR VGND sg13cmos5l_decap_8
X_070_ _070_/Q FrameData[26] VGND VPWR FrameStrobe[2] latch
XFILLER_2_245 VPWR VGND sg13cmos5l_decap_8
X_337_ _337_/X S1END[2] S2MID[1] S4END[13] _019_/X _028_/Q _029_/Q VPWR VGND sg13cmos5l_mux4_1
X_199_ N4BEG[10] _312_/X VPWR VGND sg13cmos5l_buf_1
X_268_ FrameStrobe_O[14] FrameStrobe[14] VPWR VGND sg13cmos5l_buf_1
XFILLER_2_84 VPWR VGND sg13cmos5l_decap_8
XANTENNA_12 FrameData[10] VPWR VGND sg13cmos5l_antennanp
XANTENNA_23 FrameData[10] VPWR VGND sg13cmos5l_antennanp
XANTENNA_34 FrameData[1] VPWR VGND sg13cmos5l_antennanp
XANTENNA_45 FrameData[24] VPWR VGND sg13cmos5l_antennanp
XANTENNA_56 FrameData[24] VPWR VGND sg13cmos5l_antennanp
XANTENNA_67 FrameData[8] VPWR VGND sg13cmos5l_antennanp
XANTENNA_78 FrameData[8] VPWR VGND sg13cmos5l_antennanp
XANTENNA_89 SS4END[3] VPWR VGND sg13cmos5l_antennanp
XFILLER_15_105 VPWR VGND sg13cmos5l_decap_8
XFILLER_7_315 VPWR VGND sg13cmos5l_decap_8
XFILLER_11_366 VPWR VGND sg13cmos5l_decap_8
XFILLER_11_344 VPWR VGND sg13cmos5l_fill_1
X_053_ _053_/Q FrameData[9] VGND VPWR FrameStrobe[2] latch
X_122_ _122_/Q FrameData[14] VGND VPWR FrameStrobe[0] latch
XFILLER_7_337 VPWR VGND sg13cmos5l_fill_2
XFILLER_2_0 VPWR VGND sg13cmos5l_decap_8
XFILLER_11_93 VPWR VGND sg13cmos5l_decap_4
XFILLER_16_8 VPWR VGND sg13cmos5l_decap_4
XFILLER_14_193 VPWR VGND sg13cmos5l_fill_1
XFILLER_12_108 VPWR VGND sg13cmos5l_decap_8
XFILLER_0_546 VPWR VGND sg13cmos5l_decap_4
XFILLER_0_502 VPWR VGND sg13cmos5l_decap_8
XFILLER_16_458 VPWR VGND sg13cmos5l_fill_2
X_105_ _105_/Q FrameData[29] VGND VPWR FrameStrobe[1] latch
XFILLER_11_130 VPWR VGND sg13cmos5l_fill_2
X_036_ _036_/Q FrameData[24] VGND VPWR FrameStrobe[3] latch
XFILLER_3_395 VPWR VGND sg13cmos5l_decap_8
XFILLER_13_439 VPWR VGND sg13cmos5l_decap_8
XFILLER_4_159 VPWR VGND sg13cmos5l_decap_8
XFILLER_0_332 VPWR VGND sg13cmos5l_fill_1
XFILLER_16_233 VPWR VGND sg13cmos5l_decap_4
XFILLER_8_443 VPWR VGND sg13cmos5l_decap_8
XFILLER_12_483 VPWR VGND sg13cmos5l_decap_8
X_019_ _019_/X _149_/Q _149_/D _024_/Q VPWR VGND sg13cmos5l_mux2_1
XFILLER_13_17 VPWR VGND sg13cmos5l_fill_1
XFILLER_5_468 VPWR VGND sg13cmos5l_decap_8
XFILLER_0_140 VPWR VGND sg13cmos5l_fill_1
XFILLER_0_195 VPWR VGND sg13cmos5l_fill_1
XFILLER_6_7 VPWR VGND sg13cmos5l_decap_8
X_284_ _284_/X S2MID[2] S2END[5] S4END[10] SS4END[10] _126_/Q _127_/Q VPWR VGND sg13cmos5l_mux4_1
XFILLER_5_265 VPWR VGND sg13cmos5l_decap_8
XFILLER_5_232 VPWR VGND sg13cmos5l_decap_8
XFILLER_10_29 VPWR VGND sg13cmos5l_decap_8
XFILLER_11_537 VPWR VGND sg13cmos5l_fill_2
XFILLER_7_519 VPWR VGND sg13cmos5l_decap_8
XFILLER_2_224 VPWR VGND sg13cmos5l_decap_8
X_336_ _336_/X S1END[1] S2MID[2] S4END[14] _019_/X _030_/Q _031_/Q VPWR VGND sg13cmos5l_mux4_1
X_267_ FrameStrobe_O[13] FrameStrobe[13] VPWR VGND sg13cmos5l_buf_1
X_198_ N4BEG[9] _313_/X VPWR VGND sg13cmos5l_buf_1
XFILLER_2_63 VPWR VGND sg13cmos5l_decap_8
XANTENNA_13 FrameData[10] VPWR VGND sg13cmos5l_antennanp
XANTENNA_24 FrameData[10] VPWR VGND sg13cmos5l_antennanp
XANTENNA_35 FrameData[1] VPWR VGND sg13cmos5l_antennanp
XANTENNA_46 FrameData[24] VPWR VGND sg13cmos5l_antennanp
XANTENNA_57 FrameData[24] VPWR VGND sg13cmos5l_antennanp
XANTENNA_68 FrameData[8] VPWR VGND sg13cmos5l_antennanp
XANTENNA_79 FrameData[8] VPWR VGND sg13cmos5l_antennanp
X_121_ _121_/Q FrameData[13] VGND VPWR FrameStrobe[0] latch
X_052_ _052_/Q FrameData[8] VGND VPWR FrameStrobe[2] latch
XFILLER_3_511 VPWR VGND sg13cmos5l_decap_8
X_319_ _319_/X S2MID[3] S4END[12] SS4END[3] _153_/Q _064_/Q _065_/Q VPWR VGND sg13cmos5l_mux4_1
XFILLER_16_17 VPWR VGND sg13cmos5l_decap_4
X_035_ _035_/Q FrameData[23] VGND VPWR FrameStrobe[3] latch
X_104_ _104_/Q FrameData[28] VGND VPWR FrameStrobe[1] latch
XFILLER_8_84 VPWR VGND sg13cmos5l_fill_1
XFILLER_4_138 VPWR VGND sg13cmos5l_decap_8
XFILLER_8_422 VPWR VGND sg13cmos5l_decap_8
XFILLER_16_256 VPWR VGND sg13cmos5l_decap_8
XFILLER_12_462 VPWR VGND sg13cmos5l_decap_8
X_018_ _149_/D SLOT_SOFT_RST_N _022_/Q VPWR VGND sg13cmos5l_xor2_1
XFILLER_8_499 VPWR VGND sg13cmos5l_decap_8
XFILLER_3_182 VPWR VGND sg13cmos5l_decap_8
XFILLER_1_119 VPWR VGND sg13cmos5l_decap_8
XFILLER_0_152 VPWR VGND sg13cmos5l_fill_2
XFILLER_12_292 VPWR VGND sg13cmos5l_decap_8
XFILLER_12_270 VPWR VGND sg13cmos5l_decap_8
XFILLER_8_274 VPWR VGND sg13cmos5l_fill_2
XFILLER_5_63 VPWR VGND sg13cmos5l_fill_2
XFILLER_10_0 VPWR VGND sg13cmos5l_decap_8
X_283_ _283_/X S2MID[1] S2END[6] S4END[9] SS4END[9] _124_/Q _125_/Q VPWR VGND sg13cmos5l_mux4_1
XFILLER_14_94 VPWR VGND sg13cmos5l_fill_2
XFILLER_5_222 VPWR VGND sg13cmos5l_decap_4
XFILLER_5_211 VPWR VGND sg13cmos5l_decap_8
XFILLER_9_550 VPWR VGND sg13cmos5l_fill_1
XFILLER_11_516 VPWR VGND sg13cmos5l_decap_8
XFILLER_2_203 VPWR VGND sg13cmos5l_decap_8
XFILLER_14_310 VPWR VGND sg13cmos5l_fill_1
X_197_ N4BEG[8] _314_/X VPWR VGND sg13cmos5l_buf_1
X_335_ _335_/X S1END[0] S2MID[3] S4END[15] _019_/X _032_/Q _033_/Q VPWR VGND sg13cmos5l_mux4_1
X_266_ FrameStrobe_O[12] FrameStrobe[12] VPWR VGND sg13cmos5l_buf_1
XFILLER_2_42 VPWR VGND sg13cmos5l_decap_8
XANTENNA_14 FrameData[10] VPWR VGND sg13cmos5l_antennanp
XANTENNA_25 FrameData[10] VPWR VGND sg13cmos5l_antennanp
XANTENNA_36 FrameData[1] VPWR VGND sg13cmos5l_antennanp
XANTENNA_47 FrameData[24] VPWR VGND sg13cmos5l_antennanp
XANTENNA_58 FrameData[24] VPWR VGND sg13cmos5l_antennanp
XANTENNA_69 FrameData[8] VPWR VGND sg13cmos5l_antennanp
XFILLER_9_380 VPWR VGND sg13cmos5l_fill_1
X_051_ _051_/Q FrameData[7] VGND VPWR FrameStrobe[2] latch
X_120_ _120_/Q FrameData[12] VGND VPWR FrameStrobe[0] latch
XFILLER_11_335 VPWR VGND sg13cmos5l_decap_8
XFILLER_11_302 VPWR VGND sg13cmos5l_fill_1
XFILLER_11_73 VPWR VGND sg13cmos5l_fill_2
XFILLER_11_62 VPWR VGND sg13cmos5l_decap_4
XFILLER_14_173 VPWR VGND sg13cmos5l_fill_1
X_249_ FrameData_O[27] FrameData[27] VPWR VGND sg13cmos5l_buf_1
X_318_ _318_/X S2MID[4] S4END[11] SS4END[4] _154_/Q _066_/Q _067_/Q VPWR VGND sg13cmos5l_mux4_1
XFILLER_6_361 VPWR VGND sg13cmos5l_decap_8
XFILLER_0_526 VPWR VGND sg13cmos5l_decap_8
XFILLER_11_132 VPWR VGND sg13cmos5l_fill_1
X_034_ _034_/Q FrameData[22] VGND VPWR FrameStrobe[3] latch
X_103_ _103_/Q FrameData[27] VGND VPWR FrameStrobe[1] latch
XFILLER_7_114 VPWR VGND sg13cmos5l_decap_4
XFILLER_3_320 VPWR VGND sg13cmos5l_decap_8
XFILLER_11_176 VPWR VGND sg13cmos5l_decap_8
XFILLER_11_154 VPWR VGND sg13cmos5l_fill_1
XFILLER_8_63 VPWR VGND sg13cmos5l_decap_8
XFILLER_4_117 VPWR VGND sg13cmos5l_decap_8
XFILLER_0_356 VPWR VGND sg13cmos5l_decap_8
XANTENNA__200__X N4BEG[11] VPWR VGND sg13cmos5l_antennanp
XFILLER_12_441 VPWR VGND sg13cmos5l_decap_8
XFILLER_8_478 VPWR VGND sg13cmos5l_decap_8
XFILLER_3_161 VPWR VGND sg13cmos5l_decap_8
XFILLER_9_209 VPWR VGND sg13cmos5l_decap_8
XFILLER_0_186 VPWR VGND sg13cmos5l_decap_8
XFILLER_0_131 VPWR VGND sg13cmos5l_decap_8
XFILLER_8_253 VPWR VGND sg13cmos5l_decap_8
XFILLER_8_231 VPWR VGND sg13cmos5l_decap_8
XFILLER_5_42 VPWR VGND sg13cmos5l_decap_8
XFILLER_10_208 VPWR VGND sg13cmos5l_decap_4
XFILLER_2_429 VPWR VGND sg13cmos5l_fill_1
XFILLER_14_514 VPWR VGND sg13cmos5l_decap_8
X_282_ _282_/X S2MID[0] S2END[7] S4END[8] SS4END[8] _122_/Q _123_/Q VPWR VGND sg13cmos5l_mux4_1
XFILLER_14_62 VPWR VGND sg13cmos5l_decap_8
XFILLER_14_51 VPWR VGND sg13cmos5l_fill_1
XFILLER_2_259 VPWR VGND sg13cmos5l_decap_8
X_334_ _334_/X S2MID[7] S2END[0] SS4END[12] _019_/X _034_/Q _035_/Q VPWR VGND sg13cmos5l_mux4_1
X_196_ N4BEG[7] _315_/X VPWR VGND sg13cmos5l_buf_1
X_265_ FrameStrobe_O[11] FrameStrobe[11] VPWR VGND sg13cmos5l_buf_1
XFILLER_6_532 VPWR VGND sg13cmos5l_fill_2
XFILLER_2_21 VPWR VGND sg13cmos5l_decap_8
XFILLER_2_98 VPWR VGND sg13cmos5l_decap_8
XANTENNA_15 FrameData[10] VPWR VGND sg13cmos5l_antennanp
XANTENNA_26 FrameData[1] VPWR VGND sg13cmos5l_antennanp
XANTENNA_37 FrameData[1] VPWR VGND sg13cmos5l_antennanp
XANTENNA_48 FrameData[24] VPWR VGND sg13cmos5l_antennanp
XANTENNA_59 FrameData[24] VPWR VGND sg13cmos5l_antennanp
XFILLER_15_119 VPWR VGND sg13cmos5l_decap_8
XFILLER_11_314 VPWR VGND sg13cmos5l_decap_8
X_050_ _050_/Q FrameData[6] VGND VPWR FrameStrobe[2] latch
XFILLER_11_41 VPWR VGND sg13cmos5l_decap_8
XANTENNA__203__X N4BEG[14] VPWR VGND sg13cmos5l_antennanp
X_317_ _317_/X S2MID[5] S4END[10] SS4END[5] _155_/Q _068_/Q _069_/Q VPWR VGND sg13cmos5l_mux4_1
X_179_ N2BEG[6] _331_/X VPWR VGND sg13cmos5l_buf_1
X_248_ FrameData_O[26] FrameData[26] VPWR VGND sg13cmos5l_buf_1
XFILLER_6_340 VPWR VGND sg13cmos5l_fill_1
XFILLER_0_516 VPWR VGND sg13cmos5l_decap_8
XFILLER_11_144 VPWR VGND sg13cmos5l_fill_2
X_033_ _033_/Q FrameData[21] VGND VPWR FrameStrobe[3] latch
X_102_ _102_/Q FrameData[26] VGND VPWR FrameStrobe[1] latch
XFILLER_7_137 VPWR VGND sg13cmos5l_fill_2
XFILLER_3_354 VPWR VGND sg13cmos5l_decap_8
XFILLER_14_8 VPWR VGND sg13cmos5l_fill_1
XFILLER_0_0 VPWR VGND sg13cmos5l_decap_8
XFILLER_8_42 VPWR VGND sg13cmos5l_decap_8
XFILLER_15_483 VPWR VGND sg13cmos5l_decap_8
XFILLER_16_203 VPWR VGND sg13cmos5l_decap_8
XFILLER_8_457 VPWR VGND sg13cmos5l_decap_8
XFILLER_12_497 VPWR VGND sg13cmos5l_decap_8
XFILLER_3_140 VPWR VGND sg13cmos5l_decap_8
XFILLER_13_239 VPWR VGND sg13cmos5l_decap_4
XFILLER_5_427 VPWR VGND sg13cmos5l_decap_8
XFILLER_0_165 VPWR VGND sg13cmos5l_fill_2
XANTENNA__211__X NN4BEG[6] VPWR VGND sg13cmos5l_antennanp
XFILLER_8_287 VPWR VGND sg13cmos5l_fill_2
XFILLER_5_21 VPWR VGND sg13cmos5l_decap_8
XFILLER_4_482 VPWR VGND sg13cmos5l_decap_8
XFILLER_2_408 VPWR VGND sg13cmos5l_decap_8
XFILLER_14_537 VPWR VGND sg13cmos5l_fill_2
X_281_ N2BEG[3] S2MID[4] VPWR VGND sg13cmos5l_buf_1
XFILLER_5_246 VPWR VGND sg13cmos5l_decap_8
XFILLER_14_41 VPWR VGND sg13cmos5l_decap_4
XANTENNA__206__X NN4BEG[1] VPWR VGND sg13cmos5l_antennanp
XFILLER_5_279 VPWR VGND sg13cmos5l_decap_8
XFILLER_5_257 VPWR VGND sg13cmos5l_fill_1
XFILLER_4_7 VPWR VGND sg13cmos5l_decap_8
XFILLER_2_238 VPWR VGND sg13cmos5l_decap_8
X_333_ _333_/X S2MID[5] S2END[2] SS4END[13] _019_/X _036_/Q _037_/Q VPWR VGND sg13cmos5l_mux4_1
X_264_ FrameStrobe_O[10] FrameStrobe[10] VPWR VGND sg13cmos5l_buf_1
X_195_ N4BEG[6] _316_/X VPWR VGND sg13cmos5l_buf_1
XFILLER_6_511 VPWR VGND sg13cmos5l_decap_8
XFILLER_2_77 VPWR VGND sg13cmos5l_decap_8
XFILLER_1_271 VPWR VGND sg13cmos5l_decap_8
XANTENNA_16 FrameData[10] VPWR VGND sg13cmos5l_antennanp
XANTENNA_27 FrameData[1] VPWR VGND sg13cmos5l_antennanp
XANTENNA_38 FrameData[1] VPWR VGND sg13cmos5l_antennanp
XANTENNA_49 FrameData[24] VPWR VGND sg13cmos5l_antennanp
XFILLER_7_308 VPWR VGND sg13cmos5l_decap_8
XFILLER_3_525 VPWR VGND sg13cmos5l_fill_2
XFILLER_11_359 VPWR VGND sg13cmos5l_decap_8
XFILLER_11_20 VPWR VGND sg13cmos5l_decap_8
XFILLER_11_97 VPWR VGND sg13cmos5l_fill_1
XFILLER_14_131 VPWR VGND sg13cmos5l_decap_8
X_247_ FrameData_O[25] FrameData[25] VPWR VGND sg13cmos5l_buf_1
X_316_ _316_/X S2MID[6] S4END[9] SS4END[6] _156_/Q _070_/Q _071_/Q VPWR VGND sg13cmos5l_mux4_1
XFILLER_14_186 VPWR VGND sg13cmos5l_decap_8
X_178_ N2BEG[5] S2MID[2] VPWR VGND sg13cmos5l_buf_1
XFILLER_6_352 VPWR VGND sg13cmos5l_fill_2
XFILLER_10_381 VPWR VGND sg13cmos5l_fill_2
X_101_ _101_/Q FrameData[25] VGND VPWR FrameStrobe[1] latch
X_032_ _032_/Q FrameData[20] VGND VPWR FrameStrobe[3] latch
XANTENNA__214__X NN4BEG[9] VPWR VGND sg13cmos5l_antennanp
XFILLER_15_473 VPWR VGND sg13cmos5l_decap_4
XFILLER_15_451 VPWR VGND sg13cmos5l_decap_8
XFILLER_15_440 VPWR VGND sg13cmos5l_fill_2
XFILLER_8_21 VPWR VGND sg13cmos5l_decap_8
XFILLER_16_237 VPWR VGND sg13cmos5l_fill_1
XFILLER_16_226 VPWR VGND sg13cmos5l_decap_8
XANTENNA__209__X NN4BEG[4] VPWR VGND sg13cmos5l_antennanp
XFILLER_8_436 VPWR VGND sg13cmos5l_decap_8
XFILLER_12_476 VPWR VGND sg13cmos5l_decap_8
XFILLER_3_196 VPWR VGND sg13cmos5l_decap_8
XFILLER_0_111 VPWR VGND sg13cmos5l_fill_1
XFILLER_12_284 VPWR VGND sg13cmos5l_fill_1
XFILLER_5_88 VPWR VGND sg13cmos5l_decap_8
X_280_ N2BEG[2] _333_/X VPWR VGND sg13cmos5l_buf_1
XFILLER_14_549 VPWR VGND sg13cmos5l_fill_2
XFILLER_14_20 VPWR VGND sg13cmos5l_decap_8
XANTENNA__222__X FrameData_O[0] VPWR VGND sg13cmos5l_antennanp
XFILLER_9_520 VPWR VGND sg13cmos5l_decap_8
XFILLER_2_217 VPWR VGND sg13cmos5l_decap_8
X_332_ _332_/X S2MID[3] S2END[4] SS4END[14] _019_/X _038_/Q _039_/Q VPWR VGND sg13cmos5l_mux4_1
X_263_ FrameStrobe_O[9] FrameStrobe[9] VPWR VGND sg13cmos5l_buf_1
XFILLER_14_368 VPWR VGND sg13cmos5l_decap_4
XFILLER_14_346 VPWR VGND sg13cmos5l_fill_1
XANTENNA__217__X NN4BEG[12] VPWR VGND sg13cmos5l_antennanp
X_194_ N4BEG[5] _317_/X VPWR VGND sg13cmos5l_buf_1
XFILLER_6_534 VPWR VGND sg13cmos5l_fill_1
XFILLER_2_56 VPWR VGND sg13cmos5l_decap_8
XFILLER_1_250 VPWR VGND sg13cmos5l_decap_8
XANTENNA_17 FrameData[10] VPWR VGND sg13cmos5l_antennanp
XANTENNA_28 FrameData[1] VPWR VGND sg13cmos5l_antennanp
XANTENNA_39 FrameData[1] VPWR VGND sg13cmos5l_antennanp
XFILLER_3_504 VPWR VGND sg13cmos5l_decap_8
XFILLER_14_110 VPWR VGND sg13cmos5l_decap_8
X_177_ N2BEG[4] _332_/X VPWR VGND sg13cmos5l_buf_1
X_246_ FrameData_O[24] FrameData[24] VPWR VGND sg13cmos5l_buf_1
X_315_ _315_/X S2MID[7] S4END[8] SS4END[7] _157_/Q _072_/Q _073_/Q VPWR VGND sg13cmos5l_mux4_1
XFILLER_6_331 VPWR VGND sg13cmos5l_decap_8
XFILLER_14_198 VPWR VGND sg13cmos5l_decap_8
XFILLER_9_180 VPWR VGND sg13cmos5l_decap_8
X_031_ _031_/Q FrameData[19] VGND VPWR FrameStrobe[3] latch
X_100_ _100_/Q FrameData[24] VGND VPWR FrameStrobe[1] latch
XFILLER_7_139 VPWR VGND sg13cmos5l_fill_1
XFILLER_3_334 VPWR VGND sg13cmos5l_fill_2
XANTENNA__230__X FrameData_O[8] VPWR VGND sg13cmos5l_antennanp
X_229_ FrameData_O[7] FrameData[7] VPWR VGND sg13cmos5l_buf_1
XFILLER_8_99 VPWR VGND sg13cmos5l_fill_2
XFILLER_8_77 VPWR VGND sg13cmos5l_decap_8
XFILLER_6_194 VPWR VGND sg13cmos5l_decap_8
XFILLER_16_249 VPWR VGND sg13cmos5l_decap_8
XFILLER_16_216 VPWR VGND sg13cmos5l_fill_2
XFILLER_12_455 VPWR VGND sg13cmos5l_decap_8
XFILLER_8_415 VPWR VGND sg13cmos5l_decap_8
XANTENNA__225__X FrameData_O[3] VPWR VGND sg13cmos5l_antennanp
XFILLER_3_175 VPWR VGND sg13cmos5l_decap_8
XFILLER_12_7 VPWR VGND sg13cmos5l_decap_8
XFILLER_0_167 VPWR VGND sg13cmos5l_fill_1
XFILLER_0_145 VPWR VGND sg13cmos5l_decap_8
XFILLER_0_123 VPWR VGND sg13cmos5l_decap_4
XFILLER_12_263 VPWR VGND sg13cmos5l_decap_8
XFILLER_12_252 VPWR VGND sg13cmos5l_decap_4
XFILLER_8_267 VPWR VGND sg13cmos5l_decap_8
XFILLER_5_56 VPWR VGND sg13cmos5l_decap_8
XFILLER_5_226 VPWR VGND sg13cmos5l_fill_2
XFILLER_11_509 VPWR VGND sg13cmos5l_decap_8
Xclkbuf_2_0__f_UserCLK_regs _154_/CLK clkbuf_0_UserCLK_regs/X VPWR VGND sg13cmos5l_buf_8
X_331_ _331_/X S2MID[1] S2END[6] SS4END[15] _019_/X _040_/Q _041_/Q VPWR VGND sg13cmos5l_mux4_1
XFILLER_14_303 VPWR VGND sg13cmos5l_decap_8
X_193_ N4BEG[4] _318_/X VPWR VGND sg13cmos5l_buf_1
X_262_ FrameStrobe_O[8] FrameStrobe[8] VPWR VGND sg13cmos5l_buf_1
XFILLER_10_531 VPWR VGND sg13cmos5l_decap_8
XFILLER_6_546 VPWR VGND sg13cmos5l_fill_1
XANTENNA__233__X FrameData_O[11] VPWR VGND sg13cmos5l_antennanp
XFILLER_2_35 VPWR VGND sg13cmos5l_decap_8
XANTENNA_18 FrameData[10] VPWR VGND sg13cmos5l_antennanp
XANTENNA_29 FrameData[1] VPWR VGND sg13cmos5l_antennanp
XFILLER_9_362 VPWR VGND sg13cmos5l_decap_8
XFILLER_11_328 VPWR VGND sg13cmos5l_decap_8
XFILLER_3_527 VPWR VGND sg13cmos5l_fill_1
XFILLER_11_55 VPWR VGND sg13cmos5l_decap_8
X_314_ _314_/X S2MID[0] S4END[7] SS4END[8] _150_/Q _074_/Q _075_/Q VPWR VGND sg13cmos5l_mux4_1
XFILLER_14_177 VPWR VGND sg13cmos5l_decap_4
XFILLER_14_166 VPWR VGND sg13cmos5l_decap_8
XANTENNA__228__X FrameData_O[6] VPWR VGND sg13cmos5l_antennanp
X_176_ Co VPWR VGND sg13cmos5l_tielo
X_245_ FrameData_O[23] FrameData[23] VPWR VGND sg13cmos5l_buf_1
XFILLER_6_387 VPWR VGND sg13cmos5l_fill_1
X_030_ _030_/Q FrameData[18] VGND VPWR FrameStrobe[3] latch
XFILLER_7_107 VPWR VGND sg13cmos5l_fill_2
XFILLER_11_169 VPWR VGND sg13cmos5l_decap_8
XFILLER_3_313 VPWR VGND sg13cmos5l_decap_8
XFILLER_8_56 VPWR VGND sg13cmos5l_fill_2
XFILLER_15_497 VPWR VGND sg13cmos5l_decap_8
X_159_ _159_/L_HI VPWR VGND sg13cmos5l_tiehi
X_228_ FrameData_O[6] FrameData[6] VPWR VGND sg13cmos5l_buf_1
XFILLER_6_162 VPWR VGND sg13cmos5l_fill_1
XFILLER_0_349 VPWR VGND sg13cmos5l_decap_8
XFILLER_8_405 VPWR VGND sg13cmos5l_fill_2
XFILLER_12_434 VPWR VGND sg13cmos5l_decap_8
XFILLER_3_154 VPWR VGND sg13cmos5l_decap_8
XANTENNA__241__X FrameData_O[19] VPWR VGND sg13cmos5l_antennanp
XFILLER_7_460 VPWR VGND sg13cmos5l_fill_1
XFILLER_0_179 VPWR VGND sg13cmos5l_fill_2
XFILLER_0_102 VPWR VGND sg13cmos5l_decap_8
XFILLER_8_246 VPWR VGND sg13cmos5l_decap_8
XFILLER_12_231 VPWR VGND sg13cmos5l_decap_8
XANTENNA__236__X FrameData_O[14] VPWR VGND sg13cmos5l_antennanp
XFILLER_5_79 VPWR VGND sg13cmos5l_fill_2
XFILLER_5_35 VPWR VGND sg13cmos5l_decap_8
XFILLER_4_496 VPWR VGND sg13cmos5l_decap_8
XFILLER_4_441 VPWR VGND sg13cmos5l_fill_1
XFILLER_14_507 VPWR VGND sg13cmos5l_decap_8
XFILLER_14_55 VPWR VGND sg13cmos5l_decap_8
X_330_ _330_/X S1END[0] S2MID[0] S2END[7] _150_/Q _042_/Q _043_/Q VPWR VGND sg13cmos5l_mux4_1
X_192_ N4BEG[3] _319_/X VPWR VGND sg13cmos5l_buf_1
X_261_ FrameStrobe_O[7] FrameStrobe[7] VPWR VGND sg13cmos5l_buf_1
XFILLER_6_525 VPWR VGND sg13cmos5l_decap_8
XFILLER_10_510 VPWR VGND sg13cmos5l_decap_8
XFILLER_9_0 VPWR VGND sg13cmos5l_decap_8
XFILLER_2_14 VPWR VGND sg13cmos5l_decap_8
XANTENNA_19 FrameData[10] VPWR VGND sg13cmos5l_antennanp
XFILLER_9_341 VPWR VGND sg13cmos5l_decap_8
XFILLER_2_7 VPWR VGND sg13cmos5l_decap_8
XFILLER_11_34 VPWR VGND sg13cmos5l_decap_8
X_244_ FrameData_O[22] FrameData[22] VPWR VGND sg13cmos5l_buf_1
X_313_ _313_/X S2MID[1] S4END[6] SS4END[9] _151_/Q _076_/Q _077_/Q VPWR VGND sg13cmos5l_mux4_1
XFILLER_14_145 VPWR VGND sg13cmos5l_decap_8
X_175_ _175_/L_HI VPWR VGND sg13cmos5l_tiehi
XANTENNA__244__X FrameData_O[22] VPWR VGND sg13cmos5l_antennanp
XFILLER_0_509 VPWR VGND sg13cmos5l_decap_8
XFILLER_3_336 VPWR VGND sg13cmos5l_fill_1
XANTENNA__239__X FrameData_O[17] VPWR VGND sg13cmos5l_antennanp
X_227_ FrameData_O[5] FrameData[5] VPWR VGND sg13cmos5l_buf_1
XFILLER_8_35 VPWR VGND sg13cmos5l_decap_8
XFILLER_15_465 VPWR VGND sg13cmos5l_decap_4
XFILLER_10_170 VPWR VGND sg13cmos5l_fill_2
X_089_ _089_/Q FrameData[13] VGND VPWR FrameStrobe[1] latch
X_158_ _158_/L_HI VPWR VGND sg13cmos5l_tiehi
XFILLER_6_141 VPWR VGND sg13cmos5l_fill_2
XFILLER_2_380 VPWR VGND sg13cmos5l_decap_8
XFILLER_3_133 VPWR VGND sg13cmos5l_decap_8
XFILLER_15_295 VPWR VGND sg13cmos5l_decap_4
XFILLER_15_262 VPWR VGND sg13cmos5l_decap_4
XFILLER_15_251 VPWR VGND sg13cmos5l_decap_4
XFILLER_0_158 VPWR VGND sg13cmos5l_decap_8
XANTENNA__252__X FrameData_O[30] VPWR VGND sg13cmos5l_antennanp
XFILLER_5_14 VPWR VGND sg13cmos5l_decap_8
XFILLER_4_453 VPWR VGND sg13cmos5l_fill_2
XFILLER_14_34 VPWR VGND sg13cmos5l_decap_8
XFILLER_5_239 VPWR VGND sg13cmos5l_decap_8
XFILLER_9_534 VPWR VGND sg13cmos5l_fill_1
XANTENNA__247__X FrameData_O[25] VPWR VGND sg13cmos5l_antennanp
X_260_ FrameStrobe_O[6] FrameStrobe[6] VPWR VGND sg13cmos5l_buf_1
X_191_ N4BEG[2] _320_/X VPWR VGND sg13cmos5l_buf_1
XFILLER_6_504 VPWR VGND sg13cmos5l_decap_8
XFILLER_1_264 VPWR VGND sg13cmos5l_decap_8
XFILLER_9_320 VPWR VGND sg13cmos5l_decap_8
XFILLER_9_397 VPWR VGND sg13cmos5l_decap_8
XFILLER_3_518 VPWR VGND sg13cmos5l_decap_8
XFILLER_11_13 VPWR VGND sg13cmos5l_decap_8
XFILLER_11_79 VPWR VGND sg13cmos5l_decap_8
X_243_ FrameData_O[21] FrameData[21] VPWR VGND sg13cmos5l_buf_1
X_312_ _312_/X S2MID[2] S4END[5] SS4END[10] _152_/Q _078_/Q _079_/Q VPWR VGND sg13cmos5l_mux4_1
XFILLER_14_124 VPWR VGND sg13cmos5l_decap_8
XFILLER_10_352 VPWR VGND sg13cmos5l_fill_1
X_174_ _174_/L_HI VPWR VGND sg13cmos5l_tiehi
XANTENNA__260__X FrameStrobe_O[6] VPWR VGND sg13cmos5l_antennanp
XFILLER_3_91 VPWR VGND sg13cmos5l_decap_8
XFILLER_7_109 VPWR VGND sg13cmos5l_fill_1
XFILLER_15_477 VPWR VGND sg13cmos5l_fill_2
X_157_ _157_/Q _157_/CLK DEBUG_OUT7 _171_/L_HI VPWR VGND sg13cmos5l_dfrbpq_1
X_226_ FrameData_O[4] FrameData[4] VPWR VGND sg13cmos5l_buf_1
XFILLER_8_58 VPWR VGND sg13cmos5l_fill_1
XFILLER_8_14 VPWR VGND sg13cmos5l_decap_8
XFILLER_6_131 VPWR VGND sg13cmos5l_fill_2
XANTENNA__255__X FrameStrobe_O[1] VPWR VGND sg13cmos5l_antennanp
X_088_ _088_/Q FrameData[12] VGND VPWR FrameStrobe[1] latch
XFILLER_8_429 VPWR VGND sg13cmos5l_decap_8
XFILLER_8_407 VPWR VGND sg13cmos5l_fill_1
XFILLER_12_469 VPWR VGND sg13cmos5l_decap_8
XFILLER_12_425 VPWR VGND sg13cmos5l_fill_2
XFILLER_3_189 VPWR VGND sg13cmos5l_decap_8
XFILLER_3_112 VPWR VGND sg13cmos5l_decap_8
X_209_ NN4BEG[4] _302_/X VPWR VGND sg13cmos5l_buf_1
XFILLER_0_81 VPWR VGND sg13cmos5l_decap_4
XFILLER_4_432 VPWR VGND sg13cmos5l_decap_8
XFILLER_12_299 VPWR VGND sg13cmos5l_decap_8
XFILLER_12_277 VPWR VGND sg13cmos5l_decap_8
XFILLER_10_7 VPWR VGND sg13cmos5l_decap_8
XFILLER_14_13 VPWR VGND sg13cmos5l_decap_8
XFILLER_9_513 VPWR VGND sg13cmos5l_decap_8
XANTENNA__263__X FrameStrobe_O[9] VPWR VGND sg13cmos5l_antennanp
XFILLER_6_91 VPWR VGND sg13cmos5l_decap_4
X_190_ N4BEG[1] _321_/X VPWR VGND sg13cmos5l_buf_1
XFILLER_14_339 VPWR VGND sg13cmos5l_decap_8
XFILLER_2_49 VPWR VGND sg13cmos5l_decap_8
XFILLER_1_298 VPWR VGND sg13cmos5l_decap_8
XFILLER_1_243 VPWR VGND sg13cmos5l_decap_8
XANTENNA__258__X FrameStrobe_O[4] VPWR VGND sg13cmos5l_antennanp
XFILLER_13_394 VPWR VGND sg13cmos5l_decap_4
XFILLER_14_103 VPWR VGND sg13cmos5l_decap_8
X_173_ _173_/L_HI VPWR VGND sg13cmos5l_tiehi
X_242_ FrameData_O[20] FrameData[20] VPWR VGND sg13cmos5l_buf_1
X_311_ _311_/X S2MID[3] S4END[4] SS4END[11] _153_/Q _080_/Q _081_/Q VPWR VGND sg13cmos5l_mux4_1
XFILLER_2_541 VPWR VGND sg13cmos5l_fill_2
XFILLER_2_530 VPWR VGND sg13cmos5l_decap_8
XFILLER_9_173 VPWR VGND sg13cmos5l_fill_2
XFILLER_3_70 VPWR VGND sg13cmos5l_decap_8
XFILLER_3_327 VPWR VGND sg13cmos5l_decap_8
X_087_ _087_/Q FrameData[11] VGND VPWR FrameStrobe[1] latch
X_156_ _156_/Q _156_/CLK DEBUG_OUT6 _170_/L_HI VPWR VGND sg13cmos5l_dfrbpq_1
X_225_ FrameData_O[3] FrameData[3] VPWR VGND sg13cmos5l_buf_1
XFILLER_10_172 VPWR VGND sg13cmos5l_fill_1
XANTENNA__271__X FrameStrobe_O[17] VPWR VGND sg13cmos5l_antennanp
XANTENNA__181__X N2BEGb[0] VPWR VGND sg13cmos5l_antennanp
XFILLER_12_448 VPWR VGND sg13cmos5l_decap_8
XFILLER_3_168 VPWR VGND sg13cmos5l_decap_8
XANTENNA__266__X FrameStrobe_O[12] VPWR VGND sg13cmos5l_antennanp
X_139_ _139_/Q FrameData[31] VGND VPWR FrameStrobe[0] latch
X_208_ NN4BEG[3] _303_/X VPWR VGND sg13cmos5l_buf_1
XFILLER_11_481 VPWR VGND sg13cmos5l_decap_8
XFILLER_0_138 VPWR VGND sg13cmos5l_fill_2
XFILLER_0_116 VPWR VGND sg13cmos5l_decap_8
XFILLER_12_245 VPWR VGND sg13cmos5l_decap_8
XFILLER_8_238 VPWR VGND sg13cmos5l_fill_1
XFILLER_5_49 VPWR VGND sg13cmos5l_decap_8
XFILLER_4_411 VPWR VGND sg13cmos5l_decap_8
XFILLER_14_69 VPWR VGND sg13cmos5l_decap_8
XFILLER_1_458 VPWR VGND sg13cmos5l_decap_4
XFILLER_4_263 VPWR VGND sg13cmos5l_fill_1
XFILLER_4_252 VPWR VGND sg13cmos5l_fill_2
XFILLER_16_392 VPWR VGND sg13cmos5l_fill_1
XFILLER_10_524 VPWR VGND sg13cmos5l_decap_8
XFILLER_2_28 VPWR VGND sg13cmos5l_decap_8
XFILLER_13_351 VPWR VGND sg13cmos5l_decap_4
XANTENNA__274__X N1BEG[0] VPWR VGND sg13cmos5l_antennanp
XFILLER_9_355 VPWR VGND sg13cmos5l_decap_8
XFILLER_9_388 VPWR VGND sg13cmos5l_fill_2
XFILLER_13_384 VPWR VGND sg13cmos5l_fill_2
XANTENNA__184__X N2BEGb[3] VPWR VGND sg13cmos5l_antennanp
XFILLER_11_48 VPWR VGND sg13cmos5l_decap_8
X_310_ _310_/X S2MID[4] S4END[3] SS4END[12] _154_/Q _082_/Q _083_/Q VPWR VGND sg13cmos5l_mux4_1
XFILLER_14_159 VPWR VGND sg13cmos5l_decap_8
X_172_ _172_/L_HI VPWR VGND sg13cmos5l_tiehi
X_241_ FrameData_O[19] FrameData[19] VPWR VGND sg13cmos5l_buf_1
XFILLER_7_0 VPWR VGND sg13cmos5l_decap_8
XANTENNA__269__X FrameStrobe_O[15] VPWR VGND sg13cmos5l_antennanp
XANTENNA__179__X N2BEG[6] VPWR VGND sg13cmos5l_antennanp
XFILLER_3_306 VPWR VGND sg13cmos5l_decap_8
XFILLER_0_7 VPWR VGND sg13cmos5l_decap_8
X_224_ FrameData_O[2] FrameData[2] VPWR VGND sg13cmos5l_buf_1
XFILLER_8_49 VPWR VGND sg13cmos5l_decap_8
XFILLER_15_446 VPWR VGND sg13cmos5l_fill_2
X_086_ _086_/Q FrameData[10] VGND VPWR FrameStrobe[1] latch
X_155_ _155_/Q _157_/CLK DEBUG_OUT5 _169_/L_HI VPWR VGND sg13cmos5l_dfrbpq_1
XFILLER_6_133 VPWR VGND sg13cmos5l_fill_1
XFILLER_2_394 VPWR VGND sg13cmos5l_decap_4
XFILLER_2_350 VPWR VGND sg13cmos5l_decap_8
XFILLER_3_147 VPWR VGND sg13cmos5l_decap_8
X_207_ NN4BEG[2] _304_/X VPWR VGND sg13cmos5l_buf_1
X_069_ _069_/Q FrameData[25] VGND VPWR FrameStrobe[2] latch
X_138_ _138_/Q FrameData[30] VGND VPWR FrameStrobe[0] latch
XANTENNA__192__X N4BEG[3] VPWR VGND sg13cmos5l_antennanp
XANTENNA__141__Q DEBUG_IN0 VPWR VGND sg13cmos5l_antennanp
XFILLER_8_206 VPWR VGND sg13cmos5l_fill_2
XFILLER_12_224 VPWR VGND sg13cmos5l_decap_8
XFILLER_5_28 VPWR VGND sg13cmos5l_decap_8
XFILLER_4_489 VPWR VGND sg13cmos5l_decap_8
XFILLER_16_530 VPWR VGND sg13cmos5l_decap_8
XANTENNA__277__X N1BEG[3] VPWR VGND sg13cmos5l_antennanp
XFILLER_7_294 VPWR VGND sg13cmos5l_decap_8
XANTENNA__187__X N2BEGb[6] VPWR VGND sg13cmos5l_antennanp
XFILLER_6_518 VPWR VGND sg13cmos5l_decap_8
XFILLER_10_503 VPWR VGND sg13cmos5l_decap_8
XFILLER_1_234 VPWR VGND sg13cmos5l_decap_4
XFILLER_1_278 VPWR VGND sg13cmos5l_decap_8
XFILLER_9_334 VPWR VGND sg13cmos5l_fill_2
XFILLER_13_330 VPWR VGND sg13cmos5l_decap_8
XFILLER_11_27 VPWR VGND sg13cmos5l_decap_8
X_240_ FrameData_O[18] FrameData[18] VPWR VGND sg13cmos5l_buf_1
XFILLER_14_138 VPWR VGND sg13cmos5l_decap_8
X_171_ _171_/L_HI VPWR VGND sg13cmos5l_tiehi
XFILLER_6_348 VPWR VGND sg13cmos5l_decap_4
XFILLER_9_175 VPWR VGND sg13cmos5l_fill_1
XFILLER_13_160 VPWR VGND sg13cmos5l_fill_2
XFILLER_9_197 VPWR VGND sg13cmos5l_decap_8
XANTENNA__195__X N4BEG[6] VPWR VGND sg13cmos5l_antennanp
XANTENNA__144__Q DEBUG_IN3 VPWR VGND sg13cmos5l_antennanp
X_223_ FrameData_O[1] FrameData[1] VPWR VGND sg13cmos5l_buf_1
XFILLER_8_28 VPWR VGND sg13cmos5l_decap_8
XFILLER_15_469 VPWR VGND sg13cmos5l_fill_1
XFILLER_15_458 VPWR VGND sg13cmos5l_decap_8
X_085_ _085_/Q FrameData[9] VGND VPWR FrameStrobe[1] latch
X_154_ _154_/Q _154_/CLK DEBUG_OUT4 _168_/L_HI VPWR VGND sg13cmos5l_dfrbpq_1
XFILLER_10_163 VPWR VGND sg13cmos5l_decap_8
XFILLER_2_373 VPWR VGND sg13cmos5l_decap_8
XFILLER_2_362 VPWR VGND sg13cmos5l_fill_2
XFILLER_3_126 VPWR VGND sg13cmos5l_decap_8
XFILLER_15_266 VPWR VGND sg13cmos5l_fill_1
X_137_ _137_/Q FrameData[29] VGND VPWR FrameStrobe[0] latch
X_206_ NN4BEG[1] _305_/X VPWR VGND sg13cmos5l_buf_1
XFILLER_7_432 VPWR VGND sg13cmos5l_fill_1
XFILLER_15_299 VPWR VGND sg13cmos5l_fill_1
XFILLER_15_288 VPWR VGND sg13cmos5l_decap_8
X_068_ _068_/Q FrameData[24] VGND VPWR FrameStrobe[2] latch
XFILLER_7_498 VPWR VGND sg13cmos5l_decap_8
XFILLER_9_60 VPWR VGND sg13cmos5l_fill_1
XFILLER_9_93 VPWR VGND sg13cmos5l_decap_4
XFILLER_12_214 VPWR VGND sg13cmos5l_fill_2
XFILLER_4_446 VPWR VGND sg13cmos5l_decap_8
XFILLER_11_291 VPWR VGND sg13cmos5l_decap_8
XFILLER_3_490 VPWR VGND sg13cmos5l_decap_8
XFILLER_15_0 VPWR VGND sg13cmos5l_decap_8
XFILLER_14_49 VPWR VGND sg13cmos5l_fill_2
XFILLER_14_27 VPWR VGND sg13cmos5l_decap_8
XFILLER_13_523 VPWR VGND sg13cmos5l_decap_4
XFILLER_9_527 VPWR VGND sg13cmos5l_decap_8
XFILLER_4_254 VPWR VGND sg13cmos5l_fill_1
XFILLER_0_471 VPWR VGND sg13cmos5l_decap_4
XANTENNA__198__X N4BEG[9] VPWR VGND sg13cmos5l_antennanp
XANTENNA__147__Q DEBUG_IN6 VPWR VGND sg13cmos5l_antennanp
XFILLER_1_257 VPWR VGND sg13cmos5l_decap_8
XFILLER_15_92 VPWR VGND sg13cmos5l_decap_8
XFILLER_13_386 VPWR VGND sg13cmos5l_fill_1
X_170_ _170_/L_HI VPWR VGND sg13cmos5l_tiehi
XFILLER_14_117 VPWR VGND sg13cmos5l_decap_8
XFILLER_6_338 VPWR VGND sg13cmos5l_fill_2
X_299_ _299_/X S2END[7] S4END[7] SS4END[8] _150_/Q _104_/Q _105_/Q VPWR VGND sg13cmos5l_mux4_1
XFILLER_9_187 VPWR VGND sg13cmos5l_fill_2
XFILLER_3_84 VPWR VGND sg13cmos5l_decap_8
X_153_ _153_/Q _154_/CLK DEBUG_OUT3 _167_/L_HI VPWR VGND sg13cmos5l_dfrbpq_1
X_222_ FrameData_O[0] FrameData[0] VPWR VGND sg13cmos5l_buf_1
XFILLER_6_124 VPWR VGND sg13cmos5l_decap_8
XFILLER_10_142 VPWR VGND sg13cmos5l_decap_8
XFILLER_10_120 VPWR VGND sg13cmos5l_fill_1
X_084_ _084_/Q FrameData[8] VGND VPWR FrameStrobe[1] latch
XFILLER_12_71 VPWR VGND sg13cmos5l_fill_2
XFILLER_12_418 VPWR VGND sg13cmos5l_decap_8
XFILLER_3_105 VPWR VGND sg13cmos5l_decap_8
X_136_ _136_/Q FrameData[28] VGND VPWR FrameStrobe[0] latch
X_205_ NN4BEG[0] _306_/X VPWR VGND sg13cmos5l_buf_1
XFILLER_11_495 VPWR VGND sg13cmos5l_decap_8
XFILLER_11_462 VPWR VGND sg13cmos5l_fill_1
X_067_ _067_/Q FrameData[23] VGND VPWR FrameStrobe[2] latch
XFILLER_2_182 VPWR VGND sg13cmos5l_decap_8
XFILLER_0_96 VPWR VGND sg13cmos5l_fill_2
XFILLER_0_74 VPWR VGND sg13cmos5l_decap_8
XFILLER_0_63 VPWR VGND sg13cmos5l_decap_8
XFILLER_8_208 VPWR VGND sg13cmos5l_fill_1
XFILLER_4_425 VPWR VGND sg13cmos5l_decap_8
X_119_ _119_/Q FrameData[11] VGND VPWR FrameStrobe[0] latch
XFILLER_7_252 VPWR VGND sg13cmos5l_fill_1
XFILLER_11_270 VPWR VGND sg13cmos5l_decap_8
Xclkbuf_2_1__f_UserCLK_regs _157_/CLK clkbuf_0_UserCLK_regs/X VPWR VGND sg13cmos5l_buf_8
XFILLER_9_506 VPWR VGND sg13cmos5l_decap_8
XFILLER_13_502 VPWR VGND sg13cmos5l_decap_8
XFILLER_4_200 VPWR VGND sg13cmos5l_fill_1
XFILLER_4_299 VPWR VGND sg13cmos5l_decap_4
XFILLER_6_95 VPWR VGND sg13cmos5l_fill_2
XFILLER_10_549 VPWR VGND sg13cmos5l_fill_2
XFILLER_10_538 VPWR VGND sg13cmos5l_fill_1
XFILLER_9_336 VPWR VGND sg13cmos5l_fill_1
XFILLER_9_369 VPWR VGND sg13cmos5l_decap_4
XFILLER_15_60 VPWR VGND sg13cmos5l_decap_8
XFILLER_13_398 VPWR VGND sg13cmos5l_fill_2
XFILLER_5_531 VPWR VGND sg13cmos5l_decap_4
XFILLER_0_291 VPWR VGND sg13cmos5l_decap_8
XFILLER_2_523 VPWR VGND sg13cmos5l_decap_8
X_298_ _298_/X S2END[0] S4END[8] SS4END[7] _157_/Q _106_/Q _107_/Q VPWR VGND sg13cmos5l_mux4_1
XFILLER_9_166 VPWR VGND sg13cmos5l_decap_8
XFILLER_9_144 VPWR VGND sg13cmos5l_fill_1
XFILLER_9_133 VPWR VGND sg13cmos5l_decap_4
XFILLER_13_162 VPWR VGND sg13cmos5l_fill_1
XFILLER_3_63 VPWR VGND sg13cmos5l_decap_8
XFILLER_15_405 VPWR VGND sg13cmos5l_fill_2
X_083_ _083_/Q FrameData[7] VGND VPWR FrameStrobe[1] latch
X_152_ _152_/Q _154_/CLK DEBUG_OUT2 _166_/L_HI VPWR VGND sg13cmos5l_dfrbpq_1
X_221_ UserCLKo _221_/A VPWR VGND sg13cmos5l_buf_1
XFILLER_12_50 VPWR VGND sg13cmos5l_decap_8
XFILLER_5_0 VPWR VGND sg13cmos5l_decap_8
XFILLER_12_94 VPWR VGND sg13cmos5l_decap_8
XFILLER_14_493 VPWR VGND sg13cmos5l_decap_8
X_204_ N4BEG[15] _307_/X VPWR VGND sg13cmos5l_buf_1
XFILLER_11_441 VPWR VGND sg13cmos5l_decap_8
X_066_ _066_/Q FrameData[22] VGND VPWR FrameStrobe[2] latch
X_135_ _135_/Q FrameData[27] VGND VPWR FrameStrobe[0] latch
XFILLER_11_474 VPWR VGND sg13cmos5l_decap_8
XFILLER_2_161 VPWR VGND sg13cmos5l_decap_8
XFILLER_0_42 VPWR VGND sg13cmos5l_decap_8
XFILLER_0_109 VPWR VGND sg13cmos5l_fill_2
XFILLER_12_238 VPWR VGND sg13cmos5l_decap_8
XFILLER_12_216 VPWR VGND sg13cmos5l_fill_1
XFILLER_4_404 VPWR VGND sg13cmos5l_decap_8
XFILLER_16_544 VPWR VGND sg13cmos5l_decap_8
X_049_ _049_/Q FrameData[5] VGND VPWR FrameStrobe[2] latch
X_118_ _118_/Q FrameData[10] VGND VPWR FrameStrobe[0] latch
XFILLER_4_245 VPWR VGND sg13cmos5l_decap_8
XFILLER_16_385 VPWR VGND sg13cmos5l_decap_8
XANTENNA_1 FrameData[10] VPWR VGND sg13cmos5l_antennanp
XFILLER_6_63 VPWR VGND sg13cmos5l_decap_8
XFILLER_10_517 VPWR VGND sg13cmos5l_decap_8
XFILLER_9_7 VPWR VGND sg13cmos5l_decap_8
XFILLER_9_348 VPWR VGND sg13cmos5l_decap_8
XFILLER_5_510 VPWR VGND sg13cmos5l_decap_8
XFILLER_0_270 VPWR VGND sg13cmos5l_decap_8
XFILLER_2_502 VPWR VGND sg13cmos5l_decap_8
XFILLER_13_174 VPWR VGND sg13cmos5l_fill_1
X_297_ _297_/X S2END[1] S4END[9] SS4END[6] _156_/Q _108_/Q _109_/Q VPWR VGND sg13cmos5l_mux4_1
XFILLER_9_189 VPWR VGND sg13cmos5l_fill_1
XFILLER_5_373 VPWR VGND sg13cmos5l_fill_1
XFILLER_5_362 VPWR VGND sg13cmos5l_decap_8
XFILLER_3_42 VPWR VGND sg13cmos5l_decap_8
X_220_ NN4BEG[15] _291_/X VPWR VGND sg13cmos5l_buf_1
X_082_ _082_/Q FrameData[6] VGND VPWR FrameStrobe[1] latch
X_151_ _151_/Q _154_/CLK DEBUG_OUT1 _165_/L_HI VPWR VGND sg13cmos5l_dfrbpq_1
XFILLER_2_387 VPWR VGND sg13cmos5l_decap_8
XFILLER_2_343 VPWR VGND sg13cmos5l_decap_8
XFILLER_14_472 VPWR VGND sg13cmos5l_decap_8
XFILLER_5_170 VPWR VGND sg13cmos5l_fill_2
X_203_ N4BEG[14] _308_/X VPWR VGND sg13cmos5l_buf_1
XFILLER_11_420 VPWR VGND sg13cmos5l_decap_8
X_065_ _065_/Q FrameData[21] VGND VPWR FrameStrobe[2] latch
X_134_ _134_/Q FrameData[26] VGND VPWR FrameStrobe[0] latch
XFILLER_2_140 VPWR VGND sg13cmos5l_decap_8
XFILLER_0_21 VPWR VGND sg13cmos5l_decap_8
Xclkbuf_0_UserCLK clkbuf_0_UserCLK/X UserCLK VPWR VGND sg13cmos5l_buf_8
XFILLER_6_490 VPWR VGND sg13cmos5l_decap_8
XANTENNA__201__X N4BEG[12] VPWR VGND sg13cmos5l_antennanp
XFILLER_16_523 VPWR VGND sg13cmos5l_decap_8
X_117_ _117_/Q FrameData[9] VGND VPWR FrameStrobe[0] latch
X_048_ _048_/Q FrameData[4] VGND VPWR FrameStrobe[2] latch
XFILLER_7_287 VPWR VGND sg13cmos5l_decap_8
XANTENNA__021__X USR_IRQ VPWR VGND sg13cmos5l_antennanp
XFILLER_16_342 VPWR VGND sg13cmos5l_decap_8
XANTENNA_2 FrameData[10] VPWR VGND sg13cmos5l_antennanp
XFILLER_6_42 VPWR VGND sg13cmos5l_decap_8
XFILLER_13_0 VPWR VGND sg13cmos5l_decap_8
XFILLER_1_238 VPWR VGND sg13cmos5l_fill_1
XFILLER_1_227 VPWR VGND sg13cmos5l_decap_8
XFILLER_1_216 VPWR VGND sg13cmos5l_decap_8
XFILLER_13_323 VPWR VGND sg13cmos5l_decap_8
XFILLER_9_327 VPWR VGND sg13cmos5l_decap_8
XFILLER_8_371 VPWR VGND sg13cmos5l_decap_4
X_296_ _296_/X S2END[2] S4END[10] SS4END[5] _155_/Q _110_/Q _111_/Q VPWR VGND sg13cmos5l_mux4_1
XFILLER_13_153 VPWR VGND sg13cmos5l_decap_8
XFILLER_3_98 VPWR VGND sg13cmos5l_decap_8
XFILLER_3_21 VPWR VGND sg13cmos5l_decap_8
XFILLER_15_407 VPWR VGND sg13cmos5l_fill_1
X_150_ _150_/Q _154_/CLK DEBUG_OUT0 _164_/L_HI VPWR VGND sg13cmos5l_dfrbpq_1
X_081_ _081_/Q FrameData[5] VGND VPWR FrameStrobe[1] latch
XFILLER_2_322 VPWR VGND sg13cmos5l_decap_8
XFILLER_12_30 VPWR VGND sg13cmos5l_fill_2
XFILLER_10_156 VPWR VGND sg13cmos5l_decap_8
XANTENNA__204__X N4BEG[15] VPWR VGND sg13cmos5l_antennanp
X_279_ N2BEG[1] S2MID[6] VPWR VGND sg13cmos5l_buf_1
XFILLER_14_451 VPWR VGND sg13cmos5l_decap_8
XFILLER_3_119 VPWR VGND sg13cmos5l_decap_8
X_133_ _133_/Q FrameData[25] VGND VPWR FrameStrobe[0] latch
X_202_ N4BEG[13] _309_/X VPWR VGND sg13cmos5l_buf_1
XFILLER_7_458 VPWR VGND sg13cmos5l_fill_2
XFILLER_7_425 VPWR VGND sg13cmos5l_decap_8
X_064_ _064_/Q FrameData[20] VGND VPWR FrameStrobe[2] latch
XFILLER_2_196 VPWR VGND sg13cmos5l_decap_8
XFILLER_9_42 VPWR VGND sg13cmos5l_decap_8
XFILLER_9_97 VPWR VGND sg13cmos5l_fill_2
XFILLER_12_207 VPWR VGND sg13cmos5l_decap_8
XFILLER_4_439 VPWR VGND sg13cmos5l_fill_2
XFILLER_16_502 VPWR VGND sg13cmos5l_decap_8
X_116_ _116_/Q FrameData[8] VGND VPWR FrameStrobe[0] latch
XFILLER_11_284 VPWR VGND sg13cmos5l_decap_8
X_047_ _047_/Q FrameData[3] VGND VPWR FrameStrobe[2] latch
XFILLER_3_483 VPWR VGND sg13cmos5l_decap_8
XFILLER_13_527 VPWR VGND sg13cmos5l_fill_2
XFILLER_13_516 VPWR VGND sg13cmos5l_decap_8
XANTENNA__212__X NN4BEG[7] VPWR VGND sg13cmos5l_antennanp
XFILLER_0_475 VPWR VGND sg13cmos5l_fill_1
XFILLER_8_531 VPWR VGND sg13cmos5l_fill_1
XFILLER_8_520 VPWR VGND sg13cmos5l_decap_8
XANTENNA_3 FrameData[10] VPWR VGND sg13cmos5l_antennanp
XFILLER_6_21 VPWR VGND sg13cmos5l_decap_8
XFILLER_15_52 VPWR VGND sg13cmos5l_fill_1
XANTENNA__207__X NN4BEG[2] VPWR VGND sg13cmos5l_antennanp
XFILLER_16_162 VPWR VGND sg13cmos5l_fill_1
XFILLER_10_305 VPWR VGND sg13cmos5l_decap_8
XFILLER_2_537 VPWR VGND sg13cmos5l_decap_4
X_295_ _295_/X S2END[3] S4END[11] SS4END[4] _154_/Q _112_/Q _113_/Q VPWR VGND sg13cmos5l_mux4_1
XFILLER_13_132 VPWR VGND sg13cmos5l_decap_8
XFILLER_5_331 VPWR VGND sg13cmos5l_fill_2
XFILLER_3_77 VPWR VGND sg13cmos5l_decap_8
X_080_ _080_/Q FrameData[4] VGND VPWR FrameStrobe[1] latch
XFILLER_10_135 VPWR VGND sg13cmos5l_decap_8
XFILLER_10_102 VPWR VGND sg13cmos5l_decap_8
XFILLER_2_301 VPWR VGND sg13cmos5l_decap_8
XFILLER_12_64 VPWR VGND sg13cmos5l_decap_8
XFILLER_2_367 VPWR VGND sg13cmos5l_fill_2
XANTENNA__220__X NN4BEG[15] VPWR VGND sg13cmos5l_antennanp
XFILLER_14_430 VPWR VGND sg13cmos5l_decap_8
X_278_ N2BEG[0] _334_/X VPWR VGND sg13cmos5l_buf_1
X_063_ _063_/Q FrameData[19] VGND VPWR FrameStrobe[2] latch
X_132_ _132_/Q FrameData[24] VGND VPWR FrameStrobe[0] latch
X_201_ N4BEG[12] _310_/X VPWR VGND sg13cmos5l_buf_1
XFILLER_11_488 VPWR VGND sg13cmos5l_decap_8
XFILLER_11_455 VPWR VGND sg13cmos5l_decap_8
XANTENNA__215__X NN4BEG[10] VPWR VGND sg13cmos5l_antennanp
XFILLER_3_0 VPWR VGND sg13cmos5l_decap_8
XFILLER_2_175 VPWR VGND sg13cmos5l_decap_8
XFILLER_0_56 VPWR VGND sg13cmos5l_decap_8
XFILLER_9_21 VPWR VGND sg13cmos5l_decap_8
XFILLER_0_89 VPWR VGND sg13cmos5l_decap_8
XFILLER_4_418 VPWR VGND sg13cmos5l_decap_8
X_046_ _046_/Q FrameData[2] VGND VPWR FrameStrobe[2] latch
X_115_ _115_/Q FrameData[7] VGND VPWR FrameStrobe[0] latch
XFILLER_7_245 VPWR VGND sg13cmos5l_decap_8
XFILLER_11_263 VPWR VGND sg13cmos5l_decap_8
XFILLER_3_462 VPWR VGND sg13cmos5l_fill_1
XFILLER_3_451 VPWR VGND sg13cmos5l_decap_8
XFILLER_4_215 VPWR VGND sg13cmos5l_fill_2
XFILLER_4_259 VPWR VGND sg13cmos5l_decap_4
XFILLER_16_311 VPWR VGND sg13cmos5l_fill_2
XANTENNA_4 FrameData[10] VPWR VGND sg13cmos5l_antennanp
X_029_ _029_/Q FrameData[17] VGND VPWR FrameStrobe[3] latch
XFILLER_3_292 VPWR VGND sg13cmos5l_decap_8
XFILLER_5_535 VPWR VGND sg13cmos5l_fill_2
XFILLER_5_524 VPWR VGND sg13cmos5l_decap_8
XANTENNA__223__X FrameData_O[1] VPWR VGND sg13cmos5l_antennanp
XFILLER_0_284 VPWR VGND sg13cmos5l_decap_8
XFILLER_16_185 VPWR VGND sg13cmos5l_decap_4
XFILLER_16_152 VPWR VGND sg13cmos5l_fill_1
.ends
