* NGSPICE file created from EXT_PMOD.ext - technology: ihp-sg13cmos5l

* Black-box entry subcircuit for sg13cmos5l_decap_8 abstract view
.subckt sg13cmos5l_decap_8 VDD VSS
.ends

* Black-box entry subcircuit for sg13cmos5l_decap_4 abstract view
.subckt sg13cmos5l_decap_4 VDD VSS
.ends

* Black-box entry subcircuit for sg13cmos5l_antennanp abstract view
.subckt sg13cmos5l_antennanp A VDD VSS
.ends

* Black-box entry subcircuit for sg13cmos5l_buf_1 abstract view
.subckt sg13cmos5l_buf_1 X A VDD VSS
.ends

* Black-box entry subcircuit for sg13cmos5l_fill_2 abstract view
.subckt sg13cmos5l_fill_2 VDD VSS
.ends

* Black-box entry subcircuit for latch abstract view
.subckt latch Q D VSS VDD GATE
.ends

* Black-box entry subcircuit for sg13cmos5l_tiehi abstract view
.subckt sg13cmos5l_tiehi L_HI VDD VSS
.ends

* Black-box entry subcircuit for sg13cmos5l_fill_1 abstract view
.subckt sg13cmos5l_fill_1 VDD VSS
.ends

* Black-box entry subcircuit for sg13cmos5l_mux2_1 abstract view
.subckt sg13cmos5l_mux2_1 X A0 A1 S VDD VSS
.ends

* Black-box entry subcircuit for sg13cmos5l_nor2b_1 abstract view
.subckt sg13cmos5l_nor2b_1 Y A B_N VDD VSS
.ends

* Black-box entry subcircuit for sg13cmos5l_mux4_1 abstract view
.subckt sg13cmos5l_mux4_1 X A0 A1 A2 A3 S0 S1 VDD VSS
.ends

* Black-box entry subcircuit for sg13cmos5l_inv_1 abstract view
.subckt sg13cmos5l_inv_1 Y A VDD VSS
.ends

* Black-box entry subcircuit for sg13cmos5l_dfrbpq_1 abstract view
.subckt sg13cmos5l_dfrbpq_1 Q CLK D RESET_B VDD VSS
.ends

* Black-box entry subcircuit for sg13cmos5l_o21ai_1 abstract view
.subckt sg13cmos5l_o21ai_1 Y A1 A2 B1 VDD VSS
.ends

* Black-box entry subcircuit for sg13cmos5l_or2_1 abstract view
.subckt sg13cmos5l_or2_1 X A B VDD VSS
.ends

* Black-box entry subcircuit for sg13cmos5l_a21oi_1 abstract view
.subckt sg13cmos5l_a21oi_1 Y A1 A2 B1 VDD VSS
.ends

* Black-box entry subcircuit for sg13cmos5l_a221oi_1 abstract view
.subckt sg13cmos5l_a221oi_1 Y A1 A2 B1 B2 C1 VDD VSS
.ends

* Black-box entry subcircuit for sg13cmos5l_nor2_1 abstract view
.subckt sg13cmos5l_nor2_1 Y A B VDD VSS
.ends

.subckt EXT_PMOD PMOD_IO_I0 PMOD_IO_I1 PMOD_IO_I2 PMOD_IO_I3 PMOD_IO_I4 PMOD_IO_I5
+ PMOD_IO_I6 PMOD_IO_I7 PMOD_IO_O0 PMOD_IO_O1 PMOD_IO_O2 PMOD_IO_O3 PMOD_IO_O4 PMOD_IO_O5
+ PMOD_IO_O6 PMOD_IO_O7 PMOD_IO_OE_O0 PMOD_IO_OE_O1 PMOD_IO_OE_O2 PMOD_IO_OE_O3 PMOD_IO_OE_O4
+ PMOD_IO_OE_O5 PMOD_IO_OE_O6 PMOD_IO_OE_O7 Tile_X0Y0_Ci Tile_X0Y0_FrameData[0] Tile_X0Y0_FrameData[10]
+ Tile_X0Y0_FrameData[11] Tile_X0Y0_FrameData[12] Tile_X0Y0_FrameData[13] Tile_X0Y0_FrameData[14]
+ Tile_X0Y0_FrameData[15] Tile_X0Y0_FrameData[16] Tile_X0Y0_FrameData[17] Tile_X0Y0_FrameData[18]
+ Tile_X0Y0_FrameData[19] Tile_X0Y0_FrameData[1] Tile_X0Y0_FrameData[20] Tile_X0Y0_FrameData[21]
+ Tile_X0Y0_FrameData[22] Tile_X0Y0_FrameData[23] Tile_X0Y0_FrameData[24] Tile_X0Y0_FrameData[25]
+ Tile_X0Y0_FrameData[26] Tile_X0Y0_FrameData[27] Tile_X0Y0_FrameData[28] Tile_X0Y0_FrameData[29]
+ Tile_X0Y0_FrameData[2] Tile_X0Y0_FrameData[30] Tile_X0Y0_FrameData[31] Tile_X0Y0_FrameData[3]
+ Tile_X0Y0_FrameData[4] Tile_X0Y0_FrameData[5] Tile_X0Y0_FrameData[6] Tile_X0Y0_FrameData[7]
+ Tile_X0Y0_FrameData[8] Tile_X0Y0_FrameData[9] Tile_X0Y0_FrameStrobe[0] Tile_X0Y0_FrameStrobe[10]
+ Tile_X0Y0_FrameStrobe[11] Tile_X0Y0_FrameStrobe[12] Tile_X0Y0_FrameStrobe[13] Tile_X0Y0_FrameStrobe[14]
+ Tile_X0Y0_FrameStrobe[15] Tile_X0Y0_FrameStrobe[16] Tile_X0Y0_FrameStrobe[17] Tile_X0Y0_FrameStrobe[18]
+ Tile_X0Y0_FrameStrobe[19] Tile_X0Y0_FrameStrobe[1] Tile_X0Y0_FrameStrobe[2] Tile_X0Y0_FrameStrobe[3]
+ Tile_X0Y0_FrameStrobe[4] Tile_X0Y0_FrameStrobe[5] Tile_X0Y0_FrameStrobe[6] Tile_X0Y0_FrameStrobe[7]
+ Tile_X0Y0_FrameStrobe[8] Tile_X0Y0_FrameStrobe[9] Tile_X0Y0_FrameStrobe_O[0] Tile_X0Y0_FrameStrobe_O[10]
+ Tile_X0Y0_FrameStrobe_O[11] Tile_X0Y0_FrameStrobe_O[12] Tile_X0Y0_FrameStrobe_O[13]
+ Tile_X0Y0_FrameStrobe_O[14] Tile_X0Y0_FrameStrobe_O[15] Tile_X0Y0_FrameStrobe_O[16]
+ Tile_X0Y0_FrameStrobe_O[17] Tile_X0Y0_FrameStrobe_O[18] Tile_X0Y0_FrameStrobe_O[19]
+ Tile_X0Y0_FrameStrobe_O[1] Tile_X0Y0_FrameStrobe_O[2] Tile_X0Y0_FrameStrobe_O[3]
+ Tile_X0Y0_FrameStrobe_O[4] Tile_X0Y0_FrameStrobe_O[5] Tile_X0Y0_FrameStrobe_O[6]
+ Tile_X0Y0_FrameStrobe_O[7] Tile_X0Y0_FrameStrobe_O[8] Tile_X0Y0_FrameStrobe_O[9]
+ Tile_X0Y0_N1END[0] Tile_X0Y0_N1END[1] Tile_X0Y0_N1END[2] Tile_X0Y0_N1END[3] Tile_X0Y0_N2END[0]
+ Tile_X0Y0_N2END[1] Tile_X0Y0_N2END[2] Tile_X0Y0_N2END[3] Tile_X0Y0_N2END[4] Tile_X0Y0_N2END[5]
+ Tile_X0Y0_N2END[6] Tile_X0Y0_N2END[7] Tile_X0Y0_N2MID[0] Tile_X0Y0_N2MID[1] Tile_X0Y0_N2MID[2]
+ Tile_X0Y0_N2MID[3] Tile_X0Y0_N2MID[4] Tile_X0Y0_N2MID[5] Tile_X0Y0_N2MID[6] Tile_X0Y0_N2MID[7]
+ Tile_X0Y0_N4END[0] Tile_X0Y0_N4END[10] Tile_X0Y0_N4END[11] Tile_X0Y0_N4END[12] Tile_X0Y0_N4END[13]
+ Tile_X0Y0_N4END[14] Tile_X0Y0_N4END[15] Tile_X0Y0_N4END[1] Tile_X0Y0_N4END[2] Tile_X0Y0_N4END[3]
+ Tile_X0Y0_N4END[4] Tile_X0Y0_N4END[5] Tile_X0Y0_N4END[6] Tile_X0Y0_N4END[7] Tile_X0Y0_N4END[8]
+ Tile_X0Y0_N4END[9] Tile_X0Y0_NN4END[0] Tile_X0Y0_NN4END[10] Tile_X0Y0_NN4END[11]
+ Tile_X0Y0_NN4END[12] Tile_X0Y0_NN4END[13] Tile_X0Y0_NN4END[14] Tile_X0Y0_NN4END[15]
+ Tile_X0Y0_NN4END[1] Tile_X0Y0_NN4END[2] Tile_X0Y0_NN4END[3] Tile_X0Y0_NN4END[4]
+ Tile_X0Y0_NN4END[5] Tile_X0Y0_NN4END[6] Tile_X0Y0_NN4END[7] Tile_X0Y0_NN4END[8]
+ Tile_X0Y0_NN4END[9] Tile_X0Y0_S1BEG[0] Tile_X0Y0_S1BEG[1] Tile_X0Y0_S1BEG[2] Tile_X0Y0_S1BEG[3]
+ Tile_X0Y0_S2BEG[0] Tile_X0Y0_S2BEG[1] Tile_X0Y0_S2BEG[2] Tile_X0Y0_S2BEG[3] Tile_X0Y0_S2BEG[4]
+ Tile_X0Y0_S2BEG[5] Tile_X0Y0_S2BEG[6] Tile_X0Y0_S2BEG[7] Tile_X0Y0_S2BEGb[0] Tile_X0Y0_S2BEGb[1]
+ Tile_X0Y0_S2BEGb[2] Tile_X0Y0_S2BEGb[3] Tile_X0Y0_S2BEGb[4] Tile_X0Y0_S2BEGb[5]
+ Tile_X0Y0_S2BEGb[6] Tile_X0Y0_S2BEGb[7] Tile_X0Y0_S4BEG[0] Tile_X0Y0_S4BEG[10] Tile_X0Y0_S4BEG[11]
+ Tile_X0Y0_S4BEG[12] Tile_X0Y0_S4BEG[13] Tile_X0Y0_S4BEG[14] Tile_X0Y0_S4BEG[15]
+ Tile_X0Y0_S4BEG[1] Tile_X0Y0_S4BEG[2] Tile_X0Y0_S4BEG[3] Tile_X0Y0_S4BEG[4] Tile_X0Y0_S4BEG[5]
+ Tile_X0Y0_S4BEG[6] Tile_X0Y0_S4BEG[7] Tile_X0Y0_S4BEG[8] Tile_X0Y0_S4BEG[9] Tile_X0Y0_SS4BEG[0]
+ Tile_X0Y0_SS4BEG[10] Tile_X0Y0_SS4BEG[11] Tile_X0Y0_SS4BEG[12] Tile_X0Y0_SS4BEG[13]
+ Tile_X0Y0_SS4BEG[14] Tile_X0Y0_SS4BEG[15] Tile_X0Y0_SS4BEG[1] Tile_X0Y0_SS4BEG[2]
+ Tile_X0Y0_SS4BEG[3] Tile_X0Y0_SS4BEG[4] Tile_X0Y0_SS4BEG[5] Tile_X0Y0_SS4BEG[6]
+ Tile_X0Y0_SS4BEG[7] Tile_X0Y0_SS4BEG[8] Tile_X0Y0_SS4BEG[9] Tile_X0Y0_UserCLK Tile_X1Y0_Ci
+ Tile_X1Y0_FrameData_O[0] Tile_X1Y0_FrameData_O[10] Tile_X1Y0_FrameData_O[11] Tile_X1Y0_FrameData_O[12]
+ Tile_X1Y0_FrameData_O[13] Tile_X1Y0_FrameData_O[14] Tile_X1Y0_FrameData_O[15] Tile_X1Y0_FrameData_O[16]
+ Tile_X1Y0_FrameData_O[17] Tile_X1Y0_FrameData_O[18] Tile_X1Y0_FrameData_O[19] Tile_X1Y0_FrameData_O[1]
+ Tile_X1Y0_FrameData_O[20] Tile_X1Y0_FrameData_O[21] Tile_X1Y0_FrameData_O[22] Tile_X1Y0_FrameData_O[23]
+ Tile_X1Y0_FrameData_O[24] Tile_X1Y0_FrameData_O[25] Tile_X1Y0_FrameData_O[26] Tile_X1Y0_FrameData_O[27]
+ Tile_X1Y0_FrameData_O[28] Tile_X1Y0_FrameData_O[29] Tile_X1Y0_FrameData_O[2] Tile_X1Y0_FrameData_O[30]
+ Tile_X1Y0_FrameData_O[31] Tile_X1Y0_FrameData_O[3] Tile_X1Y0_FrameData_O[4] Tile_X1Y0_FrameData_O[5]
+ Tile_X1Y0_FrameData_O[6] Tile_X1Y0_FrameData_O[7] Tile_X1Y0_FrameData_O[8] Tile_X1Y0_FrameData_O[9]
+ Tile_X1Y0_FrameStrobe[0] Tile_X1Y0_FrameStrobe[10] Tile_X1Y0_FrameStrobe[11] Tile_X1Y0_FrameStrobe[12]
+ Tile_X1Y0_FrameStrobe[13] Tile_X1Y0_FrameStrobe[14] Tile_X1Y0_FrameStrobe[15] Tile_X1Y0_FrameStrobe[16]
+ Tile_X1Y0_FrameStrobe[17] Tile_X1Y0_FrameStrobe[18] Tile_X1Y0_FrameStrobe[19] Tile_X1Y0_FrameStrobe[1]
+ Tile_X1Y0_FrameStrobe[2] Tile_X1Y0_FrameStrobe[3] Tile_X1Y0_FrameStrobe[4] Tile_X1Y0_FrameStrobe[5]
+ Tile_X1Y0_FrameStrobe[6] Tile_X1Y0_FrameStrobe[7] Tile_X1Y0_FrameStrobe[8] Tile_X1Y0_FrameStrobe[9]
+ Tile_X1Y0_FrameStrobe_O[0] Tile_X1Y0_FrameStrobe_O[10] Tile_X1Y0_FrameStrobe_O[11]
+ Tile_X1Y0_FrameStrobe_O[12] Tile_X1Y0_FrameStrobe_O[13] Tile_X1Y0_FrameStrobe_O[14]
+ Tile_X1Y0_FrameStrobe_O[15] Tile_X1Y0_FrameStrobe_O[16] Tile_X1Y0_FrameStrobe_O[17]
+ Tile_X1Y0_FrameStrobe_O[18] Tile_X1Y0_FrameStrobe_O[19] Tile_X1Y0_FrameStrobe_O[1]
+ Tile_X1Y0_FrameStrobe_O[2] Tile_X1Y0_FrameStrobe_O[3] Tile_X1Y0_FrameStrobe_O[4]
+ Tile_X1Y0_FrameStrobe_O[5] Tile_X1Y0_FrameStrobe_O[6] Tile_X1Y0_FrameStrobe_O[7]
+ Tile_X1Y0_FrameStrobe_O[8] Tile_X1Y0_FrameStrobe_O[9] Tile_X1Y0_N1END[0] Tile_X1Y0_N1END[1]
+ Tile_X1Y0_N1END[2] Tile_X1Y0_N1END[3] Tile_X1Y0_N2END[0] Tile_X1Y0_N2END[1] Tile_X1Y0_N2END[2]
+ Tile_X1Y0_N2END[3] Tile_X1Y0_N2END[4] Tile_X1Y0_N2END[5] Tile_X1Y0_N2END[6] Tile_X1Y0_N2END[7]
+ Tile_X1Y0_N2MID[0] Tile_X1Y0_N2MID[1] Tile_X1Y0_N2MID[2] Tile_X1Y0_N2MID[3] Tile_X1Y0_N2MID[4]
+ Tile_X1Y0_N2MID[5] Tile_X1Y0_N2MID[6] Tile_X1Y0_N2MID[7] Tile_X1Y0_N4END[0] Tile_X1Y0_N4END[10]
+ Tile_X1Y0_N4END[11] Tile_X1Y0_N4END[12] Tile_X1Y0_N4END[13] Tile_X1Y0_N4END[14]
+ Tile_X1Y0_N4END[15] Tile_X1Y0_N4END[1] Tile_X1Y0_N4END[2] Tile_X1Y0_N4END[3] Tile_X1Y0_N4END[4]
+ Tile_X1Y0_N4END[5] Tile_X1Y0_N4END[6] Tile_X1Y0_N4END[7] Tile_X1Y0_N4END[8] Tile_X1Y0_N4END[9]
+ Tile_X1Y0_NN4END[0] Tile_X1Y0_NN4END[10] Tile_X1Y0_NN4END[11] Tile_X1Y0_NN4END[12]
+ Tile_X1Y0_NN4END[13] Tile_X1Y0_NN4END[14] Tile_X1Y0_NN4END[15] Tile_X1Y0_NN4END[1]
+ Tile_X1Y0_NN4END[2] Tile_X1Y0_NN4END[3] Tile_X1Y0_NN4END[4] Tile_X1Y0_NN4END[5]
+ Tile_X1Y0_NN4END[6] Tile_X1Y0_NN4END[7] Tile_X1Y0_NN4END[8] Tile_X1Y0_NN4END[9]
+ Tile_X1Y0_S1BEG[0] Tile_X1Y0_S1BEG[1] Tile_X1Y0_S1BEG[2] Tile_X1Y0_S1BEG[3] Tile_X1Y0_S2BEG[0]
+ Tile_X1Y0_S2BEG[1] Tile_X1Y0_S2BEG[2] Tile_X1Y0_S2BEG[3] Tile_X1Y0_S2BEG[4] Tile_X1Y0_S2BEG[5]
+ Tile_X1Y0_S2BEG[6] Tile_X1Y0_S2BEG[7] Tile_X1Y0_S2BEGb[0] Tile_X1Y0_S2BEGb[1] Tile_X1Y0_S2BEGb[2]
+ Tile_X1Y0_S2BEGb[3] Tile_X1Y0_S2BEGb[4] Tile_X1Y0_S2BEGb[5] Tile_X1Y0_S2BEGb[6]
+ Tile_X1Y0_S2BEGb[7] Tile_X1Y0_S4BEG[0] Tile_X1Y0_S4BEG[10] Tile_X1Y0_S4BEG[11] Tile_X1Y0_S4BEG[12]
+ Tile_X1Y0_S4BEG[13] Tile_X1Y0_S4BEG[14] Tile_X1Y0_S4BEG[15] Tile_X1Y0_S4BEG[1] Tile_X1Y0_S4BEG[2]
+ Tile_X1Y0_S4BEG[3] Tile_X1Y0_S4BEG[4] Tile_X1Y0_S4BEG[5] Tile_X1Y0_S4BEG[6] Tile_X1Y0_S4BEG[7]
+ Tile_X1Y0_S4BEG[8] Tile_X1Y0_S4BEG[9] Tile_X1Y0_SS4BEG[0] Tile_X1Y0_SS4BEG[10] Tile_X1Y0_SS4BEG[11]
+ Tile_X1Y0_SS4BEG[12] Tile_X1Y0_SS4BEG[13] Tile_X1Y0_SS4BEG[14] Tile_X1Y0_SS4BEG[15]
+ Tile_X1Y0_SS4BEG[1] Tile_X1Y0_SS4BEG[2] Tile_X1Y0_SS4BEG[3] Tile_X1Y0_SS4BEG[4]
+ Tile_X1Y0_SS4BEG[5] Tile_X1Y0_SS4BEG[6] Tile_X1Y0_SS4BEG[7] Tile_X1Y0_SS4BEG[8]
+ Tile_X1Y0_SS4BEG[9] Tile_X1Y0_UserCLKo VGND VPWR
XFILLER_10_339 VPWR VGND sg13cmos5l_decap_8
XFILLER_11_1097 VPWR VGND sg13cmos5l_decap_4
XFILLER_7_7 VPWR VGND sg13cmos5l_decap_8
XFILLER_2_549 VPWR VGND sg13cmos5l_decap_8
XANTENNA_202 Tile_X0Y0_FrameData[1] VPWR VGND sg13cmos5l_antennanp
XANTENNA_213 Tile_X0Y0_FrameData[3] VPWR VGND sg13cmos5l_antennanp
XANTENNA_224 Tile_X0Y0_FrameData[3] VPWR VGND sg13cmos5l_antennanp
XANTENNA_235 Tile_X0Y0_FrameData[3] VPWR VGND sg13cmos5l_antennanp
XANTENNA_246 Tile_X0Y0_FrameData[8] VPWR VGND sg13cmos5l_antennanp
XANTENNA_257 Tile_X0Y0_FrameData[8] VPWR VGND sg13cmos5l_antennanp
XANTENNA_268 Tile_X0Y0_FrameData[8] VPWR VGND sg13cmos5l_antennanp
XANTENNA_279 Tile_X0Y0_FrameData[8] VPWR VGND sg13cmos5l_antennanp
XFILLER_13_133 VPWR VGND sg13cmos5l_decap_8
XFILLER_14_656 VPWR VGND sg13cmos5l_decap_4
X_432_ Tile_X0Y0_S4BEG[1] _569_/X VPWR VGND sg13cmos5l_buf_1
X_501_ Tile_X1Y0_S1BEG[2] Tile_X1Y0_N1END[1] VPWR VGND sg13cmos5l_buf_1
XFILLER_10_840 VPWR VGND sg13cmos5l_fill_2
X_294_ _294_/Q Tile_X0Y0_FrameData[27] VGND VPWR Tile_X0Y0_FrameStrobe[1] latch
X_363_ _363_/L_HI VPWR VGND sg13cmos5l_tiehi
XFILLER_9_126 VPWR VGND sg13cmos5l_decap_8
XFILLER_6_811 VPWR VGND sg13cmos5l_decap_8
XFILLER_6_877 VPWR VGND sg13cmos5l_decap_8
XFILLER_5_387 VPWR VGND sg13cmos5l_decap_4
XFILLER_5_354 VPWR VGND sg13cmos5l_fill_2
XFILLER_3_56 VPWR VGND sg13cmos5l_decap_8
XFILLER_1_582 VPWR VGND sg13cmos5l_fill_2
XFILLER_3_1018 VPWR VGND sg13cmos5l_decap_8
XFILLER_9_671 VPWR VGND sg13cmos5l_decap_8
XFILLER_10_147 VPWR VGND sg13cmos5l_decap_8
XFILLER_11_626 VPWR VGND sg13cmos5l_decap_8
XFILLER_11_637 VPWR VGND sg13cmos5l_fill_1
XFILLER_12_32 VPWR VGND sg13cmos5l_decap_8
XFILLER_7_608 VPWR VGND sg13cmos5l_decap_8
XFILLER_6_107 VPWR VGND sg13cmos5l_decap_8
XANTENNA__501__X Tile_X1Y0_S1BEG[2] VPWR VGND sg13cmos5l_antennanp
XFILLER_3_836 VPWR VGND sg13cmos5l_fill_1
XFILLER_2_313 VPWR VGND sg13cmos5l_decap_8
XFILLER_14_420 VPWR VGND sg13cmos5l_decap_8
XFILLER_14_497 VPWR VGND sg13cmos5l_decap_8
XFILLER_15_998 VPWR VGND sg13cmos5l_decap_4
X_346_ _346_/Q Tile_X0Y0_FrameData[7] VGND VPWR Tile_X0Y0_FrameStrobe[2] latch
X_415_ Tile_X0Y0_S2BEG[0] Tile_X0Y0_N2MID[7] VPWR VGND sg13cmos5l_buf_1
X_277_ _277_/Q Tile_X0Y0_FrameData[12] VGND VPWR Tile_X0Y0_FrameStrobe[0] latch
XANTENNA__411__X Tile_X0Y0_S1BEG[0] VPWR VGND sg13cmos5l_antennanp
XFILLER_9_490 VPWR VGND sg13cmos5l_decap_8
XFILLER_11_423 VPWR VGND sg13cmos5l_decap_8
XFILLER_16_729 VPWR VGND sg13cmos5l_decap_8
X_200_ _200_/Q Tile_X0Y0_FrameData[16] VGND VPWR Tile_X1Y0_FrameStrobe[2] latch
X_131_ _131_/Q Tile_X0Y0_FrameData[21] VGND VPWR Tile_X1Y0_FrameStrobe[0] latch
X_062_ _245_/D _642_/X _229_/Q _232_/Q VPWR VGND sg13cmos5l_mux2_1
XFILLER_8_939 VPWR VGND sg13cmos5l_fill_1
XFILLER_3_622 VPWR VGND sg13cmos5l_decap_8
XFILLER_2_110 VPWR VGND sg13cmos5l_fill_2
XFILLER_0_35 VPWR VGND sg13cmos5l_decap_8
XANTENNA__406__X Tile_X0Y0_FrameStrobe_O[15] VPWR VGND sg13cmos5l_antennanp
XFILLER_14_294 VPWR VGND sg13cmos5l_decap_8
XFILLER_15_795 VPWR VGND sg13cmos5l_fill_1
X_329_ _329_/Q Tile_X0Y0_FrameData[24] VGND VPWR Tile_X0Y0_FrameStrobe[2] latch
XFILLER_9_77 VPWR VGND sg13cmos5l_decap_8
XFILLER_6_493 VPWR VGND sg13cmos5l_decap_8
XFILLER_9_1024 VPWR VGND sg13cmos5l_decap_8
XFILLER_12_765 VPWR VGND sg13cmos5l_fill_2
XFILLER_15_1007 VPWR VGND sg13cmos5l_decap_8
XFILLER_8_714 VPWR VGND sg13cmos5l_decap_8
X_114_ PMOD_IO_O4 _223_/Q _074_/X VPWR VGND sg13cmos5l_nor2b_1
XFILLER_7_279 VPWR VGND sg13cmos5l_fill_1
XFILLER_7_268 VPWR VGND sg13cmos5l_decap_4
XFILLER_7_246 VPWR VGND sg13cmos5l_fill_1
XFILLER_4_975 VPWR VGND sg13cmos5l_decap_8
XFILLER_13_518 VPWR VGND sg13cmos5l_decap_8
XFILLER_14_1062 VPWR VGND sg13cmos5l_decap_8
XFILLER_4_249 VPWR VGND sg13cmos5l_decap_8
XFILLER_0_433 VPWR VGND sg13cmos5l_fill_1
XFILLER_0_488 VPWR VGND sg13cmos5l_decap_8
XFILLER_1_967 VPWR VGND sg13cmos5l_fill_2
XFILLER_16_367 VPWR VGND sg13cmos5l_decap_8
X_594_ _594_/X Tile_X0Y0_N2END[2] Tile_X0Y0_N4END[10] Tile_X0Y0_NN4END[5] _119_/X
+ _281_/Q _280_/Q VPWR VGND sg13cmos5l_mux4_1
XFILLER_12_540 VPWR VGND sg13cmos5l_decap_8
XFILLER_8_588 VPWR VGND sg13cmos5l_decap_8
XFILLER_8_511 VPWR VGND sg13cmos5l_decap_8
XANTENNA_5 Tile_X0Y0_FrameData[0] VPWR VGND sg13cmos5l_antennanp
XFILLER_6_56 VPWR VGND sg13cmos5l_decap_8
XFILLER_4_750 VPWR VGND sg13cmos5l_decap_8
XFILLER_6_1027 VPWR VGND sg13cmos5l_decap_8
XFILLER_13_315 VPWR VGND sg13cmos5l_decap_8
XFILLER_15_21 VPWR VGND sg13cmos5l_decap_8
XFILLER_15_98 VPWR VGND sg13cmos5l_decap_8
XANTENNA__504__X Tile_X1Y0_S2BEG[1] VPWR VGND sg13cmos5l_antennanp
XFILLER_5_547 VPWR VGND sg13cmos5l_decap_8
XFILLER_0_296 VPWR VGND sg13cmos5l_decap_4
XFILLER_1_797 VPWR VGND sg13cmos5l_fill_2
XFILLER_5_1060 VPWR VGND sg13cmos5l_decap_8
X_646_ _646_/X Tile_X1Y0_N2MID[7] Tile_X1Y0_N2END[0] Tile_X1Y0_N4END[15] Tile_X1Y0_NN4END[15]
+ _126_/Q _125_/Q VPWR VGND sg13cmos5l_mux4_1
X_577_ _577_/X Tile_X0Y0_N2MID[1] Tile_X0Y0_N4END[6] Tile_X0Y0_NN4END[9] _092_/X _315_/Q
+ _314_/Q VPWR VGND sg13cmos5l_mux4_1
XANTENNA__414__X Tile_X0Y0_S1BEG[3] VPWR VGND sg13cmos5l_antennanp
XFILLER_9_886 VPWR VGND sg13cmos5l_fill_2
XFILLER_8_396 VPWR VGND sg13cmos5l_decap_8
XFILLER_8_374 VPWR VGND sg13cmos5l_fill_1
XFILLER_11_0 VPWR VGND sg13cmos5l_decap_8
XFILLER_11_1076 VPWR VGND sg13cmos5l_decap_8
XFILLER_2_528 VPWR VGND sg13cmos5l_decap_8
X_500_ Tile_X1Y0_S1BEG[1] Tile_X1Y0_N1END[2] VPWR VGND sg13cmos5l_buf_1
XANTENNA_203 Tile_X0Y0_FrameData[25] VPWR VGND sg13cmos5l_antennanp
XANTENNA_214 Tile_X0Y0_FrameData[3] VPWR VGND sg13cmos5l_antennanp
XANTENNA_225 Tile_X0Y0_FrameData[3] VPWR VGND sg13cmos5l_antennanp
XANTENNA_236 Tile_X0Y0_FrameData[3] VPWR VGND sg13cmos5l_antennanp
XANTENNA_247 Tile_X0Y0_FrameData[8] VPWR VGND sg13cmos5l_antennanp
XANTENNA_258 Tile_X0Y0_FrameData[8] VPWR VGND sg13cmos5l_antennanp
XANTENNA_269 Tile_X0Y0_FrameData[8] VPWR VGND sg13cmos5l_antennanp
XFILLER_13_112 VPWR VGND sg13cmos5l_decap_8
XFILLER_14_635 VPWR VGND sg13cmos5l_decap_8
XFILLER_14_679 VPWR VGND sg13cmos5l_decap_8
X_362_ _362_/L_HI VPWR VGND sg13cmos5l_tiehi
X_431_ Tile_X0Y0_S4BEG[0] _568_/X VPWR VGND sg13cmos5l_buf_1
XFILLER_9_105 VPWR VGND sg13cmos5l_decap_8
XFILLER_13_189 VPWR VGND sg13cmos5l_decap_8
X_293_ _293_/Q Tile_X0Y0_FrameData[28] VGND VPWR Tile_X0Y0_FrameStrobe[1] latch
XFILLER_6_801 VPWR VGND sg13cmos5l_decap_8
XFILLER_1_561 VPWR VGND sg13cmos5l_decap_8
XFILLER_3_35 VPWR VGND sg13cmos5l_decap_8
XANTENNA__409__X Tile_X0Y0_FrameStrobe_O[18] VPWR VGND sg13cmos5l_antennanp
X_629_ _629_/X Tile_X1Y0_N2END[5] Tile_X1Y0_N4END[5] Tile_X1Y0_NN4END[10] _064_/X
+ _162_/Q _161_/Q VPWR VGND sg13cmos5l_mux4_1
XFILLER_8_171 VPWR VGND sg13cmos5l_decap_8
XFILLER_11_605 VPWR VGND sg13cmos5l_decap_8
XFILLER_10_126 VPWR VGND sg13cmos5l_decap_8
XFILLER_12_99 VPWR VGND sg13cmos5l_decap_8
XFILLER_2_303 VPWR VGND sg13cmos5l_fill_2
XFILLER_15_911 VPWR VGND sg13cmos5l_decap_4
XFILLER_2_1074 VPWR VGND sg13cmos5l_decap_8
XFILLER_14_476 VPWR VGND sg13cmos5l_decap_8
X_276_ _276_/Q Tile_X0Y0_FrameData[13] VGND VPWR Tile_X0Y0_FrameStrobe[0] latch
X_345_ _345_/Q Tile_X0Y0_FrameData[8] VGND VPWR Tile_X0Y0_FrameStrobe[2] latch
X_414_ Tile_X0Y0_S1BEG[3] Tile_X0Y0_N1END[0] VPWR VGND sg13cmos5l_buf_1
XFILLER_6_675 VPWR VGND sg13cmos5l_decap_8
XFILLER_11_402 VPWR VGND sg13cmos5l_decap_8
XFILLER_12_936 VPWR VGND sg13cmos5l_fill_2
X_130_ _130_/Q Tile_X0Y0_FrameData[22] VGND VPWR Tile_X1Y0_FrameStrobe[0] latch
XFILLER_8_918 VPWR VGND sg13cmos5l_fill_1
XANTENNA__512__X Tile_X1Y0_S2BEGb[1] VPWR VGND sg13cmos5l_antennanp
XFILLER_11_479 VPWR VGND sg13cmos5l_decap_8
X_061_ _061_/Y _244_/Q VPWR VGND sg13cmos5l_inv_1
XFILLER_0_14 VPWR VGND sg13cmos5l_decap_8
XFILLER_14_240 VPWR VGND sg13cmos5l_fill_1
XFILLER_15_763 VPWR VGND sg13cmos5l_fill_1
XFILLER_14_273 VPWR VGND sg13cmos5l_decap_8
X_328_ _328_/Q Tile_X0Y0_FrameData[25] VGND VPWR Tile_X0Y0_FrameStrobe[2] latch
X_259_ _259_/Q Tile_X0Y0_FrameData[30] VGND VPWR Tile_X0Y0_FrameStrobe[0] latch
XFILLER_9_56 VPWR VGND sg13cmos5l_decap_8
XANTENNA__422__X Tile_X0Y0_S2BEG[7] VPWR VGND sg13cmos5l_antennanp
XFILLER_9_1003 VPWR VGND sg13cmos5l_decap_8
XFILLER_7_984 VPWR VGND sg13cmos5l_decap_8
XFILLER_6_472 VPWR VGND sg13cmos5l_decap_8
XFILLER_0_615 VPWR VGND sg13cmos5l_fill_1
XANTENNA__507__X Tile_X1Y0_S2BEG[4] VPWR VGND sg13cmos5l_antennanp
XFILLER_11_254 VPWR VGND sg13cmos5l_decap_4
X_113_ PMOD_IO_O3 _223_/Q _081_/X VPWR VGND sg13cmos5l_nor2b_1
XFILLER_3_486 VPWR VGND sg13cmos5l_decap_8
XFILLER_3_420 VPWR VGND sg13cmos5l_decap_8
XFILLER_15_7 VPWR VGND sg13cmos5l_decap_8
XANTENNA__417__X Tile_X0Y0_S2BEG[2] VPWR VGND sg13cmos5l_antennanp
XFILLER_1_902 VPWR VGND sg13cmos5l_decap_8
XFILLER_5_707 VPWR VGND sg13cmos5l_decap_8
XFILLER_0_467 VPWR VGND sg13cmos5l_decap_8
XFILLER_0_478 VPWR VGND sg13cmos5l_fill_2
XFILLER_1_979 VPWR VGND sg13cmos5l_decap_8
X_593_ _593_/X Tile_X0Y0_N2END[1] Tile_X0Y0_N4END[9] Tile_X0Y0_NN4END[6] _091_/X _283_/Q
+ _282_/Q VPWR VGND sg13cmos5l_mux4_1
XANTENNA_6 Tile_X0Y0_FrameData[0] VPWR VGND sg13cmos5l_antennanp
XFILLER_12_596 VPWR VGND sg13cmos5l_decap_8
XFILLER_8_567 VPWR VGND sg13cmos5l_decap_8
XFILLER_6_35 VPWR VGND sg13cmos5l_decap_8
XFILLER_4_740 VPWR VGND sg13cmos5l_decap_8
XFILLER_3_250 VPWR VGND sg13cmos5l_decap_4
XFILLER_1_209 VPWR VGND sg13cmos5l_fill_2
XFILLER_15_77 VPWR VGND sg13cmos5l_decap_8
XFILLER_16_1103 VPWR VGND sg13cmos5l_decap_8
XFILLER_5_526 VPWR VGND sg13cmos5l_decap_8
XANTENNA__520__X Tile_X1Y0_S4BEG[1] VPWR VGND sg13cmos5l_antennanp
XFILLER_0_264 VPWR VGND sg13cmos5l_fill_1
XFILLER_1_765 VPWR VGND sg13cmos5l_decap_4
X_645_ _645_/X Tile_X1Y0_N2MID[5] Tile_X1Y0_N2END[2] Tile_X1Y0_N4END[13] Tile_X1Y0_NN4END[13]
+ _130_/Q _129_/Q VPWR VGND sg13cmos5l_mux4_1
XFILLER_16_143 VPWR VGND sg13cmos5l_decap_8
XFILLER_16_198 VPWR VGND sg13cmos5l_decap_8
X_576_ _576_/X Tile_X0Y0_N2MID[0] Tile_X0Y0_N4END[7] Tile_X0Y0_NN4END[8] _091_/X _317_/Q
+ _316_/Q VPWR VGND sg13cmos5l_mux4_1
XFILLER_12_393 VPWR VGND sg13cmos5l_decap_8
XFILLER_8_331 VPWR VGND sg13cmos5l_decap_8
XANTENNA__430__X Tile_X0Y0_S2BEGb[7] VPWR VGND sg13cmos5l_antennanp
XFILLER_4_592 VPWR VGND sg13cmos5l_decap_8
XFILLER_11_1055 VPWR VGND sg13cmos5l_decap_8
XFILLER_2_507 VPWR VGND sg13cmos5l_decap_8
XANTENNA_204 Tile_X0Y0_FrameData[25] VPWR VGND sg13cmos5l_antennanp
XANTENNA_215 Tile_X0Y0_FrameData[3] VPWR VGND sg13cmos5l_antennanp
XANTENNA_226 Tile_X0Y0_FrameData[3] VPWR VGND sg13cmos5l_antennanp
XANTENNA_237 Tile_X0Y0_FrameData[3] VPWR VGND sg13cmos5l_antennanp
XANTENNA_248 Tile_X0Y0_FrameData[8] VPWR VGND sg13cmos5l_antennanp
XANTENNA_259 Tile_X0Y0_FrameData[8] VPWR VGND sg13cmos5l_antennanp
XANTENNA__515__X Tile_X1Y0_S2BEGb[4] VPWR VGND sg13cmos5l_antennanp
XFILLER_13_168 VPWR VGND sg13cmos5l_decap_8
XFILLER_14_614 VPWR VGND sg13cmos5l_decap_8
X_292_ _292_/Q Tile_X0Y0_FrameData[29] VGND VPWR Tile_X0Y0_FrameStrobe[1] latch
X_361_ _361_/L_HI VPWR VGND sg13cmos5l_tiehi
X_430_ Tile_X0Y0_S2BEGb[7] _567_/X VPWR VGND sg13cmos5l_buf_1
XFILLER_6_846 VPWR VGND sg13cmos5l_decap_4
XFILLER_1_540 VPWR VGND sg13cmos5l_decap_8
XFILLER_1_584 VPWR VGND sg13cmos5l_fill_1
XFILLER_3_14 VPWR VGND sg13cmos5l_decap_8
X_628_ _628_/X Tile_X1Y0_N2END[4] Tile_X1Y0_N4END[4] Tile_X1Y0_NN4END[11] _089_/X
+ _164_/Q _163_/Q VPWR VGND sg13cmos5l_mux4_1
XANTENNA__425__X Tile_X0Y0_S2BEGb[2] VPWR VGND sg13cmos5l_antennanp
XFILLER_12_190 VPWR VGND sg13cmos5l_decap_8
X_559_ _559_/X Tile_X1Y0_N1END[0] Tile_X1Y0_N2END[2] Tile_X1Y0_N4END[15] Tile_X1Y0_NN4END[15]
+ _124_/Q _123_/Q VPWR VGND sg13cmos5l_mux4_1
XFILLER_8_150 VPWR VGND sg13cmos5l_decap_8
XFILLER_10_105 VPWR VGND sg13cmos5l_decap_8
XFILLER_12_78 VPWR VGND sg13cmos5l_decap_8
XFILLER_12_89 VPWR VGND sg13cmos5l_fill_2
XFILLER_3_816 VPWR VGND sg13cmos5l_fill_2
XFILLER_2_348 VPWR VGND sg13cmos5l_fill_2
X_413_ Tile_X0Y0_S1BEG[2] Tile_X0Y0_N1END[1] VPWR VGND sg13cmos5l_buf_1
XFILLER_2_1053 VPWR VGND sg13cmos5l_decap_8
XFILLER_10_661 VPWR VGND sg13cmos5l_decap_8
XFILLER_14_455 VPWR VGND sg13cmos5l_decap_8
X_275_ _275_/Q Tile_X0Y0_FrameData[14] VGND VPWR Tile_X0Y0_FrameStrobe[0] latch
X_344_ _344_/Q Tile_X0Y0_FrameData[9] VGND VPWR Tile_X0Y0_FrameStrobe[2] latch
XFILLER_4_90 VPWR VGND sg13cmos5l_decap_8
XFILLER_11_458 VPWR VGND sg13cmos5l_decap_8
X_060_ _060_/Y _250_/Q VPWR VGND sg13cmos5l_inv_1
XFILLER_3_657 VPWR VGND sg13cmos5l_decap_4
XFILLER_2_134 VPWR VGND sg13cmos5l_decap_8
XFILLER_14_252 VPWR VGND sg13cmos5l_decap_8
XFILLER_15_720 VPWR VGND sg13cmos5l_decap_8
XFILLER_9_35 VPWR VGND sg13cmos5l_decap_8
X_327_ _327_/Q Tile_X0Y0_FrameData[26] VGND VPWR Tile_X0Y0_FrameStrobe[2] latch
X_258_ _258_/Q Tile_X0Y0_UserCLK _559_/X _352_/L_HI VPWR VGND sg13cmos5l_dfrbpq_1
X_189_ _189_/Q Tile_X0Y0_FrameData[27] VGND VPWR Tile_X1Y0_FrameStrobe[2] latch
XFILLER_7_963 VPWR VGND sg13cmos5l_fill_2
XFILLER_6_451 VPWR VGND sg13cmos5l_decap_8
XFILLER_9_1059 VPWR VGND sg13cmos5l_decap_8
XFILLER_0_638 VPWR VGND sg13cmos5l_fill_1
XFILLER_16_528 VPWR VGND sg13cmos5l_decap_8
XFILLER_16_539 VPWR VGND sg13cmos5l_fill_1
XANTENNA__523__X Tile_X1Y0_S4BEG[4] VPWR VGND sg13cmos5l_antennanp
XFILLER_12_745 VPWR VGND sg13cmos5l_decap_4
X_112_ PMOD_IO_O2 _223_/Q _071_/X VPWR VGND sg13cmos5l_nor2b_1
XFILLER_1_0 VPWR VGND sg13cmos5l_decap_8
XFILLER_3_465 VPWR VGND sg13cmos5l_decap_8
XFILLER_15_583 VPWR VGND sg13cmos5l_decap_8
XANTENNA__433__X Tile_X0Y0_S4BEG[2] VPWR VGND sg13cmos5l_antennanp
XFILLER_14_1097 VPWR VGND sg13cmos5l_decap_8
X_592_ _592_/X Tile_X0Y0_N2END[0] Tile_X0Y0_N4END[8] Tile_X0Y0_NN4END[7] _092_/X _285_/Q
+ _284_/Q VPWR VGND sg13cmos5l_mux4_1
XANTENNA__518__X Tile_X1Y0_S2BEGb[7] VPWR VGND sg13cmos5l_antennanp
XFILLER_16_347 VPWR VGND sg13cmos5l_fill_2
XANTENNA_7 Tile_X0Y0_FrameData[0] VPWR VGND sg13cmos5l_antennanp
XFILLER_12_575 VPWR VGND sg13cmos5l_decap_8
XFILLER_8_546 VPWR VGND sg13cmos5l_decap_8
XFILLER_6_14 VPWR VGND sg13cmos5l_decap_8
XFILLER_4_796 VPWR VGND sg13cmos5l_fill_2
XFILLER_3_284 VPWR VGND sg13cmos5l_fill_2
XANTENNA__428__X Tile_X0Y0_S2BEGb[5] VPWR VGND sg13cmos5l_antennanp
XFILLER_15_380 VPWR VGND sg13cmos5l_decap_8
XFILLER_15_56 VPWR VGND sg13cmos5l_decap_8
XFILLER_5_505 VPWR VGND sg13cmos5l_decap_8
XFILLER_0_287 VPWR VGND sg13cmos5l_fill_2
XFILLER_16_122 VPWR VGND sg13cmos5l_decap_8
X_644_ _644_/X Tile_X1Y0_N2MID[3] Tile_X1Y0_N2END[4] Tile_X1Y0_N4END[11] Tile_X1Y0_NN4END[11]
+ _134_/Q _133_/Q VPWR VGND sg13cmos5l_mux4_1
X_575_ _575_/X Tile_X0Y0_N2MID[7] Tile_X0Y0_N4END[8] Tile_X0Y0_NN4END[7] _119_/X _319_/Q
+ _318_/Q VPWR VGND sg13cmos5l_mux4_1
XFILLER_12_372 VPWR VGND sg13cmos5l_decap_8
XFILLER_16_177 VPWR VGND sg13cmos5l_decap_4
XFILLER_9_888 VPWR VGND sg13cmos5l_fill_1
XFILLER_4_571 VPWR VGND sg13cmos5l_decap_8
XFILLER_11_1023 VPWR VGND sg13cmos5l_decap_8
XANTENNA_205 Tile_X0Y0_FrameData[25] VPWR VGND sg13cmos5l_antennanp
XANTENNA_216 Tile_X0Y0_FrameData[3] VPWR VGND sg13cmos5l_antennanp
XANTENNA_227 Tile_X0Y0_FrameData[3] VPWR VGND sg13cmos5l_antennanp
XANTENNA_238 Tile_X0Y0_FrameData[3] VPWR VGND sg13cmos5l_antennanp
XANTENNA_249 Tile_X0Y0_FrameData[8] VPWR VGND sg13cmos5l_antennanp
XFILLER_13_147 VPWR VGND sg13cmos5l_decap_8
X_291_ _291_/Q Tile_X0Y0_FrameData[30] VGND VPWR Tile_X0Y0_FrameStrobe[1] latch
X_360_ _360_/L_HI VPWR VGND sg13cmos5l_tiehi
XANTENNA__531__X Tile_X1Y0_S4BEG[12] VPWR VGND sg13cmos5l_antennanp
XFILLER_10_898 VPWR VGND sg13cmos5l_decap_8
XFILLER_6_825 VPWR VGND sg13cmos5l_decap_8
XFILLER_5_324 VPWR VGND sg13cmos5l_decap_8
XFILLER_1_596 VPWR VGND sg13cmos5l_fill_2
X_627_ _627_/X Tile_X1Y0_N2END[3] Tile_X1Y0_N4END[3] Tile_X1Y0_NN4END[12] _087_/X
+ _166_/Q _165_/Q VPWR VGND sg13cmos5l_mux4_1
X_558_ _558_/X Tile_X1Y0_N2MID[6] Tile_X1Y0_N2END[1] Tile_X1Y0_N4END[14] Tile_X1Y0_NN4END[14]
+ _128_/Q _127_/Q VPWR VGND sg13cmos5l_mux4_1
X_489_ Tile_X1Y0_FrameStrobe_O[10] Tile_X1Y0_FrameStrobe[10] VPWR VGND sg13cmos5l_buf_1
XFILLER_9_685 VPWR VGND sg13cmos5l_decap_4
XANTENNA__441__X Tile_X0Y0_S4BEG[10] VPWR VGND sg13cmos5l_antennanp
XFILLER_12_46 VPWR VGND sg13cmos5l_decap_8
XFILLER_5_7 VPWR VGND sg13cmos5l_decap_8
XFILLER_2_305 VPWR VGND sg13cmos5l_fill_1
XANTENNA__526__X Tile_X1Y0_S4BEG[7] VPWR VGND sg13cmos5l_antennanp
XFILLER_14_434 VPWR VGND sg13cmos5l_decap_8
XFILLER_15_946 VPWR VGND sg13cmos5l_fill_1
X_412_ Tile_X0Y0_S1BEG[1] Tile_X0Y0_N1END[2] VPWR VGND sg13cmos5l_buf_1
XFILLER_2_1032 VPWR VGND sg13cmos5l_decap_8
XFILLER_10_640 VPWR VGND sg13cmos5l_decap_8
X_274_ _274_/Q Tile_X0Y0_FrameData[15] VGND VPWR Tile_X0Y0_FrameStrobe[0] latch
X_343_ _343_/Q Tile_X0Y0_FrameData[10] VGND VPWR Tile_X0Y0_FrameStrobe[2] latch
XFILLER_6_633 VPWR VGND sg13cmos5l_decap_8
XFILLER_5_143 VPWR VGND sg13cmos5l_fill_2
XFILLER_2_883 VPWR VGND sg13cmos5l_decap_4
XANTENNA__436__X Tile_X0Y0_S4BEG[5] VPWR VGND sg13cmos5l_antennanp
XFILLER_11_437 VPWR VGND sg13cmos5l_decap_8
XFILLER_7_408 VPWR VGND sg13cmos5l_decap_8
XFILLER_3_636 VPWR VGND sg13cmos5l_decap_8
XFILLER_2_168 VPWR VGND sg13cmos5l_decap_8
XFILLER_2_157 VPWR VGND sg13cmos5l_decap_4
XFILLER_0_49 VPWR VGND sg13cmos5l_decap_8
XFILLER_4_1105 VPWR VGND sg13cmos5l_fill_1
XFILLER_14_231 VPWR VGND sg13cmos5l_decap_8
XFILLER_15_787 VPWR VGND sg13cmos5l_fill_1
X_326_ _326_/Q Tile_X0Y0_FrameData[27] VGND VPWR Tile_X0Y0_FrameStrobe[2] latch
XFILLER_9_14 VPWR VGND sg13cmos5l_decap_8
X_257_ _257_/Q Tile_X0Y0_UserCLK _558_/X _364_/L_HI VPWR VGND sg13cmos5l_dfrbpq_1
X_188_ _188_/Q Tile_X0Y0_FrameData[28] VGND VPWR Tile_X1Y0_FrameStrobe[2] latch
XFILLER_6_430 VPWR VGND sg13cmos5l_decap_8
XFILLER_9_1038 VPWR VGND sg13cmos5l_decap_8
XFILLER_16_507 VPWR VGND sg13cmos5l_decap_8
XFILLER_11_212 VPWR VGND sg13cmos5l_decap_8
XFILLER_12_702 VPWR VGND sg13cmos5l_decap_8
X_111_ PMOD_IO_O1 _223_/Q _110_/X VPWR VGND sg13cmos5l_nor2b_1
XFILLER_8_728 VPWR VGND sg13cmos5l_decap_8
XFILLER_4_989 VPWR VGND sg13cmos5l_decap_4
XFILLER_3_444 VPWR VGND sg13cmos5l_decap_8
XFILLER_8_1071 VPWR VGND sg13cmos5l_decap_8
XFILLER_15_562 VPWR VGND sg13cmos5l_decap_8
X_309_ _309_/Q Tile_X0Y0_FrameData[12] VGND VPWR Tile_X0Y0_FrameStrobe[1] latch
XFILLER_6_293 VPWR VGND sg13cmos5l_decap_8
XFILLER_1_70 VPWR VGND sg13cmos5l_fill_2
XFILLER_14_1021 VPWR VGND sg13cmos5l_decap_8
XFILLER_14_1032 VPWR VGND sg13cmos5l_decap_8
XFILLER_14_1076 VPWR VGND sg13cmos5l_decap_8
XFILLER_16_304 VPWR VGND sg13cmos5l_decap_8
XFILLER_16_326 VPWR VGND sg13cmos5l_decap_8
X_591_ _591_/X Tile_X0Y0_N2END[7] Tile_X0Y0_N4END[7] Tile_X0Y0_NN4END[8] _119_/X _287_/Q
+ _286_/Q VPWR VGND sg13cmos5l_mux4_1
XANTENNA__534__X Tile_X1Y0_S4BEG[15] VPWR VGND sg13cmos5l_antennanp
XFILLER_12_554 VPWR VGND sg13cmos5l_decap_8
XFILLER_8_525 VPWR VGND sg13cmos5l_decap_8
XANTENNA_8 Tile_X0Y0_FrameData[0] VPWR VGND sg13cmos5l_antennanp
XFILLER_6_1008 VPWR VGND sg13cmos5l_fill_1
XANTENNA__444__X Tile_X0Y0_S4BEG[13] VPWR VGND sg13cmos5l_antennanp
XFILLER_7_580 VPWR VGND sg13cmos5l_decap_8
XFILLER_13_329 VPWR VGND sg13cmos5l_decap_8
XFILLER_15_35 VPWR VGND sg13cmos5l_decap_8
XFILLER_0_211 VPWR VGND sg13cmos5l_decap_8
XANTENNA__529__X Tile_X1Y0_S4BEG[10] VPWR VGND sg13cmos5l_antennanp
XFILLER_16_101 VPWR VGND sg13cmos5l_decap_8
XFILLER_16_156 VPWR VGND sg13cmos5l_decap_8
X_643_ _643_/X Tile_X1Y0_N2MID[1] Tile_X1Y0_N2END[6] Tile_X1Y0_N4END[9] Tile_X1Y0_NN4END[9]
+ _138_/Q _137_/Q VPWR VGND sg13cmos5l_mux4_1
X_574_ _574_/X Tile_X0Y0_N2MID[6] Tile_X0Y0_N4END[9] Tile_X0Y0_NN4END[6] _092_/X _321_/Q
+ _320_/Q VPWR VGND sg13cmos5l_mux4_1
XFILLER_5_1074 VPWR VGND sg13cmos5l_decap_8
XFILLER_12_351 VPWR VGND sg13cmos5l_decap_8
XFILLER_9_801 VPWR VGND sg13cmos5l_decap_8
XFILLER_4_550 VPWR VGND sg13cmos5l_decap_8
XANTENNA__439__X Tile_X0Y0_S4BEG[8] VPWR VGND sg13cmos5l_antennanp
XFILLER_11_1002 VPWR VGND sg13cmos5l_decap_8
XANTENNA_206 Tile_X0Y0_FrameData[25] VPWR VGND sg13cmos5l_antennanp
XANTENNA_217 Tile_X0Y0_FrameData[3] VPWR VGND sg13cmos5l_antennanp
XANTENNA_228 Tile_X0Y0_FrameData[3] VPWR VGND sg13cmos5l_antennanp
XANTENNA_239 Tile_X0Y0_FrameData[3] VPWR VGND sg13cmos5l_antennanp
XFILLER_14_605 VPWR VGND sg13cmos5l_decap_4
XFILLER_13_126 VPWR VGND sg13cmos5l_decap_8
XFILLER_14_649 VPWR VGND sg13cmos5l_decap_8
X_290_ _290_/Q Tile_X0Y0_FrameData[31] VGND VPWR Tile_X0Y0_FrameStrobe[1] latch
XFILLER_9_119 VPWR VGND sg13cmos5l_decap_8
XFILLER_6_859 VPWR VGND sg13cmos5l_decap_4
XFILLER_1_575 VPWR VGND sg13cmos5l_decap_8
XFILLER_3_49 VPWR VGND sg13cmos5l_decap_8
XFILLER_13_671 VPWR VGND sg13cmos5l_decap_8
X_488_ Tile_X1Y0_FrameStrobe_O[9] Tile_X1Y0_FrameStrobe[9] VPWR VGND sg13cmos5l_buf_1
X_626_ _626_/X Tile_X1Y0_N2END[2] Tile_X1Y0_N4END[2] Tile_X1Y0_NN4END[13] _085_/X
+ _168_/Q _167_/Q VPWR VGND sg13cmos5l_mux4_1
X_557_ _557_/X Tile_X1Y0_N2MID[4] Tile_X1Y0_N2END[3] Tile_X1Y0_N4END[12] Tile_X1Y0_NN4END[12]
+ _132_/Q _131_/Q VPWR VGND sg13cmos5l_mux4_1
XFILLER_9_697 VPWR VGND sg13cmos5l_decap_8
XFILLER_9_664 VPWR VGND sg13cmos5l_decap_8
XFILLER_10_1090 VPWR VGND sg13cmos5l_fill_1
XFILLER_5_892 VPWR VGND sg13cmos5l_fill_1
XFILLER_11_619 VPWR VGND sg13cmos5l_decap_8
XFILLER_12_14 VPWR VGND sg13cmos5l_fill_1
XFILLER_12_25 VPWR VGND sg13cmos5l_decap_8
XFILLER_2_1000 VPWR VGND sg13cmos5l_fill_1
XFILLER_2_1011 VPWR VGND sg13cmos5l_decap_8
XFILLER_14_413 VPWR VGND sg13cmos5l_decap_8
X_342_ _342_/Q Tile_X0Y0_FrameData[11] VGND VPWR Tile_X0Y0_FrameStrobe[2] latch
X_411_ Tile_X0Y0_S1BEG[0] Tile_X0Y0_N1END[3] VPWR VGND sg13cmos5l_buf_1
XFILLER_2_1088 VPWR VGND sg13cmos5l_fill_2
XANTENNA__542__X Tile_X1Y0_SS4BEG[7] VPWR VGND sg13cmos5l_antennanp
X_273_ _273_/Q Tile_X0Y0_FrameData[16] VGND VPWR Tile_X0Y0_FrameStrobe[0] latch
XFILLER_6_612 VPWR VGND sg13cmos5l_decap_8
XFILLER_6_689 VPWR VGND sg13cmos5l_decap_8
XFILLER_5_166 VPWR VGND sg13cmos5l_decap_4
XFILLER_2_862 VPWR VGND sg13cmos5l_decap_8
XFILLER_2_840 VPWR VGND sg13cmos5l_decap_8
X_609_ _609_/X Tile_X1Y0_N2MID[1] Tile_X1Y0_N4END[14] Tile_X1Y0_NN4END[1] _087_/X
+ _202_/Q _201_/Q VPWR VGND sg13cmos5l_mux4_1
XFILLER_13_490 VPWR VGND sg13cmos5l_decap_8
XANTENNA__452__X Tile_X1Y0_FrameData_O[5] VPWR VGND sg13cmos5l_antennanp
XFILLER_9_483 VPWR VGND sg13cmos5l_decap_8
XFILLER_11_416 VPWR VGND sg13cmos5l_decap_8
XFILLER_2_103 VPWR VGND sg13cmos5l_decap_8
XANTENNA__537__X Tile_X1Y0_SS4BEG[2] VPWR VGND sg13cmos5l_antennanp
XFILLER_0_28 VPWR VGND sg13cmos5l_decap_8
XFILLER_14_210 VPWR VGND sg13cmos5l_decap_8
XFILLER_14_287 VPWR VGND sg13cmos5l_decap_8
X_325_ _325_/Q Tile_X0Y0_FrameData[28] VGND VPWR Tile_X0Y0_FrameStrobe[2] latch
XFILLER_10_493 VPWR VGND sg13cmos5l_decap_8
X_256_ _256_/Q Tile_X0Y0_UserCLK _557_/X _353_/L_HI VPWR VGND sg13cmos5l_dfrbpq_1
X_187_ _187_/Q Tile_X0Y0_FrameData[29] VGND VPWR Tile_X1Y0_FrameStrobe[2] latch
XFILLER_7_998 VPWR VGND sg13cmos5l_decap_8
XFILLER_7_965 VPWR VGND sg13cmos5l_fill_1
XFILLER_6_486 VPWR VGND sg13cmos5l_decap_8
XFILLER_9_1017 VPWR VGND sg13cmos5l_decap_8
XANTENNA__447__X Tile_X1Y0_FrameData_O[0] VPWR VGND sg13cmos5l_antennanp
XFILLER_9_291 VPWR VGND sg13cmos5l_fill_2
X_110_ _110_/X _252_/Q _553_/X _233_/Q VPWR VGND sg13cmos5l_mux2_1
XFILLER_4_968 VPWR VGND sg13cmos5l_decap_8
XFILLER_3_434 VPWR VGND sg13cmos5l_decap_8
XFILLER_8_1050 VPWR VGND sg13cmos5l_decap_8
XFILLER_15_541 VPWR VGND sg13cmos5l_decap_8
X_308_ _308_/Q Tile_X0Y0_FrameData[13] VGND VPWR Tile_X0Y0_FrameStrobe[1] latch
X_239_ _239_/Q Tile_X0Y0_UserCLK _239_/D _365_/L_HI VPWR VGND sg13cmos5l_dfrbpq_1
XFILLER_7_773 VPWR VGND sg13cmos5l_decap_4
XFILLER_6_272 VPWR VGND sg13cmos5l_decap_8
XFILLER_3_990 VPWR VGND sg13cmos5l_decap_8
XFILLER_1_93 VPWR VGND sg13cmos5l_decap_8
XFILLER_14_1000 VPWR VGND sg13cmos5l_decap_8
XFILLER_14_1055 VPWR VGND sg13cmos5l_decap_8
XFILLER_0_437 VPWR VGND sg13cmos5l_decap_4
XFILLER_16_349 VPWR VGND sg13cmos5l_fill_1
X_590_ _590_/X Tile_X0Y0_N2END[6] Tile_X0Y0_N4END[6] Tile_X0Y0_NN4END[9] _091_/X _289_/Q
+ _288_/Q VPWR VGND sg13cmos5l_mux4_1
XFILLER_12_533 VPWR VGND sg13cmos5l_decap_8
XFILLER_8_504 VPWR VGND sg13cmos5l_decap_8
XANTENNA_9 Tile_X0Y0_FrameData[0] VPWR VGND sg13cmos5l_antennanp
XANTENNA__550__X Tile_X1Y0_SS4BEG[15] VPWR VGND sg13cmos5l_antennanp
XFILLER_10_91 VPWR VGND sg13cmos5l_decap_8
XFILLER_6_49 VPWR VGND sg13cmos5l_decap_8
XFILLER_4_798 VPWR VGND sg13cmos5l_fill_1
XFILLER_3_286 VPWR VGND sg13cmos5l_fill_1
XFILLER_0_971 VPWR VGND sg13cmos5l_fill_2
XFILLER_13_7 VPWR VGND sg13cmos5l_decap_8
XANTENNA__460__X Tile_X1Y0_FrameData_O[13] VPWR VGND sg13cmos5l_antennanp
XFILLER_15_14 VPWR VGND sg13cmos5l_decap_8
XFILLER_13_308 VPWR VGND sg13cmos5l_decap_8
X_642_ _642_/X Tile_X0Y0_N2MID[5] Tile_X0Y0_N2END[2] Tile_X0Y0_N4END[13] Tile_X0Y0_NN4END[13]
+ _259_/Q _350_/Q VPWR VGND sg13cmos5l_mux4_1
XFILLER_5_1053 VPWR VGND sg13cmos5l_decap_8
XANTENNA__545__X Tile_X1Y0_SS4BEG[10] VPWR VGND sg13cmos5l_antennanp
XFILLER_12_330 VPWR VGND sg13cmos5l_decap_8
X_573_ _573_/X Tile_X0Y0_N2MID[5] Tile_X0Y0_N4END[10] Tile_X0Y0_NN4END[5] _091_/X
+ _323_/Q _322_/Q VPWR VGND sg13cmos5l_mux4_1
XFILLER_9_879 VPWR VGND sg13cmos5l_decap_8
XFILLER_8_389 VPWR VGND sg13cmos5l_decap_8
XFILLER_8_323 VPWR VGND sg13cmos5l_fill_1
XFILLER_8_312 VPWR VGND sg13cmos5l_decap_8
XFILLER_0_790 VPWR VGND sg13cmos5l_fill_1
XANTENNA__455__X Tile_X1Y0_FrameData_O[8] VPWR VGND sg13cmos5l_antennanp
XFILLER_16_680 VPWR VGND sg13cmos5l_decap_8
XFILLER_11_1036 VPWR VGND sg13cmos5l_fill_2
XFILLER_11_1069 VPWR VGND sg13cmos5l_decap_8
XANTENNA_207 Tile_X0Y0_FrameData[25] VPWR VGND sg13cmos5l_antennanp
XANTENNA_218 Tile_X0Y0_FrameData[3] VPWR VGND sg13cmos5l_antennanp
XANTENNA_229 Tile_X0Y0_FrameData[3] VPWR VGND sg13cmos5l_antennanp
XFILLER_13_105 VPWR VGND sg13cmos5l_decap_8
XFILLER_14_628 VPWR VGND sg13cmos5l_decap_8
XFILLER_10_845 VPWR VGND sg13cmos5l_decap_4
XFILLER_1_554 VPWR VGND sg13cmos5l_decap_8
XFILLER_3_28 VPWR VGND sg13cmos5l_decap_8
X_625_ _625_/X Tile_X1Y0_N2END[1] Tile_X1Y0_N4END[1] Tile_X1Y0_NN4END[14] _095_/X
+ _170_/Q _169_/Q VPWR VGND sg13cmos5l_mux4_1
X_487_ Tile_X1Y0_FrameStrobe_O[8] Tile_X1Y0_FrameStrobe[8] VPWR VGND sg13cmos5l_buf_1
X_556_ _556_/X Tile_X1Y0_N2MID[2] Tile_X1Y0_N2END[5] Tile_X1Y0_N4END[10] Tile_X1Y0_NN4END[10]
+ _136_/Q _135_/Q VPWR VGND sg13cmos5l_mux4_1
XFILLER_8_164 VPWR VGND sg13cmos5l_decap_8
XFILLER_10_119 VPWR VGND sg13cmos5l_decap_8
XFILLER_14_469 VPWR VGND sg13cmos5l_decap_8
X_272_ _272_/Q Tile_X0Y0_FrameData[17] VGND VPWR Tile_X0Y0_FrameStrobe[0] latch
X_341_ _341_/Q Tile_X0Y0_FrameData[12] VGND VPWR Tile_X0Y0_FrameStrobe[2] latch
X_410_ Tile_X0Y0_FrameStrobe_O[19] Tile_X0Y0_FrameStrobe[19] VPWR VGND sg13cmos5l_buf_1
XFILLER_2_1067 VPWR VGND sg13cmos5l_decap_8
XFILLER_6_668 VPWR VGND sg13cmos5l_decap_8
XFILLER_5_134 VPWR VGND sg13cmos5l_fill_2
X_608_ _608_/X Tile_X1Y0_N2MID[0] Tile_X1Y0_N4END[15] Tile_X1Y0_NN4END[0] _089_/X
+ _204_/Q _203_/Q VPWR VGND sg13cmos5l_mux4_1
X_539_ Tile_X1Y0_SS4BEG[4] _628_/X VPWR VGND sg13cmos5l_buf_1
XFILLER_9_462 VPWR VGND sg13cmos5l_decap_8
XFILLER_2_148 VPWR VGND sg13cmos5l_fill_2
XFILLER_11_995 VPWR VGND sg13cmos5l_decap_8
XFILLER_14_266 VPWR VGND sg13cmos5l_fill_2
XFILLER_15_778 VPWR VGND sg13cmos5l_fill_1
X_324_ _324_/Q Tile_X0Y0_FrameData[29] VGND VPWR Tile_X0Y0_FrameStrobe[2] latch
X_255_ _255_/Q Tile_X0Y0_UserCLK _556_/X _370_/L_HI VPWR VGND sg13cmos5l_dfrbpq_1
XFILLER_9_49 VPWR VGND sg13cmos5l_decap_8
XFILLER_10_472 VPWR VGND sg13cmos5l_decap_8
XFILLER_13_91 VPWR VGND sg13cmos5l_decap_8
X_186_ _186_/Q Tile_X0Y0_FrameData[30] VGND VPWR Tile_X1Y0_FrameStrobe[2] latch
XFILLER_7_977 VPWR VGND sg13cmos5l_fill_2
XFILLER_6_465 VPWR VGND sg13cmos5l_decap_8
XFILLER_1_170 VPWR VGND sg13cmos5l_decap_8
XANTENNA__463__X Tile_X1Y0_FrameData_O[16] VPWR VGND sg13cmos5l_antennanp
XFILLER_11_258 VPWR VGND sg13cmos5l_fill_1
XFILLER_3_479 VPWR VGND sg13cmos5l_decap_8
XANTENNA__548__X Tile_X1Y0_SS4BEG[13] VPWR VGND sg13cmos5l_antennanp
XFILLER_15_520 VPWR VGND sg13cmos5l_decap_8
XFILLER_15_597 VPWR VGND sg13cmos5l_fill_1
XFILLER_11_770 VPWR VGND sg13cmos5l_fill_1
X_307_ _307_/Q Tile_X0Y0_FrameData[14] VGND VPWR Tile_X0Y0_FrameStrobe[1] latch
X_238_ _238_/Q Tile_X0Y0_UserCLK _238_/D _363_/L_HI VPWR VGND sg13cmos5l_dfrbpq_1
X_169_ _169_/Q Tile_X0Y0_FrameData[15] VGND VPWR Tile_X1Y0_FrameStrobe[1] latch
XANTENNA__458__X Tile_X1Y0_FrameData_O[11] VPWR VGND sg13cmos5l_antennanp
XFILLER_0_449 VPWR VGND sg13cmos5l_fill_1
XFILLER_12_512 VPWR VGND sg13cmos5l_decap_8
XFILLER_12_589 VPWR VGND sg13cmos5l_decap_8
XFILLER_6_28 VPWR VGND sg13cmos5l_decap_8
XFILLER_0_950 VPWR VGND sg13cmos5l_decap_8
XFILLER_10_70 VPWR VGND sg13cmos5l_decap_8
XFILLER_4_733 VPWR VGND sg13cmos5l_decap_8
XFILLER_3_254 VPWR VGND sg13cmos5l_fill_2
XFILLER_3_243 VPWR VGND sg13cmos5l_decap_8
XFILLER_15_394 VPWR VGND sg13cmos5l_decap_8
XFILLER_5_519 VPWR VGND sg13cmos5l_decap_8
XFILLER_0_235 VPWR VGND sg13cmos5l_decap_8
XFILLER_1_758 VPWR VGND sg13cmos5l_decap_8
X_641_ _641_/X Tile_X0Y0_N2MID[3] Tile_X0Y0_N2END[4] Tile_X0Y0_N4END[11] Tile_X0Y0_NN4END[11]
+ _263_/Q _262_/Q VPWR VGND sg13cmos5l_mux4_1
X_572_ _572_/X Tile_X0Y0_N2MID[4] Tile_X0Y0_N4END[11] Tile_X0Y0_NN4END[4] _119_/X
+ _325_/Q _324_/Q VPWR VGND sg13cmos5l_mux4_1
XFILLER_5_1032 VPWR VGND sg13cmos5l_decap_8
XFILLER_13_832 VPWR VGND sg13cmos5l_fill_1
XFILLER_16_136 VPWR VGND sg13cmos5l_decap_8
XFILLER_9_836 VPWR VGND sg13cmos5l_fill_1
XFILLER_12_386 VPWR VGND sg13cmos5l_decap_8
XFILLER_4_585 VPWR VGND sg13cmos5l_decap_8
XANTENNA__471__X Tile_X1Y0_FrameData_O[24] VPWR VGND sg13cmos5l_antennanp
XFILLER_11_1048 VPWR VGND sg13cmos5l_decap_8
XANTENNA_208 Tile_X0Y0_FrameData[25] VPWR VGND sg13cmos5l_antennanp
XANTENNA_219 Tile_X0Y0_FrameData[3] VPWR VGND sg13cmos5l_antennanp
XANTENNA__381__X Tile_X0Y0_SS4BEG[6] VPWR VGND sg13cmos5l_antennanp
XFILLER_6_839 VPWR VGND sg13cmos5l_decap_8
XFILLER_5_316 VPWR VGND sg13cmos5l_decap_4
XFILLER_1_533 VPWR VGND sg13cmos5l_decap_8
X_624_ _624_/X Tile_X1Y0_N2END[0] Tile_X1Y0_N4END[0] Tile_X1Y0_NN4END[15] _064_/X
+ _172_/Q _171_/Q VPWR VGND sg13cmos5l_mux4_1
X_555_ _555_/X Tile_X1Y0_N2MID[0] Tile_X1Y0_N2END[7] Tile_X1Y0_N4END[8] Tile_X1Y0_NN4END[8]
+ _140_/Q _139_/Q VPWR VGND sg13cmos5l_mux4_1
XFILLER_12_183 VPWR VGND sg13cmos5l_decap_8
XFILLER_13_651 VPWR VGND sg13cmos5l_decap_8
XFILLER_16_91 VPWR VGND sg13cmos5l_decap_8
X_486_ Tile_X1Y0_FrameStrobe_O[7] Tile_X1Y0_FrameStrobe[7] VPWR VGND sg13cmos5l_buf_1
XFILLER_8_143 VPWR VGND sg13cmos5l_decap_8
XFILLER_10_1081 VPWR VGND sg13cmos5l_decap_8
XFILLER_5_861 VPWR VGND sg13cmos5l_fill_2
XANTENNA__466__X Tile_X1Y0_FrameData_O[19] VPWR VGND sg13cmos5l_antennanp
XFILLER_3_809 VPWR VGND sg13cmos5l_decap_8
XANTENNA__376__X Tile_X0Y0_SS4BEG[1] VPWR VGND sg13cmos5l_antennanp
XFILLER_2_1046 VPWR VGND sg13cmos5l_decap_8
XFILLER_10_654 VPWR VGND sg13cmos5l_decap_8
XFILLER_14_448 VPWR VGND sg13cmos5l_decap_8
X_271_ _271_/Q Tile_X0Y0_FrameData[18] VGND VPWR Tile_X0Y0_FrameStrobe[0] latch
X_340_ _340_/Q Tile_X0Y0_FrameData[13] VGND VPWR Tile_X0Y0_FrameStrobe[2] latch
XFILLER_6_647 VPWR VGND sg13cmos5l_decap_8
XFILLER_2_897 VPWR VGND sg13cmos5l_decap_8
X_538_ Tile_X1Y0_SS4BEG[3] _627_/X VPWR VGND sg13cmos5l_buf_1
X_607_ _607_/X Tile_X1Y0_N1END[3] Tile_X1Y0_N2MID[7] Tile_X1Y0_N2END[0] _085_/X _206_/Q
+ _205_/Q VPWR VGND sg13cmos5l_mux4_1
X_469_ Tile_X1Y0_FrameData_O[22] Tile_X0Y0_FrameData[22] VPWR VGND sg13cmos5l_buf_1
XFILLER_9_441 VPWR VGND sg13cmos5l_decap_8
XFILLER_4_83 VPWR VGND sg13cmos5l_decap_8
XFILLER_3_7 VPWR VGND sg13cmos5l_decap_8
XFILLER_14_245 VPWR VGND sg13cmos5l_decap_8
XFILLER_15_713 VPWR VGND sg13cmos5l_decap_8
XFILLER_10_451 VPWR VGND sg13cmos5l_decap_8
XFILLER_13_70 VPWR VGND sg13cmos5l_decap_8
X_323_ _323_/Q Tile_X0Y0_FrameData[30] VGND VPWR Tile_X0Y0_FrameStrobe[2] latch
X_254_ _254_/Q Tile_X0Y0_UserCLK _555_/X _369_/L_HI VPWR VGND sg13cmos5l_dfrbpq_1
X_185_ _185_/Q Tile_X0Y0_FrameData[31] VGND VPWR Tile_X1Y0_FrameStrobe[2] latch
XFILLER_9_28 VPWR VGND sg13cmos5l_decap_8
XFILLER_7_923 VPWR VGND sg13cmos5l_fill_1
XFILLER_6_444 VPWR VGND sg13cmos5l_decap_8
XFILLER_1_182 VPWR VGND sg13cmos5l_decap_8
XFILLER_1_193 VPWR VGND sg13cmos5l_fill_1
XANTENNA_380 Tile_X0Y0_FrameData[5] VPWR VGND sg13cmos5l_antennanp
XFILLER_12_738 VPWR VGND sg13cmos5l_decap_8
XFILLER_12_749 VPWR VGND sg13cmos5l_fill_2
XFILLER_7_208 VPWR VGND sg13cmos5l_fill_2
XFILLER_4_937 VPWR VGND sg13cmos5l_decap_4
XFILLER_3_458 VPWR VGND sg13cmos5l_decap_8
XFILLER_15_576 VPWR VGND sg13cmos5l_decap_8
X_306_ _306_/Q Tile_X0Y0_FrameData[15] VGND VPWR Tile_X0Y0_FrameStrobe[1] latch
XFILLER_10_292 VPWR VGND sg13cmos5l_fill_2
X_237_ _237_/Q Tile_X0Y0_UserCLK _237_/D _367_/L_HI VPWR VGND sg13cmos5l_dfrbpq_1
X_168_ _168_/Q Tile_X0Y0_FrameData[16] VGND VPWR Tile_X1Y0_FrameStrobe[1] latch
X_099_ _099_/Y _120_/A _249_/D _098_/X VPWR VGND sg13cmos5l_o21ai_1
XANTENNA__474__X Tile_X1Y0_FrameData_O[27] VPWR VGND sg13cmos5l_antennanp
XFILLER_14_1046 VPWR VGND sg13cmos5l_decap_4
XFILLER_0_428 VPWR VGND sg13cmos5l_fill_2
XFILLER_1_918 VPWR VGND sg13cmos5l_fill_2
XANTENNA__384__X Tile_X0Y0_SS4BEG[9] VPWR VGND sg13cmos5l_antennanp
XFILLER_16_318 VPWR VGND sg13cmos5l_decap_4
XFILLER_12_568 VPWR VGND sg13cmos5l_decap_8
XFILLER_8_539 VPWR VGND sg13cmos5l_decap_8
XFILLER_4_712 VPWR VGND sg13cmos5l_decap_8
XFILLER_4_789 VPWR VGND sg13cmos5l_decap_8
XFILLER_3_277 VPWR VGND sg13cmos5l_decap_8
XFILLER_15_373 VPWR VGND sg13cmos5l_decap_8
XFILLER_7_594 VPWR VGND sg13cmos5l_decap_8
XANTENNA__469__X Tile_X1Y0_FrameData_O[22] VPWR VGND sg13cmos5l_antennanp
XFILLER_15_49 VPWR VGND sg13cmos5l_decap_8
XANTENNA__379__X Tile_X0Y0_SS4BEG[4] VPWR VGND sg13cmos5l_antennanp
XFILLER_16_115 VPWR VGND sg13cmos5l_decap_8
X_640_ _640_/X Tile_X0Y0_N2MID[1] Tile_X0Y0_N2END[6] Tile_X0Y0_N4END[9] Tile_X0Y0_NN4END[9]
+ _267_/Q _266_/Q VPWR VGND sg13cmos5l_mux4_1
X_571_ _571_/X Tile_X0Y0_N2MID[3] Tile_X0Y0_N4END[12] Tile_X0Y0_NN4END[3] _092_/X
+ _327_/Q _326_/Q VPWR VGND sg13cmos5l_mux4_1
XFILLER_5_1088 VPWR VGND sg13cmos5l_fill_1
XFILLER_5_1011 VPWR VGND sg13cmos5l_decap_8
XFILLER_12_365 VPWR VGND sg13cmos5l_decap_8
XFILLER_13_800 VPWR VGND sg13cmos5l_fill_1
XFILLER_13_822 VPWR VGND sg13cmos5l_fill_2
XFILLER_13_888 VPWR VGND sg13cmos5l_decap_4
XFILLER_9_826 VPWR VGND sg13cmos5l_fill_2
XFILLER_4_564 VPWR VGND sg13cmos5l_decap_8
XFILLER_11_1016 VPWR VGND sg13cmos5l_decap_8
XANTENNA_209 Tile_X0Y0_FrameData[25] VPWR VGND sg13cmos5l_antennanp
XFILLER_6_818 VPWR VGND sg13cmos5l_decap_8
XFILLER_1_512 VPWR VGND sg13cmos5l_decap_8
XFILLER_1_589 VPWR VGND sg13cmos5l_decap_8
XFILLER_16_70 VPWR VGND sg13cmos5l_decap_8
X_485_ Tile_X1Y0_FrameStrobe_O[6] Tile_X1Y0_FrameStrobe[6] VPWR VGND sg13cmos5l_buf_1
X_623_ _623_/X Tile_X1Y0_N2MID[7] Tile_X1Y0_N4END[0] Tile_X1Y0_NN4END[15] _089_/X
+ _174_/Q _173_/Q VPWR VGND sg13cmos5l_mux4_1
X_554_ _554_/X Tile_X0Y0_N2MID[4] Tile_X0Y0_N2END[3] Tile_X0Y0_N4END[12] Tile_X0Y0_NN4END[12]
+ _261_/Q _260_/Q VPWR VGND sg13cmos5l_mux4_1
XFILLER_12_162 VPWR VGND sg13cmos5l_decap_8
XFILLER_13_630 VPWR VGND sg13cmos5l_decap_8
XFILLER_13_685 VPWR VGND sg13cmos5l_decap_4
XFILLER_9_689 VPWR VGND sg13cmos5l_fill_1
XFILLER_9_678 VPWR VGND sg13cmos5l_decap_8
XFILLER_9_623 VPWR VGND sg13cmos5l_decap_4
XFILLER_10_1060 VPWR VGND sg13cmos5l_decap_8
XANTENNA__482__X Tile_X1Y0_FrameStrobe_O[3] VPWR VGND sg13cmos5l_antennanp
XFILLER_12_39 VPWR VGND sg13cmos5l_decap_8
XFILLER_14_427 VPWR VGND sg13cmos5l_decap_8
XFILLER_2_1025 VPWR VGND sg13cmos5l_decap_8
XANTENNA__392__X Tile_X0Y0_FrameStrobe_O[1] VPWR VGND sg13cmos5l_antennanp
XFILLER_10_633 VPWR VGND sg13cmos5l_decap_8
X_270_ _270_/Q Tile_X0Y0_FrameData[19] VGND VPWR Tile_X0Y0_FrameStrobe[0] latch
XFILLER_6_626 VPWR VGND sg13cmos5l_decap_8
XFILLER_2_854 VPWR VGND sg13cmos5l_fill_1
X_468_ Tile_X1Y0_FrameData_O[21] Tile_X0Y0_FrameData[21] VPWR VGND sg13cmos5l_buf_1
X_537_ Tile_X1Y0_SS4BEG[2] _626_/X VPWR VGND sg13cmos5l_buf_1
X_606_ _606_/X Tile_X1Y0_N1END[2] Tile_X1Y0_N2MID[6] Tile_X1Y0_N2END[1] _087_/X _208_/Q
+ _207_/Q VPWR VGND sg13cmos5l_mux4_1
XFILLER_12_1100 VPWR VGND sg13cmos5l_fill_1
X_399_ Tile_X0Y0_FrameStrobe_O[8] Tile_X0Y0_FrameStrobe[8] VPWR VGND sg13cmos5l_buf_1
XFILLER_9_497 VPWR VGND sg13cmos5l_decap_8
XFILLER_9_420 VPWR VGND sg13cmos5l_decap_8
XFILLER_5_681 VPWR VGND sg13cmos5l_decap_4
XFILLER_4_180 VPWR VGND sg13cmos5l_decap_8
XANTENNA__477__X Tile_X1Y0_FrameData_O[30] VPWR VGND sg13cmos5l_antennanp
XFILLER_1_1091 VPWR VGND sg13cmos5l_decap_4
XFILLER_3_629 VPWR VGND sg13cmos5l_decap_8
XANTENNA__387__X Tile_X0Y0_SS4BEG[12] VPWR VGND sg13cmos5l_antennanp
XFILLER_14_224 VPWR VGND sg13cmos5l_decap_8
XFILLER_14_268 VPWR VGND sg13cmos5l_fill_1
XFILLER_15_736 VPWR VGND sg13cmos5l_decap_4
X_322_ _322_/Q Tile_X0Y0_FrameData[31] VGND VPWR Tile_X0Y0_FrameStrobe[2] latch
XFILLER_10_430 VPWR VGND sg13cmos5l_decap_8
X_253_ _253_/Q Tile_X0Y0_UserCLK _554_/X _372_/L_HI VPWR VGND sg13cmos5l_dfrbpq_1
X_184_ _184_/Q Tile_X0Y0_FrameData[0] VGND VPWR Tile_X1Y0_FrameStrobe[1] latch
XFILLER_7_979 VPWR VGND sg13cmos5l_fill_1
XFILLER_6_423 VPWR VGND sg13cmos5l_decap_8
XFILLER_2_684 VPWR VGND sg13cmos5l_fill_2
XANTENNA_370 Tile_X0Y0_FrameData[24] VPWR VGND sg13cmos5l_antennanp
XFILLER_9_250 VPWR VGND sg13cmos5l_fill_1
XFILLER_11_205 VPWR VGND sg13cmos5l_decap_8
XFILLER_8_1064 VPWR VGND sg13cmos5l_decap_8
XFILLER_15_555 VPWR VGND sg13cmos5l_decap_8
X_305_ _305_/Q Tile_X0Y0_FrameData[16] VGND VPWR Tile_X0Y0_FrameStrobe[1] latch
X_236_ _236_/Q Tile_X0Y0_UserCLK _236_/D _366_/L_HI VPWR VGND sg13cmos5l_dfrbpq_1
X_167_ _167_/Q Tile_X0Y0_FrameData[17] VGND VPWR Tile_X1Y0_FrameStrobe[1] latch
X_098_ _098_/X _233_/Q _249_/Q VPWR VGND sg13cmos5l_or2_1
XFILLER_7_710 VPWR VGND sg13cmos5l_decap_4
XFILLER_6_286 VPWR VGND sg13cmos5l_decap_8
XFILLER_1_63 VPWR VGND sg13cmos5l_decap_8
XANTENNA__490__X Tile_X1Y0_FrameStrobe_O[11] VPWR VGND sg13cmos5l_antennanp
XFILLER_14_1014 VPWR VGND sg13cmos5l_decap_8
XFILLER_14_1069 VPWR VGND sg13cmos5l_decap_8
XFILLER_12_547 VPWR VGND sg13cmos5l_decap_8
XFILLER_8_518 VPWR VGND sg13cmos5l_decap_8
XFILLER_4_757 VPWR VGND sg13cmos5l_decap_4
XFILLER_0_930 VPWR VGND sg13cmos5l_fill_1
XFILLER_15_352 VPWR VGND sg13cmos5l_decap_8
XFILLER_11_591 VPWR VGND sg13cmos5l_decap_8
X_219_ _219_/Q Tile_X0Y0_FrameData[29] VGND VPWR Tile_X1Y0_FrameStrobe[3] latch
XFILLER_13_1091 VPWR VGND sg13cmos5l_fill_1
XFILLER_7_573 VPWR VGND sg13cmos5l_decap_8
XANTENNA__485__X Tile_X1Y0_FrameStrobe_O[6] VPWR VGND sg13cmos5l_antennanp
XFILLER_0_1112 VPWR VGND sg13cmos5l_fill_2
XFILLER_15_28 VPWR VGND sg13cmos5l_decap_8
XFILLER_0_204 VPWR VGND sg13cmos5l_decap_8
XANTENNA__395__X Tile_X0Y0_FrameStrobe_O[4] VPWR VGND sg13cmos5l_antennanp
X_570_ _570_/X Tile_X0Y0_N2MID[2] Tile_X0Y0_N4END[13] Tile_X0Y0_NN4END[2] _091_/X
+ _329_/Q _328_/Q VPWR VGND sg13cmos5l_mux4_1
XFILLER_5_1067 VPWR VGND sg13cmos5l_decap_8
XFILLER_12_344 VPWR VGND sg13cmos5l_decap_8
XFILLER_4_543 VPWR VGND sg13cmos5l_decap_8
XFILLER_11_7 VPWR VGND sg13cmos5l_decap_8
XFILLER_15_182 VPWR VGND sg13cmos5l_fill_2
XFILLER_16_694 VPWR VGND sg13cmos5l_decap_8
XFILLER_14_609 VPWR VGND sg13cmos5l_fill_2
XFILLER_13_119 VPWR VGND sg13cmos5l_decap_8
XFILLER_1_568 VPWR VGND sg13cmos5l_decap_8
X_622_ _622_/X Tile_X1Y0_N2MID[6] Tile_X1Y0_N4END[1] Tile_X1Y0_NN4END[14] _064_/X
+ _176_/Q _175_/Q VPWR VGND sg13cmos5l_mux4_1
X_484_ Tile_X1Y0_FrameStrobe_O[5] Tile_X1Y0_FrameStrobe[5] VPWR VGND sg13cmos5l_buf_1
X_553_ _553_/X Tile_X0Y0_N2MID[2] Tile_X0Y0_N2END[5] Tile_X0Y0_N4END[10] Tile_X0Y0_NN4END[10]
+ _265_/Q _264_/Q VPWR VGND sg13cmos5l_mux4_1
XFILLER_9_602 VPWR VGND sg13cmos5l_decap_8
XFILLER_12_141 VPWR VGND sg13cmos5l_decap_8
XFILLER_8_178 VPWR VGND sg13cmos5l_decap_4
XFILLER_8_112 VPWR VGND sg13cmos5l_decap_8
XFILLER_5_830 VPWR VGND sg13cmos5l_fill_2
XFILLER_5_863 VPWR VGND sg13cmos5l_fill_1
XFILLER_12_18 VPWR VGND sg13cmos5l_decap_8
XFILLER_2_1004 VPWR VGND sg13cmos5l_decap_8
XFILLER_14_406 VPWR VGND sg13cmos5l_decap_8
XFILLER_10_612 VPWR VGND sg13cmos5l_decap_8
XFILLER_6_605 VPWR VGND sg13cmos5l_decap_8
XFILLER_2_833 VPWR VGND sg13cmos5l_decap_8
X_605_ _605_/X Tile_X1Y0_N1END[1] Tile_X1Y0_N2MID[5] Tile_X1Y0_N2END[2] _089_/X _210_/Q
+ _209_/Q VPWR VGND sg13cmos5l_mux4_1
XFILLER_13_483 VPWR VGND sg13cmos5l_decap_8
X_398_ Tile_X0Y0_FrameStrobe_O[7] Tile_X0Y0_FrameStrobe[7] VPWR VGND sg13cmos5l_buf_1
X_467_ Tile_X1Y0_FrameData_O[20] Tile_X0Y0_FrameData[20] VPWR VGND sg13cmos5l_buf_1
X_536_ Tile_X1Y0_SS4BEG[1] _625_/X VPWR VGND sg13cmos5l_buf_1
XFILLER_12_1112 VPWR VGND sg13cmos5l_fill_2
XFILLER_9_476 VPWR VGND sg13cmos5l_decap_8
XFILLER_4_63 VPWR VGND sg13cmos5l_decap_4
XANTENNA__493__X Tile_X1Y0_FrameStrobe_O[14] VPWR VGND sg13cmos5l_antennanp
XFILLER_1_1070 VPWR VGND sg13cmos5l_decap_8
XFILLER_11_409 VPWR VGND sg13cmos5l_decap_8
XFILLER_11_921 VPWR VGND sg13cmos5l_fill_1
XFILLER_14_203 VPWR VGND sg13cmos5l_decap_8
X_321_ _321_/Q Tile_X0Y0_FrameData[0] VGND VPWR Tile_X0Y0_FrameStrobe[1] latch
X_252_ _252_/Q Tile_X0Y0_UserCLK _553_/X _371_/L_HI VPWR VGND sg13cmos5l_dfrbpq_1
XFILLER_10_486 VPWR VGND sg13cmos5l_decap_8
X_183_ _183_/Q Tile_X0Y0_FrameData[1] VGND VPWR Tile_X1Y0_FrameStrobe[1] latch
XFILLER_6_479 VPWR VGND sg13cmos5l_decap_8
XFILLER_1_140 VPWR VGND sg13cmos5l_fill_1
XFILLER_2_641 VPWR VGND sg13cmos5l_decap_4
XANTENNA_360 Tile_X0Y0_FrameData[24] VPWR VGND sg13cmos5l_antennanp
XANTENNA_371 Tile_X0Y0_FrameData[24] VPWR VGND sg13cmos5l_antennanp
XFILLER_13_280 VPWR VGND sg13cmos5l_decap_8
X_519_ Tile_X1Y0_S4BEG[0] _608_/X VPWR VGND sg13cmos5l_buf_1
XFILLER_6_980 VPWR VGND sg13cmos5l_decap_8
XANTENNA__488__X Tile_X1Y0_FrameStrobe_O[9] VPWR VGND sg13cmos5l_antennanp
XFILLER_3_427 VPWR VGND sg13cmos5l_decap_8
XANTENNA__398__X Tile_X0Y0_FrameStrobe_O[7] VPWR VGND sg13cmos5l_antennanp
XFILLER_8_1043 VPWR VGND sg13cmos5l_decap_8
XFILLER_15_534 VPWR VGND sg13cmos5l_decap_8
XFILLER_10_261 VPWR VGND sg13cmos5l_decap_8
X_304_ _304_/Q Tile_X0Y0_FrameData[17] VGND VPWR Tile_X0Y0_FrameStrobe[1] latch
X_235_ _235_/Q Tile_X0Y0_UserCLK _235_/D _368_/L_HI VPWR VGND sg13cmos5l_dfrbpq_1
XFILLER_6_210 VPWR VGND sg13cmos5l_fill_2
X_166_ _166_/Q Tile_X0Y0_FrameData[18] VGND VPWR Tile_X1Y0_FrameStrobe[1] latch
X_097_ _097_/X _257_/Q _558_/X _233_/Q VPWR VGND sg13cmos5l_mux2_1
XFILLER_7_777 VPWR VGND sg13cmos5l_fill_1
XFILLER_7_766 VPWR VGND sg13cmos5l_decap_8
XFILLER_6_265 VPWR VGND sg13cmos5l_decap_8
XFILLER_6_254 VPWR VGND sg13cmos5l_decap_4
XFILLER_3_983 VPWR VGND sg13cmos5l_decap_8
XFILLER_1_42 VPWR VGND sg13cmos5l_decap_8
XFILLER_2_493 VPWR VGND sg13cmos5l_decap_8
XANTENNA_190 Tile_X0Y0_FrameData[1] VPWR VGND sg13cmos5l_antennanp
XFILLER_1_909 VPWR VGND sg13cmos5l_fill_2
XFILLER_12_526 VPWR VGND sg13cmos5l_decap_8
XFILLER_0_997 VPWR VGND sg13cmos5l_fill_1
XFILLER_10_84 VPWR VGND sg13cmos5l_decap_8
XFILLER_15_331 VPWR VGND sg13cmos5l_decap_8
XFILLER_11_570 VPWR VGND sg13cmos5l_decap_8
X_218_ _218_/Q Tile_X0Y0_FrameData[30] VGND VPWR Tile_X1Y0_FrameStrobe[3] latch
X_149_ _149_/Q Tile_X0Y0_FrameData[3] VGND VPWR Tile_X1Y0_FrameStrobe[0] latch
XFILLER_7_552 VPWR VGND sg13cmos5l_decap_8
XFILLER_1_728 VPWR VGND sg13cmos5l_fill_2
XFILLER_5_1046 VPWR VGND sg13cmos5l_decap_8
XANTENNA_90 Tile_X0Y0_FrameData[13] VPWR VGND sg13cmos5l_antennanp
XFILLER_12_323 VPWR VGND sg13cmos5l_decap_8
XFILLER_9_828 VPWR VGND sg13cmos5l_fill_1
XFILLER_8_338 VPWR VGND sg13cmos5l_decap_4
XFILLER_8_305 VPWR VGND sg13cmos5l_decap_8
XFILLER_4_599 VPWR VGND sg13cmos5l_decap_8
XFILLER_4_522 VPWR VGND sg13cmos5l_decap_8
XFILLER_0_761 VPWR VGND sg13cmos5l_fill_1
XFILLER_15_161 VPWR VGND sg13cmos5l_decap_8
XFILLER_16_673 VPWR VGND sg13cmos5l_decap_8
XFILLER_7_63 VPWR VGND sg13cmos5l_decap_4
XANTENNA__496__X Tile_X1Y0_FrameStrobe_O[17] VPWR VGND sg13cmos5l_antennanp
XFILLER_1_547 VPWR VGND sg13cmos5l_decap_8
X_621_ _621_/X Tile_X1Y0_N2MID[5] Tile_X1Y0_N4END[2] Tile_X1Y0_NN4END[13] _095_/X
+ _178_/Q _177_/Q VPWR VGND sg13cmos5l_mux4_1
XFILLER_12_120 VPWR VGND sg13cmos5l_decap_8
XFILLER_13_665 VPWR VGND sg13cmos5l_fill_2
X_483_ Tile_X1Y0_FrameStrobe_O[4] Tile_X1Y0_FrameStrobe[4] VPWR VGND sg13cmos5l_buf_1
X_552_ _552_/X Tile_X0Y0_N2MID[0] Tile_X0Y0_N2END[7] Tile_X0Y0_N4END[8] Tile_X0Y0_NN4END[8]
+ _269_/Q _268_/Q VPWR VGND sg13cmos5l_mux4_1
XFILLER_12_197 VPWR VGND sg13cmos5l_decap_8
XFILLER_13_698 VPWR VGND sg13cmos5l_fill_2
XFILLER_8_157 VPWR VGND sg13cmos5l_decap_8
XFILLER_0_580 VPWR VGND sg13cmos5l_decap_8
XFILLER_10_668 VPWR VGND sg13cmos5l_decap_4
XFILLER_5_127 VPWR VGND sg13cmos5l_decap_8
XFILLER_2_801 VPWR VGND sg13cmos5l_decap_4
X_535_ Tile_X1Y0_SS4BEG[0] _624_/X VPWR VGND sg13cmos5l_buf_1
X_604_ _604_/X Tile_X1Y0_N1END[0] Tile_X1Y0_N2MID[4] Tile_X1Y0_N2END[3] _064_/X _212_/Q
+ _211_/Q VPWR VGND sg13cmos5l_mux4_1
XFILLER_13_462 VPWR VGND sg13cmos5l_decap_8
XFILLER_14_963 VPWR VGND sg13cmos5l_fill_2
X_397_ Tile_X0Y0_FrameStrobe_O[6] Tile_X0Y0_FrameStrobe[6] VPWR VGND sg13cmos5l_buf_1
X_466_ Tile_X1Y0_FrameData_O[19] Tile_X0Y0_FrameData[19] VPWR VGND sg13cmos5l_buf_1
XFILLER_9_455 VPWR VGND sg13cmos5l_decap_8
XFILLER_4_42 VPWR VGND sg13cmos5l_decap_8
XFILLER_4_97 VPWR VGND sg13cmos5l_decap_8
XFILLER_15_727 VPWR VGND sg13cmos5l_fill_2
XFILLER_14_259 VPWR VGND sg13cmos5l_decap_8
X_320_ _320_/Q Tile_X0Y0_FrameData[1] VGND VPWR Tile_X0Y0_FrameStrobe[1] latch
X_251_ _251_/Q Tile_X0Y0_UserCLK _552_/X _374_/L_HI VPWR VGND sg13cmos5l_dfrbpq_1
X_182_ _182_/Q Tile_X0Y0_FrameData[2] VGND VPWR Tile_X1Y0_FrameStrobe[1] latch
XFILLER_7_904 VPWR VGND sg13cmos5l_fill_2
XFILLER_10_465 VPWR VGND sg13cmos5l_decap_8
XFILLER_13_84 VPWR VGND sg13cmos5l_decap_8
XFILLER_8_0 VPWR VGND sg13cmos5l_decap_8
XFILLER_6_458 VPWR VGND sg13cmos5l_decap_8
XFILLER_2_686 VPWR VGND sg13cmos5l_fill_1
XANTENNA_350 Tile_X0Y0_FrameData[20] VPWR VGND sg13cmos5l_antennanp
XANTENNA_361 Tile_X0Y0_FrameData[24] VPWR VGND sg13cmos5l_antennanp
XANTENNA_372 Tile_X0Y0_FrameData[24] VPWR VGND sg13cmos5l_antennanp
X_518_ Tile_X1Y0_S2BEGb[7] _607_/X VPWR VGND sg13cmos5l_buf_1
X_449_ Tile_X1Y0_FrameData_O[2] Tile_X0Y0_FrameData[2] VPWR VGND sg13cmos5l_buf_1
XFILLER_9_296 VPWR VGND sg13cmos5l_decap_4
XFILLER_5_491 VPWR VGND sg13cmos5l_decap_8
XFILLER_1_7 VPWR VGND sg13cmos5l_decap_8
XFILLER_8_1022 VPWR VGND sg13cmos5l_decap_8
XFILLER_15_513 VPWR VGND sg13cmos5l_decap_8
XFILLER_10_251 VPWR VGND sg13cmos5l_fill_2
XFILLER_11_741 VPWR VGND sg13cmos5l_fill_1
XFILLER_11_763 VPWR VGND sg13cmos5l_decap_8
X_303_ _303_/Q Tile_X0Y0_FrameData[18] VGND VPWR Tile_X0Y0_FrameStrobe[1] latch
X_234_ _234_/Q Tile_X0Y0_FrameData[27] VGND VPWR Tile_X1Y0_FrameStrobe[3] latch
X_165_ _165_/Q Tile_X0Y0_FrameData[19] VGND VPWR Tile_X1Y0_FrameStrobe[1] latch
XFILLER_6_233 VPWR VGND sg13cmos5l_decap_8
X_096_ _249_/D _646_/X _225_/Q _232_/Q VPWR VGND sg13cmos5l_mux2_1
XFILLER_3_940 VPWR VGND sg13cmos5l_fill_1
XFILLER_2_472 VPWR VGND sg13cmos5l_decap_8
XFILLER_1_21 VPWR VGND sg13cmos5l_decap_8
XANTENNA_180 Tile_X0Y0_FrameData[1] VPWR VGND sg13cmos5l_antennanp
XANTENNA_191 Tile_X0Y0_FrameData[1] VPWR VGND sg13cmos5l_antennanp
XANTENNA__499__X Tile_X1Y0_S1BEG[0] VPWR VGND sg13cmos5l_antennanp
XFILLER_12_505 VPWR VGND sg13cmos5l_decap_8
XFILLER_10_63 VPWR VGND sg13cmos5l_decap_8
XFILLER_4_726 VPWR VGND sg13cmos5l_decap_8
XFILLER_3_236 VPWR VGND sg13cmos5l_decap_8
XFILLER_0_943 VPWR VGND sg13cmos5l_decap_8
XFILLER_0_976 VPWR VGND sg13cmos5l_decap_4
XFILLER_15_310 VPWR VGND sg13cmos5l_decap_8
XFILLER_15_387 VPWR VGND sg13cmos5l_decap_8
XFILLER_13_1082 VPWR VGND sg13cmos5l_decap_8
X_217_ _217_/Q Tile_X0Y0_FrameData[31] VGND VPWR Tile_X1Y0_FrameStrobe[3] latch
X_148_ _148_/Q Tile_X0Y0_FrameData[4] VGND VPWR Tile_X1Y0_FrameStrobe[0] latch
XFILLER_7_531 VPWR VGND sg13cmos5l_decap_8
X_079_ _246_/D _643_/X _228_/Q _232_/Q VPWR VGND sg13cmos5l_mux2_1
XFILLER_0_228 VPWR VGND sg13cmos5l_decap_8
XFILLER_5_1025 VPWR VGND sg13cmos5l_decap_8
XFILLER_12_302 VPWR VGND sg13cmos5l_decap_8
XFILLER_16_129 VPWR VGND sg13cmos5l_decap_8
XANTENNA_80 Tile_X0Y0_FrameData[11] VPWR VGND sg13cmos5l_antennanp
XANTENNA_91 Tile_X0Y0_FrameData[13] VPWR VGND sg13cmos5l_antennanp
XFILLER_12_379 VPWR VGND sg13cmos5l_decap_8
XFILLER_4_501 VPWR VGND sg13cmos5l_decap_8
XFILLER_4_578 VPWR VGND sg13cmos5l_decap_8
XFILLER_0_795 VPWR VGND sg13cmos5l_decap_8
XFILLER_16_652 VPWR VGND sg13cmos5l_decap_8
XFILLER_15_140 VPWR VGND sg13cmos5l_decap_8
XFILLER_15_184 VPWR VGND sg13cmos5l_fill_1
XFILLER_8_851 VPWR VGND sg13cmos5l_decap_8
XFILLER_7_42 VPWR VGND sg13cmos5l_decap_8
XFILLER_7_394 VPWR VGND sg13cmos5l_decap_8
XFILLER_7_350 VPWR VGND sg13cmos5l_decap_4
XFILLER_4_1080 VPWR VGND sg13cmos5l_decap_8
XFILLER_1_526 VPWR VGND sg13cmos5l_decap_8
X_551_ Tile_X1Y0_UserCLKo Tile_X0Y0_UserCLK VPWR VGND sg13cmos5l_buf_1
X_620_ _620_/X Tile_X1Y0_N2MID[4] Tile_X1Y0_N4END[3] Tile_X1Y0_NN4END[12] _085_/X
+ _180_/Q _179_/Q VPWR VGND sg13cmos5l_mux4_1
XFILLER_12_176 VPWR VGND sg13cmos5l_decap_8
XFILLER_13_644 VPWR VGND sg13cmos5l_decap_8
XFILLER_16_84 VPWR VGND sg13cmos5l_decap_8
X_482_ Tile_X1Y0_FrameStrobe_O[3] Tile_X1Y0_FrameStrobe[3] VPWR VGND sg13cmos5l_buf_1
XFILLER_8_136 VPWR VGND sg13cmos5l_decap_8
XFILLER_10_1074 VPWR VGND sg13cmos5l_decap_8
XFILLER_5_832 VPWR VGND sg13cmos5l_fill_1
XFILLER_4_331 VPWR VGND sg13cmos5l_decap_8
XFILLER_16_482 VPWR VGND sg13cmos5l_decap_8
XFILLER_16_493 VPWR VGND sg13cmos5l_decap_8
XFILLER_2_1039 VPWR VGND sg13cmos5l_decap_8
XFILLER_10_647 VPWR VGND sg13cmos5l_decap_8
XFILLER_5_106 VPWR VGND sg13cmos5l_fill_2
X_465_ Tile_X1Y0_FrameData_O[18] Tile_X0Y0_FrameData[18] VPWR VGND sg13cmos5l_buf_1
X_534_ Tile_X1Y0_S4BEG[15] _623_/X VPWR VGND sg13cmos5l_buf_1
X_603_ _603_/X Tile_X1Y0_N1END[3] Tile_X1Y0_N2MID[3] Tile_X1Y0_N2END[4] _095_/X _214_/Q
+ _213_/Q VPWR VGND sg13cmos5l_mux4_1
XFILLER_13_441 VPWR VGND sg13cmos5l_decap_8
XFILLER_14_975 VPWR VGND sg13cmos5l_decap_8
X_396_ Tile_X0Y0_FrameStrobe_O[5] Tile_X0Y0_FrameStrobe[5] VPWR VGND sg13cmos5l_buf_1
XFILLER_9_434 VPWR VGND sg13cmos5l_decap_8
XANTENNA__104__Y PMOD_IO_OE_O5 VPWR VGND sg13cmos5l_antennanp
XFILLER_5_673 VPWR VGND sg13cmos5l_fill_1
XFILLER_4_76 VPWR VGND sg13cmos5l_decap_8
XFILLER_4_21 VPWR VGND sg13cmos5l_decap_8
XFILLER_14_238 VPWR VGND sg13cmos5l_fill_2
XFILLER_15_706 VPWR VGND sg13cmos5l_decap_8
XFILLER_10_444 VPWR VGND sg13cmos5l_decap_8
XFILLER_13_63 VPWR VGND sg13cmos5l_decap_8
X_250_ _250_/Q Tile_X0Y0_UserCLK _250_/D _373_/L_HI VPWR VGND sg13cmos5l_dfrbpq_1
X_181_ _181_/Q Tile_X0Y0_FrameData[3] VGND VPWR Tile_X1Y0_FrameStrobe[1] latch
XFILLER_7_938 VPWR VGND sg13cmos5l_fill_1
XFILLER_6_437 VPWR VGND sg13cmos5l_decap_8
XFILLER_2_654 VPWR VGND sg13cmos5l_fill_2
XFILLER_1_197 VPWR VGND sg13cmos5l_decap_8
XANTENNA_340 Tile_X0Y0_N2MID[4] VPWR VGND sg13cmos5l_antennanp
XANTENNA_351 Tile_X0Y0_FrameData[20] VPWR VGND sg13cmos5l_antennanp
XANTENNA_362 Tile_X0Y0_FrameData[24] VPWR VGND sg13cmos5l_antennanp
XANTENNA_373 Tile_X0Y0_FrameData[5] VPWR VGND sg13cmos5l_antennanp
XFILLER_14_750 VPWR VGND sg13cmos5l_decap_8
X_448_ Tile_X1Y0_FrameData_O[1] Tile_X0Y0_FrameData[1] VPWR VGND sg13cmos5l_buf_1
X_517_ Tile_X1Y0_S2BEGb[6] _606_/X VPWR VGND sg13cmos5l_buf_1
X_379_ Tile_X0Y0_SS4BEG[4] _588_/X VPWR VGND sg13cmos5l_buf_1
XFILLER_5_470 VPWR VGND sg13cmos5l_decap_8
XFILLER_3_1112 VPWR VGND sg13cmos5l_fill_2
XFILLER_11_219 VPWR VGND sg13cmos5l_decap_8
XFILLER_12_709 VPWR VGND sg13cmos5l_fill_1
XFILLER_8_1078 VPWR VGND sg13cmos5l_decap_8
XFILLER_8_1001 VPWR VGND sg13cmos5l_decap_8
XFILLER_15_569 VPWR VGND sg13cmos5l_decap_8
X_302_ _302_/Q Tile_X0Y0_FrameData[19] VGND VPWR Tile_X0Y0_FrameStrobe[1] latch
X_233_ _233_/Q Tile_X0Y0_FrameData[26] VGND VPWR Tile_X1Y0_FrameStrobe[3] latch
X_164_ _164_/Q Tile_X0Y0_FrameData[20] VGND VPWR Tile_X1Y0_FrameStrobe[1] latch
X_095_ _095_/X _241_/Q _241_/D _234_/Q VPWR VGND sg13cmos5l_mux2_1
XFILLER_7_735 VPWR VGND sg13cmos5l_fill_2
XFILLER_2_451 VPWR VGND sg13cmos5l_decap_8
XANTENNA_170 Tile_X0Y0_FrameData[1] VPWR VGND sg13cmos5l_antennanp
XANTENNA_181 Tile_X0Y0_FrameData[1] VPWR VGND sg13cmos5l_antennanp
XANTENNA_192 Tile_X0Y0_FrameData[1] VPWR VGND sg13cmos5l_antennanp
XFILLER_14_1028 VPWR VGND sg13cmos5l_fill_1
XFILLER_14_1039 VPWR VGND sg13cmos5l_decap_8
XFILLER_4_705 VPWR VGND sg13cmos5l_decap_8
XFILLER_10_42 VPWR VGND sg13cmos5l_decap_8
XFILLER_15_366 VPWR VGND sg13cmos5l_decap_8
XFILLER_13_1061 VPWR VGND sg13cmos5l_decap_8
X_216_ _216_/Q Tile_X0Y0_FrameData[0] VGND VPWR Tile_X1Y0_FrameStrobe[2] latch
X_147_ _147_/Q Tile_X0Y0_FrameData[5] VGND VPWR Tile_X1Y0_FrameStrobe[0] latch
X_078_ _248_/D _645_/X _226_/Q _232_/Q VPWR VGND sg13cmos5l_mux2_1
XFILLER_7_587 VPWR VGND sg13cmos5l_decap_8
XFILLER_7_510 VPWR VGND sg13cmos5l_decap_8
XANTENNA__112__Y PMOD_IO_O2 VPWR VGND sg13cmos5l_antennanp
XFILLER_3_793 VPWR VGND sg13cmos5l_fill_1
XFILLER_0_1104 VPWR VGND sg13cmos5l_fill_2
XFILLER_0_218 VPWR VGND sg13cmos5l_decap_8
XFILLER_16_108 VPWR VGND sg13cmos5l_decap_8
XFILLER_5_1004 VPWR VGND sg13cmos5l_decap_8
XFILLER_12_358 VPWR VGND sg13cmos5l_decap_8
XFILLER_9_819 VPWR VGND sg13cmos5l_decap_8
XFILLER_9_808 VPWR VGND sg13cmos5l_decap_4
XANTENNA_70 Tile_X0Y0_FrameData[11] VPWR VGND sg13cmos5l_antennanp
XANTENNA_81 Tile_X0Y0_FrameData[11] VPWR VGND sg13cmos5l_antennanp
XANTENNA_92 Tile_X0Y0_FrameData[13] VPWR VGND sg13cmos5l_antennanp
XFILLER_4_557 VPWR VGND sg13cmos5l_decap_8
XFILLER_0_752 VPWR VGND sg13cmos5l_decap_8
XFILLER_16_620 VPWR VGND sg13cmos5l_fill_1
XFILLER_11_1009 VPWR VGND sg13cmos5l_decap_8
XFILLER_15_1112 VPWR VGND sg13cmos5l_fill_2
XFILLER_15_196 VPWR VGND sg13cmos5l_decap_8
XFILLER_7_21 VPWR VGND sg13cmos5l_decap_8
XFILLER_7_384 VPWR VGND sg13cmos5l_fill_2
XFILLER_16_0 VPWR VGND sg13cmos5l_decap_8
XFILLER_1_505 VPWR VGND sg13cmos5l_decap_8
X_481_ Tile_X1Y0_FrameStrobe_O[2] Tile_X1Y0_FrameStrobe[2] VPWR VGND sg13cmos5l_buf_1
X_550_ Tile_X1Y0_SS4BEG[15] _639_/X VPWR VGND sg13cmos5l_buf_1
XFILLER_12_155 VPWR VGND sg13cmos5l_decap_8
XFILLER_13_623 VPWR VGND sg13cmos5l_decap_8
XFILLER_13_678 VPWR VGND sg13cmos5l_decap_8
XFILLER_13_689 VPWR VGND sg13cmos5l_fill_2
XFILLER_16_63 VPWR VGND sg13cmos5l_decap_8
XFILLER_9_627 VPWR VGND sg13cmos5l_fill_2
XFILLER_9_616 VPWR VGND sg13cmos5l_decap_8
XFILLER_8_126 VPWR VGND sg13cmos5l_fill_2
XFILLER_10_1020 VPWR VGND sg13cmos5l_decap_8
XFILLER_10_1053 VPWR VGND sg13cmos5l_decap_8
XFILLER_5_822 VPWR VGND sg13cmos5l_decap_4
XFILLER_4_310 VPWR VGND sg13cmos5l_decap_8
XFILLER_2_1018 VPWR VGND sg13cmos5l_decap_8
XFILLER_10_626 VPWR VGND sg13cmos5l_decap_8
XFILLER_6_619 VPWR VGND sg13cmos5l_decap_8
XFILLER_2_847 VPWR VGND sg13cmos5l_decap_8
XFILLER_1_368 VPWR VGND sg13cmos5l_fill_1
X_602_ _602_/X Tile_X1Y0_N1END[2] Tile_X1Y0_N2MID[2] Tile_X1Y0_N2END[5] _085_/X _216_/Q
+ _215_/Q VPWR VGND sg13cmos5l_mux4_1
XFILLER_2_869 VPWR VGND sg13cmos5l_decap_8
XFILLER_13_420 VPWR VGND sg13cmos5l_decap_8
X_464_ Tile_X1Y0_FrameData_O[17] Tile_X0Y0_FrameData[17] VPWR VGND sg13cmos5l_buf_1
X_533_ Tile_X1Y0_S4BEG[14] _622_/X VPWR VGND sg13cmos5l_buf_1
XFILLER_12_1104 VPWR VGND sg13cmos5l_fill_2
XFILLER_13_497 VPWR VGND sg13cmos5l_decap_8
XFILLER_14_987 VPWR VGND sg13cmos5l_fill_1
X_395_ Tile_X0Y0_FrameStrobe_O[4] Tile_X0Y0_FrameStrobe[4] VPWR VGND sg13cmos5l_buf_1
XFILLER_9_413 VPWR VGND sg13cmos5l_decap_8
XANTENNA__401__X Tile_X0Y0_FrameStrobe_O[10] VPWR VGND sg13cmos5l_antennanp
XFILLER_5_685 VPWR VGND sg13cmos5l_fill_1
XFILLER_4_173 VPWR VGND sg13cmos5l_decap_8
XFILLER_4_140 VPWR VGND sg13cmos5l_decap_4
XFILLER_1_1084 VPWR VGND sg13cmos5l_decap_8
XFILLER_1_1095 VPWR VGND sg13cmos5l_fill_2
XFILLER_8_490 VPWR VGND sg13cmos5l_decap_8
XFILLER_14_217 VPWR VGND sg13cmos5l_decap_8
XFILLER_10_423 VPWR VGND sg13cmos5l_decap_8
XFILLER_13_42 VPWR VGND sg13cmos5l_decap_8
X_180_ _180_/Q Tile_X0Y0_FrameData[4] VGND VPWR Tile_X1Y0_FrameStrobe[1] latch
XFILLER_6_416 VPWR VGND sg13cmos5l_decap_8
XFILLER_2_677 VPWR VGND sg13cmos5l_decap_8
XANTENNA_330 Tile_X0Y0_FrameData[9] VPWR VGND sg13cmos5l_antennanp
XANTENNA_341 Tile_X0Y0_N2MID[4] VPWR VGND sg13cmos5l_antennanp
XANTENNA_352 Tile_X0Y0_FrameData[20] VPWR VGND sg13cmos5l_antennanp
XANTENNA_363 Tile_X0Y0_FrameData[24] VPWR VGND sg13cmos5l_antennanp
XANTENNA_374 Tile_X0Y0_FrameData[5] VPWR VGND sg13cmos5l_antennanp
XFILLER_13_294 VPWR VGND sg13cmos5l_decap_8
X_378_ Tile_X0Y0_SS4BEG[3] _587_/X VPWR VGND sg13cmos5l_buf_1
X_447_ Tile_X1Y0_FrameData_O[0] Tile_X0Y0_FrameData[0] VPWR VGND sg13cmos5l_buf_1
X_516_ Tile_X1Y0_S2BEGb[5] _605_/X VPWR VGND sg13cmos5l_buf_1
XANTENNA__115__Y PMOD_IO_O5 VPWR VGND sg13cmos5l_antennanp
XFILLER_10_990 VPWR VGND sg13cmos5l_fill_2
XFILLER_16_1070 VPWR VGND sg13cmos5l_decap_8
XFILLER_6_994 VPWR VGND sg13cmos5l_decap_8
XFILLER_8_1057 VPWR VGND sg13cmos5l_decap_8
XFILLER_11_732 VPWR VGND sg13cmos5l_fill_2
XFILLER_15_548 VPWR VGND sg13cmos5l_decap_8
X_301_ _301_/Q Tile_X0Y0_FrameData[20] VGND VPWR Tile_X0Y0_FrameStrobe[1] latch
X_232_ _232_/Q Tile_X0Y0_FrameData[25] VGND VPWR Tile_X1Y0_FrameStrobe[3] latch
XFILLER_10_253 VPWR VGND sg13cmos5l_fill_1
X_163_ _163_/Q Tile_X0Y0_FrameData[21] VGND VPWR Tile_X1Y0_FrameStrobe[1] latch
X_094_ _241_/D PMOD_IO_I6 _558_/X _222_/Q VPWR VGND sg13cmos5l_mux2_1
XFILLER_7_703 VPWR VGND sg13cmos5l_decap_8
XFILLER_6_279 VPWR VGND sg13cmos5l_decap_8
XFILLER_3_997 VPWR VGND sg13cmos5l_decap_8
XFILLER_2_430 VPWR VGND sg13cmos5l_decap_8
XANTENNA_160 Tile_X0Y0_FrameData[18] VPWR VGND sg13cmos5l_antennanp
XFILLER_1_56 VPWR VGND sg13cmos5l_decap_8
XANTENNA_171 Tile_X0Y0_FrameData[1] VPWR VGND sg13cmos5l_antennanp
XANTENNA_182 Tile_X0Y0_FrameData[1] VPWR VGND sg13cmos5l_antennanp
XANTENNA_193 Tile_X0Y0_FrameData[1] VPWR VGND sg13cmos5l_antennanp
XFILLER_14_1007 VPWR VGND sg13cmos5l_decap_8
XFILLER_14_581 VPWR VGND sg13cmos5l_decap_8
XFILLER_10_21 VPWR VGND sg13cmos5l_decap_8
XFILLER_0_934 VPWR VGND sg13cmos5l_fill_1
XFILLER_10_98 VPWR VGND sg13cmos5l_decap_8
XFILLER_15_345 VPWR VGND sg13cmos5l_decap_8
XFILLER_11_584 VPWR VGND sg13cmos5l_decap_8
X_215_ _215_/Q Tile_X0Y0_FrameData[1] VGND VPWR Tile_X1Y0_FrameStrobe[2] latch
XFILLER_13_1040 VPWR VGND sg13cmos5l_decap_8
X_146_ _146_/Q Tile_X0Y0_FrameData[6] VGND VPWR Tile_X1Y0_FrameStrobe[0] latch
X_077_ PMOD_IO_OE_O4 _223_/Q _074_/X _076_/Y VPWR VGND sg13cmos5l_a21oi_1
XFILLER_7_566 VPWR VGND sg13cmos5l_decap_8
XFILLER_12_337 VPWR VGND sg13cmos5l_decap_8
XFILLER_8_319 VPWR VGND sg13cmos5l_decap_4
XANTENNA_60 Tile_X0Y0_FrameData[11] VPWR VGND sg13cmos5l_antennanp
XANTENNA_71 Tile_X0Y0_FrameData[11] VPWR VGND sg13cmos5l_antennanp
XANTENNA_82 Tile_X0Y0_FrameData[11] VPWR VGND sg13cmos5l_antennanp
XANTENNA_93 Tile_X0Y0_FrameData[13] VPWR VGND sg13cmos5l_antennanp
XFILLER_4_536 VPWR VGND sg13cmos5l_decap_8
XFILLER_0_720 VPWR VGND sg13cmos5l_decap_4
XFILLER_15_175 VPWR VGND sg13cmos5l_decap_8
XFILLER_16_687 VPWR VGND sg13cmos5l_decap_8
XANTENNA__404__X Tile_X0Y0_FrameStrobe_O[13] VPWR VGND sg13cmos5l_antennanp
XFILLER_11_381 VPWR VGND sg13cmos5l_decap_8
XFILLER_12_871 VPWR VGND sg13cmos5l_fill_1
XFILLER_8_842 VPWR VGND sg13cmos5l_decap_4
X_129_ _129_/Q Tile_X0Y0_FrameData[23] VGND VPWR Tile_X1Y0_FrameStrobe[0] latch
XFILLER_3_591 VPWR VGND sg13cmos5l_fill_2
XFILLER_13_602 VPWR VGND sg13cmos5l_decap_8
XFILLER_16_42 VPWR VGND sg13cmos5l_decap_8
X_480_ Tile_X1Y0_FrameStrobe_O[1] Tile_X1Y0_FrameStrobe[1] VPWR VGND sg13cmos5l_buf_1
XFILLER_12_134 VPWR VGND sg13cmos5l_decap_8
XFILLER_9_639 VPWR VGND sg13cmos5l_decap_4
XFILLER_8_105 VPWR VGND sg13cmos5l_decap_8
XFILLER_0_594 VPWR VGND sg13cmos5l_decap_8
XFILLER_16_451 VPWR VGND sg13cmos5l_decap_8
XFILLER_16_462 VPWR VGND sg13cmos5l_fill_1
XFILLER_16_473 VPWR VGND sg13cmos5l_decap_4
XFILLER_8_661 VPWR VGND sg13cmos5l_decap_8
XFILLER_10_605 VPWR VGND sg13cmos5l_decap_8
X_601_ _601_/X Tile_X1Y0_N1END[1] Tile_X1Y0_N2MID[1] Tile_X1Y0_N2END[6] _087_/X _218_/Q
+ _217_/Q VPWR VGND sg13cmos5l_mux4_1
XFILLER_13_476 VPWR VGND sg13cmos5l_decap_8
X_394_ Tile_X0Y0_FrameStrobe_O[3] Tile_X0Y0_FrameStrobe[3] VPWR VGND sg13cmos5l_buf_1
X_463_ Tile_X1Y0_FrameData_O[16] Tile_X0Y0_FrameData[16] VPWR VGND sg13cmos5l_buf_1
X_532_ Tile_X1Y0_S4BEG[13] _621_/X VPWR VGND sg13cmos5l_buf_1
XFILLER_9_469 VPWR VGND sg13cmos5l_decap_8
XFILLER_4_67 VPWR VGND sg13cmos5l_fill_2
XFILLER_4_56 VPWR VGND sg13cmos5l_decap_8
XFILLER_1_1063 VPWR VGND sg13cmos5l_decap_8
XFILLER_10_402 VPWR VGND sg13cmos5l_decap_8
XFILLER_10_479 VPWR VGND sg13cmos5l_decap_8
XFILLER_13_21 VPWR VGND sg13cmos5l_decap_8
XFILLER_13_98 VPWR VGND sg13cmos5l_decap_8
XANTENNA__502__X Tile_X1Y0_S1BEG[3] VPWR VGND sg13cmos5l_antennanp
XFILLER_1_100 VPWR VGND sg13cmos5l_fill_1
XFILLER_1_133 VPWR VGND sg13cmos5l_decap_8
XFILLER_1_144 VPWR VGND sg13cmos5l_decap_4
XFILLER_1_177 VPWR VGND sg13cmos5l_fill_1
XFILLER_2_645 VPWR VGND sg13cmos5l_fill_2
XFILLER_2_634 VPWR VGND sg13cmos5l_fill_2
XFILLER_2_612 VPWR VGND sg13cmos5l_fill_1
XANTENNA_320 Tile_X0Y0_FrameData[9] VPWR VGND sg13cmos5l_antennanp
XANTENNA_331 Tile_X0Y0_FrameData[9] VPWR VGND sg13cmos5l_antennanp
XANTENNA_342 Tile_X0Y0_N2MID[4] VPWR VGND sg13cmos5l_antennanp
X_515_ Tile_X1Y0_S2BEGb[4] _604_/X VPWR VGND sg13cmos5l_buf_1
XANTENNA_353 Tile_X0Y0_FrameData[20] VPWR VGND sg13cmos5l_antennanp
XANTENNA_364 Tile_X0Y0_FrameData[24] VPWR VGND sg13cmos5l_antennanp
XANTENNA_375 Tile_X0Y0_FrameData[5] VPWR VGND sg13cmos5l_antennanp
XFILLER_13_273 VPWR VGND sg13cmos5l_decap_8
XFILLER_16_1060 VPWR VGND sg13cmos5l_fill_1
X_377_ Tile_X0Y0_SS4BEG[2] _586_/X VPWR VGND sg13cmos5l_buf_1
X_446_ Tile_X0Y0_S4BEG[15] _583_/X VPWR VGND sg13cmos5l_buf_1
XFILLER_9_244 VPWR VGND sg13cmos5l_fill_2
XANTENNA__412__X Tile_X0Y0_S1BEG[1] VPWR VGND sg13cmos5l_antennanp
XFILLER_16_1082 VPWR VGND sg13cmos5l_decap_8
XFILLER_6_973 VPWR VGND sg13cmos5l_decap_8
XFILLER_6_940 VPWR VGND sg13cmos5l_decap_4
XFILLER_8_1036 VPWR VGND sg13cmos5l_decap_8
XFILLER_15_527 VPWR VGND sg13cmos5l_decap_8
XFILLER_10_210 VPWR VGND sg13cmos5l_fill_1
XFILLER_10_243 VPWR VGND sg13cmos5l_fill_1
X_300_ _300_/Q Tile_X0Y0_FrameData[21] VGND VPWR Tile_X0Y0_FrameStrobe[1] latch
X_231_ _231_/Q Tile_X0Y0_FrameData[24] VGND VPWR Tile_X1Y0_FrameStrobe[3] latch
X_162_ _162_/Q Tile_X0Y0_FrameData[22] VGND VPWR Tile_X1Y0_FrameStrobe[1] latch
XFILLER_11_799 VPWR VGND sg13cmos5l_decap_8
X_093_ _244_/D _641_/X _230_/Q _232_/Q VPWR VGND sg13cmos5l_mux2_1
XFILLER_7_737 VPWR VGND sg13cmos5l_fill_1
XFILLER_6_247 VPWR VGND sg13cmos5l_decap_8
XFILLER_6_0 VPWR VGND sg13cmos5l_decap_8
XFILLER_1_35 VPWR VGND sg13cmos5l_decap_8
XFILLER_3_976 VPWR VGND sg13cmos5l_decap_8
XFILLER_2_486 VPWR VGND sg13cmos5l_decap_8
XANTENNA_150 Tile_X0Y0_FrameData[18] VPWR VGND sg13cmos5l_antennanp
XANTENNA_161 Tile_X0Y0_FrameData[18] VPWR VGND sg13cmos5l_antennanp
XANTENNA_172 Tile_X0Y0_FrameData[1] VPWR VGND sg13cmos5l_antennanp
XANTENNA_183 Tile_X0Y0_FrameData[1] VPWR VGND sg13cmos5l_antennanp
XANTENNA_194 Tile_X0Y0_FrameData[1] VPWR VGND sg13cmos5l_antennanp
XANTENNA__407__X Tile_X0Y0_FrameStrobe_O[16] VPWR VGND sg13cmos5l_antennanp
XFILLER_14_560 VPWR VGND sg13cmos5l_decap_8
X_429_ Tile_X0Y0_S2BEGb[6] _566_/X VPWR VGND sg13cmos5l_buf_1
XFILLER_12_519 VPWR VGND sg13cmos5l_decap_8
XFILLER_0_957 VPWR VGND sg13cmos5l_decap_4
XFILLER_10_77 VPWR VGND sg13cmos5l_decap_8
XFILLER_15_324 VPWR VGND sg13cmos5l_decap_8
XFILLER_11_563 VPWR VGND sg13cmos5l_decap_8
X_214_ _214_/Q Tile_X0Y0_FrameData[2] VGND VPWR Tile_X1Y0_FrameStrobe[2] latch
X_145_ _145_/Q Tile_X0Y0_FrameData[7] VGND VPWR Tile_X1Y0_FrameStrobe[0] latch
XFILLER_7_545 VPWR VGND sg13cmos5l_decap_8
X_076_ _076_/Y _120_/A _247_/D _075_/X VPWR VGND sg13cmos5l_o21ai_1
XFILLER_5_1039 VPWR VGND sg13cmos5l_decap_8
XANTENNA_50 Tile_X0Y0_FrameData[11] VPWR VGND sg13cmos5l_antennanp
XANTENNA_61 Tile_X0Y0_FrameData[11] VPWR VGND sg13cmos5l_antennanp
XANTENNA_72 Tile_X0Y0_FrameData[11] VPWR VGND sg13cmos5l_antennanp
XANTENNA_83 Tile_X0Y0_FrameData[11] VPWR VGND sg13cmos5l_antennanp
XFILLER_12_316 VPWR VGND sg13cmos5l_decap_8
XFILLER_13_828 VPWR VGND sg13cmos5l_decap_4
XANTENNA_94 Tile_X0Y0_FrameData[13] VPWR VGND sg13cmos5l_antennanp
XFILLER_0_732 VPWR VGND sg13cmos5l_fill_1
XFILLER_4_515 VPWR VGND sg13cmos5l_decap_8
XANTENNA__510__X Tile_X1Y0_S2BEG[7] VPWR VGND sg13cmos5l_antennanp
XFILLER_15_154 VPWR VGND sg13cmos5l_fill_2
XFILLER_16_611 VPWR VGND sg13cmos5l_decap_8
XFILLER_16_666 VPWR VGND sg13cmos5l_decap_8
XFILLER_11_360 VPWR VGND sg13cmos5l_decap_8
X_128_ _128_/Q Tile_X0Y0_FrameData[24] VGND VPWR Tile_X1Y0_FrameStrobe[0] latch
XFILLER_8_821 VPWR VGND sg13cmos5l_decap_8
XFILLER_7_67 VPWR VGND sg13cmos5l_fill_1
XFILLER_7_56 VPWR VGND sg13cmos5l_decap_8
XFILLER_7_320 VPWR VGND sg13cmos5l_fill_2
XANTENNA__420__X Tile_X0Y0_S2BEG[5] VPWR VGND sg13cmos5l_antennanp
X_059_ _059_/Y _246_/Q VPWR VGND sg13cmos5l_inv_1
XFILLER_3_570 VPWR VGND sg13cmos5l_decap_8
XFILLER_12_113 VPWR VGND sg13cmos5l_decap_8
XFILLER_13_658 VPWR VGND sg13cmos5l_decap_8
XFILLER_16_21 VPWR VGND sg13cmos5l_decap_8
XANTENNA__505__X Tile_X1Y0_S2BEG[2] VPWR VGND sg13cmos5l_antennanp
XFILLER_8_128 VPWR VGND sg13cmos5l_fill_1
XFILLER_0_573 VPWR VGND sg13cmos5l_decap_8
XFILLER_10_1088 VPWR VGND sg13cmos5l_fill_2
XFILLER_4_367 VPWR VGND sg13cmos5l_fill_2
XFILLER_4_356 VPWR VGND sg13cmos5l_decap_4
XANTENNA__415__X Tile_X0Y0_S2BEG[0] VPWR VGND sg13cmos5l_antennanp
XFILLER_6_1112 VPWR VGND sg13cmos5l_fill_2
X_531_ Tile_X1Y0_S4BEG[12] _620_/X VPWR VGND sg13cmos5l_buf_1
X_600_ _600_/X Tile_X1Y0_N1END[0] Tile_X1Y0_N2MID[0] Tile_X1Y0_N2END[7] _089_/X _220_/Q
+ _219_/Q VPWR VGND sg13cmos5l_mux4_1
XFILLER_13_455 VPWR VGND sg13cmos5l_decap_8
X_393_ Tile_X0Y0_FrameStrobe_O[2] Tile_X0Y0_FrameStrobe[2] VPWR VGND sg13cmos5l_buf_1
X_462_ Tile_X1Y0_FrameData_O[15] Tile_X0Y0_FrameData[15] VPWR VGND sg13cmos5l_buf_1
XFILLER_9_448 VPWR VGND sg13cmos5l_decap_8
XFILLER_5_621 VPWR VGND sg13cmos5l_fill_2
XFILLER_5_610 VPWR VGND sg13cmos5l_decap_8
XFILLER_4_35 VPWR VGND sg13cmos5l_decap_8
XFILLER_16_282 VPWR VGND sg13cmos5l_decap_8
XFILLER_16_293 VPWR VGND sg13cmos5l_fill_1
XFILLER_1_1042 VPWR VGND sg13cmos5l_decap_8
XFILLER_11_959 VPWR VGND sg13cmos5l_fill_2
XFILLER_10_458 VPWR VGND sg13cmos5l_decap_8
XFILLER_13_77 VPWR VGND sg13cmos5l_decap_8
XFILLER_1_189 VPWR VGND sg13cmos5l_decap_4
XANTENNA_310 Tile_X0Y0_FrameData[9] VPWR VGND sg13cmos5l_antennanp
XANTENNA_321 Tile_X0Y0_FrameData[9] VPWR VGND sg13cmos5l_antennanp
XANTENNA_332 Tile_X0Y0_FrameData[9] VPWR VGND sg13cmos5l_antennanp
XANTENNA_343 Tile_X0Y0_N2MID[4] VPWR VGND sg13cmos5l_antennanp
XANTENNA_354 Tile_X0Y0_FrameData[20] VPWR VGND sg13cmos5l_antennanp
XANTENNA_365 Tile_X0Y0_FrameData[24] VPWR VGND sg13cmos5l_antennanp
XANTENNA_376 Tile_X0Y0_FrameData[5] VPWR VGND sg13cmos5l_antennanp
X_514_ Tile_X1Y0_S2BEGb[3] _603_/X VPWR VGND sg13cmos5l_buf_1
XFILLER_13_252 VPWR VGND sg13cmos5l_decap_8
XFILLER_14_764 VPWR VGND sg13cmos5l_decap_4
X_376_ Tile_X0Y0_SS4BEG[1] _585_/X VPWR VGND sg13cmos5l_buf_1
X_445_ Tile_X0Y0_S4BEG[14] _582_/X VPWR VGND sg13cmos5l_buf_1
XFILLER_5_484 VPWR VGND sg13cmos5l_decap_8
XFILLER_8_1015 VPWR VGND sg13cmos5l_decap_8
XFILLER_15_506 VPWR VGND sg13cmos5l_decap_8
XFILLER_10_277 VPWR VGND sg13cmos5l_decap_4
X_230_ _230_/Q Tile_X0Y0_FrameData[23] VGND VPWR Tile_X1Y0_FrameStrobe[3] latch
X_161_ _161_/Q Tile_X0Y0_FrameData[23] VGND VPWR Tile_X1Y0_FrameStrobe[1] latch
XANTENNA__513__X Tile_X1Y0_S2BEGb[2] VPWR VGND sg13cmos5l_antennanp
X_092_ _092_/X _235_/Q _235_/D _234_/Q VPWR VGND sg13cmos5l_mux2_1
XFILLER_2_465 VPWR VGND sg13cmos5l_decap_8
XFILLER_1_14 VPWR VGND sg13cmos5l_decap_8
XANTENNA_140 Tile_X0Y0_FrameData[18] VPWR VGND sg13cmos5l_antennanp
XANTENNA_151 Tile_X0Y0_FrameData[18] VPWR VGND sg13cmos5l_antennanp
XANTENNA_162 Tile_X0Y0_FrameData[18] VPWR VGND sg13cmos5l_antennanp
XANTENNA_173 Tile_X0Y0_FrameData[1] VPWR VGND sg13cmos5l_antennanp
XANTENNA_184 Tile_X0Y0_FrameData[1] VPWR VGND sg13cmos5l_antennanp
XANTENNA_195 Tile_X0Y0_FrameData[1] VPWR VGND sg13cmos5l_antennanp
X_428_ Tile_X0Y0_S2BEGb[5] _565_/X VPWR VGND sg13cmos5l_buf_1
XANTENNA__423__X Tile_X0Y0_S2BEGb[0] VPWR VGND sg13cmos5l_antennanp
X_359_ _359_/L_HI VPWR VGND sg13cmos5l_tiehi
XFILLER_5_270 VPWR VGND sg13cmos5l_fill_1
XFILLER_0_914 VPWR VGND sg13cmos5l_decap_8
XFILLER_10_56 VPWR VGND sg13cmos5l_decap_8
XFILLER_4_719 VPWR VGND sg13cmos5l_decap_8
XFILLER_0_925 VPWR VGND sg13cmos5l_fill_2
XANTENNA__508__X Tile_X1Y0_S2BEG[5] VPWR VGND sg13cmos5l_antennanp
XFILLER_15_303 VPWR VGND sg13cmos5l_decap_8
XFILLER_11_542 VPWR VGND sg13cmos5l_decap_8
XFILLER_13_1075 VPWR VGND sg13cmos5l_decap_8
X_213_ _213_/Q Tile_X0Y0_FrameData[3] VGND VPWR Tile_X1Y0_FrameStrobe[2] latch
X_144_ _144_/Q Tile_X0Y0_FrameData[8] VGND VPWR Tile_X1Y0_FrameStrobe[0] latch
X_075_ _075_/X _233_/Q _247_/Q VPWR VGND sg13cmos5l_or2_1
XFILLER_7_524 VPWR VGND sg13cmos5l_decap_8
XANTENNA__418__X Tile_X0Y0_S2BEG[3] VPWR VGND sg13cmos5l_antennanp
XFILLER_5_1018 VPWR VGND sg13cmos5l_decap_8
XANTENNA_40 Tile_X0Y0_FrameData[11] VPWR VGND sg13cmos5l_antennanp
XANTENNA_51 Tile_X0Y0_FrameData[11] VPWR VGND sg13cmos5l_antennanp
XANTENNA_62 Tile_X0Y0_FrameData[11] VPWR VGND sg13cmos5l_antennanp
XANTENNA_73 Tile_X0Y0_FrameData[11] VPWR VGND sg13cmos5l_antennanp
XANTENNA_84 Tile_X0Y0_FrameData[11] VPWR VGND sg13cmos5l_antennanp
XANTENNA_95 Tile_X0Y0_FrameData[13] VPWR VGND sg13cmos5l_antennanp
XFILLER_0_744 VPWR VGND sg13cmos5l_fill_1
XFILLER_0_766 VPWR VGND sg13cmos5l_fill_1
XFILLER_0_777 VPWR VGND sg13cmos5l_decap_4
XFILLER_0_788 VPWR VGND sg13cmos5l_fill_2
XFILLER_12_840 VPWR VGND sg13cmos5l_fill_1
XFILLER_15_133 VPWR VGND sg13cmos5l_decap_8
XFILLER_16_645 VPWR VGND sg13cmos5l_decap_8
XFILLER_8_800 VPWR VGND sg13cmos5l_decap_8
X_127_ _127_/Q Tile_X0Y0_FrameData[25] VGND VPWR Tile_X1Y0_FrameStrobe[0] latch
X_058_ _058_/Y _245_/Q VPWR VGND sg13cmos5l_inv_1
XFILLER_8_899 VPWR VGND sg13cmos5l_fill_2
XFILLER_7_354 VPWR VGND sg13cmos5l_fill_2
XFILLER_7_35 VPWR VGND sg13cmos5l_decap_8
XFILLER_7_310 VPWR VGND sg13cmos5l_fill_2
XFILLER_3_593 VPWR VGND sg13cmos5l_fill_1
XFILLER_4_1073 VPWR VGND sg13cmos5l_decap_8
XFILLER_1_519 VPWR VGND sg13cmos5l_decap_8
XFILLER_12_169 VPWR VGND sg13cmos5l_decap_8
XFILLER_13_637 VPWR VGND sg13cmos5l_decap_8
XFILLER_16_77 VPWR VGND sg13cmos5l_decap_8
XFILLER_10_1034 VPWR VGND sg13cmos5l_fill_2
XFILLER_10_1067 VPWR VGND sg13cmos5l_decap_8
XFILLER_4_324 VPWR VGND sg13cmos5l_decap_8
XFILLER_4_302 VPWR VGND sg13cmos5l_fill_1
XANTENNA__521__X Tile_X1Y0_S4BEG[2] VPWR VGND sg13cmos5l_antennanp
XFILLER_0_552 VPWR VGND sg13cmos5l_decap_8
XFILLER_16_431 VPWR VGND sg13cmos5l_fill_2
XFILLER_11_191 VPWR VGND sg13cmos5l_decap_8
XFILLER_8_630 VPWR VGND sg13cmos5l_fill_2
XANTENNA__431__X Tile_X0Y0_S4BEG[0] VPWR VGND sg13cmos5l_antennanp
XFILLER_14_0 VPWR VGND sg13cmos5l_decap_8
X_461_ Tile_X1Y0_FrameData_O[14] Tile_X0Y0_FrameData[14] VPWR VGND sg13cmos5l_buf_1
X_530_ Tile_X1Y0_S4BEG[11] _619_/X VPWR VGND sg13cmos5l_buf_1
XANTENNA__516__X Tile_X1Y0_S2BEGb[5] VPWR VGND sg13cmos5l_antennanp
XFILLER_13_434 VPWR VGND sg13cmos5l_decap_8
XFILLER_14_968 VPWR VGND sg13cmos5l_fill_2
X_392_ Tile_X0Y0_FrameStrobe_O[1] Tile_X0Y0_FrameStrobe[1] VPWR VGND sg13cmos5l_buf_1
XFILLER_9_427 VPWR VGND sg13cmos5l_decap_8
XFILLER_4_187 VPWR VGND sg13cmos5l_decap_4
XFILLER_4_14 VPWR VGND sg13cmos5l_decap_8
XANTENNA__426__X Tile_X0Y0_S2BEGb[3] VPWR VGND sg13cmos5l_antennanp
XFILLER_16_261 VPWR VGND sg13cmos5l_decap_8
XFILLER_1_1021 VPWR VGND sg13cmos5l_decap_8
XFILLER_10_437 VPWR VGND sg13cmos5l_decap_8
XFILLER_13_56 VPWR VGND sg13cmos5l_decap_8
XFILLER_2_636 VPWR VGND sg13cmos5l_fill_1
XANTENNA_300 Tile_X0Y0_FrameData[9] VPWR VGND sg13cmos5l_antennanp
XANTENNA_311 Tile_X0Y0_FrameData[9] VPWR VGND sg13cmos5l_antennanp
XANTENNA_322 Tile_X0Y0_FrameData[9] VPWR VGND sg13cmos5l_antennanp
XANTENNA_333 Tile_X0Y0_FrameData[9] VPWR VGND sg13cmos5l_antennanp
XANTENNA_344 Tile_X1Y0_FrameStrobe[15] VPWR VGND sg13cmos5l_antennanp
XANTENNA_355 Tile_X0Y0_FrameData[20] VPWR VGND sg13cmos5l_antennanp
XANTENNA_366 Tile_X0Y0_FrameData[24] VPWR VGND sg13cmos5l_antennanp
XANTENNA_377 Tile_X0Y0_FrameData[5] VPWR VGND sg13cmos5l_antennanp
XFILLER_13_231 VPWR VGND sg13cmos5l_decap_8
XFILLER_14_743 VPWR VGND sg13cmos5l_decap_8
X_444_ Tile_X0Y0_S4BEG[13] _581_/X VPWR VGND sg13cmos5l_buf_1
X_513_ Tile_X1Y0_S2BEGb[2] _602_/X VPWR VGND sg13cmos5l_buf_1
XFILLER_16_1040 VPWR VGND sg13cmos5l_decap_8
X_375_ Tile_X0Y0_SS4BEG[0] _584_/X VPWR VGND sg13cmos5l_buf_1
XFILLER_9_279 VPWR VGND sg13cmos5l_fill_2
XFILLER_5_463 VPWR VGND sg13cmos5l_decap_8
XFILLER_11_702 VPWR VGND sg13cmos5l_fill_2
X_160_ _160_/Q Tile_X0Y0_FrameData[24] VGND VPWR Tile_X1Y0_FrameStrobe[1] latch
X_091_ _091_/X _237_/Q _237_/D _234_/Q VPWR VGND sg13cmos5l_mux2_1
XFILLER_3_912 VPWR VGND sg13cmos5l_fill_1
XFILLER_2_444 VPWR VGND sg13cmos5l_decap_8
XANTENNA_130 Tile_X0Y0_FrameData[13] VPWR VGND sg13cmos5l_antennanp
XANTENNA_141 Tile_X0Y0_FrameData[18] VPWR VGND sg13cmos5l_antennanp
XANTENNA_152 Tile_X0Y0_FrameData[18] VPWR VGND sg13cmos5l_antennanp
XANTENNA_163 Tile_X0Y0_FrameData[18] VPWR VGND sg13cmos5l_antennanp
XANTENNA_174 Tile_X0Y0_FrameData[1] VPWR VGND sg13cmos5l_antennanp
XANTENNA_185 Tile_X0Y0_FrameData[1] VPWR VGND sg13cmos5l_antennanp
XANTENNA_196 Tile_X0Y0_FrameData[1] VPWR VGND sg13cmos5l_antennanp
XFILLER_14_595 VPWR VGND sg13cmos5l_decap_4
X_358_ _358_/L_HI VPWR VGND sg13cmos5l_tiehi
X_427_ Tile_X0Y0_S2BEGb[4] _564_/X VPWR VGND sg13cmos5l_buf_1
XFILLER_10_790 VPWR VGND sg13cmos5l_fill_1
X_289_ _289_/Q Tile_X0Y0_FrameData[0] VGND VPWR Tile_X0Y0_FrameStrobe[0] latch
XFILLER_6_750 VPWR VGND sg13cmos5l_fill_1
XFILLER_7_1082 VPWR VGND sg13cmos5l_decap_8
XFILLER_10_35 VPWR VGND sg13cmos5l_decap_8
XFILLER_11_521 VPWR VGND sg13cmos5l_decap_8
XFILLER_15_359 VPWR VGND sg13cmos5l_decap_8
X_212_ _212_/Q Tile_X0Y0_FrameData[4] VGND VPWR Tile_X1Y0_FrameStrobe[2] latch
XANTENNA__524__X Tile_X1Y0_S4BEG[5] VPWR VGND sg13cmos5l_antennanp
XFILLER_11_598 VPWR VGND sg13cmos5l_decap_8
XFILLER_13_1054 VPWR VGND sg13cmos5l_decap_8
X_143_ _143_/Q Tile_X0Y0_FrameData[9] VGND VPWR Tile_X1Y0_FrameStrobe[0] latch
X_074_ _074_/X _255_/Q _556_/X _233_/Q VPWR VGND sg13cmos5l_mux2_1
XFILLER_7_503 VPWR VGND sg13cmos5l_decap_8
XFILLER_3_764 VPWR VGND sg13cmos5l_decap_4
XFILLER_2_296 VPWR VGND sg13cmos5l_decap_8
XANTENNA__434__X Tile_X0Y0_S4BEG[3] VPWR VGND sg13cmos5l_antennanp
XFILLER_14_392 VPWR VGND sg13cmos5l_decap_8
XFILLER_6_591 VPWR VGND sg13cmos5l_decap_8
XANTENNA_30 Tile_X0Y0_FrameData[0] VPWR VGND sg13cmos5l_antennanp
XANTENNA_41 Tile_X0Y0_FrameData[11] VPWR VGND sg13cmos5l_antennanp
XANTENNA_52 Tile_X0Y0_FrameData[11] VPWR VGND sg13cmos5l_antennanp
XANTENNA_63 Tile_X0Y0_FrameData[11] VPWR VGND sg13cmos5l_antennanp
XANTENNA_74 Tile_X0Y0_FrameData[11] VPWR VGND sg13cmos5l_antennanp
XANTENNA_85 Tile_X0Y0_FrameData[11] VPWR VGND sg13cmos5l_antennanp
XANTENNA_96 Tile_X0Y0_FrameData[13] VPWR VGND sg13cmos5l_antennanp
XANTENNA__519__X Tile_X1Y0_S4BEG[0] VPWR VGND sg13cmos5l_antennanp
XFILLER_15_112 VPWR VGND sg13cmos5l_decap_8
XFILLER_12_852 VPWR VGND sg13cmos5l_decap_4
XFILLER_15_1105 VPWR VGND sg13cmos5l_decap_8
XFILLER_15_156 VPWR VGND sg13cmos5l_fill_1
XFILLER_15_189 VPWR VGND sg13cmos5l_decap_8
XFILLER_7_322 VPWR VGND sg13cmos5l_fill_1
XFILLER_7_14 VPWR VGND sg13cmos5l_decap_8
XFILLER_11_395 VPWR VGND sg13cmos5l_decap_8
X_126_ _126_/Q Tile_X0Y0_FrameData[26] VGND VPWR Tile_X1Y0_FrameStrobe[0] latch
X_057_ _120_/A _233_/Q VPWR VGND sg13cmos5l_inv_1
XFILLER_4_1052 VPWR VGND sg13cmos5l_decap_8
XANTENNA__429__X Tile_X0Y0_S2BEGb[6] VPWR VGND sg13cmos5l_antennanp
XFILLER_12_148 VPWR VGND sg13cmos5l_decap_8
XFILLER_13_616 VPWR VGND sg13cmos5l_decap_8
XFILLER_16_56 VPWR VGND sg13cmos5l_decap_8
XFILLER_9_609 VPWR VGND sg13cmos5l_decap_8
XFILLER_8_119 VPWR VGND sg13cmos5l_decap_8
XFILLER_10_1013 VPWR VGND sg13cmos5l_decap_8
XFILLER_10_1046 VPWR VGND sg13cmos5l_decap_8
XFILLER_5_815 VPWR VGND sg13cmos5l_decap_8
XFILLER_16_410 VPWR VGND sg13cmos5l_decap_8
XFILLER_11_170 VPWR VGND sg13cmos5l_decap_8
XFILLER_12_671 VPWR VGND sg13cmos5l_fill_2
XFILLER_8_675 VPWR VGND sg13cmos5l_decap_4
XFILLER_8_642 VPWR VGND sg13cmos5l_decap_8
X_109_ PMOD_IO_O0 _223_/Q _066_/X VPWR VGND sg13cmos5l_nor2b_1
XFILLER_7_185 VPWR VGND sg13cmos5l_fill_2
XFILLER_4_881 VPWR VGND sg13cmos5l_decap_4
XFILLER_10_619 VPWR VGND sg13cmos5l_decap_8
XFILLER_13_413 VPWR VGND sg13cmos5l_decap_8
X_391_ Tile_X0Y0_FrameStrobe_O[0] Tile_X0Y0_FrameStrobe[0] VPWR VGND sg13cmos5l_buf_1
X_460_ Tile_X1Y0_FrameData_O[13] Tile_X0Y0_FrameData[13] VPWR VGND sg13cmos5l_buf_1
XFILLER_9_406 VPWR VGND sg13cmos5l_decap_8
XANTENNA__532__X Tile_X1Y0_S4BEG[13] VPWR VGND sg13cmos5l_antennanp
XFILLER_4_166 VPWR VGND sg13cmos5l_decap_8
XFILLER_4_144 VPWR VGND sg13cmos5l_fill_1
XFILLER_4_111 VPWR VGND sg13cmos5l_decap_8
XFILLER_1_1000 VPWR VGND sg13cmos5l_fill_2
XFILLER_16_240 VPWR VGND sg13cmos5l_decap_8
XFILLER_1_1077 VPWR VGND sg13cmos5l_decap_8
X_589_ _589_/X Tile_X0Y0_N2END[5] Tile_X0Y0_N4END[5] Tile_X0Y0_NN4END[10] _092_/X
+ _291_/Q _290_/Q VPWR VGND sg13cmos5l_mux4_1
XANTENNA__442__X Tile_X0Y0_S4BEG[11] VPWR VGND sg13cmos5l_antennanp
XFILLER_8_483 VPWR VGND sg13cmos5l_decap_8
XFILLER_10_416 VPWR VGND sg13cmos5l_decap_8
XFILLER_13_35 VPWR VGND sg13cmos5l_decap_8
XFILLER_6_409 VPWR VGND sg13cmos5l_decap_8
XANTENNA_301 Tile_X0Y0_FrameData[9] VPWR VGND sg13cmos5l_antennanp
XANTENNA_312 Tile_X0Y0_FrameData[9] VPWR VGND sg13cmos5l_antennanp
XANTENNA_323 Tile_X0Y0_FrameData[9] VPWR VGND sg13cmos5l_antennanp
XANTENNA_334 Tile_X0Y0_FrameData[9] VPWR VGND sg13cmos5l_antennanp
XANTENNA_345 Tile_X1Y0_FrameStrobe[5] VPWR VGND sg13cmos5l_antennanp
XANTENNA_356 Tile_X0Y0_FrameData[20] VPWR VGND sg13cmos5l_antennanp
XANTENNA_367 Tile_X0Y0_FrameData[24] VPWR VGND sg13cmos5l_antennanp
XANTENNA_378 Tile_X0Y0_FrameData[5] VPWR VGND sg13cmos5l_antennanp
XANTENNA__527__X Tile_X1Y0_S4BEG[8] VPWR VGND sg13cmos5l_antennanp
XFILLER_13_210 VPWR VGND sg13cmos5l_decap_8
XFILLER_14_700 VPWR VGND sg13cmos5l_decap_8
X_374_ _374_/L_HI VPWR VGND sg13cmos5l_tiehi
X_443_ Tile_X0Y0_S4BEG[12] _580_/X VPWR VGND sg13cmos5l_buf_1
X_512_ Tile_X1Y0_S2BEGb[1] _601_/X VPWR VGND sg13cmos5l_buf_1
XFILLER_13_287 VPWR VGND sg13cmos5l_decap_8
XFILLER_16_1052 VPWR VGND sg13cmos5l_fill_1
XFILLER_16_1096 VPWR VGND sg13cmos5l_decap_8
XFILLER_6_987 VPWR VGND sg13cmos5l_decap_8
XFILLER_5_442 VPWR VGND sg13cmos5l_decap_8
XANTENNA__437__X Tile_X0Y0_S4BEG[6] VPWR VGND sg13cmos5l_antennanp
XFILLER_0_191 VPWR VGND sg13cmos5l_fill_2
XFILLER_8_291 VPWR VGND sg13cmos5l_decap_8
XFILLER_10_268 VPWR VGND sg13cmos5l_fill_2
X_090_ _237_/D PMOD_IO_I2 _554_/X _222_/Q VPWR VGND sg13cmos5l_mux2_1
XFILLER_6_206 VPWR VGND sg13cmos5l_decap_4
XFILLER_2_423 VPWR VGND sg13cmos5l_decap_8
XANTENNA_120 Tile_X0Y0_FrameData[13] VPWR VGND sg13cmos5l_antennanp
XANTENNA_131 Tile_X0Y0_FrameData[13] VPWR VGND sg13cmos5l_antennanp
XANTENNA_142 Tile_X0Y0_FrameData[18] VPWR VGND sg13cmos5l_antennanp
XFILLER_1_49 VPWR VGND sg13cmos5l_decap_8
XANTENNA_153 Tile_X0Y0_FrameData[18] VPWR VGND sg13cmos5l_antennanp
XANTENNA_164 Tile_X0Y0_FrameData[18] VPWR VGND sg13cmos5l_antennanp
XANTENNA_175 Tile_X0Y0_FrameData[1] VPWR VGND sg13cmos5l_antennanp
XANTENNA_186 Tile_X0Y0_FrameData[1] VPWR VGND sg13cmos5l_antennanp
XANTENNA_197 Tile_X0Y0_FrameData[1] VPWR VGND sg13cmos5l_antennanp
XFILLER_14_574 VPWR VGND sg13cmos5l_decap_8
X_357_ _357_/L_HI VPWR VGND sg13cmos5l_tiehi
X_426_ Tile_X0Y0_S2BEGb[3] _563_/X VPWR VGND sg13cmos5l_buf_1
X_288_ _288_/Q Tile_X0Y0_FrameData[1] VGND VPWR Tile_X0Y0_FrameStrobe[0] latch
XFILLER_7_1061 VPWR VGND sg13cmos5l_decap_8
XFILLER_0_938 VPWR VGND sg13cmos5l_fill_2
XFILLER_10_14 VPWR VGND sg13cmos5l_decap_8
XFILLER_11_500 VPWR VGND sg13cmos5l_decap_8
XFILLER_15_338 VPWR VGND sg13cmos5l_decap_8
X_211_ _211_/Q Tile_X0Y0_FrameData[5] VGND VPWR Tile_X1Y0_FrameStrobe[2] latch
X_142_ _142_/Q Tile_X0Y0_FrameData[10] VGND VPWR Tile_X1Y0_FrameStrobe[0] latch
XANTENNA__540__X Tile_X1Y0_SS4BEG[5] VPWR VGND sg13cmos5l_antennanp
XFILLER_11_577 VPWR VGND sg13cmos5l_decap_8
XFILLER_13_1033 VPWR VGND sg13cmos5l_decap_8
X_073_ _247_/D _644_/X _227_/Q _232_/Q VPWR VGND sg13cmos5l_mux2_1
XFILLER_7_559 VPWR VGND sg13cmos5l_decap_8
XFILLER_4_0 VPWR VGND sg13cmos5l_decap_8
XFILLER_3_721 VPWR VGND sg13cmos5l_decap_4
XFILLER_3_798 VPWR VGND sg13cmos5l_fill_1
XFILLER_15_872 VPWR VGND sg13cmos5l_fill_2
XFILLER_14_371 VPWR VGND sg13cmos5l_decap_8
X_409_ Tile_X0Y0_FrameStrobe_O[18] Tile_X0Y0_FrameStrobe[18] VPWR VGND sg13cmos5l_buf_1
XANTENNA__450__X Tile_X1Y0_FrameData_O[3] VPWR VGND sg13cmos5l_antennanp
XFILLER_9_1112 VPWR VGND sg13cmos5l_fill_2
XFILLER_6_570 VPWR VGND sg13cmos5l_decap_8
XANTENNA_20 Tile_X0Y0_FrameData[0] VPWR VGND sg13cmos5l_antennanp
XANTENNA_31 Tile_X0Y0_FrameData[0] VPWR VGND sg13cmos5l_antennanp
XANTENNA_42 Tile_X0Y0_FrameData[11] VPWR VGND sg13cmos5l_antennanp
XANTENNA_53 Tile_X0Y0_FrameData[11] VPWR VGND sg13cmos5l_antennanp
XANTENNA_64 Tile_X0Y0_FrameData[11] VPWR VGND sg13cmos5l_antennanp
XANTENNA_75 Tile_X0Y0_FrameData[11] VPWR VGND sg13cmos5l_antennanp
XANTENNA_86 Tile_X0Y0_FrameData[13] VPWR VGND sg13cmos5l_antennanp
XANTENNA_97 Tile_X0Y0_FrameData[13] VPWR VGND sg13cmos5l_antennanp
XFILLER_4_529 VPWR VGND sg13cmos5l_decap_8
XFILLER_0_724 VPWR VGND sg13cmos5l_fill_1
XFILLER_15_168 VPWR VGND sg13cmos5l_decap_8
XANTENNA__535__X Tile_X1Y0_SS4BEG[0] VPWR VGND sg13cmos5l_antennanp
XFILLER_11_374 VPWR VGND sg13cmos5l_decap_8
X_125_ _125_/Q Tile_X0Y0_FrameData[27] VGND VPWR Tile_X1Y0_FrameStrobe[0] latch
XFILLER_8_846 VPWR VGND sg13cmos5l_fill_2
XFILLER_8_835 VPWR VGND sg13cmos5l_decap_8
XFILLER_7_312 VPWR VGND sg13cmos5l_fill_1
XFILLER_3_584 VPWR VGND sg13cmos5l_decap_8
XFILLER_4_1031 VPWR VGND sg13cmos5l_decap_8
XANTENNA__445__X Tile_X0Y0_S4BEG[14] VPWR VGND sg13cmos5l_antennanp
XFILLER_16_35 VPWR VGND sg13cmos5l_decap_8
XFILLER_12_127 VPWR VGND sg13cmos5l_decap_8
XFILLER_0_587 VPWR VGND sg13cmos5l_decap_8
XFILLER_16_433 VPWR VGND sg13cmos5l_fill_1
XFILLER_16_444 VPWR VGND sg13cmos5l_decap_8
XFILLER_16_466 VPWR VGND sg13cmos5l_decap_8
XFILLER_16_477 VPWR VGND sg13cmos5l_fill_2
X_108_ PMOD_IO_OE_O7 _120_/A _060_/Y _107_/X _223_/Q _106_/Y VPWR VGND sg13cmos5l_a221oi_1
XFILLER_4_893 VPWR VGND sg13cmos5l_decap_4
XFILLER_3_381 VPWR VGND sg13cmos5l_fill_2
XFILLER_8_91 VPWR VGND sg13cmos5l_decap_8
XANTENNA__069__Y PMOD_IO_OE_O0 VPWR VGND sg13cmos5l_antennanp
X_390_ Tile_X0Y0_SS4BEG[15] _599_/X VPWR VGND sg13cmos5l_buf_1
XFILLER_13_469 VPWR VGND sg13cmos5l_decap_8
XFILLER_1_830 VPWR VGND sg13cmos5l_fill_1
XFILLER_4_49 VPWR VGND sg13cmos5l_decap_8
XFILLER_1_1056 VPWR VGND sg13cmos5l_decap_8
XFILLER_12_491 VPWR VGND sg13cmos5l_decap_8
XFILLER_13_992 VPWR VGND sg13cmos5l_decap_8
X_588_ _588_/X Tile_X0Y0_N2END[4] Tile_X0Y0_N4END[4] Tile_X0Y0_NN4END[11] _119_/X
+ _293_/Q _292_/Q VPWR VGND sg13cmos5l_mux4_1
XFILLER_9_996 VPWR VGND sg13cmos5l_decap_8
XFILLER_8_462 VPWR VGND sg13cmos5l_decap_8
XFILLER_13_14 VPWR VGND sg13cmos5l_decap_8
XFILLER_1_148 VPWR VGND sg13cmos5l_fill_1
XFILLER_8_7 VPWR VGND sg13cmos5l_decap_8
XFILLER_2_605 VPWR VGND sg13cmos5l_decap_8
XANTENNA_302 Tile_X0Y0_FrameData[9] VPWR VGND sg13cmos5l_antennanp
XANTENNA_313 Tile_X0Y0_FrameData[9] VPWR VGND sg13cmos5l_antennanp
XANTENNA_324 Tile_X0Y0_FrameData[9] VPWR VGND sg13cmos5l_antennanp
X_511_ Tile_X1Y0_S2BEGb[0] _600_/X VPWR VGND sg13cmos5l_buf_1
XANTENNA_335 Tile_X0Y0_FrameData[9] VPWR VGND sg13cmos5l_antennanp
XANTENNA_346 Tile_X1Y0_N4END[1] VPWR VGND sg13cmos5l_antennanp
XANTENNA_357 Tile_X0Y0_FrameData[20] VPWR VGND sg13cmos5l_antennanp
XANTENNA_368 Tile_X0Y0_FrameData[24] VPWR VGND sg13cmos5l_antennanp
XANTENNA_379 Tile_X0Y0_FrameData[5] VPWR VGND sg13cmos5l_antennanp
XFILLER_13_266 VPWR VGND sg13cmos5l_decap_8
X_373_ _373_/L_HI VPWR VGND sg13cmos5l_tiehi
X_442_ Tile_X0Y0_S4BEG[11] _579_/X VPWR VGND sg13cmos5l_buf_1
XFILLER_9_237 VPWR VGND sg13cmos5l_decap_8
XFILLER_9_226 VPWR VGND sg13cmos5l_decap_4
XANTENNA__543__X Tile_X1Y0_SS4BEG[8] VPWR VGND sg13cmos5l_antennanp
XFILLER_10_973 VPWR VGND sg13cmos5l_fill_2
XFILLER_6_922 VPWR VGND sg13cmos5l_decap_4
XFILLER_5_498 VPWR VGND sg13cmos5l_decap_8
XFILLER_5_421 VPWR VGND sg13cmos5l_decap_8
XFILLER_0_181 VPWR VGND sg13cmos5l_fill_2
XANTENNA__453__X Tile_X1Y0_FrameData_O[6] VPWR VGND sg13cmos5l_antennanp
XFILLER_8_1029 VPWR VGND sg13cmos5l_decap_8
XFILLER_5_92 VPWR VGND sg13cmos5l_decap_8
XFILLER_5_70 VPWR VGND sg13cmos5l_decap_8
XANTENNA__082__Y PMOD_IO_OE_O3 VPWR VGND sg13cmos5l_antennanp
XFILLER_1_28 VPWR VGND sg13cmos5l_decap_8
XFILLER_3_969 VPWR VGND sg13cmos5l_decap_8
XFILLER_2_479 VPWR VGND sg13cmos5l_decap_8
XANTENNA_110 Tile_X0Y0_FrameData[13] VPWR VGND sg13cmos5l_antennanp
XANTENNA_121 Tile_X0Y0_FrameData[13] VPWR VGND sg13cmos5l_antennanp
XANTENNA_132 Tile_X0Y0_FrameData[13] VPWR VGND sg13cmos5l_antennanp
XANTENNA_143 Tile_X0Y0_FrameData[18] VPWR VGND sg13cmos5l_antennanp
XANTENNA_154 Tile_X0Y0_FrameData[18] VPWR VGND sg13cmos5l_antennanp
XANTENNA_165 Tile_X0Y0_FrameData[18] VPWR VGND sg13cmos5l_antennanp
XANTENNA_176 Tile_X0Y0_FrameData[1] VPWR VGND sg13cmos5l_antennanp
XANTENNA__538__X Tile_X1Y0_SS4BEG[3] VPWR VGND sg13cmos5l_antennanp
XANTENNA_187 Tile_X0Y0_FrameData[1] VPWR VGND sg13cmos5l_antennanp
XANTENNA_198 Tile_X0Y0_FrameData[1] VPWR VGND sg13cmos5l_antennanp
XFILLER_14_553 VPWR VGND sg13cmos5l_decap_8
X_287_ _287_/Q Tile_X0Y0_FrameData[2] VGND VPWR Tile_X0Y0_FrameStrobe[0] latch
X_356_ _356_/L_HI VPWR VGND sg13cmos5l_tiehi
X_425_ Tile_X0Y0_S2BEGb[2] _562_/X VPWR VGND sg13cmos5l_buf_1
XFILLER_6_741 VPWR VGND sg13cmos5l_decap_8
XANTENNA__448__X Tile_X1Y0_FrameData_O[1] VPWR VGND sg13cmos5l_antennanp
XFILLER_7_1040 VPWR VGND sg13cmos5l_decap_8
XANTENNA__077__Y PMOD_IO_OE_O4 VPWR VGND sg13cmos5l_antennanp
XFILLER_15_317 VPWR VGND sg13cmos5l_decap_8
XFILLER_16_807 VPWR VGND sg13cmos5l_fill_2
XFILLER_11_556 VPWR VGND sg13cmos5l_decap_8
XFILLER_13_1001 VPWR VGND sg13cmos5l_fill_1
XFILLER_13_1012 VPWR VGND sg13cmos5l_decap_8
X_210_ _210_/Q Tile_X0Y0_FrameData[6] VGND VPWR Tile_X1Y0_FrameStrobe[2] latch
X_141_ _141_/Q Tile_X0Y0_FrameData[11] VGND VPWR Tile_X1Y0_FrameStrobe[0] latch
XFILLER_7_538 VPWR VGND sg13cmos5l_decap_8
XFILLER_13_1089 VPWR VGND sg13cmos5l_fill_2
X_072_ PMOD_IO_OE_O2 _120_/A _058_/Y _071_/X _223_/Q _070_/Y VPWR VGND sg13cmos5l_a221oi_1
XFILLER_3_711 VPWR VGND sg13cmos5l_fill_2
XFILLER_3_700 VPWR VGND sg13cmos5l_decap_8
XFILLER_2_221 VPWR VGND sg13cmos5l_decap_8
XFILLER_14_350 VPWR VGND sg13cmos5l_decap_8
X_408_ Tile_X0Y0_FrameStrobe_O[17] Tile_X0Y0_FrameStrobe[17] VPWR VGND sg13cmos5l_buf_1
X_339_ _339_/Q Tile_X0Y0_FrameData[14] VGND VPWR Tile_X0Y0_FrameStrobe[2] latch
XANTENNA_10 Tile_X0Y0_FrameData[0] VPWR VGND sg13cmos5l_antennanp
XANTENNA_21 Tile_X0Y0_FrameData[0] VPWR VGND sg13cmos5l_antennanp
XANTENNA_32 Tile_X0Y0_FrameData[0] VPWR VGND sg13cmos5l_antennanp
XANTENNA_43 Tile_X0Y0_FrameData[11] VPWR VGND sg13cmos5l_antennanp
XANTENNA_54 Tile_X0Y0_FrameData[11] VPWR VGND sg13cmos5l_antennanp
XANTENNA_65 Tile_X0Y0_FrameData[11] VPWR VGND sg13cmos5l_antennanp
XFILLER_12_309 VPWR VGND sg13cmos5l_decap_8
XANTENNA_76 Tile_X0Y0_FrameData[11] VPWR VGND sg13cmos5l_antennanp
XANTENNA_87 Tile_X0Y0_FrameData[13] VPWR VGND sg13cmos5l_antennanp
XANTENNA_98 Tile_X0Y0_FrameData[13] VPWR VGND sg13cmos5l_antennanp
XFILLER_4_508 VPWR VGND sg13cmos5l_decap_8
XFILLER_15_147 VPWR VGND sg13cmos5l_decap_8
XFILLER_16_604 VPWR VGND sg13cmos5l_decap_8
XFILLER_16_659 VPWR VGND sg13cmos5l_decap_8
XANTENNA__551__X Tile_X1Y0_UserCLKo VPWR VGND sg13cmos5l_antennanp
XFILLER_11_331 VPWR VGND sg13cmos5l_fill_1
X_124_ _124_/Q Tile_X0Y0_FrameData[28] VGND VPWR Tile_X1Y0_FrameStrobe[0] latch
XFILLER_8_858 VPWR VGND sg13cmos5l_fill_2
XFILLER_8_814 VPWR VGND sg13cmos5l_decap_8
XFILLER_7_49 VPWR VGND sg13cmos5l_decap_8
XFILLER_11_91 VPWR VGND sg13cmos5l_decap_4
XFILLER_3_563 VPWR VGND sg13cmos5l_decap_8
XFILLER_4_1010 VPWR VGND sg13cmos5l_decap_8
XFILLER_15_692 VPWR VGND sg13cmos5l_decap_8
XANTENNA__461__X Tile_X1Y0_FrameData_O[14] VPWR VGND sg13cmos5l_antennanp
XFILLER_7_880 VPWR VGND sg13cmos5l_decap_8
XFILLER_12_106 VPWR VGND sg13cmos5l_decap_8
XFILLER_16_14 VPWR VGND sg13cmos5l_decap_8
XFILLER_0_544 VPWR VGND sg13cmos5l_decap_4
XFILLER_4_338 VPWR VGND sg13cmos5l_decap_4
XFILLER_0_566 VPWR VGND sg13cmos5l_decap_8
XFILLER_16_401 VPWR VGND sg13cmos5l_decap_4
XANTENNA__546__X Tile_X1Y0_SS4BEG[11] VPWR VGND sg13cmos5l_antennanp
XFILLER_12_673 VPWR VGND sg13cmos5l_fill_1
XFILLER_16_489 VPWR VGND sg13cmos5l_fill_1
X_107_ _107_/X _258_/Q _559_/X _233_/Q VPWR VGND sg13cmos5l_mux2_1
XFILLER_7_110 VPWR VGND sg13cmos5l_decap_8
XFILLER_4_850 VPWR VGND sg13cmos5l_fill_1
XFILLER_3_393 VPWR VGND sg13cmos5l_fill_2
XANTENNA__456__X Tile_X1Y0_FrameData_O[9] VPWR VGND sg13cmos5l_antennanp
XFILLER_8_70 VPWR VGND sg13cmos5l_decap_8
XFILLER_13_448 VPWR VGND sg13cmos5l_decap_8
XFILLER_5_669 VPWR VGND sg13cmos5l_decap_4
XFILLER_5_603 VPWR VGND sg13cmos5l_decap_8
XFILLER_1_875 VPWR VGND sg13cmos5l_fill_1
XFILLER_4_28 VPWR VGND sg13cmos5l_decap_8
XFILLER_16_275 VPWR VGND sg13cmos5l_decap_8
XFILLER_1_1002 VPWR VGND sg13cmos5l_fill_1
XFILLER_1_1035 VPWR VGND sg13cmos5l_decap_8
X_587_ _587_/X Tile_X0Y0_N2END[3] Tile_X0Y0_N4END[3] Tile_X0Y0_NN4END[12] _091_/X
+ _295_/Q _294_/Q VPWR VGND sg13cmos5l_mux4_1
XFILLER_12_470 VPWR VGND sg13cmos5l_decap_8
XFILLER_16_297 VPWR VGND sg13cmos5l_decap_8
XFILLER_8_441 VPWR VGND sg13cmos5l_decap_8
XFILLER_4_680 VPWR VGND sg13cmos5l_decap_4
XFILLER_12_0 VPWR VGND sg13cmos5l_decap_8
XANTENNA_303 Tile_X0Y0_FrameData[9] VPWR VGND sg13cmos5l_antennanp
XANTENNA_314 Tile_X0Y0_FrameData[9] VPWR VGND sg13cmos5l_antennanp
XANTENNA_325 Tile_X0Y0_FrameData[9] VPWR VGND sg13cmos5l_antennanp
XANTENNA_336 Tile_X0Y0_FrameData[9] VPWR VGND sg13cmos5l_antennanp
XANTENNA_347 Tile_X1Y0_N4END[1] VPWR VGND sg13cmos5l_antennanp
XANTENNA_358 Tile_X0Y0_FrameData[20] VPWR VGND sg13cmos5l_antennanp
X_441_ Tile_X0Y0_S4BEG[10] _578_/X VPWR VGND sg13cmos5l_buf_1
X_510_ Tile_X1Y0_S2BEG[7] Tile_X1Y0_N2MID[0] VPWR VGND sg13cmos5l_buf_1
XANTENNA_369 Tile_X0Y0_FrameData[24] VPWR VGND sg13cmos5l_antennanp
XFILLER_13_245 VPWR VGND sg13cmos5l_decap_8
XFILLER_14_757 VPWR VGND sg13cmos5l_decap_8
XFILLER_14_768 VPWR VGND sg13cmos5l_fill_1
X_372_ _372_/L_HI VPWR VGND sg13cmos5l_tiehi
XFILLER_6_912 VPWR VGND sg13cmos5l_fill_2
XFILLER_6_934 VPWR VGND sg13cmos5l_fill_2
XFILLER_5_477 VPWR VGND sg13cmos5l_decap_8
XFILLER_0_193 VPWR VGND sg13cmos5l_fill_1
X_639_ _639_/X Tile_X1Y0_N2END[7] Tile_X1Y0_N4END[15] Tile_X1Y0_NN4END[0] _064_/X
+ _142_/Q _141_/Q VPWR VGND sg13cmos5l_mux4_1
XFILLER_9_772 VPWR VGND sg13cmos5l_decap_8
XFILLER_8_1008 VPWR VGND sg13cmos5l_decap_8
XFILLER_2_458 VPWR VGND sg13cmos5l_decap_8
XANTENNA_100 Tile_X0Y0_FrameData[13] VPWR VGND sg13cmos5l_antennanp
XANTENNA_111 Tile_X0Y0_FrameData[13] VPWR VGND sg13cmos5l_antennanp
XANTENNA_122 Tile_X0Y0_FrameData[13] VPWR VGND sg13cmos5l_antennanp
XANTENNA_133 Tile_X0Y0_FrameData[13] VPWR VGND sg13cmos5l_antennanp
XANTENNA_144 Tile_X0Y0_FrameData[18] VPWR VGND sg13cmos5l_antennanp
XANTENNA_155 Tile_X0Y0_FrameData[18] VPWR VGND sg13cmos5l_antennanp
XANTENNA_166 Tile_X0Y0_FrameData[18] VPWR VGND sg13cmos5l_antennanp
XANTENNA_177 Tile_X0Y0_FrameData[1] VPWR VGND sg13cmos5l_antennanp
XANTENNA_188 Tile_X0Y0_FrameData[1] VPWR VGND sg13cmos5l_antennanp
XANTENNA_199 Tile_X0Y0_FrameData[1] VPWR VGND sg13cmos5l_antennanp
XFILLER_14_532 VPWR VGND sg13cmos5l_decap_8
X_424_ Tile_X0Y0_S2BEGb[1] _561_/X VPWR VGND sg13cmos5l_buf_1
XFILLER_14_91 VPWR VGND sg13cmos5l_decap_8
X_286_ _286_/Q Tile_X0Y0_FrameData[3] VGND VPWR Tile_X0Y0_FrameStrobe[0] latch
X_355_ _355_/L_HI VPWR VGND sg13cmos5l_tiehi
XFILLER_1_491 VPWR VGND sg13cmos5l_decap_8
XANTENNA__464__X Tile_X1Y0_FrameData_O[17] VPWR VGND sg13cmos5l_antennanp
XFILLER_10_49 VPWR VGND sg13cmos5l_decap_8
XFILLER_0_907 VPWR VGND sg13cmos5l_decap_8
XFILLER_11_535 VPWR VGND sg13cmos5l_decap_8
XFILLER_13_1068 VPWR VGND sg13cmos5l_decap_8
X_140_ _140_/Q Tile_X0Y0_FrameData[12] VGND VPWR Tile_X1Y0_FrameStrobe[0] latch
X_071_ _071_/X _253_/Q _554_/X _233_/Q VPWR VGND sg13cmos5l_mux2_1
XFILLER_7_517 VPWR VGND sg13cmos5l_decap_8
XFILLER_3_789 VPWR VGND sg13cmos5l_decap_4
XFILLER_2_266 VPWR VGND sg13cmos5l_fill_2
XFILLER_2_200 VPWR VGND sg13cmos5l_decap_8
XANTENNA__549__X Tile_X1Y0_SS4BEG[14] VPWR VGND sg13cmos5l_antennanp
X_338_ _338_/Q Tile_X0Y0_FrameData[15] VGND VPWR Tile_X0Y0_FrameStrobe[2] latch
X_407_ Tile_X0Y0_FrameStrobe_O[16] Tile_X0Y0_FrameStrobe[16] VPWR VGND sg13cmos5l_buf_1
X_269_ _269_/Q Tile_X0Y0_FrameData[20] VGND VPWR Tile_X0Y0_FrameStrobe[0] latch
XANTENNA__459__X Tile_X1Y0_FrameData_O[12] VPWR VGND sg13cmos5l_antennanp
XANTENNA_11 Tile_X0Y0_FrameData[0] VPWR VGND sg13cmos5l_antennanp
XANTENNA_22 Tile_X0Y0_FrameData[0] VPWR VGND sg13cmos5l_antennanp
XANTENNA_33 Tile_X0Y0_FrameData[0] VPWR VGND sg13cmos5l_antennanp
XANTENNA_44 Tile_X0Y0_FrameData[11] VPWR VGND sg13cmos5l_antennanp
XANTENNA_55 Tile_X0Y0_FrameData[11] VPWR VGND sg13cmos5l_antennanp
XANTENNA_66 Tile_X0Y0_FrameData[11] VPWR VGND sg13cmos5l_antennanp
XANTENNA_77 Tile_X0Y0_FrameData[11] VPWR VGND sg13cmos5l_antennanp
XANTENNA_88 Tile_X0Y0_FrameData[13] VPWR VGND sg13cmos5l_antennanp
XANTENNA_99 Tile_X0Y0_FrameData[13] VPWR VGND sg13cmos5l_antennanp
XFILLER_0_715 VPWR VGND sg13cmos5l_fill_1
XFILLER_0_737 VPWR VGND sg13cmos5l_decap_8
XFILLER_0_759 VPWR VGND sg13cmos5l_fill_2
XFILLER_11_321 VPWR VGND sg13cmos5l_fill_1
XFILLER_15_126 VPWR VGND sg13cmos5l_decap_8
XFILLER_16_638 VPWR VGND sg13cmos5l_decap_8
X_123_ _123_/Q Tile_X0Y0_FrameData[29] VGND VPWR Tile_X1Y0_FrameStrobe[0] latch
XFILLER_7_28 VPWR VGND sg13cmos5l_decap_8
XFILLER_11_70 VPWR VGND sg13cmos5l_decap_8
XFILLER_3_542 VPWR VGND sg13cmos5l_decap_8
XFILLER_16_7 VPWR VGND sg13cmos5l_decap_8
XFILLER_4_1066 VPWR VGND sg13cmos5l_decap_8
XFILLER_15_671 VPWR VGND sg13cmos5l_decap_8
XFILLER_10_1027 VPWR VGND sg13cmos5l_fill_2
XFILLER_4_317 VPWR VGND sg13cmos5l_decap_8
XFILLER_16_424 VPWR VGND sg13cmos5l_decap_8
XFILLER_12_652 VPWR VGND sg13cmos5l_decap_4
XFILLER_8_623 VPWR VGND sg13cmos5l_decap_8
XFILLER_11_184 VPWR VGND sg13cmos5l_decap_8
X_106_ _106_/Y _120_/A _250_/D VPWR VGND sg13cmos5l_nor2_1
XANTENNA__472__X Tile_X1Y0_FrameData_O[25] VPWR VGND sg13cmos5l_antennanp
XANTENNA__382__X Tile_X0Y0_SS4BEG[7] VPWR VGND sg13cmos5l_antennanp
XFILLER_13_427 VPWR VGND sg13cmos5l_decap_8
XFILLER_14_939 VPWR VGND sg13cmos5l_fill_2
XFILLER_1_821 VPWR VGND sg13cmos5l_fill_1
XFILLER_16_254 VPWR VGND sg13cmos5l_decap_8
XFILLER_1_1014 VPWR VGND sg13cmos5l_decap_8
X_586_ _586_/X Tile_X0Y0_N2END[2] Tile_X0Y0_N4END[2] Tile_X0Y0_NN4END[13] _092_/X
+ _297_/Q _296_/Q VPWR VGND sg13cmos5l_mux4_1
XFILLER_8_497 VPWR VGND sg13cmos5l_decap_8
XFILLER_8_431 VPWR VGND sg13cmos5l_fill_2
XANTENNA__467__X Tile_X1Y0_FrameData_O[20] VPWR VGND sg13cmos5l_antennanp
XFILLER_13_49 VPWR VGND sg13cmos5l_decap_8
XANTENNA_304 Tile_X0Y0_FrameData[9] VPWR VGND sg13cmos5l_antennanp
XANTENNA_315 Tile_X0Y0_FrameData[9] VPWR VGND sg13cmos5l_antennanp
XANTENNA_326 Tile_X0Y0_FrameData[9] VPWR VGND sg13cmos5l_antennanp
XANTENNA_337 Tile_X0Y0_FrameData[9] VPWR VGND sg13cmos5l_antennanp
XANTENNA_348 Tile_X1Y0_N4END[1] VPWR VGND sg13cmos5l_antennanp
XANTENNA_359 Tile_X0Y0_FrameData[24] VPWR VGND sg13cmos5l_antennanp
XANTENNA__377__X Tile_X0Y0_SS4BEG[2] VPWR VGND sg13cmos5l_antennanp
XFILLER_13_224 VPWR VGND sg13cmos5l_decap_8
XFILLER_14_714 VPWR VGND sg13cmos5l_decap_4
XFILLER_14_736 VPWR VGND sg13cmos5l_decap_8
X_371_ _371_/L_HI VPWR VGND sg13cmos5l_tiehi
X_440_ Tile_X0Y0_S4BEG[9] _577_/X VPWR VGND sg13cmos5l_buf_1
XFILLER_10_942 VPWR VGND sg13cmos5l_fill_1
XFILLER_10_953 VPWR VGND sg13cmos5l_fill_1
XFILLER_10_975 VPWR VGND sg13cmos5l_fill_1
XFILLER_10_986 VPWR VGND sg13cmos5l_decap_4
XFILLER_16_1033 VPWR VGND sg13cmos5l_decap_8
XFILLER_16_1077 VPWR VGND sg13cmos5l_fill_2
XFILLER_5_456 VPWR VGND sg13cmos5l_decap_8
XFILLER_1_684 VPWR VGND sg13cmos5l_decap_4
X_638_ _638_/X Tile_X1Y0_N2END[6] Tile_X1Y0_N4END[14] Tile_X1Y0_NN4END[1] _089_/X
+ _144_/Q _143_/Q VPWR VGND sg13cmos5l_mux4_1
X_569_ _569_/X Tile_X0Y0_N2MID[1] Tile_X0Y0_N4END[14] Tile_X0Y0_NN4END[1] _119_/X
+ _331_/Q _330_/Q VPWR VGND sg13cmos5l_mux4_1
XFILLER_8_250 VPWR VGND sg13cmos5l_fill_2
XFILLER_3_905 VPWR VGND sg13cmos5l_decap_8
XFILLER_2_437 VPWR VGND sg13cmos5l_decap_8
XANTENNA_101 Tile_X0Y0_FrameData[13] VPWR VGND sg13cmos5l_antennanp
XANTENNA_112 Tile_X0Y0_FrameData[13] VPWR VGND sg13cmos5l_antennanp
XANTENNA_123 Tile_X0Y0_FrameData[13] VPWR VGND sg13cmos5l_antennanp
XANTENNA_134 Tile_X0Y0_FrameData[13] VPWR VGND sg13cmos5l_antennanp
XANTENNA_145 Tile_X0Y0_FrameData[18] VPWR VGND sg13cmos5l_antennanp
XANTENNA_156 Tile_X0Y0_FrameData[18] VPWR VGND sg13cmos5l_antennanp
XANTENNA_167 Tile_X0Y0_FrameData[1] VPWR VGND sg13cmos5l_antennanp
XANTENNA_178 Tile_X0Y0_FrameData[1] VPWR VGND sg13cmos5l_antennanp
XANTENNA_189 Tile_X0Y0_FrameData[1] VPWR VGND sg13cmos5l_antennanp
XFILLER_14_511 VPWR VGND sg13cmos5l_decap_8
XFILLER_14_588 VPWR VGND sg13cmos5l_decap_8
XFILLER_14_599 VPWR VGND sg13cmos5l_fill_2
X_354_ _354_/L_HI VPWR VGND sg13cmos5l_tiehi
X_423_ Tile_X0Y0_S2BEGb[0] _560_/X VPWR VGND sg13cmos5l_buf_1
XFILLER_10_761 VPWR VGND sg13cmos5l_decap_8
XFILLER_14_70 VPWR VGND sg13cmos5l_decap_8
X_285_ _285_/Q Tile_X0Y0_FrameData[4] VGND VPWR Tile_X0Y0_FrameStrobe[0] latch
XFILLER_6_710 VPWR VGND sg13cmos5l_fill_2
XFILLER_1_470 VPWR VGND sg13cmos5l_decap_8
XFILLER_5_275 VPWR VGND sg13cmos5l_fill_1
XFILLER_2_982 VPWR VGND sg13cmos5l_decap_8
XFILLER_7_1075 VPWR VGND sg13cmos5l_decap_8
XANTENNA__480__X Tile_X1Y0_FrameStrobe_O[1] VPWR VGND sg13cmos5l_antennanp
XFILLER_10_28 VPWR VGND sg13cmos5l_decap_8
XFILLER_9_581 VPWR VGND sg13cmos5l_decap_8
XFILLER_11_514 VPWR VGND sg13cmos5l_decap_8
XANTENNA__390__X Tile_X0Y0_SS4BEG[15] VPWR VGND sg13cmos5l_antennanp
XFILLER_13_1047 VPWR VGND sg13cmos5l_decap_8
X_070_ _070_/Y _120_/A _245_/D VPWR VGND sg13cmos5l_nor2_1
XFILLER_3_713 VPWR VGND sg13cmos5l_fill_1
XFILLER_3_757 VPWR VGND sg13cmos5l_decap_8
XFILLER_14_385 VPWR VGND sg13cmos5l_decap_8
X_337_ _337_/Q Tile_X0Y0_FrameData[16] VGND VPWR Tile_X0Y0_FrameStrobe[2] latch
X_406_ Tile_X0Y0_FrameStrobe_O[15] Tile_X0Y0_FrameStrobe[15] VPWR VGND sg13cmos5l_buf_1
XFILLER_10_591 VPWR VGND sg13cmos5l_decap_8
X_268_ _268_/Q Tile_X0Y0_FrameData[21] VGND VPWR Tile_X0Y0_FrameStrobe[0] latch
X_199_ _199_/Q Tile_X0Y0_FrameData[17] VGND VPWR Tile_X1Y0_FrameStrobe[2] latch
XFILLER_6_584 VPWR VGND sg13cmos5l_decap_8
XANTENNA__475__X Tile_X1Y0_FrameData_O[28] VPWR VGND sg13cmos5l_antennanp
XANTENNA_12 Tile_X0Y0_FrameData[0] VPWR VGND sg13cmos5l_antennanp
XANTENNA_23 Tile_X0Y0_FrameData[0] VPWR VGND sg13cmos5l_antennanp
XANTENNA_34 Tile_X0Y0_FrameData[0] VPWR VGND sg13cmos5l_antennanp
XANTENNA_45 Tile_X0Y0_FrameData[11] VPWR VGND sg13cmos5l_antennanp
XANTENNA_56 Tile_X0Y0_FrameData[11] VPWR VGND sg13cmos5l_antennanp
XANTENNA_67 Tile_X0Y0_FrameData[11] VPWR VGND sg13cmos5l_antennanp
XANTENNA_78 Tile_X0Y0_FrameData[11] VPWR VGND sg13cmos5l_antennanp
XANTENNA_89 Tile_X0Y0_FrameData[13] VPWR VGND sg13cmos5l_antennanp
XFILLER_0_705 VPWR VGND sg13cmos5l_decap_8
XFILLER_12_1091 VPWR VGND sg13cmos5l_decap_8
XANTENNA__385__X Tile_X0Y0_SS4BEG[10] VPWR VGND sg13cmos5l_antennanp
XFILLER_15_105 VPWR VGND sg13cmos5l_decap_8
XFILLER_16_628 VPWR VGND sg13cmos5l_decap_8
XFILLER_12_834 VPWR VGND sg13cmos5l_fill_2
XFILLER_12_845 VPWR VGND sg13cmos5l_decap_8
XFILLER_12_856 VPWR VGND sg13cmos5l_fill_1
XFILLER_11_388 VPWR VGND sg13cmos5l_decap_8
XFILLER_2_0 VPWR VGND sg13cmos5l_decap_8
X_122_ _122_/Q Tile_X0Y0_FrameData[30] VGND VPWR Tile_X1Y0_FrameStrobe[0] latch
XFILLER_7_326 VPWR VGND sg13cmos5l_fill_2
XFILLER_3_521 VPWR VGND sg13cmos5l_decap_8
XFILLER_15_650 VPWR VGND sg13cmos5l_decap_8
XFILLER_4_1045 VPWR VGND sg13cmos5l_decap_8
XFILLER_14_182 VPWR VGND sg13cmos5l_decap_8
XFILLER_13_609 VPWR VGND sg13cmos5l_decap_8
XFILLER_16_49 VPWR VGND sg13cmos5l_decap_8
XFILLER_10_1006 VPWR VGND sg13cmos5l_decap_8
XFILLER_10_1039 VPWR VGND sg13cmos5l_decap_8
XFILLER_5_808 VPWR VGND sg13cmos5l_decap_8
XFILLER_0_502 VPWR VGND sg13cmos5l_decap_4
XFILLER_16_458 VPWR VGND sg13cmos5l_decap_4
XFILLER_11_163 VPWR VGND sg13cmos5l_decap_8
XFILLER_12_631 VPWR VGND sg13cmos5l_decap_8
XFILLER_12_664 VPWR VGND sg13cmos5l_decap_8
X_105_ _250_/D _647_/X _224_/Q _232_/Q VPWR VGND sg13cmos5l_mux2_1
XFILLER_8_668 VPWR VGND sg13cmos5l_decap_8
XFILLER_8_635 VPWR VGND sg13cmos5l_decap_8
XFILLER_8_602 VPWR VGND sg13cmos5l_decap_8
XFILLER_7_156 VPWR VGND sg13cmos5l_fill_1
XFILLER_7_178 VPWR VGND sg13cmos5l_decap_8
XFILLER_4_885 VPWR VGND sg13cmos5l_fill_1
XFILLER_4_874 VPWR VGND sg13cmos5l_decap_8
XFILLER_4_841 VPWR VGND sg13cmos5l_decap_8
XFILLER_16_992 VPWR VGND sg13cmos5l_fill_1
XFILLER_13_406 VPWR VGND sg13cmos5l_decap_8
XFILLER_4_104 VPWR VGND sg13cmos5l_decap_8
XFILLER_0_387 VPWR VGND sg13cmos5l_fill_1
XFILLER_16_233 VPWR VGND sg13cmos5l_decap_8
X_585_ _585_/X Tile_X0Y0_N2END[1] Tile_X0Y0_N4END[1] Tile_X0Y0_NN4END[14] _119_/X
+ _299_/Q _298_/Q VPWR VGND sg13cmos5l_mux4_1
XFILLER_9_911 VPWR VGND sg13cmos5l_fill_1
XFILLER_9_900 VPWR VGND sg13cmos5l_fill_2
XFILLER_8_476 VPWR VGND sg13cmos5l_decap_8
XFILLER_8_410 VPWR VGND sg13cmos5l_decap_8
XANTENNA__483__X Tile_X1Y0_FrameStrobe_O[4] VPWR VGND sg13cmos5l_antennanp
XFILLER_10_409 VPWR VGND sg13cmos5l_decap_8
XFILLER_13_28 VPWR VGND sg13cmos5l_decap_8
XFILLER_11_1101 VPWR VGND sg13cmos5l_fill_1
XANTENNA_305 Tile_X0Y0_FrameData[9] VPWR VGND sg13cmos5l_antennanp
XANTENNA_316 Tile_X0Y0_FrameData[9] VPWR VGND sg13cmos5l_antennanp
XANTENNA_327 Tile_X0Y0_FrameData[9] VPWR VGND sg13cmos5l_antennanp
XANTENNA_338 Tile_X0Y0_FrameData[9] VPWR VGND sg13cmos5l_antennanp
XANTENNA_349 Tile_X1Y0_N4END[1] VPWR VGND sg13cmos5l_antennanp
XANTENNA__393__X Tile_X0Y0_FrameStrobe_O[2] VPWR VGND sg13cmos5l_antennanp
XFILLER_0_1092 VPWR VGND sg13cmos5l_decap_8
XFILLER_13_203 VPWR VGND sg13cmos5l_decap_8
XFILLER_14_726 VPWR VGND sg13cmos5l_decap_8
X_370_ _370_/L_HI VPWR VGND sg13cmos5l_tiehi
XFILLER_10_932 VPWR VGND sg13cmos5l_fill_2
XFILLER_16_1056 VPWR VGND sg13cmos5l_fill_1
XFILLER_16_1089 VPWR VGND sg13cmos5l_decap_8
XFILLER_6_936 VPWR VGND sg13cmos5l_fill_1
XFILLER_6_914 VPWR VGND sg13cmos5l_fill_1
XFILLER_5_435 VPWR VGND sg13cmos5l_decap_8
XFILLER_1_652 VPWR VGND sg13cmos5l_decap_4
X_637_ _637_/X Tile_X1Y0_N2END[5] Tile_X1Y0_N4END[13] Tile_X1Y0_NN4END[2] _087_/X
+ _146_/Q _145_/Q VPWR VGND sg13cmos5l_mux4_1
X_499_ Tile_X1Y0_S1BEG[0] Tile_X1Y0_N1END[3] VPWR VGND sg13cmos5l_buf_1
X_568_ _568_/X Tile_X0Y0_N2MID[0] Tile_X0Y0_N4END[15] Tile_X0Y0_NN4END[0] _092_/X
+ _333_/Q _332_/Q VPWR VGND sg13cmos5l_mux4_1
XFILLER_8_262 VPWR VGND sg13cmos5l_fill_1
XANTENNA__478__X Tile_X1Y0_FrameData_O[31] VPWR VGND sg13cmos5l_antennanp
XFILLER_5_84 VPWR VGND sg13cmos5l_fill_1
XFILLER_10_206 VPWR VGND sg13cmos5l_decap_4
XFILLER_10_239 VPWR VGND sg13cmos5l_decap_4
XFILLER_6_7 VPWR VGND sg13cmos5l_decap_8
XANTENNA_102 Tile_X0Y0_FrameData[13] VPWR VGND sg13cmos5l_antennanp
XANTENNA_113 Tile_X0Y0_FrameData[13] VPWR VGND sg13cmos5l_antennanp
XANTENNA_124 Tile_X0Y0_FrameData[13] VPWR VGND sg13cmos5l_antennanp
XANTENNA__388__X Tile_X0Y0_SS4BEG[13] VPWR VGND sg13cmos5l_antennanp
XANTENNA_135 Tile_X0Y0_FrameData[18] VPWR VGND sg13cmos5l_antennanp
XANTENNA_146 Tile_X0Y0_FrameData[18] VPWR VGND sg13cmos5l_antennanp
XANTENNA_157 Tile_X0Y0_FrameData[18] VPWR VGND sg13cmos5l_antennanp
XANTENNA_168 Tile_X0Y0_FrameData[1] VPWR VGND sg13cmos5l_antennanp
XANTENNA_179 Tile_X0Y0_FrameData[1] VPWR VGND sg13cmos5l_antennanp
XFILLER_14_567 VPWR VGND sg13cmos5l_decap_8
X_284_ _284_/Q Tile_X0Y0_FrameData[5] VGND VPWR Tile_X0Y0_FrameStrobe[0] latch
X_353_ _353_/L_HI VPWR VGND sg13cmos5l_tiehi
X_422_ Tile_X0Y0_S2BEG[7] Tile_X0Y0_N2MID[0] VPWR VGND sg13cmos5l_buf_1
XFILLER_5_221 VPWR VGND sg13cmos5l_decap_8
XFILLER_7_1054 VPWR VGND sg13cmos5l_decap_8
XFILLER_9_560 VPWR VGND sg13cmos5l_decap_8
XFILLER_13_1026 VPWR VGND sg13cmos5l_decap_8
XFILLER_3_725 VPWR VGND sg13cmos5l_fill_1
XFILLER_2_235 VPWR VGND sg13cmos5l_fill_2
XFILLER_15_843 VPWR VGND sg13cmos5l_fill_2
XFILLER_10_570 VPWR VGND sg13cmos5l_decap_8
XFILLER_14_364 VPWR VGND sg13cmos5l_decap_8
X_267_ _267_/Q Tile_X0Y0_FrameData[22] VGND VPWR Tile_X0Y0_FrameStrobe[0] latch
X_336_ _336_/Q Tile_X0Y0_FrameData[17] VGND VPWR Tile_X0Y0_FrameStrobe[2] latch
X_405_ Tile_X0Y0_FrameStrobe_O[14] Tile_X0Y0_FrameStrobe[14] VPWR VGND sg13cmos5l_buf_1
X_198_ _198_/Q Tile_X0Y0_FrameData[18] VGND VPWR Tile_X1Y0_FrameStrobe[2] latch
XFILLER_9_1105 VPWR VGND sg13cmos5l_fill_1
XFILLER_6_563 VPWR VGND sg13cmos5l_decap_8
XFILLER_1_290 VPWR VGND sg13cmos5l_decap_4
XFILLER_2_96 VPWR VGND sg13cmos5l_decap_8
XFILLER_2_63 VPWR VGND sg13cmos5l_decap_4
XANTENNA_13 Tile_X0Y0_FrameData[0] VPWR VGND sg13cmos5l_antennanp
XANTENNA_24 Tile_X0Y0_FrameData[0] VPWR VGND sg13cmos5l_antennanp
XANTENNA_35 Tile_X0Y0_FrameData[0] VPWR VGND sg13cmos5l_antennanp
XANTENNA_46 Tile_X0Y0_FrameData[11] VPWR VGND sg13cmos5l_antennanp
XANTENNA_57 Tile_X0Y0_FrameData[11] VPWR VGND sg13cmos5l_antennanp
XANTENNA_68 Tile_X0Y0_FrameData[11] VPWR VGND sg13cmos5l_antennanp
XANTENNA_79 Tile_X0Y0_FrameData[11] VPWR VGND sg13cmos5l_antennanp
XANTENNA__491__X Tile_X1Y0_FrameStrobe_O[12] VPWR VGND sg13cmos5l_antennanp
XFILLER_12_1070 VPWR VGND sg13cmos5l_decap_8
XFILLER_16_618 VPWR VGND sg13cmos5l_fill_2
XFILLER_11_367 VPWR VGND sg13cmos5l_decap_8
XFILLER_12_802 VPWR VGND sg13cmos5l_decap_4
X_121_ PMOD_IO_OE_O1 _120_/A _061_/Y _110_/X _223_/Q _120_/Y VPWR VGND sg13cmos5l_a221oi_1
XFILLER_8_828 VPWR VGND sg13cmos5l_decap_8
XFILLER_3_577 VPWR VGND sg13cmos5l_decap_8
XFILLER_3_500 VPWR VGND sg13cmos5l_decap_8
XFILLER_4_1024 VPWR VGND sg13cmos5l_decap_8
XFILLER_14_161 VPWR VGND sg13cmos5l_decap_8
X_319_ _319_/Q Tile_X0Y0_FrameData[2] VGND VPWR Tile_X0Y0_FrameStrobe[1] latch
XFILLER_7_894 VPWR VGND sg13cmos5l_fill_2
XANTENNA__486__X Tile_X1Y0_FrameStrobe_O[7] VPWR VGND sg13cmos5l_antennanp
XFILLER_16_28 VPWR VGND sg13cmos5l_decap_8
XFILLER_10_1029 VPWR VGND sg13cmos5l_fill_1
XANTENNA__396__X Tile_X0Y0_FrameStrobe_O[5] VPWR VGND sg13cmos5l_antennanp
XFILLER_12_610 VPWR VGND sg13cmos5l_decap_8
XFILLER_16_437 VPWR VGND sg13cmos5l_decap_8
XFILLER_11_142 VPWR VGND sg13cmos5l_decap_8
X_104_ PMOD_IO_OE_O5 _223_/Q _101_/X _103_/Y VPWR VGND sg13cmos5l_a21oi_1
XFILLER_7_146 VPWR VGND sg13cmos5l_fill_2
XFILLER_4_897 VPWR VGND sg13cmos5l_fill_2
XFILLER_3_352 VPWR VGND sg13cmos5l_decap_8
XFILLER_15_492 VPWR VGND sg13cmos5l_decap_8
XFILLER_16_971 VPWR VGND sg13cmos5l_fill_2
XFILLER_8_84 VPWR VGND sg13cmos5l_decap_8
XFILLER_5_617 VPWR VGND sg13cmos5l_decap_4
XFILLER_0_300 VPWR VGND sg13cmos5l_fill_1
XFILLER_16_212 VPWR VGND sg13cmos5l_decap_8
XFILLER_1_1049 VPWR VGND sg13cmos5l_decap_8
XFILLER_16_289 VPWR VGND sg13cmos5l_decap_4
X_584_ _584_/X Tile_X0Y0_N2END[0] Tile_X0Y0_N4END[0] Tile_X0Y0_NN4END[15] _091_/X
+ _301_/Q _300_/Q VPWR VGND sg13cmos5l_mux4_1
XFILLER_12_484 VPWR VGND sg13cmos5l_decap_8
XFILLER_8_455 VPWR VGND sg13cmos5l_decap_8
XFILLER_8_433 VPWR VGND sg13cmos5l_fill_1
XFILLER_11_1113 VPWR VGND sg13cmos5l_fill_1
XFILLER_1_108 VPWR VGND sg13cmos5l_decap_4
XANTENNA_306 Tile_X0Y0_FrameData[9] VPWR VGND sg13cmos5l_antennanp
XANTENNA_317 Tile_X0Y0_FrameData[9] VPWR VGND sg13cmos5l_antennanp
XANTENNA_328 Tile_X0Y0_FrameData[9] VPWR VGND sg13cmos5l_antennanp
XANTENNA_339 Tile_X0Y0_N2MID[4] VPWR VGND sg13cmos5l_antennanp
XFILLER_13_259 VPWR VGND sg13cmos5l_decap_8
XFILLER_16_1013 VPWR VGND sg13cmos5l_fill_2
XFILLER_9_219 VPWR VGND sg13cmos5l_decap_8
XFILLER_10_922 VPWR VGND sg13cmos5l_fill_2
XFILLER_10_999 VPWR VGND sg13cmos5l_decap_8
XFILLER_6_926 VPWR VGND sg13cmos5l_fill_1
XFILLER_5_414 VPWR VGND sg13cmos5l_decap_8
XFILLER_0_130 VPWR VGND sg13cmos5l_fill_1
X_636_ _636_/X Tile_X1Y0_N2END[4] Tile_X1Y0_N4END[12] Tile_X1Y0_NN4END[3] _085_/X
+ _148_/Q _147_/Q VPWR VGND sg13cmos5l_mux4_1
X_567_ _567_/X Tile_X0Y0_N1END[3] Tile_X0Y0_N2MID[7] Tile_X0Y0_N2END[0] _119_/X _335_/Q
+ _334_/Q VPWR VGND sg13cmos5l_mux4_1
XFILLER_12_281 VPWR VGND sg13cmos5l_decap_8
XFILLER_13_793 VPWR VGND sg13cmos5l_decap_8
X_498_ Tile_X1Y0_FrameStrobe_O[19] Tile_X1Y0_FrameStrobe[19] VPWR VGND sg13cmos5l_buf_1
XFILLER_5_63 VPWR VGND sg13cmos5l_decap_8
XFILLER_4_480 VPWR VGND sg13cmos5l_decap_8
XFILLER_10_0 VPWR VGND sg13cmos5l_decap_8
XANTENNA__494__X Tile_X1Y0_FrameStrobe_O[15] VPWR VGND sg13cmos5l_antennanp
XANTENNA_103 Tile_X0Y0_FrameData[13] VPWR VGND sg13cmos5l_antennanp
XANTENNA_114 Tile_X0Y0_FrameData[13] VPWR VGND sg13cmos5l_antennanp
XANTENNA_125 Tile_X0Y0_FrameData[13] VPWR VGND sg13cmos5l_antennanp
XANTENNA_136 Tile_X0Y0_FrameData[18] VPWR VGND sg13cmos5l_antennanp
XANTENNA_147 Tile_X0Y0_FrameData[18] VPWR VGND sg13cmos5l_antennanp
XANTENNA_158 Tile_X0Y0_FrameData[18] VPWR VGND sg13cmos5l_antennanp
X_421_ Tile_X0Y0_S2BEG[6] Tile_X0Y0_N2MID[1] VPWR VGND sg13cmos5l_buf_1
XANTENNA_169 Tile_X0Y0_FrameData[1] VPWR VGND sg13cmos5l_antennanp
XFILLER_14_546 VPWR VGND sg13cmos5l_decap_8
X_283_ _283_/Q Tile_X0Y0_FrameData[6] VGND VPWR Tile_X0Y0_FrameStrobe[0] latch
X_352_ _352_/L_HI VPWR VGND sg13cmos5l_tiehi
XFILLER_6_712 VPWR VGND sg13cmos5l_fill_1
XFILLER_5_266 VPWR VGND sg13cmos5l_decap_4
XFILLER_5_200 VPWR VGND sg13cmos5l_decap_8
XFILLER_7_1033 VPWR VGND sg13cmos5l_decap_8
X_619_ _619_/X Tile_X1Y0_N2MID[3] Tile_X1Y0_N4END[4] Tile_X1Y0_NN4END[11] _087_/X
+ _182_/Q _181_/Q VPWR VGND sg13cmos5l_mux4_1
XANTENNA__489__X Tile_X1Y0_FrameStrobe_O[10] VPWR VGND sg13cmos5l_antennanp
XFILLER_11_549 VPWR VGND sg13cmos5l_decap_8
XFILLER_13_1005 VPWR VGND sg13cmos5l_decap_8
XFILLER_2_214 VPWR VGND sg13cmos5l_decap_8
XANTENNA__399__X Tile_X0Y0_FrameStrobe_O[8] VPWR VGND sg13cmos5l_antennanp
XFILLER_14_343 VPWR VGND sg13cmos5l_decap_8
X_404_ Tile_X0Y0_FrameStrobe_O[13] Tile_X0Y0_FrameStrobe[13] VPWR VGND sg13cmos5l_buf_1
X_266_ _266_/Q Tile_X0Y0_FrameData[23] VGND VPWR Tile_X0Y0_FrameStrobe[0] latch
X_335_ _335_/Q Tile_X0Y0_FrameData[18] VGND VPWR Tile_X0Y0_FrameStrobe[2] latch
X_197_ _197_/Q Tile_X0Y0_FrameData[19] VGND VPWR Tile_X1Y0_FrameStrobe[2] latch
XFILLER_6_542 VPWR VGND sg13cmos5l_decap_8
XFILLER_2_75 VPWR VGND sg13cmos5l_decap_8
XFILLER_2_42 VPWR VGND sg13cmos5l_decap_8
XANTENNA_14 Tile_X0Y0_FrameData[0] VPWR VGND sg13cmos5l_antennanp
XANTENNA_25 Tile_X0Y0_FrameData[0] VPWR VGND sg13cmos5l_antennanp
XANTENNA_36 Tile_X0Y0_FrameData[0] VPWR VGND sg13cmos5l_antennanp
XANTENNA_47 Tile_X0Y0_FrameData[11] VPWR VGND sg13cmos5l_antennanp
XANTENNA_58 Tile_X0Y0_FrameData[11] VPWR VGND sg13cmos5l_antennanp
XANTENNA_69 Tile_X0Y0_FrameData[11] VPWR VGND sg13cmos5l_antennanp
XFILLER_9_391 VPWR VGND sg13cmos5l_decap_8
X_120_ _120_/Y _120_/A _244_/D VPWR VGND sg13cmos5l_nor2_1
XFILLER_8_807 VPWR VGND sg13cmos5l_decap_8
XFILLER_7_328 VPWR VGND sg13cmos5l_fill_1
XFILLER_11_84 VPWR VGND sg13cmos5l_decap_8
XFILLER_11_95 VPWR VGND sg13cmos5l_fill_1
XFILLER_3_556 VPWR VGND sg13cmos5l_decap_8
XFILLER_4_1003 VPWR VGND sg13cmos5l_decap_8
XFILLER_14_140 VPWR VGND sg13cmos5l_decap_8
XFILLER_15_685 VPWR VGND sg13cmos5l_decap_8
XFILLER_10_390 VPWR VGND sg13cmos5l_decap_8
X_318_ _318_/Q Tile_X0Y0_FrameData[3] VGND VPWR Tile_X0Y0_FrameStrobe[1] latch
X_249_ _249_/Q Tile_X0Y0_UserCLK _249_/D _354_/L_HI VPWR VGND sg13cmos5l_dfrbpq_1
XFILLER_7_873 VPWR VGND sg13cmos5l_decap_8
XFILLER_7_862 VPWR VGND sg13cmos5l_decap_8
XFILLER_7_840 VPWR VGND sg13cmos5l_fill_1
XFILLER_0_559 VPWR VGND sg13cmos5l_decap_8
XFILLER_16_405 VPWR VGND sg13cmos5l_fill_2
XFILLER_11_121 VPWR VGND sg13cmos5l_decap_8
XFILLER_11_198 VPWR VGND sg13cmos5l_decap_8
X_103_ _103_/Y _120_/A _248_/D _102_/X VPWR VGND sg13cmos5l_o21ai_1
XFILLER_7_103 VPWR VGND sg13cmos5l_decap_8
XFILLER_4_865 VPWR VGND sg13cmos5l_fill_2
XFILLER_14_7 VPWR VGND sg13cmos5l_decap_8
XFILLER_15_471 VPWR VGND sg13cmos5l_decap_8
XFILLER_8_63 VPWR VGND sg13cmos5l_decap_8
XANTENNA__497__X Tile_X1Y0_FrameStrobe_O[18] VPWR VGND sg13cmos5l_antennanp
XFILLER_0_334 VPWR VGND sg13cmos5l_fill_2
XFILLER_1_802 VPWR VGND sg13cmos5l_decap_8
XFILLER_1_879 VPWR VGND sg13cmos5l_fill_2
XFILLER_1_1028 VPWR VGND sg13cmos5l_decap_8
X_583_ _583_/X Tile_X0Y0_N2MID[7] Tile_X0Y0_N4END[0] Tile_X0Y0_NN4END[15] _092_/X
+ _303_/Q _302_/Q VPWR VGND sg13cmos5l_mux4_1
XFILLER_12_463 VPWR VGND sg13cmos5l_decap_8
XFILLER_13_942 VPWR VGND sg13cmos5l_fill_2
XFILLER_13_975 VPWR VGND sg13cmos5l_decap_4
XFILLER_16_268 VPWR VGND sg13cmos5l_decap_8
XFILLER_4_673 VPWR VGND sg13cmos5l_decap_8
XFILLER_3_161 VPWR VGND sg13cmos5l_fill_2
XFILLER_0_890 VPWR VGND sg13cmos5l_decap_8
XANTENNA_307 Tile_X0Y0_FrameData[9] VPWR VGND sg13cmos5l_antennanp
XANTENNA_318 Tile_X0Y0_FrameData[9] VPWR VGND sg13cmos5l_antennanp
XANTENNA_329 Tile_X0Y0_FrameData[9] VPWR VGND sg13cmos5l_antennanp
XFILLER_0_1083 VPWR VGND sg13cmos5l_fill_1
XFILLER_13_238 VPWR VGND sg13cmos5l_decap_8
XFILLER_16_1047 VPWR VGND sg13cmos5l_fill_2
XFILLER_6_905 VPWR VGND sg13cmos5l_decap_8
XFILLER_0_197 VPWR VGND sg13cmos5l_decap_8
X_635_ _635_/X Tile_X1Y0_N2END[3] Tile_X1Y0_N4END[11] Tile_X1Y0_NN4END[4] _095_/X
+ _150_/Q _149_/Q VPWR VGND sg13cmos5l_mux4_1
X_566_ _566_/X Tile_X0Y0_N1END[2] Tile_X0Y0_N2MID[6] Tile_X0Y0_N2END[1] _092_/X _337_/Q
+ _336_/Q VPWR VGND sg13cmos5l_mux4_1
XFILLER_12_260 VPWR VGND sg13cmos5l_decap_8
X_497_ Tile_X1Y0_FrameStrobe_O[18] Tile_X1Y0_FrameStrobe[18] VPWR VGND sg13cmos5l_buf_1
XFILLER_9_765 VPWR VGND sg13cmos5l_decap_8
XFILLER_5_960 VPWR VGND sg13cmos5l_fill_2
XFILLER_5_42 VPWR VGND sg13cmos5l_decap_8
XFILLER_15_1091 VPWR VGND sg13cmos5l_decap_8
XFILLER_2_418 VPWR VGND sg13cmos5l_fill_1
XANTENNA_104 Tile_X0Y0_FrameData[13] VPWR VGND sg13cmos5l_antennanp
XANTENNA_115 Tile_X0Y0_FrameData[13] VPWR VGND sg13cmos5l_antennanp
XANTENNA_126 Tile_X0Y0_FrameData[13] VPWR VGND sg13cmos5l_antennanp
XANTENNA_137 Tile_X0Y0_FrameData[18] VPWR VGND sg13cmos5l_antennanp
XANTENNA_148 Tile_X0Y0_FrameData[18] VPWR VGND sg13cmos5l_antennanp
XANTENNA_159 Tile_X0Y0_FrameData[18] VPWR VGND sg13cmos5l_antennanp
XFILLER_14_525 VPWR VGND sg13cmos5l_decap_8
X_351_ _351_/L_HI VPWR VGND sg13cmos5l_tiehi
X_420_ Tile_X0Y0_S2BEG[5] Tile_X0Y0_N2MID[2] VPWR VGND sg13cmos5l_buf_1
XFILLER_2_1112 VPWR VGND sg13cmos5l_fill_2
XFILLER_10_753 VPWR VGND sg13cmos5l_fill_1
XFILLER_10_786 VPWR VGND sg13cmos5l_decap_4
XFILLER_14_84 VPWR VGND sg13cmos5l_decap_8
X_282_ _282_/Q Tile_X0Y0_FrameData[7] VGND VPWR Tile_X0Y0_FrameStrobe[0] latch
XFILLER_6_779 VPWR VGND sg13cmos5l_fill_1
XFILLER_2_963 VPWR VGND sg13cmos5l_fill_1
XFILLER_1_484 VPWR VGND sg13cmos5l_decap_8
XFILLER_7_1012 VPWR VGND sg13cmos5l_decap_8
X_549_ Tile_X1Y0_SS4BEG[14] _638_/X VPWR VGND sg13cmos5l_buf_1
X_618_ _618_/X Tile_X1Y0_N2MID[2] Tile_X1Y0_N4END[5] Tile_X1Y0_NN4END[10] _089_/X
+ _184_/Q _183_/Q VPWR VGND sg13cmos5l_mux4_1
XFILLER_9_595 VPWR VGND sg13cmos5l_decap_8
XFILLER_11_528 VPWR VGND sg13cmos5l_decap_8
XFILLER_2_237 VPWR VGND sg13cmos5l_fill_1
XFILLER_14_322 VPWR VGND sg13cmos5l_decap_8
XFILLER_14_399 VPWR VGND sg13cmos5l_decap_8
X_334_ _334_/Q Tile_X0Y0_FrameData[19] VGND VPWR Tile_X0Y0_FrameStrobe[2] latch
X_403_ Tile_X0Y0_FrameStrobe_O[12] Tile_X0Y0_FrameStrobe[12] VPWR VGND sg13cmos5l_buf_1
X_265_ _265_/Q Tile_X0Y0_FrameData[24] VGND VPWR Tile_X0Y0_FrameStrobe[0] latch
X_196_ _196_/Q Tile_X0Y0_FrameData[20] VGND VPWR Tile_X1Y0_FrameStrobe[2] latch
XFILLER_6_521 VPWR VGND sg13cmos5l_decap_8
XFILLER_6_598 VPWR VGND sg13cmos5l_decap_8
XFILLER_2_21 VPWR VGND sg13cmos5l_decap_8
XANTENNA_15 Tile_X0Y0_FrameData[0] VPWR VGND sg13cmos5l_antennanp
XANTENNA_26 Tile_X0Y0_FrameData[0] VPWR VGND sg13cmos5l_antennanp
XANTENNA_37 Tile_X0Y0_FrameData[11] VPWR VGND sg13cmos5l_antennanp
XANTENNA_48 Tile_X0Y0_FrameData[11] VPWR VGND sg13cmos5l_antennanp
XANTENNA_59 Tile_X0Y0_FrameData[11] VPWR VGND sg13cmos5l_antennanp
XFILLER_11_314 VPWR VGND sg13cmos5l_decap_8
XFILLER_15_119 VPWR VGND sg13cmos5l_decap_8
XFILLER_11_63 VPWR VGND sg13cmos5l_decap_8
XFILLER_3_535 VPWR VGND sg13cmos5l_decap_8
XFILLER_4_1059 VPWR VGND sg13cmos5l_decap_8
XFILLER_14_196 VPWR VGND sg13cmos5l_decap_8
XFILLER_15_664 VPWR VGND sg13cmos5l_decap_8
X_317_ _317_/Q Tile_X0Y0_FrameData[4] VGND VPWR Tile_X0Y0_FrameStrobe[1] latch
X_248_ _248_/Q Tile_X0Y0_UserCLK _248_/D _351_/L_HI VPWR VGND sg13cmos5l_dfrbpq_1
X_179_ _179_/Q Tile_X0Y0_FrameData[5] VGND VPWR Tile_X1Y0_FrameStrobe[1] latch
XFILLER_7_896 VPWR VGND sg13cmos5l_fill_1
XFILLER_6_373 VPWR VGND sg13cmos5l_fill_1
XFILLER_6_362 VPWR VGND sg13cmos5l_decap_8
XFILLER_16_417 VPWR VGND sg13cmos5l_decap_8
XFILLER_11_100 VPWR VGND sg13cmos5l_decap_8
XFILLER_12_645 VPWR VGND sg13cmos5l_decap_8
XFILLER_12_656 VPWR VGND sg13cmos5l_fill_1
XFILLER_8_616 VPWR VGND sg13cmos5l_decap_8
XFILLER_11_177 VPWR VGND sg13cmos5l_decap_8
X_102_ _102_/X _233_/Q _248_/Q VPWR VGND sg13cmos5l_or2_1
XFILLER_8_649 VPWR VGND sg13cmos5l_fill_2
XFILLER_7_148 VPWR VGND sg13cmos5l_fill_1
XFILLER_0_0 VPWR VGND sg13cmos5l_decap_8
XFILLER_15_450 VPWR VGND sg13cmos5l_decap_8
XFILLER_16_951 VPWR VGND sg13cmos5l_fill_1
XFILLER_8_42 VPWR VGND sg13cmos5l_decap_8
XFILLER_6_181 VPWR VGND sg13cmos5l_fill_1
XFILLER_4_129 VPWR VGND sg13cmos5l_decap_4
XFILLER_4_118 VPWR VGND sg13cmos5l_decap_4
XFILLER_16_247 VPWR VGND sg13cmos5l_decap_8
XFILLER_1_1007 VPWR VGND sg13cmos5l_decap_8
X_582_ _582_/X Tile_X0Y0_N2MID[6] Tile_X0Y0_N4END[1] Tile_X0Y0_NN4END[14] _091_/X
+ _305_/Q _304_/Q VPWR VGND sg13cmos5l_mux4_1
XFILLER_12_442 VPWR VGND sg13cmos5l_decap_8
XFILLER_9_958 VPWR VGND sg13cmos5l_fill_1
XFILLER_9_947 VPWR VGND sg13cmos5l_fill_1
XFILLER_8_424 VPWR VGND sg13cmos5l_decap_8
XANTENNA_308 Tile_X0Y0_FrameData[9] VPWR VGND sg13cmos5l_antennanp
XANTENNA_319 Tile_X0Y0_FrameData[9] VPWR VGND sg13cmos5l_antennanp
XFILLER_14_707 VPWR VGND sg13cmos5l_decap_8
XFILLER_14_718 VPWR VGND sg13cmos5l_fill_1
XFILLER_13_217 VPWR VGND sg13cmos5l_decap_8
XFILLER_16_1015 VPWR VGND sg13cmos5l_fill_1
XFILLER_16_1026 VPWR VGND sg13cmos5l_decap_8
XFILLER_0_110 VPWR VGND sg13cmos5l_decap_8
XFILLER_0_121 VPWR VGND sg13cmos5l_fill_1
XFILLER_5_449 VPWR VGND sg13cmos5l_decap_8
XFILLER_1_677 VPWR VGND sg13cmos5l_decap_8
X_634_ _634_/X Tile_X1Y0_N2END[2] Tile_X1Y0_N4END[10] Tile_X1Y0_NN4END[5] _064_/X
+ _152_/Q _151_/Q VPWR VGND sg13cmos5l_mux4_1
XFILLER_13_740 VPWR VGND sg13cmos5l_fill_1
XFILLER_13_762 VPWR VGND sg13cmos5l_decap_8
X_496_ Tile_X1Y0_FrameStrobe_O[17] Tile_X1Y0_FrameStrobe[17] VPWR VGND sg13cmos5l_buf_1
X_565_ _565_/X Tile_X0Y0_N1END[1] Tile_X0Y0_N2MID[5] Tile_X0Y0_N2END[2] _091_/X _339_/Q
+ _338_/Q VPWR VGND sg13cmos5l_mux4_1
XFILLER_9_711 VPWR VGND sg13cmos5l_fill_1
XFILLER_13_784 VPWR VGND sg13cmos5l_fill_2
XFILLER_8_298 VPWR VGND sg13cmos5l_decap_8
XFILLER_5_21 VPWR VGND sg13cmos5l_decap_8
XFILLER_5_983 VPWR VGND sg13cmos5l_decap_4
XFILLER_5_972 VPWR VGND sg13cmos5l_fill_1
XFILLER_15_1070 VPWR VGND sg13cmos5l_decap_8
XANTENNA_105 Tile_X0Y0_FrameData[13] VPWR VGND sg13cmos5l_antennanp
XANTENNA_116 Tile_X0Y0_FrameData[13] VPWR VGND sg13cmos5l_antennanp
XANTENNA_127 Tile_X0Y0_FrameData[13] VPWR VGND sg13cmos5l_antennanp
XANTENNA_138 Tile_X0Y0_FrameData[18] VPWR VGND sg13cmos5l_antennanp
XANTENNA_149 Tile_X0Y0_FrameData[18] VPWR VGND sg13cmos5l_antennanp
XFILLER_14_504 VPWR VGND sg13cmos5l_decap_8
X_350_ _350_/Q Tile_X0Y0_FrameData[31] VGND VPWR Tile_X0Y0_FrameStrobe[0] latch
XFILLER_14_63 VPWR VGND sg13cmos5l_decap_8
X_281_ _281_/Q Tile_X0Y0_FrameData[8] VGND VPWR Tile_X0Y0_FrameStrobe[0] latch
XFILLER_6_703 VPWR VGND sg13cmos5l_decap_8
XFILLER_5_235 VPWR VGND sg13cmos5l_fill_2
XFILLER_1_463 VPWR VGND sg13cmos5l_decap_8
XFILLER_2_975 VPWR VGND sg13cmos5l_decap_8
XFILLER_2_953 VPWR VGND sg13cmos5l_fill_2
X_617_ _617_/X Tile_X1Y0_N2MID[1] Tile_X1Y0_N4END[6] Tile_X1Y0_NN4END[9] _064_/X _186_/Q
+ _185_/Q VPWR VGND sg13cmos5l_mux4_1
XFILLER_7_1068 VPWR VGND sg13cmos5l_decap_8
XFILLER_13_581 VPWR VGND sg13cmos5l_decap_8
X_479_ Tile_X1Y0_FrameStrobe_O[0] Tile_X1Y0_FrameStrobe[0] VPWR VGND sg13cmos5l_buf_1
X_548_ Tile_X1Y0_SS4BEG[13] _637_/X VPWR VGND sg13cmos5l_buf_1
XFILLER_9_574 VPWR VGND sg13cmos5l_decap_8
XFILLER_11_507 VPWR VGND sg13cmos5l_decap_8
XFILLER_4_7 VPWR VGND sg13cmos5l_decap_8
XFILLER_6_1090 VPWR VGND sg13cmos5l_decap_8
XFILLER_14_301 VPWR VGND sg13cmos5l_decap_8
XFILLER_14_378 VPWR VGND sg13cmos5l_decap_8
X_264_ _264_/Q Tile_X0Y0_FrameData[25] VGND VPWR Tile_X0Y0_FrameStrobe[0] latch
X_333_ _333_/Q Tile_X0Y0_FrameData[20] VGND VPWR Tile_X0Y0_FrameStrobe[2] latch
X_402_ Tile_X0Y0_FrameStrobe_O[11] Tile_X0Y0_FrameStrobe[11] VPWR VGND sg13cmos5l_buf_1
XFILLER_10_584 VPWR VGND sg13cmos5l_decap_8
X_195_ _195_/Q Tile_X0Y0_FrameData[21] VGND VPWR Tile_X1Y0_FrameStrobe[2] latch
XFILLER_6_577 VPWR VGND sg13cmos5l_decap_8
XFILLER_6_500 VPWR VGND sg13cmos5l_decap_8
XFILLER_2_794 VPWR VGND sg13cmos5l_decap_8
XANTENNA_16 Tile_X0Y0_FrameData[0] VPWR VGND sg13cmos5l_antennanp
XANTENNA_27 Tile_X0Y0_FrameData[0] VPWR VGND sg13cmos5l_antennanp
XANTENNA_38 Tile_X0Y0_FrameData[11] VPWR VGND sg13cmos5l_antennanp
XANTENNA_49 Tile_X0Y0_FrameData[11] VPWR VGND sg13cmos5l_antennanp
XFILLER_12_1084 VPWR VGND sg13cmos5l_decap_8
XFILLER_11_42 VPWR VGND sg13cmos5l_decap_8
XFILLER_3_514 VPWR VGND sg13cmos5l_decap_8
XFILLER_15_643 VPWR VGND sg13cmos5l_decap_8
XFILLER_4_1038 VPWR VGND sg13cmos5l_decap_8
XFILLER_14_175 VPWR VGND sg13cmos5l_decap_8
X_316_ _316_/Q Tile_X0Y0_FrameData[5] VGND VPWR Tile_X0Y0_FrameStrobe[1] latch
X_247_ _247_/Q Tile_X0Y0_UserCLK _247_/D _356_/L_HI VPWR VGND sg13cmos5l_dfrbpq_1
XANTENNA__113__Y PMOD_IO_O3 VPWR VGND sg13cmos5l_antennanp
X_178_ _178_/Q Tile_X0Y0_FrameData[6] VGND VPWR Tile_X1Y0_FrameStrobe[1] latch
XFILLER_2_591 VPWR VGND sg13cmos5l_decap_8
XFILLER_14_1113 VPWR VGND sg13cmos5l_fill_1
XFILLER_0_506 VPWR VGND sg13cmos5l_fill_1
XFILLER_0_539 VPWR VGND sg13cmos5l_fill_1
XFILLER_3_1060 VPWR VGND sg13cmos5l_decap_8
XFILLER_11_156 VPWR VGND sg13cmos5l_decap_8
XFILLER_12_624 VPWR VGND sg13cmos5l_decap_8
X_101_ _101_/X _256_/Q _557_/X _233_/Q VPWR VGND sg13cmos5l_mux2_1
XFILLER_4_834 VPWR VGND sg13cmos5l_decap_8
XANTENNA__108__Y PMOD_IO_OE_O7 VPWR VGND sg13cmos5l_antennanp
XFILLER_8_98 VPWR VGND sg13cmos5l_decap_8
XFILLER_8_21 VPWR VGND sg13cmos5l_decap_8
XFILLER_12_421 VPWR VGND sg13cmos5l_decap_8
XFILLER_16_226 VPWR VGND sg13cmos5l_decap_8
X_581_ _581_/X Tile_X0Y0_N2MID[5] Tile_X0Y0_N4END[2] Tile_X0Y0_NN4END[13] _119_/X
+ _307_/Q _306_/Q VPWR VGND sg13cmos5l_mux4_1
XFILLER_12_498 VPWR VGND sg13cmos5l_decap_8
XFILLER_13_999 VPWR VGND sg13cmos5l_fill_2
XFILLER_8_469 VPWR VGND sg13cmos5l_decap_8
XFILLER_8_403 VPWR VGND sg13cmos5l_decap_8
XANTENNA_309 Tile_X0Y0_FrameData[9] VPWR VGND sg13cmos5l_antennanp
XFILLER_0_1052 VPWR VGND sg13cmos5l_fill_2
XFILLER_5_428 VPWR VGND sg13cmos5l_decap_8
XFILLER_1_601 VPWR VGND sg13cmos5l_decap_8
X_633_ _633_/X Tile_X1Y0_N2END[1] Tile_X1Y0_N4END[9] Tile_X1Y0_NN4END[6] _089_/X _154_/Q
+ _153_/Q VPWR VGND sg13cmos5l_mux4_1
X_495_ Tile_X1Y0_FrameStrobe_O[16] Tile_X1Y0_FrameStrobe[16] VPWR VGND sg13cmos5l_buf_1
X_564_ _564_/X Tile_X0Y0_N1END[0] Tile_X0Y0_N2MID[4] Tile_X0Y0_N2END[3] _119_/X _341_/Q
+ _340_/Q VPWR VGND sg13cmos5l_mux4_1
XFILLER_12_295 VPWR VGND sg13cmos5l_decap_8
XFILLER_8_255 VPWR VGND sg13cmos5l_decap_8
XANTENNA__121__Y PMOD_IO_OE_O1 VPWR VGND sg13cmos5l_antennanp
XANTENNA__402__X Tile_X0Y0_FrameStrobe_O[11] VPWR VGND sg13cmos5l_antennanp
XFILLER_5_99 VPWR VGND sg13cmos5l_decap_8
XFILLER_5_77 VPWR VGND sg13cmos5l_decap_8
XFILLER_4_494 VPWR VGND sg13cmos5l_decap_8
XFILLER_16_590 VPWR VGND sg13cmos5l_decap_8
XANTENNA_106 Tile_X0Y0_FrameData[13] VPWR VGND sg13cmos5l_antennanp
XANTENNA_117 Tile_X0Y0_FrameData[13] VPWR VGND sg13cmos5l_antennanp
XANTENNA_128 Tile_X0Y0_FrameData[13] VPWR VGND sg13cmos5l_antennanp
XANTENNA_139 Tile_X0Y0_FrameData[18] VPWR VGND sg13cmos5l_antennanp
XFILLER_10_700 VPWR VGND sg13cmos5l_decap_4
XFILLER_14_42 VPWR VGND sg13cmos5l_decap_8
X_280_ _280_/Q Tile_X0Y0_FrameData[9] VGND VPWR Tile_X0Y0_FrameStrobe[0] latch
XFILLER_6_748 VPWR VGND sg13cmos5l_fill_2
XFILLER_5_214 VPWR VGND sg13cmos5l_decap_8
XFILLER_1_442 VPWR VGND sg13cmos5l_decap_8
XFILLER_7_1047 VPWR VGND sg13cmos5l_decap_8
X_547_ Tile_X1Y0_SS4BEG[12] _636_/X VPWR VGND sg13cmos5l_buf_1
X_616_ _616_/X Tile_X1Y0_N2MID[0] Tile_X1Y0_N4END[7] Tile_X1Y0_NN4END[8] _095_/X _188_/Q
+ _187_/Q VPWR VGND sg13cmos5l_mux4_1
XANTENNA__116__Y PMOD_IO_O6 VPWR VGND sg13cmos5l_antennanp
XFILLER_13_560 VPWR VGND sg13cmos5l_decap_8
X_478_ Tile_X1Y0_FrameData_O[31] Tile_X0Y0_FrameData[31] VPWR VGND sg13cmos5l_buf_1
XFILLER_9_553 VPWR VGND sg13cmos5l_decap_8
XFILLER_4_291 VPWR VGND sg13cmos5l_decap_8
XFILLER_13_1019 VPWR VGND sg13cmos5l_decap_8
XFILLER_2_228 VPWR VGND sg13cmos5l_decap_8
X_401_ Tile_X0Y0_FrameStrobe_O[10] Tile_X0Y0_FrameStrobe[10] VPWR VGND sg13cmos5l_buf_1
XFILLER_14_357 VPWR VGND sg13cmos5l_decap_8
X_332_ _332_/Q Tile_X0Y0_FrameData[21] VGND VPWR Tile_X0Y0_FrameStrobe[2] latch
X_263_ _263_/Q Tile_X0Y0_FrameData[26] VGND VPWR Tile_X0Y0_FrameStrobe[0] latch
XFILLER_10_563 VPWR VGND sg13cmos5l_decap_8
X_194_ _194_/Q Tile_X0Y0_FrameData[22] VGND VPWR Tile_X1Y0_FrameStrobe[2] latch
XFILLER_6_556 VPWR VGND sg13cmos5l_decap_8
XFILLER_2_740 VPWR VGND sg13cmos5l_decap_8
XFILLER_1_283 VPWR VGND sg13cmos5l_decap_8
XFILLER_1_294 VPWR VGND sg13cmos5l_fill_2
XFILLER_2_89 VPWR VGND sg13cmos5l_decap_8
XFILLER_2_67 VPWR VGND sg13cmos5l_fill_1
XFILLER_2_56 VPWR VGND sg13cmos5l_decap_8
XANTENNA_17 Tile_X0Y0_FrameData[0] VPWR VGND sg13cmos5l_antennanp
XANTENNA_28 Tile_X0Y0_FrameData[0] VPWR VGND sg13cmos5l_antennanp
XANTENNA_39 Tile_X0Y0_FrameData[11] VPWR VGND sg13cmos5l_antennanp
XFILLER_12_1063 VPWR VGND sg13cmos5l_decap_8
XFILLER_12_806 VPWR VGND sg13cmos5l_fill_1
XFILLER_11_21 VPWR VGND sg13cmos5l_decap_8
XANTENNA__500__X Tile_X1Y0_S1BEG[1] VPWR VGND sg13cmos5l_antennanp
XFILLER_4_1017 VPWR VGND sg13cmos5l_decap_8
XFILLER_14_154 VPWR VGND sg13cmos5l_decap_8
XFILLER_15_622 VPWR VGND sg13cmos5l_fill_2
XFILLER_15_699 VPWR VGND sg13cmos5l_decap_8
X_315_ _315_/Q Tile_X0Y0_FrameData[6] VGND VPWR Tile_X0Y0_FrameStrobe[1] latch
X_246_ _246_/Q Tile_X0Y0_UserCLK _246_/D _355_/L_HI VPWR VGND sg13cmos5l_dfrbpq_1
X_177_ _177_/Q Tile_X0Y0_FrameData[7] VGND VPWR Tile_X1Y0_FrameStrobe[1] latch
XANTENNA__410__X Tile_X0Y0_FrameStrobe_O[19] VPWR VGND sg13cmos5l_antennanp
XFILLER_7_887 VPWR VGND sg13cmos5l_decap_8
XFILLER_2_570 VPWR VGND sg13cmos5l_decap_8
XFILLER_12_603 VPWR VGND sg13cmos5l_decap_8
XFILLER_11_135 VPWR VGND sg13cmos5l_decap_8
X_100_ PMOD_IO_OE_O6 _223_/Q _097_/X _099_/Y VPWR VGND sg13cmos5l_a21oi_1
XFILLER_7_139 VPWR VGND sg13cmos5l_decap_8
XFILLER_7_117 VPWR VGND sg13cmos5l_fill_1
XFILLER_3_345 VPWR VGND sg13cmos5l_decap_8
XFILLER_15_485 VPWR VGND sg13cmos5l_decap_8
XFILLER_16_931 VPWR VGND sg13cmos5l_fill_1
XFILLER_16_964 VPWR VGND sg13cmos5l_decap_8
XANTENNA__405__X Tile_X0Y0_FrameStrobe_O[14] VPWR VGND sg13cmos5l_antennanp
X_229_ _229_/Q Tile_X0Y0_FrameData[22] VGND VPWR Tile_X1Y0_FrameStrobe[3] latch
XFILLER_8_77 VPWR VGND sg13cmos5l_decap_8
XFILLER_7_640 VPWR VGND sg13cmos5l_decap_4
XFILLER_6_172 VPWR VGND sg13cmos5l_decap_8
XFILLER_0_326 VPWR VGND sg13cmos5l_fill_1
XFILLER_1_816 VPWR VGND sg13cmos5l_fill_2
XFILLER_16_205 VPWR VGND sg13cmos5l_decap_4
X_580_ _580_/X Tile_X0Y0_N2MID[4] Tile_X0Y0_N4END[3] Tile_X0Y0_NN4END[12] _092_/X
+ _309_/Q _308_/Q VPWR VGND sg13cmos5l_mux4_1
XFILLER_12_400 VPWR VGND sg13cmos5l_decap_8
XFILLER_12_477 VPWR VGND sg13cmos5l_decap_8
XFILLER_8_448 VPWR VGND sg13cmos5l_decap_8
XFILLER_4_610 VPWR VGND sg13cmos5l_fill_1
XFILLER_12_7 VPWR VGND sg13cmos5l_decap_8
XFILLER_16_761 VPWR VGND sg13cmos5l_fill_2
XFILLER_15_282 VPWR VGND sg13cmos5l_decap_8
XFILLER_11_1106 VPWR VGND sg13cmos5l_decap_8
XFILLER_0_1031 VPWR VGND sg13cmos5l_decap_8
XFILLER_16_1006 VPWR VGND sg13cmos5l_decap_8
XFILLER_5_407 VPWR VGND sg13cmos5l_decap_8
X_632_ _632_/X Tile_X1Y0_N2END[0] Tile_X1Y0_N4END[8] Tile_X1Y0_NN4END[7] _087_/X _156_/Q
+ _155_/Q VPWR VGND sg13cmos5l_mux4_1
X_563_ _563_/X Tile_X0Y0_N1END[3] Tile_X0Y0_N2MID[3] Tile_X0Y0_N2END[4] _092_/X _343_/Q
+ _342_/Q VPWR VGND sg13cmos5l_mux4_1
XFILLER_12_274 VPWR VGND sg13cmos5l_decap_8
X_494_ Tile_X1Y0_FrameStrobe_O[15] Tile_X1Y0_FrameStrobe[15] VPWR VGND sg13cmos5l_buf_1
XFILLER_9_779 VPWR VGND sg13cmos5l_fill_1
XFILLER_5_996 VPWR VGND sg13cmos5l_fill_1
XFILLER_5_56 VPWR VGND sg13cmos5l_decap_8
XFILLER_4_473 VPWR VGND sg13cmos5l_decap_8
XFILLER_4_440 VPWR VGND sg13cmos5l_fill_1
XANTENNA_107 Tile_X0Y0_FrameData[13] VPWR VGND sg13cmos5l_antennanp
XANTENNA_118 Tile_X0Y0_FrameData[13] VPWR VGND sg13cmos5l_antennanp
XANTENNA_129 Tile_X0Y0_FrameData[13] VPWR VGND sg13cmos5l_antennanp
XFILLER_14_21 VPWR VGND sg13cmos5l_decap_8
XFILLER_14_539 VPWR VGND sg13cmos5l_decap_8
XANTENNA__503__X Tile_X1Y0_S2BEG[0] VPWR VGND sg13cmos5l_antennanp
XFILLER_14_98 VPWR VGND sg13cmos5l_decap_8
XFILLER_5_237 VPWR VGND sg13cmos5l_fill_1
XFILLER_2_911 VPWR VGND sg13cmos5l_decap_8
XFILLER_1_498 VPWR VGND sg13cmos5l_decap_8
XFILLER_7_1026 VPWR VGND sg13cmos5l_decap_8
XFILLER_2_955 VPWR VGND sg13cmos5l_fill_1
X_546_ Tile_X1Y0_SS4BEG[11] _635_/X VPWR VGND sg13cmos5l_buf_1
X_615_ _615_/X Tile_X1Y0_N2MID[7] Tile_X1Y0_N4END[8] Tile_X1Y0_NN4END[7] _085_/X _190_/Q
+ _189_/Q VPWR VGND sg13cmos5l_mux4_1
X_477_ Tile_X1Y0_FrameData_O[30] Tile_X0Y0_FrameData[30] VPWR VGND sg13cmos5l_buf_1
XFILLER_9_532 VPWR VGND sg13cmos5l_decap_8
XANTENNA__413__X Tile_X0Y0_S1BEG[2] VPWR VGND sg13cmos5l_antennanp
XFILLER_4_281 VPWR VGND sg13cmos5l_decap_8
XFILLER_4_270 VPWR VGND sg13cmos5l_decap_8
XFILLER_2_207 VPWR VGND sg13cmos5l_decap_8
XFILLER_14_336 VPWR VGND sg13cmos5l_decap_8
X_331_ _331_/Q Tile_X0Y0_FrameData[22] VGND VPWR Tile_X0Y0_FrameStrobe[2] latch
X_400_ Tile_X0Y0_FrameStrobe_O[9] Tile_X0Y0_FrameStrobe[9] VPWR VGND sg13cmos5l_buf_1
XFILLER_10_542 VPWR VGND sg13cmos5l_decap_8
X_262_ _262_/Q Tile_X0Y0_FrameData[27] VGND VPWR Tile_X0Y0_FrameStrobe[0] latch
X_193_ _193_/Q Tile_X0Y0_FrameData[23] VGND VPWR Tile_X1Y0_FrameStrobe[2] latch
XFILLER_6_535 VPWR VGND sg13cmos5l_decap_8
XFILLER_1_251 VPWR VGND sg13cmos5l_decap_4
XFILLER_1_262 VPWR VGND sg13cmos5l_fill_1
XFILLER_1_273 VPWR VGND sg13cmos5l_decap_4
XFILLER_2_35 VPWR VGND sg13cmos5l_decap_8
XANTENNA_18 Tile_X0Y0_FrameData[0] VPWR VGND sg13cmos5l_antennanp
XANTENNA_29 Tile_X0Y0_FrameData[0] VPWR VGND sg13cmos5l_antennanp
XANTENNA__408__X Tile_X0Y0_FrameStrobe_O[17] VPWR VGND sg13cmos5l_antennanp
X_529_ Tile_X1Y0_S4BEG[10] _618_/X VPWR VGND sg13cmos5l_buf_1
XFILLER_12_1020 VPWR VGND sg13cmos5l_decap_8
XFILLER_12_1031 VPWR VGND sg13cmos5l_fill_1
XFILLER_9_384 VPWR VGND sg13cmos5l_decap_8
XFILLER_9_362 VPWR VGND sg13cmos5l_fill_2
XFILLER_11_77 VPWR VGND sg13cmos5l_decap_8
XFILLER_3_549 VPWR VGND sg13cmos5l_decap_8
XFILLER_14_133 VPWR VGND sg13cmos5l_decap_8
XFILLER_15_601 VPWR VGND sg13cmos5l_decap_8
XFILLER_15_678 VPWR VGND sg13cmos5l_decap_8
X_314_ _314_/Q Tile_X0Y0_FrameData[7] VGND VPWR Tile_X0Y0_FrameStrobe[1] latch
XFILLER_10_350 VPWR VGND sg13cmos5l_fill_1
XFILLER_10_383 VPWR VGND sg13cmos5l_decap_8
X_245_ _245_/Q Tile_X0Y0_UserCLK _245_/D _358_/L_HI VPWR VGND sg13cmos5l_dfrbpq_1
X_176_ _176_/Q Tile_X0Y0_FrameData[8] VGND VPWR Tile_X1Y0_FrameStrobe[1] latch
XANTENNA_290 Tile_X0Y0_FrameData[9] VPWR VGND sg13cmos5l_antennanp
XFILLER_14_1104 VPWR VGND sg13cmos5l_fill_2
XFILLER_11_114 VPWR VGND sg13cmos5l_decap_8
XANTENNA__511__X Tile_X1Y0_S2BEGb[0] VPWR VGND sg13cmos5l_antennanp
XFILLER_4_858 VPWR VGND sg13cmos5l_decap_8
XFILLER_15_464 VPWR VGND sg13cmos5l_decap_8
XFILLER_16_976 VPWR VGND sg13cmos5l_fill_2
XFILLER_8_56 VPWR VGND sg13cmos5l_decap_8
XANTENNA__421__X Tile_X0Y0_S2BEG[6] VPWR VGND sg13cmos5l_antennanp
XFILLER_10_180 VPWR VGND sg13cmos5l_decap_4
XFILLER_11_681 VPWR VGND sg13cmos5l_decap_8
X_228_ _228_/Q Tile_X0Y0_FrameData[21] VGND VPWR Tile_X1Y0_FrameStrobe[3] latch
X_159_ _159_/Q Tile_X0Y0_FrameData[25] VGND VPWR Tile_X1Y0_FrameStrobe[1] latch
XFILLER_7_696 VPWR VGND sg13cmos5l_decap_8
XFILLER_6_151 VPWR VGND sg13cmos5l_decap_8
XFILLER_1_828 VPWR VGND sg13cmos5l_fill_2
XANTENNA__506__X Tile_X1Y0_S2BEG[3] VPWR VGND sg13cmos5l_antennanp
XFILLER_12_456 VPWR VGND sg13cmos5l_decap_8
XFILLER_0_872 VPWR VGND sg13cmos5l_decap_8
XFILLER_15_261 VPWR VGND sg13cmos5l_decap_4
XFILLER_16_740 VPWR VGND sg13cmos5l_fill_1
XANTENNA__416__X Tile_X0Y0_S2BEG[1] VPWR VGND sg13cmos5l_antennanp
XFILLER_8_994 VPWR VGND sg13cmos5l_decap_8
XFILLER_7_482 VPWR VGND sg13cmos5l_decap_8
X_493_ Tile_X1Y0_FrameStrobe_O[14] Tile_X1Y0_FrameStrobe[14] VPWR VGND sg13cmos5l_buf_1
X_631_ _631_/X Tile_X1Y0_N2END[7] Tile_X1Y0_N4END[7] Tile_X1Y0_NN4END[8] _085_/X _158_/Q
+ _157_/Q VPWR VGND sg13cmos5l_mux4_1
X_562_ _562_/X Tile_X0Y0_N1END[2] Tile_X0Y0_N2MID[2] Tile_X0Y0_N2END[5] _091_/X _345_/Q
+ _344_/Q VPWR VGND sg13cmos5l_mux4_1
XFILLER_12_253 VPWR VGND sg13cmos5l_decap_8
XFILLER_8_246 VPWR VGND sg13cmos5l_decap_4
XFILLER_5_35 VPWR VGND sg13cmos5l_decap_8
XFILLER_4_452 VPWR VGND sg13cmos5l_decap_8
XFILLER_15_1084 VPWR VGND sg13cmos5l_decap_8
XANTENNA_108 Tile_X0Y0_FrameData[13] VPWR VGND sg13cmos5l_antennanp
XANTENNA_119 Tile_X0Y0_FrameData[13] VPWR VGND sg13cmos5l_antennanp
XFILLER_14_518 VPWR VGND sg13cmos5l_decap_8
XFILLER_10_746 VPWR VGND sg13cmos5l_decap_8
XFILLER_10_768 VPWR VGND sg13cmos5l_decap_4
XFILLER_10_779 VPWR VGND sg13cmos5l_decap_8
XFILLER_14_77 VPWR VGND sg13cmos5l_decap_8
XFILLER_1_477 VPWR VGND sg13cmos5l_decap_8
XFILLER_7_1005 VPWR VGND sg13cmos5l_decap_8
XFILLER_2_989 VPWR VGND sg13cmos5l_decap_8
X_476_ Tile_X1Y0_FrameData_O[29] Tile_X0Y0_FrameData[29] VPWR VGND sg13cmos5l_buf_1
X_545_ Tile_X1Y0_SS4BEG[10] _634_/X VPWR VGND sg13cmos5l_buf_1
X_614_ _614_/X Tile_X1Y0_N2MID[6] Tile_X1Y0_N4END[9] Tile_X1Y0_NN4END[6] _087_/X _192_/Q
+ _191_/Q VPWR VGND sg13cmos5l_mux4_1
XFILLER_13_595 VPWR VGND sg13cmos5l_decap_8
XFILLER_9_588 VPWR VGND sg13cmos5l_decap_8
XFILLER_9_511 VPWR VGND sg13cmos5l_decap_8
XFILLER_14_315 VPWR VGND sg13cmos5l_decap_8
X_330_ _330_/Q Tile_X0Y0_FrameData[23] VGND VPWR Tile_X0Y0_FrameStrobe[2] latch
XANTENNA__514__X Tile_X1Y0_S2BEGb[3] VPWR VGND sg13cmos5l_antennanp
XFILLER_10_521 VPWR VGND sg13cmos5l_decap_8
XFILLER_10_598 VPWR VGND sg13cmos5l_decap_8
X_261_ _261_/Q Tile_X0Y0_FrameData[28] VGND VPWR Tile_X0Y0_FrameStrobe[0] latch
X_192_ _192_/Q Tile_X0Y0_FrameData[24] VGND VPWR Tile_X1Y0_FrameStrobe[2] latch
XFILLER_6_514 VPWR VGND sg13cmos5l_decap_8
XFILLER_9_0 VPWR VGND sg13cmos5l_decap_8
XFILLER_2_14 VPWR VGND sg13cmos5l_decap_8
XANTENNA_19 Tile_X0Y0_FrameData[0] VPWR VGND sg13cmos5l_antennanp
XFILLER_13_392 VPWR VGND sg13cmos5l_decap_8
X_459_ Tile_X1Y0_FrameData_O[12] Tile_X0Y0_FrameData[12] VPWR VGND sg13cmos5l_buf_1
X_528_ Tile_X1Y0_S4BEG[9] _617_/X VPWR VGND sg13cmos5l_buf_1
XANTENNA__424__X Tile_X0Y0_S2BEGb[1] VPWR VGND sg13cmos5l_antennanp
XFILLER_12_1098 VPWR VGND sg13cmos5l_fill_2
XFILLER_11_307 VPWR VGND sg13cmos5l_decap_8
XFILLER_11_329 VPWR VGND sg13cmos5l_fill_2
XFILLER_11_56 VPWR VGND sg13cmos5l_decap_8
XFILLER_3_528 VPWR VGND sg13cmos5l_decap_8
XFILLER_2_7 VPWR VGND sg13cmos5l_decap_8
XANTENNA__509__X Tile_X1Y0_S2BEG[6] VPWR VGND sg13cmos5l_antennanp
XFILLER_14_112 VPWR VGND sg13cmos5l_decap_8
XFILLER_14_189 VPWR VGND sg13cmos5l_decap_8
XFILLER_15_624 VPWR VGND sg13cmos5l_fill_1
XFILLER_15_657 VPWR VGND sg13cmos5l_decap_8
X_313_ _313_/Q Tile_X0Y0_FrameData[8] VGND VPWR Tile_X0Y0_FrameStrobe[1] latch
X_244_ _244_/Q Tile_X0Y0_UserCLK _244_/D _357_/L_HI VPWR VGND sg13cmos5l_dfrbpq_1
XFILLER_10_362 VPWR VGND sg13cmos5l_decap_8
X_175_ _175_/Q Tile_X0Y0_FrameData[9] VGND VPWR Tile_X1Y0_FrameStrobe[1] latch
XFILLER_6_300 VPWR VGND sg13cmos5l_decap_4
XANTENNA__419__X Tile_X0Y0_S2BEG[4] VPWR VGND sg13cmos5l_antennanp
XANTENNA_280 Tile_X0Y0_FrameData[8] VPWR VGND sg13cmos5l_antennanp
XANTENNA_291 Tile_X0Y0_FrameData[9] VPWR VGND sg13cmos5l_antennanp
XFILLER_9_182 VPWR VGND sg13cmos5l_decap_4
XFILLER_12_638 VPWR VGND sg13cmos5l_decap_8
XFILLER_8_609 VPWR VGND sg13cmos5l_decap_8
XFILLER_4_848 VPWR VGND sg13cmos5l_fill_2
XFILLER_3_336 VPWR VGND sg13cmos5l_fill_2
XFILLER_15_443 VPWR VGND sg13cmos5l_decap_8
XFILLER_16_999 VPWR VGND sg13cmos5l_decap_8
X_227_ _227_/Q Tile_X0Y0_FrameData[20] VGND VPWR Tile_X1Y0_FrameStrobe[3] latch
XFILLER_8_35 VPWR VGND sg13cmos5l_decap_8
XFILLER_10_192 VPWR VGND sg13cmos5l_decap_8
X_158_ _158_/Q Tile_X0Y0_FrameData[26] VGND VPWR Tile_X1Y0_FrameStrobe[1] latch
X_089_ _089_/X _238_/Q _238_/D _234_/Q VPWR VGND sg13cmos5l_mux2_1
XFILLER_7_686 VPWR VGND sg13cmos5l_fill_2
XFILLER_6_196 VPWR VGND sg13cmos5l_fill_2
XFILLER_12_435 VPWR VGND sg13cmos5l_decap_8
XFILLER_8_417 VPWR VGND sg13cmos5l_decap_8
XANTENNA__522__X Tile_X1Y0_S4BEG[3] VPWR VGND sg13cmos5l_antennanp
XFILLER_3_111 VPWR VGND sg13cmos5l_fill_1
XFILLER_3_100 VPWR VGND sg13cmos5l_decap_4
XFILLER_3_188 VPWR VGND sg13cmos5l_fill_2
XFILLER_15_240 VPWR VGND sg13cmos5l_decap_8
XANTENNA__432__X Tile_X0Y0_S4BEG[1] VPWR VGND sg13cmos5l_antennanp
XFILLER_7_461 VPWR VGND sg13cmos5l_decap_8
XFILLER_0_1066 VPWR VGND sg13cmos5l_fill_1
XFILLER_0_1099 VPWR VGND sg13cmos5l_fill_2
XFILLER_16_1019 VPWR VGND sg13cmos5l_decap_8
XFILLER_0_103 VPWR VGND sg13cmos5l_decap_8
XFILLER_1_615 VPWR VGND sg13cmos5l_fill_2
X_630_ _630_/X Tile_X1Y0_N2END[6] Tile_X1Y0_N4END[6] Tile_X1Y0_NN4END[9] _095_/X _160_/Q
+ _159_/Q VPWR VGND sg13cmos5l_mux4_1
XFILLER_9_1080 VPWR VGND sg13cmos5l_decap_8
XANTENNA__517__X Tile_X1Y0_S2BEGb[6] VPWR VGND sg13cmos5l_antennanp
XFILLER_13_700 VPWR VGND sg13cmos5l_fill_1
X_492_ Tile_X1Y0_FrameStrobe_O[13] Tile_X1Y0_FrameStrobe[13] VPWR VGND sg13cmos5l_buf_1
X_561_ _561_/X Tile_X0Y0_N1END[1] Tile_X0Y0_N2MID[1] Tile_X0Y0_N2END[6] _119_/X _347_/Q
+ _346_/Q VPWR VGND sg13cmos5l_mux4_1
XFILLER_12_232 VPWR VGND sg13cmos5l_decap_8
XFILLER_13_777 VPWR VGND sg13cmos5l_decap_8
XFILLER_9_704 VPWR VGND sg13cmos5l_decap_8
XFILLER_5_987 VPWR VGND sg13cmos5l_fill_1
XFILLER_5_976 VPWR VGND sg13cmos5l_decap_8
XFILLER_5_965 VPWR VGND sg13cmos5l_decap_8
XFILLER_5_14 VPWR VGND sg13cmos5l_decap_8
XANTENNA__427__X Tile_X0Y0_S2BEGb[4] VPWR VGND sg13cmos5l_antennanp
XFILLER_16_571 VPWR VGND sg13cmos5l_decap_8
XFILLER_15_1063 VPWR VGND sg13cmos5l_decap_8
XFILLER_8_770 VPWR VGND sg13cmos5l_fill_1
XANTENNA_109 Tile_X0Y0_FrameData[13] VPWR VGND sg13cmos5l_antennanp
XFILLER_14_56 VPWR VGND sg13cmos5l_decap_8
XFILLER_5_228 VPWR VGND sg13cmos5l_decap_8
XFILLER_1_456 VPWR VGND sg13cmos5l_decap_8
XFILLER_2_968 VPWR VGND sg13cmos5l_decap_8
XFILLER_2_946 VPWR VGND sg13cmos5l_decap_8
XFILLER_2_935 VPWR VGND sg13cmos5l_decap_8
X_613_ _613_/X Tile_X1Y0_N2MID[5] Tile_X1Y0_N4END[10] Tile_X1Y0_NN4END[5] _089_/X
+ _194_/Q _193_/Q VPWR VGND sg13cmos5l_mux4_1
XFILLER_13_574 VPWR VGND sg13cmos5l_decap_8
X_475_ Tile_X1Y0_FrameData_O[28] Tile_X0Y0_FrameData[28] VPWR VGND sg13cmos5l_buf_1
X_544_ Tile_X1Y0_SS4BEG[9] _633_/X VPWR VGND sg13cmos5l_buf_1
XFILLER_9_567 VPWR VGND sg13cmos5l_decap_8
XFILLER_6_1083 VPWR VGND sg13cmos5l_decap_8
XFILLER_10_500 VPWR VGND sg13cmos5l_decap_8
XFILLER_15_817 VPWR VGND sg13cmos5l_fill_2
X_260_ _260_/Q Tile_X0Y0_FrameData[29] VGND VPWR Tile_X0Y0_FrameStrobe[0] latch
XFILLER_10_577 VPWR VGND sg13cmos5l_decap_8
X_191_ _191_/Q Tile_X0Y0_FrameData[25] VGND VPWR Tile_X1Y0_FrameStrobe[2] latch
XANTENNA__530__X Tile_X1Y0_S4BEG[11] VPWR VGND sg13cmos5l_antennanp
XFILLER_2_787 VPWR VGND sg13cmos5l_decap_8
XFILLER_2_776 VPWR VGND sg13cmos5l_decap_4
X_527_ Tile_X1Y0_S4BEG[8] _616_/X VPWR VGND sg13cmos5l_buf_1
XFILLER_13_371 VPWR VGND sg13cmos5l_decap_8
X_389_ Tile_X0Y0_SS4BEG[14] _598_/X VPWR VGND sg13cmos5l_buf_1
X_458_ Tile_X1Y0_FrameData_O[11] Tile_X0Y0_FrameData[11] VPWR VGND sg13cmos5l_buf_1
XANTENNA__440__X Tile_X0Y0_S4BEG[9] VPWR VGND sg13cmos5l_antennanp
XFILLER_12_1077 VPWR VGND sg13cmos5l_decap_8
XFILLER_11_35 VPWR VGND sg13cmos5l_decap_8
XFILLER_3_507 VPWR VGND sg13cmos5l_decap_8
XANTENNA__525__X Tile_X1Y0_S4BEG[6] VPWR VGND sg13cmos5l_antennanp
XFILLER_11_820 VPWR VGND sg13cmos5l_fill_1
XFILLER_14_168 VPWR VGND sg13cmos5l_decap_8
X_312_ _312_/Q Tile_X0Y0_FrameData[9] VGND VPWR Tile_X0Y0_FrameStrobe[1] latch
X_243_ _243_/Q Tile_X0Y0_UserCLK _243_/D _360_/L_HI VPWR VGND sg13cmos5l_dfrbpq_1
XFILLER_7_813 VPWR VGND sg13cmos5l_fill_1
X_174_ _174_/Q Tile_X0Y0_FrameData[10] VGND VPWR Tile_X1Y0_FrameStrobe[1] latch
XFILLER_2_584 VPWR VGND sg13cmos5l_decap_8
XANTENNA_270 Tile_X0Y0_FrameData[8] VPWR VGND sg13cmos5l_antennanp
XANTENNA_281 Tile_X0Y0_FrameData[8] VPWR VGND sg13cmos5l_antennanp
XANTENNA_292 Tile_X0Y0_FrameData[9] VPWR VGND sg13cmos5l_antennanp
XANTENNA__435__X Tile_X0Y0_S4BEG[4] VPWR VGND sg13cmos5l_antennanp
XFILLER_3_1053 VPWR VGND sg13cmos5l_decap_8
XFILLER_11_149 VPWR VGND sg13cmos5l_decap_8
XFILLER_12_617 VPWR VGND sg13cmos5l_decap_8
XFILLER_4_827 VPWR VGND sg13cmos5l_decap_8
XFILLER_3_359 VPWR VGND sg13cmos5l_fill_1
XFILLER_3_315 VPWR VGND sg13cmos5l_decap_8
XFILLER_15_422 VPWR VGND sg13cmos5l_decap_8
XFILLER_16_978 VPWR VGND sg13cmos5l_fill_1
XFILLER_15_499 VPWR VGND sg13cmos5l_decap_8
X_226_ _226_/Q Tile_X0Y0_FrameData[19] VGND VPWR Tile_X1Y0_FrameStrobe[3] latch
X_157_ _157_/Q Tile_X0Y0_FrameData[27] VGND VPWR Tile_X1Y0_FrameStrobe[1] latch
XFILLER_8_14 VPWR VGND sg13cmos5l_decap_8
XFILLER_7_665 VPWR VGND sg13cmos5l_decap_8
X_088_ _238_/D PMOD_IO_I3 _555_/X _222_/Q VPWR VGND sg13cmos5l_mux2_1
XFILLER_16_219 VPWR VGND sg13cmos5l_decap_8
XFILLER_12_414 VPWR VGND sg13cmos5l_decap_8
XFILLER_4_668 VPWR VGND sg13cmos5l_fill_1
XFILLER_15_230 VPWR VGND sg13cmos5l_decap_8
XFILLER_15_296 VPWR VGND sg13cmos5l_decap_8
X_209_ _209_/Q Tile_X0Y0_FrameData[7] VGND VPWR Tile_X1Y0_FrameStrobe[2] latch
XFILLER_7_440 VPWR VGND sg13cmos5l_decap_8
XFILLER_0_1001 VPWR VGND sg13cmos5l_decap_4
XFILLER_0_1012 VPWR VGND sg13cmos5l_fill_2
XFILLER_0_1045 VPWR VGND sg13cmos5l_decap_8
XFILLER_0_70 VPWR VGND sg13cmos5l_decap_8
XFILLER_0_81 VPWR VGND sg13cmos5l_fill_1
XFILLER_0_126 VPWR VGND sg13cmos5l_decap_4
XFILLER_1_638 VPWR VGND sg13cmos5l_decap_8
X_560_ _560_/X Tile_X0Y0_N1END[0] Tile_X0Y0_N2MID[0] Tile_X0Y0_N2END[7] _092_/X _349_/Q
+ _348_/Q VPWR VGND sg13cmos5l_mux4_1
XFILLER_12_211 VPWR VGND sg13cmos5l_decap_8
X_491_ Tile_X1Y0_FrameStrobe_O[12] Tile_X1Y0_FrameStrobe[12] VPWR VGND sg13cmos5l_buf_1
XANTENNA__533__X Tile_X1Y0_S4BEG[14] VPWR VGND sg13cmos5l_antennanp
XFILLER_12_288 VPWR VGND sg13cmos5l_decap_8
XFILLER_4_421 VPWR VGND sg13cmos5l_fill_1
XFILLER_4_487 VPWR VGND sg13cmos5l_decap_8
XFILLER_10_7 VPWR VGND sg13cmos5l_decap_8
XFILLER_16_550 VPWR VGND sg13cmos5l_decap_8
XANTENNA__443__X Tile_X0Y0_S4BEG[12] VPWR VGND sg13cmos5l_antennanp
XFILLER_15_1042 VPWR VGND sg13cmos5l_decap_8
XFILLER_14_35 VPWR VGND sg13cmos5l_decap_8
XANTENNA__072__Y PMOD_IO_OE_O2 VPWR VGND sg13cmos5l_antennanp
XFILLER_1_435 VPWR VGND sg13cmos5l_decap_8
XFILLER_2_925 VPWR VGND sg13cmos5l_fill_2
XANTENNA__528__X Tile_X1Y0_S4BEG[9] VPWR VGND sg13cmos5l_antennanp
X_543_ Tile_X1Y0_SS4BEG[8] _632_/X VPWR VGND sg13cmos5l_buf_1
X_612_ _612_/X Tile_X1Y0_N2MID[4] Tile_X1Y0_N4END[11] Tile_X1Y0_NN4END[4] _064_/X
+ _196_/Q _195_/Q VPWR VGND sg13cmos5l_mux4_1
XFILLER_13_553 VPWR VGND sg13cmos5l_decap_8
X_474_ Tile_X1Y0_FrameData_O[27] Tile_X0Y0_FrameData[27] VPWR VGND sg13cmos5l_buf_1
XFILLER_9_546 VPWR VGND sg13cmos5l_decap_8
XFILLER_5_774 VPWR VGND sg13cmos5l_decap_4
XANTENNA__438__X Tile_X0Y0_S4BEG[7] VPWR VGND sg13cmos5l_antennanp
XFILLER_16_380 VPWR VGND sg13cmos5l_decap_8
XFILLER_6_1062 VPWR VGND sg13cmos5l_decap_8
X_190_ _190_/Q Tile_X0Y0_FrameData[26] VGND VPWR Tile_X1Y0_FrameStrobe[2] latch
XFILLER_10_556 VPWR VGND sg13cmos5l_decap_8
XFILLER_6_549 VPWR VGND sg13cmos5l_decap_8
XFILLER_2_733 VPWR VGND sg13cmos5l_decap_8
XFILLER_2_49 VPWR VGND sg13cmos5l_decap_8
X_526_ Tile_X1Y0_S4BEG[7] _615_/X VPWR VGND sg13cmos5l_buf_1
XFILLER_13_350 VPWR VGND sg13cmos5l_decap_8
X_388_ Tile_X0Y0_SS4BEG[13] _597_/X VPWR VGND sg13cmos5l_buf_1
X_457_ Tile_X1Y0_FrameData_O[10] Tile_X0Y0_FrameData[10] VPWR VGND sg13cmos5l_buf_1
XFILLER_9_398 VPWR VGND sg13cmos5l_decap_4
XFILLER_9_321 VPWR VGND sg13cmos5l_fill_2
XFILLER_12_1056 VPWR VGND sg13cmos5l_decap_8
XFILLER_5_582 VPWR VGND sg13cmos5l_decap_8
XFILLER_11_14 VPWR VGND sg13cmos5l_decap_8
XFILLER_15_615 VPWR VGND sg13cmos5l_decap_8
XFILLER_11_876 VPWR VGND sg13cmos5l_fill_1
XFILLER_14_147 VPWR VGND sg13cmos5l_decap_8
X_311_ _311_/Q Tile_X0Y0_FrameData[10] VGND VPWR Tile_X0Y0_FrameStrobe[1] latch
X_242_ _242_/Q Tile_X0Y0_UserCLK _242_/D _359_/L_HI VPWR VGND sg13cmos5l_dfrbpq_1
X_173_ _173_/Q Tile_X0Y0_FrameData[11] VGND VPWR Tile_X1Y0_FrameStrobe[1] latch
XFILLER_7_825 VPWR VGND sg13cmos5l_fill_1
XANTENNA__541__X Tile_X1Y0_SS4BEG[6] VPWR VGND sg13cmos5l_antennanp
XFILLER_10_397 VPWR VGND sg13cmos5l_fill_1
XFILLER_7_869 VPWR VGND sg13cmos5l_fill_1
XFILLER_2_563 VPWR VGND sg13cmos5l_decap_8
XANTENNA_260 Tile_X0Y0_FrameData[8] VPWR VGND sg13cmos5l_antennanp
XANTENNA_271 Tile_X0Y0_FrameData[8] VPWR VGND sg13cmos5l_antennanp
XANTENNA_282 Tile_X0Y0_FrameData[8] VPWR VGND sg13cmos5l_antennanp
XANTENNA_293 Tile_X0Y0_FrameData[9] VPWR VGND sg13cmos5l_antennanp
X_509_ Tile_X1Y0_S2BEG[6] Tile_X1Y0_N2MID[1] VPWR VGND sg13cmos5l_buf_1
XANTENNA__451__X Tile_X1Y0_FrameData_O[4] VPWR VGND sg13cmos5l_antennanp
XFILLER_3_70 VPWR VGND sg13cmos5l_decap_4
XFILLER_3_1032 VPWR VGND sg13cmos5l_decap_8
XFILLER_11_128 VPWR VGND sg13cmos5l_decap_8
XANTENNA__536__X Tile_X1Y0_SS4BEG[1] VPWR VGND sg13cmos5l_antennanp
XFILLER_15_401 VPWR VGND sg13cmos5l_decap_8
XFILLER_15_478 VPWR VGND sg13cmos5l_decap_8
XFILLER_10_161 VPWR VGND sg13cmos5l_decap_4
XFILLER_11_695 VPWR VGND sg13cmos5l_decap_8
X_225_ _225_/Q Tile_X0Y0_FrameData[18] VGND VPWR Tile_X1Y0_FrameStrobe[3] latch
X_156_ _156_/Q Tile_X0Y0_FrameData[28] VGND VPWR Tile_X1Y0_FrameStrobe[1] latch
X_087_ _087_/X _239_/Q _239_/D _234_/Q VPWR VGND sg13cmos5l_mux2_1
XFILLER_7_688 VPWR VGND sg13cmos5l_fill_1
XFILLER_7_622 VPWR VGND sg13cmos5l_decap_8
XFILLER_6_132 VPWR VGND sg13cmos5l_decap_4
XFILLER_6_121 VPWR VGND sg13cmos5l_fill_1
XFILLER_6_198 VPWR VGND sg13cmos5l_fill_1
XFILLER_3_872 VPWR VGND sg13cmos5l_fill_2
XANTENNA__446__X Tile_X0Y0_S4BEG[15] VPWR VGND sg13cmos5l_antennanp
XFILLER_1_809 VPWR VGND sg13cmos5l_decap_8
XFILLER_9_909 VPWR VGND sg13cmos5l_fill_2
XFILLER_0_842 VPWR VGND sg13cmos5l_decap_8
XFILLER_0_853 VPWR VGND sg13cmos5l_fill_2
XFILLER_0_897 VPWR VGND sg13cmos5l_fill_2
XFILLER_16_710 VPWR VGND sg13cmos5l_decap_8
XFILLER_15_275 VPWR VGND sg13cmos5l_decap_8
X_208_ _208_/Q Tile_X0Y0_FrameData[8] VGND VPWR Tile_X1Y0_FrameStrobe[2] latch
X_139_ _139_/Q Tile_X0Y0_FrameData[13] VGND VPWR Tile_X1Y0_FrameStrobe[0] latch
XFILLER_7_496 VPWR VGND sg13cmos5l_decap_8
XFILLER_0_1024 VPWR VGND sg13cmos5l_decap_8
XFILLER_9_91 VPWR VGND sg13cmos5l_decap_8
XFILLER_12_267 VPWR VGND sg13cmos5l_decap_8
X_490_ Tile_X1Y0_FrameStrobe_O[11] Tile_X1Y0_FrameStrobe[11] VPWR VGND sg13cmos5l_buf_1
XFILLER_5_49 VPWR VGND sg13cmos5l_decap_8
XFILLER_4_466 VPWR VGND sg13cmos5l_decap_8
XFILLER_4_433 VPWR VGND sg13cmos5l_decap_8
XFILLER_15_1021 VPWR VGND sg13cmos5l_decap_8
XFILLER_15_1098 VPWR VGND sg13cmos5l_decap_8
XFILLER_14_14 VPWR VGND sg13cmos5l_decap_8
XFILLER_2_904 VPWR VGND sg13cmos5l_decap_8
XFILLER_7_1019 VPWR VGND sg13cmos5l_decap_8
XFILLER_2_959 VPWR VGND sg13cmos5l_decap_4
X_473_ Tile_X1Y0_FrameData_O[26] Tile_X0Y0_FrameData[26] VPWR VGND sg13cmos5l_buf_1
X_542_ Tile_X1Y0_SS4BEG[7] _631_/X VPWR VGND sg13cmos5l_buf_1
X_611_ _611_/X Tile_X1Y0_N2MID[3] Tile_X1Y0_N4END[12] Tile_X1Y0_NN4END[3] _095_/X
+ _198_/Q _197_/Q VPWR VGND sg13cmos5l_mux4_1
XANTENNA__544__X Tile_X1Y0_SS4BEG[9] VPWR VGND sg13cmos5l_antennanp
XFILLER_13_532 VPWR VGND sg13cmos5l_decap_8
XFILLER_9_525 VPWR VGND sg13cmos5l_decap_8
XFILLER_5_753 VPWR VGND sg13cmos5l_fill_2
XFILLER_4_263 VPWR VGND sg13cmos5l_decap_8
XANTENNA__454__X Tile_X1Y0_FrameData_O[7] VPWR VGND sg13cmos5l_antennanp
XFILLER_6_70 VPWR VGND sg13cmos5l_decap_4
XFILLER_14_329 VPWR VGND sg13cmos5l_decap_8
XFILLER_6_1041 VPWR VGND sg13cmos5l_decap_8
XFILLER_10_535 VPWR VGND sg13cmos5l_decap_8
XFILLER_1_211 VPWR VGND sg13cmos5l_fill_1
XFILLER_1_222 VPWR VGND sg13cmos5l_fill_2
XFILLER_6_528 VPWR VGND sg13cmos5l_decap_8
XFILLER_2_712 VPWR VGND sg13cmos5l_decap_8
XANTENNA__539__X Tile_X1Y0_SS4BEG[4] VPWR VGND sg13cmos5l_antennanp
XFILLER_1_244 VPWR VGND sg13cmos5l_decap_8
XFILLER_1_266 VPWR VGND sg13cmos5l_decap_8
XFILLER_1_277 VPWR VGND sg13cmos5l_fill_2
XFILLER_2_28 VPWR VGND sg13cmos5l_decap_8
X_456_ Tile_X1Y0_FrameData_O[9] Tile_X0Y0_FrameData[9] VPWR VGND sg13cmos5l_buf_1
X_525_ Tile_X1Y0_S4BEG[6] _614_/X VPWR VGND sg13cmos5l_buf_1
XFILLER_12_1013 VPWR VGND sg13cmos5l_decap_8
XFILLER_12_1035 VPWR VGND sg13cmos5l_decap_4
X_387_ Tile_X0Y0_SS4BEG[12] _596_/X VPWR VGND sg13cmos5l_buf_1
XFILLER_9_377 VPWR VGND sg13cmos5l_decap_4
XFILLER_5_561 VPWR VGND sg13cmos5l_decap_8
XANTENNA__449__X Tile_X1Y0_FrameData_O[2] VPWR VGND sg13cmos5l_antennanp
XFILLER_14_126 VPWR VGND sg13cmos5l_decap_8
X_310_ _310_/Q Tile_X0Y0_FrameData[11] VGND VPWR Tile_X0Y0_FrameStrobe[1] latch
XFILLER_10_332 VPWR VGND sg13cmos5l_decap_8
XFILLER_10_376 VPWR VGND sg13cmos5l_decap_8
X_241_ _241_/Q Tile_X0Y0_UserCLK _241_/D _362_/L_HI VPWR VGND sg13cmos5l_dfrbpq_1
X_172_ _172_/Q Tile_X0Y0_FrameData[12] VGND VPWR Tile_X1Y0_FrameStrobe[1] latch
XFILLER_6_369 VPWR VGND sg13cmos5l_decap_4
XFILLER_11_1090 VPWR VGND sg13cmos5l_decap_8
XFILLER_7_0 VPWR VGND sg13cmos5l_decap_8
XFILLER_2_542 VPWR VGND sg13cmos5l_decap_8
XANTENNA_250 Tile_X0Y0_FrameData[8] VPWR VGND sg13cmos5l_antennanp
XANTENNA_261 Tile_X0Y0_FrameData[8] VPWR VGND sg13cmos5l_antennanp
XANTENNA_272 Tile_X0Y0_FrameData[8] VPWR VGND sg13cmos5l_antennanp
XANTENNA_283 Tile_X0Y0_FrameData[8] VPWR VGND sg13cmos5l_antennanp
XANTENNA_294 Tile_X0Y0_FrameData[9] VPWR VGND sg13cmos5l_antennanp
XFILLER_14_660 VPWR VGND sg13cmos5l_fill_2
XFILLER_14_693 VPWR VGND sg13cmos5l_fill_2
X_439_ Tile_X0Y0_S4BEG[8] _576_/X VPWR VGND sg13cmos5l_buf_1
X_508_ Tile_X1Y0_S2BEG[5] Tile_X1Y0_N2MID[2] VPWR VGND sg13cmos5l_buf_1
XFILLER_6_870 VPWR VGND sg13cmos5l_decap_8
XFILLER_5_391 VPWR VGND sg13cmos5l_fill_1
XFILLER_3_1011 VPWR VGND sg13cmos5l_decap_8
XFILLER_11_107 VPWR VGND sg13cmos5l_decap_8
XFILLER_0_7 VPWR VGND sg13cmos5l_decap_8
XFILLER_15_457 VPWR VGND sg13cmos5l_decap_8
X_224_ _224_/Q Tile_X0Y0_FrameData[17] VGND VPWR Tile_X1Y0_FrameStrobe[3] latch
XFILLER_8_49 VPWR VGND sg13cmos5l_decap_8
XFILLER_10_140 VPWR VGND sg13cmos5l_decap_8
XFILLER_10_173 VPWR VGND sg13cmos5l_decap_8
XFILLER_10_184 VPWR VGND sg13cmos5l_fill_1
XFILLER_11_674 VPWR VGND sg13cmos5l_decap_8
X_155_ _155_/Q Tile_X0Y0_FrameData[29] VGND VPWR Tile_X1Y0_FrameStrobe[1] latch
X_086_ _239_/D PMOD_IO_I4 _556_/X _222_/Q VPWR VGND sg13cmos5l_mux2_1
XFILLER_7_601 VPWR VGND sg13cmos5l_decap_8
XFILLER_6_144 VPWR VGND sg13cmos5l_decap_8
XFILLER_3_895 VPWR VGND sg13cmos5l_fill_2
XANTENNA__462__X Tile_X1Y0_FrameData_O[15] VPWR VGND sg13cmos5l_antennanp
XFILLER_14_490 VPWR VGND sg13cmos5l_decap_8
XFILLER_12_449 VPWR VGND sg13cmos5l_decap_8
XFILLER_3_136 VPWR VGND sg13cmos5l_decap_4
XANTENNA__547__X Tile_X1Y0_SS4BEG[12] VPWR VGND sg13cmos5l_antennanp
XFILLER_15_210 VPWR VGND sg13cmos5l_fill_2
XFILLER_16_722 VPWR VGND sg13cmos5l_decap_8
XFILLER_16_744 VPWR VGND sg13cmos5l_decap_4
XFILLER_11_493 VPWR VGND sg13cmos5l_decap_8
XFILLER_15_254 VPWR VGND sg13cmos5l_decap_8
X_207_ _207_/Q Tile_X0Y0_FrameData[9] VGND VPWR Tile_X1Y0_FrameStrobe[2] latch
XFILLER_8_954 VPWR VGND sg13cmos5l_fill_2
X_138_ _138_/Q Tile_X0Y0_FrameData[14] VGND VPWR Tile_X1Y0_FrameStrobe[0] latch
X_069_ PMOD_IO_OE_O0 _223_/Q _066_/X _068_/Y VPWR VGND sg13cmos5l_a21oi_1
XFILLER_8_987 VPWR VGND sg13cmos5l_decap_8
XFILLER_7_475 VPWR VGND sg13cmos5l_decap_8
XANTENNA__457__X Tile_X1Y0_FrameData_O[10] VPWR VGND sg13cmos5l_antennanp
XFILLER_9_70 VPWR VGND sg13cmos5l_decap_8
XFILLER_0_117 VPWR VGND sg13cmos5l_decap_4
XFILLER_9_1094 VPWR VGND sg13cmos5l_fill_2
XFILLER_12_246 VPWR VGND sg13cmos5l_decap_8
XFILLER_13_769 VPWR VGND sg13cmos5l_decap_4
XFILLER_8_239 VPWR VGND sg13cmos5l_decap_8
XFILLER_8_217 VPWR VGND sg13cmos5l_fill_1
XFILLER_5_28 VPWR VGND sg13cmos5l_decap_8
XFILLER_4_445 VPWR VGND sg13cmos5l_decap_8
XFILLER_16_585 VPWR VGND sg13cmos5l_fill_2
XFILLER_15_1077 VPWR VGND sg13cmos5l_decap_8
XFILLER_7_283 VPWR VGND sg13cmos5l_fill_1
XFILLER_7_272 VPWR VGND sg13cmos5l_fill_1
XFILLER_10_739 VPWR VGND sg13cmos5l_decap_8
X_610_ _610_/X Tile_X1Y0_N2MID[2] Tile_X1Y0_N4END[13] Tile_X1Y0_NN4END[2] _085_/X
+ _200_/Q _199_/Q VPWR VGND sg13cmos5l_mux4_1
XFILLER_13_511 VPWR VGND sg13cmos5l_decap_8
X_472_ Tile_X1Y0_FrameData_O[25] Tile_X0Y0_FrameData[25] VPWR VGND sg13cmos5l_buf_1
X_541_ Tile_X1Y0_SS4BEG[6] _630_/X VPWR VGND sg13cmos5l_buf_1
XFILLER_13_588 VPWR VGND sg13cmos5l_decap_8
XFILLER_9_504 VPWR VGND sg13cmos5l_decap_8
XFILLER_1_993 VPWR VGND sg13cmos5l_decap_8
XFILLER_16_360 VPWR VGND sg13cmos5l_decap_8
XANTENNA__470__X Tile_X1Y0_FrameData_O[23] VPWR VGND sg13cmos5l_antennanp
XFILLER_8_581 VPWR VGND sg13cmos5l_decap_8
XFILLER_6_1020 VPWR VGND sg13cmos5l_decap_8
XFILLER_14_308 VPWR VGND sg13cmos5l_decap_8
XFILLER_6_1097 VPWR VGND sg13cmos5l_fill_2
XFILLER_10_514 VPWR VGND sg13cmos5l_decap_8
XFILLER_6_507 VPWR VGND sg13cmos5l_decap_8
XANTENNA__380__X Tile_X0Y0_SS4BEG[5] VPWR VGND sg13cmos5l_antennanp
XFILLER_13_385 VPWR VGND sg13cmos5l_decap_8
XFILLER_15_91 VPWR VGND sg13cmos5l_decap_8
X_386_ Tile_X0Y0_SS4BEG[11] _595_/X VPWR VGND sg13cmos5l_buf_1
X_455_ Tile_X1Y0_FrameData_O[8] Tile_X0Y0_FrameData[8] VPWR VGND sg13cmos5l_buf_1
X_524_ Tile_X1Y0_S4BEG[5] _613_/X VPWR VGND sg13cmos5l_buf_1
XFILLER_9_323 VPWR VGND sg13cmos5l_fill_1
XFILLER_5_540 VPWR VGND sg13cmos5l_decap_8
XANTENNA__465__X Tile_X1Y0_FrameData_O[18] VPWR VGND sg13cmos5l_antennanp
XFILLER_11_49 VPWR VGND sg13cmos5l_decap_8
XANTENNA__375__X Tile_X0Y0_SS4BEG[0] VPWR VGND sg13cmos5l_antennanp
XFILLER_14_105 VPWR VGND sg13cmos5l_decap_8
X_240_ _240_/Q Tile_X0Y0_UserCLK _240_/D _361_/L_HI VPWR VGND sg13cmos5l_dfrbpq_1
X_171_ _171_/Q Tile_X0Y0_FrameData[13] VGND VPWR Tile_X1Y0_FrameStrobe[1] latch
XFILLER_6_304 VPWR VGND sg13cmos5l_fill_2
XFILLER_2_598 VPWR VGND sg13cmos5l_decap_8
XFILLER_2_521 VPWR VGND sg13cmos5l_decap_8
XANTENNA_240 Tile_X0Y0_FrameData[3] VPWR VGND sg13cmos5l_antennanp
XANTENNA_251 Tile_X0Y0_FrameData[8] VPWR VGND sg13cmos5l_antennanp
XANTENNA_262 Tile_X0Y0_FrameData[8] VPWR VGND sg13cmos5l_antennanp
XANTENNA_273 Tile_X0Y0_FrameData[8] VPWR VGND sg13cmos5l_antennanp
XANTENNA_284 Tile_X0Y0_FrameData[8] VPWR VGND sg13cmos5l_antennanp
XANTENNA_295 Tile_X0Y0_FrameData[9] VPWR VGND sg13cmos5l_antennanp
XFILLER_13_182 VPWR VGND sg13cmos5l_decap_8
XFILLER_14_1109 VPWR VGND sg13cmos5l_decap_4
XFILLER_14_672 VPWR VGND sg13cmos5l_decap_8
X_369_ _369_/L_HI VPWR VGND sg13cmos5l_tiehi
X_438_ Tile_X0Y0_S4BEG[7] _575_/X VPWR VGND sg13cmos5l_buf_1
X_507_ Tile_X1Y0_S2BEG[4] Tile_X1Y0_N2MID[3] VPWR VGND sg13cmos5l_buf_1
XFILLER_9_175 VPWR VGND sg13cmos5l_decap_8
XFILLER_9_186 VPWR VGND sg13cmos5l_fill_2
XFILLER_3_1067 VPWR VGND sg13cmos5l_decap_8
XFILLER_3_329 VPWR VGND sg13cmos5l_decap_8
XFILLER_15_436 VPWR VGND sg13cmos5l_decap_8
XFILLER_16_937 VPWR VGND sg13cmos5l_fill_2
X_223_ _223_/Q Tile_X0Y0_FrameData[16] VGND VPWR Tile_X1Y0_FrameStrobe[3] latch
XFILLER_8_28 VPWR VGND sg13cmos5l_decap_8
XFILLER_6_101 VPWR VGND sg13cmos5l_fill_2
X_154_ _154_/Q Tile_X0Y0_FrameData[30] VGND VPWR Tile_X1Y0_FrameStrobe[1] latch
X_085_ _085_/X _240_/Q _240_/D _234_/Q VPWR VGND sg13cmos5l_mux2_1
XFILLER_7_679 VPWR VGND sg13cmos5l_decap_8
XFILLER_6_189 VPWR VGND sg13cmos5l_decap_8
XFILLER_2_384 VPWR VGND sg13cmos5l_fill_1
XFILLER_12_428 VPWR VGND sg13cmos5l_decap_8
XFILLER_0_899 VPWR VGND sg13cmos5l_fill_1
XFILLER_16_701 VPWR VGND sg13cmos5l_decap_4
XFILLER_11_472 VPWR VGND sg13cmos5l_decap_8
X_206_ _206_/Q Tile_X0Y0_FrameData[10] VGND VPWR Tile_X1Y0_FrameStrobe[2] latch
X_137_ _137_/Q Tile_X0Y0_FrameData[15] VGND VPWR Tile_X1Y0_FrameStrobe[0] latch
XFILLER_7_454 VPWR VGND sg13cmos5l_decap_8
X_068_ _068_/Y _120_/A _243_/D _067_/X VPWR VGND sg13cmos5l_o21ai_1
XFILLER_3_693 VPWR VGND sg13cmos5l_decap_8
XANTENNA__473__X Tile_X1Y0_FrameData_O[26] VPWR VGND sg13cmos5l_antennanp
XFILLER_1_608 VPWR VGND sg13cmos5l_decap_8
XFILLER_9_1073 VPWR VGND sg13cmos5l_decap_8
XANTENNA__383__X Tile_X0Y0_SS4BEG[8] VPWR VGND sg13cmos5l_antennanp
XFILLER_12_225 VPWR VGND sg13cmos5l_decap_8
XFILLER_16_564 VPWR VGND sg13cmos5l_decap_8
XFILLER_16_597 VPWR VGND sg13cmos5l_decap_8
XFILLER_11_280 VPWR VGND sg13cmos5l_fill_2
XFILLER_15_1056 VPWR VGND sg13cmos5l_decap_8
XFILLER_8_763 VPWR VGND sg13cmos5l_decap_8
XANTENNA__468__X Tile_X1Y0_FrameData_O[21] VPWR VGND sg13cmos5l_antennanp
XFILLER_15_0 VPWR VGND sg13cmos5l_decap_8
XFILLER_14_49 VPWR VGND sg13cmos5l_decap_8
XFILLER_1_449 VPWR VGND sg13cmos5l_decap_8
XANTENNA__378__X Tile_X0Y0_SS4BEG[3] VPWR VGND sg13cmos5l_antennanp
X_540_ Tile_X1Y0_SS4BEG[5] _629_/X VPWR VGND sg13cmos5l_buf_1
XFILLER_13_567 VPWR VGND sg13cmos5l_decap_8
X_471_ Tile_X1Y0_FrameData_O[24] Tile_X0Y0_FrameData[24] VPWR VGND sg13cmos5l_buf_1
XFILLER_5_755 VPWR VGND sg13cmos5l_fill_1
XFILLER_0_460 VPWR VGND sg13cmos5l_decap_8
XFILLER_1_972 VPWR VGND sg13cmos5l_decap_8
XFILLER_4_298 VPWR VGND sg13cmos5l_decap_4
XFILLER_16_394 VPWR VGND sg13cmos5l_decap_8
XFILLER_8_560 VPWR VGND sg13cmos5l_decap_8
XFILLER_6_1076 VPWR VGND sg13cmos5l_decap_8
XFILLER_2_747 VPWR VGND sg13cmos5l_fill_1
X_523_ Tile_X1Y0_S4BEG[4] _612_/X VPWR VGND sg13cmos5l_buf_1
XFILLER_13_364 VPWR VGND sg13cmos5l_decap_8
XFILLER_14_810 VPWR VGND sg13cmos5l_fill_1
XFILLER_15_70 VPWR VGND sg13cmos5l_decap_8
X_385_ Tile_X0Y0_SS4BEG[10] _594_/X VPWR VGND sg13cmos5l_buf_1
X_454_ Tile_X1Y0_FrameData_O[7] Tile_X0Y0_FrameData[7] VPWR VGND sg13cmos5l_buf_1
XFILLER_9_368 VPWR VGND sg13cmos5l_fill_2
XFILLER_5_596 VPWR VGND sg13cmos5l_decap_8
XFILLER_16_191 VPWR VGND sg13cmos5l_decap_8
XANTENNA__481__X Tile_X1Y0_FrameStrobe_O[2] VPWR VGND sg13cmos5l_antennanp
XFILLER_11_28 VPWR VGND sg13cmos5l_decap_8
XFILLER_15_629 VPWR VGND sg13cmos5l_decap_8
X_170_ _170_/Q Tile_X0Y0_FrameData[14] VGND VPWR Tile_X1Y0_FrameStrobe[1] latch
XFILLER_7_806 VPWR VGND sg13cmos5l_decap_8
XANTENNA__391__X Tile_X0Y0_FrameStrobe_O[0] VPWR VGND sg13cmos5l_antennanp
XFILLER_6_316 VPWR VGND sg13cmos5l_fill_1
XFILLER_2_500 VPWR VGND sg13cmos5l_decap_8
XFILLER_2_577 VPWR VGND sg13cmos5l_decap_8
XANTENNA_230 Tile_X0Y0_FrameData[3] VPWR VGND sg13cmos5l_antennanp
XANTENNA_241 Tile_X0Y0_FrameData[8] VPWR VGND sg13cmos5l_antennanp
XANTENNA_252 Tile_X0Y0_FrameData[8] VPWR VGND sg13cmos5l_antennanp
XANTENNA_263 Tile_X0Y0_FrameData[8] VPWR VGND sg13cmos5l_antennanp
XANTENNA_274 Tile_X0Y0_FrameData[8] VPWR VGND sg13cmos5l_antennanp
XANTENNA_285 Tile_X0Y0_FrameData[8] VPWR VGND sg13cmos5l_antennanp
X_506_ Tile_X1Y0_S2BEG[3] Tile_X1Y0_N2MID[4] VPWR VGND sg13cmos5l_buf_1
XANTENNA_296 Tile_X0Y0_FrameData[9] VPWR VGND sg13cmos5l_antennanp
XFILLER_13_161 VPWR VGND sg13cmos5l_decap_8
XFILLER_14_695 VPWR VGND sg13cmos5l_fill_1
X_299_ _299_/Q Tile_X0Y0_FrameData[22] VGND VPWR Tile_X0Y0_FrameStrobe[1] latch
X_368_ _368_/L_HI VPWR VGND sg13cmos5l_tiehi
X_437_ Tile_X0Y0_S4BEG[6] _574_/X VPWR VGND sg13cmos5l_buf_1
XFILLER_6_850 VPWR VGND sg13cmos5l_fill_2
XANTENNA__476__X Tile_X1Y0_FrameData_O[29] VPWR VGND sg13cmos5l_antennanp
XFILLER_3_95 VPWR VGND sg13cmos5l_fill_1
XFILLER_3_1046 VPWR VGND sg13cmos5l_decap_8
XANTENNA__386__X Tile_X0Y0_SS4BEG[11] VPWR VGND sg13cmos5l_antennanp
XFILLER_15_415 VPWR VGND sg13cmos5l_decap_8
X_222_ _222_/Q Tile_X0Y0_FrameData[15] VGND VPWR Tile_X1Y0_FrameStrobe[3] latch
X_153_ _153_/Q Tile_X0Y0_FrameData[31] VGND VPWR Tile_X1Y0_FrameStrobe[1] latch
XFILLER_12_60 VPWR VGND sg13cmos5l_decap_4
XFILLER_12_71 VPWR VGND sg13cmos5l_decap_8
X_084_ _240_/D PMOD_IO_I5 _557_/X _222_/Q VPWR VGND sg13cmos5l_mux2_1
XFILLER_6_179 VPWR VGND sg13cmos5l_fill_2
XFILLER_3_897 VPWR VGND sg13cmos5l_fill_1
XFILLER_13_908 VPWR VGND sg13cmos5l_decap_8
XFILLER_12_407 VPWR VGND sg13cmos5l_decap_8
XFILLER_4_639 VPWR VGND sg13cmos5l_decap_4
XFILLER_4_606 VPWR VGND sg13cmos5l_decap_4
XFILLER_15_223 VPWR VGND sg13cmos5l_decap_8
XFILLER_15_289 VPWR VGND sg13cmos5l_decap_8
XFILLER_16_757 VPWR VGND sg13cmos5l_decap_4
XFILLER_11_451 VPWR VGND sg13cmos5l_decap_8
X_205_ _205_/Q Tile_X0Y0_FrameData[11] VGND VPWR Tile_X1Y0_FrameStrobe[2] latch
X_136_ _136_/Q Tile_X0Y0_FrameData[16] VGND VPWR Tile_X1Y0_FrameStrobe[0] latch
XFILLER_7_433 VPWR VGND sg13cmos5l_decap_8
XFILLER_7_422 VPWR VGND sg13cmos5l_decap_8
X_067_ _067_/X _233_/Q _243_/Q VPWR VGND sg13cmos5l_or2_1
XFILLER_3_650 VPWR VGND sg13cmos5l_decap_8
XFILLER_0_1038 VPWR VGND sg13cmos5l_decap_8
XFILLER_0_63 VPWR VGND sg13cmos5l_decap_8
XFILLER_0_85 VPWR VGND sg13cmos5l_decap_8
XFILLER_0_96 VPWR VGND sg13cmos5l_decap_8
XFILLER_9_1096 VPWR VGND sg13cmos5l_fill_1
XFILLER_9_1052 VPWR VGND sg13cmos5l_decap_8
XFILLER_12_204 VPWR VGND sg13cmos5l_decap_8
XFILLER_4_414 VPWR VGND sg13cmos5l_decap_8
XFILLER_0_653 VPWR VGND sg13cmos5l_fill_2
XFILLER_0_697 VPWR VGND sg13cmos5l_fill_1
XFILLER_16_521 VPWR VGND sg13cmos5l_decap_8
XFILLER_16_543 VPWR VGND sg13cmos5l_decap_8
XFILLER_15_1002 VPWR VGND sg13cmos5l_fill_2
XFILLER_15_1035 VPWR VGND sg13cmos5l_decap_8
X_119_ _119_/X _236_/Q _236_/D _234_/Q VPWR VGND sg13cmos5l_mux2_1
XFILLER_8_742 VPWR VGND sg13cmos5l_decap_8
XANTENNA__484__X Tile_X1Y0_FrameStrobe_O[5] VPWR VGND sg13cmos5l_antennanp
XFILLER_14_28 VPWR VGND sg13cmos5l_decap_8
XFILLER_1_428 VPWR VGND sg13cmos5l_decap_8
XFILLER_2_918 VPWR VGND sg13cmos5l_decap_8
XANTENNA__394__X Tile_X0Y0_FrameStrobe_O[3] VPWR VGND sg13cmos5l_antennanp
XFILLER_13_546 VPWR VGND sg13cmos5l_decap_8
X_470_ Tile_X1Y0_FrameData_O[23] Tile_X0Y0_FrameData[23] VPWR VGND sg13cmos5l_buf_1
XFILLER_9_539 VPWR VGND sg13cmos5l_decap_8
XFILLER_14_1090 VPWR VGND sg13cmos5l_decap_8
XFILLER_5_778 VPWR VGND sg13cmos5l_fill_2
XFILLER_4_277 VPWR VGND sg13cmos5l_fill_1
XFILLER_16_340 VPWR VGND sg13cmos5l_decap_8
X_599_ _599_/X Tile_X0Y0_N2END[7] Tile_X0Y0_N4END[15] Tile_X0Y0_NN4END[0] _091_/X
+ _271_/Q _270_/Q VPWR VGND sg13cmos5l_mux4_1
XANTENNA__479__X Tile_X1Y0_FrameStrobe_O[0] VPWR VGND sg13cmos5l_antennanp
XFILLER_6_1099 VPWR VGND sg13cmos5l_fill_1
XFILLER_6_1055 VPWR VGND sg13cmos5l_decap_8
XFILLER_10_549 VPWR VGND sg13cmos5l_decap_8
XANTENNA__389__X Tile_X0Y0_SS4BEG[14] VPWR VGND sg13cmos5l_antennanp
XFILLER_1_258 VPWR VGND sg13cmos5l_fill_1
XFILLER_2_726 VPWR VGND sg13cmos5l_decap_8
X_453_ Tile_X1Y0_FrameData_O[6] Tile_X0Y0_FrameData[6] VPWR VGND sg13cmos5l_buf_1
X_522_ Tile_X1Y0_S4BEG[3] _611_/X VPWR VGND sg13cmos5l_buf_1
XFILLER_12_1027 VPWR VGND sg13cmos5l_decap_4
XFILLER_13_343 VPWR VGND sg13cmos5l_decap_8
X_384_ Tile_X0Y0_SS4BEG[9] _593_/X VPWR VGND sg13cmos5l_buf_1
XFILLER_9_314 VPWR VGND sg13cmos5l_decap_8
XFILLER_12_1049 VPWR VGND sg13cmos5l_decap_8
XFILLER_5_575 VPWR VGND sg13cmos5l_decap_8
XFILLER_16_170 VPWR VGND sg13cmos5l_decap_8
XFILLER_15_608 VPWR VGND sg13cmos5l_decap_8
XFILLER_10_346 VPWR VGND sg13cmos5l_decap_4
XFILLER_7_818 VPWR VGND sg13cmos5l_decap_8
XFILLER_2_556 VPWR VGND sg13cmos5l_decap_8
XANTENNA_220 Tile_X0Y0_FrameData[3] VPWR VGND sg13cmos5l_antennanp
XANTENNA_231 Tile_X0Y0_FrameData[3] VPWR VGND sg13cmos5l_antennanp
XANTENNA_242 Tile_X0Y0_FrameData[8] VPWR VGND sg13cmos5l_antennanp
XANTENNA_253 Tile_X0Y0_FrameData[8] VPWR VGND sg13cmos5l_antennanp
XANTENNA_264 Tile_X0Y0_FrameData[8] VPWR VGND sg13cmos5l_antennanp
XANTENNA_275 Tile_X0Y0_FrameData[8] VPWR VGND sg13cmos5l_antennanp
XANTENNA_286 Tile_X0Y0_FrameData[8] VPWR VGND sg13cmos5l_antennanp
XANTENNA_297 Tile_X0Y0_FrameData[9] VPWR VGND sg13cmos5l_antennanp
XFILLER_13_140 VPWR VGND sg13cmos5l_decap_8
X_436_ Tile_X0Y0_S4BEG[5] _573_/X VPWR VGND sg13cmos5l_buf_1
X_505_ Tile_X1Y0_S2BEG[2] Tile_X1Y0_N2MID[5] VPWR VGND sg13cmos5l_buf_1
XFILLER_10_880 VPWR VGND sg13cmos5l_fill_1
X_298_ _298_/Q Tile_X0Y0_FrameData[23] VGND VPWR Tile_X0Y0_FrameStrobe[1] latch
X_367_ _367_/L_HI VPWR VGND sg13cmos5l_tiehi
XFILLER_9_133 VPWR VGND sg13cmos5l_decap_8
XFILLER_3_63 VPWR VGND sg13cmos5l_decap_8
XFILLER_3_1025 VPWR VGND sg13cmos5l_decap_8
XANTENNA__492__X Tile_X1Y0_FrameStrobe_O[13] VPWR VGND sg13cmos5l_antennanp
XFILLER_10_154 VPWR VGND sg13cmos5l_decap_8
XFILLER_10_165 VPWR VGND sg13cmos5l_fill_1
XFILLER_11_633 VPWR VGND sg13cmos5l_decap_4
XFILLER_11_688 VPWR VGND sg13cmos5l_decap_8
X_221_ _221_/Q Tile_X0Y0_FrameData[31] VGND VPWR Tile_X1Y0_FrameStrobe[0] latch
X_152_ _152_/Q Tile_X0Y0_FrameData[0] VGND VPWR Tile_X1Y0_FrameStrobe[0] latch
X_083_ _235_/D PMOD_IO_I0 _552_/X _222_/Q VPWR VGND sg13cmos5l_mux2_1
XFILLER_7_615 VPWR VGND sg13cmos5l_decap_8
XFILLER_6_136 VPWR VGND sg13cmos5l_fill_1
XFILLER_6_125 VPWR VGND sg13cmos5l_decap_8
XFILLER_6_114 VPWR VGND sg13cmos5l_decap_8
XFILLER_12_94 VPWR VGND sg13cmos5l_fill_1
XFILLER_5_0 VPWR VGND sg13cmos5l_decap_8
XFILLER_3_865 VPWR VGND sg13cmos5l_decap_8
XFILLER_3_832 VPWR VGND sg13cmos5l_decap_4
XFILLER_2_320 VPWR VGND sg13cmos5l_decap_8
X_419_ Tile_X0Y0_S2BEG[4] Tile_X0Y0_N2MID[3] VPWR VGND sg13cmos5l_buf_1
XANTENNA__487__X Tile_X1Y0_FrameStrobe_O[8] VPWR VGND sg13cmos5l_antennanp
XFILLER_0_802 VPWR VGND sg13cmos5l_decap_8
XANTENNA__397__X Tile_X0Y0_FrameStrobe_O[6] VPWR VGND sg13cmos5l_antennanp
XFILLER_0_879 VPWR VGND sg13cmos5l_fill_2
XFILLER_11_430 VPWR VGND sg13cmos5l_decap_8
XFILLER_15_268 VPWR VGND sg13cmos5l_decap_8
XFILLER_16_736 VPWR VGND sg13cmos5l_decap_4
X_204_ _204_/Q Tile_X0Y0_FrameData[12] VGND VPWR Tile_X1Y0_FrameStrobe[2] latch
X_135_ _135_/Q Tile_X0Y0_FrameData[17] VGND VPWR Tile_X1Y0_FrameStrobe[0] latch
X_066_ _066_/X _251_/Q _552_/X _233_/Q VPWR VGND sg13cmos5l_mux2_1
XFILLER_8_935 VPWR VGND sg13cmos5l_decap_4
XFILLER_7_489 VPWR VGND sg13cmos5l_decap_8
XFILLER_7_401 VPWR VGND sg13cmos5l_decap_8
XFILLER_0_1017 VPWR VGND sg13cmos5l_decap_8
XFILLER_0_42 VPWR VGND sg13cmos5l_decap_8
XFILLER_9_84 VPWR VGND sg13cmos5l_decap_8
XFILLER_9_1031 VPWR VGND sg13cmos5l_decap_8
XFILLER_4_426 VPWR VGND sg13cmos5l_decap_8
XFILLER_4_459 VPWR VGND sg13cmos5l_decap_8
XFILLER_16_500 VPWR VGND sg13cmos5l_decap_8
XFILLER_11_282 VPWR VGND sg13cmos5l_fill_1
XFILLER_12_761 VPWR VGND sg13cmos5l_decap_4
XFILLER_15_1014 VPWR VGND sg13cmos5l_decap_8
XFILLER_8_721 VPWR VGND sg13cmos5l_decap_8
X_118_ _236_/D PMOD_IO_I1 _553_/X _222_/Q VPWR VGND sg13cmos5l_mux2_1
XFILLER_4_982 VPWR VGND sg13cmos5l_decap_8
XFILLER_13_525 VPWR VGND sg13cmos5l_decap_8
XFILLER_9_518 VPWR VGND sg13cmos5l_decap_8
XFILLER_4_223 VPWR VGND sg13cmos5l_fill_1
XFILLER_0_495 VPWR VGND sg13cmos5l_decap_8
XFILLER_1_963 VPWR VGND sg13cmos5l_decap_4
XFILLER_16_374 VPWR VGND sg13cmos5l_fill_2
XFILLER_1_1112 VPWR VGND sg13cmos5l_fill_2
X_598_ _598_/X Tile_X0Y0_N2END[6] Tile_X0Y0_N4END[14] Tile_X0Y0_NN4END[1] _092_/X
+ _273_/Q _272_/Q VPWR VGND sg13cmos5l_mux4_1
XANTENNA_1 Tile_X0Y0_FrameData[0] VPWR VGND sg13cmos5l_antennanp
XFILLER_8_595 VPWR VGND sg13cmos5l_decap_8
XFILLER_6_74 VPWR VGND sg13cmos5l_fill_2
XFILLER_6_63 VPWR VGND sg13cmos5l_decap_8
XFILLER_6_1001 VPWR VGND sg13cmos5l_decap_8
XANTENNA__495__X Tile_X1Y0_FrameStrobe_O[16] VPWR VGND sg13cmos5l_antennanp
XFILLER_6_1034 VPWR VGND sg13cmos5l_decap_8
XFILLER_10_528 VPWR VGND sg13cmos5l_decap_8
XFILLER_1_204 VPWR VGND sg13cmos5l_fill_1
XFILLER_1_215 VPWR VGND sg13cmos5l_decap_8
XFILLER_9_7 VPWR VGND sg13cmos5l_decap_8
XFILLER_13_322 VPWR VGND sg13cmos5l_decap_8
X_383_ Tile_X0Y0_SS4BEG[8] _592_/X VPWR VGND sg13cmos5l_buf_1
X_452_ Tile_X1Y0_FrameData_O[5] Tile_X0Y0_FrameData[5] VPWR VGND sg13cmos5l_buf_1
X_521_ Tile_X1Y0_S4BEG[2] _610_/X VPWR VGND sg13cmos5l_buf_1
XFILLER_12_1006 VPWR VGND sg13cmos5l_decap_8
XFILLER_13_399 VPWR VGND sg13cmos5l_decap_8
XFILLER_5_554 VPWR VGND sg13cmos5l_decap_8
XFILLER_14_119 VPWR VGND sg13cmos5l_decap_8
XFILLER_10_358 VPWR VGND sg13cmos5l_fill_1
XFILLER_10_369 VPWR VGND sg13cmos5l_decap_8
XFILLER_11_1083 VPWR VGND sg13cmos5l_decap_8
XFILLER_2_535 VPWR VGND sg13cmos5l_decap_8
XANTENNA_210 Tile_X0Y0_FrameData[25] VPWR VGND sg13cmos5l_antennanp
XANTENNA_221 Tile_X0Y0_FrameData[3] VPWR VGND sg13cmos5l_antennanp
XANTENNA_232 Tile_X0Y0_FrameData[3] VPWR VGND sg13cmos5l_antennanp
XANTENNA_243 Tile_X0Y0_FrameData[8] VPWR VGND sg13cmos5l_antennanp
XANTENNA_254 Tile_X0Y0_FrameData[8] VPWR VGND sg13cmos5l_antennanp
XANTENNA_265 Tile_X0Y0_FrameData[8] VPWR VGND sg13cmos5l_antennanp
XANTENNA_276 Tile_X0Y0_FrameData[8] VPWR VGND sg13cmos5l_antennanp
XANTENNA_287 Tile_X0Y0_FrameData[8] VPWR VGND sg13cmos5l_antennanp
XANTENNA_298 Tile_X0Y0_FrameData[9] VPWR VGND sg13cmos5l_antennanp
XFILLER_14_642 VPWR VGND sg13cmos5l_decap_8
XFILLER_14_686 VPWR VGND sg13cmos5l_decap_8
X_366_ _366_/L_HI VPWR VGND sg13cmos5l_tiehi
X_435_ Tile_X0Y0_S4BEG[4] _572_/X VPWR VGND sg13cmos5l_buf_1
X_504_ Tile_X1Y0_S2BEG[1] Tile_X1Y0_N2MID[6] VPWR VGND sg13cmos5l_buf_1
XFILLER_9_112 VPWR VGND sg13cmos5l_decap_8
XFILLER_10_892 VPWR VGND sg13cmos5l_fill_2
XFILLER_13_196 VPWR VGND sg13cmos5l_decap_8
X_297_ _297_/Q Tile_X0Y0_FrameData[24] VGND VPWR Tile_X0Y0_FrameStrobe[1] latch
XFILLER_3_42 VPWR VGND sg13cmos5l_decap_8
XFILLER_3_1004 VPWR VGND sg13cmos5l_decap_8
XFILLER_11_612 VPWR VGND sg13cmos5l_decap_8
X_220_ _220_/Q Tile_X0Y0_FrameData[28] VGND VPWR Tile_X1Y0_FrameStrobe[3] latch
XFILLER_10_133 VPWR VGND sg13cmos5l_decap_8
XFILLER_10_199 VPWR VGND sg13cmos5l_decap_8
XFILLER_11_645 VPWR VGND sg13cmos5l_fill_1
XFILLER_11_667 VPWR VGND sg13cmos5l_decap_8
X_151_ _151_/Q Tile_X0Y0_FrameData[1] VGND VPWR Tile_X1Y0_FrameStrobe[0] latch
X_082_ PMOD_IO_OE_O3 _120_/A _059_/Y _081_/X _223_/Q _080_/Y VPWR VGND sg13cmos5l_a221oi_1
XFILLER_2_1081 VPWR VGND sg13cmos5l_decap_8
XFILLER_14_483 VPWR VGND sg13cmos5l_decap_8
X_349_ _349_/Q Tile_X0Y0_FrameData[4] VGND VPWR Tile_X0Y0_FrameStrobe[2] latch
X_418_ Tile_X0Y0_S2BEG[3] Tile_X0Y0_N2MID[4] VPWR VGND sg13cmos5l_buf_1
XFILLER_6_682 VPWR VGND sg13cmos5l_decap_8
XFILLER_5_170 VPWR VGND sg13cmos5l_fill_2
XFILLER_0_858 VPWR VGND sg13cmos5l_decap_4
XFILLER_15_203 VPWR VGND sg13cmos5l_decap_8
XFILLER_16_748 VPWR VGND sg13cmos5l_fill_2
XFILLER_15_247 VPWR VGND sg13cmos5l_decap_8
X_203_ _203_/Q Tile_X0Y0_FrameData[13] VGND VPWR Tile_X1Y0_FrameStrobe[2] latch
XFILLER_11_486 VPWR VGND sg13cmos5l_decap_8
X_134_ _134_/Q Tile_X0Y0_FrameData[18] VGND VPWR Tile_X1Y0_FrameStrobe[0] latch
X_065_ _243_/D _640_/X _231_/Q _232_/Q VPWR VGND sg13cmos5l_mux2_1
XFILLER_7_468 VPWR VGND sg13cmos5l_decap_8
XANTENNA__100__Y PMOD_IO_OE_O6 VPWR VGND sg13cmos5l_antennanp
XFILLER_0_21 VPWR VGND sg13cmos5l_decap_8
XFILLER_14_280 VPWR VGND sg13cmos5l_decap_8
XFILLER_9_63 VPWR VGND sg13cmos5l_decap_8
XANTENNA__498__X Tile_X1Y0_FrameStrobe_O[19] VPWR VGND sg13cmos5l_antennanp
XFILLER_9_1010 VPWR VGND sg13cmos5l_decap_8
XFILLER_7_991 VPWR VGND sg13cmos5l_decap_8
XFILLER_9_1087 VPWR VGND sg13cmos5l_decap_8
XFILLER_12_239 VPWR VGND sg13cmos5l_decap_8
XFILLER_13_729 VPWR VGND sg13cmos5l_fill_1
XFILLER_0_677 VPWR VGND sg13cmos5l_fill_1
XFILLER_16_578 VPWR VGND sg13cmos5l_decap_8
X_117_ PMOD_IO_O7 _223_/Q _107_/X VPWR VGND sg13cmos5l_nor2b_1
XFILLER_8_700 VPWR VGND sg13cmos5l_decap_8
XFILLER_7_210 VPWR VGND sg13cmos5l_fill_1
XFILLER_7_287 VPWR VGND sg13cmos5l_fill_2
XFILLER_4_961 VPWR VGND sg13cmos5l_decap_8
XFILLER_4_950 VPWR VGND sg13cmos5l_decap_4
XFILLER_3_493 VPWR VGND sg13cmos5l_decap_8
XFILLER_13_504 VPWR VGND sg13cmos5l_decap_8
XFILLER_5_714 VPWR VGND sg13cmos5l_decap_4
XFILLER_0_441 VPWR VGND sg13cmos5l_fill_1
XFILLER_0_474 VPWR VGND sg13cmos5l_decap_4
XFILLER_1_986 VPWR VGND sg13cmos5l_decap_8
XFILLER_16_353 VPWR VGND sg13cmos5l_decap_8
X_597_ _597_/X Tile_X0Y0_N2END[5] Tile_X0Y0_N4END[13] Tile_X0Y0_NN4END[2] _119_/X
+ _275_/Q _274_/Q VPWR VGND sg13cmos5l_mux4_1
XANTENNA_2 Tile_X0Y0_FrameData[0] VPWR VGND sg13cmos5l_antennanp
XFILLER_8_574 VPWR VGND sg13cmos5l_decap_8
XFILLER_6_42 VPWR VGND sg13cmos5l_decap_8
XFILLER_6_97 VPWR VGND sg13cmos5l_decap_4
XFILLER_6_1013 VPWR VGND sg13cmos5l_decap_8
XFILLER_13_0 VPWR VGND sg13cmos5l_decap_8
XFILLER_10_507 VPWR VGND sg13cmos5l_decap_8
X_520_ Tile_X1Y0_S4BEG[1] _609_/X VPWR VGND sg13cmos5l_buf_1
XFILLER_13_301 VPWR VGND sg13cmos5l_decap_8
XFILLER_14_868 VPWR VGND sg13cmos5l_fill_2
XFILLER_15_84 VPWR VGND sg13cmos5l_decap_8
XFILLER_16_1110 VPWR VGND sg13cmos5l_decap_4
X_382_ Tile_X0Y0_SS4BEG[7] _591_/X VPWR VGND sg13cmos5l_buf_1
X_451_ Tile_X1Y0_FrameData_O[4] Tile_X0Y0_FrameData[4] VPWR VGND sg13cmos5l_buf_1
XFILLER_13_378 VPWR VGND sg13cmos5l_decap_8
XFILLER_5_533 VPWR VGND sg13cmos5l_decap_8
XFILLER_0_282 VPWR VGND sg13cmos5l_fill_2
XFILLER_16_150 VPWR VGND sg13cmos5l_fill_2
XFILLER_8_382 VPWR VGND sg13cmos5l_decap_8
XFILLER_11_816 VPWR VGND sg13cmos5l_decap_4
XFILLER_11_838 VPWR VGND sg13cmos5l_fill_1
XFILLER_11_1062 VPWR VGND sg13cmos5l_decap_8
XFILLER_2_514 VPWR VGND sg13cmos5l_decap_8
XANTENNA_200 Tile_X0Y0_FrameData[1] VPWR VGND sg13cmos5l_antennanp
XANTENNA_211 Tile_X0Y0_FrameData[3] VPWR VGND sg13cmos5l_antennanp
XANTENNA_222 Tile_X0Y0_FrameData[3] VPWR VGND sg13cmos5l_antennanp
XANTENNA_233 Tile_X0Y0_FrameData[3] VPWR VGND sg13cmos5l_antennanp
X_503_ Tile_X1Y0_S2BEG[0] Tile_X1Y0_N2MID[7] VPWR VGND sg13cmos5l_buf_1
XANTENNA_244 Tile_X0Y0_FrameData[8] VPWR VGND sg13cmos5l_antennanp
XANTENNA_255 Tile_X0Y0_FrameData[8] VPWR VGND sg13cmos5l_antennanp
XANTENNA_266 Tile_X0Y0_FrameData[8] VPWR VGND sg13cmos5l_antennanp
XANTENNA_277 Tile_X0Y0_FrameData[8] VPWR VGND sg13cmos5l_antennanp
XANTENNA_288 Tile_X0Y0_FrameData[8] VPWR VGND sg13cmos5l_antennanp
XANTENNA_299 Tile_X0Y0_FrameData[9] VPWR VGND sg13cmos5l_antennanp
XFILLER_13_175 VPWR VGND sg13cmos5l_decap_8
XFILLER_14_621 VPWR VGND sg13cmos5l_decap_8
XFILLER_14_665 VPWR VGND sg13cmos5l_decap_8
X_296_ _296_/Q Tile_X0Y0_FrameData[25] VGND VPWR Tile_X0Y0_FrameStrobe[1] latch
X_365_ _365_/L_HI VPWR VGND sg13cmos5l_tiehi
X_434_ Tile_X0Y0_S4BEG[3] _571_/X VPWR VGND sg13cmos5l_buf_1
XFILLER_5_396 VPWR VGND sg13cmos5l_fill_1
XFILLER_3_21 VPWR VGND sg13cmos5l_decap_8
XFILLER_10_112 VPWR VGND sg13cmos5l_decap_8
XFILLER_15_429 VPWR VGND sg13cmos5l_decap_8
X_150_ _150_/Q Tile_X0Y0_FrameData[2] VGND VPWR Tile_X1Y0_FrameStrobe[0] latch
XFILLER_12_85 VPWR VGND sg13cmos5l_decap_4
XFILLER_13_1113 VPWR VGND sg13cmos5l_fill_1
X_081_ _081_/X _254_/Q _555_/X _233_/Q VPWR VGND sg13cmos5l_mux2_1
XFILLER_2_1060 VPWR VGND sg13cmos5l_decap_8
XFILLER_14_462 VPWR VGND sg13cmos5l_decap_8
X_279_ _279_/Q Tile_X0Y0_FrameData[10] VGND VPWR Tile_X0Y0_FrameStrobe[0] latch
X_348_ _348_/Q Tile_X0Y0_FrameData[5] VGND VPWR Tile_X0Y0_FrameStrobe[2] latch
X_417_ Tile_X0Y0_S2BEG[2] Tile_X0Y0_N2MID[5] VPWR VGND sg13cmos5l_buf_1
XFILLER_6_661 VPWR VGND sg13cmos5l_decap_8
XFILLER_0_826 VPWR VGND sg13cmos5l_fill_2
XFILLER_16_705 VPWR VGND sg13cmos5l_fill_2
XFILLER_11_465 VPWR VGND sg13cmos5l_decap_8
XFILLER_12_999 VPWR VGND sg13cmos5l_decap_8
X_202_ _202_/Q Tile_X0Y0_FrameData[14] VGND VPWR Tile_X1Y0_FrameStrobe[2] latch
X_133_ _133_/Q Tile_X0Y0_FrameData[19] VGND VPWR Tile_X1Y0_FrameStrobe[0] latch
XFILLER_8_926 VPWR VGND sg13cmos5l_decap_4
XFILLER_7_447 VPWR VGND sg13cmos5l_decap_8
X_064_ _064_/X _242_/Q _242_/D _234_/Q VPWR VGND sg13cmos5l_mux2_1
XFILLER_0_1008 VPWR VGND sg13cmos5l_fill_1
XFILLER_0_77 VPWR VGND sg13cmos5l_decap_4
XFILLER_9_42 VPWR VGND sg13cmos5l_decap_8
XFILLER_7_970 VPWR VGND sg13cmos5l_decap_8
XFILLER_9_1066 VPWR VGND sg13cmos5l_decap_8
XFILLER_12_218 VPWR VGND sg13cmos5l_decap_8
XFILLER_0_601 VPWR VGND sg13cmos5l_decap_8
XFILLER_5_918 VPWR VGND sg13cmos5l_fill_1
XFILLER_16_535 VPWR VGND sg13cmos5l_decap_4
XFILLER_16_557 VPWR VGND sg13cmos5l_decap_8
XFILLER_15_1049 VPWR VGND sg13cmos5l_decap_8
X_116_ PMOD_IO_O6 _223_/Q _097_/X VPWR VGND sg13cmos5l_nor2b_1
XFILLER_8_778 VPWR VGND sg13cmos5l_fill_1
XFILLER_7_277 VPWR VGND sg13cmos5l_fill_2
XANTENNA__111__Y PMOD_IO_O1 VPWR VGND sg13cmos5l_antennanp
XFILLER_3_472 VPWR VGND sg13cmos5l_decap_8
XFILLER_15_590 VPWR VGND sg13cmos5l_decap_8
XFILLER_0_420 VPWR VGND sg13cmos5l_fill_1
XFILLER_0_453 VPWR VGND sg13cmos5l_decap_8
XFILLER_12_582 VPWR VGND sg13cmos5l_decap_8
XFILLER_16_376 VPWR VGND sg13cmos5l_fill_1
XFILLER_16_387 VPWR VGND sg13cmos5l_decap_8
X_596_ _596_/X Tile_X0Y0_N2END[4] Tile_X0Y0_N4END[12] Tile_X0Y0_NN4END[3] _091_/X
+ _277_/Q _276_/Q VPWR VGND sg13cmos5l_mux4_1
XANTENNA_3 Tile_X0Y0_FrameData[0] VPWR VGND sg13cmos5l_antennanp
XFILLER_8_553 VPWR VGND sg13cmos5l_decap_8
XFILLER_6_21 VPWR VGND sg13cmos5l_decap_8
XFILLER_6_1069 VPWR VGND sg13cmos5l_decap_8
XFILLER_1_228 VPWR VGND sg13cmos5l_decap_8
XFILLER_1_239 VPWR VGND sg13cmos5l_fill_2
XFILLER_13_357 VPWR VGND sg13cmos5l_decap_8
XFILLER_15_63 VPWR VGND sg13cmos5l_decap_8
X_381_ Tile_X0Y0_SS4BEG[6] _590_/X VPWR VGND sg13cmos5l_buf_1
X_450_ Tile_X1Y0_FrameData_O[3] Tile_X0Y0_FrameData[3] VPWR VGND sg13cmos5l_buf_1
XFILLER_5_589 VPWR VGND sg13cmos5l_decap_8
XFILLER_5_512 VPWR VGND sg13cmos5l_decap_8
XFILLER_1_751 VPWR VGND sg13cmos5l_decap_8
XFILLER_16_184 VPWR VGND sg13cmos5l_decap_8
X_579_ _579_/X Tile_X0Y0_N2MID[3] Tile_X0Y0_N4END[4] Tile_X0Y0_NN4END[11] _091_/X
+ _311_/Q _310_/Q VPWR VGND sg13cmos5l_mux4_1
XFILLER_11_1030 VPWR VGND sg13cmos5l_fill_2
XFILLER_11_1041 VPWR VGND sg13cmos5l_decap_8
XFILLER_6_309 VPWR VGND sg13cmos5l_decap_8
XANTENNA_201 Tile_X0Y0_FrameData[1] VPWR VGND sg13cmos5l_antennanp
XANTENNA_212 Tile_X0Y0_FrameData[3] VPWR VGND sg13cmos5l_antennanp
XANTENNA_223 Tile_X0Y0_FrameData[3] VPWR VGND sg13cmos5l_antennanp
XANTENNA_234 Tile_X0Y0_FrameData[3] VPWR VGND sg13cmos5l_antennanp
XANTENNA_245 Tile_X0Y0_FrameData[8] VPWR VGND sg13cmos5l_antennanp
XANTENNA_256 Tile_X0Y0_FrameData[8] VPWR VGND sg13cmos5l_antennanp
XANTENNA_267 Tile_X0Y0_FrameData[8] VPWR VGND sg13cmos5l_antennanp
X_433_ Tile_X0Y0_S4BEG[2] _570_/X VPWR VGND sg13cmos5l_buf_1
X_502_ Tile_X1Y0_S1BEG[3] Tile_X1Y0_N1END[0] VPWR VGND sg13cmos5l_buf_1
XANTENNA_278 Tile_X0Y0_FrameData[8] VPWR VGND sg13cmos5l_antennanp
XANTENNA_289 Tile_X0Y0_FrameData[8] VPWR VGND sg13cmos5l_antennanp
XFILLER_13_154 VPWR VGND sg13cmos5l_decap_8
X_295_ _295_/Q Tile_X0Y0_FrameData[26] VGND VPWR Tile_X0Y0_FrameStrobe[1] latch
X_364_ _364_/L_HI VPWR VGND sg13cmos5l_tiehi
XFILLER_9_147 VPWR VGND sg13cmos5l_decap_8
XFILLER_6_832 VPWR VGND sg13cmos5l_decap_8
XFILLER_5_331 VPWR VGND sg13cmos5l_fill_2
XANTENNA__400__X Tile_X0Y0_FrameStrobe_O[9] VPWR VGND sg13cmos5l_antennanp
XFILLER_3_1039 VPWR VGND sg13cmos5l_decap_8
XFILLER_15_408 VPWR VGND sg13cmos5l_decap_8
X_080_ _080_/Y _120_/A _246_/D VPWR VGND sg13cmos5l_nor2_1
XFILLER_7_629 VPWR VGND sg13cmos5l_decap_4
XFILLER_12_53 VPWR VGND sg13cmos5l_decap_8
XFILLER_3_802 VPWR VGND sg13cmos5l_decap_8
XFILLER_14_441 VPWR VGND sg13cmos5l_decap_8
X_416_ Tile_X0Y0_S2BEG[1] Tile_X0Y0_N2MID[6] VPWR VGND sg13cmos5l_buf_1
X_278_ _278_/Q Tile_X0Y0_FrameData[11] VGND VPWR Tile_X0Y0_FrameStrobe[0] latch
X_347_ _347_/Q Tile_X0Y0_FrameData[6] VGND VPWR Tile_X0Y0_FrameStrobe[2] latch
XFILLER_6_640 VPWR VGND sg13cmos5l_decap_8
XANTENNA__114__Y PMOD_IO_O4 VPWR VGND sg13cmos5l_antennanp
XFILLER_2_890 VPWR VGND sg13cmos5l_decap_8
XFILLER_0_816 VPWR VGND sg13cmos5l_fill_2
XFILLER_0_838 VPWR VGND sg13cmos5l_fill_1
XFILLER_0_849 VPWR VGND sg13cmos5l_decap_4
XFILLER_12_923 VPWR VGND sg13cmos5l_fill_1
XFILLER_15_216 VPWR VGND sg13cmos5l_decap_8
XFILLER_16_717 VPWR VGND sg13cmos5l_fill_2
XFILLER_11_444 VPWR VGND sg13cmos5l_decap_8
XFILLER_12_989 VPWR VGND sg13cmos5l_fill_2
X_201_ _201_/Q Tile_X0Y0_FrameData[15] VGND VPWR Tile_X1Y0_FrameStrobe[2] latch
X_132_ _132_/Q Tile_X0Y0_FrameData[20] VGND VPWR Tile_X1Y0_FrameStrobe[0] latch
X_063_ _242_/D PMOD_IO_I7 _559_/X _222_/Q VPWR VGND sg13cmos5l_mux2_1
XFILLER_7_415 VPWR VGND sg13cmos5l_decap_8
XFILLER_3_643 VPWR VGND sg13cmos5l_decap_4
XFILLER_3_0 VPWR VGND sg13cmos5l_decap_8
XFILLER_2_175 VPWR VGND sg13cmos5l_decap_4
XFILLER_0_56 VPWR VGND sg13cmos5l_decap_8
XFILLER_4_1112 VPWR VGND sg13cmos5l_fill_2
XANTENNA__109__Y PMOD_IO_O0 VPWR VGND sg13cmos5l_antennanp
XFILLER_15_761 VPWR VGND sg13cmos5l_fill_2
XFILLER_15_783 VPWR VGND sg13cmos5l_decap_4
XFILLER_9_21 VPWR VGND sg13cmos5l_decap_8
XFILLER_9_98 VPWR VGND sg13cmos5l_decap_8
XFILLER_9_1045 VPWR VGND sg13cmos5l_decap_8
XFILLER_0_646 VPWR VGND sg13cmos5l_decap_8
XFILLER_16_514 VPWR VGND sg13cmos5l_decap_4
XFILLER_15_1028 VPWR VGND sg13cmos5l_decap_8
X_115_ PMOD_IO_O5 _223_/Q _101_/X VPWR VGND sg13cmos5l_nor2b_1
XFILLER_8_735 VPWR VGND sg13cmos5l_decap_8
XFILLER_4_941 VPWR VGND sg13cmos5l_fill_2
XFILLER_4_930 VPWR VGND sg13cmos5l_decap_8
XFILLER_4_996 VPWR VGND sg13cmos5l_decap_8
XFILLER_3_451 VPWR VGND sg13cmos5l_decap_8
XFILLER_13_539 VPWR VGND sg13cmos5l_decap_8
XFILLER_14_1050 VPWR VGND sg13cmos5l_fill_2
XFILLER_14_1083 VPWR VGND sg13cmos5l_decap_8
XFILLER_16_311 VPWR VGND sg13cmos5l_decap_8
XFILLER_16_322 VPWR VGND sg13cmos5l_fill_1
XFILLER_16_333 VPWR VGND sg13cmos5l_decap_8
XFILLER_1_1104 VPWR VGND sg13cmos5l_fill_2
X_595_ _595_/X Tile_X0Y0_N2END[3] Tile_X0Y0_N4END[11] Tile_X0Y0_NN4END[4] _092_/X
+ _279_/Q _278_/Q VPWR VGND sg13cmos5l_mux4_1
XFILLER_12_561 VPWR VGND sg13cmos5l_decap_8
XFILLER_8_532 VPWR VGND sg13cmos5l_decap_8
XANTENNA_4 Tile_X0Y0_FrameData[0] VPWR VGND sg13cmos5l_antennanp
XANTENNA__403__X Tile_X0Y0_FrameStrobe_O[12] VPWR VGND sg13cmos5l_antennanp
XFILLER_6_1048 VPWR VGND sg13cmos5l_decap_8
XFILLER_2_719 VPWR VGND sg13cmos5l_decap_8
XFILLER_13_336 VPWR VGND sg13cmos5l_decap_8
XFILLER_15_42 VPWR VGND sg13cmos5l_decap_8
X_380_ Tile_X0Y0_SS4BEG[5] _589_/X VPWR VGND sg13cmos5l_buf_1
XFILLER_9_307 VPWR VGND sg13cmos5l_decap_8
XFILLER_5_568 VPWR VGND sg13cmos5l_decap_8
XFILLER_16_152 VPWR VGND sg13cmos5l_fill_1
XFILLER_16_163 VPWR VGND sg13cmos5l_decap_8
X_647_ _647_/X Tile_X1Y0_N1END[1] Tile_X1Y0_N2END[3] Tile_X1Y0_N4END[14] Tile_X1Y0_NN4END[14]
+ _122_/Q _221_/Q VPWR VGND sg13cmos5l_mux4_1
X_578_ _578_/X Tile_X0Y0_N2MID[2] Tile_X0Y0_N4END[5] Tile_X0Y0_NN4END[10] _119_/X
+ _313_/Q _312_/Q VPWR VGND sg13cmos5l_mux4_1
XFILLER_5_1081 VPWR VGND sg13cmos5l_decap_8
XANTENNA__117__Y PMOD_IO_O7 VPWR VGND sg13cmos5l_antennanp
XFILLER_13_870 VPWR VGND sg13cmos5l_fill_1
XFILLER_13_892 VPWR VGND sg13cmos5l_fill_2
XFILLER_9_896 VPWR VGND sg13cmos5l_decap_4
.ends
