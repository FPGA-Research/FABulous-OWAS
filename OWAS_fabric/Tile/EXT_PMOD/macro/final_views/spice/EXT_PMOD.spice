* NGSPICE file created from EXT_PMOD.ext - technology: ihp-sg13cmos5l

* Black-box entry subcircuit for sg13cmos5l_decap_8 abstract view
.subckt sg13cmos5l_decap_8 VDD VSS
.ends

* Black-box entry subcircuit for sg13cmos5l_antennanp abstract view
.subckt sg13cmos5l_antennanp A VDD VSS
.ends

* Black-box entry subcircuit for sg13cmos5l_fill_2 abstract view
.subckt sg13cmos5l_fill_2 VDD VSS
.ends

* Black-box entry subcircuit for sg13cmos5l_buf_1 abstract view
.subckt sg13cmos5l_buf_1 X A VDD VSS
.ends

* Black-box entry subcircuit for latch abstract view
.subckt latch Q D VSS VDD GATE
.ends

* Black-box entry subcircuit for sg13cmos5l_tiehi abstract view
.subckt sg13cmos5l_tiehi L_HI VDD VSS
.ends

* Black-box entry subcircuit for sg13cmos5l_fill_1 abstract view
.subckt sg13cmos5l_fill_1 VDD VSS
.ends

* Black-box entry subcircuit for sg13cmos5l_decap_4 abstract view
.subckt sg13cmos5l_decap_4 VDD VSS
.ends

* Black-box entry subcircuit for sg13cmos5l_mux2_1 abstract view
.subckt sg13cmos5l_mux2_1 X A0 A1 S VDD VSS
.ends

* Black-box entry subcircuit for sg13cmos5l_nor2b_1 abstract view
.subckt sg13cmos5l_nor2b_1 Y A B_N VDD VSS
.ends

* Black-box entry subcircuit for sg13cmos5l_mux4_1 abstract view
.subckt sg13cmos5l_mux4_1 X A0 A1 A2 A3 S0 S1 VDD VSS
.ends

* Black-box entry subcircuit for sg13cmos5l_inv_1 abstract view
.subckt sg13cmos5l_inv_1 Y A VDD VSS
.ends

* Black-box entry subcircuit for sg13cmos5l_dfrbpq_1 abstract view
.subckt sg13cmos5l_dfrbpq_1 Q CLK D RESET_B VDD VSS
.ends

* Black-box entry subcircuit for sg13cmos5l_o21ai_1 abstract view
.subckt sg13cmos5l_o21ai_1 Y A1 A2 B1 VDD VSS
.ends

* Black-box entry subcircuit for sg13cmos5l_or2_1 abstract view
.subckt sg13cmos5l_or2_1 X A B VDD VSS
.ends

* Black-box entry subcircuit for sg13cmos5l_a21oi_1 abstract view
.subckt sg13cmos5l_a21oi_1 Y A1 A2 B1 VDD VSS
.ends

* Black-box entry subcircuit for sg13cmos5l_a221oi_1 abstract view
.subckt sg13cmos5l_a221oi_1 Y A1 A2 B1 B2 C1 VDD VSS
.ends

* Black-box entry subcircuit for sg13cmos5l_nor2_1 abstract view
.subckt sg13cmos5l_nor2_1 Y A B VDD VSS
.ends

.subckt EXT_PMOD PMOD_IO_I0 PMOD_IO_I1 PMOD_IO_I2 PMOD_IO_I3 PMOD_IO_I4 PMOD_IO_I5
+ PMOD_IO_I6 PMOD_IO_I7 PMOD_IO_O0 PMOD_IO_O1 PMOD_IO_O2 PMOD_IO_O3 PMOD_IO_O4 PMOD_IO_O5
+ PMOD_IO_O6 PMOD_IO_O7 PMOD_IO_OE_O0 PMOD_IO_OE_O1 PMOD_IO_OE_O2 PMOD_IO_OE_O3 PMOD_IO_OE_O4
+ PMOD_IO_OE_O5 PMOD_IO_OE_O6 PMOD_IO_OE_O7 Tile_X0Y0_Ci Tile_X0Y0_FrameData[0] Tile_X0Y0_FrameData[10]
+ Tile_X0Y0_FrameData[11] Tile_X0Y0_FrameData[12] Tile_X0Y0_FrameData[13] Tile_X0Y0_FrameData[14]
+ Tile_X0Y0_FrameData[15] Tile_X0Y0_FrameData[16] Tile_X0Y0_FrameData[17] Tile_X0Y0_FrameData[18]
+ Tile_X0Y0_FrameData[19] Tile_X0Y0_FrameData[1] Tile_X0Y0_FrameData[20] Tile_X0Y0_FrameData[21]
+ Tile_X0Y0_FrameData[22] Tile_X0Y0_FrameData[23] Tile_X0Y0_FrameData[24] Tile_X0Y0_FrameData[25]
+ Tile_X0Y0_FrameData[26] Tile_X0Y0_FrameData[27] Tile_X0Y0_FrameData[28] Tile_X0Y0_FrameData[29]
+ Tile_X0Y0_FrameData[2] Tile_X0Y0_FrameData[30] Tile_X0Y0_FrameData[31] Tile_X0Y0_FrameData[3]
+ Tile_X0Y0_FrameData[4] Tile_X0Y0_FrameData[5] Tile_X0Y0_FrameData[6] Tile_X0Y0_FrameData[7]
+ Tile_X0Y0_FrameData[8] Tile_X0Y0_FrameData[9] Tile_X0Y0_FrameStrobe[0] Tile_X0Y0_FrameStrobe[10]
+ Tile_X0Y0_FrameStrobe[11] Tile_X0Y0_FrameStrobe[12] Tile_X0Y0_FrameStrobe[13] Tile_X0Y0_FrameStrobe[14]
+ Tile_X0Y0_FrameStrobe[15] Tile_X0Y0_FrameStrobe[16] Tile_X0Y0_FrameStrobe[17] Tile_X0Y0_FrameStrobe[18]
+ Tile_X0Y0_FrameStrobe[19] Tile_X0Y0_FrameStrobe[1] Tile_X0Y0_FrameStrobe[2] Tile_X0Y0_FrameStrobe[3]
+ Tile_X0Y0_FrameStrobe[4] Tile_X0Y0_FrameStrobe[5] Tile_X0Y0_FrameStrobe[6] Tile_X0Y0_FrameStrobe[7]
+ Tile_X0Y0_FrameStrobe[8] Tile_X0Y0_FrameStrobe[9] Tile_X0Y0_FrameStrobe_O[0] Tile_X0Y0_FrameStrobe_O[10]
+ Tile_X0Y0_FrameStrobe_O[11] Tile_X0Y0_FrameStrobe_O[12] Tile_X0Y0_FrameStrobe_O[13]
+ Tile_X0Y0_FrameStrobe_O[14] Tile_X0Y0_FrameStrobe_O[15] Tile_X0Y0_FrameStrobe_O[16]
+ Tile_X0Y0_FrameStrobe_O[17] Tile_X0Y0_FrameStrobe_O[18] Tile_X0Y0_FrameStrobe_O[19]
+ Tile_X0Y0_FrameStrobe_O[1] Tile_X0Y0_FrameStrobe_O[2] Tile_X0Y0_FrameStrobe_O[3]
+ Tile_X0Y0_FrameStrobe_O[4] Tile_X0Y0_FrameStrobe_O[5] Tile_X0Y0_FrameStrobe_O[6]
+ Tile_X0Y0_FrameStrobe_O[7] Tile_X0Y0_FrameStrobe_O[8] Tile_X0Y0_FrameStrobe_O[9]
+ Tile_X0Y0_N1END[0] Tile_X0Y0_N1END[1] Tile_X0Y0_N1END[2] Tile_X0Y0_N1END[3] Tile_X0Y0_N2END[0]
+ Tile_X0Y0_N2END[1] Tile_X0Y0_N2END[2] Tile_X0Y0_N2END[3] Tile_X0Y0_N2END[4] Tile_X0Y0_N2END[5]
+ Tile_X0Y0_N2END[6] Tile_X0Y0_N2END[7] Tile_X0Y0_N2MID[0] Tile_X0Y0_N2MID[1] Tile_X0Y0_N2MID[2]
+ Tile_X0Y0_N2MID[3] Tile_X0Y0_N2MID[4] Tile_X0Y0_N2MID[5] Tile_X0Y0_N2MID[6] Tile_X0Y0_N2MID[7]
+ Tile_X0Y0_N4END[0] Tile_X0Y0_N4END[10] Tile_X0Y0_N4END[11] Tile_X0Y0_N4END[12] Tile_X0Y0_N4END[13]
+ Tile_X0Y0_N4END[14] Tile_X0Y0_N4END[15] Tile_X0Y0_N4END[1] Tile_X0Y0_N4END[2] Tile_X0Y0_N4END[3]
+ Tile_X0Y0_N4END[4] Tile_X0Y0_N4END[5] Tile_X0Y0_N4END[6] Tile_X0Y0_N4END[7] Tile_X0Y0_N4END[8]
+ Tile_X0Y0_N4END[9] Tile_X0Y0_NN4END[0] Tile_X0Y0_NN4END[10] Tile_X0Y0_NN4END[11]
+ Tile_X0Y0_NN4END[12] Tile_X0Y0_NN4END[13] Tile_X0Y0_NN4END[14] Tile_X0Y0_NN4END[15]
+ Tile_X0Y0_NN4END[1] Tile_X0Y0_NN4END[2] Tile_X0Y0_NN4END[3] Tile_X0Y0_NN4END[4]
+ Tile_X0Y0_NN4END[5] Tile_X0Y0_NN4END[6] Tile_X0Y0_NN4END[7] Tile_X0Y0_NN4END[8]
+ Tile_X0Y0_NN4END[9] Tile_X0Y0_S1BEG[0] Tile_X0Y0_S1BEG[1] Tile_X0Y0_S1BEG[2] Tile_X0Y0_S1BEG[3]
+ Tile_X0Y0_S2BEG[0] Tile_X0Y0_S2BEG[1] Tile_X0Y0_S2BEG[2] Tile_X0Y0_S2BEG[3] Tile_X0Y0_S2BEG[4]
+ Tile_X0Y0_S2BEG[5] Tile_X0Y0_S2BEG[6] Tile_X0Y0_S2BEG[7] Tile_X0Y0_S2BEGb[0] Tile_X0Y0_S2BEGb[1]
+ Tile_X0Y0_S2BEGb[2] Tile_X0Y0_S2BEGb[3] Tile_X0Y0_S2BEGb[4] Tile_X0Y0_S2BEGb[5]
+ Tile_X0Y0_S2BEGb[6] Tile_X0Y0_S2BEGb[7] Tile_X0Y0_S4BEG[0] Tile_X0Y0_S4BEG[10] Tile_X0Y0_S4BEG[11]
+ Tile_X0Y0_S4BEG[12] Tile_X0Y0_S4BEG[13] Tile_X0Y0_S4BEG[14] Tile_X0Y0_S4BEG[15]
+ Tile_X0Y0_S4BEG[1] Tile_X0Y0_S4BEG[2] Tile_X0Y0_S4BEG[3] Tile_X0Y0_S4BEG[4] Tile_X0Y0_S4BEG[5]
+ Tile_X0Y0_S4BEG[6] Tile_X0Y0_S4BEG[7] Tile_X0Y0_S4BEG[8] Tile_X0Y0_S4BEG[9] Tile_X0Y0_SS4BEG[0]
+ Tile_X0Y0_SS4BEG[10] Tile_X0Y0_SS4BEG[11] Tile_X0Y0_SS4BEG[12] Tile_X0Y0_SS4BEG[13]
+ Tile_X0Y0_SS4BEG[14] Tile_X0Y0_SS4BEG[15] Tile_X0Y0_SS4BEG[1] Tile_X0Y0_SS4BEG[2]
+ Tile_X0Y0_SS4BEG[3] Tile_X0Y0_SS4BEG[4] Tile_X0Y0_SS4BEG[5] Tile_X0Y0_SS4BEG[6]
+ Tile_X0Y0_SS4BEG[7] Tile_X0Y0_SS4BEG[8] Tile_X0Y0_SS4BEG[9] Tile_X0Y0_UserCLK Tile_X1Y0_Ci
+ Tile_X1Y0_FrameData_O[0] Tile_X1Y0_FrameData_O[10] Tile_X1Y0_FrameData_O[11] Tile_X1Y0_FrameData_O[12]
+ Tile_X1Y0_FrameData_O[13] Tile_X1Y0_FrameData_O[14] Tile_X1Y0_FrameData_O[15] Tile_X1Y0_FrameData_O[16]
+ Tile_X1Y0_FrameData_O[17] Tile_X1Y0_FrameData_O[18] Tile_X1Y0_FrameData_O[19] Tile_X1Y0_FrameData_O[1]
+ Tile_X1Y0_FrameData_O[20] Tile_X1Y0_FrameData_O[21] Tile_X1Y0_FrameData_O[22] Tile_X1Y0_FrameData_O[23]
+ Tile_X1Y0_FrameData_O[24] Tile_X1Y0_FrameData_O[25] Tile_X1Y0_FrameData_O[26] Tile_X1Y0_FrameData_O[27]
+ Tile_X1Y0_FrameData_O[28] Tile_X1Y0_FrameData_O[29] Tile_X1Y0_FrameData_O[2] Tile_X1Y0_FrameData_O[30]
+ Tile_X1Y0_FrameData_O[31] Tile_X1Y0_FrameData_O[3] Tile_X1Y0_FrameData_O[4] Tile_X1Y0_FrameData_O[5]
+ Tile_X1Y0_FrameData_O[6] Tile_X1Y0_FrameData_O[7] Tile_X1Y0_FrameData_O[8] Tile_X1Y0_FrameData_O[9]
+ Tile_X1Y0_FrameStrobe[0] Tile_X1Y0_FrameStrobe[10] Tile_X1Y0_FrameStrobe[11] Tile_X1Y0_FrameStrobe[12]
+ Tile_X1Y0_FrameStrobe[13] Tile_X1Y0_FrameStrobe[14] Tile_X1Y0_FrameStrobe[15] Tile_X1Y0_FrameStrobe[16]
+ Tile_X1Y0_FrameStrobe[17] Tile_X1Y0_FrameStrobe[18] Tile_X1Y0_FrameStrobe[19] Tile_X1Y0_FrameStrobe[1]
+ Tile_X1Y0_FrameStrobe[2] Tile_X1Y0_FrameStrobe[3] Tile_X1Y0_FrameStrobe[4] Tile_X1Y0_FrameStrobe[5]
+ Tile_X1Y0_FrameStrobe[6] Tile_X1Y0_FrameStrobe[7] Tile_X1Y0_FrameStrobe[8] Tile_X1Y0_FrameStrobe[9]
+ Tile_X1Y0_FrameStrobe_O[0] Tile_X1Y0_FrameStrobe_O[10] Tile_X1Y0_FrameStrobe_O[11]
+ Tile_X1Y0_FrameStrobe_O[12] Tile_X1Y0_FrameStrobe_O[13] Tile_X1Y0_FrameStrobe_O[14]
+ Tile_X1Y0_FrameStrobe_O[15] Tile_X1Y0_FrameStrobe_O[16] Tile_X1Y0_FrameStrobe_O[17]
+ Tile_X1Y0_FrameStrobe_O[18] Tile_X1Y0_FrameStrobe_O[19] Tile_X1Y0_FrameStrobe_O[1]
+ Tile_X1Y0_FrameStrobe_O[2] Tile_X1Y0_FrameStrobe_O[3] Tile_X1Y0_FrameStrobe_O[4]
+ Tile_X1Y0_FrameStrobe_O[5] Tile_X1Y0_FrameStrobe_O[6] Tile_X1Y0_FrameStrobe_O[7]
+ Tile_X1Y0_FrameStrobe_O[8] Tile_X1Y0_FrameStrobe_O[9] Tile_X1Y0_N1END[0] Tile_X1Y0_N1END[1]
+ Tile_X1Y0_N1END[2] Tile_X1Y0_N1END[3] Tile_X1Y0_N2END[0] Tile_X1Y0_N2END[1] Tile_X1Y0_N2END[2]
+ Tile_X1Y0_N2END[3] Tile_X1Y0_N2END[4] Tile_X1Y0_N2END[5] Tile_X1Y0_N2END[6] Tile_X1Y0_N2END[7]
+ Tile_X1Y0_N2MID[0] Tile_X1Y0_N2MID[1] Tile_X1Y0_N2MID[2] Tile_X1Y0_N2MID[3] Tile_X1Y0_N2MID[4]
+ Tile_X1Y0_N2MID[5] Tile_X1Y0_N2MID[6] Tile_X1Y0_N2MID[7] Tile_X1Y0_N4END[0] Tile_X1Y0_N4END[10]
+ Tile_X1Y0_N4END[11] Tile_X1Y0_N4END[12] Tile_X1Y0_N4END[13] Tile_X1Y0_N4END[14]
+ Tile_X1Y0_N4END[15] Tile_X1Y0_N4END[1] Tile_X1Y0_N4END[2] Tile_X1Y0_N4END[3] Tile_X1Y0_N4END[4]
+ Tile_X1Y0_N4END[5] Tile_X1Y0_N4END[6] Tile_X1Y0_N4END[7] Tile_X1Y0_N4END[8] Tile_X1Y0_N4END[9]
+ Tile_X1Y0_NN4END[0] Tile_X1Y0_NN4END[10] Tile_X1Y0_NN4END[11] Tile_X1Y0_NN4END[12]
+ Tile_X1Y0_NN4END[13] Tile_X1Y0_NN4END[14] Tile_X1Y0_NN4END[15] Tile_X1Y0_NN4END[1]
+ Tile_X1Y0_NN4END[2] Tile_X1Y0_NN4END[3] Tile_X1Y0_NN4END[4] Tile_X1Y0_NN4END[5]
+ Tile_X1Y0_NN4END[6] Tile_X1Y0_NN4END[7] Tile_X1Y0_NN4END[8] Tile_X1Y0_NN4END[9]
+ Tile_X1Y0_S1BEG[0] Tile_X1Y0_S1BEG[1] Tile_X1Y0_S1BEG[2] Tile_X1Y0_S1BEG[3] Tile_X1Y0_S2BEG[0]
+ Tile_X1Y0_S2BEG[1] Tile_X1Y0_S2BEG[2] Tile_X1Y0_S2BEG[3] Tile_X1Y0_S2BEG[4] Tile_X1Y0_S2BEG[5]
+ Tile_X1Y0_S2BEG[6] Tile_X1Y0_S2BEG[7] Tile_X1Y0_S2BEGb[0] Tile_X1Y0_S2BEGb[1] Tile_X1Y0_S2BEGb[2]
+ Tile_X1Y0_S2BEGb[3] Tile_X1Y0_S2BEGb[4] Tile_X1Y0_S2BEGb[5] Tile_X1Y0_S2BEGb[6]
+ Tile_X1Y0_S2BEGb[7] Tile_X1Y0_S4BEG[0] Tile_X1Y0_S4BEG[10] Tile_X1Y0_S4BEG[11] Tile_X1Y0_S4BEG[12]
+ Tile_X1Y0_S4BEG[13] Tile_X1Y0_S4BEG[14] Tile_X1Y0_S4BEG[15] Tile_X1Y0_S4BEG[1] Tile_X1Y0_S4BEG[2]
+ Tile_X1Y0_S4BEG[3] Tile_X1Y0_S4BEG[4] Tile_X1Y0_S4BEG[5] Tile_X1Y0_S4BEG[6] Tile_X1Y0_S4BEG[7]
+ Tile_X1Y0_S4BEG[8] Tile_X1Y0_S4BEG[9] Tile_X1Y0_SS4BEG[0] Tile_X1Y0_SS4BEG[10] Tile_X1Y0_SS4BEG[11]
+ Tile_X1Y0_SS4BEG[12] Tile_X1Y0_SS4BEG[13] Tile_X1Y0_SS4BEG[14] Tile_X1Y0_SS4BEG[15]
+ Tile_X1Y0_SS4BEG[1] Tile_X1Y0_SS4BEG[2] Tile_X1Y0_SS4BEG[3] Tile_X1Y0_SS4BEG[4]
+ Tile_X1Y0_SS4BEG[5] Tile_X1Y0_SS4BEG[6] Tile_X1Y0_SS4BEG[7] Tile_X1Y0_SS4BEG[8]
+ Tile_X1Y0_SS4BEG[9] Tile_X1Y0_UserCLKo VGND VPWR
XFILLER_7_7 VPWR VGND sg13cmos5l_decap_8
XANTENNA_202 Tile_X0Y0_FrameData[3] VPWR VGND sg13cmos5l_antennanp
XANTENNA_213 Tile_X0Y0_FrameData[3] VPWR VGND sg13cmos5l_antennanp
XANTENNA_224 Tile_X0Y0_FrameData[3] VPWR VGND sg13cmos5l_antennanp
XANTENNA_235 Tile_X0Y0_FrameData[3] VPWR VGND sg13cmos5l_antennanp
XANTENNA_246 Tile_X0Y0_FrameData[5] VPWR VGND sg13cmos5l_antennanp
XANTENNA_257 Tile_X0Y0_FrameData[5] VPWR VGND sg13cmos5l_antennanp
XANTENNA_268 Tile_X0Y0_FrameData[5] VPWR VGND sg13cmos5l_antennanp
XANTENNA_279 Tile_X0Y0_FrameData[5] VPWR VGND sg13cmos5l_antennanp
XFILLER_13_133 VPWR VGND sg13cmos5l_decap_8
XFILLER_14_623 VPWR VGND sg13cmos5l_fill_2
XFILLER_14_656 VPWR VGND sg13cmos5l_fill_2
X_432_ Tile_X0Y0_S4BEG[1] _569_/X VPWR VGND sg13cmos5l_buf_1
X_501_ Tile_X1Y0_S1BEG[2] Tile_X1Y0_N1END[1] VPWR VGND sg13cmos5l_buf_1
X_294_ _294_/Q Tile_X0Y0_FrameData[27] VGND VPWR Tile_X0Y0_FrameStrobe[1] latch
X_363_ _363_/L_HI VPWR VGND sg13cmos5l_tiehi
XFILLER_3_45 VPWR VGND sg13cmos5l_decap_8
XFILLER_3_23 VPWR VGND sg13cmos5l_fill_1
XFILLER_17_483 VPWR VGND sg13cmos5l_decap_8
XFILLER_10_103 VPWR VGND sg13cmos5l_decap_8
XFILLER_12_21 VPWR VGND sg13cmos5l_decap_8
XANTENNA__501__X Tile_X1Y0_S1BEG[2] VPWR VGND sg13cmos5l_antennanp
XFILLER_12_65 VPWR VGND sg13cmos5l_decap_8
XFILLER_3_869 VPWR VGND sg13cmos5l_decap_8
XFILLER_2_368 VPWR VGND sg13cmos5l_fill_2
XFILLER_2_357 VPWR VGND sg13cmos5l_fill_1
XFILLER_18_247 VPWR VGND sg13cmos5l_decap_4
XFILLER_14_420 VPWR VGND sg13cmos5l_decap_8
XFILLER_14_497 VPWR VGND sg13cmos5l_decap_8
X_346_ _346_/Q Tile_X0Y0_FrameData[7] VGND VPWR Tile_X0Y0_FrameStrobe[2] latch
X_415_ Tile_X0Y0_S2BEG[0] Tile_X0Y0_N2MID[7] VPWR VGND sg13cmos5l_buf_1
X_277_ _277_/Q Tile_X0Y0_FrameData[12] VGND VPWR Tile_X0Y0_FrameStrobe[0] latch
XFILLER_5_151 VPWR VGND sg13cmos5l_decap_8
XANTENNA__411__X Tile_X0Y0_S1BEG[0] VPWR VGND sg13cmos5l_antennanp
XFILLER_17_280 VPWR VGND sg13cmos5l_decap_8
XFILLER_11_401 VPWR VGND sg13cmos5l_decap_8
XFILLER_15_217 VPWR VGND sg13cmos5l_decap_8
X_200_ _200_/Q Tile_X0Y0_FrameData[16] VGND VPWR Tile_X1Y0_FrameStrobe[2] latch
XFILLER_11_478 VPWR VGND sg13cmos5l_decap_8
X_131_ _131_/Q Tile_X0Y0_FrameData[21] VGND VPWR Tile_X1Y0_FrameStrobe[0] latch
X_062_ _245_/D _642_/X _229_/Q _232_/Q VPWR VGND sg13cmos5l_mux2_1
XFILLER_8_917 VPWR VGND sg13cmos5l_decap_8
XFILLER_7_427 VPWR VGND sg13cmos5l_decap_8
XFILLER_3_688 VPWR VGND sg13cmos5l_decap_8
XFILLER_3_622 VPWR VGND sg13cmos5l_decap_8
XFILLER_0_35 VPWR VGND sg13cmos5l_fill_1
XFILLER_0_46 VPWR VGND sg13cmos5l_fill_2
XFILLER_0_68 VPWR VGND sg13cmos5l_fill_2
XFILLER_0_79 VPWR VGND sg13cmos5l_decap_8
XANTENNA__406__X Tile_X0Y0_FrameStrobe_O[15] VPWR VGND sg13cmos5l_antennanp
XFILLER_14_294 VPWR VGND sg13cmos5l_decap_8
X_329_ _329_/Q Tile_X0Y0_FrameData[24] VGND VPWR Tile_X0Y0_FrameStrobe[2] latch
XFILLER_6_460 VPWR VGND sg13cmos5l_decap_8
XFILLER_5_909 VPWR VGND sg13cmos5l_decap_8
XFILLER_16_504 VPWR VGND sg13cmos5l_decap_8
XFILLER_18_42 VPWR VGND sg13cmos5l_decap_8
XFILLER_11_275 VPWR VGND sg13cmos5l_decap_8
XFILLER_8_736 VPWR VGND sg13cmos5l_decap_8
X_114_ PMOD_IO_O4 _223_/Q _074_/X VPWR VGND sg13cmos5l_nor2b_1
XFILLER_3_452 VPWR VGND sg13cmos5l_decap_8
XFILLER_15_581 VPWR VGND sg13cmos5l_decap_8
XFILLER_13_518 VPWR VGND sg13cmos5l_fill_2
XFILLER_4_216 VPWR VGND sg13cmos5l_decap_8
XFILLER_0_499 VPWR VGND sg13cmos5l_fill_2
XFILLER_16_301 VPWR VGND sg13cmos5l_decap_8
XFILLER_16_378 VPWR VGND sg13cmos5l_decap_8
X_594_ _594_/X Tile_X0Y0_N2END[2] Tile_X0Y0_N4END[10] Tile_X0Y0_NN4END[5] _119_/X
+ _281_/Q _280_/Q VPWR VGND sg13cmos5l_mux4_1
XFILLER_12_562 VPWR VGND sg13cmos5l_decap_8
XANTENNA_5 Tile_X0Y0_FrameData[16] VPWR VGND sg13cmos5l_antennanp
XFILLER_6_89 VPWR VGND sg13cmos5l_fill_2
XFILLER_6_67 VPWR VGND sg13cmos5l_fill_1
XFILLER_3_282 VPWR VGND sg13cmos5l_fill_2
XFILLER_13_315 VPWR VGND sg13cmos5l_decap_8
XFILLER_15_21 VPWR VGND sg13cmos5l_decap_8
XFILLER_15_98 VPWR VGND sg13cmos5l_decap_8
XFILLER_9_308 VPWR VGND sg13cmos5l_decap_4
XFILLER_5_503 VPWR VGND sg13cmos5l_decap_8
XANTENNA__504__X Tile_X1Y0_S2BEG[1] VPWR VGND sg13cmos5l_antennanp
XFILLER_0_230 VPWR VGND sg13cmos5l_decap_8
XFILLER_5_569 VPWR VGND sg13cmos5l_decap_4
XFILLER_1_742 VPWR VGND sg13cmos5l_decap_8
XFILLER_16_175 VPWR VGND sg13cmos5l_decap_8
XFILLER_17_665 VPWR VGND sg13cmos5l_fill_2
X_646_ _646_/X Tile_X1Y0_N2MID[7] Tile_X1Y0_N2END[0] Tile_X1Y0_N4END[15] Tile_X1Y0_NN4END[15]
+ _126_/Q _125_/Q VPWR VGND sg13cmos5l_mux4_1
X_577_ _577_/X Tile_X0Y0_N2MID[1] Tile_X0Y0_N4END[6] Tile_X0Y0_NN4END[9] _092_/X _315_/Q
+ _314_/Q VPWR VGND sg13cmos5l_mux4_1
XANTENNA__414__X Tile_X0Y0_S1BEG[3] VPWR VGND sg13cmos5l_antennanp
XFILLER_9_875 VPWR VGND sg13cmos5l_decap_8
XFILLER_11_0 VPWR VGND sg13cmos5l_decap_8
X_500_ Tile_X1Y0_S1BEG[1] Tile_X1Y0_N1END[2] VPWR VGND sg13cmos5l_buf_1
XANTENNA_203 Tile_X0Y0_FrameData[3] VPWR VGND sg13cmos5l_antennanp
XANTENNA_214 Tile_X0Y0_FrameData[3] VPWR VGND sg13cmos5l_antennanp
XANTENNA_225 Tile_X0Y0_FrameData[3] VPWR VGND sg13cmos5l_antennanp
XANTENNA_236 Tile_X0Y0_FrameData[3] VPWR VGND sg13cmos5l_antennanp
XANTENNA_247 Tile_X0Y0_FrameData[5] VPWR VGND sg13cmos5l_antennanp
XANTENNA_258 Tile_X0Y0_FrameData[5] VPWR VGND sg13cmos5l_antennanp
XANTENNA_269 Tile_X0Y0_FrameData[5] VPWR VGND sg13cmos5l_antennanp
XFILLER_13_112 VPWR VGND sg13cmos5l_decap_8
XFILLER_14_602 VPWR VGND sg13cmos5l_decap_8
X_362_ _362_/L_HI VPWR VGND sg13cmos5l_tiehi
X_431_ Tile_X0Y0_S4BEG[0] _568_/X VPWR VGND sg13cmos5l_buf_1
XFILLER_10_885 VPWR VGND sg13cmos5l_decap_8
XFILLER_13_189 VPWR VGND sg13cmos5l_decap_8
X_293_ _293_/Q Tile_X0Y0_FrameData[28] VGND VPWR Tile_X0Y0_FrameStrobe[1] latch
XFILLER_9_138 VPWR VGND sg13cmos5l_decap_8
XFILLER_6_845 VPWR VGND sg13cmos5l_decap_8
XFILLER_5_333 VPWR VGND sg13cmos5l_decap_8
XFILLER_3_68 VPWR VGND sg13cmos5l_fill_2
XFILLER_3_57 VPWR VGND sg13cmos5l_decap_8
XANTENNA__409__X Tile_X0Y0_FrameStrobe_O[18] VPWR VGND sg13cmos5l_antennanp
XFILLER_17_462 VPWR VGND sg13cmos5l_decap_8
X_629_ _629_/X Tile_X1Y0_N2END[5] Tile_X1Y0_N4END[5] Tile_X1Y0_NN4END[10] _064_/X
+ _162_/Q _161_/Q VPWR VGND sg13cmos5l_mux4_1
XFILLER_10_159 VPWR VGND sg13cmos5l_decap_8
XFILLER_6_119 VPWR VGND sg13cmos5l_decap_4
XFILLER_2_347 VPWR VGND sg13cmos5l_fill_2
XFILLER_15_922 VPWR VGND sg13cmos5l_decap_8
XFILLER_14_476 VPWR VGND sg13cmos5l_decap_8
X_276_ _276_/Q Tile_X0Y0_FrameData[13] VGND VPWR Tile_X0Y0_FrameStrobe[0] latch
X_345_ _345_/Q Tile_X0Y0_FrameData[8] VGND VPWR Tile_X0Y0_FrameStrobe[2] latch
X_414_ Tile_X0Y0_S1BEG[3] Tile_X0Y0_N1END[0] VPWR VGND sg13cmos5l_buf_1
XFILLER_10_693 VPWR VGND sg13cmos5l_decap_8
XFILLER_6_686 VPWR VGND sg13cmos5l_decap_8
XFILLER_5_196 VPWR VGND sg13cmos5l_fill_1
XFILLER_0_807 VPWR VGND sg13cmos5l_decap_8
XFILLER_11_457 VPWR VGND sg13cmos5l_decap_8
XFILLER_12_936 VPWR VGND sg13cmos5l_decap_4
XFILLER_12_958 VPWR VGND sg13cmos5l_fill_2
X_130_ _130_/Q Tile_X0Y0_FrameData[22] VGND VPWR Tile_X1Y0_FrameStrobe[0] latch
XFILLER_7_406 VPWR VGND sg13cmos5l_decap_8
XANTENNA__512__X Tile_X1Y0_S2BEGb[1] VPWR VGND sg13cmos5l_antennanp
X_061_ _061_/Y _244_/Q VPWR VGND sg13cmos5l_inv_1
XFILLER_2_122 VPWR VGND sg13cmos5l_decap_8
XFILLER_2_177 VPWR VGND sg13cmos5l_fill_2
XFILLER_15_752 VPWR VGND sg13cmos5l_fill_2
XFILLER_14_273 VPWR VGND sg13cmos5l_decap_8
X_328_ _328_/Q Tile_X0Y0_FrameData[25] VGND VPWR Tile_X0Y0_FrameStrobe[2] latch
X_259_ _259_/Q Tile_X0Y0_FrameData[30] VGND VPWR Tile_X0Y0_FrameStrobe[0] latch
XFILLER_9_89 VPWR VGND sg13cmos5l_decap_8
XFILLER_9_56 VPWR VGND sg13cmos5l_decap_8
XANTENNA__422__X Tile_X0Y0_S2BEG[7] VPWR VGND sg13cmos5l_antennanp
XFILLER_0_659 VPWR VGND sg13cmos5l_decap_4
XFILLER_18_21 VPWR VGND sg13cmos5l_decap_8
XANTENNA__507__X Tile_X1Y0_S2BEG[4] VPWR VGND sg13cmos5l_antennanp
XFILLER_11_254 VPWR VGND sg13cmos5l_decap_8
X_113_ PMOD_IO_O3 _223_/Q _081_/X VPWR VGND sg13cmos5l_nor2b_1
XFILLER_7_247 VPWR VGND sg13cmos5l_fill_1
XFILLER_7_214 VPWR VGND sg13cmos5l_decap_4
XFILLER_7_258 VPWR VGND sg13cmos5l_decap_4
XFILLER_3_431 VPWR VGND sg13cmos5l_decap_8
XFILLER_15_7 VPWR VGND sg13cmos5l_decap_8
XANTENNA__417__X Tile_X0Y0_S2BEG[2] VPWR VGND sg13cmos5l_antennanp
XFILLER_15_560 VPWR VGND sg13cmos5l_decap_8
XFILLER_7_781 VPWR VGND sg13cmos5l_fill_2
XFILLER_1_913 VPWR VGND sg13cmos5l_fill_1
XFILLER_1_902 VPWR VGND sg13cmos5l_decap_8
XFILLER_1_946 VPWR VGND sg13cmos5l_fill_2
XFILLER_16_357 VPWR VGND sg13cmos5l_decap_8
X_593_ _593_/X Tile_X0Y0_N2END[1] Tile_X0Y0_N4END[9] Tile_X0Y0_NN4END[6] _091_/X _283_/Q
+ _282_/Q VPWR VGND sg13cmos5l_mux4_1
XANTENNA_6 Tile_X0Y0_FrameData[16] VPWR VGND sg13cmos5l_antennanp
XFILLER_12_541 VPWR VGND sg13cmos5l_decap_8
XFILLER_8_578 VPWR VGND sg13cmos5l_decap_8
XFILLER_6_57 VPWR VGND sg13cmos5l_fill_1
XFILLER_6_79 VPWR VGND sg13cmos5l_fill_2
XFILLER_16_880 VPWR VGND sg13cmos5l_decap_8
XFILLER_15_77 VPWR VGND sg13cmos5l_decap_8
XANTENNA__520__X Tile_X1Y0_S4BEG[1] VPWR VGND sg13cmos5l_antennanp
XFILLER_1_765 VPWR VGND sg13cmos5l_decap_8
XFILLER_1_721 VPWR VGND sg13cmos5l_decap_8
XFILLER_1_710 VPWR VGND sg13cmos5l_fill_1
XFILLER_0_286 VPWR VGND sg13cmos5l_decap_8
XFILLER_17_644 VPWR VGND sg13cmos5l_decap_8
X_645_ _645_/X Tile_X1Y0_N2MID[5] Tile_X1Y0_N2END[2] Tile_X1Y0_N4END[13] Tile_X1Y0_NN4END[13]
+ _130_/Q _129_/Q VPWR VGND sg13cmos5l_mux4_1
XFILLER_1_798 VPWR VGND sg13cmos5l_decap_8
XFILLER_13_883 VPWR VGND sg13cmos5l_decap_8
XFILLER_16_154 VPWR VGND sg13cmos5l_decap_8
X_576_ _576_/X Tile_X0Y0_N2MID[0] Tile_X0Y0_N4END[7] Tile_X0Y0_NN4END[8] _091_/X _317_/Q
+ _316_/Q VPWR VGND sg13cmos5l_mux4_1
XFILLER_9_854 VPWR VGND sg13cmos5l_decap_8
XFILLER_9_810 VPWR VGND sg13cmos5l_decap_8
XANTENNA__430__X Tile_X0Y0_S2BEGb[7] VPWR VGND sg13cmos5l_antennanp
XFILLER_11_809 VPWR VGND sg13cmos5l_decap_8
XANTENNA_204 Tile_X0Y0_FrameData[3] VPWR VGND sg13cmos5l_antennanp
XANTENNA_215 Tile_X0Y0_FrameData[3] VPWR VGND sg13cmos5l_antennanp
XFILLER_18_408 VPWR VGND sg13cmos5l_decap_8
XANTENNA_226 Tile_X0Y0_FrameData[3] VPWR VGND sg13cmos5l_antennanp
XANTENNA_237 Tile_X0Y0_FrameData[5] VPWR VGND sg13cmos5l_antennanp
XANTENNA_248 Tile_X0Y0_FrameData[5] VPWR VGND sg13cmos5l_antennanp
XANTENNA_259 Tile_X0Y0_FrameData[5] VPWR VGND sg13cmos5l_antennanp
XANTENNA__515__X Tile_X1Y0_S2BEGb[4] VPWR VGND sg13cmos5l_antennanp
XFILLER_13_168 VPWR VGND sg13cmos5l_decap_8
XFILLER_14_658 VPWR VGND sg13cmos5l_fill_1
X_292_ _292_/Q Tile_X0Y0_FrameData[29] VGND VPWR Tile_X0Y0_FrameStrobe[1] latch
X_361_ _361_/L_HI VPWR VGND sg13cmos5l_tiehi
X_430_ Tile_X0Y0_S2BEGb[7] _567_/X VPWR VGND sg13cmos5l_buf_1
XFILLER_9_117 VPWR VGND sg13cmos5l_decap_8
XFILLER_10_864 VPWR VGND sg13cmos5l_decap_8
XFILLER_5_389 VPWR VGND sg13cmos5l_fill_1
XFILLER_5_378 VPWR VGND sg13cmos5l_decap_8
XFILLER_5_323 VPWR VGND sg13cmos5l_decap_8
XFILLER_17_441 VPWR VGND sg13cmos5l_decap_8
X_628_ _628_/X Tile_X1Y0_N2END[4] Tile_X1Y0_N4END[4] Tile_X1Y0_NN4END[11] _089_/X
+ _164_/Q _163_/Q VPWR VGND sg13cmos5l_mux4_1
XANTENNA__425__X Tile_X0Y0_S2BEGb[2] VPWR VGND sg13cmos5l_antennanp
X_559_ _559_/X Tile_X1Y0_N1END[0] Tile_X1Y0_N2END[2] Tile_X1Y0_N4END[15] Tile_X1Y0_NN4END[15]
+ _124_/Q _123_/Q VPWR VGND sg13cmos5l_mux4_1
XFILLER_10_138 VPWR VGND sg13cmos5l_decap_8
XFILLER_3_805 VPWR VGND sg13cmos5l_decap_4
XFILLER_15_901 VPWR VGND sg13cmos5l_decap_8
XFILLER_15_945 VPWR VGND sg13cmos5l_fill_2
X_413_ Tile_X0Y0_S1BEG[2] Tile_X0Y0_N1END[1] VPWR VGND sg13cmos5l_buf_1
XFILLER_18_216 VPWR VGND sg13cmos5l_decap_8
XFILLER_14_455 VPWR VGND sg13cmos5l_decap_8
X_275_ _275_/Q Tile_X0Y0_FrameData[14] VGND VPWR Tile_X0Y0_FrameStrobe[0] latch
X_344_ _344_/Q Tile_X0Y0_FrameData[9] VGND VPWR Tile_X0Y0_FrameStrobe[2] latch
XFILLER_5_120 VPWR VGND sg13cmos5l_fill_1
XFILLER_9_481 VPWR VGND sg13cmos5l_decap_8
XFILLER_4_90 VPWR VGND sg13cmos5l_fill_2
XFILLER_11_436 VPWR VGND sg13cmos5l_decap_8
XFILLER_12_915 VPWR VGND sg13cmos5l_decap_8
X_060_ _060_/Y _250_/Q VPWR VGND sg13cmos5l_inv_1
XFILLER_2_156 VPWR VGND sg13cmos5l_decap_8
XFILLER_0_48 VPWR VGND sg13cmos5l_fill_1
XFILLER_14_252 VPWR VGND sg13cmos5l_decap_8
XFILLER_9_35 VPWR VGND sg13cmos5l_decap_8
XFILLER_10_491 VPWR VGND sg13cmos5l_decap_8
X_327_ _327_/Q Tile_X0Y0_FrameData[26] VGND VPWR Tile_X0Y0_FrameStrobe[2] latch
X_258_ _258_/Q Tile_X0Y0_UserCLK _559_/X _352_/L_HI VPWR VGND sg13cmos5l_dfrbpq_1
X_189_ _189_/Q Tile_X0Y0_FrameData[27] VGND VPWR Tile_X1Y0_FrameStrobe[2] latch
XFILLER_7_930 VPWR VGND sg13cmos5l_fill_2
XFILLER_6_495 VPWR VGND sg13cmos5l_decap_8
XFILLER_0_605 VPWR VGND sg13cmos5l_decap_8
XFILLER_16_539 VPWR VGND sg13cmos5l_decap_8
XFILLER_18_77 VPWR VGND sg13cmos5l_decap_8
XANTENNA__523__X Tile_X1Y0_S4BEG[4] VPWR VGND sg13cmos5l_antennanp
XFILLER_11_233 VPWR VGND sg13cmos5l_decap_8
X_112_ PMOD_IO_O2 _223_/Q _071_/X VPWR VGND sg13cmos5l_nor2b_1
XFILLER_1_0 VPWR VGND sg13cmos5l_decap_8
XANTENNA__433__X Tile_X0Y0_S4BEG[2] VPWR VGND sg13cmos5l_antennanp
XFILLER_7_760 VPWR VGND sg13cmos5l_decap_8
XFILLER_1_958 VPWR VGND sg13cmos5l_fill_2
XFILLER_17_837 VPWR VGND sg13cmos5l_decap_4
X_592_ _592_/X Tile_X0Y0_N2END[0] Tile_X0Y0_N4END[8] Tile_X0Y0_NN4END[7] _092_/X _285_/Q
+ _284_/Q VPWR VGND sg13cmos5l_mux4_1
XANTENNA__518__X Tile_X1Y0_S2BEGb[7] VPWR VGND sg13cmos5l_antennanp
XFILLER_12_520 VPWR VGND sg13cmos5l_decap_8
XFILLER_16_336 VPWR VGND sg13cmos5l_decap_8
XANTENNA_7 Tile_X0Y0_FrameData[16] VPWR VGND sg13cmos5l_antennanp
XFILLER_12_597 VPWR VGND sg13cmos5l_fill_2
XFILLER_8_524 VPWR VGND sg13cmos5l_decap_8
XANTENNA__428__X Tile_X0Y0_S2BEGb[5] VPWR VGND sg13cmos5l_antennanp
XFILLER_7_590 VPWR VGND sg13cmos5l_decap_8
XFILLER_15_56 VPWR VGND sg13cmos5l_decap_8
XFILLER_5_538 VPWR VGND sg13cmos5l_fill_1
XFILLER_0_265 VPWR VGND sg13cmos5l_decap_8
XFILLER_16_133 VPWR VGND sg13cmos5l_decap_8
XFILLER_17_623 VPWR VGND sg13cmos5l_decap_8
XFILLER_17_667 VPWR VGND sg13cmos5l_fill_1
X_644_ _644_/X Tile_X1Y0_N2MID[3] Tile_X1Y0_N2END[4] Tile_X1Y0_N4END[11] Tile_X1Y0_NN4END[11]
+ _134_/Q _133_/Q VPWR VGND sg13cmos5l_mux4_1
X_575_ _575_/X Tile_X0Y0_N2MID[7] Tile_X0Y0_N4END[8] Tile_X0Y0_NN4END[7] _119_/X _319_/Q
+ _318_/Q VPWR VGND sg13cmos5l_mux4_1
XFILLER_12_394 VPWR VGND sg13cmos5l_decap_8
XFILLER_13_862 VPWR VGND sg13cmos5l_decap_8
XFILLER_8_398 VPWR VGND sg13cmos5l_decap_8
XFILLER_4_560 VPWR VGND sg13cmos5l_decap_8
XFILLER_10_309 VPWR VGND sg13cmos5l_decap_8
XFILLER_7_90 VPWR VGND sg13cmos5l_decap_8
XANTENNA_205 Tile_X0Y0_FrameData[3] VPWR VGND sg13cmos5l_antennanp
XANTENNA_216 Tile_X0Y0_FrameData[3] VPWR VGND sg13cmos5l_antennanp
XANTENNA_227 Tile_X0Y0_FrameData[3] VPWR VGND sg13cmos5l_antennanp
XANTENNA_238 Tile_X0Y0_FrameData[5] VPWR VGND sg13cmos5l_antennanp
XANTENNA_249 Tile_X0Y0_FrameData[5] VPWR VGND sg13cmos5l_antennanp
XFILLER_13_147 VPWR VGND sg13cmos5l_decap_8
X_291_ _291_/Q Tile_X0Y0_FrameData[30] VGND VPWR Tile_X0Y0_FrameStrobe[1] latch
X_360_ _360_/L_HI VPWR VGND sg13cmos5l_tiehi
XANTENNA__531__X Tile_X1Y0_S4BEG[12] VPWR VGND sg13cmos5l_antennanp
XFILLER_5_346 VPWR VGND sg13cmos5l_fill_1
XFILLER_17_420 VPWR VGND sg13cmos5l_decap_8
XFILLER_17_497 VPWR VGND sg13cmos5l_decap_8
X_627_ _627_/X Tile_X1Y0_N2END[3] Tile_X1Y0_N4END[3] Tile_X1Y0_NN4END[12] _087_/X
+ _166_/Q _165_/Q VPWR VGND sg13cmos5l_mux4_1
X_558_ _558_/X Tile_X1Y0_N2MID[6] Tile_X1Y0_N2END[1] Tile_X1Y0_N4END[14] Tile_X1Y0_NN4END[14]
+ _128_/Q _127_/Q VPWR VGND sg13cmos5l_mux4_1
XFILLER_18_943 VPWR VGND sg13cmos5l_decap_8
XFILLER_12_191 VPWR VGND sg13cmos5l_decap_8
X_489_ Tile_X1Y0_FrameStrobe_O[10] Tile_X1Y0_FrameStrobe[10] VPWR VGND sg13cmos5l_buf_1
XFILLER_9_685 VPWR VGND sg13cmos5l_decap_8
XFILLER_9_663 VPWR VGND sg13cmos5l_decap_8
XFILLER_8_151 VPWR VGND sg13cmos5l_fill_2
XANTENNA__441__X Tile_X0Y0_S4BEG[10] VPWR VGND sg13cmos5l_antennanp
XFILLER_10_117 VPWR VGND sg13cmos5l_decap_8
XFILLER_12_35 VPWR VGND sg13cmos5l_decap_8
XFILLER_12_79 VPWR VGND sg13cmos5l_decap_8
XFILLER_5_7 VPWR VGND sg13cmos5l_fill_2
XANTENNA__526__X Tile_X1Y0_S4BEG[7] VPWR VGND sg13cmos5l_antennanp
XFILLER_14_434 VPWR VGND sg13cmos5l_decap_8
X_412_ Tile_X0Y0_S1BEG[1] Tile_X0Y0_N1END[2] VPWR VGND sg13cmos5l_buf_1
X_274_ _274_/Q Tile_X0Y0_FrameData[15] VGND VPWR Tile_X0Y0_FrameStrobe[0] latch
X_343_ _343_/Q Tile_X0Y0_FrameData[10] VGND VPWR Tile_X0Y0_FrameStrobe[2] latch
XFILLER_6_622 VPWR VGND sg13cmos5l_decap_8
XFILLER_2_883 VPWR VGND sg13cmos5l_decap_4
XANTENNA__436__X Tile_X0Y0_S4BEG[5] VPWR VGND sg13cmos5l_antennanp
XFILLER_17_294 VPWR VGND sg13cmos5l_decap_8
XFILLER_9_460 VPWR VGND sg13cmos5l_decap_8
XFILLER_11_415 VPWR VGND sg13cmos5l_decap_8
XFILLER_14_231 VPWR VGND sg13cmos5l_decap_8
XFILLER_15_710 VPWR VGND sg13cmos5l_fill_1
X_326_ _326_/Q Tile_X0Y0_FrameData[27] VGND VPWR Tile_X0Y0_FrameStrobe[2] latch
XFILLER_9_14 VPWR VGND sg13cmos5l_decap_8
XFILLER_10_470 VPWR VGND sg13cmos5l_decap_8
X_257_ _257_/Q Tile_X0Y0_UserCLK _558_/X _364_/L_HI VPWR VGND sg13cmos5l_dfrbpq_1
X_188_ _188_/Q Tile_X0Y0_FrameData[28] VGND VPWR Tile_X1Y0_FrameStrobe[2] latch
XFILLER_6_474 VPWR VGND sg13cmos5l_decap_8
XFILLER_18_592 VPWR VGND sg13cmos5l_fill_1
XFILLER_18_581 VPWR VGND sg13cmos5l_fill_1
XFILLER_0_617 VPWR VGND sg13cmos5l_decap_8
XFILLER_18_56 VPWR VGND sg13cmos5l_decap_8
XFILLER_11_212 VPWR VGND sg13cmos5l_decap_8
XFILLER_12_713 VPWR VGND sg13cmos5l_fill_2
XFILLER_12_746 VPWR VGND sg13cmos5l_fill_2
XFILLER_16_518 VPWR VGND sg13cmos5l_decap_8
XFILLER_18_89 VPWR VGND sg13cmos5l_decap_8
XFILLER_11_289 VPWR VGND sg13cmos5l_decap_8
X_111_ PMOD_IO_O1 _223_/Q _110_/X VPWR VGND sg13cmos5l_nor2b_1
XFILLER_15_595 VPWR VGND sg13cmos5l_decap_8
X_309_ _309_/Q Tile_X0Y0_FrameData[12] VGND VPWR Tile_X0Y0_FrameStrobe[1] latch
XFILLER_16_315 VPWR VGND sg13cmos5l_decap_8
X_591_ _591_/X Tile_X0Y0_N2END[7] Tile_X0Y0_N4END[7] Tile_X0Y0_NN4END[8] _119_/X _287_/Q
+ _286_/Q VPWR VGND sg13cmos5l_mux4_1
XANTENNA__534__X Tile_X1Y0_S4BEG[15] VPWR VGND sg13cmos5l_antennanp
XFILLER_12_576 VPWR VGND sg13cmos5l_decap_8
XFILLER_8_503 VPWR VGND sg13cmos5l_decap_8
XANTENNA_8 Tile_X0Y0_FrameData[16] VPWR VGND sg13cmos5l_antennanp
XFILLER_6_48 VPWR VGND sg13cmos5l_decap_8
XFILLER_4_731 VPWR VGND sg13cmos5l_fill_2
XFILLER_3_230 VPWR VGND sg13cmos5l_fill_2
XANTENNA__444__X Tile_X0Y0_S4BEG[13] VPWR VGND sg13cmos5l_antennanp
XFILLER_15_392 VPWR VGND sg13cmos5l_decap_8
XFILLER_13_329 VPWR VGND sg13cmos5l_decap_8
XFILLER_15_35 VPWR VGND sg13cmos5l_decap_8
XFILLER_5_517 VPWR VGND sg13cmos5l_decap_8
XFILLER_0_244 VPWR VGND sg13cmos5l_decap_8
XFILLER_1_756 VPWR VGND sg13cmos5l_fill_2
XANTENNA__529__X Tile_X1Y0_S4BEG[10] VPWR VGND sg13cmos5l_antennanp
XFILLER_16_112 VPWR VGND sg13cmos5l_decap_8
XFILLER_16_189 VPWR VGND sg13cmos5l_decap_8
XFILLER_17_602 VPWR VGND sg13cmos5l_decap_8
X_643_ _643_/X Tile_X1Y0_N2MID[1] Tile_X1Y0_N2END[6] Tile_X1Y0_N4END[9] Tile_X1Y0_NN4END[9]
+ _138_/Q _137_/Q VPWR VGND sg13cmos5l_mux4_1
X_574_ _574_/X Tile_X0Y0_N2MID[6] Tile_X0Y0_N4END[9] Tile_X0Y0_NN4END[6] _092_/X _321_/Q
+ _320_/Q VPWR VGND sg13cmos5l_mux4_1
XFILLER_12_373 VPWR VGND sg13cmos5l_decap_8
XFILLER_9_889 VPWR VGND sg13cmos5l_decap_8
XFILLER_8_377 VPWR VGND sg13cmos5l_decap_8
XFILLER_8_300 VPWR VGND sg13cmos5l_fill_2
XANTENNA__439__X Tile_X0Y0_S4BEG[8] VPWR VGND sg13cmos5l_antennanp
XANTENNA_206 Tile_X0Y0_FrameData[3] VPWR VGND sg13cmos5l_antennanp
XANTENNA_217 Tile_X0Y0_FrameData[3] VPWR VGND sg13cmos5l_antennanp
XANTENNA_228 Tile_X0Y0_FrameData[3] VPWR VGND sg13cmos5l_antennanp
XANTENNA_239 Tile_X0Y0_FrameData[5] VPWR VGND sg13cmos5l_antennanp
XFILLER_14_616 VPWR VGND sg13cmos5l_decap_8
XFILLER_13_126 VPWR VGND sg13cmos5l_decap_8
X_290_ _290_/Q Tile_X0Y0_FrameData[31] VGND VPWR Tile_X0Y0_FrameStrobe[1] latch
XFILLER_10_899 VPWR VGND sg13cmos5l_decap_8
XFILLER_18_922 VPWR VGND sg13cmos5l_fill_2
XFILLER_18_911 VPWR VGND sg13cmos5l_decap_8
XFILLER_17_476 VPWR VGND sg13cmos5l_decap_8
X_488_ Tile_X1Y0_FrameStrobe_O[9] Tile_X1Y0_FrameStrobe[9] VPWR VGND sg13cmos5l_buf_1
X_626_ _626_/X Tile_X1Y0_N2END[2] Tile_X1Y0_N4END[2] Tile_X1Y0_NN4END[13] _085_/X
+ _168_/Q _167_/Q VPWR VGND sg13cmos5l_mux4_1
X_557_ _557_/X Tile_X1Y0_N2MID[4] Tile_X1Y0_N2END[3] Tile_X1Y0_N4END[12] Tile_X1Y0_NN4END[12]
+ _132_/Q _131_/Q VPWR VGND sg13cmos5l_mux4_1
XFILLER_12_170 VPWR VGND sg13cmos5l_decap_8
XFILLER_9_631 VPWR VGND sg13cmos5l_decap_4
XFILLER_5_881 VPWR VGND sg13cmos5l_fill_2
XFILLER_12_14 VPWR VGND sg13cmos5l_decap_8
XFILLER_12_58 VPWR VGND sg13cmos5l_decap_8
XFILLER_3_829 VPWR VGND sg13cmos5l_decap_4
XFILLER_14_413 VPWR VGND sg13cmos5l_decap_8
XFILLER_15_936 VPWR VGND sg13cmos5l_decap_4
XFILLER_15_947 VPWR VGND sg13cmos5l_fill_1
XFILLER_15_958 VPWR VGND sg13cmos5l_fill_2
X_342_ _342_/Q Tile_X0Y0_FrameData[11] VGND VPWR Tile_X0Y0_FrameStrobe[2] latch
X_411_ Tile_X0Y0_S1BEG[0] Tile_X0Y0_N1END[3] VPWR VGND sg13cmos5l_buf_1
XANTENNA__542__X Tile_X1Y0_SS4BEG[7] VPWR VGND sg13cmos5l_antennanp
XFILLER_10_641 VPWR VGND sg13cmos5l_decap_8
X_273_ _273_/Q Tile_X0Y0_FrameData[16] VGND VPWR Tile_X0Y0_FrameStrobe[0] latch
XFILLER_2_851 VPWR VGND sg13cmos5l_decap_8
XFILLER_17_273 VPWR VGND sg13cmos5l_decap_8
X_609_ _609_/X Tile_X1Y0_N2MID[1] Tile_X1Y0_N4END[14] Tile_X1Y0_NN4END[1] _087_/X
+ _202_/Q _201_/Q VPWR VGND sg13cmos5l_mux4_1
XFILLER_13_490 VPWR VGND sg13cmos5l_decap_8
XANTENNA__452__X Tile_X1Y0_FrameData_O[5] VPWR VGND sg13cmos5l_antennanp
XANTENNA__537__X Tile_X1Y0_SS4BEG[2] VPWR VGND sg13cmos5l_antennanp
XFILLER_0_28 VPWR VGND sg13cmos5l_decap_8
XFILLER_0_39 VPWR VGND sg13cmos5l_decap_8
XFILLER_14_210 VPWR VGND sg13cmos5l_decap_8
XFILLER_14_287 VPWR VGND sg13cmos5l_decap_8
X_325_ _325_/Q Tile_X0Y0_FrameData[28] VGND VPWR Tile_X0Y0_FrameStrobe[2] latch
X_256_ _256_/Q Tile_X0Y0_UserCLK _557_/X _353_/L_HI VPWR VGND sg13cmos5l_dfrbpq_1
X_187_ _187_/Q Tile_X0Y0_FrameData[29] VGND VPWR Tile_X1Y0_FrameStrobe[2] latch
XFILLER_7_932 VPWR VGND sg13cmos5l_fill_1
XFILLER_6_453 VPWR VGND sg13cmos5l_decap_8
XANTENNA__447__X Tile_X1Y0_FrameData_O[0] VPWR VGND sg13cmos5l_antennanp
XFILLER_18_35 VPWR VGND sg13cmos5l_decap_8
X_110_ _110_/X _252_/Q _553_/X _233_/Q VPWR VGND sg13cmos5l_mux2_1
XFILLER_8_729 VPWR VGND sg13cmos5l_decap_8
XFILLER_11_268 VPWR VGND sg13cmos5l_decap_8
XFILLER_3_445 VPWR VGND sg13cmos5l_decap_8
XFILLER_15_574 VPWR VGND sg13cmos5l_decap_8
X_308_ _308_/Q Tile_X0Y0_FrameData[13] VGND VPWR Tile_X0Y0_FrameStrobe[1] latch
X_239_ _239_/Q Tile_X0Y0_UserCLK _239_/D _365_/L_HI VPWR VGND sg13cmos5l_dfrbpq_1
XFILLER_7_751 VPWR VGND sg13cmos5l_decap_4
XFILLER_18_390 VPWR VGND sg13cmos5l_decap_8
XFILLER_4_209 VPWR VGND sg13cmos5l_decap_8
X_590_ _590_/X Tile_X0Y0_N2END[6] Tile_X0Y0_N4END[6] Tile_X0Y0_NN4END[9] _091_/X _289_/Q
+ _288_/Q VPWR VGND sg13cmos5l_mux4_1
XFILLER_12_555 VPWR VGND sg13cmos5l_decap_8
XANTENNA_9 Tile_X0Y0_FrameData[1] VPWR VGND sg13cmos5l_antennanp
XANTENNA__550__X Tile_X1Y0_SS4BEG[15] VPWR VGND sg13cmos5l_antennanp
XFILLER_13_7 VPWR VGND sg13cmos5l_decap_8
XFILLER_15_371 VPWR VGND sg13cmos5l_decap_8
XFILLER_16_894 VPWR VGND sg13cmos5l_decap_8
XANTENNA__460__X Tile_X1Y0_FrameData_O[13] VPWR VGND sg13cmos5l_antennanp
XFILLER_15_14 VPWR VGND sg13cmos5l_decap_8
XFILLER_13_308 VPWR VGND sg13cmos5l_decap_8
XFILLER_0_223 VPWR VGND sg13cmos5l_decap_8
X_642_ _642_/X Tile_X0Y0_N2MID[5] Tile_X0Y0_N2END[2] Tile_X0Y0_N4END[13] Tile_X0Y0_NN4END[13]
+ _259_/Q _350_/Q VPWR VGND sg13cmos5l_mux4_1
XANTENNA__545__X Tile_X1Y0_SS4BEG[10] VPWR VGND sg13cmos5l_antennanp
XFILLER_13_820 VPWR VGND sg13cmos5l_fill_1
XFILLER_16_168 VPWR VGND sg13cmos5l_decap_8
XFILLER_17_658 VPWR VGND sg13cmos5l_decap_8
X_573_ _573_/X Tile_X0Y0_N2MID[5] Tile_X0Y0_N4END[10] Tile_X0Y0_NN4END[5] _091_/X
+ _323_/Q _322_/Q VPWR VGND sg13cmos5l_mux4_1
XFILLER_12_352 VPWR VGND sg13cmos5l_decap_8
XFILLER_13_897 VPWR VGND sg13cmos5l_decap_8
XFILLER_9_868 VPWR VGND sg13cmos5l_decap_8
XANTENNA__455__X Tile_X1Y0_FrameData_O[8] VPWR VGND sg13cmos5l_antennanp
XANTENNA_207 Tile_X0Y0_FrameData[3] VPWR VGND sg13cmos5l_antennanp
XANTENNA_218 Tile_X0Y0_FrameData[3] VPWR VGND sg13cmos5l_antennanp
XANTENNA_229 Tile_X0Y0_FrameData[3] VPWR VGND sg13cmos5l_antennanp
XFILLER_13_105 VPWR VGND sg13cmos5l_decap_8
XFILLER_10_878 VPWR VGND sg13cmos5l_decap_8
XFILLER_6_827 VPWR VGND sg13cmos5l_decap_8
XFILLER_5_359 VPWR VGND sg13cmos5l_fill_1
XFILLER_1_543 VPWR VGND sg13cmos5l_fill_2
XFILLER_1_521 VPWR VGND sg13cmos5l_decap_4
XFILLER_17_455 VPWR VGND sg13cmos5l_decap_8
X_625_ _625_/X Tile_X1Y0_N2END[1] Tile_X1Y0_N4END[1] Tile_X1Y0_NN4END[14] _095_/X
+ _170_/Q _169_/Q VPWR VGND sg13cmos5l_mux4_1
X_487_ Tile_X1Y0_FrameStrobe_O[8] Tile_X1Y0_FrameStrobe[8] VPWR VGND sg13cmos5l_buf_1
X_556_ _556_/X Tile_X1Y0_N2MID[2] Tile_X1Y0_N2END[5] Tile_X1Y0_N4END[10] Tile_X1Y0_NN4END[10]
+ _136_/Q _135_/Q VPWR VGND sg13cmos5l_mux4_1
XFILLER_8_153 VPWR VGND sg13cmos5l_fill_1
XFILLER_8_131 VPWR VGND sg13cmos5l_decap_8
XFILLER_5_860 VPWR VGND sg13cmos5l_decap_8
XFILLER_5_9 VPWR VGND sg13cmos5l_fill_1
XFILLER_14_469 VPWR VGND sg13cmos5l_decap_8
XFILLER_15_915 VPWR VGND sg13cmos5l_decap_8
X_272_ _272_/Q Tile_X0Y0_FrameData[17] VGND VPWR Tile_X0Y0_FrameStrobe[0] latch
X_341_ _341_/Q Tile_X0Y0_FrameData[12] VGND VPWR Tile_X0Y0_FrameStrobe[2] latch
X_410_ Tile_X0Y0_FrameStrobe_O[19] Tile_X0Y0_FrameStrobe[19] VPWR VGND sg13cmos5l_buf_1
XFILLER_10_686 VPWR VGND sg13cmos5l_decap_8
XFILLER_6_679 VPWR VGND sg13cmos5l_decap_8
XFILLER_17_252 VPWR VGND sg13cmos5l_decap_8
X_608_ _608_/X Tile_X1Y0_N2MID[0] Tile_X1Y0_N4END[15] Tile_X1Y0_NN4END[0] _089_/X
+ _204_/Q _203_/Q VPWR VGND sg13cmos5l_mux4_1
X_539_ Tile_X1Y0_SS4BEG[4] _628_/X VPWR VGND sg13cmos5l_buf_1
XFILLER_9_495 VPWR VGND sg13cmos5l_decap_8
XFILLER_12_929 VPWR VGND sg13cmos5l_decap_8
XFILLER_2_115 VPWR VGND sg13cmos5l_decap_8
XFILLER_11_951 VPWR VGND sg13cmos5l_decap_8
XFILLER_14_266 VPWR VGND sg13cmos5l_decap_8
X_324_ _324_/Q Tile_X0Y0_FrameData[29] VGND VPWR Tile_X0Y0_FrameStrobe[2] latch
X_255_ _255_/Q Tile_X0Y0_UserCLK _556_/X _370_/L_HI VPWR VGND sg13cmos5l_dfrbpq_1
XFILLER_9_49 VPWR VGND sg13cmos5l_decap_8
XFILLER_13_91 VPWR VGND sg13cmos5l_decap_8
X_186_ _186_/Q Tile_X0Y0_FrameData[30] VGND VPWR Tile_X1Y0_FrameStrobe[2] latch
XFILLER_6_432 VPWR VGND sg13cmos5l_decap_8
XFILLER_18_550 VPWR VGND sg13cmos5l_fill_2
XANTENNA__463__X Tile_X1Y0_FrameData_O[16] VPWR VGND sg13cmos5l_antennanp
XFILLER_18_14 VPWR VGND sg13cmos5l_decap_8
XFILLER_11_247 VPWR VGND sg13cmos5l_decap_8
XFILLER_7_218 VPWR VGND sg13cmos5l_fill_1
XFILLER_7_207 VPWR VGND sg13cmos5l_decap_8
XFILLER_4_914 VPWR VGND sg13cmos5l_fill_1
XANTENNA__548__X Tile_X1Y0_SS4BEG[13] VPWR VGND sg13cmos5l_antennanp
XFILLER_15_553 VPWR VGND sg13cmos5l_decap_8
X_307_ _307_/Q Tile_X0Y0_FrameData[14] VGND VPWR Tile_X0Y0_FrameStrobe[1] latch
X_238_ _238_/Q Tile_X0Y0_UserCLK _238_/D _363_/L_HI VPWR VGND sg13cmos5l_dfrbpq_1
X_169_ _169_/Q Tile_X0Y0_FrameData[15] VGND VPWR Tile_X1Y0_FrameStrobe[1] latch
XFILLER_7_774 VPWR VGND sg13cmos5l_decap_8
XFILLER_6_273 VPWR VGND sg13cmos5l_fill_2
XANTENNA__458__X Tile_X1Y0_FrameData_O[11] VPWR VGND sg13cmos5l_antennanp
XFILLER_1_939 VPWR VGND sg13cmos5l_decap_8
XFILLER_12_534 VPWR VGND sg13cmos5l_decap_8
XFILLER_8_549 VPWR VGND sg13cmos5l_fill_1
XFILLER_6_17 VPWR VGND sg13cmos5l_fill_2
XFILLER_4_788 VPWR VGND sg13cmos5l_fill_2
XFILLER_4_733 VPWR VGND sg13cmos5l_fill_1
XFILLER_15_350 VPWR VGND sg13cmos5l_decap_8
XFILLER_16_873 VPWR VGND sg13cmos5l_decap_8
XFILLER_7_571 VPWR VGND sg13cmos5l_fill_1
XFILLER_0_202 VPWR VGND sg13cmos5l_decap_8
XFILLER_1_714 VPWR VGND sg13cmos5l_decap_8
XFILLER_1_703 VPWR VGND sg13cmos5l_decap_8
XFILLER_0_279 VPWR VGND sg13cmos5l_decap_8
XFILLER_17_637 VPWR VGND sg13cmos5l_decap_8
X_641_ _641_/X Tile_X0Y0_N2MID[3] Tile_X0Y0_N2END[4] Tile_X0Y0_N4END[11] Tile_X0Y0_NN4END[11]
+ _263_/Q _262_/Q VPWR VGND sg13cmos5l_mux4_1
X_572_ _572_/X Tile_X0Y0_N2MID[4] Tile_X0Y0_N4END[11] Tile_X0Y0_NN4END[4] _119_/X
+ _325_/Q _324_/Q VPWR VGND sg13cmos5l_mux4_1
XFILLER_12_331 VPWR VGND sg13cmos5l_decap_8
XFILLER_13_876 VPWR VGND sg13cmos5l_decap_8
XFILLER_16_147 VPWR VGND sg13cmos5l_decap_8
XFILLER_9_803 VPWR VGND sg13cmos5l_decap_8
XFILLER_8_302 VPWR VGND sg13cmos5l_fill_1
XFILLER_9_847 VPWR VGND sg13cmos5l_decap_8
XANTENNA__471__X Tile_X1Y0_FrameData_O[24] VPWR VGND sg13cmos5l_antennanp
XANTENNA_208 Tile_X0Y0_FrameData[3] VPWR VGND sg13cmos5l_antennanp
XANTENNA_219 Tile_X0Y0_FrameData[3] VPWR VGND sg13cmos5l_antennanp
XANTENNA__381__X Tile_X0Y0_SS4BEG[6] VPWR VGND sg13cmos5l_antennanp
XFILLER_10_857 VPWR VGND sg13cmos5l_decap_8
XFILLER_6_806 VPWR VGND sg13cmos5l_decap_8
XFILLER_1_500 VPWR VGND sg13cmos5l_decap_8
XFILLER_17_434 VPWR VGND sg13cmos5l_decap_8
X_624_ _624_/X Tile_X1Y0_N2END[0] Tile_X1Y0_N4END[0] Tile_X1Y0_NN4END[15] _064_/X
+ _172_/Q _171_/Q VPWR VGND sg13cmos5l_mux4_1
X_555_ _555_/X Tile_X1Y0_N2MID[0] Tile_X1Y0_N2END[7] Tile_X1Y0_N4END[8] Tile_X1Y0_NN4END[8]
+ _140_/Q _139_/Q VPWR VGND sg13cmos5l_mux4_1
XFILLER_18_957 VPWR VGND sg13cmos5l_fill_2
XFILLER_16_91 VPWR VGND sg13cmos5l_decap_8
X_486_ Tile_X1Y0_FrameStrobe_O[7] Tile_X1Y0_FrameStrobe[7] VPWR VGND sg13cmos5l_buf_1
XFILLER_9_677 VPWR VGND sg13cmos5l_fill_1
XFILLER_9_622 VPWR VGND sg13cmos5l_fill_2
XFILLER_8_110 VPWR VGND sg13cmos5l_decap_8
XFILLER_5_883 VPWR VGND sg13cmos5l_fill_1
XFILLER_5_850 VPWR VGND sg13cmos5l_decap_4
XANTENNA__466__X Tile_X1Y0_FrameData_O[19] VPWR VGND sg13cmos5l_antennanp
XFILLER_12_49 VPWR VGND sg13cmos5l_decap_4
XFILLER_3_809 VPWR VGND sg13cmos5l_fill_2
XFILLER_2_319 VPWR VGND sg13cmos5l_decap_8
XANTENNA__376__X Tile_X0Y0_SS4BEG[1] VPWR VGND sg13cmos5l_antennanp
XFILLER_18_209 VPWR VGND sg13cmos5l_decap_8
XFILLER_14_448 VPWR VGND sg13cmos5l_decap_8
X_271_ _271_/Q Tile_X0Y0_FrameData[18] VGND VPWR Tile_X0Y0_FrameStrobe[0] latch
X_340_ _340_/Q Tile_X0Y0_FrameData[13] VGND VPWR Tile_X0Y0_FrameStrobe[2] latch
XFILLER_6_636 VPWR VGND sg13cmos5l_decap_4
XFILLER_5_135 VPWR VGND sg13cmos5l_fill_2
XFILLER_1_385 VPWR VGND sg13cmos5l_fill_2
XFILLER_17_231 VPWR VGND sg13cmos5l_decap_8
X_538_ Tile_X1Y0_SS4BEG[3] _627_/X VPWR VGND sg13cmos5l_buf_1
X_607_ _607_/X Tile_X1Y0_N1END[3] Tile_X1Y0_N2MID[7] Tile_X1Y0_N2END[0] _085_/X _206_/Q
+ _205_/Q VPWR VGND sg13cmos5l_mux4_1
XFILLER_18_787 VPWR VGND sg13cmos5l_fill_1
X_469_ Tile_X1Y0_FrameData_O[22] Tile_X0Y0_FrameData[22] VPWR VGND sg13cmos5l_buf_1
XFILLER_9_474 VPWR VGND sg13cmos5l_decap_8
XFILLER_11_429 VPWR VGND sg13cmos5l_decap_8
XFILLER_12_908 VPWR VGND sg13cmos5l_decap_8
XFILLER_3_7 VPWR VGND sg13cmos5l_decap_8
XFILLER_14_245 VPWR VGND sg13cmos5l_decap_8
XFILLER_10_484 VPWR VGND sg13cmos5l_decap_8
XFILLER_13_70 VPWR VGND sg13cmos5l_decap_8
X_323_ _323_/Q Tile_X0Y0_FrameData[30] VGND VPWR Tile_X0Y0_FrameStrobe[2] latch
X_254_ _254_/Q Tile_X0Y0_UserCLK _555_/X _369_/L_HI VPWR VGND sg13cmos5l_dfrbpq_1
X_185_ _185_/Q Tile_X0Y0_FrameData[31] VGND VPWR Tile_X1Y0_FrameStrobe[2] latch
XFILLER_9_28 VPWR VGND sg13cmos5l_decap_8
XFILLER_7_923 VPWR VGND sg13cmos5l_decap_8
XFILLER_6_411 VPWR VGND sg13cmos5l_decap_8
XFILLER_6_488 VPWR VGND sg13cmos5l_decap_8
XFILLER_11_226 VPWR VGND sg13cmos5l_decap_8
XFILLER_15_532 VPWR VGND sg13cmos5l_decap_8
X_306_ _306_/Q Tile_X0Y0_FrameData[15] VGND VPWR Tile_X0Y0_FrameStrobe[1] latch
XFILLER_10_281 VPWR VGND sg13cmos5l_decap_8
X_237_ _237_/Q Tile_X0Y0_UserCLK _237_/D _367_/L_HI VPWR VGND sg13cmos5l_dfrbpq_1
X_168_ _168_/Q Tile_X0Y0_FrameData[16] VGND VPWR Tile_X1Y0_FrameStrobe[1] latch
XFILLER_7_797 VPWR VGND sg13cmos5l_decap_4
XFILLER_7_786 VPWR VGND sg13cmos5l_decap_4
X_099_ _099_/Y _120_/A _249_/D _098_/X VPWR VGND sg13cmos5l_o21ai_1
XANTENNA__474__X Tile_X1Y0_FrameData_O[27] VPWR VGND sg13cmos5l_antennanp
XANTENNA__384__X Tile_X0Y0_SS4BEG[9] VPWR VGND sg13cmos5l_antennanp
XFILLER_12_513 VPWR VGND sg13cmos5l_decap_8
XFILLER_16_329 VPWR VGND sg13cmos5l_decap_8
XFILLER_8_517 VPWR VGND sg13cmos5l_decap_8
XFILLER_10_82 VPWR VGND sg13cmos5l_decap_8
XFILLER_7_583 VPWR VGND sg13cmos5l_decap_8
XANTENNA__469__X Tile_X1Y0_FrameData_O[22] VPWR VGND sg13cmos5l_antennanp
XFILLER_15_49 VPWR VGND sg13cmos5l_decap_8
XANTENNA__379__X Tile_X0Y0_SS4BEG[4] VPWR VGND sg13cmos5l_antennanp
XFILLER_0_258 VPWR VGND sg13cmos5l_decap_8
XFILLER_16_126 VPWR VGND sg13cmos5l_decap_8
XFILLER_17_616 VPWR VGND sg13cmos5l_decap_8
X_640_ _640_/X Tile_X0Y0_N2MID[1] Tile_X0Y0_N2END[6] Tile_X0Y0_N4END[9] Tile_X0Y0_NN4END[9]
+ _267_/Q _266_/Q VPWR VGND sg13cmos5l_mux4_1
X_571_ _571_/X Tile_X0Y0_N2MID[3] Tile_X0Y0_N4END[12] Tile_X0Y0_NN4END[3] _092_/X
+ _327_/Q _326_/Q VPWR VGND sg13cmos5l_mux4_1
XFILLER_12_310 VPWR VGND sg13cmos5l_decap_8
XFILLER_12_387 VPWR VGND sg13cmos5l_decap_8
XFILLER_13_855 VPWR VGND sg13cmos5l_decap_8
XFILLER_8_325 VPWR VGND sg13cmos5l_decap_4
XFILLER_4_553 VPWR VGND sg13cmos5l_decap_8
XFILLER_0_781 VPWR VGND sg13cmos5l_fill_1
XFILLER_16_693 VPWR VGND sg13cmos5l_fill_2
XFILLER_7_83 VPWR VGND sg13cmos5l_decap_8
XANTENNA_209 Tile_X0Y0_FrameData[3] VPWR VGND sg13cmos5l_antennanp
XFILLER_16_70 VPWR VGND sg13cmos5l_decap_8
XFILLER_17_413 VPWR VGND sg13cmos5l_decap_8
X_485_ Tile_X1Y0_FrameStrobe_O[6] Tile_X1Y0_FrameStrobe[6] VPWR VGND sg13cmos5l_buf_1
X_623_ _623_/X Tile_X1Y0_N2MID[7] Tile_X1Y0_N4END[0] Tile_X1Y0_NN4END[15] _089_/X
+ _174_/Q _173_/Q VPWR VGND sg13cmos5l_mux4_1
X_554_ _554_/X Tile_X0Y0_N2MID[4] Tile_X0Y0_N2END[3] Tile_X0Y0_N4END[12] Tile_X0Y0_NN4END[12]
+ _261_/Q _260_/Q VPWR VGND sg13cmos5l_mux4_1
XFILLER_18_936 VPWR VGND sg13cmos5l_decap_8
XFILLER_12_184 VPWR VGND sg13cmos5l_decap_8
XFILLER_13_630 VPWR VGND sg13cmos5l_decap_8
XFILLER_5_895 VPWR VGND sg13cmos5l_decap_8
XFILLER_4_383 VPWR VGND sg13cmos5l_decap_4
XANTENNA__482__X Tile_X1Y0_FrameStrobe_O[3] VPWR VGND sg13cmos5l_antennanp
XFILLER_16_490 VPWR VGND sg13cmos5l_decap_8
XFILLER_12_28 VPWR VGND sg13cmos5l_decap_8
XFILLER_14_427 VPWR VGND sg13cmos5l_decap_8
XANTENNA__392__X Tile_X0Y0_FrameStrobe_O[1] VPWR VGND sg13cmos5l_antennanp
XFILLER_10_655 VPWR VGND sg13cmos5l_fill_2
X_270_ _270_/Q Tile_X0Y0_FrameData[19] VGND VPWR Tile_X0Y0_FrameStrobe[0] latch
XFILLER_5_158 VPWR VGND sg13cmos5l_fill_2
XFILLER_2_876 VPWR VGND sg13cmos5l_decap_8
XFILLER_2_865 VPWR VGND sg13cmos5l_decap_4
XFILLER_1_331 VPWR VGND sg13cmos5l_fill_1
XFILLER_17_210 VPWR VGND sg13cmos5l_decap_8
XFILLER_2_887 VPWR VGND sg13cmos5l_fill_1
XFILLER_17_287 VPWR VGND sg13cmos5l_decap_8
X_468_ Tile_X1Y0_FrameData_O[21] Tile_X0Y0_FrameData[21] VPWR VGND sg13cmos5l_buf_1
X_537_ Tile_X1Y0_SS4BEG[2] _626_/X VPWR VGND sg13cmos5l_buf_1
X_606_ _606_/X Tile_X1Y0_N1END[2] Tile_X1Y0_N2MID[6] Tile_X1Y0_N2END[1] _087_/X _208_/Q
+ _207_/Q VPWR VGND sg13cmos5l_mux4_1
X_399_ Tile_X0Y0_FrameStrobe_O[8] Tile_X0Y0_FrameStrobe[8] VPWR VGND sg13cmos5l_buf_1
XFILLER_9_453 VPWR VGND sg13cmos5l_decap_8
XFILLER_4_62 VPWR VGND sg13cmos5l_fill_1
XANTENNA__477__X Tile_X1Y0_FrameData_O[30] VPWR VGND sg13cmos5l_antennanp
XFILLER_11_408 VPWR VGND sg13cmos5l_decap_8
XFILLER_3_629 VPWR VGND sg13cmos5l_fill_2
XANTENNA__387__X Tile_X0Y0_SS4BEG[12] VPWR VGND sg13cmos5l_antennanp
XFILLER_14_224 VPWR VGND sg13cmos5l_decap_8
X_322_ _322_/Q Tile_X0Y0_FrameData[31] VGND VPWR Tile_X0Y0_FrameStrobe[2] latch
XFILLER_10_463 VPWR VGND sg13cmos5l_decap_8
X_253_ _253_/Q Tile_X0Y0_UserCLK _554_/X _372_/L_HI VPWR VGND sg13cmos5l_dfrbpq_1
X_184_ _184_/Q Tile_X0Y0_FrameData[0] VGND VPWR Tile_X1Y0_FrameStrobe[1] latch
XFILLER_7_902 VPWR VGND sg13cmos5l_decap_8
XFILLER_6_467 VPWR VGND sg13cmos5l_decap_8
XFILLER_1_172 VPWR VGND sg13cmos5l_fill_2
XFILLER_18_596 VPWR VGND sg13cmos5l_decap_4
XFILLER_18_585 VPWR VGND sg13cmos5l_decap_8
XFILLER_18_574 VPWR VGND sg13cmos5l_decap_8
XFILLER_18_49 VPWR VGND sg13cmos5l_decap_8
XFILLER_11_205 VPWR VGND sg13cmos5l_decap_8
XFILLER_3_459 VPWR VGND sg13cmos5l_fill_2
XFILLER_15_511 VPWR VGND sg13cmos5l_decap_8
XFILLER_15_588 VPWR VGND sg13cmos5l_decap_8
X_305_ _305_/Q Tile_X0Y0_FrameData[16] VGND VPWR Tile_X0Y0_FrameStrobe[1] latch
XFILLER_10_260 VPWR VGND sg13cmos5l_decap_8
XFILLER_11_783 VPWR VGND sg13cmos5l_fill_2
X_236_ _236_/Q Tile_X0Y0_UserCLK _236_/D _366_/L_HI VPWR VGND sg13cmos5l_dfrbpq_1
X_167_ _167_/Q Tile_X0Y0_FrameData[17] VGND VPWR Tile_X1Y0_FrameStrobe[1] latch
X_098_ _098_/X _233_/Q _249_/Q VPWR VGND sg13cmos5l_or2_1
XFILLER_6_275 VPWR VGND sg13cmos5l_fill_1
XFILLER_6_242 VPWR VGND sg13cmos5l_decap_8
XFILLER_2_492 VPWR VGND sg13cmos5l_decap_4
XFILLER_1_30 VPWR VGND sg13cmos5l_fill_1
XANTENNA__490__X Tile_X1Y0_FrameStrobe_O[11] VPWR VGND sg13cmos5l_antennanp
XFILLER_16_308 VPWR VGND sg13cmos5l_decap_8
XFILLER_12_569 VPWR VGND sg13cmos5l_decap_8
XFILLER_6_19 VPWR VGND sg13cmos5l_fill_1
XFILLER_4_702 VPWR VGND sg13cmos5l_fill_1
XFILLER_3_278 VPWR VGND sg13cmos5l_decap_4
XFILLER_11_591 VPWR VGND sg13cmos5l_decap_8
XFILLER_15_385 VPWR VGND sg13cmos5l_decap_8
X_219_ _219_/Q Tile_X0Y0_FrameData[29] VGND VPWR Tile_X1Y0_FrameStrobe[3] latch
XFILLER_18_0 VPWR VGND sg13cmos5l_decap_8
XANTENNA__485__X Tile_X1Y0_FrameStrobe_O[6] VPWR VGND sg13cmos5l_antennanp
XFILLER_15_28 VPWR VGND sg13cmos5l_decap_8
XFILLER_0_237 VPWR VGND sg13cmos5l_decap_8
XFILLER_1_749 VPWR VGND sg13cmos5l_decap_8
XANTENNA__395__X Tile_X0Y0_FrameStrobe_O[4] VPWR VGND sg13cmos5l_antennanp
XFILLER_16_105 VPWR VGND sg13cmos5l_decap_8
X_570_ _570_/X Tile_X0Y0_N2MID[2] Tile_X0Y0_N4END[13] Tile_X0Y0_NN4END[2] _091_/X
+ _329_/Q _328_/Q VPWR VGND sg13cmos5l_mux4_1
XFILLER_12_366 VPWR VGND sg13cmos5l_decap_8
XFILLER_4_532 VPWR VGND sg13cmos5l_decap_8
XFILLER_11_7 VPWR VGND sg13cmos5l_decap_8
XFILLER_15_182 VPWR VGND sg13cmos5l_decap_8
XFILLER_8_882 VPWR VGND sg13cmos5l_decap_8
XFILLER_7_392 VPWR VGND sg13cmos5l_decap_8
XFILLER_14_609 VPWR VGND sg13cmos5l_decap_8
XFILLER_13_119 VPWR VGND sg13cmos5l_decap_8
X_622_ _622_/X Tile_X1Y0_N2MID[6] Tile_X1Y0_N4END[1] Tile_X1Y0_NN4END[14] _064_/X
+ _176_/Q _175_/Q VPWR VGND sg13cmos5l_mux4_1
XFILLER_18_904 VPWR VGND sg13cmos5l_decap_8
XFILLER_17_469 VPWR VGND sg13cmos5l_decap_8
X_484_ Tile_X1Y0_FrameStrobe_O[5] Tile_X1Y0_FrameStrobe[5] VPWR VGND sg13cmos5l_buf_1
X_553_ _553_/X Tile_X0Y0_N2MID[2] Tile_X0Y0_N2END[5] Tile_X0Y0_N4END[10] Tile_X0Y0_NN4END[10]
+ _265_/Q _264_/Q VPWR VGND sg13cmos5l_mux4_1
XFILLER_18_959 VPWR VGND sg13cmos5l_fill_1
XFILLER_12_163 VPWR VGND sg13cmos5l_decap_8
XFILLER_8_145 VPWR VGND sg13cmos5l_fill_2
XFILLER_5_874 VPWR VGND sg13cmos5l_decap_8
XFILLER_4_373 VPWR VGND sg13cmos5l_fill_2
XFILLER_14_406 VPWR VGND sg13cmos5l_decap_8
XFILLER_15_929 VPWR VGND sg13cmos5l_decap_8
XFILLER_10_634 VPWR VGND sg13cmos5l_decap_8
X_605_ _605_/X Tile_X1Y0_N1END[1] Tile_X1Y0_N2MID[5] Tile_X1Y0_N2END[2] _089_/X _210_/Q
+ _209_/Q VPWR VGND sg13cmos5l_mux4_1
XFILLER_13_483 VPWR VGND sg13cmos5l_decap_8
XFILLER_17_266 VPWR VGND sg13cmos5l_decap_8
X_398_ Tile_X0Y0_FrameStrobe_O[7] Tile_X0Y0_FrameStrobe[7] VPWR VGND sg13cmos5l_buf_1
X_467_ Tile_X1Y0_FrameData_O[20] Tile_X0Y0_FrameData[20] VPWR VGND sg13cmos5l_buf_1
X_536_ Tile_X1Y0_SS4BEG[1] _625_/X VPWR VGND sg13cmos5l_buf_1
XFILLER_9_432 VPWR VGND sg13cmos5l_decap_8
XFILLER_4_74 VPWR VGND sg13cmos5l_decap_4
XFILLER_4_41 VPWR VGND sg13cmos5l_decap_8
XANTENNA__493__X Tile_X1Y0_FrameStrobe_O[14] VPWR VGND sg13cmos5l_antennanp
XFILLER_2_129 VPWR VGND sg13cmos5l_fill_2
XFILLER_11_921 VPWR VGND sg13cmos5l_decap_8
XFILLER_14_203 VPWR VGND sg13cmos5l_decap_8
X_321_ _321_/Q Tile_X0Y0_FrameData[0] VGND VPWR Tile_X0Y0_FrameStrobe[1] latch
X_252_ _252_/Q Tile_X0Y0_UserCLK _553_/X _371_/L_HI VPWR VGND sg13cmos5l_dfrbpq_1
XFILLER_10_442 VPWR VGND sg13cmos5l_decap_8
X_183_ _183_/Q Tile_X0Y0_FrameData[1] VGND VPWR Tile_X1Y0_FrameStrobe[1] latch
XFILLER_7_958 VPWR VGND sg13cmos5l_fill_2
XFILLER_7_936 VPWR VGND sg13cmos5l_fill_1
XFILLER_6_446 VPWR VGND sg13cmos5l_decap_8
XFILLER_2_696 VPWR VGND sg13cmos5l_decap_4
XFILLER_2_652 VPWR VGND sg13cmos5l_decap_8
XFILLER_1_162 VPWR VGND sg13cmos5l_fill_2
XFILLER_18_564 VPWR VGND sg13cmos5l_decap_8
XFILLER_18_542 VPWR VGND sg13cmos5l_fill_1
XFILLER_13_280 VPWR VGND sg13cmos5l_decap_8
X_519_ Tile_X1Y0_S4BEG[0] _608_/X VPWR VGND sg13cmos5l_buf_1
XANTENNA__488__X Tile_X1Y0_FrameStrobe_O[9] VPWR VGND sg13cmos5l_antennanp
XFILLER_18_28 VPWR VGND sg13cmos5l_decap_8
XANTENNA__398__X Tile_X0Y0_FrameStrobe_O[7] VPWR VGND sg13cmos5l_antennanp
XFILLER_3_438 VPWR VGND sg13cmos5l_decap_8
XFILLER_15_567 VPWR VGND sg13cmos5l_decap_8
X_304_ _304_/Q Tile_X0Y0_FrameData[17] VGND VPWR Tile_X0Y0_FrameStrobe[1] latch
X_235_ _235_/Q Tile_X0Y0_UserCLK _235_/D _368_/L_HI VPWR VGND sg13cmos5l_dfrbpq_1
XFILLER_7_711 VPWR VGND sg13cmos5l_fill_1
X_166_ _166_/Q Tile_X0Y0_FrameData[18] VGND VPWR Tile_X1Y0_FrameStrobe[1] latch
X_097_ _097_/X _257_/Q _558_/X _233_/Q VPWR VGND sg13cmos5l_mux2_1
XFILLER_7_755 VPWR VGND sg13cmos5l_fill_2
XFILLER_2_471 VPWR VGND sg13cmos5l_decap_8
XANTENNA_190 Tile_X0Y0_FrameData[2] VPWR VGND sg13cmos5l_antennanp
XFILLER_1_75 VPWR VGND sg13cmos5l_fill_1
XFILLER_18_383 VPWR VGND sg13cmos5l_decap_8
XFILLER_18_372 VPWR VGND sg13cmos5l_fill_1
XFILLER_1_909 VPWR VGND sg13cmos5l_decap_4
XFILLER_12_548 VPWR VGND sg13cmos5l_decap_8
XFILLER_15_364 VPWR VGND sg13cmos5l_decap_8
XFILLER_16_887 VPWR VGND sg13cmos5l_decap_8
XFILLER_11_570 VPWR VGND sg13cmos5l_decap_8
X_218_ _218_/Q Tile_X0Y0_FrameData[30] VGND VPWR Tile_X1Y0_FrameStrobe[3] latch
X_149_ _149_/Q Tile_X0Y0_FrameData[3] VGND VPWR Tile_X1Y0_FrameStrobe[0] latch
XFILLER_7_552 VPWR VGND sg13cmos5l_decap_8
XFILLER_0_216 VPWR VGND sg13cmos5l_decap_8
XFILLER_1_728 VPWR VGND sg13cmos5l_decap_8
XANTENNA_90 Tile_X0Y0_FrameData[23] VPWR VGND sg13cmos5l_antennanp
XFILLER_12_345 VPWR VGND sg13cmos5l_decap_8
XFILLER_9_817 VPWR VGND sg13cmos5l_fill_2
XFILLER_15_161 VPWR VGND sg13cmos5l_decap_8
XFILLER_16_695 VPWR VGND sg13cmos5l_fill_1
XANTENNA__496__X Tile_X1Y0_FrameStrobe_O[17] VPWR VGND sg13cmos5l_antennanp
XFILLER_1_536 VPWR VGND sg13cmos5l_decap_8
X_621_ _621_/X Tile_X1Y0_N2MID[5] Tile_X1Y0_N4END[2] Tile_X1Y0_NN4END[13] _095_/X
+ _178_/Q _177_/Q VPWR VGND sg13cmos5l_mux4_1
XFILLER_12_142 VPWR VGND sg13cmos5l_decap_8
XFILLER_17_448 VPWR VGND sg13cmos5l_decap_8
X_483_ Tile_X1Y0_FrameStrobe_O[4] Tile_X1Y0_FrameStrobe[4] VPWR VGND sg13cmos5l_buf_1
X_552_ _552_/X Tile_X0Y0_N2MID[0] Tile_X0Y0_N2END[7] Tile_X0Y0_N4END[8] Tile_X0Y0_NN4END[8]
+ _269_/Q _268_/Q VPWR VGND sg13cmos5l_mux4_1
XFILLER_8_124 VPWR VGND sg13cmos5l_decap_8
XFILLER_0_591 VPWR VGND sg13cmos5l_decap_8
XFILLER_15_908 VPWR VGND sg13cmos5l_decap_8
XFILLER_10_657 VPWR VGND sg13cmos5l_fill_1
XFILLER_5_116 VPWR VGND sg13cmos5l_decap_4
XFILLER_2_801 VPWR VGND sg13cmos5l_decap_8
XFILLER_17_245 VPWR VGND sg13cmos5l_decap_8
X_535_ Tile_X1Y0_SS4BEG[0] _624_/X VPWR VGND sg13cmos5l_buf_1
X_604_ _604_/X Tile_X1Y0_N1END[0] Tile_X1Y0_N2MID[4] Tile_X1Y0_N2END[3] _064_/X _212_/Q
+ _211_/Q VPWR VGND sg13cmos5l_mux4_1
XFILLER_18_724 VPWR VGND sg13cmos5l_fill_2
XFILLER_13_462 VPWR VGND sg13cmos5l_decap_8
X_397_ Tile_X0Y0_FrameStrobe_O[6] Tile_X0Y0_FrameStrobe[6] VPWR VGND sg13cmos5l_buf_1
X_466_ Tile_X1Y0_FrameData_O[19] Tile_X0Y0_FrameData[19] VPWR VGND sg13cmos5l_buf_1
XFILLER_9_411 VPWR VGND sg13cmos5l_decap_8
XFILLER_9_488 VPWR VGND sg13cmos5l_decap_8
XFILLER_5_694 VPWR VGND sg13cmos5l_decap_8
XFILLER_4_86 VPWR VGND sg13cmos5l_decap_4
XFILLER_2_108 VPWR VGND sg13cmos5l_decap_8
XFILLER_10_421 VPWR VGND sg13cmos5l_decap_8
XFILLER_11_900 VPWR VGND sg13cmos5l_decap_8
XFILLER_14_259 VPWR VGND sg13cmos5l_decap_8
X_320_ _320_/Q Tile_X0Y0_FrameData[1] VGND VPWR Tile_X0Y0_FrameStrobe[1] latch
X_251_ _251_/Q Tile_X0Y0_UserCLK _552_/X _374_/L_HI VPWR VGND sg13cmos5l_dfrbpq_1
X_182_ _182_/Q Tile_X0Y0_FrameData[2] VGND VPWR Tile_X1Y0_FrameStrobe[1] latch
XFILLER_10_498 VPWR VGND sg13cmos5l_decap_8
XFILLER_13_84 VPWR VGND sg13cmos5l_decap_8
XFILLER_8_0 VPWR VGND sg13cmos5l_decap_8
XFILLER_6_425 VPWR VGND sg13cmos5l_decap_8
XFILLER_2_620 VPWR VGND sg13cmos5l_fill_1
XANTENNA_350 Tile_X0Y0_FrameData[22] VPWR VGND sg13cmos5l_antennanp
X_518_ Tile_X1Y0_S2BEGb[7] _607_/X VPWR VGND sg13cmos5l_buf_1
X_449_ Tile_X1Y0_FrameData_O[2] Tile_X0Y0_FrameData[2] VPWR VGND sg13cmos5l_buf_1
XFILLER_9_263 VPWR VGND sg13cmos5l_decap_8
XFILLER_4_907 VPWR VGND sg13cmos5l_decap_8
XFILLER_1_7 VPWR VGND sg13cmos5l_decap_8
XFILLER_15_546 VPWR VGND sg13cmos5l_decap_8
XFILLER_10_273 VPWR VGND sg13cmos5l_fill_1
XFILLER_10_295 VPWR VGND sg13cmos5l_decap_8
X_303_ _303_/Q Tile_X0Y0_FrameData[18] VGND VPWR Tile_X0Y0_FrameStrobe[1] latch
X_234_ _234_/Q Tile_X0Y0_FrameData[27] VGND VPWR Tile_X1Y0_FrameStrobe[3] latch
X_165_ _165_/Q Tile_X0Y0_FrameData[19] VGND VPWR Tile_X1Y0_FrameStrobe[1] latch
XFILLER_7_767 VPWR VGND sg13cmos5l_decap_4
X_096_ _249_/D _646_/X _225_/Q _232_/Q VPWR VGND sg13cmos5l_mux2_1
XFILLER_6_266 VPWR VGND sg13cmos5l_decap_8
XFILLER_2_450 VPWR VGND sg13cmos5l_decap_8
XFILLER_18_351 VPWR VGND sg13cmos5l_decap_8
XANTENNA_180 Tile_X0Y0_FrameData[2] VPWR VGND sg13cmos5l_antennanp
XANTENNA_191 Tile_X0Y0_FrameData[2] VPWR VGND sg13cmos5l_antennanp
XANTENNA__499__X Tile_X1Y0_S1BEG[0] VPWR VGND sg13cmos5l_antennanp
XFILLER_12_527 VPWR VGND sg13cmos5l_decap_8
XFILLER_10_63 VPWR VGND sg13cmos5l_fill_2
XFILLER_10_96 VPWR VGND sg13cmos5l_decap_8
XFILLER_4_759 VPWR VGND sg13cmos5l_fill_1
XFILLER_3_214 VPWR VGND sg13cmos5l_decap_4
XFILLER_0_954 VPWR VGND sg13cmos5l_decap_4
XFILLER_15_343 VPWR VGND sg13cmos5l_decap_8
XFILLER_16_866 VPWR VGND sg13cmos5l_decap_8
X_217_ _217_/Q Tile_X0Y0_FrameData[31] VGND VPWR Tile_X1Y0_FrameStrobe[3] latch
X_148_ _148_/Q Tile_X0Y0_FrameData[4] VGND VPWR Tile_X1Y0_FrameStrobe[0] latch
XFILLER_7_597 VPWR VGND sg13cmos5l_decap_8
XFILLER_7_531 VPWR VGND sg13cmos5l_decap_8
X_079_ _246_/D _643_/X _228_/Q _232_/Q VPWR VGND sg13cmos5l_mux2_1
XFILLER_18_192 VPWR VGND sg13cmos5l_decap_8
XFILLER_12_324 VPWR VGND sg13cmos5l_decap_8
XFILLER_13_869 VPWR VGND sg13cmos5l_decap_8
XANTENNA_80 Tile_X0Y0_FrameData[23] VPWR VGND sg13cmos5l_antennanp
XANTENNA_91 Tile_X0Y0_FrameData[23] VPWR VGND sg13cmos5l_antennanp
XFILLER_8_317 VPWR VGND sg13cmos5l_fill_1
XFILLER_0_762 VPWR VGND sg13cmos5l_decap_8
XFILLER_4_567 VPWR VGND sg13cmos5l_decap_4
XFILLER_16_630 VPWR VGND sg13cmos5l_decap_8
XFILLER_15_140 VPWR VGND sg13cmos5l_decap_8
XFILLER_7_97 VPWR VGND sg13cmos5l_decap_4
XFILLER_7_361 VPWR VGND sg13cmos5l_fill_2
XFILLER_7_350 VPWR VGND sg13cmos5l_decap_8
XFILLER_17_427 VPWR VGND sg13cmos5l_decap_8
X_551_ Tile_X1Y0_UserCLKo Tile_X0Y0_UserCLK VPWR VGND sg13cmos5l_buf_1
X_620_ _620_/X Tile_X1Y0_N2MID[4] Tile_X1Y0_N4END[3] Tile_X1Y0_NN4END[12] _085_/X
+ _180_/Q _179_/Q VPWR VGND sg13cmos5l_mux4_1
XFILLER_12_121 VPWR VGND sg13cmos5l_decap_8
XFILLER_13_644 VPWR VGND sg13cmos5l_decap_8
XFILLER_16_84 VPWR VGND sg13cmos5l_decap_8
X_482_ Tile_X1Y0_FrameStrobe_O[3] Tile_X1Y0_FrameStrobe[3] VPWR VGND sg13cmos5l_buf_1
XFILLER_9_615 VPWR VGND sg13cmos5l_decap_8
XFILLER_12_198 VPWR VGND sg13cmos5l_decap_8
XFILLER_8_147 VPWR VGND sg13cmos5l_fill_1
XFILLER_5_854 VPWR VGND sg13cmos5l_fill_2
XFILLER_5_821 VPWR VGND sg13cmos5l_fill_1
XFILLER_4_375 VPWR VGND sg13cmos5l_fill_1
XFILLER_6_629 VPWR VGND sg13cmos5l_decap_8
XFILLER_17_224 VPWR VGND sg13cmos5l_decap_8
X_465_ Tile_X1Y0_FrameData_O[18] Tile_X0Y0_FrameData[18] VPWR VGND sg13cmos5l_buf_1
X_534_ Tile_X1Y0_S4BEG[15] _623_/X VPWR VGND sg13cmos5l_buf_1
X_603_ _603_/X Tile_X1Y0_N1END[3] Tile_X1Y0_N2MID[3] Tile_X1Y0_N2END[4] _095_/X _214_/Q
+ _213_/Q VPWR VGND sg13cmos5l_mux4_1
XFILLER_18_769 VPWR VGND sg13cmos5l_fill_2
XFILLER_13_441 VPWR VGND sg13cmos5l_decap_8
X_396_ Tile_X0Y0_FrameStrobe_O[5] Tile_X0Y0_FrameStrobe[5] VPWR VGND sg13cmos5l_buf_1
XFILLER_9_467 VPWR VGND sg13cmos5l_decap_8
XANTENNA__104__Y PMOD_IO_OE_O5 VPWR VGND sg13cmos5l_antennanp
XFILLER_14_238 VPWR VGND sg13cmos5l_decap_8
XFILLER_10_400 VPWR VGND sg13cmos5l_decap_8
XFILLER_10_477 VPWR VGND sg13cmos5l_decap_8
XFILLER_13_63 VPWR VGND sg13cmos5l_decap_8
X_250_ _250_/Q Tile_X0Y0_UserCLK _250_/D _373_/L_HI VPWR VGND sg13cmos5l_dfrbpq_1
X_181_ _181_/Q Tile_X0Y0_FrameData[3] VGND VPWR Tile_X1Y0_FrameStrobe[1] latch
XFILLER_7_916 VPWR VGND sg13cmos5l_decap_8
XFILLER_6_404 VPWR VGND sg13cmos5l_decap_8
XFILLER_2_665 VPWR VGND sg13cmos5l_decap_4
XFILLER_1_164 VPWR VGND sg13cmos5l_fill_1
XANTENNA_340 Tile_X1Y0_N4END[11] VPWR VGND sg13cmos5l_antennanp
XANTENNA_351 Tile_X0Y0_FrameData[22] VPWR VGND sg13cmos5l_antennanp
X_448_ Tile_X1Y0_FrameData_O[1] Tile_X0Y0_FrameData[1] VPWR VGND sg13cmos5l_buf_1
X_517_ Tile_X1Y0_S2BEGb[6] _606_/X VPWR VGND sg13cmos5l_buf_1
XFILLER_18_555 VPWR VGND sg13cmos5l_decap_4
X_379_ Tile_X0Y0_SS4BEG[4] _588_/X VPWR VGND sg13cmos5l_buf_1
XFILLER_9_220 VPWR VGND sg13cmos5l_fill_1
XFILLER_11_219 VPWR VGND sg13cmos5l_decap_8
XFILLER_15_525 VPWR VGND sg13cmos5l_decap_8
X_302_ _302_/Q Tile_X0Y0_FrameData[19] VGND VPWR Tile_X0Y0_FrameStrobe[1] latch
XFILLER_11_742 VPWR VGND sg13cmos5l_decap_8
XFILLER_11_753 VPWR VGND sg13cmos5l_fill_1
XFILLER_11_764 VPWR VGND sg13cmos5l_fill_2
X_233_ _233_/Q Tile_X0Y0_FrameData[26] VGND VPWR Tile_X1Y0_FrameStrobe[3] latch
X_164_ _164_/Q Tile_X0Y0_FrameData[20] VGND VPWR Tile_X1Y0_FrameStrobe[1] latch
X_095_ _095_/X _241_/Q _241_/D _234_/Q VPWR VGND sg13cmos5l_mux2_1
XFILLER_6_256 VPWR VGND sg13cmos5l_fill_2
XFILLER_6_212 VPWR VGND sg13cmos5l_fill_1
XFILLER_18_330 VPWR VGND sg13cmos5l_decap_8
XANTENNA_170 Tile_X0Y0_FrameData[2] VPWR VGND sg13cmos5l_antennanp
XANTENNA_181 Tile_X0Y0_FrameData[2] VPWR VGND sg13cmos5l_antennanp
XANTENNA_192 Tile_X0Y0_FrameData[2] VPWR VGND sg13cmos5l_antennanp
XFILLER_12_506 VPWR VGND sg13cmos5l_decap_8
XFILLER_10_42 VPWR VGND sg13cmos5l_decap_8
XFILLER_10_75 VPWR VGND sg13cmos5l_decap_8
XFILLER_3_226 VPWR VGND sg13cmos5l_decap_4
XFILLER_15_322 VPWR VGND sg13cmos5l_decap_8
XFILLER_15_399 VPWR VGND sg13cmos5l_decap_8
X_216_ _216_/Q Tile_X0Y0_FrameData[0] VGND VPWR Tile_X1Y0_FrameStrobe[2] latch
X_147_ _147_/Q Tile_X0Y0_FrameData[5] VGND VPWR Tile_X1Y0_FrameStrobe[0] latch
X_078_ _248_/D _645_/X _226_/Q _232_/Q VPWR VGND sg13cmos5l_mux2_1
XFILLER_7_576 VPWR VGND sg13cmos5l_decap_8
XANTENNA__112__Y PMOD_IO_O2 VPWR VGND sg13cmos5l_antennanp
XFILLER_16_119 VPWR VGND sg13cmos5l_decap_8
XFILLER_17_609 VPWR VGND sg13cmos5l_decap_8
XFILLER_12_303 VPWR VGND sg13cmos5l_decap_8
XFILLER_13_848 VPWR VGND sg13cmos5l_decap_8
XFILLER_9_819 VPWR VGND sg13cmos5l_fill_1
XANTENNA_70 Tile_X0Y0_FrameData[23] VPWR VGND sg13cmos5l_antennanp
XANTENNA_81 Tile_X0Y0_FrameData[23] VPWR VGND sg13cmos5l_antennanp
XANTENNA_92 Tile_X0Y0_FrameData[23] VPWR VGND sg13cmos5l_antennanp
XFILLER_8_329 VPWR VGND sg13cmos5l_fill_2
XFILLER_4_546 VPWR VGND sg13cmos5l_decap_8
XFILLER_0_774 VPWR VGND sg13cmos5l_decap_4
XFILLER_0_785 VPWR VGND sg13cmos5l_fill_2
XFILLER_11_380 VPWR VGND sg13cmos5l_decap_8
XFILLER_12_881 VPWR VGND sg13cmos5l_fill_2
XFILLER_15_196 VPWR VGND sg13cmos5l_decap_8
XFILLER_8_852 VPWR VGND sg13cmos5l_decap_8
XFILLER_8_830 VPWR VGND sg13cmos5l_fill_1
XFILLER_7_21 VPWR VGND sg13cmos5l_decap_8
XFILLER_8_896 VPWR VGND sg13cmos5l_decap_8
XFILLER_7_76 VPWR VGND sg13cmos5l_decap_8
XFILLER_16_0 VPWR VGND sg13cmos5l_decap_8
XFILLER_17_406 VPWR VGND sg13cmos5l_decap_8
X_481_ Tile_X1Y0_FrameStrobe_O[2] Tile_X1Y0_FrameStrobe[2] VPWR VGND sg13cmos5l_buf_1
X_550_ Tile_X1Y0_SS4BEG[15] _639_/X VPWR VGND sg13cmos5l_buf_1
XFILLER_18_918 VPWR VGND sg13cmos5l_decap_4
XFILLER_12_100 VPWR VGND sg13cmos5l_decap_8
XFILLER_12_177 VPWR VGND sg13cmos5l_decap_8
XFILLER_13_623 VPWR VGND sg13cmos5l_decap_8
XFILLER_13_689 VPWR VGND sg13cmos5l_decap_4
XFILLER_16_63 VPWR VGND sg13cmos5l_decap_8
XFILLER_5_888 VPWR VGND sg13cmos5l_decap_8
XFILLER_4_387 VPWR VGND sg13cmos5l_fill_2
XFILLER_4_354 VPWR VGND sg13cmos5l_fill_1
XFILLER_16_483 VPWR VGND sg13cmos5l_decap_8
XFILLER_17_940 VPWR VGND sg13cmos5l_decap_8
XFILLER_8_693 VPWR VGND sg13cmos5l_fill_1
XFILLER_8_682 VPWR VGND sg13cmos5l_decap_8
XFILLER_10_648 VPWR VGND sg13cmos5l_decap_8
XFILLER_2_858 VPWR VGND sg13cmos5l_decap_8
XFILLER_17_203 VPWR VGND sg13cmos5l_decap_8
X_602_ _602_/X Tile_X1Y0_N1END[2] Tile_X1Y0_N2MID[2] Tile_X1Y0_N2END[5] _085_/X _216_/Q
+ _215_/Q VPWR VGND sg13cmos5l_mux4_1
XFILLER_13_420 VPWR VGND sg13cmos5l_decap_8
X_464_ Tile_X1Y0_FrameData_O[17] Tile_X0Y0_FrameData[17] VPWR VGND sg13cmos5l_buf_1
X_533_ Tile_X1Y0_S4BEG[14] _622_/X VPWR VGND sg13cmos5l_buf_1
XFILLER_13_497 VPWR VGND sg13cmos5l_decap_8
X_395_ Tile_X0Y0_FrameStrobe_O[4] Tile_X0Y0_FrameStrobe[4] VPWR VGND sg13cmos5l_buf_1
XFILLER_9_446 VPWR VGND sg13cmos5l_decap_8
XANTENNA__401__X Tile_X0Y0_FrameStrobe_O[10] VPWR VGND sg13cmos5l_antennanp
XFILLER_4_55 VPWR VGND sg13cmos5l_decap_8
XFILLER_4_195 VPWR VGND sg13cmos5l_decap_8
XFILLER_4_162 VPWR VGND sg13cmos5l_decap_8
XFILLER_16_280 VPWR VGND sg13cmos5l_decap_8
XFILLER_14_217 VPWR VGND sg13cmos5l_decap_8
XFILLER_10_456 VPWR VGND sg13cmos5l_decap_8
XFILLER_11_935 VPWR VGND sg13cmos5l_decap_4
XFILLER_13_42 VPWR VGND sg13cmos5l_decap_8
X_180_ _180_/Q Tile_X0Y0_FrameData[4] VGND VPWR Tile_X1Y0_FrameStrobe[1] latch
XFILLER_18_512 VPWR VGND sg13cmos5l_fill_2
XANTENNA_330 Tile_X0Y0_NN4END[11] VPWR VGND sg13cmos5l_antennanp
XANTENNA_341 Tile_X1Y0_N4END[11] VPWR VGND sg13cmos5l_antennanp
XANTENNA_352 Tile_X0Y0_FrameData[22] VPWR VGND sg13cmos5l_antennanp
XFILLER_13_294 VPWR VGND sg13cmos5l_decap_8
X_378_ Tile_X0Y0_SS4BEG[3] _587_/X VPWR VGND sg13cmos5l_buf_1
X_447_ Tile_X1Y0_FrameData_O[0] Tile_X0Y0_FrameData[0] VPWR VGND sg13cmos5l_buf_1
X_516_ Tile_X1Y0_S2BEGb[5] _605_/X VPWR VGND sg13cmos5l_buf_1
XANTENNA__115__Y PMOD_IO_O5 VPWR VGND sg13cmos5l_antennanp
XFILLER_5_460 VPWR VGND sg13cmos5l_decap_8
XFILLER_15_504 VPWR VGND sg13cmos5l_decap_8
X_301_ _301_/Q Tile_X0Y0_FrameData[20] VGND VPWR Tile_X0Y0_FrameStrobe[1] latch
X_232_ _232_/Q Tile_X0Y0_FrameData[25] VGND VPWR Tile_X1Y0_FrameStrobe[3] latch
XFILLER_11_776 VPWR VGND sg13cmos5l_decap_4
X_163_ _163_/Q Tile_X0Y0_FrameData[21] VGND VPWR Tile_X1Y0_FrameStrobe[1] latch
X_094_ _241_/D PMOD_IO_I6 _558_/X _222_/Q VPWR VGND sg13cmos5l_mux2_1
XFILLER_2_496 VPWR VGND sg13cmos5l_fill_1
XFILLER_2_485 VPWR VGND sg13cmos5l_decap_8
XANTENNA_160 Tile_X0Y0_FrameData[27] VPWR VGND sg13cmos5l_antennanp
XFILLER_18_397 VPWR VGND sg13cmos5l_fill_1
XANTENNA_171 Tile_X0Y0_FrameData[2] VPWR VGND sg13cmos5l_antennanp
XANTENNA_182 Tile_X0Y0_FrameData[2] VPWR VGND sg13cmos5l_antennanp
XANTENNA_193 Tile_X0Y0_FrameData[2] VPWR VGND sg13cmos5l_antennanp
XFILLER_14_581 VPWR VGND sg13cmos5l_decap_8
XFILLER_10_21 VPWR VGND sg13cmos5l_decap_8
XFILLER_10_65 VPWR VGND sg13cmos5l_fill_1
XFILLER_15_301 VPWR VGND sg13cmos5l_decap_8
XFILLER_11_584 VPWR VGND sg13cmos5l_decap_8
XFILLER_15_378 VPWR VGND sg13cmos5l_decap_8
X_215_ _215_/Q Tile_X0Y0_FrameData[1] VGND VPWR Tile_X1Y0_FrameStrobe[2] latch
X_146_ _146_/Q Tile_X0Y0_FrameData[6] VGND VPWR Tile_X1Y0_FrameStrobe[0] latch
X_077_ PMOD_IO_OE_O4 _223_/Q _074_/X _076_/Y VPWR VGND sg13cmos5l_a21oi_1
XFILLER_3_750 VPWR VGND sg13cmos5l_decap_8
XFILLER_18_161 VPWR VGND sg13cmos5l_decap_8
XFILLER_12_359 VPWR VGND sg13cmos5l_decap_8
XANTENNA_60 Tile_X0Y0_FrameData[23] VPWR VGND sg13cmos5l_antennanp
XANTENNA_71 Tile_X0Y0_FrameData[23] VPWR VGND sg13cmos5l_antennanp
XANTENNA_82 Tile_X0Y0_FrameData[23] VPWR VGND sg13cmos5l_antennanp
XANTENNA_93 Tile_X0Y0_FrameData[23] VPWR VGND sg13cmos5l_antennanp
XFILLER_4_525 VPWR VGND sg13cmos5l_decap_8
XFILLER_0_797 VPWR VGND sg13cmos5l_fill_2
XFILLER_15_175 VPWR VGND sg13cmos5l_decap_8
XFILLER_16_654 VPWR VGND sg13cmos5l_decap_4
XANTENNA__404__X Tile_X0Y0_FrameStrobe_O[13] VPWR VGND sg13cmos5l_antennanp
XFILLER_8_875 VPWR VGND sg13cmos5l_decap_8
XFILLER_8_842 VPWR VGND sg13cmos5l_fill_2
XFILLER_7_374 VPWR VGND sg13cmos5l_fill_1
X_129_ _129_/Q Tile_X0Y0_FrameData[23] VGND VPWR Tile_X1Y0_FrameStrobe[0] latch
XFILLER_7_385 VPWR VGND sg13cmos5l_decap_8
XFILLER_10_808 VPWR VGND sg13cmos5l_decap_8
XFILLER_13_602 VPWR VGND sg13cmos5l_decap_8
XFILLER_16_42 VPWR VGND sg13cmos5l_decap_8
X_480_ Tile_X1Y0_FrameStrobe_O[1] Tile_X1Y0_FrameStrobe[1] VPWR VGND sg13cmos5l_buf_1
XFILLER_12_156 VPWR VGND sg13cmos5l_decap_8
XFILLER_8_138 VPWR VGND sg13cmos5l_decap_8
XFILLER_5_867 VPWR VGND sg13cmos5l_decap_8
XFILLER_4_366 VPWR VGND sg13cmos5l_decap_8
XFILLER_0_572 VPWR VGND sg13cmos5l_decap_8
XFILLER_16_462 VPWR VGND sg13cmos5l_decap_8
XFILLER_7_193 VPWR VGND sg13cmos5l_decap_8
XFILLER_2_815 VPWR VGND sg13cmos5l_decap_8
X_601_ _601_/X Tile_X1Y0_N1END[1] Tile_X1Y0_N2MID[1] Tile_X1Y0_N2END[6] _087_/X _218_/Q
+ _217_/Q VPWR VGND sg13cmos5l_mux4_1
XFILLER_18_716 VPWR VGND sg13cmos5l_fill_2
XFILLER_13_476 VPWR VGND sg13cmos5l_decap_8
XFILLER_14_911 VPWR VGND sg13cmos5l_decap_8
XFILLER_17_259 VPWR VGND sg13cmos5l_decap_8
X_394_ Tile_X0Y0_FrameStrobe_O[3] Tile_X0Y0_FrameStrobe[3] VPWR VGND sg13cmos5l_buf_1
X_463_ Tile_X1Y0_FrameData_O[16] Tile_X0Y0_FrameData[16] VPWR VGND sg13cmos5l_buf_1
X_532_ Tile_X1Y0_S4BEG[13] _621_/X VPWR VGND sg13cmos5l_buf_1
XFILLER_9_425 VPWR VGND sg13cmos5l_decap_8
XFILLER_4_78 VPWR VGND sg13cmos5l_fill_1
XFILLER_4_67 VPWR VGND sg13cmos5l_decap_8
XFILLER_4_34 VPWR VGND sg13cmos5l_decap_8
XFILLER_11_914 VPWR VGND sg13cmos5l_decap_8
XFILLER_10_435 VPWR VGND sg13cmos5l_decap_8
XFILLER_11_958 VPWR VGND sg13cmos5l_fill_2
XFILLER_13_21 VPWR VGND sg13cmos5l_decap_8
XFILLER_13_98 VPWR VGND sg13cmos5l_decap_8
XFILLER_6_439 VPWR VGND sg13cmos5l_decap_8
XANTENNA__502__X Tile_X1Y0_S1BEG[3] VPWR VGND sg13cmos5l_antennanp
XFILLER_1_155 VPWR VGND sg13cmos5l_decap_8
XANTENNA_320 Tile_X0Y0_FrameData[7] VPWR VGND sg13cmos5l_antennanp
XANTENNA_331 Tile_X0Y0_NN4END[11] VPWR VGND sg13cmos5l_antennanp
XANTENNA_342 Tile_X1Y0_N4END[11] VPWR VGND sg13cmos5l_antennanp
X_515_ Tile_X1Y0_S2BEGb[4] _604_/X VPWR VGND sg13cmos5l_buf_1
XFILLER_18_546 VPWR VGND sg13cmos5l_decap_4
XFILLER_18_535 VPWR VGND sg13cmos5l_decap_8
XANTENNA_353 Tile_X0Y0_FrameData[22] VPWR VGND sg13cmos5l_antennanp
XFILLER_13_273 VPWR VGND sg13cmos5l_decap_8
XFILLER_14_741 VPWR VGND sg13cmos5l_fill_1
XFILLER_14_752 VPWR VGND sg13cmos5l_fill_1
X_377_ Tile_X0Y0_SS4BEG[2] _586_/X VPWR VGND sg13cmos5l_buf_1
X_446_ Tile_X0Y0_S4BEG[15] _583_/X VPWR VGND sg13cmos5l_buf_1
XANTENNA__412__X Tile_X0Y0_S1BEG[1] VPWR VGND sg13cmos5l_antennanp
XFILLER_10_232 VPWR VGND sg13cmos5l_decap_8
XFILLER_10_243 VPWR VGND sg13cmos5l_fill_2
XFILLER_11_700 VPWR VGND sg13cmos5l_fill_2
X_300_ _300_/Q Tile_X0Y0_FrameData[21] VGND VPWR Tile_X0Y0_FrameStrobe[1] latch
X_231_ _231_/Q Tile_X0Y0_FrameData[24] VGND VPWR Tile_X1Y0_FrameStrobe[3] latch
X_162_ _162_/Q Tile_X0Y0_FrameData[22] VGND VPWR Tile_X1Y0_FrameStrobe[1] latch
XFILLER_7_704 VPWR VGND sg13cmos5l_decap_8
X_093_ _244_/D _641_/X _230_/Q _232_/Q VPWR VGND sg13cmos5l_mux2_1
XFILLER_6_258 VPWR VGND sg13cmos5l_fill_1
XFILLER_6_0 VPWR VGND sg13cmos5l_decap_8
XFILLER_2_464 VPWR VGND sg13cmos5l_decap_8
XFILLER_1_35 VPWR VGND sg13cmos5l_fill_2
XANTENNA_150 Tile_X0Y0_FrameData[27] VPWR VGND sg13cmos5l_antennanp
XANTENNA_161 Tile_X0Y0_FrameData[27] VPWR VGND sg13cmos5l_antennanp
XANTENNA_172 Tile_X0Y0_FrameData[2] VPWR VGND sg13cmos5l_antennanp
XANTENNA_183 Tile_X0Y0_FrameData[2] VPWR VGND sg13cmos5l_antennanp
XANTENNA_194 Tile_X0Y0_FrameData[2] VPWR VGND sg13cmos5l_antennanp
XFILLER_1_68 VPWR VGND sg13cmos5l_decap_8
XFILLER_18_376 VPWR VGND sg13cmos5l_decap_8
XFILLER_18_365 VPWR VGND sg13cmos5l_decap_8
XANTENNA__407__X Tile_X0Y0_FrameStrobe_O[16] VPWR VGND sg13cmos5l_antennanp
XFILLER_14_560 VPWR VGND sg13cmos5l_decap_8
X_429_ Tile_X0Y0_S2BEGb[6] _566_/X VPWR VGND sg13cmos5l_buf_1
XFILLER_15_357 VPWR VGND sg13cmos5l_decap_8
XFILLER_16_847 VPWR VGND sg13cmos5l_fill_2
XFILLER_11_563 VPWR VGND sg13cmos5l_decap_8
X_214_ _214_/Q Tile_X0Y0_FrameData[2] VGND VPWR Tile_X1Y0_FrameStrobe[2] latch
X_145_ _145_/Q Tile_X0Y0_FrameData[7] VGND VPWR Tile_X1Y0_FrameStrobe[0] latch
XFILLER_7_567 VPWR VGND sg13cmos5l_decap_4
XFILLER_7_545 VPWR VGND sg13cmos5l_decap_8
X_076_ _076_/Y _120_/A _247_/D _075_/X VPWR VGND sg13cmos5l_o21ai_1
XFILLER_2_261 VPWR VGND sg13cmos5l_decap_8
XFILLER_18_151 VPWR VGND sg13cmos5l_decap_8
XFILLER_15_880 VPWR VGND sg13cmos5l_decap_8
XFILLER_0_209 VPWR VGND sg13cmos5l_decap_8
XANTENNA_50 Tile_X0Y0_FrameData[23] VPWR VGND sg13cmos5l_antennanp
XANTENNA_61 Tile_X0Y0_FrameData[23] VPWR VGND sg13cmos5l_antennanp
XANTENNA_72 Tile_X0Y0_FrameData[23] VPWR VGND sg13cmos5l_antennanp
XANTENNA_83 Tile_X0Y0_FrameData[23] VPWR VGND sg13cmos5l_antennanp
XFILLER_12_338 VPWR VGND sg13cmos5l_decap_8
XANTENNA_94 Tile_X0Y0_FrameData[23] VPWR VGND sg13cmos5l_antennanp
XFILLER_0_732 VPWR VGND sg13cmos5l_decap_8
XANTENNA__510__X Tile_X1Y0_S2BEG[7] VPWR VGND sg13cmos5l_antennanp
XFILLER_0_787 VPWR VGND sg13cmos5l_fill_1
XFILLER_15_154 VPWR VGND sg13cmos5l_decap_8
XFILLER_16_644 VPWR VGND sg13cmos5l_decap_4
XFILLER_12_883 VPWR VGND sg13cmos5l_fill_1
XFILLER_12_894 VPWR VGND sg13cmos5l_decap_8
X_128_ _128_/Q Tile_X0Y0_FrameData[24] VGND VPWR Tile_X1Y0_FrameStrobe[0] latch
XANTENNA__420__X Tile_X0Y0_S2BEG[5] VPWR VGND sg13cmos5l_antennanp
X_059_ _059_/Y _246_/Q VPWR VGND sg13cmos5l_inv_1
XFILLER_1_529 VPWR VGND sg13cmos5l_decap_8
XFILLER_1_507 VPWR VGND sg13cmos5l_decap_8
XFILLER_12_135 VPWR VGND sg13cmos5l_decap_8
XFILLER_16_21 VPWR VGND sg13cmos5l_decap_8
XFILLER_16_98 VPWR VGND sg13cmos5l_decap_8
XANTENNA__505__X Tile_X1Y0_S2BEG[2] VPWR VGND sg13cmos5l_antennanp
XFILLER_8_117 VPWR VGND sg13cmos5l_decap_8
XFILLER_5_802 VPWR VGND sg13cmos5l_decap_8
XFILLER_16_441 VPWR VGND sg13cmos5l_decap_8
XANTENNA__415__X Tile_X0Y0_S2BEG[0] VPWR VGND sg13cmos5l_antennanp
XFILLER_7_161 VPWR VGND sg13cmos5l_decap_8
XFILLER_17_238 VPWR VGND sg13cmos5l_decap_8
X_531_ Tile_X1Y0_S4BEG[12] _620_/X VPWR VGND sg13cmos5l_buf_1
X_600_ _600_/X Tile_X1Y0_N1END[0] Tile_X1Y0_N2MID[0] Tile_X1Y0_N2END[7] _089_/X _220_/Q
+ _219_/Q VPWR VGND sg13cmos5l_mux4_1
XFILLER_13_455 VPWR VGND sg13cmos5l_decap_8
X_393_ Tile_X0Y0_FrameStrobe_O[2] Tile_X0Y0_FrameStrobe[2] VPWR VGND sg13cmos5l_buf_1
X_462_ Tile_X1Y0_FrameData_O[15] Tile_X0Y0_FrameData[15] VPWR VGND sg13cmos5l_buf_1
XFILLER_9_404 VPWR VGND sg13cmos5l_decap_8
XFILLER_5_687 VPWR VGND sg13cmos5l_decap_8
XFILLER_4_120 VPWR VGND sg13cmos5l_decap_8
XFILLER_1_871 VPWR VGND sg13cmos5l_fill_2
XFILLER_17_794 VPWR VGND sg13cmos5l_fill_2
XFILLER_10_414 VPWR VGND sg13cmos5l_decap_8
XFILLER_13_77 VPWR VGND sg13cmos5l_decap_8
XFILLER_6_418 VPWR VGND sg13cmos5l_decap_8
XFILLER_2_613 VPWR VGND sg13cmos5l_decap_8
XFILLER_1_178 VPWR VGND sg13cmos5l_fill_1
XANTENNA_310 Tile_X0Y0_FrameData[7] VPWR VGND sg13cmos5l_antennanp
XANTENNA_321 Tile_X0Y0_N2END[5] VPWR VGND sg13cmos5l_antennanp
XANTENNA_332 Tile_X0Y0_NN4END[11] VPWR VGND sg13cmos5l_antennanp
XANTENNA_343 Tile_X1Y0_N4END[11] VPWR VGND sg13cmos5l_antennanp
XANTENNA_354 Tile_X0Y0_FrameData[22] VPWR VGND sg13cmos5l_antennanp
X_514_ Tile_X1Y0_S2BEGb[3] _603_/X VPWR VGND sg13cmos5l_buf_1
XFILLER_18_525 VPWR VGND sg13cmos5l_decap_8
XFILLER_18_514 VPWR VGND sg13cmos5l_fill_1
XFILLER_13_252 VPWR VGND sg13cmos5l_decap_8
X_376_ Tile_X0Y0_SS4BEG[1] _585_/X VPWR VGND sg13cmos5l_buf_1
X_445_ Tile_X0Y0_S4BEG[14] _582_/X VPWR VGND sg13cmos5l_buf_1
XFILLER_9_256 VPWR VGND sg13cmos5l_decap_8
XFILLER_15_539 VPWR VGND sg13cmos5l_decap_8
X_230_ _230_/Q Tile_X0Y0_FrameData[23] VGND VPWR Tile_X1Y0_FrameStrobe[3] latch
X_161_ _161_/Q Tile_X0Y0_FrameData[23] VGND VPWR Tile_X1Y0_FrameStrobe[1] latch
XANTENNA__513__X Tile_X1Y0_S2BEGb[2] VPWR VGND sg13cmos5l_antennanp
XFILLER_10_288 VPWR VGND sg13cmos5l_decap_8
X_092_ _092_/X _235_/Q _235_/D _234_/Q VPWR VGND sg13cmos5l_mux2_1
XFILLER_3_911 VPWR VGND sg13cmos5l_decap_8
XFILLER_2_443 VPWR VGND sg13cmos5l_decap_8
XFILLER_1_14 VPWR VGND sg13cmos5l_decap_8
XFILLER_18_344 VPWR VGND sg13cmos5l_decap_8
XANTENNA_140 Tile_X0Y0_FrameData[27] VPWR VGND sg13cmos5l_antennanp
XANTENNA_151 Tile_X0Y0_FrameData[27] VPWR VGND sg13cmos5l_antennanp
XANTENNA_162 Tile_X0Y0_FrameData[27] VPWR VGND sg13cmos5l_antennanp
XANTENNA_173 Tile_X0Y0_FrameData[2] VPWR VGND sg13cmos5l_antennanp
XANTENNA_184 Tile_X0Y0_FrameData[2] VPWR VGND sg13cmos5l_antennanp
XANTENNA_195 Tile_X0Y0_FrameData[2] VPWR VGND sg13cmos5l_antennanp
X_428_ Tile_X0Y0_S2BEGb[5] _565_/X VPWR VGND sg13cmos5l_buf_1
XANTENNA__423__X Tile_X0Y0_S2BEGb[0] VPWR VGND sg13cmos5l_antennanp
X_359_ _359_/L_HI VPWR VGND sg13cmos5l_tiehi
XFILLER_0_903 VPWR VGND sg13cmos5l_decap_4
XFILLER_10_56 VPWR VGND sg13cmos5l_decap_8
XFILLER_3_218 VPWR VGND sg13cmos5l_fill_1
XFILLER_3_207 VPWR VGND sg13cmos5l_decap_8
XFILLER_0_958 VPWR VGND sg13cmos5l_fill_2
XFILLER_10_89 VPWR VGND sg13cmos5l_decap_8
XANTENNA__508__X Tile_X1Y0_S2BEG[5] VPWR VGND sg13cmos5l_antennanp
XFILLER_15_336 VPWR VGND sg13cmos5l_decap_8
XFILLER_16_804 VPWR VGND sg13cmos5l_fill_2
XFILLER_16_859 VPWR VGND sg13cmos5l_decap_8
XFILLER_11_542 VPWR VGND sg13cmos5l_decap_8
X_213_ _213_/Q Tile_X0Y0_FrameData[3] VGND VPWR Tile_X1Y0_FrameStrobe[2] latch
X_144_ _144_/Q Tile_X0Y0_FrameData[8] VGND VPWR Tile_X1Y0_FrameStrobe[0] latch
X_075_ _075_/X _233_/Q _247_/Q VPWR VGND sg13cmos5l_or2_1
XFILLER_7_524 VPWR VGND sg13cmos5l_decap_8
XFILLER_2_240 VPWR VGND sg13cmos5l_decap_8
XFILLER_18_185 VPWR VGND sg13cmos5l_decap_8
XANTENNA__418__X Tile_X0Y0_S2BEG[3] VPWR VGND sg13cmos5l_antennanp
XFILLER_12_317 VPWR VGND sg13cmos5l_decap_8
XFILLER_13_818 VPWR VGND sg13cmos5l_fill_2
XANTENNA_40 Tile_X0Y0_FrameData[1] VPWR VGND sg13cmos5l_antennanp
XANTENNA_51 Tile_X0Y0_FrameData[23] VPWR VGND sg13cmos5l_antennanp
XANTENNA_62 Tile_X0Y0_FrameData[23] VPWR VGND sg13cmos5l_antennanp
XANTENNA_73 Tile_X0Y0_FrameData[23] VPWR VGND sg13cmos5l_antennanp
XANTENNA_84 Tile_X0Y0_FrameData[23] VPWR VGND sg13cmos5l_antennanp
XANTENNA_95 Tile_X0Y0_FrameData[23] VPWR VGND sg13cmos5l_antennanp
XFILLER_0_799 VPWR VGND sg13cmos5l_fill_1
XFILLER_16_623 VPWR VGND sg13cmos5l_decap_8
XFILLER_12_862 VPWR VGND sg13cmos5l_decap_8
XFILLER_15_133 VPWR VGND sg13cmos5l_decap_8
XFILLER_11_394 VPWR VGND sg13cmos5l_decap_8
X_127_ _127_/Q Tile_X0Y0_FrameData[25] VGND VPWR Tile_X1Y0_FrameStrobe[0] latch
X_058_ _058_/Y _245_/Q VPWR VGND sg13cmos5l_inv_1
XFILLER_8_866 VPWR VGND sg13cmos5l_fill_2
XFILLER_8_844 VPWR VGND sg13cmos5l_fill_1
XFILLER_7_35 VPWR VGND sg13cmos5l_fill_2
XFILLER_7_343 VPWR VGND sg13cmos5l_decap_8
XFILLER_12_114 VPWR VGND sg13cmos5l_decap_8
XFILLER_13_637 VPWR VGND sg13cmos5l_decap_8
XFILLER_16_77 VPWR VGND sg13cmos5l_decap_8
XFILLER_9_608 VPWR VGND sg13cmos5l_decap_8
XFILLER_4_302 VPWR VGND sg13cmos5l_decap_8
XANTENNA__521__X Tile_X1Y0_S4BEG[2] VPWR VGND sg13cmos5l_antennanp
XFILLER_16_420 VPWR VGND sg13cmos5l_decap_8
XFILLER_17_954 VPWR VGND sg13cmos5l_decap_4
XFILLER_11_191 VPWR VGND sg13cmos5l_decap_8
XFILLER_16_497 VPWR VGND sg13cmos5l_decap_8
XANTENNA__431__X Tile_X0Y0_S4BEG[0] VPWR VGND sg13cmos5l_antennanp
XFILLER_4_891 VPWR VGND sg13cmos5l_decap_8
XFILLER_14_0 VPWR VGND sg13cmos5l_decap_8
XFILLER_17_217 VPWR VGND sg13cmos5l_decap_8
X_461_ Tile_X1Y0_FrameData_O[14] Tile_X0Y0_FrameData[14] VPWR VGND sg13cmos5l_buf_1
X_530_ Tile_X1Y0_S4BEG[11] _619_/X VPWR VGND sg13cmos5l_buf_1
XFILLER_18_718 VPWR VGND sg13cmos5l_fill_1
XANTENNA__516__X Tile_X1Y0_S2BEGb[5] VPWR VGND sg13cmos5l_antennanp
XFILLER_13_434 VPWR VGND sg13cmos5l_decap_8
X_392_ Tile_X0Y0_FrameStrobe_O[1] Tile_X0Y0_FrameStrobe[1] VPWR VGND sg13cmos5l_buf_1
XFILLER_5_633 VPWR VGND sg13cmos5l_fill_2
XANTENNA__426__X Tile_X0Y0_S2BEGb[3] VPWR VGND sg13cmos5l_antennanp
XFILLER_16_294 VPWR VGND sg13cmos5l_decap_8
XFILLER_8_482 VPWR VGND sg13cmos5l_decap_8
XFILLER_13_56 VPWR VGND sg13cmos5l_decap_8
XFILLER_7_909 VPWR VGND sg13cmos5l_decap_8
XFILLER_2_669 VPWR VGND sg13cmos5l_fill_2
XFILLER_1_168 VPWR VGND sg13cmos5l_decap_4
XANTENNA_300 Tile_X0Y0_FrameData[7] VPWR VGND sg13cmos5l_antennanp
XANTENNA_311 Tile_X0Y0_FrameData[7] VPWR VGND sg13cmos5l_antennanp
XANTENNA_322 Tile_X0Y0_N2END[5] VPWR VGND sg13cmos5l_antennanp
XANTENNA_333 Tile_X0Y0_NN4END[11] VPWR VGND sg13cmos5l_antennanp
XANTENNA_344 Tile_X1Y0_N4END[11] VPWR VGND sg13cmos5l_antennanp
XANTENNA_355 Tile_X0Y0_FrameData[22] VPWR VGND sg13cmos5l_antennanp
XFILLER_13_231 VPWR VGND sg13cmos5l_decap_8
X_444_ Tile_X0Y0_S4BEG[13] _581_/X VPWR VGND sg13cmos5l_buf_1
X_513_ Tile_X1Y0_S2BEGb[2] _602_/X VPWR VGND sg13cmos5l_buf_1
XFILLER_18_559 VPWR VGND sg13cmos5l_fill_2
X_375_ Tile_X0Y0_SS4BEG[0] _584_/X VPWR VGND sg13cmos5l_buf_1
XFILLER_5_496 VPWR VGND sg13cmos5l_decap_8
XFILLER_1_691 VPWR VGND sg13cmos5l_fill_1
XFILLER_17_581 VPWR VGND sg13cmos5l_decap_8
XFILLER_15_518 VPWR VGND sg13cmos5l_decap_8
XFILLER_10_256 VPWR VGND sg13cmos5l_fill_1
XFILLER_10_267 VPWR VGND sg13cmos5l_fill_2
X_160_ _160_/Q Tile_X0Y0_FrameData[24] VGND VPWR Tile_X1Y0_FrameStrobe[1] latch
X_091_ _091_/X _237_/Q _237_/D _234_/Q VPWR VGND sg13cmos5l_mux2_1
XFILLER_6_249 VPWR VGND sg13cmos5l_decap_8
XFILLER_6_205 VPWR VGND sg13cmos5l_decap_8
XFILLER_2_422 VPWR VGND sg13cmos5l_decap_8
XFILLER_18_323 VPWR VGND sg13cmos5l_decap_8
XANTENNA_130 Tile_X0Y0_FrameData[27] VPWR VGND sg13cmos5l_antennanp
XANTENNA_141 Tile_X0Y0_FrameData[27] VPWR VGND sg13cmos5l_antennanp
XANTENNA_152 Tile_X0Y0_FrameData[27] VPWR VGND sg13cmos5l_antennanp
XANTENNA_163 Tile_X0Y0_FrameData[27] VPWR VGND sg13cmos5l_antennanp
XANTENNA_174 Tile_X0Y0_FrameData[2] VPWR VGND sg13cmos5l_antennanp
XANTENNA_185 Tile_X0Y0_FrameData[2] VPWR VGND sg13cmos5l_antennanp
XANTENNA_196 Tile_X0Y0_FrameData[2] VPWR VGND sg13cmos5l_antennanp
XFILLER_14_595 VPWR VGND sg13cmos5l_decap_8
X_358_ _358_/L_HI VPWR VGND sg13cmos5l_tiehi
X_427_ Tile_X0Y0_S2BEGb[4] _564_/X VPWR VGND sg13cmos5l_buf_1
X_289_ _289_/Q Tile_X0Y0_FrameData[0] VGND VPWR Tile_X0Y0_FrameStrobe[0] latch
XFILLER_5_293 VPWR VGND sg13cmos5l_fill_2
XFILLER_10_35 VPWR VGND sg13cmos5l_decap_8
XFILLER_11_521 VPWR VGND sg13cmos5l_decap_8
XFILLER_15_315 VPWR VGND sg13cmos5l_decap_8
X_212_ _212_/Q Tile_X0Y0_FrameData[4] VGND VPWR Tile_X1Y0_FrameStrobe[2] latch
XANTENNA__524__X Tile_X1Y0_S4BEG[5] VPWR VGND sg13cmos5l_antennanp
XFILLER_11_598 VPWR VGND sg13cmos5l_fill_2
X_143_ _143_/Q Tile_X0Y0_FrameData[9] VGND VPWR Tile_X1Y0_FrameStrobe[0] latch
X_074_ _074_/X _255_/Q _556_/X _233_/Q VPWR VGND sg13cmos5l_mux2_1
XFILLER_3_764 VPWR VGND sg13cmos5l_decap_4
XFILLER_2_285 VPWR VGND sg13cmos5l_decap_4
XFILLER_18_120 VPWR VGND sg13cmos5l_decap_8
XFILLER_18_175 VPWR VGND sg13cmos5l_decap_8
XFILLER_18_7 VPWR VGND sg13cmos5l_decap_8
XANTENNA__434__X Tile_X0Y0_S4BEG[3] VPWR VGND sg13cmos5l_antennanp
XFILLER_14_392 VPWR VGND sg13cmos5l_decap_8
XFILLER_2_80 VPWR VGND sg13cmos5l_decap_8
XANTENNA_30 Tile_X0Y0_FrameData[1] VPWR VGND sg13cmos5l_antennanp
XANTENNA_41 Tile_X0Y0_FrameData[1] VPWR VGND sg13cmos5l_antennanp
XANTENNA_52 Tile_X0Y0_FrameData[23] VPWR VGND sg13cmos5l_antennanp
XANTENNA_63 Tile_X0Y0_FrameData[23] VPWR VGND sg13cmos5l_antennanp
XANTENNA_74 Tile_X0Y0_FrameData[23] VPWR VGND sg13cmos5l_antennanp
XANTENNA_85 Tile_X0Y0_FrameData[23] VPWR VGND sg13cmos5l_antennanp
XANTENNA_96 Tile_X0Y0_FrameData[23] VPWR VGND sg13cmos5l_antennanp
XFILLER_4_539 VPWR VGND sg13cmos5l_decap_8
XFILLER_0_723 VPWR VGND sg13cmos5l_fill_2
XANTENNA__519__X Tile_X1Y0_S4BEG[0] VPWR VGND sg13cmos5l_antennanp
XFILLER_15_112 VPWR VGND sg13cmos5l_decap_8
XFILLER_16_602 VPWR VGND sg13cmos5l_decap_8
XFILLER_11_373 VPWR VGND sg13cmos5l_decap_8
XFILLER_12_841 VPWR VGND sg13cmos5l_decap_8
XFILLER_15_189 VPWR VGND sg13cmos5l_decap_8
XFILLER_8_823 VPWR VGND sg13cmos5l_decap_8
XFILLER_7_14 VPWR VGND sg13cmos5l_decap_8
X_126_ _126_/Q Tile_X0Y0_FrameData[26] VGND VPWR Tile_X1Y0_FrameStrobe[0] latch
X_057_ _120_/A _233_/Q VPWR VGND sg13cmos5l_inv_1
XFILLER_8_889 VPWR VGND sg13cmos5l_decap_8
XFILLER_7_69 VPWR VGND sg13cmos5l_decap_8
XFILLER_7_399 VPWR VGND sg13cmos5l_decap_8
XFILLER_3_561 VPWR VGND sg13cmos5l_decap_8
XANTENNA__429__X Tile_X0Y0_S2BEGb[6] VPWR VGND sg13cmos5l_antennanp
XFILLER_13_616 VPWR VGND sg13cmos5l_decap_8
XFILLER_16_56 VPWR VGND sg13cmos5l_decap_8
XFILLER_0_586 VPWR VGND sg13cmos5l_fill_1
XFILLER_16_476 VPWR VGND sg13cmos5l_decap_8
XFILLER_17_933 VPWR VGND sg13cmos5l_decap_8
XFILLER_11_170 VPWR VGND sg13cmos5l_decap_8
XFILLER_8_675 VPWR VGND sg13cmos5l_decap_8
X_109_ PMOD_IO_O0 _223_/Q _066_/X VPWR VGND sg13cmos5l_nor2b_1
XFILLER_13_413 VPWR VGND sg13cmos5l_decap_8
X_391_ Tile_X0Y0_FrameStrobe_O[0] Tile_X0Y0_FrameStrobe[0] VPWR VGND sg13cmos5l_buf_1
X_460_ Tile_X1Y0_FrameData_O[13] Tile_X0Y0_FrameData[13] VPWR VGND sg13cmos5l_buf_1
XFILLER_9_439 VPWR VGND sg13cmos5l_decap_8
XANTENNA__532__X Tile_X1Y0_S4BEG[13] VPWR VGND sg13cmos5l_antennanp
XFILLER_4_48 VPWR VGND sg13cmos5l_decap_8
XFILLER_4_155 VPWR VGND sg13cmos5l_decap_8
XFILLER_1_895 VPWR VGND sg13cmos5l_decap_8
XFILLER_1_873 VPWR VGND sg13cmos5l_fill_1
XFILLER_16_273 VPWR VGND sg13cmos5l_decap_8
X_589_ _589_/X Tile_X0Y0_N2END[5] Tile_X0Y0_N4END[5] Tile_X0Y0_NN4END[10] _092_/X
+ _291_/Q _290_/Q VPWR VGND sg13cmos5l_mux4_1
XANTENNA__442__X Tile_X0Y0_S4BEG[11] VPWR VGND sg13cmos5l_antennanp
XFILLER_9_940 VPWR VGND sg13cmos5l_fill_1
XFILLER_8_461 VPWR VGND sg13cmos5l_decap_8
XFILLER_10_449 VPWR VGND sg13cmos5l_decap_8
XFILLER_11_928 VPWR VGND sg13cmos5l_decap_8
XFILLER_11_939 VPWR VGND sg13cmos5l_fill_2
XFILLER_13_35 VPWR VGND sg13cmos5l_decap_8
XFILLER_2_659 VPWR VGND sg13cmos5l_fill_2
XFILLER_1_114 VPWR VGND sg13cmos5l_decap_4
XANTENNA_301 Tile_X0Y0_FrameData[7] VPWR VGND sg13cmos5l_antennanp
XFILLER_18_505 VPWR VGND sg13cmos5l_decap_8
XANTENNA_312 Tile_X0Y0_FrameData[7] VPWR VGND sg13cmos5l_antennanp
XANTENNA_323 Tile_X0Y0_N2END[5] VPWR VGND sg13cmos5l_antennanp
XANTENNA_334 Tile_X0Y0_NN4END[11] VPWR VGND sg13cmos5l_antennanp
XANTENNA_345 Tile_X1Y0_N4END[11] VPWR VGND sg13cmos5l_antennanp
XANTENNA__527__X Tile_X1Y0_S4BEG[8] VPWR VGND sg13cmos5l_antennanp
XFILLER_13_210 VPWR VGND sg13cmos5l_decap_8
X_374_ _374_/L_HI VPWR VGND sg13cmos5l_tiehi
X_443_ Tile_X0Y0_S4BEG[12] _580_/X VPWR VGND sg13cmos5l_buf_1
X_512_ Tile_X1Y0_S2BEGb[1] _601_/X VPWR VGND sg13cmos5l_buf_1
XFILLER_13_287 VPWR VGND sg13cmos5l_decap_8
XFILLER_5_453 VPWR VGND sg13cmos5l_decap_8
XANTENNA__437__X Tile_X0Y0_S4BEG[6] VPWR VGND sg13cmos5l_antennanp
XFILLER_17_560 VPWR VGND sg13cmos5l_decap_8
XFILLER_5_80 VPWR VGND sg13cmos5l_decap_8
X_090_ _237_/D PMOD_IO_I2 _554_/X _222_/Q VPWR VGND sg13cmos5l_mux2_1
XFILLER_2_478 VPWR VGND sg13cmos5l_decap_8
XANTENNA_120 Tile_X0Y0_FrameData[27] VPWR VGND sg13cmos5l_antennanp
XANTENNA_131 Tile_X0Y0_FrameData[27] VPWR VGND sg13cmos5l_antennanp
XANTENNA_142 Tile_X0Y0_FrameData[27] VPWR VGND sg13cmos5l_antennanp
XFILLER_18_302 VPWR VGND sg13cmos5l_decap_8
XANTENNA_153 Tile_X0Y0_FrameData[27] VPWR VGND sg13cmos5l_antennanp
XANTENNA_164 Tile_X0Y0_FrameData[27] VPWR VGND sg13cmos5l_antennanp
XANTENNA_175 Tile_X0Y0_FrameData[2] VPWR VGND sg13cmos5l_antennanp
XANTENNA_186 Tile_X0Y0_FrameData[2] VPWR VGND sg13cmos5l_antennanp
XANTENNA_197 Tile_X0Y0_FrameData[2] VPWR VGND sg13cmos5l_antennanp
XFILLER_14_574 VPWR VGND sg13cmos5l_decap_8
X_357_ _357_/L_HI VPWR VGND sg13cmos5l_tiehi
X_426_ Tile_X0Y0_S2BEGb[3] _563_/X VPWR VGND sg13cmos5l_buf_1
X_288_ _288_/Q Tile_X0Y0_FrameData[1] VGND VPWR Tile_X0Y0_FrameStrobe[0] latch
XFILLER_5_272 VPWR VGND sg13cmos5l_fill_2
XFILLER_18_891 VPWR VGND sg13cmos5l_fill_1
XFILLER_18_880 VPWR VGND sg13cmos5l_fill_1
XFILLER_10_14 VPWR VGND sg13cmos5l_decap_8
XFILLER_10_69 VPWR VGND sg13cmos5l_fill_2
XFILLER_11_500 VPWR VGND sg13cmos5l_decap_8
X_211_ _211_/Q Tile_X0Y0_FrameData[5] VGND VPWR Tile_X1Y0_FrameStrobe[2] latch
X_142_ _142_/Q Tile_X0Y0_FrameData[10] VGND VPWR Tile_X1Y0_FrameStrobe[0] latch
XANTENNA__540__X Tile_X1Y0_SS4BEG[5] VPWR VGND sg13cmos5l_antennanp
XFILLER_11_577 VPWR VGND sg13cmos5l_decap_8
X_073_ _247_/D _644_/X _227_/Q _232_/Q VPWR VGND sg13cmos5l_mux2_1
XFILLER_7_559 VPWR VGND sg13cmos5l_fill_1
XFILLER_4_0 VPWR VGND sg13cmos5l_decap_4
XFILLER_3_743 VPWR VGND sg13cmos5l_decap_8
XFILLER_3_798 VPWR VGND sg13cmos5l_decap_8
XFILLER_2_275 VPWR VGND sg13cmos5l_decap_8
XFILLER_14_371 VPWR VGND sg13cmos5l_decap_8
XFILLER_15_894 VPWR VGND sg13cmos5l_decap_8
X_409_ Tile_X0Y0_FrameStrobe_O[18] Tile_X0Y0_FrameStrobe[18] VPWR VGND sg13cmos5l_buf_1
XANTENNA__450__X Tile_X1Y0_FrameData_O[3] VPWR VGND sg13cmos5l_antennanp
XFILLER_6_592 VPWR VGND sg13cmos5l_fill_2
XANTENNA_20 Tile_X0Y0_FrameData[1] VPWR VGND sg13cmos5l_antennanp
XANTENNA_31 Tile_X0Y0_FrameData[1] VPWR VGND sg13cmos5l_antennanp
XANTENNA_42 Tile_X0Y0_FrameData[1] VPWR VGND sg13cmos5l_antennanp
XANTENNA_53 Tile_X0Y0_FrameData[23] VPWR VGND sg13cmos5l_antennanp
XANTENNA_64 Tile_X0Y0_FrameData[23] VPWR VGND sg13cmos5l_antennanp
XANTENNA_75 Tile_X0Y0_FrameData[23] VPWR VGND sg13cmos5l_antennanp
XANTENNA_86 Tile_X0Y0_FrameData[23] VPWR VGND sg13cmos5l_antennanp
XANTENNA_97 Tile_X0Y0_FrameData[23] VPWR VGND sg13cmos5l_antennanp
XFILLER_4_518 VPWR VGND sg13cmos5l_decap_8
XFILLER_15_168 VPWR VGND sg13cmos5l_decap_8
XANTENNA__535__X Tile_X1Y0_SS4BEG[0] VPWR VGND sg13cmos5l_antennanp
XFILLER_11_352 VPWR VGND sg13cmos5l_decap_8
XFILLER_12_820 VPWR VGND sg13cmos5l_decap_8
X_125_ _125_/Q Tile_X0Y0_FrameData[27] VGND VPWR Tile_X1Y0_FrameStrobe[0] latch
XFILLER_8_835 VPWR VGND sg13cmos5l_decap_8
XFILLER_8_802 VPWR VGND sg13cmos5l_decap_8
XFILLER_7_37 VPWR VGND sg13cmos5l_fill_1
XFILLER_7_378 VPWR VGND sg13cmos5l_decap_8
XANTENNA__445__X Tile_X0Y0_S4BEG[14] VPWR VGND sg13cmos5l_antennanp
XFILLER_16_35 VPWR VGND sg13cmos5l_decap_8
XFILLER_12_149 VPWR VGND sg13cmos5l_decap_8
XFILLER_0_543 VPWR VGND sg13cmos5l_fill_1
XFILLER_0_565 VPWR VGND sg13cmos5l_decap_8
XFILLER_0_598 VPWR VGND sg13cmos5l_decap_8
XFILLER_17_912 VPWR VGND sg13cmos5l_decap_8
XFILLER_16_455 VPWR VGND sg13cmos5l_decap_8
XFILLER_12_672 VPWR VGND sg13cmos5l_decap_8
X_108_ PMOD_IO_OE_O7 _120_/A _060_/Y _107_/X _223_/Q _106_/Y VPWR VGND sg13cmos5l_a221oi_1
XFILLER_2_808 VPWR VGND sg13cmos5l_decap_8
XANTENNA__069__Y PMOD_IO_OE_O0 VPWR VGND sg13cmos5l_antennanp
XFILLER_14_904 VPWR VGND sg13cmos5l_decap_8
XFILLER_14_959 VPWR VGND sg13cmos5l_fill_1
X_390_ Tile_X0Y0_SS4BEG[15] _599_/X VPWR VGND sg13cmos5l_buf_1
XFILLER_13_469 VPWR VGND sg13cmos5l_decap_8
XFILLER_9_418 VPWR VGND sg13cmos5l_decap_8
XFILLER_5_613 VPWR VGND sg13cmos5l_decap_4
XFILLER_0_340 VPWR VGND sg13cmos5l_fill_1
XFILLER_0_351 VPWR VGND sg13cmos5l_fill_2
XFILLER_16_252 VPWR VGND sg13cmos5l_decap_8
X_588_ _588_/X Tile_X0Y0_N2END[4] Tile_X0Y0_N4END[4] Tile_X0Y0_NN4END[11] _119_/X
+ _293_/Q _292_/Q VPWR VGND sg13cmos5l_mux4_1
XFILLER_8_440 VPWR VGND sg13cmos5l_decap_8
XFILLER_11_907 VPWR VGND sg13cmos5l_decap_8
XFILLER_10_428 VPWR VGND sg13cmos5l_decap_8
XFILLER_13_14 VPWR VGND sg13cmos5l_decap_8
XFILLER_8_7 VPWR VGND sg13cmos5l_decap_8
XFILLER_1_148 VPWR VGND sg13cmos5l_decap_8
XFILLER_1_126 VPWR VGND sg13cmos5l_fill_1
XANTENNA_302 Tile_X0Y0_FrameData[7] VPWR VGND sg13cmos5l_antennanp
XANTENNA_313 Tile_X0Y0_FrameData[7] VPWR VGND sg13cmos5l_antennanp
XANTENNA_324 Tile_X0Y0_N2END[5] VPWR VGND sg13cmos5l_antennanp
X_511_ Tile_X1Y0_S2BEGb[0] _600_/X VPWR VGND sg13cmos5l_buf_1
XANTENNA_335 Tile_X0Y0_NN4END[11] VPWR VGND sg13cmos5l_antennanp
XANTENNA_346 Tile_X1Y0_N4END[11] VPWR VGND sg13cmos5l_antennanp
XFILLER_13_266 VPWR VGND sg13cmos5l_decap_8
X_373_ _373_/L_HI VPWR VGND sg13cmos5l_tiehi
X_442_ Tile_X0Y0_S4BEG[11] _579_/X VPWR VGND sg13cmos5l_buf_1
XANTENNA__543__X Tile_X1Y0_SS4BEG[8] VPWR VGND sg13cmos5l_antennanp
XFILLER_5_432 VPWR VGND sg13cmos5l_decap_8
XFILLER_1_682 VPWR VGND sg13cmos5l_decap_8
XANTENNA__453__X Tile_X1Y0_FrameData_O[6] VPWR VGND sg13cmos5l_antennanp
XANTENNA__082__Y PMOD_IO_OE_O3 VPWR VGND sg13cmos5l_antennanp
XFILLER_7_719 VPWR VGND sg13cmos5l_decap_4
XFILLER_3_925 VPWR VGND sg13cmos5l_decap_8
XFILLER_2_457 VPWR VGND sg13cmos5l_decap_8
XFILLER_1_28 VPWR VGND sg13cmos5l_fill_2
XANTENNA_110 Tile_X0Y0_FrameData[27] VPWR VGND sg13cmos5l_antennanp
XANTENNA_121 Tile_X0Y0_FrameData[27] VPWR VGND sg13cmos5l_antennanp
XANTENNA_132 Tile_X0Y0_FrameData[27] VPWR VGND sg13cmos5l_antennanp
XANTENNA_143 Tile_X0Y0_FrameData[27] VPWR VGND sg13cmos5l_antennanp
XANTENNA_154 Tile_X0Y0_FrameData[27] VPWR VGND sg13cmos5l_antennanp
XANTENNA_165 Tile_X0Y0_FrameData[2] VPWR VGND sg13cmos5l_antennanp
XANTENNA_176 Tile_X0Y0_FrameData[2] VPWR VGND sg13cmos5l_antennanp
XANTENNA__538__X Tile_X1Y0_SS4BEG[3] VPWR VGND sg13cmos5l_antennanp
XFILLER_18_358 VPWR VGND sg13cmos5l_decap_8
XANTENNA_187 Tile_X0Y0_FrameData[2] VPWR VGND sg13cmos5l_antennanp
XANTENNA_198 Tile_X0Y0_FrameData[2] VPWR VGND sg13cmos5l_antennanp
XFILLER_14_553 VPWR VGND sg13cmos5l_decap_8
X_287_ _287_/Q Tile_X0Y0_FrameData[2] VGND VPWR Tile_X0Y0_FrameStrobe[0] latch
X_356_ _356_/L_HI VPWR VGND sg13cmos5l_tiehi
X_425_ Tile_X0Y0_S2BEGb[2] _562_/X VPWR VGND sg13cmos5l_buf_1
XANTENNA__448__X Tile_X1Y0_FrameData_O[1] VPWR VGND sg13cmos5l_antennanp
XFILLER_9_590 VPWR VGND sg13cmos5l_decap_8
XANTENNA__077__Y PMOD_IO_OE_O4 VPWR VGND sg13cmos5l_antennanp
XFILLER_11_556 VPWR VGND sg13cmos5l_decap_8
X_210_ _210_/Q Tile_X0Y0_FrameData[6] VGND VPWR Tile_X1Y0_FrameStrobe[2] latch
X_141_ _141_/Q Tile_X0Y0_FrameData[11] VGND VPWR Tile_X1Y0_FrameStrobe[0] latch
XFILLER_7_538 VPWR VGND sg13cmos5l_decap_8
X_072_ PMOD_IO_OE_O2 _120_/A _058_/Y _071_/X _223_/Q _070_/Y VPWR VGND sg13cmos5l_a221oi_1
XFILLER_3_722 VPWR VGND sg13cmos5l_decap_8
XFILLER_3_711 VPWR VGND sg13cmos5l_fill_1
XFILLER_2_254 VPWR VGND sg13cmos5l_decap_8
XFILLER_2_232 VPWR VGND sg13cmos5l_fill_1
XFILLER_2_221 VPWR VGND sg13cmos5l_decap_8
XFILLER_14_350 VPWR VGND sg13cmos5l_decap_8
XFILLER_15_873 VPWR VGND sg13cmos5l_decap_8
XFILLER_18_144 VPWR VGND sg13cmos5l_decap_8
X_408_ Tile_X0Y0_FrameStrobe_O[17] Tile_X0Y0_FrameStrobe[17] VPWR VGND sg13cmos5l_buf_1
XFILLER_18_199 VPWR VGND sg13cmos5l_decap_8
X_339_ _339_/Q Tile_X0Y0_FrameData[14] VGND VPWR Tile_X0Y0_FrameStrobe[2] latch
XFILLER_6_582 VPWR VGND sg13cmos5l_fill_2
XANTENNA_10 Tile_X0Y0_FrameData[1] VPWR VGND sg13cmos5l_antennanp
XANTENNA_21 Tile_X0Y0_FrameData[1] VPWR VGND sg13cmos5l_antennanp
XANTENNA_32 Tile_X0Y0_FrameData[1] VPWR VGND sg13cmos5l_antennanp
XANTENNA_43 Tile_X0Y0_FrameData[1] VPWR VGND sg13cmos5l_antennanp
XANTENNA_54 Tile_X0Y0_FrameData[23] VPWR VGND sg13cmos5l_antennanp
XANTENNA_65 Tile_X0Y0_FrameData[23] VPWR VGND sg13cmos5l_antennanp
XANTENNA_76 Tile_X0Y0_FrameData[23] VPWR VGND sg13cmos5l_antennanp
XANTENNA_87 Tile_X0Y0_FrameData[23] VPWR VGND sg13cmos5l_antennanp
XANTENNA_98 Tile_X0Y0_FrameData[23] VPWR VGND sg13cmos5l_antennanp
XFILLER_0_769 VPWR VGND sg13cmos5l_fill_2
XFILLER_15_147 VPWR VGND sg13cmos5l_decap_8
XFILLER_16_637 VPWR VGND sg13cmos5l_decap_8
XFILLER_16_648 VPWR VGND sg13cmos5l_fill_2
XANTENNA__551__X Tile_X1Y0_UserCLKo VPWR VGND sg13cmos5l_antennanp
XFILLER_11_331 VPWR VGND sg13cmos5l_decap_8
XFILLER_12_876 VPWR VGND sg13cmos5l_fill_1
XFILLER_12_887 VPWR VGND sg13cmos5l_decap_8
X_124_ _124_/Q Tile_X0Y0_FrameData[28] VGND VPWR Tile_X1Y0_FrameStrobe[0] latch
XFILLER_7_357 VPWR VGND sg13cmos5l_decap_4
XFILLER_3_585 VPWR VGND sg13cmos5l_decap_4
XFILLER_15_670 VPWR VGND sg13cmos5l_decap_4
XANTENNA__461__X Tile_X1Y0_FrameData_O[14] VPWR VGND sg13cmos5l_antennanp
XFILLER_6_390 VPWR VGND sg13cmos5l_decap_8
XFILLER_16_14 VPWR VGND sg13cmos5l_decap_8
XFILLER_12_128 VPWR VGND sg13cmos5l_decap_8
XFILLER_5_817 VPWR VGND sg13cmos5l_decap_4
XFILLER_4_316 VPWR VGND sg13cmos5l_fill_2
XFILLER_0_511 VPWR VGND sg13cmos5l_decap_8
XANTENNA__546__X Tile_X1Y0_SS4BEG[11] VPWR VGND sg13cmos5l_antennanp
XFILLER_16_434 VPWR VGND sg13cmos5l_decap_8
X_107_ _107_/X _258_/Q _559_/X _233_/Q VPWR VGND sg13cmos5l_mux2_1
XFILLER_7_154 VPWR VGND sg13cmos5l_decap_8
XANTENNA__456__X Tile_X1Y0_FrameData_O[9] VPWR VGND sg13cmos5l_antennanp
XFILLER_8_70 VPWR VGND sg13cmos5l_decap_8
XFILLER_13_448 VPWR VGND sg13cmos5l_decap_8
XFILLER_4_113 VPWR VGND sg13cmos5l_decap_8
XFILLER_0_385 VPWR VGND sg13cmos5l_fill_1
XFILLER_0_396 VPWR VGND sg13cmos5l_fill_1
XFILLER_1_864 VPWR VGND sg13cmos5l_decap_8
XFILLER_16_231 VPWR VGND sg13cmos5l_decap_8
XFILLER_17_765 VPWR VGND sg13cmos5l_fill_2
X_587_ _587_/X Tile_X0Y0_N2END[3] Tile_X0Y0_N4END[3] Tile_X0Y0_NN4END[12] _091_/X
+ _295_/Q _294_/Q VPWR VGND sg13cmos5l_mux4_1
XFILLER_12_492 VPWR VGND sg13cmos5l_decap_8
XFILLER_9_931 VPWR VGND sg13cmos5l_decap_4
XFILLER_8_496 VPWR VGND sg13cmos5l_decap_8
XFILLER_12_0 VPWR VGND sg13cmos5l_decap_8
XFILLER_10_407 VPWR VGND sg13cmos5l_decap_8
XFILLER_2_606 VPWR VGND sg13cmos5l_decap_8
XANTENNA_303 Tile_X0Y0_FrameData[7] VPWR VGND sg13cmos5l_antennanp
XANTENNA_314 Tile_X0Y0_FrameData[7] VPWR VGND sg13cmos5l_antennanp
XANTENNA_325 Tile_X0Y0_N4END[4] VPWR VGND sg13cmos5l_antennanp
XANTENNA_336 Tile_X0Y0_NN4END[11] VPWR VGND sg13cmos5l_antennanp
XANTENNA_347 Tile_X0Y0_FrameData[22] VPWR VGND sg13cmos5l_antennanp
XFILLER_14_702 VPWR VGND sg13cmos5l_fill_2
X_441_ Tile_X0Y0_S4BEG[10] _578_/X VPWR VGND sg13cmos5l_buf_1
X_510_ Tile_X1Y0_S2BEG[7] Tile_X1Y0_N2MID[0] VPWR VGND sg13cmos5l_buf_1
XFILLER_18_518 VPWR VGND sg13cmos5l_decap_8
XFILLER_10_941 VPWR VGND sg13cmos5l_fill_1
XFILLER_13_245 VPWR VGND sg13cmos5l_decap_8
X_372_ _372_/L_HI VPWR VGND sg13cmos5l_tiehi
XFILLER_9_249 VPWR VGND sg13cmos5l_decap_8
XFILLER_5_411 VPWR VGND sg13cmos5l_decap_8
XFILLER_0_160 VPWR VGND sg13cmos5l_decap_8
XFILLER_0_193 VPWR VGND sg13cmos5l_decap_4
XFILLER_1_661 VPWR VGND sg13cmos5l_decap_8
XFILLER_17_595 VPWR VGND sg13cmos5l_decap_8
X_639_ _639_/X Tile_X1Y0_N2END[7] Tile_X1Y0_N4END[15] Tile_X1Y0_NN4END[0] _064_/X
+ _142_/Q _141_/Q VPWR VGND sg13cmos5l_mux4_1
XFILLER_9_761 VPWR VGND sg13cmos5l_decap_8
XFILLER_11_749 VPWR VGND sg13cmos5l_decap_4
XFILLER_3_904 VPWR VGND sg13cmos5l_decap_8
XFILLER_2_436 VPWR VGND sg13cmos5l_decap_8
XANTENNA_100 Tile_X0Y0_FrameData[23] VPWR VGND sg13cmos5l_antennanp
XANTENNA_111 Tile_X0Y0_FrameData[27] VPWR VGND sg13cmos5l_antennanp
XANTENNA_122 Tile_X0Y0_FrameData[27] VPWR VGND sg13cmos5l_antennanp
XANTENNA_133 Tile_X0Y0_FrameData[27] VPWR VGND sg13cmos5l_antennanp
XANTENNA_144 Tile_X0Y0_FrameData[27] VPWR VGND sg13cmos5l_antennanp
XANTENNA_155 Tile_X0Y0_FrameData[27] VPWR VGND sg13cmos5l_antennanp
XANTENNA_166 Tile_X0Y0_FrameData[2] VPWR VGND sg13cmos5l_antennanp
XANTENNA_177 Tile_X0Y0_FrameData[2] VPWR VGND sg13cmos5l_antennanp
XANTENNA_188 Tile_X0Y0_FrameData[2] VPWR VGND sg13cmos5l_antennanp
XANTENNA_199 Tile_X0Y0_FrameData[2] VPWR VGND sg13cmos5l_antennanp
XFILLER_14_532 VPWR VGND sg13cmos5l_decap_8
X_424_ Tile_X0Y0_S2BEGb[1] _561_/X VPWR VGND sg13cmos5l_buf_1
XFILLER_18_337 VPWR VGND sg13cmos5l_decap_8
XFILLER_14_91 VPWR VGND sg13cmos5l_decap_8
X_286_ _286_/Q Tile_X0Y0_FrameData[3] VGND VPWR Tile_X0Y0_FrameStrobe[0] latch
X_355_ _355_/L_HI VPWR VGND sg13cmos5l_tiehi
XFILLER_18_871 VPWR VGND sg13cmos5l_decap_8
XANTENNA__464__X Tile_X1Y0_FrameData_O[17] VPWR VGND sg13cmos5l_antennanp
XFILLER_17_392 VPWR VGND sg13cmos5l_decap_8
XFILLER_10_49 VPWR VGND sg13cmos5l_decap_8
XFILLER_15_329 VPWR VGND sg13cmos5l_decap_8
XFILLER_11_535 VPWR VGND sg13cmos5l_decap_8
X_140_ _140_/Q Tile_X0Y0_FrameData[12] VGND VPWR Tile_X1Y0_FrameStrobe[0] latch
X_071_ _071_/X _253_/Q _554_/X _233_/Q VPWR VGND sg13cmos5l_mux2_1
XFILLER_2_200 VPWR VGND sg13cmos5l_decap_8
XANTENNA__549__X Tile_X1Y0_SS4BEG[14] VPWR VGND sg13cmos5l_antennanp
XFILLER_15_852 VPWR VGND sg13cmos5l_decap_8
X_338_ _338_/Q Tile_X0Y0_FrameData[15] VGND VPWR Tile_X0Y0_FrameStrobe[2] latch
X_407_ Tile_X0Y0_FrameStrobe_O[16] Tile_X0Y0_FrameStrobe[16] VPWR VGND sg13cmos5l_buf_1
X_269_ _269_/Q Tile_X0Y0_FrameData[20] VGND VPWR Tile_X0Y0_FrameStrobe[0] latch
XFILLER_6_561 VPWR VGND sg13cmos5l_decap_8
XANTENNA__459__X Tile_X1Y0_FrameData_O[12] VPWR VGND sg13cmos5l_antennanp
XFILLER_2_50 VPWR VGND sg13cmos5l_decap_8
XANTENNA_11 Tile_X0Y0_FrameData[1] VPWR VGND sg13cmos5l_antennanp
XANTENNA_22 Tile_X0Y0_FrameData[1] VPWR VGND sg13cmos5l_antennanp
XANTENNA_33 Tile_X0Y0_FrameData[1] VPWR VGND sg13cmos5l_antennanp
XANTENNA_44 Tile_X0Y0_FrameData[1] VPWR VGND sg13cmos5l_antennanp
XANTENNA_55 Tile_X0Y0_FrameData[23] VPWR VGND sg13cmos5l_antennanp
XANTENNA_66 Tile_X0Y0_FrameData[23] VPWR VGND sg13cmos5l_antennanp
XANTENNA_77 Tile_X0Y0_FrameData[23] VPWR VGND sg13cmos5l_antennanp
XANTENNA_88 Tile_X0Y0_FrameData[23] VPWR VGND sg13cmos5l_antennanp
XANTENNA_99 Tile_X0Y0_FrameData[23] VPWR VGND sg13cmos5l_antennanp
XFILLER_0_704 VPWR VGND sg13cmos5l_decap_4
XFILLER_0_715 VPWR VGND sg13cmos5l_fill_1
XFILLER_16_616 VPWR VGND sg13cmos5l_decap_8
XFILLER_11_310 VPWR VGND sg13cmos5l_decap_8
XFILLER_12_855 VPWR VGND sg13cmos5l_decap_8
XFILLER_15_126 VPWR VGND sg13cmos5l_decap_8
XFILLER_11_387 VPWR VGND sg13cmos5l_decap_8
X_123_ _123_/Q Tile_X0Y0_FrameData[29] VGND VPWR Tile_X1Y0_FrameStrobe[0] latch
XFILLER_8_859 VPWR VGND sg13cmos5l_decap_8
XFILLER_7_28 VPWR VGND sg13cmos5l_decap_8
XFILLER_3_575 VPWR VGND sg13cmos5l_fill_2
XFILLER_16_7 VPWR VGND sg13cmos5l_decap_8
XFILLER_7_881 VPWR VGND sg13cmos5l_decap_8
XFILLER_12_107 VPWR VGND sg13cmos5l_decap_8
XFILLER_16_413 VPWR VGND sg13cmos5l_decap_8
XFILLER_17_947 VPWR VGND sg13cmos5l_decap_8
XFILLER_17_958 VPWR VGND sg13cmos5l_fill_2
XFILLER_11_184 VPWR VGND sg13cmos5l_decap_8
X_106_ _106_/Y _120_/A _250_/D VPWR VGND sg13cmos5l_nor2_1
XFILLER_8_689 VPWR VGND sg13cmos5l_decap_4
XFILLER_4_884 VPWR VGND sg13cmos5l_decap_8
XFILLER_4_851 VPWR VGND sg13cmos5l_fill_2
XFILLER_4_840 VPWR VGND sg13cmos5l_decap_8
XFILLER_15_490 VPWR VGND sg13cmos5l_decap_8
XANTENNA__472__X Tile_X1Y0_FrameData_O[25] VPWR VGND sg13cmos5l_antennanp
XANTENNA__382__X Tile_X0Y0_SS4BEG[7] VPWR VGND sg13cmos5l_antennanp
XFILLER_13_427 VPWR VGND sg13cmos5l_decap_8
XFILLER_5_626 VPWR VGND sg13cmos5l_decap_8
XFILLER_4_169 VPWR VGND sg13cmos5l_fill_1
XFILLER_16_210 VPWR VGND sg13cmos5l_decap_8
XFILLER_16_287 VPWR VGND sg13cmos5l_decap_8
XFILLER_17_91 VPWR VGND sg13cmos5l_decap_8
X_586_ _586_/X Tile_X0Y0_N2END[2] Tile_X0Y0_N4END[2] Tile_X0Y0_NN4END[13] _092_/X
+ _297_/Q _296_/Q VPWR VGND sg13cmos5l_mux4_1
XFILLER_12_471 VPWR VGND sg13cmos5l_decap_8
XFILLER_9_910 VPWR VGND sg13cmos5l_decap_8
XFILLER_8_475 VPWR VGND sg13cmos5l_decap_8
XANTENNA__467__X Tile_X1Y0_FrameData_O[20] VPWR VGND sg13cmos5l_antennanp
XFILLER_13_49 VPWR VGND sg13cmos5l_decap_8
XANTENNA_304 Tile_X0Y0_FrameData[7] VPWR VGND sg13cmos5l_antennanp
XANTENNA_315 Tile_X0Y0_FrameData[7] VPWR VGND sg13cmos5l_antennanp
XANTENNA_326 Tile_X0Y0_N4END[4] VPWR VGND sg13cmos5l_antennanp
XANTENNA_337 Tile_X0Y0_NN4END[11] VPWR VGND sg13cmos5l_antennanp
XANTENNA_348 Tile_X0Y0_FrameData[22] VPWR VGND sg13cmos5l_antennanp
XANTENNA__377__X Tile_X0Y0_SS4BEG[2] VPWR VGND sg13cmos5l_antennanp
XFILLER_13_224 VPWR VGND sg13cmos5l_decap_8
X_371_ _371_/L_HI VPWR VGND sg13cmos5l_tiehi
X_440_ Tile_X0Y0_S4BEG[9] _577_/X VPWR VGND sg13cmos5l_buf_1
XFILLER_10_920 VPWR VGND sg13cmos5l_decap_8
XFILLER_5_467 VPWR VGND sg13cmos5l_decap_8
XFILLER_0_183 VPWR VGND sg13cmos5l_fill_1
XFILLER_17_574 VPWR VGND sg13cmos5l_decap_8
X_638_ _638_/X Tile_X1Y0_N2END[6] Tile_X1Y0_N4END[14] Tile_X1Y0_NN4END[1] _089_/X
+ _144_/Q _143_/Q VPWR VGND sg13cmos5l_mux4_1
X_569_ _569_/X Tile_X0Y0_N2MID[1] Tile_X0Y0_N4END[14] Tile_X0Y0_NN4END[1] _119_/X
+ _331_/Q _330_/Q VPWR VGND sg13cmos5l_mux4_1
XFILLER_9_740 VPWR VGND sg13cmos5l_decap_8
XFILLER_5_61 VPWR VGND sg13cmos5l_decap_8
XFILLER_18_316 VPWR VGND sg13cmos5l_decap_8
XANTENNA_101 Tile_X0Y0_FrameData[23] VPWR VGND sg13cmos5l_antennanp
XANTENNA_112 Tile_X0Y0_FrameData[27] VPWR VGND sg13cmos5l_antennanp
XANTENNA_123 Tile_X0Y0_FrameData[27] VPWR VGND sg13cmos5l_antennanp
XANTENNA_134 Tile_X0Y0_FrameData[27] VPWR VGND sg13cmos5l_antennanp
XANTENNA_145 Tile_X0Y0_FrameData[27] VPWR VGND sg13cmos5l_antennanp
XANTENNA_156 Tile_X0Y0_FrameData[27] VPWR VGND sg13cmos5l_antennanp
XANTENNA_167 Tile_X0Y0_FrameData[2] VPWR VGND sg13cmos5l_antennanp
XANTENNA_178 Tile_X0Y0_FrameData[2] VPWR VGND sg13cmos5l_antennanp
XANTENNA_189 Tile_X0Y0_FrameData[2] VPWR VGND sg13cmos5l_antennanp
XFILLER_14_511 VPWR VGND sg13cmos5l_decap_8
XFILLER_14_588 VPWR VGND sg13cmos5l_decap_8
X_354_ _354_/L_HI VPWR VGND sg13cmos5l_tiehi
X_423_ Tile_X0Y0_S2BEGb[0] _560_/X VPWR VGND sg13cmos5l_buf_1
XFILLER_10_750 VPWR VGND sg13cmos5l_decap_8
XFILLER_14_70 VPWR VGND sg13cmos5l_decap_8
X_285_ _285_/Q Tile_X0Y0_FrameData[4] VGND VPWR Tile_X0Y0_FrameStrobe[0] latch
XFILLER_17_371 VPWR VGND sg13cmos5l_decap_8
XANTENNA__480__X Tile_X1Y0_FrameStrobe_O[1] VPWR VGND sg13cmos5l_antennanp
XFILLER_10_28 VPWR VGND sg13cmos5l_decap_8
XFILLER_11_514 VPWR VGND sg13cmos5l_decap_8
XFILLER_15_308 VPWR VGND sg13cmos5l_decap_8
XANTENNA__390__X Tile_X0Y0_SS4BEG[15] VPWR VGND sg13cmos5l_antennanp
X_070_ _070_/Y _120_/A _245_/D VPWR VGND sg13cmos5l_nor2_1
XFILLER_3_702 VPWR VGND sg13cmos5l_decap_8
XFILLER_3_768 VPWR VGND sg13cmos5l_fill_1
XFILLER_3_757 VPWR VGND sg13cmos5l_decap_8
XFILLER_2_289 VPWR VGND sg13cmos5l_fill_2
XFILLER_18_113 VPWR VGND sg13cmos5l_decap_8
XFILLER_18_168 VPWR VGND sg13cmos5l_decap_8
XFILLER_14_385 VPWR VGND sg13cmos5l_decap_8
X_337_ _337_/Q Tile_X0Y0_FrameData[16] VGND VPWR Tile_X0Y0_FrameStrobe[2] latch
X_406_ Tile_X0Y0_FrameStrobe_O[15] Tile_X0Y0_FrameStrobe[15] VPWR VGND sg13cmos5l_buf_1
XFILLER_10_580 VPWR VGND sg13cmos5l_decap_4
X_268_ _268_/Q Tile_X0Y0_FrameData[21] VGND VPWR Tile_X0Y0_FrameStrobe[0] latch
X_199_ _199_/Q Tile_X0Y0_FrameData[17] VGND VPWR Tile_X1Y0_FrameStrobe[2] latch
XFILLER_6_584 VPWR VGND sg13cmos5l_fill_1
XFILLER_2_73 VPWR VGND sg13cmos5l_decap_4
XANTENNA__475__X Tile_X1Y0_FrameData_O[28] VPWR VGND sg13cmos5l_antennanp
XANTENNA_12 Tile_X0Y0_FrameData[1] VPWR VGND sg13cmos5l_antennanp
XANTENNA_23 Tile_X0Y0_FrameData[1] VPWR VGND sg13cmos5l_antennanp
XANTENNA_34 Tile_X0Y0_FrameData[1] VPWR VGND sg13cmos5l_antennanp
XANTENNA_45 Tile_X0Y0_FrameData[23] VPWR VGND sg13cmos5l_antennanp
XANTENNA_56 Tile_X0Y0_FrameData[23] VPWR VGND sg13cmos5l_antennanp
XANTENNA_67 Tile_X0Y0_FrameData[23] VPWR VGND sg13cmos5l_antennanp
XANTENNA_78 Tile_X0Y0_FrameData[23] VPWR VGND sg13cmos5l_antennanp
XANTENNA_89 Tile_X0Y0_FrameData[23] VPWR VGND sg13cmos5l_antennanp
XANTENNA__385__X Tile_X0Y0_SS4BEG[10] VPWR VGND sg13cmos5l_antennanp
XFILLER_15_105 VPWR VGND sg13cmos5l_decap_8
XFILLER_11_366 VPWR VGND sg13cmos5l_decap_8
XFILLER_12_834 VPWR VGND sg13cmos5l_decap_8
XFILLER_8_816 VPWR VGND sg13cmos5l_decap_8
XFILLER_11_93 VPWR VGND sg13cmos5l_decap_8
X_122_ _122_/Q Tile_X0Y0_FrameData[30] VGND VPWR Tile_X1Y0_FrameStrobe[0] latch
XFILLER_2_0 VPWR VGND sg13cmos5l_decap_4
XFILLER_14_182 VPWR VGND sg13cmos5l_decap_8
XFILLER_13_609 VPWR VGND sg13cmos5l_decap_8
XFILLER_16_49 VPWR VGND sg13cmos5l_decap_8
XFILLER_4_318 VPWR VGND sg13cmos5l_fill_1
XFILLER_0_579 VPWR VGND sg13cmos5l_decap_8
XFILLER_16_469 VPWR VGND sg13cmos5l_decap_8
XFILLER_17_926 VPWR VGND sg13cmos5l_decap_8
XFILLER_11_163 VPWR VGND sg13cmos5l_decap_8
XFILLER_12_620 VPWR VGND sg13cmos5l_decap_8
X_105_ _250_/D _647_/X _224_/Q _232_/Q VPWR VGND sg13cmos5l_mux2_1
XFILLER_7_112 VPWR VGND sg13cmos5l_fill_2
XFILLER_13_406 VPWR VGND sg13cmos5l_decap_8
XFILLER_14_918 VPWR VGND sg13cmos5l_decap_8
XFILLER_16_266 VPWR VGND sg13cmos5l_decap_8
XFILLER_17_70 VPWR VGND sg13cmos5l_decap_8
X_585_ _585_/X Tile_X0Y0_N2END[1] Tile_X0Y0_N4END[1] Tile_X0Y0_NN4END[14] _119_/X
+ _299_/Q _298_/Q VPWR VGND sg13cmos5l_mux4_1
XFILLER_12_450 VPWR VGND sg13cmos5l_decap_8
XFILLER_9_955 VPWR VGND sg13cmos5l_decap_4
XFILLER_8_454 VPWR VGND sg13cmos5l_decap_8
XFILLER_4_693 VPWR VGND sg13cmos5l_fill_2
XANTENNA__483__X Tile_X1Y0_FrameStrobe_O[4] VPWR VGND sg13cmos5l_antennanp
XFILLER_13_28 VPWR VGND sg13cmos5l_decap_8
XFILLER_1_118 VPWR VGND sg13cmos5l_fill_1
XFILLER_1_107 VPWR VGND sg13cmos5l_decap_8
XANTENNA_305 Tile_X0Y0_FrameData[7] VPWR VGND sg13cmos5l_antennanp
XANTENNA_316 Tile_X0Y0_FrameData[7] VPWR VGND sg13cmos5l_antennanp
XANTENNA_327 Tile_X0Y0_N4END[4] VPWR VGND sg13cmos5l_antennanp
XANTENNA_338 Tile_X1Y0_N4END[11] VPWR VGND sg13cmos5l_antennanp
XANTENNA_349 Tile_X0Y0_FrameData[22] VPWR VGND sg13cmos5l_antennanp
XANTENNA__393__X Tile_X0Y0_FrameStrobe_O[2] VPWR VGND sg13cmos5l_antennanp
XFILLER_13_203 VPWR VGND sg13cmos5l_decap_8
X_370_ _370_/L_HI VPWR VGND sg13cmos5l_tiehi
XFILLER_5_446 VPWR VGND sg13cmos5l_decap_8
XFILLER_1_696 VPWR VGND sg13cmos5l_decap_8
XFILLER_17_553 VPWR VGND sg13cmos5l_decap_8
X_637_ _637_/X Tile_X1Y0_N2END[5] Tile_X1Y0_N4END[13] Tile_X1Y0_NN4END[2] _087_/X
+ _146_/Q _145_/Q VPWR VGND sg13cmos5l_mux4_1
X_499_ Tile_X1Y0_S1BEG[0] Tile_X1Y0_N1END[3] VPWR VGND sg13cmos5l_buf_1
X_568_ _568_/X Tile_X0Y0_N2MID[0] Tile_X0Y0_N4END[15] Tile_X0Y0_NN4END[0] _092_/X
+ _333_/Q _332_/Q VPWR VGND sg13cmos5l_mux4_1
XFILLER_9_730 VPWR VGND sg13cmos5l_fill_2
XFILLER_8_284 VPWR VGND sg13cmos5l_fill_2
XFILLER_8_251 VPWR VGND sg13cmos5l_fill_2
XFILLER_5_73 VPWR VGND sg13cmos5l_decap_8
XANTENNA__478__X Tile_X1Y0_FrameData_O[31] VPWR VGND sg13cmos5l_antennanp
XFILLER_10_239 VPWR VGND sg13cmos5l_decap_4
XFILLER_6_7 VPWR VGND sg13cmos5l_fill_2
XANTENNA_102 Tile_X0Y0_FrameData[23] VPWR VGND sg13cmos5l_antennanp
XANTENNA_113 Tile_X0Y0_FrameData[27] VPWR VGND sg13cmos5l_antennanp
XANTENNA_124 Tile_X0Y0_FrameData[27] VPWR VGND sg13cmos5l_antennanp
XANTENNA__388__X Tile_X0Y0_SS4BEG[13] VPWR VGND sg13cmos5l_antennanp
XANTENNA_135 Tile_X0Y0_FrameData[27] VPWR VGND sg13cmos5l_antennanp
XANTENNA_146 Tile_X0Y0_FrameData[27] VPWR VGND sg13cmos5l_antennanp
XANTENNA_157 Tile_X0Y0_FrameData[27] VPWR VGND sg13cmos5l_antennanp
XANTENNA_168 Tile_X0Y0_FrameData[2] VPWR VGND sg13cmos5l_antennanp
XANTENNA_179 Tile_X0Y0_FrameData[2] VPWR VGND sg13cmos5l_antennanp
XFILLER_14_567 VPWR VGND sg13cmos5l_decap_8
X_284_ _284_/Q Tile_X0Y0_FrameData[5] VGND VPWR Tile_X0Y0_FrameStrobe[0] latch
X_353_ _353_/L_HI VPWR VGND sg13cmos5l_tiehi
X_422_ Tile_X0Y0_S2BEG[7] Tile_X0Y0_N2MID[0] VPWR VGND sg13cmos5l_buf_1
XFILLER_10_784 VPWR VGND sg13cmos5l_decap_4
XFILLER_10_795 VPWR VGND sg13cmos5l_decap_4
XFILLER_6_766 VPWR VGND sg13cmos5l_fill_2
XFILLER_5_232 VPWR VGND sg13cmos5l_decap_8
XFILLER_17_350 VPWR VGND sg13cmos5l_decap_8
XFILLER_18_895 VPWR VGND sg13cmos5l_decap_4
XFILLER_18_884 VPWR VGND sg13cmos5l_decap_8
XFILLER_3_736 VPWR VGND sg13cmos5l_decap_8
XFILLER_4_4 VPWR VGND sg13cmos5l_fill_2
XFILLER_2_268 VPWR VGND sg13cmos5l_decap_8
XFILLER_18_103 VPWR VGND sg13cmos5l_decap_8
XFILLER_14_364 VPWR VGND sg13cmos5l_decap_8
XFILLER_15_887 VPWR VGND sg13cmos5l_decap_8
X_267_ _267_/Q Tile_X0Y0_FrameData[22] VGND VPWR Tile_X0Y0_FrameStrobe[0] latch
X_336_ _336_/Q Tile_X0Y0_FrameData[17] VGND VPWR Tile_X0Y0_FrameStrobe[2] latch
X_405_ Tile_X0Y0_FrameStrobe_O[14] Tile_X0Y0_FrameStrobe[14] VPWR VGND sg13cmos5l_buf_1
X_198_ _198_/Q Tile_X0Y0_FrameData[18] VGND VPWR Tile_X1Y0_FrameStrobe[2] latch
XANTENNA_13 Tile_X0Y0_FrameData[1] VPWR VGND sg13cmos5l_antennanp
XANTENNA_24 Tile_X0Y0_FrameData[1] VPWR VGND sg13cmos5l_antennanp
XANTENNA_35 Tile_X0Y0_FrameData[1] VPWR VGND sg13cmos5l_antennanp
XANTENNA_46 Tile_X0Y0_FrameData[23] VPWR VGND sg13cmos5l_antennanp
XANTENNA_57 Tile_X0Y0_FrameData[23] VPWR VGND sg13cmos5l_antennanp
XANTENNA_68 Tile_X0Y0_FrameData[23] VPWR VGND sg13cmos5l_antennanp
XANTENNA_79 Tile_X0Y0_FrameData[23] VPWR VGND sg13cmos5l_antennanp
XANTENNA__491__X Tile_X1Y0_FrameStrobe_O[12] VPWR VGND sg13cmos5l_antennanp
XFILLER_9_390 VPWR VGND sg13cmos5l_decap_8
XFILLER_0_739 VPWR VGND sg13cmos5l_fill_2
XFILLER_11_345 VPWR VGND sg13cmos5l_decap_8
X_121_ PMOD_IO_OE_O1 _120_/A _061_/Y _110_/X _223_/Q _120_/Y VPWR VGND sg13cmos5l_a221oi_1
XFILLER_11_72 VPWR VGND sg13cmos5l_decap_8
XFILLER_3_577 VPWR VGND sg13cmos5l_fill_1
XFILLER_14_161 VPWR VGND sg13cmos5l_decap_8
XFILLER_15_640 VPWR VGND sg13cmos5l_decap_8
XFILLER_15_651 VPWR VGND sg13cmos5l_fill_1
X_319_ _319_/Q Tile_X0Y0_FrameData[2] VGND VPWR Tile_X0Y0_FrameStrobe[1] latch
XANTENNA__486__X Tile_X1Y0_FrameStrobe_O[7] VPWR VGND sg13cmos5l_antennanp
XFILLER_16_28 VPWR VGND sg13cmos5l_decap_8
XFILLER_5_809 VPWR VGND sg13cmos5l_fill_1
XANTENNA__396__X Tile_X0Y0_FrameStrobe_O[5] VPWR VGND sg13cmos5l_antennanp
XFILLER_0_525 VPWR VGND sg13cmos5l_fill_1
XFILLER_0_536 VPWR VGND sg13cmos5l_decap_8
XFILLER_17_905 VPWR VGND sg13cmos5l_decap_8
XFILLER_16_448 VPWR VGND sg13cmos5l_decap_8
XFILLER_11_142 VPWR VGND sg13cmos5l_decap_8
X_104_ PMOD_IO_OE_O5 _223_/Q _101_/X _103_/Y VPWR VGND sg13cmos5l_a21oi_1
XFILLER_8_625 VPWR VGND sg13cmos5l_decap_4
XFILLER_7_168 VPWR VGND sg13cmos5l_decap_4
XFILLER_4_864 VPWR VGND sg13cmos5l_decap_4
XFILLER_7_691 VPWR VGND sg13cmos5l_fill_2
XFILLER_5_617 VPWR VGND sg13cmos5l_fill_2
XFILLER_5_606 VPWR VGND sg13cmos5l_decap_8
XFILLER_4_127 VPWR VGND sg13cmos5l_decap_8
XFILLER_0_366 VPWR VGND sg13cmos5l_fill_2
XFILLER_17_713 VPWR VGND sg13cmos5l_fill_2
XFILLER_16_245 VPWR VGND sg13cmos5l_decap_8
X_584_ _584_/X Tile_X0Y0_N2END[0] Tile_X0Y0_N4END[0] Tile_X0Y0_NN4END[15] _091_/X
+ _301_/Q _300_/Q VPWR VGND sg13cmos5l_mux4_1
XFILLER_8_433 VPWR VGND sg13cmos5l_decap_8
XANTENNA_306 Tile_X0Y0_FrameData[7] VPWR VGND sg13cmos5l_antennanp
XANTENNA_317 Tile_X0Y0_FrameData[7] VPWR VGND sg13cmos5l_antennanp
XANTENNA_328 Tile_X0Y0_N4END[4] VPWR VGND sg13cmos5l_antennanp
XANTENNA_339 Tile_X1Y0_N4END[11] VPWR VGND sg13cmos5l_antennanp
XFILLER_13_259 VPWR VGND sg13cmos5l_decap_8
XFILLER_5_425 VPWR VGND sg13cmos5l_decap_8
XFILLER_0_141 VPWR VGND sg13cmos5l_decap_4
XFILLER_0_174 VPWR VGND sg13cmos5l_decap_4
XFILLER_1_675 VPWR VGND sg13cmos5l_decap_8
XFILLER_1_631 VPWR VGND sg13cmos5l_fill_2
XFILLER_17_532 VPWR VGND sg13cmos5l_decap_8
X_636_ _636_/X Tile_X1Y0_N2END[4] Tile_X1Y0_N4END[12] Tile_X1Y0_NN4END[3] _085_/X
+ _148_/Q _147_/Q VPWR VGND sg13cmos5l_mux4_1
X_567_ _567_/X Tile_X0Y0_N1END[3] Tile_X0Y0_N2MID[7] Tile_X0Y0_N2END[0] _119_/X _335_/Q
+ _334_/Q VPWR VGND sg13cmos5l_mux4_1
X_498_ Tile_X1Y0_FrameStrobe_O[19] Tile_X1Y0_FrameStrobe[19] VPWR VGND sg13cmos5l_buf_1
XFILLER_8_230 VPWR VGND sg13cmos5l_decap_8
XFILLER_4_480 VPWR VGND sg13cmos5l_decap_8
XFILLER_10_0 VPWR VGND sg13cmos5l_decap_8
XANTENNA__494__X Tile_X1Y0_FrameStrobe_O[15] VPWR VGND sg13cmos5l_antennanp
XFILLER_3_918 VPWR VGND sg13cmos5l_decap_8
XANTENNA_103 Tile_X0Y0_FrameData[23] VPWR VGND sg13cmos5l_antennanp
XANTENNA_114 Tile_X0Y0_FrameData[27] VPWR VGND sg13cmos5l_antennanp
XANTENNA_125 Tile_X0Y0_FrameData[27] VPWR VGND sg13cmos5l_antennanp
XANTENNA_136 Tile_X0Y0_FrameData[27] VPWR VGND sg13cmos5l_antennanp
XANTENNA_147 Tile_X0Y0_FrameData[27] VPWR VGND sg13cmos5l_antennanp
XANTENNA_158 Tile_X0Y0_FrameData[27] VPWR VGND sg13cmos5l_antennanp
X_421_ Tile_X0Y0_S2BEG[6] Tile_X0Y0_N2MID[1] VPWR VGND sg13cmos5l_buf_1
XANTENNA_169 Tile_X0Y0_FrameData[2] VPWR VGND sg13cmos5l_antennanp
XFILLER_14_546 VPWR VGND sg13cmos5l_decap_8
X_283_ _283_/Q Tile_X0Y0_FrameData[6] VGND VPWR Tile_X0Y0_FrameStrobe[0] latch
X_352_ _352_/L_HI VPWR VGND sg13cmos5l_tiehi
XFILLER_6_701 VPWR VGND sg13cmos5l_decap_8
XFILLER_5_277 VPWR VGND sg13cmos5l_decap_4
XFILLER_5_222 VPWR VGND sg13cmos5l_fill_2
XFILLER_1_494 VPWR VGND sg13cmos5l_fill_2
X_619_ _619_/X Tile_X1Y0_N2MID[3] Tile_X1Y0_N4END[4] Tile_X1Y0_NN4END[11] _087_/X
+ _182_/Q _181_/Q VPWR VGND sg13cmos5l_mux4_1
XFILLER_9_583 VPWR VGND sg13cmos5l_decap_8
XANTENNA__489__X Tile_X1Y0_FrameStrobe_O[10] VPWR VGND sg13cmos5l_antennanp
XFILLER_11_549 VPWR VGND sg13cmos5l_decap_8
XFILLER_3_715 VPWR VGND sg13cmos5l_decap_8
XFILLER_2_247 VPWR VGND sg13cmos5l_decap_8
XFILLER_2_214 VPWR VGND sg13cmos5l_decap_8
XANTENNA__399__X Tile_X0Y0_FrameStrobe_O[8] VPWR VGND sg13cmos5l_antennanp
XFILLER_14_343 VPWR VGND sg13cmos5l_decap_8
XFILLER_15_866 VPWR VGND sg13cmos5l_decap_8
XFILLER_18_137 VPWR VGND sg13cmos5l_decap_8
X_404_ Tile_X0Y0_FrameStrobe_O[13] Tile_X0Y0_FrameStrobe[13] VPWR VGND sg13cmos5l_buf_1
X_266_ _266_/Q Tile_X0Y0_FrameData[23] VGND VPWR Tile_X0Y0_FrameStrobe[0] latch
X_335_ _335_/Q Tile_X0Y0_FrameData[18] VGND VPWR Tile_X0Y0_FrameStrobe[2] latch
X_197_ _197_/Q Tile_X0Y0_FrameData[19] VGND VPWR Tile_X1Y0_FrameStrobe[2] latch
XFILLER_6_520 VPWR VGND sg13cmos5l_decap_4
XFILLER_6_575 VPWR VGND sg13cmos5l_decap_8
XANTENNA_14 Tile_X0Y0_FrameData[1] VPWR VGND sg13cmos5l_antennanp
XANTENNA_25 Tile_X0Y0_FrameData[1] VPWR VGND sg13cmos5l_antennanp
XANTENNA_36 Tile_X0Y0_FrameData[1] VPWR VGND sg13cmos5l_antennanp
XANTENNA_47 Tile_X0Y0_FrameData[23] VPWR VGND sg13cmos5l_antennanp
XANTENNA_58 Tile_X0Y0_FrameData[23] VPWR VGND sg13cmos5l_antennanp
XANTENNA_69 Tile_X0Y0_FrameData[23] VPWR VGND sg13cmos5l_antennanp
XFILLER_11_324 VPWR VGND sg13cmos5l_decap_8
XFILLER_12_869 VPWR VGND sg13cmos5l_decap_8
X_120_ _120_/Y _120_/A _244_/D VPWR VGND sg13cmos5l_nor2_1
XFILLER_3_589 VPWR VGND sg13cmos5l_fill_2
XFILLER_3_534 VPWR VGND sg13cmos5l_decap_4
XFILLER_3_523 VPWR VGND sg13cmos5l_fill_1
XFILLER_14_140 VPWR VGND sg13cmos5l_decap_8
XFILLER_15_630 VPWR VGND sg13cmos5l_decap_4
XFILLER_15_674 VPWR VGND sg13cmos5l_fill_2
X_318_ _318_/Q Tile_X0Y0_FrameData[3] VGND VPWR Tile_X0Y0_FrameStrobe[1] latch
X_249_ _249_/Q Tile_X0Y0_UserCLK _249_/D _354_/L_HI VPWR VGND sg13cmos5l_dfrbpq_1
XFILLER_7_895 VPWR VGND sg13cmos5l_decap_8
XFILLER_6_383 VPWR VGND sg13cmos5l_decap_8
XFILLER_11_121 VPWR VGND sg13cmos5l_decap_8
XFILLER_16_427 VPWR VGND sg13cmos5l_decap_8
XFILLER_11_198 VPWR VGND sg13cmos5l_decap_8
X_103_ _103_/Y _120_/A _248_/D _102_/X VPWR VGND sg13cmos5l_o21ai_1
XFILLER_8_637 VPWR VGND sg13cmos5l_fill_2
XFILLER_7_125 VPWR VGND sg13cmos5l_fill_1
XFILLER_4_898 VPWR VGND sg13cmos5l_fill_2
XFILLER_14_7 VPWR VGND sg13cmos5l_decap_8
XFILLER_8_63 VPWR VGND sg13cmos5l_decap_8
XFILLER_7_670 VPWR VGND sg13cmos5l_decap_8
XANTENNA__497__X Tile_X1Y0_FrameStrobe_O[18] VPWR VGND sg13cmos5l_antennanp
XFILLER_16_224 VPWR VGND sg13cmos5l_decap_8
X_583_ _583_/X Tile_X0Y0_N2MID[7] Tile_X0Y0_N4END[0] Tile_X0Y0_NN4END[15] _092_/X
+ _303_/Q _302_/Q VPWR VGND sg13cmos5l_mux4_1
XFILLER_12_485 VPWR VGND sg13cmos5l_decap_8
XFILLER_9_935 VPWR VGND sg13cmos5l_fill_1
XFILLER_9_924 VPWR VGND sg13cmos5l_decap_8
XFILLER_8_412 VPWR VGND sg13cmos5l_decap_8
XFILLER_8_489 VPWR VGND sg13cmos5l_decap_8
XFILLER_4_662 VPWR VGND sg13cmos5l_fill_2
XANTENNA_307 Tile_X0Y0_FrameData[7] VPWR VGND sg13cmos5l_antennanp
XANTENNA_318 Tile_X0Y0_FrameData[7] VPWR VGND sg13cmos5l_antennanp
XANTENNA_329 Tile_X0Y0_NN4END[11] VPWR VGND sg13cmos5l_antennanp
XFILLER_10_934 VPWR VGND sg13cmos5l_fill_2
XFILLER_13_238 VPWR VGND sg13cmos5l_decap_8
XFILLER_14_739 VPWR VGND sg13cmos5l_fill_2
XFILLER_5_404 VPWR VGND sg13cmos5l_decap_8
XFILLER_0_120 VPWR VGND sg13cmos5l_decap_8
XFILLER_0_197 VPWR VGND sg13cmos5l_fill_2
XFILLER_1_654 VPWR VGND sg13cmos5l_decap_8
XFILLER_17_511 VPWR VGND sg13cmos5l_decap_8
XFILLER_17_588 VPWR VGND sg13cmos5l_decap_8
X_635_ _635_/X Tile_X1Y0_N2END[3] Tile_X1Y0_N4END[11] Tile_X1Y0_NN4END[4] _095_/X
+ _150_/Q _149_/Q VPWR VGND sg13cmos5l_mux4_1
X_566_ _566_/X Tile_X0Y0_N1END[2] Tile_X0Y0_N2MID[6] Tile_X0Y0_N2END[1] _092_/X _337_/Q
+ _336_/Q VPWR VGND sg13cmos5l_mux4_1
XFILLER_12_282 VPWR VGND sg13cmos5l_decap_8
X_497_ Tile_X1Y0_FrameStrobe_O[18] Tile_X1Y0_FrameStrobe[18] VPWR VGND sg13cmos5l_buf_1
XFILLER_9_754 VPWR VGND sg13cmos5l_decap_8
XFILLER_9_732 VPWR VGND sg13cmos5l_fill_1
XFILLER_2_429 VPWR VGND sg13cmos5l_decap_8
XFILLER_6_9 VPWR VGND sg13cmos5l_fill_1
XANTENNA_104 Tile_X0Y0_FrameData[23] VPWR VGND sg13cmos5l_antennanp
XANTENNA_115 Tile_X0Y0_FrameData[27] VPWR VGND sg13cmos5l_antennanp
XANTENNA_126 Tile_X0Y0_FrameData[27] VPWR VGND sg13cmos5l_antennanp
XANTENNA_137 Tile_X0Y0_FrameData[27] VPWR VGND sg13cmos5l_antennanp
XANTENNA_148 Tile_X0Y0_FrameData[27] VPWR VGND sg13cmos5l_antennanp
XANTENNA_159 Tile_X0Y0_FrameData[27] VPWR VGND sg13cmos5l_antennanp
XFILLER_14_525 VPWR VGND sg13cmos5l_decap_8
X_351_ _351_/L_HI VPWR VGND sg13cmos5l_tiehi
X_420_ Tile_X0Y0_S2BEG[5] Tile_X0Y0_N2MID[2] VPWR VGND sg13cmos5l_buf_1
XFILLER_14_84 VPWR VGND sg13cmos5l_decap_8
X_282_ _282_/Q Tile_X0Y0_FrameData[7] VGND VPWR Tile_X0Y0_FrameStrobe[0] latch
XFILLER_6_768 VPWR VGND sg13cmos5l_fill_1
XFILLER_5_289 VPWR VGND sg13cmos5l_decap_4
XFILLER_17_385 VPWR VGND sg13cmos5l_decap_8
X_549_ Tile_X1Y0_SS4BEG[14] _638_/X VPWR VGND sg13cmos5l_buf_1
X_618_ _618_/X Tile_X1Y0_N2MID[2] Tile_X1Y0_N4END[5] Tile_X1Y0_NN4END[10] _089_/X
+ _184_/Q _183_/Q VPWR VGND sg13cmos5l_mux4_1
XFILLER_18_864 VPWR VGND sg13cmos5l_decap_8
XFILLER_9_551 VPWR VGND sg13cmos5l_decap_8
XFILLER_11_528 VPWR VGND sg13cmos5l_decap_8
XFILLER_18_127 VPWR VGND sg13cmos5l_decap_8
XFILLER_14_322 VPWR VGND sg13cmos5l_decap_8
XFILLER_14_399 VPWR VGND sg13cmos5l_decap_8
X_334_ _334_/Q Tile_X0Y0_FrameData[19] VGND VPWR Tile_X0Y0_FrameStrobe[2] latch
X_403_ Tile_X0Y0_FrameStrobe_O[12] Tile_X0Y0_FrameStrobe[12] VPWR VGND sg13cmos5l_buf_1
X_265_ _265_/Q Tile_X0Y0_FrameData[24] VGND VPWR Tile_X0Y0_FrameStrobe[0] latch
X_196_ _196_/Q Tile_X0Y0_FrameData[20] VGND VPWR Tile_X1Y0_FrameStrobe[2] latch
XFILLER_2_793 VPWR VGND sg13cmos5l_decap_4
XFILLER_2_782 VPWR VGND sg13cmos5l_decap_4
XFILLER_2_43 VPWR VGND sg13cmos5l_decap_8
XFILLER_17_182 VPWR VGND sg13cmos5l_decap_8
XFILLER_18_661 VPWR VGND sg13cmos5l_decap_8
XANTENNA_15 Tile_X0Y0_FrameData[1] VPWR VGND sg13cmos5l_antennanp
XANTENNA_26 Tile_X0Y0_FrameData[1] VPWR VGND sg13cmos5l_antennanp
XANTENNA_37 Tile_X0Y0_FrameData[1] VPWR VGND sg13cmos5l_antennanp
XANTENNA_48 Tile_X0Y0_FrameData[23] VPWR VGND sg13cmos5l_antennanp
XANTENNA_59 Tile_X0Y0_FrameData[23] VPWR VGND sg13cmos5l_antennanp
XFILLER_11_303 VPWR VGND sg13cmos5l_decap_8
XFILLER_15_119 VPWR VGND sg13cmos5l_decap_8
XFILLER_16_609 VPWR VGND sg13cmos5l_decap_8
XFILLER_12_848 VPWR VGND sg13cmos5l_decap_8
XFILLER_3_502 VPWR VGND sg13cmos5l_decap_8
XFILLER_11_52 VPWR VGND sg13cmos5l_fill_2
XFILLER_3_568 VPWR VGND sg13cmos5l_decap_8
XFILLER_14_196 VPWR VGND sg13cmos5l_decap_8
X_317_ _317_/Q Tile_X0Y0_FrameData[4] VGND VPWR Tile_X0Y0_FrameStrobe[1] latch
X_248_ _248_/Q Tile_X0Y0_UserCLK _248_/D _351_/L_HI VPWR VGND sg13cmos5l_dfrbpq_1
X_179_ _179_/Q Tile_X0Y0_FrameData[5] VGND VPWR Tile_X1Y0_FrameStrobe[1] latch
XFILLER_7_874 VPWR VGND sg13cmos5l_decap_8
XFILLER_7_830 VPWR VGND sg13cmos5l_decap_8
XFILLER_16_406 VPWR VGND sg13cmos5l_decap_8
XFILLER_11_100 VPWR VGND sg13cmos5l_decap_8
XFILLER_11_177 VPWR VGND sg13cmos5l_decap_8
X_102_ _102_/X _233_/Q _248_/Q VPWR VGND sg13cmos5l_or2_1
XFILLER_4_877 VPWR VGND sg13cmos5l_decap_8
XFILLER_4_833 VPWR VGND sg13cmos5l_decap_8
XFILLER_3_354 VPWR VGND sg13cmos5l_fill_2
XFILLER_0_0 VPWR VGND sg13cmos5l_decap_8
XFILLER_16_940 VPWR VGND sg13cmos5l_fill_1
XFILLER_16_951 VPWR VGND sg13cmos5l_decap_8
XFILLER_15_483 VPWR VGND sg13cmos5l_decap_8
XFILLER_8_42 VPWR VGND sg13cmos5l_decap_8
XFILLER_16_203 VPWR VGND sg13cmos5l_decap_8
XFILLER_17_84 VPWR VGND sg13cmos5l_decap_8
X_582_ _582_/X Tile_X0Y0_N2MID[6] Tile_X0Y0_N4END[1] Tile_X0Y0_NN4END[14] _091_/X
+ _305_/Q _304_/Q VPWR VGND sg13cmos5l_mux4_1
XFILLER_12_464 VPWR VGND sg13cmos5l_decap_8
XFILLER_9_903 VPWR VGND sg13cmos5l_decap_8
XFILLER_8_468 VPWR VGND sg13cmos5l_decap_8
XFILLER_0_880 VPWR VGND sg13cmos5l_fill_1
XFILLER_15_280 VPWR VGND sg13cmos5l_decap_8
XFILLER_7_490 VPWR VGND sg13cmos5l_decap_4
XANTENNA_308 Tile_X0Y0_FrameData[7] VPWR VGND sg13cmos5l_antennanp
XANTENNA_319 Tile_X0Y0_FrameData[7] VPWR VGND sg13cmos5l_antennanp
XFILLER_10_913 VPWR VGND sg13cmos5l_decap_8
XFILLER_13_217 VPWR VGND sg13cmos5l_decap_8
X_634_ _634_/X Tile_X1Y0_N2END[2] Tile_X1Y0_N4END[10] Tile_X1Y0_NN4END[5] _064_/X
+ _152_/Q _151_/Q VPWR VGND sg13cmos5l_mux4_1
XFILLER_17_567 VPWR VGND sg13cmos5l_decap_8
X_496_ Tile_X1Y0_FrameStrobe_O[17] Tile_X1Y0_FrameStrobe[17] VPWR VGND sg13cmos5l_buf_1
X_565_ _565_/X Tile_X0Y0_N1END[1] Tile_X0Y0_N2MID[5] Tile_X0Y0_N2END[2] _091_/X _339_/Q
+ _338_/Q VPWR VGND sg13cmos5l_mux4_1
XFILLER_12_261 VPWR VGND sg13cmos5l_decap_8
XFILLER_5_54 VPWR VGND sg13cmos5l_decap_4
XFILLER_18_309 VPWR VGND sg13cmos5l_decap_8
XANTENNA_105 Tile_X0Y0_FrameData[23] VPWR VGND sg13cmos5l_antennanp
XANTENNA_116 Tile_X0Y0_FrameData[27] VPWR VGND sg13cmos5l_antennanp
XANTENNA_127 Tile_X0Y0_FrameData[27] VPWR VGND sg13cmos5l_antennanp
XANTENNA_138 Tile_X0Y0_FrameData[27] VPWR VGND sg13cmos5l_antennanp
XANTENNA_149 Tile_X0Y0_FrameData[27] VPWR VGND sg13cmos5l_antennanp
XFILLER_14_504 VPWR VGND sg13cmos5l_decap_8
X_350_ _350_/Q Tile_X0Y0_FrameData[31] VGND VPWR Tile_X0Y0_FrameStrobe[0] latch
XFILLER_10_721 VPWR VGND sg13cmos5l_fill_1
XFILLER_10_765 VPWR VGND sg13cmos5l_decap_4
XFILLER_14_63 VPWR VGND sg13cmos5l_decap_8
X_281_ _281_/Q Tile_X0Y0_FrameData[8] VGND VPWR Tile_X0Y0_FrameStrobe[0] latch
XFILLER_5_224 VPWR VGND sg13cmos5l_fill_1
XFILLER_2_920 VPWR VGND sg13cmos5l_decap_8
XFILLER_1_452 VPWR VGND sg13cmos5l_decap_8
XFILLER_1_430 VPWR VGND sg13cmos5l_fill_2
XFILLER_17_364 VPWR VGND sg13cmos5l_decap_8
X_617_ _617_/X Tile_X1Y0_N2MID[1] Tile_X1Y0_N4END[6] Tile_X1Y0_NN4END[9] _064_/X _186_/Q
+ _185_/Q VPWR VGND sg13cmos5l_mux4_1
XFILLER_13_581 VPWR VGND sg13cmos5l_decap_8
X_479_ Tile_X1Y0_FrameStrobe_O[0] Tile_X1Y0_FrameStrobe[0] VPWR VGND sg13cmos5l_buf_1
X_548_ Tile_X1Y0_SS4BEG[13] _637_/X VPWR VGND sg13cmos5l_buf_1
XFILLER_9_530 VPWR VGND sg13cmos5l_decap_8
XFILLER_11_507 VPWR VGND sg13cmos5l_decap_8
XFILLER_14_301 VPWR VGND sg13cmos5l_decap_8
XFILLER_14_378 VPWR VGND sg13cmos5l_decap_8
XFILLER_15_824 VPWR VGND sg13cmos5l_fill_1
X_264_ _264_/Q Tile_X0Y0_FrameData[25] VGND VPWR Tile_X0Y0_FrameStrobe[0] latch
X_333_ _333_/Q Tile_X0Y0_FrameData[20] VGND VPWR Tile_X0Y0_FrameStrobe[2] latch
X_402_ Tile_X0Y0_FrameStrobe_O[11] Tile_X0Y0_FrameStrobe[11] VPWR VGND sg13cmos5l_buf_1
XFILLER_10_540 VPWR VGND sg13cmos5l_decap_8
XFILLER_10_584 VPWR VGND sg13cmos5l_fill_1
X_195_ _195_/Q Tile_X0Y0_FrameData[21] VGND VPWR Tile_X1Y0_FrameStrobe[2] latch
XFILLER_2_66 VPWR VGND sg13cmos5l_decap_8
XFILLER_17_161 VPWR VGND sg13cmos5l_decap_8
XANTENNA_16 Tile_X0Y0_FrameData[1] VPWR VGND sg13cmos5l_antennanp
XANTENNA_27 Tile_X0Y0_FrameData[1] VPWR VGND sg13cmos5l_antennanp
XANTENNA_38 Tile_X0Y0_FrameData[1] VPWR VGND sg13cmos5l_antennanp
XANTENNA_49 Tile_X0Y0_FrameData[23] VPWR VGND sg13cmos5l_antennanp
XFILLER_14_890 VPWR VGND sg13cmos5l_decap_8
XFILLER_12_827 VPWR VGND sg13cmos5l_decap_8
XFILLER_8_809 VPWR VGND sg13cmos5l_decap_8
XFILLER_11_31 VPWR VGND sg13cmos5l_decap_8
XFILLER_11_359 VPWR VGND sg13cmos5l_decap_8
XFILLER_11_86 VPWR VGND sg13cmos5l_decap_8
XFILLER_2_4 VPWR VGND sg13cmos5l_fill_2
XFILLER_11_893 VPWR VGND sg13cmos5l_decap_8
XFILLER_14_175 VPWR VGND sg13cmos5l_decap_8
X_316_ _316_/Q Tile_X0Y0_FrameData[5] VGND VPWR Tile_X0Y0_FrameStrobe[1] latch
X_247_ _247_/Q Tile_X0Y0_UserCLK _247_/D _356_/L_HI VPWR VGND sg13cmos5l_dfrbpq_1
XANTENNA__113__Y PMOD_IO_O3 VPWR VGND sg13cmos5l_antennanp
X_178_ _178_/Q Tile_X0Y0_FrameData[6] VGND VPWR Tile_X1Y0_FrameStrobe[1] latch
XFILLER_17_919 VPWR VGND sg13cmos5l_decap_8
XFILLER_11_156 VPWR VGND sg13cmos5l_decap_8
XFILLER_12_613 VPWR VGND sg13cmos5l_decap_8
X_101_ _101_/X _256_/Q _557_/X _233_/Q VPWR VGND sg13cmos5l_mux2_1
XFILLER_8_639 VPWR VGND sg13cmos5l_fill_1
XFILLER_4_812 VPWR VGND sg13cmos5l_decap_8
XFILLER_15_462 VPWR VGND sg13cmos5l_decap_8
XANTENNA__108__Y PMOD_IO_OE_O7 VPWR VGND sg13cmos5l_antennanp
XFILLER_8_87 VPWR VGND sg13cmos5l_fill_2
XFILLER_8_21 VPWR VGND sg13cmos5l_decap_8
XFILLER_0_303 VPWR VGND sg13cmos5l_decap_4
XFILLER_1_859 VPWR VGND sg13cmos5l_fill_2
XFILLER_13_911 VPWR VGND sg13cmos5l_decap_8
XFILLER_16_259 VPWR VGND sg13cmos5l_decap_8
XFILLER_17_63 VPWR VGND sg13cmos5l_decap_8
X_581_ _581_/X Tile_X0Y0_N2MID[5] Tile_X0Y0_N4END[2] Tile_X0Y0_NN4END[13] _119_/X
+ _307_/Q _306_/Q VPWR VGND sg13cmos5l_mux4_1
XFILLER_12_443 VPWR VGND sg13cmos5l_decap_8
XFILLER_9_959 VPWR VGND sg13cmos5l_fill_1
XFILLER_8_447 VPWR VGND sg13cmos5l_decap_8
XFILLER_4_664 VPWR VGND sg13cmos5l_fill_1
XFILLER_3_185 VPWR VGND sg13cmos5l_fill_1
XANTENNA_309 Tile_X0Y0_FrameData[7] VPWR VGND sg13cmos5l_antennanp
XFILLER_10_936 VPWR VGND sg13cmos5l_fill_1
XFILLER_10_958 VPWR VGND sg13cmos5l_fill_2
XFILLER_5_439 VPWR VGND sg13cmos5l_decap_8
XFILLER_0_188 VPWR VGND sg13cmos5l_fill_2
XFILLER_17_546 VPWR VGND sg13cmos5l_decap_8
X_633_ _633_/X Tile_X1Y0_N2END[1] Tile_X1Y0_N4END[9] Tile_X1Y0_NN4END[6] _089_/X _154_/Q
+ _153_/Q VPWR VGND sg13cmos5l_mux4_1
XFILLER_1_689 VPWR VGND sg13cmos5l_fill_2
XFILLER_12_240 VPWR VGND sg13cmos5l_decap_8
XFILLER_13_730 VPWR VGND sg13cmos5l_decap_4
XFILLER_13_741 VPWR VGND sg13cmos5l_fill_1
XFILLER_13_752 VPWR VGND sg13cmos5l_fill_1
X_495_ Tile_X1Y0_FrameStrobe_O[16] Tile_X1Y0_FrameStrobe[16] VPWR VGND sg13cmos5l_buf_1
X_564_ _564_/X Tile_X0Y0_N1END[0] Tile_X0Y0_N2MID[4] Tile_X0Y0_N2END[3] _119_/X _341_/Q
+ _340_/Q VPWR VGND sg13cmos5l_mux4_1
XFILLER_9_723 VPWR VGND sg13cmos5l_decap_8
XFILLER_8_244 VPWR VGND sg13cmos5l_decap_8
XANTENNA__121__Y PMOD_IO_OE_O1 VPWR VGND sg13cmos5l_antennanp
XANTENNA__402__X Tile_X0Y0_FrameStrobe_O[11] VPWR VGND sg13cmos5l_antennanp
XANTENNA_106 Tile_X0Y0_FrameData[23] VPWR VGND sg13cmos5l_antennanp
XANTENNA_117 Tile_X0Y0_FrameData[27] VPWR VGND sg13cmos5l_antennanp
XANTENNA_128 Tile_X0Y0_FrameData[27] VPWR VGND sg13cmos5l_antennanp
XANTENNA_139 Tile_X0Y0_FrameData[27] VPWR VGND sg13cmos5l_antennanp
XFILLER_10_700 VPWR VGND sg13cmos5l_decap_4
XFILLER_14_42 VPWR VGND sg13cmos5l_decap_8
X_280_ _280_/Q Tile_X0Y0_FrameData[9] VGND VPWR Tile_X0Y0_FrameStrobe[0] latch
XFILLER_10_777 VPWR VGND sg13cmos5l_decap_8
XFILLER_10_799 VPWR VGND sg13cmos5l_fill_2
XFILLER_17_343 VPWR VGND sg13cmos5l_decap_8
X_547_ Tile_X1Y0_SS4BEG[12] _636_/X VPWR VGND sg13cmos5l_buf_1
X_616_ _616_/X Tile_X1Y0_N2MID[0] Tile_X1Y0_N4END[7] Tile_X1Y0_NN4END[8] _095_/X _188_/Q
+ _187_/Q VPWR VGND sg13cmos5l_mux4_1
XFILLER_18_899 VPWR VGND sg13cmos5l_fill_2
XANTENNA__116__Y PMOD_IO_O6 VPWR VGND sg13cmos5l_antennanp
XFILLER_13_560 VPWR VGND sg13cmos5l_decap_8
X_478_ Tile_X1Y0_FrameData_O[31] Tile_X0Y0_FrameData[31] VPWR VGND sg13cmos5l_buf_1
XFILLER_9_597 VPWR VGND sg13cmos5l_decap_4
XFILLER_4_291 VPWR VGND sg13cmos5l_fill_1
XFILLER_3_729 VPWR VGND sg13cmos5l_decap_8
XFILLER_2_228 VPWR VGND sg13cmos5l_decap_4
X_401_ Tile_X0Y0_FrameStrobe_O[10] Tile_X0Y0_FrameStrobe[10] VPWR VGND sg13cmos5l_buf_1
XFILLER_14_357 VPWR VGND sg13cmos5l_decap_8
X_332_ _332_/Q Tile_X0Y0_FrameData[21] VGND VPWR Tile_X0Y0_FrameStrobe[2] latch
X_263_ _263_/Q Tile_X0Y0_FrameData[26] VGND VPWR Tile_X0Y0_FrameStrobe[0] latch
X_194_ _194_/Q Tile_X0Y0_FrameData[22] VGND VPWR Tile_X1Y0_FrameStrobe[2] latch
XFILLER_6_534 VPWR VGND sg13cmos5l_decap_4
XFILLER_2_34 VPWR VGND sg13cmos5l_fill_2
XFILLER_1_294 VPWR VGND sg13cmos5l_fill_1
XFILLER_1_272 VPWR VGND sg13cmos5l_decap_8
XFILLER_17_140 VPWR VGND sg13cmos5l_decap_8
XANTENNA_17 Tile_X0Y0_FrameData[1] VPWR VGND sg13cmos5l_antennanp
XANTENNA_28 Tile_X0Y0_FrameData[1] VPWR VGND sg13cmos5l_antennanp
XANTENNA_39 Tile_X0Y0_FrameData[1] VPWR VGND sg13cmos5l_antennanp
XFILLER_9_383 VPWR VGND sg13cmos5l_decap_8
XFILLER_11_338 VPWR VGND sg13cmos5l_decap_8
XFILLER_11_65 VPWR VGND sg13cmos5l_decap_8
XANTENNA__500__X Tile_X1Y0_S1BEG[1] VPWR VGND sg13cmos5l_antennanp
XFILLER_14_154 VPWR VGND sg13cmos5l_decap_8
XFILLER_10_393 VPWR VGND sg13cmos5l_decap_8
XFILLER_11_872 VPWR VGND sg13cmos5l_decap_8
X_315_ _315_/Q Tile_X0Y0_FrameData[6] VGND VPWR Tile_X0Y0_FrameStrobe[1] latch
X_246_ _246_/Q Tile_X0Y0_UserCLK _246_/D _355_/L_HI VPWR VGND sg13cmos5l_dfrbpq_1
X_177_ _177_/Q Tile_X0Y0_FrameData[7] VGND VPWR Tile_X1Y0_FrameStrobe[1] latch
XANTENNA__410__X Tile_X0Y0_FrameStrobe_O[19] VPWR VGND sg13cmos5l_antennanp
XFILLER_6_397 VPWR VGND sg13cmos5l_decap_8
XFILLER_2_581 VPWR VGND sg13cmos5l_decap_4
XFILLER_18_493 VPWR VGND sg13cmos5l_fill_2
XFILLER_0_518 VPWR VGND sg13cmos5l_decap_8
XFILLER_11_135 VPWR VGND sg13cmos5l_decap_8
X_100_ PMOD_IO_OE_O6 _223_/Q _097_/X _099_/Y VPWR VGND sg13cmos5l_a21oi_1
XFILLER_8_629 VPWR VGND sg13cmos5l_fill_1
XFILLER_4_868 VPWR VGND sg13cmos5l_fill_2
XFILLER_4_857 VPWR VGND sg13cmos5l_decap_8
XFILLER_3_312 VPWR VGND sg13cmos5l_decap_8
XFILLER_15_441 VPWR VGND sg13cmos5l_decap_8
XANTENNA__405__X Tile_X0Y0_FrameStrobe_O[14] VPWR VGND sg13cmos5l_antennanp
X_229_ _229_/Q Tile_X0Y0_FrameData[22] VGND VPWR Tile_X1Y0_FrameStrobe[3] latch
XFILLER_8_77 VPWR VGND sg13cmos5l_fill_2
XFILLER_7_684 VPWR VGND sg13cmos5l_decap_8
XFILLER_1_805 VPWR VGND sg13cmos5l_fill_2
X_580_ _580_/X Tile_X0Y0_N2MID[4] Tile_X0Y0_N4END[3] Tile_X0Y0_NN4END[12] _092_/X
+ _309_/Q _308_/Q VPWR VGND sg13cmos5l_mux4_1
XFILLER_12_422 VPWR VGND sg13cmos5l_decap_8
XFILLER_16_238 VPWR VGND sg13cmos5l_decap_8
XFILLER_17_42 VPWR VGND sg13cmos5l_decap_8
XFILLER_12_499 VPWR VGND sg13cmos5l_decap_8
XFILLER_8_426 VPWR VGND sg13cmos5l_decap_8
XFILLER_4_654 VPWR VGND sg13cmos5l_fill_1
XFILLER_3_164 VPWR VGND sg13cmos5l_decap_8
XFILLER_3_153 VPWR VGND sg13cmos5l_decap_8
XFILLER_12_7 VPWR VGND sg13cmos5l_decap_8
XFILLER_5_418 VPWR VGND sg13cmos5l_decap_8
XFILLER_0_134 VPWR VGND sg13cmos5l_decap_8
XFILLER_0_167 VPWR VGND sg13cmos5l_decap_8
XFILLER_0_178 VPWR VGND sg13cmos5l_fill_2
XFILLER_1_668 VPWR VGND sg13cmos5l_decap_8
XFILLER_1_624 VPWR VGND sg13cmos5l_decap_8
XFILLER_17_525 VPWR VGND sg13cmos5l_decap_8
X_632_ _632_/X Tile_X1Y0_N2END[0] Tile_X1Y0_N4END[8] Tile_X1Y0_NN4END[7] _087_/X _156_/Q
+ _155_/Q VPWR VGND sg13cmos5l_mux4_1
X_563_ _563_/X Tile_X0Y0_N1END[3] Tile_X0Y0_N2MID[3] Tile_X0Y0_N2END[4] _092_/X _343_/Q
+ _342_/Q VPWR VGND sg13cmos5l_mux4_1
XFILLER_12_296 VPWR VGND sg13cmos5l_decap_8
X_494_ Tile_X1Y0_FrameStrobe_O[15] Tile_X1Y0_FrameStrobe[15] VPWR VGND sg13cmos5l_buf_1
XFILLER_9_768 VPWR VGND sg13cmos5l_decap_8
XFILLER_9_713 VPWR VGND sg13cmos5l_fill_2
XFILLER_8_223 VPWR VGND sg13cmos5l_decap_8
XFILLER_5_45 VPWR VGND sg13cmos5l_decap_4
XFILLER_4_473 VPWR VGND sg13cmos5l_decap_8
XANTENNA_107 Tile_X0Y0_FrameData[23] VPWR VGND sg13cmos5l_antennanp
XANTENNA_118 Tile_X0Y0_FrameData[27] VPWR VGND sg13cmos5l_antennanp
XANTENNA_129 Tile_X0Y0_FrameData[27] VPWR VGND sg13cmos5l_antennanp
XFILLER_14_21 VPWR VGND sg13cmos5l_decap_8
XFILLER_14_539 VPWR VGND sg13cmos5l_decap_8
XANTENNA__503__X Tile_X1Y0_S2BEG[0] VPWR VGND sg13cmos5l_antennanp
XFILLER_14_98 VPWR VGND sg13cmos5l_decap_8
XFILLER_1_432 VPWR VGND sg13cmos5l_fill_1
XFILLER_17_322 VPWR VGND sg13cmos5l_decap_8
XFILLER_17_399 VPWR VGND sg13cmos5l_decap_8
X_546_ Tile_X1Y0_SS4BEG[11] _635_/X VPWR VGND sg13cmos5l_buf_1
X_615_ _615_/X Tile_X1Y0_N2MID[7] Tile_X1Y0_N4END[8] Tile_X1Y0_NN4END[7] _085_/X _190_/Q
+ _189_/Q VPWR VGND sg13cmos5l_mux4_1
XFILLER_18_878 VPWR VGND sg13cmos5l_fill_2
X_477_ Tile_X1Y0_FrameData_O[30] Tile_X0Y0_FrameData[30] VPWR VGND sg13cmos5l_buf_1
XFILLER_9_576 VPWR VGND sg13cmos5l_decap_8
XFILLER_9_565 VPWR VGND sg13cmos5l_decap_4
XANTENNA__413__X Tile_X0Y0_S1BEG[2] VPWR VGND sg13cmos5l_antennanp
XFILLER_2_207 VPWR VGND sg13cmos5l_decap_8
XFILLER_14_336 VPWR VGND sg13cmos5l_decap_8
XFILLER_15_859 VPWR VGND sg13cmos5l_decap_8
X_331_ _331_/Q Tile_X0Y0_FrameData[22] VGND VPWR Tile_X0Y0_FrameStrobe[2] latch
X_400_ Tile_X0Y0_FrameStrobe_O[9] Tile_X0Y0_FrameStrobe[9] VPWR VGND sg13cmos5l_buf_1
X_262_ _262_/Q Tile_X0Y0_FrameData[27] VGND VPWR Tile_X0Y0_FrameStrobe[0] latch
X_193_ _193_/Q Tile_X0Y0_FrameData[23] VGND VPWR Tile_X1Y0_FrameStrobe[2] latch
XFILLER_6_524 VPWR VGND sg13cmos5l_fill_1
XFILLER_6_502 VPWR VGND sg13cmos5l_decap_8
XFILLER_6_568 VPWR VGND sg13cmos5l_decap_8
XFILLER_1_251 VPWR VGND sg13cmos5l_decap_8
XFILLER_2_57 VPWR VGND sg13cmos5l_fill_2
XANTENNA_18 Tile_X0Y0_FrameData[1] VPWR VGND sg13cmos5l_antennanp
XANTENNA_29 Tile_X0Y0_FrameData[1] VPWR VGND sg13cmos5l_antennanp
XANTENNA__408__X Tile_X0Y0_FrameStrobe_O[17] VPWR VGND sg13cmos5l_antennanp
XFILLER_17_196 VPWR VGND sg13cmos5l_decap_8
X_529_ Tile_X1Y0_S4BEG[10] _618_/X VPWR VGND sg13cmos5l_buf_1
XFILLER_9_362 VPWR VGND sg13cmos5l_decap_8
XFILLER_5_590 VPWR VGND sg13cmos5l_fill_2
XFILLER_11_317 VPWR VGND sg13cmos5l_decap_8
XFILLER_3_538 VPWR VGND sg13cmos5l_fill_2
XFILLER_3_516 VPWR VGND sg13cmos5l_decap_8
XFILLER_14_133 VPWR VGND sg13cmos5l_decap_8
XFILLER_15_623 VPWR VGND sg13cmos5l_decap_8
XFILLER_15_634 VPWR VGND sg13cmos5l_fill_2
X_314_ _314_/Q Tile_X0Y0_FrameData[7] VGND VPWR Tile_X0Y0_FrameStrobe[1] latch
XFILLER_10_372 VPWR VGND sg13cmos5l_decap_8
XFILLER_11_851 VPWR VGND sg13cmos5l_fill_2
X_245_ _245_/Q Tile_X0Y0_UserCLK _245_/D _358_/L_HI VPWR VGND sg13cmos5l_dfrbpq_1
X_176_ _176_/Q Tile_X0Y0_FrameData[8] VGND VPWR Tile_X1Y0_FrameStrobe[1] latch
XFILLER_7_888 VPWR VGND sg13cmos5l_decap_8
XFILLER_6_376 VPWR VGND sg13cmos5l_decap_8
XFILLER_6_321 VPWR VGND sg13cmos5l_decap_8
XFILLER_18_472 VPWR VGND sg13cmos5l_decap_8
XFILLER_18_461 VPWR VGND sg13cmos5l_fill_1
XANTENNA_290 Tile_X0Y0_FrameData[7] VPWR VGND sg13cmos5l_antennanp
XFILLER_11_114 VPWR VGND sg13cmos5l_decap_8
XFILLER_7_118 VPWR VGND sg13cmos5l_decap_8
XANTENNA__511__X Tile_X1Y0_S2BEGb[0] VPWR VGND sg13cmos5l_antennanp
XFILLER_4_847 VPWR VGND sg13cmos5l_decap_4
XFILLER_15_420 VPWR VGND sg13cmos5l_decap_8
XFILLER_15_497 VPWR VGND sg13cmos5l_decap_8
XFILLER_8_56 VPWR VGND sg13cmos5l_decap_8
XANTENNA__421__X Tile_X0Y0_S2BEG[6] VPWR VGND sg13cmos5l_antennanp
XFILLER_10_180 VPWR VGND sg13cmos5l_decap_4
X_228_ _228_/Q Tile_X0Y0_FrameData[21] VGND VPWR Tile_X1Y0_FrameStrobe[3] latch
X_159_ _159_/Q Tile_X0Y0_FrameData[25] VGND VPWR Tile_X1Y0_FrameStrobe[1] latch
XFILLER_7_663 VPWR VGND sg13cmos5l_decap_8
XFILLER_16_217 VPWR VGND sg13cmos5l_decap_8
XFILLER_17_21 VPWR VGND sg13cmos5l_decap_8
XANTENNA__506__X Tile_X1Y0_S2BEG[3] VPWR VGND sg13cmos5l_antennanp
XFILLER_12_401 VPWR VGND sg13cmos5l_decap_8
XFILLER_12_478 VPWR VGND sg13cmos5l_decap_8
XFILLER_17_98 VPWR VGND sg13cmos5l_decap_8
XFILLER_9_917 VPWR VGND sg13cmos5l_decap_8
XFILLER_8_405 VPWR VGND sg13cmos5l_decap_8
XANTENNA__416__X Tile_X0Y0_S2BEG[1] VPWR VGND sg13cmos5l_antennanp
XFILLER_15_294 VPWR VGND sg13cmos5l_decap_8
XFILLER_10_927 VPWR VGND sg13cmos5l_decap_8
XFILLER_0_113 VPWR VGND sg13cmos5l_decap_8
XFILLER_17_504 VPWR VGND sg13cmos5l_decap_8
X_493_ Tile_X1Y0_FrameStrobe_O[14] Tile_X1Y0_FrameStrobe[14] VPWR VGND sg13cmos5l_buf_1
X_631_ _631_/X Tile_X1Y0_N2END[7] Tile_X1Y0_N4END[7] Tile_X1Y0_NN4END[8] _085_/X _158_/Q
+ _157_/Q VPWR VGND sg13cmos5l_mux4_1
X_562_ _562_/X Tile_X0Y0_N1END[2] Tile_X0Y0_N2MID[2] Tile_X0Y0_N2END[5] _091_/X _345_/Q
+ _344_/Q VPWR VGND sg13cmos5l_mux4_1
XFILLER_12_275 VPWR VGND sg13cmos5l_decap_8
XFILLER_9_747 VPWR VGND sg13cmos5l_decap_8
XFILLER_9_703 VPWR VGND sg13cmos5l_decap_8
XFILLER_5_920 VPWR VGND sg13cmos5l_fill_1
XFILLER_5_68 VPWR VGND sg13cmos5l_fill_2
XFILLER_4_452 VPWR VGND sg13cmos5l_decap_8
XFILLER_0_691 VPWR VGND sg13cmos5l_fill_2
XFILLER_16_581 VPWR VGND sg13cmos5l_decap_8
XANTENNA_108 Tile_X0Y0_FrameData[23] VPWR VGND sg13cmos5l_antennanp
XANTENNA_119 Tile_X0Y0_FrameData[27] VPWR VGND sg13cmos5l_antennanp
XFILLER_14_518 VPWR VGND sg13cmos5l_decap_8
XFILLER_10_757 VPWR VGND sg13cmos5l_fill_1
XFILLER_14_77 VPWR VGND sg13cmos5l_decap_8
XFILLER_2_934 VPWR VGND sg13cmos5l_decap_4
XFILLER_17_301 VPWR VGND sg13cmos5l_decap_8
XFILLER_17_378 VPWR VGND sg13cmos5l_decap_8
X_476_ Tile_X1Y0_FrameData_O[29] Tile_X0Y0_FrameData[29] VPWR VGND sg13cmos5l_buf_1
X_545_ Tile_X1Y0_SS4BEG[10] _634_/X VPWR VGND sg13cmos5l_buf_1
X_614_ _614_/X Tile_X1Y0_N2MID[6] Tile_X1Y0_N4END[9] Tile_X1Y0_NN4END[6] _087_/X _192_/Q
+ _191_/Q VPWR VGND sg13cmos5l_mux4_1
XFILLER_13_595 VPWR VGND sg13cmos5l_decap_8
XFILLER_9_544 VPWR VGND sg13cmos5l_decap_8
XFILLER_3_709 VPWR VGND sg13cmos5l_fill_2
XFILLER_14_315 VPWR VGND sg13cmos5l_decap_8
X_330_ _330_/Q Tile_X0Y0_FrameData[23] VGND VPWR Tile_X0Y0_FrameStrobe[2] latch
XANTENNA__514__X Tile_X1Y0_S2BEGb[3] VPWR VGND sg13cmos5l_antennanp
X_261_ _261_/Q Tile_X0Y0_FrameData[28] VGND VPWR Tile_X0Y0_FrameStrobe[0] latch
X_192_ _192_/Q Tile_X0Y0_FrameData[24] VGND VPWR Tile_X1Y0_FrameStrobe[2] latch
XFILLER_9_0 VPWR VGND sg13cmos5l_decap_8
XFILLER_2_775 VPWR VGND sg13cmos5l_decap_8
XFILLER_2_764 VPWR VGND sg13cmos5l_decap_4
XFILLER_2_720 VPWR VGND sg13cmos5l_decap_8
XFILLER_18_654 VPWR VGND sg13cmos5l_decap_8
XFILLER_18_621 VPWR VGND sg13cmos5l_fill_1
XANTENNA_19 Tile_X0Y0_FrameData[1] VPWR VGND sg13cmos5l_antennanp
XFILLER_13_392 VPWR VGND sg13cmos5l_decap_8
XFILLER_17_175 VPWR VGND sg13cmos5l_decap_8
X_459_ Tile_X1Y0_FrameData_O[12] Tile_X0Y0_FrameData[12] VPWR VGND sg13cmos5l_buf_1
X_528_ Tile_X1Y0_S4BEG[9] _617_/X VPWR VGND sg13cmos5l_buf_1
XANTENNA__424__X Tile_X0Y0_S2BEGb[1] VPWR VGND sg13cmos5l_antennanp
XFILLER_11_45 VPWR VGND sg13cmos5l_decap_8
XANTENNA__509__X Tile_X1Y0_S2BEG[6] VPWR VGND sg13cmos5l_antennanp
XFILLER_15_602 VPWR VGND sg13cmos5l_decap_8
XFILLER_11_830 VPWR VGND sg13cmos5l_decap_8
XFILLER_14_112 VPWR VGND sg13cmos5l_decap_8
XFILLER_14_189 VPWR VGND sg13cmos5l_decap_8
X_313_ _313_/Q Tile_X0Y0_FrameData[8] VGND VPWR Tile_X0Y0_FrameStrobe[1] latch
X_244_ _244_/Q Tile_X0Y0_UserCLK _244_/D _357_/L_HI VPWR VGND sg13cmos5l_dfrbpq_1
XFILLER_7_801 VPWR VGND sg13cmos5l_fill_1
XFILLER_10_351 VPWR VGND sg13cmos5l_decap_8
X_175_ _175_/Q Tile_X0Y0_FrameData[9] VGND VPWR Tile_X1Y0_FrameStrobe[1] latch
XFILLER_2_572 VPWR VGND sg13cmos5l_decap_4
XANTENNA__419__X Tile_X0Y0_S2BEG[4] VPWR VGND sg13cmos5l_antennanp
XANTENNA_280 Tile_X0Y0_FrameData[5] VPWR VGND sg13cmos5l_antennanp
XANTENNA_291 Tile_X0Y0_FrameData[7] VPWR VGND sg13cmos5l_antennanp
XFILLER_12_627 VPWR VGND sg13cmos5l_fill_1
XFILLER_7_108 VPWR VGND sg13cmos5l_decap_4
XFILLER_4_826 VPWR VGND sg13cmos5l_decap_8
XFILLER_16_922 VPWR VGND sg13cmos5l_decap_8
XFILLER_16_944 VPWR VGND sg13cmos5l_fill_1
XFILLER_11_671 VPWR VGND sg13cmos5l_decap_8
XFILLER_15_476 VPWR VGND sg13cmos5l_decap_8
X_227_ _227_/Q Tile_X0Y0_FrameData[20] VGND VPWR Tile_X1Y0_FrameStrobe[3] latch
XFILLER_8_79 VPWR VGND sg13cmos5l_fill_1
XFILLER_8_35 VPWR VGND sg13cmos5l_decap_8
XFILLER_7_642 VPWR VGND sg13cmos5l_decap_8
XFILLER_10_192 VPWR VGND sg13cmos5l_decap_8
X_158_ _158_/Q Tile_X0Y0_FrameData[26] VGND VPWR Tile_X1Y0_FrameStrobe[1] latch
X_089_ _089_/X _238_/Q _238_/D _234_/Q VPWR VGND sg13cmos5l_mux2_1
XFILLER_7_697 VPWR VGND sg13cmos5l_decap_8
XFILLER_18_281 VPWR VGND sg13cmos5l_decap_8
XFILLER_18_270 VPWR VGND sg13cmos5l_decap_8
XFILLER_0_328 VPWR VGND sg13cmos5l_fill_2
XFILLER_1_807 VPWR VGND sg13cmos5l_fill_1
XFILLER_17_77 VPWR VGND sg13cmos5l_decap_8
XFILLER_12_457 VPWR VGND sg13cmos5l_decap_8
XFILLER_13_925 VPWR VGND sg13cmos5l_decap_4
XANTENNA__522__X Tile_X1Y0_S4BEG[3] VPWR VGND sg13cmos5l_antennanp
XFILLER_0_873 VPWR VGND sg13cmos5l_decap_8
XFILLER_0_884 VPWR VGND sg13cmos5l_fill_2
XFILLER_15_273 VPWR VGND sg13cmos5l_decap_8
XANTENNA__432__X Tile_X0Y0_S4BEG[1] VPWR VGND sg13cmos5l_antennanp
XFILLER_8_951 VPWR VGND sg13cmos5l_decap_8
XFILLER_7_494 VPWR VGND sg13cmos5l_fill_2
XFILLER_7_483 VPWR VGND sg13cmos5l_decap_8
XFILLER_10_906 VPWR VGND sg13cmos5l_decap_8
XFILLER_0_103 VPWR VGND sg13cmos5l_decap_4
X_630_ _630_/X Tile_X1Y0_N2END[6] Tile_X1Y0_N4END[6] Tile_X1Y0_NN4END[9] _095_/X _160_/Q
+ _159_/Q VPWR VGND sg13cmos5l_mux4_1
XANTENNA__517__X Tile_X1Y0_S2BEGb[6] VPWR VGND sg13cmos5l_antennanp
X_492_ Tile_X1Y0_FrameStrobe_O[13] Tile_X1Y0_FrameStrobe[13] VPWR VGND sg13cmos5l_buf_1
X_561_ _561_/X Tile_X0Y0_N1END[1] Tile_X0Y0_N2MID[1] Tile_X0Y0_N2END[6] _119_/X _347_/Q
+ _346_/Q VPWR VGND sg13cmos5l_mux4_1
XFILLER_12_254 VPWR VGND sg13cmos5l_decap_8
XFILLER_9_715 VPWR VGND sg13cmos5l_fill_1
XFILLER_4_431 VPWR VGND sg13cmos5l_decap_8
XANTENNA__427__X Tile_X0Y0_S2BEGb[4] VPWR VGND sg13cmos5l_antennanp
XFILLER_16_560 VPWR VGND sg13cmos5l_decap_8
XFILLER_8_770 VPWR VGND sg13cmos5l_decap_8
XANTENNA_109 Tile_X0Y0_FrameData[27] VPWR VGND sg13cmos5l_antennanp
XFILLER_10_769 VPWR VGND sg13cmos5l_fill_1
XFILLER_14_56 VPWR VGND sg13cmos5l_decap_8
XFILLER_5_239 VPWR VGND sg13cmos5l_decap_8
XFILLER_2_957 VPWR VGND sg13cmos5l_fill_2
XFILLER_1_445 VPWR VGND sg13cmos5l_decap_8
X_613_ _613_/X Tile_X1Y0_N2MID[5] Tile_X1Y0_N4END[10] Tile_X1Y0_NN4END[5] _089_/X
+ _194_/Q _193_/Q VPWR VGND sg13cmos5l_mux4_1
XFILLER_13_574 VPWR VGND sg13cmos5l_decap_8
XFILLER_17_357 VPWR VGND sg13cmos5l_decap_8
X_475_ Tile_X1Y0_FrameData_O[28] Tile_X0Y0_FrameData[28] VPWR VGND sg13cmos5l_buf_1
X_544_ Tile_X1Y0_SS4BEG[9] _633_/X VPWR VGND sg13cmos5l_buf_1
XFILLER_9_523 VPWR VGND sg13cmos5l_decap_8
XFILLER_5_762 VPWR VGND sg13cmos5l_fill_2
XFILLER_4_283 VPWR VGND sg13cmos5l_decap_4
XFILLER_17_891 VPWR VGND sg13cmos5l_decap_8
XFILLER_15_817 VPWR VGND sg13cmos5l_fill_2
X_260_ _260_/Q Tile_X0Y0_FrameData[29] VGND VPWR Tile_X0Y0_FrameStrobe[0] latch
XFILLER_10_533 VPWR VGND sg13cmos5l_decap_8
X_191_ _191_/Q Tile_X0Y0_FrameData[25] VGND VPWR Tile_X1Y0_FrameStrobe[2] latch
XANTENNA__530__X Tile_X1Y0_S4BEG[11] VPWR VGND sg13cmos5l_antennanp
XFILLER_17_154 VPWR VGND sg13cmos5l_decap_8
X_527_ Tile_X1Y0_S4BEG[8] _616_/X VPWR VGND sg13cmos5l_buf_1
XFILLER_18_644 VPWR VGND sg13cmos5l_decap_8
XFILLER_18_600 VPWR VGND sg13cmos5l_fill_2
XFILLER_13_371 VPWR VGND sg13cmos5l_decap_8
XFILLER_14_883 VPWR VGND sg13cmos5l_decap_8
X_389_ Tile_X0Y0_SS4BEG[14] _598_/X VPWR VGND sg13cmos5l_buf_1
X_458_ Tile_X1Y0_FrameData_O[11] Tile_X0Y0_FrameData[11] VPWR VGND sg13cmos5l_buf_1
XANTENNA__440__X Tile_X0Y0_S4BEG[9] VPWR VGND sg13cmos5l_antennanp
XFILLER_9_397 VPWR VGND sg13cmos5l_decap_8
XFILLER_11_24 VPWR VGND sg13cmos5l_decap_8
XFILLER_11_79 VPWR VGND sg13cmos5l_decap_8
XANTENNA__525__X Tile_X1Y0_S4BEG[6] VPWR VGND sg13cmos5l_antennanp
XFILLER_10_330 VPWR VGND sg13cmos5l_decap_8
XFILLER_11_853 VPWR VGND sg13cmos5l_fill_1
XFILLER_11_886 VPWR VGND sg13cmos5l_decap_8
XFILLER_14_168 VPWR VGND sg13cmos5l_decap_8
XFILLER_15_647 VPWR VGND sg13cmos5l_decap_4
X_312_ _312_/Q Tile_X0Y0_FrameData[9] VGND VPWR Tile_X0Y0_FrameStrobe[1] latch
X_243_ _243_/Q Tile_X0Y0_UserCLK _243_/D _360_/L_HI VPWR VGND sg13cmos5l_dfrbpq_1
X_174_ _174_/Q Tile_X0Y0_FrameData[10] VGND VPWR Tile_X1Y0_FrameStrobe[1] latch
XANTENNA_270 Tile_X0Y0_FrameData[5] VPWR VGND sg13cmos5l_antennanp
XANTENNA_281 Tile_X0Y0_FrameData[5] VPWR VGND sg13cmos5l_antennanp
XANTENNA_292 Tile_X0Y0_FrameData[7] VPWR VGND sg13cmos5l_antennanp
XANTENNA__435__X Tile_X0Y0_S4BEG[4] VPWR VGND sg13cmos5l_antennanp
XFILLER_9_183 VPWR VGND sg13cmos5l_fill_2
XFILLER_11_149 VPWR VGND sg13cmos5l_decap_8
XFILLER_12_606 VPWR VGND sg13cmos5l_decap_8
XFILLER_15_455 VPWR VGND sg13cmos5l_decap_8
XFILLER_16_901 VPWR VGND sg13cmos5l_decap_8
X_226_ _226_/Q Tile_X0Y0_FrameData[19] VGND VPWR Tile_X1Y0_FrameStrobe[3] latch
X_157_ _157_/Q Tile_X0Y0_FrameData[27] VGND VPWR Tile_X1Y0_FrameStrobe[1] latch
XFILLER_8_14 VPWR VGND sg13cmos5l_decap_8
XFILLER_6_153 VPWR VGND sg13cmos5l_fill_2
X_088_ _238_/D PMOD_IO_I3 _555_/X _222_/Q VPWR VGND sg13cmos5l_mux2_1
XFILLER_2_370 VPWR VGND sg13cmos5l_fill_1
XFILLER_0_307 VPWR VGND sg13cmos5l_fill_1
XFILLER_13_904 VPWR VGND sg13cmos5l_decap_8
XFILLER_17_56 VPWR VGND sg13cmos5l_decap_8
XFILLER_12_436 VPWR VGND sg13cmos5l_decap_8
XFILLER_4_602 VPWR VGND sg13cmos5l_decap_8
XFILLER_3_178 VPWR VGND sg13cmos5l_decap_8
XFILLER_0_896 VPWR VGND sg13cmos5l_decap_8
XFILLER_15_252 VPWR VGND sg13cmos5l_decap_8
X_209_ _209_/Q Tile_X0Y0_FrameData[7] VGND VPWR Tile_X1Y0_FrameStrobe[2] latch
XFILLER_7_462 VPWR VGND sg13cmos5l_decap_8
XFILLER_0_70 VPWR VGND sg13cmos5l_fill_1
XFILLER_17_0 VPWR VGND sg13cmos5l_decap_8
X_560_ _560_/X Tile_X0Y0_N1END[0] Tile_X0Y0_N2MID[0] Tile_X0Y0_N2END[7] _092_/X _349_/Q
+ _348_/Q VPWR VGND sg13cmos5l_mux4_1
XFILLER_12_233 VPWR VGND sg13cmos5l_decap_8
XFILLER_13_734 VPWR VGND sg13cmos5l_fill_1
XFILLER_13_767 VPWR VGND sg13cmos5l_fill_2
XFILLER_17_539 VPWR VGND sg13cmos5l_decap_8
X_491_ Tile_X1Y0_FrameStrobe_O[12] Tile_X1Y0_FrameStrobe[12] VPWR VGND sg13cmos5l_buf_1
XANTENNA__533__X Tile_X1Y0_S4BEG[14] VPWR VGND sg13cmos5l_antennanp
XFILLER_13_789 VPWR VGND sg13cmos5l_fill_2
XFILLER_8_237 VPWR VGND sg13cmos5l_decap_8
XFILLER_4_487 VPWR VGND sg13cmos5l_fill_2
XFILLER_10_7 VPWR VGND sg13cmos5l_decap_8
XANTENNA__443__X Tile_X0Y0_S4BEG[12] VPWR VGND sg13cmos5l_antennanp
XFILLER_14_35 VPWR VGND sg13cmos5l_decap_8
XANTENNA__072__Y PMOD_IO_OE_O2 VPWR VGND sg13cmos5l_antennanp
XFILLER_10_704 VPWR VGND sg13cmos5l_fill_1
XFILLER_6_708 VPWR VGND sg13cmos5l_fill_2
XANTENNA__528__X Tile_X1Y0_S4BEG[9] VPWR VGND sg13cmos5l_antennanp
XFILLER_17_336 VPWR VGND sg13cmos5l_decap_8
X_543_ Tile_X1Y0_SS4BEG[8] _632_/X VPWR VGND sg13cmos5l_buf_1
X_612_ _612_/X Tile_X1Y0_N2MID[4] Tile_X1Y0_N4END[11] Tile_X1Y0_NN4END[4] _064_/X
+ _196_/Q _195_/Q VPWR VGND sg13cmos5l_mux4_1
XFILLER_13_520 VPWR VGND sg13cmos5l_fill_1
XFILLER_13_553 VPWR VGND sg13cmos5l_decap_8
X_474_ Tile_X1Y0_FrameData_O[27] Tile_X0Y0_FrameData[27] VPWR VGND sg13cmos5l_buf_1
XFILLER_9_502 VPWR VGND sg13cmos5l_decap_8
XFILLER_4_262 VPWR VGND sg13cmos5l_decap_8
XFILLER_4_295 VPWR VGND sg13cmos5l_decap_8
XANTENNA__438__X Tile_X0Y0_S4BEG[7] VPWR VGND sg13cmos5l_antennanp
XFILLER_17_870 VPWR VGND sg13cmos5l_decap_8
XFILLER_10_512 VPWR VGND sg13cmos5l_decap_8
X_190_ _190_/Q Tile_X0Y0_FrameData[26] VGND VPWR Tile_X1Y0_FrameStrobe[2] latch
XFILLER_6_538 VPWR VGND sg13cmos5l_fill_1
XFILLER_2_700 VPWR VGND sg13cmos5l_fill_2
XFILLER_1_287 VPWR VGND sg13cmos5l_decap_8
XFILLER_1_265 VPWR VGND sg13cmos5l_decap_8
XFILLER_17_133 VPWR VGND sg13cmos5l_decap_8
X_526_ Tile_X1Y0_S4BEG[7] _615_/X VPWR VGND sg13cmos5l_buf_1
XFILLER_13_350 VPWR VGND sg13cmos5l_decap_8
XFILLER_14_862 VPWR VGND sg13cmos5l_decap_8
X_388_ Tile_X0Y0_SS4BEG[13] _597_/X VPWR VGND sg13cmos5l_buf_1
X_457_ Tile_X1Y0_FrameData_O[10] Tile_X0Y0_FrameData[10] VPWR VGND sg13cmos5l_buf_1
XFILLER_9_376 VPWR VGND sg13cmos5l_decap_8
XFILLER_5_560 VPWR VGND sg13cmos5l_decap_4
XFILLER_11_58 VPWR VGND sg13cmos5l_decap_8
XFILLER_10_386 VPWR VGND sg13cmos5l_decap_8
XFILLER_11_865 VPWR VGND sg13cmos5l_decap_8
XFILLER_14_147 VPWR VGND sg13cmos5l_decap_8
X_311_ _311_/Q Tile_X0Y0_FrameData[10] VGND VPWR Tile_X0Y0_FrameStrobe[1] latch
X_242_ _242_/Q Tile_X0Y0_UserCLK _242_/D _359_/L_HI VPWR VGND sg13cmos5l_dfrbpq_1
X_173_ _173_/Q Tile_X0Y0_FrameData[11] VGND VPWR Tile_X1Y0_FrameStrobe[1] latch
XANTENNA__541__X Tile_X1Y0_SS4BEG[6] VPWR VGND sg13cmos5l_antennanp
XFILLER_2_530 VPWR VGND sg13cmos5l_decap_8
XANTENNA_260 Tile_X0Y0_FrameData[5] VPWR VGND sg13cmos5l_antennanp
XANTENNA_271 Tile_X0Y0_FrameData[5] VPWR VGND sg13cmos5l_antennanp
XANTENNA_282 Tile_X0Y0_FrameData[5] VPWR VGND sg13cmos5l_antennanp
XANTENNA_293 Tile_X0Y0_FrameData[7] VPWR VGND sg13cmos5l_antennanp
X_509_ Tile_X1Y0_S2BEG[6] Tile_X1Y0_N2MID[1] VPWR VGND sg13cmos5l_buf_1
XFILLER_18_486 VPWR VGND sg13cmos5l_decap_8
XANTENNA__451__X Tile_X1Y0_FrameData_O[4] VPWR VGND sg13cmos5l_antennanp
XFILLER_11_128 VPWR VGND sg13cmos5l_decap_8
XANTENNA__536__X Tile_X1Y0_SS4BEG[1] VPWR VGND sg13cmos5l_antennanp
XFILLER_15_434 VPWR VGND sg13cmos5l_decap_8
X_225_ _225_/Q Tile_X0Y0_FrameData[18] VGND VPWR Tile_X1Y0_FrameStrobe[3] latch
X_156_ _156_/Q Tile_X0Y0_FrameData[28] VGND VPWR Tile_X1Y0_FrameStrobe[1] latch
X_087_ _087_/X _239_/Q _239_/D _234_/Q VPWR VGND sg13cmos5l_mux2_1
XFILLER_7_677 VPWR VGND sg13cmos5l_decap_8
XFILLER_7_622 VPWR VGND sg13cmos5l_fill_2
XFILLER_7_611 VPWR VGND sg13cmos5l_decap_8
XFILLER_2_382 VPWR VGND sg13cmos5l_fill_2
XANTENNA__446__X Tile_X0Y0_S4BEG[15] VPWR VGND sg13cmos5l_antennanp
XFILLER_12_415 VPWR VGND sg13cmos5l_decap_8
XFILLER_17_35 VPWR VGND sg13cmos5l_decap_8
XFILLER_8_419 VPWR VGND sg13cmos5l_decap_8
XFILLER_4_625 VPWR VGND sg13cmos5l_fill_1
XFILLER_0_831 VPWR VGND sg13cmos5l_fill_2
XFILLER_4_647 VPWR VGND sg13cmos5l_decap_8
XFILLER_15_231 VPWR VGND sg13cmos5l_decap_8
XFILLER_8_931 VPWR VGND sg13cmos5l_decap_4
XFILLER_11_492 VPWR VGND sg13cmos5l_decap_4
X_208_ _208_/Q Tile_X0Y0_FrameData[8] VGND VPWR Tile_X1Y0_FrameStrobe[2] latch
X_139_ _139_/Q Tile_X0Y0_FrameData[13] VGND VPWR Tile_X1Y0_FrameStrobe[0] latch
XFILLER_7_441 VPWR VGND sg13cmos5l_decap_8
XFILLER_0_93 VPWR VGND sg13cmos5l_fill_2
XFILLER_0_127 VPWR VGND sg13cmos5l_decap_8
XFILLER_0_149 VPWR VGND sg13cmos5l_decap_8
XFILLER_17_518 VPWR VGND sg13cmos5l_decap_8
XFILLER_12_212 VPWR VGND sg13cmos5l_decap_8
XFILLER_13_724 VPWR VGND sg13cmos5l_fill_2
X_490_ Tile_X1Y0_FrameStrobe_O[11] Tile_X1Y0_FrameStrobe[11] VPWR VGND sg13cmos5l_buf_1
XFILLER_8_216 VPWR VGND sg13cmos5l_decap_8
XFILLER_12_289 VPWR VGND sg13cmos5l_decap_8
XFILLER_5_49 VPWR VGND sg13cmos5l_fill_1
XFILLER_16_595 VPWR VGND sg13cmos5l_decap_8
XFILLER_8_750 VPWR VGND sg13cmos5l_decap_8
XFILLER_14_14 VPWR VGND sg13cmos5l_decap_8
XFILLER_2_959 VPWR VGND sg13cmos5l_fill_1
XFILLER_17_315 VPWR VGND sg13cmos5l_decap_8
X_473_ Tile_X1Y0_FrameData_O[26] Tile_X0Y0_FrameData[26] VPWR VGND sg13cmos5l_buf_1
X_542_ Tile_X1Y0_SS4BEG[7] _631_/X VPWR VGND sg13cmos5l_buf_1
X_611_ _611_/X Tile_X1Y0_N2MID[3] Tile_X1Y0_N4END[12] Tile_X1Y0_NN4END[3] _095_/X
+ _198_/Q _197_/Q VPWR VGND sg13cmos5l_mux4_1
XANTENNA__544__X Tile_X1Y0_SS4BEG[9] VPWR VGND sg13cmos5l_antennanp
XFILLER_13_532 VPWR VGND sg13cmos5l_decap_8
XFILLER_9_558 VPWR VGND sg13cmos5l_decap_8
XFILLER_4_230 VPWR VGND sg13cmos5l_decap_4
XANTENNA__454__X Tile_X1Y0_FrameData_O[7] VPWR VGND sg13cmos5l_antennanp
XFILLER_16_392 VPWR VGND sg13cmos5l_decap_8
XFILLER_6_81 VPWR VGND sg13cmos5l_fill_1
XFILLER_14_329 VPWR VGND sg13cmos5l_decap_8
XFILLER_1_233 VPWR VGND sg13cmos5l_decap_4
XFILLER_1_211 VPWR VGND sg13cmos5l_decap_8
XANTENNA__539__X Tile_X1Y0_SS4BEG[4] VPWR VGND sg13cmos5l_antennanp
XFILLER_17_112 VPWR VGND sg13cmos5l_decap_8
XFILLER_1_244 VPWR VGND sg13cmos5l_decap_8
XFILLER_18_635 VPWR VGND sg13cmos5l_decap_4
XFILLER_17_189 VPWR VGND sg13cmos5l_decap_8
X_456_ Tile_X1Y0_FrameData_O[9] Tile_X0Y0_FrameData[9] VPWR VGND sg13cmos5l_buf_1
X_525_ Tile_X1Y0_S4BEG[6] _614_/X VPWR VGND sg13cmos5l_buf_1
XFILLER_18_668 VPWR VGND sg13cmos5l_decap_8
X_387_ Tile_X0Y0_SS4BEG[12] _596_/X VPWR VGND sg13cmos5l_buf_1
XFILLER_9_355 VPWR VGND sg13cmos5l_decap_8
XFILLER_5_583 VPWR VGND sg13cmos5l_decap_8
XANTENNA__449__X Tile_X1Y0_FrameData_O[2] VPWR VGND sg13cmos5l_antennanp
XFILLER_3_509 VPWR VGND sg13cmos5l_decap_8
XFILLER_14_126 VPWR VGND sg13cmos5l_decap_8
XFILLER_15_616 VPWR VGND sg13cmos5l_decap_8
X_310_ _310_/Q Tile_X0Y0_FrameData[11] VGND VPWR Tile_X0Y0_FrameStrobe[1] latch
XFILLER_10_365 VPWR VGND sg13cmos5l_decap_8
XFILLER_11_844 VPWR VGND sg13cmos5l_fill_2
X_241_ _241_/Q Tile_X0Y0_UserCLK _241_/D _362_/L_HI VPWR VGND sg13cmos5l_dfrbpq_1
X_172_ _172_/Q Tile_X0Y0_FrameData[12] VGND VPWR Tile_X1Y0_FrameStrobe[1] latch
XFILLER_7_837 VPWR VGND sg13cmos5l_decap_8
XFILLER_6_369 VPWR VGND sg13cmos5l_decap_4
XFILLER_6_314 VPWR VGND sg13cmos5l_decap_8
XFILLER_7_0 VPWR VGND sg13cmos5l_decap_8
XFILLER_18_465 VPWR VGND sg13cmos5l_decap_8
XFILLER_18_454 VPWR VGND sg13cmos5l_decap_8
XANTENNA_250 Tile_X0Y0_FrameData[5] VPWR VGND sg13cmos5l_antennanp
XANTENNA_261 Tile_X0Y0_FrameData[5] VPWR VGND sg13cmos5l_antennanp
XANTENNA_272 Tile_X0Y0_FrameData[5] VPWR VGND sg13cmos5l_antennanp
XANTENNA_283 Tile_X0Y0_FrameData[5] VPWR VGND sg13cmos5l_antennanp
XANTENNA_294 Tile_X0Y0_FrameData[7] VPWR VGND sg13cmos5l_antennanp
X_439_ Tile_X0Y0_S4BEG[8] _576_/X VPWR VGND sg13cmos5l_buf_1
X_508_ Tile_X1Y0_S2BEG[5] Tile_X1Y0_N2MID[2] VPWR VGND sg13cmos5l_buf_1
XFILLER_18_498 VPWR VGND sg13cmos5l_decap_8
XFILLER_11_107 VPWR VGND sg13cmos5l_decap_8
XFILLER_15_413 VPWR VGND sg13cmos5l_decap_8
XFILLER_16_936 VPWR VGND sg13cmos5l_decap_4
XFILLER_16_958 VPWR VGND sg13cmos5l_fill_2
X_224_ _224_/Q Tile_X0Y0_FrameData[17] VGND VPWR Tile_X1Y0_FrameStrobe[3] latch
XFILLER_8_49 VPWR VGND sg13cmos5l_decap_8
XFILLER_10_173 VPWR VGND sg13cmos5l_decap_8
XFILLER_10_184 VPWR VGND sg13cmos5l_fill_1
XFILLER_11_696 VPWR VGND sg13cmos5l_decap_4
X_155_ _155_/Q Tile_X0Y0_FrameData[29] VGND VPWR Tile_X1Y0_FrameStrobe[1] latch
X_086_ _239_/D PMOD_IO_I4 _556_/X _222_/Q VPWR VGND sg13cmos5l_mux2_1
XFILLER_7_656 VPWR VGND sg13cmos5l_decap_8
XFILLER_3_862 VPWR VGND sg13cmos5l_decap_8
XFILLER_2_361 VPWR VGND sg13cmos5l_decap_8
XFILLER_18_295 VPWR VGND sg13cmos5l_decap_8
XFILLER_18_251 VPWR VGND sg13cmos5l_fill_2
XFILLER_18_240 VPWR VGND sg13cmos5l_decap_8
XANTENNA__462__X Tile_X1Y0_FrameData_O[15] VPWR VGND sg13cmos5l_antennanp
XFILLER_14_490 VPWR VGND sg13cmos5l_decap_8
XFILLER_17_14 VPWR VGND sg13cmos5l_decap_8
XFILLER_3_125 VPWR VGND sg13cmos5l_decap_8
XFILLER_0_821 VPWR VGND sg13cmos5l_decap_4
XANTENNA__547__X Tile_X1Y0_SS4BEG[12] VPWR VGND sg13cmos5l_antennanp
XFILLER_15_210 VPWR VGND sg13cmos5l_decap_8
XFILLER_11_471 VPWR VGND sg13cmos5l_decap_8
XFILLER_15_287 VPWR VGND sg13cmos5l_decap_8
X_207_ _207_/Q Tile_X0Y0_FrameData[9] VGND VPWR Tile_X1Y0_FrameStrobe[2] latch
XFILLER_8_910 VPWR VGND sg13cmos5l_decap_8
XFILLER_7_420 VPWR VGND sg13cmos5l_decap_8
X_138_ _138_/Q Tile_X0Y0_FrameData[14] VGND VPWR Tile_X1Y0_FrameStrobe[0] latch
X_069_ PMOD_IO_OE_O0 _223_/Q _066_/X _068_/Y VPWR VGND sg13cmos5l_a21oi_1
XFILLER_3_681 VPWR VGND sg13cmos5l_decap_8
XANTENNA__457__X Tile_X1Y0_FrameData_O[10] VPWR VGND sg13cmos5l_antennanp
XFILLER_0_61 VPWR VGND sg13cmos5l_decap_8
XFILLER_9_70 VPWR VGND sg13cmos5l_fill_1
XFILLER_12_268 VPWR VGND sg13cmos5l_decap_8
XFILLER_5_902 VPWR VGND sg13cmos5l_decap_8
XFILLER_4_489 VPWR VGND sg13cmos5l_fill_1
XFILLER_4_445 VPWR VGND sg13cmos5l_decap_8
XFILLER_0_684 VPWR VGND sg13cmos5l_decap_8
XFILLER_16_574 VPWR VGND sg13cmos5l_decap_8
XFILLER_8_795 VPWR VGND sg13cmos5l_decap_8
XFILLER_8_784 VPWR VGND sg13cmos5l_decap_8
XFILLER_7_294 VPWR VGND sg13cmos5l_fill_1
XFILLER_2_938 VPWR VGND sg13cmos5l_fill_2
XFILLER_2_927 VPWR VGND sg13cmos5l_decap_8
X_610_ _610_/X Tile_X1Y0_N2MID[2] Tile_X1Y0_N4END[13] Tile_X1Y0_NN4END[2] _085_/X
+ _200_/Q _199_/Q VPWR VGND sg13cmos5l_mux4_1
XFILLER_1_459 VPWR VGND sg13cmos5l_decap_8
X_472_ Tile_X1Y0_FrameData_O[25] Tile_X0Y0_FrameData[25] VPWR VGND sg13cmos5l_buf_1
X_541_ Tile_X1Y0_SS4BEG[6] _630_/X VPWR VGND sg13cmos5l_buf_1
XFILLER_13_588 VPWR VGND sg13cmos5l_decap_8
XFILLER_9_537 VPWR VGND sg13cmos5l_decap_8
XFILLER_16_371 VPWR VGND sg13cmos5l_decap_8
XANTENNA__470__X Tile_X1Y0_FrameData_O[23] VPWR VGND sg13cmos5l_antennanp
XFILLER_14_308 VPWR VGND sg13cmos5l_decap_8
XFILLER_10_547 VPWR VGND sg13cmos5l_decap_4
XFILLER_10_558 VPWR VGND sg13cmos5l_fill_1
XFILLER_6_529 VPWR VGND sg13cmos5l_fill_2
XANTENNA__380__X Tile_X0Y0_SS4BEG[5] VPWR VGND sg13cmos5l_antennanp
XFILLER_2_735 VPWR VGND sg13cmos5l_fill_1
XFILLER_2_713 VPWR VGND sg13cmos5l_decap_8
XFILLER_18_625 VPWR VGND sg13cmos5l_decap_8
XFILLER_18_614 VPWR VGND sg13cmos5l_decap_8
XFILLER_13_385 VPWR VGND sg13cmos5l_decap_8
XFILLER_14_897 VPWR VGND sg13cmos5l_decap_8
XFILLER_15_91 VPWR VGND sg13cmos5l_decap_8
XFILLER_17_168 VPWR VGND sg13cmos5l_decap_8
X_386_ Tile_X0Y0_SS4BEG[11] _595_/X VPWR VGND sg13cmos5l_buf_1
X_455_ Tile_X1Y0_FrameData_O[8] Tile_X0Y0_FrameData[8] VPWR VGND sg13cmos5l_buf_1
X_524_ Tile_X1Y0_S4BEG[5] _613_/X VPWR VGND sg13cmos5l_buf_1
XFILLER_9_312 VPWR VGND sg13cmos5l_fill_1
XANTENNA__465__X Tile_X1Y0_FrameData_O[18] VPWR VGND sg13cmos5l_antennanp
XFILLER_11_38 VPWR VGND sg13cmos5l_decap_8
XANTENNA__375__X Tile_X0Y0_SS4BEG[0] VPWR VGND sg13cmos5l_antennanp
XFILLER_11_823 VPWR VGND sg13cmos5l_decap_8
XFILLER_14_105 VPWR VGND sg13cmos5l_decap_8
X_240_ _240_/Q Tile_X0Y0_UserCLK _240_/D _361_/L_HI VPWR VGND sg13cmos5l_dfrbpq_1
XFILLER_10_344 VPWR VGND sg13cmos5l_decap_8
X_171_ _171_/Q Tile_X0Y0_FrameData[13] VGND VPWR Tile_X1Y0_FrameStrobe[1] latch
XFILLER_2_576 VPWR VGND sg13cmos5l_fill_2
XANTENNA_240 Tile_X0Y0_FrameData[5] VPWR VGND sg13cmos5l_antennanp
XANTENNA_251 Tile_X0Y0_FrameData[5] VPWR VGND sg13cmos5l_antennanp
XANTENNA_262 Tile_X0Y0_FrameData[5] VPWR VGND sg13cmos5l_antennanp
XANTENNA_273 Tile_X0Y0_FrameData[5] VPWR VGND sg13cmos5l_antennanp
XANTENNA_284 Tile_X0Y0_FrameData[5] VPWR VGND sg13cmos5l_antennanp
XANTENNA_295 Tile_X0Y0_FrameData[7] VPWR VGND sg13cmos5l_antennanp
XFILLER_13_182 VPWR VGND sg13cmos5l_decap_8
X_369_ _369_/L_HI VPWR VGND sg13cmos5l_tiehi
X_438_ Tile_X0Y0_S4BEG[7] _575_/X VPWR VGND sg13cmos5l_buf_1
X_507_ Tile_X1Y0_S2BEG[4] Tile_X1Y0_N2MID[3] VPWR VGND sg13cmos5l_buf_1
XFILLER_9_131 VPWR VGND sg13cmos5l_decap_8
XFILLER_4_819 VPWR VGND sg13cmos5l_decap_8
XFILLER_16_915 VPWR VGND sg13cmos5l_decap_8
XFILLER_10_152 VPWR VGND sg13cmos5l_decap_8
XFILLER_15_469 VPWR VGND sg13cmos5l_decap_8
X_223_ _223_/Q Tile_X0Y0_FrameData[16] VGND VPWR Tile_X1Y0_FrameStrobe[3] latch
XFILLER_8_28 VPWR VGND sg13cmos5l_decap_8
X_154_ _154_/Q Tile_X0Y0_FrameData[30] VGND VPWR Tile_X1Y0_FrameStrobe[1] latch
X_085_ _085_/X _240_/Q _240_/D _234_/Q VPWR VGND sg13cmos5l_mux2_1
XFILLER_7_635 VPWR VGND sg13cmos5l_decap_8
XFILLER_6_123 VPWR VGND sg13cmos5l_fill_2
XFILLER_6_112 VPWR VGND sg13cmos5l_decap_8
XFILLER_2_384 VPWR VGND sg13cmos5l_fill_1
XFILLER_18_263 VPWR VGND sg13cmos5l_decap_8
XFILLER_13_918 VPWR VGND sg13cmos5l_decap_8
XFILLER_4_616 VPWR VGND sg13cmos5l_fill_2
XFILLER_15_266 VPWR VGND sg13cmos5l_decap_8
XFILLER_11_450 VPWR VGND sg13cmos5l_decap_8
XFILLER_12_940 VPWR VGND sg13cmos5l_fill_1
XFILLER_12_951 VPWR VGND sg13cmos5l_decap_8
X_206_ _206_/Q Tile_X0Y0_FrameData[10] VGND VPWR Tile_X1Y0_FrameStrobe[2] latch
X_137_ _137_/Q Tile_X0Y0_FrameData[15] VGND VPWR Tile_X1Y0_FrameStrobe[0] latch
XFILLER_7_476 VPWR VGND sg13cmos5l_decap_8
X_068_ _068_/Y _120_/A _243_/D _067_/X VPWR VGND sg13cmos5l_o21ai_1
XFILLER_2_170 VPWR VGND sg13cmos5l_decap_8
XANTENNA__473__X Tile_X1Y0_FrameData_O[26] VPWR VGND sg13cmos5l_antennanp
XFILLER_0_95 VPWR VGND sg13cmos5l_fill_1
XFILLER_9_82 VPWR VGND sg13cmos5l_decap_8
XFILLER_0_107 VPWR VGND sg13cmos5l_fill_2
XANTENNA__383__X Tile_X0Y0_SS4BEG[8] VPWR VGND sg13cmos5l_antennanp
XFILLER_12_247 VPWR VGND sg13cmos5l_decap_8
XFILLER_4_424 VPWR VGND sg13cmos5l_decap_8
XFILLER_0_641 VPWR VGND sg13cmos5l_fill_1
XFILLER_0_696 VPWR VGND sg13cmos5l_fill_1
XFILLER_16_553 VPWR VGND sg13cmos5l_decap_8
XFILLER_8_763 VPWR VGND sg13cmos5l_decap_8
XFILLER_7_262 VPWR VGND sg13cmos5l_fill_2
XFILLER_7_251 VPWR VGND sg13cmos5l_decap_8
XFILLER_7_240 VPWR VGND sg13cmos5l_fill_2
XANTENNA__468__X Tile_X1Y0_FrameData_O[21] VPWR VGND sg13cmos5l_antennanp
XFILLER_15_0 VPWR VGND sg13cmos5l_decap_8
XFILLER_14_49 VPWR VGND sg13cmos5l_decap_8
XANTENNA__378__X Tile_X0Y0_SS4BEG[3] VPWR VGND sg13cmos5l_antennanp
X_540_ Tile_X1Y0_SS4BEG[5] _629_/X VPWR VGND sg13cmos5l_buf_1
XFILLER_13_567 VPWR VGND sg13cmos5l_decap_8
X_471_ Tile_X1Y0_FrameData_O[24] Tile_X0Y0_FrameData[24] VPWR VGND sg13cmos5l_buf_1
XFILLER_9_516 VPWR VGND sg13cmos5l_decap_8
XFILLER_5_722 VPWR VGND sg13cmos5l_decap_8
XFILLER_4_287 VPWR VGND sg13cmos5l_fill_1
XFILLER_4_276 VPWR VGND sg13cmos5l_decap_8
XFILLER_0_493 VPWR VGND sg13cmos5l_fill_2
XFILLER_16_350 VPWR VGND sg13cmos5l_decap_8
XFILLER_17_884 VPWR VGND sg13cmos5l_decap_8
XFILLER_8_571 VPWR VGND sg13cmos5l_decap_8
XFILLER_6_72 VPWR VGND sg13cmos5l_decap_8
XFILLER_10_526 VPWR VGND sg13cmos5l_decap_8
XFILLER_1_279 VPWR VGND sg13cmos5l_fill_1
XFILLER_17_147 VPWR VGND sg13cmos5l_decap_8
X_523_ Tile_X1Y0_S4BEG[4] _612_/X VPWR VGND sg13cmos5l_buf_1
XFILLER_13_364 VPWR VGND sg13cmos5l_decap_8
XFILLER_14_876 VPWR VGND sg13cmos5l_decap_8
XFILLER_15_70 VPWR VGND sg13cmos5l_decap_8
X_385_ Tile_X0Y0_SS4BEG[10] _594_/X VPWR VGND sg13cmos5l_buf_1
X_454_ Tile_X1Y0_FrameData_O[7] Tile_X0Y0_FrameData[7] VPWR VGND sg13cmos5l_buf_1
XANTENNA__481__X Tile_X1Y0_FrameStrobe_O[2] VPWR VGND sg13cmos5l_antennanp
XFILLER_11_17 VPWR VGND sg13cmos5l_decap_8
XFILLER_10_323 VPWR VGND sg13cmos5l_decap_8
XFILLER_11_846 VPWR VGND sg13cmos5l_fill_1
X_170_ _170_/Q Tile_X0Y0_FrameData[14] VGND VPWR Tile_X1Y0_FrameStrobe[1] latch
XANTENNA__391__X Tile_X0Y0_FrameStrobe_O[0] VPWR VGND sg13cmos5l_antennanp
XFILLER_11_879 VPWR VGND sg13cmos5l_decap_8
XFILLER_18_401 VPWR VGND sg13cmos5l_decap_8
XANTENNA_230 Tile_X0Y0_FrameData[3] VPWR VGND sg13cmos5l_antennanp
XANTENNA_241 Tile_X0Y0_FrameData[5] VPWR VGND sg13cmos5l_antennanp
XANTENNA_252 Tile_X0Y0_FrameData[5] VPWR VGND sg13cmos5l_antennanp
XANTENNA_263 Tile_X0Y0_FrameData[5] VPWR VGND sg13cmos5l_antennanp
XANTENNA_274 Tile_X0Y0_FrameData[5] VPWR VGND sg13cmos5l_antennanp
XANTENNA_285 Tile_X0Y0_FrameData[5] VPWR VGND sg13cmos5l_antennanp
X_506_ Tile_X1Y0_S2BEG[3] Tile_X1Y0_N2MID[4] VPWR VGND sg13cmos5l_buf_1
XANTENNA_296 Tile_X0Y0_FrameData[7] VPWR VGND sg13cmos5l_antennanp
XFILLER_13_161 VPWR VGND sg13cmos5l_decap_8
X_299_ _299_/Q Tile_X0Y0_FrameData[22] VGND VPWR Tile_X0Y0_FrameStrobe[1] latch
X_368_ _368_/L_HI VPWR VGND sg13cmos5l_tiehi
X_437_ Tile_X0Y0_S4BEG[6] _574_/X VPWR VGND sg13cmos5l_buf_1
XFILLER_9_176 VPWR VGND sg13cmos5l_decap_8
XFILLER_9_110 VPWR VGND sg13cmos5l_decap_8
XFILLER_5_371 VPWR VGND sg13cmos5l_decap_8
XANTENNA__476__X Tile_X1Y0_FrameData_O[29] VPWR VGND sg13cmos5l_antennanp
XFILLER_3_84 VPWR VGND sg13cmos5l_fill_2
XFILLER_3_73 VPWR VGND sg13cmos5l_decap_4
XANTENNA__386__X Tile_X0Y0_SS4BEG[11] VPWR VGND sg13cmos5l_antennanp
XFILLER_15_448 VPWR VGND sg13cmos5l_decap_8
XFILLER_10_131 VPWR VGND sg13cmos5l_decap_8
X_222_ _222_/Q Tile_X0Y0_FrameData[15] VGND VPWR Tile_X1Y0_FrameStrobe[3] latch
X_153_ _153_/Q Tile_X0Y0_FrameData[31] VGND VPWR Tile_X1Y0_FrameStrobe[1] latch
XFILLER_12_93 VPWR VGND sg13cmos5l_decap_8
X_084_ _240_/D PMOD_IO_I5 _557_/X _222_/Q VPWR VGND sg13cmos5l_mux2_1
XFILLER_3_897 VPWR VGND sg13cmos5l_decap_8
XFILLER_17_49 VPWR VGND sg13cmos5l_decap_8
XFILLER_12_429 VPWR VGND sg13cmos5l_decap_8
XFILLER_0_856 VPWR VGND sg13cmos5l_fill_1
XFILLER_15_245 VPWR VGND sg13cmos5l_decap_8
XFILLER_16_768 VPWR VGND sg13cmos5l_fill_1
X_205_ _205_/Q Tile_X0Y0_FrameData[11] VGND VPWR Tile_X1Y0_FrameStrobe[2] latch
X_136_ _136_/Q Tile_X0Y0_FrameData[16] VGND VPWR Tile_X1Y0_FrameStrobe[0] latch
XFILLER_7_455 VPWR VGND sg13cmos5l_decap_8
X_067_ _067_/X _233_/Q _243_/Q VPWR VGND sg13cmos5l_or2_1
XFILLER_12_226 VPWR VGND sg13cmos5l_decap_8
XFILLER_0_631 VPWR VGND sg13cmos5l_fill_2
XFILLER_5_959 VPWR VGND sg13cmos5l_fill_1
XFILLER_16_532 VPWR VGND sg13cmos5l_decap_8
XFILLER_18_70 VPWR VGND sg13cmos5l_decap_8
X_119_ _119_/X _236_/Q _236_/D _234_/Q VPWR VGND sg13cmos5l_mux2_1
XFILLER_7_285 VPWR VGND sg13cmos5l_fill_2
XANTENNA__484__X Tile_X1Y0_FrameStrobe_O[5] VPWR VGND sg13cmos5l_antennanp
XFILLER_10_719 VPWR VGND sg13cmos5l_fill_2
XFILLER_14_28 VPWR VGND sg13cmos5l_decap_8
XFILLER_17_329 VPWR VGND sg13cmos5l_decap_8
XANTENNA__394__X Tile_X0Y0_FrameStrobe_O[3] VPWR VGND sg13cmos5l_antennanp
XFILLER_13_546 VPWR VGND sg13cmos5l_decap_8
X_470_ Tile_X1Y0_FrameData_O[23] Tile_X0Y0_FrameData[23] VPWR VGND sg13cmos5l_buf_1
XFILLER_4_255 VPWR VGND sg13cmos5l_decap_8
XFILLER_1_951 VPWR VGND sg13cmos5l_decap_8
XFILLER_17_863 VPWR VGND sg13cmos5l_decap_8
X_599_ _599_/X Tile_X0Y0_N2END[7] Tile_X0Y0_N4END[15] Tile_X0Y0_NN4END[0] _091_/X
+ _271_/Q _270_/Q VPWR VGND sg13cmos5l_mux4_1
XFILLER_12_590 VPWR VGND sg13cmos5l_decap_8
XANTENNA__479__X Tile_X1Y0_FrameStrobe_O[0] VPWR VGND sg13cmos5l_antennanp
XFILLER_10_505 VPWR VGND sg13cmos5l_decap_8
XFILLER_6_509 VPWR VGND sg13cmos5l_decap_4
XANTENNA__389__X Tile_X0Y0_SS4BEG[14] VPWR VGND sg13cmos5l_antennanp
XFILLER_17_126 VPWR VGND sg13cmos5l_decap_8
X_453_ Tile_X1Y0_FrameData_O[6] Tile_X0Y0_FrameData[6] VPWR VGND sg13cmos5l_buf_1
X_522_ Tile_X1Y0_S4BEG[3] _611_/X VPWR VGND sg13cmos5l_buf_1
XFILLER_18_605 VPWR VGND sg13cmos5l_decap_4
XFILLER_13_343 VPWR VGND sg13cmos5l_decap_8
XFILLER_14_855 VPWR VGND sg13cmos5l_decap_8
X_384_ Tile_X0Y0_SS4BEG[9] _593_/X VPWR VGND sg13cmos5l_buf_1
XFILLER_9_369 VPWR VGND sg13cmos5l_decap_8
XFILLER_5_564 VPWR VGND sg13cmos5l_fill_1
XFILLER_8_391 VPWR VGND sg13cmos5l_decap_8
XFILLER_10_302 VPWR VGND sg13cmos5l_decap_8
XFILLER_11_858 VPWR VGND sg13cmos5l_decap_8
XFILLER_10_379 VPWR VGND sg13cmos5l_decap_8
XFILLER_6_328 VPWR VGND sg13cmos5l_fill_2
XANTENNA_220 Tile_X0Y0_FrameData[3] VPWR VGND sg13cmos5l_antennanp
XANTENNA_231 Tile_X0Y0_FrameData[3] VPWR VGND sg13cmos5l_antennanp
XANTENNA_242 Tile_X0Y0_FrameData[5] VPWR VGND sg13cmos5l_antennanp
XANTENNA_253 Tile_X0Y0_FrameData[5] VPWR VGND sg13cmos5l_antennanp
XANTENNA_264 Tile_X0Y0_FrameData[5] VPWR VGND sg13cmos5l_antennanp
XANTENNA_275 Tile_X0Y0_FrameData[5] VPWR VGND sg13cmos5l_antennanp
XANTENNA_286 Tile_X0Y0_FrameData[7] VPWR VGND sg13cmos5l_antennanp
XANTENNA_297 Tile_X0Y0_FrameData[7] VPWR VGND sg13cmos5l_antennanp
XFILLER_13_140 VPWR VGND sg13cmos5l_decap_8
X_436_ Tile_X0Y0_S4BEG[5] _573_/X VPWR VGND sg13cmos5l_buf_1
X_505_ Tile_X1Y0_S2BEG[2] Tile_X1Y0_N2MID[5] VPWR VGND sg13cmos5l_buf_1
XFILLER_18_479 VPWR VGND sg13cmos5l_decap_8
X_298_ _298_/Q Tile_X0Y0_FrameData[23] VGND VPWR Tile_X0Y0_FrameStrobe[1] latch
X_367_ _367_/L_HI VPWR VGND sg13cmos5l_tiehi
XFILLER_9_188 VPWR VGND sg13cmos5l_decap_4
XFILLER_5_350 VPWR VGND sg13cmos5l_fill_2
XFILLER_3_52 VPWR VGND sg13cmos5l_fill_1
XANTENNA__492__X Tile_X1Y0_FrameStrobe_O[13] VPWR VGND sg13cmos5l_antennanp
XFILLER_17_490 VPWR VGND sg13cmos5l_decap_8
XFILLER_15_427 VPWR VGND sg13cmos5l_decap_8
XFILLER_10_110 VPWR VGND sg13cmos5l_decap_8
XFILLER_12_72 VPWR VGND sg13cmos5l_decap_8
X_221_ _221_/Q Tile_X0Y0_FrameData[31] VGND VPWR Tile_X1Y0_FrameStrobe[0] latch
X_152_ _152_/Q Tile_X0Y0_FrameData[0] VGND VPWR Tile_X1Y0_FrameStrobe[0] latch
X_083_ _235_/D PMOD_IO_I0 _552_/X _222_/Q VPWR VGND sg13cmos5l_mux2_1
XFILLER_7_604 VPWR VGND sg13cmos5l_decap_8
XFILLER_5_0 VPWR VGND sg13cmos5l_decap_8
XFILLER_2_375 VPWR VGND sg13cmos5l_decap_8
X_419_ Tile_X0Y0_S2BEG[4] Tile_X0Y0_N2MID[3] VPWR VGND sg13cmos5l_buf_1
XFILLER_6_670 VPWR VGND sg13cmos5l_fill_2
XANTENNA__487__X Tile_X1Y0_FrameStrobe_O[8] VPWR VGND sg13cmos5l_antennanp
XFILLER_12_408 VPWR VGND sg13cmos5l_decap_8
XFILLER_17_28 VPWR VGND sg13cmos5l_decap_8
XANTENNA__397__X Tile_X0Y0_FrameStrobe_O[6] VPWR VGND sg13cmos5l_antennanp
XFILLER_15_224 VPWR VGND sg13cmos5l_decap_8
X_204_ _204_/Q Tile_X0Y0_FrameData[12] VGND VPWR Tile_X1Y0_FrameStrobe[2] latch
XFILLER_11_485 VPWR VGND sg13cmos5l_decap_8
X_135_ _135_/Q Tile_X0Y0_FrameData[17] VGND VPWR Tile_X1Y0_FrameStrobe[0] latch
X_066_ _066_/X _251_/Q _552_/X _233_/Q VPWR VGND sg13cmos5l_mux2_1
XFILLER_8_935 VPWR VGND sg13cmos5l_fill_2
XFILLER_8_924 VPWR VGND sg13cmos5l_decap_8
XFILLER_7_434 VPWR VGND sg13cmos5l_decap_8
XFILLER_3_695 VPWR VGND sg13cmos5l_decap_8
XFILLER_0_75 VPWR VGND sg13cmos5l_fill_1
XFILLER_0_86 VPWR VGND sg13cmos5l_decap_8
XFILLER_12_205 VPWR VGND sg13cmos5l_decap_8
XFILLER_13_739 VPWR VGND sg13cmos5l_fill_2
XFILLER_5_916 VPWR VGND sg13cmos5l_decap_4
XFILLER_4_459 VPWR VGND sg13cmos5l_decap_8
XFILLER_16_511 VPWR VGND sg13cmos5l_decap_8
XFILLER_11_282 VPWR VGND sg13cmos5l_decap_8
XFILLER_16_588 VPWR VGND sg13cmos5l_decap_8
XFILLER_8_743 VPWR VGND sg13cmos5l_decap_8
X_118_ _236_/D PMOD_IO_I1 _553_/X _222_/Q VPWR VGND sg13cmos5l_mux2_1
XFILLER_7_242 VPWR VGND sg13cmos5l_fill_1
XFILLER_17_308 VPWR VGND sg13cmos5l_decap_8
XFILLER_13_525 VPWR VGND sg13cmos5l_decap_8
XFILLER_5_757 VPWR VGND sg13cmos5l_fill_1
XFILLER_4_223 VPWR VGND sg13cmos5l_decap_8
XFILLER_1_930 VPWR VGND sg13cmos5l_fill_1
XFILLER_16_385 VPWR VGND sg13cmos5l_decap_8
X_598_ _598_/X Tile_X0Y0_N2END[6] Tile_X0Y0_N4END[14] Tile_X0Y0_NN4END[1] _092_/X
+ _273_/Q _272_/Q VPWR VGND sg13cmos5l_mux4_1
XANTENNA_1 Tile_X0Y0_FrameData[16] VPWR VGND sg13cmos5l_antennanp
XFILLER_8_595 VPWR VGND sg13cmos5l_fill_2
XFILLER_6_41 VPWR VGND sg13cmos5l_decap_8
XFILLER_4_790 VPWR VGND sg13cmos5l_fill_1
XANTENNA__495__X Tile_X1Y0_FrameStrobe_O[16] VPWR VGND sg13cmos5l_antennanp
XFILLER_9_7 VPWR VGND sg13cmos5l_decap_8
XFILLER_2_727 VPWR VGND sg13cmos5l_fill_1
XFILLER_1_226 VPWR VGND sg13cmos5l_decap_8
XFILLER_13_322 VPWR VGND sg13cmos5l_decap_8
XFILLER_17_105 VPWR VGND sg13cmos5l_decap_8
X_383_ Tile_X0Y0_SS4BEG[8] _592_/X VPWR VGND sg13cmos5l_buf_1
X_452_ Tile_X1Y0_FrameData_O[5] Tile_X0Y0_FrameData[5] VPWR VGND sg13cmos5l_buf_1
X_521_ Tile_X1Y0_S4BEG[2] _610_/X VPWR VGND sg13cmos5l_buf_1
XFILLER_18_639 VPWR VGND sg13cmos5l_fill_2
XFILLER_13_399 VPWR VGND sg13cmos5l_decap_8
XFILLER_9_348 VPWR VGND sg13cmos5l_decap_8
XFILLER_5_510 VPWR VGND sg13cmos5l_decap_8
XFILLER_5_576 VPWR VGND sg13cmos5l_decap_8
XFILLER_16_182 VPWR VGND sg13cmos5l_decap_8
XFILLER_9_882 VPWR VGND sg13cmos5l_decap_8
XFILLER_14_119 VPWR VGND sg13cmos5l_decap_8
XFILLER_15_609 VPWR VGND sg13cmos5l_decap_8
XFILLER_10_358 VPWR VGND sg13cmos5l_decap_8
XFILLER_11_837 VPWR VGND sg13cmos5l_decap_8
XFILLER_18_447 VPWR VGND sg13cmos5l_decap_8
XFILLER_18_425 VPWR VGND sg13cmos5l_fill_2
XANTENNA_210 Tile_X0Y0_FrameData[3] VPWR VGND sg13cmos5l_antennanp
XANTENNA_221 Tile_X0Y0_FrameData[3] VPWR VGND sg13cmos5l_antennanp
XANTENNA_232 Tile_X0Y0_FrameData[3] VPWR VGND sg13cmos5l_antennanp
XANTENNA_243 Tile_X0Y0_FrameData[5] VPWR VGND sg13cmos5l_antennanp
XANTENNA_254 Tile_X0Y0_FrameData[5] VPWR VGND sg13cmos5l_antennanp
XANTENNA_265 Tile_X0Y0_FrameData[5] VPWR VGND sg13cmos5l_antennanp
XANTENNA_276 Tile_X0Y0_FrameData[5] VPWR VGND sg13cmos5l_antennanp
XANTENNA_287 Tile_X0Y0_FrameData[7] VPWR VGND sg13cmos5l_antennanp
XANTENNA_298 Tile_X0Y0_FrameData[7] VPWR VGND sg13cmos5l_antennanp
XFILLER_14_686 VPWR VGND sg13cmos5l_fill_2
X_366_ _366_/L_HI VPWR VGND sg13cmos5l_tiehi
X_435_ Tile_X0Y0_S4BEG[4] _572_/X VPWR VGND sg13cmos5l_buf_1
X_504_ Tile_X1Y0_S2BEG[1] Tile_X1Y0_N2MID[6] VPWR VGND sg13cmos5l_buf_1
XFILLER_10_892 VPWR VGND sg13cmos5l_decap_8
XFILLER_13_196 VPWR VGND sg13cmos5l_decap_8
X_297_ _297_/Q Tile_X0Y0_FrameData[24] VGND VPWR Tile_X0Y0_FrameStrobe[1] latch
XFILLER_9_145 VPWR VGND sg13cmos5l_fill_2
XFILLER_6_852 VPWR VGND sg13cmos5l_decap_4
XFILLER_5_340 VPWR VGND sg13cmos5l_fill_2
XFILLER_3_86 VPWR VGND sg13cmos5l_fill_1
XFILLER_3_64 VPWR VGND sg13cmos5l_decap_4
XFILLER_15_406 VPWR VGND sg13cmos5l_decap_8
XFILLER_16_929 VPWR VGND sg13cmos5l_decap_8
X_220_ _220_/Q Tile_X0Y0_FrameData[28] VGND VPWR Tile_X1Y0_FrameStrobe[3] latch
XFILLER_10_166 VPWR VGND sg13cmos5l_decap_8
XFILLER_10_199 VPWR VGND sg13cmos5l_fill_2
XFILLER_11_678 VPWR VGND sg13cmos5l_decap_4
X_151_ _151_/Q Tile_X0Y0_FrameData[1] VGND VPWR Tile_X1Y0_FrameStrobe[0] latch
X_082_ PMOD_IO_OE_O3 _120_/A _059_/Y _081_/X _223_/Q _080_/Y VPWR VGND sg13cmos5l_a221oi_1
XFILLER_7_649 VPWR VGND sg13cmos5l_decap_8
XFILLER_3_822 VPWR VGND sg13cmos5l_decap_8
XFILLER_3_833 VPWR VGND sg13cmos5l_fill_1
XFILLER_15_940 VPWR VGND sg13cmos5l_fill_1
XFILLER_18_288 VPWR VGND sg13cmos5l_decap_8
XFILLER_18_277 VPWR VGND sg13cmos5l_fill_1
XFILLER_18_233 VPWR VGND sg13cmos5l_decap_8
XFILLER_14_483 VPWR VGND sg13cmos5l_decap_8
XFILLER_15_951 VPWR VGND sg13cmos5l_decap_8
X_349_ _349_/Q Tile_X0Y0_FrameData[4] VGND VPWR Tile_X0Y0_FrameStrobe[2] latch
X_418_ Tile_X0Y0_S2BEG[3] Tile_X0Y0_N2MID[4] VPWR VGND sg13cmos5l_buf_1
XFILLER_6_693 VPWR VGND sg13cmos5l_fill_1
XFILLER_0_803 VPWR VGND sg13cmos5l_fill_1
XFILLER_0_814 VPWR VGND sg13cmos5l_decap_8
XFILLER_0_825 VPWR VGND sg13cmos5l_fill_2
XFILLER_3_118 VPWR VGND sg13cmos5l_decap_8
XFILLER_15_203 VPWR VGND sg13cmos5l_decap_8
XFILLER_11_464 VPWR VGND sg13cmos5l_decap_8
X_203_ _203_/Q Tile_X0Y0_FrameData[13] VGND VPWR Tile_X1Y0_FrameStrobe[2] latch
XFILLER_8_903 VPWR VGND sg13cmos5l_decap_8
XFILLER_7_413 VPWR VGND sg13cmos5l_decap_8
X_134_ _134_/Q Tile_X0Y0_FrameData[18] VGND VPWR Tile_X1Y0_FrameStrobe[0] latch
X_065_ _243_/D _640_/X _231_/Q _232_/Q VPWR VGND sg13cmos5l_mux2_1
XFILLER_8_958 VPWR VGND sg13cmos5l_fill_2
XANTENNA__100__Y PMOD_IO_OE_O6 VPWR VGND sg13cmos5l_antennanp
XFILLER_0_21 VPWR VGND sg13cmos5l_decap_8
XFILLER_14_280 VPWR VGND sg13cmos5l_decap_8
XFILLER_9_96 VPWR VGND sg13cmos5l_decap_8
XFILLER_9_63 VPWR VGND sg13cmos5l_decap_8
XANTENNA__498__X Tile_X1Y0_FrameStrobe_O[19] VPWR VGND sg13cmos5l_antennanp
XFILLER_4_438 VPWR VGND sg13cmos5l_decap_8
XFILLER_0_633 VPWR VGND sg13cmos5l_fill_1
XFILLER_16_567 VPWR VGND sg13cmos5l_decap_8
XFILLER_11_261 VPWR VGND sg13cmos5l_decap_8
X_117_ PMOD_IO_O7 _223_/Q _107_/X VPWR VGND sg13cmos5l_nor2b_1
XFILLER_8_777 VPWR VGND sg13cmos5l_decap_8
XFILLER_8_722 VPWR VGND sg13cmos5l_decap_8
XFILLER_3_471 VPWR VGND sg13cmos5l_fill_2
XFILLER_13_504 VPWR VGND sg13cmos5l_decap_8
XFILLER_4_202 VPWR VGND sg13cmos5l_decap_8
XFILLER_16_364 VPWR VGND sg13cmos5l_decap_8
XFILLER_17_898 VPWR VGND sg13cmos5l_decap_8
X_597_ _597_/X Tile_X0Y0_N2END[5] Tile_X0Y0_N4END[13] Tile_X0Y0_NN4END[2] _119_/X
+ _275_/Q _274_/Q VPWR VGND sg13cmos5l_mux4_1
XANTENNA_2 Tile_X0Y0_FrameData[16] VPWR VGND sg13cmos5l_antennanp
XFILLER_8_585 VPWR VGND sg13cmos5l_fill_2
XFILLER_13_0 VPWR VGND sg13cmos5l_decap_8
XFILLER_2_706 VPWR VGND sg13cmos5l_decap_8
X_520_ Tile_X1Y0_S4BEG[1] _609_/X VPWR VGND sg13cmos5l_buf_1
XFILLER_13_301 VPWR VGND sg13cmos5l_decap_8
XFILLER_15_84 VPWR VGND sg13cmos5l_decap_8
X_382_ Tile_X0Y0_SS4BEG[7] _591_/X VPWR VGND sg13cmos5l_buf_1
X_451_ Tile_X1Y0_FrameData_O[4] Tile_X0Y0_FrameData[4] VPWR VGND sg13cmos5l_buf_1
XFILLER_13_378 VPWR VGND sg13cmos5l_decap_8
XFILLER_5_599 VPWR VGND sg13cmos5l_decap_8
XFILLER_1_772 VPWR VGND sg13cmos5l_fill_1
XFILLER_0_293 VPWR VGND sg13cmos5l_fill_1
XFILLER_17_651 VPWR VGND sg13cmos5l_decap_8
XFILLER_13_890 VPWR VGND sg13cmos5l_decap_8
XFILLER_16_161 VPWR VGND sg13cmos5l_decap_8
XFILLER_9_861 VPWR VGND sg13cmos5l_decap_8
XFILLER_11_816 VPWR VGND sg13cmos5l_decap_8
XFILLER_10_337 VPWR VGND sg13cmos5l_decap_8
XANTENNA_200 Tile_X0Y0_FrameData[2] VPWR VGND sg13cmos5l_antennanp
XANTENNA_211 Tile_X0Y0_FrameData[3] VPWR VGND sg13cmos5l_antennanp
XANTENNA_222 Tile_X0Y0_FrameData[3] VPWR VGND sg13cmos5l_antennanp
XANTENNA_233 Tile_X0Y0_FrameData[3] VPWR VGND sg13cmos5l_antennanp
X_503_ Tile_X1Y0_S2BEG[0] Tile_X1Y0_N2MID[7] VPWR VGND sg13cmos5l_buf_1
XFILLER_18_437 VPWR VGND sg13cmos5l_decap_8
XFILLER_18_415 VPWR VGND sg13cmos5l_decap_8
XANTENNA_244 Tile_X0Y0_FrameData[5] VPWR VGND sg13cmos5l_antennanp
XANTENNA_255 Tile_X0Y0_FrameData[5] VPWR VGND sg13cmos5l_antennanp
XANTENNA_266 Tile_X0Y0_FrameData[5] VPWR VGND sg13cmos5l_antennanp
XANTENNA_277 Tile_X0Y0_FrameData[5] VPWR VGND sg13cmos5l_antennanp
XANTENNA_288 Tile_X0Y0_FrameData[7] VPWR VGND sg13cmos5l_antennanp
XANTENNA_299 Tile_X0Y0_FrameData[7] VPWR VGND sg13cmos5l_antennanp
XFILLER_13_175 VPWR VGND sg13cmos5l_decap_8
X_296_ _296_/Q Tile_X0Y0_FrameData[25] VGND VPWR Tile_X0Y0_FrameStrobe[1] latch
X_365_ _365_/L_HI VPWR VGND sg13cmos5l_tiehi
X_434_ Tile_X0Y0_S4BEG[3] _571_/X VPWR VGND sg13cmos5l_buf_1
XFILLER_9_124 VPWR VGND sg13cmos5l_decap_8
XFILLER_10_871 VPWR VGND sg13cmos5l_decap_8
XFILLER_5_385 VPWR VGND sg13cmos5l_decap_4
XFILLER_3_21 VPWR VGND sg13cmos5l_fill_2
XFILLER_16_908 VPWR VGND sg13cmos5l_decap_8
XFILLER_11_635 VPWR VGND sg13cmos5l_decap_4
X_150_ _150_/Q Tile_X0Y0_FrameData[2] VGND VPWR Tile_X1Y0_FrameStrobe[0] latch
XFILLER_10_145 VPWR VGND sg13cmos5l_decap_8
X_081_ _081_/X _254_/Q _555_/X _233_/Q VPWR VGND sg13cmos5l_mux2_1
XFILLER_7_628 VPWR VGND sg13cmos5l_decap_8
XFILLER_18_256 VPWR VGND sg13cmos5l_decap_8
XFILLER_18_223 VPWR VGND sg13cmos5l_decap_8
XFILLER_14_462 VPWR VGND sg13cmos5l_decap_8
X_279_ _279_/Q Tile_X0Y0_FrameData[10] VGND VPWR Tile_X0Y0_FrameStrobe[0] latch
X_348_ _348_/Q Tile_X0Y0_FrameData[5] VGND VPWR Tile_X0Y0_FrameStrobe[2] latch
X_417_ Tile_X0Y0_S2BEG[2] Tile_X0Y0_N2MID[5] VPWR VGND sg13cmos5l_buf_1
XFILLER_5_160 VPWR VGND sg13cmos5l_fill_1
XFILLER_4_609 VPWR VGND sg13cmos5l_decap_8
XFILLER_15_259 VPWR VGND sg13cmos5l_decap_8
XFILLER_11_443 VPWR VGND sg13cmos5l_decap_8
XFILLER_12_922 VPWR VGND sg13cmos5l_decap_8
X_202_ _202_/Q Tile_X0Y0_FrameData[14] VGND VPWR Tile_X1Y0_FrameStrobe[2] latch
X_133_ _133_/Q Tile_X0Y0_FrameData[19] VGND VPWR Tile_X1Y0_FrameStrobe[0] latch
X_064_ _064_/X _242_/Q _242_/D _234_/Q VPWR VGND sg13cmos5l_mux2_1
XFILLER_7_469 VPWR VGND sg13cmos5l_decap_8
XFILLER_3_631 VPWR VGND sg13cmos5l_fill_1
XFILLER_2_163 VPWR VGND sg13cmos5l_decap_8
XFILLER_17_7 VPWR VGND sg13cmos5l_decap_8
XFILLER_9_42 VPWR VGND sg13cmos5l_decap_8
XFILLER_9_75 VPWR VGND sg13cmos5l_decap_8
XFILLER_0_612 VPWR VGND sg13cmos5l_fill_1
XFILLER_16_546 VPWR VGND sg13cmos5l_decap_8
XFILLER_18_84 VPWR VGND sg13cmos5l_fill_2
XFILLER_11_240 VPWR VGND sg13cmos5l_decap_8
X_116_ PMOD_IO_O6 _223_/Q _097_/X VPWR VGND sg13cmos5l_nor2b_1
XFILLER_7_200 VPWR VGND sg13cmos5l_decap_8
XANTENNA__111__Y PMOD_IO_O1 VPWR VGND sg13cmos5l_antennanp
XFILLER_4_940 VPWR VGND sg13cmos5l_fill_1
XFILLER_9_509 VPWR VGND sg13cmos5l_decap_8
XFILLER_0_453 VPWR VGND sg13cmos5l_decap_8
XFILLER_0_464 VPWR VGND sg13cmos5l_decap_4
XFILLER_4_269 VPWR VGND sg13cmos5l_decap_8
XFILLER_16_343 VPWR VGND sg13cmos5l_decap_8
XFILLER_17_877 VPWR VGND sg13cmos5l_decap_8
X_596_ _596_/X Tile_X0Y0_N2END[4] Tile_X0Y0_N4END[12] Tile_X0Y0_NN4END[3] _091_/X
+ _277_/Q _276_/Q VPWR VGND sg13cmos5l_mux4_1
XFILLER_8_531 VPWR VGND sg13cmos5l_decap_4
XANTENNA_3 Tile_X0Y0_FrameData[16] VPWR VGND sg13cmos5l_antennanp
XFILLER_8_542 VPWR VGND sg13cmos5l_decap_8
XFILLER_6_65 VPWR VGND sg13cmos5l_fill_2
XFILLER_10_519 VPWR VGND sg13cmos5l_decap_8
XFILLER_13_357 VPWR VGND sg13cmos5l_decap_8
XFILLER_14_869 VPWR VGND sg13cmos5l_decap_8
XFILLER_15_63 VPWR VGND sg13cmos5l_decap_8
X_381_ Tile_X0Y0_SS4BEG[6] _590_/X VPWR VGND sg13cmos5l_buf_1
X_450_ Tile_X1Y0_FrameData_O[3] Tile_X0Y0_FrameData[3] VPWR VGND sg13cmos5l_buf_1
XFILLER_0_272 VPWR VGND sg13cmos5l_decap_8
XFILLER_16_140 VPWR VGND sg13cmos5l_decap_8
XFILLER_17_630 VPWR VGND sg13cmos5l_decap_8
X_579_ _579_/X Tile_X0Y0_N2MID[3] Tile_X0Y0_N4END[4] Tile_X0Y0_NN4END[11] _091_/X
+ _311_/Q _310_/Q VPWR VGND sg13cmos5l_mux4_1
XFILLER_10_316 VPWR VGND sg13cmos5l_decap_8
XFILLER_2_504 VPWR VGND sg13cmos5l_fill_1
XFILLER_2_526 VPWR VGND sg13cmos5l_fill_1
XANTENNA_201 Tile_X0Y0_FrameData[3] VPWR VGND sg13cmos5l_antennanp
XANTENNA_212 Tile_X0Y0_FrameData[3] VPWR VGND sg13cmos5l_antennanp
XANTENNA_223 Tile_X0Y0_FrameData[3] VPWR VGND sg13cmos5l_antennanp
XANTENNA_234 Tile_X0Y0_FrameData[3] VPWR VGND sg13cmos5l_antennanp
XANTENNA_245 Tile_X0Y0_FrameData[5] VPWR VGND sg13cmos5l_antennanp
XANTENNA_256 Tile_X0Y0_FrameData[5] VPWR VGND sg13cmos5l_antennanp
XANTENNA_267 Tile_X0Y0_FrameData[5] VPWR VGND sg13cmos5l_antennanp
X_433_ Tile_X0Y0_S4BEG[2] _570_/X VPWR VGND sg13cmos5l_buf_1
X_502_ Tile_X1Y0_S1BEG[3] Tile_X1Y0_N1END[0] VPWR VGND sg13cmos5l_buf_1
XFILLER_18_427 VPWR VGND sg13cmos5l_fill_1
XANTENNA_278 Tile_X0Y0_FrameData[5] VPWR VGND sg13cmos5l_antennanp
XANTENNA_289 Tile_X0Y0_FrameData[7] VPWR VGND sg13cmos5l_antennanp
XFILLER_10_850 VPWR VGND sg13cmos5l_decap_8
XFILLER_13_154 VPWR VGND sg13cmos5l_decap_8
X_295_ _295_/Q Tile_X0Y0_FrameData[26] VGND VPWR Tile_X0Y0_FrameStrobe[1] latch
X_364_ _364_/L_HI VPWR VGND sg13cmos5l_tiehi
XFILLER_9_147 VPWR VGND sg13cmos5l_fill_1
XFILLER_9_103 VPWR VGND sg13cmos5l_decap_8
XFILLER_5_397 VPWR VGND sg13cmos5l_decap_8
XANTENNA__400__X Tile_X0Y0_FrameStrobe_O[9] VPWR VGND sg13cmos5l_antennanp
XFILLER_1_570 VPWR VGND sg13cmos5l_fill_1
XFILLER_18_950 VPWR VGND sg13cmos5l_decap_8
XFILLER_9_692 VPWR VGND sg13cmos5l_decap_8
XFILLER_9_670 VPWR VGND sg13cmos5l_decap_8
XFILLER_10_124 VPWR VGND sg13cmos5l_decap_8
X_080_ _080_/Y _120_/A _246_/D VPWR VGND sg13cmos5l_nor2_1
XFILLER_7_618 VPWR VGND sg13cmos5l_fill_1
XFILLER_12_42 VPWR VGND sg13cmos5l_decap_8
XFILLER_12_53 VPWR VGND sg13cmos5l_fill_2
XFILLER_12_86 VPWR VGND sg13cmos5l_decap_8
XFILLER_14_441 VPWR VGND sg13cmos5l_decap_8
X_416_ Tile_X0Y0_S2BEG[1] Tile_X0Y0_N2MID[6] VPWR VGND sg13cmos5l_buf_1
X_278_ _278_/Q Tile_X0Y0_FrameData[11] VGND VPWR Tile_X0Y0_FrameStrobe[0] latch
X_347_ _347_/Q Tile_X0Y0_FrameData[6] VGND VPWR Tile_X0Y0_FrameStrobe[2] latch
XFILLER_6_640 VPWR VGND sg13cmos5l_fill_2
XANTENNA__114__Y PMOD_IO_O4 VPWR VGND sg13cmos5l_antennanp
XFILLER_18_780 VPWR VGND sg13cmos5l_fill_2
XFILLER_12_901 VPWR VGND sg13cmos5l_decap_8
XFILLER_15_238 VPWR VGND sg13cmos5l_decap_8
XFILLER_11_422 VPWR VGND sg13cmos5l_decap_8
X_201_ _201_/Q Tile_X0Y0_FrameData[15] VGND VPWR Tile_X1Y0_FrameStrobe[2] latch
X_132_ _132_/Q Tile_X0Y0_FrameData[20] VGND VPWR Tile_X1Y0_FrameStrobe[0] latch
X_063_ _242_/D PMOD_IO_I7 _559_/X _222_/Q VPWR VGND sg13cmos5l_mux2_1
XFILLER_7_448 VPWR VGND sg13cmos5l_decap_8
XFILLER_3_654 VPWR VGND sg13cmos5l_fill_2
XFILLER_3_0 VPWR VGND sg13cmos5l_decap_8
XFILLER_0_56 VPWR VGND sg13cmos5l_fill_2
XANTENNA__109__Y PMOD_IO_O0 VPWR VGND sg13cmos5l_antennanp
XFILLER_9_21 VPWR VGND sg13cmos5l_decap_8
XFILLER_6_481 VPWR VGND sg13cmos5l_decap_8
XFILLER_12_219 VPWR VGND sg13cmos5l_decap_8
XFILLER_0_624 VPWR VGND sg13cmos5l_decap_8
XFILLER_16_525 VPWR VGND sg13cmos5l_decap_8
XFILLER_18_63 VPWR VGND sg13cmos5l_decap_8
XFILLER_12_742 VPWR VGND sg13cmos5l_decap_4
XFILLER_18_96 VPWR VGND sg13cmos5l_decap_8
XFILLER_11_296 VPWR VGND sg13cmos5l_decap_8
X_115_ PMOD_IO_O5 _223_/Q _101_/X VPWR VGND sg13cmos5l_nor2b_1
XFILLER_8_757 VPWR VGND sg13cmos5l_fill_2
XFILLER_3_495 VPWR VGND sg13cmos5l_decap_8
XFILLER_3_473 VPWR VGND sg13cmos5l_fill_1
XFILLER_7_790 VPWR VGND sg13cmos5l_fill_1
XFILLER_13_539 VPWR VGND sg13cmos5l_decap_8
XFILLER_16_322 VPWR VGND sg13cmos5l_decap_8
XFILLER_17_856 VPWR VGND sg13cmos5l_decap_8
X_595_ _595_/X Tile_X0Y0_N2END[3] Tile_X0Y0_N4END[11] Tile_X0Y0_NN4END[4] _092_/X
+ _279_/Q _278_/Q VPWR VGND sg13cmos5l_mux4_1
XFILLER_12_583 VPWR VGND sg13cmos5l_decap_8
XFILLER_16_399 VPWR VGND sg13cmos5l_decap_8
XFILLER_8_510 VPWR VGND sg13cmos5l_decap_8
XANTENNA_4 Tile_X0Y0_FrameData[16] VPWR VGND sg13cmos5l_antennanp
XANTENNA__403__X Tile_X0Y0_FrameStrobe_O[12] VPWR VGND sg13cmos5l_antennanp
XFILLER_8_587 VPWR VGND sg13cmos5l_fill_1
XFILLER_6_55 VPWR VGND sg13cmos5l_fill_2
XFILLER_1_218 VPWR VGND sg13cmos5l_fill_1
XFILLER_17_119 VPWR VGND sg13cmos5l_decap_8
XFILLER_18_609 VPWR VGND sg13cmos5l_fill_2
XFILLER_13_336 VPWR VGND sg13cmos5l_decap_8
XFILLER_14_848 VPWR VGND sg13cmos5l_decap_8
XFILLER_15_42 VPWR VGND sg13cmos5l_decap_8
X_380_ Tile_X0Y0_SS4BEG[5] _589_/X VPWR VGND sg13cmos5l_buf_1
XFILLER_5_524 VPWR VGND sg13cmos5l_decap_8
XFILLER_0_251 VPWR VGND sg13cmos5l_decap_8
XFILLER_16_196 VPWR VGND sg13cmos5l_decap_8
X_647_ _647_/X Tile_X1Y0_N1END[1] Tile_X1Y0_N2END[3] Tile_X1Y0_N4END[14] Tile_X1Y0_NN4END[14]
+ _122_/Q _221_/Q VPWR VGND sg13cmos5l_mux4_1
X_578_ _578_/X Tile_X0Y0_N2MID[2] Tile_X0Y0_N4END[5] Tile_X0Y0_NN4END[10] _119_/X
+ _313_/Q _312_/Q VPWR VGND sg13cmos5l_mux4_1
XANTENNA__117__Y PMOD_IO_O7 VPWR VGND sg13cmos5l_antennanp
XFILLER_12_380 VPWR VGND sg13cmos5l_decap_8
XFILLER_9_896 VPWR VGND sg13cmos5l_decap_8
XFILLER_9_841 VPWR VGND sg13cmos5l_fill_2
XFILLER_8_384 VPWR VGND sg13cmos5l_decap_8
.ends
