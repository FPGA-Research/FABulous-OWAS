* NGSPICE file created from NPU_ACCUM_S.ext - technology: ihp-sg13cmos5l

* Black-box entry subcircuit for sg13cmos5l_decap_4 abstract view
.subckt sg13cmos5l_decap_4 VDD VSS
.ends

* Black-box entry subcircuit for latch abstract view
.subckt latch Q D VSS VDD GATE
.ends

* Black-box entry subcircuit for sg13cmos5l_fill_2 abstract view
.subckt sg13cmos5l_fill_2 VDD VSS
.ends

* Black-box entry subcircuit for sg13cmos5l_decap_8 abstract view
.subckt sg13cmos5l_decap_8 VDD VSS
.ends

* Black-box entry subcircuit for sg13cmos5l_fill_1 abstract view
.subckt sg13cmos5l_fill_1 VDD VSS
.ends

* Black-box entry subcircuit for sg13cmos5l_antennanp abstract view
.subckt sg13cmos5l_antennanp A VDD VSS
.ends

* Black-box entry subcircuit for sg13cmos5l_mux4_1 abstract view
.subckt sg13cmos5l_mux4_1 X A0 A1 A2 A3 S0 S1 VDD VSS
.ends

* Black-box entry subcircuit for sg13cmos5l_nor2b_1 abstract view
.subckt sg13cmos5l_nor2b_1 Y A B_N VDD VSS
.ends

* Black-box entry subcircuit for sg13cmos5l_buf_1 abstract view
.subckt sg13cmos5l_buf_1 X A VDD VSS
.ends

* Black-box entry subcircuit for sg13cmos5l_tiehi abstract view
.subckt sg13cmos5l_tiehi L_HI VDD VSS
.ends

* Black-box entry subcircuit for sg13cmos5l_dfrbpq_1 abstract view
.subckt sg13cmos5l_dfrbpq_1 Q CLK D RESET_B VDD VSS
.ends

* Black-box entry subcircuit for sg13cmos5l_tielo abstract view
.subckt sg13cmos5l_tielo L_LO VDD VSS
.ends

.subckt NPU_ACCUM_S NPU_ADDR0 NPU_ADDR1 NPU_ADDR2 NPU_ADDR3 NPU_ADDR4 NPU_ADDR5 NPU_ADDR6
+ NPU_ADDR7 NPU_RDATA0 NPU_RDATA1 NPU_RDATA10 NPU_RDATA11 NPU_RDATA12 NPU_RDATA13
+ NPU_RDATA14 NPU_RDATA15 NPU_RDATA16 NPU_RDATA17 NPU_RDATA18 NPU_RDATA19 NPU_RDATA2
+ NPU_RDATA20 NPU_RDATA21 NPU_RDATA22 NPU_RDATA23 NPU_RDATA24 NPU_RDATA25 NPU_RDATA26
+ NPU_RDATA27 NPU_RDATA28 NPU_RDATA29 NPU_RDATA3 NPU_RDATA30 NPU_RDATA31 NPU_RDATA4
+ NPU_RDATA5 NPU_RDATA6 NPU_RDATA7 NPU_RDATA8 NPU_RDATA9 NPU_READ_BANK_SEL0 NPU_READ_BANK_SEL1
+ NPU_READ_BANK_SEL2 NPU_WDATA0 NPU_WDATA1 NPU_WDATA10 NPU_WDATA11 NPU_WDATA12 NPU_WDATA13
+ NPU_WDATA14 NPU_WDATA15 NPU_WDATA16 NPU_WDATA17 NPU_WDATA18 NPU_WDATA19 NPU_WDATA2
+ NPU_WDATA20 NPU_WDATA21 NPU_WDATA22 NPU_WDATA23 NPU_WDATA24 NPU_WDATA25 NPU_WDATA26
+ NPU_WDATA27 NPU_WDATA28 NPU_WDATA29 NPU_WDATA3 NPU_WDATA30 NPU_WDATA31 NPU_WDATA4
+ NPU_WDATA5 NPU_WDATA6 NPU_WDATA7 NPU_WDATA8 NPU_WDATA9 NPU_WE0 NPU_WE1 NPU_WE2 NPU_WE3
+ NPU_WE4 NPU_WE5 NPU_WE6 NPU_WE7 Tile_X0Y0_Co Tile_X0Y0_FrameData[0] Tile_X0Y0_FrameData[10]
+ Tile_X0Y0_FrameData[11] Tile_X0Y0_FrameData[12] Tile_X0Y0_FrameData[13] Tile_X0Y0_FrameData[14]
+ Tile_X0Y0_FrameData[15] Tile_X0Y0_FrameData[16] Tile_X0Y0_FrameData[17] Tile_X0Y0_FrameData[18]
+ Tile_X0Y0_FrameData[19] Tile_X0Y0_FrameData[1] Tile_X0Y0_FrameData[20] Tile_X0Y0_FrameData[21]
+ Tile_X0Y0_FrameData[22] Tile_X0Y0_FrameData[23] Tile_X0Y0_FrameData[24] Tile_X0Y0_FrameData[25]
+ Tile_X0Y0_FrameData[26] Tile_X0Y0_FrameData[27] Tile_X0Y0_FrameData[28] Tile_X0Y0_FrameData[29]
+ Tile_X0Y0_FrameData[2] Tile_X0Y0_FrameData[30] Tile_X0Y0_FrameData[31] Tile_X0Y0_FrameData[3]
+ Tile_X0Y0_FrameData[4] Tile_X0Y0_FrameData[5] Tile_X0Y0_FrameData[6] Tile_X0Y0_FrameData[7]
+ Tile_X0Y0_FrameData[8] Tile_X0Y0_FrameData[9] Tile_X0Y0_FrameStrobe[0] Tile_X0Y0_FrameStrobe[10]
+ Tile_X0Y0_FrameStrobe[11] Tile_X0Y0_FrameStrobe[12] Tile_X0Y0_FrameStrobe[13] Tile_X0Y0_FrameStrobe[14]
+ Tile_X0Y0_FrameStrobe[15] Tile_X0Y0_FrameStrobe[16] Tile_X0Y0_FrameStrobe[17] Tile_X0Y0_FrameStrobe[18]
+ Tile_X0Y0_FrameStrobe[19] Tile_X0Y0_FrameStrobe[1] Tile_X0Y0_FrameStrobe[2] Tile_X0Y0_FrameStrobe[3]
+ Tile_X0Y0_FrameStrobe[4] Tile_X0Y0_FrameStrobe[5] Tile_X0Y0_FrameStrobe[6] Tile_X0Y0_FrameStrobe[7]
+ Tile_X0Y0_FrameStrobe[8] Tile_X0Y0_FrameStrobe[9] Tile_X0Y0_FrameStrobe_O[0] Tile_X0Y0_FrameStrobe_O[10]
+ Tile_X0Y0_FrameStrobe_O[11] Tile_X0Y0_FrameStrobe_O[12] Tile_X0Y0_FrameStrobe_O[13]
+ Tile_X0Y0_FrameStrobe_O[14] Tile_X0Y0_FrameStrobe_O[15] Tile_X0Y0_FrameStrobe_O[16]
+ Tile_X0Y0_FrameStrobe_O[17] Tile_X0Y0_FrameStrobe_O[18] Tile_X0Y0_FrameStrobe_O[19]
+ Tile_X0Y0_FrameStrobe_O[1] Tile_X0Y0_FrameStrobe_O[2] Tile_X0Y0_FrameStrobe_O[3]
+ Tile_X0Y0_FrameStrobe_O[4] Tile_X0Y0_FrameStrobe_O[5] Tile_X0Y0_FrameStrobe_O[6]
+ Tile_X0Y0_FrameStrobe_O[7] Tile_X0Y0_FrameStrobe_O[8] Tile_X0Y0_FrameStrobe_O[9]
+ Tile_X0Y0_N1BEG[0] Tile_X0Y0_N1BEG[1] Tile_X0Y0_N1BEG[2] Tile_X0Y0_N1BEG[3] Tile_X0Y0_N2BEG[0]
+ Tile_X0Y0_N2BEG[1] Tile_X0Y0_N2BEG[2] Tile_X0Y0_N2BEG[3] Tile_X0Y0_N2BEG[4] Tile_X0Y0_N2BEG[5]
+ Tile_X0Y0_N2BEG[6] Tile_X0Y0_N2BEG[7] Tile_X0Y0_N2BEGb[0] Tile_X0Y0_N2BEGb[1] Tile_X0Y0_N2BEGb[2]
+ Tile_X0Y0_N2BEGb[3] Tile_X0Y0_N2BEGb[4] Tile_X0Y0_N2BEGb[5] Tile_X0Y0_N2BEGb[6]
+ Tile_X0Y0_N2BEGb[7] Tile_X0Y0_N4BEG[0] Tile_X0Y0_N4BEG[10] Tile_X0Y0_N4BEG[11] Tile_X0Y0_N4BEG[12]
+ Tile_X0Y0_N4BEG[13] Tile_X0Y0_N4BEG[14] Tile_X0Y0_N4BEG[15] Tile_X0Y0_N4BEG[1] Tile_X0Y0_N4BEG[2]
+ Tile_X0Y0_N4BEG[3] Tile_X0Y0_N4BEG[4] Tile_X0Y0_N4BEG[5] Tile_X0Y0_N4BEG[6] Tile_X0Y0_N4BEG[7]
+ Tile_X0Y0_N4BEG[8] Tile_X0Y0_N4BEG[9] Tile_X0Y0_NN4BEG[0] Tile_X0Y0_NN4BEG[10] Tile_X0Y0_NN4BEG[11]
+ Tile_X0Y0_NN4BEG[12] Tile_X0Y0_NN4BEG[13] Tile_X0Y0_NN4BEG[14] Tile_X0Y0_NN4BEG[15]
+ Tile_X0Y0_NN4BEG[1] Tile_X0Y0_NN4BEG[2] Tile_X0Y0_NN4BEG[3] Tile_X0Y0_NN4BEG[4]
+ Tile_X0Y0_NN4BEG[5] Tile_X0Y0_NN4BEG[6] Tile_X0Y0_NN4BEG[7] Tile_X0Y0_NN4BEG[8]
+ Tile_X0Y0_NN4BEG[9] Tile_X0Y0_S1END[0] Tile_X0Y0_S1END[1] Tile_X0Y0_S1END[2] Tile_X0Y0_S1END[3]
+ Tile_X0Y0_S2END[0] Tile_X0Y0_S2END[1] Tile_X0Y0_S2END[2] Tile_X0Y0_S2END[3] Tile_X0Y0_S2END[4]
+ Tile_X0Y0_S2END[5] Tile_X0Y0_S2END[6] Tile_X0Y0_S2END[7] Tile_X0Y0_S2MID[0] Tile_X0Y0_S2MID[1]
+ Tile_X0Y0_S2MID[2] Tile_X0Y0_S2MID[3] Tile_X0Y0_S2MID[4] Tile_X0Y0_S2MID[5] Tile_X0Y0_S2MID[6]
+ Tile_X0Y0_S2MID[7] Tile_X0Y0_S4END[0] Tile_X0Y0_S4END[10] Tile_X0Y0_S4END[11] Tile_X0Y0_S4END[12]
+ Tile_X0Y0_S4END[13] Tile_X0Y0_S4END[14] Tile_X0Y0_S4END[15] Tile_X0Y0_S4END[1] Tile_X0Y0_S4END[2]
+ Tile_X0Y0_S4END[3] Tile_X0Y0_S4END[4] Tile_X0Y0_S4END[5] Tile_X0Y0_S4END[6] Tile_X0Y0_S4END[7]
+ Tile_X0Y0_S4END[8] Tile_X0Y0_S4END[9] Tile_X0Y0_SS4END[0] Tile_X0Y0_SS4END[10] Tile_X0Y0_SS4END[11]
+ Tile_X0Y0_SS4END[12] Tile_X0Y0_SS4END[13] Tile_X0Y0_SS4END[14] Tile_X0Y0_SS4END[15]
+ Tile_X0Y0_SS4END[1] Tile_X0Y0_SS4END[2] Tile_X0Y0_SS4END[3] Tile_X0Y0_SS4END[4]
+ Tile_X0Y0_SS4END[5] Tile_X0Y0_SS4END[6] Tile_X0Y0_SS4END[7] Tile_X0Y0_SS4END[8]
+ Tile_X0Y0_SS4END[9] Tile_X0Y0_UserCLK Tile_X1Y0_Co Tile_X1Y0_FrameStrobe[0] Tile_X1Y0_FrameStrobe[10]
+ Tile_X1Y0_FrameStrobe[11] Tile_X1Y0_FrameStrobe[12] Tile_X1Y0_FrameStrobe[13] Tile_X1Y0_FrameStrobe[14]
+ Tile_X1Y0_FrameStrobe[15] Tile_X1Y0_FrameStrobe[16] Tile_X1Y0_FrameStrobe[17] Tile_X1Y0_FrameStrobe[18]
+ Tile_X1Y0_FrameStrobe[19] Tile_X1Y0_FrameStrobe[1] Tile_X1Y0_FrameStrobe[2] Tile_X1Y0_FrameStrobe[3]
+ Tile_X1Y0_FrameStrobe[4] Tile_X1Y0_FrameStrobe[5] Tile_X1Y0_FrameStrobe[6] Tile_X1Y0_FrameStrobe[7]
+ Tile_X1Y0_FrameStrobe[8] Tile_X1Y0_FrameStrobe[9] Tile_X1Y0_FrameStrobe_O[0] Tile_X1Y0_FrameStrobe_O[10]
+ Tile_X1Y0_FrameStrobe_O[11] Tile_X1Y0_FrameStrobe_O[12] Tile_X1Y0_FrameStrobe_O[13]
+ Tile_X1Y0_FrameStrobe_O[14] Tile_X1Y0_FrameStrobe_O[15] Tile_X1Y0_FrameStrobe_O[16]
+ Tile_X1Y0_FrameStrobe_O[17] Tile_X1Y0_FrameStrobe_O[18] Tile_X1Y0_FrameStrobe_O[19]
+ Tile_X1Y0_FrameStrobe_O[1] Tile_X1Y0_FrameStrobe_O[2] Tile_X1Y0_FrameStrobe_O[3]
+ Tile_X1Y0_FrameStrobe_O[4] Tile_X1Y0_FrameStrobe_O[5] Tile_X1Y0_FrameStrobe_O[6]
+ Tile_X1Y0_FrameStrobe_O[7] Tile_X1Y0_FrameStrobe_O[8] Tile_X1Y0_FrameStrobe_O[9]
+ Tile_X1Y0_N1BEG[0] Tile_X1Y0_N1BEG[1] Tile_X1Y0_N1BEG[2] Tile_X1Y0_N1BEG[3] Tile_X1Y0_N2BEG[0]
+ Tile_X1Y0_N2BEG[1] Tile_X1Y0_N2BEG[2] Tile_X1Y0_N2BEG[3] Tile_X1Y0_N2BEG[4] Tile_X1Y0_N2BEG[5]
+ Tile_X1Y0_N2BEG[6] Tile_X1Y0_N2BEG[7] Tile_X1Y0_N2BEGb[0] Tile_X1Y0_N2BEGb[1] Tile_X1Y0_N2BEGb[2]
+ Tile_X1Y0_N2BEGb[3] Tile_X1Y0_N2BEGb[4] Tile_X1Y0_N2BEGb[5] Tile_X1Y0_N2BEGb[6]
+ Tile_X1Y0_N2BEGb[7] Tile_X1Y0_N4BEG[0] Tile_X1Y0_N4BEG[10] Tile_X1Y0_N4BEG[11] Tile_X1Y0_N4BEG[12]
+ Tile_X1Y0_N4BEG[13] Tile_X1Y0_N4BEG[14] Tile_X1Y0_N4BEG[15] Tile_X1Y0_N4BEG[1] Tile_X1Y0_N4BEG[2]
+ Tile_X1Y0_N4BEG[3] Tile_X1Y0_N4BEG[4] Tile_X1Y0_N4BEG[5] Tile_X1Y0_N4BEG[6] Tile_X1Y0_N4BEG[7]
+ Tile_X1Y0_N4BEG[8] Tile_X1Y0_N4BEG[9] Tile_X1Y0_NN4BEG[0] Tile_X1Y0_NN4BEG[10] Tile_X1Y0_NN4BEG[11]
+ Tile_X1Y0_NN4BEG[12] Tile_X1Y0_NN4BEG[13] Tile_X1Y0_NN4BEG[14] Tile_X1Y0_NN4BEG[15]
+ Tile_X1Y0_NN4BEG[1] Tile_X1Y0_NN4BEG[2] Tile_X1Y0_NN4BEG[3] Tile_X1Y0_NN4BEG[4]
+ Tile_X1Y0_NN4BEG[5] Tile_X1Y0_NN4BEG[6] Tile_X1Y0_NN4BEG[7] Tile_X1Y0_NN4BEG[8]
+ Tile_X1Y0_NN4BEG[9] Tile_X1Y0_S1END[0] Tile_X1Y0_S1END[1] Tile_X1Y0_S1END[2] Tile_X1Y0_S1END[3]
+ Tile_X1Y0_S2END[0] Tile_X1Y0_S2END[1] Tile_X1Y0_S2END[2] Tile_X1Y0_S2END[3] Tile_X1Y0_S2END[4]
+ Tile_X1Y0_S2END[5] Tile_X1Y0_S2END[6] Tile_X1Y0_S2END[7] Tile_X1Y0_S2MID[0] Tile_X1Y0_S2MID[1]
+ Tile_X1Y0_S2MID[2] Tile_X1Y0_S2MID[3] Tile_X1Y0_S2MID[4] Tile_X1Y0_S2MID[5] Tile_X1Y0_S2MID[6]
+ Tile_X1Y0_S2MID[7] Tile_X1Y0_S4END[0] Tile_X1Y0_S4END[10] Tile_X1Y0_S4END[11] Tile_X1Y0_S4END[12]
+ Tile_X1Y0_S4END[13] Tile_X1Y0_S4END[14] Tile_X1Y0_S4END[15] Tile_X1Y0_S4END[1] Tile_X1Y0_S4END[2]
+ Tile_X1Y0_S4END[3] Tile_X1Y0_S4END[4] Tile_X1Y0_S4END[5] Tile_X1Y0_S4END[6] Tile_X1Y0_S4END[7]
+ Tile_X1Y0_S4END[8] Tile_X1Y0_S4END[9] Tile_X1Y0_SS4END[0] Tile_X1Y0_SS4END[10] Tile_X1Y0_SS4END[11]
+ Tile_X1Y0_SS4END[12] Tile_X1Y0_SS4END[13] Tile_X1Y0_SS4END[14] Tile_X1Y0_SS4END[15]
+ Tile_X1Y0_SS4END[1] Tile_X1Y0_SS4END[2] Tile_X1Y0_SS4END[3] Tile_X1Y0_SS4END[4]
+ Tile_X1Y0_SS4END[5] Tile_X1Y0_SS4END[6] Tile_X1Y0_SS4END[7] Tile_X1Y0_SS4END[8]
+ Tile_X1Y0_SS4END[9] Tile_X2Y0_Co Tile_X2Y0_FrameStrobe[0] Tile_X2Y0_FrameStrobe[10]
+ Tile_X2Y0_FrameStrobe[11] Tile_X2Y0_FrameStrobe[12] Tile_X2Y0_FrameStrobe[13] Tile_X2Y0_FrameStrobe[14]
+ Tile_X2Y0_FrameStrobe[15] Tile_X2Y0_FrameStrobe[16] Tile_X2Y0_FrameStrobe[17] Tile_X2Y0_FrameStrobe[18]
+ Tile_X2Y0_FrameStrobe[19] Tile_X2Y0_FrameStrobe[1] Tile_X2Y0_FrameStrobe[2] Tile_X2Y0_FrameStrobe[3]
+ Tile_X2Y0_FrameStrobe[4] Tile_X2Y0_FrameStrobe[5] Tile_X2Y0_FrameStrobe[6] Tile_X2Y0_FrameStrobe[7]
+ Tile_X2Y0_FrameStrobe[8] Tile_X2Y0_FrameStrobe[9] Tile_X2Y0_FrameStrobe_O[0] Tile_X2Y0_FrameStrobe_O[10]
+ Tile_X2Y0_FrameStrobe_O[11] Tile_X2Y0_FrameStrobe_O[12] Tile_X2Y0_FrameStrobe_O[13]
+ Tile_X2Y0_FrameStrobe_O[14] Tile_X2Y0_FrameStrobe_O[15] Tile_X2Y0_FrameStrobe_O[16]
+ Tile_X2Y0_FrameStrobe_O[17] Tile_X2Y0_FrameStrobe_O[18] Tile_X2Y0_FrameStrobe_O[19]
+ Tile_X2Y0_FrameStrobe_O[1] Tile_X2Y0_FrameStrobe_O[2] Tile_X2Y0_FrameStrobe_O[3]
+ Tile_X2Y0_FrameStrobe_O[4] Tile_X2Y0_FrameStrobe_O[5] Tile_X2Y0_FrameStrobe_O[6]
+ Tile_X2Y0_FrameStrobe_O[7] Tile_X2Y0_FrameStrobe_O[8] Tile_X2Y0_FrameStrobe_O[9]
+ Tile_X2Y0_N1BEG[0] Tile_X2Y0_N1BEG[1] Tile_X2Y0_N1BEG[2] Tile_X2Y0_N1BEG[3] Tile_X2Y0_N2BEG[0]
+ Tile_X2Y0_N2BEG[1] Tile_X2Y0_N2BEG[2] Tile_X2Y0_N2BEG[3] Tile_X2Y0_N2BEG[4] Tile_X2Y0_N2BEG[5]
+ Tile_X2Y0_N2BEG[6] Tile_X2Y0_N2BEG[7] Tile_X2Y0_N2BEGb[0] Tile_X2Y0_N2BEGb[1] Tile_X2Y0_N2BEGb[2]
+ Tile_X2Y0_N2BEGb[3] Tile_X2Y0_N2BEGb[4] Tile_X2Y0_N2BEGb[5] Tile_X2Y0_N2BEGb[6]
+ Tile_X2Y0_N2BEGb[7] Tile_X2Y0_N4BEG[0] Tile_X2Y0_N4BEG[10] Tile_X2Y0_N4BEG[11] Tile_X2Y0_N4BEG[12]
+ Tile_X2Y0_N4BEG[13] Tile_X2Y0_N4BEG[14] Tile_X2Y0_N4BEG[15] Tile_X2Y0_N4BEG[1] Tile_X2Y0_N4BEG[2]
+ Tile_X2Y0_N4BEG[3] Tile_X2Y0_N4BEG[4] Tile_X2Y0_N4BEG[5] Tile_X2Y0_N4BEG[6] Tile_X2Y0_N4BEG[7]
+ Tile_X2Y0_N4BEG[8] Tile_X2Y0_N4BEG[9] Tile_X2Y0_NN4BEG[0] Tile_X2Y0_NN4BEG[10] Tile_X2Y0_NN4BEG[11]
+ Tile_X2Y0_NN4BEG[12] Tile_X2Y0_NN4BEG[13] Tile_X2Y0_NN4BEG[14] Tile_X2Y0_NN4BEG[15]
+ Tile_X2Y0_NN4BEG[1] Tile_X2Y0_NN4BEG[2] Tile_X2Y0_NN4BEG[3] Tile_X2Y0_NN4BEG[4]
+ Tile_X2Y0_NN4BEG[5] Tile_X2Y0_NN4BEG[6] Tile_X2Y0_NN4BEG[7] Tile_X2Y0_NN4BEG[8]
+ Tile_X2Y0_NN4BEG[9] Tile_X2Y0_S1END[0] Tile_X2Y0_S1END[1] Tile_X2Y0_S1END[2] Tile_X2Y0_S1END[3]
+ Tile_X2Y0_S2END[0] Tile_X2Y0_S2END[1] Tile_X2Y0_S2END[2] Tile_X2Y0_S2END[3] Tile_X2Y0_S2END[4]
+ Tile_X2Y0_S2END[5] Tile_X2Y0_S2END[6] Tile_X2Y0_S2END[7] Tile_X2Y0_S2MID[0] Tile_X2Y0_S2MID[1]
+ Tile_X2Y0_S2MID[2] Tile_X2Y0_S2MID[3] Tile_X2Y0_S2MID[4] Tile_X2Y0_S2MID[5] Tile_X2Y0_S2MID[6]
+ Tile_X2Y0_S2MID[7] Tile_X2Y0_S4END[0] Tile_X2Y0_S4END[10] Tile_X2Y0_S4END[11] Tile_X2Y0_S4END[12]
+ Tile_X2Y0_S4END[13] Tile_X2Y0_S4END[14] Tile_X2Y0_S4END[15] Tile_X2Y0_S4END[1] Tile_X2Y0_S4END[2]
+ Tile_X2Y0_S4END[3] Tile_X2Y0_S4END[4] Tile_X2Y0_S4END[5] Tile_X2Y0_S4END[6] Tile_X2Y0_S4END[7]
+ Tile_X2Y0_S4END[8] Tile_X2Y0_S4END[9] Tile_X2Y0_SS4END[0] Tile_X2Y0_SS4END[10] Tile_X2Y0_SS4END[11]
+ Tile_X2Y0_SS4END[12] Tile_X2Y0_SS4END[13] Tile_X2Y0_SS4END[14] Tile_X2Y0_SS4END[15]
+ Tile_X2Y0_SS4END[1] Tile_X2Y0_SS4END[2] Tile_X2Y0_SS4END[3] Tile_X2Y0_SS4END[4]
+ Tile_X2Y0_SS4END[5] Tile_X2Y0_SS4END[6] Tile_X2Y0_SS4END[7] Tile_X2Y0_SS4END[8]
+ Tile_X2Y0_SS4END[9] Tile_X3Y0_Co Tile_X3Y0_FrameStrobe[0] Tile_X3Y0_FrameStrobe[10]
+ Tile_X3Y0_FrameStrobe[11] Tile_X3Y0_FrameStrobe[12] Tile_X3Y0_FrameStrobe[13] Tile_X3Y0_FrameStrobe[14]
+ Tile_X3Y0_FrameStrobe[15] Tile_X3Y0_FrameStrobe[16] Tile_X3Y0_FrameStrobe[17] Tile_X3Y0_FrameStrobe[18]
+ Tile_X3Y0_FrameStrobe[19] Tile_X3Y0_FrameStrobe[1] Tile_X3Y0_FrameStrobe[2] Tile_X3Y0_FrameStrobe[3]
+ Tile_X3Y0_FrameStrobe[4] Tile_X3Y0_FrameStrobe[5] Tile_X3Y0_FrameStrobe[6] Tile_X3Y0_FrameStrobe[7]
+ Tile_X3Y0_FrameStrobe[8] Tile_X3Y0_FrameStrobe[9] Tile_X3Y0_FrameStrobe_O[0] Tile_X3Y0_FrameStrobe_O[10]
+ Tile_X3Y0_FrameStrobe_O[11] Tile_X3Y0_FrameStrobe_O[12] Tile_X3Y0_FrameStrobe_O[13]
+ Tile_X3Y0_FrameStrobe_O[14] Tile_X3Y0_FrameStrobe_O[15] Tile_X3Y0_FrameStrobe_O[16]
+ Tile_X3Y0_FrameStrobe_O[17] Tile_X3Y0_FrameStrobe_O[18] Tile_X3Y0_FrameStrobe_O[19]
+ Tile_X3Y0_FrameStrobe_O[1] Tile_X3Y0_FrameStrobe_O[2] Tile_X3Y0_FrameStrobe_O[3]
+ Tile_X3Y0_FrameStrobe_O[4] Tile_X3Y0_FrameStrobe_O[5] Tile_X3Y0_FrameStrobe_O[6]
+ Tile_X3Y0_FrameStrobe_O[7] Tile_X3Y0_FrameStrobe_O[8] Tile_X3Y0_FrameStrobe_O[9]
+ Tile_X3Y0_N1BEG[0] Tile_X3Y0_N1BEG[1] Tile_X3Y0_N1BEG[2] Tile_X3Y0_N1BEG[3] Tile_X3Y0_N2BEG[0]
+ Tile_X3Y0_N2BEG[1] Tile_X3Y0_N2BEG[2] Tile_X3Y0_N2BEG[3] Tile_X3Y0_N2BEG[4] Tile_X3Y0_N2BEG[5]
+ Tile_X3Y0_N2BEG[6] Tile_X3Y0_N2BEG[7] Tile_X3Y0_N2BEGb[0] Tile_X3Y0_N2BEGb[1] Tile_X3Y0_N2BEGb[2]
+ Tile_X3Y0_N2BEGb[3] Tile_X3Y0_N2BEGb[4] Tile_X3Y0_N2BEGb[5] Tile_X3Y0_N2BEGb[6]
+ Tile_X3Y0_N2BEGb[7] Tile_X3Y0_N4BEG[0] Tile_X3Y0_N4BEG[10] Tile_X3Y0_N4BEG[11] Tile_X3Y0_N4BEG[12]
+ Tile_X3Y0_N4BEG[13] Tile_X3Y0_N4BEG[14] Tile_X3Y0_N4BEG[15] Tile_X3Y0_N4BEG[1] Tile_X3Y0_N4BEG[2]
+ Tile_X3Y0_N4BEG[3] Tile_X3Y0_N4BEG[4] Tile_X3Y0_N4BEG[5] Tile_X3Y0_N4BEG[6] Tile_X3Y0_N4BEG[7]
+ Tile_X3Y0_N4BEG[8] Tile_X3Y0_N4BEG[9] Tile_X3Y0_NN4BEG[0] Tile_X3Y0_NN4BEG[10] Tile_X3Y0_NN4BEG[11]
+ Tile_X3Y0_NN4BEG[12] Tile_X3Y0_NN4BEG[13] Tile_X3Y0_NN4BEG[14] Tile_X3Y0_NN4BEG[15]
+ Tile_X3Y0_NN4BEG[1] Tile_X3Y0_NN4BEG[2] Tile_X3Y0_NN4BEG[3] Tile_X3Y0_NN4BEG[4]
+ Tile_X3Y0_NN4BEG[5] Tile_X3Y0_NN4BEG[6] Tile_X3Y0_NN4BEG[7] Tile_X3Y0_NN4BEG[8]
+ Tile_X3Y0_NN4BEG[9] Tile_X3Y0_S1END[0] Tile_X3Y0_S1END[1] Tile_X3Y0_S1END[2] Tile_X3Y0_S1END[3]
+ Tile_X3Y0_S2END[0] Tile_X3Y0_S2END[1] Tile_X3Y0_S2END[2] Tile_X3Y0_S2END[3] Tile_X3Y0_S2END[4]
+ Tile_X3Y0_S2END[5] Tile_X3Y0_S2END[6] Tile_X3Y0_S2END[7] Tile_X3Y0_S2MID[0] Tile_X3Y0_S2MID[1]
+ Tile_X3Y0_S2MID[2] Tile_X3Y0_S2MID[3] Tile_X3Y0_S2MID[4] Tile_X3Y0_S2MID[5] Tile_X3Y0_S2MID[6]
+ Tile_X3Y0_S2MID[7] Tile_X3Y0_S4END[0] Tile_X3Y0_S4END[10] Tile_X3Y0_S4END[11] Tile_X3Y0_S4END[12]
+ Tile_X3Y0_S4END[13] Tile_X3Y0_S4END[14] Tile_X3Y0_S4END[15] Tile_X3Y0_S4END[1] Tile_X3Y0_S4END[2]
+ Tile_X3Y0_S4END[3] Tile_X3Y0_S4END[4] Tile_X3Y0_S4END[5] Tile_X3Y0_S4END[6] Tile_X3Y0_S4END[7]
+ Tile_X3Y0_S4END[8] Tile_X3Y0_S4END[9] Tile_X3Y0_SS4END[0] Tile_X3Y0_SS4END[10] Tile_X3Y0_SS4END[11]
+ Tile_X3Y0_SS4END[12] Tile_X3Y0_SS4END[13] Tile_X3Y0_SS4END[14] Tile_X3Y0_SS4END[15]
+ Tile_X3Y0_SS4END[1] Tile_X3Y0_SS4END[2] Tile_X3Y0_SS4END[3] Tile_X3Y0_SS4END[4]
+ Tile_X3Y0_SS4END[5] Tile_X3Y0_SS4END[6] Tile_X3Y0_SS4END[7] Tile_X3Y0_SS4END[8]
+ Tile_X3Y0_SS4END[9] Tile_X4Y0_Co Tile_X4Y0_FrameData_O[0] Tile_X4Y0_FrameData_O[10]
+ Tile_X4Y0_FrameData_O[11] Tile_X4Y0_FrameData_O[12] Tile_X4Y0_FrameData_O[13] Tile_X4Y0_FrameData_O[14]
+ Tile_X4Y0_FrameData_O[15] Tile_X4Y0_FrameData_O[16] Tile_X4Y0_FrameData_O[17] Tile_X4Y0_FrameData_O[18]
+ Tile_X4Y0_FrameData_O[19] Tile_X4Y0_FrameData_O[1] Tile_X4Y0_FrameData_O[20] Tile_X4Y0_FrameData_O[21]
+ Tile_X4Y0_FrameData_O[22] Tile_X4Y0_FrameData_O[23] Tile_X4Y0_FrameData_O[24] Tile_X4Y0_FrameData_O[25]
+ Tile_X4Y0_FrameData_O[26] Tile_X4Y0_FrameData_O[27] Tile_X4Y0_FrameData_O[28] Tile_X4Y0_FrameData_O[29]
+ Tile_X4Y0_FrameData_O[2] Tile_X4Y0_FrameData_O[30] Tile_X4Y0_FrameData_O[31] Tile_X4Y0_FrameData_O[3]
+ Tile_X4Y0_FrameData_O[4] Tile_X4Y0_FrameData_O[5] Tile_X4Y0_FrameData_O[6] Tile_X4Y0_FrameData_O[7]
+ Tile_X4Y0_FrameData_O[8] Tile_X4Y0_FrameData_O[9] Tile_X4Y0_FrameStrobe[0] Tile_X4Y0_FrameStrobe[10]
+ Tile_X4Y0_FrameStrobe[11] Tile_X4Y0_FrameStrobe[12] Tile_X4Y0_FrameStrobe[13] Tile_X4Y0_FrameStrobe[14]
+ Tile_X4Y0_FrameStrobe[15] Tile_X4Y0_FrameStrobe[16] Tile_X4Y0_FrameStrobe[17] Tile_X4Y0_FrameStrobe[18]
+ Tile_X4Y0_FrameStrobe[19] Tile_X4Y0_FrameStrobe[1] Tile_X4Y0_FrameStrobe[2] Tile_X4Y0_FrameStrobe[3]
+ Tile_X4Y0_FrameStrobe[4] Tile_X4Y0_FrameStrobe[5] Tile_X4Y0_FrameStrobe[6] Tile_X4Y0_FrameStrobe[7]
+ Tile_X4Y0_FrameStrobe[8] Tile_X4Y0_FrameStrobe[9] Tile_X4Y0_FrameStrobe_O[0] Tile_X4Y0_FrameStrobe_O[10]
+ Tile_X4Y0_FrameStrobe_O[11] Tile_X4Y0_FrameStrobe_O[12] Tile_X4Y0_FrameStrobe_O[13]
+ Tile_X4Y0_FrameStrobe_O[14] Tile_X4Y0_FrameStrobe_O[15] Tile_X4Y0_FrameStrobe_O[16]
+ Tile_X4Y0_FrameStrobe_O[17] Tile_X4Y0_FrameStrobe_O[18] Tile_X4Y0_FrameStrobe_O[19]
+ Tile_X4Y0_FrameStrobe_O[1] Tile_X4Y0_FrameStrobe_O[2] Tile_X4Y0_FrameStrobe_O[3]
+ Tile_X4Y0_FrameStrobe_O[4] Tile_X4Y0_FrameStrobe_O[5] Tile_X4Y0_FrameStrobe_O[6]
+ Tile_X4Y0_FrameStrobe_O[7] Tile_X4Y0_FrameStrobe_O[8] Tile_X4Y0_FrameStrobe_O[9]
+ Tile_X4Y0_N1BEG[0] Tile_X4Y0_N1BEG[1] Tile_X4Y0_N1BEG[2] Tile_X4Y0_N1BEG[3] Tile_X4Y0_N2BEG[0]
+ Tile_X4Y0_N2BEG[1] Tile_X4Y0_N2BEG[2] Tile_X4Y0_N2BEG[3] Tile_X4Y0_N2BEG[4] Tile_X4Y0_N2BEG[5]
+ Tile_X4Y0_N2BEG[6] Tile_X4Y0_N2BEG[7] Tile_X4Y0_N2BEGb[0] Tile_X4Y0_N2BEGb[1] Tile_X4Y0_N2BEGb[2]
+ Tile_X4Y0_N2BEGb[3] Tile_X4Y0_N2BEGb[4] Tile_X4Y0_N2BEGb[5] Tile_X4Y0_N2BEGb[6]
+ Tile_X4Y0_N2BEGb[7] Tile_X4Y0_N4BEG[0] Tile_X4Y0_N4BEG[10] Tile_X4Y0_N4BEG[11] Tile_X4Y0_N4BEG[12]
+ Tile_X4Y0_N4BEG[13] Tile_X4Y0_N4BEG[14] Tile_X4Y0_N4BEG[15] Tile_X4Y0_N4BEG[1] Tile_X4Y0_N4BEG[2]
+ Tile_X4Y0_N4BEG[3] Tile_X4Y0_N4BEG[4] Tile_X4Y0_N4BEG[5] Tile_X4Y0_N4BEG[6] Tile_X4Y0_N4BEG[7]
+ Tile_X4Y0_N4BEG[8] Tile_X4Y0_N4BEG[9] Tile_X4Y0_NN4BEG[0] Tile_X4Y0_NN4BEG[10] Tile_X4Y0_NN4BEG[11]
+ Tile_X4Y0_NN4BEG[12] Tile_X4Y0_NN4BEG[13] Tile_X4Y0_NN4BEG[14] Tile_X4Y0_NN4BEG[15]
+ Tile_X4Y0_NN4BEG[1] Tile_X4Y0_NN4BEG[2] Tile_X4Y0_NN4BEG[3] Tile_X4Y0_NN4BEG[4]
+ Tile_X4Y0_NN4BEG[5] Tile_X4Y0_NN4BEG[6] Tile_X4Y0_NN4BEG[7] Tile_X4Y0_NN4BEG[8]
+ Tile_X4Y0_NN4BEG[9] Tile_X4Y0_S1END[0] Tile_X4Y0_S1END[1] Tile_X4Y0_S1END[2] Tile_X4Y0_S1END[3]
+ Tile_X4Y0_S2END[0] Tile_X4Y0_S2END[1] Tile_X4Y0_S2END[2] Tile_X4Y0_S2END[3] Tile_X4Y0_S2END[4]
+ Tile_X4Y0_S2END[5] Tile_X4Y0_S2END[6] Tile_X4Y0_S2END[7] Tile_X4Y0_S2MID[0] Tile_X4Y0_S2MID[1]
+ Tile_X4Y0_S2MID[2] Tile_X4Y0_S2MID[3] Tile_X4Y0_S2MID[4] Tile_X4Y0_S2MID[5] Tile_X4Y0_S2MID[6]
+ Tile_X4Y0_S2MID[7] Tile_X4Y0_S4END[0] Tile_X4Y0_S4END[10] Tile_X4Y0_S4END[11] Tile_X4Y0_S4END[12]
+ Tile_X4Y0_S4END[13] Tile_X4Y0_S4END[14] Tile_X4Y0_S4END[15] Tile_X4Y0_S4END[1] Tile_X4Y0_S4END[2]
+ Tile_X4Y0_S4END[3] Tile_X4Y0_S4END[4] Tile_X4Y0_S4END[5] Tile_X4Y0_S4END[6] Tile_X4Y0_S4END[7]
+ Tile_X4Y0_S4END[8] Tile_X4Y0_S4END[9] Tile_X4Y0_SS4END[0] Tile_X4Y0_SS4END[10] Tile_X4Y0_SS4END[11]
+ Tile_X4Y0_SS4END[12] Tile_X4Y0_SS4END[13] Tile_X4Y0_SS4END[14] Tile_X4Y0_SS4END[15]
+ Tile_X4Y0_SS4END[1] Tile_X4Y0_SS4END[2] Tile_X4Y0_SS4END[3] Tile_X4Y0_SS4END[4]
+ Tile_X4Y0_SS4END[5] Tile_X4Y0_SS4END[6] Tile_X4Y0_SS4END[7] Tile_X4Y0_SS4END[8]
+ Tile_X4Y0_SS4END[9] Tile_X4Y0_UserCLKo VGND VPWR
XFILLER_3_2412 VPWR VGND sg13cmos5l_decap_4
X_0367_ _0367_/Q Tile_X0Y0_FrameData[10] VGND VPWR Tile_X2Y0_FrameStrobe[1] latch
XFILLER_3_1700 VPWR VGND sg13cmos5l_fill_2
X_0298_ _0298_/Q Tile_X0Y0_FrameData[31] VGND VPWR Tile_X1Y0_FrameStrobe[3] latch
XFILLER_3_1766 VPWR VGND sg13cmos5l_decap_8
XFILLER_17_2122 VPWR VGND sg13cmos5l_decap_4
XFILLER_17_1421 VPWR VGND sg13cmos5l_decap_8
XFILLER_10_328 VPWR VGND sg13cmos5l_fill_2
XFILLER_11_1020 VPWR VGND sg13cmos5l_decap_8
XFILLER_11_1042 VPWR VGND sg13cmos5l_decap_8
XFILLER_7_7 VPWR VGND sg13cmos5l_decap_8
XFILLER_2_538 VPWR VGND sg13cmos5l_decap_8
XFILLER_8_2345 VPWR VGND sg13cmos5l_decap_8
XFILLER_8_1644 VPWR VGND sg13cmos5l_fill_1
XFILLER_8_1666 VPWR VGND sg13cmos5l_decap_4
XANTENNA_202 Tile_X0Y0_FrameData[23] VPWR VGND sg13cmos5l_antennanp
XANTENNA_213 Tile_X0Y0_FrameData[23] VPWR VGND sg13cmos5l_antennanp
XANTENNA_224 Tile_X0Y0_FrameData[28] VPWR VGND sg13cmos5l_antennanp
XANTENNA_235 Tile_X0Y0_FrameData[28] VPWR VGND sg13cmos5l_antennanp
XANTENNA_246 Tile_X0Y0_FrameData[18] VPWR VGND sg13cmos5l_antennanp
XFILLER_18_1229 VPWR VGND sg13cmos5l_decap_8
XFILLER_14_656 VPWR VGND sg13cmos5l_decap_8
XFILLER_14_689 VPWR VGND sg13cmos5l_decap_4
XFILLER_14_667 VPWR VGND sg13cmos5l_fill_1
XFILLER_9_137 VPWR VGND sg13cmos5l_fill_1
XFILLER_6_855 VPWR VGND sg13cmos5l_fill_2
XFILLER_5_332 VPWR VGND sg13cmos5l_decap_4
XANTENNA__0900__X Tile_X3Y0_FrameStrobe_O[0] VPWR VGND sg13cmos5l_antennanp
XFILLER_6_899 VPWR VGND sg13cmos5l_decap_8
XFILLER_3_56 VPWR VGND sg13cmos5l_decap_8
XFILLER_1_560 VPWR VGND sg13cmos5l_decap_8
X_1270_ _1270_/X Tile_X3Y0_S2MID[6] Tile_X3Y0_S4END[9] Tile_X3Y0_SS4END[6] _0574_/Q
+ _0477_/Q _0476_/Q VPWR VGND sg13cmos5l_mux4_1
XFILLER_7_1143 VPWR VGND sg13cmos5l_decap_8
X_0221_ _0221_/Q Tile_X0Y0_FrameData[12] VGND VPWR Tile_X1Y0_FrameStrobe[0] latch
X_0152_ _0152_/Q Tile_X0Y0_FrameData[1] VGND VPWR Tile_X0Y0_FrameStrobe[1] latch
XFILLER_0_1928 VPWR VGND sg13cmos5l_decap_8
X_0083_ _0558_/D _0518_/Q _1095_/X VPWR VGND sg13cmos5l_nor2b_1
XFILLER_14_2306 VPWR VGND sg13cmos5l_decap_8
X_0985_ Tile_X2Y0_FrameStrobe_O[13] Tile_X2Y0_FrameStrobe[13] VPWR VGND sg13cmos5l_buf_1
XFILLER_12_2052 VPWR VGND sg13cmos5l_decap_8
XFILLER_12_1340 VPWR VGND sg13cmos5l_decap_8
XANTENNA__0810__X Tile_X4Y0_FrameData_O[14] VPWR VGND sg13cmos5l_antennanp
XFILLER_9_1964 VPWR VGND sg13cmos5l_decap_8
XFILLER_5_1806 VPWR VGND sg13cmos5l_decap_8
X_0419_ _0419_/Q Tile_X0Y0_FrameData[22] VGND VPWR Tile_X3Y0_FrameStrobe[0] latch
XFILLER_3_2286 VPWR VGND sg13cmos5l_decap_8
XFILLER_3_1574 VPWR VGND sg13cmos5l_decap_8
XFILLER_11_615 VPWR VGND sg13cmos5l_decap_8
XFILLER_10_103 VPWR VGND sg13cmos5l_fill_2
XFILLER_11_626 VPWR VGND sg13cmos5l_fill_2
XFILLER_10_147 VPWR VGND sg13cmos5l_fill_2
XFILLER_7_619 VPWR VGND sg13cmos5l_decap_8
XFILLER_13_1104 VPWR VGND sg13cmos5l_decap_8
XFILLER_12_21 VPWR VGND sg13cmos5l_decap_8
XFILLER_12_43 VPWR VGND sg13cmos5l_decap_8
XFILLER_12_32 VPWR VGND sg13cmos5l_fill_1
XANTENNA__0720__X Tile_X0Y0_FrameStrobe_O[12] VPWR VGND sg13cmos5l_antennanp
XFILLER_3_858 VPWR VGND sg13cmos5l_decap_8
XFILLER_2_357 VPWR VGND sg13cmos5l_decap_4
XFILLER_8_2164 VPWR VGND sg13cmos5l_decap_8
XFILLER_8_1441 VPWR VGND sg13cmos5l_decap_8
XFILLER_4_2017 VPWR VGND sg13cmos5l_decap_8
XFILLER_4_1338 VPWR VGND sg13cmos5l_decap_8
XFILLER_18_247 VPWR VGND sg13cmos5l_decap_8
XFILLER_18_236 VPWR VGND sg13cmos5l_fill_1
XFILLER_2_1073 VPWR VGND sg13cmos5l_decap_8
XFILLER_15_932 VPWR VGND sg13cmos5l_decap_8
XFILLER_15_1958 VPWR VGND sg13cmos5l_fill_2
X_0770_ Tile_X0Y0_NN4BEG[6] _1166_/X VPWR VGND sg13cmos5l_buf_1
XFILLER_13_2372 VPWR VGND sg13cmos5l_decap_8
XFILLER_6_652 VPWR VGND sg13cmos5l_decap_8
XFILLER_5_140 VPWR VGND sg13cmos5l_decap_8
XFILLER_6_674 VPWR VGND sg13cmos5l_decap_8
X_1253_ _1253_/X Tile_X2Y0_S2END[5] Tile_X2Y0_S4END[13] Tile_X2Y0_SS4END[2] _0586_/Q
+ _0335_/Q _0334_/Q VPWR VGND sg13cmos5l_mux4_1
XFILLER_0_2404 VPWR VGND sg13cmos5l_decap_4
X_0204_ _0204_/Q Tile_X0Y0_FrameData[29] VGND VPWR Tile_X1Y0_FrameStrobe[0] latch
XFILLER_0_1703 VPWR VGND sg13cmos5l_decap_8
X_1184_ _1184_/X Tile_X1Y0_S2MID[0] Tile_X1Y0_S4END[15] Tile_X1Y0_SS4END[0] _0588_/Q
+ _0297_/Q _0296_/Q VPWR VGND sg13cmos5l_mux4_1
XFILLER_4_1850 VPWR VGND sg13cmos5l_decap_8
X_0135_ _0135_/Q Tile_X0Y0_FrameData[18] VGND VPWR Tile_X0Y0_FrameStrobe[1] latch
XFILLER_0_1769 VPWR VGND sg13cmos5l_decap_8
XFILLER_17_291 VPWR VGND sg13cmos5l_fill_1
XANTENNA__0805__X Tile_X4Y0_FrameData_O[9] VPWR VGND sg13cmos5l_antennanp
X_0968_ Tile_X3Y0_NN4BEG[12] _1292_/X VPWR VGND sg13cmos5l_buf_1
XFILLER_14_1457 VPWR VGND sg13cmos5l_decap_8
XFILLER_9_490 VPWR VGND sg13cmos5l_decap_8
X_0899_ Tile_X4Y0_NN4BEG[15] Tile_X4Y0_SS4END[0] VPWR VGND sg13cmos5l_buf_1
XFILLER_0_839 VPWR VGND sg13cmos5l_decap_4
XFILLER_9_1750 VPWR VGND sg13cmos5l_fill_1
XFILLER_5_2348 VPWR VGND sg13cmos5l_decap_8
XFILLER_3_2083 VPWR VGND sg13cmos5l_decap_8
XFILLER_3_1371 VPWR VGND sg13cmos5l_decap_8
XFILLER_16_729 VPWR VGND sg13cmos5l_decap_8
XANTENNA__0715__X Tile_X0Y0_FrameStrobe_O[7] VPWR VGND sg13cmos5l_antennanp
XFILLER_8_939 VPWR VGND sg13cmos5l_decap_8
XFILLER_10_1844 VPWR VGND sg13cmos5l_decap_8
XFILLER_3_655 VPWR VGND sg13cmos5l_decap_8
XFILLER_2_154 VPWR VGND sg13cmos5l_decap_8
XFILLER_17_9 VPWR VGND sg13cmos5l_fill_1
XFILLER_0_35 VPWR VGND sg13cmos5l_decap_8
XFILLER_4_1168 VPWR VGND sg13cmos5l_decap_8
XFILLER_15_740 VPWR VGND sg13cmos5l_fill_2
XFILLER_15_784 VPWR VGND sg13cmos5l_fill_2
XFILLER_15_2412 VPWR VGND sg13cmos5l_fill_1
XFILLER_14_294 VPWR VGND sg13cmos5l_decap_8
X_0822_ Tile_X4Y0_FrameData_O[26] Tile_X0Y0_FrameData[26] VPWR VGND sg13cmos5l_buf_1
X_0753_ Tile_X0Y0_N4BEG[5] _1149_/X VPWR VGND sg13cmos5l_buf_1
XFILLER_7_994 VPWR VGND sg13cmos5l_decap_8
X_0684_ _0684_/L_HI VPWR VGND sg13cmos5l_tiehi
XFILLER_6_1967 VPWR VGND sg13cmos5l_decap_8
X_1236_ _1236_/X Tile_X2Y0_S2MID[4] Tile_X2Y0_S4END[3] Tile_X2Y0_SS4END[12] _0586_/Q
+ _0369_/Q _0368_/Q VPWR VGND sg13cmos5l_mux4_1
XFILLER_4_2381 VPWR VGND sg13cmos5l_decap_8
XFILLER_2_1809 VPWR VGND sg13cmos5l_decap_8
XFILLER_0_2256 VPWR VGND sg13cmos5l_decap_8
X_1167_ _1167_/X Tile_X0Y0_S2END[7] Tile_X0Y0_S4END[7] Tile_X0Y0_SS4END[8] _0598_/Q
+ _0139_/Q _0138_/Q VPWR VGND sg13cmos5l_mux4_1
X_0118_ _0118_/Q Tile_X0Y0_FrameData[3] VGND VPWR Tile_X0Y0_FrameStrobe[0] latch
XFILLER_0_1577 VPWR VGND sg13cmos5l_decap_8
X_1098_ _1098_/X Tile_X3Y0_S1END[1] Tile_X3Y0_S2MID[2] Tile_X3Y0_S2MID[5] Tile_X3Y0_S2END[2]
+ _0415_/Q _0414_/Q VPWR VGND sg13cmos5l_mux4_1
XFILLER_0_647 VPWR VGND sg13cmos5l_decap_8
XFILLER_5_2145 VPWR VGND sg13cmos5l_decap_8
XFILLER_1_2009 VPWR VGND sg13cmos5l_decap_8
XFILLER_5_1466 VPWR VGND sg13cmos5l_decap_8
XFILLER_18_86 VPWR VGND sg13cmos5l_decap_4
XFILLER_12_710 VPWR VGND sg13cmos5l_fill_2
XFILLER_11_253 VPWR VGND sg13cmos5l_decap_8
XFILLER_10_2320 VPWR VGND sg13cmos5l_decap_8
XFILLER_7_246 VPWR VGND sg13cmos5l_decap_8
XFILLER_10_1630 VPWR VGND sg13cmos5l_decap_8
XFILLER_10_2397 VPWR VGND sg13cmos5l_decap_8
XFILLER_10_1696 VPWR VGND sg13cmos5l_decap_8
XFILLER_4_986 VPWR VGND sg13cmos5l_decap_8
XFILLER_3_452 VPWR VGND sg13cmos5l_decap_8
X_1021_ Tile_X1Y0_N4BEG[9] _1193_/X VPWR VGND sg13cmos5l_buf_1
XFILLER_1_1820 VPWR VGND sg13cmos5l_decap_8
XFILLER_15_2286 VPWR VGND sg13cmos5l_decap_8
XFILLER_11_2139 VPWR VGND sg13cmos5l_decap_8
XFILLER_11_1438 VPWR VGND sg13cmos5l_decap_8
X_0805_ Tile_X4Y0_FrameData_O[9] Tile_X0Y0_FrameData[9] VPWR VGND sg13cmos5l_buf_1
X_0736_ Tile_X0Y0_N2BEG[4] Tile_X0Y0_S2MID[3] VPWR VGND sg13cmos5l_buf_1
X_0667_ _0667_/L_HI VPWR VGND sg13cmos5l_tiehi
X_0598_ _0598_/Q Tile_X0Y0_UserCLK NPU_RDATA26 _0614_/L_HI VPWR VGND sg13cmos5l_dfrbpq_1
XFILLER_6_1742 VPWR VGND sg13cmos5l_decap_8
XFILLER_6_1753 VPWR VGND sg13cmos5l_decap_8
X_1219_ _1219_/X Tile_X2Y0_S1END[3] Tile_X2Y0_S2MID[3] Tile_X2Y0_S2END[4] _0583_/Q
+ _0403_/Q _0402_/Q VPWR VGND sg13cmos5l_mux4_1
XFILLER_2_1617 VPWR VGND sg13cmos5l_decap_8
XFILLER_0_2075 VPWR VGND sg13cmos5l_decap_8
XFILLER_0_1363 VPWR VGND sg13cmos5l_decap_4
XFILLER_16_1305 VPWR VGND sg13cmos5l_decap_8
XFILLER_4_238 VPWR VGND sg13cmos5l_decap_8
XFILLER_11_1950 VPWR VGND sg13cmos5l_decap_8
XFILLER_7_2207 VPWR VGND sg13cmos5l_decap_8
XFILLER_1_923 VPWR VGND sg13cmos5l_decap_8
XFILLER_7_1506 VPWR VGND sg13cmos5l_decap_8
XFILLER_1_989 VPWR VGND sg13cmos5l_decap_8
XFILLER_5_1263 VPWR VGND sg13cmos5l_decap_8
XFILLER_17_802 VPWR VGND sg13cmos5l_fill_2
XFILLER_16_312 VPWR VGND sg13cmos5l_fill_2
XFILLER_17_879 VPWR VGND sg13cmos5l_decap_4
XANTENNA__0903__X Tile_X3Y0_FrameStrobe_O[3] VPWR VGND sg13cmos5l_antennanp
XFILLER_8_500 VPWR VGND sg13cmos5l_decap_8
XFILLER_16_1850 VPWR VGND sg13cmos5l_decap_8
XANTENNA_5 NPU_RDATA10 VPWR VGND sg13cmos5l_antennanp
XFILLER_6_56 VPWR VGND sg13cmos5l_decap_8
XFILLER_12_1758 VPWR VGND sg13cmos5l_decap_4
XFILLER_10_1460 VPWR VGND sg13cmos5l_decap_8
X_0521_ NPU_READ_BANK_SEL0 Tile_X0Y0_UserCLK _1133_/X _0631_/L_HI VPWR VGND sg13cmos5l_dfrbpq_1
XFILLER_4_750 VPWR VGND sg13cmos5l_decap_8
X_0452_ _0452_/Q Tile_X0Y0_FrameData[21] VGND VPWR Tile_X3Y0_FrameStrobe[1] latch
X_0383_ _0383_/Q Tile_X0Y0_FrameData[26] VGND VPWR Tile_X2Y0_FrameStrobe[2] latch
XFILLER_3_1915 VPWR VGND sg13cmos5l_decap_8
XFILLER_1_2373 VPWR VGND sg13cmos5l_decap_8
X_1004_ Tile_X1Y0_NN4BEG[8] _1208_/X VPWR VGND sg13cmos5l_buf_1
XFILLER_1_1672 VPWR VGND sg13cmos5l_decap_4
XFILLER_17_2304 VPWR VGND sg13cmos5l_fill_1
XFILLER_17_1669 VPWR VGND sg13cmos5l_fill_1
XANTENNA__0813__X Tile_X4Y0_FrameData_O[17] VPWR VGND sg13cmos5l_antennanp
XFILLER_15_1360 VPWR VGND sg13cmos5l_decap_8
X_0719_ Tile_X0Y0_FrameStrobe_O[11] Tile_X0Y0_FrameStrobe[11] VPWR VGND sg13cmos5l_buf_1
XFILLER_6_2295 VPWR VGND sg13cmos5l_decap_8
XFILLER_6_1583 VPWR VGND sg13cmos5l_decap_8
XFILLER_2_2137 VPWR VGND sg13cmos5l_decap_8
XFILLER_2_1414 VPWR VGND sg13cmos5l_decap_8
XFILLER_0_1171 VPWR VGND sg13cmos5l_decap_4
XFILLER_15_32 VPWR VGND sg13cmos5l_fill_1
XFILLER_15_21 VPWR VGND sg13cmos5l_decap_8
XFILLER_15_65 VPWR VGND sg13cmos5l_fill_2
XFILLER_15_87 VPWR VGND sg13cmos5l_decap_8
XANTENNA__0723__X Tile_X0Y0_FrameStrobe_O[15] VPWR VGND sg13cmos5l_antennanp
XFILLER_16_1168 VPWR VGND sg13cmos5l_decap_8
XFILLER_5_569 VPWR VGND sg13cmos5l_decap_8
XFILLER_11_1791 VPWR VGND sg13cmos5l_fill_2
XFILLER_7_2048 VPWR VGND sg13cmos5l_decap_8
XFILLER_0_285 VPWR VGND sg13cmos5l_fill_2
XFILLER_7_1369 VPWR VGND sg13cmos5l_decap_8
XFILLER_1_797 VPWR VGND sg13cmos5l_decap_8
XFILLER_5_1071 VPWR VGND sg13cmos5l_decap_8
XFILLER_17_610 VPWR VGND sg13cmos5l_fill_1
XFILLER_2_1970 VPWR VGND sg13cmos5l_decap_8
XFILLER_17_643 VPWR VGND sg13cmos5l_decap_4
XFILLER_2_1992 VPWR VGND sg13cmos5l_decap_8
XFILLER_17_687 VPWR VGND sg13cmos5l_decap_8
XFILLER_16_175 VPWR VGND sg13cmos5l_decap_8
XFILLER_18_1989 VPWR VGND sg13cmos5l_decap_8
XFILLER_12_2267 VPWR VGND sg13cmos5l_decap_8
XFILLER_8_396 VPWR VGND sg13cmos5l_decap_4
X_0504_ _0504_/Q Tile_X0Y0_FrameData[1] VGND VPWR Tile_X3Y0_FrameStrobe[2] latch
X_0435_ _0435_/Q Tile_X0Y0_FrameData[6] VGND VPWR Tile_X3Y0_FrameStrobe[0] latch
XFILLER_11_0 VPWR VGND sg13cmos5l_decap_8
X_0366_ _0366_/Q Tile_X0Y0_FrameData[11] VGND VPWR Tile_X2Y0_FrameStrobe[1] latch
XANTENNA__0808__X Tile_X4Y0_FrameData_O[12] VPWR VGND sg13cmos5l_antennanp
X_0297_ _0297_/Q Tile_X0Y0_FrameData[0] VGND VPWR Tile_X1Y0_FrameStrobe[2] latch
XFILLER_3_1745 VPWR VGND sg13cmos5l_decap_8
XFILLER_17_2134 VPWR VGND sg13cmos5l_decap_4
XFILLER_17_1400 VPWR VGND sg13cmos5l_decap_8
XFILLER_17_1499 VPWR VGND sg13cmos5l_decap_8
XFILLER_15_1190 VPWR VGND sg13cmos5l_fill_1
XFILLER_2_517 VPWR VGND sg13cmos5l_decap_8
XFILLER_8_2324 VPWR VGND sg13cmos5l_decap_8
XANTENNA__0718__X Tile_X0Y0_FrameStrobe_O[10] VPWR VGND sg13cmos5l_antennanp
XFILLER_6_1380 VPWR VGND sg13cmos5l_decap_8
XFILLER_2_1200 VPWR VGND sg13cmos5l_fill_1
XANTENNA_203 Tile_X0Y0_FrameData[23] VPWR VGND sg13cmos5l_antennanp
XANTENNA_214 Tile_X0Y0_FrameData[23] VPWR VGND sg13cmos5l_antennanp
XANTENNA_225 Tile_X0Y0_FrameData[28] VPWR VGND sg13cmos5l_antennanp
XANTENNA_236 Tile_X0Y0_FrameData[18] VPWR VGND sg13cmos5l_antennanp
XANTENNA_247 Tile_X0Y0_FrameData[18] VPWR VGND sg13cmos5l_antennanp
XFILLER_2_1288 VPWR VGND sg13cmos5l_decap_8
XFILLER_13_112 VPWR VGND sg13cmos5l_decap_8
XFILLER_6_812 VPWR VGND sg13cmos5l_decap_8
XFILLER_10_885 VPWR VGND sg13cmos5l_decap_8
XFILLER_6_823 VPWR VGND sg13cmos5l_fill_1
XFILLER_5_311 VPWR VGND sg13cmos5l_decap_8
XFILLER_13_1875 VPWR VGND sg13cmos5l_decap_4
XFILLER_3_35 VPWR VGND sg13cmos5l_decap_8
X_0220_ _0220_/Q Tile_X0Y0_FrameData[13] VGND VPWR Tile_X1Y0_FrameStrobe[0] latch
X_0151_ _0151_/Q Tile_X0Y0_FrameData[2] VGND VPWR Tile_X0Y0_FrameStrobe[1] latch
XFILLER_17_473 VPWR VGND sg13cmos5l_decap_8
XFILLER_14_1606 VPWR VGND sg13cmos5l_decap_8
XFILLER_9_650 VPWR VGND sg13cmos5l_decap_8
X_0984_ Tile_X2Y0_FrameStrobe_O[12] Tile_X2Y0_FrameStrobe[12] VPWR VGND sg13cmos5l_buf_1
XFILLER_18_1797 VPWR VGND sg13cmos5l_decap_8
XFILLER_12_2031 VPWR VGND sg13cmos5l_decap_8
XFILLER_9_672 VPWR VGND sg13cmos5l_fill_1
XFILLER_9_694 VPWR VGND sg13cmos5l_decap_8
XFILLER_8_182 VPWR VGND sg13cmos5l_decap_8
XFILLER_12_1396 VPWR VGND sg13cmos5l_decap_8
XFILLER_9_1943 VPWR VGND sg13cmos5l_decap_8
X_0418_ _0418_/Q Tile_X0Y0_FrameData[23] VGND VPWR Tile_X3Y0_FrameStrobe[0] latch
X_0349_ _0349_/Q Tile_X0Y0_FrameData[28] VGND VPWR Tile_X2Y0_FrameStrobe[1] latch
XFILLER_3_2265 VPWR VGND sg13cmos5l_decap_8
XFILLER_3_1553 VPWR VGND sg13cmos5l_decap_8
XFILLER_6_119 VPWR VGND sg13cmos5l_decap_8
XFILLER_3_826 VPWR VGND sg13cmos5l_fill_2
XFILLER_3_815 VPWR VGND sg13cmos5l_decap_8
XFILLER_2_336 VPWR VGND sg13cmos5l_decap_8
XFILLER_8_2143 VPWR VGND sg13cmos5l_decap_8
XFILLER_8_1420 VPWR VGND sg13cmos5l_decap_8
XFILLER_4_1317 VPWR VGND sg13cmos5l_decap_8
XFILLER_8_1497 VPWR VGND sg13cmos5l_decap_8
XFILLER_18_215 VPWR VGND sg13cmos5l_decap_8
XFILLER_2_1052 VPWR VGND sg13cmos5l_decap_8
XFILLER_18_1005 VPWR VGND sg13cmos5l_fill_1
XFILLER_15_988 VPWR VGND sg13cmos5l_decap_8
XFILLER_14_487 VPWR VGND sg13cmos5l_decap_8
XFILLER_15_1937 VPWR VGND sg13cmos5l_decap_8
XFILLER_13_2351 VPWR VGND sg13cmos5l_decap_8
XANTENNA__0911__X Tile_X3Y0_FrameStrobe_O[11] VPWR VGND sg13cmos5l_antennanp
XFILLER_6_631 VPWR VGND sg13cmos5l_decap_8
XFILLER_13_2395 VPWR VGND sg13cmos5l_fill_1
XFILLER_5_185 VPWR VGND sg13cmos5l_decap_8
X_1252_ _1252_/X Tile_X2Y0_S2END[4] Tile_X2Y0_S4END[12] Tile_X2Y0_SS4END[3] _0587_/Q
+ _0337_/Q _0336_/Q VPWR VGND sg13cmos5l_mux4_1
X_0203_ _0203_/Q Tile_X0Y0_FrameData[30] VGND VPWR Tile_X1Y0_FrameStrobe[0] latch
X_1183_ _1183_/X Tile_X1Y0_S1END[3] Tile_X1Y0_S2MID[7] Tile_X1Y0_S2END[0] _0595_/Q
+ _0299_/Q _0298_/Q VPWR VGND sg13cmos5l_mux4_1
X_0134_ _0134_/Q Tile_X0Y0_FrameData[19] VGND VPWR Tile_X0Y0_FrameStrobe[1] latch
XFILLER_18_1583 VPWR VGND sg13cmos5l_decap_8
XFILLER_18_1572 VPWR VGND sg13cmos5l_fill_1
XFILLER_14_2137 VPWR VGND sg13cmos5l_decap_8
X_0967_ Tile_X3Y0_NN4BEG[11] _1291_/X VPWR VGND sg13cmos5l_buf_1
XFILLER_14_1436 VPWR VGND sg13cmos5l_decap_8
XANTENNA__0821__X Tile_X4Y0_FrameData_O[25] VPWR VGND sg13cmos5l_antennanp
X_0898_ Tile_X4Y0_NN4BEG[14] Tile_X4Y0_SS4END[1] VPWR VGND sg13cmos5l_buf_1
XFILLER_0_829 VPWR VGND sg13cmos5l_decap_4
XFILLER_5_2327 VPWR VGND sg13cmos5l_decap_8
XFILLER_5_1648 VPWR VGND sg13cmos5l_decap_8
XFILLER_3_2062 VPWR VGND sg13cmos5l_decap_8
XFILLER_3_1350 VPWR VGND sg13cmos5l_decap_8
XFILLER_12_925 VPWR VGND sg13cmos5l_fill_2
XFILLER_8_918 VPWR VGND sg13cmos5l_decap_8
XFILLER_11_446 VPWR VGND sg13cmos5l_decap_8
XANTENNA__0731__X Tile_X0Y0_N1BEG[3] VPWR VGND sg13cmos5l_antennanp
XFILLER_10_1823 VPWR VGND sg13cmos5l_decap_8
XFILLER_3_634 VPWR VGND sg13cmos5l_decap_8
XFILLER_2_133 VPWR VGND sg13cmos5l_decap_8
XFILLER_8_1283 VPWR VGND sg13cmos5l_decap_4
XFILLER_0_14 VPWR VGND sg13cmos5l_decap_8
XFILLER_4_1147 VPWR VGND sg13cmos5l_decap_8
XANTENNA__0906__X Tile_X3Y0_FrameStrobe_O[6] VPWR VGND sg13cmos5l_antennanp
X_0821_ Tile_X4Y0_FrameData_O[25] Tile_X0Y0_FrameData[25] VPWR VGND sg13cmos5l_buf_1
X_0752_ Tile_X0Y0_N4BEG[4] _1148_/X VPWR VGND sg13cmos5l_buf_1
XFILLER_13_2192 VPWR VGND sg13cmos5l_fill_1
XFILLER_13_2181 VPWR VGND sg13cmos5l_decap_8
XFILLER_7_973 VPWR VGND sg13cmos5l_decap_8
X_0683_ _0683_/L_HI VPWR VGND sg13cmos5l_tiehi
XFILLER_6_1946 VPWR VGND sg13cmos5l_decap_8
X_1235_ _1235_/X Tile_X2Y0_S2MID[3] Tile_X2Y0_S4END[4] Tile_X2Y0_SS4END[11] _0585_/Q
+ _0371_/Q _0370_/Q VPWR VGND sg13cmos5l_mux4_1
XFILLER_4_2360 VPWR VGND sg13cmos5l_decap_8
XFILLER_0_2235 VPWR VGND sg13cmos5l_fill_2
X_1166_ _1166_/X Tile_X0Y0_S2END[6] Tile_X0Y0_S4END[6] Tile_X0Y0_SS4END[9] _0599_/Q
+ _0141_/Q _0140_/Q VPWR VGND sg13cmos5l_mux4_1
XANTENNA__0816__X Tile_X4Y0_FrameData_O[20] VPWR VGND sg13cmos5l_antennanp
X_0117_ _0117_/Q Tile_X0Y0_FrameData[4] VGND VPWR Tile_X0Y0_FrameStrobe[0] latch
XFILLER_4_1692 VPWR VGND sg13cmos5l_decap_8
X_1097_ _1097_/X Tile_X3Y0_S1END[0] Tile_X3Y0_S2MID[3] Tile_X3Y0_S2MID[4] Tile_X3Y0_S2END[3]
+ _0417_/Q _0416_/Q VPWR VGND sg13cmos5l_mux4_1
XFILLER_18_2070 VPWR VGND sg13cmos5l_decap_4
XFILLER_18_2092 VPWR VGND sg13cmos5l_decap_8
XFILLER_18_1380 VPWR VGND sg13cmos5l_fill_2
XFILLER_14_1266 VPWR VGND sg13cmos5l_fill_2
XFILLER_0_637 VPWR VGND sg13cmos5l_decap_4
XFILLER_5_2124 VPWR VGND sg13cmos5l_decap_8
XFILLER_5_1445 VPWR VGND sg13cmos5l_decap_8
XFILLER_1_1309 VPWR VGND sg13cmos5l_decap_8
XANTENNA__0726__X Tile_X0Y0_FrameStrobe_O[18] VPWR VGND sg13cmos5l_antennanp
XFILLER_12_744 VPWR VGND sg13cmos5l_fill_1
XFILLER_8_737 VPWR VGND sg13cmos5l_decap_4
XFILLER_10_2376 VPWR VGND sg13cmos5l_decap_8
XFILLER_4_965 VPWR VGND sg13cmos5l_decap_8
XFILLER_3_431 VPWR VGND sg13cmos5l_decap_8
XFILLER_15_7 VPWR VGND sg13cmos5l_decap_8
X_1020_ Tile_X1Y0_N4BEG[8] _1192_/X VPWR VGND sg13cmos5l_buf_1
XFILLER_1_1876 VPWR VGND sg13cmos5l_decap_8
XFILLER_15_593 VPWR VGND sg13cmos5l_fill_2
XFILLER_15_2265 VPWR VGND sg13cmos5l_decap_8
X_0804_ Tile_X4Y0_FrameData_O[8] Tile_X0Y0_FrameData[8] VPWR VGND sg13cmos5l_buf_1
XFILLER_11_2118 VPWR VGND sg13cmos5l_decap_8
XFILLER_11_1417 VPWR VGND sg13cmos5l_decap_8
XFILLER_7_770 VPWR VGND sg13cmos5l_decap_8
XFILLER_15_1586 VPWR VGND sg13cmos5l_fill_1
X_0735_ Tile_X0Y0_N2BEG[3] Tile_X0Y0_S2MID[4] VPWR VGND sg13cmos5l_buf_1
X_0666_ _0666_/L_HI VPWR VGND sg13cmos5l_tiehi
XFILLER_6_2400 VPWR VGND sg13cmos5l_decap_8
X_0597_ _0597_/Q Tile_X0Y0_UserCLK NPU_RDATA25 _0613_/L_HI VPWR VGND sg13cmos5l_dfrbpq_1
XFILLER_0_2010 VPWR VGND sg13cmos5l_decap_8
X_1218_ _1218_/X Tile_X2Y0_S1END[2] Tile_X2Y0_S2MID[2] Tile_X2Y0_S2END[5] _0582_/Q
+ _0405_/Q _0404_/Q VPWR VGND sg13cmos5l_mux4_1
XFILLER_0_1320 VPWR VGND sg13cmos5l_fill_1
XFILLER_0_2054 VPWR VGND sg13cmos5l_decap_8
X_1149_ _1149_/X Tile_X0Y0_S2MID[5] Tile_X0Y0_S4END[10] Tile_X0Y0_SS4END[5] _0599_/Q
+ _0175_/Q _0174_/Q VPWR VGND sg13cmos5l_mux4_1
XFILLER_5_707 VPWR VGND sg13cmos5l_decap_8
XFILLER_4_217 VPWR VGND sg13cmos5l_decap_8
XFILLER_1_968 VPWR VGND sg13cmos5l_decap_8
XFILLER_9_2090 VPWR VGND sg13cmos5l_decap_8
XFILLER_16_324 VPWR VGND sg13cmos5l_decap_8
XFILLER_12_2416 VPWR VGND sg13cmos5l_fill_2
XFILLER_12_585 VPWR VGND sg13cmos5l_fill_2
XFILLER_8_556 VPWR VGND sg13cmos5l_decap_8
XFILLER_16_1884 VPWR VGND sg13cmos5l_decap_8
XANTENNA_6 NPU_RDATA10 VPWR VGND sg13cmos5l_antennanp
XFILLER_6_35 VPWR VGND sg13cmos5l_decap_8
XFILLER_10_2195 VPWR VGND sg13cmos5l_fill_2
X_0520_ _0520_/Q Tile_X0Y0_FrameData[25] VGND VPWR Tile_X4Y0_FrameStrobe[0] latch
X_0451_ _0451_/Q Tile_X0Y0_FrameData[22] VGND VPWR Tile_X3Y0_FrameStrobe[1] latch
XFILLER_3_294 VPWR VGND sg13cmos5l_decap_8
X_0382_ _0382_/Q Tile_X0Y0_FrameData[27] VGND VPWR Tile_X2Y0_FrameStrobe[2] latch
XFILLER_6_1039 VPWR VGND sg13cmos5l_decap_8
X_1003_ Tile_X1Y0_NN4BEG[7] _1207_/X VPWR VGND sg13cmos5l_buf_1
XFILLER_1_2352 VPWR VGND sg13cmos5l_decap_8
XFILLER_1_1640 VPWR VGND sg13cmos5l_decap_8
XFILLER_17_1626 VPWR VGND sg13cmos5l_fill_1
XFILLER_17_1648 VPWR VGND sg13cmos5l_decap_8
XFILLER_15_2084 VPWR VGND sg13cmos5l_decap_8
X_0718_ Tile_X0Y0_FrameStrobe_O[10] Tile_X0Y0_FrameStrobe[10] VPWR VGND sg13cmos5l_buf_1
X_0649_ _0649_/L_HI VPWR VGND sg13cmos5l_tiehi
XFILLER_8_1805 VPWR VGND sg13cmos5l_decap_4
XFILLER_6_2274 VPWR VGND sg13cmos5l_decap_8
XFILLER_2_2116 VPWR VGND sg13cmos5l_decap_8
XFILLER_6_1562 VPWR VGND sg13cmos5l_decap_8
XFILLER_13_305 VPWR VGND sg13cmos5l_decap_4
XFILLER_16_1136 VPWR VGND sg13cmos5l_decap_8
XFILLER_5_548 VPWR VGND sg13cmos5l_decap_8
XFILLER_7_2027 VPWR VGND sg13cmos5l_decap_8
XFILLER_0_264 VPWR VGND sg13cmos5l_decap_8
XFILLER_7_1315 VPWR VGND sg13cmos5l_fill_2
XFILLER_1_776 VPWR VGND sg13cmos5l_decap_8
XFILLER_0_275 VPWR VGND sg13cmos5l_fill_2
XFILLER_0_297 VPWR VGND sg13cmos5l_decap_4
XFILLER_7_1348 VPWR VGND sg13cmos5l_decap_8
XFILLER_5_1050 VPWR VGND sg13cmos5l_decap_8
XANTENNA__0914__X Tile_X3Y0_FrameStrobe_O[14] VPWR VGND sg13cmos5l_antennanp
XFILLER_18_1968 VPWR VGND sg13cmos5l_decap_4
XFILLER_18_1946 VPWR VGND sg13cmos5l_decap_4
XFILLER_16_2393 VPWR VGND sg13cmos5l_decap_4
XFILLER_8_364 VPWR VGND sg13cmos5l_decap_4
XFILLER_12_2246 VPWR VGND sg13cmos5l_decap_8
XFILLER_12_1501 VPWR VGND sg13cmos5l_decap_8
XFILLER_12_1523 VPWR VGND sg13cmos5l_decap_4
X_0503_ _0503_/Q Tile_X0Y0_FrameData[2] VGND VPWR Tile_X3Y0_FrameStrobe[2] latch
X_0434_ _0434_/Q Tile_X0Y0_FrameData[7] VGND VPWR Tile_X3Y0_FrameStrobe[0] latch
X_0365_ _0365_/Q Tile_X0Y0_FrameData[12] VGND VPWR Tile_X2Y0_FrameStrobe[1] latch
XFILLER_7_1882 VPWR VGND sg13cmos5l_decap_8
XFILLER_3_1713 VPWR VGND sg13cmos5l_decap_8
X_0296_ _0296_/Q Tile_X0Y0_FrameData[1] VGND VPWR Tile_X1Y0_FrameStrobe[2] latch
XFILLER_1_2160 VPWR VGND sg13cmos5l_fill_1
XANTENNA__0824__X Tile_X4Y0_FrameData_O[28] VPWR VGND sg13cmos5l_antennanp
XFILLER_17_1467 VPWR VGND sg13cmos5l_fill_2
XFILLER_17_1456 VPWR VGND sg13cmos5l_decap_8
XFILLER_8_2303 VPWR VGND sg13cmos5l_decap_8
XFILLER_8_1624 VPWR VGND sg13cmos5l_decap_8
XFILLER_6_2093 VPWR VGND sg13cmos5l_decap_8
XFILLER_2_1212 VPWR VGND sg13cmos5l_decap_8
XANTENNA_204 Tile_X0Y0_FrameData[23] VPWR VGND sg13cmos5l_antennanp
XANTENNA_215 Tile_X0Y0_FrameData[23] VPWR VGND sg13cmos5l_antennanp
XANTENNA_226 Tile_X0Y0_FrameData[28] VPWR VGND sg13cmos5l_antennanp
XANTENNA_237 Tile_X0Y0_FrameData[18] VPWR VGND sg13cmos5l_antennanp
XANTENNA_248 Tile_X0Y0_FrameData[18] VPWR VGND sg13cmos5l_antennanp
XFILLER_2_1267 VPWR VGND sg13cmos5l_decap_8
XFILLER_14_603 VPWR VGND sg13cmos5l_fill_1
XFILLER_18_1209 VPWR VGND sg13cmos5l_fill_2
XANTENNA__0734__X Tile_X0Y0_N2BEG[2] VPWR VGND sg13cmos5l_antennanp
XFILLER_13_135 VPWR VGND sg13cmos5l_decap_8
XFILLER_10_842 VPWR VGND sg13cmos5l_fill_1
XFILLER_10_897 VPWR VGND sg13cmos5l_decap_4
XFILLER_13_1854 VPWR VGND sg13cmos5l_decap_8
XFILLER_6_857 VPWR VGND sg13cmos5l_fill_1
XFILLER_13_1898 VPWR VGND sg13cmos5l_decap_8
XFILLER_5_389 VPWR VGND sg13cmos5l_fill_2
XFILLER_3_14 VPWR VGND sg13cmos5l_decap_8
XFILLER_7_1123 VPWR VGND sg13cmos5l_decap_4
XFILLER_1_595 VPWR VGND sg13cmos5l_decap_8
XANTENNA__0909__X Tile_X3Y0_FrameStrobe_O[9] VPWR VGND sg13cmos5l_antennanp
X_0150_ _0150_/Q Tile_X0Y0_FrameData[3] VGND VPWR Tile_X0Y0_FrameStrobe[1] latch
XFILLER_0_1908 VPWR VGND sg13cmos5l_decap_8
XFILLER_18_964 VPWR VGND sg13cmos5l_fill_2
XFILLER_17_452 VPWR VGND sg13cmos5l_decap_8
XFILLER_18_1732 VPWR VGND sg13cmos5l_decap_4
X_0983_ Tile_X2Y0_FrameStrobe_O[11] Tile_X2Y0_FrameStrobe[11] VPWR VGND sg13cmos5l_buf_1
XFILLER_12_2010 VPWR VGND sg13cmos5l_decap_8
XFILLER_8_161 VPWR VGND sg13cmos5l_decap_8
XFILLER_12_2087 VPWR VGND sg13cmos5l_decap_8
XFILLER_12_1375 VPWR VGND sg13cmos5l_decap_8
XFILLER_5_890 VPWR VGND sg13cmos5l_fill_2
XFILLER_9_1922 VPWR VGND sg13cmos5l_decap_8
XANTENNA__0819__X Tile_X4Y0_FrameData_O[23] VPWR VGND sg13cmos5l_antennanp
XFILLER_9_1999 VPWR VGND sg13cmos5l_decap_8
X_0417_ _0417_/Q Tile_X0Y0_FrameData[24] VGND VPWR Tile_X3Y0_FrameStrobe[0] latch
X_0348_ _0348_/Q Tile_X0Y0_FrameData[29] VGND VPWR Tile_X2Y0_FrameStrobe[1] latch
XFILLER_3_2244 VPWR VGND sg13cmos5l_decap_8
XFILLER_3_1532 VPWR VGND sg13cmos5l_decap_8
X_0279_ _0279_/Q Tile_X0Y0_FrameData[18] VGND VPWR Tile_X1Y0_FrameStrobe[2] latch
XFILLER_2_315 VPWR VGND sg13cmos5l_decap_8
XFILLER_8_2122 VPWR VGND sg13cmos5l_decap_8
XANTENNA__0729__X Tile_X0Y0_N1BEG[1] VPWR VGND sg13cmos5l_antennanp
XFILLER_8_1476 VPWR VGND sg13cmos5l_decap_8
XFILLER_2_1031 VPWR VGND sg13cmos5l_decap_8
XFILLER_15_967 VPWR VGND sg13cmos5l_decap_8
XFILLER_14_466 VPWR VGND sg13cmos5l_decap_8
XFILLER_15_1916 VPWR VGND sg13cmos5l_decap_8
XFILLER_13_2330 VPWR VGND sg13cmos5l_decap_8
XFILLER_10_661 VPWR VGND sg13cmos5l_fill_1
XFILLER_10_672 VPWR VGND sg13cmos5l_decap_8
XFILLER_6_610 VPWR VGND sg13cmos5l_decap_8
XFILLER_5_164 VPWR VGND sg13cmos5l_decap_8
XFILLER_9_1207 VPWR VGND sg13cmos5l_decap_4
XFILLER_1_370 VPWR VGND sg13cmos5l_decap_4
X_1251_ _1251_/X Tile_X2Y0_S2END[3] Tile_X2Y0_S4END[11] Tile_X2Y0_SS4END[4] _0584_/Q
+ _0339_/Q _0338_/Q VPWR VGND sg13cmos5l_mux4_1
X_0202_ _0202_/Q Tile_X0Y0_FrameData[31] VGND VPWR Tile_X0Y0_FrameStrobe[0] latch
X_1182_ _1182_/X Tile_X1Y0_S1END[2] Tile_X1Y0_S2MID[6] Tile_X1Y0_S2END[1] _0594_/Q
+ _0301_/Q _0300_/Q VPWR VGND sg13cmos5l_mux4_1
XFILLER_0_2417 VPWR VGND sg13cmos5l_fill_1
X_0133_ _0133_/Q Tile_X0Y0_FrameData[20] VGND VPWR Tile_X0Y0_FrameStrobe[1] latch
XFILLER_0_1716 VPWR VGND sg13cmos5l_decap_8
XFILLER_4_1885 VPWR VGND sg13cmos5l_decap_8
XFILLER_18_783 VPWR VGND sg13cmos5l_decap_8
XFILLER_18_1551 VPWR VGND sg13cmos5l_fill_1
XFILLER_14_2116 VPWR VGND sg13cmos5l_decap_8
XFILLER_18_1562 VPWR VGND sg13cmos5l_fill_1
XFILLER_14_1415 VPWR VGND sg13cmos5l_decap_8
X_0966_ Tile_X3Y0_NN4BEG[10] _1290_/X VPWR VGND sg13cmos5l_buf_1
X_0897_ Tile_X4Y0_NN4BEG[13] Tile_X4Y0_SS4END[2] VPWR VGND sg13cmos5l_buf_1
XFILLER_9_1741 VPWR VGND sg13cmos5l_fill_2
XFILLER_5_2306 VPWR VGND sg13cmos5l_decap_8
XFILLER_5_1627 VPWR VGND sg13cmos5l_decap_8
XFILLER_3_2041 VPWR VGND sg13cmos5l_decap_8
XFILLER_12_959 VPWR VGND sg13cmos5l_decap_8
XFILLER_11_425 VPWR VGND sg13cmos5l_decap_8
XFILLER_7_429 VPWR VGND sg13cmos5l_decap_8
XFILLER_10_1813 VPWR VGND sg13cmos5l_fill_2
XFILLER_10_1879 VPWR VGND sg13cmos5l_decap_8
XFILLER_3_613 VPWR VGND sg13cmos5l_decap_8
XFILLER_2_112 VPWR VGND sg13cmos5l_decap_8
XFILLER_2_189 VPWR VGND sg13cmos5l_decap_8
XFILLER_4_1126 VPWR VGND sg13cmos5l_decap_8
XFILLER_9_35 VPWR VGND sg13cmos5l_decap_8
XFILLER_15_797 VPWR VGND sg13cmos5l_fill_2
XFILLER_15_786 VPWR VGND sg13cmos5l_fill_1
XFILLER_9_57 VPWR VGND sg13cmos5l_decap_8
XANTENNA__0922__X Tile_X3Y0_N1BEG[2] VPWR VGND sg13cmos5l_antennanp
X_0820_ Tile_X4Y0_FrameData_O[24] Tile_X0Y0_FrameData[24] VPWR VGND sg13cmos5l_buf_1
XFILLER_10_480 VPWR VGND sg13cmos5l_decap_8
X_0751_ Tile_X0Y0_N4BEG[3] _1147_/X VPWR VGND sg13cmos5l_buf_1
XFILLER_7_952 VPWR VGND sg13cmos5l_decap_8
XFILLER_11_992 VPWR VGND sg13cmos5l_decap_8
X_0682_ _0682_/L_HI VPWR VGND sg13cmos5l_tiehi
XFILLER_6_484 VPWR VGND sg13cmos5l_decap_8
XFILLER_9_1015 VPWR VGND sg13cmos5l_decap_8
XFILLER_9_1026 VPWR VGND sg13cmos5l_fill_1
XFILLER_9_1048 VPWR VGND sg13cmos5l_decap_8
X_1234_ _1234_/X Tile_X2Y0_S2MID[2] Tile_X2Y0_S4END[5] Tile_X2Y0_SS4END[10] _0584_/Q
+ _0373_/Q _0372_/Q VPWR VGND sg13cmos5l_mux4_1
XFILLER_6_1925 VPWR VGND sg13cmos5l_decap_8
X_1165_ _1165_/X Tile_X0Y0_S2END[5] Tile_X0Y0_S4END[5] Tile_X0Y0_SS4END[10] _0598_/Q
+ _0143_/Q _0142_/Q VPWR VGND sg13cmos5l_mux4_1
XFILLER_4_1660 VPWR VGND sg13cmos5l_decap_8
XFILLER_0_1524 VPWR VGND sg13cmos5l_decap_8
X_0116_ _0116_/Q Tile_X0Y0_FrameData[5] VGND VPWR Tile_X0Y0_FrameStrobe[0] latch
X_1096_ _1096_/X Tile_X3Y0_S1END[3] Tile_X3Y0_S2MID[3] Tile_X3Y0_S2MID[4] Tile_X3Y0_S2END[4]
+ _0419_/Q _0418_/Q VPWR VGND sg13cmos5l_mux4_1
XANTENNA__0832__X Tile_X4Y0_FrameStrobe_O[4] VPWR VGND sg13cmos5l_antennanp
XFILLER_14_1245 VPWR VGND sg13cmos5l_fill_2
X_0949_ Tile_X3Y0_N4BEG[9] _1273_/X VPWR VGND sg13cmos5l_buf_1
XFILLER_9_2283 VPWR VGND sg13cmos5l_decap_8
XFILLER_5_2103 VPWR VGND sg13cmos5l_decap_8
XFILLER_9_1593 VPWR VGND sg13cmos5l_decap_8
XFILLER_5_1424 VPWR VGND sg13cmos5l_decap_8
XFILLER_16_517 VPWR VGND sg13cmos5l_decap_8
XFILLER_15_1009 VPWR VGND sg13cmos5l_decap_8
XANTENNA__0742__X Tile_X0Y0_N2BEGb[2] VPWR VGND sg13cmos5l_antennanp
XFILLER_12_1919 VPWR VGND sg13cmos5l_decap_8
XFILLER_11_288 VPWR VGND sg13cmos5l_decap_8
XFILLER_10_1610 VPWR VGND sg13cmos5l_decap_8
XFILLER_10_2355 VPWR VGND sg13cmos5l_decap_8
XFILLER_10_1621 VPWR VGND sg13cmos5l_fill_2
XFILLER_4_944 VPWR VGND sg13cmos5l_decap_8
XFILLER_3_410 VPWR VGND sg13cmos5l_decap_8
XFILLER_3_487 VPWR VGND sg13cmos5l_decap_8
XFILLER_1_0 VPWR VGND sg13cmos5l_decap_8
XFILLER_8_1092 VPWR VGND sg13cmos5l_decap_8
XANTENNA__0917__X Tile_X3Y0_FrameStrobe_O[17] VPWR VGND sg13cmos5l_antennanp
XFILLER_5_1991 VPWR VGND sg13cmos5l_decap_8
XFILLER_1_1888 VPWR VGND sg13cmos5l_fill_2
XFILLER_1_1855 VPWR VGND sg13cmos5l_decap_8
XFILLER_15_561 VPWR VGND sg13cmos5l_decap_8
XFILLER_15_583 VPWR VGND sg13cmos5l_fill_2
XFILLER_15_2244 VPWR VGND sg13cmos5l_decap_8
X_0803_ Tile_X4Y0_FrameData_O[7] Tile_X0Y0_FrameData[7] VPWR VGND sg13cmos5l_buf_1
X_0734_ Tile_X0Y0_N2BEG[2] Tile_X0Y0_S2MID[5] VPWR VGND sg13cmos5l_buf_1
X_0665_ _0665_/L_HI VPWR VGND sg13cmos5l_tiehi
X_0596_ _0596_/Q Tile_X0Y0_UserCLK NPU_RDATA24 _0612_/L_HI VPWR VGND sg13cmos5l_dfrbpq_1
XFILLER_2_2309 VPWR VGND sg13cmos5l_decap_8
XANTENNA__0827__X Tile_X4Y0_FrameData_O[31] VPWR VGND sg13cmos5l_antennanp
X_1217_ _1217_/X Tile_X2Y0_S1END[1] Tile_X2Y0_S2MID[1] Tile_X2Y0_S2END[6] _0581_/Q
+ _0407_/Q _0406_/Q VPWR VGND sg13cmos5l_mux4_1
XFILLER_0_2033 VPWR VGND sg13cmos5l_decap_8
XFILLER_1_91 VPWR VGND sg13cmos5l_decap_8
XFILLER_0_1332 VPWR VGND sg13cmos5l_decap_8
XFILLER_0_1343 VPWR VGND sg13cmos5l_fill_2
X_1148_ _1148_/X Tile_X0Y0_S2MID[4] Tile_X0Y0_S4END[11] Tile_X0Y0_SS4END[4] _0598_/Q
+ _0177_/Q _0176_/Q VPWR VGND sg13cmos5l_mux4_1
XFILLER_0_1387 VPWR VGND sg13cmos5l_decap_8
X_1079_ Tile_X2Y0_N2BEGb[3] _1219_/X VPWR VGND sg13cmos5l_buf_1
XFILLER_16_2008 VPWR VGND sg13cmos5l_fill_1
XFILLER_13_509 VPWR VGND sg13cmos5l_decap_8
XFILLER_0_1398 VPWR VGND sg13cmos5l_decap_8
XFILLER_14_1042 VPWR VGND sg13cmos5l_decap_8
XFILLER_5_719 VPWR VGND sg13cmos5l_decap_8
XFILLER_14_1075 VPWR VGND sg13cmos5l_fill_2
XFILLER_11_1985 VPWR VGND sg13cmos5l_decap_8
XFILLER_0_435 VPWR VGND sg13cmos5l_fill_2
XFILLER_9_1390 VPWR VGND sg13cmos5l_decap_8
XANTENNA__0737__X Tile_X0Y0_N2BEG[5] VPWR VGND sg13cmos5l_antennanp
XFILLER_5_1298 VPWR VGND sg13cmos5l_decap_8
XFILLER_1_1129 VPWR VGND sg13cmos5l_decap_8
XFILLER_16_347 VPWR VGND sg13cmos5l_fill_1
XFILLER_8_535 VPWR VGND sg13cmos5l_decap_8
XFILLER_16_1863 VPWR VGND sg13cmos5l_decap_8
XFILLER_12_1705 VPWR VGND sg13cmos5l_fill_1
XFILLER_6_14 VPWR VGND sg13cmos5l_decap_8
XANTENNA_7 NPU_RDATA12 VPWR VGND sg13cmos5l_antennanp
XFILLER_10_1495 VPWR VGND sg13cmos5l_decap_8
X_0450_ _0450_/Q Tile_X0Y0_FrameData[23] VGND VPWR Tile_X3Y0_FrameStrobe[1] latch
XFILLER_4_785 VPWR VGND sg13cmos5l_decap_8
XFILLER_3_273 VPWR VGND sg13cmos5l_decap_8
X_0381_ _0381_/Q Tile_X0Y0_FrameData[28] VGND VPWR Tile_X2Y0_FrameStrobe[2] latch
XFILLER_6_1018 VPWR VGND sg13cmos5l_decap_8
XFILLER_0_980 VPWR VGND sg13cmos5l_decap_8
XFILLER_1_2331 VPWR VGND sg13cmos5l_decap_8
X_1002_ Tile_X1Y0_NN4BEG[6] _1206_/X VPWR VGND sg13cmos5l_buf_1
XFILLER_15_2052 VPWR VGND sg13cmos5l_decap_8
XFILLER_15_2063 VPWR VGND sg13cmos5l_fill_2
XFILLER_11_1237 VPWR VGND sg13cmos5l_decap_8
X_0717_ Tile_X0Y0_FrameStrobe_O[9] Tile_X0Y0_FrameStrobe[9] VPWR VGND sg13cmos5l_buf_1
X_0648_ _0648_/L_HI VPWR VGND sg13cmos5l_tiehi
X_0579_ _0579_/Q Tile_X0Y0_UserCLK NPU_RDATA7 _0642_/L_HI VPWR VGND sg13cmos5l_dfrbpq_1
XFILLER_6_2253 VPWR VGND sg13cmos5l_decap_8
XFILLER_6_1541 VPWR VGND sg13cmos5l_decap_8
XFILLER_2_1449 VPWR VGND sg13cmos5l_decap_8
XFILLER_0_1140 VPWR VGND sg13cmos5l_decap_8
XFILLER_0_1151 VPWR VGND sg13cmos5l_fill_2
XFILLER_13_339 VPWR VGND sg13cmos5l_decap_4
XFILLER_15_67 VPWR VGND sg13cmos5l_fill_1
XFILLER_5_527 VPWR VGND sg13cmos5l_decap_8
XFILLER_1_722 VPWR VGND sg13cmos5l_fill_1
XFILLER_7_1327 VPWR VGND sg13cmos5l_decap_8
XFILLER_1_755 VPWR VGND sg13cmos5l_decap_8
XFILLER_16_122 VPWR VGND sg13cmos5l_decap_4
XFILLER_16_133 VPWR VGND sg13cmos5l_decap_8
XFILLER_9_822 VPWR VGND sg13cmos5l_fill_2
XFILLER_8_321 VPWR VGND sg13cmos5l_fill_1
XFILLER_16_2372 VPWR VGND sg13cmos5l_decap_8
XFILLER_12_2225 VPWR VGND sg13cmos5l_decap_8
XANTENNA__0930__X Tile_X3Y0_N2BEG[6] VPWR VGND sg13cmos5l_antennanp
XFILLER_12_1546 VPWR VGND sg13cmos5l_decap_8
XFILLER_12_1568 VPWR VGND sg13cmos5l_decap_8
X_0502_ _0502_/Q Tile_X0Y0_FrameData[3] VGND VPWR Tile_X3Y0_FrameStrobe[2] latch
XFILLER_4_582 VPWR VGND sg13cmos5l_decap_8
X_0433_ _0433_/Q Tile_X0Y0_FrameData[8] VGND VPWR Tile_X3Y0_FrameStrobe[0] latch
X_0364_ _0364_/Q Tile_X0Y0_FrameData[13] VGND VPWR Tile_X2Y0_FrameStrobe[1] latch
X_0295_ _0295_/Q Tile_X0Y0_FrameData[2] VGND VPWR Tile_X1Y0_FrameStrobe[2] latch
XFILLER_1_1493 VPWR VGND sg13cmos5l_decap_8
XFILLER_17_2114 VPWR VGND sg13cmos5l_decap_4
XANTENNA__1001__X Tile_X1Y0_NN4BEG[5] VPWR VGND sg13cmos5l_antennanp
XFILLER_17_1435 VPWR VGND sg13cmos5l_decap_8
XFILLER_17_1479 VPWR VGND sg13cmos5l_decap_4
XANTENNA__0840__X Tile_X4Y0_FrameStrobe_O[12] VPWR VGND sg13cmos5l_antennanp
XFILLER_11_1056 VPWR VGND sg13cmos5l_decap_8
XFILLER_8_2359 VPWR VGND sg13cmos5l_decap_8
XFILLER_8_1636 VPWR VGND sg13cmos5l_decap_4
XFILLER_6_2072 VPWR VGND sg13cmos5l_decap_8
XANTENNA_205 Tile_X0Y0_FrameData[23] VPWR VGND sg13cmos5l_antennanp
XANTENNA_216 Tile_X0Y0_FrameData[23] VPWR VGND sg13cmos5l_antennanp
XANTENNA_227 Tile_X0Y0_FrameData[28] VPWR VGND sg13cmos5l_antennanp
XANTENNA_238 Tile_X0Y0_FrameData[18] VPWR VGND sg13cmos5l_antennanp
XANTENNA_249 Tile_X0Y0_FrameData[18] VPWR VGND sg13cmos5l_antennanp
XANTENNA__0750__X Tile_X0Y0_N4BEG[2] VPWR VGND sg13cmos5l_antennanp
XFILLER_13_1833 VPWR VGND sg13cmos5l_decap_8
XFILLER_11_2291 VPWR VGND sg13cmos5l_decap_8
XFILLER_11_1590 VPWR VGND sg13cmos5l_fill_1
XFILLER_7_1102 VPWR VGND sg13cmos5l_decap_8
XFILLER_1_574 VPWR VGND sg13cmos5l_decap_8
XFILLER_7_1157 VPWR VGND sg13cmos5l_decap_8
XFILLER_18_943 VPWR VGND sg13cmos5l_decap_8
XANTENNA__0925__X Tile_X3Y0_N2BEG[1] VPWR VGND sg13cmos5l_antennanp
XFILLER_17_497 VPWR VGND sg13cmos5l_fill_1
XFILLER_18_1711 VPWR VGND sg13cmos5l_decap_8
X_0982_ Tile_X2Y0_FrameStrobe_O[10] Tile_X2Y0_FrameStrobe[10] VPWR VGND sg13cmos5l_buf_1
XFILLER_18_1766 VPWR VGND sg13cmos5l_decap_8
XFILLER_9_641 VPWR VGND sg13cmos5l_decap_4
XFILLER_16_2191 VPWR VGND sg13cmos5l_decap_8
XFILLER_8_140 VPWR VGND sg13cmos5l_decap_8
XFILLER_12_2066 VPWR VGND sg13cmos5l_decap_8
XFILLER_12_191 VPWR VGND sg13cmos5l_decap_8
XFILLER_12_1310 VPWR VGND sg13cmos5l_fill_2
XFILLER_12_1354 VPWR VGND sg13cmos5l_decap_8
XFILLER_9_1901 VPWR VGND sg13cmos5l_decap_8
XFILLER_9_1978 VPWR VGND sg13cmos5l_decap_8
X_0416_ _0416_/Q Tile_X0Y0_FrameData[25] VGND VPWR Tile_X3Y0_FrameStrobe[0] latch
XFILLER_3_2223 VPWR VGND sg13cmos5l_decap_8
X_0347_ _0347_/Q Tile_X0Y0_FrameData[30] VGND VPWR Tile_X2Y0_FrameStrobe[1] latch
XFILLER_3_1511 VPWR VGND sg13cmos5l_decap_8
XANTENNA__0835__X Tile_X4Y0_FrameStrobe_O[7] VPWR VGND sg13cmos5l_antennanp
X_0278_ _0278_/Q Tile_X0Y0_FrameData[19] VGND VPWR Tile_X1Y0_FrameStrobe[2] latch
XFILLER_3_1588 VPWR VGND sg13cmos5l_decap_8
XFILLER_17_1221 VPWR VGND sg13cmos5l_decap_4
XFILLER_11_607 VPWR VGND sg13cmos5l_fill_1
XFILLER_13_1118 VPWR VGND sg13cmos5l_fill_2
XFILLER_12_68 VPWR VGND sg13cmos5l_decap_8
XFILLER_8_2101 VPWR VGND sg13cmos5l_decap_8
XFILLER_5_7 VPWR VGND sg13cmos5l_decap_8
XFILLER_8_2178 VPWR VGND sg13cmos5l_decap_8
XFILLER_8_1455 VPWR VGND sg13cmos5l_decap_8
XFILLER_6_1190 VPWR VGND sg13cmos5l_fill_2
XFILLER_2_1010 VPWR VGND sg13cmos5l_decap_8
XANTENNA__0745__X Tile_X0Y0_N2BEGb[5] VPWR VGND sg13cmos5l_antennanp
XFILLER_2_1087 VPWR VGND sg13cmos5l_decap_8
XFILLER_15_946 VPWR VGND sg13cmos5l_decap_8
XFILLER_18_1018 VPWR VGND sg13cmos5l_decap_8
XFILLER_14_445 VPWR VGND sg13cmos5l_decap_8
XFILLER_13_2386 VPWR VGND sg13cmos5l_decap_8
XFILLER_6_688 VPWR VGND sg13cmos5l_decap_4
XFILLER_6_666 VPWR VGND sg13cmos5l_fill_1
XFILLER_9_1219 VPWR VGND sg13cmos5l_decap_8
X_1250_ _1250_/X Tile_X2Y0_S2END[2] Tile_X2Y0_S4END[10] Tile_X2Y0_SS4END[5] _0585_/Q
+ _0341_/Q _0340_/Q VPWR VGND sg13cmos5l_mux4_1
X_0201_ _0201_/Q Tile_X0Y0_FrameData[16] VGND VPWR Tile_X0Y0_FrameStrobe[3] latch
X_1181_ _1181_/X Tile_X1Y0_S1END[1] Tile_X1Y0_S2MID[5] Tile_X1Y0_S2END[2] _0593_/Q
+ _0303_/Q _0302_/Q VPWR VGND sg13cmos5l_mux4_1
X_0132_ _0132_/Q Tile_X0Y0_FrameData[21] VGND VPWR Tile_X0Y0_FrameStrobe[1] latch
XFILLER_4_1864 VPWR VGND sg13cmos5l_decap_8
XFILLER_4_1831 VPWR VGND sg13cmos5l_fill_2
XFILLER_0_1739 VPWR VGND sg13cmos5l_decap_8
XFILLER_18_2253 VPWR VGND sg13cmos5l_fill_1
XFILLER_18_2242 VPWR VGND sg13cmos5l_decap_8
XFILLER_18_2220 VPWR VGND sg13cmos5l_decap_8
XFILLER_18_2275 VPWR VGND sg13cmos5l_fill_1
XFILLER_18_1541 VPWR VGND sg13cmos5l_fill_1
X_0965_ Tile_X3Y0_NN4BEG[9] _1289_/X VPWR VGND sg13cmos5l_buf_1
X_0896_ Tile_X4Y0_NN4BEG[12] Tile_X4Y0_SS4END[3] VPWR VGND sg13cmos5l_buf_1
XFILLER_12_1162 VPWR VGND sg13cmos5l_fill_2
XFILLER_12_1195 VPWR VGND sg13cmos5l_decap_8
XFILLER_0_809 VPWR VGND sg13cmos5l_fill_2
XFILLER_5_1606 VPWR VGND sg13cmos5l_decap_8
XFILLER_4_91 VPWR VGND sg13cmos5l_decap_8
XFILLER_9_1786 VPWR VGND sg13cmos5l_decap_8
XFILLER_3_2020 VPWR VGND sg13cmos5l_decap_8
XFILLER_3_2097 VPWR VGND sg13cmos5l_decap_8
XFILLER_3_1385 VPWR VGND sg13cmos5l_decap_8
XFILLER_12_938 VPWR VGND sg13cmos5l_decap_8
XFILLER_12_927 VPWR VGND sg13cmos5l_fill_1
XFILLER_14_1983 VPWR VGND sg13cmos5l_decap_8
XFILLER_14_1972 VPWR VGND sg13cmos5l_decap_8
XFILLER_10_1858 VPWR VGND sg13cmos5l_decap_8
XFILLER_3_669 VPWR VGND sg13cmos5l_decap_8
XFILLER_2_168 VPWR VGND sg13cmos5l_decap_8
XFILLER_4_1105 VPWR VGND sg13cmos5l_decap_8
XFILLER_0_49 VPWR VGND sg13cmos5l_decap_8
XFILLER_9_14 VPWR VGND sg13cmos5l_decap_8
XFILLER_15_2404 VPWR VGND sg13cmos5l_fill_1
XFILLER_15_1747 VPWR VGND sg13cmos5l_decap_4
X_0750_ Tile_X0Y0_N4BEG[2] _1146_/X VPWR VGND sg13cmos5l_buf_1
XFILLER_7_931 VPWR VGND sg13cmos5l_decap_8
XFILLER_11_971 VPWR VGND sg13cmos5l_decap_8
XFILLER_6_463 VPWR VGND sg13cmos5l_decap_8
X_0681_ _0681_/L_HI VPWR VGND sg13cmos5l_tiehi
XFILLER_13_1493 VPWR VGND sg13cmos5l_decap_8
XFILLER_6_1904 VPWR VGND sg13cmos5l_decap_8
X_1233_ _1233_/X Tile_X2Y0_S2MID[1] Tile_X2Y0_S4END[6] Tile_X2Y0_SS4END[9] _0585_/Q
+ _0375_/Q _0374_/Q VPWR VGND sg13cmos5l_mux4_1
XFILLER_0_1503 VPWR VGND sg13cmos5l_decap_8
X_1164_ _1164_/X Tile_X0Y0_S2END[4] Tile_X0Y0_S4END[4] Tile_X0Y0_SS4END[11] _0599_/Q
+ _0145_/Q _0144_/Q VPWR VGND sg13cmos5l_mux4_1
XFILLER_4_2395 VPWR VGND sg13cmos5l_decap_8
X_0115_ _0115_/Q Tile_X0Y0_FrameData[6] VGND VPWR Tile_X0Y0_FrameStrobe[0] latch
X_1095_ _1095_/X Tile_X3Y0_S1END[2] Tile_X3Y0_S2MID[2] Tile_X3Y0_S2MID[5] Tile_X3Y0_S2END[5]
+ _0421_/Q _0420_/Q VPWR VGND sg13cmos5l_mux4_1
XFILLER_18_570 VPWR VGND sg13cmos5l_decap_4
XFILLER_0_1547 VPWR VGND sg13cmos5l_decap_8
X_0948_ Tile_X3Y0_N4BEG[8] _1272_/X VPWR VGND sg13cmos5l_buf_1
XFILLER_9_290 VPWR VGND sg13cmos5l_decap_8
XFILLER_14_1279 VPWR VGND sg13cmos5l_fill_1
X_0879_ Tile_X4Y0_N4BEG[11] Tile_X4Y0_S4END[4] VPWR VGND sg13cmos5l_buf_1
XFILLER_0_606 VPWR VGND sg13cmos5l_decap_8
XFILLER_0_617 VPWR VGND sg13cmos5l_fill_2
XFILLER_9_2262 VPWR VGND sg13cmos5l_decap_8
XFILLER_9_1572 VPWR VGND sg13cmos5l_decap_8
XFILLER_5_2159 VPWR VGND sg13cmos5l_decap_8
XFILLER_5_1403 VPWR VGND sg13cmos5l_decap_8
XFILLER_3_1171 VPWR VGND sg13cmos5l_decap_4
XFILLER_12_735 VPWR VGND sg13cmos5l_decap_8
XFILLER_11_223 VPWR VGND sg13cmos5l_decap_8
XFILLER_7_205 VPWR VGND sg13cmos5l_decap_8
XFILLER_12_779 VPWR VGND sg13cmos5l_decap_8
XFILLER_7_238 VPWR VGND sg13cmos5l_fill_1
XFILLER_7_227 VPWR VGND sg13cmos5l_decap_8
XFILLER_11_267 VPWR VGND sg13cmos5l_decap_4
XFILLER_10_2334 VPWR VGND sg13cmos5l_decap_8
XFILLER_10_1644 VPWR VGND sg13cmos5l_fill_1
XFILLER_4_923 VPWR VGND sg13cmos5l_decap_8
XFILLER_10_1666 VPWR VGND sg13cmos5l_decap_4
XFILLER_3_466 VPWR VGND sg13cmos5l_decap_8
XFILLER_5_1970 VPWR VGND sg13cmos5l_decap_8
XFILLER_1_1834 VPWR VGND sg13cmos5l_decap_8
XFILLER_17_1809 VPWR VGND sg13cmos5l_decap_8
XANTENNA__0933__X Tile_X3Y0_N2BEGb[1] VPWR VGND sg13cmos5l_antennanp
XFILLER_15_2223 VPWR VGND sg13cmos5l_decap_8
X_0802_ Tile_X4Y0_FrameData_O[6] Tile_X0Y0_FrameData[6] VPWR VGND sg13cmos5l_buf_1
XFILLER_15_1577 VPWR VGND sg13cmos5l_fill_2
XFILLER_11_790 VPWR VGND sg13cmos5l_decap_8
X_0733_ Tile_X0Y0_N2BEG[1] Tile_X0Y0_S2MID[6] VPWR VGND sg13cmos5l_buf_1
X_0664_ _0664_/L_HI VPWR VGND sg13cmos5l_tiehi
XFILLER_6_293 VPWR VGND sg13cmos5l_fill_1
X_0595_ _0595_/Q Tile_X0Y0_UserCLK NPU_RDATA23 _0611_/L_HI VPWR VGND sg13cmos5l_dfrbpq_1
XFILLER_0_2001 VPWR VGND sg13cmos5l_fill_1
X_1216_ _1216_/X Tile_X2Y0_S1END[0] Tile_X2Y0_S2MID[0] Tile_X2Y0_S2END[7] _0580_/Q
+ _0409_/Q _0408_/Q VPWR VGND sg13cmos5l_mux4_1
XFILLER_6_1789 VPWR VGND sg13cmos5l_decap_8
XFILLER_4_2192 VPWR VGND sg13cmos5l_decap_8
XFILLER_0_1311 VPWR VGND sg13cmos5l_fill_2
X_1147_ _1147_/X Tile_X0Y0_S2MID[3] Tile_X0Y0_S4END[12] Tile_X0Y0_SS4END[3] _0597_/Q
+ _0179_/Q _0178_/Q VPWR VGND sg13cmos5l_mux4_1
XFILLER_1_70 VPWR VGND sg13cmos5l_decap_8
XANTENNA__1004__X Tile_X1Y0_NN4BEG[8] VPWR VGND sg13cmos5l_antennanp
XFILLER_0_2089 VPWR VGND sg13cmos5l_decap_8
X_1078_ Tile_X2Y0_N2BEGb[2] _1218_/X VPWR VGND sg13cmos5l_buf_1
XANTENNA__0843__X Tile_X4Y0_FrameStrobe_O[15] VPWR VGND sg13cmos5l_antennanp
XFILLER_16_1319 VPWR VGND sg13cmos5l_decap_4
XFILLER_14_1021 VPWR VGND sg13cmos5l_decap_8
XFILLER_11_1964 VPWR VGND sg13cmos5l_decap_8
XFILLER_1_915 VPWR VGND sg13cmos5l_decap_4
XFILLER_1_937 VPWR VGND sg13cmos5l_fill_2
XFILLER_0_469 VPWR VGND sg13cmos5l_decap_8
XFILLER_5_1277 VPWR VGND sg13cmos5l_decap_8
XFILLER_1_1108 VPWR VGND sg13cmos5l_decap_8
XANTENNA__0753__X Tile_X0Y0_N4BEG[5] VPWR VGND sg13cmos5l_antennanp
XFILLER_12_554 VPWR VGND sg13cmos5l_fill_1
XFILLER_12_532 VPWR VGND sg13cmos5l_fill_2
XFILLER_8_514 VPWR VGND sg13cmos5l_decap_8
XFILLER_12_576 VPWR VGND sg13cmos5l_fill_2
XANTENNA_8 NPU_RDATA12 VPWR VGND sg13cmos5l_antennanp
XFILLER_10_2153 VPWR VGND sg13cmos5l_decap_8
XFILLER_10_1474 VPWR VGND sg13cmos5l_decap_8
XFILLER_4_764 VPWR VGND sg13cmos5l_decap_8
XFILLER_3_252 VPWR VGND sg13cmos5l_decap_8
X_0380_ _0380_/Q Tile_X0Y0_FrameData[29] VGND VPWR Tile_X2Y0_FrameStrobe[2] latch
XANTENNA__0928__X Tile_X3Y0_N2BEG[4] VPWR VGND sg13cmos5l_antennanp
XFILLER_3_1929 VPWR VGND sg13cmos5l_decap_8
XFILLER_1_2310 VPWR VGND sg13cmos5l_decap_8
X_1001_ Tile_X1Y0_NN4BEG[5] _1205_/X VPWR VGND sg13cmos5l_buf_1
XFILLER_1_2387 VPWR VGND sg13cmos5l_decap_8
XFILLER_17_2329 VPWR VGND sg13cmos5l_decap_8
XFILLER_17_1617 VPWR VGND sg13cmos5l_fill_2
XFILLER_15_2031 VPWR VGND sg13cmos5l_decap_8
XFILLER_11_1227 VPWR VGND sg13cmos5l_fill_2
X_0716_ Tile_X0Y0_FrameStrobe_O[8] Tile_X0Y0_FrameStrobe[8] VPWR VGND sg13cmos5l_buf_1
XFILLER_7_591 VPWR VGND sg13cmos5l_decap_8
XFILLER_7_580 VPWR VGND sg13cmos5l_decap_8
X_0647_ _0647_/L_HI VPWR VGND sg13cmos5l_tiehi
X_0578_ _0578_/Q Tile_X0Y0_UserCLK NPU_RDATA6 _0643_/L_HI VPWR VGND sg13cmos5l_dfrbpq_1
XFILLER_8_1818 VPWR VGND sg13cmos5l_decap_8
XFILLER_6_2232 VPWR VGND sg13cmos5l_decap_8
XANTENNA__0838__X Tile_X4Y0_FrameStrobe_O[10] VPWR VGND sg13cmos5l_antennanp
XFILLER_6_1520 VPWR VGND sg13cmos5l_decap_8
XFILLER_6_1597 VPWR VGND sg13cmos5l_decap_8
XFILLER_2_1428 VPWR VGND sg13cmos5l_decap_8
XFILLER_15_79 VPWR VGND sg13cmos5l_decap_4
XFILLER_16_1149 VPWR VGND sg13cmos5l_decap_8
XFILLER_16_1127 VPWR VGND sg13cmos5l_fill_2
XANTENNA__0522__Q NPU_READ_BANK_SEL1 VPWR VGND sg13cmos5l_antennanp
XFILLER_5_506 VPWR VGND sg13cmos5l_decap_8
XFILLER_1_734 VPWR VGND sg13cmos5l_decap_8
XFILLER_0_222 VPWR VGND sg13cmos5l_decap_8
XFILLER_0_233 VPWR VGND sg13cmos5l_decap_8
XANTENNA__0748__X Tile_X0Y0_N4BEG[0] VPWR VGND sg13cmos5l_antennanp
XFILLER_17_602 VPWR VGND sg13cmos5l_fill_2
XFILLER_5_1085 VPWR VGND sg13cmos5l_decap_8
XFILLER_2_1984 VPWR VGND sg13cmos5l_decap_4
XFILLER_16_189 VPWR VGND sg13cmos5l_fill_2
XFILLER_9_801 VPWR VGND sg13cmos5l_fill_1
XFILLER_16_2351 VPWR VGND sg13cmos5l_decap_8
XFILLER_9_834 VPWR VGND sg13cmos5l_decap_4
XFILLER_9_845 VPWR VGND sg13cmos5l_fill_2
XFILLER_9_889 VPWR VGND sg13cmos5l_decap_8
X_0501_ _0501_/Q Tile_X0Y0_FrameData[4] VGND VPWR Tile_X3Y0_FrameStrobe[2] latch
XFILLER_4_561 VPWR VGND sg13cmos5l_decap_8
X_0432_ _0432_/Q Tile_X0Y0_FrameData[9] VGND VPWR Tile_X3Y0_FrameStrobe[0] latch
X_0363_ _0363_/Q Tile_X0Y0_FrameData[14] VGND VPWR Tile_X2Y0_FrameStrobe[1] latch
XFILLER_3_2416 VPWR VGND sg13cmos5l_fill_2
XFILLER_3_2405 VPWR VGND sg13cmos5l_decap_8
XFILLER_7_1862 VPWR VGND sg13cmos5l_decap_8
X_0294_ _0294_/Q Tile_X0Y0_FrameData[3] VGND VPWR Tile_X1Y0_FrameStrobe[2] latch
XFILLER_3_1726 VPWR VGND sg13cmos5l_fill_2
XFILLER_3_1759 VPWR VGND sg13cmos5l_decap_8
XFILLER_1_1472 VPWR VGND sg13cmos5l_decap_8
XFILLER_17_2126 VPWR VGND sg13cmos5l_fill_2
XFILLER_17_1414 VPWR VGND sg13cmos5l_decap_4
XFILLER_11_1013 VPWR VGND sg13cmos5l_decap_8
XFILLER_11_1035 VPWR VGND sg13cmos5l_decap_8
XFILLER_7_91 VPWR VGND sg13cmos5l_decap_8
XFILLER_8_2338 VPWR VGND sg13cmos5l_decap_8
XFILLER_8_1659 VPWR VGND sg13cmos5l_decap_4
XFILLER_6_2051 VPWR VGND sg13cmos5l_decap_8
XANTENNA_206 Tile_X0Y0_FrameData[23] VPWR VGND sg13cmos5l_antennanp
XFILLER_6_1394 VPWR VGND sg13cmos5l_decap_8
XANTENNA_217 Tile_X0Y0_FrameData[23] VPWR VGND sg13cmos5l_antennanp
XANTENNA_228 Tile_X0Y0_FrameData[28] VPWR VGND sg13cmos5l_antennanp
XANTENNA_239 Tile_X0Y0_FrameData[18] VPWR VGND sg13cmos5l_antennanp
XFILLER_14_649 VPWR VGND sg13cmos5l_decap_8
XFILLER_13_126 VPWR VGND sg13cmos5l_fill_2
XFILLER_10_822 VPWR VGND sg13cmos5l_fill_2
XFILLER_5_347 VPWR VGND sg13cmos5l_decap_8
XFILLER_5_336 VPWR VGND sg13cmos5l_fill_1
XFILLER_5_325 VPWR VGND sg13cmos5l_decap_8
XFILLER_11_2270 VPWR VGND sg13cmos5l_decap_8
XFILLER_1_553 VPWR VGND sg13cmos5l_decap_8
XFILLER_3_49 VPWR VGND sg13cmos5l_decap_8
XFILLER_7_1136 VPWR VGND sg13cmos5l_decap_8
XFILLER_18_988 VPWR VGND sg13cmos5l_fill_2
XFILLER_18_966 VPWR VGND sg13cmos5l_fill_1
XFILLER_17_432 VPWR VGND sg13cmos5l_fill_2
XFILLER_2_1781 VPWR VGND sg13cmos5l_decap_8
XFILLER_18_2413 VPWR VGND sg13cmos5l_decap_4
XFILLER_17_487 VPWR VGND sg13cmos5l_decap_8
X_0981_ Tile_X2Y0_FrameStrobe_O[9] Tile_X2Y0_FrameStrobe[9] VPWR VGND sg13cmos5l_buf_1
XANTENNA__0941__X Tile_X3Y0_N4BEG[1] VPWR VGND sg13cmos5l_antennanp
XFILLER_12_2045 VPWR VGND sg13cmos5l_decap_8
XFILLER_8_196 VPWR VGND sg13cmos5l_decap_8
XFILLER_12_1333 VPWR VGND sg13cmos5l_decap_8
XFILLER_5_892 VPWR VGND sg13cmos5l_fill_1
XFILLER_9_1957 VPWR VGND sg13cmos5l_decap_8
X_0415_ _0415_/Q Tile_X0Y0_FrameData[26] VGND VPWR Tile_X3Y0_FrameStrobe[0] latch
XFILLER_7_2382 VPWR VGND sg13cmos5l_decap_8
XFILLER_3_2202 VPWR VGND sg13cmos5l_decap_8
X_0346_ _0346_/Q Tile_X0Y0_FrameData[31] VGND VPWR Tile_X2Y0_FrameStrobe[1] latch
X_0277_ _0277_/Q Tile_X0Y0_FrameData[20] VGND VPWR Tile_X1Y0_FrameStrobe[2] latch
XFILLER_3_2279 VPWR VGND sg13cmos5l_decap_8
XFILLER_3_1567 VPWR VGND sg13cmos5l_decap_8
XANTENNA__1012__X Tile_X1Y0_N4BEG[0] VPWR VGND sg13cmos5l_antennanp
XFILLER_1_1291 VPWR VGND sg13cmos5l_decap_8
XANTENNA__0851__X Tile_X4Y0_N1BEG[3] VPWR VGND sg13cmos5l_antennanp
XFILLER_17_1266 VPWR VGND sg13cmos5l_decap_4
XFILLER_12_36 VPWR VGND sg13cmos5l_decap_8
XFILLER_12_14 VPWR VGND sg13cmos5l_decap_8
XFILLER_8_2157 VPWR VGND sg13cmos5l_decap_8
XFILLER_8_1434 VPWR VGND sg13cmos5l_decap_8
XFILLER_18_229 VPWR VGND sg13cmos5l_decap_8
XFILLER_2_1066 VPWR VGND sg13cmos5l_decap_8
XFILLER_15_925 VPWR VGND sg13cmos5l_decap_8
XANTENNA__0761__X Tile_X0Y0_N4BEG[13] VPWR VGND sg13cmos5l_antennanp
XFILLER_10_630 VPWR VGND sg13cmos5l_fill_1
XFILLER_10_652 VPWR VGND sg13cmos5l_decap_4
XFILLER_13_2365 VPWR VGND sg13cmos5l_decap_8
XFILLER_6_645 VPWR VGND sg13cmos5l_fill_2
XFILLER_5_133 VPWR VGND sg13cmos5l_decap_8
XFILLER_13_1664 VPWR VGND sg13cmos5l_fill_2
XFILLER_5_199 VPWR VGND sg13cmos5l_decap_8
XFILLER_2_873 VPWR VGND sg13cmos5l_fill_2
X_0200_ _0200_/Q Tile_X0Y0_FrameData[17] VGND VPWR Tile_X0Y0_FrameStrobe[3] latch
X_1180_ _1180_/X Tile_X1Y0_S1END[0] Tile_X1Y0_S2MID[4] Tile_X1Y0_S2END[3] _0592_/Q
+ _0305_/Q _0304_/Q VPWR VGND sg13cmos5l_mux4_1
XANTENNA__0936__X Tile_X3Y0_N2BEGb[4] VPWR VGND sg13cmos5l_antennanp
XFILLER_0_2408 VPWR VGND sg13cmos5l_fill_2
X_0131_ _0131_/Q Tile_X0Y0_FrameData[22] VGND VPWR Tile_X0Y0_FrameStrobe[1] latch
XFILLER_4_1843 VPWR VGND sg13cmos5l_decap_8
XFILLER_18_763 VPWR VGND sg13cmos5l_fill_2
XFILLER_18_1520 VPWR VGND sg13cmos5l_fill_2
X_0964_ Tile_X3Y0_NN4BEG[8] _1288_/X VPWR VGND sg13cmos5l_buf_1
XFILLER_18_1597 VPWR VGND sg13cmos5l_fill_1
XFILLER_9_483 VPWR VGND sg13cmos5l_decap_8
X_0895_ Tile_X4Y0_NN4BEG[11] Tile_X4Y0_SS4END[4] VPWR VGND sg13cmos5l_buf_1
XFILLER_4_70 VPWR VGND sg13cmos5l_decap_8
XANTENNA__1007__X Tile_X1Y0_NN4BEG[11] VPWR VGND sg13cmos5l_antennanp
XANTENNA__0846__X Tile_X4Y0_FrameStrobe_O[18] VPWR VGND sg13cmos5l_antennanp
X_0329_ _0329_/Q Tile_X0Y0_FrameData[16] VGND VPWR Tile_X2Y0_FrameStrobe[0] latch
XFILLER_3_2076 VPWR VGND sg13cmos5l_decap_8
XFILLER_3_1364 VPWR VGND sg13cmos5l_decap_8
XFILLER_17_1030 VPWR VGND sg13cmos5l_decap_4
XFILLER_17_1074 VPWR VGND sg13cmos5l_fill_2
XFILLER_17_1063 VPWR VGND sg13cmos5l_decap_4
XFILLER_14_1951 VPWR VGND sg13cmos5l_decap_8
XFILLER_10_1815 VPWR VGND sg13cmos5l_fill_1
XFILLER_10_1837 VPWR VGND sg13cmos5l_decap_8
XANTENNA__0530__Q NPU_WDATA6 VPWR VGND sg13cmos5l_antennanp
XFILLER_3_648 VPWR VGND sg13cmos5l_decap_8
XFILLER_2_147 VPWR VGND sg13cmos5l_decap_8
XANTENNA__0756__X Tile_X0Y0_N4BEG[8] VPWR VGND sg13cmos5l_antennanp
XFILLER_0_28 VPWR VGND sg13cmos5l_decap_8
XFILLER_15_700 VPWR VGND sg13cmos5l_decap_4
XFILLER_15_777 VPWR VGND sg13cmos5l_decap_8
XFILLER_15_2416 VPWR VGND sg13cmos5l_fill_2
XFILLER_14_265 VPWR VGND sg13cmos5l_fill_1
XFILLER_14_287 VPWR VGND sg13cmos5l_decap_8
XFILLER_7_910 VPWR VGND sg13cmos5l_decap_8
XFILLER_11_950 VPWR VGND sg13cmos5l_decap_8
XFILLER_15_1759 VPWR VGND sg13cmos5l_fill_2
XFILLER_13_2151 VPWR VGND sg13cmos5l_decap_8
X_0680_ _0680_/L_HI VPWR VGND sg13cmos5l_tiehi
XFILLER_6_442 VPWR VGND sg13cmos5l_decap_8
XFILLER_13_1472 VPWR VGND sg13cmos5l_decap_8
XFILLER_7_987 VPWR VGND sg13cmos5l_decap_8
XFILLER_2_692 VPWR VGND sg13cmos5l_decap_4
X_1232_ _1232_/X Tile_X2Y0_S2MID[0] Tile_X2Y0_S4END[7] Tile_X2Y0_SS4END[8] _0584_/Q
+ _0377_/Q _0376_/Q VPWR VGND sg13cmos5l_mux4_1
XFILLER_4_2374 VPWR VGND sg13cmos5l_decap_8
X_1163_ _1163_/X Tile_X0Y0_S2END[3] Tile_X0Y0_S4END[3] Tile_X0Y0_SS4END[12] _0596_/Q
+ _0147_/Q _0146_/Q VPWR VGND sg13cmos5l_mux4_1
X_0114_ _0114_/Q Tile_X0Y0_FrameData[7] VGND VPWR Tile_X0Y0_FrameStrobe[0] latch
X_1094_ _1094_/X Tile_X3Y0_S1END[1] Tile_X3Y0_S2MID[1] Tile_X3Y0_S2MID[6] Tile_X3Y0_S2END[6]
+ _0423_/Q _0422_/Q VPWR VGND sg13cmos5l_mux4_1
X_0947_ Tile_X3Y0_N4BEG[7] _1271_/X VPWR VGND sg13cmos5l_buf_1
XFILLER_14_1247 VPWR VGND sg13cmos5l_fill_1
XFILLER_9_280 VPWR VGND sg13cmos5l_decap_8
X_0878_ Tile_X4Y0_N4BEG[10] Tile_X4Y0_S4END[5] VPWR VGND sg13cmos5l_buf_1
XFILLER_9_2241 VPWR VGND sg13cmos5l_decap_8
XFILLER_9_1540 VPWR VGND sg13cmos5l_decap_8
XFILLER_5_2138 VPWR VGND sg13cmos5l_decap_8
XFILLER_5_1459 VPWR VGND sg13cmos5l_decap_8
XFILLER_3_1150 VPWR VGND sg13cmos5l_decap_8
XFILLER_18_79 VPWR VGND sg13cmos5l_decap_8
XANTENNA__0525__Q NPU_WDATA1 VPWR VGND sg13cmos5l_antennanp
XFILLER_11_246 VPWR VGND sg13cmos5l_decap_8
XFILLER_10_2313 VPWR VGND sg13cmos5l_decap_8
XFILLER_11_279 VPWR VGND sg13cmos5l_decap_4
XFILLER_3_445 VPWR VGND sg13cmos5l_decap_8
XFILLER_10_1689 VPWR VGND sg13cmos5l_decap_8
XFILLER_4_979 VPWR VGND sg13cmos5l_decap_8
XFILLER_8_1083 VPWR VGND sg13cmos5l_fill_2
XFILLER_8_1072 VPWR VGND sg13cmos5l_decap_8
XFILLER_1_1813 VPWR VGND sg13cmos5l_decap_8
XFILLER_15_552 VPWR VGND sg13cmos5l_fill_2
X_0801_ Tile_X4Y0_FrameData_O[5] Tile_X0Y0_FrameData[5] VPWR VGND sg13cmos5l_buf_1
XFILLER_15_2279 VPWR VGND sg13cmos5l_decap_8
X_0732_ Tile_X0Y0_N2BEG[0] Tile_X0Y0_S2MID[7] VPWR VGND sg13cmos5l_buf_1
XFILLER_7_784 VPWR VGND sg13cmos5l_decap_8
X_0663_ _0663_/L_HI VPWR VGND sg13cmos5l_tiehi
X_0594_ _0594_/Q Tile_X0Y0_UserCLK NPU_RDATA22 _0610_/L_HI VPWR VGND sg13cmos5l_dfrbpq_1
XFILLER_6_2414 VPWR VGND sg13cmos5l_decap_4
XFILLER_6_1735 VPWR VGND sg13cmos5l_decap_8
X_1215_ _1215_/X Tile_X1Y0_S2END[7] Tile_X1Y0_S4END[15] Tile_X1Y0_SS4END[0] _0594_/Q
+ _0235_/Q _0234_/Q VPWR VGND sg13cmos5l_mux4_1
XFILLER_6_1779 VPWR VGND sg13cmos5l_fill_2
XFILLER_4_2171 VPWR VGND sg13cmos5l_decap_8
X_1146_ _1146_/X Tile_X0Y0_S2MID[2] Tile_X0Y0_S4END[13] Tile_X0Y0_SS4END[2] _0596_/Q
+ _0181_/Q _0180_/Q VPWR VGND sg13cmos5l_mux4_1
XFILLER_0_2068 VPWR VGND sg13cmos5l_decap_8
XFILLER_4_1492 VPWR VGND sg13cmos5l_decap_8
XFILLER_0_1356 VPWR VGND sg13cmos5l_decap_8
XFILLER_0_1367 VPWR VGND sg13cmos5l_fill_2
X_1077_ Tile_X2Y0_N2BEGb[1] _1217_/X VPWR VGND sg13cmos5l_buf_1
XANTENNA__1020__X Tile_X1Y0_N4BEG[8] VPWR VGND sg13cmos5l_antennanp
XFILLER_14_1000 VPWR VGND sg13cmos5l_decap_8
XFILLER_14_1066 VPWR VGND sg13cmos5l_fill_2
XFILLER_11_1943 VPWR VGND sg13cmos5l_decap_8
XFILLER_1_949 VPWR VGND sg13cmos5l_fill_2
XFILLER_5_1223 VPWR VGND sg13cmos5l_fill_2
XFILLER_5_1256 VPWR VGND sg13cmos5l_decap_8
XFILLER_0_1890 VPWR VGND sg13cmos5l_decap_8
XFILLER_12_511 VPWR VGND sg13cmos5l_decap_8
XFILLER_16_1843 VPWR VGND sg13cmos5l_decap_8
XFILLER_16_1898 VPWR VGND sg13cmos5l_decap_8
XANTENNA_9 NPU_RDATA13 VPWR VGND sg13cmos5l_antennanp
XFILLER_10_2132 VPWR VGND sg13cmos5l_decap_8
XFILLER_6_49 VPWR VGND sg13cmos5l_decap_8
XFILLER_10_1453 VPWR VGND sg13cmos5l_decap_8
XFILLER_4_743 VPWR VGND sg13cmos5l_decap_8
XFILLER_3_231 VPWR VGND sg13cmos5l_decap_8
XFILLER_3_1908 VPWR VGND sg13cmos5l_decap_8
XFILLER_13_7 VPWR VGND sg13cmos5l_decap_8
X_1000_ Tile_X1Y0_NN4BEG[4] _1204_/X VPWR VGND sg13cmos5l_buf_1
XFILLER_1_2366 VPWR VGND sg13cmos5l_decap_8
XFILLER_1_1654 VPWR VGND sg13cmos5l_decap_8
XANTENNA__0944__X Tile_X3Y0_N4BEG[4] VPWR VGND sg13cmos5l_antennanp
XFILLER_1_1676 VPWR VGND sg13cmos5l_fill_2
XFILLER_1_1665 VPWR VGND sg13cmos5l_decap_8
XFILLER_16_894 VPWR VGND sg13cmos5l_decap_8
XFILLER_15_2010 VPWR VGND sg13cmos5l_decap_8
XFILLER_15_2065 VPWR VGND sg13cmos5l_fill_1
XFILLER_15_1331 VPWR VGND sg13cmos5l_fill_1
XFILLER_15_2098 VPWR VGND sg13cmos5l_decap_8
X_0715_ Tile_X0Y0_FrameStrobe_O[7] Tile_X0Y0_FrameStrobe[7] VPWR VGND sg13cmos5l_buf_1
X_0646_ _0646_/L_HI VPWR VGND sg13cmos5l_tiehi
X_0577_ _0577_/Q Tile_X0Y0_UserCLK NPU_RDATA5 _0644_/L_HI VPWR VGND sg13cmos5l_dfrbpq_1
XFILLER_6_2288 VPWR VGND sg13cmos5l_decap_8
XANTENNA__1015__X Tile_X1Y0_N4BEG[3] VPWR VGND sg13cmos5l_antennanp
XFILLER_6_1576 VPWR VGND sg13cmos5l_decap_8
XFILLER_2_1407 VPWR VGND sg13cmos5l_decap_8
XANTENNA__0854__X Tile_X4Y0_N2BEG[2] VPWR VGND sg13cmos5l_antennanp
X_1129_ _1129_/X Tile_X0Y0_S4END[0] Tile_X0Y0_S4END[3] Tile_X0Y0_SS4END[1] Tile_X0Y0_SS4END[3]
+ _0097_/Q _0096_/Q VPWR VGND sg13cmos5l_mux4_1
XFILLER_15_14 VPWR VGND sg13cmos5l_decap_8
XFILLER_14_809 VPWR VGND sg13cmos5l_fill_2
XFILLER_0_1164 VPWR VGND sg13cmos5l_decap_8
XFILLER_0_1175 VPWR VGND sg13cmos5l_fill_2
XFILLER_15_47 VPWR VGND sg13cmos5l_decap_4
XFILLER_15_58 VPWR VGND sg13cmos5l_decap_8
XFILLER_11_1773 VPWR VGND sg13cmos5l_decap_8
XFILLER_7_2008 VPWR VGND sg13cmos5l_fill_1
XFILLER_5_1064 VPWR VGND sg13cmos5l_decap_8
XFILLER_17_647 VPWR VGND sg13cmos5l_fill_2
XANTENNA__0764__X Tile_X0Y0_NN4BEG[0] VPWR VGND sg13cmos5l_antennanp
XFILLER_2_1963 VPWR VGND sg13cmos5l_decap_8
XFILLER_16_168 VPWR VGND sg13cmos5l_decap_8
XFILLER_16_2330 VPWR VGND sg13cmos5l_decap_8
XFILLER_16_1662 VPWR VGND sg13cmos5l_decap_4
XFILLER_12_374 VPWR VGND sg13cmos5l_fill_2
X_0500_ _0500_/Q Tile_X0Y0_FrameData[5] VGND VPWR Tile_X3Y0_FrameStrobe[2] latch
XFILLER_4_540 VPWR VGND sg13cmos5l_decap_8
XANTENNA__0939__X Tile_X3Y0_N2BEGb[7] VPWR VGND sg13cmos5l_antennanp
X_0431_ _0431_/Q Tile_X0Y0_FrameData[10] VGND VPWR Tile_X3Y0_FrameStrobe[0] latch
X_0362_ _0362_/Q Tile_X0Y0_FrameData[15] VGND VPWR Tile_X2Y0_FrameStrobe[1] latch
X_0293_ _0293_/Q Tile_X0Y0_FrameData[4] VGND VPWR Tile_X1Y0_FrameStrobe[2] latch
XFILLER_7_1896 VPWR VGND sg13cmos5l_decap_8
XFILLER_3_1738 VPWR VGND sg13cmos5l_decap_8
XFILLER_1_1451 VPWR VGND sg13cmos5l_decap_8
XFILLER_17_2105 VPWR VGND sg13cmos5l_decap_4
XFILLER_8_890 VPWR VGND sg13cmos5l_decap_8
XFILLER_7_70 VPWR VGND sg13cmos5l_decap_8
XFILLER_8_2317 VPWR VGND sg13cmos5l_decap_8
XANTENNA__0849__X Tile_X4Y0_N1BEG[1] VPWR VGND sg13cmos5l_antennanp
X_0629_ _0629_/L_HI VPWR VGND sg13cmos5l_tiehi
XFILLER_6_2030 VPWR VGND sg13cmos5l_decap_8
XFILLER_6_1373 VPWR VGND sg13cmos5l_decap_8
XANTENNA_207 Tile_X0Y0_FrameData[23] VPWR VGND sg13cmos5l_antennanp
XANTENNA_218 Tile_X0Y0_FrameData[23] VPWR VGND sg13cmos5l_antennanp
XANTENNA_229 Tile_X0Y0_FrameData[28] VPWR VGND sg13cmos5l_antennanp
XFILLER_14_639 VPWR VGND sg13cmos5l_decap_4
XFILLER_13_149 VPWR VGND sg13cmos5l_decap_4
XANTENNA__0533__Q NPU_WDATA9 VPWR VGND sg13cmos5l_antennanp
XFILLER_6_805 VPWR VGND sg13cmos5l_decap_8
XFILLER_5_304 VPWR VGND sg13cmos5l_decap_8
XFILLER_17_1982 VPWR VGND sg13cmos5l_fill_1
XFILLER_13_1879 VPWR VGND sg13cmos5l_fill_1
XFILLER_13_1868 VPWR VGND sg13cmos5l_decap_8
XFILLER_11_1581 VPWR VGND sg13cmos5l_decap_8
XANTENNA__0759__X Tile_X0Y0_N4BEG[11] VPWR VGND sg13cmos5l_antennanp
XFILLER_3_28 VPWR VGND sg13cmos5l_decap_8
XFILLER_1_532 VPWR VGND sg13cmos5l_decap_8
XFILLER_2_1760 VPWR VGND sg13cmos5l_decap_8
XFILLER_17_466 VPWR VGND sg13cmos5l_decap_8
X_0980_ Tile_X2Y0_FrameStrobe_O[8] Tile_X2Y0_FrameStrobe[8] VPWR VGND sg13cmos5l_buf_1
XFILLER_12_2024 VPWR VGND sg13cmos5l_decap_8
XFILLER_12_160 VPWR VGND sg13cmos5l_fill_2
XFILLER_12_182 VPWR VGND sg13cmos5l_decap_4
XFILLER_8_175 VPWR VGND sg13cmos5l_decap_8
XFILLER_12_1389 VPWR VGND sg13cmos5l_decap_8
XFILLER_9_1936 VPWR VGND sg13cmos5l_decap_8
X_0414_ _0414_/Q Tile_X0Y0_FrameData[27] VGND VPWR Tile_X3Y0_FrameStrobe[0] latch
XFILLER_7_2361 VPWR VGND sg13cmos5l_decap_8
X_0345_ _0345_/Q Tile_X0Y0_FrameData[0] VGND VPWR Tile_X2Y0_FrameStrobe[0] latch
XFILLER_3_2258 VPWR VGND sg13cmos5l_decap_8
X_0276_ _0276_/Q Tile_X0Y0_FrameData[21] VGND VPWR Tile_X1Y0_FrameStrobe[2] latch
XFILLER_3_1546 VPWR VGND sg13cmos5l_decap_8
XFILLER_17_1234 VPWR VGND sg13cmos5l_decap_4
XFILLER_10_108 VPWR VGND sg13cmos5l_decap_4
XFILLER_3_808 VPWR VGND sg13cmos5l_decap_8
XFILLER_2_329 VPWR VGND sg13cmos5l_decap_8
XFILLER_8_2136 VPWR VGND sg13cmos5l_decap_8
XFILLER_8_1413 VPWR VGND sg13cmos5l_decap_8
XFILLER_18_208 VPWR VGND sg13cmos5l_decap_8
XANTENNA__0528__Q NPU_WDATA4 VPWR VGND sg13cmos5l_antennanp
XFILLER_2_1045 VPWR VGND sg13cmos5l_decap_8
XFILLER_13_2344 VPWR VGND sg13cmos5l_decap_8
XFILLER_10_686 VPWR VGND sg13cmos5l_decap_4
XFILLER_6_624 VPWR VGND sg13cmos5l_decap_8
XFILLER_5_112 VPWR VGND sg13cmos5l_decap_8
XFILLER_10_697 VPWR VGND sg13cmos5l_decap_8
XFILLER_13_1687 VPWR VGND sg13cmos5l_decap_4
XFILLER_5_178 VPWR VGND sg13cmos5l_decap_8
XFILLER_11_2090 VPWR VGND sg13cmos5l_decap_8
XFILLER_4_1811 VPWR VGND sg13cmos5l_decap_8
X_0130_ _0130_/Q Tile_X0Y0_FrameData[23] VGND VPWR Tile_X0Y0_FrameStrobe[1] latch
XFILLER_18_753 VPWR VGND sg13cmos5l_decap_8
XFILLER_4_1899 VPWR VGND sg13cmos5l_decap_8
XFILLER_18_797 VPWR VGND sg13cmos5l_decap_8
XFILLER_17_263 VPWR VGND sg13cmos5l_fill_2
XANTENNA__0952__X Tile_X3Y0_N4BEG[12] VPWR VGND sg13cmos5l_antennanp
XFILLER_18_1532 VPWR VGND sg13cmos5l_decap_8
X_0963_ Tile_X3Y0_NN4BEG[7] _1287_/X VPWR VGND sg13cmos5l_buf_1
XFILLER_14_1429 VPWR VGND sg13cmos5l_decap_8
X_0894_ Tile_X4Y0_NN4BEG[10] Tile_X4Y0_SS4END[5] VPWR VGND sg13cmos5l_buf_1
XFILLER_12_1164 VPWR VGND sg13cmos5l_fill_1
XFILLER_12_1153 VPWR VGND sg13cmos5l_fill_1
XFILLER_12_1131 VPWR VGND sg13cmos5l_decap_4
XFILLER_12_1186 VPWR VGND sg13cmos5l_decap_4
XFILLER_9_2412 VPWR VGND sg13cmos5l_decap_4
XFILLER_9_1733 VPWR VGND sg13cmos5l_fill_2
X_0328_ _0328_/Q Tile_X0Y0_FrameData[17] VGND VPWR Tile_X2Y0_FrameStrobe[0] latch
XFILLER_3_2055 VPWR VGND sg13cmos5l_decap_8
XFILLER_3_1343 VPWR VGND sg13cmos5l_decap_8
XANTENNA__1023__X Tile_X1Y0_N4BEG[11] VPWR VGND sg13cmos5l_antennanp
X_0259_ _0259_/Q Tile_X0Y0_FrameData[6] VGND VPWR Tile_X1Y0_FrameStrobe[1] latch
XANTENNA__0862__X Tile_X4Y0_N2BEGb[2] VPWR VGND sg13cmos5l_antennanp
XFILLER_11_439 VPWR VGND sg13cmos5l_decap_8
XFILLER_14_1930 VPWR VGND sg13cmos5l_decap_8
XFILLER_3_627 VPWR VGND sg13cmos5l_decap_8
XFILLER_2_126 VPWR VGND sg13cmos5l_decap_8
XFILLER_14_200 VPWR VGND sg13cmos5l_decap_4
XANTENNA__0772__X Tile_X0Y0_NN4BEG[8] VPWR VGND sg13cmos5l_antennanp
XFILLER_14_233 VPWR VGND sg13cmos5l_decap_4
XFILLER_9_49 VPWR VGND sg13cmos5l_fill_1
XFILLER_13_2174 VPWR VGND sg13cmos5l_decap_8
XFILLER_10_494 VPWR VGND sg13cmos5l_decap_8
XFILLER_7_966 VPWR VGND sg13cmos5l_decap_8
XFILLER_13_80 VPWR VGND sg13cmos5l_fill_2
XFILLER_13_1451 VPWR VGND sg13cmos5l_decap_8
XFILLER_6_498 VPWR VGND sg13cmos5l_decap_8
XFILLER_2_671 VPWR VGND sg13cmos5l_decap_8
XANTENNA__0947__X Tile_X3Y0_N4BEG[7] VPWR VGND sg13cmos5l_antennanp
X_1231_ _1231_/X Tile_X2Y0_S2MID[7] Tile_X2Y0_S4END[8] Tile_X2Y0_SS4END[7] _0583_/Q
+ _0379_/Q _0378_/Q VPWR VGND sg13cmos5l_mux4_1
XFILLER_6_1939 VPWR VGND sg13cmos5l_decap_8
XFILLER_0_2206 VPWR VGND sg13cmos5l_fill_2
XFILLER_4_2353 VPWR VGND sg13cmos5l_decap_8
X_1162_ _1162_/X Tile_X0Y0_S2END[2] Tile_X0Y0_S4END[2] Tile_X0Y0_SS4END[13] _0597_/Q
+ _0149_/Q _0148_/Q VPWR VGND sg13cmos5l_mux4_1
X_0113_ _0113_/Q Tile_X0Y0_FrameData[8] VGND VPWR Tile_X0Y0_FrameStrobe[0] latch
X_1093_ _1093_/X Tile_X3Y0_S1END[0] Tile_X3Y0_S2MID[0] Tile_X3Y0_S2MID[7] Tile_X3Y0_S2END[7]
+ _0425_/Q _0424_/Q VPWR VGND sg13cmos5l_mux4_1
XFILLER_4_1685 VPWR VGND sg13cmos5l_decap_8
XFILLER_4_1674 VPWR VGND sg13cmos5l_fill_1
XFILLER_0_1538 VPWR VGND sg13cmos5l_decap_4
XFILLER_18_594 VPWR VGND sg13cmos5l_fill_1
XFILLER_18_2085 VPWR VGND sg13cmos5l_decap_8
XFILLER_18_2074 VPWR VGND sg13cmos5l_fill_1
XFILLER_18_2063 VPWR VGND sg13cmos5l_decap_8
XFILLER_18_1362 VPWR VGND sg13cmos5l_decap_8
X_0946_ Tile_X3Y0_N4BEG[6] _1270_/X VPWR VGND sg13cmos5l_buf_1
XFILLER_14_1259 VPWR VGND sg13cmos5l_decap_8
X_0877_ Tile_X4Y0_N4BEG[9] Tile_X4Y0_S4END[6] VPWR VGND sg13cmos5l_buf_1
XANTENNA__1018__X Tile_X1Y0_N4BEG[6] VPWR VGND sg13cmos5l_antennanp
XFILLER_5_2117 VPWR VGND sg13cmos5l_decap_8
XANTENNA__0857__X Tile_X4Y0_N2BEG[5] VPWR VGND sg13cmos5l_antennanp
XFILLER_9_2297 VPWR VGND sg13cmos5l_decap_8
XFILLER_5_1438 VPWR VGND sg13cmos5l_decap_8
XFILLER_12_726 VPWR VGND sg13cmos5l_fill_2
XFILLER_12_748 VPWR VGND sg13cmos5l_decap_4
XFILLER_10_1602 VPWR VGND sg13cmos5l_fill_1
XANTENNA__0541__Q NPU_WDATA17 VPWR VGND sg13cmos5l_antennanp
XFILLER_10_2369 VPWR VGND sg13cmos5l_decap_8
XFILLER_14_1782 VPWR VGND sg13cmos5l_decap_8
XFILLER_4_958 VPWR VGND sg13cmos5l_decap_8
XFILLER_3_424 VPWR VGND sg13cmos5l_decap_8
XFILLER_10_1679 VPWR VGND sg13cmos5l_fill_2
XANTENNA__0767__X Tile_X0Y0_NN4BEG[3] VPWR VGND sg13cmos5l_antennanp
XFILLER_8_1051 VPWR VGND sg13cmos5l_decap_8
XFILLER_1_1869 VPWR VGND sg13cmos5l_decap_8
XFILLER_15_575 VPWR VGND sg13cmos5l_fill_1
XFILLER_15_2258 VPWR VGND sg13cmos5l_decap_8
X_0800_ Tile_X4Y0_FrameData_O[4] Tile_X0Y0_FrameData[4] VPWR VGND sg13cmos5l_buf_1
XFILLER_11_770 VPWR VGND sg13cmos5l_decap_4
X_0731_ Tile_X0Y0_N1BEG[3] Tile_X0Y0_S1END[0] VPWR VGND sg13cmos5l_buf_1
XFILLER_7_741 VPWR VGND sg13cmos5l_decap_8
XFILLER_7_763 VPWR VGND sg13cmos5l_decap_8
X_0662_ _0662_/L_HI VPWR VGND sg13cmos5l_tiehi
XFILLER_6_273 VPWR VGND sg13cmos5l_fill_2
X_0593_ _0593_/Q Tile_X0Y0_UserCLK NPU_RDATA21 _0609_/L_HI VPWR VGND sg13cmos5l_dfrbpq_1
X_1214_ _1214_/X Tile_X1Y0_S2END[6] Tile_X1Y0_S4END[14] Tile_X1Y0_SS4END[1] _0595_/Q
+ _0237_/Q _0236_/Q VPWR VGND sg13cmos5l_mux4_1
XFILLER_4_2150 VPWR VGND sg13cmos5l_decap_8
XFILLER_0_2047 VPWR VGND sg13cmos5l_decap_8
X_1145_ _1145_/X Tile_X0Y0_S2MID[1] Tile_X0Y0_S4END[14] Tile_X0Y0_SS4END[1] _0597_/Q
+ _0183_/Q _0182_/Q VPWR VGND sg13cmos5l_mux4_1
XFILLER_4_1471 VPWR VGND sg13cmos5l_decap_8
X_1076_ Tile_X2Y0_N2BEGb[0] _1216_/X VPWR VGND sg13cmos5l_buf_1
XFILLER_18_391 VPWR VGND sg13cmos5l_decap_8
XFILLER_14_1056 VPWR VGND sg13cmos5l_fill_2
X_0929_ Tile_X3Y0_N2BEG[5] Tile_X3Y0_S2MID[2] VPWR VGND sg13cmos5l_buf_1
XFILLER_11_1922 VPWR VGND sg13cmos5l_decap_8
XFILLER_11_1999 VPWR VGND sg13cmos5l_decap_8
XFILLER_9_2083 VPWR VGND sg13cmos5l_decap_8
XFILLER_16_317 VPWR VGND sg13cmos5l_decap_8
XANTENNA__0536__Q NPU_WDATA12 VPWR VGND sg13cmos5l_antennanp
XFILLER_16_1800 VPWR VGND sg13cmos5l_fill_2
XFILLER_12_545 VPWR VGND sg13cmos5l_fill_2
XFILLER_12_534 VPWR VGND sg13cmos5l_fill_1
XFILLER_10_2111 VPWR VGND sg13cmos5l_decap_8
XFILLER_8_549 VPWR VGND sg13cmos5l_decap_8
XFILLER_16_1877 VPWR VGND sg13cmos5l_decap_8
XFILLER_6_28 VPWR VGND sg13cmos5l_decap_8
XFILLER_10_1432 VPWR VGND sg13cmos5l_decap_8
XFILLER_4_722 VPWR VGND sg13cmos5l_decap_8
XFILLER_3_210 VPWR VGND sg13cmos5l_decap_8
XFILLER_10_70 VPWR VGND sg13cmos5l_fill_2
XFILLER_4_799 VPWR VGND sg13cmos5l_decap_8
XFILLER_3_287 VPWR VGND sg13cmos5l_decap_8
XFILLER_0_994 VPWR VGND sg13cmos5l_decap_8
XFILLER_1_2345 VPWR VGND sg13cmos5l_decap_8
XFILLER_1_1633 VPWR VGND sg13cmos5l_decap_8
XFILLER_17_2309 VPWR VGND sg13cmos5l_fill_1
XANTENNA__0960__X Tile_X3Y0_NN4BEG[4] VPWR VGND sg13cmos5l_antennanp
XFILLER_15_2077 VPWR VGND sg13cmos5l_decap_8
XFILLER_11_1229 VPWR VGND sg13cmos5l_fill_1
X_0714_ Tile_X0Y0_FrameStrobe_O[6] Tile_X0Y0_FrameStrobe[6] VPWR VGND sg13cmos5l_buf_1
X_0645_ _0645_/L_HI VPWR VGND sg13cmos5l_tiehi
X_0576_ _0576_/Q Tile_X0Y0_UserCLK NPU_RDATA4 _0646_/L_HI VPWR VGND sg13cmos5l_dfrbpq_1
XFILLER_6_2267 VPWR VGND sg13cmos5l_decap_8
XFILLER_6_1555 VPWR VGND sg13cmos5l_decap_8
XFILLER_2_2109 VPWR VGND sg13cmos5l_decap_8
X_1128_ _1128_/X Tile_X0Y0_S4END[4] Tile_X0Y0_S4END[5] Tile_X0Y0_SS4END[4] Tile_X0Y0_SS4END[6]
+ _0099_/Q _0098_/Q VPWR VGND sg13cmos5l_mux4_1
XANTENNA__1031__X Tile_X1Y0_N2BEGb[3] VPWR VGND sg13cmos5l_antennanp
X_1059_ Tile_X1Y0_FrameStrobe_O[11] Tile_X1Y0_FrameStrobe[11] VPWR VGND sg13cmos5l_buf_1
XFILLER_13_309 VPWR VGND sg13cmos5l_fill_2
XANTENNA__0870__X Tile_X4Y0_N4BEG[2] VPWR VGND sg13cmos5l_antennanp
XFILLER_1_703 VPWR VGND sg13cmos5l_fill_1
XFILLER_7_1308 VPWR VGND sg13cmos5l_decap_8
XFILLER_1_769 VPWR VGND sg13cmos5l_decap_8
XFILLER_0_257 VPWR VGND sg13cmos5l_decap_8
XFILLER_5_1043 VPWR VGND sg13cmos5l_decap_8
XFILLER_2_1942 VPWR VGND sg13cmos5l_decap_8
XFILLER_16_103 VPWR VGND sg13cmos5l_fill_2
XFILLER_16_147 VPWR VGND sg13cmos5l_decap_4
XFILLER_18_1939 VPWR VGND sg13cmos5l_decap_8
XANTENNA__0780__X Tile_X2Y0_NN4BEG[0] VPWR VGND sg13cmos5l_antennanp
XFILLER_16_2397 VPWR VGND sg13cmos5l_fill_1
XFILLER_16_2386 VPWR VGND sg13cmos5l_decap_8
XFILLER_12_2239 VPWR VGND sg13cmos5l_decap_8
XFILLER_12_1527 VPWR VGND sg13cmos5l_fill_2
XFILLER_12_1516 VPWR VGND sg13cmos5l_decap_8
X_0430_ _0430_/Q Tile_X0Y0_FrameData[11] VGND VPWR Tile_X3Y0_FrameStrobe[0] latch
XFILLER_4_596 VPWR VGND sg13cmos5l_decap_8
X_0361_ _0361_/Q Tile_X0Y0_FrameData[16] VGND VPWR Tile_X2Y0_FrameStrobe[1] latch
XFILLER_0_791 VPWR VGND sg13cmos5l_decap_8
XANTENNA__0955__X Tile_X3Y0_N4BEG[15] VPWR VGND sg13cmos5l_antennanp
X_0292_ _0292_/Q Tile_X0Y0_FrameData[5] VGND VPWR Tile_X1Y0_FrameStrobe[2] latch
XFILLER_3_1706 VPWR VGND sg13cmos5l_decap_8
XFILLER_1_2153 VPWR VGND sg13cmos5l_decap_8
XFILLER_1_1430 VPWR VGND sg13cmos5l_decap_8
XFILLER_17_1449 VPWR VGND sg13cmos5l_decap_8
X_0628_ _0628_/L_HI VPWR VGND sg13cmos5l_tiehi
XFILLER_8_1617 VPWR VGND sg13cmos5l_decap_8
X_0559_ NPU_WE3 Tile_X0Y0_UserCLK _0559_/D _0668_/L_HI VPWR VGND sg13cmos5l_dfrbpq_1
XANTENNA__1026__X Tile_X1Y0_N4BEG[14] VPWR VGND sg13cmos5l_antennanp
XFILLER_6_2086 VPWR VGND sg13cmos5l_decap_8
XFILLER_6_1352 VPWR VGND sg13cmos5l_decap_8
XFILLER_2_1205 VPWR VGND sg13cmos5l_decap_8
XANTENNA__0865__X Tile_X4Y0_N2BEGb[5] VPWR VGND sg13cmos5l_antennanp
XANTENNA_208 Tile_X0Y0_FrameData[23] VPWR VGND sg13cmos5l_antennanp
XANTENNA_219 Tile_X0Y0_FrameData[28] VPWR VGND sg13cmos5l_antennanp
XFILLER_13_106 VPWR VGND sg13cmos5l_fill_2
XFILLER_17_1972 VPWR VGND sg13cmos5l_fill_2
XFILLER_13_1847 VPWR VGND sg13cmos5l_decap_8
XFILLER_1_511 VPWR VGND sg13cmos5l_decap_8
XFILLER_7_1116 VPWR VGND sg13cmos5l_decap_8
XFILLER_7_1127 VPWR VGND sg13cmos5l_fill_2
XFILLER_1_588 VPWR VGND sg13cmos5l_decap_8
XANTENNA__0775__X Tile_X0Y0_NN4BEG[11] VPWR VGND sg13cmos5l_antennanp
XFILLER_18_957 VPWR VGND sg13cmos5l_decap_8
XFILLER_17_445 VPWR VGND sg13cmos5l_decap_8
XFILLER_17_434 VPWR VGND sg13cmos5l_fill_1
XFILLER_18_1758 VPWR VGND sg13cmos5l_decap_4
XFILLER_18_1736 VPWR VGND sg13cmos5l_fill_1
XFILLER_18_1725 VPWR VGND sg13cmos5l_decap_8
XFILLER_16_91 VPWR VGND sg13cmos5l_decap_4
XFILLER_8_110 VPWR VGND sg13cmos5l_fill_1
XFILLER_13_673 VPWR VGND sg13cmos5l_fill_2
XFILLER_12_2003 VPWR VGND sg13cmos5l_decap_8
XFILLER_8_154 VPWR VGND sg13cmos5l_decap_8
XFILLER_16_1482 VPWR VGND sg13cmos5l_decap_8
XFILLER_5_850 VPWR VGND sg13cmos5l_fill_1
XFILLER_12_1368 VPWR VGND sg13cmos5l_decap_8
XFILLER_10_1081 VPWR VGND sg13cmos5l_decap_8
XFILLER_9_1915 VPWR VGND sg13cmos5l_decap_8
XFILLER_4_371 VPWR VGND sg13cmos5l_fill_1
X_0413_ _0413_/Q Tile_X0Y0_FrameData[28] VGND VPWR Tile_X3Y0_FrameStrobe[0] latch
XFILLER_7_2340 VPWR VGND sg13cmos5l_decap_8
X_0344_ _0344_/Q Tile_X0Y0_FrameData[1] VGND VPWR Tile_X2Y0_FrameStrobe[0] latch
XFILLER_3_2237 VPWR VGND sg13cmos5l_decap_8
X_0275_ _0275_/Q Tile_X0Y0_FrameData[22] VGND VPWR Tile_X1Y0_FrameStrobe[2] latch
XFILLER_3_1525 VPWR VGND sg13cmos5l_decap_8
XFILLER_2_308 VPWR VGND sg13cmos5l_decap_8
XFILLER_12_1891 VPWR VGND sg13cmos5l_decap_8
XFILLER_8_2115 VPWR VGND sg13cmos5l_decap_8
XFILLER_8_1469 VPWR VGND sg13cmos5l_decap_8
XFILLER_2_1024 VPWR VGND sg13cmos5l_decap_8
XFILLER_14_404 VPWR VGND sg13cmos5l_fill_2
XANTENNA__0544__Q NPU_WDATA20 VPWR VGND sg13cmos5l_antennanp
XFILLER_14_459 VPWR VGND sg13cmos5l_decap_8
XFILLER_10_610 VPWR VGND sg13cmos5l_decap_8
XFILLER_15_1909 VPWR VGND sg13cmos5l_decap_8
XFILLER_13_2323 VPWR VGND sg13cmos5l_decap_8
XFILLER_6_603 VPWR VGND sg13cmos5l_decap_8
XFILLER_10_665 VPWR VGND sg13cmos5l_decap_8
XFILLER_6_647 VPWR VGND sg13cmos5l_fill_1
XFILLER_5_157 VPWR VGND sg13cmos5l_decap_8
XFILLER_1_374 VPWR VGND sg13cmos5l_fill_1
XFILLER_1_363 VPWR VGND sg13cmos5l_decap_8
XFILLER_4_1878 VPWR VGND sg13cmos5l_decap_8
XFILLER_2_2281 VPWR VGND sg13cmos5l_decap_8
XFILLER_18_732 VPWR VGND sg13cmos5l_decap_8
XFILLER_18_776 VPWR VGND sg13cmos5l_decap_8
XFILLER_18_2201 VPWR VGND sg13cmos5l_decap_4
XFILLER_14_2109 VPWR VGND sg13cmos5l_decap_8
X_0962_ Tile_X3Y0_NN4BEG[6] _1286_/X VPWR VGND sg13cmos5l_buf_1
XFILLER_14_993 VPWR VGND sg13cmos5l_decap_8
XFILLER_14_1408 VPWR VGND sg13cmos5l_decap_8
XFILLER_13_481 VPWR VGND sg13cmos5l_decap_8
XFILLER_9_463 VPWR VGND sg13cmos5l_fill_2
X_0893_ Tile_X4Y0_NN4BEG[9] Tile_X4Y0_SS4END[6] VPWR VGND sg13cmos5l_buf_1
XFILLER_9_2402 VPWR VGND sg13cmos5l_decap_8
XFILLER_9_1723 VPWR VGND sg13cmos5l_fill_1
XFILLER_7_2181 VPWR VGND sg13cmos5l_decap_8
X_0327_ _0327_/Q Tile_X0Y0_FrameData[18] VGND VPWR Tile_X2Y0_FrameStrobe[0] latch
XFILLER_3_2034 VPWR VGND sg13cmos5l_decap_8
XFILLER_3_1322 VPWR VGND sg13cmos5l_decap_8
X_0258_ _0258_/Q Tile_X0Y0_FrameData[7] VGND VPWR Tile_X1Y0_FrameStrobe[1] latch
X_0189_ _0189_/Q Tile_X0Y0_FrameData[28] VGND VPWR Tile_X0Y0_FrameStrobe[3] latch
XFILLER_3_1399 VPWR VGND sg13cmos5l_decap_8
XFILLER_11_418 VPWR VGND sg13cmos5l_decap_8
XFILLER_11_407 VPWR VGND sg13cmos5l_decap_8
XFILLER_10_1806 VPWR VGND sg13cmos5l_decap_8
XFILLER_3_606 VPWR VGND sg13cmos5l_decap_8
XFILLER_14_1997 VPWR VGND sg13cmos5l_decap_8
XFILLER_3_7 VPWR VGND sg13cmos5l_decap_8
XFILLER_2_105 VPWR VGND sg13cmos5l_decap_8
XFILLER_8_1211 VPWR VGND sg13cmos5l_fill_1
XANTENNA__0539__Q NPU_WDATA15 VPWR VGND sg13cmos5l_antennanp
XFILLER_4_1119 VPWR VGND sg13cmos5l_decap_8
XFILLER_9_28 VPWR VGND sg13cmos5l_decap_8
XFILLER_11_985 VPWR VGND sg13cmos5l_decap_8
XFILLER_10_473 VPWR VGND sg13cmos5l_decap_8
XFILLER_7_945 VPWR VGND sg13cmos5l_decap_8
XFILLER_13_1430 VPWR VGND sg13cmos5l_decap_8
XFILLER_6_477 VPWR VGND sg13cmos5l_decap_8
XFILLER_9_1008 VPWR VGND sg13cmos5l_decap_8
XFILLER_2_650 VPWR VGND sg13cmos5l_decap_8
X_1230_ _1230_/X Tile_X2Y0_S2MID[6] Tile_X2Y0_S4END[9] Tile_X2Y0_SS4END[6] _0582_/Q
+ _0381_/Q _0380_/Q VPWR VGND sg13cmos5l_mux4_1
XFILLER_6_1918 VPWR VGND sg13cmos5l_decap_8
XFILLER_4_2332 VPWR VGND sg13cmos5l_decap_8
XFILLER_1_182 VPWR VGND sg13cmos5l_decap_8
X_1161_ _1161_/X Tile_X0Y0_S2END[1] Tile_X0Y0_S4END[1] Tile_X0Y0_SS4END[14] _0596_/Q
+ _0151_/Q _0150_/Q VPWR VGND sg13cmos5l_mux4_1
X_0112_ _0112_/Q Tile_X0Y0_FrameData[9] VGND VPWR Tile_X0Y0_FrameStrobe[0] latch
XFILLER_4_1653 VPWR VGND sg13cmos5l_decap_8
XFILLER_0_1517 VPWR VGND sg13cmos5l_decap_8
X_1092_ _1092_/X Tile_X2Y0_S1END[3] Tile_X2Y0_S2MID[0] Tile_X2Y0_S2MID[7] Tile_X2Y0_S2END[0]
+ _0315_/Q _0410_/Q VPWR VGND sg13cmos5l_mux4_1
XANTENNA__0963__X Tile_X3Y0_NN4BEG[7] VPWR VGND sg13cmos5l_antennanp
XFILLER_18_2031 VPWR VGND sg13cmos5l_fill_2
XFILLER_18_1341 VPWR VGND sg13cmos5l_decap_8
X_0945_ Tile_X3Y0_N4BEG[5] _1269_/X VPWR VGND sg13cmos5l_buf_1
XFILLER_14_1238 VPWR VGND sg13cmos5l_decap_8
XFILLER_14_1227 VPWR VGND sg13cmos5l_fill_1
XFILLER_9_271 VPWR VGND sg13cmos5l_fill_2
X_0876_ Tile_X4Y0_N4BEG[8] Tile_X4Y0_S4END[7] VPWR VGND sg13cmos5l_buf_1
XFILLER_9_1520 VPWR VGND sg13cmos5l_fill_2
XFILLER_9_2276 VPWR VGND sg13cmos5l_decap_8
XFILLER_9_1564 VPWR VGND sg13cmos5l_decap_4
XFILLER_9_1586 VPWR VGND sg13cmos5l_decap_8
XFILLER_5_1417 VPWR VGND sg13cmos5l_decap_8
XANTENNA__1034__X Tile_X1Y0_N2BEGb[6] VPWR VGND sg13cmos5l_antennanp
XANTENNA__0873__X Tile_X4Y0_N4BEG[5] VPWR VGND sg13cmos5l_antennanp
XFILLER_11_237 VPWR VGND sg13cmos5l_fill_2
XFILLER_7_219 VPWR VGND sg13cmos5l_fill_1
XFILLER_14_1750 VPWR VGND sg13cmos5l_fill_2
XFILLER_10_2348 VPWR VGND sg13cmos5l_decap_8
XFILLER_4_937 VPWR VGND sg13cmos5l_decap_8
XFILLER_8_1030 VPWR VGND sg13cmos5l_fill_2
XFILLER_5_1984 VPWR VGND sg13cmos5l_decap_8
XANTENNA__0783__X Tile_X2Y0_NN4BEG[3] VPWR VGND sg13cmos5l_antennanp
XFILLER_1_1848 VPWR VGND sg13cmos5l_decap_8
XFILLER_15_2237 VPWR VGND sg13cmos5l_decap_8
XFILLER_15_1536 VPWR VGND sg13cmos5l_decap_4
X_0730_ Tile_X0Y0_N1BEG[2] Tile_X0Y0_S1END[1] VPWR VGND sg13cmos5l_buf_1
XFILLER_6_252 VPWR VGND sg13cmos5l_decap_8
X_0661_ _0661_/L_HI VPWR VGND sg13cmos5l_tiehi
X_0592_ _0592_/Q Tile_X0Y0_UserCLK NPU_RDATA20 _0608_/L_HI VPWR VGND sg13cmos5l_dfrbpq_1
XANTENNA__0958__X Tile_X3Y0_NN4BEG[2] VPWR VGND sg13cmos5l_antennanp
X_1213_ _1213_/X Tile_X1Y0_S2END[5] Tile_X1Y0_S4END[13] Tile_X1Y0_SS4END[2] _0594_/Q
+ _0239_/Q _0238_/Q VPWR VGND sg13cmos5l_mux4_1
X_1144_ _1144_/X Tile_X0Y0_S2MID[0] Tile_X0Y0_S4END[15] Tile_X0Y0_SS4END[0] _0596_/Q
+ _0185_/Q _0184_/Q VPWR VGND sg13cmos5l_mux4_1
XFILLER_4_1450 VPWR VGND sg13cmos5l_decap_8
XANTENNA__0693__X Tile_X2Y0_N4BEG[1] VPWR VGND sg13cmos5l_antennanp
XFILLER_0_1325 VPWR VGND sg13cmos5l_decap_8
X_1075_ Tile_X2Y0_N2BEG[7] Tile_X2Y0_S2MID[0] VPWR VGND sg13cmos5l_buf_1
XFILLER_1_84 VPWR VGND sg13cmos5l_decap_8
XFILLER_18_370 VPWR VGND sg13cmos5l_decap_8
XFILLER_18_1171 VPWR VGND sg13cmos5l_fill_2
XFILLER_11_1901 VPWR VGND sg13cmos5l_decap_8
XFILLER_14_1035 VPWR VGND sg13cmos5l_decap_8
X_0928_ Tile_X3Y0_N2BEG[4] Tile_X3Y0_S2MID[3] VPWR VGND sg13cmos5l_buf_1
XANTENNA__1029__X Tile_X1Y0_N2BEGb[1] VPWR VGND sg13cmos5l_antennanp
X_0859_ Tile_X4Y0_N2BEG[7] Tile_X4Y0_S2MID[0] VPWR VGND sg13cmos5l_buf_1
XFILLER_11_1978 VPWR VGND sg13cmos5l_decap_8
XANTENNA__0868__X Tile_X4Y0_N4BEG[0] VPWR VGND sg13cmos5l_antennanp
XFILLER_0_428 VPWR VGND sg13cmos5l_fill_2
XFILLER_9_2062 VPWR VGND sg13cmos5l_decap_8
XFILLER_9_1383 VPWR VGND sg13cmos5l_decap_8
XFILLER_8_528 VPWR VGND sg13cmos5l_decap_8
XANTENNA__0552__Q NPU_WDATA28 VPWR VGND sg13cmos5l_antennanp
XFILLER_10_1411 VPWR VGND sg13cmos5l_decap_8
XFILLER_4_701 VPWR VGND sg13cmos5l_decap_8
XFILLER_14_2292 VPWR VGND sg13cmos5l_decap_8
XFILLER_10_2167 VPWR VGND sg13cmos5l_decap_4
XFILLER_14_1591 VPWR VGND sg13cmos5l_decap_8
XANTENNA__0778__X Tile_X0Y0_NN4BEG[14] VPWR VGND sg13cmos5l_antennanp
XFILLER_10_1488 VPWR VGND sg13cmos5l_decap_8
XFILLER_4_778 VPWR VGND sg13cmos5l_decap_8
XFILLER_3_266 VPWR VGND sg13cmos5l_decap_8
XFILLER_0_973 VPWR VGND sg13cmos5l_decap_8
XFILLER_1_2324 VPWR VGND sg13cmos5l_decap_8
XFILLER_5_1792 VPWR VGND sg13cmos5l_decap_8
XFILLER_1_1612 VPWR VGND sg13cmos5l_decap_8
XFILLER_15_2045 VPWR VGND sg13cmos5l_decap_8
XFILLER_15_1399 VPWR VGND sg13cmos5l_decap_8
XFILLER_11_590 VPWR VGND sg13cmos5l_decap_8
X_0713_ Tile_X0Y0_FrameStrobe_O[5] Tile_X0Y0_FrameStrobe[5] VPWR VGND sg13cmos5l_buf_1
X_0644_ _0644_/L_HI VPWR VGND sg13cmos5l_tiehi
X_0575_ _0575_/Q Tile_X0Y0_UserCLK NPU_RDATA3 _0647_/L_HI VPWR VGND sg13cmos5l_dfrbpq_1
XFILLER_6_2246 VPWR VGND sg13cmos5l_decap_8
XFILLER_6_1534 VPWR VGND sg13cmos5l_decap_8
X_1127_ _1127_/X Tile_X0Y0_S4END[5] Tile_X0Y0_S4END[6] Tile_X0Y0_SS4END[5] Tile_X0Y0_SS4END[7]
+ _0101_/Q _0100_/Q VPWR VGND sg13cmos5l_mux4_1
XFILLER_0_1133 VPWR VGND sg13cmos5l_decap_8
XFILLER_0_1188 VPWR VGND sg13cmos5l_fill_2
X_1058_ Tile_X1Y0_FrameStrobe_O[10] Tile_X1Y0_FrameStrobe[10] VPWR VGND sg13cmos5l_buf_1
XFILLER_0_203 VPWR VGND sg13cmos5l_fill_1
XFILLER_1_748 VPWR VGND sg13cmos5l_decap_8
XFILLER_0_247 VPWR VGND sg13cmos5l_decap_4
XFILLER_5_1022 VPWR VGND sg13cmos5l_decap_8
XANTENNA__0547__Q NPU_WDATA23 VPWR VGND sg13cmos5l_antennanp
XFILLER_5_1099 VPWR VGND sg13cmos5l_decap_8
XFILLER_2_1921 VPWR VGND sg13cmos5l_decap_8
XFILLER_16_115 VPWR VGND sg13cmos5l_decap_8
XFILLER_0_2390 VPWR VGND sg13cmos5l_decap_8
XFILLER_13_811 VPWR VGND sg13cmos5l_fill_2
XFILLER_18_1929 VPWR VGND sg13cmos5l_decap_8
XFILLER_16_2365 VPWR VGND sg13cmos5l_decap_8
XFILLER_8_314 VPWR VGND sg13cmos5l_decap_8
XFILLER_12_1539 VPWR VGND sg13cmos5l_decap_8
XFILLER_10_1230 VPWR VGND sg13cmos5l_fill_2
XFILLER_4_575 VPWR VGND sg13cmos5l_decap_8
X_0360_ _0360_/Q Tile_X0Y0_FrameData[17] VGND VPWR Tile_X2Y0_FrameStrobe[1] latch
XFILLER_0_781 VPWR VGND sg13cmos5l_decap_4
X_0291_ _0291_/Q Tile_X0Y0_FrameData[6] VGND VPWR Tile_X1Y0_FrameStrobe[2] latch
XFILLER_7_1876 VPWR VGND sg13cmos5l_fill_2
XFILLER_1_2132 VPWR VGND sg13cmos5l_decap_8
XFILLER_1_1486 VPWR VGND sg13cmos5l_decap_8
XFILLER_17_2118 VPWR VGND sg13cmos5l_fill_1
XANTENNA__0971__X Tile_X3Y0_NN4BEG[15] VPWR VGND sg13cmos5l_antennanp
XFILLER_16_671 VPWR VGND sg13cmos5l_fill_1
XFILLER_17_1428 VPWR VGND sg13cmos5l_decap_8
XFILLER_11_1027 VPWR VGND sg13cmos5l_fill_1
XFILLER_11_1049 VPWR VGND sg13cmos5l_decap_8
X_0627_ _0627_/L_HI VPWR VGND sg13cmos5l_tiehi
X_0558_ NPU_WE2 Tile_X0Y0_UserCLK _0558_/D _0669_/L_HI VPWR VGND sg13cmos5l_dfrbpq_1
XFILLER_6_2065 VPWR VGND sg13cmos5l_decap_8
XFILLER_6_1331 VPWR VGND sg13cmos5l_decap_8
X_0489_ _0489_/Q Tile_X0Y0_FrameData[16] VGND VPWR Tile_X3Y0_FrameStrobe[2] latch
XANTENNA_209 Tile_X0Y0_FrameData[23] VPWR VGND sg13cmos5l_antennanp
XANTENNA__1042__X Tile_X1Y0_N2BEG[6] VPWR VGND sg13cmos5l_antennanp
XANTENNA__0881__X Tile_X4Y0_N4BEG[13] VPWR VGND sg13cmos5l_antennanp
XFILLER_10_814 VPWR VGND sg13cmos5l_decap_4
XFILLER_11_2284 VPWR VGND sg13cmos5l_decap_8
XFILLER_1_567 VPWR VGND sg13cmos5l_decap_8
XFILLER_18_903 VPWR VGND sg13cmos5l_fill_1
XFILLER_2_1795 VPWR VGND sg13cmos5l_decap_8
XANTENNA__0791__X Tile_X2Y0_NN4BEG[11] VPWR VGND sg13cmos5l_antennanp
XFILLER_18_1704 VPWR VGND sg13cmos5l_decap_8
XFILLER_16_70 VPWR VGND sg13cmos5l_decap_8
XFILLER_9_601 VPWR VGND sg13cmos5l_fill_2
XFILLER_9_634 VPWR VGND sg13cmos5l_decap_4
XFILLER_9_645 VPWR VGND sg13cmos5l_fill_1
XFILLER_8_133 VPWR VGND sg13cmos5l_decap_8
XFILLER_16_1461 VPWR VGND sg13cmos5l_decap_8
XFILLER_12_1303 VPWR VGND sg13cmos5l_decap_8
XFILLER_12_2059 VPWR VGND sg13cmos5l_decap_8
XFILLER_12_1347 VPWR VGND sg13cmos5l_decap_8
XFILLER_5_862 VPWR VGND sg13cmos5l_fill_1
XFILLER_4_350 VPWR VGND sg13cmos5l_decap_8
X_0412_ _0412_/Q Tile_X0Y0_FrameData[29] VGND VPWR Tile_X3Y0_FrameStrobe[0] latch
XANTENNA__0966__X Tile_X3Y0_NN4BEG[10] VPWR VGND sg13cmos5l_antennanp
X_0343_ _0343_/Q Tile_X0Y0_FrameData[2] VGND VPWR Tile_X2Y0_FrameStrobe[0] latch
XFILLER_7_2396 VPWR VGND sg13cmos5l_decap_8
XFILLER_3_2216 VPWR VGND sg13cmos5l_decap_8
XFILLER_3_1504 VPWR VGND sg13cmos5l_decap_8
X_0274_ _0274_/Q Tile_X0Y0_FrameData[23] VGND VPWR Tile_X1Y0_FrameStrobe[2] latch
XFILLER_1_1283 VPWR VGND sg13cmos5l_decap_4
XFILLER_17_1225 VPWR VGND sg13cmos5l_fill_2
XFILLER_12_28 VPWR VGND sg13cmos5l_decap_4
XFILLER_12_1870 VPWR VGND sg13cmos5l_decap_8
XANTENNA__1037__X Tile_X1Y0_N2BEG[1] VPWR VGND sg13cmos5l_antennanp
XANTENNA__0876__X Tile_X4Y0_N4BEG[8] VPWR VGND sg13cmos5l_antennanp
XFILLER_8_1448 VPWR VGND sg13cmos5l_decap_8
XFILLER_6_1172 VPWR VGND sg13cmos5l_decap_8
XFILLER_2_1003 VPWR VGND sg13cmos5l_decap_8
XFILLER_15_939 VPWR VGND sg13cmos5l_decap_8
XFILLER_14_438 VPWR VGND sg13cmos5l_decap_8
XFILLER_13_2302 VPWR VGND sg13cmos5l_decap_8
XFILLER_13_2379 VPWR VGND sg13cmos5l_decap_8
XFILLER_13_1623 VPWR VGND sg13cmos5l_decap_4
XANTENNA__0560__Q NPU_WE4 VPWR VGND sg13cmos5l_antennanp
XFILLER_6_659 VPWR VGND sg13cmos5l_decap_8
XFILLER_2_810 VPWR VGND sg13cmos5l_decap_8
XFILLER_1_342 VPWR VGND sg13cmos5l_decap_8
XANTENNA__0786__X Tile_X2Y0_NN4BEG[6] VPWR VGND sg13cmos5l_antennanp
XFILLER_8_1982 VPWR VGND sg13cmos5l_decap_8
XFILLER_18_711 VPWR VGND sg13cmos5l_decap_8
XFILLER_4_1857 VPWR VGND sg13cmos5l_decap_8
XFILLER_2_2260 VPWR VGND sg13cmos5l_decap_8
XFILLER_18_2213 VPWR VGND sg13cmos5l_decap_8
XFILLER_17_287 VPWR VGND sg13cmos5l_decap_4
XFILLER_17_265 VPWR VGND sg13cmos5l_fill_1
X_0961_ Tile_X3Y0_NN4BEG[5] _1285_/X VPWR VGND sg13cmos5l_buf_1
XFILLER_14_972 VPWR VGND sg13cmos5l_decap_8
XFILLER_13_460 VPWR VGND sg13cmos5l_decap_8
X_0892_ Tile_X4Y0_NN4BEG[8] Tile_X4Y0_SS4END[7] VPWR VGND sg13cmos5l_buf_1
XFILLER_9_497 VPWR VGND sg13cmos5l_decap_8
XFILLER_16_1291 VPWR VGND sg13cmos5l_decap_8
XFILLER_5_681 VPWR VGND sg13cmos5l_decap_8
XFILLER_4_84 VPWR VGND sg13cmos5l_decap_8
XANTENNA__0696__X Tile_X2Y0_N4BEG[4] VPWR VGND sg13cmos5l_antennanp
XFILLER_9_1779 VPWR VGND sg13cmos5l_decap_8
XFILLER_7_2160 VPWR VGND sg13cmos5l_decap_8
XFILLER_3_2013 VPWR VGND sg13cmos5l_decap_8
X_0326_ _0326_/Q Tile_X0Y0_FrameData[19] VGND VPWR Tile_X2Y0_FrameStrobe[0] latch
XFILLER_3_1301 VPWR VGND sg13cmos5l_decap_8
X_0257_ _0257_/Q Tile_X0Y0_FrameData[8] VGND VPWR Tile_X1Y0_FrameStrobe[1] latch
XFILLER_7_1492 VPWR VGND sg13cmos5l_decap_8
XFILLER_3_1378 VPWR VGND sg13cmos5l_decap_8
X_0188_ _0188_/Q Tile_X0Y0_FrameData[29] VGND VPWR Tile_X0Y0_FrameStrobe[3] latch
XFILLER_1_1080 VPWR VGND sg13cmos5l_decap_8
XFILLER_14_1965 VPWR VGND sg13cmos5l_decap_8
XANTENNA__0555__Q NPU_WDATA31 VPWR VGND sg13cmos5l_antennanp
XFILLER_15_736 VPWR VGND sg13cmos5l_fill_1
XFILLER_17_2290 VPWR VGND sg13cmos5l_fill_2
XFILLER_10_441 VPWR VGND sg13cmos5l_fill_2
XFILLER_7_924 VPWR VGND sg13cmos5l_decap_8
XFILLER_13_2165 VPWR VGND sg13cmos5l_fill_2
XFILLER_13_2143 VPWR VGND sg13cmos5l_decap_4
XFILLER_11_964 VPWR VGND sg13cmos5l_decap_8
XFILLER_6_423 VPWR VGND sg13cmos5l_fill_2
XFILLER_6_456 VPWR VGND sg13cmos5l_decap_8
XFILLER_13_1486 VPWR VGND sg13cmos5l_decap_8
XFILLER_1_161 VPWR VGND sg13cmos5l_decap_8
XFILLER_4_2311 VPWR VGND sg13cmos5l_decap_8
X_1160_ _1160_/X Tile_X0Y0_S2END[0] Tile_X0Y0_S4END[0] Tile_X0Y0_SS4END[15] _0597_/Q
+ _0153_/Q _0152_/Q VPWR VGND sg13cmos5l_mux4_1
X_0111_ _0111_/Q Tile_X0Y0_FrameData[10] VGND VPWR Tile_X0Y0_FrameStrobe[0] latch
XFILLER_4_2388 VPWR VGND sg13cmos5l_decap_8
XFILLER_4_1632 VPWR VGND sg13cmos5l_decap_8
X_1091_ _1091_/X Tile_X2Y0_S1END[2] Tile_X2Y0_S2MID[1] Tile_X2Y0_S2MID[6] Tile_X2Y0_S2END[1]
+ _0317_/Q _0316_/Q VPWR VGND sg13cmos5l_mux4_1
XFILLER_18_574 VPWR VGND sg13cmos5l_fill_1
XFILLER_18_563 VPWR VGND sg13cmos5l_decap_8
XFILLER_18_1320 VPWR VGND sg13cmos5l_decap_8
X_0944_ Tile_X3Y0_N4BEG[4] _1268_/X VPWR VGND sg13cmos5l_buf_1
XFILLER_13_290 VPWR VGND sg13cmos5l_decap_8
X_0875_ Tile_X4Y0_N4BEG[7] Tile_X4Y0_S4END[8] VPWR VGND sg13cmos5l_buf_1
XFILLER_6_990 VPWR VGND sg13cmos5l_decap_8
XFILLER_9_2255 VPWR VGND sg13cmos5l_decap_8
XFILLER_9_1554 VPWR VGND sg13cmos5l_decap_4
X_0309_ _0309_/Q Tile_X0Y0_FrameData[20] VGND VPWR Tile_X1Y0_FrameStrobe[3] latch
X_1289_ _1289_/X Tile_X3Y0_S2END[1] Tile_X3Y0_S4END[9] Tile_X3Y0_SS4END[6] _0576_/Q
+ _0439_/Q _0438_/Q VPWR VGND sg13cmos5l_mux4_1
XFILLER_3_1164 VPWR VGND sg13cmos5l_decap_8
XFILLER_3_1175 VPWR VGND sg13cmos5l_fill_2
XANTENNA__1050__X Tile_X1Y0_FrameStrobe_O[2] VPWR VGND sg13cmos5l_antennanp
XFILLER_12_706 VPWR VGND sg13cmos5l_decap_4
XFILLER_10_2327 VPWR VGND sg13cmos5l_decap_8
XFILLER_14_1762 VPWR VGND sg13cmos5l_fill_2
XFILLER_4_916 VPWR VGND sg13cmos5l_decap_8
XFILLER_10_1637 VPWR VGND sg13cmos5l_decap_8
XFILLER_10_1659 VPWR VGND sg13cmos5l_decap_4
XFILLER_3_459 VPWR VGND sg13cmos5l_decap_8
XFILLER_5_1963 VPWR VGND sg13cmos5l_decap_8
XFILLER_1_1827 VPWR VGND sg13cmos5l_decap_8
XFILLER_15_533 VPWR VGND sg13cmos5l_fill_2
XFILLER_15_522 VPWR VGND sg13cmos5l_decap_8
XFILLER_15_599 VPWR VGND sg13cmos5l_decap_4
XFILLER_15_1504 VPWR VGND sg13cmos5l_decap_4
XFILLER_11_783 VPWR VGND sg13cmos5l_decap_8
XFILLER_10_282 VPWR VGND sg13cmos5l_fill_2
XFILLER_6_231 VPWR VGND sg13cmos5l_decap_8
X_0660_ _0660_/L_HI VPWR VGND sg13cmos5l_tiehi
XFILLER_7_798 VPWR VGND sg13cmos5l_decap_8
XFILLER_6_286 VPWR VGND sg13cmos5l_decap_8
XFILLER_6_275 VPWR VGND sg13cmos5l_fill_1
X_0591_ _0591_/Q Tile_X0Y0_UserCLK NPU_RDATA19 _0607_/L_HI VPWR VGND sg13cmos5l_dfrbpq_1
XFILLER_3_982 VPWR VGND sg13cmos5l_decap_8
X_1212_ _1212_/X Tile_X1Y0_S2END[4] Tile_X1Y0_S4END[12] Tile_X1Y0_SS4END[3] _0595_/Q
+ _0241_/Q _0240_/Q VPWR VGND sg13cmos5l_mux4_1
XANTENNA__0974__X Tile_X2Y0_FrameStrobe_O[2] VPWR VGND sg13cmos5l_antennanp
X_1143_ _1143_/X Tile_X0Y0_S1END[3] Tile_X0Y0_S2MID[7] Tile_X0Y0_S2END[0] _0603_/Q
+ _0187_/Q _0186_/Q VPWR VGND sg13cmos5l_mux4_1
XFILLER_4_2185 VPWR VGND sg13cmos5l_decap_8
XFILLER_1_63 VPWR VGND sg13cmos5l_decap_8
X_1074_ Tile_X2Y0_N2BEG[6] Tile_X2Y0_S2MID[1] VPWR VGND sg13cmos5l_buf_1
XFILLER_14_1014 VPWR VGND sg13cmos5l_decap_8
X_0927_ Tile_X3Y0_N2BEG[3] Tile_X3Y0_S2MID[4] VPWR VGND sg13cmos5l_buf_1
XFILLER_14_1058 VPWR VGND sg13cmos5l_fill_1
X_0858_ Tile_X4Y0_N2BEG[6] Tile_X4Y0_S2MID[1] VPWR VGND sg13cmos5l_buf_1
XFILLER_11_1957 VPWR VGND sg13cmos5l_decap_8
X_0789_ Tile_X2Y0_NN4BEG[9] _1249_/X VPWR VGND sg13cmos5l_buf_1
XFILLER_9_2041 VPWR VGND sg13cmos5l_decap_8
XFILLER_1_919 VPWR VGND sg13cmos5l_fill_1
XANTENNA__1045__X Tile_X1Y0_N1BEG[1] VPWR VGND sg13cmos5l_antennanp
XFILLER_9_1362 VPWR VGND sg13cmos5l_decap_8
XANTENNA__0884__X Tile_X4Y0_NN4BEG[0] VPWR VGND sg13cmos5l_antennanp
XFILLER_12_525 VPWR VGND sg13cmos5l_decap_8
XFILLER_8_507 VPWR VGND sg13cmos5l_decap_8
XFILLER_16_1857 VPWR VGND sg13cmos5l_fill_2
XFILLER_14_2271 VPWR VGND sg13cmos5l_decap_8
XFILLER_10_2146 VPWR VGND sg13cmos5l_decap_8
XFILLER_10_1467 VPWR VGND sg13cmos5l_decap_8
XFILLER_4_757 VPWR VGND sg13cmos5l_decap_8
XFILLER_3_245 VPWR VGND sg13cmos5l_decap_8
XFILLER_10_50 VPWR VGND sg13cmos5l_fill_2
XFILLER_0_930 VPWR VGND sg13cmos5l_fill_1
XFILLER_1_2303 VPWR VGND sg13cmos5l_decap_8
XANTENNA__0794__X Tile_X2Y0_NN4BEG[14] VPWR VGND sg13cmos5l_antennanp
XFILLER_5_1760 VPWR VGND sg13cmos5l_fill_1
XFILLER_15_374 VPWR VGND sg13cmos5l_decap_4
XFILLER_15_2024 VPWR VGND sg13cmos5l_decap_8
XFILLER_15_1301 VPWR VGND sg13cmos5l_fill_2
XFILLER_15_1367 VPWR VGND sg13cmos5l_fill_2
X_0712_ Tile_X0Y0_FrameStrobe_O[4] Tile_X0Y0_FrameStrobe[4] VPWR VGND sg13cmos5l_buf_1
XFILLER_7_562 VPWR VGND sg13cmos5l_decap_8
XANTENNA__0969__X Tile_X3Y0_NN4BEG[13] VPWR VGND sg13cmos5l_antennanp
X_0643_ _0643_/L_HI VPWR VGND sg13cmos5l_tiehi
X_0574_ _0574_/Q Tile_X0Y0_UserCLK NPU_RDATA2 _0648_/L_HI VPWR VGND sg13cmos5l_dfrbpq_1
XFILLER_6_1513 VPWR VGND sg13cmos5l_decap_8
XFILLER_18_0 VPWR VGND sg13cmos5l_fill_1
X_1126_ _1126_/X Tile_X0Y0_S4END[6] Tile_X0Y0_S4END[7] Tile_X0Y0_SS4END[4] Tile_X0Y0_SS4END[6]
+ _0103_/Q _0102_/Q VPWR VGND sg13cmos5l_mux4_1
XFILLER_0_1123 VPWR VGND sg13cmos5l_decap_4
X_1057_ Tile_X1Y0_FrameStrobe_O[9] Tile_X1Y0_FrameStrobe[9] VPWR VGND sg13cmos5l_buf_1
XFILLER_15_28 VPWR VGND sg13cmos5l_decap_4
XFILLER_11_2400 VPWR VGND sg13cmos5l_fill_1
XANTENNA__0879__X Tile_X4Y0_N4BEG[11] VPWR VGND sg13cmos5l_antennanp
XFILLER_11_1787 VPWR VGND sg13cmos5l_decap_4
XFILLER_1_727 VPWR VGND sg13cmos5l_decap_8
XFILLER_0_215 VPWR VGND sg13cmos5l_decap_8
XFILLER_5_1001 VPWR VGND sg13cmos5l_decap_8
XFILLER_2_1900 VPWR VGND sg13cmos5l_decap_8
XFILLER_5_1078 VPWR VGND sg13cmos5l_decap_8
XFILLER_2_1977 VPWR VGND sg13cmos5l_decap_8
XFILLER_2_1999 VPWR VGND sg13cmos5l_decap_8
XANTENNA__0563__Q NPU_WE7 VPWR VGND sg13cmos5l_antennanp
XFILLER_0_1690 VPWR VGND sg13cmos5l_decap_8
XFILLER_12_311 VPWR VGND sg13cmos5l_decap_4
XFILLER_9_805 VPWR VGND sg13cmos5l_decap_4
XFILLER_9_827 VPWR VGND sg13cmos5l_decap_4
XFILLER_16_2344 VPWR VGND sg13cmos5l_decap_8
XFILLER_16_1621 VPWR VGND sg13cmos5l_decap_4
XFILLER_12_322 VPWR VGND sg13cmos5l_decap_8
XANTENNA__0789__X Tile_X2Y0_NN4BEG[9] VPWR VGND sg13cmos5l_antennanp
XFILLER_4_554 VPWR VGND sg13cmos5l_decap_8
X_0290_ _0290_/Q Tile_X0Y0_FrameData[7] VGND VPWR Tile_X1Y0_FrameStrobe[2] latch
XFILLER_7_1855 VPWR VGND sg13cmos5l_decap_8
XFILLER_1_2111 VPWR VGND sg13cmos5l_decap_8
XFILLER_11_7 VPWR VGND sg13cmos5l_decap_8
XFILLER_1_1465 VPWR VGND sg13cmos5l_decap_8
XFILLER_17_1407 VPWR VGND sg13cmos5l_decap_8
XFILLER_15_1153 VPWR VGND sg13cmos5l_decap_4
XFILLER_11_1006 VPWR VGND sg13cmos5l_decap_8
XFILLER_15_1186 VPWR VGND sg13cmos5l_decap_4
XANTENNA__0699__X Tile_X2Y0_N4BEG[7] VPWR VGND sg13cmos5l_antennanp
XFILLER_7_84 VPWR VGND sg13cmos5l_decap_8
X_0626_ _0626_/L_HI VPWR VGND sg13cmos5l_tiehi
X_0557_ NPU_WE1 Tile_X0Y0_UserCLK _0557_/D _0670_/L_HI VPWR VGND sg13cmos5l_dfrbpq_1
XFILLER_6_2044 VPWR VGND sg13cmos5l_decap_8
XFILLER_6_1310 VPWR VGND sg13cmos5l_decap_8
X_0488_ _0488_/Q Tile_X0Y0_FrameData[17] VGND VPWR Tile_X3Y0_FrameStrobe[2] latch
XFILLER_6_1387 VPWR VGND sg13cmos5l_decap_8
X_1109_ _1109_/X Tile_X1Y0_S4END[4] Tile_X1Y0_S4END[7] Tile_X1Y0_SS4END[5] Tile_X1Y0_SS4END[7]
+ _0217_/Q _0216_/Q VPWR VGND sg13cmos5l_mux4_1
XFILLER_13_119 VPWR VGND sg13cmos5l_decap_8
XFILLER_13_108 VPWR VGND sg13cmos5l_fill_1
XFILLER_17_1930 VPWR VGND sg13cmos5l_decap_4
XFILLER_6_819 VPWR VGND sg13cmos5l_decap_4
XFILLER_17_1974 VPWR VGND sg13cmos5l_fill_1
XFILLER_5_318 VPWR VGND sg13cmos5l_decap_8
XFILLER_11_2263 VPWR VGND sg13cmos5l_decap_8
XFILLER_1_546 VPWR VGND sg13cmos5l_decap_8
XANTENNA__0558__Q NPU_WE2 VPWR VGND sg13cmos5l_antennanp
XFILLER_17_425 VPWR VGND sg13cmos5l_decap_4
XFILLER_2_1774 VPWR VGND sg13cmos5l_decap_8
XFILLER_18_2417 VPWR VGND sg13cmos5l_fill_1
XFILLER_18_2406 VPWR VGND sg13cmos5l_fill_1
XFILLER_9_624 VPWR VGND sg13cmos5l_decap_8
XFILLER_13_664 VPWR VGND sg13cmos5l_fill_2
XFILLER_9_657 VPWR VGND sg13cmos5l_decap_8
XFILLER_9_668 VPWR VGND sg13cmos5l_decap_4
XFILLER_16_1440 VPWR VGND sg13cmos5l_decap_8
XFILLER_12_2038 VPWR VGND sg13cmos5l_decap_8
XFILLER_8_189 VPWR VGND sg13cmos5l_decap_8
XFILLER_5_896 VPWR VGND sg13cmos5l_decap_8
X_0411_ _0411_/Q Tile_X0Y0_FrameData[30] VGND VPWR Tile_X3Y0_FrameStrobe[0] latch
X_0342_ _0342_/Q Tile_X0Y0_FrameData[3] VGND VPWR Tile_X2Y0_FrameStrobe[0] latch
XFILLER_7_2375 VPWR VGND sg13cmos5l_decap_8
X_0273_ _0273_/Q Tile_X0Y0_FrameData[24] VGND VPWR Tile_X1Y0_FrameStrobe[2] latch
XANTENNA__0982__X Tile_X2Y0_FrameStrobe_O[10] VPWR VGND sg13cmos5l_antennanp
XFILLER_1_1262 VPWR VGND sg13cmos5l_decap_8
X_0609_ _0609_/L_HI VPWR VGND sg13cmos5l_tiehi
XFILLER_8_1427 VPWR VGND sg13cmos5l_decap_8
XANTENNA__1053__X Tile_X1Y0_FrameStrobe_O[5] VPWR VGND sg13cmos5l_antennanp
XFILLER_6_1151 VPWR VGND sg13cmos5l_decap_8
XFILLER_6_1195 VPWR VGND sg13cmos5l_fill_2
XANTENNA__0892__X Tile_X4Y0_NN4BEG[8] VPWR VGND sg13cmos5l_antennanp
XFILLER_2_1059 VPWR VGND sg13cmos5l_decap_8
XFILLER_14_406 VPWR VGND sg13cmos5l_fill_1
XFILLER_10_645 VPWR VGND sg13cmos5l_decap_8
XFILLER_10_656 VPWR VGND sg13cmos5l_fill_2
XFILLER_13_2358 VPWR VGND sg13cmos5l_decap_8
XFILLER_6_638 VPWR VGND sg13cmos5l_decap_8
XFILLER_5_126 VPWR VGND sg13cmos5l_decap_8
XFILLER_1_321 VPWR VGND sg13cmos5l_decap_8
XFILLER_8_1961 VPWR VGND sg13cmos5l_decap_8
XFILLER_4_1836 VPWR VGND sg13cmos5l_decap_8
XFILLER_4_1825 VPWR VGND sg13cmos5l_fill_2
XFILLER_2_1582 VPWR VGND sg13cmos5l_decap_8
XFILLER_18_1513 VPWR VGND sg13cmos5l_decap_4
XFILLER_14_951 VPWR VGND sg13cmos5l_decap_8
X_0960_ Tile_X3Y0_NN4BEG[4] _1284_/X VPWR VGND sg13cmos5l_buf_1
XFILLER_18_1546 VPWR VGND sg13cmos5l_fill_2
XFILLER_9_432 VPWR VGND sg13cmos5l_decap_8
XFILLER_9_476 VPWR VGND sg13cmos5l_decap_8
X_0891_ Tile_X4Y0_NN4BEG[7] Tile_X4Y0_SS4END[8] VPWR VGND sg13cmos5l_buf_1
XFILLER_5_660 VPWR VGND sg13cmos5l_decap_8
XANTENNA__0977__X Tile_X2Y0_FrameStrobe_O[5] VPWR VGND sg13cmos5l_antennanp
XFILLER_4_63 VPWR VGND sg13cmos5l_decap_8
X_0325_ _0325_/Q Tile_X0Y0_FrameData[20] VGND VPWR Tile_X2Y0_FrameStrobe[0] latch
XFILLER_7_1471 VPWR VGND sg13cmos5l_decap_8
X_0256_ _0256_/Q Tile_X0Y0_FrameData[9] VGND VPWR Tile_X1Y0_FrameStrobe[1] latch
XFILLER_3_2069 VPWR VGND sg13cmos5l_decap_8
XFILLER_3_1357 VPWR VGND sg13cmos5l_decap_8
X_0187_ _0187_/Q Tile_X0Y0_FrameData[30] VGND VPWR Tile_X0Y0_FrameStrobe[3] latch
XFILLER_17_1023 VPWR VGND sg13cmos5l_decap_8
XFILLER_17_1034 VPWR VGND sg13cmos5l_fill_1
XFILLER_14_1944 VPWR VGND sg13cmos5l_decap_8
XANTENNA__1048__X Tile_X1Y0_FrameStrobe_O[0] VPWR VGND sg13cmos5l_antennanp
XANTENNA__0887__X Tile_X4Y0_NN4BEG[3] VPWR VGND sg13cmos5l_antennanp
XFILLER_3_1880 VPWR VGND sg13cmos5l_decap_8
XFILLER_15_704 VPWR VGND sg13cmos5l_fill_1
XFILLER_10_420 VPWR VGND sg13cmos5l_decap_8
XFILLER_13_2122 VPWR VGND sg13cmos5l_decap_8
XFILLER_11_943 VPWR VGND sg13cmos5l_decap_8
XANTENNA__0571__Q NPU_ADDR7 VPWR VGND sg13cmos5l_antennanp
XFILLER_6_402 VPWR VGND sg13cmos5l_decap_8
XFILLER_6_435 VPWR VGND sg13cmos5l_decap_8
XFILLER_13_2188 VPWR VGND sg13cmos5l_decap_4
XFILLER_13_1465 VPWR VGND sg13cmos5l_decap_8
XANTENNA__0797__X Tile_X4Y0_FrameData_O[1] VPWR VGND sg13cmos5l_antennanp
XFILLER_2_685 VPWR VGND sg13cmos5l_decap_8
XFILLER_1_140 VPWR VGND sg13cmos5l_decap_8
XFILLER_2_696 VPWR VGND sg13cmos5l_fill_1
XFILLER_4_1611 VPWR VGND sg13cmos5l_decap_8
X_0110_ _0110_/Q Tile_X0Y0_FrameData[11] VGND VPWR Tile_X0Y0_FrameStrobe[0] latch
XFILLER_8_1791 VPWR VGND sg13cmos5l_decap_8
XFILLER_4_2367 VPWR VGND sg13cmos5l_decap_8
X_1090_ _1090_/X Tile_X2Y0_S1END[1] Tile_X2Y0_S2MID[2] Tile_X2Y0_S2MID[5] Tile_X2Y0_S2END[2]
+ _0319_/Q _0318_/Q VPWR VGND sg13cmos5l_mux4_1
XFILLER_4_1699 VPWR VGND sg13cmos5l_decap_8
XFILLER_18_2033 VPWR VGND sg13cmos5l_fill_1
XFILLER_18_2099 VPWR VGND sg13cmos5l_decap_8
X_0943_ Tile_X3Y0_N4BEG[3] _1267_/X VPWR VGND sg13cmos5l_buf_1
XFILLER_18_1376 VPWR VGND sg13cmos5l_decap_4
X_0874_ Tile_X4Y0_N4BEG[6] Tile_X4Y0_S4END[9] VPWR VGND sg13cmos5l_buf_1
XFILLER_9_2223 VPWR VGND sg13cmos5l_fill_1
XFILLER_9_2234 VPWR VGND sg13cmos5l_decap_8
XFILLER_9_1533 VPWR VGND sg13cmos5l_decap_8
X_0308_ _0308_/Q Tile_X0Y0_FrameData[21] VGND VPWR Tile_X1Y0_FrameStrobe[3] latch
X_1288_ _1288_/X Tile_X3Y0_S2END[0] Tile_X3Y0_S4END[8] Tile_X3Y0_SS4END[7] _0577_/Q
+ _0441_/Q _0440_/Q VPWR VGND sg13cmos5l_mux4_1
XFILLER_3_1143 VPWR VGND sg13cmos5l_decap_8
X_0239_ _0239_/Q Tile_X0Y0_FrameData[26] VGND VPWR Tile_X1Y0_FrameStrobe[1] latch
XFILLER_10_2306 VPWR VGND sg13cmos5l_decap_8
XFILLER_10_1649 VPWR VGND sg13cmos5l_fill_2
XFILLER_14_1796 VPWR VGND sg13cmos5l_decap_8
XFILLER_3_438 VPWR VGND sg13cmos5l_decap_8
XFILLER_8_1032 VPWR VGND sg13cmos5l_fill_1
XFILLER_8_1065 VPWR VGND sg13cmos5l_decap_8
XFILLER_5_1942 VPWR VGND sg13cmos5l_decap_8
XANTENNA__0566__Q NPU_ADDR2 VPWR VGND sg13cmos5l_antennanp
XFILLER_1_1806 VPWR VGND sg13cmos5l_decap_8
XFILLER_15_501 VPWR VGND sg13cmos5l_decap_8
XFILLER_15_545 VPWR VGND sg13cmos5l_decap_8
XFILLER_15_589 VPWR VGND sg13cmos5l_decap_4
XFILLER_7_700 VPWR VGND sg13cmos5l_decap_8
XFILLER_6_210 VPWR VGND sg13cmos5l_decap_8
XFILLER_7_777 VPWR VGND sg13cmos5l_decap_8
XFILLER_7_755 VPWR VGND sg13cmos5l_fill_1
X_0590_ _0590_/Q Tile_X0Y0_UserCLK NPU_RDATA18 _0606_/L_HI VPWR VGND sg13cmos5l_dfrbpq_1
XFILLER_6_298 VPWR VGND sg13cmos5l_decap_4
XFILLER_6_2407 VPWR VGND sg13cmos5l_decap_8
XFILLER_3_961 VPWR VGND sg13cmos5l_decap_8
XFILLER_2_482 VPWR VGND sg13cmos5l_decap_8
X_1211_ _1211_/X Tile_X1Y0_S2END[3] Tile_X1Y0_S4END[11] Tile_X1Y0_SS4END[4] _0592_/Q
+ _0243_/Q _0242_/Q VPWR VGND sg13cmos5l_mux4_1
XFILLER_6_1728 VPWR VGND sg13cmos5l_decap_8
XFILLER_4_2164 VPWR VGND sg13cmos5l_decap_8
XFILLER_0_2017 VPWR VGND sg13cmos5l_decap_8
XFILLER_0_2028 VPWR VGND sg13cmos5l_fill_1
X_1142_ _1142_/X Tile_X0Y0_S1END[2] Tile_X0Y0_S2MID[6] Tile_X0Y0_S2END[1] _0602_/Q
+ _0189_/Q _0188_/Q VPWR VGND sg13cmos5l_mux4_1
XFILLER_1_42 VPWR VGND sg13cmos5l_decap_8
XFILLER_0_1316 VPWR VGND sg13cmos5l_decap_4
X_1073_ Tile_X2Y0_N2BEG[5] Tile_X2Y0_S2MID[2] VPWR VGND sg13cmos5l_buf_1
XFILLER_4_1485 VPWR VGND sg13cmos5l_decap_8
XFILLER_0_1349 VPWR VGND sg13cmos5l_decap_8
XANTENNA__0990__X Tile_X2Y0_FrameStrobe_O[18] VPWR VGND sg13cmos5l_antennanp
XANTENNA_190 Tile_X0Y0_FrameData[22] VPWR VGND sg13cmos5l_antennanp
X_0926_ Tile_X3Y0_N2BEG[2] Tile_X3Y0_S2MID[5] VPWR VGND sg13cmos5l_buf_1
X_0857_ Tile_X4Y0_N2BEG[5] Tile_X4Y0_S2MID[2] VPWR VGND sg13cmos5l_buf_1
XFILLER_11_1936 VPWR VGND sg13cmos5l_decap_8
X_0788_ Tile_X2Y0_NN4BEG[8] _1248_/X VPWR VGND sg13cmos5l_buf_1
XFILLER_0_419 VPWR VGND sg13cmos5l_fill_2
XFILLER_9_2020 VPWR VGND sg13cmos5l_decap_8
XFILLER_9_2097 VPWR VGND sg13cmos5l_decap_8
XFILLER_5_1205 VPWR VGND sg13cmos5l_decap_4
XFILLER_5_1216 VPWR VGND sg13cmos5l_decap_8
XANTENNA__1061__X Tile_X1Y0_FrameStrobe_O[13] VPWR VGND sg13cmos5l_antennanp
XFILLER_0_1883 VPWR VGND sg13cmos5l_decap_8
XFILLER_12_504 VPWR VGND sg13cmos5l_decap_8
XFILLER_16_1836 VPWR VGND sg13cmos5l_decap_8
XFILLER_14_2250 VPWR VGND sg13cmos5l_decap_8
XFILLER_10_2125 VPWR VGND sg13cmos5l_decap_8
XFILLER_10_1446 VPWR VGND sg13cmos5l_decap_8
XFILLER_4_736 VPWR VGND sg13cmos5l_decap_8
XFILLER_3_224 VPWR VGND sg13cmos5l_decap_8
XFILLER_5_1783 VPWR VGND sg13cmos5l_fill_1
XFILLER_5_1772 VPWR VGND sg13cmos5l_decap_8
XFILLER_1_2359 VPWR VGND sg13cmos5l_decap_8
XFILLER_1_1647 VPWR VGND sg13cmos5l_decap_8
XFILLER_16_832 VPWR VGND sg13cmos5l_fill_2
XFILLER_16_854 VPWR VGND sg13cmos5l_fill_2
XFILLER_16_887 VPWR VGND sg13cmos5l_decap_8
XFILLER_15_2003 VPWR VGND sg13cmos5l_decap_8
X_0711_ Tile_X0Y0_FrameStrobe_O[3] Tile_X0Y0_FrameStrobe[3] VPWR VGND sg13cmos5l_buf_1
XFILLER_7_541 VPWR VGND sg13cmos5l_decap_8
XFILLER_11_581 VPWR VGND sg13cmos5l_decap_4
X_0642_ _0642_/L_HI VPWR VGND sg13cmos5l_tiehi
X_0573_ _0573_/Q Tile_X0Y0_UserCLK NPU_RDATA1 _0649_/L_HI VPWR VGND sg13cmos5l_dfrbpq_1
XFILLER_3_780 VPWR VGND sg13cmos5l_decap_8
XANTENNA__0985__X Tile_X2Y0_FrameStrobe_O[13] VPWR VGND sg13cmos5l_antennanp
XFILLER_6_1569 VPWR VGND sg13cmos5l_decap_8
X_1125_ _1125_/X Tile_X0Y0_S4END[4] Tile_X0Y0_S4END[7] Tile_X0Y0_SS4END[5] Tile_X0Y0_SS4END[7]
+ _0105_/Q _0104_/Q VPWR VGND sg13cmos5l_mux4_1
XFILLER_4_1282 VPWR VGND sg13cmos5l_decap_8
XFILLER_0_1157 VPWR VGND sg13cmos5l_decap_8
X_1056_ Tile_X1Y0_FrameStrobe_O[8] Tile_X1Y0_FrameStrobe[8] VPWR VGND sg13cmos5l_buf_1
X_0909_ Tile_X3Y0_FrameStrobe_O[9] Tile_X3Y0_FrameStrobe[9] VPWR VGND sg13cmos5l_buf_1
XFILLER_11_1766 VPWR VGND sg13cmos5l_decap_8
XANTENNA__1056__X Tile_X1Y0_FrameStrobe_O[8] VPWR VGND sg13cmos5l_antennanp
XANTENNA__0895__X Tile_X4Y0_NN4BEG[11] VPWR VGND sg13cmos5l_antennanp
XFILLER_9_1193 VPWR VGND sg13cmos5l_decap_8
XFILLER_5_1057 VPWR VGND sg13cmos5l_decap_8
XFILLER_2_1956 VPWR VGND sg13cmos5l_decap_8
XFILLER_0_1680 VPWR VGND sg13cmos5l_decap_4
XFILLER_16_2323 VPWR VGND sg13cmos5l_decap_8
XFILLER_13_813 VPWR VGND sg13cmos5l_fill_1
XFILLER_16_1611 VPWR VGND sg13cmos5l_fill_2
XFILLER_13_868 VPWR VGND sg13cmos5l_fill_2
XFILLER_16_1655 VPWR VGND sg13cmos5l_fill_2
XFILLER_12_1508 VPWR VGND sg13cmos5l_decap_4
XANTENNA_90 Tile_X0Y0_FrameData[21] VPWR VGND sg13cmos5l_antennanp
XFILLER_4_533 VPWR VGND sg13cmos5l_decap_8
XFILLER_0_750 VPWR VGND sg13cmos5l_decap_8
XFILLER_7_1812 VPWR VGND sg13cmos5l_decap_4
XFILLER_7_1801 VPWR VGND sg13cmos5l_decap_8
XFILLER_0_761 VPWR VGND sg13cmos5l_fill_2
XFILLER_7_1889 VPWR VGND sg13cmos5l_decap_8
XFILLER_7_1878 VPWR VGND sg13cmos5l_fill_1
XFILLER_5_2292 VPWR VGND sg13cmos5l_decap_8
XFILLER_1_1400 VPWR VGND sg13cmos5l_fill_2
XFILLER_1_1444 VPWR VGND sg13cmos5l_decap_8
XFILLER_17_2109 VPWR VGND sg13cmos5l_fill_2
XFILLER_16_651 VPWR VGND sg13cmos5l_decap_8
XFILLER_16_662 VPWR VGND sg13cmos5l_decap_8
XFILLER_15_1110 VPWR VGND sg13cmos5l_decap_8
XFILLER_8_883 VPWR VGND sg13cmos5l_decap_8
XFILLER_7_63 VPWR VGND sg13cmos5l_decap_8
X_0625_ _0625_/L_HI VPWR VGND sg13cmos5l_tiehi
X_0556_ NPU_WE0 Tile_X0Y0_UserCLK _0556_/D _0671_/L_HI VPWR VGND sg13cmos5l_dfrbpq_1
XFILLER_6_2023 VPWR VGND sg13cmos5l_decap_8
X_0487_ _0487_/Q Tile_X0Y0_FrameData[18] VGND VPWR Tile_X3Y0_FrameStrobe[2] latch
XFILLER_6_1366 VPWR VGND sg13cmos5l_decap_8
XFILLER_2_1219 VPWR VGND sg13cmos5l_decap_4
X_1108_ _1108_/X Tile_X1Y0_S4END[8] Tile_X1Y0_S4END[9] Tile_X1Y0_SS4END[8] Tile_X1Y0_SS4END[10]
+ _0219_/Q _0218_/Q VPWR VGND sg13cmos5l_mux4_1
X_1039_ Tile_X1Y0_N2BEG[3] Tile_X1Y0_S2MID[4] VPWR VGND sg13cmos5l_buf_1
XFILLER_17_1953 VPWR VGND sg13cmos5l_fill_1
XFILLER_10_838 VPWR VGND sg13cmos5l_decap_4
XFILLER_11_2242 VPWR VGND sg13cmos5l_decap_8
XFILLER_1_525 VPWR VGND sg13cmos5l_decap_8
XFILLER_2_1753 VPWR VGND sg13cmos5l_decap_8
XFILLER_17_459 VPWR VGND sg13cmos5l_decap_8
XFILLER_16_61 VPWR VGND sg13cmos5l_decap_4
XFILLER_16_2142 VPWR VGND sg13cmos5l_decap_8
XFILLER_12_2017 VPWR VGND sg13cmos5l_decap_8
XFILLER_12_186 VPWR VGND sg13cmos5l_fill_1
XFILLER_12_175 VPWR VGND sg13cmos5l_decap_8
XFILLER_8_168 VPWR VGND sg13cmos5l_decap_8
XFILLER_16_1496 VPWR VGND sg13cmos5l_decap_8
XFILLER_10_1073 VPWR VGND sg13cmos5l_decap_4
XFILLER_10_1095 VPWR VGND sg13cmos5l_fill_2
XFILLER_9_1929 VPWR VGND sg13cmos5l_decap_8
X_0410_ _0410_/Q Tile_X0Y0_FrameData[31] VGND VPWR Tile_X2Y0_FrameStrobe[0] latch
X_0341_ _0341_/Q Tile_X0Y0_FrameData[4] VGND VPWR Tile_X2Y0_FrameStrobe[0] latch
XFILLER_7_2354 VPWR VGND sg13cmos5l_decap_8
XFILLER_7_1620 VPWR VGND sg13cmos5l_fill_1
X_0272_ _0272_/Q Tile_X0Y0_FrameData[25] VGND VPWR Tile_X1Y0_FrameStrobe[2] latch
XFILLER_3_1539 VPWR VGND sg13cmos5l_decap_8
XFILLER_17_982 VPWR VGND sg13cmos5l_decap_8
X_0608_ _0608_/L_HI VPWR VGND sg13cmos5l_tiehi
XFILLER_8_2129 VPWR VGND sg13cmos5l_decap_8
XFILLER_8_1406 VPWR VGND sg13cmos5l_decap_8
X_0539_ NPU_WDATA15 Tile_X0Y0_UserCLK _1116_/X _0662_/L_HI VPWR VGND sg13cmos5l_dfrbpq_1
XFILLER_6_1130 VPWR VGND sg13cmos5l_decap_8
XFILLER_2_1038 VPWR VGND sg13cmos5l_decap_8
XFILLER_13_2337 VPWR VGND sg13cmos5l_decap_8
XFILLER_6_617 VPWR VGND sg13cmos5l_decap_8
XFILLER_10_679 VPWR VGND sg13cmos5l_decap_8
XFILLER_5_105 VPWR VGND sg13cmos5l_decap_8
XFILLER_11_2083 VPWR VGND sg13cmos5l_decap_8
XFILLER_11_1382 VPWR VGND sg13cmos5l_decap_8
XFILLER_2_834 VPWR VGND sg13cmos5l_decap_4
XANTENNA__0569__Q NPU_ADDR5 VPWR VGND sg13cmos5l_antennanp
XFILLER_8_1940 VPWR VGND sg13cmos5l_decap_8
XFILLER_17_201 VPWR VGND sg13cmos5l_fill_2
XFILLER_2_2295 VPWR VGND sg13cmos5l_decap_8
XFILLER_18_746 VPWR VGND sg13cmos5l_decap_8
XFILLER_2_1561 VPWR VGND sg13cmos5l_decap_8
XFILLER_14_930 VPWR VGND sg13cmos5l_decap_8
XFILLER_18_1525 VPWR VGND sg13cmos5l_decap_8
X_0890_ Tile_X4Y0_NN4BEG[6] Tile_X4Y0_SS4END[9] VPWR VGND sg13cmos5l_buf_1
XFILLER_18_1558 VPWR VGND sg13cmos5l_decap_4
XFILLER_13_495 VPWR VGND sg13cmos5l_decap_8
XFILLER_16_1282 VPWR VGND sg13cmos5l_fill_2
XFILLER_12_1135 VPWR VGND sg13cmos5l_fill_2
XFILLER_9_2416 VPWR VGND sg13cmos5l_fill_2
XFILLER_4_42 VPWR VGND sg13cmos5l_decap_8
XFILLER_4_182 VPWR VGND sg13cmos5l_decap_8
X_0324_ _0324_/Q Tile_X0Y0_FrameData[21] VGND VPWR Tile_X2Y0_FrameStrobe[0] latch
XFILLER_7_1450 VPWR VGND sg13cmos5l_decap_8
XFILLER_3_2048 VPWR VGND sg13cmos5l_decap_8
XANTENNA__0993__X Tile_X2Y0_N1BEG[1] VPWR VGND sg13cmos5l_antennanp
X_0255_ _0255_/Q Tile_X0Y0_FrameData[10] VGND VPWR Tile_X1Y0_FrameStrobe[1] latch
XFILLER_3_1336 VPWR VGND sg13cmos5l_decap_8
X_0186_ _0186_/Q Tile_X0Y0_FrameData[31] VGND VPWR Tile_X0Y0_FrameStrobe[3] latch
XFILLER_14_1923 VPWR VGND sg13cmos5l_decap_8
XFILLER_2_119 VPWR VGND sg13cmos5l_decap_8
XFILLER_8_1225 VPWR VGND sg13cmos5l_decap_4
XANTENNA__1064__X Tile_X1Y0_FrameStrobe_O[16] VPWR VGND sg13cmos5l_antennanp
XFILLER_8_1258 VPWR VGND sg13cmos5l_decap_4
XFILLER_14_204 VPWR VGND sg13cmos5l_fill_1
XFILLER_14_226 VPWR VGND sg13cmos5l_decap_8
XFILLER_13_2101 VPWR VGND sg13cmos5l_decap_8
XFILLER_13_40 VPWR VGND sg13cmos5l_fill_2
XFILLER_10_487 VPWR VGND sg13cmos5l_decap_8
XFILLER_7_959 VPWR VGND sg13cmos5l_decap_8
XFILLER_13_73 VPWR VGND sg13cmos5l_decap_8
XFILLER_13_1444 VPWR VGND sg13cmos5l_decap_8
XFILLER_11_999 VPWR VGND sg13cmos5l_decap_8
XFILLER_8_0 VPWR VGND sg13cmos5l_decap_8
XFILLER_2_664 VPWR VGND sg13cmos5l_decap_8
XFILLER_8_1770 VPWR VGND sg13cmos5l_decap_8
XFILLER_4_2346 VPWR VGND sg13cmos5l_decap_8
XFILLER_1_196 VPWR VGND sg13cmos5l_decap_8
XFILLER_4_1678 VPWR VGND sg13cmos5l_decap_8
XFILLER_4_1667 VPWR VGND sg13cmos5l_decap_8
XFILLER_18_532 VPWR VGND sg13cmos5l_fill_1
XFILLER_2_2081 VPWR VGND sg13cmos5l_decap_8
XFILLER_18_2056 VPWR VGND sg13cmos5l_decap_8
XFILLER_18_1311 VPWR VGND sg13cmos5l_decap_4
XFILLER_18_2078 VPWR VGND sg13cmos5l_decap_8
XFILLER_18_1355 VPWR VGND sg13cmos5l_decap_8
XFILLER_9_252 VPWR VGND sg13cmos5l_fill_2
X_0942_ Tile_X3Y0_N4BEG[2] _1266_/X VPWR VGND sg13cmos5l_buf_1
X_0873_ Tile_X4Y0_N4BEG[5] Tile_X4Y0_S4END[10] VPWR VGND sg13cmos5l_buf_1
XANTENNA__0988__X Tile_X2Y0_FrameStrobe_O[16] VPWR VGND sg13cmos5l_antennanp
X_0307_ _0307_/Q Tile_X0Y0_FrameData[22] VGND VPWR Tile_X1Y0_FrameStrobe[3] latch
X_1287_ _1287_/X Tile_X3Y0_S2END[7] Tile_X3Y0_S4END[7] Tile_X3Y0_SS4END[8] _0574_/Q
+ _0443_/Q _0442_/Q VPWR VGND sg13cmos5l_mux4_1
XFILLER_3_1122 VPWR VGND sg13cmos5l_decap_8
X_0238_ _0238_/Q Tile_X0Y0_FrameData[27] VGND VPWR Tile_X1Y0_FrameStrobe[1] latch
X_0169_ _0169_/Q Tile_X0Y0_FrameData[16] VGND VPWR Tile_X0Y0_FrameStrobe[2] latch
XFILLER_12_719 VPWR VGND sg13cmos5l_decap_8
XANTENNA__1059__X Tile_X1Y0_FrameStrobe_O[11] VPWR VGND sg13cmos5l_antennanp
XFILLER_10_1617 VPWR VGND sg13cmos5l_fill_1
XFILLER_14_1775 VPWR VGND sg13cmos5l_decap_8
XFILLER_14_1764 VPWR VGND sg13cmos5l_fill_1
XANTENNA__0898__X Tile_X4Y0_NN4BEG[14] VPWR VGND sg13cmos5l_antennanp
XFILLER_3_417 VPWR VGND sg13cmos5l_decap_8
XFILLER_1_7 VPWR VGND sg13cmos5l_decap_8
XFILLER_8_1044 VPWR VGND sg13cmos5l_decap_8
XFILLER_8_1099 VPWR VGND sg13cmos5l_decap_8
XFILLER_5_1921 VPWR VGND sg13cmos5l_decap_8
XFILLER_5_1998 VPWR VGND sg13cmos5l_decap_8
XFILLER_15_579 VPWR VGND sg13cmos5l_decap_4
XFILLER_15_568 VPWR VGND sg13cmos5l_decap_8
XFILLER_15_1517 VPWR VGND sg13cmos5l_fill_1
XFILLER_11_741 VPWR VGND sg13cmos5l_fill_1
XFILLER_11_730 VPWR VGND sg13cmos5l_decap_8
XFILLER_10_251 VPWR VGND sg13cmos5l_fill_2
XFILLER_7_734 VPWR VGND sg13cmos5l_decap_8
XFILLER_11_774 VPWR VGND sg13cmos5l_fill_2
XFILLER_10_284 VPWR VGND sg13cmos5l_fill_1
XFILLER_6_266 VPWR VGND sg13cmos5l_decap_8
XFILLER_3_940 VPWR VGND sg13cmos5l_decap_8
XFILLER_2_461 VPWR VGND sg13cmos5l_decap_8
X_1210_ _1210_/X Tile_X1Y0_S2END[2] Tile_X1Y0_S4END[10] Tile_X1Y0_SS4END[5] _0593_/Q
+ _0245_/Q _0244_/Q VPWR VGND sg13cmos5l_mux4_1
X_1141_ _1141_/X Tile_X0Y0_S1END[1] Tile_X0Y0_S2MID[5] Tile_X0Y0_S2END[2] _0601_/Q
+ _0191_/Q _0190_/Q VPWR VGND sg13cmos5l_mux4_1
XFILLER_4_2143 VPWR VGND sg13cmos5l_decap_8
XFILLER_1_21 VPWR VGND sg13cmos5l_decap_8
X_1072_ Tile_X2Y0_N2BEG[4] Tile_X2Y0_S2MID[3] VPWR VGND sg13cmos5l_buf_1
XFILLER_4_1464 VPWR VGND sg13cmos5l_decap_8
XFILLER_1_98 VPWR VGND sg13cmos5l_decap_8
XFILLER_0_1339 VPWR VGND sg13cmos5l_decap_4
XFILLER_18_384 VPWR VGND sg13cmos5l_decap_8
XANTENNA_180 NPU_RDATA11 VPWR VGND sg13cmos5l_antennanp
XANTENNA_191 Tile_X0Y0_FrameData[22] VPWR VGND sg13cmos5l_antennanp
XFILLER_18_1163 VPWR VGND sg13cmos5l_fill_1
X_0925_ Tile_X3Y0_N2BEG[1] Tile_X3Y0_S2MID[6] VPWR VGND sg13cmos5l_buf_1
XFILLER_14_1049 VPWR VGND sg13cmos5l_decap_8
XFILLER_11_1915 VPWR VGND sg13cmos5l_decap_8
X_0856_ Tile_X4Y0_N2BEG[4] Tile_X4Y0_S2MID[3] VPWR VGND sg13cmos5l_buf_1
X_0787_ Tile_X2Y0_NN4BEG[7] _1247_/X VPWR VGND sg13cmos5l_buf_1
XFILLER_9_1331 VPWR VGND sg13cmos5l_fill_1
XFILLER_9_2076 VPWR VGND sg13cmos5l_decap_8
XFILLER_9_1397 VPWR VGND sg13cmos5l_decap_8
XFILLER_0_1873 VPWR VGND sg13cmos5l_decap_4
XFILLER_12_538 VPWR VGND sg13cmos5l_decap_8
XFILLER_10_2104 VPWR VGND sg13cmos5l_decap_8
XFILLER_10_1425 VPWR VGND sg13cmos5l_decap_8
XFILLER_4_715 VPWR VGND sg13cmos5l_decap_8
XFILLER_3_203 VPWR VGND sg13cmos5l_decap_8
XFILLER_10_63 VPWR VGND sg13cmos5l_decap_8
XFILLER_10_96 VPWR VGND sg13cmos5l_decap_8
XFILLER_0_987 VPWR VGND sg13cmos5l_decap_8
XFILLER_5_1751 VPWR VGND sg13cmos5l_decap_4
XFILLER_1_2338 VPWR VGND sg13cmos5l_decap_8
XFILLER_1_1626 VPWR VGND sg13cmos5l_decap_8
XFILLER_15_2059 VPWR VGND sg13cmos5l_fill_1
X_0710_ Tile_X0Y0_FrameStrobe_O[2] Tile_X0Y0_FrameStrobe[2] VPWR VGND sg13cmos5l_buf_1
XFILLER_7_520 VPWR VGND sg13cmos5l_decap_8
X_0641_ _0641_/L_HI VPWR VGND sg13cmos5l_tiehi
XFILLER_13_1082 VPWR VGND sg13cmos5l_fill_1
X_0572_ _0572_/Q Tile_X0Y0_UserCLK NPU_RDATA0 _0650_/L_HI VPWR VGND sg13cmos5l_dfrbpq_1
XFILLER_10_1992 VPWR VGND sg13cmos5l_decap_8
XFILLER_2_280 VPWR VGND sg13cmos5l_decap_8
XFILLER_6_1548 VPWR VGND sg13cmos5l_decap_8
XANTENNA__0689__L_LO Tile_X4Y0_Co VPWR VGND sg13cmos5l_antennanp
X_1124_ _1124_/X Tile_X0Y0_S4END[8] Tile_X0Y0_S4END[9] Tile_X0Y0_SS4END[8] Tile_X0Y0_SS4END[10]
+ _0107_/Q _0106_/Q VPWR VGND sg13cmos5l_mux4_1
XFILLER_4_1261 VPWR VGND sg13cmos5l_decap_8
XFILLER_0_1103 VPWR VGND sg13cmos5l_fill_2
X_1055_ Tile_X1Y0_FrameStrobe_O[7] Tile_X1Y0_FrameStrobe[7] VPWR VGND sg13cmos5l_buf_1
XFILLER_0_1147 VPWR VGND sg13cmos5l_decap_4
XFILLER_18_192 VPWR VGND sg13cmos5l_fill_2
XFILLER_18_181 VPWR VGND sg13cmos5l_decap_8
X_0908_ Tile_X3Y0_FrameStrobe_O[8] Tile_X3Y0_FrameStrobe[8] VPWR VGND sg13cmos5l_buf_1
XFILLER_15_1881 VPWR VGND sg13cmos5l_decap_8
XFILLER_11_1756 VPWR VGND sg13cmos5l_fill_2
X_0839_ Tile_X4Y0_FrameStrobe_O[11] Tile_X4Y0_FrameStrobe[11] VPWR VGND sg13cmos5l_buf_1
XFILLER_1_718 VPWR VGND sg13cmos5l_decap_4
XFILLER_1_707 VPWR VGND sg13cmos5l_decap_8
XFILLER_9_1150 VPWR VGND sg13cmos5l_fill_1
XFILLER_9_1161 VPWR VGND sg13cmos5l_decap_8
XANTENNA__1072__X Tile_X2Y0_N2BEG[4] VPWR VGND sg13cmos5l_antennanp
XFILLER_5_1036 VPWR VGND sg13cmos5l_decap_8
XFILLER_2_1935 VPWR VGND sg13cmos5l_decap_8
XFILLER_17_608 VPWR VGND sg13cmos5l_fill_2
XFILLER_0_2382 VPWR VGND sg13cmos5l_fill_1
XFILLER_16_2302 VPWR VGND sg13cmos5l_decap_4
XFILLER_9_818 VPWR VGND sg13cmos5l_fill_1
XFILLER_16_2379 VPWR VGND sg13cmos5l_decap_8
XFILLER_14_2081 VPWR VGND sg13cmos5l_decap_8
XANTENNA_80 Tile_X0Y0_FrameData[21] VPWR VGND sg13cmos5l_antennanp
XANTENNA_91 Tile_X0Y0_FrameData[26] VPWR VGND sg13cmos5l_antennanp
XFILLER_4_512 VPWR VGND sg13cmos5l_decap_8
XFILLER_10_1299 VPWR VGND sg13cmos5l_decap_4
XFILLER_4_589 VPWR VGND sg13cmos5l_decap_8
XFILLER_5_2271 VPWR VGND sg13cmos5l_decap_8
XFILLER_1_2146 VPWR VGND sg13cmos5l_decap_8
XFILLER_5_1592 VPWR VGND sg13cmos5l_decap_8
XFILLER_1_1423 VPWR VGND sg13cmos5l_decap_8
XFILLER_1_1412 VPWR VGND sg13cmos5l_fill_1
XFILLER_15_151 VPWR VGND sg13cmos5l_fill_2
XFILLER_12_891 VPWR VGND sg13cmos5l_fill_2
XFILLER_12_880 VPWR VGND sg13cmos5l_decap_4
XFILLER_7_42 VPWR VGND sg13cmos5l_decap_8
X_0624_ _0624_/L_HI VPWR VGND sg13cmos5l_tiehi
XANTENNA__0996__X Tile_X1Y0_NN4BEG[0] VPWR VGND sg13cmos5l_antennanp
X_0555_ NPU_WDATA31 Tile_X0Y0_UserCLK _1132_/X _0678_/L_HI VPWR VGND sg13cmos5l_dfrbpq_1
XFILLER_6_2002 VPWR VGND sg13cmos5l_decap_8
X_0486_ _0486_/Q Tile_X0Y0_FrameData[19] VGND VPWR Tile_X3Y0_FrameStrobe[2] latch
XFILLER_6_2079 VPWR VGND sg13cmos5l_decap_8
XFILLER_6_1345 VPWR VGND sg13cmos5l_decap_8
X_1107_ _1107_/X Tile_X1Y0_S4END[9] Tile_X1Y0_S4END[10] Tile_X1Y0_SS4END[9] Tile_X1Y0_SS4END[11]
+ _0221_/Q _0220_/Q VPWR VGND sg13cmos5l_mux4_1
XFILLER_4_1091 VPWR VGND sg13cmos5l_decap_8
X_1038_ Tile_X1Y0_N2BEG[2] Tile_X1Y0_S2MID[5] VPWR VGND sg13cmos5l_buf_1
XFILLER_17_1987 VPWR VGND sg13cmos5l_decap_8
XFILLER_17_1965 VPWR VGND sg13cmos5l_fill_2
XFILLER_17_1998 VPWR VGND sg13cmos5l_decap_4
XANTENNA__1067__X Tile_X1Y0_FrameStrobe_O[19] VPWR VGND sg13cmos5l_antennanp
XFILLER_11_2298 VPWR VGND sg13cmos5l_decap_8
XFILLER_1_504 VPWR VGND sg13cmos5l_decap_8
XFILLER_7_1109 VPWR VGND sg13cmos5l_decap_8
XFILLER_2_2400 VPWR VGND sg13cmos5l_decap_8
XFILLER_6_1890 VPWR VGND sg13cmos5l_decap_8
XFILLER_2_1732 VPWR VGND sg13cmos5l_decap_8
XFILLER_17_438 VPWR VGND sg13cmos5l_decap_8
XFILLER_18_1718 VPWR VGND sg13cmos5l_decap_8
XFILLER_8_103 VPWR VGND sg13cmos5l_fill_2
XFILLER_8_114 VPWR VGND sg13cmos5l_fill_1
XFILLER_16_2198 VPWR VGND sg13cmos5l_decap_8
XFILLER_8_147 VPWR VGND sg13cmos5l_decap_8
XFILLER_16_1475 VPWR VGND sg13cmos5l_decap_8
XFILLER_12_198 VPWR VGND sg13cmos5l_decap_8
XFILLER_5_810 VPWR VGND sg13cmos5l_decap_8
XFILLER_10_1052 VPWR VGND sg13cmos5l_decap_8
XFILLER_9_1908 VPWR VGND sg13cmos5l_decap_8
X_0340_ _0340_/Q Tile_X0Y0_FrameData[5] VGND VPWR Tile_X2Y0_FrameStrobe[0] latch
XFILLER_7_2333 VPWR VGND sg13cmos5l_decap_8
XFILLER_0_581 VPWR VGND sg13cmos5l_decap_8
X_0271_ _0271_/Q Tile_X0Y0_FrameData[26] VGND VPWR Tile_X1Y0_FrameStrobe[2] latch
XFILLER_3_1518 VPWR VGND sg13cmos5l_decap_8
XFILLER_17_961 VPWR VGND sg13cmos5l_decap_8
XFILLER_16_482 VPWR VGND sg13cmos5l_decap_8
XFILLER_7_191 VPWR VGND sg13cmos5l_decap_8
XFILLER_12_1884 VPWR VGND sg13cmos5l_decap_8
XFILLER_8_2108 VPWR VGND sg13cmos5l_decap_8
X_0607_ _0607_/L_HI VPWR VGND sg13cmos5l_tiehi
X_0538_ NPU_WDATA14 Tile_X0Y0_UserCLK _1115_/X _0663_/L_HI VPWR VGND sg13cmos5l_dfrbpq_1
X_0469_ _0469_/Q Tile_X0Y0_FrameData[4] VGND VPWR Tile_X3Y0_FrameStrobe[1] latch
XFILLER_6_1186 VPWR VGND sg13cmos5l_decap_4
XFILLER_2_1017 VPWR VGND sg13cmos5l_decap_8
XFILLER_10_603 VPWR VGND sg13cmos5l_decap_8
XFILLER_13_2316 VPWR VGND sg13cmos5l_decap_8
XFILLER_11_2062 VPWR VGND sg13cmos5l_decap_8
XFILLER_11_1361 VPWR VGND sg13cmos5l_decap_8
XFILLER_2_824 VPWR VGND sg13cmos5l_decap_8
XFILLER_1_356 VPWR VGND sg13cmos5l_decap_8
XFILLER_8_1996 VPWR VGND sg13cmos5l_decap_8
XFILLER_4_1805 VPWR VGND sg13cmos5l_fill_2
XFILLER_18_725 VPWR VGND sg13cmos5l_decap_8
XFILLER_2_2274 VPWR VGND sg13cmos5l_decap_8
XFILLER_2_1540 VPWR VGND sg13cmos5l_decap_8
XFILLER_18_769 VPWR VGND sg13cmos5l_decap_8
XFILLER_18_2227 VPWR VGND sg13cmos5l_decap_8
XFILLER_14_986 VPWR VGND sg13cmos5l_decap_8
XFILLER_13_474 VPWR VGND sg13cmos5l_decap_8
XFILLER_9_456 VPWR VGND sg13cmos5l_decap_8
XFILLER_12_1158 VPWR VGND sg13cmos5l_fill_1
XFILLER_5_695 VPWR VGND sg13cmos5l_fill_2
XFILLER_4_21 VPWR VGND sg13cmos5l_decap_8
XFILLER_4_161 VPWR VGND sg13cmos5l_decap_8
XFILLER_9_1727 VPWR VGND sg13cmos5l_fill_2
XFILLER_7_2174 VPWR VGND sg13cmos5l_decap_8
XFILLER_4_98 VPWR VGND sg13cmos5l_decap_8
X_0323_ _0323_/Q Tile_X0Y0_FrameData[22] VGND VPWR Tile_X2Y0_FrameStrobe[0] latch
XFILLER_3_2027 VPWR VGND sg13cmos5l_decap_8
X_0254_ _0254_/Q Tile_X0Y0_FrameData[11] VGND VPWR Tile_X1Y0_FrameStrobe[1] latch
XFILLER_3_1315 VPWR VGND sg13cmos5l_decap_8
X_0185_ _0185_/Q Tile_X0Y0_FrameData[0] VGND VPWR Tile_X0Y0_FrameStrobe[2] latch
XFILLER_1_1094 VPWR VGND sg13cmos5l_decap_8
XFILLER_14_1902 VPWR VGND sg13cmos5l_decap_8
XFILLER_12_2393 VPWR VGND sg13cmos5l_decap_8
XFILLER_8_1215 VPWR VGND sg13cmos5l_fill_2
XFILLER_8_1204 VPWR VGND sg13cmos5l_decap_8
XANTENNA__1080__X Tile_X2Y0_N2BEGb[4] VPWR VGND sg13cmos5l_antennanp
XFILLER_7_905 VPWR VGND sg13cmos5l_fill_2
XFILLER_17_1570 VPWR VGND sg13cmos5l_fill_1
XFILLER_7_938 VPWR VGND sg13cmos5l_decap_8
XFILLER_13_1423 VPWR VGND sg13cmos5l_decap_8
XFILLER_11_978 VPWR VGND sg13cmos5l_decap_8
XFILLER_11_1191 VPWR VGND sg13cmos5l_fill_1
XFILLER_2_643 VPWR VGND sg13cmos5l_decap_8
XFILLER_1_175 VPWR VGND sg13cmos5l_decap_8
XFILLER_4_2325 VPWR VGND sg13cmos5l_decap_8
XFILLER_4_1646 VPWR VGND sg13cmos5l_decap_8
XFILLER_2_2060 VPWR VGND sg13cmos5l_decap_8
XFILLER_18_2024 VPWR VGND sg13cmos5l_decap_8
X_0941_ Tile_X3Y0_N4BEG[1] _1265_/X VPWR VGND sg13cmos5l_buf_1
XFILLER_18_1334 VPWR VGND sg13cmos5l_decap_8
XFILLER_13_282 VPWR VGND sg13cmos5l_fill_1
XFILLER_13_271 VPWR VGND sg13cmos5l_decap_8
XFILLER_9_264 VPWR VGND sg13cmos5l_decap_8
X_0872_ Tile_X4Y0_N4BEG[4] Tile_X4Y0_S4END[11] VPWR VGND sg13cmos5l_buf_1
XFILLER_9_297 VPWR VGND sg13cmos5l_decap_4
XFILLER_5_492 VPWR VGND sg13cmos5l_decap_8
XFILLER_9_1502 VPWR VGND sg13cmos5l_decap_8
XFILLER_9_1513 VPWR VGND sg13cmos5l_fill_1
XFILLER_9_2269 VPWR VGND sg13cmos5l_decap_8
XFILLER_9_1568 VPWR VGND sg13cmos5l_fill_1
XFILLER_9_1579 VPWR VGND sg13cmos5l_decap_8
X_0306_ _0306_/Q Tile_X0Y0_FrameData[23] VGND VPWR Tile_X1Y0_FrameStrobe[3] latch
XFILLER_7_1270 VPWR VGND sg13cmos5l_decap_4
XFILLER_3_1101 VPWR VGND sg13cmos5l_decap_8
X_1286_ _1286_/X Tile_X3Y0_S2END[6] Tile_X3Y0_S4END[6] Tile_X3Y0_SS4END[9] _0575_/Q
+ _0445_/Q _0444_/Q VPWR VGND sg13cmos5l_mux4_1
X_0237_ _0237_/Q Tile_X0Y0_FrameData[28] VGND VPWR Tile_X1Y0_FrameStrobe[1] latch
X_0168_ _0168_/Q Tile_X0Y0_FrameData[17] VGND VPWR Tile_X0Y0_FrameStrobe[2] latch
X_0099_ _0099_/Q Tile_X0Y0_FrameData[22] VGND VPWR Tile_X0Y0_FrameStrobe[0] latch
XFILLER_11_219 VPWR VGND sg13cmos5l_fill_1
XANTENNA__1075__X Tile_X2Y0_N2BEG[7] VPWR VGND sg13cmos5l_antennanp
XFILLER_8_1023 VPWR VGND sg13cmos5l_decap_8
XFILLER_5_1900 VPWR VGND sg13cmos5l_decap_8
XFILLER_5_1977 VPWR VGND sg13cmos5l_decap_8
XFILLER_3_2391 VPWR VGND sg13cmos5l_decap_8
XFILLER_11_797 VPWR VGND sg13cmos5l_decap_8
XFILLER_6_245 VPWR VGND sg13cmos5l_decap_8
XFILLER_13_1264 VPWR VGND sg13cmos5l_fill_2
XFILLER_2_440 VPWR VGND sg13cmos5l_decap_8
XFILLER_3_996 VPWR VGND sg13cmos5l_decap_8
XFILLER_4_2122 VPWR VGND sg13cmos5l_decap_8
X_1140_ _1140_/X Tile_X0Y0_S1END[0] Tile_X0Y0_S2MID[4] Tile_X0Y0_S2END[3] _0600_/Q
+ _0193_/Q _0192_/Q VPWR VGND sg13cmos5l_mux4_1
XFILLER_4_1443 VPWR VGND sg13cmos5l_decap_8
X_1071_ Tile_X2Y0_N2BEG[3] Tile_X2Y0_S2MID[4] VPWR VGND sg13cmos5l_buf_1
XFILLER_4_2199 VPWR VGND sg13cmos5l_decap_8
XFILLER_1_77 VPWR VGND sg13cmos5l_decap_8
XFILLER_18_363 VPWR VGND sg13cmos5l_fill_2
XANTENNA_170 Tile_X0Y0_FrameData[31] VPWR VGND sg13cmos5l_antennanp
XANTENNA_181 NPU_RDATA14 VPWR VGND sg13cmos5l_antennanp
XANTENNA_192 Tile_X0Y0_FrameData[22] VPWR VGND sg13cmos5l_antennanp
XFILLER_18_1142 VPWR VGND sg13cmos5l_fill_1
X_0924_ Tile_X3Y0_N2BEG[0] Tile_X3Y0_S2MID[7] VPWR VGND sg13cmos5l_buf_1
XFILLER_14_1028 VPWR VGND sg13cmos5l_decap_8
XANTENNA__0999__X Tile_X1Y0_NN4BEG[3] VPWR VGND sg13cmos5l_antennanp
X_0855_ Tile_X4Y0_N2BEG[3] Tile_X4Y0_S2MID[4] VPWR VGND sg13cmos5l_buf_1
X_0786_ Tile_X2Y0_NN4BEG[6] _1246_/X VPWR VGND sg13cmos5l_buf_1
XFILLER_9_2055 VPWR VGND sg13cmos5l_decap_8
XFILLER_9_1376 VPWR VGND sg13cmos5l_decap_8
X_1269_ _1269_/X Tile_X3Y0_S2MID[5] Tile_X3Y0_S4END[10] Tile_X3Y0_SS4END[5] _0575_/Q
+ _0479_/Q _0478_/Q VPWR VGND sg13cmos5l_mux4_1
XFILLER_16_1805 VPWR VGND sg13cmos5l_fill_2
XFILLER_14_2285 VPWR VGND sg13cmos5l_decap_8
XANTENNA__0702__X Tile_X2Y0_N4BEG[10] VPWR VGND sg13cmos5l_antennanp
XFILLER_10_1404 VPWR VGND sg13cmos5l_decap_8
XFILLER_14_1584 VPWR VGND sg13cmos5l_decap_8
XFILLER_14_1573 VPWR VGND sg13cmos5l_decap_8
XFILLER_3_259 VPWR VGND sg13cmos5l_decap_8
XFILLER_0_922 VPWR VGND sg13cmos5l_decap_4
XFILLER_10_86 VPWR VGND sg13cmos5l_fill_2
XFILLER_0_966 VPWR VGND sg13cmos5l_decap_8
XFILLER_5_1730 VPWR VGND sg13cmos5l_decap_8
XFILLER_1_2317 VPWR VGND sg13cmos5l_decap_8
XFILLER_1_1605 VPWR VGND sg13cmos5l_decap_8
XFILLER_15_311 VPWR VGND sg13cmos5l_fill_1
XFILLER_15_2038 VPWR VGND sg13cmos5l_decap_8
XFILLER_11_550 VPWR VGND sg13cmos5l_decap_4
XFILLER_7_576 VPWR VGND sg13cmos5l_fill_1
X_0640_ _0640_/L_HI VPWR VGND sg13cmos5l_tiehi
XFILLER_7_598 VPWR VGND sg13cmos5l_decap_8
XFILLER_10_1971 VPWR VGND sg13cmos5l_decap_8
X_0571_ NPU_ADDR7 Tile_X0Y0_UserCLK _1092_/X _0658_/L_HI VPWR VGND sg13cmos5l_dfrbpq_1
XFILLER_6_2239 VPWR VGND sg13cmos5l_decap_8
XFILLER_6_1527 VPWR VGND sg13cmos5l_decap_8
X_1123_ _1123_/X Tile_X0Y0_S4END[9] Tile_X0Y0_S4END[10] Tile_X0Y0_SS4END[9] Tile_X0Y0_SS4END[11]
+ _0109_/Q _0108_/Q VPWR VGND sg13cmos5l_mux4_1
XFILLER_4_1240 VPWR VGND sg13cmos5l_decap_8
X_1054_ Tile_X1Y0_FrameStrobe_O[6] Tile_X1Y0_FrameStrobe[6] VPWR VGND sg13cmos5l_buf_1
X_0907_ Tile_X3Y0_FrameStrobe_O[7] Tile_X3Y0_FrameStrobe[7] VPWR VGND sg13cmos5l_buf_1
X_0838_ Tile_X4Y0_FrameStrobe_O[10] Tile_X4Y0_FrameStrobe[10] VPWR VGND sg13cmos5l_buf_1
X_0769_ Tile_X0Y0_NN4BEG[5] _1165_/X VPWR VGND sg13cmos5l_buf_1
XFILLER_5_1015 VPWR VGND sg13cmos5l_decap_8
XFILLER_2_1914 VPWR VGND sg13cmos5l_decap_8
XFILLER_0_2361 VPWR VGND sg13cmos5l_decap_8
XFILLER_16_2358 VPWR VGND sg13cmos5l_decap_8
XFILLER_16_1657 VPWR VGND sg13cmos5l_fill_1
XFILLER_14_2060 VPWR VGND sg13cmos5l_decap_8
XANTENNA_70 Tile_X0Y0_FrameData[15] VPWR VGND sg13cmos5l_antennanp
XANTENNA_81 Tile_X0Y0_FrameData[21] VPWR VGND sg13cmos5l_antennanp
XANTENNA_92 Tile_X0Y0_FrameData[26] VPWR VGND sg13cmos5l_antennanp
XFILLER_10_1267 VPWR VGND sg13cmos5l_fill_1
XFILLER_4_568 VPWR VGND sg13cmos5l_decap_8
XFILLER_0_774 VPWR VGND sg13cmos5l_decap_8
XFILLER_0_785 VPWR VGND sg13cmos5l_fill_2
XFILLER_7_1869 VPWR VGND sg13cmos5l_decap_8
XFILLER_5_2250 VPWR VGND sg13cmos5l_decap_8
XFILLER_1_2125 VPWR VGND sg13cmos5l_decap_8
XFILLER_5_1571 VPWR VGND sg13cmos5l_decap_8
XFILLER_1_1479 VPWR VGND sg13cmos5l_decap_8
XFILLER_16_686 VPWR VGND sg13cmos5l_decap_4
XFILLER_16_697 VPWR VGND sg13cmos5l_decap_8
XFILLER_7_21 VPWR VGND sg13cmos5l_decap_8
XFILLER_7_340 VPWR VGND sg13cmos5l_fill_2
X_0623_ _0623_/L_HI VPWR VGND sg13cmos5l_tiehi
XFILLER_7_98 VPWR VGND sg13cmos5l_decap_8
X_0554_ NPU_WDATA30 Tile_X0Y0_UserCLK _1131_/X _0679_/L_HI VPWR VGND sg13cmos5l_dfrbpq_1
X_0485_ _0485_/Q Tile_X0Y0_FrameData[20] VGND VPWR Tile_X3Y0_FrameStrobe[2] latch
XFILLER_6_2058 VPWR VGND sg13cmos5l_decap_8
XFILLER_6_1324 VPWR VGND sg13cmos5l_decap_8
XFILLER_16_0 VPWR VGND sg13cmos5l_decap_8
X_1106_ _1106_/X Tile_X1Y0_S4END[10] Tile_X1Y0_S4END[11] Tile_X1Y0_SS4END[8] Tile_X1Y0_SS4END[10]
+ _0223_/Q _0222_/Q VPWR VGND sg13cmos5l_mux4_1
XFILLER_4_1070 VPWR VGND sg13cmos5l_decap_8
X_1037_ Tile_X1Y0_N2BEG[1] Tile_X1Y0_S2MID[6] VPWR VGND sg13cmos5l_buf_1
XFILLER_10_818 VPWR VGND sg13cmos5l_fill_1
XFILLER_15_2391 VPWR VGND sg13cmos5l_decap_8
XFILLER_15_1690 VPWR VGND sg13cmos5l_decap_4
XFILLER_11_2277 VPWR VGND sg13cmos5l_decap_8
XANTENNA__1083__X Tile_X2Y0_N2BEGb[7] VPWR VGND sg13cmos5l_antennanp
XFILLER_2_1711 VPWR VGND sg13cmos5l_decap_8
XFILLER_17_406 VPWR VGND sg13cmos5l_decap_8
XFILLER_2_1788 VPWR VGND sg13cmos5l_decap_8
XFILLER_12_100 VPWR VGND sg13cmos5l_decap_8
XFILLER_16_2133 VPWR VGND sg13cmos5l_fill_2
XFILLER_13_656 VPWR VGND sg13cmos5l_fill_1
XFILLER_8_126 VPWR VGND sg13cmos5l_decap_8
XFILLER_16_1454 VPWR VGND sg13cmos5l_decap_8
XFILLER_12_166 VPWR VGND sg13cmos5l_fill_2
XANTENNA__0688__L_LO Tile_X2Y0_Co VPWR VGND sg13cmos5l_antennanp
XFILLER_5_855 VPWR VGND sg13cmos5l_decap_8
XFILLER_4_343 VPWR VGND sg13cmos5l_decap_8
XFILLER_4_365 VPWR VGND sg13cmos5l_fill_2
XFILLER_10_1097 VPWR VGND sg13cmos5l_fill_1
XFILLER_7_2312 VPWR VGND sg13cmos5l_decap_8
XFILLER_0_560 VPWR VGND sg13cmos5l_decap_8
X_0270_ _0270_/Q Tile_X0Y0_FrameData[27] VGND VPWR Tile_X1Y0_FrameStrobe[2] latch
XFILLER_7_2389 VPWR VGND sg13cmos5l_decap_8
XFILLER_3_2209 VPWR VGND sg13cmos5l_decap_8
XFILLER_1_1210 VPWR VGND sg13cmos5l_decap_8
XFILLER_1_1221 VPWR VGND sg13cmos5l_fill_2
XFILLER_17_940 VPWR VGND sg13cmos5l_decap_8
XFILLER_1_1276 VPWR VGND sg13cmos5l_decap_8
XFILLER_16_461 VPWR VGND sg13cmos5l_decap_8
XFILLER_8_682 VPWR VGND sg13cmos5l_decap_4
XFILLER_8_693 VPWR VGND sg13cmos5l_decap_8
XFILLER_7_170 VPWR VGND sg13cmos5l_decap_8
XFILLER_12_1863 VPWR VGND sg13cmos5l_decap_8
XANTENNA__0800__X Tile_X4Y0_FrameData_O[4] VPWR VGND sg13cmos5l_antennanp
X_0606_ _0606_/L_HI VPWR VGND sg13cmos5l_tiehi
X_0537_ NPU_WDATA13 Tile_X0Y0_UserCLK _1114_/X _0664_/L_HI VPWR VGND sg13cmos5l_dfrbpq_1
X_0468_ _0468_/Q Tile_X0Y0_FrameData[5] VGND VPWR Tile_X3Y0_FrameStrobe[1] latch
X_0399_ _0399_/Q Tile_X0Y0_FrameData[10] VGND VPWR Tile_X2Y0_FrameStrobe[2] latch
XFILLER_6_1165 VPWR VGND sg13cmos5l_decap_8
XFILLER_17_1730 VPWR VGND sg13cmos5l_fill_1
XFILLER_13_1627 VPWR VGND sg13cmos5l_fill_2
XANTENNA__1078__X Tile_X2Y0_N2BEGb[2] VPWR VGND sg13cmos5l_antennanp
XFILLER_11_2041 VPWR VGND sg13cmos5l_decap_8
XFILLER_2_803 VPWR VGND sg13cmos5l_decap_8
XANTENNA__0710__X Tile_X0Y0_FrameStrobe_O[2] VPWR VGND sg13cmos5l_antennanp
XFILLER_1_335 VPWR VGND sg13cmos5l_decap_8
XFILLER_8_1975 VPWR VGND sg13cmos5l_decap_8
XFILLER_2_2253 VPWR VGND sg13cmos5l_decap_8
XFILLER_2_1596 VPWR VGND sg13cmos5l_decap_8
XFILLER_14_965 VPWR VGND sg13cmos5l_decap_8
XFILLER_13_453 VPWR VGND sg13cmos5l_decap_8
XFILLER_16_1262 VPWR VGND sg13cmos5l_decap_4
XFILLER_5_674 VPWR VGND sg13cmos5l_decap_8
XFILLER_4_140 VPWR VGND sg13cmos5l_decap_8
XFILLER_4_77 VPWR VGND sg13cmos5l_decap_8
X_0322_ _0322_/Q Tile_X0Y0_FrameData[23] VGND VPWR Tile_X2Y0_FrameStrobe[0] latch
XFILLER_7_2153 VPWR VGND sg13cmos5l_decap_8
XFILLER_3_2006 VPWR VGND sg13cmos5l_decap_8
X_0253_ _0253_/Q Tile_X0Y0_FrameData[12] VGND VPWR Tile_X1Y0_FrameStrobe[1] latch
XFILLER_7_1485 VPWR VGND sg13cmos5l_decap_8
X_0184_ _0184_/Q Tile_X0Y0_FrameData[1] VGND VPWR Tile_X0Y0_FrameStrobe[2] latch
XFILLER_1_1073 VPWR VGND sg13cmos5l_decap_8
XFILLER_16_291 VPWR VGND sg13cmos5l_decap_8
XFILLER_9_980 VPWR VGND sg13cmos5l_decap_8
XFILLER_14_1958 VPWR VGND sg13cmos5l_decap_8
XFILLER_12_2372 VPWR VGND sg13cmos5l_decap_8
XFILLER_12_1671 VPWR VGND sg13cmos5l_decap_4
XFILLER_3_1894 VPWR VGND sg13cmos5l_decap_8
XANTENNA__0705__X Tile_X2Y0_N4BEG[13] VPWR VGND sg13cmos5l_antennanp
XFILLER_10_434 VPWR VGND sg13cmos5l_decap_8
XFILLER_7_917 VPWR VGND sg13cmos5l_decap_8
XFILLER_17_2283 VPWR VGND sg13cmos5l_decap_8
XFILLER_13_42 VPWR VGND sg13cmos5l_fill_1
XFILLER_13_2147 VPWR VGND sg13cmos5l_fill_1
XFILLER_13_2136 VPWR VGND sg13cmos5l_decap_8
XFILLER_13_1402 VPWR VGND sg13cmos5l_decap_8
XFILLER_11_957 VPWR VGND sg13cmos5l_decap_8
XFILLER_6_416 VPWR VGND sg13cmos5l_decap_8
XFILLER_13_64 VPWR VGND sg13cmos5l_decap_4
XFILLER_13_2158 VPWR VGND sg13cmos5l_decap_8
XFILLER_6_449 VPWR VGND sg13cmos5l_decap_8
XFILLER_13_1479 VPWR VGND sg13cmos5l_decap_8
XFILLER_2_622 VPWR VGND sg13cmos5l_decap_8
XFILLER_4_2304 VPWR VGND sg13cmos5l_decap_8
XFILLER_1_154 VPWR VGND sg13cmos5l_decap_8
XFILLER_4_1625 VPWR VGND sg13cmos5l_decap_8
XFILLER_18_556 VPWR VGND sg13cmos5l_decap_8
XFILLER_2_1393 VPWR VGND sg13cmos5l_decap_8
X_0940_ Tile_X3Y0_N4BEG[0] _1264_/X VPWR VGND sg13cmos5l_buf_1
X_0871_ Tile_X4Y0_N4BEG[3] Tile_X4Y0_S4END[12] VPWR VGND sg13cmos5l_buf_1
XFILLER_10_990 VPWR VGND sg13cmos5l_decap_8
XFILLER_9_2204 VPWR VGND sg13cmos5l_fill_2
XFILLER_6_983 VPWR VGND sg13cmos5l_decap_8
XFILLER_5_471 VPWR VGND sg13cmos5l_decap_8
XFILLER_9_2248 VPWR VGND sg13cmos5l_decap_8
XFILLER_9_1547 VPWR VGND sg13cmos5l_decap_8
XFILLER_9_1558 VPWR VGND sg13cmos5l_fill_2
X_0305_ _0305_/Q Tile_X0Y0_FrameData[24] VGND VPWR Tile_X1Y0_FrameStrobe[3] latch
X_1285_ _1285_/X Tile_X3Y0_S2END[5] Tile_X3Y0_S4END[5] Tile_X3Y0_SS4END[10] _0574_/Q
+ _0447_/Q _0446_/Q VPWR VGND sg13cmos5l_mux4_1
X_0236_ _0236_/Q Tile_X0Y0_FrameData[29] VGND VPWR Tile_X1Y0_FrameStrobe[1] latch
XFILLER_7_1282 VPWR VGND sg13cmos5l_decap_8
XFILLER_3_1157 VPWR VGND sg13cmos5l_decap_8
X_0167_ _0167_/Q Tile_X0Y0_FrameData[18] VGND VPWR Tile_X0Y0_FrameStrobe[2] latch
X_0098_ _0098_/Q Tile_X0Y0_FrameData[23] VGND VPWR Tile_X0Y0_FrameStrobe[0] latch
XFILLER_14_1755 VPWR VGND sg13cmos5l_decap_8
XFILLER_4_909 VPWR VGND sg13cmos5l_decap_8
XFILLER_8_1002 VPWR VGND sg13cmos5l_decap_8
XFILLER_8_1079 VPWR VGND sg13cmos5l_decap_4
XFILLER_5_1956 VPWR VGND sg13cmos5l_decap_8
XFILLER_3_2370 VPWR VGND sg13cmos5l_decap_8
XFILLER_15_515 VPWR VGND sg13cmos5l_decap_8
XFILLER_15_1508 VPWR VGND sg13cmos5l_fill_2
XFILLER_11_710 VPWR VGND sg13cmos5l_fill_2
XFILLER_10_253 VPWR VGND sg13cmos5l_fill_1
XFILLER_7_714 VPWR VGND sg13cmos5l_decap_4
XFILLER_6_224 VPWR VGND sg13cmos5l_decap_8
XFILLER_6_279 VPWR VGND sg13cmos5l_decap_8
XFILLER_3_975 VPWR VGND sg13cmos5l_decap_8
XFILLER_4_2101 VPWR VGND sg13cmos5l_decap_8
XFILLER_2_496 VPWR VGND sg13cmos5l_decap_8
XFILLER_8_1591 VPWR VGND sg13cmos5l_decap_4
XFILLER_4_2178 VPWR VGND sg13cmos5l_decap_8
XFILLER_4_1422 VPWR VGND sg13cmos5l_decap_8
XFILLER_1_56 VPWR VGND sg13cmos5l_decap_8
X_1070_ Tile_X2Y0_N2BEG[2] Tile_X2Y0_S2MID[5] VPWR VGND sg13cmos5l_buf_1
XFILLER_4_1499 VPWR VGND sg13cmos5l_decap_8
XANTENNA_160 Tile_X0Y0_FrameData[31] VPWR VGND sg13cmos5l_antennanp
XANTENNA_171 Tile_X0Y0_FrameData[31] VPWR VGND sg13cmos5l_antennanp
XANTENNA_182 NPU_RDATA2 VPWR VGND sg13cmos5l_antennanp
XANTENNA_193 Tile_X0Y0_FrameData[22] VPWR VGND sg13cmos5l_antennanp
X_0923_ Tile_X3Y0_N1BEG[3] Tile_X3Y0_S1END[0] VPWR VGND sg13cmos5l_buf_1
XFILLER_14_1007 VPWR VGND sg13cmos5l_decap_8
X_0854_ Tile_X4Y0_N2BEG[2] Tile_X4Y0_S2MID[5] VPWR VGND sg13cmos5l_buf_1
X_0785_ Tile_X2Y0_NN4BEG[5] _1245_/X VPWR VGND sg13cmos5l_buf_1
XFILLER_6_791 VPWR VGND sg13cmos5l_decap_8
XFILLER_9_2034 VPWR VGND sg13cmos5l_decap_8
XFILLER_5_290 VPWR VGND sg13cmos5l_decap_8
XFILLER_9_1322 VPWR VGND sg13cmos5l_decap_8
X_1268_ _1268_/X Tile_X3Y0_S2MID[4] Tile_X3Y0_S4END[11] Tile_X3Y0_SS4END[4] _0574_/Q
+ _0481_/Q _0480_/Q VPWR VGND sg13cmos5l_mux4_1
X_0219_ _0219_/Q Tile_X0Y0_FrameData[14] VGND VPWR Tile_X1Y0_FrameStrobe[0] latch
X_1199_ _1199_/X Tile_X1Y0_S2MID[7] Tile_X1Y0_S4END[0] Tile_X1Y0_SS4END[15] _0595_/Q
+ _0267_/Q _0266_/Q VPWR VGND sg13cmos5l_mux4_1
XFILLER_0_1842 VPWR VGND sg13cmos5l_decap_8
XFILLER_0_1853 VPWR VGND sg13cmos5l_fill_2
XFILLER_0_1897 VPWR VGND sg13cmos5l_decap_8
XFILLER_12_518 VPWR VGND sg13cmos5l_decap_8
XFILLER_14_2264 VPWR VGND sg13cmos5l_decap_8
XFILLER_10_2139 VPWR VGND sg13cmos5l_decap_8
XFILLER_14_1563 VPWR VGND sg13cmos5l_decap_4
XFILLER_10_21 VPWR VGND sg13cmos5l_decap_8
XFILLER_10_32 VPWR VGND sg13cmos5l_fill_1
XFILLER_10_43 VPWR VGND sg13cmos5l_decap_8
XFILLER_3_238 VPWR VGND sg13cmos5l_decap_8
XFILLER_16_824 VPWR VGND sg13cmos5l_fill_1
XFILLER_16_813 VPWR VGND sg13cmos5l_decap_8
XFILLER_15_378 VPWR VGND sg13cmos5l_fill_2
XFILLER_15_2017 VPWR VGND sg13cmos5l_decap_8
XFILLER_7_555 VPWR VGND sg13cmos5l_decap_8
X_0570_ NPU_ADDR6 Tile_X0Y0_UserCLK _1091_/X _0632_/L_HI VPWR VGND sg13cmos5l_dfrbpq_1
XFILLER_3_794 VPWR VGND sg13cmos5l_decap_8
XFILLER_6_1506 VPWR VGND sg13cmos5l_decap_8
X_1122_ _1122_/X Tile_X0Y0_S4END[10] Tile_X0Y0_S4END[11] Tile_X0Y0_SS4END[8] Tile_X0Y0_SS4END[10]
+ _0111_/Q _0110_/Q VPWR VGND sg13cmos5l_mux4_1
XFILLER_0_1116 VPWR VGND sg13cmos5l_decap_8
XFILLER_0_1127 VPWR VGND sg13cmos5l_fill_2
X_1053_ Tile_X1Y0_FrameStrobe_O[5] Tile_X1Y0_FrameStrobe[5] VPWR VGND sg13cmos5l_buf_1
XFILLER_4_1296 VPWR VGND sg13cmos5l_decap_8
XFILLER_18_172 VPWR VGND sg13cmos5l_fill_1
XANTENNA__0803__X Tile_X4Y0_FrameData_O[7] VPWR VGND sg13cmos5l_antennanp
X_0906_ Tile_X3Y0_FrameStrobe_O[6] Tile_X3Y0_FrameStrobe[6] VPWR VGND sg13cmos5l_buf_1
XFILLER_11_1758 VPWR VGND sg13cmos5l_fill_1
X_0837_ Tile_X4Y0_FrameStrobe_O[9] Tile_X4Y0_FrameStrobe[9] VPWR VGND sg13cmos5l_buf_1
X_0768_ Tile_X0Y0_NN4BEG[4] _1164_/X VPWR VGND sg13cmos5l_buf_1
XFILLER_0_208 VPWR VGND sg13cmos5l_decap_8
X_0699_ Tile_X2Y0_N4BEG[7] _1231_/X VPWR VGND sg13cmos5l_buf_1
XFILLER_0_2340 VPWR VGND sg13cmos5l_decap_8
XFILLER_9_809 VPWR VGND sg13cmos5l_fill_2
XFILLER_16_2337 VPWR VGND sg13cmos5l_decap_8
XFILLER_16_1603 VPWR VGND sg13cmos5l_decap_4
XFILLER_16_1625 VPWR VGND sg13cmos5l_fill_2
XANTENNA__0713__X Tile_X0Y0_FrameStrobe_O[5] VPWR VGND sg13cmos5l_antennanp
XANTENNA_60 Tile_X0Y0_FrameData[15] VPWR VGND sg13cmos5l_antennanp
XANTENNA_71 Tile_X0Y0_FrameData[15] VPWR VGND sg13cmos5l_antennanp
XANTENNA_82 Tile_X0Y0_FrameData[21] VPWR VGND sg13cmos5l_antennanp
XANTENNA_93 Tile_X0Y0_FrameData[26] VPWR VGND sg13cmos5l_antennanp
XFILLER_14_1371 VPWR VGND sg13cmos5l_decap_8
XFILLER_4_547 VPWR VGND sg13cmos5l_decap_8
XFILLER_0_731 VPWR VGND sg13cmos5l_decap_8
XFILLER_7_1848 VPWR VGND sg13cmos5l_decap_8
XFILLER_5_1550 VPWR VGND sg13cmos5l_decap_8
XFILLER_1_2104 VPWR VGND sg13cmos5l_decap_8
XFILLER_1_1458 VPWR VGND sg13cmos5l_decap_8
XFILLER_15_1124 VPWR VGND sg13cmos5l_fill_1
XFILLER_15_1157 VPWR VGND sg13cmos5l_fill_1
XFILLER_12_893 VPWR VGND sg13cmos5l_fill_1
XFILLER_8_897 VPWR VGND sg13cmos5l_decap_8
XFILLER_7_77 VPWR VGND sg13cmos5l_decap_8
X_0622_ _0622_/L_HI VPWR VGND sg13cmos5l_tiehi
X_0553_ NPU_WDATA29 Tile_X0Y0_UserCLK _1130_/X _0634_/L_HI VPWR VGND sg13cmos5l_dfrbpq_1
X_0484_ _0484_/Q Tile_X0Y0_FrameData[21] VGND VPWR Tile_X3Y0_FrameStrobe[2] latch
XFILLER_6_2037 VPWR VGND sg13cmos5l_decap_8
XFILLER_6_1303 VPWR VGND sg13cmos5l_decap_8
X_1105_ _1105_/X Tile_X1Y0_S4END[8] Tile_X1Y0_S4END[11] Tile_X1Y0_SS4END[9] Tile_X1Y0_SS4END[11]
+ _0225_/Q _0224_/Q VPWR VGND sg13cmos5l_mux4_1
X_1036_ Tile_X1Y0_N2BEG[0] Tile_X1Y0_S2MID[7] VPWR VGND sg13cmos5l_buf_1
XFILLER_1_1981 VPWR VGND sg13cmos5l_decap_8
XFILLER_17_1934 VPWR VGND sg13cmos5l_fill_1
XFILLER_17_1923 VPWR VGND sg13cmos5l_decap_8
XFILLER_17_1978 VPWR VGND sg13cmos5l_decap_4
XFILLER_17_1967 VPWR VGND sg13cmos5l_fill_1
XFILLER_15_2370 VPWR VGND sg13cmos5l_decap_8
XFILLER_11_2256 VPWR VGND sg13cmos5l_decap_8
XFILLER_11_1588 VPWR VGND sg13cmos5l_fill_2
XFILLER_1_539 VPWR VGND sg13cmos5l_decap_8
XFILLER_2_1701 VPWR VGND sg13cmos5l_decap_8
XANTENNA__0708__X Tile_X0Y0_FrameStrobe_O[0] VPWR VGND sg13cmos5l_antennanp
XFILLER_2_1767 VPWR VGND sg13cmos5l_decap_8
XFILLER_16_2112 VPWR VGND sg13cmos5l_fill_2
XFILLER_13_602 VPWR VGND sg13cmos5l_fill_2
XFILLER_16_2156 VPWR VGND sg13cmos5l_decap_4
XFILLER_16_1433 VPWR VGND sg13cmos5l_decap_8
XFILLER_12_156 VPWR VGND sg13cmos5l_decap_4
XFILLER_4_322 VPWR VGND sg13cmos5l_decap_8
XFILLER_7_2368 VPWR VGND sg13cmos5l_decap_8
XFILLER_7_1656 VPWR VGND sg13cmos5l_fill_2
XFILLER_1_1255 VPWR VGND sg13cmos5l_decap_8
XFILLER_16_440 VPWR VGND sg13cmos5l_decap_8
XFILLER_12_1842 VPWR VGND sg13cmos5l_decap_8
X_0605_ _0605_/L_HI VPWR VGND sg13cmos5l_tiehi
X_0536_ NPU_WDATA12 Tile_X0Y0_UserCLK _1113_/X _0635_/L_HI VPWR VGND sg13cmos5l_dfrbpq_1
X_0467_ _0467_/Q Tile_X0Y0_FrameData[6] VGND VPWR Tile_X3Y0_FrameStrobe[1] latch
XFILLER_6_1144 VPWR VGND sg13cmos5l_decap_8
X_0398_ _0398_/Q Tile_X0Y0_FrameData[11] VGND VPWR Tile_X2Y0_FrameStrobe[2] latch
X_1019_ Tile_X1Y0_N4BEG[7] _1191_/X VPWR VGND sg13cmos5l_buf_1
XFILLER_10_638 VPWR VGND sg13cmos5l_decap_8
XFILLER_5_119 VPWR VGND sg13cmos5l_decap_8
XFILLER_11_2020 VPWR VGND sg13cmos5l_decap_8
XFILLER_11_2097 VPWR VGND sg13cmos5l_decap_8
XFILLER_11_1396 VPWR VGND sg13cmos5l_decap_8
XFILLER_1_314 VPWR VGND sg13cmos5l_decap_8
XFILLER_8_1954 VPWR VGND sg13cmos5l_decap_8
XFILLER_4_1818 VPWR VGND sg13cmos5l_decap_8
XFILLER_2_2232 VPWR VGND sg13cmos5l_decap_8
XFILLER_2_1575 VPWR VGND sg13cmos5l_decap_8
XFILLER_18_1539 VPWR VGND sg13cmos5l_fill_2
XFILLER_14_944 VPWR VGND sg13cmos5l_decap_8
XFILLER_13_432 VPWR VGND sg13cmos5l_decap_8
XFILLER_9_425 VPWR VGND sg13cmos5l_decap_8
XFILLER_16_1230 VPWR VGND sg13cmos5l_decap_8
XFILLER_9_469 VPWR VGND sg13cmos5l_decap_8
XANTENNA__0901__X Tile_X3Y0_FrameStrobe_O[1] VPWR VGND sg13cmos5l_antennanp
XFILLER_5_653 VPWR VGND sg13cmos5l_decap_8
XFILLER_7_2132 VPWR VGND sg13cmos5l_decap_8
XFILLER_4_56 VPWR VGND sg13cmos5l_decap_8
XFILLER_4_196 VPWR VGND sg13cmos5l_decap_8
X_0321_ _0321_/Q Tile_X0Y0_FrameData[24] VGND VPWR Tile_X2Y0_FrameStrobe[0] latch
XFILLER_1_870 VPWR VGND sg13cmos5l_fill_1
X_0252_ _0252_/Q Tile_X0Y0_FrameData[13] VGND VPWR Tile_X1Y0_FrameStrobe[1] latch
XFILLER_7_1464 VPWR VGND sg13cmos5l_decap_8
X_0183_ _0183_/Q Tile_X0Y0_FrameData[2] VGND VPWR Tile_X0Y0_FrameStrobe[2] latch
XFILLER_1_1052 VPWR VGND sg13cmos5l_decap_8
XFILLER_16_270 VPWR VGND sg13cmos5l_decap_8
XFILLER_17_1016 VPWR VGND sg13cmos5l_decap_8
XFILLER_14_1937 VPWR VGND sg13cmos5l_decap_8
XFILLER_12_2351 VPWR VGND sg13cmos5l_decap_8
XANTENNA__0811__X Tile_X4Y0_FrameData_O[15] VPWR VGND sg13cmos5l_antennanp
XFILLER_8_1217 VPWR VGND sg13cmos5l_fill_1
X_0519_ _0519_/Q Tile_X0Y0_FrameData[24] VGND VPWR Tile_X4Y0_FrameStrobe[0] latch
XANTENNA__0687__L_LO Tile_X0Y0_Co VPWR VGND sg13cmos5l_antennanp
XFILLER_3_1873 VPWR VGND sg13cmos5l_decap_8
XFILLER_15_708 VPWR VGND sg13cmos5l_decap_8
XFILLER_17_2262 VPWR VGND sg13cmos5l_decap_8
XFILLER_11_925 VPWR VGND sg13cmos5l_fill_1
XFILLER_10_413 VPWR VGND sg13cmos5l_decap_8
XFILLER_17_2295 VPWR VGND sg13cmos5l_decap_8
XFILLER_17_1561 VPWR VGND sg13cmos5l_fill_1
XFILLER_13_32 VPWR VGND sg13cmos5l_fill_1
XFILLER_13_2115 VPWR VGND sg13cmos5l_decap_8
XFILLER_13_21 VPWR VGND sg13cmos5l_decap_8
XFILLER_11_936 VPWR VGND sg13cmos5l_decap_8
XFILLER_6_428 VPWR VGND sg13cmos5l_decap_8
XFILLER_13_1458 VPWR VGND sg13cmos5l_decap_8
XANTENNA__0721__X Tile_X0Y0_FrameStrobe_O[13] VPWR VGND sg13cmos5l_antennanp
XFILLER_2_601 VPWR VGND sg13cmos5l_decap_8
XFILLER_1_133 VPWR VGND sg13cmos5l_decap_8
XFILLER_2_678 VPWR VGND sg13cmos5l_decap_8
XFILLER_8_1784 VPWR VGND sg13cmos5l_decap_8
XFILLER_4_1604 VPWR VGND sg13cmos5l_decap_8
XFILLER_18_502 VPWR VGND sg13cmos5l_fill_2
XFILLER_2_2095 VPWR VGND sg13cmos5l_decap_8
XFILLER_2_1372 VPWR VGND sg13cmos5l_decap_8
XFILLER_14_741 VPWR VGND sg13cmos5l_decap_8
XFILLER_18_1369 VPWR VGND sg13cmos5l_decap_8
XFILLER_13_262 VPWR VGND sg13cmos5l_fill_2
X_0870_ Tile_X4Y0_N4BEG[2] Tile_X4Y0_S4END[13] VPWR VGND sg13cmos5l_buf_1
XFILLER_16_1082 VPWR VGND sg13cmos5l_decap_8
XFILLER_6_962 VPWR VGND sg13cmos5l_decap_8
XFILLER_5_450 VPWR VGND sg13cmos5l_decap_8
XFILLER_9_2216 VPWR VGND sg13cmos5l_fill_2
XFILLER_9_2227 VPWR VGND sg13cmos5l_decap_8
XFILLER_9_1526 VPWR VGND sg13cmos5l_decap_8
X_0304_ _0304_/Q Tile_X0Y0_FrameData[25] VGND VPWR Tile_X1Y0_FrameStrobe[3] latch
X_1284_ _1284_/X Tile_X3Y0_S2END[4] Tile_X3Y0_S4END[4] Tile_X3Y0_SS4END[11] _0575_/Q
+ _0449_/Q _0448_/Q VPWR VGND sg13cmos5l_mux4_1
XFILLER_7_1250 VPWR VGND sg13cmos5l_fill_1
X_0235_ _0235_/Q Tile_X0Y0_FrameData[30] VGND VPWR Tile_X1Y0_FrameStrobe[1] latch
XFILLER_7_1294 VPWR VGND sg13cmos5l_decap_8
XFILLER_3_1136 VPWR VGND sg13cmos5l_decap_8
X_0166_ _0166_/Q Tile_X0Y0_FrameData[19] VGND VPWR Tile_X0Y0_FrameStrobe[2] latch
XANTENNA__0806__X Tile_X4Y0_FrameData_O[10] VPWR VGND sg13cmos5l_antennanp
X_0097_ _0097_/Q Tile_X0Y0_FrameData[24] VGND VPWR Tile_X0Y0_FrameStrobe[0] latch
XFILLER_14_2413 VPWR VGND sg13cmos5l_fill_2
XFILLER_14_1723 VPWR VGND sg13cmos5l_fill_2
X_0999_ Tile_X1Y0_NN4BEG[3] _1203_/X VPWR VGND sg13cmos5l_buf_1
XFILLER_14_1789 VPWR VGND sg13cmos5l_decap_4
XFILLER_12_1480 VPWR VGND sg13cmos5l_decap_8
XFILLER_8_1058 VPWR VGND sg13cmos5l_decap_8
XFILLER_5_1935 VPWR VGND sg13cmos5l_decap_8
XANTENNA__0716__X Tile_X0Y0_FrameStrobe_O[8] VPWR VGND sg13cmos5l_antennanp
XFILLER_15_538 VPWR VGND sg13cmos5l_decap_8
XFILLER_17_2081 VPWR VGND sg13cmos5l_fill_2
XFILLER_17_2070 VPWR VGND sg13cmos5l_decap_8
XFILLER_11_722 VPWR VGND sg13cmos5l_fill_1
XFILLER_7_748 VPWR VGND sg13cmos5l_decap_8
XFILLER_6_203 VPWR VGND sg13cmos5l_decap_8
XFILLER_17_1391 VPWR VGND sg13cmos5l_decap_4
XFILLER_6_0 VPWR VGND sg13cmos5l_decap_8
XFILLER_3_954 VPWR VGND sg13cmos5l_decap_8
XFILLER_2_475 VPWR VGND sg13cmos5l_decap_8
XFILLER_8_2282 VPWR VGND sg13cmos5l_decap_8
XFILLER_4_1401 VPWR VGND sg13cmos5l_decap_8
XFILLER_4_2157 VPWR VGND sg13cmos5l_decap_8
XFILLER_1_35 VPWR VGND sg13cmos5l_decap_8
XFILLER_18_310 VPWR VGND sg13cmos5l_decap_4
XFILLER_4_1478 VPWR VGND sg13cmos5l_decap_8
XFILLER_18_365 VPWR VGND sg13cmos5l_fill_1
XANTENNA_150 Tile_X0Y0_FrameData[30] VPWR VGND sg13cmos5l_antennanp
XANTENNA_161 Tile_X0Y0_FrameData[31] VPWR VGND sg13cmos5l_antennanp
XFILLER_2_1180 VPWR VGND sg13cmos5l_decap_8
XFILLER_18_398 VPWR VGND sg13cmos5l_decap_8
XANTENNA_172 Tile_X0Y0_FrameData[31] VPWR VGND sg13cmos5l_antennanp
XANTENNA_183 NPU_RDATA9 VPWR VGND sg13cmos5l_antennanp
XANTENNA_194 Tile_X0Y0_FrameData[22] VPWR VGND sg13cmos5l_antennanp
X_0922_ Tile_X3Y0_N1BEG[2] Tile_X3Y0_S1END[1] VPWR VGND sg13cmos5l_buf_1
XFILLER_18_1188 VPWR VGND sg13cmos5l_fill_2
X_0853_ Tile_X4Y0_N2BEG[1] Tile_X4Y0_S2MID[6] VPWR VGND sg13cmos5l_buf_1
XFILLER_11_1929 VPWR VGND sg13cmos5l_decap_8
X_0784_ Tile_X2Y0_NN4BEG[4] _1244_/X VPWR VGND sg13cmos5l_buf_1
XFILLER_6_770 VPWR VGND sg13cmos5l_decap_8
XFILLER_9_2013 VPWR VGND sg13cmos5l_decap_8
X_1267_ _1267_/X Tile_X3Y0_S2MID[3] Tile_X3Y0_S4END[12] Tile_X3Y0_SS4END[3] _0573_/Q
+ _0483_/Q _0482_/Q VPWR VGND sg13cmos5l_mux4_1
X_0218_ _0218_/Q Tile_X0Y0_FrameData[15] VGND VPWR Tile_X1Y0_FrameStrobe[0] latch
X_1198_ _1198_/X Tile_X1Y0_S2MID[6] Tile_X1Y0_S4END[1] Tile_X1Y0_SS4END[14] _0594_/Q
+ _0269_/Q _0268_/Q VPWR VGND sg13cmos5l_mux4_1
XFILLER_4_1990 VPWR VGND sg13cmos5l_decap_8
X_0149_ _0149_/Q Tile_X0Y0_FrameData[4] VGND VPWR Tile_X0Y0_FrameStrobe[1] latch
XFILLER_16_1829 VPWR VGND sg13cmos5l_decap_8
XFILLER_16_1807 VPWR VGND sg13cmos5l_fill_1
XFILLER_14_2243 VPWR VGND sg13cmos5l_decap_8
XFILLER_10_2118 VPWR VGND sg13cmos5l_decap_8
XFILLER_10_1439 VPWR VGND sg13cmos5l_decap_8
XFILLER_4_729 VPWR VGND sg13cmos5l_decap_8
XFILLER_3_217 VPWR VGND sg13cmos5l_decap_8
XFILLER_10_88 VPWR VGND sg13cmos5l_fill_1
XFILLER_0_935 VPWR VGND sg13cmos5l_decap_4
XFILLER_5_2411 VPWR VGND sg13cmos5l_decap_8
XFILLER_5_1710 VPWR VGND sg13cmos5l_decap_8
XFILLER_5_1765 VPWR VGND sg13cmos5l_decap_8
XFILLER_11_585 VPWR VGND sg13cmos5l_fill_2
XFILLER_11_574 VPWR VGND sg13cmos5l_decap_8
XFILLER_7_534 VPWR VGND sg13cmos5l_decap_8
XFILLER_13_1052 VPWR VGND sg13cmos5l_decap_8
XFILLER_3_773 VPWR VGND sg13cmos5l_decap_8
XFILLER_2_294 VPWR VGND sg13cmos5l_decap_8
X_1121_ _1121_/X Tile_X0Y0_S4END[8] Tile_X0Y0_S4END[11] Tile_X0Y0_SS4END[9] Tile_X0Y0_SS4END[11]
+ _0113_/Q _0112_/Q VPWR VGND sg13cmos5l_mux4_1
X_1052_ Tile_X1Y0_FrameStrobe_O[4] Tile_X1Y0_FrameStrobe[4] VPWR VGND sg13cmos5l_buf_1
XFILLER_4_1275 VPWR VGND sg13cmos5l_decap_8
X_0905_ Tile_X3Y0_FrameStrobe_O[5] Tile_X3Y0_FrameStrobe[5] VPWR VGND sg13cmos5l_buf_1
X_0836_ Tile_X4Y0_FrameStrobe_O[8] Tile_X4Y0_FrameStrobe[8] VPWR VGND sg13cmos5l_buf_1
XFILLER_15_1895 VPWR VGND sg13cmos5l_decap_8
X_0767_ Tile_X0Y0_NN4BEG[3] _1163_/X VPWR VGND sg13cmos5l_buf_1
X_0698_ Tile_X2Y0_N4BEG[6] _1230_/X VPWR VGND sg13cmos5l_buf_1
XFILLER_9_1186 VPWR VGND sg13cmos5l_decap_4
XFILLER_2_1949 VPWR VGND sg13cmos5l_decap_8
XFILLER_0_1673 VPWR VGND sg13cmos5l_decap_8
XFILLER_13_806 VPWR VGND sg13cmos5l_fill_2
XFILLER_0_1684 VPWR VGND sg13cmos5l_fill_2
XFILLER_16_2316 VPWR VGND sg13cmos5l_decap_8
XANTENNA_50 Tile_X0Y0_FrameData[12] VPWR VGND sg13cmos5l_antennanp
XFILLER_16_1648 VPWR VGND sg13cmos5l_decap_8
XANTENNA_61 Tile_X0Y0_FrameData[15] VPWR VGND sg13cmos5l_antennanp
XANTENNA_72 Tile_X0Y0_FrameData[15] VPWR VGND sg13cmos5l_antennanp
XANTENNA_83 Tile_X0Y0_FrameData[21] VPWR VGND sg13cmos5l_antennanp
XFILLER_14_2095 VPWR VGND sg13cmos5l_decap_8
XANTENNA_94 Tile_X0Y0_FrameData[26] VPWR VGND sg13cmos5l_antennanp
XFILLER_14_1394 VPWR VGND sg13cmos5l_decap_8
XFILLER_4_526 VPWR VGND sg13cmos5l_decap_8
XFILLER_0_743 VPWR VGND sg13cmos5l_decap_8
XFILLER_7_1816 VPWR VGND sg13cmos5l_fill_2
XFILLER_0_798 VPWR VGND sg13cmos5l_decap_8
XFILLER_5_2285 VPWR VGND sg13cmos5l_decap_8
XFILLER_1_1437 VPWR VGND sg13cmos5l_decap_8
XFILLER_16_622 VPWR VGND sg13cmos5l_fill_1
XFILLER_16_644 VPWR VGND sg13cmos5l_decap_8
XANTENNA__0904__X Tile_X3Y0_FrameStrobe_O[4] VPWR VGND sg13cmos5l_antennanp
XFILLER_8_821 VPWR VGND sg13cmos5l_fill_1
XFILLER_8_810 VPWR VGND sg13cmos5l_fill_1
XFILLER_8_843 VPWR VGND sg13cmos5l_decap_4
XFILLER_7_342 VPWR VGND sg13cmos5l_fill_1
XFILLER_7_56 VPWR VGND sg13cmos5l_decap_8
XFILLER_7_353 VPWR VGND sg13cmos5l_fill_2
X_0621_ _0621_/L_HI VPWR VGND sg13cmos5l_tiehi
X_0552_ NPU_WDATA28 Tile_X0Y0_UserCLK _1129_/X _0645_/L_HI VPWR VGND sg13cmos5l_dfrbpq_1
XFILLER_10_1792 VPWR VGND sg13cmos5l_decap_4
X_0483_ _0483_/Q Tile_X0Y0_FrameData[22] VGND VPWR Tile_X3Y0_FrameStrobe[2] latch
XFILLER_6_2016 VPWR VGND sg13cmos5l_decap_8
XFILLER_3_592 VPWR VGND sg13cmos5l_decap_8
XFILLER_6_1359 VPWR VGND sg13cmos5l_decap_8
X_1104_ _1104_/X Tile_X1Y0_S4END[12] Tile_X1Y0_S4END[13] Tile_X1Y0_SS4END[12] Tile_X1Y0_SS4END[14]
+ _0227_/Q _0226_/Q VPWR VGND sg13cmos5l_mux4_1
X_1035_ Tile_X1Y0_N2BEGb[7] _1183_/X VPWR VGND sg13cmos5l_buf_1
XFILLER_1_1960 VPWR VGND sg13cmos5l_decap_8
XFILLER_17_1902 VPWR VGND sg13cmos5l_decap_8
XANTENNA__0814__X Tile_X4Y0_FrameData_O[18] VPWR VGND sg13cmos5l_antennanp
XFILLER_10_809 VPWR VGND sg13cmos5l_fill_2
XFILLER_17_1946 VPWR VGND sg13cmos5l_decap_8
XFILLER_11_1501 VPWR VGND sg13cmos5l_decap_8
X_0819_ Tile_X4Y0_FrameData_O[23] Tile_X0Y0_FrameData[23] VPWR VGND sg13cmos5l_buf_1
XFILLER_1_518 VPWR VGND sg13cmos5l_decap_8
XFILLER_2_2414 VPWR VGND sg13cmos5l_decap_4
XFILLER_2_1746 VPWR VGND sg13cmos5l_decap_8
XFILLER_16_21 VPWR VGND sg13cmos5l_decap_8
XFILLER_16_65 VPWR VGND sg13cmos5l_fill_2
XFILLER_13_625 VPWR VGND sg13cmos5l_fill_2
XANTENNA__0724__X Tile_X0Y0_FrameStrobe_O[16] VPWR VGND sg13cmos5l_antennanp
XFILLER_16_98 VPWR VGND sg13cmos5l_fill_1
XFILLER_16_1412 VPWR VGND sg13cmos5l_decap_8
XFILLER_13_669 VPWR VGND sg13cmos5l_decap_4
XFILLER_12_146 VPWR VGND sg13cmos5l_fill_2
XFILLER_16_1489 VPWR VGND sg13cmos5l_decap_8
XFILLER_10_1011 VPWR VGND sg13cmos5l_decap_8
XFILLER_4_301 VPWR VGND sg13cmos5l_decap_8
XFILLER_10_1066 VPWR VGND sg13cmos5l_decap_8
XFILLER_4_367 VPWR VGND sg13cmos5l_fill_1
XFILLER_10_1088 VPWR VGND sg13cmos5l_decap_8
XFILLER_7_2347 VPWR VGND sg13cmos5l_decap_8
XFILLER_7_1679 VPWR VGND sg13cmos5l_fill_1
XFILLER_5_2082 VPWR VGND sg13cmos5l_decap_8
XFILLER_1_1223 VPWR VGND sg13cmos5l_fill_1
XFILLER_17_975 VPWR VGND sg13cmos5l_decap_8
XFILLER_16_496 VPWR VGND sg13cmos5l_decap_8
XFILLER_12_1821 VPWR VGND sg13cmos5l_decap_8
X_0604_ _0604_/L_HI VPWR VGND sg13cmos5l_tiehi
XFILLER_12_1898 VPWR VGND sg13cmos5l_decap_8
X_0535_ NPU_WDATA11 Tile_X0Y0_UserCLK _1112_/X _0636_/L_HI VPWR VGND sg13cmos5l_dfrbpq_1
X_0466_ _0466_/Q Tile_X0Y0_FrameData[7] VGND VPWR Tile_X3Y0_FrameStrobe[1] latch
XANTENNA__0809__X Tile_X4Y0_FrameData_O[13] VPWR VGND sg13cmos5l_antennanp
XFILLER_6_1123 VPWR VGND sg13cmos5l_decap_8
X_0397_ _0397_/Q Tile_X0Y0_FrameData[12] VGND VPWR Tile_X2Y0_FrameStrobe[2] latch
X_1018_ Tile_X1Y0_N4BEG[6] _1190_/X VPWR VGND sg13cmos5l_buf_1
XFILLER_17_2400 VPWR VGND sg13cmos5l_fill_1
XFILLER_10_617 VPWR VGND sg13cmos5l_decap_8
XFILLER_10_628 VPWR VGND sg13cmos5l_fill_2
XFILLER_17_1798 VPWR VGND sg13cmos5l_decap_4
XFILLER_11_2076 VPWR VGND sg13cmos5l_decap_8
XFILLER_11_1375 VPWR VGND sg13cmos5l_decap_8
XFILLER_8_1933 VPWR VGND sg13cmos5l_decap_8
XANTENNA__0719__X Tile_X0Y0_FrameStrobe_O[11] VPWR VGND sg13cmos5l_antennanp
XFILLER_18_706 VPWR VGND sg13cmos5l_fill_1
XFILLER_18_739 VPWR VGND sg13cmos5l_decap_8
XFILLER_2_2288 VPWR VGND sg13cmos5l_decap_8
XFILLER_2_1554 VPWR VGND sg13cmos5l_decap_8
XFILLER_18_1507 VPWR VGND sg13cmos5l_fill_2
XFILLER_13_488 VPWR VGND sg13cmos5l_decap_8
XFILLER_16_1275 VPWR VGND sg13cmos5l_decap_8
XFILLER_5_632 VPWR VGND sg13cmos5l_decap_8
XFILLER_4_175 VPWR VGND sg13cmos5l_decap_8
XFILLER_7_2111 VPWR VGND sg13cmos5l_decap_8
XFILLER_4_35 VPWR VGND sg13cmos5l_decap_8
X_0320_ _0320_/Q Tile_X0Y0_FrameData[25] VGND VPWR Tile_X2Y0_FrameStrobe[0] latch
XFILLER_7_2188 VPWR VGND sg13cmos5l_decap_4
XFILLER_7_1443 VPWR VGND sg13cmos5l_decap_8
X_0251_ _0251_/Q Tile_X0Y0_FrameData[14] VGND VPWR Tile_X1Y0_FrameStrobe[1] latch
X_0182_ _0182_/Q Tile_X0Y0_FrameData[3] VGND VPWR Tile_X0Y0_FrameStrobe[2] latch
XFILLER_3_1329 VPWR VGND sg13cmos5l_decap_8
XFILLER_1_1031 VPWR VGND sg13cmos5l_decap_8
XFILLER_16_260 VPWR VGND sg13cmos5l_fill_2
XFILLER_14_1916 VPWR VGND sg13cmos5l_decap_8
XFILLER_12_2330 VPWR VGND sg13cmos5l_decap_8
XFILLER_12_1651 VPWR VGND sg13cmos5l_decap_4
XFILLER_12_1684 VPWR VGND sg13cmos5l_fill_2
X_0518_ _0518_/Q Tile_X0Y0_FrameData[23] VGND VPWR Tile_X4Y0_FrameStrobe[0] latch
XFILLER_8_1229 VPWR VGND sg13cmos5l_fill_1
X_0449_ _0449_/Q Tile_X0Y0_FrameData[24] VGND VPWR Tile_X3Y0_FrameStrobe[1] latch
XFILLER_3_1852 VPWR VGND sg13cmos5l_decap_8
XFILLER_17_2241 VPWR VGND sg13cmos5l_fill_2
XFILLER_13_99 VPWR VGND sg13cmos5l_decap_8
XFILLER_13_1437 VPWR VGND sg13cmos5l_decap_8
XFILLER_2_657 VPWR VGND sg13cmos5l_decap_8
XFILLER_1_112 VPWR VGND sg13cmos5l_decap_8
XFILLER_1_189 VPWR VGND sg13cmos5l_decap_8
XFILLER_8_1763 VPWR VGND sg13cmos5l_decap_8
XFILLER_4_2339 VPWR VGND sg13cmos5l_decap_8
XFILLER_2_2074 VPWR VGND sg13cmos5l_decap_8
XFILLER_2_1351 VPWR VGND sg13cmos5l_decap_8
XFILLER_18_2049 VPWR VGND sg13cmos5l_decap_8
XFILLER_18_1304 VPWR VGND sg13cmos5l_decap_8
XFILLER_18_1348 VPWR VGND sg13cmos5l_decap_8
XFILLER_18_1315 VPWR VGND sg13cmos5l_fill_1
XFILLER_9_234 VPWR VGND sg13cmos5l_decap_4
XFILLER_14_797 VPWR VGND sg13cmos5l_fill_2
XANTENNA__0912__X Tile_X3Y0_FrameStrobe_O[12] VPWR VGND sg13cmos5l_antennanp
XFILLER_9_245 VPWR VGND sg13cmos5l_decap_8
XFILLER_16_1061 VPWR VGND sg13cmos5l_fill_1
XFILLER_6_941 VPWR VGND sg13cmos5l_decap_8
XFILLER_13_1982 VPWR VGND sg13cmos5l_decap_8
X_0303_ _0303_/Q Tile_X0Y0_FrameData[26] VGND VPWR Tile_X1Y0_FrameStrobe[3] latch
X_1283_ _1283_/X Tile_X3Y0_S2END[3] Tile_X3Y0_S4END[3] Tile_X3Y0_SS4END[12] _0572_/Q
+ _0451_/Q _0450_/Q VPWR VGND sg13cmos5l_mux4_1
XFILLER_7_1262 VPWR VGND sg13cmos5l_fill_1
X_0234_ _0234_/Q Tile_X0Y0_FrameData[31] VGND VPWR Tile_X1Y0_FrameStrobe[1] latch
XFILLER_3_1115 VPWR VGND sg13cmos5l_decap_8
X_0165_ _0165_/Q Tile_X0Y0_FrameData[20] VGND VPWR Tile_X0Y0_FrameStrobe[2] latch
X_0096_ _0096_/Q Tile_X0Y0_FrameData[25] VGND VPWR Tile_X0Y0_FrameStrobe[0] latch
XANTENNA__0822__X Tile_X4Y0_FrameData_O[26] VPWR VGND sg13cmos5l_antennanp
X_0998_ Tile_X1Y0_NN4BEG[2] _1202_/X VPWR VGND sg13cmos5l_buf_1
XFILLER_14_1768 VPWR VGND sg13cmos5l_decap_8
XFILLER_14_1746 VPWR VGND sg13cmos5l_decap_4
XFILLER_12_2171 VPWR VGND sg13cmos5l_decap_8
XFILLER_8_1037 VPWR VGND sg13cmos5l_decap_8
XFILLER_5_1914 VPWR VGND sg13cmos5l_decap_8
XFILLER_3_1693 VPWR VGND sg13cmos5l_decap_8
XANTENNA__0732__X Tile_X0Y0_N2BEG[0] VPWR VGND sg13cmos5l_antennanp
XFILLER_17_2093 VPWR VGND sg13cmos5l_fill_1
XFILLER_7_727 VPWR VGND sg13cmos5l_decap_8
XFILLER_13_1223 VPWR VGND sg13cmos5l_decap_4
XFILLER_6_259 VPWR VGND sg13cmos5l_decap_8
XFILLER_3_933 VPWR VGND sg13cmos5l_decap_8
XFILLER_2_454 VPWR VGND sg13cmos5l_decap_8
XFILLER_8_2261 VPWR VGND sg13cmos5l_decap_8
XFILLER_4_2136 VPWR VGND sg13cmos5l_decap_8
XFILLER_1_14 VPWR VGND sg13cmos5l_decap_8
XFILLER_4_1457 VPWR VGND sg13cmos5l_decap_8
XFILLER_18_344 VPWR VGND sg13cmos5l_fill_2
XANTENNA__0907__X Tile_X3Y0_FrameStrobe_O[7] VPWR VGND sg13cmos5l_antennanp
XFILLER_18_377 VPWR VGND sg13cmos5l_decap_8
XANTENNA_140 Tile_X0Y0_FrameData[30] VPWR VGND sg13cmos5l_antennanp
XANTENNA_151 Tile_X0Y0_FrameData[30] VPWR VGND sg13cmos5l_antennanp
XANTENNA_162 Tile_X0Y0_FrameData[31] VPWR VGND sg13cmos5l_antennanp
XANTENNA_173 Tile_X0Y0_FrameData[31] VPWR VGND sg13cmos5l_antennanp
XANTENNA_184 _1093_/X VPWR VGND sg13cmos5l_antennanp
XANTENNA_195 Tile_X0Y0_FrameData[22] VPWR VGND sg13cmos5l_antennanp
X_0921_ Tile_X3Y0_N1BEG[1] Tile_X3Y0_S1END[2] VPWR VGND sg13cmos5l_buf_1
XFILLER_14_561 VPWR VGND sg13cmos5l_decap_8
X_0852_ Tile_X4Y0_N2BEG[0] Tile_X4Y0_S2MID[7] VPWR VGND sg13cmos5l_buf_1
XFILLER_11_1908 VPWR VGND sg13cmos5l_decap_8
X_0783_ Tile_X2Y0_NN4BEG[3] _1243_/X VPWR VGND sg13cmos5l_buf_1
XFILLER_9_2069 VPWR VGND sg13cmos5l_decap_8
X_1266_ _1266_/X Tile_X3Y0_S2MID[2] Tile_X3Y0_S4END[13] Tile_X3Y0_SS4END[2] _0572_/Q
+ _0485_/Q _0484_/Q VPWR VGND sg13cmos5l_mux4_1
XANTENNA__0817__X Tile_X4Y0_FrameData_O[21] VPWR VGND sg13cmos5l_antennanp
XFILLER_0_1800 VPWR VGND sg13cmos5l_decap_8
XFILLER_0_1811 VPWR VGND sg13cmos5l_decap_8
X_0217_ _0217_/Q Tile_X0Y0_FrameData[16] VGND VPWR Tile_X1Y0_FrameStrobe[0] latch
X_1197_ _1197_/X Tile_X1Y0_S2MID[5] Tile_X1Y0_S4END[2] Tile_X1Y0_SS4END[13] _0595_/Q
+ _0271_/Q _0270_/Q VPWR VGND sg13cmos5l_mux4_1
X_0148_ _0148_/Q Tile_X0Y0_FrameData[5] VGND VPWR Tile_X0Y0_FrameStrobe[1] latch
XFILLER_0_1866 VPWR VGND sg13cmos5l_decap_8
XFILLER_0_1877 VPWR VGND sg13cmos5l_fill_2
XFILLER_14_2222 VPWR VGND sg13cmos5l_decap_8
XFILLER_14_1510 VPWR VGND sg13cmos5l_fill_1
XFILLER_14_1532 VPWR VGND sg13cmos5l_fill_2
XFILLER_4_708 VPWR VGND sg13cmos5l_decap_8
XFILLER_14_2299 VPWR VGND sg13cmos5l_decap_8
XFILLER_10_1418 VPWR VGND sg13cmos5l_decap_8
XFILLER_14_1598 VPWR VGND sg13cmos5l_fill_1
XFILLER_0_914 VPWR VGND sg13cmos5l_decap_4
XFILLER_10_56 VPWR VGND sg13cmos5l_decap_8
XFILLER_9_1880 VPWR VGND sg13cmos5l_decap_8
XFILLER_5_1744 VPWR VGND sg13cmos5l_decap_8
XANTENNA__0727__X Tile_X0Y0_FrameStrobe_O[19] VPWR VGND sg13cmos5l_antennanp
XFILLER_5_1799 VPWR VGND sg13cmos5l_decap_8
XFILLER_5_1788 VPWR VGND sg13cmos5l_fill_1
XFILLER_1_1619 VPWR VGND sg13cmos5l_decap_8
XFILLER_3_1490 VPWR VGND sg13cmos5l_decap_8
XFILLER_16_837 VPWR VGND sg13cmos5l_fill_2
XFILLER_15_336 VPWR VGND sg13cmos5l_decap_8
XFILLER_7_513 VPWR VGND sg13cmos5l_decap_8
XFILLER_13_1031 VPWR VGND sg13cmos5l_decap_8
XFILLER_11_597 VPWR VGND sg13cmos5l_decap_4
XFILLER_13_1097 VPWR VGND sg13cmos5l_decap_8
XFILLER_10_1985 VPWR VGND sg13cmos5l_decap_8
XFILLER_3_752 VPWR VGND sg13cmos5l_decap_8
XFILLER_2_273 VPWR VGND sg13cmos5l_decap_8
XFILLER_8_2080 VPWR VGND sg13cmos5l_decap_8
X_1120_ _1120_/X Tile_X0Y0_S4END[12] Tile_X0Y0_S4END[13] Tile_X0Y0_SS4END[12] Tile_X0Y0_SS4END[14]
+ _0115_/Q _0114_/Q VPWR VGND sg13cmos5l_mux4_1
X_1051_ Tile_X1Y0_FrameStrobe_O[3] Tile_X1Y0_FrameStrobe[3] VPWR VGND sg13cmos5l_buf_1
XFILLER_4_1254 VPWR VGND sg13cmos5l_decap_8
X_0904_ Tile_X3Y0_FrameStrobe_O[4] Tile_X3Y0_FrameStrobe[4] VPWR VGND sg13cmos5l_buf_1
X_0835_ Tile_X4Y0_FrameStrobe_O[7] Tile_X4Y0_FrameStrobe[7] VPWR VGND sg13cmos5l_buf_1
XFILLER_15_1874 VPWR VGND sg13cmos5l_decap_8
X_0766_ Tile_X0Y0_NN4BEG[2] _1162_/X VPWR VGND sg13cmos5l_buf_1
X_0697_ Tile_X2Y0_N4BEG[5] _1229_/X VPWR VGND sg13cmos5l_buf_1
XFILLER_9_1132 VPWR VGND sg13cmos5l_decap_4
XFILLER_9_1143 VPWR VGND sg13cmos5l_decap_8
XFILLER_9_1154 VPWR VGND sg13cmos5l_decap_8
XFILLER_5_1029 VPWR VGND sg13cmos5l_decap_8
X_1249_ _1249_/X Tile_X2Y0_S2END[1] Tile_X2Y0_S4END[9] Tile_X2Y0_SS4END[6] _0584_/Q
+ _0343_/Q _0342_/Q VPWR VGND sg13cmos5l_mux4_1
XFILLER_2_1928 VPWR VGND sg13cmos5l_decap_8
XFILLER_0_2375 VPWR VGND sg13cmos5l_decap_4
XFILLER_0_2386 VPWR VGND sg13cmos5l_fill_1
XFILLER_0_2397 VPWR VGND sg13cmos5l_decap_8
XFILLER_13_818 VPWR VGND sg13cmos5l_fill_1
XFILLER_16_1616 VPWR VGND sg13cmos5l_fill_1
XANTENNA_40 NPU_RDATA31 VPWR VGND sg13cmos5l_antennanp
XANTENNA_51 Tile_X0Y0_FrameData[12] VPWR VGND sg13cmos5l_antennanp
XANTENNA_62 Tile_X0Y0_FrameData[15] VPWR VGND sg13cmos5l_antennanp
XANTENNA_73 Tile_X0Y0_FrameData[15] VPWR VGND sg13cmos5l_antennanp
XANTENNA_84 Tile_X0Y0_FrameData[21] VPWR VGND sg13cmos5l_antennanp
XFILLER_14_2074 VPWR VGND sg13cmos5l_decap_8
XANTENNA_95 Tile_X0Y0_FrameData[26] VPWR VGND sg13cmos5l_antennanp
XFILLER_4_505 VPWR VGND sg13cmos5l_decap_8
XFILLER_10_1226 VPWR VGND sg13cmos5l_decap_4
XFILLER_5_2264 VPWR VGND sg13cmos5l_decap_8
XFILLER_5_1585 VPWR VGND sg13cmos5l_decap_8
XFILLER_1_2139 VPWR VGND sg13cmos5l_decap_8
XFILLER_1_1416 VPWR VGND sg13cmos5l_decap_8
XFILLER_15_166 VPWR VGND sg13cmos5l_fill_2
XFILLER_12_873 VPWR VGND sg13cmos5l_decap_8
XFILLER_7_35 VPWR VGND sg13cmos5l_decap_8
XFILLER_11_372 VPWR VGND sg13cmos5l_decap_4
XANTENNA__0920__X Tile_X3Y0_N1BEG[0] VPWR VGND sg13cmos5l_antennanp
X_0620_ _0620_/L_HI VPWR VGND sg13cmos5l_tiehi
XFILLER_10_1771 VPWR VGND sg13cmos5l_decap_8
X_0551_ NPU_WDATA27 Tile_X0Y0_UserCLK _1128_/X _0656_/L_HI VPWR VGND sg13cmos5l_dfrbpq_1
XFILLER_3_571 VPWR VGND sg13cmos5l_decap_8
X_0482_ _0482_/Q Tile_X0Y0_FrameData[23] VGND VPWR Tile_X3Y0_FrameStrobe[2] latch
XFILLER_6_1338 VPWR VGND sg13cmos5l_decap_8
X_1103_ _1103_/X Tile_X1Y0_S4END[13] Tile_X1Y0_S4END[14] Tile_X1Y0_SS4END[13] Tile_X1Y0_SS4END[15]
+ _0229_/Q _0228_/Q VPWR VGND sg13cmos5l_mux4_1
X_1034_ Tile_X1Y0_N2BEGb[6] _1182_/X VPWR VGND sg13cmos5l_buf_1
XFILLER_4_1084 VPWR VGND sg13cmos5l_decap_8
XFILLER_1_1950 VPWR VGND sg13cmos5l_decap_4
XFILLER_17_1958 VPWR VGND sg13cmos5l_decap_8
XANTENNA__0830__X Tile_X4Y0_FrameStrobe_O[2] VPWR VGND sg13cmos5l_antennanp
X_0818_ Tile_X4Y0_FrameData_O[22] Tile_X0Y0_FrameData[22] VPWR VGND sg13cmos5l_buf_1
X_0749_ Tile_X0Y0_N4BEG[1] _1145_/X VPWR VGND sg13cmos5l_buf_1
XFILLER_6_1883 VPWR VGND sg13cmos5l_decap_8
XFILLER_2_1725 VPWR VGND sg13cmos5l_decap_8
XFILLER_16_33 VPWR VGND sg13cmos5l_decap_8
XFILLER_0_1482 VPWR VGND sg13cmos5l_decap_8
XFILLER_16_77 VPWR VGND sg13cmos5l_decap_8
XFILLER_16_2114 VPWR VGND sg13cmos5l_fill_1
XFILLER_13_615 VPWR VGND sg13cmos5l_decap_8
XFILLER_13_604 VPWR VGND sg13cmos5l_fill_1
XFILLER_16_1468 VPWR VGND sg13cmos5l_decap_8
XFILLER_5_803 VPWR VGND sg13cmos5l_decap_8
XANTENNA__0740__X Tile_X0Y0_N2BEGb[0] VPWR VGND sg13cmos5l_antennanp
XFILLER_10_1045 VPWR VGND sg13cmos5l_decap_8
XFILLER_4_357 VPWR VGND sg13cmos5l_decap_4
XFILLER_7_2326 VPWR VGND sg13cmos5l_decap_8
XFILLER_0_574 VPWR VGND sg13cmos5l_decap_8
XFILLER_5_2061 VPWR VGND sg13cmos5l_decap_8
XFILLER_5_1382 VPWR VGND sg13cmos5l_decap_8
XFILLER_17_954 VPWR VGND sg13cmos5l_decap_8
XANTENNA__0915__X Tile_X3Y0_FrameStrobe_O[15] VPWR VGND sg13cmos5l_antennanp
XFILLER_16_475 VPWR VGND sg13cmos5l_decap_8
XFILLER_8_663 VPWR VGND sg13cmos5l_decap_4
XFILLER_16_1980 VPWR VGND sg13cmos5l_decap_8
XFILLER_12_692 VPWR VGND sg13cmos5l_decap_8
XFILLER_7_184 VPWR VGND sg13cmos5l_decap_8
XFILLER_7_162 VPWR VGND sg13cmos5l_fill_1
X_0603_ _0603_/Q Tile_X0Y0_UserCLK NPU_RDATA31 _0619_/L_HI VPWR VGND sg13cmos5l_dfrbpq_1
XFILLER_12_1877 VPWR VGND sg13cmos5l_decap_8
X_0534_ NPU_WDATA10 Tile_X0Y0_UserCLK _1111_/X _0637_/L_HI VPWR VGND sg13cmos5l_dfrbpq_1
X_0465_ _0465_/Q Tile_X0Y0_FrameData[8] VGND VPWR Tile_X3Y0_FrameStrobe[1] latch
XFILLER_6_1102 VPWR VGND sg13cmos5l_decap_8
X_0396_ _0396_/Q Tile_X0Y0_FrameData[13] VGND VPWR Tile_X2Y0_FrameStrobe[2] latch
XFILLER_6_1179 VPWR VGND sg13cmos5l_decap_4
XFILLER_14_0 VPWR VGND sg13cmos5l_decap_8
XANTENNA__0825__X Tile_X4Y0_FrameData_O[29] VPWR VGND sg13cmos5l_antennanp
X_1017_ Tile_X1Y0_N4BEG[5] _1189_/X VPWR VGND sg13cmos5l_buf_1
XFILLER_17_1700 VPWR VGND sg13cmos5l_decap_8
XFILLER_13_2309 VPWR VGND sg13cmos5l_decap_8
XFILLER_15_1490 VPWR VGND sg13cmos5l_decap_8
XFILLER_11_2055 VPWR VGND sg13cmos5l_decap_8
XFILLER_11_1354 VPWR VGND sg13cmos5l_decap_8
XFILLER_2_817 VPWR VGND sg13cmos5l_decap_8
XFILLER_1_349 VPWR VGND sg13cmos5l_decap_8
XFILLER_8_1912 VPWR VGND sg13cmos5l_decap_8
XFILLER_8_1989 VPWR VGND sg13cmos5l_decap_8
XFILLER_2_2212 VPWR VGND sg13cmos5l_decap_4
XFILLER_18_718 VPWR VGND sg13cmos5l_decap_8
XFILLER_2_2267 VPWR VGND sg13cmos5l_decap_8
XFILLER_2_1533 VPWR VGND sg13cmos5l_decap_8
XANTENNA__0735__X Tile_X0Y0_N2BEG[3] VPWR VGND sg13cmos5l_antennanp
XFILLER_14_979 VPWR VGND sg13cmos5l_decap_8
XFILLER_13_467 VPWR VGND sg13cmos5l_decap_8
XFILLER_9_449 VPWR VGND sg13cmos5l_decap_8
XFILLER_5_611 VPWR VGND sg13cmos5l_decap_8
XFILLER_16_1298 VPWR VGND sg13cmos5l_decap_8
XFILLER_5_688 VPWR VGND sg13cmos5l_decap_8
XFILLER_4_154 VPWR VGND sg13cmos5l_decap_8
XFILLER_4_14 VPWR VGND sg13cmos5l_decap_8
XFILLER_1_850 VPWR VGND sg13cmos5l_fill_2
XFILLER_0_360 VPWR VGND sg13cmos5l_decap_8
X_0250_ _0250_/Q Tile_X0Y0_FrameData[15] VGND VPWR Tile_X1Y0_FrameStrobe[1] latch
XFILLER_7_2167 VPWR VGND sg13cmos5l_decap_8
XFILLER_7_1422 VPWR VGND sg13cmos5l_decap_8
XFILLER_3_1308 VPWR VGND sg13cmos5l_decap_8
X_0181_ _0181_/Q Tile_X0Y0_FrameData[4] VGND VPWR Tile_X0Y0_FrameStrobe[2] latch
XFILLER_7_1499 VPWR VGND sg13cmos5l_decap_8
XFILLER_1_1010 VPWR VGND sg13cmos5l_decap_8
XFILLER_17_773 VPWR VGND sg13cmos5l_decap_4
XFILLER_17_751 VPWR VGND sg13cmos5l_fill_1
XFILLER_1_1087 VPWR VGND sg13cmos5l_decap_8
XFILLER_9_994 VPWR VGND sg13cmos5l_decap_8
XFILLER_12_2386 VPWR VGND sg13cmos5l_decap_8
XFILLER_12_1630 VPWR VGND sg13cmos5l_decap_8
XFILLER_8_493 VPWR VGND sg13cmos5l_decap_8
XFILLER_12_1696 VPWR VGND sg13cmos5l_decap_4
X_0517_ _0517_/Q Tile_X0Y0_FrameData[22] VGND VPWR Tile_X4Y0_FrameStrobe[0] latch
X_0448_ _0448_/Q Tile_X0Y0_FrameData[25] VGND VPWR Tile_X3Y0_FrameStrobe[1] latch
X_0379_ _0379_/Q Tile_X0Y0_FrameData[30] VGND VPWR Tile_X2Y0_FrameStrobe[2] latch
XFILLER_3_1831 VPWR VGND sg13cmos5l_decap_8
XFILLER_17_1552 VPWR VGND sg13cmos5l_decap_4
XFILLER_13_1416 VPWR VGND sg13cmos5l_decap_8
XFILLER_11_1140 VPWR VGND sg13cmos5l_decap_8
XFILLER_11_1184 VPWR VGND sg13cmos5l_decap_8
XFILLER_2_636 VPWR VGND sg13cmos5l_decap_8
XFILLER_8_1742 VPWR VGND sg13cmos5l_decap_8
XFILLER_4_2318 VPWR VGND sg13cmos5l_decap_8
XFILLER_1_168 VPWR VGND sg13cmos5l_decap_8
XFILLER_4_1639 VPWR VGND sg13cmos5l_decap_8
XFILLER_2_2053 VPWR VGND sg13cmos5l_decap_8
XFILLER_2_2020 VPWR VGND sg13cmos5l_fill_1
XFILLER_2_1330 VPWR VGND sg13cmos5l_decap_8
XFILLER_18_1327 VPWR VGND sg13cmos5l_decap_8
XFILLER_13_242 VPWR VGND sg13cmos5l_decap_8
XFILLER_13_231 VPWR VGND sg13cmos5l_decap_8
XFILLER_9_213 VPWR VGND sg13cmos5l_decap_8
XFILLER_13_253 VPWR VGND sg13cmos5l_fill_2
XFILLER_9_257 VPWR VGND sg13cmos5l_decap_8
XFILLER_16_1051 VPWR VGND sg13cmos5l_fill_1
XFILLER_13_297 VPWR VGND sg13cmos5l_decap_4
XFILLER_6_920 VPWR VGND sg13cmos5l_decap_8
XFILLER_13_1961 VPWR VGND sg13cmos5l_decap_8
XFILLER_6_997 VPWR VGND sg13cmos5l_decap_8
XFILLER_9_2218 VPWR VGND sg13cmos5l_fill_1
XFILLER_5_485 VPWR VGND sg13cmos5l_decap_8
X_0302_ _0302_/Q Tile_X0Y0_FrameData[27] VGND VPWR Tile_X1Y0_FrameStrobe[3] latch
X_1282_ _1282_/X Tile_X3Y0_S2END[2] Tile_X3Y0_S4END[2] Tile_X3Y0_SS4END[13] _0573_/Q
+ _0453_/Q _0452_/Q VPWR VGND sg13cmos5l_mux4_1
X_0233_ _0233_/Q Tile_X0Y0_FrameData[0] VGND VPWR Tile_X1Y0_FrameStrobe[0] latch
XFILLER_7_1274 VPWR VGND sg13cmos5l_fill_1
X_0164_ _0164_/Q Tile_X0Y0_FrameData[21] VGND VPWR Tile_X0Y0_FrameStrobe[2] latch
X_0095_ _0095_/Q Tile_X0Y0_FrameData[26] VGND VPWR Tile_X0Y0_FrameStrobe[0] latch
XFILLER_18_1861 VPWR VGND sg13cmos5l_fill_1
X_0997_ Tile_X1Y0_NN4BEG[1] _1201_/X VPWR VGND sg13cmos5l_buf_1
XFILLER_12_2150 VPWR VGND sg13cmos5l_decap_8
XFILLER_8_1016 VPWR VGND sg13cmos5l_decap_8
XFILLER_3_2384 VPWR VGND sg13cmos5l_decap_8
XFILLER_3_1672 VPWR VGND sg13cmos5l_decap_8
XFILLER_15_529 VPWR VGND sg13cmos5l_decap_4
XFILLER_10_201 VPWR VGND sg13cmos5l_decap_8
XFILLER_10_223 VPWR VGND sg13cmos5l_fill_2
XFILLER_17_1382 VPWR VGND sg13cmos5l_decap_4
XFILLER_13_1235 VPWR VGND sg13cmos5l_fill_1
XFILLER_6_238 VPWR VGND sg13cmos5l_decap_8
XFILLER_3_912 VPWR VGND sg13cmos5l_decap_8
XFILLER_3_989 VPWR VGND sg13cmos5l_decap_8
XFILLER_2_433 VPWR VGND sg13cmos5l_decap_8
XFILLER_8_2240 VPWR VGND sg13cmos5l_decap_8
XFILLER_4_2115 VPWR VGND sg13cmos5l_decap_8
XFILLER_4_1436 VPWR VGND sg13cmos5l_decap_8
XFILLER_18_356 VPWR VGND sg13cmos5l_decap_8
XANTENNA_130 Tile_X0Y0_FrameData[30] VPWR VGND sg13cmos5l_antennanp
XANTENNA_141 Tile_X0Y0_FrameData[30] VPWR VGND sg13cmos5l_antennanp
XANTENNA_152 Tile_X0Y0_FrameData[30] VPWR VGND sg13cmos5l_antennanp
XFILLER_2_1171 VPWR VGND sg13cmos5l_decap_4
XANTENNA_163 Tile_X0Y0_FrameData[31] VPWR VGND sg13cmos5l_antennanp
XANTENNA_174 Tile_X0Y0_FrameData[31] VPWR VGND sg13cmos5l_antennanp
XANTENNA_185 Tile_X0Y0_FrameData[22] VPWR VGND sg13cmos5l_antennanp
XANTENNA_196 Tile_X0Y0_FrameData[22] VPWR VGND sg13cmos5l_antennanp
XANTENNA__0923__X Tile_X3Y0_N1BEG[3] VPWR VGND sg13cmos5l_antennanp
X_0920_ Tile_X3Y0_N1BEG[0] Tile_X3Y0_S1END[3] VPWR VGND sg13cmos5l_buf_1
X_0851_ Tile_X4Y0_N1BEG[3] Tile_X4Y0_S1END[0] VPWR VGND sg13cmos5l_buf_1
X_0782_ Tile_X2Y0_NN4BEG[2] _1242_/X VPWR VGND sg13cmos5l_buf_1
XFILLER_13_1791 VPWR VGND sg13cmos5l_decap_8
XFILLER_9_2048 VPWR VGND sg13cmos5l_decap_8
XFILLER_9_1369 VPWR VGND sg13cmos5l_decap_8
X_1265_ _1265_/X Tile_X3Y0_S2MID[1] Tile_X3Y0_S4END[14] Tile_X3Y0_SS4END[1] _0573_/Q
+ _0487_/Q _0486_/Q VPWR VGND sg13cmos5l_mux4_1
XFILLER_7_1071 VPWR VGND sg13cmos5l_decap_8
X_0216_ _0216_/Q Tile_X0Y0_FrameData[17] VGND VPWR Tile_X1Y0_FrameStrobe[0] latch
X_1196_ _1196_/X Tile_X1Y0_S2MID[4] Tile_X1Y0_S4END[3] Tile_X1Y0_SS4END[12] _0594_/Q
+ _0273_/Q _0272_/Q VPWR VGND sg13cmos5l_mux4_1
X_0147_ _0147_/Q Tile_X0Y0_FrameData[6] VGND VPWR Tile_X0Y0_FrameStrobe[1] latch
XANTENNA__0833__X Tile_X4Y0_FrameStrobe_O[5] VPWR VGND sg13cmos5l_antennanp
XFILLER_14_2201 VPWR VGND sg13cmos5l_decap_8
XFILLER_14_2278 VPWR VGND sg13cmos5l_decap_8
XFILLER_10_79 VPWR VGND sg13cmos5l_decap_8
XFILLER_0_926 VPWR VGND sg13cmos5l_fill_1
XFILLER_5_1723 VPWR VGND sg13cmos5l_decap_8
XFILLER_3_2181 VPWR VGND sg13cmos5l_decap_8
XANTENNA__0743__X Tile_X0Y0_N2BEGb[3] VPWR VGND sg13cmos5l_antennanp
XFILLER_11_521 VPWR VGND sg13cmos5l_decap_8
XFILLER_13_1010 VPWR VGND sg13cmos5l_decap_8
XFILLER_11_554 VPWR VGND sg13cmos5l_fill_1
XFILLER_7_569 VPWR VGND sg13cmos5l_decap_8
XFILLER_10_1942 VPWR VGND sg13cmos5l_decap_8
XFILLER_10_1964 VPWR VGND sg13cmos5l_decap_8
XFILLER_3_731 VPWR VGND sg13cmos5l_decap_8
XFILLER_2_252 VPWR VGND sg13cmos5l_decap_8
XANTENNA__0918__X Tile_X3Y0_FrameStrobe_O[18] VPWR VGND sg13cmos5l_antennanp
XFILLER_4_1233 VPWR VGND sg13cmos5l_fill_2
X_1050_ Tile_X1Y0_FrameStrobe_O[2] Tile_X1Y0_FrameStrobe[2] VPWR VGND sg13cmos5l_buf_1
XFILLER_15_871 VPWR VGND sg13cmos5l_fill_1
XFILLER_15_893 VPWR VGND sg13cmos5l_fill_1
XFILLER_14_381 VPWR VGND sg13cmos5l_fill_2
X_0903_ Tile_X3Y0_FrameStrobe_O[3] Tile_X3Y0_FrameStrobe[3] VPWR VGND sg13cmos5l_buf_1
X_0834_ Tile_X4Y0_FrameStrobe_O[6] Tile_X4Y0_FrameStrobe[6] VPWR VGND sg13cmos5l_buf_1
X_0765_ Tile_X0Y0_NN4BEG[1] _1161_/X VPWR VGND sg13cmos5l_buf_1
X_0696_ Tile_X2Y0_N4BEG[4] _1228_/X VPWR VGND sg13cmos5l_buf_1
XFILLER_5_1008 VPWR VGND sg13cmos5l_decap_8
XANTENNA__0828__X Tile_X4Y0_FrameStrobe_O[0] VPWR VGND sg13cmos5l_antennanp
XFILLER_2_1907 VPWR VGND sg13cmos5l_decap_8
X_1248_ _1248_/X Tile_X2Y0_S2END[0] Tile_X2Y0_S4END[8] Tile_X2Y0_SS4END[7] _0585_/Q
+ _0345_/Q _0344_/Q VPWR VGND sg13cmos5l_mux4_1
XFILLER_2_91 VPWR VGND sg13cmos5l_decap_8
XFILLER_0_2354 VPWR VGND sg13cmos5l_decap_8
X_1179_ _1179_/X Tile_X1Y0_S1END[3] Tile_X1Y0_S2MID[3] Tile_X1Y0_S2END[4] _0591_/Q
+ _0307_/Q _0306_/Q VPWR VGND sg13cmos5l_mux4_1
XFILLER_0_1697 VPWR VGND sg13cmos5l_fill_2
XANTENNA_30 NPU_RDATA26 VPWR VGND sg13cmos5l_antennanp
XANTENNA_41 NPU_RDATA31 VPWR VGND sg13cmos5l_antennanp
XFILLER_14_2053 VPWR VGND sg13cmos5l_decap_8
XANTENNA_52 Tile_X0Y0_FrameData[12] VPWR VGND sg13cmos5l_antennanp
XANTENNA_63 Tile_X0Y0_FrameData[15] VPWR VGND sg13cmos5l_antennanp
XANTENNA_74 Tile_X0Y0_FrameData[21] VPWR VGND sg13cmos5l_antennanp
XANTENNA_85 Tile_X0Y0_FrameData[21] VPWR VGND sg13cmos5l_antennanp
XANTENNA_96 Tile_X0Y0_FrameData[26] VPWR VGND sg13cmos5l_antennanp
XFILLER_14_1385 VPWR VGND sg13cmos5l_decap_4
XFILLER_0_767 VPWR VGND sg13cmos5l_decap_8
XFILLER_5_2243 VPWR VGND sg13cmos5l_decap_8
XANTENNA__0738__X Tile_X0Y0_N2BEG[6] VPWR VGND sg13cmos5l_antennanp
XFILLER_1_2118 VPWR VGND sg13cmos5l_decap_8
XFILLER_5_1564 VPWR VGND sg13cmos5l_decap_8
XFILLER_15_101 VPWR VGND sg13cmos5l_decap_4
XFILLER_15_123 VPWR VGND sg13cmos5l_fill_2
XFILLER_16_679 VPWR VGND sg13cmos5l_decap_8
XFILLER_8_801 VPWR VGND sg13cmos5l_decap_8
XFILLER_7_333 VPWR VGND sg13cmos5l_decap_8
XFILLER_7_14 VPWR VGND sg13cmos5l_decap_8
XFILLER_11_362 VPWR VGND sg13cmos5l_fill_2
X_0550_ NPU_WDATA26 Tile_X0Y0_UserCLK _1127_/X _0659_/L_HI VPWR VGND sg13cmos5l_dfrbpq_1
XFILLER_3_550 VPWR VGND sg13cmos5l_decap_8
X_0481_ _0481_/Q Tile_X0Y0_FrameData[24] VGND VPWR Tile_X3Y0_FrameStrobe[2] latch
XFILLER_6_1317 VPWR VGND sg13cmos5l_decap_8
X_1102_ _1102_/X Tile_X1Y0_S4END[14] Tile_X1Y0_S4END[15] Tile_X1Y0_SS4END[12] Tile_X1Y0_SS4END[14]
+ _0231_/Q _0230_/Q VPWR VGND sg13cmos5l_mux4_1
X_1033_ Tile_X1Y0_N2BEGb[5] _1181_/X VPWR VGND sg13cmos5l_buf_1
XFILLER_4_1063 VPWR VGND sg13cmos5l_decap_8
XFILLER_1_1995 VPWR VGND sg13cmos5l_decap_8
XFILLER_15_2384 VPWR VGND sg13cmos5l_decap_8
XFILLER_15_1683 VPWR VGND sg13cmos5l_decap_8
X_0817_ Tile_X4Y0_FrameData_O[21] Tile_X0Y0_FrameData[21] VPWR VGND sg13cmos5l_buf_1
X_0748_ Tile_X0Y0_N4BEG[0] _1144_/X VPWR VGND sg13cmos5l_buf_1
X_0679_ _0679_/L_HI VPWR VGND sg13cmos5l_tiehi
XFILLER_6_1862 VPWR VGND sg13cmos5l_decap_8
XFILLER_0_2173 VPWR VGND sg13cmos5l_decap_4
XFILLER_0_1461 VPWR VGND sg13cmos5l_decap_8
XFILLER_16_2126 VPWR VGND sg13cmos5l_decap_8
XFILLER_13_649 VPWR VGND sg13cmos5l_decap_8
XFILLER_13_627 VPWR VGND sg13cmos5l_fill_1
XFILLER_8_108 VPWR VGND sg13cmos5l_fill_2
XFILLER_12_148 VPWR VGND sg13cmos5l_fill_1
XFILLER_8_119 VPWR VGND sg13cmos5l_decap_4
XFILLER_16_1447 VPWR VGND sg13cmos5l_decap_8
XFILLER_5_848 VPWR VGND sg13cmos5l_fill_2
XFILLER_4_336 VPWR VGND sg13cmos5l_decap_8
XFILLER_7_2305 VPWR VGND sg13cmos5l_decap_8
XFILLER_0_553 VPWR VGND sg13cmos5l_decap_8
XFILLER_7_1604 VPWR VGND sg13cmos5l_decap_4
XFILLER_5_2040 VPWR VGND sg13cmos5l_decap_8
XFILLER_5_1361 VPWR VGND sg13cmos5l_decap_8
XFILLER_17_933 VPWR VGND sg13cmos5l_decap_8
XFILLER_16_410 VPWR VGND sg13cmos5l_fill_1
XFILLER_1_1269 VPWR VGND sg13cmos5l_decap_8
XFILLER_17_999 VPWR VGND sg13cmos5l_fill_1
XFILLER_16_454 VPWR VGND sg13cmos5l_decap_8
XANTENNA__0931__X Tile_X3Y0_N2BEG[7] VPWR VGND sg13cmos5l_antennanp
XFILLER_11_181 VPWR VGND sg13cmos5l_fill_1
XFILLER_8_675 VPWR VGND sg13cmos5l_decap_8
XFILLER_12_1856 VPWR VGND sg13cmos5l_decap_8
XFILLER_10_2292 VPWR VGND sg13cmos5l_decap_8
X_0602_ _0602_/Q Tile_X0Y0_UserCLK NPU_RDATA30 _0618_/L_HI VPWR VGND sg13cmos5l_dfrbpq_1
XFILLER_10_1591 VPWR VGND sg13cmos5l_decap_8
X_0533_ NPU_WDATA9 Tile_X0Y0_UserCLK _1110_/X _0638_/L_HI VPWR VGND sg13cmos5l_dfrbpq_1
X_0464_ _0464_/Q Tile_X0Y0_FrameData[9] VGND VPWR Tile_X3Y0_FrameStrobe[1] latch
X_0395_ _0395_/Q Tile_X0Y0_FrameData[14] VGND VPWR Tile_X2Y0_FrameStrobe[2] latch
XFILLER_6_1158 VPWR VGND sg13cmos5l_decap_8
X_1016_ Tile_X1Y0_N4BEG[4] _1188_/X VPWR VGND sg13cmos5l_buf_1
XFILLER_1_1792 VPWR VGND sg13cmos5l_decap_8
XANTENNA__1002__X Tile_X1Y0_NN4BEG[6] VPWR VGND sg13cmos5l_antennanp
XFILLER_17_1756 VPWR VGND sg13cmos5l_decap_8
XFILLER_17_1745 VPWR VGND sg13cmos5l_decap_4
XANTENNA__0841__X Tile_X4Y0_FrameStrobe_O[13] VPWR VGND sg13cmos5l_antennanp
XFILLER_11_2034 VPWR VGND sg13cmos5l_decap_8
XFILLER_11_1311 VPWR VGND sg13cmos5l_decap_8
XFILLER_11_1322 VPWR VGND sg13cmos5l_fill_2
XFILLER_1_328 VPWR VGND sg13cmos5l_decap_8
XFILLER_8_1968 VPWR VGND sg13cmos5l_decap_8
XFILLER_6_2393 VPWR VGND sg13cmos5l_decap_8
XFILLER_2_2246 VPWR VGND sg13cmos5l_decap_8
XFILLER_2_1512 VPWR VGND sg13cmos5l_decap_8
XFILLER_2_1589 VPWR VGND sg13cmos5l_decap_8
XFILLER_18_1509 VPWR VGND sg13cmos5l_fill_1
XFILLER_14_958 VPWR VGND sg13cmos5l_decap_8
XFILLER_13_446 VPWR VGND sg13cmos5l_decap_8
XFILLER_9_439 VPWR VGND sg13cmos5l_decap_8
XANTENNA__0751__X Tile_X0Y0_N4BEG[3] VPWR VGND sg13cmos5l_antennanp
XFILLER_16_1266 VPWR VGND sg13cmos5l_fill_2
XFILLER_4_133 VPWR VGND sg13cmos5l_decap_8
XFILLER_5_667 VPWR VGND sg13cmos5l_decap_8
XFILLER_7_2146 VPWR VGND sg13cmos5l_decap_8
XFILLER_7_1401 VPWR VGND sg13cmos5l_decap_8
XFILLER_7_1478 VPWR VGND sg13cmos5l_decap_8
X_0180_ _0180_/Q Tile_X0Y0_FrameData[5] VGND VPWR Tile_X0Y0_FrameStrobe[2] latch
XANTENNA__0926__X Tile_X3Y0_N2BEG[2] VPWR VGND sg13cmos5l_antennanp
XFILLER_1_1066 VPWR VGND sg13cmos5l_decap_8
XFILLER_16_262 VPWR VGND sg13cmos5l_fill_1
XFILLER_12_490 VPWR VGND sg13cmos5l_decap_8
XFILLER_9_973 VPWR VGND sg13cmos5l_decap_8
XFILLER_8_472 VPWR VGND sg13cmos5l_decap_8
XFILLER_12_2365 VPWR VGND sg13cmos5l_decap_8
XFILLER_12_1620 VPWR VGND sg13cmos5l_fill_1
XFILLER_12_1675 VPWR VGND sg13cmos5l_fill_2
X_0516_ _0516_/Q Tile_X0Y0_FrameData[21] VGND VPWR Tile_X4Y0_FrameStrobe[0] latch
X_0447_ _0447_/Q Tile_X0Y0_FrameData[26] VGND VPWR Tile_X3Y0_FrameStrobe[1] latch
X_0378_ _0378_/Q Tile_X0Y0_FrameData[31] VGND VPWR Tile_X2Y0_FrameStrobe[2] latch
XANTENNA__0836__X Tile_X4Y0_FrameStrobe_O[8] VPWR VGND sg13cmos5l_antennanp
XFILLER_3_1887 VPWR VGND sg13cmos5l_decap_8
XFILLER_17_2243 VPWR VGND sg13cmos5l_fill_1
XFILLER_17_2276 VPWR VGND sg13cmos5l_decap_8
XFILLER_13_2129 VPWR VGND sg13cmos5l_decap_8
XFILLER_10_427 VPWR VGND sg13cmos5l_decap_8
XFILLER_17_1575 VPWR VGND sg13cmos5l_decap_4
XFILLER_6_409 VPWR VGND sg13cmos5l_decap_8
XFILLER_13_68 VPWR VGND sg13cmos5l_fill_2
XFILLER_11_1174 VPWR VGND sg13cmos5l_fill_2
XFILLER_2_615 VPWR VGND sg13cmos5l_decap_8
XFILLER_8_2411 VPWR VGND sg13cmos5l_decap_8
XFILLER_8_1710 VPWR VGND sg13cmos5l_fill_1
XFILLER_1_147 VPWR VGND sg13cmos5l_decap_8
XFILLER_4_1618 VPWR VGND sg13cmos5l_decap_8
XFILLER_8_1798 VPWR VGND sg13cmos5l_decap_8
XFILLER_2_2032 VPWR VGND sg13cmos5l_decap_8
XANTENNA__0746__X Tile_X0Y0_N2BEGb[6] VPWR VGND sg13cmos5l_antennanp
XFILLER_18_2007 VPWR VGND sg13cmos5l_fill_1
XFILLER_2_1386 VPWR VGND sg13cmos5l_decap_8
XFILLER_14_755 VPWR VGND sg13cmos5l_decap_4
XFILLER_16_1096 VPWR VGND sg13cmos5l_decap_4
XFILLER_16_1074 VPWR VGND sg13cmos5l_decap_4
XFILLER_13_1940 VPWR VGND sg13cmos5l_decap_8
XFILLER_10_983 VPWR VGND sg13cmos5l_decap_8
XFILLER_6_976 VPWR VGND sg13cmos5l_decap_8
XFILLER_5_464 VPWR VGND sg13cmos5l_decap_8
X_0301_ _0301_/Q Tile_X0Y0_FrameData[28] VGND VPWR Tile_X1Y0_FrameStrobe[3] latch
X_1281_ _1281_/X Tile_X3Y0_S2END[1] Tile_X3Y0_S4END[1] Tile_X3Y0_SS4END[14] _0572_/Q
+ _0455_/Q _0454_/Q VPWR VGND sg13cmos5l_mux4_1
X_0232_ _0232_/Q Tile_X0Y0_FrameData[1] VGND VPWR Tile_X1Y0_FrameStrobe[0] latch
X_0163_ _0163_/Q Tile_X0Y0_FrameData[22] VGND VPWR Tile_X0Y0_FrameStrobe[2] latch
X_0094_ _0094_/Q Tile_X0Y0_FrameData[27] VGND VPWR Tile_X0Y0_FrameStrobe[0] latch
XFILLER_17_560 VPWR VGND sg13cmos5l_fill_1
XFILLER_17_593 VPWR VGND sg13cmos5l_fill_2
XFILLER_18_1840 VPWR VGND sg13cmos5l_decap_8
X_0996_ Tile_X1Y0_NN4BEG[0] _1200_/X VPWR VGND sg13cmos5l_buf_1
XFILLER_8_280 VPWR VGND sg13cmos5l_decap_4
XFILLER_12_1494 VPWR VGND sg13cmos5l_decap_8
XFILLER_5_91 VPWR VGND sg13cmos5l_decap_8
XFILLER_5_1949 VPWR VGND sg13cmos5l_decap_8
XFILLER_3_2363 VPWR VGND sg13cmos5l_decap_8
XFILLER_3_1651 VPWR VGND sg13cmos5l_decap_8
XFILLER_15_508 VPWR VGND sg13cmos5l_decap_8
XFILLER_7_707 VPWR VGND sg13cmos5l_decap_8
XFILLER_7_718 VPWR VGND sg13cmos5l_fill_2
XFILLER_6_217 VPWR VGND sg13cmos5l_decap_8
XFILLER_3_968 VPWR VGND sg13cmos5l_decap_8
XFILLER_2_489 VPWR VGND sg13cmos5l_decap_8
XFILLER_8_2296 VPWR VGND sg13cmos5l_decap_8
XFILLER_8_1595 VPWR VGND sg13cmos5l_fill_1
XFILLER_8_1584 VPWR VGND sg13cmos5l_decap_8
XFILLER_4_1415 VPWR VGND sg13cmos5l_decap_8
XFILLER_1_49 VPWR VGND sg13cmos5l_decap_8
XFILLER_18_324 VPWR VGND sg13cmos5l_fill_2
XFILLER_18_302 VPWR VGND sg13cmos5l_decap_4
XFILLER_2_1150 VPWR VGND sg13cmos5l_decap_8
XANTENNA_120 Tile_X0Y0_FrameData[29] VPWR VGND sg13cmos5l_antennanp
XANTENNA_131 Tile_X0Y0_FrameData[30] VPWR VGND sg13cmos5l_antennanp
XANTENNA_142 Tile_X0Y0_FrameData[30] VPWR VGND sg13cmos5l_antennanp
XANTENNA_153 Tile_X0Y0_FrameData[30] VPWR VGND sg13cmos5l_antennanp
XANTENNA_164 Tile_X0Y0_FrameData[31] VPWR VGND sg13cmos5l_antennanp
XANTENNA_175 Tile_X0Y0_FrameData[31] VPWR VGND sg13cmos5l_antennanp
XFILLER_2_1194 VPWR VGND sg13cmos5l_fill_2
XFILLER_18_1103 VPWR VGND sg13cmos5l_decap_8
XANTENNA_186 Tile_X0Y0_FrameData[22] VPWR VGND sg13cmos5l_antennanp
XANTENNA_197 Tile_X0Y0_FrameData[22] VPWR VGND sg13cmos5l_antennanp
XFILLER_18_1147 VPWR VGND sg13cmos5l_fill_2
XFILLER_14_596 VPWR VGND sg13cmos5l_fill_2
X_0850_ Tile_X4Y0_N1BEG[2] Tile_X4Y0_S1END[1] VPWR VGND sg13cmos5l_buf_1
X_0781_ Tile_X2Y0_NN4BEG[1] _1241_/X VPWR VGND sg13cmos5l_buf_1
XFILLER_6_784 VPWR VGND sg13cmos5l_decap_8
XFILLER_9_2027 VPWR VGND sg13cmos5l_decap_8
XFILLER_5_283 VPWR VGND sg13cmos5l_decap_8
XFILLER_9_1315 VPWR VGND sg13cmos5l_decap_8
X_1264_ _1264_/X Tile_X3Y0_S2MID[0] Tile_X3Y0_S4END[15] Tile_X3Y0_SS4END[0] _0572_/Q
+ _0489_/Q _0488_/Q VPWR VGND sg13cmos5l_mux4_1
XFILLER_7_1050 VPWR VGND sg13cmos5l_decap_8
X_0215_ _0215_/Q Tile_X0Y0_FrameData[18] VGND VPWR Tile_X1Y0_FrameStrobe[0] latch
X_1195_ _1195_/X Tile_X1Y0_S2MID[3] Tile_X1Y0_S4END[4] Tile_X1Y0_SS4END[11] _0593_/Q
+ _0275_/Q _0274_/Q VPWR VGND sg13cmos5l_mux4_1
XFILLER_4_1971 VPWR VGND sg13cmos5l_fill_1
XFILLER_0_1835 VPWR VGND sg13cmos5l_decap_8
X_0146_ _0146_/Q Tile_X0Y0_FrameData[7] VGND VPWR Tile_X0Y0_FrameStrobe[1] latch
XFILLER_18_880 VPWR VGND sg13cmos5l_decap_8
XFILLER_18_2360 VPWR VGND sg13cmos5l_fill_1
XANTENNA__1010__X Tile_X1Y0_NN4BEG[14] VPWR VGND sg13cmos5l_antennanp
XFILLER_14_2257 VPWR VGND sg13cmos5l_decap_8
XFILLER_14_1534 VPWR VGND sg13cmos5l_fill_1
X_0979_ Tile_X2Y0_FrameStrobe_O[7] Tile_X2Y0_FrameStrobe[7] VPWR VGND sg13cmos5l_buf_1
XFILLER_14_1567 VPWR VGND sg13cmos5l_fill_2
XFILLER_14_1556 VPWR VGND sg13cmos5l_decap_8
XFILLER_10_14 VPWR VGND sg13cmos5l_decap_8
XFILLER_10_36 VPWR VGND sg13cmos5l_decap_8
XFILLER_0_905 VPWR VGND sg13cmos5l_fill_2
XFILLER_3_2160 VPWR VGND sg13cmos5l_decap_8
XFILLER_5_1779 VPWR VGND sg13cmos5l_decap_4
XFILLER_16_806 VPWR VGND sg13cmos5l_decap_8
XFILLER_16_839 VPWR VGND sg13cmos5l_fill_1
XFILLER_16_828 VPWR VGND sg13cmos5l_decap_4
XFILLER_11_500 VPWR VGND sg13cmos5l_decap_8
XFILLER_11_566 VPWR VGND sg13cmos5l_fill_1
XFILLER_7_548 VPWR VGND sg13cmos5l_decap_8
XFILLER_10_1921 VPWR VGND sg13cmos5l_decap_8
XFILLER_13_1066 VPWR VGND sg13cmos5l_fill_1
XFILLER_4_0 VPWR VGND sg13cmos5l_decap_8
XFILLER_2_231 VPWR VGND sg13cmos5l_decap_8
XFILLER_3_787 VPWR VGND sg13cmos5l_decap_8
XFILLER_4_1201 VPWR VGND sg13cmos5l_decap_8
XFILLER_8_1392 VPWR VGND sg13cmos5l_decap_8
XFILLER_4_1212 VPWR VGND sg13cmos5l_decap_8
XFILLER_0_1109 VPWR VGND sg13cmos5l_decap_8
XFILLER_18_110 VPWR VGND sg13cmos5l_fill_1
XFILLER_4_1289 VPWR VGND sg13cmos5l_decap_8
XFILLER_18_176 VPWR VGND sg13cmos5l_fill_2
XANTENNA__0934__X Tile_X3Y0_N2BEGb[2] VPWR VGND sg13cmos5l_antennanp
X_0902_ Tile_X3Y0_FrameStrobe_O[2] Tile_X3Y0_FrameStrobe[2] VPWR VGND sg13cmos5l_buf_1
XFILLER_15_1832 VPWR VGND sg13cmos5l_decap_4
XFILLER_15_1810 VPWR VGND sg13cmos5l_decap_8
X_0833_ Tile_X4Y0_FrameStrobe_O[5] Tile_X4Y0_FrameStrobe[5] VPWR VGND sg13cmos5l_buf_1
X_0764_ Tile_X0Y0_NN4BEG[0] _1160_/X VPWR VGND sg13cmos5l_buf_1
X_0695_ Tile_X2Y0_N4BEG[3] _1227_/X VPWR VGND sg13cmos5l_buf_1
XFILLER_2_70 VPWR VGND sg13cmos5l_decap_8
XANTENNA__1005__X Tile_X1Y0_NN4BEG[9] VPWR VGND sg13cmos5l_antennanp
XFILLER_0_2333 VPWR VGND sg13cmos5l_decap_8
X_1247_ _1247_/X Tile_X2Y0_S2END[7] Tile_X2Y0_S4END[7] Tile_X2Y0_SS4END[8] _0582_/Q
+ _0347_/Q _0346_/Q VPWR VGND sg13cmos5l_mux4_1
X_1178_ _1178_/X Tile_X1Y0_S1END[2] Tile_X1Y0_S2MID[2] Tile_X1Y0_S2END[5] _0590_/Q
+ _0309_/Q _0308_/Q VPWR VGND sg13cmos5l_mux4_1
XANTENNA__0844__X Tile_X4Y0_FrameStrobe_O[16] VPWR VGND sg13cmos5l_antennanp
X_0129_ _0129_/Q Tile_X0Y0_FrameData[24] VGND VPWR Tile_X0Y0_FrameStrobe[1] latch
XANTENNA_20 NPU_RDATA21 VPWR VGND sg13cmos5l_antennanp
XANTENNA_31 NPU_RDATA27 VPWR VGND sg13cmos5l_antennanp
XFILLER_14_2032 VPWR VGND sg13cmos5l_decap_8
XANTENNA_42 NPU_RDATA4 VPWR VGND sg13cmos5l_antennanp
XANTENNA_53 Tile_X0Y0_FrameData[12] VPWR VGND sg13cmos5l_antennanp
XANTENNA_64 Tile_X0Y0_FrameData[15] VPWR VGND sg13cmos5l_antennanp
XANTENNA_75 Tile_X0Y0_FrameData[21] VPWR VGND sg13cmos5l_antennanp
XFILLER_14_1342 VPWR VGND sg13cmos5l_decap_8
XFILLER_14_1331 VPWR VGND sg13cmos5l_fill_1
XANTENNA_86 Tile_X0Y0_FrameData[21] VPWR VGND sg13cmos5l_antennanp
XANTENNA_97 Tile_X0Y0_FrameData[26] VPWR VGND sg13cmos5l_antennanp
XFILLER_14_1364 VPWR VGND sg13cmos5l_decap_8
XFILLER_7_1808 VPWR VGND sg13cmos5l_fill_1
XFILLER_0_757 VPWR VGND sg13cmos5l_decap_4
XFILLER_5_2222 VPWR VGND sg13cmos5l_decap_8
XFILLER_5_1543 VPWR VGND sg13cmos5l_decap_8
XFILLER_5_2299 VPWR VGND sg13cmos5l_decap_8
XANTENNA__0754__X Tile_X0Y0_N4BEG[6] VPWR VGND sg13cmos5l_antennanp
XFILLER_16_658 VPWR VGND sg13cmos5l_fill_1
XFILLER_16_669 VPWR VGND sg13cmos5l_fill_2
XFILLER_15_1117 VPWR VGND sg13cmos5l_decap_8
XFILLER_7_389 VPWR VGND sg13cmos5l_fill_2
XFILLER_10_1751 VPWR VGND sg13cmos5l_decap_8
XFILLER_10_1762 VPWR VGND sg13cmos5l_decap_4
X_0480_ _0480_/Q Tile_X0Y0_FrameData[25] VGND VPWR Tile_X3Y0_FrameStrobe[2] latch
XANTENNA__0929__X Tile_X3Y0_N2BEG[5] VPWR VGND sg13cmos5l_antennanp
X_1101_ _1101_/X Tile_X1Y0_S4END[12] Tile_X1Y0_S4END[15] Tile_X1Y0_SS4END[13] Tile_X1Y0_SS4END[15]
+ _0233_/Q _0232_/Q VPWR VGND sg13cmos5l_mux4_1
XFILLER_4_1042 VPWR VGND sg13cmos5l_decap_8
X_1032_ Tile_X1Y0_N2BEGb[4] _1180_/X VPWR VGND sg13cmos5l_buf_1
XFILLER_1_1974 VPWR VGND sg13cmos5l_decap_8
XFILLER_17_1916 VPWR VGND sg13cmos5l_decap_8
XFILLER_15_2363 VPWR VGND sg13cmos5l_decap_8
XFILLER_11_2249 VPWR VGND sg13cmos5l_decap_8
X_0816_ Tile_X4Y0_FrameData_O[20] Tile_X0Y0_FrameData[20] VPWR VGND sg13cmos5l_buf_1
X_0747_ Tile_X0Y0_N2BEGb[7] _1143_/X VPWR VGND sg13cmos5l_buf_1
X_0678_ _0678_/L_HI VPWR VGND sg13cmos5l_tiehi
XANTENNA__0839__X Tile_X4Y0_FrameStrobe_O[11] VPWR VGND sg13cmos5l_antennanp
XFILLER_0_2152 VPWR VGND sg13cmos5l_decap_8
XFILLER_0_1440 VPWR VGND sg13cmos5l_decap_8
XFILLER_16_2105 VPWR VGND sg13cmos5l_decap_8
XFILLER_16_2149 VPWR VGND sg13cmos5l_decap_4
XFILLER_16_1426 VPWR VGND sg13cmos5l_decap_8
XANTENNA__0523__Q NPU_READ_BANK_SEL2 VPWR VGND sg13cmos5l_antennanp
XFILLER_10_1025 VPWR VGND sg13cmos5l_decap_8
XFILLER_4_315 VPWR VGND sg13cmos5l_decap_8
XFILLER_14_1161 VPWR VGND sg13cmos5l_decap_8
XANTENNA__0749__X Tile_X0Y0_N4BEG[1] VPWR VGND sg13cmos5l_antennanp
XFILLER_0_532 VPWR VGND sg13cmos5l_decap_8
XFILLER_7_1616 VPWR VGND sg13cmos5l_decap_4
XFILLER_5_2096 VPWR VGND sg13cmos5l_decap_8
XFILLER_5_1340 VPWR VGND sg13cmos5l_decap_8
XFILLER_17_912 VPWR VGND sg13cmos5l_decap_8
XFILLER_16_433 VPWR VGND sg13cmos5l_decap_8
XFILLER_17_989 VPWR VGND sg13cmos5l_decap_4
XFILLER_8_621 VPWR VGND sg13cmos5l_decap_8
XFILLER_12_1813 VPWR VGND sg13cmos5l_decap_4
XFILLER_12_1835 VPWR VGND sg13cmos5l_decap_8
XFILLER_10_2271 VPWR VGND sg13cmos5l_decap_8
X_0601_ _0601_/Q Tile_X0Y0_UserCLK NPU_RDATA29 _0617_/L_HI VPWR VGND sg13cmos5l_dfrbpq_1
X_0532_ NPU_WDATA8 Tile_X0Y0_UserCLK _1109_/X _0639_/L_HI VPWR VGND sg13cmos5l_dfrbpq_1
X_0463_ _0463_/Q Tile_X0Y0_FrameData[10] VGND VPWR Tile_X3Y0_FrameStrobe[1] latch
X_0394_ _0394_/Q Tile_X0Y0_FrameData[15] VGND VPWR Tile_X2Y0_FrameStrobe[2] latch
XFILLER_6_1137 VPWR VGND sg13cmos5l_decap_8
X_1015_ Tile_X1Y0_N4BEG[3] _1187_/X VPWR VGND sg13cmos5l_buf_1
XFILLER_1_1771 VPWR VGND sg13cmos5l_decap_8
XFILLER_15_2160 VPWR VGND sg13cmos5l_fill_2
XFILLER_11_2013 VPWR VGND sg13cmos5l_decap_8
XFILLER_11_1345 VPWR VGND sg13cmos5l_decap_4
XFILLER_11_1389 VPWR VGND sg13cmos5l_decap_8
XFILLER_8_1947 VPWR VGND sg13cmos5l_decap_8
XFILLER_6_2372 VPWR VGND sg13cmos5l_decap_8
XFILLER_2_2225 VPWR VGND sg13cmos5l_decap_8
XFILLER_2_2203 VPWR VGND sg13cmos5l_decap_4
XFILLER_2_1568 VPWR VGND sg13cmos5l_decap_8
XFILLER_14_937 VPWR VGND sg13cmos5l_decap_8
XFILLER_14_926 VPWR VGND sg13cmos5l_fill_1
XFILLER_13_425 VPWR VGND sg13cmos5l_decap_8
XFILLER_5_646 VPWR VGND sg13cmos5l_decap_8
XFILLER_4_112 VPWR VGND sg13cmos5l_decap_8
XFILLER_4_49 VPWR VGND sg13cmos5l_decap_8
XFILLER_4_189 VPWR VGND sg13cmos5l_decap_8
XFILLER_7_2125 VPWR VGND sg13cmos5l_decap_8
XFILLER_1_863 VPWR VGND sg13cmos5l_decap_8
XFILLER_1_852 VPWR VGND sg13cmos5l_fill_1
XFILLER_7_1457 VPWR VGND sg13cmos5l_decap_8
XFILLER_1_1045 VPWR VGND sg13cmos5l_decap_8
XFILLER_16_252 VPWR VGND sg13cmos5l_fill_1
XANTENNA__0942__X Tile_X3Y0_N4BEG[2] VPWR VGND sg13cmos5l_antennanp
XFILLER_17_1009 VPWR VGND sg13cmos5l_decap_8
XFILLER_9_952 VPWR VGND sg13cmos5l_decap_8
XFILLER_8_451 VPWR VGND sg13cmos5l_decap_8
XFILLER_12_2344 VPWR VGND sg13cmos5l_decap_8
XFILLER_10_2090 VPWR VGND sg13cmos5l_decap_8
X_0515_ _0515_/Q Tile_X0Y0_FrameData[20] VGND VPWR Tile_X4Y0_FrameStrobe[0] latch
X_0446_ _0446_/Q Tile_X0Y0_FrameData[27] VGND VPWR Tile_X3Y0_FrameStrobe[1] latch
X_0377_ _0377_/Q Tile_X0Y0_FrameData[0] VGND VPWR Tile_X2Y0_FrameStrobe[1] latch
XFILLER_7_1980 VPWR VGND sg13cmos5l_decap_8
XFILLER_3_1866 VPWR VGND sg13cmos5l_decap_8
XANTENNA__1013__X Tile_X1Y0_N4BEG[1] VPWR VGND sg13cmos5l_antennanp
XFILLER_17_2255 VPWR VGND sg13cmos5l_decap_8
XANTENNA__0852__X Tile_X4Y0_N2BEG[0] VPWR VGND sg13cmos5l_antennanp
XFILLER_10_406 VPWR VGND sg13cmos5l_decap_8
XFILLER_13_2108 VPWR VGND sg13cmos5l_decap_8
XFILLER_13_14 VPWR VGND sg13cmos5l_decap_8
XFILLER_11_929 VPWR VGND sg13cmos5l_decap_8
XFILLER_11_918 VPWR VGND sg13cmos5l_decap_8
XFILLER_8_7 VPWR VGND sg13cmos5l_decap_8
XFILLER_8_2401 VPWR VGND sg13cmos5l_decap_8
XFILLER_1_126 VPWR VGND sg13cmos5l_decap_8
XFILLER_8_1733 VPWR VGND sg13cmos5l_fill_2
XFILLER_8_1722 VPWR VGND sg13cmos5l_decap_8
XFILLER_8_1777 VPWR VGND sg13cmos5l_decap_8
XFILLER_6_2191 VPWR VGND sg13cmos5l_fill_1
XFILLER_2_2088 VPWR VGND sg13cmos5l_decap_8
XFILLER_2_1365 VPWR VGND sg13cmos5l_decap_8
XFILLER_13_200 VPWR VGND sg13cmos5l_fill_1
XFILLER_14_734 VPWR VGND sg13cmos5l_decap_8
XANTENNA__0762__X Tile_X0Y0_N4BEG[14] VPWR VGND sg13cmos5l_antennanp
XFILLER_10_962 VPWR VGND sg13cmos5l_decap_8
XFILLER_6_955 VPWR VGND sg13cmos5l_decap_8
XFILLER_5_443 VPWR VGND sg13cmos5l_decap_8
XFILLER_13_1996 VPWR VGND sg13cmos5l_decap_8
X_0300_ _0300_/Q Tile_X0Y0_FrameData[29] VGND VPWR Tile_X1Y0_FrameStrobe[3] latch
X_1280_ _1280_/X Tile_X3Y0_S2END[0] Tile_X3Y0_S4END[0] Tile_X3Y0_SS4END[15] _0573_/Q
+ _0457_/Q _0456_/Q VPWR VGND sg13cmos5l_mux4_1
XFILLER_7_1221 VPWR VGND sg13cmos5l_decap_4
XFILLER_1_682 VPWR VGND sg13cmos5l_decap_8
XANTENNA__0937__X Tile_X3Y0_N2BEGb[5] VPWR VGND sg13cmos5l_antennanp
XFILLER_0_192 VPWR VGND sg13cmos5l_decap_8
X_0231_ _0231_/Q Tile_X0Y0_FrameData[2] VGND VPWR Tile_X1Y0_FrameStrobe[0] latch
X_0162_ _0162_/Q Tile_X0Y0_FrameData[23] VGND VPWR Tile_X0Y0_FrameStrobe[2] latch
XFILLER_3_1129 VPWR VGND sg13cmos5l_decap_8
X_0093_ _0093_/Q Tile_X0Y0_FrameData[28] VGND VPWR Tile_X0Y0_FrameStrobe[0] latch
XFILLER_17_550 VPWR VGND sg13cmos5l_fill_2
X_0995_ Tile_X2Y0_N1BEG[3] Tile_X2Y0_S1END[0] VPWR VGND sg13cmos5l_buf_1
XFILLER_12_2185 VPWR VGND sg13cmos5l_fill_1
XFILLER_12_1473 VPWR VGND sg13cmos5l_decap_8
XFILLER_5_70 VPWR VGND sg13cmos5l_decap_8
XANTENNA__1008__X Tile_X1Y0_NN4BEG[12] VPWR VGND sg13cmos5l_antennanp
XANTENNA__0847__X Tile_X4Y0_FrameStrobe_O[19] VPWR VGND sg13cmos5l_antennanp
X_0429_ _0429_/Q Tile_X0Y0_FrameData[12] VGND VPWR Tile_X3Y0_FrameStrobe[0] latch
XFILLER_5_1928 VPWR VGND sg13cmos5l_decap_8
XFILLER_3_2342 VPWR VGND sg13cmos5l_decap_8
XFILLER_3_1630 VPWR VGND sg13cmos5l_decap_8
XFILLER_17_2063 VPWR VGND sg13cmos5l_fill_1
XFILLER_17_2052 VPWR VGND sg13cmos5l_fill_1
XFILLER_11_715 VPWR VGND sg13cmos5l_decap_8
XFILLER_10_225 VPWR VGND sg13cmos5l_fill_1
XFILLER_11_737 VPWR VGND sg13cmos5l_decap_4
XFILLER_17_1395 VPWR VGND sg13cmos5l_fill_2
XANTENNA__0531__Q NPU_WDATA7 VPWR VGND sg13cmos5l_antennanp
XFILLER_3_947 VPWR VGND sg13cmos5l_decap_8
XFILLER_2_468 VPWR VGND sg13cmos5l_decap_8
XFILLER_8_2275 VPWR VGND sg13cmos5l_decap_8
XFILLER_8_1552 VPWR VGND sg13cmos5l_decap_8
XANTENNA__0757__X Tile_X0Y0_N4BEG[9] VPWR VGND sg13cmos5l_antennanp
XFILLER_1_28 VPWR VGND sg13cmos5l_decap_8
XANTENNA_110 Tile_X0Y0_FrameData[29] VPWR VGND sg13cmos5l_antennanp
XANTENNA_121 Tile_X0Y0_FrameData[29] VPWR VGND sg13cmos5l_antennanp
XANTENNA_132 Tile_X0Y0_FrameData[30] VPWR VGND sg13cmos5l_antennanp
XANTENNA_143 Tile_X0Y0_FrameData[30] VPWR VGND sg13cmos5l_antennanp
XANTENNA_154 Tile_X0Y0_FrameData[30] VPWR VGND sg13cmos5l_antennanp
XANTENNA_165 Tile_X0Y0_FrameData[31] VPWR VGND sg13cmos5l_antennanp
XANTENNA_176 Tile_X0Y0_FrameData[31] VPWR VGND sg13cmos5l_antennanp
XANTENNA_187 Tile_X0Y0_FrameData[22] VPWR VGND sg13cmos5l_antennanp
XANTENNA_198 Tile_X0Y0_FrameData[22] VPWR VGND sg13cmos5l_antennanp
XFILLER_18_1137 VPWR VGND sg13cmos5l_fill_1
XFILLER_18_1159 VPWR VGND sg13cmos5l_decap_4
X_0780_ Tile_X2Y0_NN4BEG[0] _1240_/X VPWR VGND sg13cmos5l_buf_1
XFILLER_6_741 VPWR VGND sg13cmos5l_fill_1
XFILLER_9_2006 VPWR VGND sg13cmos5l_decap_8
XFILLER_5_262 VPWR VGND sg13cmos5l_decap_8
X_1263_ _1263_/X Tile_X3Y0_S1END[3] Tile_X3Y0_S2MID[7] Tile_X3Y0_S2END[0] _0579_/Q
+ _0491_/Q _0490_/Q VPWR VGND sg13cmos5l_mux4_1
XFILLER_1_490 VPWR VGND sg13cmos5l_decap_8
X_0214_ _0214_/Q Tile_X0Y0_FrameData[19] VGND VPWR Tile_X1Y0_FrameStrobe[0] latch
XFILLER_7_1095 VPWR VGND sg13cmos5l_decap_8
X_1194_ _1194_/X Tile_X1Y0_S2MID[2] Tile_X1Y0_S4END[5] Tile_X1Y0_SS4END[10] _0592_/Q
+ _0277_/Q _0276_/Q VPWR VGND sg13cmos5l_mux4_1
XFILLER_0_1825 VPWR VGND sg13cmos5l_decap_4
X_0145_ _0145_/Q Tile_X0Y0_FrameData[8] VGND VPWR Tile_X0Y0_FrameStrobe[1] latch
XFILLER_4_1983 VPWR VGND sg13cmos5l_decap_8
XFILLER_18_892 VPWR VGND sg13cmos5l_fill_1
XFILLER_14_2236 VPWR VGND sg13cmos5l_decap_8
XFILLER_18_1693 VPWR VGND sg13cmos5l_decap_4
X_0978_ Tile_X2Y0_FrameStrobe_O[6] Tile_X2Y0_FrameStrobe[6] VPWR VGND sg13cmos5l_buf_1
XFILLER_5_2404 VPWR VGND sg13cmos5l_decap_8
XFILLER_9_1894 VPWR VGND sg13cmos5l_decap_8
XFILLER_5_1703 VPWR VGND sg13cmos5l_decap_8
XFILLER_5_1758 VPWR VGND sg13cmos5l_fill_2
XANTENNA__0526__Q NPU_WDATA2 VPWR VGND sg13cmos5l_antennanp
XFILLER_11_545 VPWR VGND sg13cmos5l_fill_2
XFILLER_7_527 VPWR VGND sg13cmos5l_decap_8
XFILLER_10_1900 VPWR VGND sg13cmos5l_decap_8
XFILLER_13_1045 VPWR VGND sg13cmos5l_decap_8
XFILLER_13_1078 VPWR VGND sg13cmos5l_decap_4
XFILLER_2_210 VPWR VGND sg13cmos5l_decap_8
XFILLER_10_1999 VPWR VGND sg13cmos5l_decap_8
XFILLER_3_766 VPWR VGND sg13cmos5l_decap_8
XFILLER_2_287 VPWR VGND sg13cmos5l_decap_8
XFILLER_8_2094 VPWR VGND sg13cmos5l_decap_8
XFILLER_4_1235 VPWR VGND sg13cmos5l_fill_1
XFILLER_4_1268 VPWR VGND sg13cmos5l_decap_8
XFILLER_18_122 VPWR VGND sg13cmos5l_fill_2
XFILLER_18_188 VPWR VGND sg13cmos5l_decap_4
X_0901_ Tile_X3Y0_FrameStrobe_O[1] Tile_X3Y0_FrameStrobe[1] VPWR VGND sg13cmos5l_buf_1
XANTENNA__0950__X Tile_X3Y0_N4BEG[10] VPWR VGND sg13cmos5l_antennanp
X_0832_ Tile_X4Y0_FrameStrobe_O[4] Tile_X4Y0_FrameStrobe[4] VPWR VGND sg13cmos5l_buf_1
XFILLER_15_1888 VPWR VGND sg13cmos5l_decap_8
X_0763_ Tile_X0Y0_N4BEG[15] _1159_/X VPWR VGND sg13cmos5l_buf_1
X_0694_ Tile_X2Y0_N4BEG[2] _1226_/X VPWR VGND sg13cmos5l_buf_1
XFILLER_6_582 VPWR VGND sg13cmos5l_decap_8
XFILLER_9_1168 VPWR VGND sg13cmos5l_fill_1
XFILLER_9_1179 VPWR VGND sg13cmos5l_decap_8
XFILLER_0_2312 VPWR VGND sg13cmos5l_decap_8
X_1246_ _1246_/X Tile_X2Y0_S2END[6] Tile_X2Y0_S4END[6] Tile_X2Y0_SS4END[9] _0583_/Q
+ _0349_/Q _0348_/Q VPWR VGND sg13cmos5l_mux4_1
X_1177_ _1177_/X Tile_X1Y0_S1END[1] Tile_X1Y0_S2MID[1] Tile_X1Y0_S2END[6] _0589_/Q
+ _0311_/Q _0310_/Q VPWR VGND sg13cmos5l_mux4_1
XFILLER_4_1791 VPWR VGND sg13cmos5l_decap_8
XFILLER_0_1633 VPWR VGND sg13cmos5l_fill_2
X_0128_ _0128_/Q Tile_X0Y0_FrameData[25] VGND VPWR Tile_X0Y0_FrameStrobe[1] latch
XFILLER_16_2309 VPWR VGND sg13cmos5l_decap_8
XANTENNA__1021__X Tile_X1Y0_N4BEG[9] VPWR VGND sg13cmos5l_antennanp
XFILLER_14_2011 VPWR VGND sg13cmos5l_decap_8
XANTENNA_10 NPU_RDATA15 VPWR VGND sg13cmos5l_antennanp
XANTENNA_21 NPU_RDATA22 VPWR VGND sg13cmos5l_antennanp
XANTENNA_32 NPU_RDATA27 VPWR VGND sg13cmos5l_antennanp
XANTENNA_43 NPU_RDATA5 VPWR VGND sg13cmos5l_antennanp
XANTENNA_54 Tile_X0Y0_FrameData[12] VPWR VGND sg13cmos5l_antennanp
XANTENNA_65 Tile_X0Y0_FrameData[15] VPWR VGND sg13cmos5l_antennanp
XANTENNA__0860__X Tile_X4Y0_N2BEGb[0] VPWR VGND sg13cmos5l_antennanp
XANTENNA_76 Tile_X0Y0_FrameData[21] VPWR VGND sg13cmos5l_antennanp
XANTENNA_87 Tile_X0Y0_FrameData[21] VPWR VGND sg13cmos5l_antennanp
XANTENNA_98 Tile_X0Y0_FrameData[26] VPWR VGND sg13cmos5l_antennanp
XFILLER_14_2088 VPWR VGND sg13cmos5l_decap_8
XFILLER_4_519 VPWR VGND sg13cmos5l_decap_8
XFILLER_5_2201 VPWR VGND sg13cmos5l_decap_8
XFILLER_9_2381 VPWR VGND sg13cmos5l_decap_8
XFILLER_5_2278 VPWR VGND sg13cmos5l_decap_8
XFILLER_5_1522 VPWR VGND sg13cmos5l_decap_8
XFILLER_1_1408 VPWR VGND sg13cmos5l_decap_4
XFILLER_5_1599 VPWR VGND sg13cmos5l_decap_8
XFILLER_15_125 VPWR VGND sg13cmos5l_fill_1
XFILLER_15_147 VPWR VGND sg13cmos5l_decap_4
XFILLER_12_865 VPWR VGND sg13cmos5l_fill_1
XFILLER_11_320 VPWR VGND sg13cmos5l_decap_8
XANTENNA__0770__X Tile_X0Y0_NN4BEG[6] VPWR VGND sg13cmos5l_antennanp
XFILLER_8_847 VPWR VGND sg13cmos5l_fill_1
XFILLER_11_364 VPWR VGND sg13cmos5l_fill_1
XFILLER_7_49 VPWR VGND sg13cmos5l_decap_8
XFILLER_10_1785 VPWR VGND sg13cmos5l_decap_8
XFILLER_6_2009 VPWR VGND sg13cmos5l_decap_8
XFILLER_3_585 VPWR VGND sg13cmos5l_decap_8
X_1100_ _1100_/X Tile_X3Y0_S1END[3] Tile_X3Y0_S2MID[0] Tile_X3Y0_S2MID[7] Tile_X3Y0_S2END[0]
+ _0411_/Q _0506_/Q VPWR VGND sg13cmos5l_mux4_1
XFILLER_4_1021 VPWR VGND sg13cmos5l_decap_8
XANTENNA__0945__X Tile_X3Y0_N4BEG[5] VPWR VGND sg13cmos5l_antennanp
X_1031_ Tile_X1Y0_N2BEGb[3] _1179_/X VPWR VGND sg13cmos5l_buf_1
XFILLER_4_1098 VPWR VGND sg13cmos5l_decap_8
XFILLER_17_1939 VPWR VGND sg13cmos5l_decap_4
XFILLER_15_2342 VPWR VGND sg13cmos5l_decap_8
XFILLER_15_1674 VPWR VGND sg13cmos5l_decap_4
X_0815_ Tile_X4Y0_FrameData_O[19] Tile_X0Y0_FrameData[19] VPWR VGND sg13cmos5l_buf_1
X_0746_ Tile_X0Y0_N2BEGb[6] _1142_/X VPWR VGND sg13cmos5l_buf_1
X_0677_ _0677_/L_HI VPWR VGND sg13cmos5l_tiehi
XANTENNA__1016__X Tile_X1Y0_N4BEG[4] VPWR VGND sg13cmos5l_antennanp
XFILLER_2_2407 VPWR VGND sg13cmos5l_decap_8
XANTENNA__0855__X Tile_X4Y0_N2BEG[3] VPWR VGND sg13cmos5l_antennanp
XFILLER_0_2131 VPWR VGND sg13cmos5l_decap_8
X_1229_ _1229_/X Tile_X2Y0_S2MID[5] Tile_X2Y0_S4END[10] Tile_X2Y0_SS4END[5] _0583_/Q
+ _0383_/Q _0382_/Q VPWR VGND sg13cmos5l_mux4_1
XFILLER_6_1897 VPWR VGND sg13cmos5l_decap_8
XFILLER_2_1739 VPWR VGND sg13cmos5l_decap_8
XFILLER_16_14 VPWR VGND sg13cmos5l_decap_8
XFILLER_0_1496 VPWR VGND sg13cmos5l_decap_8
XFILLER_16_1405 VPWR VGND sg13cmos5l_decap_8
XFILLER_10_1004 VPWR VGND sg13cmos5l_decap_8
XFILLER_5_817 VPWR VGND sg13cmos5l_decap_8
XFILLER_10_1059 VPWR VGND sg13cmos5l_decap_8
XFILLER_0_511 VPWR VGND sg13cmos5l_decap_8
XFILLER_0_588 VPWR VGND sg13cmos5l_decap_8
XFILLER_0_599 VPWR VGND sg13cmos5l_decap_8
XFILLER_5_2075 VPWR VGND sg13cmos5l_decap_8
XANTENNA__0765__X Tile_X0Y0_NN4BEG[1] VPWR VGND sg13cmos5l_antennanp
XFILLER_5_1396 VPWR VGND sg13cmos5l_decap_8
XFILLER_17_968 VPWR VGND sg13cmos5l_decap_8
XFILLER_16_489 VPWR VGND sg13cmos5l_decap_8
XFILLER_12_673 VPWR VGND sg13cmos5l_fill_2
XFILLER_12_662 VPWR VGND sg13cmos5l_decap_8
XFILLER_16_1994 VPWR VGND sg13cmos5l_decap_8
X_0600_ _0600_/Q Tile_X0Y0_UserCLK NPU_RDATA28 _0616_/L_HI VPWR VGND sg13cmos5l_dfrbpq_1
XFILLER_7_198 VPWR VGND sg13cmos5l_decap_8
X_0531_ NPU_WDATA7 Tile_X0Y0_UserCLK _1108_/X _0640_/L_HI VPWR VGND sg13cmos5l_dfrbpq_1
X_0462_ _0462_/Q Tile_X0Y0_FrameData[11] VGND VPWR Tile_X3Y0_FrameStrobe[1] latch
X_0393_ _0393_/Q Tile_X0Y0_FrameData[16] VGND VPWR Tile_X2Y0_FrameStrobe[2] latch
XFILLER_6_1116 VPWR VGND sg13cmos5l_decap_8
X_1014_ Tile_X1Y0_N4BEG[2] _1186_/X VPWR VGND sg13cmos5l_buf_1
XFILLER_1_1750 VPWR VGND sg13cmos5l_decap_8
XFILLER_17_2404 VPWR VGND sg13cmos5l_fill_1
XFILLER_8_81 VPWR VGND sg13cmos5l_decap_8
XFILLER_11_2069 VPWR VGND sg13cmos5l_decap_8
XFILLER_11_1368 VPWR VGND sg13cmos5l_decap_8
X_0729_ Tile_X0Y0_N1BEG[1] Tile_X0Y0_S1END[2] VPWR VGND sg13cmos5l_buf_1
XFILLER_8_1926 VPWR VGND sg13cmos5l_decap_8
XFILLER_6_2351 VPWR VGND sg13cmos5l_decap_8
XFILLER_2_1547 VPWR VGND sg13cmos5l_decap_8
XFILLER_0_1271 VPWR VGND sg13cmos5l_fill_2
XANTENNA__0534__Q NPU_WDATA10 VPWR VGND sg13cmos5l_antennanp
XFILLER_5_625 VPWR VGND sg13cmos5l_decap_8
XFILLER_11_1880 VPWR VGND sg13cmos5l_decap_8
XFILLER_7_2104 VPWR VGND sg13cmos5l_decap_8
XFILLER_4_28 VPWR VGND sg13cmos5l_decap_8
XFILLER_4_168 VPWR VGND sg13cmos5l_decap_8
XFILLER_7_1436 VPWR VGND sg13cmos5l_decap_8
XFILLER_1_1024 VPWR VGND sg13cmos5l_decap_8
XFILLER_16_220 VPWR VGND sg13cmos5l_fill_1
XFILLER_17_798 VPWR VGND sg13cmos5l_fill_1
XFILLER_9_931 VPWR VGND sg13cmos5l_decap_8
XFILLER_8_430 VPWR VGND sg13cmos5l_decap_8
XFILLER_14_1909 VPWR VGND sg13cmos5l_decap_8
XFILLER_13_982 VPWR VGND sg13cmos5l_decap_8
XFILLER_12_2323 VPWR VGND sg13cmos5l_decap_8
XFILLER_12_1655 VPWR VGND sg13cmos5l_fill_2
XFILLER_12_1644 VPWR VGND sg13cmos5l_decap_8
XFILLER_4_680 VPWR VGND sg13cmos5l_decap_8
XFILLER_10_1390 VPWR VGND sg13cmos5l_decap_8
X_0514_ _0514_/Q Tile_X0Y0_FrameData[19] VGND VPWR Tile_X4Y0_FrameStrobe[0] latch
X_0445_ _0445_/Q Tile_X0Y0_FrameData[28] VGND VPWR Tile_X3Y0_FrameStrobe[1] latch
X_0376_ _0376_/Q Tile_X0Y0_FrameData[1] VGND VPWR Tile_X2Y0_FrameStrobe[1] latch
XFILLER_3_1812 VPWR VGND sg13cmos5l_fill_2
XFILLER_3_1801 VPWR VGND sg13cmos5l_decap_8
XFILLER_12_0 VPWR VGND sg13cmos5l_decap_8
XFILLER_3_1845 VPWR VGND sg13cmos5l_decap_8
XFILLER_1_1591 VPWR VGND sg13cmos5l_decap_8
XFILLER_17_2234 VPWR VGND sg13cmos5l_decap_8
XFILLER_11_1121 VPWR VGND sg13cmos5l_fill_2
XFILLER_11_1154 VPWR VGND sg13cmos5l_decap_4
XFILLER_11_1176 VPWR VGND sg13cmos5l_fill_1
XFILLER_1_105 VPWR VGND sg13cmos5l_decap_8
XFILLER_8_1756 VPWR VGND sg13cmos5l_decap_8
XFILLER_6_2170 VPWR VGND sg13cmos5l_decap_8
XANTENNA__0529__Q NPU_WDATA5 VPWR VGND sg13cmos5l_antennanp
XFILLER_2_2067 VPWR VGND sg13cmos5l_decap_8
XFILLER_2_1344 VPWR VGND sg13cmos5l_decap_8
XFILLER_14_724 VPWR VGND sg13cmos5l_fill_2
XFILLER_14_768 VPWR VGND sg13cmos5l_fill_1
XFILLER_9_227 VPWR VGND sg13cmos5l_decap_8
XFILLER_13_278 VPWR VGND sg13cmos5l_decap_4
XFILLER_10_941 VPWR VGND sg13cmos5l_decap_8
XFILLER_6_934 VPWR VGND sg13cmos5l_decap_8
XFILLER_5_422 VPWR VGND sg13cmos5l_decap_8
XFILLER_13_1975 VPWR VGND sg13cmos5l_decap_8
XFILLER_5_499 VPWR VGND sg13cmos5l_decap_8
XFILLER_9_1509 VPWR VGND sg13cmos5l_decap_4
XFILLER_1_694 VPWR VGND sg13cmos5l_decap_4
X_0230_ _0230_/Q Tile_X0Y0_FrameData[3] VGND VPWR Tile_X1Y0_FrameStrobe[0] latch
XFILLER_3_1108 VPWR VGND sg13cmos5l_decap_8
X_0161_ _0161_/Q Tile_X0Y0_FrameData[24] VGND VPWR Tile_X0Y0_FrameStrobe[2] latch
X_0092_ _0092_/Q Tile_X0Y0_FrameData[29] VGND VPWR Tile_X0Y0_FrameStrobe[0] latch
XFILLER_17_540 VPWR VGND sg13cmos5l_decap_8
XANTENNA__0953__X Tile_X3Y0_N4BEG[13] VPWR VGND sg13cmos5l_antennanp
XFILLER_9_772 VPWR VGND sg13cmos5l_decap_8
X_0994_ Tile_X2Y0_N1BEG[2] Tile_X2Y0_S1END[1] VPWR VGND sg13cmos5l_buf_1
XFILLER_12_2164 VPWR VGND sg13cmos5l_decap_8
XFILLER_12_1452 VPWR VGND sg13cmos5l_decap_8
XFILLER_5_1907 VPWR VGND sg13cmos5l_decap_8
X_0428_ _0428_/Q Tile_X0Y0_FrameData[13] VGND VPWR Tile_X3Y0_FrameStrobe[0] latch
XFILLER_3_2321 VPWR VGND sg13cmos5l_decap_8
X_0359_ _0359_/Q Tile_X0Y0_FrameData[18] VGND VPWR Tile_X2Y0_FrameStrobe[1] latch
XANTENNA__1024__X Tile_X1Y0_N4BEG[12] VPWR VGND sg13cmos5l_antennanp
XFILLER_3_2398 VPWR VGND sg13cmos5l_decap_8
XANTENNA__0863__X Tile_X4Y0_N2BEGb[3] VPWR VGND sg13cmos5l_antennanp
XFILLER_3_1686 VPWR VGND sg13cmos5l_decap_8
XFILLER_17_2097 VPWR VGND sg13cmos5l_fill_2
XFILLER_17_2086 VPWR VGND sg13cmos5l_decap_8
XFILLER_17_1330 VPWR VGND sg13cmos5l_fill_2
XFILLER_13_1227 VPWR VGND sg13cmos5l_fill_1
XFILLER_3_926 VPWR VGND sg13cmos5l_decap_8
XFILLER_2_447 VPWR VGND sg13cmos5l_decap_8
XFILLER_8_2254 VPWR VGND sg13cmos5l_decap_8
XFILLER_8_1531 VPWR VGND sg13cmos5l_decap_8
XFILLER_4_2129 VPWR VGND sg13cmos5l_decap_8
XANTENNA_100 Tile_X0Y0_FrameData[26] VPWR VGND sg13cmos5l_antennanp
XFILLER_18_337 VPWR VGND sg13cmos5l_decap_8
XANTENNA_111 Tile_X0Y0_FrameData[29] VPWR VGND sg13cmos5l_antennanp
XANTENNA_122 Tile_X0Y0_FrameData[29] VPWR VGND sg13cmos5l_antennanp
XANTENNA_133 Tile_X0Y0_FrameData[30] VPWR VGND sg13cmos5l_antennanp
XANTENNA_144 Tile_X0Y0_FrameData[30] VPWR VGND sg13cmos5l_antennanp
XANTENNA_155 Tile_X0Y0_FrameData[30] VPWR VGND sg13cmos5l_antennanp
XANTENNA_166 Tile_X0Y0_FrameData[31] VPWR VGND sg13cmos5l_antennanp
XANTENNA__0773__X Tile_X0Y0_NN4BEG[9] VPWR VGND sg13cmos5l_antennanp
XANTENNA_177 Tile_X0Y0_FrameData[31] VPWR VGND sg13cmos5l_antennanp
XANTENNA_188 Tile_X0Y0_FrameData[22] VPWR VGND sg13cmos5l_antennanp
XANTENNA_199 Tile_X0Y0_FrameData[22] VPWR VGND sg13cmos5l_antennanp
XFILLER_14_598 VPWR VGND sg13cmos5l_fill_1
XFILLER_10_760 VPWR VGND sg13cmos5l_fill_1
XFILLER_6_731 VPWR VGND sg13cmos5l_fill_2
XFILLER_5_241 VPWR VGND sg13cmos5l_decap_8
XFILLER_9_1306 VPWR VGND sg13cmos5l_fill_2
XANTENNA__0948__X Tile_X3Y0_N4BEG[8] VPWR VGND sg13cmos5l_antennanp
X_1262_ _1262_/X Tile_X3Y0_S1END[2] Tile_X3Y0_S2MID[6] Tile_X3Y0_S2END[1] _0578_/Q
+ _0493_/Q _0492_/Q VPWR VGND sg13cmos5l_mux4_1
X_0213_ _0213_/Q Tile_X0Y0_FrameData[20] VGND VPWR Tile_X1Y0_FrameStrobe[0] latch
X_1193_ _1193_/X Tile_X1Y0_S2MID[1] Tile_X1Y0_S4END[6] Tile_X1Y0_SS4END[9] _0593_/Q
+ _0279_/Q _0278_/Q VPWR VGND sg13cmos5l_mux4_1
XFILLER_4_1962 VPWR VGND sg13cmos5l_decap_8
X_0144_ _0144_/Q Tile_X0Y0_FrameData[9] VGND VPWR Tile_X0Y0_FrameStrobe[1] latch
XFILLER_0_1859 VPWR VGND sg13cmos5l_decap_8
XFILLER_18_2351 VPWR VGND sg13cmos5l_decap_8
XFILLER_17_392 VPWR VGND sg13cmos5l_decap_8
XFILLER_14_2215 VPWR VGND sg13cmos5l_decap_8
X_0977_ Tile_X2Y0_FrameStrobe_O[5] Tile_X2Y0_FrameStrobe[5] VPWR VGND sg13cmos5l_buf_1
XANTENNA__1019__X Tile_X1Y0_N4BEG[7] VPWR VGND sg13cmos5l_antennanp
XFILLER_0_918 VPWR VGND sg13cmos5l_fill_1
XANTENNA__0858__X Tile_X4Y0_N2BEG[6] VPWR VGND sg13cmos5l_antennanp
XFILLER_9_1840 VPWR VGND sg13cmos5l_decap_8
XFILLER_9_1873 VPWR VGND sg13cmos5l_decap_8
XFILLER_5_1737 VPWR VGND sg13cmos5l_decap_8
XFILLER_3_2195 VPWR VGND sg13cmos5l_decap_8
XFILLER_3_1483 VPWR VGND sg13cmos5l_decap_8
XFILLER_7_506 VPWR VGND sg13cmos5l_decap_8
XFILLER_11_535 VPWR VGND sg13cmos5l_decap_4
XANTENNA__0542__Q NPU_WDATA18 VPWR VGND sg13cmos5l_antennanp
XFILLER_13_1024 VPWR VGND sg13cmos5l_decap_8
XFILLER_10_1956 VPWR VGND sg13cmos5l_decap_4
XFILLER_10_1978 VPWR VGND sg13cmos5l_decap_8
XFILLER_3_745 VPWR VGND sg13cmos5l_decap_8
XANTENNA__0768__X Tile_X0Y0_NN4BEG[4] VPWR VGND sg13cmos5l_antennanp
XFILLER_2_266 VPWR VGND sg13cmos5l_decap_8
XFILLER_8_2073 VPWR VGND sg13cmos5l_decap_8
XFILLER_4_1247 VPWR VGND sg13cmos5l_decap_8
XFILLER_18_156 VPWR VGND sg13cmos5l_fill_2
X_0900_ Tile_X3Y0_FrameStrobe_O[0] Tile_X3Y0_FrameStrobe[0] VPWR VGND sg13cmos5l_buf_1
XFILLER_14_351 VPWR VGND sg13cmos5l_fill_2
X_0831_ Tile_X4Y0_FrameStrobe_O[3] Tile_X4Y0_FrameStrobe[3] VPWR VGND sg13cmos5l_buf_1
XFILLER_15_1867 VPWR VGND sg13cmos5l_decap_8
X_0762_ Tile_X0Y0_N4BEG[14] _1158_/X VPWR VGND sg13cmos5l_buf_1
XFILLER_13_2281 VPWR VGND sg13cmos5l_decap_8
XFILLER_6_561 VPWR VGND sg13cmos5l_decap_8
X_0693_ Tile_X2Y0_N4BEG[1] _1225_/X VPWR VGND sg13cmos5l_buf_1
XFILLER_9_1125 VPWR VGND sg13cmos5l_decap_8
X_1245_ _1245_/X Tile_X2Y0_S2END[5] Tile_X2Y0_S4END[5] Tile_X2Y0_SS4END[10] _0582_/Q
+ _0351_/Q _0350_/Q VPWR VGND sg13cmos5l_mux4_1
X_1176_ _1176_/X Tile_X1Y0_S1END[0] Tile_X1Y0_S2MID[0] Tile_X1Y0_S2END[7] _0588_/Q
+ _0313_/Q _0312_/Q VPWR VGND sg13cmos5l_mux4_1
XFILLER_4_1770 VPWR VGND sg13cmos5l_decap_8
XFILLER_0_2368 VPWR VGND sg13cmos5l_decap_8
X_0127_ _0127_/Q Tile_X0Y0_FrameData[26] VGND VPWR Tile_X0Y0_FrameStrobe[1] latch
XANTENNA_11 NPU_RDATA16 VPWR VGND sg13cmos5l_antennanp
XANTENNA_22 NPU_RDATA22 VPWR VGND sg13cmos5l_antennanp
XANTENNA_33 NPU_RDATA28 VPWR VGND sg13cmos5l_antennanp
XANTENNA_44 NPU_RDATA6 VPWR VGND sg13cmos5l_antennanp
XANTENNA_55 Tile_X0Y0_FrameData[12] VPWR VGND sg13cmos5l_antennanp
XANTENNA_66 Tile_X0Y0_FrameData[15] VPWR VGND sg13cmos5l_antennanp
XFILLER_14_2067 VPWR VGND sg13cmos5l_decap_8
XFILLER_14_1322 VPWR VGND sg13cmos5l_decap_8
XANTENNA_77 Tile_X0Y0_FrameData[21] VPWR VGND sg13cmos5l_antennanp
XANTENNA_88 Tile_X0Y0_FrameData[21] VPWR VGND sg13cmos5l_antennanp
XANTENNA_99 Tile_X0Y0_FrameData[26] VPWR VGND sg13cmos5l_antennanp
XFILLER_9_2360 VPWR VGND sg13cmos5l_decap_8
XFILLER_9_1670 VPWR VGND sg13cmos5l_decap_8
XFILLER_9_1681 VPWR VGND sg13cmos5l_fill_1
XFILLER_5_2257 VPWR VGND sg13cmos5l_decap_8
XFILLER_5_1501 VPWR VGND sg13cmos5l_decap_8
XANTENNA__0537__Q NPU_WDATA13 VPWR VGND sg13cmos5l_antennanp
XFILLER_5_1578 VPWR VGND sg13cmos5l_decap_8
XFILLER_3_1280 VPWR VGND sg13cmos5l_decap_8
XFILLER_15_159 VPWR VGND sg13cmos5l_decap_8
XFILLER_12_800 VPWR VGND sg13cmos5l_fill_1
XFILLER_7_28 VPWR VGND sg13cmos5l_decap_8
XFILLER_10_1742 VPWR VGND sg13cmos5l_fill_2
XFILLER_3_564 VPWR VGND sg13cmos5l_decap_8
XFILLER_4_1000 VPWR VGND sg13cmos5l_decap_8
XFILLER_16_7 VPWR VGND sg13cmos5l_decap_8
X_1030_ Tile_X1Y0_N2BEGb[2] _1178_/X VPWR VGND sg13cmos5l_buf_1
XFILLER_4_1077 VPWR VGND sg13cmos5l_decap_8
XFILLER_1_1954 VPWR VGND sg13cmos5l_fill_2
XFILLER_1_1943 VPWR VGND sg13cmos5l_decap_8
XANTENNA__0961__X Tile_X3Y0_NN4BEG[5] VPWR VGND sg13cmos5l_antennanp
XFILLER_15_693 VPWR VGND sg13cmos5l_decap_8
XFILLER_15_2321 VPWR VGND sg13cmos5l_decap_8
X_0814_ Tile_X4Y0_FrameData_O[18] Tile_X0Y0_FrameData[18] VPWR VGND sg13cmos5l_buf_1
XFILLER_15_2398 VPWR VGND sg13cmos5l_fill_2
XFILLER_15_1653 VPWR VGND sg13cmos5l_fill_1
XFILLER_15_1697 VPWR VGND sg13cmos5l_fill_1
X_0745_ Tile_X0Y0_N2BEGb[5] _1141_/X VPWR VGND sg13cmos5l_buf_1
X_0676_ _0676_/L_HI VPWR VGND sg13cmos5l_tiehi
XFILLER_6_1810 VPWR VGND sg13cmos5l_decap_8
XFILLER_6_1876 VPWR VGND sg13cmos5l_decap_8
XFILLER_0_2110 VPWR VGND sg13cmos5l_decap_8
X_1228_ _1228_/X Tile_X2Y0_S2MID[4] Tile_X2Y0_S4END[11] Tile_X2Y0_SS4END[4] _0582_/Q
+ _0385_/Q _0384_/Q VPWR VGND sg13cmos5l_mux4_1
XFILLER_4_2290 VPWR VGND sg13cmos5l_decap_8
XFILLER_2_1718 VPWR VGND sg13cmos5l_decap_8
XANTENNA__1032__X Tile_X1Y0_N2BEGb[4] VPWR VGND sg13cmos5l_antennanp
X_1159_ _1159_/X Tile_X0Y0_S2MID[7] Tile_X0Y0_S4END[0] Tile_X0Y0_SS4END[15] _0603_/Q
+ _0155_/Q _0154_/Q VPWR VGND sg13cmos5l_mux4_1
XFILLER_13_608 VPWR VGND sg13cmos5l_decap_8
XFILLER_0_1475 VPWR VGND sg13cmos5l_decap_8
XANTENNA__0871__X Tile_X4Y0_N4BEG[3] VPWR VGND sg13cmos5l_antennanp
XFILLER_14_1185 VPWR VGND sg13cmos5l_decap_8
XFILLER_7_2319 VPWR VGND sg13cmos5l_decap_8
XFILLER_0_567 VPWR VGND sg13cmos5l_decap_8
XFILLER_5_2054 VPWR VGND sg13cmos5l_decap_8
XFILLER_5_1375 VPWR VGND sg13cmos5l_decap_8
XFILLER_17_947 VPWR VGND sg13cmos5l_decap_8
XFILLER_16_468 VPWR VGND sg13cmos5l_decap_8
XANTENNA__0781__X Tile_X2Y0_NN4BEG[1] VPWR VGND sg13cmos5l_antennanp
XFILLER_12_630 VPWR VGND sg13cmos5l_decap_8
XFILLER_11_140 VPWR VGND sg13cmos5l_decap_8
XFILLER_8_612 VPWR VGND sg13cmos5l_fill_2
XFILLER_16_1940 VPWR VGND sg13cmos5l_decap_4
XFILLER_8_656 VPWR VGND sg13cmos5l_decap_8
XFILLER_16_1973 VPWR VGND sg13cmos5l_decap_8
XFILLER_12_685 VPWR VGND sg13cmos5l_decap_8
XFILLER_8_667 VPWR VGND sg13cmos5l_fill_1
XFILLER_7_155 VPWR VGND sg13cmos5l_decap_8
XFILLER_7_177 VPWR VGND sg13cmos5l_decap_8
X_0530_ NPU_WDATA6 Tile_X0Y0_UserCLK _1107_/X _0641_/L_HI VPWR VGND sg13cmos5l_dfrbpq_1
XFILLER_10_1572 VPWR VGND sg13cmos5l_fill_2
X_0461_ _0461_/Q Tile_X0Y0_FrameData[12] VGND VPWR Tile_X3Y0_FrameStrobe[1] latch
X_0392_ _0392_/Q Tile_X0Y0_FrameData[17] VGND VPWR Tile_X2Y0_FrameStrobe[2] latch
XANTENNA__0956__X Tile_X3Y0_NN4BEG[0] VPWR VGND sg13cmos5l_antennanp
X_1013_ Tile_X1Y0_N4BEG[1] _1185_/X VPWR VGND sg13cmos5l_buf_1
XFILLER_17_2416 VPWR VGND sg13cmos5l_fill_2
XFILLER_16_991 VPWR VGND sg13cmos5l_decap_8
XFILLER_8_60 VPWR VGND sg13cmos5l_decap_8
XFILLER_15_2173 VPWR VGND sg13cmos5l_decap_4
XFILLER_15_2162 VPWR VGND sg13cmos5l_fill_1
XFILLER_11_1303 VPWR VGND sg13cmos5l_fill_1
XFILLER_15_1483 VPWR VGND sg13cmos5l_decap_8
XFILLER_11_2048 VPWR VGND sg13cmos5l_decap_8
X_0728_ Tile_X0Y0_N1BEG[0] Tile_X0Y0_S1END[3] VPWR VGND sg13cmos5l_buf_1
XANTENNA__1027__X Tile_X1Y0_N4BEG[15] VPWR VGND sg13cmos5l_antennanp
X_0659_ _0659_/L_HI VPWR VGND sg13cmos5l_tiehi
XFILLER_8_1905 VPWR VGND sg13cmos5l_decap_8
XFILLER_6_2330 VPWR VGND sg13cmos5l_decap_8
XANTENNA__0866__X Tile_X4Y0_N2BEGb[6] VPWR VGND sg13cmos5l_antennanp
XFILLER_2_2216 VPWR VGND sg13cmos5l_fill_2
XFILLER_2_1526 VPWR VGND sg13cmos5l_decap_8
XFILLER_16_1225 VPWR VGND sg13cmos5l_fill_2
XFILLER_16_1203 VPWR VGND sg13cmos5l_fill_1
XFILLER_5_604 VPWR VGND sg13cmos5l_decap_8
XANTENNA__0550__Q NPU_WDATA26 VPWR VGND sg13cmos5l_antennanp
XFILLER_4_147 VPWR VGND sg13cmos5l_decap_8
XFILLER_1_832 VPWR VGND sg13cmos5l_decap_8
XFILLER_0_353 VPWR VGND sg13cmos5l_decap_8
XFILLER_7_1415 VPWR VGND sg13cmos5l_decap_8
XANTENNA__0776__X Tile_X0Y0_NN4BEG[12] VPWR VGND sg13cmos5l_antennanp
XFILLER_1_1003 VPWR VGND sg13cmos5l_decap_8
XFILLER_16_298 VPWR VGND sg13cmos5l_fill_2
XFILLER_9_910 VPWR VGND sg13cmos5l_decap_8
XFILLER_13_961 VPWR VGND sg13cmos5l_decap_8
XFILLER_12_2302 VPWR VGND sg13cmos5l_decap_8
XFILLER_9_987 VPWR VGND sg13cmos5l_decap_8
XFILLER_12_1612 VPWR VGND sg13cmos5l_fill_1
XFILLER_8_486 VPWR VGND sg13cmos5l_decap_8
XFILLER_12_2379 VPWR VGND sg13cmos5l_decap_8
XFILLER_12_1689 VPWR VGND sg13cmos5l_decap_8
X_0513_ _0513_/Q Tile_X0Y0_FrameData[18] VGND VPWR Tile_X4Y0_FrameStrobe[0] latch
X_0444_ _0444_/Q Tile_X0Y0_FrameData[29] VGND VPWR Tile_X3Y0_FrameStrobe[1] latch
X_0375_ _0375_/Q Tile_X0Y0_FrameData[2] VGND VPWR Tile_X2Y0_FrameStrobe[1] latch
XFILLER_3_1824 VPWR VGND sg13cmos5l_decap_8
XFILLER_1_2282 VPWR VGND sg13cmos5l_decap_8
XFILLER_1_1570 VPWR VGND sg13cmos5l_decap_8
XFILLER_17_2202 VPWR VGND sg13cmos5l_decap_8
XFILLER_17_1556 VPWR VGND sg13cmos5l_fill_1
XFILLER_13_1409 VPWR VGND sg13cmos5l_decap_8
XFILLER_11_1100 VPWR VGND sg13cmos5l_decap_8
XFILLER_2_629 VPWR VGND sg13cmos5l_decap_8
XFILLER_2_2013 VPWR VGND sg13cmos5l_decap_8
XFILLER_6_1492 VPWR VGND sg13cmos5l_decap_8
XFILLER_2_2046 VPWR VGND sg13cmos5l_decap_8
XFILLER_2_1323 VPWR VGND sg13cmos5l_decap_8
XANTENNA__0545__Q NPU_WDATA21 VPWR VGND sg13cmos5l_antennanp
XFILLER_13_224 VPWR VGND sg13cmos5l_decap_8
XFILLER_10_920 VPWR VGND sg13cmos5l_decap_8
XFILLER_16_1044 VPWR VGND sg13cmos5l_decap_8
XFILLER_10_997 VPWR VGND sg13cmos5l_decap_8
XFILLER_6_913 VPWR VGND sg13cmos5l_decap_8
XFILLER_13_1954 VPWR VGND sg13cmos5l_decap_8
XFILLER_5_478 VPWR VGND sg13cmos5l_decap_8
XFILLER_1_651 VPWR VGND sg13cmos5l_decap_8
XFILLER_0_161 VPWR VGND sg13cmos5l_decap_8
X_0160_ _0160_/Q Tile_X0Y0_FrameData[25] VGND VPWR Tile_X0Y0_FrameStrobe[2] latch
XFILLER_7_1289 VPWR VGND sg13cmos5l_fill_1
X_0091_ _0091_/Q Tile_X0Y0_FrameData[30] VGND VPWR Tile_X0Y0_FrameStrobe[0] latch
XFILLER_14_2408 VPWR VGND sg13cmos5l_fill_2
X_0993_ Tile_X2Y0_N1BEG[1] Tile_X2Y0_S1END[2] VPWR VGND sg13cmos5l_buf_1
XFILLER_18_1865 VPWR VGND sg13cmos5l_decap_4
XFILLER_18_1854 VPWR VGND sg13cmos5l_decap_8
XFILLER_9_751 VPWR VGND sg13cmos5l_decap_8
XFILLER_16_2290 VPWR VGND sg13cmos5l_fill_2
XFILLER_8_272 VPWR VGND sg13cmos5l_fill_1
XFILLER_8_261 VPWR VGND sg13cmos5l_decap_8
XFILLER_12_2143 VPWR VGND sg13cmos5l_decap_8
XFILLER_12_1431 VPWR VGND sg13cmos5l_decap_8
XFILLER_8_1009 VPWR VGND sg13cmos5l_decap_8
XFILLER_3_2300 VPWR VGND sg13cmos5l_decap_8
X_0427_ _0427_/Q Tile_X0Y0_FrameData[14] VGND VPWR Tile_X3Y0_FrameStrobe[0] latch
X_0358_ _0358_/Q Tile_X0Y0_FrameData[19] VGND VPWR Tile_X2Y0_FrameStrobe[1] latch
XFILLER_3_2377 VPWR VGND sg13cmos5l_decap_8
XFILLER_3_1665 VPWR VGND sg13cmos5l_decap_8
X_0289_ _0289_/Q Tile_X0Y0_FrameData[8] VGND VPWR Tile_X1Y0_FrameStrobe[2] latch
XFILLER_1_2090 VPWR VGND sg13cmos5l_decap_8
XFILLER_17_2021 VPWR VGND sg13cmos5l_decap_4
XANTENNA__1040__X Tile_X1Y0_N2BEG[4] VPWR VGND sg13cmos5l_antennanp
XFILLER_17_2043 VPWR VGND sg13cmos5l_fill_2
XFILLER_11_706 VPWR VGND sg13cmos5l_decap_4
XFILLER_10_216 VPWR VGND sg13cmos5l_decap_8
XFILLER_17_1386 VPWR VGND sg13cmos5l_fill_1
XFILLER_17_1375 VPWR VGND sg13cmos5l_decap_8
XFILLER_3_905 VPWR VGND sg13cmos5l_decap_8
XFILLER_2_426 VPWR VGND sg13cmos5l_decap_8
XFILLER_8_2233 VPWR VGND sg13cmos5l_decap_8
XFILLER_4_2108 VPWR VGND sg13cmos5l_decap_8
XFILLER_4_1429 VPWR VGND sg13cmos5l_decap_8
XFILLER_18_349 VPWR VGND sg13cmos5l_decap_8
XANTENNA_101 Tile_X0Y0_FrameData[26] VPWR VGND sg13cmos5l_antennanp
XANTENNA_112 Tile_X0Y0_FrameData[29] VPWR VGND sg13cmos5l_antennanp
XANTENNA_123 Tile_X0Y0_FrameData[29] VPWR VGND sg13cmos5l_antennanp
XANTENNA_134 Tile_X0Y0_FrameData[30] VPWR VGND sg13cmos5l_antennanp
XFILLER_2_1175 VPWR VGND sg13cmos5l_fill_2
XFILLER_2_1164 VPWR VGND sg13cmos5l_decap_8
XANTENNA_145 Tile_X0Y0_FrameData[30] VPWR VGND sg13cmos5l_antennanp
XANTENNA_156 Tile_X0Y0_FrameData[30] VPWR VGND sg13cmos5l_antennanp
XANTENNA_167 Tile_X0Y0_FrameData[31] VPWR VGND sg13cmos5l_antennanp
XFILLER_14_522 VPWR VGND sg13cmos5l_decap_8
XANTENNA_178 NPU_RDATA0 VPWR VGND sg13cmos5l_antennanp
XANTENNA_189 Tile_X0Y0_FrameData[22] VPWR VGND sg13cmos5l_antennanp
XFILLER_5_220 VPWR VGND sg13cmos5l_decap_8
XFILLER_6_798 VPWR VGND sg13cmos5l_decap_8
XFILLER_5_297 VPWR VGND sg13cmos5l_decap_8
XFILLER_9_1329 VPWR VGND sg13cmos5l_fill_2
XFILLER_2_982 VPWR VGND sg13cmos5l_decap_8
X_1261_ _1261_/X Tile_X3Y0_S1END[1] Tile_X3Y0_S2MID[5] Tile_X3Y0_S2END[2] _0577_/Q
+ _0495_/Q _0494_/Q VPWR VGND sg13cmos5l_mux4_1
X_0212_ _0212_/Q Tile_X0Y0_FrameData[21] VGND VPWR Tile_X1Y0_FrameStrobe[0] latch
X_1192_ _1192_/X Tile_X1Y0_S2MID[0] Tile_X1Y0_S4END[7] Tile_X1Y0_SS4END[8] _0592_/Q
+ _0281_/Q _0280_/Q VPWR VGND sg13cmos5l_mux4_1
XFILLER_7_1064 VPWR VGND sg13cmos5l_decap_8
XANTENNA__0964__X Tile_X3Y0_NN4BEG[8] VPWR VGND sg13cmos5l_antennanp
X_0143_ _0143_/Q Tile_X0Y0_FrameData[10] VGND VPWR Tile_X0Y0_FrameStrobe[1] latch
XFILLER_4_1941 VPWR VGND sg13cmos5l_decap_8
XFILLER_0_1849 VPWR VGND sg13cmos5l_decap_4
XFILLER_18_1651 VPWR VGND sg13cmos5l_fill_1
X_0976_ Tile_X2Y0_FrameStrobe_O[4] Tile_X2Y0_FrameStrobe[4] VPWR VGND sg13cmos5l_buf_1
XFILLER_10_28 VPWR VGND sg13cmos5l_decap_4
XFILLER_9_1852 VPWR VGND sg13cmos5l_decap_8
XANTENNA__1035__X Tile_X1Y0_N2BEGb[7] VPWR VGND sg13cmos5l_antennanp
XANTENNA__0874__X Tile_X4Y0_N4BEG[6] VPWR VGND sg13cmos5l_antennanp
XFILLER_3_2174 VPWR VGND sg13cmos5l_decap_8
XFILLER_3_1462 VPWR VGND sg13cmos5l_decap_8
XFILLER_11_514 VPWR VGND sg13cmos5l_decap_8
XFILLER_13_1003 VPWR VGND sg13cmos5l_decap_8
XFILLER_10_1935 VPWR VGND sg13cmos5l_decap_8
XFILLER_3_724 VPWR VGND sg13cmos5l_decap_8
XFILLER_2_245 VPWR VGND sg13cmos5l_decap_8
XFILLER_8_2052 VPWR VGND sg13cmos5l_decap_8
XFILLER_4_1226 VPWR VGND sg13cmos5l_decap_8
XANTENNA__0784__X Tile_X2Y0_NN4BEG[4] VPWR VGND sg13cmos5l_antennanp
XFILLER_18_124 VPWR VGND sg13cmos5l_fill_1
XFILLER_18_168 VPWR VGND sg13cmos5l_fill_1
XFILLER_14_330 VPWR VGND sg13cmos5l_fill_2
XFILLER_15_1824 VPWR VGND sg13cmos5l_fill_1
X_0830_ Tile_X4Y0_FrameStrobe_O[2] Tile_X4Y0_FrameStrobe[2] VPWR VGND sg13cmos5l_buf_1
X_0761_ Tile_X0Y0_N4BEG[13] _1157_/X VPWR VGND sg13cmos5l_buf_1
XFILLER_13_2260 VPWR VGND sg13cmos5l_decap_8
XFILLER_6_540 VPWR VGND sg13cmos5l_decap_8
X_0692_ Tile_X2Y0_N4BEG[0] _1224_/X VPWR VGND sg13cmos5l_buf_1
XANTENNA__0959__X Tile_X3Y0_NN4BEG[3] VPWR VGND sg13cmos5l_antennanp
X_1244_ _1244_/X Tile_X2Y0_S2END[4] Tile_X2Y0_S4END[4] Tile_X2Y0_SS4END[11] _0583_/Q
+ _0353_/Q _0352_/Q VPWR VGND sg13cmos5l_mux4_1
XFILLER_2_84 VPWR VGND sg13cmos5l_decap_8
XANTENNA__0694__X Tile_X2Y0_N4BEG[2] VPWR VGND sg13cmos5l_antennanp
XFILLER_0_1602 VPWR VGND sg13cmos5l_decap_8
XFILLER_0_1613 VPWR VGND sg13cmos5l_fill_2
XFILLER_0_2347 VPWR VGND sg13cmos5l_decap_8
X_1175_ _1175_/X Tile_X0Y0_S2END[7] Tile_X0Y0_S4END[15] Tile_X0Y0_SS4END[0] _0602_/Q
+ _0123_/Q _0122_/Q VPWR VGND sg13cmos5l_mux4_1
X_0126_ _0126_/Q Tile_X0Y0_FrameData[27] VGND VPWR Tile_X0Y0_FrameStrobe[1] latch
XANTENNA_12 NPU_RDATA17 VPWR VGND sg13cmos5l_antennanp
XANTENNA_23 NPU_RDATA23 VPWR VGND sg13cmos5l_antennanp
XFILLER_18_2182 VPWR VGND sg13cmos5l_decap_8
XANTENNA_34 NPU_RDATA28 VPWR VGND sg13cmos5l_antennanp
XANTENNA_45 NPU_RDATA7 VPWR VGND sg13cmos5l_antennanp
XANTENNA_56 Tile_X0Y0_FrameData[12] VPWR VGND sg13cmos5l_antennanp
XFILLER_14_2046 VPWR VGND sg13cmos5l_decap_8
XANTENNA_67 Tile_X0Y0_FrameData[15] VPWR VGND sg13cmos5l_antennanp
XANTENNA_78 Tile_X0Y0_FrameData[21] VPWR VGND sg13cmos5l_antennanp
XANTENNA_89 Tile_X0Y0_FrameData[21] VPWR VGND sg13cmos5l_antennanp
XFILLER_14_1356 VPWR VGND sg13cmos5l_fill_1
X_0959_ Tile_X3Y0_NN4BEG[3] _1283_/X VPWR VGND sg13cmos5l_buf_1
XFILLER_14_1389 VPWR VGND sg13cmos5l_fill_1
XFILLER_14_1378 VPWR VGND sg13cmos5l_decap_8
XANTENNA__0869__X Tile_X4Y0_N4BEG[1] VPWR VGND sg13cmos5l_antennanp
XFILLER_0_738 VPWR VGND sg13cmos5l_fill_1
XFILLER_5_2236 VPWR VGND sg13cmos5l_decap_8
XFILLER_5_1557 VPWR VGND sg13cmos5l_decap_8
XFILLER_15_116 VPWR VGND sg13cmos5l_decap_8
XFILLER_15_105 VPWR VGND sg13cmos5l_fill_1
XANTENNA__0553__Q NPU_WDATA29 VPWR VGND sg13cmos5l_antennanp
XANTENNA__0779__X Tile_X0Y0_NN4BEG[15] VPWR VGND sg13cmos5l_antennanp
XFILLER_3_543 VPWR VGND sg13cmos5l_decap_8
XFILLER_2_0 VPWR VGND sg13cmos5l_decap_8
XFILLER_4_1056 VPWR VGND sg13cmos5l_decap_8
XFILLER_1_1922 VPWR VGND sg13cmos5l_decap_8
XFILLER_1_1988 VPWR VGND sg13cmos5l_decap_8
XFILLER_15_2300 VPWR VGND sg13cmos5l_decap_8
XFILLER_14_182 VPWR VGND sg13cmos5l_decap_8
XFILLER_15_2377 VPWR VGND sg13cmos5l_decap_8
XFILLER_11_2208 VPWR VGND sg13cmos5l_fill_2
X_0813_ Tile_X4Y0_FrameData_O[17] Tile_X0Y0_FrameData[17] VPWR VGND sg13cmos5l_buf_1
X_0744_ Tile_X0Y0_N2BEGb[4] _1140_/X VPWR VGND sg13cmos5l_buf_1
X_0675_ _0675_/L_HI VPWR VGND sg13cmos5l_tiehi
XFILLER_6_1855 VPWR VGND sg13cmos5l_decap_8
X_1227_ _1227_/X Tile_X2Y0_S2MID[3] Tile_X2Y0_S4END[12] Tile_X2Y0_SS4END[3] _0581_/Q
+ _0387_/Q _0386_/Q VPWR VGND sg13cmos5l_mux4_1
XFILLER_0_2166 VPWR VGND sg13cmos5l_decap_8
X_1158_ _1158_/X Tile_X0Y0_S2MID[6] Tile_X0Y0_S4END[1] Tile_X0Y0_SS4END[14] _0602_/Q
+ _0157_/Q _0156_/Q VPWR VGND sg13cmos5l_mux4_1
XFILLER_4_1590 VPWR VGND sg13cmos5l_decap_8
XFILLER_0_1454 VPWR VGND sg13cmos5l_decap_8
XFILLER_0_2177 VPWR VGND sg13cmos5l_fill_2
X_0109_ _0109_/Q Tile_X0Y0_FrameData[12] VGND VPWR Tile_X0Y0_FrameStrobe[0] latch
X_1089_ _1089_/X Tile_X2Y0_S1END[0] Tile_X2Y0_S2MID[3] Tile_X2Y0_S2MID[4] Tile_X2Y0_S2END[3]
+ _0321_/Q _0320_/Q VPWR VGND sg13cmos5l_mux4_1
XFILLER_16_2119 VPWR VGND sg13cmos5l_decap_8
XFILLER_14_1142 VPWR VGND sg13cmos5l_fill_2
XFILLER_14_1175 VPWR VGND sg13cmos5l_fill_2
XFILLER_10_1039 VPWR VGND sg13cmos5l_fill_2
XFILLER_4_329 VPWR VGND sg13cmos5l_decap_8
XFILLER_0_546 VPWR VGND sg13cmos5l_decap_8
XFILLER_7_1608 VPWR VGND sg13cmos5l_fill_1
XFILLER_5_2033 VPWR VGND sg13cmos5l_decap_8
XANTENNA__0548__Q NPU_WDATA24 VPWR VGND sg13cmos5l_antennanp
XFILLER_5_1354 VPWR VGND sg13cmos5l_decap_8
XFILLER_17_926 VPWR VGND sg13cmos5l_decap_8
XFILLER_16_447 VPWR VGND sg13cmos5l_decap_8
XFILLER_7_112 VPWR VGND sg13cmos5l_decap_8
XFILLER_16_1963 VPWR VGND sg13cmos5l_decap_8
XFILLER_11_185 VPWR VGND sg13cmos5l_decap_4
XFILLER_12_1849 VPWR VGND sg13cmos5l_decap_8
XFILLER_10_1562 VPWR VGND sg13cmos5l_fill_2
XFILLER_10_2285 VPWR VGND sg13cmos5l_decap_8
X_0460_ _0460_/Q Tile_X0Y0_FrameData[13] VGND VPWR Tile_X3Y0_FrameStrobe[1] latch
X_0391_ _0391_/Q Tile_X0Y0_FrameData[18] VGND VPWR Tile_X2Y0_FrameStrobe[2] latch
X_1012_ Tile_X1Y0_N4BEG[0] _1184_/X VPWR VGND sg13cmos5l_buf_1
XANTENNA__0972__X Tile_X2Y0_FrameStrobe_O[0] VPWR VGND sg13cmos5l_antennanp
XFILLER_1_1785 VPWR VGND sg13cmos5l_decap_8
XFILLER_16_970 VPWR VGND sg13cmos5l_decap_8
XFILLER_15_480 VPWR VGND sg13cmos5l_decap_8
XFILLER_17_1738 VPWR VGND sg13cmos5l_decap_8
XFILLER_15_2152 VPWR VGND sg13cmos5l_fill_1
XFILLER_15_1462 VPWR VGND sg13cmos5l_decap_8
XFILLER_11_2027 VPWR VGND sg13cmos5l_decap_8
X_0727_ Tile_X0Y0_FrameStrobe_O[19] Tile_X0Y0_FrameStrobe[19] VPWR VGND sg13cmos5l_buf_1
X_0658_ _0658_/L_HI VPWR VGND sg13cmos5l_tiehi
X_0589_ _0589_/Q Tile_X0Y0_UserCLK NPU_RDATA17 _0622_/L_HI VPWR VGND sg13cmos5l_dfrbpq_1
XFILLER_6_2386 VPWR VGND sg13cmos5l_decap_8
XFILLER_2_2239 VPWR VGND sg13cmos5l_decap_8
XFILLER_2_1505 VPWR VGND sg13cmos5l_decap_8
XANTENNA__1043__X Tile_X1Y0_N2BEG[7] VPWR VGND sg13cmos5l_antennanp
XANTENNA__0882__X Tile_X4Y0_N4BEG[14] VPWR VGND sg13cmos5l_antennanp
XFILLER_13_439 VPWR VGND sg13cmos5l_decap_8
XFILLER_4_126 VPWR VGND sg13cmos5l_decap_8
XFILLER_1_811 VPWR VGND sg13cmos5l_decap_8
XFILLER_0_343 VPWR VGND sg13cmos5l_decap_4
XFILLER_7_2139 VPWR VGND sg13cmos5l_decap_8
XFILLER_5_1173 VPWR VGND sg13cmos5l_fill_2
XFILLER_5_1162 VPWR VGND sg13cmos5l_decap_8
XANTENNA__0792__X Tile_X2Y0_NN4BEG[12] VPWR VGND sg13cmos5l_antennanp
XFILLER_1_1059 VPWR VGND sg13cmos5l_decap_8
XFILLER_13_940 VPWR VGND sg13cmos5l_decap_8
XFILLER_9_966 VPWR VGND sg13cmos5l_decap_8
XFILLER_12_2358 VPWR VGND sg13cmos5l_decap_8
XFILLER_8_465 VPWR VGND sg13cmos5l_decap_8
XFILLER_16_1793 VPWR VGND sg13cmos5l_decap_8
XFILLER_12_1624 VPWR VGND sg13cmos5l_fill_2
X_0512_ _0512_/Q Tile_X0Y0_FrameData[31] VGND VPWR Tile_X4Y0_FrameStrobe[0] latch
XANTENNA__0967__X Tile_X3Y0_NN4BEG[11] VPWR VGND sg13cmos5l_antennanp
X_0443_ _0443_/Q Tile_X0Y0_FrameData[30] VGND VPWR Tile_X3Y0_FrameStrobe[1] latch
X_0374_ _0374_/Q Tile_X0Y0_FrameData[3] VGND VPWR Tile_X2Y0_FrameStrobe[1] latch
XFILLER_7_1994 VPWR VGND sg13cmos5l_decap_8
XFILLER_1_2261 VPWR VGND sg13cmos5l_decap_8
XFILLER_17_2269 VPWR VGND sg13cmos5l_decap_8
XFILLER_13_28 VPWR VGND sg13cmos5l_decap_4
XFILLER_11_1123 VPWR VGND sg13cmos5l_fill_1
XFILLER_11_1134 VPWR VGND sg13cmos5l_fill_2
XANTENNA__1038__X Tile_X1Y0_N2BEG[2] VPWR VGND sg13cmos5l_antennanp
XFILLER_11_1167 VPWR VGND sg13cmos5l_decap_8
XFILLER_2_608 VPWR VGND sg13cmos5l_decap_8
XANTENNA__0877__X Tile_X4Y0_N4BEG[9] VPWR VGND sg13cmos5l_antennanp
XFILLER_8_1714 VPWR VGND sg13cmos5l_fill_1
XFILLER_2_2025 VPWR VGND sg13cmos5l_decap_8
XFILLER_6_1471 VPWR VGND sg13cmos5l_decap_8
XFILLER_2_1302 VPWR VGND sg13cmos5l_decap_8
XFILLER_2_1379 VPWR VGND sg13cmos5l_decap_8
XFILLER_14_748 VPWR VGND sg13cmos5l_decap_8
XFILLER_14_726 VPWR VGND sg13cmos5l_fill_1
XFILLER_0_1092 VPWR VGND sg13cmos5l_decap_8
XFILLER_14_759 VPWR VGND sg13cmos5l_fill_2
XFILLER_16_1023 VPWR VGND sg13cmos5l_fill_2
XFILLER_16_1012 VPWR VGND sg13cmos5l_decap_8
XANTENNA__0561__Q NPU_WE5 VPWR VGND sg13cmos5l_antennanp
XFILLER_10_976 VPWR VGND sg13cmos5l_decap_8
XFILLER_13_1933 VPWR VGND sg13cmos5l_decap_8
XFILLER_6_969 VPWR VGND sg13cmos5l_decap_8
XFILLER_5_457 VPWR VGND sg13cmos5l_decap_8
XANTENNA__0787__X Tile_X2Y0_NN4BEG[7] VPWR VGND sg13cmos5l_antennanp
XFILLER_1_630 VPWR VGND sg13cmos5l_decap_8
XFILLER_0_151 VPWR VGND sg13cmos5l_decap_4
XFILLER_7_1246 VPWR VGND sg13cmos5l_decap_4
X_0090_ _0560_/D _0516_/Q _1097_/X VPWR VGND sg13cmos5l_nor2b_1
XFILLER_18_1833 VPWR VGND sg13cmos5l_decap_8
X_0992_ Tile_X2Y0_N1BEG[0] Tile_X2Y0_S1END[3] VPWR VGND sg13cmos5l_buf_1
XFILLER_13_770 VPWR VGND sg13cmos5l_decap_4
XFILLER_14_1719 VPWR VGND sg13cmos5l_decap_4
XFILLER_13_792 VPWR VGND sg13cmos5l_decap_8
XFILLER_13_781 VPWR VGND sg13cmos5l_decap_4
XFILLER_12_2122 VPWR VGND sg13cmos5l_decap_8
XFILLER_12_1410 VPWR VGND sg13cmos5l_decap_8
XFILLER_12_1487 VPWR VGND sg13cmos5l_decap_8
XFILLER_5_980 VPWR VGND sg13cmos5l_decap_8
XANTENNA__0697__X Tile_X2Y0_N4BEG[5] VPWR VGND sg13cmos5l_antennanp
XFILLER_5_84 VPWR VGND sg13cmos5l_decap_8
X_0426_ _0426_/Q Tile_X0Y0_FrameData[15] VGND VPWR Tile_X3Y0_FrameStrobe[0] latch
X_0357_ _0357_/Q Tile_X0Y0_FrameData[20] VGND VPWR Tile_X2Y0_FrameStrobe[1] latch
XFILLER_7_1791 VPWR VGND sg13cmos5l_fill_1
XFILLER_3_2356 VPWR VGND sg13cmos5l_decap_8
X_0288_ _0288_/Q Tile_X0Y0_FrameData[9] VGND VPWR Tile_X1Y0_FrameStrobe[2] latch
XFILLER_3_1644 VPWR VGND sg13cmos5l_decap_8
XFILLER_17_2077 VPWR VGND sg13cmos5l_fill_1
XFILLER_17_1332 VPWR VGND sg13cmos5l_fill_1
XFILLER_8_2212 VPWR VGND sg13cmos5l_decap_8
XFILLER_6_7 VPWR VGND sg13cmos5l_decap_8
XFILLER_8_1511 VPWR VGND sg13cmos5l_decap_8
XFILLER_8_2289 VPWR VGND sg13cmos5l_decap_8
XFILLER_8_1577 VPWR VGND sg13cmos5l_decap_8
XFILLER_8_1566 VPWR VGND sg13cmos5l_decap_8
XFILLER_4_1408 VPWR VGND sg13cmos5l_decap_8
XFILLER_18_317 VPWR VGND sg13cmos5l_decap_8
XANTENNA_102 Tile_X0Y0_FrameData[26] VPWR VGND sg13cmos5l_antennanp
XANTENNA_113 Tile_X0Y0_FrameData[29] VPWR VGND sg13cmos5l_antennanp
XANTENNA_124 Tile_X0Y0_FrameData[29] VPWR VGND sg13cmos5l_antennanp
XANTENNA__0556__Q NPU_WE0 VPWR VGND sg13cmos5l_antennanp
XFILLER_2_1143 VPWR VGND sg13cmos5l_decap_8
XANTENNA_135 Tile_X0Y0_FrameData[30] VPWR VGND sg13cmos5l_antennanp
XANTENNA_146 Tile_X0Y0_FrameData[30] VPWR VGND sg13cmos5l_antennanp
XANTENNA_157 Tile_X0Y0_FrameData[30] VPWR VGND sg13cmos5l_antennanp
XFILLER_2_1187 VPWR VGND sg13cmos5l_decap_8
XFILLER_14_501 VPWR VGND sg13cmos5l_decap_8
XANTENNA_168 Tile_X0Y0_FrameData[31] VPWR VGND sg13cmos5l_antennanp
XANTENNA_179 NPU_RDATA1 VPWR VGND sg13cmos5l_antennanp
XFILLER_6_733 VPWR VGND sg13cmos5l_fill_1
XFILLER_6_777 VPWR VGND sg13cmos5l_decap_8
XFILLER_5_276 VPWR VGND sg13cmos5l_decap_8
XFILLER_2_961 VPWR VGND sg13cmos5l_decap_8
X_1260_ _1260_/X Tile_X3Y0_S1END[0] Tile_X3Y0_S2MID[4] Tile_X3Y0_S2END[3] _0576_/Q
+ _0497_/Q _0496_/Q VPWR VGND sg13cmos5l_mux4_1
XFILLER_7_1043 VPWR VGND sg13cmos5l_decap_8
X_0211_ _0211_/Q Tile_X0Y0_FrameData[22] VGND VPWR Tile_X1Y0_FrameStrobe[0] latch
X_1191_ _1191_/X Tile_X1Y0_S2MID[7] Tile_X1Y0_S4END[8] Tile_X1Y0_SS4END[7] _0591_/Q
+ _0283_/Q _0282_/Q VPWR VGND sg13cmos5l_mux4_1
XFILLER_4_1920 VPWR VGND sg13cmos5l_decap_8
X_0142_ _0142_/Q Tile_X0Y0_FrameData[11] VGND VPWR Tile_X0Y0_FrameStrobe[1] latch
XFILLER_4_1997 VPWR VGND sg13cmos5l_decap_8
XFILLER_18_873 VPWR VGND sg13cmos5l_decap_8
XANTENNA__0980__X Tile_X2Y0_FrameStrobe_O[8] VPWR VGND sg13cmos5l_antennanp
XFILLER_18_1630 VPWR VGND sg13cmos5l_fill_2
XFILLER_9_560 VPWR VGND sg13cmos5l_decap_4
X_0975_ Tile_X2Y0_FrameStrobe_O[3] Tile_X2Y0_FrameStrobe[3] VPWR VGND sg13cmos5l_buf_1
XFILLER_12_1273 VPWR VGND sg13cmos5l_fill_2
XFILLER_5_1717 VPWR VGND sg13cmos5l_fill_2
X_0409_ _0409_/Q Tile_X0Y0_FrameData[0] VGND VPWR Tile_X2Y0_FrameStrobe[2] latch
XFILLER_3_2153 VPWR VGND sg13cmos5l_decap_8
XFILLER_3_1441 VPWR VGND sg13cmos5l_decap_8
XANTENNA__1051__X Tile_X1Y0_FrameStrobe_O[3] VPWR VGND sg13cmos5l_antennanp
XANTENNA__0890__X Tile_X4Y0_NN4BEG[6] VPWR VGND sg13cmos5l_antennanp
XFILLER_11_559 VPWR VGND sg13cmos5l_decap_8
XFILLER_13_1059 VPWR VGND sg13cmos5l_decap_8
XFILLER_10_1914 VPWR VGND sg13cmos5l_decap_8
XFILLER_2_224 VPWR VGND sg13cmos5l_decap_8
XFILLER_8_2031 VPWR VGND sg13cmos5l_decap_8
XFILLER_8_1352 VPWR VGND sg13cmos5l_fill_2
XFILLER_8_1385 VPWR VGND sg13cmos5l_decap_8
XFILLER_18_114 VPWR VGND sg13cmos5l_decap_4
XFILLER_18_158 VPWR VGND sg13cmos5l_fill_1
XFILLER_18_136 VPWR VGND sg13cmos5l_decap_8
XFILLER_15_1836 VPWR VGND sg13cmos5l_fill_1
XFILLER_10_570 VPWR VGND sg13cmos5l_decap_4
X_0760_ Tile_X0Y0_N4BEG[12] _1156_/X VPWR VGND sg13cmos5l_buf_1
X_0691_ Tile_X1Y0_Co VPWR VGND sg13cmos5l_tielo
XFILLER_6_596 VPWR VGND sg13cmos5l_decap_8
XFILLER_13_1593 VPWR VGND sg13cmos5l_fill_2
XANTENNA__0975__X Tile_X2Y0_FrameStrobe_O[3] VPWR VGND sg13cmos5l_antennanp
X_1243_ _1243_/X Tile_X2Y0_S2END[3] Tile_X2Y0_S4END[3] Tile_X2Y0_SS4END[12] _0580_/Q
+ _0355_/Q _0354_/Q VPWR VGND sg13cmos5l_mux4_1
XFILLER_2_63 VPWR VGND sg13cmos5l_decap_8
XFILLER_0_2326 VPWR VGND sg13cmos5l_decap_8
X_1174_ _1174_/X Tile_X0Y0_S2END[6] Tile_X0Y0_S4END[14] Tile_X0Y0_SS4END[1] _0603_/Q
+ _0125_/Q _0124_/Q VPWR VGND sg13cmos5l_mux4_1
X_0125_ _0125_/Q Tile_X0Y0_FrameData[28] VGND VPWR Tile_X0Y0_FrameStrobe[1] latch
XFILLER_18_692 VPWR VGND sg13cmos5l_decap_8
XFILLER_18_2161 VPWR VGND sg13cmos5l_decap_8
XANTENNA_13 NPU_RDATA17 VPWR VGND sg13cmos5l_antennanp
XFILLER_18_2194 VPWR VGND sg13cmos5l_decap_8
XFILLER_14_2025 VPWR VGND sg13cmos5l_decap_8
XANTENNA_24 NPU_RDATA23 VPWR VGND sg13cmos5l_antennanp
XANTENNA_35 NPU_RDATA29 VPWR VGND sg13cmos5l_antennanp
XANTENNA_46 NPU_RDATA8 VPWR VGND sg13cmos5l_antennanp
XANTENNA_57 Tile_X0Y0_FrameData[12] VPWR VGND sg13cmos5l_antennanp
XANTENNA_68 Tile_X0Y0_FrameData[15] VPWR VGND sg13cmos5l_antennanp
XANTENNA_79 Tile_X0Y0_FrameData[21] VPWR VGND sg13cmos5l_antennanp
X_0958_ Tile_X3Y0_NN4BEG[2] _1282_/X VPWR VGND sg13cmos5l_buf_1
XFILLER_14_1335 VPWR VGND sg13cmos5l_decap_8
X_0889_ Tile_X4Y0_NN4BEG[5] Tile_X4Y0_SS4END[10] VPWR VGND sg13cmos5l_buf_1
XFILLER_12_1070 VPWR VGND sg13cmos5l_fill_1
XFILLER_12_1092 VPWR VGND sg13cmos5l_fill_1
XANTENNA__1046__X Tile_X1Y0_N1BEG[2] VPWR VGND sg13cmos5l_antennanp
XFILLER_9_2395 VPWR VGND sg13cmos5l_decap_8
XFILLER_5_2215 VPWR VGND sg13cmos5l_decap_8
XANTENNA__0885__X Tile_X4Y0_NN4BEG[1] VPWR VGND sg13cmos5l_antennanp
XFILLER_5_1536 VPWR VGND sg13cmos5l_decap_8
XFILLER_16_618 VPWR VGND sg13cmos5l_decap_4
XFILLER_10_1766 VPWR VGND sg13cmos5l_fill_1
XFILLER_3_522 VPWR VGND sg13cmos5l_decap_8
XFILLER_11_61 VPWR VGND sg13cmos5l_decap_8
XFILLER_10_1799 VPWR VGND sg13cmos5l_decap_8
XFILLER_3_599 VPWR VGND sg13cmos5l_decap_8
XANTENNA__0795__X Tile_X2Y0_NN4BEG[15] VPWR VGND sg13cmos5l_antennanp
XFILLER_4_1035 VPWR VGND sg13cmos5l_decap_8
XFILLER_1_1901 VPWR VGND sg13cmos5l_decap_8
XFILLER_1_1967 VPWR VGND sg13cmos5l_decap_8
XFILLER_17_1909 VPWR VGND sg13cmos5l_decap_8
XFILLER_15_2356 VPWR VGND sg13cmos5l_decap_8
X_0812_ Tile_X4Y0_FrameData_O[16] Tile_X0Y0_FrameData[16] VPWR VGND sg13cmos5l_buf_1
XFILLER_11_1508 VPWR VGND sg13cmos5l_decap_8
XFILLER_13_2080 VPWR VGND sg13cmos5l_decap_8
X_0743_ Tile_X0Y0_N2BEGb[3] _1139_/X VPWR VGND sg13cmos5l_buf_1
X_0674_ _0674_/L_HI VPWR VGND sg13cmos5l_tiehi
X_1226_ _1226_/X Tile_X2Y0_S2MID[2] Tile_X2Y0_S4END[13] Tile_X2Y0_SS4END[2] _0580_/Q
+ _0389_/Q _0388_/Q VPWR VGND sg13cmos5l_mux4_1
XFILLER_0_2145 VPWR VGND sg13cmos5l_decap_8
X_1157_ _1157_/X Tile_X0Y0_S2MID[5] Tile_X0Y0_S4END[2] Tile_X0Y0_SS4END[13] _0603_/Q
+ _0159_/Q _0158_/Q VPWR VGND sg13cmos5l_mux4_1
XFILLER_0_1422 VPWR VGND sg13cmos5l_decap_8
X_0108_ _0108_/Q Tile_X0Y0_FrameData[13] VGND VPWR Tile_X0Y0_FrameStrobe[0] latch
XFILLER_16_28 VPWR VGND sg13cmos5l_fill_2
X_1088_ _1088_/X Tile_X2Y0_S1END[3] Tile_X2Y0_S2MID[3] Tile_X2Y0_S2MID[4] Tile_X2Y0_S2END[4]
+ _0323_/Q _0322_/Q VPWR VGND sg13cmos5l_mux4_1
XFILLER_16_1419 VPWR VGND sg13cmos5l_decap_8
XFILLER_18_1290 VPWR VGND sg13cmos5l_decap_8
XFILLER_10_1018 VPWR VGND sg13cmos5l_decap_8
XFILLER_4_308 VPWR VGND sg13cmos5l_decap_8
XFILLER_0_525 VPWR VGND sg13cmos5l_decap_8
XFILLER_9_2181 VPWR VGND sg13cmos5l_decap_4
XFILLER_5_2012 VPWR VGND sg13cmos5l_decap_8
XFILLER_5_1333 VPWR VGND sg13cmos5l_decap_8
XFILLER_5_2089 VPWR VGND sg13cmos5l_decap_8
XFILLER_16_426 VPWR VGND sg13cmos5l_decap_8
XANTENNA__0564__Q NPU_ADDR0 VPWR VGND sg13cmos5l_antennanp
XFILLER_12_621 VPWR VGND sg13cmos5l_fill_2
XFILLER_12_1828 VPWR VGND sg13cmos5l_decap_8
XFILLER_12_1806 VPWR VGND sg13cmos5l_decap_8
XFILLER_10_2264 VPWR VGND sg13cmos5l_decap_8
XFILLER_4_820 VPWR VGND sg13cmos5l_decap_8
XFILLER_10_1530 VPWR VGND sg13cmos5l_decap_8
XFILLER_10_1541 VPWR VGND sg13cmos5l_fill_2
X_0390_ _0390_/Q Tile_X0Y0_FrameData[19] VGND VPWR Tile_X2Y0_FrameStrobe[2] latch
X_1011_ Tile_X1Y0_NN4BEG[15] _1215_/X VPWR VGND sg13cmos5l_buf_1
XFILLER_1_1764 VPWR VGND sg13cmos5l_decap_8
XFILLER_15_1441 VPWR VGND sg13cmos5l_decap_8
XFILLER_11_2006 VPWR VGND sg13cmos5l_decap_8
XFILLER_11_1338 VPWR VGND sg13cmos5l_decap_8
XFILLER_8_95 VPWR VGND sg13cmos5l_decap_4
XFILLER_11_1349 VPWR VGND sg13cmos5l_fill_1
X_0726_ Tile_X0Y0_FrameStrobe_O[18] Tile_X0Y0_FrameStrobe[18] VPWR VGND sg13cmos5l_buf_1
X_0657_ _0657_/L_HI VPWR VGND sg13cmos5l_tiehi
X_0588_ _0588_/Q Tile_X0Y0_UserCLK NPU_RDATA16 _0621_/L_HI VPWR VGND sg13cmos5l_dfrbpq_1
XFILLER_6_2365 VPWR VGND sg13cmos5l_decap_8
XFILLER_2_2207 VPWR VGND sg13cmos5l_fill_1
X_1209_ _1209_/X Tile_X1Y0_S2END[1] Tile_X1Y0_S4END[9] Tile_X1Y0_SS4END[6] _0592_/Q
+ _0247_/Q _0246_/Q VPWR VGND sg13cmos5l_mux4_1
XFILLER_13_418 VPWR VGND sg13cmos5l_decap_8
XFILLER_5_639 VPWR VGND sg13cmos5l_decap_8
XFILLER_4_105 VPWR VGND sg13cmos5l_decap_8
XFILLER_11_1894 VPWR VGND sg13cmos5l_decap_8
XFILLER_7_2118 VPWR VGND sg13cmos5l_decap_8
XANTENNA__0559__Q NPU_WE3 VPWR VGND sg13cmos5l_antennanp
XFILLER_5_1141 VPWR VGND sg13cmos5l_decap_8
XFILLER_1_1038 VPWR VGND sg13cmos5l_decap_8
XFILLER_16_245 VPWR VGND sg13cmos5l_decap_8
XFILLER_9_945 VPWR VGND sg13cmos5l_decap_8
XFILLER_8_400 VPWR VGND sg13cmos5l_fill_1
XFILLER_13_996 VPWR VGND sg13cmos5l_decap_8
XFILLER_12_451 VPWR VGND sg13cmos5l_decap_8
XFILLER_8_444 VPWR VGND sg13cmos5l_decap_8
XFILLER_16_1772 VPWR VGND sg13cmos5l_decap_8
XFILLER_12_2337 VPWR VGND sg13cmos5l_decap_8
XFILLER_10_2083 VPWR VGND sg13cmos5l_decap_8
X_0511_ _0511_/Q Tile_X0Y0_FrameData[26] VGND VPWR Tile_X4Y0_FrameStrobe[0] latch
XFILLER_4_694 VPWR VGND sg13cmos5l_decap_8
X_0442_ _0442_/Q Tile_X0Y0_FrameData[31] VGND VPWR Tile_X3Y0_FrameStrobe[1] latch
XFILLER_3_182 VPWR VGND sg13cmos5l_decap_8
X_0373_ _0373_/Q Tile_X0Y0_FrameData[4] VGND VPWR Tile_X2Y0_FrameStrobe[1] latch
XFILLER_7_1973 VPWR VGND sg13cmos5l_decap_8
XANTENNA__0983__X Tile_X2Y0_FrameStrobe_O[11] VPWR VGND sg13cmos5l_antennanp
XFILLER_3_1859 VPWR VGND sg13cmos5l_decap_8
XFILLER_17_2248 VPWR VGND sg13cmos5l_decap_8
X_0709_ Tile_X0Y0_FrameStrobe_O[1] Tile_X0Y0_FrameStrobe[1] VPWR VGND sg13cmos5l_buf_1
XFILLER_1_119 VPWR VGND sg13cmos5l_decap_8
XANTENNA__1054__X Tile_X1Y0_FrameStrobe_O[6] VPWR VGND sg13cmos5l_antennanp
XFILLER_6_2184 VPWR VGND sg13cmos5l_decap_8
XFILLER_6_1450 VPWR VGND sg13cmos5l_decap_8
XFILLER_6_2195 VPWR VGND sg13cmos5l_decap_4
XANTENNA__0893__X Tile_X4Y0_NN4BEG[9] VPWR VGND sg13cmos5l_antennanp
XFILLER_2_1358 VPWR VGND sg13cmos5l_decap_8
XFILLER_0_1060 VPWR VGND sg13cmos5l_decap_8
XFILLER_13_215 VPWR VGND sg13cmos5l_fill_2
XFILLER_16_1035 VPWR VGND sg13cmos5l_decap_4
XFILLER_10_955 VPWR VGND sg13cmos5l_decap_8
XFILLER_13_1912 VPWR VGND sg13cmos5l_decap_8
XFILLER_6_948 VPWR VGND sg13cmos5l_decap_8
XFILLER_5_436 VPWR VGND sg13cmos5l_decap_8
XFILLER_13_1989 VPWR VGND sg13cmos5l_decap_8
XFILLER_1_675 VPWR VGND sg13cmos5l_decap_8
XFILLER_0_185 VPWR VGND sg13cmos5l_decap_8
XFILLER_7_1258 VPWR VGND sg13cmos5l_decap_4
XFILLER_17_598 VPWR VGND sg13cmos5l_decap_4
X_0991_ Tile_X2Y0_FrameStrobe_O[19] Tile_X2Y0_FrameStrobe[19] VPWR VGND sg13cmos5l_buf_1
XFILLER_9_731 VPWR VGND sg13cmos5l_decap_4
XFILLER_16_2270 VPWR VGND sg13cmos5l_decap_8
XFILLER_12_281 VPWR VGND sg13cmos5l_decap_8
XFILLER_12_2101 VPWR VGND sg13cmos5l_decap_8
XFILLER_9_786 VPWR VGND sg13cmos5l_decap_8
XFILLER_9_797 VPWR VGND sg13cmos5l_decap_4
XFILLER_12_2178 VPWR VGND sg13cmos5l_decap_8
XFILLER_12_1466 VPWR VGND sg13cmos5l_decap_8
XANTENNA__0978__X Tile_X2Y0_FrameStrobe_O[6] VPWR VGND sg13cmos5l_antennanp
XFILLER_5_63 VPWR VGND sg13cmos5l_decap_8
XFILLER_4_491 VPWR VGND sg13cmos5l_decap_8
X_0425_ _0425_/Q Tile_X0Y0_FrameData[16] VGND VPWR Tile_X3Y0_FrameStrobe[0] latch
XFILLER_10_0 VPWR VGND sg13cmos5l_decap_8
X_0356_ _0356_/Q Tile_X0Y0_FrameData[21] VGND VPWR Tile_X2Y0_FrameStrobe[1] latch
XFILLER_3_2335 VPWR VGND sg13cmos5l_decap_8
XFILLER_3_1623 VPWR VGND sg13cmos5l_decap_8
X_0287_ _0287_/Q Tile_X0Y0_FrameData[10] VGND VPWR Tile_X1Y0_FrameStrobe[2] latch
XFILLER_17_2045 VPWR VGND sg13cmos5l_fill_1
XANTENNA__1049__X Tile_X1Y0_FrameStrobe_O[1] VPWR VGND sg13cmos5l_antennanp
XANTENNA__0888__X Tile_X4Y0_NN4BEG[4] VPWR VGND sg13cmos5l_antennanp
XFILLER_8_2268 VPWR VGND sg13cmos5l_decap_8
XFILLER_8_1545 VPWR VGND sg13cmos5l_decap_8
XFILLER_2_1122 VPWR VGND sg13cmos5l_decap_8
XFILLER_18_329 VPWR VGND sg13cmos5l_decap_4
XANTENNA_103 Tile_X0Y0_FrameData[26] VPWR VGND sg13cmos5l_antennanp
XANTENNA_114 Tile_X0Y0_FrameData[29] VPWR VGND sg13cmos5l_antennanp
XANTENNA_125 Tile_X0Y0_FrameData[29] VPWR VGND sg13cmos5l_antennanp
XANTENNA_136 Tile_X0Y0_FrameData[30] VPWR VGND sg13cmos5l_antennanp
XANTENNA_147 Tile_X0Y0_FrameData[30] VPWR VGND sg13cmos5l_antennanp
XANTENNA_158 Tile_X0Y0_FrameData[30] VPWR VGND sg13cmos5l_antennanp
XANTENNA_169 Tile_X0Y0_FrameData[31] VPWR VGND sg13cmos5l_antennanp
XFILLER_5_255 VPWR VGND sg13cmos5l_decap_8
XANTENNA__0798__X Tile_X4Y0_FrameData_O[2] VPWR VGND sg13cmos5l_antennanp
XFILLER_2_940 VPWR VGND sg13cmos5l_decap_8
XFILLER_7_1022 VPWR VGND sg13cmos5l_decap_8
XFILLER_1_483 VPWR VGND sg13cmos5l_decap_8
X_0210_ _0210_/Q Tile_X0Y0_FrameData[23] VGND VPWR Tile_X1Y0_FrameStrobe[0] latch
X_1190_ _1190_/X Tile_X1Y0_S2MID[6] Tile_X1Y0_S4END[9] Tile_X1Y0_SS4END[6] _0590_/Q
+ _0285_/Q _0284_/Q VPWR VGND sg13cmos5l_mux4_1
X_0141_ _0141_/Q Tile_X0Y0_FrameData[12] VGND VPWR Tile_X0Y0_FrameStrobe[1] latch
XFILLER_7_1088 VPWR VGND sg13cmos5l_decap_8
XFILLER_0_1818 VPWR VGND sg13cmos5l_decap_8
XFILLER_0_1829 VPWR VGND sg13cmos5l_fill_2
XFILLER_4_1976 VPWR VGND sg13cmos5l_decap_8
XFILLER_17_373 VPWR VGND sg13cmos5l_decap_4
XFILLER_14_2229 VPWR VGND sg13cmos5l_decap_8
XFILLER_14_1506 VPWR VGND sg13cmos5l_decap_4
X_0974_ Tile_X2Y0_FrameStrobe_O[2] Tile_X2Y0_FrameStrobe[2] VPWR VGND sg13cmos5l_buf_1
XFILLER_9_594 VPWR VGND sg13cmos5l_decap_4
XFILLER_9_1887 VPWR VGND sg13cmos5l_decap_8
X_0408_ _0408_/Q Tile_X0Y0_FrameData[1] VGND VPWR Tile_X2Y0_FrameStrobe[2] latch
XFILLER_3_2132 VPWR VGND sg13cmos5l_decap_8
X_0339_ _0339_/Q Tile_X0Y0_FrameData[6] VGND VPWR Tile_X2Y0_FrameStrobe[0] latch
XFILLER_3_1420 VPWR VGND sg13cmos5l_decap_8
XFILLER_3_1497 VPWR VGND sg13cmos5l_decap_8
XFILLER_17_1152 VPWR VGND sg13cmos5l_fill_1
XFILLER_13_1038 VPWR VGND sg13cmos5l_decap_8
XFILLER_2_203 VPWR VGND sg13cmos5l_decap_8
XFILLER_8_2010 VPWR VGND sg13cmos5l_decap_8
XFILLER_3_759 VPWR VGND sg13cmos5l_decap_8
XFILLER_8_2087 VPWR VGND sg13cmos5l_decap_8
XANTENNA__0567__Q NPU_ADDR3 VPWR VGND sg13cmos5l_antennanp
XFILLER_10_593 VPWR VGND sg13cmos5l_fill_2
X_0690_ Tile_X3Y0_Co VPWR VGND sg13cmos5l_tielo
XFILLER_13_2295 VPWR VGND sg13cmos5l_decap_8
XFILLER_6_575 VPWR VGND sg13cmos5l_decap_8
X_1242_ _1242_/X Tile_X2Y0_S2END[2] Tile_X2Y0_S4END[2] Tile_X2Y0_SS4END[13] _0581_/Q
+ _0357_/Q _0356_/Q VPWR VGND sg13cmos5l_mux4_1
XFILLER_2_42 VPWR VGND sg13cmos5l_decap_8
XFILLER_1_280 VPWR VGND sg13cmos5l_decap_4
XFILLER_0_2305 VPWR VGND sg13cmos5l_decap_8
X_1173_ _1173_/X Tile_X0Y0_S2END[5] Tile_X0Y0_S4END[13] Tile_X0Y0_SS4END[2] _0602_/Q
+ _0127_/Q _0126_/Q VPWR VGND sg13cmos5l_mux4_1
XFILLER_4_1762 VPWR VGND sg13cmos5l_decap_4
XFILLER_0_1626 VPWR VGND sg13cmos5l_decap_8
X_0124_ _0124_/Q Tile_X0Y0_FrameData[29] VGND VPWR Tile_X0Y0_FrameStrobe[1] latch
XFILLER_4_1784 VPWR VGND sg13cmos5l_decap_8
XANTENNA__0991__X Tile_X2Y0_FrameStrobe_O[19] VPWR VGND sg13cmos5l_antennanp
XANTENNA_14 NPU_RDATA18 VPWR VGND sg13cmos5l_antennanp
XFILLER_14_2004 VPWR VGND sg13cmos5l_decap_8
XANTENNA_25 NPU_RDATA24 VPWR VGND sg13cmos5l_antennanp
XANTENNA_36 NPU_RDATA29 VPWR VGND sg13cmos5l_antennanp
XANTENNA_47 Tile_X0Y0_FrameData[12] VPWR VGND sg13cmos5l_antennanp
XFILLER_18_1483 VPWR VGND sg13cmos5l_fill_2
XANTENNA_58 Tile_X0Y0_FrameData[12] VPWR VGND sg13cmos5l_antennanp
XANTENNA_69 Tile_X0Y0_FrameData[15] VPWR VGND sg13cmos5l_antennanp
X_0957_ Tile_X3Y0_NN4BEG[1] _1281_/X VPWR VGND sg13cmos5l_buf_1
XFILLER_18_1494 VPWR VGND sg13cmos5l_fill_2
X_0888_ Tile_X4Y0_NN4BEG[4] Tile_X4Y0_SS4END[11] VPWR VGND sg13cmos5l_buf_1
XFILLER_9_2374 VPWR VGND sg13cmos5l_decap_8
XFILLER_9_1662 VPWR VGND sg13cmos5l_fill_1
XFILLER_5_1515 VPWR VGND sg13cmos5l_decap_8
XANTENNA__1062__X Tile_X1Y0_FrameStrobe_O[14] VPWR VGND sg13cmos5l_antennanp
XFILLER_16_608 VPWR VGND sg13cmos5l_decap_8
XFILLER_3_1294 VPWR VGND sg13cmos5l_decap_8
XFILLER_15_129 VPWR VGND sg13cmos5l_decap_8
XFILLER_10_2413 VPWR VGND sg13cmos5l_decap_4
XFILLER_10_1712 VPWR VGND sg13cmos5l_decap_8
XFILLER_10_1723 VPWR VGND sg13cmos5l_fill_1
XFILLER_3_501 VPWR VGND sg13cmos5l_decap_8
XFILLER_10_1778 VPWR VGND sg13cmos5l_decap_8
XFILLER_3_578 VPWR VGND sg13cmos5l_decap_8
XFILLER_8_1183 VPWR VGND sg13cmos5l_decap_8
XFILLER_4_1014 VPWR VGND sg13cmos5l_decap_8
XFILLER_15_2335 VPWR VGND sg13cmos5l_decap_8
X_0811_ Tile_X4Y0_FrameData_O[15] Tile_X0Y0_FrameData[15] VPWR VGND sg13cmos5l_buf_1
XFILLER_15_1634 VPWR VGND sg13cmos5l_decap_4
X_0742_ Tile_X0Y0_N2BEGb[2] _1138_/X VPWR VGND sg13cmos5l_buf_1
XFILLER_15_1678 VPWR VGND sg13cmos5l_fill_1
XFILLER_15_1667 VPWR VGND sg13cmos5l_decap_8
XFILLER_7_873 VPWR VGND sg13cmos5l_fill_1
X_0673_ _0673_/L_HI VPWR VGND sg13cmos5l_tiehi
XANTENNA__0986__X Tile_X2Y0_FrameStrobe_O[14] VPWR VGND sg13cmos5l_antennanp
X_1225_ _1225_/X Tile_X2Y0_S2MID[1] Tile_X2Y0_S4END[14] Tile_X2Y0_SS4END[1] _0581_/Q
+ _0391_/Q _0390_/Q VPWR VGND sg13cmos5l_mux4_1
XFILLER_0_1412 VPWR VGND sg13cmos5l_decap_4
XFILLER_0_2124 VPWR VGND sg13cmos5l_decap_8
X_1156_ _1156_/X Tile_X0Y0_S2MID[4] Tile_X0Y0_S4END[3] Tile_X0Y0_SS4END[12] _0602_/Q
+ _0161_/Q _0160_/Q VPWR VGND sg13cmos5l_mux4_1
X_0107_ _0107_/Q Tile_X0Y0_FrameData[14] VGND VPWR Tile_X0Y0_FrameStrobe[0] latch
XFILLER_0_1489 VPWR VGND sg13cmos5l_decap_8
X_1087_ _1087_/X Tile_X2Y0_S1END[2] Tile_X2Y0_S2MID[2] Tile_X2Y0_S2MID[5] Tile_X2Y0_S2END[5]
+ _0325_/Q _0324_/Q VPWR VGND sg13cmos5l_mux4_1
XFILLER_14_1144 VPWR VGND sg13cmos5l_fill_1
XFILLER_14_1177 VPWR VGND sg13cmos5l_fill_1
XANTENNA__1057__X Tile_X1Y0_FrameStrobe_O[9] VPWR VGND sg13cmos5l_antennanp
XFILLER_0_504 VPWR VGND sg13cmos5l_decap_8
XANTENNA__0896__X Tile_X4Y0_NN4BEG[12] VPWR VGND sg13cmos5l_antennanp
XFILLER_9_2160 VPWR VGND sg13cmos5l_decap_8
XFILLER_9_1481 VPWR VGND sg13cmos5l_decap_8
XFILLER_5_2068 VPWR VGND sg13cmos5l_decap_8
XFILLER_5_1312 VPWR VGND sg13cmos5l_decap_8
XFILLER_5_1389 VPWR VGND sg13cmos5l_decap_8
XFILLER_3_1080 VPWR VGND sg13cmos5l_decap_8
XFILLER_11_132 VPWR VGND sg13cmos5l_fill_1
XFILLER_12_655 VPWR VGND sg13cmos5l_decap_8
XFILLER_16_1987 VPWR VGND sg13cmos5l_decap_8
XFILLER_14_2390 VPWR VGND sg13cmos5l_decap_8
XFILLER_12_699 VPWR VGND sg13cmos5l_decap_4
XFILLER_10_1553 VPWR VGND sg13cmos5l_fill_2
XFILLER_4_876 VPWR VGND sg13cmos5l_fill_2
XFILLER_3_375 VPWR VGND sg13cmos5l_decap_4
XFILLER_6_1109 VPWR VGND sg13cmos5l_decap_8
XFILLER_14_7 VPWR VGND sg13cmos5l_decap_8
X_1010_ Tile_X1Y0_NN4BEG[14] _1214_/X VPWR VGND sg13cmos5l_buf_1
XFILLER_1_1743 VPWR VGND sg13cmos5l_decap_8
XFILLER_17_2408 VPWR VGND sg13cmos5l_fill_2
XFILLER_17_1707 VPWR VGND sg13cmos5l_fill_2
XFILLER_15_1420 VPWR VGND sg13cmos5l_decap_8
XFILLER_8_74 VPWR VGND sg13cmos5l_decap_8
XFILLER_15_1497 VPWR VGND sg13cmos5l_decap_8
X_0725_ Tile_X0Y0_FrameStrobe_O[17] Tile_X0Y0_FrameStrobe[17] VPWR VGND sg13cmos5l_buf_1
X_0656_ _0656_/L_HI VPWR VGND sg13cmos5l_tiehi
X_0587_ _0587_/Q Tile_X0Y0_UserCLK NPU_RDATA15 _0620_/L_HI VPWR VGND sg13cmos5l_dfrbpq_1
XFILLER_8_1919 VPWR VGND sg13cmos5l_decap_8
XFILLER_6_2344 VPWR VGND sg13cmos5l_decap_8
XFILLER_6_1632 VPWR VGND sg13cmos5l_decap_8
X_1208_ _1208_/X Tile_X1Y0_S2END[0] Tile_X1Y0_S4END[8] Tile_X1Y0_SS4END[7] _0593_/Q
+ _0249_/Q _0248_/Q VPWR VGND sg13cmos5l_mux4_1
X_1139_ _1139_/X Tile_X0Y0_S1END[3] Tile_X0Y0_S2MID[3] Tile_X0Y0_S2END[4] _0599_/Q
+ _0195_/Q _0194_/Q VPWR VGND sg13cmos5l_mux4_1
XFILLER_5_618 VPWR VGND sg13cmos5l_decap_8
XFILLER_11_1873 VPWR VGND sg13cmos5l_decap_8
XFILLER_0_323 VPWR VGND sg13cmos5l_fill_2
XFILLER_0_367 VPWR VGND sg13cmos5l_fill_1
XFILLER_7_1429 VPWR VGND sg13cmos5l_decap_8
XFILLER_5_1120 VPWR VGND sg13cmos5l_decap_8
XFILLER_1_1017 VPWR VGND sg13cmos5l_decap_8
XFILLER_17_747 VPWR VGND sg13cmos5l_decap_4
XFILLER_17_50 VPWR VGND sg13cmos5l_fill_1
XFILLER_16_202 VPWR VGND sg13cmos5l_decap_8
XFILLER_9_924 VPWR VGND sg13cmos5l_decap_8
XFILLER_8_412 VPWR VGND sg13cmos5l_decap_8
XFILLER_13_975 VPWR VGND sg13cmos5l_decap_8
XFILLER_12_2316 VPWR VGND sg13cmos5l_decap_8
XFILLER_12_1637 VPWR VGND sg13cmos5l_decap_8
XFILLER_12_1626 VPWR VGND sg13cmos5l_fill_1
XFILLER_10_2062 VPWR VGND sg13cmos5l_decap_8
X_0510_ _0510_/Q Tile_X0Y0_FrameData[27] VGND VPWR Tile_X4Y0_FrameStrobe[0] latch
XFILLER_10_1383 VPWR VGND sg13cmos5l_decap_8
XFILLER_4_673 VPWR VGND sg13cmos5l_decap_8
XFILLER_3_161 VPWR VGND sg13cmos5l_decap_8
X_0441_ _0441_/Q Tile_X0Y0_FrameData[0] VGND VPWR Tile_X3Y0_FrameStrobe[0] latch
X_0372_ _0372_/Q Tile_X0Y0_FrameData[5] VGND VPWR Tile_X2Y0_FrameStrobe[1] latch
XFILLER_7_1952 VPWR VGND sg13cmos5l_decap_8
XFILLER_3_1838 VPWR VGND sg13cmos5l_decap_8
XFILLER_1_2296 VPWR VGND sg13cmos5l_decap_8
XFILLER_1_1584 VPWR VGND sg13cmos5l_decap_8
XFILLER_17_2227 VPWR VGND sg13cmos5l_decap_8
XFILLER_17_2216 VPWR VGND sg13cmos5l_fill_2
XFILLER_11_1114 VPWR VGND sg13cmos5l_decap_8
XFILLER_11_1147 VPWR VGND sg13cmos5l_decap_4
XFILLER_11_1158 VPWR VGND sg13cmos5l_fill_2
X_0708_ Tile_X0Y0_FrameStrobe_O[0] Tile_X0Y0_FrameStrobe[0] VPWR VGND sg13cmos5l_buf_1
X_0639_ _0639_/L_HI VPWR VGND sg13cmos5l_tiehi
XFILLER_8_1749 VPWR VGND sg13cmos5l_decap_8
XFILLER_6_2163 VPWR VGND sg13cmos5l_decap_8
XFILLER_2_1337 VPWR VGND sg13cmos5l_decap_8
XANTENNA__1070__X Tile_X2Y0_N2BEG[2] VPWR VGND sg13cmos5l_antennanp
XFILLER_14_706 VPWR VGND sg13cmos5l_decap_4
XFILLER_0_1050 VPWR VGND sg13cmos5l_decap_4
XFILLER_14_717 VPWR VGND sg13cmos5l_decap_8
XFILLER_13_249 VPWR VGND sg13cmos5l_decap_4
XFILLER_13_238 VPWR VGND sg13cmos5l_fill_1
XFILLER_10_901 VPWR VGND sg13cmos5l_fill_1
XFILLER_10_934 VPWR VGND sg13cmos5l_decap_8
XFILLER_6_927 VPWR VGND sg13cmos5l_decap_8
XFILLER_13_1968 VPWR VGND sg13cmos5l_decap_8
XFILLER_11_2382 VPWR VGND sg13cmos5l_decap_8
XFILLER_0_120 VPWR VGND sg13cmos5l_decap_8
XFILLER_0_131 VPWR VGND sg13cmos5l_fill_2
XFILLER_1_665 VPWR VGND sg13cmos5l_decap_8
XFILLER_0_175 VPWR VGND sg13cmos5l_decap_4
XFILLER_1_698 VPWR VGND sg13cmos5l_fill_1
XFILLER_17_533 VPWR VGND sg13cmos5l_decap_4
XFILLER_2_1893 VPWR VGND sg13cmos5l_decap_8
X_0990_ Tile_X2Y0_FrameStrobe_O[18] Tile_X2Y0_FrameStrobe[18] VPWR VGND sg13cmos5l_buf_1
XFILLER_16_2260 VPWR VGND sg13cmos5l_decap_8
XFILLER_9_765 VPWR VGND sg13cmos5l_decap_8
XFILLER_12_2157 VPWR VGND sg13cmos5l_decap_8
XFILLER_12_1445 VPWR VGND sg13cmos5l_decap_8
XFILLER_5_42 VPWR VGND sg13cmos5l_decap_8
XFILLER_4_470 VPWR VGND sg13cmos5l_decap_8
X_0424_ _0424_/Q Tile_X0Y0_FrameData[17] VGND VPWR Tile_X3Y0_FrameStrobe[0] latch
XANTENNA__0994__X Tile_X2Y0_N1BEG[2] VPWR VGND sg13cmos5l_antennanp
XFILLER_3_2314 VPWR VGND sg13cmos5l_decap_8
X_0355_ _0355_/Q Tile_X0Y0_FrameData[22] VGND VPWR Tile_X2Y0_FrameStrobe[1] latch
XFILLER_3_1602 VPWR VGND sg13cmos5l_decap_8
X_0286_ _0286_/Q Tile_X0Y0_FrameData[11] VGND VPWR Tile_X1Y0_FrameStrobe[2] latch
XFILLER_3_1679 VPWR VGND sg13cmos5l_decap_8
XFILLER_17_2002 VPWR VGND sg13cmos5l_fill_1
XFILLER_10_208 VPWR VGND sg13cmos5l_fill_1
XFILLER_3_919 VPWR VGND sg13cmos5l_decap_8
XANTENNA__1065__X Tile_X1Y0_FrameStrobe_O[17] VPWR VGND sg13cmos5l_antennanp
XFILLER_8_2247 VPWR VGND sg13cmos5l_decap_8
XFILLER_8_1524 VPWR VGND sg13cmos5l_decap_8
XFILLER_2_1101 VPWR VGND sg13cmos5l_decap_8
XANTENNA_104 Tile_X0Y0_FrameData[26] VPWR VGND sg13cmos5l_antennanp
XANTENNA_115 Tile_X0Y0_FrameData[29] VPWR VGND sg13cmos5l_antennanp
XANTENNA_126 Tile_X0Y0_FrameData[30] VPWR VGND sg13cmos5l_antennanp
XANTENNA_137 Tile_X0Y0_FrameData[30] VPWR VGND sg13cmos5l_antennanp
XANTENNA_148 Tile_X0Y0_FrameData[30] VPWR VGND sg13cmos5l_antennanp
XANTENNA_159 Tile_X0Y0_FrameData[30] VPWR VGND sg13cmos5l_antennanp
XFILLER_10_753 VPWR VGND sg13cmos5l_decap_8
XFILLER_10_775 VPWR VGND sg13cmos5l_fill_1
XFILLER_6_724 VPWR VGND sg13cmos5l_decap_8
XFILLER_5_234 VPWR VGND sg13cmos5l_decap_8
XFILLER_7_1001 VPWR VGND sg13cmos5l_decap_8
XFILLER_1_462 VPWR VGND sg13cmos5l_decap_8
XFILLER_2_996 VPWR VGND sg13cmos5l_decap_8
XFILLER_7_1078 VPWR VGND sg13cmos5l_decap_8
X_0140_ _0140_/Q Tile_X0Y0_FrameData[13] VGND VPWR Tile_X0Y0_FrameStrobe[1] latch
XFILLER_4_1955 VPWR VGND sg13cmos5l_decap_8
XFILLER_18_853 VPWR VGND sg13cmos5l_fill_2
XFILLER_18_842 VPWR VGND sg13cmos5l_decap_8
XFILLER_18_2344 VPWR VGND sg13cmos5l_decap_8
XFILLER_14_2208 VPWR VGND sg13cmos5l_decap_8
XFILLER_18_1676 VPWR VGND sg13cmos5l_fill_2
XFILLER_13_580 VPWR VGND sg13cmos5l_decap_4
X_0973_ Tile_X2Y0_FrameStrobe_O[1] Tile_X2Y0_FrameStrobe[1] VPWR VGND sg13cmos5l_buf_1
XANTENNA__0989__X Tile_X2Y0_FrameStrobe_O[17] VPWR VGND sg13cmos5l_antennanp
XFILLER_12_1264 VPWR VGND sg13cmos5l_fill_2
XFILLER_9_1800 VPWR VGND sg13cmos5l_decap_8
XFILLER_9_1833 VPWR VGND sg13cmos5l_decap_8
XFILLER_9_1866 VPWR VGND sg13cmos5l_decap_8
X_0407_ _0407_/Q Tile_X0Y0_FrameData[2] VGND VPWR Tile_X2Y0_FrameStrobe[2] latch
XFILLER_7_2291 VPWR VGND sg13cmos5l_decap_8
XFILLER_3_2111 VPWR VGND sg13cmos5l_decap_8
X_0338_ _0338_/Q Tile_X0Y0_FrameData[7] VGND VPWR Tile_X2Y0_FrameStrobe[0] latch
XFILLER_7_1590 VPWR VGND sg13cmos5l_decap_8
XFILLER_3_2188 VPWR VGND sg13cmos5l_decap_8
X_0269_ _0269_/Q Tile_X0Y0_FrameData[28] VGND VPWR Tile_X1Y0_FrameStrobe[2] latch
XFILLER_3_1476 VPWR VGND sg13cmos5l_decap_8
XFILLER_17_1142 VPWR VGND sg13cmos5l_fill_2
XFILLER_11_539 VPWR VGND sg13cmos5l_fill_2
XFILLER_11_528 VPWR VGND sg13cmos5l_decap_8
XFILLER_17_1186 VPWR VGND sg13cmos5l_decap_8
XFILLER_13_1017 VPWR VGND sg13cmos5l_decap_8
XANTENNA__0899__X Tile_X4Y0_NN4BEG[15] VPWR VGND sg13cmos5l_antennanp
XFILLER_10_1949 VPWR VGND sg13cmos5l_decap_8
XFILLER_3_738 VPWR VGND sg13cmos5l_decap_8
XFILLER_2_259 VPWR VGND sg13cmos5l_decap_8
XFILLER_8_2066 VPWR VGND sg13cmos5l_decap_8
XFILLER_8_1321 VPWR VGND sg13cmos5l_decap_8
XFILLER_8_1354 VPWR VGND sg13cmos5l_fill_1
XFILLER_18_149 VPWR VGND sg13cmos5l_decap_8
XFILLER_13_2274 VPWR VGND sg13cmos5l_decap_8
XFILLER_6_554 VPWR VGND sg13cmos5l_decap_8
XFILLER_9_1107 VPWR VGND sg13cmos5l_decap_4
XFILLER_2_782 VPWR VGND sg13cmos5l_decap_8
X_1241_ _1241_/X Tile_X2Y0_S2END[1] Tile_X2Y0_S4END[1] Tile_X2Y0_SS4END[14] _0580_/Q
+ _0359_/Q _0358_/Q VPWR VGND sg13cmos5l_mux4_1
XFILLER_2_21 VPWR VGND sg13cmos5l_decap_8
X_1172_ _1172_/X Tile_X0Y0_S2END[4] Tile_X0Y0_S4END[12] Tile_X0Y0_SS4END[3] _0603_/Q
+ _0129_/Q _0128_/Q VPWR VGND sg13cmos5l_mux4_1
X_0123_ _0123_/Q Tile_X0Y0_FrameData[30] VGND VPWR Tile_X0Y0_FrameStrobe[1] latch
XFILLER_4_1741 VPWR VGND sg13cmos5l_decap_8
XFILLER_2_98 VPWR VGND sg13cmos5l_decap_8
XFILLER_18_672 VPWR VGND sg13cmos5l_decap_4
XFILLER_18_661 VPWR VGND sg13cmos5l_decap_8
XFILLER_18_2141 VPWR VGND sg13cmos5l_decap_4
XANTENNA_15 NPU_RDATA18 VPWR VGND sg13cmos5l_antennanp
XANTENNA_26 NPU_RDATA24 VPWR VGND sg13cmos5l_antennanp
XANTENNA_37 NPU_RDATA3 VPWR VGND sg13cmos5l_antennanp
XANTENNA_48 Tile_X0Y0_FrameData[12] VPWR VGND sg13cmos5l_antennanp
XFILLER_14_1315 VPWR VGND sg13cmos5l_decap_8
XANTENNA_59 Tile_X0Y0_FrameData[12] VPWR VGND sg13cmos5l_antennanp
X_0956_ Tile_X3Y0_NN4BEG[0] _1280_/X VPWR VGND sg13cmos5l_buf_1
XFILLER_9_392 VPWR VGND sg13cmos5l_decap_4
X_0887_ Tile_X4Y0_NN4BEG[3] Tile_X4Y0_SS4END[12] VPWR VGND sg13cmos5l_buf_1
XFILLER_12_1061 VPWR VGND sg13cmos5l_fill_2
XFILLER_12_1050 VPWR VGND sg13cmos5l_decap_8
XFILLER_9_2353 VPWR VGND sg13cmos5l_decap_8
XFILLER_9_1685 VPWR VGND sg13cmos5l_fill_1
XFILLER_3_1273 VPWR VGND sg13cmos5l_decap_8
XFILLER_8_808 VPWR VGND sg13cmos5l_fill_2
XFILLER_3_557 VPWR VGND sg13cmos5l_decap_8
XFILLER_1_1936 VPWR VGND sg13cmos5l_decap_8
XFILLER_15_686 VPWR VGND sg13cmos5l_decap_8
XFILLER_15_2314 VPWR VGND sg13cmos5l_decap_8
X_0810_ Tile_X4Y0_FrameData_O[14] Tile_X0Y0_FrameData[14] VPWR VGND sg13cmos5l_buf_1
X_0741_ Tile_X0Y0_N2BEGb[1] _1137_/X VPWR VGND sg13cmos5l_buf_1
XFILLER_13_1381 VPWR VGND sg13cmos5l_decap_8
X_0672_ _0672_/L_HI VPWR VGND sg13cmos5l_tiehi
XFILLER_6_1803 VPWR VGND sg13cmos5l_decap_8
XFILLER_0_2103 VPWR VGND sg13cmos5l_decap_8
X_1224_ _1224_/X Tile_X2Y0_S2MID[0] Tile_X2Y0_S4END[15] Tile_X2Y0_SS4END[0] _0580_/Q
+ _0393_/Q _0392_/Q VPWR VGND sg13cmos5l_mux4_1
XFILLER_6_1869 VPWR VGND sg13cmos5l_decap_8
XFILLER_4_2283 VPWR VGND sg13cmos5l_decap_8
X_1155_ _1155_/X Tile_X0Y0_S2MID[3] Tile_X0Y0_S4END[4] Tile_X0Y0_SS4END[11] _0601_/Q
+ _0163_/Q _0162_/Q VPWR VGND sg13cmos5l_mux4_1
X_0106_ _0106_/Q Tile_X0Y0_FrameData[15] VGND VPWR Tile_X0Y0_FrameStrobe[0] latch
X_1086_ _1086_/X Tile_X2Y0_S1END[1] Tile_X2Y0_S2MID[1] Tile_X2Y0_S2MID[6] Tile_X2Y0_S2END[6]
+ _0327_/Q _0326_/Q VPWR VGND sg13cmos5l_mux4_1
XFILLER_0_1468 VPWR VGND sg13cmos5l_decap_8
XFILLER_14_1123 VPWR VGND sg13cmos5l_fill_2
XFILLER_14_1156 VPWR VGND sg13cmos5l_fill_2
X_0939_ Tile_X3Y0_N2BEGb[7] _1263_/X VPWR VGND sg13cmos5l_buf_1
XANTENNA__1073__X Tile_X2Y0_N2BEG[5] VPWR VGND sg13cmos5l_antennanp
XFILLER_9_1460 VPWR VGND sg13cmos5l_decap_8
XFILLER_5_2047 VPWR VGND sg13cmos5l_decap_8
XFILLER_5_1368 VPWR VGND sg13cmos5l_decap_8
XFILLER_8_605 VPWR VGND sg13cmos5l_decap_8
XFILLER_16_1944 VPWR VGND sg13cmos5l_fill_1
XFILLER_16_1933 VPWR VGND sg13cmos5l_decap_8
XFILLER_12_678 VPWR VGND sg13cmos5l_decap_8
XFILLER_11_177 VPWR VGND sg13cmos5l_decap_4
XFILLER_7_126 VPWR VGND sg13cmos5l_fill_1
XFILLER_10_2299 VPWR VGND sg13cmos5l_decap_8
XFILLER_3_343 VPWR VGND sg13cmos5l_fill_1
XFILLER_0_0 VPWR VGND sg13cmos5l_decap_8
XFILLER_10_1598 VPWR VGND sg13cmos5l_decap_4
XFILLER_1_2401 VPWR VGND sg13cmos5l_decap_8
XFILLER_1_1722 VPWR VGND sg13cmos5l_decap_8
XFILLER_1_1799 VPWR VGND sg13cmos5l_decap_8
XFILLER_16_984 VPWR VGND sg13cmos5l_decap_8
XFILLER_15_494 VPWR VGND sg13cmos5l_decap_8
XFILLER_15_2133 VPWR VGND sg13cmos5l_fill_2
XFILLER_8_42 VPWR VGND sg13cmos5l_decap_8
XFILLER_15_2177 VPWR VGND sg13cmos5l_fill_2
XFILLER_15_2166 VPWR VGND sg13cmos5l_decap_8
XFILLER_8_53 VPWR VGND sg13cmos5l_decap_8
XFILLER_11_1318 VPWR VGND sg13cmos5l_decap_4
XFILLER_15_1476 VPWR VGND sg13cmos5l_decap_8
X_0724_ Tile_X0Y0_FrameStrobe_O[16] Tile_X0Y0_FrameStrobe[16] VPWR VGND sg13cmos5l_buf_1
XANTENNA__0997__X Tile_X1Y0_NN4BEG[1] VPWR VGND sg13cmos5l_antennanp
X_0655_ _0655_/L_HI VPWR VGND sg13cmos5l_tiehi
X_0586_ _0586_/Q Tile_X0Y0_UserCLK NPU_RDATA14 _0623_/L_HI VPWR VGND sg13cmos5l_dfrbpq_1
XFILLER_6_2323 VPWR VGND sg13cmos5l_decap_8
XFILLER_6_1611 VPWR VGND sg13cmos5l_decap_8
X_1207_ _1207_/X Tile_X1Y0_S2END[7] Tile_X1Y0_S4END[7] Tile_X1Y0_SS4END[8] _0590_/Q
+ _0251_/Q _0250_/Q VPWR VGND sg13cmos5l_mux4_1
XFILLER_4_2080 VPWR VGND sg13cmos5l_decap_8
XFILLER_2_1519 VPWR VGND sg13cmos5l_decap_8
X_1138_ _1138_/X Tile_X0Y0_S1END[2] Tile_X0Y0_S2MID[2] Tile_X0Y0_S2END[5] _0598_/Q
+ _0197_/Q _0196_/Q VPWR VGND sg13cmos5l_mux4_1
X_1069_ Tile_X2Y0_N2BEG[1] Tile_X2Y0_S2MID[6] VPWR VGND sg13cmos5l_buf_1
XFILLER_16_1218 VPWR VGND sg13cmos5l_decap_8
XANTENNA__1068__X Tile_X2Y0_N2BEG[0] VPWR VGND sg13cmos5l_antennanp
XFILLER_11_1852 VPWR VGND sg13cmos5l_decap_8
XANTENNA__0700__X Tile_X2Y0_N4BEG[8] VPWR VGND sg13cmos5l_antennanp
XFILLER_1_825 VPWR VGND sg13cmos5l_decap_8
XFILLER_7_1408 VPWR VGND sg13cmos5l_decap_8
XFILLER_17_715 VPWR VGND sg13cmos5l_decap_4
XFILLER_17_95 VPWR VGND sg13cmos5l_fill_2
XFILLER_9_903 VPWR VGND sg13cmos5l_decap_8
XFILLER_13_954 VPWR VGND sg13cmos5l_decap_8
XFILLER_12_497 VPWR VGND sg13cmos5l_decap_8
XFILLER_12_1605 VPWR VGND sg13cmos5l_decap_8
XFILLER_8_479 VPWR VGND sg13cmos5l_decap_8
XFILLER_10_2041 VPWR VGND sg13cmos5l_decap_8
XFILLER_10_1362 VPWR VGND sg13cmos5l_decap_8
XFILLER_4_652 VPWR VGND sg13cmos5l_decap_8
XFILLER_3_140 VPWR VGND sg13cmos5l_decap_8
X_0440_ _0440_/Q Tile_X0Y0_FrameData[1] VGND VPWR Tile_X3Y0_FrameStrobe[0] latch
X_0371_ _0371_/Q Tile_X0Y0_FrameData[6] VGND VPWR Tile_X2Y0_FrameStrobe[1] latch
XFILLER_7_1931 VPWR VGND sg13cmos5l_decap_8
XFILLER_3_1817 VPWR VGND sg13cmos5l_decap_8
XFILLER_1_2275 VPWR VGND sg13cmos5l_decap_8
XFILLER_1_1563 VPWR VGND sg13cmos5l_decap_8
XFILLER_16_781 VPWR VGND sg13cmos5l_decap_4
XFILLER_15_1251 VPWR VGND sg13cmos5l_fill_1
X_0707_ Tile_X2Y0_N4BEG[15] _1239_/X VPWR VGND sg13cmos5l_buf_1
X_0638_ _0638_/L_HI VPWR VGND sg13cmos5l_tiehi
X_0569_ NPU_ADDR5 Tile_X0Y0_UserCLK _1090_/X _0672_/L_HI VPWR VGND sg13cmos5l_dfrbpq_1
XFILLER_6_2142 VPWR VGND sg13cmos5l_decap_8
XFILLER_2_2006 VPWR VGND sg13cmos5l_decap_8
XFILLER_2_2039 VPWR VGND sg13cmos5l_decap_8
XFILLER_6_1485 VPWR VGND sg13cmos5l_decap_8
XFILLER_2_1316 VPWR VGND sg13cmos5l_decap_8
XFILLER_10_913 VPWR VGND sg13cmos5l_decap_8
XFILLER_16_1059 VPWR VGND sg13cmos5l_fill_2
XFILLER_6_906 VPWR VGND sg13cmos5l_decap_8
XFILLER_13_1947 VPWR VGND sg13cmos5l_decap_8
XFILLER_11_2361 VPWR VGND sg13cmos5l_decap_8
XFILLER_11_1682 VPWR VGND sg13cmos5l_decap_4
XFILLER_1_644 VPWR VGND sg13cmos5l_decap_8
XFILLER_17_501 VPWR VGND sg13cmos5l_decap_4
XFILLER_17_556 VPWR VGND sg13cmos5l_decap_4
XFILLER_2_1872 VPWR VGND sg13cmos5l_decap_8
XFILLER_18_1847 VPWR VGND sg13cmos5l_decap_8
XFILLER_9_722 VPWR VGND sg13cmos5l_decap_4
XFILLER_9_744 VPWR VGND sg13cmos5l_decap_8
XFILLER_16_2283 VPWR VGND sg13cmos5l_decap_8
XFILLER_8_254 VPWR VGND sg13cmos5l_decap_8
XFILLER_16_1582 VPWR VGND sg13cmos5l_decap_8
XFILLER_16_1560 VPWR VGND sg13cmos5l_decap_4
XFILLER_12_2136 VPWR VGND sg13cmos5l_decap_8
XFILLER_12_1424 VPWR VGND sg13cmos5l_decap_8
XFILLER_5_21 VPWR VGND sg13cmos5l_decap_8
XFILLER_5_994 VPWR VGND sg13cmos5l_decap_8
XFILLER_5_98 VPWR VGND sg13cmos5l_decap_8
X_0423_ _0423_/Q Tile_X0Y0_FrameData[18] VGND VPWR Tile_X3Y0_FrameStrobe[0] latch
X_0354_ _0354_/Q Tile_X0Y0_FrameData[23] VGND VPWR Tile_X2Y0_FrameStrobe[1] latch
XFILLER_7_1772 VPWR VGND sg13cmos5l_decap_8
X_0285_ _0285_/Q Tile_X0Y0_FrameData[12] VGND VPWR Tile_X1Y0_FrameStrobe[2] latch
XFILLER_3_1658 VPWR VGND sg13cmos5l_decap_8
XFILLER_1_2083 VPWR VGND sg13cmos5l_decap_8
XFILLER_1_1393 VPWR VGND sg13cmos5l_decap_8
XFILLER_17_2036 VPWR VGND sg13cmos5l_decap_8
XFILLER_17_1368 VPWR VGND sg13cmos5l_decap_8
XFILLER_15_1070 VPWR VGND sg13cmos5l_fill_2
XFILLER_15_1092 VPWR VGND sg13cmos5l_decap_8
XFILLER_8_2226 VPWR VGND sg13cmos5l_decap_8
XFILLER_8_2204 VPWR VGND sg13cmos5l_decap_4
XANTENNA__1081__X Tile_X2Y0_N2BEGb[5] VPWR VGND sg13cmos5l_antennanp
XFILLER_6_1282 VPWR VGND sg13cmos5l_decap_8
XANTENNA_105 Tile_X0Y0_FrameData[26] VPWR VGND sg13cmos5l_antennanp
XANTENNA_116 Tile_X0Y0_FrameData[29] VPWR VGND sg13cmos5l_antennanp
XFILLER_2_1157 VPWR VGND sg13cmos5l_decap_8
XANTENNA_127 Tile_X0Y0_FrameData[30] VPWR VGND sg13cmos5l_antennanp
XANTENNA_138 Tile_X0Y0_FrameData[30] VPWR VGND sg13cmos5l_antennanp
XANTENNA_149 Tile_X0Y0_FrameData[30] VPWR VGND sg13cmos5l_antennanp
XFILLER_14_515 VPWR VGND sg13cmos5l_decap_8
XFILLER_14_63 VPWR VGND sg13cmos5l_fill_1
XFILLER_10_732 VPWR VGND sg13cmos5l_decap_8
XFILLER_13_1700 VPWR VGND sg13cmos5l_fill_2
XFILLER_5_213 VPWR VGND sg13cmos5l_decap_8
XFILLER_2_975 VPWR VGND sg13cmos5l_decap_8
XFILLER_7_1057 VPWR VGND sg13cmos5l_decap_8
XFILLER_4_1934 VPWR VGND sg13cmos5l_decap_8
XFILLER_18_887 VPWR VGND sg13cmos5l_fill_2
XFILLER_17_342 VPWR VGND sg13cmos5l_fill_2
XFILLER_2_1680 VPWR VGND sg13cmos5l_decap_8
X_0972_ Tile_X2Y0_FrameStrobe_O[0] Tile_X2Y0_FrameStrobe[0] VPWR VGND sg13cmos5l_buf_1
XFILLER_16_2091 VPWR VGND sg13cmos5l_decap_8
XFILLER_13_592 VPWR VGND sg13cmos5l_decap_8
X_0406_ _0406_/Q Tile_X0Y0_FrameData[3] VGND VPWR Tile_X2Y0_FrameStrobe[2] latch
XFILLER_7_2270 VPWR VGND sg13cmos5l_decap_8
X_0337_ _0337_/Q Tile_X0Y0_FrameData[8] VGND VPWR Tile_X2Y0_FrameStrobe[0] latch
XFILLER_3_2167 VPWR VGND sg13cmos5l_decap_8
XFILLER_3_1455 VPWR VGND sg13cmos5l_decap_8
X_0268_ _0268_/Q Tile_X0Y0_FrameData[29] VGND VPWR Tile_X1Y0_FrameStrobe[2] latch
X_0199_ _0199_/Q Tile_X0Y0_FrameData[18] VGND VPWR Tile_X0Y0_FrameStrobe[3] latch
XFILLER_11_507 VPWR VGND sg13cmos5l_decap_8
XFILLER_10_1928 VPWR VGND sg13cmos5l_decap_8
XANTENNA__1076__X Tile_X2Y0_N2BEGb[0] VPWR VGND sg13cmos5l_antennanp
XFILLER_4_7 VPWR VGND sg13cmos5l_decap_8
XFILLER_2_238 VPWR VGND sg13cmos5l_decap_8
XFILLER_8_2045 VPWR VGND sg13cmos5l_decap_8
XFILLER_4_1208 VPWR VGND sg13cmos5l_fill_1
XFILLER_8_1399 VPWR VGND sg13cmos5l_decap_8
XFILLER_4_1219 VPWR VGND sg13cmos5l_decap_8
XFILLER_14_301 VPWR VGND sg13cmos5l_fill_1
XFILLER_14_323 VPWR VGND sg13cmos5l_decap_8
XFILLER_15_1817 VPWR VGND sg13cmos5l_decap_8
XFILLER_13_2253 VPWR VGND sg13cmos5l_decap_8
XFILLER_10_595 VPWR VGND sg13cmos5l_fill_1
XFILLER_6_533 VPWR VGND sg13cmos5l_decap_8
XFILLER_2_761 VPWR VGND sg13cmos5l_decap_8
X_1240_ _1240_/X Tile_X2Y0_S2END[0] Tile_X2Y0_S4END[0] Tile_X2Y0_SS4END[15] _0581_/Q
+ _0361_/Q _0360_/Q VPWR VGND sg13cmos5l_mux4_1
X_1171_ _1171_/X Tile_X0Y0_S2END[3] Tile_X0Y0_S4END[11] Tile_X0Y0_SS4END[4] _0600_/Q
+ _0131_/Q _0130_/Q VPWR VGND sg13cmos5l_mux4_1
XFILLER_4_1720 VPWR VGND sg13cmos5l_decap_8
XFILLER_2_77 VPWR VGND sg13cmos5l_decap_8
X_0122_ _0122_/Q Tile_X0Y0_FrameData[31] VGND VPWR Tile_X0Y0_FrameStrobe[1] latch
XFILLER_18_2120 VPWR VGND sg13cmos5l_decap_8
XFILLER_18_2175 VPWR VGND sg13cmos5l_decap_8
XANTENNA_16 NPU_RDATA19 VPWR VGND sg13cmos5l_antennanp
XANTENNA_27 NPU_RDATA25 VPWR VGND sg13cmos5l_antennanp
XANTENNA_38 NPU_RDATA30 VPWR VGND sg13cmos5l_antennanp
XFILLER_14_2039 VPWR VGND sg13cmos5l_decap_8
XANTENNA_49 Tile_X0Y0_FrameData[12] VPWR VGND sg13cmos5l_antennanp
X_0955_ Tile_X3Y0_N4BEG[15] _1279_/X VPWR VGND sg13cmos5l_buf_1
XFILLER_14_1349 VPWR VGND sg13cmos5l_decap_8
X_0886_ Tile_X4Y0_NN4BEG[2] Tile_X4Y0_SS4END[13] VPWR VGND sg13cmos5l_buf_1
XFILLER_9_2332 VPWR VGND sg13cmos5l_decap_8
XFILLER_5_2229 VPWR VGND sg13cmos5l_decap_8
XFILLER_3_1252 VPWR VGND sg13cmos5l_decap_8
XFILLER_15_109 VPWR VGND sg13cmos5l_decap_8
XANTENNA__0703__X Tile_X2Y0_N4BEG[11] VPWR VGND sg13cmos5l_antennanp
XFILLER_10_1703 VPWR VGND sg13cmos5l_fill_2
XFILLER_10_1758 VPWR VGND sg13cmos5l_fill_1
XFILLER_3_536 VPWR VGND sg13cmos5l_decap_8
XFILLER_11_75 VPWR VGND sg13cmos5l_fill_2
XFILLER_4_1049 VPWR VGND sg13cmos5l_decap_8
XFILLER_1_1915 VPWR VGND sg13cmos5l_decap_8
XFILLER_14_175 VPWR VGND sg13cmos5l_decap_8
XFILLER_15_1647 VPWR VGND sg13cmos5l_fill_2
X_0740_ Tile_X0Y0_N2BEGb[0] _1136_/X VPWR VGND sg13cmos5l_buf_1
XFILLER_15_1658 VPWR VGND sg13cmos5l_fill_2
XFILLER_13_2094 VPWR VGND sg13cmos5l_decap_8
XFILLER_13_1360 VPWR VGND sg13cmos5l_decap_8
X_0671_ _0671_/L_HI VPWR VGND sg13cmos5l_tiehi
XFILLER_2_580 VPWR VGND sg13cmos5l_decap_8
X_1223_ _1223_/X Tile_X2Y0_S1END[3] Tile_X2Y0_S2MID[7] Tile_X2Y0_S2END[0] _0587_/Q
+ _0395_/Q _0394_/Q VPWR VGND sg13cmos5l_mux4_1
XFILLER_6_1848 VPWR VGND sg13cmos5l_decap_8
XFILLER_4_2262 VPWR VGND sg13cmos5l_decap_8
X_1154_ _1154_/X Tile_X0Y0_S2MID[2] Tile_X0Y0_S4END[5] Tile_X0Y0_SS4END[10] _0600_/Q
+ _0165_/Q _0164_/Q VPWR VGND sg13cmos5l_mux4_1
XFILLER_0_2159 VPWR VGND sg13cmos5l_decap_8
X_0105_ _0105_/Q Tile_X0Y0_FrameData[16] VGND VPWR Tile_X0Y0_FrameStrobe[0] latch
X_1085_ _1085_/X Tile_X2Y0_S1END[0] Tile_X2Y0_S2MID[0] Tile_X2Y0_S2MID[7] Tile_X2Y0_S2END[7]
+ _0329_/Q _0328_/Q VPWR VGND sg13cmos5l_mux4_1
XFILLER_4_1583 VPWR VGND sg13cmos5l_decap_8
XFILLER_0_1447 VPWR VGND sg13cmos5l_decap_8
X_0938_ Tile_X3Y0_N2BEGb[6] _1262_/X VPWR VGND sg13cmos5l_buf_1
XFILLER_14_1135 VPWR VGND sg13cmos5l_decap_8
XFILLER_14_1168 VPWR VGND sg13cmos5l_decap_8
X_0869_ Tile_X4Y0_N4BEG[1] Tile_X4Y0_S4END[14] VPWR VGND sg13cmos5l_buf_1
XFILLER_0_539 VPWR VGND sg13cmos5l_decap_8
XFILLER_5_2026 VPWR VGND sg13cmos5l_decap_8
XFILLER_5_1347 VPWR VGND sg13cmos5l_decap_8
XFILLER_17_919 VPWR VGND sg13cmos5l_decap_8
XFILLER_11_112 VPWR VGND sg13cmos5l_fill_2
XFILLER_11_123 VPWR VGND sg13cmos5l_fill_1
XFILLER_16_1912 VPWR VGND sg13cmos5l_decap_8
XFILLER_7_105 VPWR VGND sg13cmos5l_decap_8
XFILLER_16_1956 VPWR VGND sg13cmos5l_decap_8
XFILLER_11_189 VPWR VGND sg13cmos5l_fill_2
XFILLER_10_2278 VPWR VGND sg13cmos5l_decap_8
XFILLER_4_834 VPWR VGND sg13cmos5l_decap_4
XFILLER_10_1577 VPWR VGND sg13cmos5l_decap_8
XFILLER_3_322 VPWR VGND sg13cmos5l_decap_8
XFILLER_1_1778 VPWR VGND sg13cmos5l_decap_8
XFILLER_16_963 VPWR VGND sg13cmos5l_decap_8
XFILLER_15_473 VPWR VGND sg13cmos5l_decap_8
XFILLER_15_2112 VPWR VGND sg13cmos5l_decap_8
XFILLER_8_21 VPWR VGND sg13cmos5l_decap_8
XFILLER_15_2145 VPWR VGND sg13cmos5l_decap_8
XFILLER_15_2189 VPWR VGND sg13cmos5l_decap_8
XFILLER_15_1455 VPWR VGND sg13cmos5l_decap_8
XFILLER_7_661 VPWR VGND sg13cmos5l_decap_8
X_0723_ Tile_X0Y0_FrameStrobe_O[15] Tile_X0Y0_FrameStrobe[15] VPWR VGND sg13cmos5l_buf_1
X_0654_ _0654_/L_HI VPWR VGND sg13cmos5l_tiehi
XFILLER_6_182 VPWR VGND sg13cmos5l_decap_8
X_0585_ _0585_/Q Tile_X0Y0_UserCLK NPU_RDATA13 _0651_/L_HI VPWR VGND sg13cmos5l_dfrbpq_1
XFILLER_6_2302 VPWR VGND sg13cmos5l_decap_8
XFILLER_6_2379 VPWR VGND sg13cmos5l_decap_8
X_1206_ _1206_/X Tile_X1Y0_S2END[6] Tile_X1Y0_S4END[6] Tile_X1Y0_SS4END[9] _0591_/Q
+ _0253_/Q _0252_/Q VPWR VGND sg13cmos5l_mux4_1
X_1137_ _1137_/X Tile_X0Y0_S1END[1] Tile_X0Y0_S2MID[1] Tile_X0Y0_S2END[6] _0597_/Q
+ _0199_/Q _0198_/Q VPWR VGND sg13cmos5l_mux4_1
XFILLER_4_1380 VPWR VGND sg13cmos5l_decap_8
XFILLER_0_1277 VPWR VGND sg13cmos5l_decap_8
X_1068_ Tile_X2Y0_N2BEG[0] Tile_X2Y0_S2MID[7] VPWR VGND sg13cmos5l_buf_1
XFILLER_11_1831 VPWR VGND sg13cmos5l_decap_8
XFILLER_4_119 VPWR VGND sg13cmos5l_decap_8
XFILLER_1_804 VPWR VGND sg13cmos5l_decap_8
XANTENNA__1084__X Tile_X4Y0_UserCLKo VPWR VGND sg13cmos5l_antennanp
XFILLER_0_336 VPWR VGND sg13cmos5l_decap_8
XFILLER_0_347 VPWR VGND sg13cmos5l_fill_2
XFILLER_5_1155 VPWR VGND sg13cmos5l_decap_8
XFILLER_13_933 VPWR VGND sg13cmos5l_decap_8
XFILLER_9_959 VPWR VGND sg13cmos5l_decap_8
XFILLER_10_2020 VPWR VGND sg13cmos5l_decap_8
XFILLER_8_458 VPWR VGND sg13cmos5l_decap_8
XFILLER_16_1786 VPWR VGND sg13cmos5l_decap_8
XFILLER_10_2097 VPWR VGND sg13cmos5l_decap_8
XFILLER_4_631 VPWR VGND sg13cmos5l_decap_8
XFILLER_3_196 VPWR VGND sg13cmos5l_decap_8
X_0370_ _0370_/Q Tile_X0Y0_FrameData[7] VGND VPWR Tile_X2Y0_FrameStrobe[1] latch
XFILLER_7_1910 VPWR VGND sg13cmos5l_decap_8
XFILLER_7_1987 VPWR VGND sg13cmos5l_decap_8
XFILLER_5_2390 VPWR VGND sg13cmos5l_decap_8
XFILLER_1_2254 VPWR VGND sg13cmos5l_decap_8
XFILLER_1_1542 VPWR VGND sg13cmos5l_decap_8
XFILLER_17_2218 VPWR VGND sg13cmos5l_fill_1
XFILLER_17_1506 VPWR VGND sg13cmos5l_decap_8
XFILLER_11_1127 VPWR VGND sg13cmos5l_decap_8
XFILLER_8_981 VPWR VGND sg13cmos5l_decap_8
XANTENNA__0801__X Tile_X4Y0_FrameData_O[5] VPWR VGND sg13cmos5l_antennanp
X_0706_ Tile_X2Y0_N4BEG[14] _1238_/X VPWR VGND sg13cmos5l_buf_1
X_0637_ _0637_/L_HI VPWR VGND sg13cmos5l_tiehi
X_0568_ NPU_ADDR4 Tile_X0Y0_UserCLK _1089_/X _0673_/L_HI VPWR VGND sg13cmos5l_dfrbpq_1
XFILLER_8_1729 VPWR VGND sg13cmos5l_decap_4
XFILLER_6_2121 VPWR VGND sg13cmos5l_decap_8
X_0499_ _0499_/Q Tile_X0Y0_FrameData[6] VGND VPWR Tile_X3Y0_FrameStrobe[2] latch
XFILLER_6_1464 VPWR VGND sg13cmos5l_decap_8
XFILLER_0_1074 VPWR VGND sg13cmos5l_decap_8
XFILLER_0_1085 VPWR VGND sg13cmos5l_decap_8
XFILLER_16_1005 VPWR VGND sg13cmos5l_decap_8
XANTENNA__1079__X Tile_X2Y0_N2BEGb[3] VPWR VGND sg13cmos5l_antennanp
XFILLER_10_969 VPWR VGND sg13cmos5l_decap_8
XFILLER_13_1926 VPWR VGND sg13cmos5l_decap_8
XFILLER_11_2340 VPWR VGND sg13cmos5l_decap_8
XANTENNA__0711__X Tile_X0Y0_FrameStrobe_O[3] VPWR VGND sg13cmos5l_antennanp
XFILLER_1_623 VPWR VGND sg13cmos5l_decap_8
XFILLER_0_144 VPWR VGND sg13cmos5l_decap_8
XFILLER_0_155 VPWR VGND sg13cmos5l_fill_2
XFILLER_1_689 VPWR VGND sg13cmos5l_fill_1
XFILLER_0_199 VPWR VGND sg13cmos5l_decap_4
XFILLER_2_1851 VPWR VGND sg13cmos5l_decap_8
XFILLER_18_1804 VPWR VGND sg13cmos5l_decap_4
XFILLER_9_701 VPWR VGND sg13cmos5l_decap_8
XFILLER_13_752 VPWR VGND sg13cmos5l_decap_4
XFILLER_12_2115 VPWR VGND sg13cmos5l_decap_8
XFILLER_16_2295 VPWR VGND sg13cmos5l_decap_8
XFILLER_12_1403 VPWR VGND sg13cmos5l_decap_8
XFILLER_5_973 VPWR VGND sg13cmos5l_decap_8
XFILLER_5_77 VPWR VGND sg13cmos5l_decap_8
X_0422_ _0422_/Q Tile_X0Y0_FrameData[19] VGND VPWR Tile_X3Y0_FrameStrobe[0] latch
X_0353_ _0353_/Q Tile_X0Y0_FrameData[24] VGND VPWR Tile_X2Y0_FrameStrobe[1] latch
XFILLER_3_2349 VPWR VGND sg13cmos5l_decap_8
X_0284_ _0284_/Q Tile_X0Y0_FrameData[13] VGND VPWR Tile_X1Y0_FrameStrobe[2] latch
XFILLER_7_1784 VPWR VGND sg13cmos5l_decap_8
XFILLER_3_1637 VPWR VGND sg13cmos5l_decap_8
XFILLER_1_2062 VPWR VGND sg13cmos5l_decap_8
XFILLER_1_1372 VPWR VGND sg13cmos5l_decap_8
XFILLER_17_2059 VPWR VGND sg13cmos5l_decap_4
XFILLER_16_590 VPWR VGND sg13cmos5l_decap_8
XFILLER_8_1504 VPWR VGND sg13cmos5l_decap_8
XFILLER_8_1559 VPWR VGND sg13cmos5l_decap_8
XANTENNA_106 Tile_X0Y0_FrameData[26] VPWR VGND sg13cmos5l_antennanp
XFILLER_2_1136 VPWR VGND sg13cmos5l_decap_8
XANTENNA_117 Tile_X0Y0_FrameData[29] VPWR VGND sg13cmos5l_antennanp
XANTENNA_128 Tile_X0Y0_FrameData[30] VPWR VGND sg13cmos5l_antennanp
XANTENNA_139 Tile_X0Y0_FrameData[30] VPWR VGND sg13cmos5l_antennanp
XANTENNA__0706__X Tile_X2Y0_N4BEG[14] VPWR VGND sg13cmos5l_antennanp
XFILLER_14_53 VPWR VGND sg13cmos5l_fill_2
XFILLER_14_42 VPWR VGND sg13cmos5l_decap_8
XFILLER_17_1881 VPWR VGND sg13cmos5l_decap_8
XFILLER_17_1870 VPWR VGND sg13cmos5l_fill_2
XFILLER_13_1723 VPWR VGND sg13cmos5l_fill_2
XFILLER_5_269 VPWR VGND sg13cmos5l_decap_8
XFILLER_11_2181 VPWR VGND sg13cmos5l_decap_4
XFILLER_11_1480 VPWR VGND sg13cmos5l_decap_8
XFILLER_2_954 VPWR VGND sg13cmos5l_decap_8
XFILLER_7_1036 VPWR VGND sg13cmos5l_decap_8
XFILLER_4_1913 VPWR VGND sg13cmos5l_decap_8
XFILLER_1_497 VPWR VGND sg13cmos5l_decap_8
XFILLER_18_811 VPWR VGND sg13cmos5l_decap_8
XFILLER_18_822 VPWR VGND sg13cmos5l_fill_2
XFILLER_2_2393 VPWR VGND sg13cmos5l_decap_8
XFILLER_18_866 VPWR VGND sg13cmos5l_decap_8
X_0971_ Tile_X3Y0_NN4BEG[15] _1295_/X VPWR VGND sg13cmos5l_buf_1
XFILLER_9_553 VPWR VGND sg13cmos5l_decap_4
XFILLER_9_564 VPWR VGND sg13cmos5l_fill_2
XFILLER_12_1211 VPWR VGND sg13cmos5l_fill_1
XFILLER_16_1391 VPWR VGND sg13cmos5l_decap_8
XFILLER_12_1233 VPWR VGND sg13cmos5l_fill_2
XFILLER_4_280 VPWR VGND sg13cmos5l_decap_8
X_0405_ _0405_/Q Tile_X0Y0_FrameData[4] VGND VPWR Tile_X2Y0_FrameStrobe[2] latch
X_0336_ _0336_/Q Tile_X0Y0_FrameData[9] VGND VPWR Tile_X2Y0_FrameStrobe[0] latch
XFILLER_3_2146 VPWR VGND sg13cmos5l_decap_8
X_0267_ _0267_/Q Tile_X0Y0_FrameData[30] VGND VPWR Tile_X1Y0_FrameStrobe[2] latch
XFILLER_3_1434 VPWR VGND sg13cmos5l_decap_8
X_0198_ _0198_/Q Tile_X0Y0_FrameData[19] VGND VPWR Tile_X0Y0_FrameStrobe[3] latch
XFILLER_17_1144 VPWR VGND sg13cmos5l_fill_1
XFILLER_10_1907 VPWR VGND sg13cmos5l_decap_8
XFILLER_2_217 VPWR VGND sg13cmos5l_decap_8
XFILLER_8_2024 VPWR VGND sg13cmos5l_decap_8
XFILLER_8_1345 VPWR VGND sg13cmos5l_decap_8
XFILLER_18_129 VPWR VGND sg13cmos5l_decap_8
XFILLER_18_118 VPWR VGND sg13cmos5l_fill_1
XFILLER_13_2232 VPWR VGND sg13cmos5l_decap_8
XFILLER_10_574 VPWR VGND sg13cmos5l_fill_2
XFILLER_6_512 VPWR VGND sg13cmos5l_decap_8
XFILLER_6_589 VPWR VGND sg13cmos5l_decap_8
XFILLER_2_740 VPWR VGND sg13cmos5l_decap_8
X_1170_ _1170_/X Tile_X0Y0_S2END[2] Tile_X0Y0_S4END[10] Tile_X0Y0_SS4END[5] _0601_/Q
+ _0133_/Q _0132_/Q VPWR VGND sg13cmos5l_mux4_1
XFILLER_2_56 VPWR VGND sg13cmos5l_decap_8
XFILLER_0_2319 VPWR VGND sg13cmos5l_decap_8
X_0121_ _0121_/Q Tile_X0Y0_FrameData[0] VGND VPWR Tile_X0Y0_FrameStrobe[0] latch
XFILLER_4_1798 VPWR VGND sg13cmos5l_decap_8
XFILLER_14_2018 VPWR VGND sg13cmos5l_decap_8
XANTENNA_17 NPU_RDATA19 VPWR VGND sg13cmos5l_antennanp
XANTENNA_28 NPU_RDATA25 VPWR VGND sg13cmos5l_antennanp
XANTENNA_39 NPU_RDATA30 VPWR VGND sg13cmos5l_antennanp
XFILLER_18_1464 VPWR VGND sg13cmos5l_fill_2
XFILLER_18_1442 VPWR VGND sg13cmos5l_decap_8
X_0954_ Tile_X3Y0_N4BEG[14] _1278_/X VPWR VGND sg13cmos5l_buf_1
X_0885_ Tile_X4Y0_NN4BEG[1] Tile_X4Y0_SS4END[14] VPWR VGND sg13cmos5l_buf_1
XFILLER_9_2311 VPWR VGND sg13cmos5l_decap_8
XFILLER_5_2208 VPWR VGND sg13cmos5l_decap_8
XFILLER_9_2388 VPWR VGND sg13cmos5l_decap_8
XFILLER_7_2090 VPWR VGND sg13cmos5l_decap_8
XFILLER_5_1529 VPWR VGND sg13cmos5l_decap_8
X_0319_ _0319_/Q Tile_X0Y0_FrameData[26] VGND VPWR Tile_X2Y0_FrameStrobe[0] latch
XFILLER_3_1220 VPWR VGND sg13cmos5l_fill_1
XFILLER_11_327 VPWR VGND sg13cmos5l_decap_8
XFILLER_11_316 VPWR VGND sg13cmos5l_fill_1
XFILLER_14_1895 VPWR VGND sg13cmos5l_decap_8
XFILLER_11_32 VPWR VGND sg13cmos5l_fill_1
XFILLER_11_21 VPWR VGND sg13cmos5l_decap_8
XFILLER_3_515 VPWR VGND sg13cmos5l_decap_8
XFILLER_11_98 VPWR VGND sg13cmos5l_decap_8
XFILLER_8_1175 VPWR VGND sg13cmos5l_decap_4
XFILLER_8_1197 VPWR VGND sg13cmos5l_decap_8
XFILLER_4_1028 VPWR VGND sg13cmos5l_decap_8
XFILLER_15_2349 VPWR VGND sg13cmos5l_decap_8
XFILLER_15_1615 VPWR VGND sg13cmos5l_decap_4
XFILLER_13_2073 VPWR VGND sg13cmos5l_decap_8
X_0670_ _0670_/L_HI VPWR VGND sg13cmos5l_tiehi
XFILLER_6_331 VPWR VGND sg13cmos5l_fill_2
X_1222_ _1222_/X Tile_X2Y0_S1END[2] Tile_X2Y0_S2MID[6] Tile_X2Y0_S2END[1] _0586_/Q
+ _0397_/Q _0396_/Q VPWR VGND sg13cmos5l_mux4_1
XFILLER_4_2241 VPWR VGND sg13cmos5l_decap_8
XFILLER_0_2138 VPWR VGND sg13cmos5l_decap_8
X_1153_ _1153_/X Tile_X0Y0_S2MID[1] Tile_X0Y0_S4END[6] Tile_X0Y0_SS4END[9] _0601_/Q
+ _0167_/Q _0166_/Q VPWR VGND sg13cmos5l_mux4_1
XFILLER_4_1562 VPWR VGND sg13cmos5l_decap_8
X_0104_ _0104_/Q Tile_X0Y0_FrameData[17] VGND VPWR Tile_X0Y0_FrameStrobe[0] latch
X_1084_ Tile_X4Y0_UserCLKo Tile_X0Y0_UserCLK VPWR VGND sg13cmos5l_buf_1
XFILLER_18_493 VPWR VGND sg13cmos5l_fill_2
XANTENNA__0804__X Tile_X4Y0_FrameData_O[8] VPWR VGND sg13cmos5l_antennanp
XFILLER_18_1283 VPWR VGND sg13cmos5l_decap_8
X_0937_ Tile_X3Y0_N2BEGb[5] _1261_/X VPWR VGND sg13cmos5l_buf_1
X_0868_ Tile_X4Y0_N4BEG[0] Tile_X4Y0_S4END[15] VPWR VGND sg13cmos5l_buf_1
X_0799_ Tile_X4Y0_FrameData_O[3] Tile_X0Y0_FrameData[3] VPWR VGND sg13cmos5l_buf_1
XFILLER_0_518 VPWR VGND sg13cmos5l_decap_8
XFILLER_9_2174 VPWR VGND sg13cmos5l_decap_8
XFILLER_5_2005 VPWR VGND sg13cmos5l_decap_8
XFILLER_9_1495 VPWR VGND sg13cmos5l_decap_8
XFILLER_5_1326 VPWR VGND sg13cmos5l_decap_8
XFILLER_16_419 VPWR VGND sg13cmos5l_decap_8
XFILLER_16_408 VPWR VGND sg13cmos5l_fill_2
XFILLER_3_1094 VPWR VGND sg13cmos5l_decap_8
XANTENNA__0714__X Tile_X0Y0_FrameStrobe_O[6] VPWR VGND sg13cmos5l_antennanp
XFILLER_12_669 VPWR VGND sg13cmos5l_decap_4
XFILLER_12_647 VPWR VGND sg13cmos5l_decap_4
XFILLER_10_1523 VPWR VGND sg13cmos5l_decap_8
XFILLER_10_2257 VPWR VGND sg13cmos5l_decap_8
XFILLER_4_813 VPWR VGND sg13cmos5l_decap_8
XFILLER_3_301 VPWR VGND sg13cmos5l_decap_8
XFILLER_4_846 VPWR VGND sg13cmos5l_fill_2
XFILLER_5_1893 VPWR VGND sg13cmos5l_decap_8
XFILLER_1_1757 VPWR VGND sg13cmos5l_decap_8
XFILLER_16_942 VPWR VGND sg13cmos5l_decap_8
XFILLER_15_452 VPWR VGND sg13cmos5l_decap_8
XFILLER_15_1434 VPWR VGND sg13cmos5l_decap_8
XFILLER_8_88 VPWR VGND sg13cmos5l_decap_8
XFILLER_7_640 VPWR VGND sg13cmos5l_decap_4
X_0722_ Tile_X0Y0_FrameStrobe_O[14] Tile_X0Y0_FrameStrobe[14] VPWR VGND sg13cmos5l_buf_1
XFILLER_6_161 VPWR VGND sg13cmos5l_decap_8
X_0653_ _0653_/L_HI VPWR VGND sg13cmos5l_tiehi
XFILLER_13_1191 VPWR VGND sg13cmos5l_fill_1
X_0584_ _0584_/Q Tile_X0Y0_UserCLK NPU_RDATA12 _0652_/L_HI VPWR VGND sg13cmos5l_dfrbpq_1
XFILLER_6_2358 VPWR VGND sg13cmos5l_decap_8
X_1205_ _1205_/X Tile_X1Y0_S2END[5] Tile_X1Y0_S4END[5] Tile_X1Y0_SS4END[10] _0590_/Q
+ _0255_/Q _0254_/Q VPWR VGND sg13cmos5l_mux4_1
X_1136_ _1136_/X Tile_X0Y0_S1END[0] Tile_X0Y0_S2MID[0] Tile_X0Y0_S2END[7] _0596_/Q
+ _0201_/Q _0200_/Q VPWR VGND sg13cmos5l_mux4_1
X_1067_ Tile_X1Y0_FrameStrobe_O[19] Tile_X1Y0_FrameStrobe[19] VPWR VGND sg13cmos5l_buf_1
XFILLER_11_1887 VPWR VGND sg13cmos5l_decap_8
XANTENNA__0709__X Tile_X0Y0_FrameStrobe_O[1] VPWR VGND sg13cmos5l_antennanp
XFILLER_5_1134 VPWR VGND sg13cmos5l_decap_8
XFILLER_16_216 VPWR VGND sg13cmos5l_decap_4
XFILLER_12_444 VPWR VGND sg13cmos5l_decap_8
XFILLER_9_938 VPWR VGND sg13cmos5l_decap_8
XFILLER_8_437 VPWR VGND sg13cmos5l_decap_8
XFILLER_8_426 VPWR VGND sg13cmos5l_fill_1
XFILLER_13_989 VPWR VGND sg13cmos5l_decap_8
XFILLER_16_1765 VPWR VGND sg13cmos5l_decap_8
XFILLER_4_610 VPWR VGND sg13cmos5l_decap_8
XFILLER_10_2076 VPWR VGND sg13cmos5l_decap_8
XFILLER_10_1397 VPWR VGND sg13cmos5l_decap_8
XFILLER_4_687 VPWR VGND sg13cmos5l_decap_8
XFILLER_3_175 VPWR VGND sg13cmos5l_decap_8
XFILLER_7_1966 VPWR VGND sg13cmos5l_decap_8
XFILLER_3_1808 VPWR VGND sg13cmos5l_decap_4
XFILLER_12_7 VPWR VGND sg13cmos5l_decap_8
XFILLER_1_1521 VPWR VGND sg13cmos5l_decap_8
XFILLER_16_761 VPWR VGND sg13cmos5l_decap_4
XFILLER_1_1598 VPWR VGND sg13cmos5l_decap_8
XFILLER_16_794 VPWR VGND sg13cmos5l_decap_4
XFILLER_16_772 VPWR VGND sg13cmos5l_fill_2
XFILLER_15_1242 VPWR VGND sg13cmos5l_decap_8
XFILLER_8_960 VPWR VGND sg13cmos5l_decap_8
X_0705_ Tile_X2Y0_N4BEG[13] _1237_/X VPWR VGND sg13cmos5l_buf_1
XFILLER_7_492 VPWR VGND sg13cmos5l_decap_8
X_0636_ _0636_/L_HI VPWR VGND sg13cmos5l_tiehi
XFILLER_8_1708 VPWR VGND sg13cmos5l_fill_2
XFILLER_6_2100 VPWR VGND sg13cmos5l_decap_8
X_0567_ NPU_ADDR3 Tile_X0Y0_UserCLK _1088_/X _0674_/L_HI VPWR VGND sg13cmos5l_dfrbpq_1
X_0498_ _0498_/Q Tile_X0Y0_FrameData[7] VGND VPWR Tile_X3Y0_FrameStrobe[2] latch
XFILLER_6_2199 VPWR VGND sg13cmos5l_fill_2
XFILLER_6_2177 VPWR VGND sg13cmos5l_decap_8
XFILLER_6_1443 VPWR VGND sg13cmos5l_decap_8
X_1119_ _1119_/X Tile_X0Y0_S4END[13] Tile_X0Y0_S4END[14] Tile_X0Y0_SS4END[13] Tile_X0Y0_SS4END[15]
+ _0117_/Q _0116_/Q VPWR VGND sg13cmos5l_mux4_1
XFILLER_13_208 VPWR VGND sg13cmos5l_decap_8
XFILLER_16_1039 VPWR VGND sg13cmos5l_fill_1
XFILLER_16_1028 VPWR VGND sg13cmos5l_decap_8
XFILLER_10_948 VPWR VGND sg13cmos5l_decap_8
XFILLER_13_1905 VPWR VGND sg13cmos5l_decap_8
XFILLER_5_429 VPWR VGND sg13cmos5l_decap_8
XFILLER_11_2396 VPWR VGND sg13cmos5l_decap_4
XFILLER_1_602 VPWR VGND sg13cmos5l_decap_8
XFILLER_2_1830 VPWR VGND sg13cmos5l_decap_8
XFILLER_9_735 VPWR VGND sg13cmos5l_fill_2
XFILLER_8_212 VPWR VGND sg13cmos5l_decap_8
XFILLER_13_764 VPWR VGND sg13cmos5l_fill_2
XFILLER_12_252 VPWR VGND sg13cmos5l_fill_1
XFILLER_16_1551 VPWR VGND sg13cmos5l_fill_2
XANTENNA__0902__X Tile_X3Y0_FrameStrobe_O[2] VPWR VGND sg13cmos5l_antennanp
XFILLER_9_779 VPWR VGND sg13cmos5l_decap_8
XFILLER_12_1459 VPWR VGND sg13cmos5l_decap_8
XFILLER_5_952 VPWR VGND sg13cmos5l_decap_8
XFILLER_5_56 VPWR VGND sg13cmos5l_decap_8
XFILLER_4_484 VPWR VGND sg13cmos5l_decap_8
X_0421_ _0421_/Q Tile_X0Y0_FrameData[20] VGND VPWR Tile_X3Y0_FrameStrobe[0] latch
X_0352_ _0352_/Q Tile_X0Y0_FrameData[25] VGND VPWR Tile_X2Y0_FrameStrobe[1] latch
XFILLER_3_2328 VPWR VGND sg13cmos5l_decap_8
X_0283_ _0283_/Q Tile_X0Y0_FrameData[14] VGND VPWR Tile_X1Y0_FrameStrobe[2] latch
XFILLER_7_1796 VPWR VGND sg13cmos5l_fill_2
XFILLER_3_1616 VPWR VGND sg13cmos5l_decap_8
XFILLER_1_2041 VPWR VGND sg13cmos5l_decap_8
XFILLER_1_1351 VPWR VGND sg13cmos5l_decap_8
XFILLER_17_2016 VPWR VGND sg13cmos5l_fill_1
XANTENNA__0812__X Tile_X4Y0_FrameData_O[16] VPWR VGND sg13cmos5l_antennanp
XFILLER_15_1083 VPWR VGND sg13cmos5l_fill_1
XFILLER_12_1982 VPWR VGND sg13cmos5l_decap_8
X_0619_ _0619_/L_HI VPWR VGND sg13cmos5l_tiehi
XFILLER_8_1538 VPWR VGND sg13cmos5l_decap_8
XANTENNA_107 Tile_X0Y0_FrameData[26] VPWR VGND sg13cmos5l_antennanp
XFILLER_2_1115 VPWR VGND sg13cmos5l_decap_8
XANTENNA_118 Tile_X0Y0_FrameData[29] VPWR VGND sg13cmos5l_antennanp
XANTENNA_129 Tile_X0Y0_FrameData[30] VPWR VGND sg13cmos5l_antennanp
XFILLER_14_21 VPWR VGND sg13cmos5l_decap_8
XFILLER_13_2403 VPWR VGND sg13cmos5l_fill_1
XANTENNA__0722__X Tile_X0Y0_FrameStrobe_O[14] VPWR VGND sg13cmos5l_antennanp
XFILLER_11_2160 VPWR VGND sg13cmos5l_decap_8
XFILLER_5_248 VPWR VGND sg13cmos5l_decap_8
XFILLER_2_933 VPWR VGND sg13cmos5l_decap_8
XFILLER_7_1015 VPWR VGND sg13cmos5l_decap_8
XFILLER_1_476 VPWR VGND sg13cmos5l_decap_8
XFILLER_4_1969 VPWR VGND sg13cmos5l_fill_2
XFILLER_2_2372 VPWR VGND sg13cmos5l_decap_8
XFILLER_17_344 VPWR VGND sg13cmos5l_fill_1
XFILLER_17_377 VPWR VGND sg13cmos5l_fill_1
XFILLER_18_2358 VPWR VGND sg13cmos5l_fill_2
XFILLER_18_1602 VPWR VGND sg13cmos5l_fill_2
XFILLER_17_399 VPWR VGND sg13cmos5l_decap_8
X_0970_ Tile_X3Y0_NN4BEG[14] _1294_/X VPWR VGND sg13cmos5l_buf_1
XFILLER_13_550 VPWR VGND sg13cmos5l_fill_2
XFILLER_9_532 VPWR VGND sg13cmos5l_decap_8
XFILLER_9_543 VPWR VGND sg13cmos5l_fill_2
XFILLER_9_587 VPWR VGND sg13cmos5l_decap_8
XFILLER_16_1370 VPWR VGND sg13cmos5l_decap_8
XFILLER_5_782 VPWR VGND sg13cmos5l_decap_8
XFILLER_9_1814 VPWR VGND sg13cmos5l_fill_2
XFILLER_9_1847 VPWR VGND sg13cmos5l_fill_2
X_0404_ _0404_/Q Tile_X0Y0_FrameData[5] VGND VPWR Tile_X2Y0_FrameStrobe[2] latch
X_0335_ _0335_/Q Tile_X0Y0_FrameData[10] VGND VPWR Tile_X2Y0_FrameStrobe[0] latch
XFILLER_3_2125 VPWR VGND sg13cmos5l_decap_8
XFILLER_3_1413 VPWR VGND sg13cmos5l_decap_8
X_0266_ _0266_/Q Tile_X0Y0_FrameData[31] VGND VPWR Tile_X1Y0_FrameStrobe[2] latch
XANTENNA__0807__X Tile_X4Y0_FrameData_O[11] VPWR VGND sg13cmos5l_antennanp
X_0197_ _0197_/Q Tile_X0Y0_FrameData[20] VGND VPWR Tile_X0Y0_FrameStrobe[3] latch
XFILLER_17_1101 VPWR VGND sg13cmos5l_decap_8
XFILLER_8_2003 VPWR VGND sg13cmos5l_decap_8
XFILLER_6_1081 VPWR VGND sg13cmos5l_decap_8
XANTENNA__0717__X Tile_X0Y0_FrameStrobe_O[9] VPWR VGND sg13cmos5l_antennanp
XFILLER_14_336 VPWR VGND sg13cmos5l_fill_1
XFILLER_17_2380 VPWR VGND sg13cmos5l_fill_2
XFILLER_10_564 VPWR VGND sg13cmos5l_fill_2
XFILLER_10_586 VPWR VGND sg13cmos5l_decap_8
XFILLER_13_2288 VPWR VGND sg13cmos5l_decap_8
XFILLER_13_1543 VPWR VGND sg13cmos5l_fill_2
XFILLER_13_1521 VPWR VGND sg13cmos5l_fill_1
XFILLER_6_568 VPWR VGND sg13cmos5l_decap_8
XFILLER_2_796 VPWR VGND sg13cmos5l_decap_8
XFILLER_2_35 VPWR VGND sg13cmos5l_decap_8
XFILLER_1_273 VPWR VGND sg13cmos5l_decap_8
X_0120_ _0120_/Q Tile_X0Y0_FrameData[1] VGND VPWR Tile_X0Y0_FrameStrobe[0] latch
XFILLER_8_1891 VPWR VGND sg13cmos5l_decap_8
XFILLER_4_1755 VPWR VGND sg13cmos5l_decap_8
XFILLER_0_1619 VPWR VGND sg13cmos5l_decap_8
XFILLER_4_1777 VPWR VGND sg13cmos5l_decap_8
XFILLER_4_1766 VPWR VGND sg13cmos5l_fill_1
XFILLER_2_2191 VPWR VGND sg13cmos5l_fill_1
XFILLER_18_2155 VPWR VGND sg13cmos5l_fill_2
XANTENNA_18 NPU_RDATA20 VPWR VGND sg13cmos5l_antennanp
XANTENNA_29 NPU_RDATA26 VPWR VGND sg13cmos5l_antennanp
X_0953_ Tile_X3Y0_N4BEG[13] _1277_/X VPWR VGND sg13cmos5l_buf_1
XFILLER_14_1329 VPWR VGND sg13cmos5l_fill_2
X_0884_ Tile_X4Y0_NN4BEG[0] Tile_X4Y0_SS4END[15] VPWR VGND sg13cmos5l_buf_1
XFILLER_5_590 VPWR VGND sg13cmos5l_decap_8
XFILLER_9_1600 VPWR VGND sg13cmos5l_decap_8
XFILLER_9_2367 VPWR VGND sg13cmos5l_decap_8
XFILLER_9_1677 VPWR VGND sg13cmos5l_decap_4
XFILLER_5_1508 VPWR VGND sg13cmos5l_decap_8
X_0318_ _0318_/Q Tile_X0Y0_FrameData[27] VGND VPWR Tile_X2Y0_FrameStrobe[0] latch
X_0249_ _0249_/Q Tile_X0Y0_FrameData[16] VGND VPWR Tile_X1Y0_FrameStrobe[1] latch
XFILLER_3_1287 VPWR VGND sg13cmos5l_decap_8
XFILLER_12_829 VPWR VGND sg13cmos5l_fill_1
XFILLER_10_2417 VPWR VGND sg13cmos5l_fill_1
XFILLER_14_1841 VPWR VGND sg13cmos5l_decap_8
XFILLER_8_1110 VPWR VGND sg13cmos5l_fill_1
XFILLER_8_1143 VPWR VGND sg13cmos5l_fill_1
XFILLER_4_1007 VPWR VGND sg13cmos5l_decap_8
XFILLER_15_2328 VPWR VGND sg13cmos5l_decap_8
XFILLER_15_1638 VPWR VGND sg13cmos5l_fill_2
XFILLER_15_1627 VPWR VGND sg13cmos5l_decap_8
XFILLER_15_1649 VPWR VGND sg13cmos5l_fill_1
XFILLER_13_2052 VPWR VGND sg13cmos5l_decap_8
XFILLER_13_1340 VPWR VGND sg13cmos5l_decap_8
XANTENNA__0910__X Tile_X3Y0_FrameStrobe_O[10] VPWR VGND sg13cmos5l_antennanp
XFILLER_13_1395 VPWR VGND sg13cmos5l_decap_8
X_1221_ _1221_/X Tile_X2Y0_S1END[1] Tile_X2Y0_S2MID[5] Tile_X2Y0_S2END[2] _0585_/Q
+ _0399_/Q _0398_/Q VPWR VGND sg13cmos5l_mux4_1
XFILLER_6_1817 VPWR VGND sg13cmos5l_fill_1
XFILLER_4_2220 VPWR VGND sg13cmos5l_decap_8
XFILLER_0_2117 VPWR VGND sg13cmos5l_decap_8
X_1152_ _1152_/X Tile_X0Y0_S2MID[0] Tile_X0Y0_S4END[7] Tile_X0Y0_SS4END[8] _0600_/Q
+ _0169_/Q _0168_/Q VPWR VGND sg13cmos5l_mux4_1
XFILLER_4_2297 VPWR VGND sg13cmos5l_decap_8
XFILLER_4_1541 VPWR VGND sg13cmos5l_decap_8
XFILLER_0_1405 VPWR VGND sg13cmos5l_decap_8
XFILLER_0_1416 VPWR VGND sg13cmos5l_fill_2
X_0103_ _0103_/Q Tile_X0Y0_FrameData[18] VGND VPWR Tile_X0Y0_FrameStrobe[0] latch
X_1083_ Tile_X2Y0_N2BEGb[7] _1223_/X VPWR VGND sg13cmos5l_buf_1
XFILLER_18_472 VPWR VGND sg13cmos5l_decap_8
XFILLER_18_1262 VPWR VGND sg13cmos5l_decap_8
X_0936_ Tile_X3Y0_N2BEGb[4] _1260_/X VPWR VGND sg13cmos5l_buf_1
XANTENNA__0820__X Tile_X4Y0_FrameData_O[24] VPWR VGND sg13cmos5l_antennanp
X_0867_ Tile_X4Y0_N2BEGb[7] Tile_X4Y0_S2END[0] VPWR VGND sg13cmos5l_buf_1
X_0798_ Tile_X4Y0_FrameData_O[2] Tile_X0Y0_FrameData[2] VPWR VGND sg13cmos5l_buf_1
XFILLER_9_2153 VPWR VGND sg13cmos5l_decap_8
XFILLER_9_1474 VPWR VGND sg13cmos5l_decap_8
XFILLER_5_1305 VPWR VGND sg13cmos5l_decap_8
XFILLER_3_1073 VPWR VGND sg13cmos5l_decap_8
XFILLER_11_114 VPWR VGND sg13cmos5l_fill_1
XFILLER_12_637 VPWR VGND sg13cmos5l_fill_2
XFILLER_11_147 VPWR VGND sg13cmos5l_fill_2
XFILLER_10_1502 VPWR VGND sg13cmos5l_decap_8
XFILLER_14_2383 VPWR VGND sg13cmos5l_decap_8
XANTENNA__0730__X Tile_X0Y0_N1BEG[2] VPWR VGND sg13cmos5l_antennanp
XFILLER_10_1546 VPWR VGND sg13cmos5l_decap_8
XFILLER_10_1568 VPWR VGND sg13cmos5l_decap_4
XFILLER_1_2415 VPWR VGND sg13cmos5l_fill_2
XFILLER_5_1872 VPWR VGND sg13cmos5l_decap_8
XFILLER_1_1736 VPWR VGND sg13cmos5l_decap_8
XFILLER_16_921 VPWR VGND sg13cmos5l_decap_8
XANTENNA__0905__X Tile_X3Y0_FrameStrobe_O[5] VPWR VGND sg13cmos5l_antennanp
XFILLER_16_998 VPWR VGND sg13cmos5l_decap_8
XFILLER_15_1413 VPWR VGND sg13cmos5l_decap_8
XFILLER_8_67 VPWR VGND sg13cmos5l_decap_8
X_0721_ Tile_X0Y0_FrameStrobe_O[13] Tile_X0Y0_FrameStrobe[13] VPWR VGND sg13cmos5l_buf_1
X_0652_ _0652_/L_HI VPWR VGND sg13cmos5l_tiehi
X_0583_ _0583_/Q Tile_X0Y0_UserCLK NPU_RDATA11 _0653_/L_HI VPWR VGND sg13cmos5l_dfrbpq_1
XFILLER_6_2337 VPWR VGND sg13cmos5l_decap_8
XFILLER_6_1625 VPWR VGND sg13cmos5l_decap_8
X_1204_ _1204_/X Tile_X1Y0_S2END[4] Tile_X1Y0_S4END[4] Tile_X1Y0_SS4END[11] _0591_/Q
+ _0257_/Q _0256_/Q VPWR VGND sg13cmos5l_mux4_1
X_1135_ _1135_/X Tile_X4Y0_S1END[2] Tile_X4Y0_S2MID[2] Tile_X4Y0_S2MID[5] Tile_X4Y0_S2END[5]
+ _0507_/Q _0512_/Q VPWR VGND sg13cmos5l_mux4_1
XFILLER_4_2094 VPWR VGND sg13cmos5l_decap_8
X_1066_ Tile_X1Y0_FrameStrobe_O[18] Tile_X1Y0_FrameStrobe[18] VPWR VGND sg13cmos5l_buf_1
XANTENNA__0815__X Tile_X4Y0_FrameData_O[19] VPWR VGND sg13cmos5l_antennanp
X_0919_ Tile_X3Y0_FrameStrobe_O[19] Tile_X3Y0_FrameStrobe[19] VPWR VGND sg13cmos5l_buf_1
XFILLER_11_1866 VPWR VGND sg13cmos5l_decap_8
XFILLER_0_316 VPWR VGND sg13cmos5l_decap_8
XFILLER_1_839 VPWR VGND sg13cmos5l_decap_8
XFILLER_9_1282 VPWR VGND sg13cmos5l_decap_8
XFILLER_5_1113 VPWR VGND sg13cmos5l_decap_8
XFILLER_17_65 VPWR VGND sg13cmos5l_fill_2
XFILLER_16_228 VPWR VGND sg13cmos5l_decap_8
XANTENNA__0725__X Tile_X0Y0_FrameStrobe_O[17] VPWR VGND sg13cmos5l_antennanp
XFILLER_0_1780 VPWR VGND sg13cmos5l_fill_2
XFILLER_9_917 VPWR VGND sg13cmos5l_decap_8
XFILLER_16_1711 VPWR VGND sg13cmos5l_decap_8
XFILLER_13_968 VPWR VGND sg13cmos5l_decap_8
XFILLER_8_405 VPWR VGND sg13cmos5l_decap_8
XFILLER_12_2309 VPWR VGND sg13cmos5l_decap_8
XFILLER_14_2180 VPWR VGND sg13cmos5l_fill_2
XFILLER_10_2055 VPWR VGND sg13cmos5l_decap_8
XFILLER_10_1376 VPWR VGND sg13cmos5l_decap_8
XFILLER_4_666 VPWR VGND sg13cmos5l_decap_8
XFILLER_3_154 VPWR VGND sg13cmos5l_decap_8
XFILLER_7_1945 VPWR VGND sg13cmos5l_decap_8
XFILLER_1_1500 VPWR VGND sg13cmos5l_decap_8
XFILLER_1_2289 VPWR VGND sg13cmos5l_decap_8
XFILLER_1_1577 VPWR VGND sg13cmos5l_decap_8
XFILLER_17_2209 VPWR VGND sg13cmos5l_decap_8
XFILLER_15_261 VPWR VGND sg13cmos5l_fill_2
XFILLER_11_1107 VPWR VGND sg13cmos5l_decap_8
X_0704_ Tile_X2Y0_N4BEG[12] _1236_/X VPWR VGND sg13cmos5l_buf_1
XFILLER_7_471 VPWR VGND sg13cmos5l_decap_8
X_0635_ _0635_/L_HI VPWR VGND sg13cmos5l_tiehi
X_0566_ NPU_ADDR2 Tile_X0Y0_UserCLK _1087_/X _0675_/L_HI VPWR VGND sg13cmos5l_dfrbpq_1
X_0497_ _0497_/Q Tile_X0Y0_FrameData[8] VGND VPWR Tile_X3Y0_FrameStrobe[2] latch
XFILLER_6_2156 VPWR VGND sg13cmos5l_decap_8
XFILLER_6_1422 VPWR VGND sg13cmos5l_decap_8
XFILLER_6_1499 VPWR VGND sg13cmos5l_decap_8
XFILLER_0_1043 VPWR VGND sg13cmos5l_decap_8
XFILLER_0_1054 VPWR VGND sg13cmos5l_fill_2
X_1118_ _1118_/X Tile_X0Y0_S4END[14] Tile_X0Y0_S4END[15] Tile_X0Y0_SS4END[12] Tile_X0Y0_SS4END[14]
+ _0119_/Q _0118_/Q VPWR VGND sg13cmos5l_mux4_1
X_1049_ Tile_X1Y0_FrameStrobe_O[1] Tile_X1Y0_FrameStrobe[1] VPWR VGND sg13cmos5l_buf_1
XFILLER_10_927 VPWR VGND sg13cmos5l_decap_8
XFILLER_11_2375 VPWR VGND sg13cmos5l_decap_8
XFILLER_0_113 VPWR VGND sg13cmos5l_decap_8
XFILLER_1_658 VPWR VGND sg13cmos5l_decap_8
XFILLER_0_168 VPWR VGND sg13cmos5l_decap_8
XFILLER_0_179 VPWR VGND sg13cmos5l_fill_2
XFILLER_17_526 VPWR VGND sg13cmos5l_decap_8
XFILLER_2_1886 VPWR VGND sg13cmos5l_decap_8
XFILLER_13_710 VPWR VGND sg13cmos5l_decap_4
XFILLER_16_2253 VPWR VGND sg13cmos5l_decap_8
XFILLER_9_758 VPWR VGND sg13cmos5l_decap_8
XFILLER_8_268 VPWR VGND sg13cmos5l_decap_4
XFILLER_16_1596 VPWR VGND sg13cmos5l_decap_8
XFILLER_16_1574 VPWR VGND sg13cmos5l_decap_4
XFILLER_12_1438 VPWR VGND sg13cmos5l_decap_8
XFILLER_5_931 VPWR VGND sg13cmos5l_decap_8
XFILLER_5_35 VPWR VGND sg13cmos5l_decap_8
XFILLER_4_463 VPWR VGND sg13cmos5l_decap_8
X_0420_ _0420_/Q Tile_X0Y0_FrameData[21] VGND VPWR Tile_X3Y0_FrameStrobe[0] latch
XFILLER_7_2410 VPWR VGND sg13cmos5l_decap_8
X_0351_ _0351_/Q Tile_X0Y0_FrameData[26] VGND VPWR Tile_X2Y0_FrameStrobe[1] latch
XFILLER_3_2307 VPWR VGND sg13cmos5l_decap_8
X_0282_ _0282_/Q Tile_X0Y0_FrameData[15] VGND VPWR Tile_X1Y0_FrameStrobe[2] latch
XFILLER_1_2020 VPWR VGND sg13cmos5l_decap_8
XFILLER_1_2097 VPWR VGND sg13cmos5l_decap_8
XFILLER_1_1330 VPWR VGND sg13cmos5l_decap_8
XFILLER_16_570 VPWR VGND sg13cmos5l_decap_4
XFILLER_15_1040 VPWR VGND sg13cmos5l_fill_2
XFILLER_12_1961 VPWR VGND sg13cmos5l_decap_8
X_0618_ _0618_/L_HI VPWR VGND sg13cmos5l_tiehi
X_0549_ NPU_WDATA25 Tile_X0Y0_UserCLK _1126_/X _0660_/L_HI VPWR VGND sg13cmos5l_dfrbpq_1
XFILLER_6_1296 VPWR VGND sg13cmos5l_decap_8
XANTENNA_108 Tile_X0Y0_FrameData[26] VPWR VGND sg13cmos5l_antennanp
XANTENNA_119 Tile_X0Y0_FrameData[29] VPWR VGND sg13cmos5l_antennanp
XFILLER_14_529 VPWR VGND sg13cmos5l_decap_8
XFILLER_17_1872 VPWR VGND sg13cmos5l_fill_1
XFILLER_10_746 VPWR VGND sg13cmos5l_decap_8
XFILLER_10_768 VPWR VGND sg13cmos5l_decap_8
XFILLER_10_779 VPWR VGND sg13cmos5l_fill_2
XFILLER_5_227 VPWR VGND sg13cmos5l_decap_8
XFILLER_2_912 VPWR VGND sg13cmos5l_decap_8
XFILLER_1_422 VPWR VGND sg13cmos5l_fill_2
XFILLER_2_989 VPWR VGND sg13cmos5l_decap_8
XFILLER_1_455 VPWR VGND sg13cmos5l_decap_8
XFILLER_4_1948 VPWR VGND sg13cmos5l_decap_8
XFILLER_2_2351 VPWR VGND sg13cmos5l_decap_8
XFILLER_18_835 VPWR VGND sg13cmos5l_decap_8
XFILLER_2_1694 VPWR VGND sg13cmos5l_decap_8
XFILLER_18_2337 VPWR VGND sg13cmos5l_decap_8
XFILLER_18_1614 VPWR VGND sg13cmos5l_decap_4
XFILLER_18_1647 VPWR VGND sg13cmos5l_fill_1
XANTENNA__0913__X Tile_X3Y0_FrameStrobe_O[13] VPWR VGND sg13cmos5l_antennanp
XFILLER_9_511 VPWR VGND sg13cmos5l_decap_8
XFILLER_16_2083 VPWR VGND sg13cmos5l_decap_4
XFILLER_16_2061 VPWR VGND sg13cmos5l_decap_8
XFILLER_13_584 VPWR VGND sg13cmos5l_fill_1
XFILLER_13_573 VPWR VGND sg13cmos5l_decap_4
XFILLER_12_1202 VPWR VGND sg13cmos5l_decap_8
XFILLER_12_1235 VPWR VGND sg13cmos5l_fill_1
XFILLER_5_761 VPWR VGND sg13cmos5l_decap_8
XFILLER_9_1826 VPWR VGND sg13cmos5l_decap_8
X_0403_ _0403_/Q Tile_X0Y0_FrameData[6] VGND VPWR Tile_X2Y0_FrameStrobe[2] latch
XFILLER_9_1859 VPWR VGND sg13cmos5l_decap_8
XFILLER_7_2284 VPWR VGND sg13cmos5l_decap_8
XFILLER_3_2104 VPWR VGND sg13cmos5l_decap_8
X_0334_ _0334_/Q Tile_X0Y0_FrameData[11] VGND VPWR Tile_X2Y0_FrameStrobe[0] latch
X_0265_ _0265_/Q Tile_X0Y0_FrameData[0] VGND VPWR Tile_X1Y0_FrameStrobe[1] latch
XFILLER_7_1583 VPWR VGND sg13cmos5l_decap_8
XFILLER_3_1469 VPWR VGND sg13cmos5l_decap_8
X_0196_ _0196_/Q Tile_X0Y0_FrameData[21] VGND VPWR Tile_X0Y0_FrameStrobe[3] latch
XFILLER_1_1171 VPWR VGND sg13cmos5l_decap_8
XANTENNA__0823__X Tile_X4Y0_FrameData_O[27] VPWR VGND sg13cmos5l_antennanp
XFILLER_17_1157 VPWR VGND sg13cmos5l_fill_1
XFILLER_17_1135 VPWR VGND sg13cmos5l_decap_8
XFILLER_8_2059 VPWR VGND sg13cmos5l_decap_8
XFILLER_8_1314 VPWR VGND sg13cmos5l_decap_8
XFILLER_6_1060 VPWR VGND sg13cmos5l_decap_8
XFILLER_3_1992 VPWR VGND sg13cmos5l_decap_8
XFILLER_15_827 VPWR VGND sg13cmos5l_fill_2
XANTENNA__0733__X Tile_X0Y0_N2BEG[1] VPWR VGND sg13cmos5l_antennanp
XFILLER_13_2212 VPWR VGND sg13cmos5l_fill_2
XFILLER_10_543 VPWR VGND sg13cmos5l_fill_2
XFILLER_17_2392 VPWR VGND sg13cmos5l_fill_2
XFILLER_13_1500 VPWR VGND sg13cmos5l_decap_4
XFILLER_13_2267 VPWR VGND sg13cmos5l_decap_8
XFILLER_6_547 VPWR VGND sg13cmos5l_decap_8
XFILLER_9_0 VPWR VGND sg13cmos5l_decap_8
XFILLER_2_775 VPWR VGND sg13cmos5l_decap_8
XFILLER_1_252 VPWR VGND sg13cmos5l_decap_8
XFILLER_4_2402 VPWR VGND sg13cmos5l_decap_8
XFILLER_2_14 VPWR VGND sg13cmos5l_decap_8
XANTENNA__0908__X Tile_X3Y0_FrameStrobe_O[8] VPWR VGND sg13cmos5l_antennanp
XFILLER_4_1734 VPWR VGND sg13cmos5l_decap_8
XFILLER_0_1609 VPWR VGND sg13cmos5l_decap_4
XFILLER_18_643 VPWR VGND sg13cmos5l_fill_2
XFILLER_18_676 VPWR VGND sg13cmos5l_fill_1
XFILLER_2_1491 VPWR VGND sg13cmos5l_decap_8
XFILLER_18_2134 VPWR VGND sg13cmos5l_decap_8
XFILLER_14_860 VPWR VGND sg13cmos5l_decap_4
XANTENNA_19 NPU_RDATA21 VPWR VGND sg13cmos5l_antennanp
X_0952_ Tile_X3Y0_N4BEG[12] _1276_/X VPWR VGND sg13cmos5l_buf_1
XFILLER_18_2189 VPWR VGND sg13cmos5l_fill_1
XFILLER_14_1308 VPWR VGND sg13cmos5l_decap_8
X_0883_ Tile_X4Y0_N4BEG[15] Tile_X4Y0_S4END[0] VPWR VGND sg13cmos5l_buf_1
XFILLER_9_396 VPWR VGND sg13cmos5l_fill_2
XFILLER_12_1043 VPWR VGND sg13cmos5l_decap_8
XFILLER_9_2346 VPWR VGND sg13cmos5l_decap_8
XFILLER_9_1689 VPWR VGND sg13cmos5l_fill_2
XANTENNA__0818__X Tile_X4Y0_FrameData_O[22] VPWR VGND sg13cmos5l_antennanp
X_0317_ _0317_/Q Tile_X0Y0_FrameData[28] VGND VPWR Tile_X2Y0_FrameStrobe[0] latch
XFILLER_7_1380 VPWR VGND sg13cmos5l_decap_8
XFILLER_3_1211 VPWR VGND sg13cmos5l_decap_8
X_0248_ _0248_/Q Tile_X0Y0_FrameData[17] VGND VPWR Tile_X1Y0_FrameStrobe[1] latch
XFILLER_3_1266 VPWR VGND sg13cmos5l_decap_8
X_0179_ _0179_/Q Tile_X0Y0_FrameData[6] VGND VPWR Tile_X0Y0_FrameStrobe[2] latch
XFILLER_14_1820 VPWR VGND sg13cmos5l_decap_8
XFILLER_2_7 VPWR VGND sg13cmos5l_decap_8
XANTENNA__0728__X Tile_X0Y0_N1BEG[0] VPWR VGND sg13cmos5l_antennanp
XFILLER_1_1929 VPWR VGND sg13cmos5l_decap_8
XFILLER_14_101 VPWR VGND sg13cmos5l_decap_4
XFILLER_15_2307 VPWR VGND sg13cmos5l_decap_8
XFILLER_14_145 VPWR VGND sg13cmos5l_fill_2
XFILLER_14_189 VPWR VGND sg13cmos5l_decap_4
XFILLER_13_2031 VPWR VGND sg13cmos5l_decap_8
XFILLER_11_830 VPWR VGND sg13cmos5l_fill_2
XFILLER_10_362 VPWR VGND sg13cmos5l_fill_2
XFILLER_7_812 VPWR VGND sg13cmos5l_decap_4
XFILLER_11_885 VPWR VGND sg13cmos5l_decap_4
XFILLER_6_333 VPWR VGND sg13cmos5l_fill_1
XFILLER_13_1374 VPWR VGND sg13cmos5l_decap_8
X_1220_ _1220_/X Tile_X2Y0_S1END[0] Tile_X2Y0_S2MID[4] Tile_X2Y0_S2END[3] _0584_/Q
+ _0401_/Q _0400_/Q VPWR VGND sg13cmos5l_mux4_1
XFILLER_2_594 VPWR VGND sg13cmos5l_decap_8
X_1151_ _1151_/X Tile_X0Y0_S2MID[7] Tile_X0Y0_S4END[8] Tile_X0Y0_SS4END[7] _0599_/Q
+ _0171_/Q _0170_/Q VPWR VGND sg13cmos5l_mux4_1
XFILLER_4_1520 VPWR VGND sg13cmos5l_decap_8
X_0102_ _0102_/Q Tile_X0Y0_FrameData[19] VGND VPWR Tile_X0Y0_FrameStrobe[0] latch
XFILLER_4_2276 VPWR VGND sg13cmos5l_decap_8
X_1082_ Tile_X2Y0_N2BEGb[6] _1222_/X VPWR VGND sg13cmos5l_buf_1
XFILLER_4_1597 VPWR VGND sg13cmos5l_decap_8
X_0935_ Tile_X3Y0_N2BEGb[3] _1259_/X VPWR VGND sg13cmos5l_buf_1
X_0866_ Tile_X4Y0_N2BEGb[6] Tile_X4Y0_S2END[1] VPWR VGND sg13cmos5l_buf_1
X_0797_ Tile_X4Y0_FrameData_O[1] Tile_X0Y0_FrameData[1] VPWR VGND sg13cmos5l_buf_1
XFILLER_9_2132 VPWR VGND sg13cmos5l_decap_8
XFILLER_9_1453 VPWR VGND sg13cmos5l_decap_8
XFILLER_3_1052 VPWR VGND sg13cmos5l_decap_8
XFILLER_0_1973 VPWR VGND sg13cmos5l_decap_4
XFILLER_16_1926 VPWR VGND sg13cmos5l_decap_8
XFILLER_7_119 VPWR VGND sg13cmos5l_decap_8
XFILLER_14_2362 VPWR VGND sg13cmos5l_decap_8
XFILLER_14_1650 VPWR VGND sg13cmos5l_decap_8
XFILLER_14_1694 VPWR VGND sg13cmos5l_decap_4
XFILLER_10_1558 VPWR VGND sg13cmos5l_decap_4
XFILLER_4_848 VPWR VGND sg13cmos5l_fill_1
XFILLER_3_336 VPWR VGND sg13cmos5l_decap_8
XFILLER_5_1851 VPWR VGND sg13cmos5l_decap_8
XFILLER_1_1715 VPWR VGND sg13cmos5l_decap_8
XFILLER_16_977 VPWR VGND sg13cmos5l_decap_8
XFILLER_15_487 VPWR VGND sg13cmos5l_decap_8
XFILLER_15_2126 VPWR VGND sg13cmos5l_decap_8
XFILLER_8_35 VPWR VGND sg13cmos5l_decap_8
XANTENNA__0921__X Tile_X3Y0_N1BEG[1] VPWR VGND sg13cmos5l_antennanp
X_0720_ Tile_X0Y0_FrameStrobe_O[12] Tile_X0Y0_FrameStrobe[12] VPWR VGND sg13cmos5l_buf_1
XFILLER_15_1469 VPWR VGND sg13cmos5l_decap_8
XFILLER_6_130 VPWR VGND sg13cmos5l_decap_8
X_0651_ _0651_/L_HI VPWR VGND sg13cmos5l_tiehi
X_0582_ _0582_/Q Tile_X0Y0_UserCLK NPU_RDATA10 _0654_/L_HI VPWR VGND sg13cmos5l_dfrbpq_1
XFILLER_6_196 VPWR VGND sg13cmos5l_decap_8
XFILLER_6_2316 VPWR VGND sg13cmos5l_decap_8
XFILLER_6_1604 VPWR VGND sg13cmos5l_decap_8
X_1203_ _1203_/X Tile_X1Y0_S2END[3] Tile_X1Y0_S4END[3] Tile_X1Y0_SS4END[12] _0588_/Q
+ _0259_/Q _0258_/Q VPWR VGND sg13cmos5l_mux4_1
XFILLER_4_2073 VPWR VGND sg13cmos5l_decap_8
X_1134_ _1134_/X Tile_X4Y0_S1END[1] Tile_X4Y0_S2MID[1] Tile_X4Y0_S2MID[6] Tile_X4Y0_S2END[6]
+ _0509_/Q _0508_/Q VPWR VGND sg13cmos5l_mux4_1
X_1065_ Tile_X1Y0_FrameStrobe_O[17] Tile_X1Y0_FrameStrobe[17] VPWR VGND sg13cmos5l_buf_1
XFILLER_4_1394 VPWR VGND sg13cmos5l_decap_8
XFILLER_18_1082 VPWR VGND sg13cmos5l_fill_1
XANTENNA__0831__X Tile_X4Y0_FrameStrobe_O[3] VPWR VGND sg13cmos5l_antennanp
XFILLER_18_1093 VPWR VGND sg13cmos5l_decap_8
X_0918_ Tile_X3Y0_FrameStrobe_O[18] Tile_X3Y0_FrameStrobe[18] VPWR VGND sg13cmos5l_buf_1
XFILLER_11_1845 VPWR VGND sg13cmos5l_decap_8
X_0849_ Tile_X4Y0_N1BEG[1] Tile_X4Y0_S1END[2] VPWR VGND sg13cmos5l_buf_1
XFILLER_1_818 VPWR VGND sg13cmos5l_decap_8
XFILLER_9_1261 VPWR VGND sg13cmos5l_decap_8
XFILLER_5_1169 VPWR VGND sg13cmos5l_decap_4
XFILLER_16_1701 VPWR VGND sg13cmos5l_fill_2
XFILLER_13_947 VPWR VGND sg13cmos5l_decap_8
XANTENNA__0741__X Tile_X0Y0_N2BEGb[1] VPWR VGND sg13cmos5l_antennanp
XFILLER_10_2034 VPWR VGND sg13cmos5l_decap_8
XFILLER_14_2192 VPWR VGND sg13cmos5l_decap_4
XFILLER_4_645 VPWR VGND sg13cmos5l_decap_8
XFILLER_3_133 VPWR VGND sg13cmos5l_decap_8
XFILLER_7_1924 VPWR VGND sg13cmos5l_decap_8
XANTENNA__0916__X Tile_X3Y0_FrameStrobe_O[16] VPWR VGND sg13cmos5l_antennanp
XFILLER_1_2268 VPWR VGND sg13cmos5l_decap_8
XFILLER_1_1556 VPWR VGND sg13cmos5l_decap_8
XFILLER_16_785 VPWR VGND sg13cmos5l_fill_2
XFILLER_15_284 VPWR VGND sg13cmos5l_decap_4
XFILLER_15_273 VPWR VGND sg13cmos5l_decap_4
XFILLER_12_980 VPWR VGND sg13cmos5l_decap_8
XFILLER_7_450 VPWR VGND sg13cmos5l_decap_8
XFILLER_8_995 VPWR VGND sg13cmos5l_decap_8
X_0703_ Tile_X2Y0_N4BEG[11] _1235_/X VPWR VGND sg13cmos5l_buf_1
X_0634_ _0634_/L_HI VPWR VGND sg13cmos5l_tiehi
X_0565_ NPU_ADDR1 Tile_X0Y0_UserCLK _1086_/X _0676_/L_HI VPWR VGND sg13cmos5l_dfrbpq_1
X_0496_ _0496_/Q Tile_X0Y0_FrameData[9] VGND VPWR Tile_X3Y0_FrameStrobe[2] latch
XFILLER_6_2135 VPWR VGND sg13cmos5l_decap_8
XFILLER_6_1401 VPWR VGND sg13cmos5l_decap_8
XFILLER_6_1478 VPWR VGND sg13cmos5l_decap_8
XFILLER_2_1309 VPWR VGND sg13cmos5l_decap_8
X_1117_ _1117_/X Tile_X0Y0_S4END[12] Tile_X0Y0_S4END[15] Tile_X0Y0_SS4END[13] Tile_X0Y0_SS4END[15]
+ _0121_/Q _0120_/Q VPWR VGND sg13cmos5l_mux4_1
XANTENNA__0826__X Tile_X4Y0_FrameData_O[30] VPWR VGND sg13cmos5l_antennanp
XFILLER_0_1022 VPWR VGND sg13cmos5l_decap_8
XFILLER_0_91 VPWR VGND sg13cmos5l_decap_8
X_1048_ Tile_X1Y0_FrameStrobe_O[0] Tile_X1Y0_FrameStrobe[0] VPWR VGND sg13cmos5l_buf_1
XFILLER_0_1099 VPWR VGND sg13cmos5l_decap_4
XFILLER_10_906 VPWR VGND sg13cmos5l_decap_8
XFILLER_16_1019 VPWR VGND sg13cmos5l_decap_4
XFILLER_11_2354 VPWR VGND sg13cmos5l_decap_8
XFILLER_1_637 VPWR VGND sg13cmos5l_decap_8
XANTENNA__0736__X Tile_X0Y0_N2BEG[4] VPWR VGND sg13cmos5l_antennanp
XFILLER_2_1865 VPWR VGND sg13cmos5l_decap_8
XANTENNA__0691__L_LO Tile_X1Y0_Co VPWR VGND sg13cmos5l_antennanp
XFILLER_16_2232 VPWR VGND sg13cmos5l_decap_8
XFILLER_16_2221 VPWR VGND sg13cmos5l_fill_1
XFILLER_13_744 VPWR VGND sg13cmos5l_fill_1
XFILLER_9_715 VPWR VGND sg13cmos5l_decap_8
XFILLER_9_726 VPWR VGND sg13cmos5l_fill_2
XFILLER_8_203 VPWR VGND sg13cmos5l_fill_2
XFILLER_16_1531 VPWR VGND sg13cmos5l_decap_8
XFILLER_13_799 VPWR VGND sg13cmos5l_decap_8
XFILLER_12_2129 VPWR VGND sg13cmos5l_decap_8
XFILLER_8_247 VPWR VGND sg13cmos5l_decap_8
XFILLER_12_1417 VPWR VGND sg13cmos5l_decap_8
XFILLER_5_910 VPWR VGND sg13cmos5l_decap_8
XFILLER_5_14 VPWR VGND sg13cmos5l_decap_8
XFILLER_4_442 VPWR VGND sg13cmos5l_decap_8
XFILLER_5_987 VPWR VGND sg13cmos5l_decap_8
XFILLER_10_1196 VPWR VGND sg13cmos5l_fill_2
X_0350_ _0350_/Q Tile_X0Y0_FrameData[27] VGND VPWR Tile_X2Y0_FrameStrobe[1] latch
X_0281_ _0281_/Q Tile_X0Y0_FrameData[16] VGND VPWR Tile_X1Y0_FrameStrobe[2] latch
XFILLER_7_1732 VPWR VGND sg13cmos5l_decap_8
XFILLER_1_2076 VPWR VGND sg13cmos5l_decap_8
XFILLER_1_1386 VPWR VGND sg13cmos5l_decap_8
XFILLER_17_2029 VPWR VGND sg13cmos5l_decap_8
XFILLER_12_1940 VPWR VGND sg13cmos5l_decap_8
XFILLER_8_2219 VPWR VGND sg13cmos5l_decap_8
XFILLER_8_2208 VPWR VGND sg13cmos5l_fill_1
X_0617_ _0617_/L_HI VPWR VGND sg13cmos5l_tiehi
X_0548_ NPU_WDATA24 Tile_X0Y0_UserCLK _1125_/X _0661_/L_HI VPWR VGND sg13cmos5l_dfrbpq_1
XFILLER_8_1518 VPWR VGND sg13cmos5l_fill_2
X_0479_ _0479_/Q Tile_X0Y0_FrameData[26] VGND VPWR Tile_X3Y0_FrameStrobe[2] latch
XANTENNA_109 Tile_X0Y0_FrameData[29] VPWR VGND sg13cmos5l_antennanp
XFILLER_14_508 VPWR VGND sg13cmos5l_decap_8
XFILLER_17_1895 VPWR VGND sg13cmos5l_decap_8
XFILLER_5_206 VPWR VGND sg13cmos5l_decap_8
XFILLER_11_1494 VPWR VGND sg13cmos5l_decap_8
XFILLER_2_968 VPWR VGND sg13cmos5l_decap_8
XFILLER_4_1927 VPWR VGND sg13cmos5l_decap_8
XFILLER_2_2330 VPWR VGND sg13cmos5l_decap_8
XFILLER_17_313 VPWR VGND sg13cmos5l_fill_1
XFILLER_2_1673 VPWR VGND sg13cmos5l_decap_8
XFILLER_18_1626 VPWR VGND sg13cmos5l_decap_4
XFILLER_16_2040 VPWR VGND sg13cmos5l_decap_8
XFILLER_13_530 VPWR VGND sg13cmos5l_decap_4
XFILLER_5_740 VPWR VGND sg13cmos5l_decap_8
XFILLER_12_1269 VPWR VGND sg13cmos5l_decap_4
XFILLER_4_294 VPWR VGND sg13cmos5l_decap_8
X_0402_ _0402_/Q Tile_X0Y0_FrameData[7] VGND VPWR Tile_X2Y0_FrameStrobe[2] latch
XFILLER_7_2263 VPWR VGND sg13cmos5l_decap_8
X_0333_ _0333_/Q Tile_X0Y0_FrameData[12] VGND VPWR Tile_X2Y0_FrameStrobe[0] latch
XFILLER_7_1562 VPWR VGND sg13cmos5l_decap_8
X_0264_ _0264_/Q Tile_X0Y0_FrameData[1] VGND VPWR Tile_X1Y0_FrameStrobe[1] latch
X_0195_ _0195_/Q Tile_X0Y0_FrameData[22] VGND VPWR Tile_X0Y0_FrameStrobe[3] latch
XFILLER_3_1448 VPWR VGND sg13cmos5l_decap_8
XFILLER_1_1150 VPWR VGND sg13cmos5l_decap_8
XFILLER_17_891 VPWR VGND sg13cmos5l_fill_2
XANTENNA__1000__X Tile_X1Y0_NN4BEG[4] VPWR VGND sg13cmos5l_antennanp
XFILLER_12_1792 VPWR VGND sg13cmos5l_decap_8
XFILLER_8_2038 VPWR VGND sg13cmos5l_decap_8
XFILLER_3_1971 VPWR VGND sg13cmos5l_decap_8
XFILLER_17_2382 VPWR VGND sg13cmos5l_fill_1
XFILLER_17_2371 VPWR VGND sg13cmos5l_decap_4
XFILLER_10_522 VPWR VGND sg13cmos5l_decap_8
XFILLER_13_2246 VPWR VGND sg13cmos5l_decap_8
XFILLER_10_566 VPWR VGND sg13cmos5l_fill_1
XFILLER_6_526 VPWR VGND sg13cmos5l_decap_8
XFILLER_13_1545 VPWR VGND sg13cmos5l_fill_1
XFILLER_13_1589 VPWR VGND sg13cmos5l_decap_4
XFILLER_2_754 VPWR VGND sg13cmos5l_decap_8
XFILLER_1_231 VPWR VGND sg13cmos5l_decap_8
XFILLER_4_1713 VPWR VGND sg13cmos5l_decap_8
XFILLER_18_611 VPWR VGND sg13cmos5l_decap_8
XFILLER_2_1470 VPWR VGND sg13cmos5l_decap_8
XFILLER_18_699 VPWR VGND sg13cmos5l_decap_8
XFILLER_18_2113 VPWR VGND sg13cmos5l_decap_8
XANTENNA__0924__X Tile_X3Y0_N2BEG[0] VPWR VGND sg13cmos5l_antennanp
XFILLER_18_2168 VPWR VGND sg13cmos5l_decap_8
X_0951_ Tile_X3Y0_N4BEG[11] _1275_/X VPWR VGND sg13cmos5l_buf_1
XFILLER_18_1456 VPWR VGND sg13cmos5l_fill_2
XFILLER_9_320 VPWR VGND sg13cmos5l_decap_8
XFILLER_18_1489 VPWR VGND sg13cmos5l_fill_1
XFILLER_13_371 VPWR VGND sg13cmos5l_decap_4
X_0882_ Tile_X4Y0_N4BEG[14] Tile_X4Y0_S4END[1] VPWR VGND sg13cmos5l_buf_1
XFILLER_12_1022 VPWR VGND sg13cmos5l_decap_8
XFILLER_9_2325 VPWR VGND sg13cmos5l_decap_8
X_0316_ _0316_/Q Tile_X0Y0_FrameData[29] VGND VPWR Tile_X2Y0_FrameStrobe[0] latch
X_0247_ _0247_/Q Tile_X0Y0_FrameData[18] VGND VPWR Tile_X1Y0_FrameStrobe[1] latch
X_0178_ _0178_/Q Tile_X0Y0_FrameData[7] VGND VPWR Tile_X0Y0_FrameStrobe[2] latch
XANTENNA__0834__X Tile_X4Y0_FrameStrobe_O[6] VPWR VGND sg13cmos5l_antennanp
XFILLER_3_529 VPWR VGND sg13cmos5l_decap_8
XFILLER_11_68 VPWR VGND sg13cmos5l_decap_4
XFILLER_1_1908 VPWR VGND sg13cmos5l_decap_8
XFILLER_15_603 VPWR VGND sg13cmos5l_fill_1
XFILLER_15_636 VPWR VGND sg13cmos5l_decap_4
XFILLER_15_614 VPWR VGND sg13cmos5l_fill_1
XANTENNA__0744__X Tile_X0Y0_N2BEGb[4] VPWR VGND sg13cmos5l_antennanp
XFILLER_15_647 VPWR VGND sg13cmos5l_decap_4
XFILLER_14_168 VPWR VGND sg13cmos5l_decap_8
XFILLER_13_2010 VPWR VGND sg13cmos5l_decap_8
XFILLER_11_842 VPWR VGND sg13cmos5l_fill_2
XFILLER_13_2087 VPWR VGND sg13cmos5l_decap_8
XFILLER_2_573 VPWR VGND sg13cmos5l_decap_8
XANTENNA__0919__X Tile_X3Y0_FrameStrobe_O[19] VPWR VGND sg13cmos5l_antennanp
XFILLER_8_2380 VPWR VGND sg13cmos5l_decap_8
X_1150_ _1150_/X Tile_X0Y0_S2MID[6] Tile_X0Y0_S4END[9] Tile_X0Y0_SS4END[6] _0598_/Q
+ _0173_/Q _0172_/Q VPWR VGND sg13cmos5l_mux4_1
XFILLER_4_2255 VPWR VGND sg13cmos5l_decap_8
X_0101_ _0101_/Q Tile_X0Y0_FrameData[20] VGND VPWR Tile_X0Y0_FrameStrobe[0] latch
X_1081_ Tile_X2Y0_N2BEGb[5] _1221_/X VPWR VGND sg13cmos5l_buf_1
XFILLER_4_1576 VPWR VGND sg13cmos5l_decap_8
XFILLER_0_1429 VPWR VGND sg13cmos5l_decap_8
X_0934_ Tile_X3Y0_N2BEGb[2] _1258_/X VPWR VGND sg13cmos5l_buf_1
XFILLER_18_1297 VPWR VGND sg13cmos5l_decap_8
XFILLER_14_1128 VPWR VGND sg13cmos5l_decap_8
XFILLER_13_190 VPWR VGND sg13cmos5l_fill_2
XFILLER_9_183 VPWR VGND sg13cmos5l_fill_2
X_0865_ Tile_X4Y0_N2BEGb[5] Tile_X4Y0_S2END[2] VPWR VGND sg13cmos5l_buf_1
X_0796_ Tile_X4Y0_FrameData_O[0] Tile_X0Y0_FrameData[0] VPWR VGND sg13cmos5l_buf_1
XFILLER_9_2111 VPWR VGND sg13cmos5l_decap_8
XFILLER_9_1432 VPWR VGND sg13cmos5l_decap_8
XANTENNA__0829__X Tile_X4Y0_FrameStrobe_O[1] VPWR VGND sg13cmos5l_antennanp
XFILLER_5_2019 VPWR VGND sg13cmos5l_decap_8
XFILLER_3_91 VPWR VGND sg13cmos5l_decap_8
X_1279_ _1279_/X Tile_X3Y0_S2MID[7] Tile_X3Y0_S4END[0] Tile_X3Y0_SS4END[15] _0579_/Q
+ _0459_/Q _0458_/Q VPWR VGND sg13cmos5l_mux4_1
XFILLER_3_1031 VPWR VGND sg13cmos5l_decap_8
XFILLER_0_1963 VPWR VGND sg13cmos5l_fill_1
XFILLER_11_105 VPWR VGND sg13cmos5l_decap_8
XFILLER_12_617 VPWR VGND sg13cmos5l_decap_4
XFILLER_16_1905 VPWR VGND sg13cmos5l_decap_8
XFILLER_12_639 VPWR VGND sg13cmos5l_fill_1
XFILLER_16_1949 VPWR VGND sg13cmos5l_decap_8
XFILLER_14_2341 VPWR VGND sg13cmos5l_decap_8
XFILLER_10_1537 VPWR VGND sg13cmos5l_decap_4
XFILLER_4_827 VPWR VGND sg13cmos5l_decap_8
XFILLER_3_315 VPWR VGND sg13cmos5l_decap_8
XANTENNA__0739__X Tile_X0Y0_N2BEG[7] VPWR VGND sg13cmos5l_antennanp
XFILLER_1_2417 VPWR VGND sg13cmos5l_fill_1
XFILLER_16_901 VPWR VGND sg13cmos5l_fill_2
XFILLER_16_956 VPWR VGND sg13cmos5l_decap_8
XFILLER_15_466 VPWR VGND sg13cmos5l_decap_8
XFILLER_15_2105 VPWR VGND sg13cmos5l_decap_8
XFILLER_8_14 VPWR VGND sg13cmos5l_decap_8
XFILLER_15_2138 VPWR VGND sg13cmos5l_decap_8
XFILLER_15_1448 VPWR VGND sg13cmos5l_decap_8
XFILLER_7_654 VPWR VGND sg13cmos5l_decap_8
X_0650_ _0650_/L_HI VPWR VGND sg13cmos5l_tiehi
XFILLER_6_175 VPWR VGND sg13cmos5l_decap_8
X_0581_ _0581_/Q Tile_X0Y0_UserCLK NPU_RDATA9 _0655_/L_HI VPWR VGND sg13cmos5l_dfrbpq_1
X_1202_ _1202_/X Tile_X1Y0_S2END[2] Tile_X1Y0_S4END[2] Tile_X1Y0_SS4END[13] _0589_/Q
+ _0261_/Q _0260_/Q VPWR VGND sg13cmos5l_mux4_1
XFILLER_4_2052 VPWR VGND sg13cmos5l_decap_8
X_1133_ _1133_/X Tile_X4Y0_S1END[0] Tile_X4Y0_S2MID[0] Tile_X4Y0_S2MID[7] Tile_X4Y0_S2END[7]
+ _0511_/Q _0510_/Q VPWR VGND sg13cmos5l_mux4_1
X_1064_ Tile_X1Y0_FrameStrobe_O[16] Tile_X1Y0_FrameStrobe[16] VPWR VGND sg13cmos5l_buf_1
XFILLER_4_1373 VPWR VGND sg13cmos5l_decap_8
XFILLER_18_282 VPWR VGND sg13cmos5l_decap_4
XFILLER_18_1050 VPWR VGND sg13cmos5l_decap_4
X_0917_ Tile_X3Y0_FrameStrobe_O[17] Tile_X3Y0_FrameStrobe[17] VPWR VGND sg13cmos5l_buf_1
XFILLER_11_1824 VPWR VGND sg13cmos5l_decap_8
XFILLER_15_1982 VPWR VGND sg13cmos5l_decap_8
XFILLER_15_1971 VPWR VGND sg13cmos5l_fill_1
X_0848_ Tile_X4Y0_N1BEG[0] Tile_X4Y0_S1END[3] VPWR VGND sg13cmos5l_buf_1
X_0779_ Tile_X0Y0_NN4BEG[15] _1175_/X VPWR VGND sg13cmos5l_buf_1
XFILLER_0_329 VPWR VGND sg13cmos5l_decap_8
XFILLER_9_1240 VPWR VGND sg13cmos5l_decap_8
XFILLER_5_1148 VPWR VGND sg13cmos5l_decap_8
XFILLER_13_926 VPWR VGND sg13cmos5l_decap_8
XFILLER_0_1793 VPWR VGND sg13cmos5l_decap_8
XFILLER_12_458 VPWR VGND sg13cmos5l_fill_2
XFILLER_16_1779 VPWR VGND sg13cmos5l_decap_8
XFILLER_10_2013 VPWR VGND sg13cmos5l_decap_8
XFILLER_4_624 VPWR VGND sg13cmos5l_decap_8
XFILLER_14_1492 VPWR VGND sg13cmos5l_decap_8
XFILLER_3_112 VPWR VGND sg13cmos5l_decap_8
XFILLER_7_1903 VPWR VGND sg13cmos5l_decap_8
XFILLER_3_189 VPWR VGND sg13cmos5l_decap_8
XFILLER_5_2383 VPWR VGND sg13cmos5l_decap_8
XFILLER_1_2247 VPWR VGND sg13cmos5l_decap_8
XFILLER_1_1535 VPWR VGND sg13cmos5l_decap_8
XANTENNA__0932__X Tile_X3Y0_N2BEGb[0] VPWR VGND sg13cmos5l_antennanp
XFILLER_8_974 VPWR VGND sg13cmos5l_decap_8
XFILLER_11_480 VPWR VGND sg13cmos5l_fill_2
X_0702_ Tile_X2Y0_N4BEG[10] _1234_/X VPWR VGND sg13cmos5l_buf_1
X_0633_ _0633_/L_HI VPWR VGND sg13cmos5l_tiehi
X_0564_ NPU_ADDR0 Tile_X0Y0_UserCLK _1085_/X _0677_/L_HI VPWR VGND sg13cmos5l_dfrbpq_1
XFILLER_6_2114 VPWR VGND sg13cmos5l_decap_8
XFILLER_3_690 VPWR VGND sg13cmos5l_decap_4
X_0495_ _0495_/Q Tile_X0Y0_FrameData[10] VGND VPWR Tile_X3Y0_FrameStrobe[2] latch
XFILLER_6_1457 VPWR VGND sg13cmos5l_decap_8
XFILLER_0_1001 VPWR VGND sg13cmos5l_decap_8
X_1116_ _1116_/X Tile_X1Y0_S4END[0] Tile_X1Y0_S4END[1] Tile_X1Y0_SS4END[0] Tile_X1Y0_SS4END[2]
+ _0203_/Q _0314_/Q VPWR VGND sg13cmos5l_mux4_1
XFILLER_0_70 VPWR VGND sg13cmos5l_decap_8
XANTENNA__1003__X Tile_X1Y0_NN4BEG[7] VPWR VGND sg13cmos5l_antennanp
XFILLER_0_1067 VPWR VGND sg13cmos5l_decap_8
X_1047_ Tile_X1Y0_N1BEG[3] Tile_X1Y0_S1END[0] VPWR VGND sg13cmos5l_buf_1
XANTENNA__0842__X Tile_X4Y0_FrameStrobe_O[14] VPWR VGND sg13cmos5l_antennanp
XFILLER_13_1919 VPWR VGND sg13cmos5l_decap_8
XFILLER_11_2333 VPWR VGND sg13cmos5l_decap_8
XFILLER_1_616 VPWR VGND sg13cmos5l_decap_8
XFILLER_0_137 VPWR VGND sg13cmos5l_decap_8
XFILLER_2_1844 VPWR VGND sg13cmos5l_decap_8
XFILLER_0_2291 VPWR VGND sg13cmos5l_decap_8
XANTENNA__0752__X Tile_X0Y0_N4BEG[4] VPWR VGND sg13cmos5l_antennanp
XFILLER_16_1510 VPWR VGND sg13cmos5l_decap_8
XFILLER_13_756 VPWR VGND sg13cmos5l_fill_1
XFILLER_16_2277 VPWR VGND sg13cmos5l_fill_2
XFILLER_12_288 VPWR VGND sg13cmos5l_fill_2
XFILLER_12_2108 VPWR VGND sg13cmos5l_decap_8
XFILLER_5_966 VPWR VGND sg13cmos5l_decap_8
XFILLER_4_421 VPWR VGND sg13cmos5l_decap_8
XFILLER_10_1186 VPWR VGND sg13cmos5l_fill_2
XFILLER_4_498 VPWR VGND sg13cmos5l_decap_8
X_0280_ _0280_/Q Tile_X0Y0_FrameData[17] VGND VPWR Tile_X1Y0_FrameStrobe[2] latch
XANTENNA__0927__X Tile_X3Y0_N2BEG[3] VPWR VGND sg13cmos5l_antennanp
XFILLER_10_7 VPWR VGND sg13cmos5l_decap_8
XFILLER_5_2180 VPWR VGND sg13cmos5l_decap_8
XFILLER_1_2055 VPWR VGND sg13cmos5l_decap_8
XFILLER_1_1365 VPWR VGND sg13cmos5l_decap_8
XFILLER_16_583 VPWR VGND sg13cmos5l_decap_8
XFILLER_8_771 VPWR VGND sg13cmos5l_fill_2
XFILLER_12_1996 VPWR VGND sg13cmos5l_decap_8
X_0616_ _0616_/L_HI VPWR VGND sg13cmos5l_tiehi
X_0547_ NPU_WDATA23 Tile_X0Y0_UserCLK _1124_/X _0680_/L_HI VPWR VGND sg13cmos5l_dfrbpq_1
XANTENNA__0837__X Tile_X4Y0_FrameStrobe_O[9] VPWR VGND sg13cmos5l_antennanp
X_0478_ _0478_/Q Tile_X0Y0_FrameData[27] VGND VPWR Tile_X3Y0_FrameStrobe[2] latch
XFILLER_6_1243 VPWR VGND sg13cmos5l_fill_2
XFILLER_6_1232 VPWR VGND sg13cmos5l_decap_4
XFILLER_2_1129 VPWR VGND sg13cmos5l_decap_8
XFILLER_14_35 VPWR VGND sg13cmos5l_decap_8
XFILLER_17_1863 VPWR VGND sg13cmos5l_decap_8
XFILLER_17_1830 VPWR VGND sg13cmos5l_decap_4
XFILLER_14_68 VPWR VGND sg13cmos5l_fill_2
XFILLER_13_1716 VPWR VGND sg13cmos5l_decap_8
XFILLER_11_2185 VPWR VGND sg13cmos5l_fill_1
XFILLER_11_2174 VPWR VGND sg13cmos5l_decap_8
XANTENNA__0521__Q NPU_READ_BANK_SEL0 VPWR VGND sg13cmos5l_antennanp
XFILLER_11_1473 VPWR VGND sg13cmos5l_decap_8
XFILLER_2_947 VPWR VGND sg13cmos5l_decap_8
XFILLER_1_424 VPWR VGND sg13cmos5l_fill_1
XFILLER_7_1029 VPWR VGND sg13cmos5l_decap_8
XFILLER_4_1906 VPWR VGND sg13cmos5l_decap_8
XANTENNA__0747__X Tile_X0Y0_N2BEGb[7] VPWR VGND sg13cmos5l_antennanp
XFILLER_18_804 VPWR VGND sg13cmos5l_decap_8
XFILLER_2_2386 VPWR VGND sg13cmos5l_decap_8
XFILLER_2_1652 VPWR VGND sg13cmos5l_decap_8
XFILLER_18_859 VPWR VGND sg13cmos5l_decap_8
XFILLER_18_1638 VPWR VGND sg13cmos5l_fill_2
XFILLER_13_542 VPWR VGND sg13cmos5l_decap_4
XFILLER_16_1351 VPWR VGND sg13cmos5l_fill_1
XFILLER_16_1340 VPWR VGND sg13cmos5l_decap_8
XFILLER_16_1384 VPWR VGND sg13cmos5l_decap_8
XFILLER_12_1226 VPWR VGND sg13cmos5l_decap_4
XFILLER_5_796 VPWR VGND sg13cmos5l_decap_8
XFILLER_4_273 VPWR VGND sg13cmos5l_decap_8
X_0401_ _0401_/Q Tile_X0Y0_FrameData[8] VGND VPWR Tile_X2Y0_FrameStrobe[2] latch
X_0332_ _0332_/Q Tile_X0Y0_FrameData[13] VGND VPWR Tile_X2Y0_FrameStrobe[0] latch
XFILLER_7_2242 VPWR VGND sg13cmos5l_decap_8
XFILLER_0_490 VPWR VGND sg13cmos5l_decap_8
XFILLER_7_1541 VPWR VGND sg13cmos5l_decap_8
XFILLER_3_2139 VPWR VGND sg13cmos5l_decap_8
X_0263_ _0263_/Q Tile_X0Y0_FrameData[2] VGND VPWR Tile_X1Y0_FrameStrobe[1] latch
XFILLER_3_1427 VPWR VGND sg13cmos5l_decap_8
X_0194_ _0194_/Q Tile_X0Y0_FrameData[23] VGND VPWR Tile_X0Y0_FrameStrobe[3] latch
XFILLER_17_1148 VPWR VGND sg13cmos5l_fill_1
XANTENNA__0690__L_LO Tile_X3Y0_Co VPWR VGND sg13cmos5l_antennanp
XFILLER_8_2017 VPWR VGND sg13cmos5l_decap_8
XFILLER_6_91 VPWR VGND sg13cmos5l_decap_8
XFILLER_8_1338 VPWR VGND sg13cmos5l_decap_8
XFILLER_6_1095 VPWR VGND sg13cmos5l_decap_8
XFILLER_3_1950 VPWR VGND sg13cmos5l_decap_8
XFILLER_15_829 VPWR VGND sg13cmos5l_fill_1
XFILLER_10_501 VPWR VGND sg13cmos5l_decap_8
XFILLER_17_2350 VPWR VGND sg13cmos5l_decap_8
XFILLER_17_2394 VPWR VGND sg13cmos5l_fill_1
XFILLER_17_1660 VPWR VGND sg13cmos5l_decap_4
XFILLER_13_2225 VPWR VGND sg13cmos5l_decap_8
XFILLER_10_556 VPWR VGND sg13cmos5l_fill_1
XFILLER_6_505 VPWR VGND sg13cmos5l_decap_8
XFILLER_2_700 VPWR VGND sg13cmos5l_decap_8
XFILLER_2_733 VPWR VGND sg13cmos5l_decap_8
XFILLER_1_210 VPWR VGND sg13cmos5l_decap_8
XFILLER_8_1872 VPWR VGND sg13cmos5l_fill_1
XFILLER_8_1861 VPWR VGND sg13cmos5l_decap_8
XFILLER_2_49 VPWR VGND sg13cmos5l_decap_8
XFILLER_18_601 VPWR VGND sg13cmos5l_decap_4
XFILLER_18_645 VPWR VGND sg13cmos5l_fill_1
XFILLER_17_111 VPWR VGND sg13cmos5l_fill_2
XFILLER_17_100 VPWR VGND sg13cmos5l_decap_8
XFILLER_2_2172 VPWR VGND sg13cmos5l_decap_8
XFILLER_17_166 VPWR VGND sg13cmos5l_decap_4
X_0950_ Tile_X3Y0_N4BEG[10] _1274_/X VPWR VGND sg13cmos5l_buf_1
XFILLER_18_1435 VPWR VGND sg13cmos5l_decap_8
XANTENNA__0940__X Tile_X3Y0_N4BEG[0] VPWR VGND sg13cmos5l_antennanp
X_0881_ Tile_X4Y0_N4BEG[13] Tile_X4Y0_S4END[2] VPWR VGND sg13cmos5l_buf_1
XFILLER_12_1001 VPWR VGND sg13cmos5l_decap_8
XFILLER_16_1192 VPWR VGND sg13cmos5l_fill_1
XFILLER_9_2304 VPWR VGND sg13cmos5l_decap_8
XFILLER_9_1614 VPWR VGND sg13cmos5l_decap_4
XFILLER_7_2083 VPWR VGND sg13cmos5l_decap_8
X_0315_ _0315_/Q Tile_X0Y0_FrameData[30] VGND VPWR Tile_X2Y0_FrameStrobe[0] latch
X_1295_ _1295_/X Tile_X3Y0_S2END[7] Tile_X3Y0_S4END[15] Tile_X3Y0_SS4END[0] _0578_/Q
+ _0427_/Q _0426_/Q VPWR VGND sg13cmos5l_mux4_1
X_0246_ _0246_/Q Tile_X0Y0_FrameData[19] VGND VPWR Tile_X1Y0_FrameStrobe[1] latch
X_0177_ _0177_/Q Tile_X0Y0_FrameData[8] VGND VPWR Tile_X0Y0_FrameStrobe[2] latch
XFILLER_11_309 VPWR VGND sg13cmos5l_decap_8
XANTENNA__1011__X Tile_X1Y0_NN4BEG[15] VPWR VGND sg13cmos5l_antennanp
XANTENNA__0850__X Tile_X4Y0_N1BEG[2] VPWR VGND sg13cmos5l_antennanp
XFILLER_11_14 VPWR VGND sg13cmos5l_decap_8
XFILLER_14_1855 VPWR VGND sg13cmos5l_fill_2
XFILLER_10_1719 VPWR VGND sg13cmos5l_decap_4
XFILLER_3_508 VPWR VGND sg13cmos5l_decap_8
XFILLER_14_1888 VPWR VGND sg13cmos5l_decap_8
XFILLER_3_1780 VPWR VGND sg13cmos5l_decap_8
XFILLER_17_2180 VPWR VGND sg13cmos5l_fill_2
XFILLER_15_1619 VPWR VGND sg13cmos5l_fill_1
XFILLER_15_1608 VPWR VGND sg13cmos5l_decap_8
XFILLER_6_302 VPWR VGND sg13cmos5l_fill_1
XFILLER_11_876 VPWR VGND sg13cmos5l_fill_2
XANTENNA__0760__X Tile_X0Y0_N4BEG[12] VPWR VGND sg13cmos5l_antennanp
XFILLER_6_324 VPWR VGND sg13cmos5l_decap_8
XFILLER_6_313 VPWR VGND sg13cmos5l_decap_8
XFILLER_13_2066 VPWR VGND sg13cmos5l_decap_8
XFILLER_13_1354 VPWR VGND sg13cmos5l_fill_2
XFILLER_2_552 VPWR VGND sg13cmos5l_decap_8
XFILLER_4_2234 VPWR VGND sg13cmos5l_decap_8
X_0100_ _0100_/Q Tile_X0Y0_FrameData[21] VGND VPWR Tile_X0Y0_FrameStrobe[0] latch
XFILLER_8_1691 VPWR VGND sg13cmos5l_decap_8
X_1080_ Tile_X2Y0_N2BEGb[4] _1220_/X VPWR VGND sg13cmos5l_buf_1
XFILLER_4_1555 VPWR VGND sg13cmos5l_decap_8
XANTENNA__0935__X Tile_X3Y0_N2BEGb[3] VPWR VGND sg13cmos5l_antennanp
XFILLER_18_1243 VPWR VGND sg13cmos5l_fill_2
X_0933_ Tile_X3Y0_N2BEGb[1] _1257_/X VPWR VGND sg13cmos5l_buf_1
XFILLER_18_1276 VPWR VGND sg13cmos5l_decap_8
X_0864_ Tile_X4Y0_N2BEGb[4] Tile_X4Y0_S2END[3] VPWR VGND sg13cmos5l_buf_1
X_0795_ Tile_X2Y0_NN4BEG[15] _1255_/X VPWR VGND sg13cmos5l_buf_1
XFILLER_9_1411 VPWR VGND sg13cmos5l_decap_8
XFILLER_9_2167 VPWR VGND sg13cmos5l_decap_8
XFILLER_9_1488 VPWR VGND sg13cmos5l_decap_8
XFILLER_5_1319 VPWR VGND sg13cmos5l_decap_8
XFILLER_3_70 VPWR VGND sg13cmos5l_decap_8
XANTENNA__1006__X Tile_X1Y0_NN4BEG[10] VPWR VGND sg13cmos5l_antennanp
XFILLER_3_1010 VPWR VGND sg13cmos5l_decap_8
X_1278_ _1278_/X Tile_X3Y0_S2MID[6] Tile_X3Y0_S4END[1] Tile_X3Y0_SS4END[14] _0578_/Q
+ _0461_/Q _0460_/Q VPWR VGND sg13cmos5l_mux4_1
XANTENNA__0845__X Tile_X4Y0_FrameStrobe_O[17] VPWR VGND sg13cmos5l_antennanp
X_0229_ _0229_/Q Tile_X0Y0_FrameData[4] VGND VPWR Tile_X1Y0_FrameStrobe[0] latch
XFILLER_3_1087 VPWR VGND sg13cmos5l_decap_8
XFILLER_0_1942 VPWR VGND sg13cmos5l_decap_8
XFILLER_11_128 VPWR VGND sg13cmos5l_decap_4
XFILLER_14_2320 VPWR VGND sg13cmos5l_decap_8
XFILLER_10_1516 VPWR VGND sg13cmos5l_decap_8
XFILLER_4_806 VPWR VGND sg13cmos5l_decap_8
XFILLER_14_1663 VPWR VGND sg13cmos5l_fill_2
XFILLER_5_1820 VPWR VGND sg13cmos5l_decap_8
XFILLER_5_1886 VPWR VGND sg13cmos5l_decap_8
XANTENNA__0755__X Tile_X0Y0_N4BEG[7] VPWR VGND sg13cmos5l_antennanp
XFILLER_16_935 VPWR VGND sg13cmos5l_decap_8
XFILLER_15_445 VPWR VGND sg13cmos5l_decap_8
XFILLER_15_1427 VPWR VGND sg13cmos5l_decap_8
XFILLER_10_161 VPWR VGND sg13cmos5l_decap_8
XFILLER_7_633 VPWR VGND sg13cmos5l_decap_8
XFILLER_10_194 VPWR VGND sg13cmos5l_decap_8
XFILLER_6_154 VPWR VGND sg13cmos5l_decap_8
X_0580_ _0580_/Q Tile_X0Y0_UserCLK NPU_RDATA8 _0657_/L_HI VPWR VGND sg13cmos5l_dfrbpq_1
X_1201_ _1201_/X Tile_X1Y0_S2END[1] Tile_X1Y0_S4END[1] Tile_X1Y0_SS4END[14] _0588_/Q
+ _0263_/Q _0262_/Q VPWR VGND sg13cmos5l_mux4_1
XFILLER_6_1639 VPWR VGND sg13cmos5l_fill_1
XFILLER_4_2031 VPWR VGND sg13cmos5l_decap_8
X_1132_ _1132_/X Tile_X0Y0_S4END[0] Tile_X0Y0_S4END[1] Tile_X0Y0_SS4END[0] Tile_X0Y0_SS4END[2]
+ _0091_/Q _0202_/Q VPWR VGND sg13cmos5l_mux4_1
XFILLER_4_1352 VPWR VGND sg13cmos5l_decap_8
X_1063_ Tile_X1Y0_FrameStrobe_O[15] Tile_X1Y0_FrameStrobe[15] VPWR VGND sg13cmos5l_buf_1
XFILLER_18_261 VPWR VGND sg13cmos5l_decap_8
XFILLER_18_1073 VPWR VGND sg13cmos5l_fill_2
X_0916_ Tile_X3Y0_FrameStrobe_O[16] Tile_X3Y0_FrameStrobe[16] VPWR VGND sg13cmos5l_buf_1
X_0847_ Tile_X4Y0_FrameStrobe_O[19] Tile_X4Y0_FrameStrobe[19] VPWR VGND sg13cmos5l_buf_1
X_0778_ Tile_X0Y0_NN4BEG[14] _1174_/X VPWR VGND sg13cmos5l_buf_1
XFILLER_9_1296 VPWR VGND sg13cmos5l_fill_2
XFILLER_5_1127 VPWR VGND sg13cmos5l_decap_8
XFILLER_17_46 VPWR VGND sg13cmos5l_decap_4
XFILLER_16_209 VPWR VGND sg13cmos5l_decap_8
XFILLER_16_1703 VPWR VGND sg13cmos5l_fill_1
XFILLER_12_437 VPWR VGND sg13cmos5l_decap_8
XFILLER_12_404 VPWR VGND sg13cmos5l_decap_4
XFILLER_8_419 VPWR VGND sg13cmos5l_decap_8
XANTENNA__0524__Q NPU_WDATA0 VPWR VGND sg13cmos5l_antennanp
XFILLER_16_1758 VPWR VGND sg13cmos5l_decap_8
XFILLER_10_2069 VPWR VGND sg13cmos5l_decap_8
XFILLER_4_603 VPWR VGND sg13cmos5l_decap_8
XFILLER_14_1471 VPWR VGND sg13cmos5l_decap_8
XFILLER_3_168 VPWR VGND sg13cmos5l_decap_8
XFILLER_7_1959 VPWR VGND sg13cmos5l_decap_8
XFILLER_5_2362 VPWR VGND sg13cmos5l_decap_8
XFILLER_1_1514 VPWR VGND sg13cmos5l_decap_8
XFILLER_16_754 VPWR VGND sg13cmos5l_decap_8
XFILLER_15_253 VPWR VGND sg13cmos5l_decap_4
XFILLER_16_798 VPWR VGND sg13cmos5l_fill_1
XFILLER_15_1235 VPWR VGND sg13cmos5l_decap_8
XFILLER_8_953 VPWR VGND sg13cmos5l_decap_8
X_0701_ Tile_X2Y0_N4BEG[9] _1233_/X VPWR VGND sg13cmos5l_buf_1
XFILLER_7_485 VPWR VGND sg13cmos5l_decap_8
X_0632_ _0632_/L_HI VPWR VGND sg13cmos5l_tiehi
X_0563_ NPU_WE7 Tile_X0Y0_UserCLK _0563_/D _0604_/L_HI VPWR VGND sg13cmos5l_dfrbpq_1
X_0494_ _0494_/Q Tile_X0Y0_FrameData[11] VGND VPWR Tile_X3Y0_FrameStrobe[2] latch
XFILLER_6_1436 VPWR VGND sg13cmos5l_decap_8
X_1115_ _1115_/X Tile_X1Y0_S4END[1] Tile_X1Y0_S4END[2] Tile_X1Y0_SS4END[1] Tile_X1Y0_SS4END[3]
+ _0205_/Q _0204_/Q VPWR VGND sg13cmos5l_mux4_1
XFILLER_4_1182 VPWR VGND sg13cmos5l_decap_8
X_1046_ Tile_X1Y0_N1BEG[2] Tile_X1Y0_S1END[1] VPWR VGND sg13cmos5l_buf_1
XFILLER_11_2312 VPWR VGND sg13cmos5l_decap_8
XFILLER_11_1655 VPWR VGND sg13cmos5l_decap_4
XFILLER_11_2389 VPWR VGND sg13cmos5l_decap_8
XFILLER_0_105 VPWR VGND sg13cmos5l_decap_4
XFILLER_0_127 VPWR VGND sg13cmos5l_decap_4
XFILLER_6_1981 VPWR VGND sg13cmos5l_decap_8
XFILLER_2_1823 VPWR VGND sg13cmos5l_decap_8
XFILLER_0_2270 VPWR VGND sg13cmos5l_decap_8
XFILLER_16_2212 VPWR VGND sg13cmos5l_fill_2
XFILLER_12_212 VPWR VGND sg13cmos5l_decap_8
XFILLER_5_945 VPWR VGND sg13cmos5l_decap_8
XFILLER_5_49 VPWR VGND sg13cmos5l_decap_8
XFILLER_4_477 VPWR VGND sg13cmos5l_decap_8
XFILLER_0_661 VPWR VGND sg13cmos5l_decap_4
XFILLER_3_1609 VPWR VGND sg13cmos5l_decap_8
XFILLER_1_2034 VPWR VGND sg13cmos5l_decap_8
XFILLER_5_1480 VPWR VGND sg13cmos5l_decap_8
XFILLER_1_1344 VPWR VGND sg13cmos5l_decap_8
XFILLER_17_2009 VPWR VGND sg13cmos5l_decap_8
XANTENNA__0943__X Tile_X3Y0_N4BEG[3] VPWR VGND sg13cmos5l_antennanp
XFILLER_7_260 VPWR VGND sg13cmos5l_decap_8
XFILLER_7_271 VPWR VGND sg13cmos5l_fill_2
XFILLER_12_1975 VPWR VGND sg13cmos5l_decap_8
X_0615_ _0615_/L_HI VPWR VGND sg13cmos5l_tiehi
X_0546_ NPU_WDATA22 Tile_X0Y0_UserCLK _1123_/X _0681_/L_HI VPWR VGND sg13cmos5l_dfrbpq_1
X_0477_ _0477_/Q Tile_X0Y0_FrameData[28] VGND VPWR Tile_X3Y0_FrameStrobe[2] latch
XFILLER_6_1277 VPWR VGND sg13cmos5l_fill_2
XFILLER_2_1108 VPWR VGND sg13cmos5l_decap_8
XANTENNA__1014__X Tile_X1Y0_N4BEG[2] VPWR VGND sg13cmos5l_antennanp
XANTENNA__0853__X Tile_X4Y0_N2BEG[1] VPWR VGND sg13cmos5l_antennanp
X_1029_ Tile_X1Y0_N2BEGb[1] _1177_/X VPWR VGND sg13cmos5l_buf_1
XFILLER_14_14 VPWR VGND sg13cmos5l_decap_8
XFILLER_17_1842 VPWR VGND sg13cmos5l_decap_8
XFILLER_13_1728 VPWR VGND sg13cmos5l_decap_4
XFILLER_11_2153 VPWR VGND sg13cmos5l_decap_8
XFILLER_11_1452 VPWR VGND sg13cmos5l_decap_8
XFILLER_2_926 VPWR VGND sg13cmos5l_decap_8
XFILLER_7_1008 VPWR VGND sg13cmos5l_decap_8
XFILLER_1_469 VPWR VGND sg13cmos5l_decap_8
XFILLER_2_2365 VPWR VGND sg13cmos5l_decap_8
XFILLER_2_1631 VPWR VGND sg13cmos5l_decap_8
XFILLER_18_849 VPWR VGND sg13cmos5l_decap_4
XANTENNA__0763__X Tile_X0Y0_N4BEG[15] VPWR VGND sg13cmos5l_antennanp
XFILLER_16_2020 VPWR VGND sg13cmos5l_decap_4
XFILLER_9_525 VPWR VGND sg13cmos5l_decap_8
XFILLER_16_2075 VPWR VGND sg13cmos5l_decap_4
XFILLER_16_1363 VPWR VGND sg13cmos5l_decap_8
XFILLER_5_775 VPWR VGND sg13cmos5l_decap_8
XFILLER_9_1807 VPWR VGND sg13cmos5l_decap_8
XFILLER_4_252 VPWR VGND sg13cmos5l_decap_8
X_0400_ _0400_/Q Tile_X0Y0_FrameData[9] VGND VPWR Tile_X2Y0_FrameStrobe[2] latch
XFILLER_7_2221 VPWR VGND sg13cmos5l_decap_8
XANTENNA__0938__X Tile_X3Y0_N2BEGb[6] VPWR VGND sg13cmos5l_antennanp
X_0331_ _0331_/Q Tile_X0Y0_FrameData[14] VGND VPWR Tile_X2Y0_FrameStrobe[0] latch
XFILLER_7_1520 VPWR VGND sg13cmos5l_decap_8
XFILLER_7_2298 VPWR VGND sg13cmos5l_decap_8
XFILLER_3_2118 VPWR VGND sg13cmos5l_decap_8
X_0262_ _0262_/Q Tile_X0Y0_FrameData[3] VGND VPWR Tile_X1Y0_FrameStrobe[1] latch
XFILLER_3_1406 VPWR VGND sg13cmos5l_decap_8
X_0193_ _0193_/Q Tile_X0Y0_FrameData[24] VGND VPWR Tile_X0Y0_FrameStrobe[3] latch
XFILLER_16_392 VPWR VGND sg13cmos5l_fill_2
XFILLER_17_1116 VPWR VGND sg13cmos5l_decap_8
XFILLER_6_70 VPWR VGND sg13cmos5l_decap_8
XANTENNA__1009__X Tile_X1Y0_NN4BEG[13] VPWR VGND sg13cmos5l_antennanp
XANTENNA__0848__X Tile_X4Y0_N1BEG[0] VPWR VGND sg13cmos5l_antennanp
XFILLER_8_1328 VPWR VGND sg13cmos5l_decap_8
X_0529_ NPU_WDATA5 Tile_X0Y0_UserCLK _1106_/X _0605_/L_HI VPWR VGND sg13cmos5l_dfrbpq_1
XFILLER_6_1074 VPWR VGND sg13cmos5l_decap_8
XANTENNA__0532__Q NPU_WDATA8 VPWR VGND sg13cmos5l_antennanp
XFILLER_10_579 VPWR VGND sg13cmos5l_decap_8
XFILLER_11_1260 VPWR VGND sg13cmos5l_decap_8
XANTENNA__0758__X Tile_X0Y0_N4BEG[10] VPWR VGND sg13cmos5l_antennanp
XFILLER_2_789 VPWR VGND sg13cmos5l_decap_8
XFILLER_1_266 VPWR VGND sg13cmos5l_decap_8
XFILLER_4_2416 VPWR VGND sg13cmos5l_fill_2
XFILLER_2_28 VPWR VGND sg13cmos5l_decap_8
XFILLER_8_1884 VPWR VGND sg13cmos5l_decap_8
XFILLER_4_1748 VPWR VGND sg13cmos5l_decap_8
XFILLER_2_2151 VPWR VGND sg13cmos5l_decap_8
XFILLER_18_635 VPWR VGND sg13cmos5l_decap_4
XFILLER_2_2184 VPWR VGND sg13cmos5l_decap_8
XFILLER_18_668 VPWR VGND sg13cmos5l_fill_1
XFILLER_18_657 VPWR VGND sg13cmos5l_fill_1
XFILLER_18_2148 VPWR VGND sg13cmos5l_decap_8
XFILLER_14_830 VPWR VGND sg13cmos5l_fill_2
X_0880_ Tile_X4Y0_N4BEG[12] Tile_X4Y0_S4END[3] VPWR VGND sg13cmos5l_buf_1
XFILLER_12_1057 VPWR VGND sg13cmos5l_decap_4
XFILLER_5_583 VPWR VGND sg13cmos5l_decap_8
XFILLER_9_1648 VPWR VGND sg13cmos5l_decap_4
XFILLER_7_2062 VPWR VGND sg13cmos5l_decap_8
X_0314_ _0314_/Q Tile_X0Y0_FrameData[31] VGND VPWR Tile_X1Y0_FrameStrobe[0] latch
X_1294_ _1294_/X Tile_X3Y0_S2END[6] Tile_X3Y0_S4END[14] Tile_X3Y0_SS4END[1] _0579_/Q
+ _0429_/Q _0428_/Q VPWR VGND sg13cmos5l_mux4_1
X_0245_ _0245_/Q Tile_X0Y0_FrameData[20] VGND VPWR Tile_X1Y0_FrameStrobe[1] latch
XFILLER_7_1394 VPWR VGND sg13cmos5l_decap_8
X_0176_ _0176_/Q Tile_X0Y0_FrameData[9] VGND VPWR Tile_X0Y0_FrameStrobe[2] latch
XFILLER_14_1834 VPWR VGND sg13cmos5l_decap_8
XFILLER_12_2281 VPWR VGND sg13cmos5l_decap_8
XFILLER_12_1591 VPWR VGND sg13cmos5l_decap_8
XANTENNA__0527__Q NPU_WDATA3 VPWR VGND sg13cmos5l_antennanp
XFILLER_17_2170 VPWR VGND sg13cmos5l_decap_4
XFILLER_11_811 VPWR VGND sg13cmos5l_fill_1
XFILLER_13_2045 VPWR VGND sg13cmos5l_decap_8
XFILLER_11_844 VPWR VGND sg13cmos5l_fill_1
XFILLER_13_1333 VPWR VGND sg13cmos5l_decap_8
XFILLER_13_1388 VPWR VGND sg13cmos5l_decap_8
XFILLER_7_0 VPWR VGND sg13cmos5l_decap_8
XFILLER_2_531 VPWR VGND sg13cmos5l_decap_8
XFILLER_4_2213 VPWR VGND sg13cmos5l_decap_8
XFILLER_4_1534 VPWR VGND sg13cmos5l_decap_8
XFILLER_18_465 VPWR VGND sg13cmos5l_decap_8
XFILLER_18_454 VPWR VGND sg13cmos5l_fill_1
XANTENNA_250 Tile_X0Y0_FrameData[18] VPWR VGND sg13cmos5l_antennanp
XFILLER_18_1222 VPWR VGND sg13cmos5l_decap_8
XFILLER_18_1211 VPWR VGND sg13cmos5l_fill_1
XANTENNA__0951__X Tile_X3Y0_N4BEG[11] VPWR VGND sg13cmos5l_antennanp
XFILLER_18_1255 VPWR VGND sg13cmos5l_decap_8
XFILLER_14_693 VPWR VGND sg13cmos5l_fill_2
XFILLER_14_682 VPWR VGND sg13cmos5l_decap_8
XFILLER_9_130 VPWR VGND sg13cmos5l_decap_8
X_0932_ Tile_X3Y0_N2BEGb[0] _1256_/X VPWR VGND sg13cmos5l_buf_1
XFILLER_14_1119 VPWR VGND sg13cmos5l_decap_4
XFILLER_14_1108 VPWR VGND sg13cmos5l_fill_1
XFILLER_13_192 VPWR VGND sg13cmos5l_fill_1
XFILLER_9_174 VPWR VGND sg13cmos5l_decap_4
X_0863_ Tile_X4Y0_N2BEGb[3] Tile_X4Y0_S2END[4] VPWR VGND sg13cmos5l_buf_1
X_0794_ Tile_X2Y0_NN4BEG[14] _1254_/X VPWR VGND sg13cmos5l_buf_1
XFILLER_6_892 VPWR VGND sg13cmos5l_decap_8
XFILLER_9_2146 VPWR VGND sg13cmos5l_decap_8
XFILLER_9_1467 VPWR VGND sg13cmos5l_decap_8
X_1277_ _1277_/X Tile_X3Y0_S2MID[5] Tile_X3Y0_S4END[2] Tile_X3Y0_SS4END[13] _0579_/Q
+ _0463_/Q _0462_/Q VPWR VGND sg13cmos5l_mux4_1
XFILLER_0_1921 VPWR VGND sg13cmos5l_decap_8
X_0228_ _0228_/Q Tile_X0Y0_FrameData[5] VGND VPWR Tile_X1Y0_FrameStrobe[0] latch
XFILLER_3_1066 VPWR VGND sg13cmos5l_decap_8
XANTENNA__1022__X Tile_X1Y0_N4BEG[10] VPWR VGND sg13cmos5l_antennanp
X_0159_ _0159_/Q Tile_X0Y0_FrameData[26] VGND VPWR Tile_X0Y0_FrameStrobe[2] latch
XANTENNA__0861__X Tile_X4Y0_N2BEGb[1] VPWR VGND sg13cmos5l_antennanp
XFILLER_14_2376 VPWR VGND sg13cmos5l_decap_8
XFILLER_0_7 VPWR VGND sg13cmos5l_decap_8
XFILLER_1_2408 VPWR VGND sg13cmos5l_decap_8
XFILLER_5_1865 VPWR VGND sg13cmos5l_decap_8
XFILLER_1_1729 VPWR VGND sg13cmos5l_decap_8
XFILLER_16_914 VPWR VGND sg13cmos5l_decap_8
XANTENNA__0771__X Tile_X0Y0_NN4BEG[7] VPWR VGND sg13cmos5l_antennanp
XFILLER_8_49 VPWR VGND sg13cmos5l_fill_1
XFILLER_15_1406 VPWR VGND sg13cmos5l_decap_8
XFILLER_10_140 VPWR VGND sg13cmos5l_decap_8
XFILLER_7_612 VPWR VGND sg13cmos5l_decap_8
XFILLER_6_144 VPWR VGND sg13cmos5l_fill_2
XFILLER_3_873 VPWR VGND sg13cmos5l_fill_1
XFILLER_2_350 VPWR VGND sg13cmos5l_decap_8
X_1200_ _1200_/X Tile_X1Y0_S2END[0] Tile_X1Y0_S4END[0] Tile_X1Y0_SS4END[15] _0589_/Q
+ _0265_/Q _0264_/Q VPWR VGND sg13cmos5l_mux4_1
XFILLER_6_1618 VPWR VGND sg13cmos5l_decap_8
XANTENNA__0946__X Tile_X3Y0_N4BEG[6] VPWR VGND sg13cmos5l_antennanp
X_1131_ _1131_/X Tile_X0Y0_S4END[1] Tile_X0Y0_S4END[2] Tile_X0Y0_SS4END[1] Tile_X0Y0_SS4END[3]
+ _0093_/Q _0092_/Q VPWR VGND sg13cmos5l_mux4_1
XFILLER_4_2087 VPWR VGND sg13cmos5l_decap_8
XFILLER_4_1331 VPWR VGND sg13cmos5l_decap_8
X_1062_ Tile_X1Y0_FrameStrobe_O[14] Tile_X1Y0_FrameStrobe[14] VPWR VGND sg13cmos5l_buf_1
XFILLER_18_240 VPWR VGND sg13cmos5l_decap_8
XFILLER_18_295 VPWR VGND sg13cmos5l_decap_8
XFILLER_18_1030 VPWR VGND sg13cmos5l_fill_2
X_0915_ Tile_X3Y0_FrameStrobe_O[15] Tile_X3Y0_FrameStrobe[15] VPWR VGND sg13cmos5l_buf_1
XFILLER_15_1951 VPWR VGND sg13cmos5l_decap_4
XFILLER_11_1859 VPWR VGND sg13cmos5l_decap_8
X_0846_ Tile_X4Y0_FrameStrobe_O[18] Tile_X4Y0_FrameStrobe[18] VPWR VGND sg13cmos5l_buf_1
X_0777_ Tile_X0Y0_NN4BEG[13] _1173_/X VPWR VGND sg13cmos5l_buf_1
XFILLER_0_309 VPWR VGND sg13cmos5l_decap_8
XANTENNA__1017__X Tile_X1Y0_N4BEG[5] VPWR VGND sg13cmos5l_antennanp
XFILLER_5_1106 VPWR VGND sg13cmos5l_decap_8
XFILLER_9_1275 VPWR VGND sg13cmos5l_decap_8
XANTENNA__0856__X Tile_X4Y0_N2BEG[4] VPWR VGND sg13cmos5l_antennanp
XFILLER_17_58 VPWR VGND sg13cmos5l_decap_4
XFILLER_0_1762 VPWR VGND sg13cmos5l_decap_8
XFILLER_14_1450 VPWR VGND sg13cmos5l_decap_8
XFILLER_10_1303 VPWR VGND sg13cmos5l_fill_1
XFILLER_10_1314 VPWR VGND sg13cmos5l_decap_8
XFILLER_10_2048 VPWR VGND sg13cmos5l_decap_8
XANTENNA__0540__Q NPU_WDATA16 VPWR VGND sg13cmos5l_antennanp
XFILLER_4_659 VPWR VGND sg13cmos5l_decap_8
XFILLER_10_1369 VPWR VGND sg13cmos5l_decap_8
XFILLER_3_147 VPWR VGND sg13cmos5l_decap_8
XFILLER_0_843 VPWR VGND sg13cmos5l_fill_1
XFILLER_7_1938 VPWR VGND sg13cmos5l_decap_8
XFILLER_5_2341 VPWR VGND sg13cmos5l_decap_8
XANTENNA__0766__X Tile_X0Y0_NN4BEG[2] VPWR VGND sg13cmos5l_antennanp
XFILLER_5_1673 VPWR VGND sg13cmos5l_fill_2
XFILLER_16_722 VPWR VGND sg13cmos5l_decap_8
XFILLER_15_210 VPWR VGND sg13cmos5l_decap_4
XFILLER_16_744 VPWR VGND sg13cmos5l_fill_2
XFILLER_8_932 VPWR VGND sg13cmos5l_decap_8
XFILLER_11_460 VPWR VGND sg13cmos5l_fill_2
X_0700_ Tile_X2Y0_N4BEG[8] _1232_/X VPWR VGND sg13cmos5l_buf_1
XFILLER_12_994 VPWR VGND sg13cmos5l_decap_8
XFILLER_11_493 VPWR VGND sg13cmos5l_decap_8
XFILLER_7_464 VPWR VGND sg13cmos5l_decap_8
X_0631_ _0631_/L_HI VPWR VGND sg13cmos5l_tiehi
X_0562_ NPU_WE6 Tile_X0Y0_UserCLK _0562_/D _0665_/L_HI VPWR VGND sg13cmos5l_dfrbpq_1
X_0493_ _0493_/Q Tile_X0Y0_FrameData[12] VGND VPWR Tile_X3Y0_FrameStrobe[2] latch
XFILLER_6_2149 VPWR VGND sg13cmos5l_decap_8
XFILLER_6_1415 VPWR VGND sg13cmos5l_decap_8
X_1114_ _1114_/X Tile_X1Y0_S4END[2] Tile_X1Y0_S4END[3] Tile_X1Y0_SS4END[0] Tile_X1Y0_SS4END[2]
+ _0207_/Q _0206_/Q VPWR VGND sg13cmos5l_mux4_1
XFILLER_4_1161 VPWR VGND sg13cmos5l_decap_8
XFILLER_0_1036 VPWR VGND sg13cmos5l_decap_8
XFILLER_4_1194 VPWR VGND sg13cmos5l_fill_2
X_1045_ Tile_X1Y0_N1BEG[1] Tile_X1Y0_S1END[2] VPWR VGND sg13cmos5l_buf_1
XFILLER_9_92 VPWR VGND sg13cmos5l_fill_2
XFILLER_11_1612 VPWR VGND sg13cmos5l_fill_1
XFILLER_11_1623 VPWR VGND sg13cmos5l_decap_4
XFILLER_11_2368 VPWR VGND sg13cmos5l_decap_8
X_0829_ Tile_X4Y0_FrameStrobe_O[1] Tile_X4Y0_FrameStrobe[1] VPWR VGND sg13cmos5l_buf_1
XFILLER_9_1094 VPWR VGND sg13cmos5l_decap_4
XFILLER_6_1960 VPWR VGND sg13cmos5l_decap_8
XFILLER_2_1802 VPWR VGND sg13cmos5l_decap_8
XFILLER_2_1879 VPWR VGND sg13cmos5l_decap_8
XANTENNA__0535__Q NPU_WDATA11 VPWR VGND sg13cmos5l_antennanp
XFILLER_0_1570 VPWR VGND sg13cmos5l_decap_8
XFILLER_13_714 VPWR VGND sg13cmos5l_fill_2
XFILLER_16_2246 VPWR VGND sg13cmos5l_decap_8
XFILLER_16_2279 VPWR VGND sg13cmos5l_fill_1
XFILLER_16_1578 VPWR VGND sg13cmos5l_fill_1
XFILLER_16_1567 VPWR VGND sg13cmos5l_decap_8
XFILLER_5_924 VPWR VGND sg13cmos5l_decap_8
XFILLER_16_1589 VPWR VGND sg13cmos5l_decap_8
XFILLER_5_28 VPWR VGND sg13cmos5l_decap_8
XFILLER_10_1144 VPWR VGND sg13cmos5l_decap_8
XFILLER_4_456 VPWR VGND sg13cmos5l_decap_8
XFILLER_10_1188 VPWR VGND sg13cmos5l_fill_1
XFILLER_7_2403 VPWR VGND sg13cmos5l_decap_8
XFILLER_7_1779 VPWR VGND sg13cmos5l_fill_1
XFILLER_1_2002 VPWR VGND sg13cmos5l_decap_8
XFILLER_1_1323 VPWR VGND sg13cmos5l_decap_8
XFILLER_18_90 VPWR VGND sg13cmos5l_fill_2
XFILLER_16_574 VPWR VGND sg13cmos5l_fill_2
XFILLER_16_563 VPWR VGND sg13cmos5l_decap_8
XFILLER_15_1033 VPWR VGND sg13cmos5l_decap_8
XFILLER_12_791 VPWR VGND sg13cmos5l_fill_2
XFILLER_15_1088 VPWR VGND sg13cmos5l_fill_1
XFILLER_15_1099 VPWR VGND sg13cmos5l_decap_8
XFILLER_12_1954 VPWR VGND sg13cmos5l_decap_8
XFILLER_10_2390 VPWR VGND sg13cmos5l_decap_8
X_0614_ _0614_/L_HI VPWR VGND sg13cmos5l_tiehi
X_0545_ NPU_WDATA21 Tile_X0Y0_UserCLK _1122_/X _0682_/L_HI VPWR VGND sg13cmos5l_dfrbpq_1
X_0476_ _0476_/Q Tile_X0Y0_FrameData[29] VGND VPWR Tile_X3Y0_FrameStrobe[2] latch
XFILLER_6_1245 VPWR VGND sg13cmos5l_fill_1
XFILLER_6_1289 VPWR VGND sg13cmos5l_decap_8
X_1028_ Tile_X1Y0_N2BEGb[0] _1176_/X VPWR VGND sg13cmos5l_buf_1
XFILLER_1_1890 VPWR VGND sg13cmos5l_fill_1
XANTENNA__1030__X Tile_X1Y0_N2BEGb[2] VPWR VGND sg13cmos5l_antennanp
XFILLER_14_59 VPWR VGND sg13cmos5l_decap_4
XFILLER_10_739 VPWR VGND sg13cmos5l_decap_8
XFILLER_11_2132 VPWR VGND sg13cmos5l_decap_8
XFILLER_11_1431 VPWR VGND sg13cmos5l_decap_8
XFILLER_1_415 VPWR VGND sg13cmos5l_decap_8
XFILLER_2_2344 VPWR VGND sg13cmos5l_decap_8
XFILLER_2_1610 VPWR VGND sg13cmos5l_decap_8
XFILLER_18_828 VPWR VGND sg13cmos5l_decap_8
XFILLER_2_1687 VPWR VGND sg13cmos5l_decap_8
XFILLER_18_1618 VPWR VGND sg13cmos5l_fill_2
XFILLER_18_1607 VPWR VGND sg13cmos5l_decap_8
XFILLER_9_504 VPWR VGND sg13cmos5l_decap_8
XFILLER_16_2054 VPWR VGND sg13cmos5l_decap_8
XFILLER_13_566 VPWR VGND sg13cmos5l_decap_8
XFILLER_9_548 VPWR VGND sg13cmos5l_fill_1
XFILLER_16_2098 VPWR VGND sg13cmos5l_decap_8
XFILLER_5_754 VPWR VGND sg13cmos5l_decap_8
XFILLER_4_231 VPWR VGND sg13cmos5l_decap_8
XFILLER_9_1819 VPWR VGND sg13cmos5l_decap_8
X_0330_ _0330_/Q Tile_X0Y0_FrameData[15] VGND VPWR Tile_X2Y0_FrameStrobe[0] latch
XFILLER_7_2277 VPWR VGND sg13cmos5l_decap_8
XFILLER_1_982 VPWR VGND sg13cmos5l_decap_8
X_0261_ _0261_/Q Tile_X0Y0_FrameData[4] VGND VPWR Tile_X1Y0_FrameStrobe[1] latch
XFILLER_7_1576 VPWR VGND sg13cmos5l_decap_8
X_0192_ _0192_/Q Tile_X0Y0_FrameData[25] VGND VPWR Tile_X0Y0_FrameStrobe[3] latch
XANTENNA__0954__X Tile_X3Y0_N4BEG[14] VPWR VGND sg13cmos5l_antennanp
XFILLER_1_1164 VPWR VGND sg13cmos5l_decap_8
XFILLER_17_883 VPWR VGND sg13cmos5l_fill_1
XFILLER_8_570 VPWR VGND sg13cmos5l_decap_8
XFILLER_12_1762 VPWR VGND sg13cmos5l_fill_2
XFILLER_12_1751 VPWR VGND sg13cmos5l_decap_8
X_0528_ NPU_WDATA4 Tile_X0Y0_UserCLK _1105_/X _0624_/L_HI VPWR VGND sg13cmos5l_dfrbpq_1
XANTENNA__1025__X Tile_X1Y0_N4BEG[13] VPWR VGND sg13cmos5l_antennanp
X_0459_ _0459_/Q Tile_X0Y0_FrameData[14] VGND VPWR Tile_X3Y0_FrameStrobe[1] latch
XFILLER_6_1053 VPWR VGND sg13cmos5l_decap_8
XANTENNA__0864__X Tile_X4Y0_N2BEGb[4] VPWR VGND sg13cmos5l_antennanp
XFILLER_3_1985 VPWR VGND sg13cmos5l_decap_8
XFILLER_10_536 VPWR VGND sg13cmos5l_decap_8
XFILLER_13_1515 VPWR VGND sg13cmos5l_fill_2
XFILLER_13_1504 VPWR VGND sg13cmos5l_fill_1
XFILLER_13_1559 VPWR VGND sg13cmos5l_fill_2
XFILLER_2_768 VPWR VGND sg13cmos5l_decap_8
XFILLER_1_245 VPWR VGND sg13cmos5l_decap_8
XFILLER_4_1727 VPWR VGND sg13cmos5l_decap_8
XFILLER_2_2130 VPWR VGND sg13cmos5l_decap_8
XFILLER_18_625 VPWR VGND sg13cmos5l_fill_2
XANTENNA__0774__X Tile_X0Y0_NN4BEG[10] VPWR VGND sg13cmos5l_antennanp
XFILLER_2_2196 VPWR VGND sg13cmos5l_decap_8
XFILLER_17_135 VPWR VGND sg13cmos5l_fill_2
XFILLER_17_113 VPWR VGND sg13cmos5l_fill_1
XFILLER_2_1484 VPWR VGND sg13cmos5l_decap_8
XFILLER_18_2127 VPWR VGND sg13cmos5l_decap_8
XFILLER_9_301 VPWR VGND sg13cmos5l_fill_1
XFILLER_16_1161 VPWR VGND sg13cmos5l_decap_8
XFILLER_12_1036 VPWR VGND sg13cmos5l_decap_8
XFILLER_5_562 VPWR VGND sg13cmos5l_decap_8
XANTENNA__0949__X Tile_X3Y0_N4BEG[9] VPWR VGND sg13cmos5l_antennanp
XFILLER_9_2339 VPWR VGND sg13cmos5l_decap_8
XFILLER_7_2041 VPWR VGND sg13cmos5l_decap_8
XFILLER_1_790 VPWR VGND sg13cmos5l_decap_8
X_0313_ _0313_/Q Tile_X0Y0_FrameData[16] VGND VPWR Tile_X1Y0_FrameStrobe[3] latch
X_1293_ _1293_/X Tile_X3Y0_S2END[5] Tile_X3Y0_S4END[13] Tile_X3Y0_SS4END[2] _0578_/Q
+ _0431_/Q _0430_/Q VPWR VGND sg13cmos5l_mux4_1
XFILLER_7_1362 VPWR VGND sg13cmos5l_decap_8
X_0244_ _0244_/Q Tile_X0Y0_FrameData[21] VGND VPWR Tile_X1Y0_FrameStrobe[1] latch
XFILLER_3_1204 VPWR VGND sg13cmos5l_decap_8
XFILLER_3_1259 VPWR VGND sg13cmos5l_decap_8
X_0175_ _0175_/Q Tile_X0Y0_FrameData[10] VGND VPWR Tile_X0Y0_FrameStrobe[2] latch
XFILLER_17_680 VPWR VGND sg13cmos5l_decap_8
XFILLER_18_1960 VPWR VGND sg13cmos5l_decap_4
XFILLER_18_1982 VPWR VGND sg13cmos5l_decap_8
XFILLER_14_1813 VPWR VGND sg13cmos5l_decap_8
XFILLER_14_1857 VPWR VGND sg13cmos5l_fill_1
XFILLER_12_2260 VPWR VGND sg13cmos5l_decap_8
XANTENNA__0859__X Tile_X4Y0_N2BEG[7] VPWR VGND sg13cmos5l_antennanp
XFILLER_14_105 VPWR VGND sg13cmos5l_fill_1
XFILLER_14_138 VPWR VGND sg13cmos5l_decap_8
XFILLER_17_2182 VPWR VGND sg13cmos5l_fill_1
XANTENNA__0543__Q NPU_WDATA19 VPWR VGND sg13cmos5l_antennanp
XFILLER_10_333 VPWR VGND sg13cmos5l_fill_1
XFILLER_7_816 VPWR VGND sg13cmos5l_fill_2
XFILLER_7_805 VPWR VGND sg13cmos5l_decap_8
XFILLER_13_2024 VPWR VGND sg13cmos5l_decap_8
XFILLER_13_1301 VPWR VGND sg13cmos5l_decap_4
XFILLER_11_889 VPWR VGND sg13cmos5l_fill_2
XFILLER_13_1367 VPWR VGND sg13cmos5l_decap_8
XFILLER_13_1356 VPWR VGND sg13cmos5l_fill_1
XANTENNA__0769__X Tile_X0Y0_NN4BEG[5] VPWR VGND sg13cmos5l_antennanp
XFILLER_2_510 VPWR VGND sg13cmos5l_decap_8
XFILLER_2_587 VPWR VGND sg13cmos5l_decap_8
XFILLER_8_2394 VPWR VGND sg13cmos5l_decap_8
XFILLER_4_2269 VPWR VGND sg13cmos5l_decap_8
XFILLER_4_1513 VPWR VGND sg13cmos5l_decap_8
XANTENNA_240 Tile_X0Y0_FrameData[18] VPWR VGND sg13cmos5l_antennanp
XANTENNA_251 Tile_X0Y0_FrameData[18] VPWR VGND sg13cmos5l_antennanp
XFILLER_2_1281 VPWR VGND sg13cmos5l_decap_8
X_0931_ Tile_X3Y0_N2BEG[7] Tile_X3Y0_S2MID[0] VPWR VGND sg13cmos5l_buf_1
XFILLER_18_1245 VPWR VGND sg13cmos5l_fill_1
XFILLER_14_672 VPWR VGND sg13cmos5l_decap_8
X_0862_ Tile_X4Y0_N2BEGb[2] Tile_X4Y0_S2END[5] VPWR VGND sg13cmos5l_buf_1
X_0793_ Tile_X2Y0_NN4BEG[13] _1253_/X VPWR VGND sg13cmos5l_buf_1
XFILLER_9_2125 VPWR VGND sg13cmos5l_decap_8
XFILLER_9_1446 VPWR VGND sg13cmos5l_decap_8
X_1276_ _1276_/X Tile_X3Y0_S2MID[4] Tile_X3Y0_S4END[3] Tile_X3Y0_SS4END[12] _0578_/Q
+ _0465_/Q _0464_/Q VPWR VGND sg13cmos5l_mux4_1
XFILLER_7_1181 VPWR VGND sg13cmos5l_fill_2
XFILLER_3_1045 VPWR VGND sg13cmos5l_decap_8
X_0227_ _0227_/Q Tile_X0Y0_FrameData[6] VGND VPWR Tile_X1Y0_FrameStrobe[0] latch
X_0158_ _0158_/Q Tile_X0Y0_FrameData[27] VGND VPWR Tile_X0Y0_FrameStrobe[2] latch
XFILLER_11_119 VPWR VGND sg13cmos5l_decap_4
X_0089_ _0557_/D _0519_/Q _1094_/X VPWR VGND sg13cmos5l_nor2b_1
XFILLER_16_1919 VPWR VGND sg13cmos5l_decap_8
XFILLER_14_2355 VPWR VGND sg13cmos5l_decap_8
XFILLER_18_1790 VPWR VGND sg13cmos5l_decap_8
XFILLER_14_1643 VPWR VGND sg13cmos5l_decap_8
XFILLER_14_1632 VPWR VGND sg13cmos5l_decap_4
XFILLER_14_1665 VPWR VGND sg13cmos5l_fill_1
XFILLER_3_329 VPWR VGND sg13cmos5l_decap_8
XFILLER_5_1844 VPWR VGND sg13cmos5l_decap_8
XANTENNA__0538__Q NPU_WDATA14 VPWR VGND sg13cmos5l_antennanp
XFILLER_1_1708 VPWR VGND sg13cmos5l_decap_8
XFILLER_15_2119 VPWR VGND sg13cmos5l_decap_8
XFILLER_8_28 VPWR VGND sg13cmos5l_decap_8
XFILLER_10_152 VPWR VGND sg13cmos5l_decap_4
XFILLER_6_112 VPWR VGND sg13cmos5l_decap_8
XFILLER_13_1120 VPWR VGND sg13cmos5l_fill_1
XFILLER_7_668 VPWR VGND sg13cmos5l_decap_4
XFILLER_6_189 VPWR VGND sg13cmos5l_decap_8
XFILLER_12_92 VPWR VGND sg13cmos5l_decap_4
XFILLER_6_2309 VPWR VGND sg13cmos5l_decap_8
XFILLER_4_2011 VPWR VGND sg13cmos5l_fill_2
X_1130_ _1130_/X Tile_X0Y0_S4END[2] Tile_X0Y0_S4END[3] Tile_X0Y0_SS4END[0] Tile_X0Y0_SS4END[2]
+ _0095_/Q _0094_/Q VPWR VGND sg13cmos5l_mux4_1
XFILLER_4_1310 VPWR VGND sg13cmos5l_decap_8
XFILLER_8_1490 VPWR VGND sg13cmos5l_decap_8
XFILLER_4_2066 VPWR VGND sg13cmos5l_decap_8
X_1061_ Tile_X1Y0_FrameStrobe_O[13] Tile_X1Y0_FrameStrobe[13] VPWR VGND sg13cmos5l_buf_1
XFILLER_4_1387 VPWR VGND sg13cmos5l_decap_8
XANTENNA__0962__X Tile_X3Y0_NN4BEG[6] VPWR VGND sg13cmos5l_antennanp
XFILLER_15_981 VPWR VGND sg13cmos5l_decap_8
XFILLER_14_480 VPWR VGND sg13cmos5l_decap_8
X_0914_ Tile_X3Y0_FrameStrobe_O[14] Tile_X3Y0_FrameStrobe[14] VPWR VGND sg13cmos5l_buf_1
XFILLER_15_1930 VPWR VGND sg13cmos5l_decap_8
X_0845_ Tile_X4Y0_FrameStrobe_O[17] Tile_X4Y0_FrameStrobe[17] VPWR VGND sg13cmos5l_buf_1
XFILLER_11_1838 VPWR VGND sg13cmos5l_decap_8
XFILLER_15_1996 VPWR VGND sg13cmos5l_decap_8
X_0776_ Tile_X0Y0_NN4BEG[12] _1172_/X VPWR VGND sg13cmos5l_buf_1
XFILLER_9_1254 VPWR VGND sg13cmos5l_decap_8
XFILLER_9_1298 VPWR VGND sg13cmos5l_fill_1
XANTENNA__1033__X Tile_X1Y0_N2BEGb[5] VPWR VGND sg13cmos5l_antennanp
X_1259_ _1259_/X Tile_X3Y0_S1END[3] Tile_X3Y0_S2MID[3] Tile_X3Y0_S2END[4] _0575_/Q
+ _0499_/Q _0498_/Q VPWR VGND sg13cmos5l_mux4_1
XFILLER_0_1730 VPWR VGND sg13cmos5l_decap_4
XANTENNA__0872__X Tile_X4Y0_N4BEG[4] VPWR VGND sg13cmos5l_antennanp
XFILLER_16_1727 VPWR VGND sg13cmos5l_decap_8
XFILLER_10_2027 VPWR VGND sg13cmos5l_decap_8
XFILLER_14_2196 VPWR VGND sg13cmos5l_fill_1
XFILLER_14_2185 VPWR VGND sg13cmos5l_decap_8
XFILLER_4_638 VPWR VGND sg13cmos5l_decap_8
XFILLER_3_126 VPWR VGND sg13cmos5l_decap_8
XFILLER_0_822 VPWR VGND sg13cmos5l_decap_8
XFILLER_0_833 VPWR VGND sg13cmos5l_fill_2
XFILLER_7_1917 VPWR VGND sg13cmos5l_decap_8
XFILLER_5_2320 VPWR VGND sg13cmos5l_decap_8
XFILLER_5_2397 VPWR VGND sg13cmos5l_decap_8
XFILLER_5_1641 VPWR VGND sg13cmos5l_decap_8
XFILLER_5_1696 VPWR VGND sg13cmos5l_decap_8
XFILLER_1_1549 VPWR VGND sg13cmos5l_decap_8
XFILLER_16_712 VPWR VGND sg13cmos5l_decap_8
XANTENNA__0782__X Tile_X2Y0_NN4BEG[2] VPWR VGND sg13cmos5l_antennanp
XFILLER_15_266 VPWR VGND sg13cmos5l_decap_8
XFILLER_15_288 VPWR VGND sg13cmos5l_fill_2
XFILLER_8_911 VPWR VGND sg13cmos5l_decap_8
XFILLER_15_1226 VPWR VGND sg13cmos5l_fill_2
XFILLER_12_973 VPWR VGND sg13cmos5l_decap_8
XFILLER_15_1259 VPWR VGND sg13cmos5l_decap_8
XFILLER_8_988 VPWR VGND sg13cmos5l_decap_8
XFILLER_7_443 VPWR VGND sg13cmos5l_decap_8
X_0630_ _0630_/L_HI VPWR VGND sg13cmos5l_tiehi
X_0561_ NPU_WE5 Tile_X0Y0_UserCLK _0561_/D _0666_/L_HI VPWR VGND sg13cmos5l_dfrbpq_1
XFILLER_10_1893 VPWR VGND sg13cmos5l_decap_8
X_0492_ _0492_/Q Tile_X0Y0_FrameData[13] VGND VPWR Tile_X3Y0_FrameStrobe[2] latch
XFILLER_6_2128 VPWR VGND sg13cmos5l_decap_8
XANTENNA__0957__X Tile_X3Y0_NN4BEG[1] VPWR VGND sg13cmos5l_antennanp
X_1113_ _1113_/X Tile_X1Y0_S4END[0] Tile_X1Y0_S4END[3] Tile_X1Y0_SS4END[1] Tile_X1Y0_SS4END[3]
+ _0209_/Q _0208_/Q VPWR VGND sg13cmos5l_mux4_1
XFILLER_4_1140 VPWR VGND sg13cmos5l_decap_8
XFILLER_0_1015 VPWR VGND sg13cmos5l_decap_8
X_1044_ Tile_X1Y0_N1BEG[0] Tile_X1Y0_S1END[3] VPWR VGND sg13cmos5l_buf_1
XANTENNA__0692__X Tile_X2Y0_N4BEG[0] VPWR VGND sg13cmos5l_antennanp
XFILLER_0_84 VPWR VGND sg13cmos5l_decap_8
XFILLER_9_71 VPWR VGND sg13cmos5l_fill_1
XFILLER_9_82 VPWR VGND sg13cmos5l_decap_8
XFILLER_11_2347 VPWR VGND sg13cmos5l_decap_8
X_0828_ Tile_X4Y0_FrameStrobe_O[0] Tile_X4Y0_FrameStrobe[0] VPWR VGND sg13cmos5l_buf_1
X_0759_ Tile_X0Y0_N4BEG[11] _1155_/X VPWR VGND sg13cmos5l_buf_1
XANTENNA__1028__X Tile_X1Y0_N2BEGb[0] VPWR VGND sg13cmos5l_antennanp
XANTENNA__0867__X Tile_X4Y0_N2BEGb[7] VPWR VGND sg13cmos5l_antennanp
XFILLER_9_1062 VPWR VGND sg13cmos5l_decap_4
XFILLER_2_1858 VPWR VGND sg13cmos5l_decap_8
XFILLER_16_2214 VPWR VGND sg13cmos5l_fill_1
XFILLER_9_708 VPWR VGND sg13cmos5l_decap_8
XFILLER_16_2225 VPWR VGND sg13cmos5l_decap_8
XFILLER_13_737 VPWR VGND sg13cmos5l_decap_8
XFILLER_16_1524 VPWR VGND sg13cmos5l_decap_8
XANTENNA__0551__Q NPU_WDATA27 VPWR VGND sg13cmos5l_antennanp
XFILLER_5_903 VPWR VGND sg13cmos5l_decap_8
XFILLER_4_435 VPWR VGND sg13cmos5l_decap_8
XFILLER_0_630 VPWR VGND sg13cmos5l_decap_8
XANTENNA__0777__X Tile_X0Y0_NN4BEG[13] VPWR VGND sg13cmos5l_antennanp
XFILLER_0_641 VPWR VGND sg13cmos5l_fill_2
XFILLER_7_1725 VPWR VGND sg13cmos5l_decap_8
XFILLER_5_2194 VPWR VGND sg13cmos5l_decap_8
XFILLER_1_2069 VPWR VGND sg13cmos5l_decap_8
XFILLER_1_1302 VPWR VGND sg13cmos5l_decap_8
XFILLER_16_531 VPWR VGND sg13cmos5l_decap_4
XFILLER_1_1379 VPWR VGND sg13cmos5l_decap_8
XFILLER_16_597 VPWR VGND sg13cmos5l_fill_2
XFILLER_8_741 VPWR VGND sg13cmos5l_fill_2
XFILLER_8_730 VPWR VGND sg13cmos5l_decap_8
XFILLER_15_1023 VPWR VGND sg13cmos5l_decap_4
XFILLER_12_1933 VPWR VGND sg13cmos5l_decap_8
X_0613_ _0613_/L_HI VPWR VGND sg13cmos5l_tiehi
X_0544_ NPU_WDATA20 Tile_X0Y0_UserCLK _1121_/X _0683_/L_HI VPWR VGND sg13cmos5l_dfrbpq_1
X_0475_ _0475_/Q Tile_X0Y0_FrameData[30] VGND VPWR Tile_X3Y0_FrameStrobe[2] latch
XFILLER_15_0 VPWR VGND sg13cmos5l_decap_8
X_1027_ Tile_X1Y0_N4BEG[15] _1199_/X VPWR VGND sg13cmos5l_buf_1
XFILLER_14_49 VPWR VGND sg13cmos5l_decap_4
XFILLER_17_1877 VPWR VGND sg13cmos5l_fill_1
XFILLER_11_2111 VPWR VGND sg13cmos5l_decap_8
XFILLER_17_1888 VPWR VGND sg13cmos5l_decap_8
XFILLER_11_1410 VPWR VGND sg13cmos5l_decap_8
XFILLER_11_1487 VPWR VGND sg13cmos5l_decap_8
XFILLER_2_2323 VPWR VGND sg13cmos5l_decap_8
XANTENNA__0546__Q NPU_WDATA22 VPWR VGND sg13cmos5l_antennanp
XFILLER_2_1666 VPWR VGND sg13cmos5l_decap_8
XFILLER_13_534 VPWR VGND sg13cmos5l_fill_1
XFILLER_13_523 VPWR VGND sg13cmos5l_decap_8
XFILLER_16_2033 VPWR VGND sg13cmos5l_decap_8
XFILLER_5_700 VPWR VGND sg13cmos5l_decap_8
XFILLER_16_1398 VPWR VGND sg13cmos5l_decap_8
XFILLER_5_733 VPWR VGND sg13cmos5l_decap_8
XFILLER_4_210 VPWR VGND sg13cmos5l_decap_8
XFILLER_4_287 VPWR VGND sg13cmos5l_decap_8
XFILLER_7_2256 VPWR VGND sg13cmos5l_decap_8
XFILLER_1_961 VPWR VGND sg13cmos5l_decap_8
XFILLER_0_460 VPWR VGND sg13cmos5l_decap_4
X_0260_ _0260_/Q Tile_X0Y0_FrameData[5] VGND VPWR Tile_X1Y0_FrameStrobe[1] latch
XFILLER_7_1555 VPWR VGND sg13cmos5l_decap_8
X_0191_ _0191_/Q Tile_X0Y0_FrameData[26] VGND VPWR Tile_X0Y0_FrameStrobe[3] latch
XFILLER_1_1143 VPWR VGND sg13cmos5l_decap_8
XFILLER_17_862 VPWR VGND sg13cmos5l_fill_2
XANTENNA__0970__X Tile_X3Y0_NN4BEG[14] VPWR VGND sg13cmos5l_antennanp
XFILLER_12_1741 VPWR VGND sg13cmos5l_fill_2
XFILLER_12_1785 VPWR VGND sg13cmos5l_decap_8
X_0527_ NPU_WDATA3 Tile_X0Y0_UserCLK _1104_/X _0625_/L_HI VPWR VGND sg13cmos5l_dfrbpq_1
X_0458_ _0458_/Q Tile_X0Y0_FrameData[15] VGND VPWR Tile_X3Y0_FrameStrobe[1] latch
XFILLER_6_1032 VPWR VGND sg13cmos5l_decap_8
X_0389_ _0389_/Q Tile_X0Y0_FrameData[20] VGND VPWR Tile_X2Y0_FrameStrobe[2] latch
XFILLER_3_1964 VPWR VGND sg13cmos5l_decap_8
XFILLER_14_309 VPWR VGND sg13cmos5l_decap_8
XANTENNA__1041__X Tile_X1Y0_N2BEG[5] VPWR VGND sg13cmos5l_antennanp
XFILLER_17_2364 VPWR VGND sg13cmos5l_decap_8
XANTENNA__0880__X Tile_X4Y0_N4BEG[12] VPWR VGND sg13cmos5l_antennanp
XFILLER_10_515 VPWR VGND sg13cmos5l_decap_8
XFILLER_17_2386 VPWR VGND sg13cmos5l_fill_2
XFILLER_17_2375 VPWR VGND sg13cmos5l_fill_2
XFILLER_17_1674 VPWR VGND sg13cmos5l_fill_2
XFILLER_13_2239 VPWR VGND sg13cmos5l_decap_8
XFILLER_6_519 VPWR VGND sg13cmos5l_decap_8
XFILLER_11_1251 VPWR VGND sg13cmos5l_decap_4
XFILLER_2_714 VPWR VGND sg13cmos5l_fill_1
XFILLER_2_747 VPWR VGND sg13cmos5l_decap_8
XFILLER_1_224 VPWR VGND sg13cmos5l_decap_8
XFILLER_4_1706 VPWR VGND sg13cmos5l_decap_8
XFILLER_2_1463 VPWR VGND sg13cmos5l_decap_8
XFILLER_18_2106 VPWR VGND sg13cmos5l_decap_8
XANTENNA__0790__X Tile_X2Y0_NN4BEG[10] VPWR VGND sg13cmos5l_antennanp
XFILLER_18_1449 VPWR VGND sg13cmos5l_decap_8
XFILLER_13_375 VPWR VGND sg13cmos5l_fill_1
XFILLER_12_1015 VPWR VGND sg13cmos5l_decap_8
XFILLER_5_541 VPWR VGND sg13cmos5l_decap_8
XFILLER_9_2318 VPWR VGND sg13cmos5l_decap_8
XFILLER_7_2020 VPWR VGND sg13cmos5l_decap_8
X_0312_ _0312_/Q Tile_X0Y0_FrameData[17] VGND VPWR Tile_X1Y0_FrameStrobe[3] latch
XFILLER_0_290 VPWR VGND sg13cmos5l_decap_8
X_1292_ _1292_/X Tile_X3Y0_S2END[4] Tile_X3Y0_S4END[12] Tile_X3Y0_SS4END[3] _0579_/Q
+ _0433_/Q _0432_/Q VPWR VGND sg13cmos5l_mux4_1
XFILLER_7_2097 VPWR VGND sg13cmos5l_decap_8
XFILLER_7_1341 VPWR VGND sg13cmos5l_decap_8
XANTENNA__0965__X Tile_X3Y0_NN4BEG[9] VPWR VGND sg13cmos5l_antennanp
X_0243_ _0243_/Q Tile_X0Y0_FrameData[22] VGND VPWR Tile_X1Y0_FrameStrobe[1] latch
X_0174_ _0174_/Q Tile_X0Y0_FrameData[11] VGND VPWR Tile_X0Y0_FrameStrobe[2] latch
XFILLER_11_28 VPWR VGND sg13cmos5l_decap_4
XFILLER_12_1582 VPWR VGND sg13cmos5l_fill_2
XANTENNA__1036__X Tile_X1Y0_N2BEG[0] VPWR VGND sg13cmos5l_antennanp
XANTENNA__0875__X Tile_X4Y0_N4BEG[7] VPWR VGND sg13cmos5l_antennanp
XFILLER_15_607 VPWR VGND sg13cmos5l_decap_8
XFILLER_3_1794 VPWR VGND sg13cmos5l_decap_8
XFILLER_15_629 VPWR VGND sg13cmos5l_decap_8
XFILLER_13_2003 VPWR VGND sg13cmos5l_decap_8
XFILLER_17_2194 VPWR VGND sg13cmos5l_decap_4
XFILLER_11_835 VPWR VGND sg13cmos5l_decap_8
XFILLER_11_1070 VPWR VGND sg13cmos5l_fill_2
XFILLER_2_566 VPWR VGND sg13cmos5l_decap_8
XFILLER_8_2373 VPWR VGND sg13cmos5l_decap_8
XANTENNA__0785__X Tile_X2Y0_NN4BEG[5] VPWR VGND sg13cmos5l_antennanp
XFILLER_4_2248 VPWR VGND sg13cmos5l_decap_8
XFILLER_4_1569 VPWR VGND sg13cmos5l_decap_8
XANTENNA_230 Tile_X0Y0_FrameData[28] VPWR VGND sg13cmos5l_antennanp
XANTENNA_241 Tile_X0Y0_FrameData[18] VPWR VGND sg13cmos5l_antennanp
XANTENNA_252 Tile_X0Y0_FrameData[18] VPWR VGND sg13cmos5l_antennanp
XFILLER_2_1260 VPWR VGND sg13cmos5l_decap_8
XFILLER_18_1202 VPWR VGND sg13cmos5l_decap_8
X_0930_ Tile_X3Y0_N2BEG[6] Tile_X3Y0_S2MID[1] VPWR VGND sg13cmos5l_buf_1
XFILLER_13_183 VPWR VGND sg13cmos5l_decap_8
X_0861_ Tile_X4Y0_N2BEGb[1] Tile_X4Y0_S2END[6] VPWR VGND sg13cmos5l_buf_1
X_0792_ Tile_X2Y0_NN4BEG[12] _1252_/X VPWR VGND sg13cmos5l_buf_1
XFILLER_13_1891 VPWR VGND sg13cmos5l_decap_8
XFILLER_9_2104 VPWR VGND sg13cmos5l_decap_8
XFILLER_9_1425 VPWR VGND sg13cmos5l_decap_8
XANTENNA__0695__X Tile_X2Y0_N4BEG[3] VPWR VGND sg13cmos5l_antennanp
X_1275_ _1275_/X Tile_X3Y0_S2MID[3] Tile_X3Y0_S4END[4] Tile_X3Y0_SS4END[11] _0577_/Q
+ _0467_/Q _0466_/Q VPWR VGND sg13cmos5l_mux4_1
XFILLER_3_84 VPWR VGND sg13cmos5l_decap_8
X_0226_ _0226_/Q Tile_X0Y0_FrameData[7] VGND VPWR Tile_X1Y0_FrameStrobe[0] latch
XFILLER_7_1193 VPWR VGND sg13cmos5l_decap_4
XFILLER_3_1024 VPWR VGND sg13cmos5l_decap_8
XFILLER_0_1956 VPWR VGND sg13cmos5l_decap_8
X_0157_ _0157_/Q Tile_X0Y0_FrameData[28] VGND VPWR Tile_X0Y0_FrameStrobe[2] latch
XFILLER_0_1989 VPWR VGND sg13cmos5l_decap_4
X_0088_ _0559_/D _0517_/Q _1096_/X VPWR VGND sg13cmos5l_nor2b_1
XFILLER_14_2334 VPWR VGND sg13cmos5l_decap_8
XFILLER_18_1780 VPWR VGND sg13cmos5l_decap_4
XFILLER_3_308 VPWR VGND sg13cmos5l_decap_8
XFILLER_12_2080 VPWR VGND sg13cmos5l_decap_8
XFILLER_9_1992 VPWR VGND sg13cmos5l_decap_8
XFILLER_5_1834 VPWR VGND sg13cmos5l_decap_4
XFILLER_16_949 VPWR VGND sg13cmos5l_decap_8
XFILLER_15_404 VPWR VGND sg13cmos5l_decap_8
XFILLER_15_459 VPWR VGND sg13cmos5l_decap_8
XANTENNA__0554__Q NPU_WDATA30 VPWR VGND sg13cmos5l_antennanp
XFILLER_11_665 VPWR VGND sg13cmos5l_decap_4
XFILLER_6_168 VPWR VGND sg13cmos5l_decap_8
XFILLER_6_146 VPWR VGND sg13cmos5l_fill_1
XFILLER_13_1154 VPWR VGND sg13cmos5l_decap_4
XFILLER_13_1187 VPWR VGND sg13cmos5l_decap_4
XFILLER_12_82 VPWR VGND sg13cmos5l_decap_4
XFILLER_8_2192 VPWR VGND sg13cmos5l_decap_4
XFILLER_4_2045 VPWR VGND sg13cmos5l_decap_8
X_1060_ Tile_X1Y0_FrameStrobe_O[12] Tile_X1Y0_FrameStrobe[12] VPWR VGND sg13cmos5l_buf_1
XFILLER_4_1366 VPWR VGND sg13cmos5l_decap_8
XFILLER_18_286 VPWR VGND sg13cmos5l_fill_2
XFILLER_18_275 VPWR VGND sg13cmos5l_fill_2
XFILLER_18_1010 VPWR VGND sg13cmos5l_fill_1
XFILLER_15_960 VPWR VGND sg13cmos5l_decap_8
XFILLER_18_1054 VPWR VGND sg13cmos5l_fill_2
XFILLER_18_1043 VPWR VGND sg13cmos5l_decap_8
XFILLER_18_1032 VPWR VGND sg13cmos5l_fill_1
X_0913_ Tile_X3Y0_FrameStrobe_O[13] Tile_X3Y0_FrameStrobe[13] VPWR VGND sg13cmos5l_buf_1
X_0844_ Tile_X4Y0_FrameStrobe_O[16] Tile_X4Y0_FrameStrobe[16] VPWR VGND sg13cmos5l_buf_1
XFILLER_15_1975 VPWR VGND sg13cmos5l_decap_8
XFILLER_15_1964 VPWR VGND sg13cmos5l_decap_8
X_0775_ Tile_X0Y0_NN4BEG[11] _1171_/X VPWR VGND sg13cmos5l_buf_1
XFILLER_9_1200 VPWR VGND sg13cmos5l_decap_8
XFILLER_9_1211 VPWR VGND sg13cmos5l_fill_1
XFILLER_9_1233 VPWR VGND sg13cmos5l_decap_8
X_1258_ _1258_/X Tile_X3Y0_S1END[2] Tile_X3Y0_S2MID[2] Tile_X3Y0_S2END[5] _0574_/Q
+ _0501_/Q _0500_/Q VPWR VGND sg13cmos5l_mux4_1
X_0209_ _0209_/Q Tile_X0Y0_FrameData[24] VGND VPWR Tile_X1Y0_FrameStrobe[0] latch
X_1189_ _1189_/X Tile_X1Y0_S2MID[5] Tile_X1Y0_S4END[10] Tile_X1Y0_SS4END[5] _0591_/Q
+ _0287_/Q _0286_/Q VPWR VGND sg13cmos5l_mux4_1
XFILLER_0_1753 VPWR VGND sg13cmos5l_decap_4
XFILLER_0_1786 VPWR VGND sg13cmos5l_decap_8
XFILLER_10_2006 VPWR VGND sg13cmos5l_decap_8
XFILLER_4_617 VPWR VGND sg13cmos5l_decap_8
XFILLER_14_1485 VPWR VGND sg13cmos5l_decap_8
XFILLER_3_105 VPWR VGND sg13cmos5l_decap_8
XANTENNA__0549__Q NPU_WDATA25 VPWR VGND sg13cmos5l_antennanp
XFILLER_5_2376 VPWR VGND sg13cmos5l_decap_8
XFILLER_5_1620 VPWR VGND sg13cmos5l_decap_8
XFILLER_1_1528 VPWR VGND sg13cmos5l_decap_8
XFILLER_16_746 VPWR VGND sg13cmos5l_fill_1
XFILLER_12_952 VPWR VGND sg13cmos5l_decap_8
XFILLER_7_422 VPWR VGND sg13cmos5l_decap_8
XFILLER_15_1249 VPWR VGND sg13cmos5l_fill_2
XFILLER_11_473 VPWR VGND sg13cmos5l_decap_8
XFILLER_11_462 VPWR VGND sg13cmos5l_fill_1
XFILLER_8_967 VPWR VGND sg13cmos5l_decap_8
XFILLER_7_499 VPWR VGND sg13cmos5l_decap_8
XFILLER_10_1872 VPWR VGND sg13cmos5l_decap_8
X_0560_ NPU_WE4 Tile_X0Y0_UserCLK _0560_/D _0667_/L_HI VPWR VGND sg13cmos5l_dfrbpq_1
X_0491_ _0491_/Q Tile_X0Y0_FrameData[14] VGND VPWR Tile_X3Y0_FrameStrobe[2] latch
XFILLER_6_2107 VPWR VGND sg13cmos5l_decap_8
XFILLER_3_683 VPWR VGND sg13cmos5l_decap_8
XFILLER_2_182 VPWR VGND sg13cmos5l_decap_8
X_1112_ _1112_/X Tile_X1Y0_S4END[4] Tile_X1Y0_S4END[5] Tile_X1Y0_SS4END[4] Tile_X1Y0_SS4END[6]
+ _0211_/Q _0210_/Q VPWR VGND sg13cmos5l_mux4_1
XANTENNA__0973__X Tile_X2Y0_FrameStrobe_O[1] VPWR VGND sg13cmos5l_antennanp
X_1043_ Tile_X1Y0_N2BEG[7] Tile_X1Y0_S2MID[0] VPWR VGND sg13cmos5l_buf_1
XFILLER_0_63 VPWR VGND sg13cmos5l_decap_8
XFILLER_4_1196 VPWR VGND sg13cmos5l_fill_1
XFILLER_15_790 VPWR VGND sg13cmos5l_decap_8
XFILLER_9_94 VPWR VGND sg13cmos5l_fill_1
XFILLER_11_2326 VPWR VGND sg13cmos5l_decap_8
XFILLER_15_1761 VPWR VGND sg13cmos5l_fill_1
X_0827_ Tile_X4Y0_FrameData_O[31] Tile_X0Y0_FrameData[31] VPWR VGND sg13cmos5l_buf_1
X_0758_ Tile_X0Y0_N4BEG[10] _1154_/X VPWR VGND sg13cmos5l_buf_1
XFILLER_1_609 VPWR VGND sg13cmos5l_decap_8
X_0689_ Tile_X4Y0_Co VPWR VGND sg13cmos5l_tielo
XFILLER_9_1041 VPWR VGND sg13cmos5l_decap_8
XANTENNA__1044__X Tile_X1Y0_N1BEG[0] VPWR VGND sg13cmos5l_antennanp
XANTENNA__0883__X Tile_X4Y0_N4BEG[15] VPWR VGND sg13cmos5l_antennanp
XFILLER_6_1995 VPWR VGND sg13cmos5l_decap_8
XFILLER_2_1837 VPWR VGND sg13cmos5l_decap_8
XFILLER_0_2284 VPWR VGND sg13cmos5l_decap_8
XFILLER_0_1561 VPWR VGND sg13cmos5l_decap_4
XFILLER_16_1503 VPWR VGND sg13cmos5l_decap_8
XFILLER_12_248 VPWR VGND sg13cmos5l_decap_4
XFILLER_8_219 VPWR VGND sg13cmos5l_decap_8
XFILLER_4_414 VPWR VGND sg13cmos5l_decap_8
XFILLER_5_959 VPWR VGND sg13cmos5l_decap_8
XFILLER_10_1179 VPWR VGND sg13cmos5l_decap_8
XFILLER_5_2173 VPWR VGND sg13cmos5l_decap_8
XANTENNA__0793__X Tile_X2Y0_NN4BEG[13] VPWR VGND sg13cmos5l_antennanp
XFILLER_5_1494 VPWR VGND sg13cmos5l_decap_8
XFILLER_1_2048 VPWR VGND sg13cmos5l_decap_8
XFILLER_1_1358 VPWR VGND sg13cmos5l_decap_8
XFILLER_16_510 VPWR VGND sg13cmos5l_decap_8
XFILLER_15_1002 VPWR VGND sg13cmos5l_decap_8
XFILLER_8_764 VPWR VGND sg13cmos5l_decap_8
XFILLER_15_1079 VPWR VGND sg13cmos5l_decap_4
XFILLER_12_1912 VPWR VGND sg13cmos5l_decap_8
X_0612_ _0612_/L_HI VPWR VGND sg13cmos5l_tiehi
XFILLER_12_1989 VPWR VGND sg13cmos5l_decap_8
XANTENNA__0968__X Tile_X3Y0_NN4BEG[12] VPWR VGND sg13cmos5l_antennanp
X_0543_ NPU_WDATA19 Tile_X0Y0_UserCLK _1120_/X _0684_/L_HI VPWR VGND sg13cmos5l_dfrbpq_1
XFILLER_3_480 VPWR VGND sg13cmos5l_decap_8
X_0474_ _0474_/Q Tile_X0Y0_FrameData[31] VGND VPWR Tile_X3Y0_FrameStrobe[2] latch
XFILLER_6_1225 VPWR VGND sg13cmos5l_decap_8
X_1026_ Tile_X1Y0_N4BEG[14] _1198_/X VPWR VGND sg13cmos5l_buf_1
XFILLER_17_1834 VPWR VGND sg13cmos5l_fill_1
XFILLER_17_1823 VPWR VGND sg13cmos5l_decap_8
XFILLER_14_28 VPWR VGND sg13cmos5l_decap_8
XFILLER_17_1856 VPWR VGND sg13cmos5l_decap_8
XFILLER_13_1709 VPWR VGND sg13cmos5l_decap_8
XFILLER_11_2167 VPWR VGND sg13cmos5l_decap_8
XANTENNA__1039__X Tile_X1Y0_N2BEG[3] VPWR VGND sg13cmos5l_antennanp
XFILLER_11_1466 VPWR VGND sg13cmos5l_decap_8
XFILLER_11_2189 VPWR VGND sg13cmos5l_decap_8
XANTENNA__0878__X Tile_X4Y0_N4BEG[10] VPWR VGND sg13cmos5l_antennanp
XFILLER_2_2302 VPWR VGND sg13cmos5l_decap_8
XFILLER_2_2379 VPWR VGND sg13cmos5l_decap_8
XFILLER_2_1645 VPWR VGND sg13cmos5l_decap_8
XFILLER_0_1380 VPWR VGND sg13cmos5l_decap_8
XFILLER_16_2001 VPWR VGND sg13cmos5l_decap_8
XFILLER_13_502 VPWR VGND sg13cmos5l_decap_8
XFILLER_13_546 VPWR VGND sg13cmos5l_fill_1
XANTENNA__0562__Q NPU_WE6 VPWR VGND sg13cmos5l_antennanp
XFILLER_9_539 VPWR VGND sg13cmos5l_decap_4
XFILLER_16_1333 VPWR VGND sg13cmos5l_decap_8
XFILLER_16_1377 VPWR VGND sg13cmos5l_decap_8
XFILLER_12_1219 VPWR VGND sg13cmos5l_decap_8
XFILLER_5_789 VPWR VGND sg13cmos5l_decap_8
XFILLER_4_266 VPWR VGND sg13cmos5l_decap_8
XANTENNA__0788__X Tile_X2Y0_NN4BEG[8] VPWR VGND sg13cmos5l_antennanp
XFILLER_7_2235 VPWR VGND sg13cmos5l_decap_8
XFILLER_0_450 VPWR VGND sg13cmos5l_decap_8
XFILLER_7_1534 VPWR VGND sg13cmos5l_decap_8
XFILLER_0_483 VPWR VGND sg13cmos5l_decap_8
X_0190_ _0190_/Q Tile_X0Y0_FrameData[27] VGND VPWR Tile_X0Y0_FrameStrobe[3] latch
XFILLER_5_1291 VPWR VGND sg13cmos5l_decap_8
XFILLER_1_1122 VPWR VGND sg13cmos5l_decap_8
XFILLER_16_340 VPWR VGND sg13cmos5l_decap_4
XFILLER_16_362 VPWR VGND sg13cmos5l_fill_2
XFILLER_17_1108 VPWR VGND sg13cmos5l_fill_1
XFILLER_8_594 VPWR VGND sg13cmos5l_decap_8
XFILLER_6_84 VPWR VGND sg13cmos5l_decap_8
XANTENNA__0698__X Tile_X2Y0_N4BEG[6] VPWR VGND sg13cmos5l_antennanp
X_0526_ NPU_WDATA2 Tile_X0Y0_UserCLK _1103_/X _0626_/L_HI VPWR VGND sg13cmos5l_dfrbpq_1
XFILLER_6_1011 VPWR VGND sg13cmos5l_decap_8
X_0457_ _0457_/Q Tile_X0Y0_FrameData[16] VGND VPWR Tile_X3Y0_FrameStrobe[1] latch
X_0388_ _0388_/Q Tile_X0Y0_FrameData[21] VGND VPWR Tile_X2Y0_FrameStrobe[2] latch
XFILLER_6_1088 VPWR VGND sg13cmos5l_decap_8
XFILLER_3_1943 VPWR VGND sg13cmos5l_decap_8
X_1009_ Tile_X1Y0_NN4BEG[13] _1213_/X VPWR VGND sg13cmos5l_buf_1
XFILLER_17_2321 VPWR VGND sg13cmos5l_decap_4
XFILLER_17_2343 VPWR VGND sg13cmos5l_decap_8
XFILLER_17_2398 VPWR VGND sg13cmos5l_fill_2
XFILLER_13_2218 VPWR VGND sg13cmos5l_decap_8
XFILLER_10_549 VPWR VGND sg13cmos5l_decap_8
XFILLER_11_1274 VPWR VGND sg13cmos5l_fill_1
XFILLER_2_726 VPWR VGND sg13cmos5l_decap_8
XFILLER_1_203 VPWR VGND sg13cmos5l_decap_8
XFILLER_8_1854 VPWR VGND sg13cmos5l_decap_8
XFILLER_8_1832 VPWR VGND sg13cmos5l_decap_8
XANTENNA__0557__Q NPU_WE1 VPWR VGND sg13cmos5l_antennanp
XFILLER_8_1898 VPWR VGND sg13cmos5l_decap_8
XFILLER_18_627 VPWR VGND sg13cmos5l_fill_1
XFILLER_2_2165 VPWR VGND sg13cmos5l_decap_8
XFILLER_2_1442 VPWR VGND sg13cmos5l_decap_8
XFILLER_18_649 VPWR VGND sg13cmos5l_fill_1
XFILLER_17_137 VPWR VGND sg13cmos5l_fill_1
XFILLER_14_811 VPWR VGND sg13cmos5l_fill_1
XFILLER_9_358 VPWR VGND sg13cmos5l_decap_4
XFILLER_9_369 VPWR VGND sg13cmos5l_fill_2
XFILLER_16_1196 VPWR VGND sg13cmos5l_decap_8
XFILLER_16_1185 VPWR VGND sg13cmos5l_decap_8
XFILLER_5_520 VPWR VGND sg13cmos5l_decap_8
XFILLER_5_597 VPWR VGND sg13cmos5l_decap_8
XFILLER_9_1607 VPWR VGND sg13cmos5l_decap_8
XFILLER_9_1618 VPWR VGND sg13cmos5l_fill_2
X_0311_ _0311_/Q Tile_X0Y0_FrameData[18] VGND VPWR Tile_X1Y0_FrameStrobe[3] latch
XFILLER_7_1320 VPWR VGND sg13cmos5l_decap_8
X_1291_ _1291_/X Tile_X3Y0_S2END[3] Tile_X3Y0_S4END[11] Tile_X3Y0_SS4END[4] _0576_/Q
+ _0435_/Q _0434_/Q VPWR VGND sg13cmos5l_mux4_1
XFILLER_7_2076 VPWR VGND sg13cmos5l_decap_8
X_0242_ _0242_/Q Tile_X0Y0_FrameData[23] VGND VPWR Tile_X1Y0_FrameStrobe[1] latch
X_0173_ _0173_/Q Tile_X0Y0_FrameData[12] VGND VPWR Tile_X0Y0_FrameStrobe[2] latch
XANTENNA__0981__X Tile_X2Y0_FrameStrobe_O[9] VPWR VGND sg13cmos5l_antennanp
XFILLER_14_1848 VPWR VGND sg13cmos5l_decap_8
XFILLER_12_2295 VPWR VGND sg13cmos5l_decap_8
XFILLER_8_1106 VPWR VGND sg13cmos5l_decap_4
XFILLER_8_1139 VPWR VGND sg13cmos5l_decap_4
X_0509_ _0509_/Q Tile_X0Y0_FrameData[28] VGND VPWR Tile_X4Y0_FrameStrobe[0] latch
XANTENNA__1052__X Tile_X1Y0_FrameStrobe_O[4] VPWR VGND sg13cmos5l_antennanp
XFILLER_3_1773 VPWR VGND sg13cmos5l_decap_8
XANTENNA__0891__X Tile_X4Y0_NN4BEG[7] VPWR VGND sg13cmos5l_antennanp
XFILLER_10_313 VPWR VGND sg13cmos5l_decap_4
XFILLER_10_324 VPWR VGND sg13cmos5l_decap_4
XFILLER_6_306 VPWR VGND sg13cmos5l_decap_8
XFILLER_17_1483 VPWR VGND sg13cmos5l_fill_1
XFILLER_17_1472 VPWR VGND sg13cmos5l_decap_8
XFILLER_13_2059 VPWR VGND sg13cmos5l_decap_8
XFILLER_11_869 VPWR VGND sg13cmos5l_decap_8
XFILLER_13_1347 VPWR VGND sg13cmos5l_decap_8
XFILLER_11_1093 VPWR VGND sg13cmos5l_decap_8
XFILLER_2_545 VPWR VGND sg13cmos5l_decap_8
XFILLER_8_2352 VPWR VGND sg13cmos5l_decap_8
XFILLER_4_2227 VPWR VGND sg13cmos5l_decap_8
XFILLER_4_1548 VPWR VGND sg13cmos5l_decap_8
XANTENNA_220 Tile_X0Y0_FrameData[28] VPWR VGND sg13cmos5l_antennanp
XANTENNA_231 Tile_X0Y0_FrameData[28] VPWR VGND sg13cmos5l_antennanp
XANTENNA_242 Tile_X0Y0_FrameData[18] VPWR VGND sg13cmos5l_antennanp
XFILLER_18_479 VPWR VGND sg13cmos5l_decap_4
XFILLER_18_1236 VPWR VGND sg13cmos5l_decap_8
XFILLER_14_663 VPWR VGND sg13cmos5l_decap_4
XFILLER_9_122 VPWR VGND sg13cmos5l_fill_1
XFILLER_18_1269 VPWR VGND sg13cmos5l_decap_8
X_0860_ Tile_X4Y0_N2BEGb[0] Tile_X4Y0_S2END[7] VPWR VGND sg13cmos5l_buf_1
X_0791_ Tile_X2Y0_NN4BEG[11] _1251_/X VPWR VGND sg13cmos5l_buf_1
XFILLER_9_1404 VPWR VGND sg13cmos5l_decap_8
XANTENNA__0976__X Tile_X2Y0_FrameStrobe_O[4] VPWR VGND sg13cmos5l_antennanp
XFILLER_3_63 VPWR VGND sg13cmos5l_decap_8
X_1274_ _1274_/X Tile_X3Y0_S2MID[2] Tile_X3Y0_S4END[5] Tile_X3Y0_SS4END[10] _0576_/Q
+ _0469_/Q _0468_/Q VPWR VGND sg13cmos5l_mux4_1
XFILLER_7_1150 VPWR VGND sg13cmos5l_decap_8
XFILLER_3_1003 VPWR VGND sg13cmos5l_decap_8
X_0225_ _0225_/Q Tile_X0Y0_FrameData[8] VGND VPWR Tile_X1Y0_FrameStrobe[0] latch
XFILLER_0_1935 VPWR VGND sg13cmos5l_decap_8
X_0156_ _0156_/Q Tile_X0Y0_FrameData[29] VGND VPWR Tile_X0Y0_FrameStrobe[2] latch
XFILLER_18_980 VPWR VGND sg13cmos5l_fill_1
XFILLER_0_1968 VPWR VGND sg13cmos5l_fill_1
X_0087_ _0562_/D _0514_/Q _1099_/X VPWR VGND sg13cmos5l_nor2b_1
XFILLER_14_2313 VPWR VGND sg13cmos5l_decap_8
XFILLER_14_1623 VPWR VGND sg13cmos5l_fill_2
X_0989_ Tile_X2Y0_FrameStrobe_O[17] Tile_X2Y0_FrameStrobe[17] VPWR VGND sg13cmos5l_buf_1
XFILLER_10_1509 VPWR VGND sg13cmos5l_decap_8
XANTENNA__1047__X Tile_X1Y0_N1BEG[3] VPWR VGND sg13cmos5l_antennanp
XANTENNA__0886__X Tile_X4Y0_NN4BEG[2] VPWR VGND sg13cmos5l_antennanp
XFILLER_9_1971 VPWR VGND sg13cmos5l_decap_8
XFILLER_5_1813 VPWR VGND sg13cmos5l_decap_8
XFILLER_5_1879 VPWR VGND sg13cmos5l_decap_8
XFILLER_3_2293 VPWR VGND sg13cmos5l_decap_8
XFILLER_3_1581 VPWR VGND sg13cmos5l_decap_8
XFILLER_16_928 VPWR VGND sg13cmos5l_decap_8
XFILLER_15_438 VPWR VGND sg13cmos5l_decap_8
XFILLER_11_622 VPWR VGND sg13cmos5l_fill_1
XANTENNA__0570__Q NPU_ADDR6 VPWR VGND sg13cmos5l_antennanp
XFILLER_7_626 VPWR VGND sg13cmos5l_decap_8
XFILLER_13_1111 VPWR VGND sg13cmos5l_decap_8
XFILLER_11_699 VPWR VGND sg13cmos5l_decap_8
XFILLER_11_677 VPWR VGND sg13cmos5l_fill_1
XFILLER_10_187 VPWR VGND sg13cmos5l_decap_8
XFILLER_12_61 VPWR VGND sg13cmos5l_decap_8
XFILLER_12_50 VPWR VGND sg13cmos5l_decap_4
XFILLER_5_0 VPWR VGND sg13cmos5l_decap_8
XFILLER_3_865 VPWR VGND sg13cmos5l_decap_4
XANTENNA__0796__X Tile_X4Y0_FrameData_O[0] VPWR VGND sg13cmos5l_antennanp
XFILLER_8_2171 VPWR VGND sg13cmos5l_decap_8
XFILLER_4_2024 VPWR VGND sg13cmos5l_decap_8
XFILLER_4_1345 VPWR VGND sg13cmos5l_decap_8
XFILLER_18_254 VPWR VGND sg13cmos5l_decap_8
XFILLER_2_1080 VPWR VGND sg13cmos5l_decap_8
XFILLER_18_1000 VPWR VGND sg13cmos5l_fill_1
X_0912_ Tile_X3Y0_FrameStrobe_O[12] Tile_X3Y0_FrameStrobe[12] VPWR VGND sg13cmos5l_buf_1
X_0843_ Tile_X4Y0_FrameStrobe_O[15] Tile_X4Y0_FrameStrobe[15] VPWR VGND sg13cmos5l_buf_1
X_0774_ Tile_X0Y0_NN4BEG[10] _1170_/X VPWR VGND sg13cmos5l_buf_1
XFILLER_6_681 VPWR VGND sg13cmos5l_decap_8
XFILLER_6_692 VPWR VGND sg13cmos5l_fill_2
XFILLER_9_1289 VPWR VGND sg13cmos5l_decap_8
X_1257_ _1257_/X Tile_X3Y0_S1END[1] Tile_X3Y0_S2MID[1] Tile_X3Y0_S2END[6] _0573_/Q
+ _0503_/Q _0502_/Q VPWR VGND sg13cmos5l_mux4_1
XFILLER_0_1710 VPWR VGND sg13cmos5l_fill_2
X_0208_ _0208_/Q Tile_X0Y0_FrameData[25] VGND VPWR Tile_X1Y0_FrameStrobe[0] latch
X_1188_ _1188_/X Tile_X1Y0_S2MID[4] Tile_X1Y0_S4END[11] Tile_X1Y0_SS4END[4] _0590_/Q
+ _0289_/Q _0288_/Q VPWR VGND sg13cmos5l_mux4_1
XFILLER_17_39 VPWR VGND sg13cmos5l_decap_8
X_0139_ _0139_/Q Tile_X0Y0_FrameData[14] VGND VPWR Tile_X0Y0_FrameStrobe[1] latch
XFILLER_0_1776 VPWR VGND sg13cmos5l_decap_4
XFILLER_12_408 VPWR VGND sg13cmos5l_fill_2
XFILLER_16_1718 VPWR VGND sg13cmos5l_fill_2
XFILLER_14_2176 VPWR VGND sg13cmos5l_decap_4
XFILLER_14_1464 VPWR VGND sg13cmos5l_decap_8
XFILLER_5_2355 VPWR VGND sg13cmos5l_decap_8
XFILLER_1_2219 VPWR VGND sg13cmos5l_fill_1
XFILLER_1_1507 VPWR VGND sg13cmos5l_decap_8
XFILLER_3_2090 VPWR VGND sg13cmos5l_decap_8
XANTENNA__0565__Q NPU_ADDR1 VPWR VGND sg13cmos5l_antennanp
XFILLER_16_736 VPWR VGND sg13cmos5l_fill_1
XFILLER_15_224 VPWR VGND sg13cmos5l_fill_1
XFILLER_15_246 VPWR VGND sg13cmos5l_decap_8
XFILLER_12_931 VPWR VGND sg13cmos5l_decap_8
XFILLER_8_946 VPWR VGND sg13cmos5l_decap_8
XFILLER_7_478 VPWR VGND sg13cmos5l_decap_8
XFILLER_10_1851 VPWR VGND sg13cmos5l_decap_8
X_0490_ _0490_/Q Tile_X0Y0_FrameData[15] VGND VPWR Tile_X3Y0_FrameStrobe[2] latch
XFILLER_3_662 VPWR VGND sg13cmos5l_decap_8
XFILLER_2_161 VPWR VGND sg13cmos5l_decap_8
XFILLER_6_1429 VPWR VGND sg13cmos5l_decap_8
X_1111_ _1111_/X Tile_X1Y0_S4END[5] Tile_X1Y0_S4END[6] Tile_X1Y0_SS4END[5] Tile_X1Y0_SS4END[7]
+ _0213_/Q _0212_/Q VPWR VGND sg13cmos5l_mux4_1
XFILLER_0_42 VPWR VGND sg13cmos5l_decap_8
X_1042_ Tile_X1Y0_N2BEG[6] Tile_X1Y0_S2MID[1] VPWR VGND sg13cmos5l_buf_1
XFILLER_4_1175 VPWR VGND sg13cmos5l_decap_8
XFILLER_15_1751 VPWR VGND sg13cmos5l_fill_1
XFILLER_15_1740 VPWR VGND sg13cmos5l_decap_8
XFILLER_11_2305 VPWR VGND sg13cmos5l_decap_8
X_0826_ Tile_X4Y0_FrameData_O[30] Tile_X0Y0_FrameData[30] VPWR VGND sg13cmos5l_buf_1
XFILLER_11_1659 VPWR VGND sg13cmos5l_fill_2
X_0757_ Tile_X0Y0_N4BEG[9] _1153_/X VPWR VGND sg13cmos5l_buf_1
X_0688_ Tile_X2Y0_Co VPWR VGND sg13cmos5l_tielo
XFILLER_6_1974 VPWR VGND sg13cmos5l_decap_8
XFILLER_2_1816 VPWR VGND sg13cmos5l_decap_8
XFILLER_0_2263 VPWR VGND sg13cmos5l_decap_8
XANTENNA__1060__X Tile_X1Y0_FrameStrobe_O[12] VPWR VGND sg13cmos5l_antennanp
XFILLER_16_2205 VPWR VGND sg13cmos5l_decap_8
XFILLER_0_1584 VPWR VGND sg13cmos5l_decap_8
XFILLER_0_1595 VPWR VGND sg13cmos5l_decap_8
XFILLER_12_205 VPWR VGND sg13cmos5l_decap_8
XFILLER_5_938 VPWR VGND sg13cmos5l_decap_8
XFILLER_7_2417 VPWR VGND sg13cmos5l_fill_1
XFILLER_0_654 VPWR VGND sg13cmos5l_decap_8
XFILLER_7_1749 VPWR VGND sg13cmos5l_fill_2
XFILLER_5_2152 VPWR VGND sg13cmos5l_decap_8
XFILLER_1_2027 VPWR VGND sg13cmos5l_decap_8
XFILLER_5_1473 VPWR VGND sg13cmos5l_decap_8
XFILLER_1_1337 VPWR VGND sg13cmos5l_decap_8
XFILLER_16_599 VPWR VGND sg13cmos5l_fill_1
XFILLER_11_271 VPWR VGND sg13cmos5l_fill_1
XFILLER_11_260 VPWR VGND sg13cmos5l_decap_4
XFILLER_7_253 VPWR VGND sg13cmos5l_decap_8
X_0611_ _0611_/L_HI VPWR VGND sg13cmos5l_tiehi
XFILLER_12_1968 VPWR VGND sg13cmos5l_decap_8
XFILLER_10_1670 VPWR VGND sg13cmos5l_fill_2
XFILLER_10_1681 VPWR VGND sg13cmos5l_fill_1
X_0542_ NPU_WDATA18 Tile_X0Y0_UserCLK _1119_/X _0685_/L_HI VPWR VGND sg13cmos5l_dfrbpq_1
XFILLER_4_993 VPWR VGND sg13cmos5l_decap_8
X_0473_ _0473_/Q Tile_X0Y0_FrameData[0] VGND VPWR Tile_X3Y0_FrameStrobe[1] latch
XANTENNA__0984__X Tile_X2Y0_FrameStrobe_O[12] VPWR VGND sg13cmos5l_antennanp
X_1025_ Tile_X1Y0_N4BEG[13] _1197_/X VPWR VGND sg13cmos5l_buf_1
XFILLER_15_2293 VPWR VGND sg13cmos5l_decap_8
XFILLER_11_2146 VPWR VGND sg13cmos5l_decap_8
XFILLER_11_1445 VPWR VGND sg13cmos5l_decap_8
X_0809_ Tile_X4Y0_FrameData_O[13] Tile_X0Y0_FrameData[13] VPWR VGND sg13cmos5l_buf_1
XFILLER_2_919 VPWR VGND sg13cmos5l_decap_8
XANTENNA__1055__X Tile_X1Y0_FrameStrobe_O[7] VPWR VGND sg13cmos5l_antennanp
XANTENNA__0894__X Tile_X4Y0_NN4BEG[10] VPWR VGND sg13cmos5l_antennanp
XFILLER_6_1760 VPWR VGND sg13cmos5l_decap_4
XFILLER_6_1771 VPWR VGND sg13cmos5l_decap_4
XFILLER_2_2358 VPWR VGND sg13cmos5l_decap_8
XFILLER_2_1624 VPWR VGND sg13cmos5l_decap_8
XFILLER_0_2082 VPWR VGND sg13cmos5l_decap_8
XFILLER_16_2013 VPWR VGND sg13cmos5l_decap_8
XFILLER_16_1312 VPWR VGND sg13cmos5l_decap_8
XFILLER_9_518 VPWR VGND sg13cmos5l_decap_8
XFILLER_16_2079 VPWR VGND sg13cmos5l_fill_1
XFILLER_16_2068 VPWR VGND sg13cmos5l_decap_8
XFILLER_16_1356 VPWR VGND sg13cmos5l_decap_8
XFILLER_12_1209 VPWR VGND sg13cmos5l_fill_2
XFILLER_5_768 VPWR VGND sg13cmos5l_decap_8
XFILLER_4_245 VPWR VGND sg13cmos5l_decap_8
XFILLER_7_2214 VPWR VGND sg13cmos5l_decap_8
XFILLER_1_930 VPWR VGND sg13cmos5l_decap_8
XFILLER_7_1513 VPWR VGND sg13cmos5l_decap_8
XFILLER_1_996 VPWR VGND sg13cmos5l_decap_8
XFILLER_5_1270 VPWR VGND sg13cmos5l_decap_8
XFILLER_1_1101 VPWR VGND sg13cmos5l_decap_8
XFILLER_17_864 VPWR VGND sg13cmos5l_fill_1
XFILLER_1_1178 VPWR VGND sg13cmos5l_fill_2
XFILLER_17_897 VPWR VGND sg13cmos5l_fill_2
XFILLER_12_2400 VPWR VGND sg13cmos5l_fill_1
XANTENNA_1 _1094_/X VPWR VGND sg13cmos5l_antennanp
XANTENNA__0979__X Tile_X2Y0_FrameStrobe_O[7] VPWR VGND sg13cmos5l_antennanp
XFILLER_12_1743 VPWR VGND sg13cmos5l_fill_1
XFILLER_6_63 VPWR VGND sg13cmos5l_decap_8
X_0525_ NPU_WDATA1 Tile_X0Y0_UserCLK _1102_/X _0627_/L_HI VPWR VGND sg13cmos5l_dfrbpq_1
X_0456_ _0456_/Q Tile_X0Y0_FrameData[17] VGND VPWR Tile_X3Y0_FrameStrobe[1] latch
X_0387_ _0387_/Q Tile_X0Y0_FrameData[22] VGND VPWR Tile_X2Y0_FrameStrobe[2] latch
XFILLER_6_1067 VPWR VGND sg13cmos5l_decap_8
XFILLER_3_1922 VPWR VGND sg13cmos5l_decap_8
XFILLER_3_1999 VPWR VGND sg13cmos5l_decap_8
XFILLER_1_2380 VPWR VGND sg13cmos5l_decap_8
X_1008_ Tile_X1Y0_NN4BEG[12] _1212_/X VPWR VGND sg13cmos5l_buf_1
XFILLER_17_2388 VPWR VGND sg13cmos5l_fill_1
XFILLER_13_1529 VPWR VGND sg13cmos5l_decap_8
XANTENNA__0889__X Tile_X4Y0_NN4BEG[5] VPWR VGND sg13cmos5l_antennanp
XFILLER_11_1220 VPWR VGND sg13cmos5l_decap_8
XFILLER_9_7 VPWR VGND sg13cmos5l_decap_8
XFILLER_1_259 VPWR VGND sg13cmos5l_decap_8
XFILLER_4_2409 VPWR VGND sg13cmos5l_decap_8
XFILLER_8_1877 VPWR VGND sg13cmos5l_decap_8
XFILLER_2_2144 VPWR VGND sg13cmos5l_decap_8
XFILLER_6_1590 VPWR VGND sg13cmos5l_decap_8
XFILLER_2_1421 VPWR VGND sg13cmos5l_decap_8
XFILLER_18_639 VPWR VGND sg13cmos5l_fill_1
XFILLER_2_1498 VPWR VGND sg13cmos5l_decap_8
XFILLER_15_83 VPWR VGND sg13cmos5l_fill_1
XFILLER_15_72 VPWR VGND sg13cmos5l_decap_8
XFILLER_15_94 VPWR VGND sg13cmos5l_decap_8
XFILLER_16_1175 VPWR VGND sg13cmos5l_fill_2
XANTENNA__0799__X Tile_X4Y0_FrameData_O[3] VPWR VGND sg13cmos5l_antennanp
XFILLER_5_576 VPWR VGND sg13cmos5l_decap_8
X_0310_ _0310_/Q Tile_X0Y0_FrameData[19] VGND VPWR Tile_X1Y0_FrameStrobe[3] latch
XFILLER_7_2055 VPWR VGND sg13cmos5l_decap_8
XFILLER_0_281 VPWR VGND sg13cmos5l_decap_4
X_1290_ _1290_/X Tile_X3Y0_S2END[2] Tile_X3Y0_S4END[10] Tile_X3Y0_SS4END[5] _0577_/Q
+ _0437_/Q _0436_/Q VPWR VGND sg13cmos5l_mux4_1
X_0241_ _0241_/Q Tile_X0Y0_FrameData[24] VGND VPWR Tile_X1Y0_FrameStrobe[1] latch
XFILLER_7_1387 VPWR VGND sg13cmos5l_decap_8
XFILLER_3_1218 VPWR VGND sg13cmos5l_fill_2
X_0172_ _0172_/Q Tile_X0Y0_FrameData[13] VGND VPWR Tile_X0Y0_FrameStrobe[2] latch
XFILLER_16_182 VPWR VGND sg13cmos5l_decap_8
XFILLER_14_1827 VPWR VGND sg13cmos5l_decap_8
XFILLER_9_882 VPWR VGND sg13cmos5l_decap_8
XFILLER_12_2274 VPWR VGND sg13cmos5l_decap_8
X_0508_ _0508_/Q Tile_X0Y0_FrameData[29] VGND VPWR Tile_X4Y0_FrameStrobe[0] latch
X_0439_ _0439_/Q Tile_X0Y0_FrameData[2] VGND VPWR Tile_X3Y0_FrameStrobe[0] latch
XFILLER_3_1752 VPWR VGND sg13cmos5l_decap_8
XFILLER_11_804 VPWR VGND sg13cmos5l_decap_8
XFILLER_17_2174 VPWR VGND sg13cmos5l_fill_2
XFILLER_13_2038 VPWR VGND sg13cmos5l_decap_8
XFILLER_11_826 VPWR VGND sg13cmos5l_decap_4
XFILLER_10_358 VPWR VGND sg13cmos5l_decap_4
XFILLER_11_1072 VPWR VGND sg13cmos5l_fill_1
XFILLER_2_524 VPWR VGND sg13cmos5l_decap_8
XFILLER_8_2331 VPWR VGND sg13cmos5l_decap_8
XANTENNA__0568__Q NPU_ADDR4 VPWR VGND sg13cmos5l_antennanp
XFILLER_8_1652 VPWR VGND sg13cmos5l_decap_8
XFILLER_4_2206 VPWR VGND sg13cmos5l_decap_8
XFILLER_4_1527 VPWR VGND sg13cmos5l_decap_8
XFILLER_18_458 VPWR VGND sg13cmos5l_decap_8
XANTENNA_210 Tile_X0Y0_FrameData[23] VPWR VGND sg13cmos5l_antennanp
XANTENNA_221 Tile_X0Y0_FrameData[28] VPWR VGND sg13cmos5l_antennanp
XANTENNA_232 Tile_X0Y0_FrameData[28] VPWR VGND sg13cmos5l_antennanp
XANTENNA_243 Tile_X0Y0_FrameData[18] VPWR VGND sg13cmos5l_antennanp
XFILLER_2_1295 VPWR VGND sg13cmos5l_decap_8
XFILLER_18_1215 VPWR VGND sg13cmos5l_decap_8
XFILLER_9_112 VPWR VGND sg13cmos5l_decap_8
XFILLER_9_145 VPWR VGND sg13cmos5l_fill_1
XFILLER_13_196 VPWR VGND sg13cmos5l_decap_4
XFILLER_9_178 VPWR VGND sg13cmos5l_fill_1
X_0790_ Tile_X2Y0_NN4BEG[10] _1250_/X VPWR VGND sg13cmos5l_buf_1
XFILLER_10_892 VPWR VGND sg13cmos5l_fill_1
XFILLER_5_340 VPWR VGND sg13cmos5l_decap_8
XFILLER_9_2139 VPWR VGND sg13cmos5l_decap_8
XFILLER_3_42 VPWR VGND sg13cmos5l_decap_8
X_1273_ _1273_/X Tile_X3Y0_S2MID[1] Tile_X3Y0_S4END[6] Tile_X3Y0_SS4END[9] _0577_/Q
+ _0471_/Q _0470_/Q VPWR VGND sg13cmos5l_mux4_1
X_0224_ _0224_/Q Tile_X0Y0_FrameData[9] VGND VPWR Tile_X1Y0_FrameStrobe[0] latch
XANTENNA__0992__X Tile_X2Y0_N1BEG[0] VPWR VGND sg13cmos5l_antennanp
XFILLER_3_1059 VPWR VGND sg13cmos5l_decap_8
X_0155_ _0155_/Q Tile_X0Y0_FrameData[30] VGND VPWR Tile_X0Y0_FrameStrobe[2] latch
X_0086_ _0563_/D _0513_/Q _1100_/X VPWR VGND sg13cmos5l_nor2b_1
XFILLER_17_480 VPWR VGND sg13cmos5l_decap_8
XFILLER_14_2369 VPWR VGND sg13cmos5l_decap_8
XFILLER_14_1613 VPWR VGND sg13cmos5l_decap_8
X_0988_ Tile_X2Y0_FrameStrobe_O[16] Tile_X2Y0_FrameStrobe[16] VPWR VGND sg13cmos5l_buf_1
XFILLER_14_1657 VPWR VGND sg13cmos5l_fill_2
XFILLER_9_1950 VPWR VGND sg13cmos5l_decap_8
XANTENNA__1063__X Tile_X1Y0_FrameStrobe_O[15] VPWR VGND sg13cmos5l_antennanp
XFILLER_5_1858 VPWR VGND sg13cmos5l_decap_8
XFILLER_3_2272 VPWR VGND sg13cmos5l_decap_8
XFILLER_16_907 VPWR VGND sg13cmos5l_decap_8
XFILLER_3_1560 VPWR VGND sg13cmos5l_decap_8
XFILLER_11_601 VPWR VGND sg13cmos5l_fill_2
XFILLER_10_133 VPWR VGND sg13cmos5l_decap_8
XFILLER_7_605 VPWR VGND sg13cmos5l_decap_8
XFILLER_17_1270 VPWR VGND sg13cmos5l_fill_2
XFILLER_11_634 VPWR VGND sg13cmos5l_fill_2
XFILLER_10_177 VPWR VGND sg13cmos5l_decap_4
XFILLER_6_126 VPWR VGND sg13cmos5l_fill_1
XFILLER_6_137 VPWR VGND sg13cmos5l_decap_8
XFILLER_3_822 VPWR VGND sg13cmos5l_decap_4
XFILLER_2_343 VPWR VGND sg13cmos5l_decap_8
XFILLER_8_2150 VPWR VGND sg13cmos5l_decap_8
XFILLER_4_1324 VPWR VGND sg13cmos5l_decap_8
XFILLER_18_222 VPWR VGND sg13cmos5l_decap_8
XFILLER_18_277 VPWR VGND sg13cmos5l_fill_1
XFILLER_15_995 VPWR VGND sg13cmos5l_decap_8
X_0911_ Tile_X3Y0_FrameStrobe_O[11] Tile_X3Y0_FrameStrobe[11] VPWR VGND sg13cmos5l_buf_1
XFILLER_18_1078 VPWR VGND sg13cmos5l_decap_4
XFILLER_14_494 VPWR VGND sg13cmos5l_decap_8
X_0842_ Tile_X4Y0_FrameStrobe_O[14] Tile_X4Y0_FrameStrobe[14] VPWR VGND sg13cmos5l_buf_1
XFILLER_15_1944 VPWR VGND sg13cmos5l_decap_8
X_0773_ Tile_X0Y0_NN4BEG[9] _1169_/X VPWR VGND sg13cmos5l_buf_1
XANTENNA__0987__X Tile_X2Y0_FrameStrobe_O[15] VPWR VGND sg13cmos5l_antennanp
XFILLER_5_192 VPWR VGND sg13cmos5l_decap_8
XFILLER_9_1268 VPWR VGND sg13cmos5l_decap_8
X_1256_ _1256_/X Tile_X3Y0_S1END[0] Tile_X3Y0_S2MID[0] Tile_X3Y0_S2END[7] _0572_/Q
+ _0505_/Q _0504_/Q VPWR VGND sg13cmos5l_mux4_1
XFILLER_17_29 VPWR VGND sg13cmos5l_fill_1
X_0207_ _0207_/Q Tile_X0Y0_FrameData[26] VGND VPWR Tile_X1Y0_FrameStrobe[0] latch
X_1187_ _1187_/X Tile_X1Y0_S2MID[3] Tile_X1Y0_S4END[12] Tile_X1Y0_SS4END[3] _0589_/Q
+ _0291_/Q _0290_/Q VPWR VGND sg13cmos5l_mux4_1
X_0138_ _0138_/Q Tile_X0Y0_FrameData[15] VGND VPWR Tile_X0Y0_FrameStrobe[1] latch
XFILLER_14_2144 VPWR VGND sg13cmos5l_fill_1
XFILLER_18_1590 VPWR VGND sg13cmos5l_decap_8
XFILLER_14_1443 VPWR VGND sg13cmos5l_decap_8
XFILLER_10_1307 VPWR VGND sg13cmos5l_decap_8
XANTENNA__1058__X Tile_X1Y0_FrameStrobe_O[10] VPWR VGND sg13cmos5l_antennanp
XANTENNA__0897__X Tile_X4Y0_NN4BEG[13] VPWR VGND sg13cmos5l_antennanp
XFILLER_5_2334 VPWR VGND sg13cmos5l_decap_8
XFILLER_5_1666 VPWR VGND sg13cmos5l_decap_8
XFILLER_5_1655 VPWR VGND sg13cmos5l_decap_8
XFILLER_16_704 VPWR VGND sg13cmos5l_fill_1
XFILLER_15_203 VPWR VGND sg13cmos5l_decap_8
XFILLER_8_925 VPWR VGND sg13cmos5l_decap_8
XFILLER_12_987 VPWR VGND sg13cmos5l_decap_8
XFILLER_11_453 VPWR VGND sg13cmos5l_decap_8
XFILLER_7_457 VPWR VGND sg13cmos5l_decap_8
XFILLER_11_486 VPWR VGND sg13cmos5l_decap_8
XFILLER_10_1830 VPWR VGND sg13cmos5l_decap_8
XFILLER_3_641 VPWR VGND sg13cmos5l_decap_8
XFILLER_2_140 VPWR VGND sg13cmos5l_decap_8
XFILLER_6_1408 VPWR VGND sg13cmos5l_decap_8
X_1110_ _1110_/X Tile_X1Y0_S4END[6] Tile_X1Y0_S4END[7] Tile_X1Y0_SS4END[4] Tile_X1Y0_SS4END[6]
+ _0215_/Q _0214_/Q VPWR VGND sg13cmos5l_mux4_1
XFILLER_0_21 VPWR VGND sg13cmos5l_decap_8
X_1041_ Tile_X1Y0_N2BEG[5] Tile_X1Y0_S2MID[2] VPWR VGND sg13cmos5l_buf_1
XFILLER_4_1154 VPWR VGND sg13cmos5l_decap_8
XFILLER_0_1029 VPWR VGND sg13cmos5l_decap_8
XFILLER_0_98 VPWR VGND sg13cmos5l_decap_8
XFILLER_15_770 VPWR VGND sg13cmos5l_decap_8
X_0825_ Tile_X4Y0_FrameData_O[29] Tile_X0Y0_FrameData[29] VPWR VGND sg13cmos5l_buf_1
XFILLER_7_980 VPWR VGND sg13cmos5l_decap_8
X_0756_ Tile_X0Y0_N4BEG[8] _1152_/X VPWR VGND sg13cmos5l_buf_1
X_0687_ Tile_X0Y0_Co VPWR VGND sg13cmos5l_tielo
XFILLER_9_1098 VPWR VGND sg13cmos5l_fill_2
XFILLER_6_1953 VPWR VGND sg13cmos5l_decap_8
X_1239_ _1239_/X Tile_X2Y0_S2MID[7] Tile_X2Y0_S4END[0] Tile_X2Y0_SS4END[15] _0587_/Q
+ _0363_/Q _0362_/Q VPWR VGND sg13cmos5l_mux4_1
XFILLER_16_2239 VPWR VGND sg13cmos5l_decap_8
XFILLER_16_1538 VPWR VGND sg13cmos5l_decap_8
XFILLER_5_917 VPWR VGND sg13cmos5l_decap_8
XFILLER_4_449 VPWR VGND sg13cmos5l_decap_8
XFILLER_0_699 VPWR VGND sg13cmos5l_fill_2
XFILLER_5_2131 VPWR VGND sg13cmos5l_decap_8
XFILLER_5_1452 VPWR VGND sg13cmos5l_decap_8
XFILLER_1_1316 VPWR VGND sg13cmos5l_decap_8
XFILLER_18_61 VPWR VGND sg13cmos5l_fill_1
XFILLER_18_72 VPWR VGND sg13cmos5l_decap_8
XFILLER_8_700 VPWR VGND sg13cmos5l_fill_2
XFILLER_11_283 VPWR VGND sg13cmos5l_fill_2
XFILLER_12_1947 VPWR VGND sg13cmos5l_decap_8
XFILLER_10_2383 VPWR VGND sg13cmos5l_decap_8
X_0610_ _0610_/L_HI VPWR VGND sg13cmos5l_tiehi
X_0541_ NPU_WDATA17 Tile_X0Y0_UserCLK _1118_/X _0686_/L_HI VPWR VGND sg13cmos5l_dfrbpq_1
XFILLER_4_972 VPWR VGND sg13cmos5l_decap_8
X_0472_ _0472_/Q Tile_X0Y0_FrameData[1] VGND VPWR Tile_X3Y0_FrameStrobe[1] latch
X_1024_ Tile_X1Y0_N4BEG[12] _1196_/X VPWR VGND sg13cmos5l_buf_1
XFILLER_1_1894 VPWR VGND sg13cmos5l_decap_8
XFILLER_1_1883 VPWR VGND sg13cmos5l_fill_2
XFILLER_15_2272 VPWR VGND sg13cmos5l_decap_8
XFILLER_11_2125 VPWR VGND sg13cmos5l_decap_8
XFILLER_11_1424 VPWR VGND sg13cmos5l_decap_8
X_0808_ Tile_X4Y0_FrameData_O[12] Tile_X0Y0_FrameData[12] VPWR VGND sg13cmos5l_buf_1
XFILLER_1_408 VPWR VGND sg13cmos5l_fill_1
X_0739_ Tile_X0Y0_N2BEG[7] Tile_X0Y0_S2MID[0] VPWR VGND sg13cmos5l_buf_1
XFILLER_2_2337 VPWR VGND sg13cmos5l_decap_8
XFILLER_2_1603 VPWR VGND sg13cmos5l_decap_8
XANTENNA__1071__X Tile_X2Y0_N2BEG[3] VPWR VGND sg13cmos5l_antennanp
XFILLER_0_2061 VPWR VGND sg13cmos5l_decap_8
XFILLER_16_2047 VPWR VGND sg13cmos5l_decap_8
XFILLER_13_559 VPWR VGND sg13cmos5l_decap_8
XFILLER_5_714 VPWR VGND sg13cmos5l_fill_1
XFILLER_5_747 VPWR VGND sg13cmos5l_decap_8
XFILLER_4_224 VPWR VGND sg13cmos5l_decap_8
XFILLER_0_430 VPWR VGND sg13cmos5l_fill_1
XFILLER_1_942 VPWR VGND sg13cmos5l_decap_8
XFILLER_1_975 VPWR VGND sg13cmos5l_decap_8
XFILLER_7_1569 VPWR VGND sg13cmos5l_decap_8
XFILLER_17_832 VPWR VGND sg13cmos5l_fill_2
XFILLER_1_1157 VPWR VGND sg13cmos5l_decap_8
XFILLER_16_331 VPWR VGND sg13cmos5l_fill_2
XFILLER_8_563 VPWR VGND sg13cmos5l_decap_8
XFILLER_16_1891 VPWR VGND sg13cmos5l_decap_8
XFILLER_12_1700 VPWR VGND sg13cmos5l_fill_2
XANTENNA_2 _1096_/X VPWR VGND sg13cmos5l_antennanp
XFILLER_6_42 VPWR VGND sg13cmos5l_decap_8
XFILLER_12_1799 VPWR VGND sg13cmos5l_decap_8
X_0524_ NPU_WDATA0 Tile_X0Y0_UserCLK _1101_/X _0628_/L_HI VPWR VGND sg13cmos5l_dfrbpq_1
XANTENNA__0995__X Tile_X2Y0_N1BEG[3] VPWR VGND sg13cmos5l_antennanp
X_0455_ _0455_/Q Tile_X0Y0_FrameData[18] VGND VPWR Tile_X3Y0_FrameStrobe[1] latch
XFILLER_6_1046 VPWR VGND sg13cmos5l_decap_8
X_0386_ _0386_/Q Tile_X0Y0_FrameData[23] VGND VPWR Tile_X2Y0_FrameStrobe[2] latch
XFILLER_3_1901 VPWR VGND sg13cmos5l_decap_8
XFILLER_13_0 VPWR VGND sg13cmos5l_decap_8
XFILLER_3_1978 VPWR VGND sg13cmos5l_decap_8
X_1007_ Tile_X1Y0_NN4BEG[11] _1211_/X VPWR VGND sg13cmos5l_buf_1
XFILLER_10_529 VPWR VGND sg13cmos5l_decap_8
XFILLER_17_1655 VPWR VGND sg13cmos5l_fill_2
XFILLER_15_2091 VPWR VGND sg13cmos5l_decap_8
XANTENNA__1066__X Tile_X1Y0_FrameStrobe_O[18] VPWR VGND sg13cmos5l_antennanp
XFILLER_1_238 VPWR VGND sg13cmos5l_decap_8
XFILLER_6_2281 VPWR VGND sg13cmos5l_decap_8
XFILLER_2_2123 VPWR VGND sg13cmos5l_decap_8
XFILLER_18_618 VPWR VGND sg13cmos5l_decap_8
XFILLER_2_1400 VPWR VGND sg13cmos5l_decap_8
XFILLER_2_1477 VPWR VGND sg13cmos5l_decap_8
XFILLER_14_802 VPWR VGND sg13cmos5l_decap_8
XFILLER_0_1190 VPWR VGND sg13cmos5l_fill_1
XFILLER_15_40 VPWR VGND sg13cmos5l_decap_8
XFILLER_13_301 VPWR VGND sg13cmos5l_fill_1
XFILLER_9_327 VPWR VGND sg13cmos5l_fill_2
XFILLER_16_1143 VPWR VGND sg13cmos5l_fill_2
XFILLER_12_1029 VPWR VGND sg13cmos5l_decap_8
XFILLER_5_555 VPWR VGND sg13cmos5l_decap_8
XFILLER_7_2001 VPWR VGND sg13cmos5l_decap_8
XFILLER_7_2034 VPWR VGND sg13cmos5l_decap_8
XFILLER_0_271 VPWR VGND sg13cmos5l_decap_4
X_0240_ _0240_/Q Tile_X0Y0_FrameData[25] VGND VPWR Tile_X1Y0_FrameStrobe[1] latch
XFILLER_1_783 VPWR VGND sg13cmos5l_decap_8
XFILLER_7_1355 VPWR VGND sg13cmos5l_decap_8
X_0171_ _0171_/Q Tile_X0Y0_FrameData[14] VGND VPWR Tile_X0Y0_FrameStrobe[2] latch
XFILLER_18_1975 VPWR VGND sg13cmos5l_decap_8
XFILLER_18_1964 VPWR VGND sg13cmos5l_fill_1
XFILLER_18_1953 VPWR VGND sg13cmos5l_decap_8
XFILLER_14_1806 VPWR VGND sg13cmos5l_decap_8
XFILLER_12_2253 VPWR VGND sg13cmos5l_decap_8
X_0507_ _0507_/Q Tile_X0Y0_FrameData[30] VGND VPWR Tile_X4Y0_FrameStrobe[0] latch
X_0438_ _0438_/Q Tile_X0Y0_FrameData[3] VGND VPWR Tile_X3Y0_FrameStrobe[0] latch
X_0369_ _0369_/Q Tile_X0Y0_FrameData[8] VGND VPWR Tile_X2Y0_FrameStrobe[1] latch
XFILLER_3_1731 VPWR VGND sg13cmos5l_decap_8
XFILLER_3_1720 VPWR VGND sg13cmos5l_fill_2
XFILLER_13_2017 VPWR VGND sg13cmos5l_decap_8
XFILLER_17_1463 VPWR VGND sg13cmos5l_decap_4
XFILLER_2_503 VPWR VGND sg13cmos5l_decap_8
XFILLER_8_2310 VPWR VGND sg13cmos5l_decap_8
XFILLER_8_2387 VPWR VGND sg13cmos5l_decap_8
XFILLER_8_1631 VPWR VGND sg13cmos5l_fill_2
XFILLER_4_1506 VPWR VGND sg13cmos5l_decap_8
XANTENNA_200 Tile_X0Y0_FrameData[22] VPWR VGND sg13cmos5l_antennanp
XANTENNA_211 Tile_X0Y0_FrameData[23] VPWR VGND sg13cmos5l_antennanp
XANTENNA_222 Tile_X0Y0_FrameData[28] VPWR VGND sg13cmos5l_antennanp
XANTENNA_233 Tile_X0Y0_FrameData[28] VPWR VGND sg13cmos5l_antennanp
XFILLER_2_1274 VPWR VGND sg13cmos5l_decap_8
XANTENNA_244 Tile_X0Y0_FrameData[18] VPWR VGND sg13cmos5l_antennanp
XFILLER_14_632 VPWR VGND sg13cmos5l_decap_8
XFILLER_14_643 VPWR VGND sg13cmos5l_fill_2
XFILLER_13_142 VPWR VGND sg13cmos5l_decap_8
XFILLER_18_1249 VPWR VGND sg13cmos5l_fill_2
XFILLER_13_153 VPWR VGND sg13cmos5l_fill_2
XFILLER_13_1861 VPWR VGND sg13cmos5l_decap_8
XFILLER_9_2118 VPWR VGND sg13cmos5l_decap_8
XFILLER_9_1439 VPWR VGND sg13cmos5l_decap_8
XFILLER_3_21 VPWR VGND sg13cmos5l_decap_8
X_1272_ _1272_/X Tile_X3Y0_S2MID[0] Tile_X3Y0_S4END[7] Tile_X3Y0_SS4END[8] _0576_/Q
+ _0473_/Q _0472_/Q VPWR VGND sg13cmos5l_mux4_1
XFILLER_3_98 VPWR VGND sg13cmos5l_decap_8
X_0223_ _0223_/Q Tile_X0Y0_FrameData[10] VGND VPWR Tile_X1Y0_FrameStrobe[0] latch
X_0154_ _0154_/Q Tile_X0Y0_FrameData[31] VGND VPWR Tile_X0Y0_FrameStrobe[2] latch
XFILLER_3_1038 VPWR VGND sg13cmos5l_decap_8
XFILLER_0_1915 VPWR VGND sg13cmos5l_fill_2
X_0085_ _0561_/D _0515_/Q _1098_/X VPWR VGND sg13cmos5l_nor2b_1
XFILLER_14_2348 VPWR VGND sg13cmos5l_decap_8
X_0987_ Tile_X2Y0_FrameStrobe_O[15] Tile_X2Y0_FrameStrobe[15] VPWR VGND sg13cmos5l_buf_1
XFILLER_12_2094 VPWR VGND sg13cmos5l_decap_8
XFILLER_12_1382 VPWR VGND sg13cmos5l_decap_8
XFILLER_3_2251 VPWR VGND sg13cmos5l_decap_8
XFILLER_10_156 VPWR VGND sg13cmos5l_fill_2
XFILLER_6_105 VPWR VGND sg13cmos5l_decap_8
XFILLER_17_1293 VPWR VGND sg13cmos5l_fill_2
XFILLER_3_801 VPWR VGND sg13cmos5l_decap_8
XFILLER_2_322 VPWR VGND sg13cmos5l_decap_8
XFILLER_4_2004 VPWR VGND sg13cmos5l_decap_8
XFILLER_8_1483 VPWR VGND sg13cmos5l_decap_8
XFILLER_4_2059 VPWR VGND sg13cmos5l_decap_8
XFILLER_4_1303 VPWR VGND sg13cmos5l_decap_8
XFILLER_18_201 VPWR VGND sg13cmos5l_decap_8
X_0910_ Tile_X3Y0_FrameStrobe_O[10] Tile_X3Y0_FrameStrobe[10] VPWR VGND sg13cmos5l_buf_1
XFILLER_15_974 VPWR VGND sg13cmos5l_decap_8
XFILLER_14_473 VPWR VGND sg13cmos5l_decap_8
XFILLER_18_1068 VPWR VGND sg13cmos5l_fill_2
XFILLER_15_1923 VPWR VGND sg13cmos5l_decap_8
X_0841_ Tile_X4Y0_FrameStrobe_O[13] Tile_X4Y0_FrameStrobe[13] VPWR VGND sg13cmos5l_buf_1
X_0772_ Tile_X0Y0_NN4BEG[8] _1168_/X VPWR VGND sg13cmos5l_buf_1
XFILLER_15_1989 VPWR VGND sg13cmos5l_decap_8
XFILLER_5_171 VPWR VGND sg13cmos5l_decap_8
XFILLER_13_1691 VPWR VGND sg13cmos5l_fill_2
XFILLER_9_1247 VPWR VGND sg13cmos5l_decap_8
XFILLER_0_2413 VPWR VGND sg13cmos5l_decap_4
X_1255_ _1255_/X Tile_X2Y0_S2END[7] Tile_X2Y0_S4END[15] Tile_X2Y0_SS4END[0] _0586_/Q
+ _0331_/Q _0330_/Q VPWR VGND sg13cmos5l_mux4_1
X_0206_ _0206_/Q Tile_X0Y0_FrameData[27] VGND VPWR Tile_X1Y0_FrameStrobe[0] latch
X_1186_ _1186_/X Tile_X1Y0_S2MID[2] Tile_X1Y0_S4END[13] Tile_X1Y0_SS4END[2] _0588_/Q
+ _0293_/Q _0292_/Q VPWR VGND sg13cmos5l_mux4_1
XFILLER_0_1723 VPWR VGND sg13cmos5l_decap_8
XFILLER_0_1734 VPWR VGND sg13cmos5l_fill_1
X_0137_ _0137_/Q Tile_X0Y0_FrameData[16] VGND VPWR Tile_X0Y0_FrameStrobe[1] latch
XFILLER_4_1892 VPWR VGND sg13cmos5l_decap_8
XFILLER_18_790 VPWR VGND sg13cmos5l_decap_8
XFILLER_18_2270 VPWR VGND sg13cmos5l_fill_2
XFILLER_14_2123 VPWR VGND sg13cmos5l_decap_8
XFILLER_14_1422 VPWR VGND sg13cmos5l_decap_8
XFILLER_14_1499 VPWR VGND sg13cmos5l_decap_8
XFILLER_3_119 VPWR VGND sg13cmos5l_decap_8
XFILLER_12_1190 VPWR VGND sg13cmos5l_fill_2
XANTENNA__1074__X Tile_X2Y0_N2BEG[6] VPWR VGND sg13cmos5l_antennanp
XFILLER_0_815 VPWR VGND sg13cmos5l_decap_8
XFILLER_5_2313 VPWR VGND sg13cmos5l_decap_8
XFILLER_5_1634 VPWR VGND sg13cmos5l_decap_8
XFILLER_5_1689 VPWR VGND sg13cmos5l_decap_8
XFILLER_8_904 VPWR VGND sg13cmos5l_decap_8
XFILLER_15_1219 VPWR VGND sg13cmos5l_decap_8
XFILLER_11_432 VPWR VGND sg13cmos5l_decap_8
XFILLER_12_966 VPWR VGND sg13cmos5l_decap_8
XFILLER_7_436 VPWR VGND sg13cmos5l_decap_8
XFILLER_3_620 VPWR VGND sg13cmos5l_decap_8
XFILLER_10_1886 VPWR VGND sg13cmos5l_decap_8
XFILLER_2_196 VPWR VGND sg13cmos5l_decap_8
XFILLER_4_1133 VPWR VGND sg13cmos5l_decap_8
XFILLER_0_1008 VPWR VGND sg13cmos5l_decap_8
X_1040_ Tile_X1Y0_N2BEG[4] Tile_X1Y0_S2MID[3] VPWR VGND sg13cmos5l_buf_1
XFILLER_0_77 VPWR VGND sg13cmos5l_decap_8
XFILLER_9_42 VPWR VGND sg13cmos5l_decap_8
XFILLER_9_64 VPWR VGND sg13cmos5l_decap_8
XFILLER_9_75 VPWR VGND sg13cmos5l_decap_8
X_0824_ Tile_X4Y0_FrameData_O[28] Tile_X0Y0_FrameData[28] VPWR VGND sg13cmos5l_buf_1
XANTENNA__0998__X Tile_X1Y0_NN4BEG[2] VPWR VGND sg13cmos5l_antennanp
X_0755_ Tile_X0Y0_N4BEG[7] _1151_/X VPWR VGND sg13cmos5l_buf_1
X_0686_ _0686_/L_HI VPWR VGND sg13cmos5l_tiehi
XFILLER_6_491 VPWR VGND sg13cmos5l_decap_8
XFILLER_9_1022 VPWR VGND sg13cmos5l_fill_1
XFILLER_9_1055 VPWR VGND sg13cmos5l_decap_8
XFILLER_6_1932 VPWR VGND sg13cmos5l_decap_8
X_1238_ _1238_/X Tile_X2Y0_S2MID[6] Tile_X2Y0_S4END[1] Tile_X2Y0_SS4END[14] _0586_/Q
+ _0365_/Q _0364_/Q VPWR VGND sg13cmos5l_mux4_1
XFILLER_0_1531 VPWR VGND sg13cmos5l_decap_8
XFILLER_0_1542 VPWR VGND sg13cmos5l_fill_1
XFILLER_0_2298 VPWR VGND sg13cmos5l_decap_8
X_1169_ _1169_/X Tile_X0Y0_S2END[1] Tile_X0Y0_S4END[9] Tile_X0Y0_SS4END[6] _0600_/Q
+ _0135_/Q _0134_/Q VPWR VGND sg13cmos5l_mux4_1
XFILLER_16_1517 VPWR VGND sg13cmos5l_decap_8
XANTENNA__1069__X Tile_X2Y0_N2BEG[1] VPWR VGND sg13cmos5l_antennanp
XFILLER_14_1252 VPWR VGND sg13cmos5l_decap_8
XFILLER_4_428 VPWR VGND sg13cmos5l_decap_8
XANTENNA__0701__X Tile_X2Y0_N4BEG[9] VPWR VGND sg13cmos5l_antennanp
XFILLER_0_623 VPWR VGND sg13cmos5l_decap_8
XFILLER_7_1718 VPWR VGND sg13cmos5l_decap_8
XFILLER_5_2110 VPWR VGND sg13cmos5l_decap_8
XFILLER_9_2290 VPWR VGND sg13cmos5l_decap_8
XFILLER_5_2187 VPWR VGND sg13cmos5l_decap_8
XFILLER_5_1431 VPWR VGND sg13cmos5l_decap_8
XFILLER_16_524 VPWR VGND sg13cmos5l_decap_8
XFILLER_15_1027 VPWR VGND sg13cmos5l_fill_2
XFILLER_15_1016 VPWR VGND sg13cmos5l_decap_8
XFILLER_12_774 VPWR VGND sg13cmos5l_fill_2
XFILLER_12_752 VPWR VGND sg13cmos5l_fill_1
XFILLER_12_1926 VPWR VGND sg13cmos5l_decap_8
XFILLER_11_295 VPWR VGND sg13cmos5l_decap_8
XFILLER_10_2362 VPWR VGND sg13cmos5l_decap_8
X_0540_ NPU_WDATA16 Tile_X0Y0_UserCLK _1117_/X _0633_/L_HI VPWR VGND sg13cmos5l_dfrbpq_1
XFILLER_4_951 VPWR VGND sg13cmos5l_decap_8
X_0471_ _0471_/Q Tile_X0Y0_FrameData[2] VGND VPWR Tile_X3Y0_FrameStrobe[1] latch
XFILLER_3_494 VPWR VGND sg13cmos5l_decap_8
X_1023_ Tile_X1Y0_N4BEG[11] _1195_/X VPWR VGND sg13cmos5l_buf_1
XFILLER_1_1862 VPWR VGND sg13cmos5l_decap_8
XFILLER_15_2251 VPWR VGND sg13cmos5l_decap_8
XFILLER_11_2104 VPWR VGND sg13cmos5l_decap_8
XFILLER_11_1403 VPWR VGND sg13cmos5l_decap_8
XFILLER_15_1561 VPWR VGND sg13cmos5l_fill_2
X_0807_ Tile_X4Y0_FrameData_O[11] Tile_X0Y0_FrameData[11] VPWR VGND sg13cmos5l_buf_1
X_0738_ Tile_X0Y0_N2BEG[6] Tile_X0Y0_S2MID[1] VPWR VGND sg13cmos5l_buf_1
X_0669_ _0669_/L_HI VPWR VGND sg13cmos5l_tiehi
XFILLER_2_2316 VPWR VGND sg13cmos5l_decap_8
XFILLER_6_1784 VPWR VGND sg13cmos5l_fill_2
XFILLER_0_2040 VPWR VGND sg13cmos5l_decap_8
XFILLER_2_1659 VPWR VGND sg13cmos5l_decap_8
XFILLER_13_516 VPWR VGND sg13cmos5l_decap_8
XFILLER_16_1347 VPWR VGND sg13cmos5l_decap_4
XFILLER_5_726 VPWR VGND sg13cmos5l_decap_8
XFILLER_4_203 VPWR VGND sg13cmos5l_decap_8
XFILLER_11_1992 VPWR VGND sg13cmos5l_decap_8
XFILLER_0_464 VPWR VGND sg13cmos5l_fill_1
XFILLER_7_2249 VPWR VGND sg13cmos5l_decap_8
XFILLER_0_497 VPWR VGND sg13cmos5l_decap_8
XFILLER_7_1548 VPWR VGND sg13cmos5l_decap_8
XFILLER_1_1136 VPWR VGND sg13cmos5l_decap_8
XFILLER_8_542 VPWR VGND sg13cmos5l_decap_8
XFILLER_16_1870 VPWR VGND sg13cmos5l_decap_8
XANTENNA_3 _1097_/X VPWR VGND sg13cmos5l_antennanp
XFILLER_6_21 VPWR VGND sg13cmos5l_decap_8
XFILLER_6_98 VPWR VGND sg13cmos5l_decap_8
X_0523_ NPU_READ_BANK_SEL2 Tile_X0Y0_UserCLK _1135_/X _0629_/L_HI VPWR VGND sg13cmos5l_dfrbpq_1
XFILLER_4_792 VPWR VGND sg13cmos5l_decap_8
XFILLER_3_280 VPWR VGND sg13cmos5l_decap_8
X_0454_ _0454_/Q Tile_X0Y0_FrameData[19] VGND VPWR Tile_X3Y0_FrameStrobe[1] latch
XFILLER_6_1025 VPWR VGND sg13cmos5l_decap_8
X_0385_ _0385_/Q Tile_X0Y0_FrameData[24] VGND VPWR Tile_X2Y0_FrameStrobe[2] latch
XFILLER_3_1957 VPWR VGND sg13cmos5l_decap_8
X_1006_ Tile_X1Y0_NN4BEG[10] _1210_/X VPWR VGND sg13cmos5l_buf_1
XFILLER_17_2302 VPWR VGND sg13cmos5l_fill_2
XFILLER_10_508 VPWR VGND sg13cmos5l_decap_8
XFILLER_17_2357 VPWR VGND sg13cmos5l_decap_8
XFILLER_17_1667 VPWR VGND sg13cmos5l_fill_2
XFILLER_15_2070 VPWR VGND sg13cmos5l_decap_8
XFILLER_11_1244 VPWR VGND sg13cmos5l_decap_8
XFILLER_11_1255 VPWR VGND sg13cmos5l_fill_2
XFILLER_2_707 VPWR VGND sg13cmos5l_decap_8
XFILLER_1_217 VPWR VGND sg13cmos5l_decap_8
XFILLER_8_1813 VPWR VGND sg13cmos5l_fill_2
XFILLER_8_1868 VPWR VGND sg13cmos5l_decap_4
XFILLER_6_2260 VPWR VGND sg13cmos5l_decap_8
XFILLER_2_2102 VPWR VGND sg13cmos5l_decap_8
XANTENNA__1082__X Tile_X2Y0_N2BEGb[6] VPWR VGND sg13cmos5l_antennanp
XFILLER_17_107 VPWR VGND sg13cmos5l_fill_1
XFILLER_2_2179 VPWR VGND sg13cmos5l_fill_1
XFILLER_2_1456 VPWR VGND sg13cmos5l_decap_8
XFILLER_16_1100 VPWR VGND sg13cmos5l_fill_2
XFILLER_16_1177 VPWR VGND sg13cmos5l_fill_1
XFILLER_12_1008 VPWR VGND sg13cmos5l_decap_8
XFILLER_5_534 VPWR VGND sg13cmos5l_decap_8
XFILLER_7_2013 VPWR VGND sg13cmos5l_decap_8
XFILLER_7_1301 VPWR VGND sg13cmos5l_decap_8
XFILLER_1_762 VPWR VGND sg13cmos5l_decap_8
XFILLER_7_1334 VPWR VGND sg13cmos5l_decap_8
X_0170_ _0170_/Q Tile_X0Y0_FrameData[15] VGND VPWR Tile_X0Y0_FrameStrobe[2] latch
XFILLER_16_140 VPWR VGND sg13cmos5l_decap_8
XFILLER_16_151 VPWR VGND sg13cmos5l_fill_2
XFILLER_12_2232 VPWR VGND sg13cmos5l_decap_8
XFILLER_12_1553 VPWR VGND sg13cmos5l_decap_4
XFILLER_12_1575 VPWR VGND sg13cmos5l_decap_4
X_0506_ _0506_/Q Tile_X0Y0_FrameData[31] VGND VPWR Tile_X3Y0_FrameStrobe[0] latch
X_0437_ _0437_/Q Tile_X0Y0_FrameData[4] VGND VPWR Tile_X3Y0_FrameStrobe[0] latch
X_0368_ _0368_/Q Tile_X0Y0_FrameData[9] VGND VPWR Tile_X2Y0_FrameStrobe[1] latch
X_0299_ _0299_/Q Tile_X0Y0_FrameData[30] VGND VPWR Tile_X1Y0_FrameStrobe[3] latch
XFILLER_3_1787 VPWR VGND sg13cmos5l_decap_8
XFILLER_17_2187 VPWR VGND sg13cmos5l_decap_8
XFILLER_17_1442 VPWR VGND sg13cmos5l_decap_8
XANTENNA__1077__X Tile_X2Y0_N2BEGb[1] VPWR VGND sg13cmos5l_antennanp
XFILLER_11_1063 VPWR VGND sg13cmos5l_decap_8
XFILLER_2_559 VPWR VGND sg13cmos5l_decap_8
XFILLER_8_2366 VPWR VGND sg13cmos5l_decap_8
XFILLER_8_1698 VPWR VGND sg13cmos5l_decap_8
XFILLER_18_405 VPWR VGND sg13cmos5l_fill_2
XFILLER_2_1231 VPWR VGND sg13cmos5l_fill_2
XANTENNA_201 Tile_X0Y0_FrameData[22] VPWR VGND sg13cmos5l_antennanp
XANTENNA_212 Tile_X0Y0_FrameData[23] VPWR VGND sg13cmos5l_antennanp
XANTENNA_223 Tile_X0Y0_FrameData[28] VPWR VGND sg13cmos5l_antennanp
XANTENNA_234 Tile_X0Y0_FrameData[28] VPWR VGND sg13cmos5l_antennanp
XANTENNA_245 Tile_X0Y0_FrameData[18] VPWR VGND sg13cmos5l_antennanp
XFILLER_14_699 VPWR VGND sg13cmos5l_decap_8
XFILLER_13_176 VPWR VGND sg13cmos5l_decap_8
XFILLER_13_1840 VPWR VGND sg13cmos5l_decap_8
XFILLER_13_1884 VPWR VGND sg13cmos5l_decap_8
XFILLER_9_1418 VPWR VGND sg13cmos5l_decap_8
X_1271_ _1271_/X Tile_X3Y0_S2MID[7] Tile_X3Y0_S4END[8] Tile_X3Y0_SS4END[7] _0575_/Q
+ _0475_/Q _0474_/Q VPWR VGND sg13cmos5l_mux4_1
XFILLER_3_77 VPWR VGND sg13cmos5l_decap_8
XFILLER_1_581 VPWR VGND sg13cmos5l_decap_8
X_0222_ _0222_/Q Tile_X0Y0_FrameData[11] VGND VPWR Tile_X1Y0_FrameStrobe[0] latch
XFILLER_7_1164 VPWR VGND sg13cmos5l_decap_8
XFILLER_3_1017 VPWR VGND sg13cmos5l_decap_8
X_0153_ _0153_/Q Tile_X0Y0_FrameData[0] VGND VPWR Tile_X0Y0_FrameStrobe[1] latch
XFILLER_18_950 VPWR VGND sg13cmos5l_decap_8
XFILLER_0_1949 VPWR VGND sg13cmos5l_decap_8
X_0084_ _0556_/D _0520_/Q _1093_/X VPWR VGND sg13cmos5l_nor2b_1
XFILLER_14_2327 VPWR VGND sg13cmos5l_decap_8
XFILLER_18_1784 VPWR VGND sg13cmos5l_fill_2
XFILLER_18_1773 VPWR VGND sg13cmos5l_decap_8
XFILLER_18_1762 VPWR VGND sg13cmos5l_fill_1
X_0986_ Tile_X2Y0_FrameStrobe_O[14] Tile_X2Y0_FrameStrobe[14] VPWR VGND sg13cmos5l_buf_1
XFILLER_14_1659 VPWR VGND sg13cmos5l_fill_1
XFILLER_12_2073 VPWR VGND sg13cmos5l_decap_8
XFILLER_12_1361 VPWR VGND sg13cmos5l_decap_8
XFILLER_9_1985 VPWR VGND sg13cmos5l_decap_8
XFILLER_5_1838 VPWR VGND sg13cmos5l_fill_2
XFILLER_5_1827 VPWR VGND sg13cmos5l_decap_8
XFILLER_3_2230 VPWR VGND sg13cmos5l_decap_8
XFILLER_3_1595 VPWR VGND sg13cmos5l_decap_8
XANTENNA__0704__X Tile_X2Y0_N4BEG[12] VPWR VGND sg13cmos5l_antennanp
XFILLER_11_636 VPWR VGND sg13cmos5l_fill_1
XFILLER_10_168 VPWR VGND sg13cmos5l_fill_2
XFILLER_13_1125 VPWR VGND sg13cmos5l_fill_1
XFILLER_11_669 VPWR VGND sg13cmos5l_fill_1
XFILLER_13_1158 VPWR VGND sg13cmos5l_fill_1
XFILLER_12_86 VPWR VGND sg13cmos5l_fill_2
XFILLER_12_75 VPWR VGND sg13cmos5l_decap_8
XFILLER_2_301 VPWR VGND sg13cmos5l_decap_8
XFILLER_8_2185 VPWR VGND sg13cmos5l_decap_8
XFILLER_8_1462 VPWR VGND sg13cmos5l_decap_8
XFILLER_4_2038 VPWR VGND sg13cmos5l_decap_8
XFILLER_4_1359 VPWR VGND sg13cmos5l_decap_8
XFILLER_18_268 VPWR VGND sg13cmos5l_decap_8
XFILLER_2_1094 VPWR VGND sg13cmos5l_decap_8
XFILLER_15_953 VPWR VGND sg13cmos5l_decap_8
XFILLER_18_1025 VPWR VGND sg13cmos5l_fill_2
XFILLER_14_452 VPWR VGND sg13cmos5l_decap_8
XFILLER_15_1902 VPWR VGND sg13cmos5l_decap_8
X_0840_ Tile_X4Y0_FrameStrobe_O[12] Tile_X4Y0_FrameStrobe[12] VPWR VGND sg13cmos5l_buf_1
X_0771_ Tile_X0Y0_NN4BEG[7] _1167_/X VPWR VGND sg13cmos5l_buf_1
XFILLER_13_2393 VPWR VGND sg13cmos5l_fill_2
XFILLER_5_150 VPWR VGND sg13cmos5l_decap_8
XFILLER_9_1226 VPWR VGND sg13cmos5l_decap_8
X_1254_ _1254_/X Tile_X2Y0_S2END[6] Tile_X2Y0_S4END[14] Tile_X2Y0_SS4END[1] _0587_/Q
+ _0333_/Q _0332_/Q VPWR VGND sg13cmos5l_mux4_1
X_0205_ _0205_/Q Tile_X0Y0_FrameData[28] VGND VPWR Tile_X1Y0_FrameStrobe[0] latch
X_1185_ _1185_/X Tile_X1Y0_S2MID[1] Tile_X1Y0_S4END[14] Tile_X1Y0_SS4END[1] _0589_/Q
+ _0295_/Q _0294_/Q VPWR VGND sg13cmos5l_mux4_1
XFILLER_4_1871 VPWR VGND sg13cmos5l_decap_8
XFILLER_0_1746 VPWR VGND sg13cmos5l_decap_8
X_0136_ _0136_/Q Tile_X0Y0_FrameData[17] VGND VPWR Tile_X0Y0_FrameStrobe[1] latch
XFILLER_0_1757 VPWR VGND sg13cmos5l_fill_1
XFILLER_14_2102 VPWR VGND sg13cmos5l_decap_8
XFILLER_18_2282 VPWR VGND sg13cmos5l_decap_4
XFILLER_14_1401 VPWR VGND sg13cmos5l_decap_8
X_0969_ Tile_X3Y0_NN4BEG[13] _1293_/X VPWR VGND sg13cmos5l_buf_1
XFILLER_14_1478 VPWR VGND sg13cmos5l_decap_8
XFILLER_0_805 VPWR VGND sg13cmos5l_decap_4
XFILLER_9_1793 VPWR VGND sg13cmos5l_decap_8
XFILLER_5_2369 VPWR VGND sg13cmos5l_decap_8
XFILLER_5_1613 VPWR VGND sg13cmos5l_decap_8
XFILLER_3_1392 VPWR VGND sg13cmos5l_decap_8
XFILLER_12_945 VPWR VGND sg13cmos5l_decap_8
XFILLER_11_400 VPWR VGND sg13cmos5l_decap_8
XFILLER_11_466 VPWR VGND sg13cmos5l_decap_8
XFILLER_14_1990 VPWR VGND sg13cmos5l_decap_8
XFILLER_10_1865 VPWR VGND sg13cmos5l_decap_8
XFILLER_3_0 VPWR VGND sg13cmos5l_decap_8
XFILLER_3_676 VPWR VGND sg13cmos5l_decap_8
XFILLER_2_175 VPWR VGND sg13cmos5l_decap_8
XFILLER_4_1112 VPWR VGND sg13cmos5l_decap_8
XFILLER_0_56 VPWR VGND sg13cmos5l_decap_8
XFILLER_4_1189 VPWR VGND sg13cmos5l_fill_2
XFILLER_9_21 VPWR VGND sg13cmos5l_decap_8
XFILLER_9_98 VPWR VGND sg13cmos5l_decap_8
X_0823_ Tile_X4Y0_FrameData_O[27] Tile_X0Y0_FrameData[27] VPWR VGND sg13cmos5l_buf_1
XFILLER_11_2319 VPWR VGND sg13cmos5l_decap_8
X_0754_ Tile_X0Y0_N4BEG[6] _1150_/X VPWR VGND sg13cmos5l_buf_1
XFILLER_6_470 VPWR VGND sg13cmos5l_decap_8
X_0685_ _0685_/L_HI VPWR VGND sg13cmos5l_tiehi
XFILLER_9_1001 VPWR VGND sg13cmos5l_decap_8
XFILLER_9_1034 VPWR VGND sg13cmos5l_decap_8
XFILLER_6_1911 VPWR VGND sg13cmos5l_decap_8
X_1237_ _1237_/X Tile_X2Y0_S2MID[5] Tile_X2Y0_S4END[2] Tile_X2Y0_SS4END[13] _0587_/Q
+ _0367_/Q _0366_/Q VPWR VGND sg13cmos5l_mux4_1
XFILLER_6_1988 VPWR VGND sg13cmos5l_decap_8
XFILLER_0_1510 VPWR VGND sg13cmos5l_decap_8
X_1168_ _1168_/X Tile_X0Y0_S2END[0] Tile_X0Y0_S4END[8] Tile_X0Y0_SS4END[7] _0601_/Q
+ _0137_/Q _0136_/Q VPWR VGND sg13cmos5l_mux4_1
XFILLER_0_1554 VPWR VGND sg13cmos5l_decap_8
XFILLER_0_2277 VPWR VGND sg13cmos5l_decap_8
X_0119_ _0119_/Q Tile_X0Y0_FrameData[2] VGND VPWR Tile_X0Y0_FrameStrobe[0] latch
XFILLER_0_1565 VPWR VGND sg13cmos5l_fill_1
X_1099_ _1099_/X Tile_X3Y0_S1END[2] Tile_X3Y0_S2MID[1] Tile_X3Y0_S2MID[6] Tile_X3Y0_S2END[1]
+ _0413_/Q _0412_/Q VPWR VGND sg13cmos5l_mux4_1
XFILLER_16_2219 VPWR VGND sg13cmos5l_fill_2
XFILLER_12_219 VPWR VGND sg13cmos5l_fill_1
XFILLER_14_1231 VPWR VGND sg13cmos5l_decap_8
XFILLER_4_407 VPWR VGND sg13cmos5l_decap_8
XFILLER_14_1275 VPWR VGND sg13cmos5l_decap_4
XFILLER_14_1297 VPWR VGND sg13cmos5l_decap_4
XFILLER_0_613 VPWR VGND sg13cmos5l_decap_4
XFILLER_5_2166 VPWR VGND sg13cmos5l_decap_8
XFILLER_5_1410 VPWR VGND sg13cmos5l_decap_8
XFILLER_5_1487 VPWR VGND sg13cmos5l_decap_8
XFILLER_16_503 VPWR VGND sg13cmos5l_decap_8
XFILLER_12_742 VPWR VGND sg13cmos5l_fill_2
XFILLER_11_230 VPWR VGND sg13cmos5l_decap_8
XFILLER_7_212 VPWR VGND sg13cmos5l_decap_8
XFILLER_12_786 VPWR VGND sg13cmos5l_fill_1
XFILLER_12_1905 VPWR VGND sg13cmos5l_decap_8
XFILLER_7_234 VPWR VGND sg13cmos5l_decap_4
XFILLER_10_2341 VPWR VGND sg13cmos5l_decap_8
XFILLER_7_267 VPWR VGND sg13cmos5l_decap_4
XFILLER_10_1651 VPWR VGND sg13cmos5l_fill_1
XFILLER_4_930 VPWR VGND sg13cmos5l_decap_8
X_0470_ _0470_/Q Tile_X0Y0_FrameData[3] VGND VPWR Tile_X3Y0_FrameStrobe[1] latch
XFILLER_3_473 VPWR VGND sg13cmos5l_decap_8
X_1022_ Tile_X1Y0_N4BEG[10] _1194_/X VPWR VGND sg13cmos5l_buf_1
XFILLER_1_1841 VPWR VGND sg13cmos5l_decap_8
XFILLER_17_1816 VPWR VGND sg13cmos5l_decap_8
XFILLER_17_1849 VPWR VGND sg13cmos5l_decap_8
XFILLER_15_2230 VPWR VGND sg13cmos5l_decap_8
XFILLER_15_1573 VPWR VGND sg13cmos5l_decap_4
XANTENNA__0802__X Tile_X4Y0_FrameData_O[6] VPWR VGND sg13cmos5l_antennanp
X_0806_ Tile_X4Y0_FrameData_O[10] Tile_X0Y0_FrameData[10] VPWR VGND sg13cmos5l_buf_1
XFILLER_11_1459 VPWR VGND sg13cmos5l_decap_8
X_0737_ Tile_X0Y0_N2BEG[5] Tile_X0Y0_S2MID[2] VPWR VGND sg13cmos5l_buf_1
X_0668_ _0668_/L_HI VPWR VGND sg13cmos5l_tiehi
X_0599_ _0599_/Q Tile_X0Y0_UserCLK NPU_RDATA27 _0615_/L_HI VPWR VGND sg13cmos5l_dfrbpq_1
XFILLER_6_1796 VPWR VGND sg13cmos5l_decap_8
XFILLER_2_1638 VPWR VGND sg13cmos5l_decap_8
XFILLER_0_1373 VPWR VGND sg13cmos5l_decap_8
XFILLER_0_2096 VPWR VGND sg13cmos5l_decap_8
XFILLER_16_2027 VPWR VGND sg13cmos5l_fill_2
XFILLER_16_1326 VPWR VGND sg13cmos5l_decap_8
XANTENNA__0712__X Tile_X0Y0_FrameStrobe_O[4] VPWR VGND sg13cmos5l_antennanp
XFILLER_11_1971 VPWR VGND sg13cmos5l_decap_8
XFILLER_4_259 VPWR VGND sg13cmos5l_decap_8
XFILLER_1_911 VPWR VGND sg13cmos5l_fill_1
XFILLER_7_2228 VPWR VGND sg13cmos5l_decap_8
XFILLER_7_1527 VPWR VGND sg13cmos5l_decap_8
XFILLER_1_955 VPWR VGND sg13cmos5l_fill_2
XFILLER_0_476 VPWR VGND sg13cmos5l_decap_8
XFILLER_5_1284 VPWR VGND sg13cmos5l_decap_8
XFILLER_1_1115 VPWR VGND sg13cmos5l_decap_8
XFILLER_16_300 VPWR VGND sg13cmos5l_fill_1
XFILLER_16_355 VPWR VGND sg13cmos5l_decap_8
XFILLER_16_388 VPWR VGND sg13cmos5l_decap_4
XFILLER_8_521 VPWR VGND sg13cmos5l_decap_8
XFILLER_12_594 VPWR VGND sg13cmos5l_fill_2
XFILLER_8_587 VPWR VGND sg13cmos5l_decap_8
XANTENNA_4 _1098_/X VPWR VGND sg13cmos5l_antennanp
XFILLER_10_2160 VPWR VGND sg13cmos5l_decap_8
XFILLER_10_2171 VPWR VGND sg13cmos5l_fill_2
X_0522_ NPU_READ_BANK_SEL1 Tile_X0Y0_UserCLK _1134_/X _0630_/L_HI VPWR VGND sg13cmos5l_dfrbpq_1
XFILLER_6_77 VPWR VGND sg13cmos5l_decap_8
XFILLER_4_771 VPWR VGND sg13cmos5l_decap_8
XFILLER_10_1481 VPWR VGND sg13cmos5l_decap_8
X_0453_ _0453_/Q Tile_X0Y0_FrameData[20] VGND VPWR Tile_X3Y0_FrameStrobe[1] latch
X_0384_ _0384_/Q Tile_X0Y0_FrameData[25] VGND VPWR Tile_X2Y0_FrameStrobe[2] latch
XFILLER_6_1004 VPWR VGND sg13cmos5l_decap_8
XFILLER_3_1936 VPWR VGND sg13cmos5l_decap_8
X_1005_ Tile_X1Y0_NN4BEG[9] _1209_/X VPWR VGND sg13cmos5l_buf_1
XFILLER_1_2394 VPWR VGND sg13cmos5l_decap_8
XFILLER_17_2336 VPWR VGND sg13cmos5l_decap_8
XFILLER_11_1267 VPWR VGND sg13cmos5l_decap_8
XFILLER_2_719 VPWR VGND sg13cmos5l_decap_8
XFILLER_8_1825 VPWR VGND sg13cmos5l_decap_8
XFILLER_8_1847 VPWR VGND sg13cmos5l_decap_8
XFILLER_2_2158 VPWR VGND sg13cmos5l_decap_8
XFILLER_2_1435 VPWR VGND sg13cmos5l_decap_8
XANTENNA__0707__X Tile_X2Y0_N4BEG[15] VPWR VGND sg13cmos5l_antennanp
XFILLER_14_815 VPWR VGND sg13cmos5l_decap_4
XFILLER_0_1181 VPWR VGND sg13cmos5l_decap_8
XFILLER_14_826 VPWR VGND sg13cmos5l_decap_4
XFILLER_9_329 VPWR VGND sg13cmos5l_fill_1
XFILLER_16_1123 VPWR VGND sg13cmos5l_decap_4
XFILLER_16_1156 VPWR VGND sg13cmos5l_fill_2
XFILLER_5_513 VPWR VGND sg13cmos5l_decap_8
XFILLER_1_741 VPWR VGND sg13cmos5l_decap_8
XFILLER_0_240 VPWR VGND sg13cmos5l_decap_8
XFILLER_0_251 VPWR VGND sg13cmos5l_fill_2
XFILLER_7_2069 VPWR VGND sg13cmos5l_decap_8
XFILLER_5_1092 VPWR VGND sg13cmos5l_decap_8
XFILLER_16_163 VPWR VGND sg13cmos5l_fill_1
XFILLER_18_1922 VPWR VGND sg13cmos5l_decap_8
XFILLER_13_870 VPWR VGND sg13cmos5l_fill_1
XFILLER_18_1999 VPWR VGND sg13cmos5l_fill_1
XFILLER_9_896 VPWR VGND sg13cmos5l_decap_8
XFILLER_12_2288 VPWR VGND sg13cmos5l_decap_8
XFILLER_12_1598 VPWR VGND sg13cmos5l_decap_8
X_0505_ _0505_/Q Tile_X0Y0_FrameData[0] VGND VPWR Tile_X3Y0_FrameStrobe[2] latch
X_0436_ _0436_/Q Tile_X0Y0_FrameData[5] VGND VPWR Tile_X3Y0_FrameStrobe[0] latch
.ends
