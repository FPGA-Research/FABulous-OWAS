* NGSPICE file created from AXIL_S_IO_W.ext - technology: ihp-sg13cmos5l

* Black-box entry subcircuit for sg13cmos5l_decap_8 abstract view
.subckt sg13cmos5l_decap_8 VDD VSS
.ends

* Black-box entry subcircuit for sg13cmos5l_antennanp abstract view
.subckt sg13cmos5l_antennanp A VDD VSS
.ends

* Black-box entry subcircuit for latch abstract view
.subckt latch Q D VSS VDD GATE
.ends

* Black-box entry subcircuit for sg13cmos5l_mux4_1 abstract view
.subckt sg13cmos5l_mux4_1 X A0 A1 A2 A3 S0 S1 VDD VSS
.ends

* Black-box entry subcircuit for sg13cmos5l_fill_1 abstract view
.subckt sg13cmos5l_fill_1 VDD VSS
.ends

* Black-box entry subcircuit for sg13cmos5l_buf_1 abstract view
.subckt sg13cmos5l_buf_1 X A VDD VSS
.ends

* Black-box entry subcircuit for sg13cmos5l_decap_4 abstract view
.subckt sg13cmos5l_decap_4 VDD VSS
.ends

* Black-box entry subcircuit for sg13cmos5l_fill_2 abstract view
.subckt sg13cmos5l_fill_2 VDD VSS
.ends

* Black-box entry subcircuit for sg13cmos5l_mux2_1 abstract view
.subckt sg13cmos5l_mux2_1 X A0 A1 S VDD VSS
.ends

* Black-box entry subcircuit for sg13cmos5l_tielo abstract view
.subckt sg13cmos5l_tielo L_LO VDD VSS
.ends

.subckt AXIL_S_IO_W AXIL_S_SOC_ARADDR0 AXIL_S_SOC_ARADDR1 AXIL_S_SOC_ARADDR2 AXIL_S_SOC_ARADDR3
+ AXIL_S_SOC_ARADDR4 AXIL_S_SOC_ARADDR5 AXIL_S_SOC_ARADDR6 AXIL_S_SOC_ARADDR7 AXIL_S_SOC_ARADDR8
+ AXIL_S_SOC_ARADDR9 AXIL_S_SOC_ARPROT0 AXIL_S_SOC_ARPROT1 AXIL_S_SOC_ARPROT2 AXIL_S_SOC_ARREADY
+ AXIL_S_SOC_ARVALID AXIL_S_SOC_AWADDR0 AXIL_S_SOC_AWADDR1 AXIL_S_SOC_AWADDR2 AXIL_S_SOC_AWADDR3
+ AXIL_S_SOC_AWADDR4 AXIL_S_SOC_AWADDR5 AXIL_S_SOC_AWADDR6 AXIL_S_SOC_AWADDR7 AXIL_S_SOC_AWADDR8
+ AXIL_S_SOC_AWADDR9 AXIL_S_SOC_AWPROT0 AXIL_S_SOC_AWPROT1 AXIL_S_SOC_AWPROT2 AXIL_S_SOC_AWREADY
+ AXIL_S_SOC_AWVALID AXIL_S_SOC_BREADY AXIL_S_SOC_BRESP0 AXIL_S_SOC_BRESP1 AXIL_S_SOC_BVALID
+ AXIL_S_SOC_RDATA0 AXIL_S_SOC_RDATA1 AXIL_S_SOC_RDATA10 AXIL_S_SOC_RDATA11 AXIL_S_SOC_RDATA12
+ AXIL_S_SOC_RDATA13 AXIL_S_SOC_RDATA14 AXIL_S_SOC_RDATA15 AXIL_S_SOC_RDATA16 AXIL_S_SOC_RDATA17
+ AXIL_S_SOC_RDATA18 AXIL_S_SOC_RDATA19 AXIL_S_SOC_RDATA2 AXIL_S_SOC_RDATA20 AXIL_S_SOC_RDATA21
+ AXIL_S_SOC_RDATA22 AXIL_S_SOC_RDATA23 AXIL_S_SOC_RDATA24 AXIL_S_SOC_RDATA25 AXIL_S_SOC_RDATA26
+ AXIL_S_SOC_RDATA27 AXIL_S_SOC_RDATA28 AXIL_S_SOC_RDATA29 AXIL_S_SOC_RDATA3 AXIL_S_SOC_RDATA30
+ AXIL_S_SOC_RDATA31 AXIL_S_SOC_RDATA4 AXIL_S_SOC_RDATA5 AXIL_S_SOC_RDATA6 AXIL_S_SOC_RDATA7
+ AXIL_S_SOC_RDATA8 AXIL_S_SOC_RDATA9 AXIL_S_SOC_RREADY AXIL_S_SOC_RRESP0 AXIL_S_SOC_RRESP1
+ AXIL_S_SOC_RVALID AXIL_S_SOC_WDATA0 AXIL_S_SOC_WDATA1 AXIL_S_SOC_WDATA10 AXIL_S_SOC_WDATA11
+ AXIL_S_SOC_WDATA12 AXIL_S_SOC_WDATA13 AXIL_S_SOC_WDATA14 AXIL_S_SOC_WDATA15 AXIL_S_SOC_WDATA16
+ AXIL_S_SOC_WDATA17 AXIL_S_SOC_WDATA18 AXIL_S_SOC_WDATA19 AXIL_S_SOC_WDATA2 AXIL_S_SOC_WDATA20
+ AXIL_S_SOC_WDATA21 AXIL_S_SOC_WDATA22 AXIL_S_SOC_WDATA23 AXIL_S_SOC_WDATA24 AXIL_S_SOC_WDATA25
+ AXIL_S_SOC_WDATA26 AXIL_S_SOC_WDATA27 AXIL_S_SOC_WDATA28 AXIL_S_SOC_WDATA29 AXIL_S_SOC_WDATA3
+ AXIL_S_SOC_WDATA30 AXIL_S_SOC_WDATA31 AXIL_S_SOC_WDATA4 AXIL_S_SOC_WDATA5 AXIL_S_SOC_WDATA6
+ AXIL_S_SOC_WDATA7 AXIL_S_SOC_WDATA8 AXIL_S_SOC_WDATA9 AXIL_S_SOC_WREADY AXIL_S_SOC_WSTRB0
+ AXIL_S_SOC_WSTRB1 AXIL_S_SOC_WSTRB2 AXIL_S_SOC_WSTRB3 AXIL_S_SOC_WVALID Tile_X0Y0_E1BEG[0]
+ Tile_X0Y0_E1BEG[1] Tile_X0Y0_E1BEG[2] Tile_X0Y0_E1BEG[3] Tile_X0Y0_E2BEG[0] Tile_X0Y0_E2BEG[1]
+ Tile_X0Y0_E2BEG[2] Tile_X0Y0_E2BEG[3] Tile_X0Y0_E2BEG[4] Tile_X0Y0_E2BEG[5] Tile_X0Y0_E2BEG[6]
+ Tile_X0Y0_E2BEG[7] Tile_X0Y0_E2BEGb[0] Tile_X0Y0_E2BEGb[1] Tile_X0Y0_E2BEGb[2] Tile_X0Y0_E2BEGb[3]
+ Tile_X0Y0_E2BEGb[4] Tile_X0Y0_E2BEGb[5] Tile_X0Y0_E2BEGb[6] Tile_X0Y0_E2BEGb[7]
+ Tile_X0Y0_E6BEG[0] Tile_X0Y0_E6BEG[10] Tile_X0Y0_E6BEG[11] Tile_X0Y0_E6BEG[1] Tile_X0Y0_E6BEG[2]
+ Tile_X0Y0_E6BEG[3] Tile_X0Y0_E6BEG[4] Tile_X0Y0_E6BEG[5] Tile_X0Y0_E6BEG[6] Tile_X0Y0_E6BEG[7]
+ Tile_X0Y0_E6BEG[8] Tile_X0Y0_E6BEG[9] Tile_X0Y0_EE4BEG[0] Tile_X0Y0_EE4BEG[10] Tile_X0Y0_EE4BEG[11]
+ Tile_X0Y0_EE4BEG[12] Tile_X0Y0_EE4BEG[13] Tile_X0Y0_EE4BEG[14] Tile_X0Y0_EE4BEG[15]
+ Tile_X0Y0_EE4BEG[1] Tile_X0Y0_EE4BEG[2] Tile_X0Y0_EE4BEG[3] Tile_X0Y0_EE4BEG[4]
+ Tile_X0Y0_EE4BEG[5] Tile_X0Y0_EE4BEG[6] Tile_X0Y0_EE4BEG[7] Tile_X0Y0_EE4BEG[8]
+ Tile_X0Y0_EE4BEG[9] Tile_X0Y0_FrameData[0] Tile_X0Y0_FrameData[10] Tile_X0Y0_FrameData[11]
+ Tile_X0Y0_FrameData[12] Tile_X0Y0_FrameData[13] Tile_X0Y0_FrameData[14] Tile_X0Y0_FrameData[15]
+ Tile_X0Y0_FrameData[16] Tile_X0Y0_FrameData[17] Tile_X0Y0_FrameData[18] Tile_X0Y0_FrameData[19]
+ Tile_X0Y0_FrameData[1] Tile_X0Y0_FrameData[20] Tile_X0Y0_FrameData[21] Tile_X0Y0_FrameData[22]
+ Tile_X0Y0_FrameData[23] Tile_X0Y0_FrameData[24] Tile_X0Y0_FrameData[25] Tile_X0Y0_FrameData[26]
+ Tile_X0Y0_FrameData[27] Tile_X0Y0_FrameData[28] Tile_X0Y0_FrameData[29] Tile_X0Y0_FrameData[2]
+ Tile_X0Y0_FrameData[30] Tile_X0Y0_FrameData[31] Tile_X0Y0_FrameData[3] Tile_X0Y0_FrameData[4]
+ Tile_X0Y0_FrameData[5] Tile_X0Y0_FrameData[6] Tile_X0Y0_FrameData[7] Tile_X0Y0_FrameData[8]
+ Tile_X0Y0_FrameData[9] Tile_X0Y0_FrameData_O[0] Tile_X0Y0_FrameData_O[10] Tile_X0Y0_FrameData_O[11]
+ Tile_X0Y0_FrameData_O[12] Tile_X0Y0_FrameData_O[13] Tile_X0Y0_FrameData_O[14] Tile_X0Y0_FrameData_O[15]
+ Tile_X0Y0_FrameData_O[16] Tile_X0Y0_FrameData_O[17] Tile_X0Y0_FrameData_O[18] Tile_X0Y0_FrameData_O[19]
+ Tile_X0Y0_FrameData_O[1] Tile_X0Y0_FrameData_O[20] Tile_X0Y0_FrameData_O[21] Tile_X0Y0_FrameData_O[22]
+ Tile_X0Y0_FrameData_O[23] Tile_X0Y0_FrameData_O[24] Tile_X0Y0_FrameData_O[25] Tile_X0Y0_FrameData_O[26]
+ Tile_X0Y0_FrameData_O[27] Tile_X0Y0_FrameData_O[28] Tile_X0Y0_FrameData_O[29] Tile_X0Y0_FrameData_O[2]
+ Tile_X0Y0_FrameData_O[30] Tile_X0Y0_FrameData_O[31] Tile_X0Y0_FrameData_O[3] Tile_X0Y0_FrameData_O[4]
+ Tile_X0Y0_FrameData_O[5] Tile_X0Y0_FrameData_O[6] Tile_X0Y0_FrameData_O[7] Tile_X0Y0_FrameData_O[8]
+ Tile_X0Y0_FrameData_O[9] Tile_X0Y0_FrameStrobe_O[0] Tile_X0Y0_FrameStrobe_O[10]
+ Tile_X0Y0_FrameStrobe_O[11] Tile_X0Y0_FrameStrobe_O[12] Tile_X0Y0_FrameStrobe_O[13]
+ Tile_X0Y0_FrameStrobe_O[14] Tile_X0Y0_FrameStrobe_O[15] Tile_X0Y0_FrameStrobe_O[16]
+ Tile_X0Y0_FrameStrobe_O[17] Tile_X0Y0_FrameStrobe_O[18] Tile_X0Y0_FrameStrobe_O[19]
+ Tile_X0Y0_FrameStrobe_O[1] Tile_X0Y0_FrameStrobe_O[2] Tile_X0Y0_FrameStrobe_O[3]
+ Tile_X0Y0_FrameStrobe_O[4] Tile_X0Y0_FrameStrobe_O[5] Tile_X0Y0_FrameStrobe_O[6]
+ Tile_X0Y0_FrameStrobe_O[7] Tile_X0Y0_FrameStrobe_O[8] Tile_X0Y0_FrameStrobe_O[9]
+ Tile_X0Y0_N1BEG[0] Tile_X0Y0_N1BEG[1] Tile_X0Y0_N1BEG[2] Tile_X0Y0_N1BEG[3] Tile_X0Y0_N2BEG[0]
+ Tile_X0Y0_N2BEG[1] Tile_X0Y0_N2BEG[2] Tile_X0Y0_N2BEG[3] Tile_X0Y0_N2BEG[4] Tile_X0Y0_N2BEG[5]
+ Tile_X0Y0_N2BEG[6] Tile_X0Y0_N2BEG[7] Tile_X0Y0_N2BEGb[0] Tile_X0Y0_N2BEGb[1] Tile_X0Y0_N2BEGb[2]
+ Tile_X0Y0_N2BEGb[3] Tile_X0Y0_N2BEGb[4] Tile_X0Y0_N2BEGb[5] Tile_X0Y0_N2BEGb[6]
+ Tile_X0Y0_N2BEGb[7] Tile_X0Y0_N4BEG[0] Tile_X0Y0_N4BEG[10] Tile_X0Y0_N4BEG[11] Tile_X0Y0_N4BEG[12]
+ Tile_X0Y0_N4BEG[13] Tile_X0Y0_N4BEG[14] Tile_X0Y0_N4BEG[15] Tile_X0Y0_N4BEG[1] Tile_X0Y0_N4BEG[2]
+ Tile_X0Y0_N4BEG[3] Tile_X0Y0_N4BEG[4] Tile_X0Y0_N4BEG[5] Tile_X0Y0_N4BEG[6] Tile_X0Y0_N4BEG[7]
+ Tile_X0Y0_N4BEG[8] Tile_X0Y0_N4BEG[9] Tile_X0Y0_S1END[0] Tile_X0Y0_S1END[1] Tile_X0Y0_S1END[2]
+ Tile_X0Y0_S1END[3] Tile_X0Y0_S2END[0] Tile_X0Y0_S2END[1] Tile_X0Y0_S2END[2] Tile_X0Y0_S2END[3]
+ Tile_X0Y0_S2END[4] Tile_X0Y0_S2END[5] Tile_X0Y0_S2END[6] Tile_X0Y0_S2END[7] Tile_X0Y0_S2MID[0]
+ Tile_X0Y0_S2MID[1] Tile_X0Y0_S2MID[2] Tile_X0Y0_S2MID[3] Tile_X0Y0_S2MID[4] Tile_X0Y0_S2MID[5]
+ Tile_X0Y0_S2MID[6] Tile_X0Y0_S2MID[7] Tile_X0Y0_S4END[0] Tile_X0Y0_S4END[10] Tile_X0Y0_S4END[11]
+ Tile_X0Y0_S4END[12] Tile_X0Y0_S4END[13] Tile_X0Y0_S4END[14] Tile_X0Y0_S4END[15]
+ Tile_X0Y0_S4END[1] Tile_X0Y0_S4END[2] Tile_X0Y0_S4END[3] Tile_X0Y0_S4END[4] Tile_X0Y0_S4END[5]
+ Tile_X0Y0_S4END[6] Tile_X0Y0_S4END[7] Tile_X0Y0_S4END[8] Tile_X0Y0_S4END[9] Tile_X0Y0_UserCLK
+ Tile_X0Y0_UserCLKo Tile_X0Y0_W1END[0] Tile_X0Y0_W1END[1] Tile_X0Y0_W1END[2] Tile_X0Y0_W1END[3]
+ Tile_X0Y0_W2END[0] Tile_X0Y0_W2END[1] Tile_X0Y0_W2END[2] Tile_X0Y0_W2END[3] Tile_X0Y0_W2END[4]
+ Tile_X0Y0_W2END[5] Tile_X0Y0_W2END[6] Tile_X0Y0_W2END[7] Tile_X0Y0_W2MID[0] Tile_X0Y0_W2MID[1]
+ Tile_X0Y0_W2MID[2] Tile_X0Y0_W2MID[3] Tile_X0Y0_W2MID[4] Tile_X0Y0_W2MID[5] Tile_X0Y0_W2MID[6]
+ Tile_X0Y0_W2MID[7] Tile_X0Y0_W6END[0] Tile_X0Y0_W6END[10] Tile_X0Y0_W6END[11] Tile_X0Y0_W6END[1]
+ Tile_X0Y0_W6END[2] Tile_X0Y0_W6END[3] Tile_X0Y0_W6END[4] Tile_X0Y0_W6END[5] Tile_X0Y0_W6END[6]
+ Tile_X0Y0_W6END[7] Tile_X0Y0_W6END[8] Tile_X0Y0_W6END[9] Tile_X0Y0_WW4END[0] Tile_X0Y0_WW4END[10]
+ Tile_X0Y0_WW4END[11] Tile_X0Y0_WW4END[12] Tile_X0Y0_WW4END[13] Tile_X0Y0_WW4END[14]
+ Tile_X0Y0_WW4END[15] Tile_X0Y0_WW4END[1] Tile_X0Y0_WW4END[2] Tile_X0Y0_WW4END[3]
+ Tile_X0Y0_WW4END[4] Tile_X0Y0_WW4END[5] Tile_X0Y0_WW4END[6] Tile_X0Y0_WW4END[7]
+ Tile_X0Y0_WW4END[8] Tile_X0Y0_WW4END[9] Tile_X0Y1_E1BEG[0] Tile_X0Y1_E1BEG[1] Tile_X0Y1_E1BEG[2]
+ Tile_X0Y1_E1BEG[3] Tile_X0Y1_E2BEG[0] Tile_X0Y1_E2BEG[1] Tile_X0Y1_E2BEG[2] Tile_X0Y1_E2BEG[3]
+ Tile_X0Y1_E2BEG[4] Tile_X0Y1_E2BEG[5] Tile_X0Y1_E2BEG[6] Tile_X0Y1_E2BEG[7] Tile_X0Y1_E2BEGb[0]
+ Tile_X0Y1_E2BEGb[1] Tile_X0Y1_E2BEGb[2] Tile_X0Y1_E2BEGb[3] Tile_X0Y1_E2BEGb[4]
+ Tile_X0Y1_E2BEGb[5] Tile_X0Y1_E2BEGb[6] Tile_X0Y1_E2BEGb[7] Tile_X0Y1_E6BEG[0] Tile_X0Y1_E6BEG[10]
+ Tile_X0Y1_E6BEG[11] Tile_X0Y1_E6BEG[1] Tile_X0Y1_E6BEG[2] Tile_X0Y1_E6BEG[3] Tile_X0Y1_E6BEG[4]
+ Tile_X0Y1_E6BEG[5] Tile_X0Y1_E6BEG[6] Tile_X0Y1_E6BEG[7] Tile_X0Y1_E6BEG[8] Tile_X0Y1_E6BEG[9]
+ Tile_X0Y1_EE4BEG[0] Tile_X0Y1_EE4BEG[10] Tile_X0Y1_EE4BEG[11] Tile_X0Y1_EE4BEG[12]
+ Tile_X0Y1_EE4BEG[13] Tile_X0Y1_EE4BEG[14] Tile_X0Y1_EE4BEG[15] Tile_X0Y1_EE4BEG[1]
+ Tile_X0Y1_EE4BEG[2] Tile_X0Y1_EE4BEG[3] Tile_X0Y1_EE4BEG[4] Tile_X0Y1_EE4BEG[5]
+ Tile_X0Y1_EE4BEG[6] Tile_X0Y1_EE4BEG[7] Tile_X0Y1_EE4BEG[8] Tile_X0Y1_EE4BEG[9]
+ Tile_X0Y1_FrameData[0] Tile_X0Y1_FrameData[10] Tile_X0Y1_FrameData[11] Tile_X0Y1_FrameData[12]
+ Tile_X0Y1_FrameData[13] Tile_X0Y1_FrameData[14] Tile_X0Y1_FrameData[15] Tile_X0Y1_FrameData[16]
+ Tile_X0Y1_FrameData[17] Tile_X0Y1_FrameData[18] Tile_X0Y1_FrameData[19] Tile_X0Y1_FrameData[1]
+ Tile_X0Y1_FrameData[20] Tile_X0Y1_FrameData[21] Tile_X0Y1_FrameData[22] Tile_X0Y1_FrameData[23]
+ Tile_X0Y1_FrameData[24] Tile_X0Y1_FrameData[25] Tile_X0Y1_FrameData[26] Tile_X0Y1_FrameData[27]
+ Tile_X0Y1_FrameData[28] Tile_X0Y1_FrameData[29] Tile_X0Y1_FrameData[2] Tile_X0Y1_FrameData[30]
+ Tile_X0Y1_FrameData[31] Tile_X0Y1_FrameData[3] Tile_X0Y1_FrameData[4] Tile_X0Y1_FrameData[5]
+ Tile_X0Y1_FrameData[6] Tile_X0Y1_FrameData[7] Tile_X0Y1_FrameData[8] Tile_X0Y1_FrameData[9]
+ Tile_X0Y1_FrameData_O[0] Tile_X0Y1_FrameData_O[10] Tile_X0Y1_FrameData_O[11] Tile_X0Y1_FrameData_O[12]
+ Tile_X0Y1_FrameData_O[13] Tile_X0Y1_FrameData_O[14] Tile_X0Y1_FrameData_O[15] Tile_X0Y1_FrameData_O[16]
+ Tile_X0Y1_FrameData_O[17] Tile_X0Y1_FrameData_O[18] Tile_X0Y1_FrameData_O[19] Tile_X0Y1_FrameData_O[1]
+ Tile_X0Y1_FrameData_O[20] Tile_X0Y1_FrameData_O[21] Tile_X0Y1_FrameData_O[22] Tile_X0Y1_FrameData_O[23]
+ Tile_X0Y1_FrameData_O[24] Tile_X0Y1_FrameData_O[25] Tile_X0Y1_FrameData_O[26] Tile_X0Y1_FrameData_O[27]
+ Tile_X0Y1_FrameData_O[28] Tile_X0Y1_FrameData_O[29] Tile_X0Y1_FrameData_O[2] Tile_X0Y1_FrameData_O[30]
+ Tile_X0Y1_FrameData_O[31] Tile_X0Y1_FrameData_O[3] Tile_X0Y1_FrameData_O[4] Tile_X0Y1_FrameData_O[5]
+ Tile_X0Y1_FrameData_O[6] Tile_X0Y1_FrameData_O[7] Tile_X0Y1_FrameData_O[8] Tile_X0Y1_FrameData_O[9]
+ Tile_X0Y1_UserCLK Tile_X0Y1_UserCLKo Tile_X0Y1_W1END[0] Tile_X0Y1_W1END[1] Tile_X0Y1_W1END[2]
+ Tile_X0Y1_W1END[3] Tile_X0Y1_W2END[0] Tile_X0Y1_W2END[1] Tile_X0Y1_W2END[2] Tile_X0Y1_W2END[3]
+ Tile_X0Y1_W2END[4] Tile_X0Y1_W2END[5] Tile_X0Y1_W2END[6] Tile_X0Y1_W2END[7] Tile_X0Y1_W2MID[0]
+ Tile_X0Y1_W2MID[1] Tile_X0Y1_W2MID[2] Tile_X0Y1_W2MID[3] Tile_X0Y1_W2MID[4] Tile_X0Y1_W2MID[5]
+ Tile_X0Y1_W2MID[6] Tile_X0Y1_W2MID[7] Tile_X0Y1_W6END[0] Tile_X0Y1_W6END[10] Tile_X0Y1_W6END[11]
+ Tile_X0Y1_W6END[1] Tile_X0Y1_W6END[2] Tile_X0Y1_W6END[3] Tile_X0Y1_W6END[4] Tile_X0Y1_W6END[5]
+ Tile_X0Y1_W6END[6] Tile_X0Y1_W6END[7] Tile_X0Y1_W6END[8] Tile_X0Y1_W6END[9] Tile_X0Y1_WW4END[0]
+ Tile_X0Y1_WW4END[10] Tile_X0Y1_WW4END[11] Tile_X0Y1_WW4END[12] Tile_X0Y1_WW4END[13]
+ Tile_X0Y1_WW4END[14] Tile_X0Y1_WW4END[15] Tile_X0Y1_WW4END[1] Tile_X0Y1_WW4END[2]
+ Tile_X0Y1_WW4END[3] Tile_X0Y1_WW4END[4] Tile_X0Y1_WW4END[5] Tile_X0Y1_WW4END[6]
+ Tile_X0Y1_WW4END[7] Tile_X0Y1_WW4END[8] Tile_X0Y1_WW4END[9] Tile_X0Y2_E1BEG[0] Tile_X0Y2_E1BEG[1]
+ Tile_X0Y2_E1BEG[2] Tile_X0Y2_E1BEG[3] Tile_X0Y2_E2BEG[0] Tile_X0Y2_E2BEG[1] Tile_X0Y2_E2BEG[2]
+ Tile_X0Y2_E2BEG[3] Tile_X0Y2_E2BEG[4] Tile_X0Y2_E2BEG[5] Tile_X0Y2_E2BEG[6] Tile_X0Y2_E2BEG[7]
+ Tile_X0Y2_E2BEGb[0] Tile_X0Y2_E2BEGb[1] Tile_X0Y2_E2BEGb[2] Tile_X0Y2_E2BEGb[3]
+ Tile_X0Y2_E2BEGb[4] Tile_X0Y2_E2BEGb[5] Tile_X0Y2_E2BEGb[6] Tile_X0Y2_E2BEGb[7]
+ Tile_X0Y2_E6BEG[0] Tile_X0Y2_E6BEG[10] Tile_X0Y2_E6BEG[11] Tile_X0Y2_E6BEG[1] Tile_X0Y2_E6BEG[2]
+ Tile_X0Y2_E6BEG[3] Tile_X0Y2_E6BEG[4] Tile_X0Y2_E6BEG[5] Tile_X0Y2_E6BEG[6] Tile_X0Y2_E6BEG[7]
+ Tile_X0Y2_E6BEG[8] Tile_X0Y2_E6BEG[9] Tile_X0Y2_EE4BEG[0] Tile_X0Y2_EE4BEG[10] Tile_X0Y2_EE4BEG[11]
+ Tile_X0Y2_EE4BEG[12] Tile_X0Y2_EE4BEG[13] Tile_X0Y2_EE4BEG[14] Tile_X0Y2_EE4BEG[15]
+ Tile_X0Y2_EE4BEG[1] Tile_X0Y2_EE4BEG[2] Tile_X0Y2_EE4BEG[3] Tile_X0Y2_EE4BEG[4]
+ Tile_X0Y2_EE4BEG[5] Tile_X0Y2_EE4BEG[6] Tile_X0Y2_EE4BEG[7] Tile_X0Y2_EE4BEG[8]
+ Tile_X0Y2_EE4BEG[9] Tile_X0Y2_FrameData[0] Tile_X0Y2_FrameData[10] Tile_X0Y2_FrameData[11]
+ Tile_X0Y2_FrameData[12] Tile_X0Y2_FrameData[13] Tile_X0Y2_FrameData[14] Tile_X0Y2_FrameData[15]
+ Tile_X0Y2_FrameData[16] Tile_X0Y2_FrameData[17] Tile_X0Y2_FrameData[18] Tile_X0Y2_FrameData[19]
+ Tile_X0Y2_FrameData[1] Tile_X0Y2_FrameData[20] Tile_X0Y2_FrameData[21] Tile_X0Y2_FrameData[22]
+ Tile_X0Y2_FrameData[23] Tile_X0Y2_FrameData[24] Tile_X0Y2_FrameData[25] Tile_X0Y2_FrameData[26]
+ Tile_X0Y2_FrameData[27] Tile_X0Y2_FrameData[28] Tile_X0Y2_FrameData[29] Tile_X0Y2_FrameData[2]
+ Tile_X0Y2_FrameData[30] Tile_X0Y2_FrameData[31] Tile_X0Y2_FrameData[3] Tile_X0Y2_FrameData[4]
+ Tile_X0Y2_FrameData[5] Tile_X0Y2_FrameData[6] Tile_X0Y2_FrameData[7] Tile_X0Y2_FrameData[8]
+ Tile_X0Y2_FrameData[9] Tile_X0Y2_FrameData_O[0] Tile_X0Y2_FrameData_O[10] Tile_X0Y2_FrameData_O[11]
+ Tile_X0Y2_FrameData_O[12] Tile_X0Y2_FrameData_O[13] Tile_X0Y2_FrameData_O[14] Tile_X0Y2_FrameData_O[15]
+ Tile_X0Y2_FrameData_O[16] Tile_X0Y2_FrameData_O[17] Tile_X0Y2_FrameData_O[18] Tile_X0Y2_FrameData_O[19]
+ Tile_X0Y2_FrameData_O[1] Tile_X0Y2_FrameData_O[20] Tile_X0Y2_FrameData_O[21] Tile_X0Y2_FrameData_O[22]
+ Tile_X0Y2_FrameData_O[23] Tile_X0Y2_FrameData_O[24] Tile_X0Y2_FrameData_O[25] Tile_X0Y2_FrameData_O[26]
+ Tile_X0Y2_FrameData_O[27] Tile_X0Y2_FrameData_O[28] Tile_X0Y2_FrameData_O[29] Tile_X0Y2_FrameData_O[2]
+ Tile_X0Y2_FrameData_O[30] Tile_X0Y2_FrameData_O[31] Tile_X0Y2_FrameData_O[3] Tile_X0Y2_FrameData_O[4]
+ Tile_X0Y2_FrameData_O[5] Tile_X0Y2_FrameData_O[6] Tile_X0Y2_FrameData_O[7] Tile_X0Y2_FrameData_O[8]
+ Tile_X0Y2_FrameData_O[9] Tile_X0Y2_UserCLK Tile_X0Y2_UserCLKo Tile_X0Y2_W1END[0]
+ Tile_X0Y2_W1END[1] Tile_X0Y2_W1END[2] Tile_X0Y2_W1END[3] Tile_X0Y2_W2END[0] Tile_X0Y2_W2END[1]
+ Tile_X0Y2_W2END[2] Tile_X0Y2_W2END[3] Tile_X0Y2_W2END[4] Tile_X0Y2_W2END[5] Tile_X0Y2_W2END[6]
+ Tile_X0Y2_W2END[7] Tile_X0Y2_W2MID[0] Tile_X0Y2_W2MID[1] Tile_X0Y2_W2MID[2] Tile_X0Y2_W2MID[3]
+ Tile_X0Y2_W2MID[4] Tile_X0Y2_W2MID[5] Tile_X0Y2_W2MID[6] Tile_X0Y2_W2MID[7] Tile_X0Y2_W6END[0]
+ Tile_X0Y2_W6END[10] Tile_X0Y2_W6END[11] Tile_X0Y2_W6END[1] Tile_X0Y2_W6END[2] Tile_X0Y2_W6END[3]
+ Tile_X0Y2_W6END[4] Tile_X0Y2_W6END[5] Tile_X0Y2_W6END[6] Tile_X0Y2_W6END[7] Tile_X0Y2_W6END[8]
+ Tile_X0Y2_W6END[9] Tile_X0Y2_WW4END[0] Tile_X0Y2_WW4END[10] Tile_X0Y2_WW4END[11]
+ Tile_X0Y2_WW4END[12] Tile_X0Y2_WW4END[13] Tile_X0Y2_WW4END[14] Tile_X0Y2_WW4END[15]
+ Tile_X0Y2_WW4END[1] Tile_X0Y2_WW4END[2] Tile_X0Y2_WW4END[3] Tile_X0Y2_WW4END[4]
+ Tile_X0Y2_WW4END[5] Tile_X0Y2_WW4END[6] Tile_X0Y2_WW4END[7] Tile_X0Y2_WW4END[8]
+ Tile_X0Y2_WW4END[9] Tile_X0Y3_E1BEG[0] Tile_X0Y3_E1BEG[1] Tile_X0Y3_E1BEG[2] Tile_X0Y3_E1BEG[3]
+ Tile_X0Y3_E2BEG[0] Tile_X0Y3_E2BEG[1] Tile_X0Y3_E2BEG[2] Tile_X0Y3_E2BEG[3] Tile_X0Y3_E2BEG[4]
+ Tile_X0Y3_E2BEG[5] Tile_X0Y3_E2BEG[6] Tile_X0Y3_E2BEG[7] Tile_X0Y3_E2BEGb[0] Tile_X0Y3_E2BEGb[1]
+ Tile_X0Y3_E2BEGb[2] Tile_X0Y3_E2BEGb[3] Tile_X0Y3_E2BEGb[4] Tile_X0Y3_E2BEGb[5]
+ Tile_X0Y3_E2BEGb[6] Tile_X0Y3_E2BEGb[7] Tile_X0Y3_E6BEG[0] Tile_X0Y3_E6BEG[10] Tile_X0Y3_E6BEG[11]
+ Tile_X0Y3_E6BEG[1] Tile_X0Y3_E6BEG[2] Tile_X0Y3_E6BEG[3] Tile_X0Y3_E6BEG[4] Tile_X0Y3_E6BEG[5]
+ Tile_X0Y3_E6BEG[6] Tile_X0Y3_E6BEG[7] Tile_X0Y3_E6BEG[8] Tile_X0Y3_E6BEG[9] Tile_X0Y3_EE4BEG[0]
+ Tile_X0Y3_EE4BEG[10] Tile_X0Y3_EE4BEG[11] Tile_X0Y3_EE4BEG[12] Tile_X0Y3_EE4BEG[13]
+ Tile_X0Y3_EE4BEG[14] Tile_X0Y3_EE4BEG[15] Tile_X0Y3_EE4BEG[1] Tile_X0Y3_EE4BEG[2]
+ Tile_X0Y3_EE4BEG[3] Tile_X0Y3_EE4BEG[4] Tile_X0Y3_EE4BEG[5] Tile_X0Y3_EE4BEG[6]
+ Tile_X0Y3_EE4BEG[7] Tile_X0Y3_EE4BEG[8] Tile_X0Y3_EE4BEG[9] Tile_X0Y3_FrameData[0]
+ Tile_X0Y3_FrameData[10] Tile_X0Y3_FrameData[11] Tile_X0Y3_FrameData[12] Tile_X0Y3_FrameData[13]
+ Tile_X0Y3_FrameData[14] Tile_X0Y3_FrameData[15] Tile_X0Y3_FrameData[16] Tile_X0Y3_FrameData[17]
+ Tile_X0Y3_FrameData[18] Tile_X0Y3_FrameData[19] Tile_X0Y3_FrameData[1] Tile_X0Y3_FrameData[20]
+ Tile_X0Y3_FrameData[21] Tile_X0Y3_FrameData[22] Tile_X0Y3_FrameData[23] Tile_X0Y3_FrameData[24]
+ Tile_X0Y3_FrameData[25] Tile_X0Y3_FrameData[26] Tile_X0Y3_FrameData[27] Tile_X0Y3_FrameData[28]
+ Tile_X0Y3_FrameData[29] Tile_X0Y3_FrameData[2] Tile_X0Y3_FrameData[30] Tile_X0Y3_FrameData[31]
+ Tile_X0Y3_FrameData[3] Tile_X0Y3_FrameData[4] Tile_X0Y3_FrameData[5] Tile_X0Y3_FrameData[6]
+ Tile_X0Y3_FrameData[7] Tile_X0Y3_FrameData[8] Tile_X0Y3_FrameData[9] Tile_X0Y3_FrameData_O[0]
+ Tile_X0Y3_FrameData_O[10] Tile_X0Y3_FrameData_O[11] Tile_X0Y3_FrameData_O[12] Tile_X0Y3_FrameData_O[13]
+ Tile_X0Y3_FrameData_O[14] Tile_X0Y3_FrameData_O[15] Tile_X0Y3_FrameData_O[16] Tile_X0Y3_FrameData_O[17]
+ Tile_X0Y3_FrameData_O[18] Tile_X0Y3_FrameData_O[19] Tile_X0Y3_FrameData_O[1] Tile_X0Y3_FrameData_O[20]
+ Tile_X0Y3_FrameData_O[21] Tile_X0Y3_FrameData_O[22] Tile_X0Y3_FrameData_O[23] Tile_X0Y3_FrameData_O[24]
+ Tile_X0Y3_FrameData_O[25] Tile_X0Y3_FrameData_O[26] Tile_X0Y3_FrameData_O[27] Tile_X0Y3_FrameData_O[28]
+ Tile_X0Y3_FrameData_O[29] Tile_X0Y3_FrameData_O[2] Tile_X0Y3_FrameData_O[30] Tile_X0Y3_FrameData_O[31]
+ Tile_X0Y3_FrameData_O[3] Tile_X0Y3_FrameData_O[4] Tile_X0Y3_FrameData_O[5] Tile_X0Y3_FrameData_O[6]
+ Tile_X0Y3_FrameData_O[7] Tile_X0Y3_FrameData_O[8] Tile_X0Y3_FrameData_O[9] Tile_X0Y3_UserCLK
+ Tile_X0Y3_UserCLKo Tile_X0Y3_W1END[0] Tile_X0Y3_W1END[1] Tile_X0Y3_W1END[2] Tile_X0Y3_W1END[3]
+ Tile_X0Y3_W2END[0] Tile_X0Y3_W2END[1] Tile_X0Y3_W2END[2] Tile_X0Y3_W2END[3] Tile_X0Y3_W2END[4]
+ Tile_X0Y3_W2END[5] Tile_X0Y3_W2END[6] Tile_X0Y3_W2END[7] Tile_X0Y3_W2MID[0] Tile_X0Y3_W2MID[1]
+ Tile_X0Y3_W2MID[2] Tile_X0Y3_W2MID[3] Tile_X0Y3_W2MID[4] Tile_X0Y3_W2MID[5] Tile_X0Y3_W2MID[6]
+ Tile_X0Y3_W2MID[7] Tile_X0Y3_W6END[0] Tile_X0Y3_W6END[10] Tile_X0Y3_W6END[11] Tile_X0Y3_W6END[1]
+ Tile_X0Y3_W6END[2] Tile_X0Y3_W6END[3] Tile_X0Y3_W6END[4] Tile_X0Y3_W6END[5] Tile_X0Y3_W6END[6]
+ Tile_X0Y3_W6END[7] Tile_X0Y3_W6END[8] Tile_X0Y3_W6END[9] Tile_X0Y3_WW4END[0] Tile_X0Y3_WW4END[10]
+ Tile_X0Y3_WW4END[11] Tile_X0Y3_WW4END[12] Tile_X0Y3_WW4END[13] Tile_X0Y3_WW4END[14]
+ Tile_X0Y3_WW4END[15] Tile_X0Y3_WW4END[1] Tile_X0Y3_WW4END[2] Tile_X0Y3_WW4END[3]
+ Tile_X0Y3_WW4END[4] Tile_X0Y3_WW4END[5] Tile_X0Y3_WW4END[6] Tile_X0Y3_WW4END[7]
+ Tile_X0Y3_WW4END[8] Tile_X0Y3_WW4END[9] Tile_X0Y4_E1BEG[0] Tile_X0Y4_E1BEG[1] Tile_X0Y4_E1BEG[2]
+ Tile_X0Y4_E1BEG[3] Tile_X0Y4_E2BEG[0] Tile_X0Y4_E2BEG[1] Tile_X0Y4_E2BEG[2] Tile_X0Y4_E2BEG[3]
+ Tile_X0Y4_E2BEG[4] Tile_X0Y4_E2BEG[5] Tile_X0Y4_E2BEG[6] Tile_X0Y4_E2BEG[7] Tile_X0Y4_E2BEGb[0]
+ Tile_X0Y4_E2BEGb[1] Tile_X0Y4_E2BEGb[2] Tile_X0Y4_E2BEGb[3] Tile_X0Y4_E2BEGb[4]
+ Tile_X0Y4_E2BEGb[5] Tile_X0Y4_E2BEGb[6] Tile_X0Y4_E2BEGb[7] Tile_X0Y4_E6BEG[0] Tile_X0Y4_E6BEG[10]
+ Tile_X0Y4_E6BEG[11] Tile_X0Y4_E6BEG[1] Tile_X0Y4_E6BEG[2] Tile_X0Y4_E6BEG[3] Tile_X0Y4_E6BEG[4]
+ Tile_X0Y4_E6BEG[5] Tile_X0Y4_E6BEG[6] Tile_X0Y4_E6BEG[7] Tile_X0Y4_E6BEG[8] Tile_X0Y4_E6BEG[9]
+ Tile_X0Y4_EE4BEG[0] Tile_X0Y4_EE4BEG[10] Tile_X0Y4_EE4BEG[11] Tile_X0Y4_EE4BEG[12]
+ Tile_X0Y4_EE4BEG[13] Tile_X0Y4_EE4BEG[14] Tile_X0Y4_EE4BEG[15] Tile_X0Y4_EE4BEG[1]
+ Tile_X0Y4_EE4BEG[2] Tile_X0Y4_EE4BEG[3] Tile_X0Y4_EE4BEG[4] Tile_X0Y4_EE4BEG[5]
+ Tile_X0Y4_EE4BEG[6] Tile_X0Y4_EE4BEG[7] Tile_X0Y4_EE4BEG[8] Tile_X0Y4_EE4BEG[9]
+ Tile_X0Y4_FrameData[0] Tile_X0Y4_FrameData[10] Tile_X0Y4_FrameData[11] Tile_X0Y4_FrameData[12]
+ Tile_X0Y4_FrameData[13] Tile_X0Y4_FrameData[14] Tile_X0Y4_FrameData[15] Tile_X0Y4_FrameData[16]
+ Tile_X0Y4_FrameData[17] Tile_X0Y4_FrameData[18] Tile_X0Y4_FrameData[19] Tile_X0Y4_FrameData[1]
+ Tile_X0Y4_FrameData[20] Tile_X0Y4_FrameData[21] Tile_X0Y4_FrameData[22] Tile_X0Y4_FrameData[23]
+ Tile_X0Y4_FrameData[24] Tile_X0Y4_FrameData[25] Tile_X0Y4_FrameData[26] Tile_X0Y4_FrameData[27]
+ Tile_X0Y4_FrameData[28] Tile_X0Y4_FrameData[29] Tile_X0Y4_FrameData[2] Tile_X0Y4_FrameData[30]
+ Tile_X0Y4_FrameData[31] Tile_X0Y4_FrameData[3] Tile_X0Y4_FrameData[4] Tile_X0Y4_FrameData[5]
+ Tile_X0Y4_FrameData[6] Tile_X0Y4_FrameData[7] Tile_X0Y4_FrameData[8] Tile_X0Y4_FrameData[9]
+ Tile_X0Y4_FrameData_O[0] Tile_X0Y4_FrameData_O[10] Tile_X0Y4_FrameData_O[11] Tile_X0Y4_FrameData_O[12]
+ Tile_X0Y4_FrameData_O[13] Tile_X0Y4_FrameData_O[14] Tile_X0Y4_FrameData_O[15] Tile_X0Y4_FrameData_O[16]
+ Tile_X0Y4_FrameData_O[17] Tile_X0Y4_FrameData_O[18] Tile_X0Y4_FrameData_O[19] Tile_X0Y4_FrameData_O[1]
+ Tile_X0Y4_FrameData_O[20] Tile_X0Y4_FrameData_O[21] Tile_X0Y4_FrameData_O[22] Tile_X0Y4_FrameData_O[23]
+ Tile_X0Y4_FrameData_O[24] Tile_X0Y4_FrameData_O[25] Tile_X0Y4_FrameData_O[26] Tile_X0Y4_FrameData_O[27]
+ Tile_X0Y4_FrameData_O[28] Tile_X0Y4_FrameData_O[29] Tile_X0Y4_FrameData_O[2] Tile_X0Y4_FrameData_O[30]
+ Tile_X0Y4_FrameData_O[31] Tile_X0Y4_FrameData_O[3] Tile_X0Y4_FrameData_O[4] Tile_X0Y4_FrameData_O[5]
+ Tile_X0Y4_FrameData_O[6] Tile_X0Y4_FrameData_O[7] Tile_X0Y4_FrameData_O[8] Tile_X0Y4_FrameData_O[9]
+ Tile_X0Y4_UserCLK Tile_X0Y4_UserCLKo Tile_X0Y4_W1END[0] Tile_X0Y4_W1END[1] Tile_X0Y4_W1END[2]
+ Tile_X0Y4_W1END[3] Tile_X0Y4_W2END[0] Tile_X0Y4_W2END[1] Tile_X0Y4_W2END[2] Tile_X0Y4_W2END[3]
+ Tile_X0Y4_W2END[4] Tile_X0Y4_W2END[5] Tile_X0Y4_W2END[6] Tile_X0Y4_W2END[7] Tile_X0Y4_W2MID[0]
+ Tile_X0Y4_W2MID[1] Tile_X0Y4_W2MID[2] Tile_X0Y4_W2MID[3] Tile_X0Y4_W2MID[4] Tile_X0Y4_W2MID[5]
+ Tile_X0Y4_W2MID[6] Tile_X0Y4_W2MID[7] Tile_X0Y4_W6END[0] Tile_X0Y4_W6END[10] Tile_X0Y4_W6END[11]
+ Tile_X0Y4_W6END[1] Tile_X0Y4_W6END[2] Tile_X0Y4_W6END[3] Tile_X0Y4_W6END[4] Tile_X0Y4_W6END[5]
+ Tile_X0Y4_W6END[6] Tile_X0Y4_W6END[7] Tile_X0Y4_W6END[8] Tile_X0Y4_W6END[9] Tile_X0Y4_WW4END[0]
+ Tile_X0Y4_WW4END[10] Tile_X0Y4_WW4END[11] Tile_X0Y4_WW4END[12] Tile_X0Y4_WW4END[13]
+ Tile_X0Y4_WW4END[14] Tile_X0Y4_WW4END[15] Tile_X0Y4_WW4END[1] Tile_X0Y4_WW4END[2]
+ Tile_X0Y4_WW4END[3] Tile_X0Y4_WW4END[4] Tile_X0Y4_WW4END[5] Tile_X0Y4_WW4END[6]
+ Tile_X0Y4_WW4END[7] Tile_X0Y4_WW4END[8] Tile_X0Y4_WW4END[9] Tile_X0Y5_E1BEG[0] Tile_X0Y5_E1BEG[1]
+ Tile_X0Y5_E1BEG[2] Tile_X0Y5_E1BEG[3] Tile_X0Y5_E2BEG[0] Tile_X0Y5_E2BEG[1] Tile_X0Y5_E2BEG[2]
+ Tile_X0Y5_E2BEG[3] Tile_X0Y5_E2BEG[4] Tile_X0Y5_E2BEG[5] Tile_X0Y5_E2BEG[6] Tile_X0Y5_E2BEG[7]
+ Tile_X0Y5_E2BEGb[0] Tile_X0Y5_E2BEGb[1] Tile_X0Y5_E2BEGb[2] Tile_X0Y5_E2BEGb[3]
+ Tile_X0Y5_E2BEGb[4] Tile_X0Y5_E2BEGb[5] Tile_X0Y5_E2BEGb[6] Tile_X0Y5_E2BEGb[7]
+ Tile_X0Y5_E6BEG[0] Tile_X0Y5_E6BEG[10] Tile_X0Y5_E6BEG[11] Tile_X0Y5_E6BEG[1] Tile_X0Y5_E6BEG[2]
+ Tile_X0Y5_E6BEG[3] Tile_X0Y5_E6BEG[4] Tile_X0Y5_E6BEG[5] Tile_X0Y5_E6BEG[6] Tile_X0Y5_E6BEG[7]
+ Tile_X0Y5_E6BEG[8] Tile_X0Y5_E6BEG[9] Tile_X0Y5_EE4BEG[0] Tile_X0Y5_EE4BEG[10] Tile_X0Y5_EE4BEG[11]
+ Tile_X0Y5_EE4BEG[12] Tile_X0Y5_EE4BEG[13] Tile_X0Y5_EE4BEG[14] Tile_X0Y5_EE4BEG[15]
+ Tile_X0Y5_EE4BEG[1] Tile_X0Y5_EE4BEG[2] Tile_X0Y5_EE4BEG[3] Tile_X0Y5_EE4BEG[4]
+ Tile_X0Y5_EE4BEG[5] Tile_X0Y5_EE4BEG[6] Tile_X0Y5_EE4BEG[7] Tile_X0Y5_EE4BEG[8]
+ Tile_X0Y5_EE4BEG[9] Tile_X0Y5_FrameData[0] Tile_X0Y5_FrameData[10] Tile_X0Y5_FrameData[11]
+ Tile_X0Y5_FrameData[12] Tile_X0Y5_FrameData[13] Tile_X0Y5_FrameData[14] Tile_X0Y5_FrameData[15]
+ Tile_X0Y5_FrameData[16] Tile_X0Y5_FrameData[17] Tile_X0Y5_FrameData[18] Tile_X0Y5_FrameData[19]
+ Tile_X0Y5_FrameData[1] Tile_X0Y5_FrameData[20] Tile_X0Y5_FrameData[21] Tile_X0Y5_FrameData[22]
+ Tile_X0Y5_FrameData[23] Tile_X0Y5_FrameData[24] Tile_X0Y5_FrameData[25] Tile_X0Y5_FrameData[26]
+ Tile_X0Y5_FrameData[27] Tile_X0Y5_FrameData[28] Tile_X0Y5_FrameData[29] Tile_X0Y5_FrameData[2]
+ Tile_X0Y5_FrameData[30] Tile_X0Y5_FrameData[31] Tile_X0Y5_FrameData[3] Tile_X0Y5_FrameData[4]
+ Tile_X0Y5_FrameData[5] Tile_X0Y5_FrameData[6] Tile_X0Y5_FrameData[7] Tile_X0Y5_FrameData[8]
+ Tile_X0Y5_FrameData[9] Tile_X0Y5_FrameData_O[0] Tile_X0Y5_FrameData_O[10] Tile_X0Y5_FrameData_O[11]
+ Tile_X0Y5_FrameData_O[12] Tile_X0Y5_FrameData_O[13] Tile_X0Y5_FrameData_O[14] Tile_X0Y5_FrameData_O[15]
+ Tile_X0Y5_FrameData_O[16] Tile_X0Y5_FrameData_O[17] Tile_X0Y5_FrameData_O[18] Tile_X0Y5_FrameData_O[19]
+ Tile_X0Y5_FrameData_O[1] Tile_X0Y5_FrameData_O[20] Tile_X0Y5_FrameData_O[21] Tile_X0Y5_FrameData_O[22]
+ Tile_X0Y5_FrameData_O[23] Tile_X0Y5_FrameData_O[24] Tile_X0Y5_FrameData_O[25] Tile_X0Y5_FrameData_O[26]
+ Tile_X0Y5_FrameData_O[27] Tile_X0Y5_FrameData_O[28] Tile_X0Y5_FrameData_O[29] Tile_X0Y5_FrameData_O[2]
+ Tile_X0Y5_FrameData_O[30] Tile_X0Y5_FrameData_O[31] Tile_X0Y5_FrameData_O[3] Tile_X0Y5_FrameData_O[4]
+ Tile_X0Y5_FrameData_O[5] Tile_X0Y5_FrameData_O[6] Tile_X0Y5_FrameData_O[7] Tile_X0Y5_FrameData_O[8]
+ Tile_X0Y5_FrameData_O[9] Tile_X0Y5_FrameStrobe[0] Tile_X0Y5_FrameStrobe[10] Tile_X0Y5_FrameStrobe[11]
+ Tile_X0Y5_FrameStrobe[12] Tile_X0Y5_FrameStrobe[13] Tile_X0Y5_FrameStrobe[14] Tile_X0Y5_FrameStrobe[15]
+ Tile_X0Y5_FrameStrobe[16] Tile_X0Y5_FrameStrobe[17] Tile_X0Y5_FrameStrobe[18] Tile_X0Y5_FrameStrobe[19]
+ Tile_X0Y5_FrameStrobe[1] Tile_X0Y5_FrameStrobe[2] Tile_X0Y5_FrameStrobe[3] Tile_X0Y5_FrameStrobe[4]
+ Tile_X0Y5_FrameStrobe[5] Tile_X0Y5_FrameStrobe[6] Tile_X0Y5_FrameStrobe[7] Tile_X0Y5_FrameStrobe[8]
+ Tile_X0Y5_FrameStrobe[9] Tile_X0Y5_N1END[0] Tile_X0Y5_N1END[1] Tile_X0Y5_N1END[2]
+ Tile_X0Y5_N1END[3] Tile_X0Y5_N2END[0] Tile_X0Y5_N2END[1] Tile_X0Y5_N2END[2] Tile_X0Y5_N2END[3]
+ Tile_X0Y5_N2END[4] Tile_X0Y5_N2END[5] Tile_X0Y5_N2END[6] Tile_X0Y5_N2END[7] Tile_X0Y5_N2MID[0]
+ Tile_X0Y5_N2MID[1] Tile_X0Y5_N2MID[2] Tile_X0Y5_N2MID[3] Tile_X0Y5_N2MID[4] Tile_X0Y5_N2MID[5]
+ Tile_X0Y5_N2MID[6] Tile_X0Y5_N2MID[7] Tile_X0Y5_N4END[0] Tile_X0Y5_N4END[10] Tile_X0Y5_N4END[11]
+ Tile_X0Y5_N4END[12] Tile_X0Y5_N4END[13] Tile_X0Y5_N4END[14] Tile_X0Y5_N4END[15]
+ Tile_X0Y5_N4END[1] Tile_X0Y5_N4END[2] Tile_X0Y5_N4END[3] Tile_X0Y5_N4END[4] Tile_X0Y5_N4END[5]
+ Tile_X0Y5_N4END[6] Tile_X0Y5_N4END[7] Tile_X0Y5_N4END[8] Tile_X0Y5_N4END[9] Tile_X0Y5_S1BEG[0]
+ Tile_X0Y5_S1BEG[1] Tile_X0Y5_S1BEG[2] Tile_X0Y5_S1BEG[3] Tile_X0Y5_S2BEG[0] Tile_X0Y5_S2BEG[1]
+ Tile_X0Y5_S2BEG[2] Tile_X0Y5_S2BEG[3] Tile_X0Y5_S2BEG[4] Tile_X0Y5_S2BEG[5] Tile_X0Y5_S2BEG[6]
+ Tile_X0Y5_S2BEG[7] Tile_X0Y5_S2BEGb[0] Tile_X0Y5_S2BEGb[1] Tile_X0Y5_S2BEGb[2] Tile_X0Y5_S2BEGb[3]
+ Tile_X0Y5_S2BEGb[4] Tile_X0Y5_S2BEGb[5] Tile_X0Y5_S2BEGb[6] Tile_X0Y5_S2BEGb[7]
+ Tile_X0Y5_S4BEG[0] Tile_X0Y5_S4BEG[10] Tile_X0Y5_S4BEG[11] Tile_X0Y5_S4BEG[12] Tile_X0Y5_S4BEG[13]
+ Tile_X0Y5_S4BEG[14] Tile_X0Y5_S4BEG[15] Tile_X0Y5_S4BEG[1] Tile_X0Y5_S4BEG[2] Tile_X0Y5_S4BEG[3]
+ Tile_X0Y5_S4BEG[4] Tile_X0Y5_S4BEG[5] Tile_X0Y5_S4BEG[6] Tile_X0Y5_S4BEG[7] Tile_X0Y5_S4BEG[8]
+ Tile_X0Y5_S4BEG[9] Tile_X0Y5_UserCLK Tile_X0Y5_UserCLKo Tile_X0Y5_W1END[0] Tile_X0Y5_W1END[1]
+ Tile_X0Y5_W1END[2] Tile_X0Y5_W1END[3] Tile_X0Y5_W2END[0] Tile_X0Y5_W2END[1] Tile_X0Y5_W2END[2]
+ Tile_X0Y5_W2END[3] Tile_X0Y5_W2END[4] Tile_X0Y5_W2END[5] Tile_X0Y5_W2END[6] Tile_X0Y5_W2END[7]
+ Tile_X0Y5_W2MID[0] Tile_X0Y5_W2MID[1] Tile_X0Y5_W2MID[2] Tile_X0Y5_W2MID[3] Tile_X0Y5_W2MID[4]
+ Tile_X0Y5_W2MID[5] Tile_X0Y5_W2MID[6] Tile_X0Y5_W2MID[7] Tile_X0Y5_W6END[0] Tile_X0Y5_W6END[10]
+ Tile_X0Y5_W6END[11] Tile_X0Y5_W6END[1] Tile_X0Y5_W6END[2] Tile_X0Y5_W6END[3] Tile_X0Y5_W6END[4]
+ Tile_X0Y5_W6END[5] Tile_X0Y5_W6END[6] Tile_X0Y5_W6END[7] Tile_X0Y5_W6END[8] Tile_X0Y5_W6END[9]
+ Tile_X0Y5_WW4END[0] Tile_X0Y5_WW4END[10] Tile_X0Y5_WW4END[11] Tile_X0Y5_WW4END[12]
+ Tile_X0Y5_WW4END[13] Tile_X0Y5_WW4END[14] Tile_X0Y5_WW4END[15] Tile_X0Y5_WW4END[1]
+ Tile_X0Y5_WW4END[2] Tile_X0Y5_WW4END[3] Tile_X0Y5_WW4END[4] Tile_X0Y5_WW4END[5]
+ Tile_X0Y5_WW4END[6] Tile_X0Y5_WW4END[7] Tile_X0Y5_WW4END[8] Tile_X0Y5_WW4END[9]
+ VGND VPWR
XFILLER_223_21 VPWR VGND sg13cmos5l_decap_8
XFILLER_239_161 VPWR VGND sg13cmos5l_decap_8
XFILLER_290_49 VPWR VGND sg13cmos5l_decap_8
XANTENNA__1911__X Tile_X0Y1_FrameData_O[24] VPWR VGND sg13cmos5l_antennanp
X_0367_ _0367_/Q Tile_X0Y1_FrameData[7] VGND VPWR Tile_X0Y5_FrameStrobe[1] latch
XFILLER_54_203 VPWR VGND sg13cmos5l_decap_8
XFILLER_39_266 VPWR VGND sg13cmos5l_decap_8
XFILLER_254_164 VPWR VGND sg13cmos5l_decap_8
XFILLER_299_14 VPWR VGND sg13cmos5l_decap_8
X_2106_ AXIL_S_SOC_RDATA0 Tile_X0Y3_W2MID[0] Tile_X0Y3_W2END[0] Tile_X0Y3_W6END[0]
+ _2589_/X _0862_/Q _0861_/Q VPWR VGND sg13cmos5l_mux4_1
X_0298_ _0298_/Q Tile_X0Y0_FrameData[28] VGND VPWR Tile_X0Y5_FrameStrobe[7] latch
XFILLER_199_219 VPWR VGND sg13cmos5l_fill_1
X_2037_ Tile_X0Y5_FrameData_O[22] Tile_X0Y5_FrameData[22] VPWR VGND sg13cmos5l_buf_1
XFILLER_167_105 VPWR VGND sg13cmos5l_decap_8
XFILLER_22_155 VPWR VGND sg13cmos5l_decap_4
XFILLER_22_166 VPWR VGND sg13cmos5l_decap_8
XFILLER_356_238 VPWR VGND sg13cmos5l_decap_8
XFILLER_182_119 VPWR VGND sg13cmos5l_decap_8
XFILLER_309_154 VPWR VGND sg13cmos5l_decap_8
XFILLER_175_182 VPWR VGND sg13cmos5l_decap_8
XFILLER_248_84 VPWR VGND sg13cmos5l_decap_8
XFILLER_184_28 VPWR VGND sg13cmos5l_decap_8
XFILLER_190_141 VPWR VGND sg13cmos5l_fill_2
XFILLER_324_146 VPWR VGND sg13cmos5l_decap_4
XFILLER_116_271 VPWR VGND sg13cmos5l_fill_2
XFILLER_7_7 VPWR VGND sg13cmos5l_decap_8
XFILLER_117_77 VPWR VGND sg13cmos5l_decap_8
XFILLER_277_223 VPWR VGND sg13cmos5l_decap_8
XFILLER_89_144 VPWR VGND sg13cmos5l_fill_1
XFILLER_133_21 VPWR VGND sg13cmos5l_decap_8
XFILLER_292_226 VPWR VGND sg13cmos5l_decap_4
XANTENNA__1821__X Tile_X0Y4_EE4BEG[4] VPWR VGND sg13cmos5l_antennanp
XFILLER_93_14 VPWR VGND sg13cmos5l_decap_8
XFILLER_45_225 VPWR VGND sg13cmos5l_decap_8
XANTENNA_202 _2391_/X VPWR VGND sg13cmos5l_antennanp
XANTENNA_213 Tile_X0Y5_FrameStrobe[13] VPWR VGND sg13cmos5l_antennanp
XANTENNA_224 Tile_X0Y5_N2MID[2] VPWR VGND sg13cmos5l_antennanp
XFILLER_260_112 VPWR VGND sg13cmos5l_decap_8
XANTENNA_235 Tile_X0Y5_N2MID[5] VPWR VGND sg13cmos5l_antennanp
XANTENNA_246 AXIL_S_SOC_WDATA22 VPWR VGND sg13cmos5l_antennanp
XANTENNA_257 AXIL_S_SOC_WDATA22 VPWR VGND sg13cmos5l_antennanp
XANTENNA_268 AXIL_S_SOC_WDATA22 VPWR VGND sg13cmos5l_antennanp
XFILLER_260_134 VPWR VGND sg13cmos5l_decap_8
XFILLER_26_63 VPWR VGND sg13cmos5l_decap_8
XANTENNA_279 AXIL_S_SOC_WDATA22 VPWR VGND sg13cmos5l_antennanp
XFILLER_13_133 VPWR VGND sg13cmos5l_decap_8
XFILLER_260_167 VPWR VGND sg13cmos5l_fill_2
XFILLER_359_28 VPWR VGND sg13cmos5l_decap_8
XFILLER_158_105 VPWR VGND sg13cmos5l_decap_8
XFILLER_289_91 VPWR VGND sg13cmos5l_decap_8
XFILLER_9_126 VPWR VGND sg13cmos5l_decap_8
XFILLER_166_160 VPWR VGND sg13cmos5l_decap_4
XFILLER_173_119 VPWR VGND sg13cmos5l_decap_8
XFILLER_220_0 VPWR VGND sg13cmos5l_decap_8
XFILLER_318_0 VPWR VGND sg13cmos5l_decap_8
XFILLER_42_73 VPWR VGND sg13cmos5l_decap_8
XFILLER_158_84 VPWR VGND sg13cmos5l_decap_8
XFILLER_308_21 VPWR VGND sg13cmos5l_decap_8
XFILLER_355_271 VPWR VGND sg13cmos5l_fill_2
XFILLER_308_98 VPWR VGND sg13cmos5l_decap_8
XANTENNA__2099__X Tile_X0Y3_E2BEGb[3] VPWR VGND sg13cmos5l_antennanp
XFILLER_268_267 VPWR VGND sg13cmos5l_fill_1
XFILLER_324_42 VPWR VGND sg13cmos5l_decap_8
XFILLER_3_56 VPWR VGND sg13cmos5l_decap_8
X_1270_ _1270_/Q Tile_X0Y5_FrameData[26] VGND VPWR Tile_X0Y5_FrameStrobe[0] latch
XANTENNA__1731__X Tile_X0Y0_E2BEG[3] VPWR VGND sg13cmos5l_antennanp
X_0221_ _0221_/Q Tile_X0Y0_FrameData[9] VGND VPWR Tile_X0Y5_FrameStrobe[4] latch
XFILLER_67_70 VPWR VGND sg13cmos5l_decap_8
X_0152_ _0152_/Q Tile_X0Y0_FrameData[14] VGND VPWR Tile_X0Y5_FrameStrobe[2] latch
XFILLER_36_203 VPWR VGND sg13cmos5l_decap_8
XFILLER_251_112 VPWR VGND sg13cmos5l_decap_8
XFILLER_36_269 VPWR VGND sg13cmos5l_decap_4
XFILLER_340_63 VPWR VGND sg13cmos5l_decap_8
XFILLER_251_145 VPWR VGND sg13cmos5l_fill_2
X_0083_ _0083_/Q Tile_X0Y0_FrameData[19] VGND VPWR Tile_X0Y5_FrameStrobe[0] latch
XFILLER_269_28 VPWR VGND sg13cmos5l_decap_8
XFILLER_83_91 VPWR VGND sg13cmos5l_decap_8
XFILLER_149_149 VPWR VGND sg13cmos5l_decap_8
X_0985_ _0985_/Q Tile_X0Y3_FrameData[29] VGND VPWR Tile_X0Y5_FrameStrobe[6] latch
XFILLER_218_21 VPWR VGND sg13cmos5l_decap_8
XFILLER_285_49 VPWR VGND sg13cmos5l_decap_8
X_2724_ _2724_/X Tile_X0Y5_N1END[3] _2796_/X AXIL_S_SOC_ARPROT1 AXIL_S_SOC_RREADY
+ _1454_/Q _1453_/Q VPWR VGND sg13cmos5l_mux4_1
XFILLER_66_0 VPWR VGND sg13cmos5l_decap_8
X_2655_ _2655_/X AXIL_S_SOC_WSTRB0 _2704_/X _2693_/X _2710_/X _1144_/Q _1143_/Q VPWR
+ VGND sg13cmos5l_mux4_1
XFILLER_361_230 VPWR VGND sg13cmos5l_fill_2
XANTENNA__1906__X Tile_X0Y1_FrameData_O[19] VPWR VGND sg13cmos5l_antennanp
XFILLER_306_168 VPWR VGND sg13cmos5l_decap_8
X_1606_ Tile_X0Y0_N4BEG[2] _1606_/A VPWR VGND sg13cmos5l_buf_1
XFILLER_259_223 VPWR VGND sg13cmos5l_decap_4
X_2586_ _2586_/X _2568_/X Tile_X0Y5_N4END[9] _2567_/X Tile_X0Y0_S4END[13] _0844_/Q
+ _0843_/Q VPWR VGND sg13cmos5l_mux4_1
XFILLER_234_42 VPWR VGND sg13cmos5l_decap_8
X_1537_ Tile_X0Y3_E6BEG[11] _2552_/X VPWR VGND sg13cmos5l_buf_1
XFILLER_219_109 VPWR VGND sg13cmos5l_fill_1
X_1468_ _1468_/Q Tile_X0Y5_FrameData[20] VGND VPWR Tile_X0Y5_FrameStrobe[6] latch
XANTENNA__1641__X Tile_X0Y0_FrameStrobe_O[1] VPWR VGND sg13cmos5l_antennanp
X_1399_ _1399_/Q Tile_X0Y5_FrameData[25] VGND VPWR Tile_X0Y5_FrameStrobe[4] latch
X_0419_ _0419_/Q Tile_X0Y1_FrameData[19] VGND VPWR Tile_X0Y5_FrameStrobe[3] latch
XFILLER_27_225 VPWR VGND sg13cmos5l_decap_4
XFILLER_103_35 VPWR VGND sg13cmos5l_decap_8
XFILLER_242_112 VPWR VGND sg13cmos5l_decap_8
XFILLER_250_63 VPWR VGND sg13cmos5l_decap_8
XFILLER_63_28 VPWR VGND sg13cmos5l_decap_8
XFILLER_179_28 VPWR VGND sg13cmos5l_decap_8
XFILLER_242_189 VPWR VGND sg13cmos5l_decap_8
XFILLER_144_7 VPWR VGND sg13cmos5l_decap_8
XFILLER_195_211 VPWR VGND sg13cmos5l_decap_8
XFILLER_50_272 VPWR VGND sg13cmos5l_fill_1
XFILLER_10_147 VPWR VGND sg13cmos5l_fill_1
XFILLER_12_21 VPWR VGND sg13cmos5l_decap_8
XFILLER_148_160 VPWR VGND sg13cmos5l_decap_8
XFILLER_344_208 VPWR VGND sg13cmos5l_decap_8
XFILLER_128_21 VPWR VGND sg13cmos5l_decap_8
XFILLER_195_49 VPWR VGND sg13cmos5l_decap_8
XFILLER_311_7 VPWR VGND sg13cmos5l_decap_8
XFILLER_352_252 VPWR VGND sg13cmos5l_decap_8
XANTENNA__1816__X Tile_X0Y4_E6BEG[11] VPWR VGND sg13cmos5l_antennanp
XFILLER_12_98 VPWR VGND sg13cmos5l_decap_8
XFILLER_163_185 VPWR VGND sg13cmos5l_fill_1
XFILLER_312_105 VPWR VGND sg13cmos5l_decap_4
XFILLER_88_14 VPWR VGND sg13cmos5l_decap_8
XFILLER_312_138 VPWR VGND sg13cmos5l_decap_8
XFILLER_144_42 VPWR VGND sg13cmos5l_decap_8
XFILLER_291_70 VPWR VGND sg13cmos5l_decap_8
XFILLER_361_29 VPWR VGND sg13cmos5l_decap_8
XANTENNA__1551__X Tile_X0Y3_EE4BEG[13] VPWR VGND sg13cmos5l_antennanp
XFILLER_218_142 VPWR VGND sg13cmos5l_fill_1
XFILLER_280_207 VPWR VGND sg13cmos5l_decap_8
XFILLER_170_0 VPWR VGND sg13cmos5l_decap_8
XFILLER_218_164 VPWR VGND sg13cmos5l_decap_8
XFILLER_218_175 VPWR VGND sg13cmos5l_fill_2
XFILLER_233_112 VPWR VGND sg13cmos5l_decap_8
XFILLER_268_0 VPWR VGND sg13cmos5l_decap_8
XFILLER_85_180 VPWR VGND sg13cmos5l_decap_8
XFILLER_37_84 VPWR VGND sg13cmos5l_decap_8
XFILLER_160_63 VPWR VGND sg13cmos5l_decap_8
XFILLER_310_77 VPWR VGND sg13cmos5l_decap_8
XFILLER_186_222 VPWR VGND sg13cmos5l_fill_2
XFILLER_146_108 VPWR VGND sg13cmos5l_decap_8
XFILLER_319_42 VPWR VGND sg13cmos5l_decap_8
X_0770_ _0770_/Q Tile_X0Y2_FrameData[4] VGND VPWR Tile_X0Y5_FrameStrobe[6] latch
XANTENNA__1726__X Tile_X0Y0_E2BEGb[6] VPWR VGND sg13cmos5l_antennanp
XFILLER_303_105 VPWR VGND sg13cmos5l_decap_8
X_2440_ _2440_/X AXIL_S_SOC_AWADDR7 _2479_/X _2472_/X _2484_/X _0668_/Q _0667_/Q VPWR
+ VGND sg13cmos5l_mux4_1
XFILLER_5_184 VPWR VGND sg13cmos5l_fill_1
XFILLER_335_63 VPWR VGND sg13cmos5l_decap_8
X_2371_ _2371_/X _2342_/X _0063_/X _2341_/X Tile_X0Y0_S4END[4] _0358_/Q _0357_/Q VPWR
+ VGND sg13cmos5l_mux4_1
X_1322_ _1322_/Q Tile_X0Y5_FrameData[6] VGND VPWR Tile_X0Y5_FrameStrobe[1] latch
XFILLER_78_91 VPWR VGND sg13cmos5l_decap_8
X_1253_ _1253_/Q Tile_X0Y4_FrameData[1] VGND VPWR Tile_X0Y5_FrameStrobe[6] latch
XFILLER_68_147 VPWR VGND sg13cmos5l_decap_8
XFILLER_204_56 VPWR VGND sg13cmos5l_decap_8
XFILLER_209_131 VPWR VGND sg13cmos5l_decap_8
X_0204_ _0204_/Q Tile_X0Y0_FrameData[26] VGND VPWR Tile_X0Y5_FrameStrobe[4] latch
XFILLER_224_112 VPWR VGND sg13cmos5l_fill_2
XFILLER_271_229 VPWR VGND sg13cmos5l_decap_8
X_1184_ _1184_/Q Tile_X0Y4_FrameData[6] VGND VPWR Tile_X0Y5_FrameStrobe[4] latch
XFILLER_351_84 VPWR VGND sg13cmos5l_decap_8
X_0135_ _0135_/Q Tile_X0Y0_FrameData[31] VGND VPWR Tile_X0Y5_FrameStrobe[2] latch
XFILLER_91_161 VPWR VGND sg13cmos5l_decap_4
XFILLER_24_228 VPWR VGND sg13cmos5l_fill_2
X_0066_ _0066_/X _2223_/X _2224_/X _1235_/Q VPWR VGND sg13cmos5l_mux2_1
XFILLER_220_77 VPWR VGND sg13cmos5l_decap_8
XFILLER_177_266 VPWR VGND sg13cmos5l_fill_2
XFILLER_192_214 VPWR VGND sg13cmos5l_fill_2
XFILLER_229_42 VPWR VGND sg13cmos5l_decap_8
XFILLER_319_260 VPWR VGND sg13cmos5l_fill_1
X_0968_ _0968_/Q Tile_X0Y3_FrameData[14] VGND VPWR Tile_X0Y5_FrameStrobe[5] latch
XFILLER_145_141 VPWR VGND sg13cmos5l_decap_8
XFILLER_334_241 VPWR VGND sg13cmos5l_fill_1
X_2707_ _2707_/X _2674_/X Tile_X0Y5_N4END[4] _2673_/X _0039_/X _1086_/Q _1085_/Q VPWR
+ VGND sg13cmos5l_mux4_1
XANTENNA__1636__X Tile_X0Y0_N1BEG[0] VPWR VGND sg13cmos5l_antennanp
XFILLER_334_263 VPWR VGND sg13cmos5l_fill_2
X_0899_ _0899_/Q Tile_X0Y3_FrameData[19] VGND VPWR Tile_X0Y5_FrameStrobe[3] latch
XFILLER_160_144 VPWR VGND sg13cmos5l_decap_8
X_2638_ _2638_/X AXIL_S_SOC_WSTRB3 AXIL_S_SOC_BREADY _2689_/X _2710_/X _1178_/Q _1177_/Q
+ VPWR VGND sg13cmos5l_mux4_1
XFILLER_245_63 VPWR VGND sg13cmos5l_decap_8
X_2569_ _2569_/X Tile_X0Y2_W1END[2] Tile_X0Y2_W6END[10] _2467_/X _2455_/X _0654_/Q
+ _0653_/Q VPWR VGND sg13cmos5l_mux4_1
XFILLER_99_272 VPWR VGND sg13cmos5l_fill_1
XFILLER_58_28 VPWR VGND sg13cmos5l_decap_8
XFILLER_160_188 VPWR VGND sg13cmos5l_fill_1
XFILLER_302_182 VPWR VGND sg13cmos5l_decap_8
XFILLER_59_147 VPWR VGND sg13cmos5l_decap_8
XFILLER_114_56 VPWR VGND sg13cmos5l_decap_8
XFILLER_261_84 VPWR VGND sg13cmos5l_decap_8
XFILLER_74_49 VPWR VGND sg13cmos5l_decap_8
XFILLER_261_7 VPWR VGND sg13cmos5l_decap_8
XFILLER_359_7 VPWR VGND sg13cmos5l_decap_8
XFILLER_215_178 VPWR VGND sg13cmos5l_fill_2
XFILLER_82_172 VPWR VGND sg13cmos5l_decap_8
XFILLER_130_77 VPWR VGND sg13cmos5l_decap_8
XFILLER_230_126 VPWR VGND sg13cmos5l_decap_8
XFILLER_90_15 VPWR VGND sg13cmos5l_decap_8
XFILLER_168_255 VPWR VGND sg13cmos5l_fill_2
XFILLER_23_42 VPWR VGND sg13cmos5l_decap_8
XFILLER_139_42 VPWR VGND sg13cmos5l_decap_8
XFILLER_183_214 VPWR VGND sg13cmos5l_decap_4
XFILLER_183_225 VPWR VGND sg13cmos5l_decap_4
XFILLER_183_247 VPWR VGND sg13cmos5l_decap_4
XFILLER_286_92 VPWR VGND sg13cmos5l_decap_8
XFILLER_99_35 VPWR VGND sg13cmos5l_decap_8
XANTENNA__1546__X Tile_X0Y3_EE4BEG[8] VPWR VGND sg13cmos5l_antennanp
XFILLER_297_126 VPWR VGND sg13cmos5l_decap_8
XFILLER_155_63 VPWR VGND sg13cmos5l_decap_8
XFILLER_2_143 VPWR VGND sg13cmos5l_decap_4
XFILLER_300_119 VPWR VGND sg13cmos5l_decap_8
XFILLER_305_77 VPWR VGND sg13cmos5l_decap_8
XFILLER_0_35 VPWR VGND sg13cmos5l_decap_8
XFILLER_171_84 VPWR VGND sg13cmos5l_decap_8
XFILLER_321_21 VPWR VGND sg13cmos5l_decap_8
XFILLER_321_76 VPWR VGND sg13cmos5l_decap_8
XFILLER_73_183 VPWR VGND sg13cmos5l_decap_8
XFILLER_159_200 VPWR VGND sg13cmos5l_fill_2
XFILLER_159_244 VPWR VGND sg13cmos5l_decap_8
X_1940_ Tile_X0Y1_E6BEG[5] _2330_/X VPWR VGND sg13cmos5l_buf_1
X_1871_ Tile_X0Y2_E2BEGb[5] _2414_/X VPWR VGND sg13cmos5l_buf_1
XFILLER_9_77 VPWR VGND sg13cmos5l_decap_8
XFILLER_119_119 VPWR VGND sg13cmos5l_decap_8
X_0822_ _0822_/Q Tile_X0Y3_FrameData[0] VGND VPWR Tile_X0Y5_FrameStrobe[0] latch
XFILLER_80_70 VPWR VGND sg13cmos5l_decap_8
XFILLER_196_70 VPWR VGND sg13cmos5l_decap_8
X_0753_ _0753_/Q Tile_X0Y2_FrameData[21] VGND VPWR Tile_X0Y5_FrameStrobe[6] latch
XFILLER_142_133 VPWR VGND sg13cmos5l_decap_8
XFILLER_288_126 VPWR VGND sg13cmos5l_decap_8
X_0684_ _0684_/Q Tile_X0Y2_FrameData[26] VGND VPWR Tile_X0Y5_FrameStrobe[4] latch
XFILLER_346_84 VPWR VGND sg13cmos5l_decap_8
XFILLER_142_166 VPWR VGND sg13cmos5l_fill_1
XFILLER_282_28 VPWR VGND sg13cmos5l_decap_8
X_2423_ _2423_/X AXIL_S_SOC_AWADDR6 AXIL_S_SOC_AWPROT0 _2470_/X _2482_/X _0702_/Q
+ _0701_/Q VPWR VGND sg13cmos5l_mux4_1
XFILLER_88_209 VPWR VGND sg13cmos5l_decap_8
X_2354_ _2354_/X _2346_/X _0030_/X _2345_/X Tile_X0Y0_S4END[6] _0346_/Q _0345_/Q VPWR
+ VGND sg13cmos5l_mux4_1
XFILLER_215_77 VPWR VGND sg13cmos5l_decap_8
XFILLER_29_0 VPWR VGND sg13cmos5l_decap_8
X_1305_ _1305_/Q Tile_X0Y5_FrameData[23] VGND VPWR Tile_X0Y5_FrameStrobe[1] latch
XFILLER_215_88 VPWR VGND sg13cmos5l_fill_2
X_2285_ _2285_/X Tile_X0Y3_W1END[1] Tile_X0Y3_WW4END[1] Tile_X0Y3_WW4END[5] Tile_X0Y3_W6END[9]
+ _1003_/Q _1002_/Q VPWR VGND sg13cmos5l_mux4_1
XFILLER_362_94 VPWR VGND sg13cmos5l_decap_8
XFILLER_231_21 VPWR VGND sg13cmos5l_decap_8
X_1236_ _1236_/Q Tile_X0Y4_FrameData[18] VGND VPWR Tile_X0Y5_FrameStrobe[6] latch
X_1167_ _1167_/Q Tile_X0Y4_FrameData[23] VGND VPWR Tile_X0Y5_FrameStrobe[4] latch
XFILLER_231_98 VPWR VGND sg13cmos5l_decap_8
X_0118_ _0118_/Q Tile_X0Y0_FrameData[16] VGND VPWR Tile_X0Y5_FrameStrobe[1] latch
X_1098_ _1098_/Q Tile_X0Y4_FrameData[28] VGND VPWR Tile_X0Y5_FrameStrobe[2] latch
XFILLER_358_119 VPWR VGND sg13cmos5l_decap_8
XFILLER_100_14 VPWR VGND sg13cmos5l_decap_8
X_0049_ _0049_/X _2219_/X _2220_/X _1238_/Q VPWR VGND sg13cmos5l_mux2_1
XFILLER_165_225 VPWR VGND sg13cmos5l_decap_8
XFILLER_220_192 VPWR VGND sg13cmos5l_decap_8
XFILLER_109_56 VPWR VGND sg13cmos5l_decap_8
XFILLER_180_217 VPWR VGND sg13cmos5l_decap_8
XFILLER_107_7 VPWR VGND sg13cmos5l_decap_8
XFILLER_256_84 VPWR VGND sg13cmos5l_decap_8
XFILLER_133_177 VPWR VGND sg13cmos5l_fill_2
XFILLER_192_28 VPWR VGND sg13cmos5l_decap_8
XFILLER_69_49 VPWR VGND sg13cmos5l_decap_8
XFILLER_125_77 VPWR VGND sg13cmos5l_decap_8
XFILLER_85_15 VPWR VGND sg13cmos5l_decap_8
XFILLER_141_21 VPWR VGND sg13cmos5l_decap_8
XFILLER_18_42 VPWR VGND sg13cmos5l_decap_8
XFILLER_235_229 VPWR VGND sg13cmos5l_decap_8
XFILLER_55_161 VPWR VGND sg13cmos5l_decap_8
XFILLER_141_87 VPWR VGND sg13cmos5l_decap_8
XFILLER_203_126 VPWR VGND sg13cmos5l_decap_8
XFILLER_349_119 VPWR VGND sg13cmos5l_decap_8
XFILLER_70_175 VPWR VGND sg13cmos5l_decap_4
XFILLER_34_63 VPWR VGND sg13cmos5l_decap_8
XFILLER_133_0 VPWR VGND sg13cmos5l_decap_8
XFILLER_156_225 VPWR VGND sg13cmos5l_decap_8
XFILLER_297_91 VPWR VGND sg13cmos5l_decap_8
XFILLER_357_196 VPWR VGND sg13cmos5l_decap_8
XFILLER_300_0 VPWR VGND sg13cmos5l_decap_8
XFILLER_50_84 VPWR VGND sg13cmos5l_decap_8
XFILLER_166_84 VPWR VGND sg13cmos5l_decap_8
XFILLER_316_21 VPWR VGND sg13cmos5l_decap_8
XFILLER_22_7 VPWR VGND sg13cmos5l_decap_8
XFILLER_316_98 VPWR VGND sg13cmos5l_decap_8
XFILLER_226_218 VPWR VGND sg13cmos5l_decap_8
XFILLER_293_173 VPWR VGND sg13cmos5l_decap_8
XFILLER_332_42 VPWR VGND sg13cmos5l_decap_8
X_2070_ Tile_X0Y5_S4BEG[3] _2070_/A VPWR VGND sg13cmos5l_buf_1
XFILLER_93_234 VPWR VGND sg13cmos5l_decap_8
X_1021_ _1021_/Q Tile_X0Y3_FrameData[25] VGND VPWR Tile_X0Y5_FrameStrobe[7] latch
XFILLER_75_70 VPWR VGND sg13cmos5l_decap_8
XFILLER_201_35 VPWR VGND sg13cmos5l_decap_8
XFILLER_277_28 VPWR VGND sg13cmos5l_decap_8
X_1923_ Tile_X0Y1_EE4BEG[4] _2313_/X VPWR VGND sg13cmos5l_buf_1
XFILLER_91_91 VPWR VGND sg13cmos5l_decap_8
XFILLER_147_214 VPWR VGND sg13cmos5l_fill_2
XFILLER_147_258 VPWR VGND sg13cmos5l_decap_4
X_1854_ Tile_X0Y4_FrameData_O[21] Tile_X0Y4_FrameData[21] VPWR VGND sg13cmos5l_buf_1
XFILLER_162_228 VPWR VGND sg13cmos5l_decap_4
X_1785_ Tile_X0Y4_E1BEG[0] _2613_/X VPWR VGND sg13cmos5l_buf_1
X_0805_ _0805_/Q Tile_X0Y3_FrameData[17] VGND VPWR Tile_X0Y5_FrameStrobe[0] latch
XFILLER_115_133 VPWR VGND sg13cmos5l_decap_8
XFILLER_293_49 VPWR VGND sg13cmos5l_decap_8
X_0736_ _0736_/Q Tile_X0Y2_FrameData[6] VGND VPWR Tile_X0Y5_FrameStrobe[5] latch
XFILLER_226_43 VPWR VGND sg13cmos5l_decap_8
XFILLER_304_255 VPWR VGND sg13cmos5l_fill_2
XANTENNA__1914__X Tile_X0Y1_FrameData_O[27] VPWR VGND sg13cmos5l_antennanp
XFILLER_130_125 VPWR VGND sg13cmos5l_decap_4
XFILLER_170_272 VPWR VGND sg13cmos5l_fill_1
XFILLER_276_107 VPWR VGND sg13cmos5l_fill_1
X_2406_ _2406_/X AXIL_S_SOC_AWADDR5 AXIL_S_SOC_AWVALID _2483_/X _2486_/X _0736_/Q
+ _0735_/Q VPWR VGND sg13cmos5l_mux4_1
X_0667_ _0667_/Q Tile_X0Y2_FrameData[11] VGND VPWR Tile_X0Y5_FrameStrobe[3] latch
XFILLER_276_129 VPWR VGND sg13cmos5l_decap_8
X_0598_ _0598_/Q Tile_X0Y2_FrameData[16] VGND VPWR Tile_X0Y5_FrameStrobe[1] latch
XFILLER_284_140 VPWR VGND sg13cmos5l_decap_8
X_2337_ _2337_/X _2342_/X _2341_/X Tile_X0Y1_W6END[0] _2337_/A3 _0318_/Q _0317_/Q
+ VPWR VGND sg13cmos5l_mux4_1
XFILLER_217_229 VPWR VGND sg13cmos5l_decap_8
XFILLER_242_42 VPWR VGND sg13cmos5l_decap_8
X_2268_ _2268_/X _2368_/X _2366_/X _2354_/X _2353_/X _0520_/Q _0519_/Q VPWR VGND sg13cmos5l_mux4_1
X_1219_ _1219_/Q Tile_X0Y4_FrameData[3] VGND VPWR Tile_X0Y5_FrameStrobe[5] latch
XFILLER_44_109 VPWR VGND sg13cmos5l_decap_8
X_2199_ _2199_/X _0064_/X Tile_X0Y0_S4END[2] _2226_/X _2225_/X _0198_/Q _0197_/Q VPWR
+ VGND sg13cmos5l_mux4_1
XFILLER_111_35 VPWR VGND sg13cmos5l_decap_8
XFILLER_240_210 VPWR VGND sg13cmos5l_decap_4
XFILLER_71_28 VPWR VGND sg13cmos5l_decap_8
XFILLER_52_175 VPWR VGND sg13cmos5l_decap_8
XFILLER_187_28 VPWR VGND sg13cmos5l_decap_8
XFILLER_224_7 VPWR VGND sg13cmos5l_decap_8
XFILLER_354_133 VPWR VGND sg13cmos5l_decap_8
XFILLER_339_196 VPWR VGND sg13cmos5l_decap_4
XFILLER_106_133 VPWR VGND sg13cmos5l_decap_8
XFILLER_20_21 VPWR VGND sg13cmos5l_decap_8
XFILLER_136_21 VPWR VGND sg13cmos5l_decap_8
XANTENNA__1824__X Tile_X0Y4_EE4BEG[7] VPWR VGND sg13cmos5l_antennanp
XFILLER_161_261 VPWR VGND sg13cmos5l_decap_8
XFILLER_161_272 VPWR VGND sg13cmos5l_fill_1
XFILLER_20_98 VPWR VGND sg13cmos5l_decap_8
XFILLER_96_14 VPWR VGND sg13cmos5l_decap_8
XFILLER_121_147 VPWR VGND sg13cmos5l_decap_8
XFILLER_152_42 VPWR VGND sg13cmos5l_decap_8
XFILLER_29_63 VPWR VGND sg13cmos5l_decap_8
XFILLER_216_251 VPWR VGND sg13cmos5l_decap_8
XFILLER_290_154 VPWR VGND sg13cmos5l_decap_8
XFILLER_302_56 VPWR VGND sg13cmos5l_decap_8
XFILLER_90_237 VPWR VGND sg13cmos5l_decap_4
XFILLER_231_221 VPWR VGND sg13cmos5l_decap_4
XFILLER_250_0 VPWR VGND sg13cmos5l_decap_8
XFILLER_45_84 VPWR VGND sg13cmos5l_decap_8
XFILLER_43_186 VPWR VGND sg13cmos5l_decap_8
XFILLER_43_175 VPWR VGND sg13cmos5l_decap_4
XFILLER_348_0 VPWR VGND sg13cmos5l_decap_8
XFILLER_345_133 VPWR VGND sg13cmos5l_decap_8
XANTENNA_5 AXIL_S_SOC_WDATA10 VPWR VGND sg13cmos5l_antennanp
XFILLER_327_42 VPWR VGND sg13cmos5l_decap_8
X_1570_ Tile_X0Y3_FrameData_O[16] Tile_X0Y3_FrameData[16] VPWR VGND sg13cmos5l_buf_1
XFILLER_6_56 VPWR VGND sg13cmos5l_decap_8
XFILLER_152_250 VPWR VGND sg13cmos5l_fill_2
XFILLER_298_232 VPWR VGND sg13cmos5l_decap_8
X_0521_ _0521_/Q Tile_X0Y1_FrameData[13] VGND VPWR Tile_X0Y5_FrameStrobe[6] latch
XFILLER_360_169 VPWR VGND sg13cmos5l_decap_8
XANTENNA__1734__X Tile_X0Y0_E2BEG[6] VPWR VGND sg13cmos5l_antennanp
XFILLER_301_203 VPWR VGND sg13cmos5l_decap_8
XFILLER_112_147 VPWR VGND sg13cmos5l_decap_8
X_0452_ _0452_/Q Tile_X0Y1_FrameData[18] VGND VPWR Tile_X0Y5_FrameStrobe[4] latch
X_0383_ _0383_/Q Tile_X0Y1_FrameData[23] VGND VPWR Tile_X0Y5_FrameStrobe[2] latch
XFILLER_343_63 VPWR VGND sg13cmos5l_decap_8
X_2122_ AXIL_S_SOC_RDATA16 Tile_X0Y1_W2MID[0] Tile_X0Y1_W2END[0] Tile_X0Y1_W6END[0]
+ _2373_/X _0382_/Q _0381_/Q VPWR VGND sg13cmos5l_mux4_1
XFILLER_86_91 VPWR VGND sg13cmos5l_decap_8
XFILLER_212_56 VPWR VGND sg13cmos5l_decap_8
XFILLER_281_154 VPWR VGND sg13cmos5l_fill_1
X_2053_ Tile_X0Y5_S2BEG[2] _2775_/X VPWR VGND sg13cmos5l_buf_1
X_1004_ _1004_/Q Tile_X0Y3_FrameData[10] VGND VPWR Tile_X0Y5_FrameStrobe[6] latch
XFILLER_179_147 VPWR VGND sg13cmos5l_decap_8
XFILLER_222_243 VPWR VGND sg13cmos5l_decap_8
XFILLER_288_49 VPWR VGND sg13cmos5l_decap_8
XFILLER_34_175 VPWR VGND sg13cmos5l_fill_2
XFILLER_96_0 VPWR VGND sg13cmos5l_decap_8
XANTENNA__1909__X Tile_X0Y1_FrameData_O[22] VPWR VGND sg13cmos5l_antennanp
X_1906_ Tile_X0Y1_FrameData_O[19] Tile_X0Y1_FrameData[19] VPWR VGND sg13cmos5l_buf_1
XFILLER_135_217 VPWR VGND sg13cmos5l_decap_8
X_1837_ Tile_X0Y4_FrameData_O[4] Tile_X0Y4_FrameData[4] VPWR VGND sg13cmos5l_buf_1
XFILLER_135_228 VPWR VGND sg13cmos5l_fill_2
XFILLER_237_42 VPWR VGND sg13cmos5l_decap_8
XFILLER_336_199 VPWR VGND sg13cmos5l_fill_2
X_1768_ Tile_X0Y2_FrameData_O[28] Tile_X0Y2_FrameData[28] VPWR VGND sg13cmos5l_buf_1
XFILLER_351_147 VPWR VGND sg13cmos5l_decap_8
XANTENNA__1644__X Tile_X0Y0_FrameStrobe_O[4] VPWR VGND sg13cmos5l_antennanp
XFILLER_289_254 VPWR VGND sg13cmos5l_decap_4
X_1699_ Tile_X0Y0_EE4BEG[7] _2188_/X VPWR VGND sg13cmos5l_buf_1
X_0719_ _0719_/Q Tile_X0Y2_FrameData[23] VGND VPWR Tile_X0Y5_FrameStrobe[5] latch
XFILLER_106_35 VPWR VGND sg13cmos5l_decap_8
XFILLER_253_63 VPWR VGND sg13cmos5l_decap_8
XFILLER_257_140 VPWR VGND sg13cmos5l_fill_1
XFILLER_257_162 VPWR VGND sg13cmos5l_fill_2
XFILLER_66_28 VPWR VGND sg13cmos5l_decap_8
XFILLER_57_245 VPWR VGND sg13cmos5l_decap_8
XFILLER_257_184 VPWR VGND sg13cmos5l_decap_8
XFILLER_122_56 VPWR VGND sg13cmos5l_decap_8
XFILLER_174_7 VPWR VGND sg13cmos5l_decap_8
XFILLER_272_198 VPWR VGND sg13cmos5l_fill_1
XFILLER_359_203 VPWR VGND sg13cmos5l_decap_8
XFILLER_15_21 VPWR VGND sg13cmos5l_decap_8
XFILLER_213_221 VPWR VGND sg13cmos5l_decap_8
XFILLER_82_49 VPWR VGND sg13cmos5l_decap_8
XFILLER_341_7 VPWR VGND sg13cmos5l_decap_8
XFILLER_198_49 VPWR VGND sg13cmos5l_decap_8
XFILLER_213_265 VPWR VGND sg13cmos5l_decap_8
XFILLER_25_197 VPWR VGND sg13cmos5l_decap_8
XFILLER_40_112 VPWR VGND sg13cmos5l_decap_8
XANTENNA__1819__X Tile_X0Y4_EE4BEG[2] VPWR VGND sg13cmos5l_antennanp
XFILLER_15_98 VPWR VGND sg13cmos5l_decap_8
XFILLER_40_145 VPWR VGND sg13cmos5l_decap_4
XFILLER_178_191 VPWR VGND sg13cmos5l_decap_4
XFILLER_31_42 VPWR VGND sg13cmos5l_decap_8
XFILLER_126_228 VPWR VGND sg13cmos5l_fill_2
XFILLER_147_42 VPWR VGND sg13cmos5l_decap_8
XFILLER_327_177 VPWR VGND sg13cmos5l_fill_1
XFILLER_327_199 VPWR VGND sg13cmos5l_fill_1
XFILLER_294_70 VPWR VGND sg13cmos5l_decap_8
XANTENNA__1554__X Tile_X0Y3_FrameData_O[0] VPWR VGND sg13cmos5l_antennanp
XFILLER_134_272 VPWR VGND sg13cmos5l_fill_1
XFILLER_295_224 VPWR VGND sg13cmos5l_decap_8
XFILLER_350_191 VPWR VGND sg13cmos5l_decap_8
XFILLER_163_63 VPWR VGND sg13cmos5l_decap_8
XFILLER_298_0 VPWR VGND sg13cmos5l_decap_8
XFILLER_313_77 VPWR VGND sg13cmos5l_decap_8
XFILLER_263_198 VPWR VGND sg13cmos5l_decap_4
XFILLER_31_112 VPWR VGND sg13cmos5l_decap_8
XANTENNA__1729__X Tile_X0Y0_E2BEG[1] VPWR VGND sg13cmos5l_antennanp
XFILLER_318_133 VPWR VGND sg13cmos5l_decap_4
X_2740_ _2740_/X AXIL_S_SOC_ARPROT0 AXIL_S_SOC_ARPROT2 _2825_/X _2797_/X _1422_/Q
+ _1421_/Q VPWR VGND sg13cmos5l_mux4_1
XFILLER_117_217 VPWR VGND sg13cmos5l_decap_8
X_2671_ _2671_/X _2678_/X _2677_/X Tile_X0Y4_W6END[2] _2671_/A3 _1034_/Q _1033_/Q
+ VPWR VGND sg13cmos5l_mux4_1
XFILLER_338_63 VPWR VGND sg13cmos5l_decap_8
XFILLER_333_103 VPWR VGND sg13cmos5l_decap_8
X_1622_ Tile_X0Y0_N2BEGb[2] _2254_/X VPWR VGND sg13cmos5l_buf_1
X_1553_ Tile_X0Y3_EE4BEG[15] _2540_/X VPWR VGND sg13cmos5l_buf_1
XFILLER_207_56 VPWR VGND sg13cmos5l_decap_8
X_1484_ _1484_/Q Tile_X0Y5_FrameData[4] VGND VPWR Tile_X0Y5_FrameStrobe[6] latch
X_0504_ _0504_/Q Tile_X0Y1_FrameData[30] VGND VPWR Tile_X0Y5_FrameStrobe[6] latch
XFILLER_354_84 VPWR VGND sg13cmos5l_decap_8
XFILLER_286_246 VPWR VGND sg13cmos5l_decap_8
XFILLER_286_268 VPWR VGND sg13cmos5l_decap_4
XFILLER_290_28 VPWR VGND sg13cmos5l_decap_8
X_0435_ _0435_/Q Tile_X0Y1_FrameData[3] VGND VPWR Tile_X0Y5_FrameStrobe[3] latch
XFILLER_98_178 VPWR VGND sg13cmos5l_decap_8
XFILLER_239_140 VPWR VGND sg13cmos5l_decap_8
XFILLER_11_0 VPWR VGND sg13cmos5l_decap_8
X_0366_ _0366_/Q Tile_X0Y1_FrameData[8] VGND VPWR Tile_X0Y5_FrameStrobe[1] latch
XFILLER_39_256 VPWR VGND sg13cmos5l_fill_2
XFILLER_223_77 VPWR VGND sg13cmos5l_decap_8
XFILLER_254_154 VPWR VGND sg13cmos5l_decap_4
X_2105_ AXIL_S_SOC_ARREADY Tile_X0Y5_W2MID[0] Tile_X0Y5_W2END[0] Tile_X0Y5_W6END[0]
+ _2825_/X _1328_/Q _1327_/Q VPWR VGND sg13cmos5l_mux4_1
X_0297_ _0297_/Q Tile_X0Y0_FrameData[29] VGND VPWR Tile_X0Y5_FrameStrobe[7] latch
XFILLER_254_187 VPWR VGND sg13cmos5l_decap_8
X_2036_ Tile_X0Y5_FrameData_O[21] Tile_X0Y5_FrameData[21] VPWR VGND sg13cmos5l_buf_1
XFILLER_54_248 VPWR VGND sg13cmos5l_decap_8
XFILLER_22_112 VPWR VGND sg13cmos5l_fill_1
XANTENNA__1639__X Tile_X0Y0_N1BEG[3] VPWR VGND sg13cmos5l_antennanp
XFILLER_356_217 VPWR VGND sg13cmos5l_decap_8
XFILLER_309_133 VPWR VGND sg13cmos5l_decap_8
XFILLER_175_161 VPWR VGND sg13cmos5l_decap_8
XFILLER_248_63 VPWR VGND sg13cmos5l_decap_8
XFILLER_117_56 VPWR VGND sg13cmos5l_decap_8
XFILLER_131_242 VPWR VGND sg13cmos5l_fill_1
XFILLER_264_84 VPWR VGND sg13cmos5l_decap_8
XFILLER_277_202 VPWR VGND sg13cmos5l_decap_8
XFILLER_291_7 VPWR VGND sg13cmos5l_decap_8
XFILLER_89_156 VPWR VGND sg13cmos5l_fill_1
XFILLER_77_49 VPWR VGND sg13cmos5l_decap_8
XFILLER_292_205 VPWR VGND sg13cmos5l_decap_8
XFILLER_292_238 VPWR VGND sg13cmos5l_decap_8
XFILLER_292_249 VPWR VGND sg13cmos5l_fill_2
XFILLER_133_77 VPWR VGND sg13cmos5l_decap_8
XFILLER_245_154 VPWR VGND sg13cmos5l_decap_8
XFILLER_245_165 VPWR VGND sg13cmos5l_fill_2
XFILLER_45_204 VPWR VGND sg13cmos5l_decap_8
XANTENNA_203 Tile_X0Y0_S2MID[5] VPWR VGND sg13cmos5l_antennanp
XANTENNA_214 Tile_X0Y5_FrameStrobe[14] VPWR VGND sg13cmos5l_antennanp
XANTENNA_225 Tile_X0Y5_N2MID[2] VPWR VGND sg13cmos5l_antennanp
XFILLER_26_42 VPWR VGND sg13cmos5l_decap_8
XANTENNA_236 AXIL_S_SOC_WDATA22 VPWR VGND sg13cmos5l_antennanp
XANTENNA_247 AXIL_S_SOC_WDATA22 VPWR VGND sg13cmos5l_antennanp
XANTENNA_258 AXIL_S_SOC_WDATA22 VPWR VGND sg13cmos5l_antennanp
XANTENNA_269 AXIL_S_SOC_WDATA22 VPWR VGND sg13cmos5l_antennanp
XFILLER_13_112 VPWR VGND sg13cmos5l_decap_8
XFILLER_198_231 VPWR VGND sg13cmos5l_fill_1
XFILLER_289_70 VPWR VGND sg13cmos5l_decap_8
XANTENNA__1549__X Tile_X0Y3_EE4BEG[11] VPWR VGND sg13cmos5l_antennanp
XFILLER_9_105 VPWR VGND sg13cmos5l_decap_8
XFILLER_201_257 VPWR VGND sg13cmos5l_decap_4
XFILLER_42_52 VPWR VGND sg13cmos5l_decap_8
XFILLER_158_63 VPWR VGND sg13cmos5l_decap_8
XFILLER_166_172 VPWR VGND sg13cmos5l_decap_8
XFILLER_213_0 VPWR VGND sg13cmos5l_decap_8
XFILLER_107_272 VPWR VGND sg13cmos5l_fill_1
XFILLER_181_175 VPWR VGND sg13cmos5l_decap_8
XFILLER_308_77 VPWR VGND sg13cmos5l_decap_8
XFILLER_181_197 VPWR VGND sg13cmos5l_decap_8
XFILLER_174_84 VPWR VGND sg13cmos5l_decap_8
XFILLER_268_235 VPWR VGND sg13cmos5l_fill_1
XFILLER_324_21 VPWR VGND sg13cmos5l_decap_8
XFILLER_3_35 VPWR VGND sg13cmos5l_decap_8
XFILLER_283_205 VPWR VGND sg13cmos5l_decap_8
XFILLER_283_216 VPWR VGND sg13cmos5l_fill_2
XFILLER_95_126 VPWR VGND sg13cmos5l_fill_2
XFILLER_95_115 VPWR VGND sg13cmos5l_decap_8
XFILLER_324_98 VPWR VGND sg13cmos5l_decap_8
X_0220_ _0220_/Q Tile_X0Y0_FrameData[10] VGND VPWR Tile_X0Y5_FrameStrobe[4] latch
XFILLER_236_154 VPWR VGND sg13cmos5l_decap_8
X_0151_ _0151_/Q Tile_X0Y0_FrameData[15] VGND VPWR Tile_X0Y5_FrameStrobe[2] latch
XFILLER_236_198 VPWR VGND sg13cmos5l_decap_8
XFILLER_340_42 VPWR VGND sg13cmos5l_decap_8
X_0082_ _0082_/Q Tile_X0Y0_FrameData[20] VGND VPWR Tile_X0Y5_FrameStrobe[0] latch
XFILLER_83_70 VPWR VGND sg13cmos5l_decap_8
XFILLER_51_218 VPWR VGND sg13cmos5l_decap_8
XFILLER_51_207 VPWR VGND sg13cmos5l_fill_1
XFILLER_199_70 VPWR VGND sg13cmos5l_decap_8
XFILLER_199_81 VPWR VGND sg13cmos5l_fill_1
XFILLER_149_106 VPWR VGND sg13cmos5l_fill_1
XFILLER_338_217 VPWR VGND sg13cmos5l_fill_1
XFILLER_285_28 VPWR VGND sg13cmos5l_decap_8
X_2723_ _2723_/X Tile_X0Y5_N1END[2] _2795_/X Tile_X0Y5_WW4END[5] AXIL_S_SOC_ARPROT0
+ _1456_/Q _1455_/Q VPWR VGND sg13cmos5l_mux4_1
X_0984_ _0984_/Q Tile_X0Y3_FrameData[30] VGND VPWR Tile_X0Y5_FrameStrobe[6] latch
XFILLER_349_84 VPWR VGND sg13cmos5l_decap_8
XFILLER_157_172 VPWR VGND sg13cmos5l_decap_8
XFILLER_157_183 VPWR VGND sg13cmos5l_fill_1
XFILLER_346_272 VPWR VGND sg13cmos5l_fill_1
XFILLER_306_147 VPWR VGND sg13cmos5l_decap_8
X_2654_ _2654_/X AXIL_S_SOC_BREADY _2701_/X _2689_/X _2709_/X _1146_/Q _1145_/Q VPWR
+ VGND sg13cmos5l_mux4_1
XFILLER_218_77 VPWR VGND sg13cmos5l_decap_8
X_1605_ Tile_X0Y0_N4BEG[1] _1605_/A VPWR VGND sg13cmos5l_buf_1
X_2585_ _2585_/X _2568_/X Tile_X0Y5_N4END[9] _2567_/X Tile_X0Y0_S4END[13] _0836_/Q
+ _0835_/Q VPWR VGND sg13cmos5l_mux4_1
XFILLER_59_0 VPWR VGND sg13cmos5l_decap_8
X_1536_ Tile_X0Y3_E6BEG[10] _2551_/X VPWR VGND sg13cmos5l_buf_1
XFILLER_113_264 VPWR VGND sg13cmos5l_fill_1
XFILLER_234_21 VPWR VGND sg13cmos5l_decap_8
XANTENNA__1922__X Tile_X0Y1_EE4BEG[3] VPWR VGND sg13cmos5l_antennanp
X_1467_ _1467_/Q Tile_X0Y5_FrameData[21] VGND VPWR Tile_X0Y5_FrameStrobe[6] latch
XFILLER_86_126 VPWR VGND sg13cmos5l_fill_1
XFILLER_234_98 VPWR VGND sg13cmos5l_decap_8
XFILLER_274_227 VPWR VGND sg13cmos5l_fill_2
X_1398_ _1398_/Q Tile_X0Y5_FrameData[26] VGND VPWR Tile_X0Y5_FrameStrobe[4] latch
X_0418_ _0418_/Q Tile_X0Y1_FrameData[20] VGND VPWR Tile_X0Y5_FrameStrobe[3] latch
XFILLER_86_148 VPWR VGND sg13cmos5l_decap_4
XFILLER_103_14 VPWR VGND sg13cmos5l_decap_8
X_0349_ _0349_/Q Tile_X0Y1_FrameData[25] VGND VPWR Tile_X0Y5_FrameStrobe[1] latch
XFILLER_227_187 VPWR VGND sg13cmos5l_decap_4
XFILLER_250_42 VPWR VGND sg13cmos5l_decap_8
XFILLER_242_168 VPWR VGND sg13cmos5l_decap_8
X_2019_ Tile_X0Y5_FrameData_O[4] Tile_X0Y5_FrameData[4] VPWR VGND sg13cmos5l_buf_1
XFILLER_50_251 VPWR VGND sg13cmos5l_decap_8
XFILLER_10_126 VPWR VGND sg13cmos5l_decap_8
XFILLER_137_7 VPWR VGND sg13cmos5l_decap_8
XFILLER_259_84 VPWR VGND sg13cmos5l_decap_8
XFILLER_195_28 VPWR VGND sg13cmos5l_decap_8
XFILLER_337_272 VPWR VGND sg13cmos5l_fill_1
XFILLER_12_77 VPWR VGND sg13cmos5l_decap_8
XFILLER_304_7 VPWR VGND sg13cmos5l_decap_8
XFILLER_352_231 VPWR VGND sg13cmos5l_decap_8
XFILLER_128_77 VPWR VGND sg13cmos5l_decap_8
XFILLER_144_21 VPWR VGND sg13cmos5l_decap_8
XANTENNA__1832__X Tile_X0Y4_EE4BEG[15] VPWR VGND sg13cmos5l_antennanp
XFILLER_320_161 VPWR VGND sg13cmos5l_fill_2
XFILLER_218_121 VPWR VGND sg13cmos5l_decap_8
XFILLER_160_42 VPWR VGND sg13cmos5l_decap_8
XFILLER_37_63 VPWR VGND sg13cmos5l_decap_8
XFILLER_163_0 VPWR VGND sg13cmos5l_decap_8
XFILLER_218_198 VPWR VGND sg13cmos5l_decap_8
XFILLER_310_56 VPWR VGND sg13cmos5l_decap_8
XFILLER_330_0 VPWR VGND sg13cmos5l_decap_8
XFILLER_53_84 VPWR VGND sg13cmos5l_decap_8
XFILLER_41_262 VPWR VGND sg13cmos5l_decap_8
XFILLER_139_150 VPWR VGND sg13cmos5l_decap_8
XFILLER_169_84 VPWR VGND sg13cmos5l_decap_8
XFILLER_186_256 VPWR VGND sg13cmos5l_fill_1
XFILLER_319_21 VPWR VGND sg13cmos5l_decap_8
XFILLER_139_161 VPWR VGND sg13cmos5l_fill_1
XFILLER_139_183 VPWR VGND sg13cmos5l_decap_8
XFILLER_319_98 VPWR VGND sg13cmos5l_decap_8
XFILLER_154_175 VPWR VGND sg13cmos5l_decap_8
XFILLER_5_141 VPWR VGND sg13cmos5l_fill_2
XFILLER_52_7 VPWR VGND sg13cmos5l_decap_8
XFILLER_335_42 VPWR VGND sg13cmos5l_decap_8
X_2370_ _2370_/X _2344_/X _0031_/X _2343_/X Tile_X0Y0_S4END[5] _0364_/Q _0363_/Q VPWR
+ VGND sg13cmos5l_mux4_1
XANTENNA__1742__X Tile_X0Y2_FrameData_O[2] VPWR VGND sg13cmos5l_antennanp
XFILLER_256_205 VPWR VGND sg13cmos5l_fill_2
X_1321_ _1321_/Q Tile_X0Y5_FrameData[7] VGND VPWR Tile_X0Y5_FrameStrobe[1] latch
XFILLER_78_70 VPWR VGND sg13cmos5l_decap_8
XFILLER_68_126 VPWR VGND sg13cmos5l_decap_8
XFILLER_110_256 VPWR VGND sg13cmos5l_fill_1
XFILLER_209_110 VPWR VGND sg13cmos5l_decap_8
XFILLER_311_183 VPWR VGND sg13cmos5l_decap_4
X_1252_ _1252_/Q Tile_X0Y4_FrameData[2] VGND VPWR Tile_X0Y5_FrameStrobe[6] latch
XFILLER_204_35 VPWR VGND sg13cmos5l_decap_8
XFILLER_271_208 VPWR VGND sg13cmos5l_decap_8
X_0203_ _0203_/Q Tile_X0Y0_FrameData[27] VGND VPWR Tile_X0Y5_FrameStrobe[4] latch
XFILLER_351_63 VPWR VGND sg13cmos5l_decap_8
X_1183_ _1183_/Q Tile_X0Y4_FrameData[7] VGND VPWR Tile_X0Y5_FrameStrobe[4] latch
XFILLER_76_181 VPWR VGND sg13cmos5l_fill_2
XFILLER_224_135 VPWR VGND sg13cmos5l_decap_4
X_0134_ _0134_/Q Tile_X0Y0_FrameData[0] VGND VPWR Tile_X0Y5_FrameStrobe[1] latch
XFILLER_94_91 VPWR VGND sg13cmos5l_decap_4
XFILLER_91_140 VPWR VGND sg13cmos5l_decap_8
X_0065_ _0065_/X _2231_/X _2232_/X _1229_/Q VPWR VGND sg13cmos5l_mux2_1
XFILLER_220_56 VPWR VGND sg13cmos5l_decap_8
XFILLER_177_234 VPWR VGND sg13cmos5l_decap_4
XFILLER_229_21 VPWR VGND sg13cmos5l_decap_8
XFILLER_296_49 VPWR VGND sg13cmos5l_decap_8
XANTENNA__1917__X Tile_X0Y1_FrameData_O[30] VPWR VGND sg13cmos5l_antennanp
XFILLER_319_272 VPWR VGND sg13cmos5l_fill_1
X_0967_ _0967_/Q Tile_X0Y3_FrameData[15] VGND VPWR Tile_X0Y5_FrameStrobe[5] latch
XFILLER_145_120 VPWR VGND sg13cmos5l_decap_8
XFILLER_192_248 VPWR VGND sg13cmos5l_decap_8
XFILLER_229_98 VPWR VGND sg13cmos5l_decap_8
X_2706_ _2706_/X _2674_/X Tile_X0Y5_N4END[4] _2673_/X _0039_/X _1078_/Q _1077_/Q VPWR
+ VGND sg13cmos5l_mux4_1
X_2637_ _2637_/X AXIL_S_SOC_WSTRB2 AXIL_S_SOC_WVALID _2685_/X _2711_/X _1180_/Q _1179_/Q
+ VPWR VGND sg13cmos5l_mux4_1
X_0898_ _0898_/Q Tile_X0Y3_FrameData[20] VGND VPWR Tile_X0Y5_FrameStrobe[3] latch
XFILLER_160_112 VPWR VGND sg13cmos5l_decap_4
XFILLER_245_42 VPWR VGND sg13cmos5l_decap_8
XFILLER_160_167 VPWR VGND sg13cmos5l_decap_8
X_2568_ _2568_/X Tile_X0Y4_W1END[1] Tile_X0Y4_W6END[5] _2692_/X _2670_/X _1262_/Q
+ _1261_/Q VPWR VGND sg13cmos5l_mux4_1
XFILLER_99_251 VPWR VGND sg13cmos5l_decap_8
XANTENNA__1652__X Tile_X0Y0_FrameStrobe_O[12] VPWR VGND sg13cmos5l_antennanp
XFILLER_101_201 VPWR VGND sg13cmos5l_decap_8
XFILLER_302_161 VPWR VGND sg13cmos5l_decap_8
X_1519_ _2455_/A3 VPWR VGND sg13cmos5l_tielo
X_2499_ _2499_/X Tile_X0Y1_W1END[1] Tile_X0Y1_W2MID[2] Tile_X0Y1_W2END[2] _2378_/X
+ _0400_/Q _0399_/Q VPWR VGND sg13cmos5l_mux4_1
XFILLER_59_126 VPWR VGND sg13cmos5l_decap_8
XFILLER_101_245 VPWR VGND sg13cmos5l_decap_8
XFILLER_114_35 VPWR VGND sg13cmos5l_decap_8
XFILLER_261_63 VPWR VGND sg13cmos5l_decap_8
XFILLER_255_260 VPWR VGND sg13cmos5l_fill_2
XFILLER_255_271 VPWR VGND sg13cmos5l_fill_2
XFILLER_74_28 VPWR VGND sg13cmos5l_decap_8
XFILLER_82_140 VPWR VGND sg13cmos5l_decap_8
XFILLER_230_105 VPWR VGND sg13cmos5l_decap_8
XFILLER_254_7 VPWR VGND sg13cmos5l_decap_8
XFILLER_130_56 VPWR VGND sg13cmos5l_decap_8
XFILLER_168_212 VPWR VGND sg13cmos5l_decap_8
XFILLER_168_234 VPWR VGND sg13cmos5l_decap_8
XFILLER_23_21 VPWR VGND sg13cmos5l_decap_8
XFILLER_139_21 VPWR VGND sg13cmos5l_decap_8
XANTENNA__1827__X Tile_X0Y4_EE4BEG[10] VPWR VGND sg13cmos5l_antennanp
XFILLER_183_259 VPWR VGND sg13cmos5l_fill_2
XFILLER_23_98 VPWR VGND sg13cmos5l_decap_8
XFILLER_286_71 VPWR VGND sg13cmos5l_decap_8
XFILLER_99_14 VPWR VGND sg13cmos5l_decap_8
XFILLER_151_112 VPWR VGND sg13cmos5l_decap_8
XFILLER_155_42 VPWR VGND sg13cmos5l_decap_8
XFILLER_297_105 VPWR VGND sg13cmos5l_decap_8
XANTENNA__1562__X Tile_X0Y3_FrameData_O[8] VPWR VGND sg13cmos5l_antennanp
XFILLER_238_227 VPWR VGND sg13cmos5l_decap_4
XFILLER_305_56 VPWR VGND sg13cmos5l_decap_8
XFILLER_171_63 VPWR VGND sg13cmos5l_decap_8
XFILLER_280_0 VPWR VGND sg13cmos5l_decap_8
XFILLER_48_95 VPWR VGND sg13cmos5l_decap_8
XFILLER_0_14 VPWR VGND sg13cmos5l_decap_8
XFILLER_246_271 VPWR VGND sg13cmos5l_fill_2
XFILLER_206_124 VPWR VGND sg13cmos5l_decap_8
XFILLER_321_55 VPWR VGND sg13cmos5l_decap_8
XFILLER_159_223 VPWR VGND sg13cmos5l_decap_8
XFILLER_221_149 VPWR VGND sg13cmos5l_decap_8
X_1870_ Tile_X0Y2_E2BEGb[4] _2413_/X VPWR VGND sg13cmos5l_buf_1
XFILLER_9_56 VPWR VGND sg13cmos5l_decap_8
XFILLER_174_226 VPWR VGND sg13cmos5l_decap_4
XFILLER_308_209 VPWR VGND sg13cmos5l_fill_1
X_0821_ _0821_/Q Tile_X0Y3_FrameData[1] VGND VPWR Tile_X0Y5_FrameStrobe[0] latch
XFILLER_80_93 VPWR VGND sg13cmos5l_fill_1
XANTENNA__1737__X Tile_X0Y0_E1BEG[1] VPWR VGND sg13cmos5l_antennanp
X_0752_ _0752_/Q Tile_X0Y2_FrameData[22] VGND VPWR Tile_X0Y5_FrameStrobe[6] latch
XFILLER_127_164 VPWR VGND sg13cmos5l_fill_2
XFILLER_288_105 VPWR VGND sg13cmos5l_decap_8
X_0683_ _0683_/Q Tile_X0Y2_FrameData[27] VGND VPWR Tile_X0Y5_FrameStrobe[4] latch
XFILLER_346_63 VPWR VGND sg13cmos5l_decap_8
X_2422_ _2422_/X AXIL_S_SOC_AWADDR5 AXIL_S_SOC_AWADDR9 _2468_/X _2483_/X _0704_/Q
+ _0703_/Q VPWR VGND sg13cmos5l_mux4_1
X_2353_ _2353_/X _2346_/X _0030_/X _2345_/X Tile_X0Y0_S4END[6] _0338_/Q _0337_/Q VPWR
+ VGND sg13cmos5l_mux4_1
XFILLER_96_210 VPWR VGND sg13cmos5l_decap_8
XFILLER_215_56 VPWR VGND sg13cmos5l_decap_8
XFILLER_229_238 VPWR VGND sg13cmos5l_fill_1
XFILLER_296_182 VPWR VGND sg13cmos5l_decap_8
X_1304_ _1304_/Q Tile_X0Y5_FrameData[24] VGND VPWR Tile_X0Y5_FrameStrobe[1] latch
XFILLER_96_254 VPWR VGND sg13cmos5l_fill_2
X_2284_ _2284_/X _2584_/X _2582_/X _2576_/X _2575_/X _1000_/Q _0999_/Q VPWR VGND sg13cmos5l_mux4_1
XFILLER_237_260 VPWR VGND sg13cmos5l_fill_1
XFILLER_237_271 VPWR VGND sg13cmos5l_fill_2
XFILLER_244_219 VPWR VGND sg13cmos5l_decap_4
X_1235_ _1235_/Q Tile_X0Y4_FrameData[19] VGND VPWR Tile_X0Y5_FrameStrobe[6] latch
X_1166_ _1166_/Q Tile_X0Y4_FrameData[24] VGND VPWR Tile_X0Y5_FrameStrobe[4] latch
XFILLER_64_140 VPWR VGND sg13cmos5l_decap_8
XFILLER_231_77 VPWR VGND sg13cmos5l_decap_8
X_0117_ _0117_/Q Tile_X0Y0_FrameData[17] VGND VPWR Tile_X0Y5_FrameStrobe[1] latch
XFILLER_212_116 VPWR VGND sg13cmos5l_decap_8
X_1097_ _1097_/Q Tile_X0Y4_FrameData[29] VGND VPWR Tile_X0Y5_FrameStrobe[2] latch
X_0048_ _2072_/A _2555_/X _2556_/X _0869_/Q VPWR VGND sg13cmos5l_mux2_1
XFILLER_220_160 VPWR VGND sg13cmos5l_decap_8
XFILLER_165_204 VPWR VGND sg13cmos5l_decap_8
XANTENNA__1647__X Tile_X0Y0_FrameStrobe_O[7] VPWR VGND sg13cmos5l_antennanp
X_1999_ Tile_X0Y5_EE4BEG[0] _2741_/X VPWR VGND sg13cmos5l_buf_1
XFILLER_109_35 VPWR VGND sg13cmos5l_decap_8
XFILLER_118_175 VPWR VGND sg13cmos5l_decap_8
XFILLER_133_123 VPWR VGND sg13cmos5l_fill_2
XFILLER_256_63 VPWR VGND sg13cmos5l_decap_8
XFILLER_279_105 VPWR VGND sg13cmos5l_decap_8
XFILLER_69_28 VPWR VGND sg13cmos5l_decap_8
XFILLER_294_119 VPWR VGND sg13cmos5l_decap_8
XFILLER_87_221 VPWR VGND sg13cmos5l_decap_8
XFILLER_125_56 VPWR VGND sg13cmos5l_decap_8
XFILLER_272_84 VPWR VGND sg13cmos5l_decap_8
XFILLER_18_21 VPWR VGND sg13cmos5l_decap_8
XFILLER_55_140 VPWR VGND sg13cmos5l_decap_8
XFILLER_141_77 VPWR VGND sg13cmos5l_fill_2
XFILLER_18_98 VPWR VGND sg13cmos5l_decap_8
XFILLER_243_252 VPWR VGND sg13cmos5l_fill_2
XFILLER_203_105 VPWR VGND sg13cmos5l_decap_8
XFILLER_70_154 VPWR VGND sg13cmos5l_decap_8
XFILLER_34_42 VPWR VGND sg13cmos5l_decap_8
XFILLER_297_70 VPWR VGND sg13cmos5l_decap_8
XFILLER_357_175 VPWR VGND sg13cmos5l_decap_8
XANTENNA__1557__X Tile_X0Y3_FrameData_O[3] VPWR VGND sg13cmos5l_antennanp
XFILLER_126_0 VPWR VGND sg13cmos5l_decap_8
XFILLER_171_207 VPWR VGND sg13cmos5l_decap_8
XFILLER_171_218 VPWR VGND sg13cmos5l_fill_2
XFILLER_50_63 VPWR VGND sg13cmos5l_decap_8
XFILLER_124_112 VPWR VGND sg13cmos5l_fill_1
XFILLER_166_63 VPWR VGND sg13cmos5l_decap_8
XFILLER_124_145 VPWR VGND sg13cmos5l_decap_8
XFILLER_124_156 VPWR VGND sg13cmos5l_fill_2
XFILLER_124_167 VPWR VGND sg13cmos5l_fill_1
XFILLER_316_77 VPWR VGND sg13cmos5l_decap_8
XFILLER_278_182 VPWR VGND sg13cmos5l_fill_2
XFILLER_285_119 VPWR VGND sg13cmos5l_decap_8
XFILLER_78_254 VPWR VGND sg13cmos5l_fill_2
XFILLER_182_84 VPWR VGND sg13cmos5l_decap_8
XFILLER_332_21 VPWR VGND sg13cmos5l_decap_8
XFILLER_15_7 VPWR VGND sg13cmos5l_decap_8
XFILLER_293_152 VPWR VGND sg13cmos5l_decap_8
XFILLER_332_98 VPWR VGND sg13cmos5l_decap_4
X_1020_ _1020_/Q Tile_X0Y3_FrameData[26] VGND VPWR Tile_X0Y5_FrameStrobe[7] latch
XFILLER_201_14 VPWR VGND sg13cmos5l_decap_8
XFILLER_61_187 VPWR VGND sg13cmos5l_fill_1
XFILLER_61_176 VPWR VGND sg13cmos5l_decap_8
XFILLER_61_154 VPWR VGND sg13cmos5l_decap_8
X_1922_ Tile_X0Y1_EE4BEG[3] _2312_/X VPWR VGND sg13cmos5l_buf_1
XFILLER_91_70 VPWR VGND sg13cmos5l_decap_8
X_1853_ Tile_X0Y4_FrameData_O[20] Tile_X0Y4_FrameData[20] VPWR VGND sg13cmos5l_buf_1
XFILLER_348_175 VPWR VGND sg13cmos5l_decap_8
X_0804_ _0804_/Q Tile_X0Y3_FrameData[18] VGND VPWR Tile_X0Y5_FrameStrobe[0] latch
XFILLER_348_186 VPWR VGND sg13cmos5l_decap_8
X_1784_ Tile_X0Y2_E2BEG[7] _2408_/X VPWR VGND sg13cmos5l_buf_1
XFILLER_357_84 VPWR VGND sg13cmos5l_decap_8
XFILLER_115_112 VPWR VGND sg13cmos5l_decap_8
XFILLER_293_28 VPWR VGND sg13cmos5l_decap_8
XFILLER_304_223 VPWR VGND sg13cmos5l_fill_2
X_0735_ _0735_/Q Tile_X0Y2_FrameData[7] VGND VPWR Tile_X0Y5_FrameStrobe[5] latch
XFILLER_226_22 VPWR VGND sg13cmos5l_decap_8
X_0666_ _0666_/Q Tile_X0Y2_FrameData[12] VGND VPWR Tile_X0Y5_FrameStrobe[3] latch
X_2405_ _2405_/X AXIL_S_SOC_AWADDR4 AXIL_S_SOC_AWPROT2 _2484_/X _2485_/X _0738_/Q
+ _0737_/Q VPWR VGND sg13cmos5l_mux4_1
XFILLER_41_0 VPWR VGND sg13cmos5l_fill_2
XFILLER_130_159 VPWR VGND sg13cmos5l_fill_1
XFILLER_226_99 VPWR VGND sg13cmos5l_decap_8
XFILLER_269_171 VPWR VGND sg13cmos5l_decap_8
XFILLER_269_182 VPWR VGND sg13cmos5l_fill_2
X_0597_ _0597_/Q Tile_X0Y2_FrameData[17] VGND VPWR Tile_X0Y5_FrameStrobe[1] latch
XFILLER_69_221 VPWR VGND sg13cmos5l_fill_2
XFILLER_242_21 VPWR VGND sg13cmos5l_decap_8
X_2336_ _2336_/X AXIL_S_SOC_WDATA3 _2372_/X _2371_/X _2380_/X _0420_/Q _0419_/Q VPWR
+ VGND sg13cmos5l_mux4_1
XANTENNA__1930__X Tile_X0Y1_EE4BEG[11] VPWR VGND sg13cmos5l_antennanp
X_2267_ _2267_/X Tile_X0Y1_W1END[2] Tile_X0Y1_WW4END[2] Tile_X0Y1_WW4END[6] Tile_X0Y1_W6END[10]
+ _0520_/Q _0519_/Q VPWR VGND sg13cmos5l_mux4_1
XFILLER_242_98 VPWR VGND sg13cmos5l_decap_8
X_1218_ _1218_/Q Tile_X0Y4_FrameData[4] VGND VPWR Tile_X0Y5_FrameStrobe[5] latch
XFILLER_84_268 VPWR VGND sg13cmos5l_decap_4
X_2198_ _2198_/X _0066_/X Tile_X0Y0_S4END[1] _2222_/X _2221_/X _0200_/Q _0199_/Q VPWR
+ VGND sg13cmos5l_mux4_1
XFILLER_111_14 VPWR VGND sg13cmos5l_decap_8
X_1149_ _1149_/Q Tile_X0Y4_FrameData[9] VGND VPWR Tile_X0Y5_FrameStrobe[3] latch
XFILLER_37_195 VPWR VGND sg13cmos5l_fill_2
XFILLER_240_222 VPWR VGND sg13cmos5l_fill_2
XFILLER_240_255 VPWR VGND sg13cmos5l_decap_8
XFILLER_52_154 VPWR VGND sg13cmos5l_decap_8
XFILLER_200_108 VPWR VGND sg13cmos5l_decap_8
XFILLER_138_226 VPWR VGND sg13cmos5l_fill_2
XFILLER_354_112 VPWR VGND sg13cmos5l_decap_8
XFILLER_217_7 VPWR VGND sg13cmos5l_decap_8
XFILLER_267_84 VPWR VGND sg13cmos5l_decap_8
XFILLER_106_112 VPWR VGND sg13cmos5l_decap_8
XFILLER_354_189 VPWR VGND sg13cmos5l_decap_8
XFILLER_161_240 VPWR VGND sg13cmos5l_decap_8
XFILLER_20_77 VPWR VGND sg13cmos5l_decap_8
XFILLER_106_178 VPWR VGND sg13cmos5l_decap_4
XFILLER_310_204 VPWR VGND sg13cmos5l_decap_8
XFILLER_121_126 VPWR VGND sg13cmos5l_decap_8
XANTENNA__2001__X Tile_X0Y5_EE4BEG[2] VPWR VGND sg13cmos5l_antennanp
XFILLER_152_21 VPWR VGND sg13cmos5l_decap_8
XFILLER_29_42 VPWR VGND sg13cmos5l_decap_8
XFILLER_208_208 VPWR VGND sg13cmos5l_decap_4
XFILLER_275_163 VPWR VGND sg13cmos5l_decap_4
XFILLER_275_174 VPWR VGND sg13cmos5l_decap_8
XANTENNA__1840__X Tile_X0Y4_FrameData_O[7] VPWR VGND sg13cmos5l_antennanp
XFILLER_28_140 VPWR VGND sg13cmos5l_decap_4
XFILLER_290_133 VPWR VGND sg13cmos5l_decap_8
XFILLER_28_184 VPWR VGND sg13cmos5l_fill_1
XFILLER_302_35 VPWR VGND sg13cmos5l_decap_8
XFILLER_90_216 VPWR VGND sg13cmos5l_decap_8
XFILLER_90_249 VPWR VGND sg13cmos5l_decap_8
XFILLER_45_63 VPWR VGND sg13cmos5l_decap_8
XFILLER_188_126 VPWR VGND sg13cmos5l_fill_1
XFILLER_43_154 VPWR VGND sg13cmos5l_decap_8
XFILLER_243_0 VPWR VGND sg13cmos5l_decap_8
XFILLER_101_91 VPWR VGND sg13cmos5l_decap_8
XFILLER_61_84 VPWR VGND sg13cmos5l_decap_8
XFILLER_345_112 VPWR VGND sg13cmos5l_decap_8
XFILLER_177_84 VPWR VGND sg13cmos5l_decap_8
XFILLER_327_21 VPWR VGND sg13cmos5l_decap_8
XANTENNA_6 AXIL_S_SOC_WDATA10 VPWR VGND sg13cmos5l_antennanp
XFILLER_6_35 VPWR VGND sg13cmos5l_decap_8
XFILLER_345_189 VPWR VGND sg13cmos5l_decap_4
X_0520_ _0520_/Q Tile_X0Y1_FrameData[14] VGND VPWR Tile_X0Y5_FrameStrobe[6] latch
XFILLER_360_148 VPWR VGND sg13cmos5l_decap_8
XFILLER_327_98 VPWR VGND sg13cmos5l_decap_8
XFILLER_112_126 VPWR VGND sg13cmos5l_decap_8
XFILLER_258_119 VPWR VGND sg13cmos5l_decap_4
X_0451_ _0451_/Q Tile_X0Y1_FrameData[19] VGND VPWR Tile_X0Y5_FrameStrobe[4] latch
X_0382_ _0382_/Q Tile_X0Y1_FrameData[24] VGND VPWR Tile_X0Y5_FrameStrobe[2] latch
XFILLER_343_42 VPWR VGND sg13cmos5l_decap_8
XFILLER_266_141 VPWR VGND sg13cmos5l_fill_1
X_2121_ AXIL_S_SOC_RDATA15 Tile_X0Y2_W2MID[7] Tile_X0Y2_W2END[7] Tile_X0Y2_W6END[7]
+ _2488_/X _0608_/Q _0607_/Q VPWR VGND sg13cmos5l_mux4_1
XFILLER_86_70 VPWR VGND sg13cmos5l_decap_8
XFILLER_66_235 VPWR VGND sg13cmos5l_fill_2
XANTENNA__1750__X Tile_X0Y2_FrameData_O[10] VPWR VGND sg13cmos5l_antennanp
XFILLER_19_140 VPWR VGND sg13cmos5l_fill_2
XFILLER_281_133 VPWR VGND sg13cmos5l_decap_8
X_2052_ Tile_X0Y5_S2BEG[1] _2774_/X VPWR VGND sg13cmos5l_buf_1
XFILLER_212_35 VPWR VGND sg13cmos5l_decap_8
X_1003_ _1003_/Q Tile_X0Y3_FrameData[11] VGND VPWR Tile_X0Y5_FrameStrobe[6] latch
XFILLER_179_126 VPWR VGND sg13cmos5l_decap_8
XFILLER_222_222 VPWR VGND sg13cmos5l_decap_8
XFILLER_288_28 VPWR VGND sg13cmos5l_decap_8
XFILLER_336_101 VPWR VGND sg13cmos5l_decap_4
XFILLER_89_0 VPWR VGND sg13cmos5l_fill_2
X_1905_ Tile_X0Y1_FrameData_O[18] Tile_X0Y1_FrameData[18] VPWR VGND sg13cmos5l_buf_1
X_1836_ Tile_X0Y4_FrameData_O[3] Tile_X0Y4_FrameData[3] VPWR VGND sg13cmos5l_buf_1
XFILLER_237_21 VPWR VGND sg13cmos5l_decap_8
X_1767_ Tile_X0Y2_FrameData_O[27] Tile_X0Y2_FrameData[27] VPWR VGND sg13cmos5l_buf_1
XFILLER_351_126 VPWR VGND sg13cmos5l_decap_8
XANTENNA__1925__X Tile_X0Y1_EE4BEG[6] VPWR VGND sg13cmos5l_antennanp
X_0718_ _0718_/Q Tile_X0Y2_FrameData[24] VGND VPWR Tile_X0Y5_FrameStrobe[5] latch
XFILLER_237_98 VPWR VGND sg13cmos5l_decap_8
X_1698_ Tile_X0Y0_EE4BEG[6] _2187_/X VPWR VGND sg13cmos5l_buf_1
XFILLER_106_14 VPWR VGND sg13cmos5l_decap_8
XFILLER_249_119 VPWR VGND sg13cmos5l_decap_8
X_0649_ _0649_/Q Tile_X0Y2_FrameData[29] VGND VPWR Tile_X0Y5_FrameStrobe[3] latch
XFILLER_253_42 VPWR VGND sg13cmos5l_decap_8
X_2319_ _2319_/X AXIL_S_SOC_WDATA6 AXIL_S_SOC_WDATA10 _2369_/X _2378_/X _0454_/Q _0453_/Q
+ VPWR VGND sg13cmos5l_mux4_1
XANTENNA__1660__X Tile_X0Y0_FrameData_O[0] VPWR VGND sg13cmos5l_antennanp
XFILLER_57_268 VPWR VGND sg13cmos5l_decap_4
XFILLER_122_35 VPWR VGND sg13cmos5l_decap_8
XFILLER_167_7 VPWR VGND sg13cmos5l_decap_8
XFILLER_82_28 VPWR VGND sg13cmos5l_decap_8
XFILLER_198_28 VPWR VGND sg13cmos5l_decap_8
XFILLER_25_154 VPWR VGND sg13cmos5l_fill_1
XFILLER_334_7 VPWR VGND sg13cmos5l_decap_8
XFILLER_80_271 VPWR VGND sg13cmos5l_fill_2
XFILLER_15_77 VPWR VGND sg13cmos5l_decap_8
XFILLER_327_112 VPWR VGND sg13cmos5l_fill_2
XFILLER_31_21 VPWR VGND sg13cmos5l_decap_8
XFILLER_147_21 VPWR VGND sg13cmos5l_decap_8
XFILLER_193_184 VPWR VGND sg13cmos5l_fill_1
XANTENNA__1835__X Tile_X0Y4_FrameData_O[2] VPWR VGND sg13cmos5l_antennanp
XFILLER_31_98 VPWR VGND sg13cmos5l_decap_8
XFILLER_342_148 VPWR VGND sg13cmos5l_decap_4
XFILLER_134_251 VPWR VGND sg13cmos5l_fill_1
XFILLER_295_203 VPWR VGND sg13cmos5l_decap_8
XFILLER_350_170 VPWR VGND sg13cmos5l_decap_8
XFILLER_0_242 VPWR VGND sg13cmos5l_fill_2
XFILLER_163_42 VPWR VGND sg13cmos5l_decap_8
XFILLER_193_0 VPWR VGND sg13cmos5l_decap_8
XANTENNA__1570__X Tile_X0Y3_FrameData_O[16] VPWR VGND sg13cmos5l_antennanp
XFILLER_313_56 VPWR VGND sg13cmos5l_decap_8
XFILLER_48_257 VPWR VGND sg13cmos5l_decap_4
XFILLER_263_155 VPWR VGND sg13cmos5l_decap_8
XFILLER_56_84 VPWR VGND sg13cmos5l_decap_8
XFILLER_360_0 VPWR VGND sg13cmos5l_decap_8
XFILLER_169_192 VPWR VGND sg13cmos5l_decap_8
XFILLER_318_112 VPWR VGND sg13cmos5l_decap_8
XFILLER_82_7 VPWR VGND sg13cmos5l_decap_8
X_2670_ _2670_/X _2676_/X _2675_/X Tile_X0Y4_W6END[1] _2670_/A3 _1036_/Q _1035_/Q
+ VPWR VGND sg13cmos5l_mux4_1
XFILLER_338_42 VPWR VGND sg13cmos5l_decap_8
XFILLER_184_195 VPWR VGND sg13cmos5l_decap_4
X_1621_ Tile_X0Y0_N2BEGb[1] _2252_/X VPWR VGND sg13cmos5l_buf_1
XANTENNA__1745__X Tile_X0Y2_FrameData_O[5] VPWR VGND sg13cmos5l_antennanp
XFILLER_333_137 VPWR VGND sg13cmos5l_decap_8
XFILLER_207_35 VPWR VGND sg13cmos5l_decap_8
X_1552_ Tile_X0Y3_EE4BEG[14] _2539_/X VPWR VGND sg13cmos5l_buf_1
XFILLER_140_221 VPWR VGND sg13cmos5l_decap_8
XFILLER_286_203 VPWR VGND sg13cmos5l_fill_1
X_1483_ _1483_/Q Tile_X0Y5_FrameData[5] VGND VPWR Tile_X0Y5_FrameStrobe[6] latch
X_0503_ _0503_/Q Tile_X0Y1_FrameData[31] VGND VPWR Tile_X0Y5_FrameStrobe[6] latch
XFILLER_354_63 VPWR VGND sg13cmos5l_decap_8
XFILLER_341_170 VPWR VGND sg13cmos5l_fill_1
X_0434_ _0434_/Q Tile_X0Y1_FrameData[4] VGND VPWR Tile_X0Y5_FrameStrobe[3] latch
XFILLER_98_157 VPWR VGND sg13cmos5l_decap_8
XFILLER_97_91 VPWR VGND sg13cmos5l_decap_8
XFILLER_39_202 VPWR VGND sg13cmos5l_decap_4
XFILLER_223_56 VPWR VGND sg13cmos5l_decap_8
XFILLER_239_196 VPWR VGND sg13cmos5l_decap_8
X_2104_ AXIL_S_SOC_BVALID Tile_X0Y4_W2MID[4] Tile_X0Y4_W2END[4] Tile_X0Y4_W6END[4]
+ _2712_/X _1088_/Q _1087_/Q VPWR VGND sg13cmos5l_mux4_1
X_0365_ _0365_/Q Tile_X0Y1_FrameData[9] VGND VPWR Tile_X0Y5_FrameStrobe[1] latch
XFILLER_254_133 VPWR VGND sg13cmos5l_decap_4
X_0296_ _0296_/Q Tile_X0Y0_FrameData[30] VGND VPWR Tile_X0Y5_FrameStrobe[7] latch
XFILLER_299_49 VPWR VGND sg13cmos5l_decap_8
X_2035_ Tile_X0Y5_FrameData_O[20] Tile_X0Y5_FrameData[20] VPWR VGND sg13cmos5l_buf_1
XFILLER_210_214 VPWR VGND sg13cmos5l_fill_2
XFILLER_309_112 VPWR VGND sg13cmos5l_decap_8
XFILLER_175_140 VPWR VGND sg13cmos5l_decap_8
XFILLER_248_42 VPWR VGND sg13cmos5l_decap_8
XANTENNA__1655__X Tile_X0Y0_FrameStrobe_O[15] VPWR VGND sg13cmos5l_antennanp
XFILLER_190_143 VPWR VGND sg13cmos5l_fill_1
XFILLER_324_126 VPWR VGND sg13cmos5l_decap_8
XFILLER_324_137 VPWR VGND sg13cmos5l_fill_2
X_1819_ Tile_X0Y4_EE4BEG[2] _2635_/X VPWR VGND sg13cmos5l_buf_1
X_2799_ _2799_/X Tile_X0Y5_N2MID[5] Tile_X0Y5_N2END[5] _2834_/X _2718_/X _1278_/Q
+ _1277_/Q VPWR VGND sg13cmos5l_mux4_1
XFILLER_117_35 VPWR VGND sg13cmos5l_decap_8
XFILLER_264_63 VPWR VGND sg13cmos5l_decap_8
XFILLER_89_135 VPWR VGND sg13cmos5l_decap_8
XFILLER_77_28 VPWR VGND sg13cmos5l_decap_8
XFILLER_133_56 VPWR VGND sg13cmos5l_decap_8
XFILLER_284_7 VPWR VGND sg13cmos5l_decap_8
XFILLER_245_133 VPWR VGND sg13cmos5l_decap_8
XFILLER_280_84 VPWR VGND sg13cmos5l_decap_8
XANTENNA_204 Tile_X0Y0_S2MID[5] VPWR VGND sg13cmos5l_antennanp
XANTENNA_215 Tile_X0Y5_FrameStrobe[15] VPWR VGND sg13cmos5l_antennanp
XFILLER_245_177 VPWR VGND sg13cmos5l_decap_8
XFILLER_245_188 VPWR VGND sg13cmos5l_fill_2
XFILLER_26_21 VPWR VGND sg13cmos5l_decap_8
XFILLER_93_49 VPWR VGND sg13cmos5l_decap_8
XANTENNA_226 Tile_X0Y5_N2MID[4] VPWR VGND sg13cmos5l_antennanp
XANTENNA_237 AXIL_S_SOC_WDATA22 VPWR VGND sg13cmos5l_antennanp
XANTENNA_248 AXIL_S_SOC_WDATA22 VPWR VGND sg13cmos5l_antennanp
XANTENNA_259 AXIL_S_SOC_WDATA22 VPWR VGND sg13cmos5l_antennanp
XFILLER_26_98 VPWR VGND sg13cmos5l_decap_8
XFILLER_53_271 VPWR VGND sg13cmos5l_fill_2
XFILLER_53_260 VPWR VGND sg13cmos5l_fill_1
XFILLER_201_214 VPWR VGND sg13cmos5l_decap_8
XFILLER_201_269 VPWR VGND sg13cmos5l_decap_4
XFILLER_42_31 VPWR VGND sg13cmos5l_decap_8
XFILLER_158_42 VPWR VGND sg13cmos5l_decap_8
XANTENNA__1565__X Tile_X0Y3_FrameData_O[11] VPWR VGND sg13cmos5l_antennanp
XFILLER_181_154 VPWR VGND sg13cmos5l_decap_8
XFILLER_206_0 VPWR VGND sg13cmos5l_decap_8
XFILLER_308_56 VPWR VGND sg13cmos5l_decap_8
XFILLER_315_126 VPWR VGND sg13cmos5l_decap_8
XFILLER_107_240 VPWR VGND sg13cmos5l_decap_8
XFILLER_174_63 VPWR VGND sg13cmos5l_decap_8
XFILLER_268_203 VPWR VGND sg13cmos5l_decap_4
XFILLER_3_14 VPWR VGND sg13cmos5l_decap_8
XFILLER_324_77 VPWR VGND sg13cmos5l_decap_8
XFILLER_190_84 VPWR VGND sg13cmos5l_decap_8
XFILLER_236_133 VPWR VGND sg13cmos5l_decap_8
X_0150_ _0150_/Q Tile_X0Y0_FrameData[16] VGND VPWR Tile_X0Y5_FrameStrobe[2] latch
XFILLER_340_21 VPWR VGND sg13cmos5l_decap_8
XFILLER_236_177 VPWR VGND sg13cmos5l_decap_8
XFILLER_291_272 VPWR VGND sg13cmos5l_fill_1
X_0081_ _0081_/Q Tile_X0Y0_FrameData[21] VGND VPWR Tile_X0Y5_FrameStrobe[0] latch
XFILLER_36_238 VPWR VGND sg13cmos5l_fill_1
XFILLER_251_158 VPWR VGND sg13cmos5l_decap_8
XFILLER_44_271 VPWR VGND sg13cmos5l_fill_2
XFILLER_340_98 VPWR VGND sg13cmos5l_decap_8
X_0983_ _0983_/Q Tile_X0Y3_FrameData[31] VGND VPWR Tile_X0Y5_FrameStrobe[6] latch
XFILLER_349_63 VPWR VGND sg13cmos5l_decap_8
X_2722_ _2722_/X Tile_X0Y5_N1END[1] _2794_/X AXIL_S_SOC_ARPROT1 AXIL_S_SOC_ARVALID
+ _1458_/Q _1457_/Q VPWR VGND sg13cmos5l_mux4_1
XFILLER_8_172 VPWR VGND sg13cmos5l_fill_2
XFILLER_306_126 VPWR VGND sg13cmos5l_decap_8
X_2653_ _2653_/X AXIL_S_SOC_WVALID _2700_/X _2685_/X _2708_/X _1148_/Q _1147_/Q VPWR
+ VGND sg13cmos5l_mux4_1
XFILLER_172_154 VPWR VGND sg13cmos5l_decap_8
XFILLER_218_56 VPWR VGND sg13cmos5l_decap_8
X_1604_ Tile_X0Y0_N4BEG[0] _1604_/A VPWR VGND sg13cmos5l_buf_1
X_2584_ _2584_/X _2570_/X Tile_X0Y5_N4END[10] _2569_/X Tile_X0Y0_S4END[14] _0842_/Q
+ _0841_/Q VPWR VGND sg13cmos5l_mux4_1
XFILLER_113_221 VPWR VGND sg13cmos5l_decap_8
XFILLER_321_118 VPWR VGND sg13cmos5l_decap_8
X_1535_ Tile_X0Y3_E6BEG[9] _2550_/X VPWR VGND sg13cmos5l_buf_1
XFILLER_86_105 VPWR VGND sg13cmos5l_decap_8
X_1466_ _1466_/Q Tile_X0Y5_FrameData[22] VGND VPWR Tile_X0Y5_FrameStrobe[6] latch
XFILLER_234_77 VPWR VGND sg13cmos5l_decap_8
X_1397_ _1397_/Q Tile_X0Y5_FrameData[27] VGND VPWR Tile_X0Y5_FrameStrobe[4] latch
X_0417_ _0417_/Q Tile_X0Y1_FrameData[21] VGND VPWR Tile_X0Y5_FrameStrobe[3] latch
X_0348_ _0348_/Q Tile_X0Y1_FrameData[26] VGND VPWR Tile_X0Y5_FrameStrobe[1] latch
XFILLER_227_166 VPWR VGND sg13cmos5l_decap_8
XFILLER_250_21 VPWR VGND sg13cmos5l_decap_8
XFILLER_27_238 VPWR VGND sg13cmos5l_decap_8
XFILLER_242_147 VPWR VGND sg13cmos5l_decap_8
X_2018_ Tile_X0Y5_FrameData_O[3] Tile_X0Y5_FrameData[3] VPWR VGND sg13cmos5l_buf_1
X_0279_ _0279_/Q Tile_X0Y0_FrameData[15] VGND VPWR Tile_X0Y5_FrameStrobe[6] latch
XFILLER_42_219 VPWR VGND sg13cmos5l_decap_4
XFILLER_250_98 VPWR VGND sg13cmos5l_decap_8
XFILLER_35_271 VPWR VGND sg13cmos5l_fill_2
XFILLER_195_202 VPWR VGND sg13cmos5l_fill_2
XFILLER_50_230 VPWR VGND sg13cmos5l_decap_8
XFILLER_10_105 VPWR VGND sg13cmos5l_decap_8
XFILLER_259_63 VPWR VGND sg13cmos5l_decap_8
XFILLER_148_184 VPWR VGND sg13cmos5l_decap_8
XFILLER_12_56 VPWR VGND sg13cmos5l_decap_8
XFILLER_352_210 VPWR VGND sg13cmos5l_decap_8
XFILLER_128_56 VPWR VGND sg13cmos5l_decap_8
XFILLER_275_84 VPWR VGND sg13cmos5l_decap_8
XFILLER_104_221 VPWR VGND sg13cmos5l_fill_1
XFILLER_88_49 VPWR VGND sg13cmos5l_decap_8
XFILLER_104_232 VPWR VGND sg13cmos5l_decap_8
XFILLER_77_127 VPWR VGND sg13cmos5l_decap_4
XFILLER_77_105 VPWR VGND sg13cmos5l_decap_8
XFILLER_144_77 VPWR VGND sg13cmos5l_decap_4
XFILLER_37_42 VPWR VGND sg13cmos5l_decap_8
XFILLER_160_21 VPWR VGND sg13cmos5l_decap_8
XFILLER_18_227 VPWR VGND sg13cmos5l_fill_2
XFILLER_233_147 VPWR VGND sg13cmos5l_decap_8
XFILLER_160_98 VPWR VGND sg13cmos5l_decap_8
XFILLER_26_271 VPWR VGND sg13cmos5l_fill_2
XFILLER_310_35 VPWR VGND sg13cmos5l_decap_8
XFILLER_156_0 VPWR VGND sg13cmos5l_decap_8
XFILLER_53_63 VPWR VGND sg13cmos5l_decap_8
XFILLER_169_63 VPWR VGND sg13cmos5l_decap_8
XFILLER_186_224 VPWR VGND sg13cmos5l_fill_1
XFILLER_186_246 VPWR VGND sg13cmos5l_fill_1
XFILLER_139_140 VPWR VGND sg13cmos5l_fill_2
XFILLER_323_0 VPWR VGND sg13cmos5l_decap_8
XFILLER_319_77 VPWR VGND sg13cmos5l_decap_8
XFILLER_154_154 VPWR VGND sg13cmos5l_decap_4
XFILLER_154_165 VPWR VGND sg13cmos5l_fill_2
XFILLER_185_84 VPWR VGND sg13cmos5l_decap_8
XFILLER_154_198 VPWR VGND sg13cmos5l_decap_8
XFILLER_335_21 VPWR VGND sg13cmos5l_decap_8
X_1320_ _1320_/Q Tile_X0Y5_FrameData[8] VGND VPWR Tile_X0Y5_FrameStrobe[1] latch
XFILLER_335_98 VPWR VGND sg13cmos5l_decap_4
XFILLER_68_105 VPWR VGND sg13cmos5l_decap_8
XFILLER_204_14 VPWR VGND sg13cmos5l_decap_8
X_1251_ _1251_/Q Tile_X0Y4_FrameData[3] VGND VPWR Tile_X0Y5_FrameStrobe[6] latch
X_1182_ _1182_/Q Tile_X0Y4_FrameData[8] VGND VPWR Tile_X0Y5_FrameStrobe[4] latch
X_0202_ _0202_/Q Tile_X0Y0_FrameData[28] VGND VPWR Tile_X0Y5_FrameStrobe[4] latch
XFILLER_351_42 VPWR VGND sg13cmos5l_decap_8
XFILLER_209_166 VPWR VGND sg13cmos5l_fill_1
X_0133_ _0133_/Q Tile_X0Y0_FrameData[1] VGND VPWR Tile_X0Y5_FrameStrobe[1] latch
XFILLER_94_70 VPWR VGND sg13cmos5l_decap_8
XFILLER_220_35 VPWR VGND sg13cmos5l_decap_8
XFILLER_224_169 VPWR VGND sg13cmos5l_decap_8
X_0064_ _0064_/X _2227_/X _2228_/X _1232_/Q VPWR VGND sg13cmos5l_mux2_1
XFILLER_177_213 VPWR VGND sg13cmos5l_decap_8
XFILLER_296_28 VPWR VGND sg13cmos5l_decap_8
XFILLER_177_257 VPWR VGND sg13cmos5l_fill_1
X_0966_ _0966_/Q Tile_X0Y3_FrameData[16] VGND VPWR Tile_X0Y5_FrameStrobe[5] latch
XFILLER_71_0 VPWR VGND sg13cmos5l_decap_8
XFILLER_229_77 VPWR VGND sg13cmos5l_decap_8
X_2705_ _2705_/X _2676_/X Tile_X0Y5_N4END[5] _2675_/X _0071_/X _1084_/Q _1083_/Q VPWR
+ VGND sg13cmos5l_mux4_1
XFILLER_145_176 VPWR VGND sg13cmos5l_decap_4
X_2636_ _2636_/X Tile_X0Y4_WW4END[7] AXIL_S_SOC_WSTRB3 _2696_/X _2712_/X _1182_/Q
+ _1181_/Q VPWR VGND sg13cmos5l_mux4_1
X_0897_ _0897_/Q Tile_X0Y3_FrameData[21] VGND VPWR Tile_X0Y5_FrameStrobe[3] latch
XFILLER_245_21 VPWR VGND sg13cmos5l_decap_8
XANTENNA__1933__X Tile_X0Y1_EE4BEG[14] VPWR VGND sg13cmos5l_antennanp
X_2567_ _2567_/X Tile_X0Y2_W1END[1] Tile_X0Y2_W6END[9] _2469_/X _2454_/X _0656_/Q
+ _0655_/Q VPWR VGND sg13cmos5l_mux4_1
XFILLER_245_98 VPWR VGND sg13cmos5l_decap_8
XFILLER_302_140 VPWR VGND sg13cmos5l_decap_8
X_1518_ _2456_/A3 VPWR VGND sg13cmos5l_tielo
X_2498_ _2498_/X Tile_X0Y4_W2MID[3] Tile_X0Y4_W2END[3] Tile_X0Y4_W6END[3] _2712_/X
+ _1248_/Q _1247_/Q VPWR VGND sg13cmos5l_mux4_1
XFILLER_59_105 VPWR VGND sg13cmos5l_decap_8
XFILLER_114_14 VPWR VGND sg13cmos5l_decap_8
X_1449_ _1449_/Q Tile_X0Y5_FrameData[7] VGND VPWR Tile_X0Y5_FrameStrobe[5] latch
XFILLER_261_42 VPWR VGND sg13cmos5l_decap_8
XFILLER_74_119 VPWR VGND sg13cmos5l_decap_4
XFILLER_215_125 VPWR VGND sg13cmos5l_decap_4
XFILLER_130_35 VPWR VGND sg13cmos5l_decap_8
XFILLER_215_158 VPWR VGND sg13cmos5l_decap_8
XFILLER_215_169 VPWR VGND sg13cmos5l_fill_2
XFILLER_247_7 VPWR VGND sg13cmos5l_decap_8
XFILLER_23_77 VPWR VGND sg13cmos5l_decap_8
XFILLER_286_50 VPWR VGND sg13cmos5l_decap_8
XFILLER_139_77 VPWR VGND sg13cmos5l_decap_8
XANTENNA__2004__X Tile_X0Y5_EE4BEG[5] VPWR VGND sg13cmos5l_antennanp
XFILLER_155_21 VPWR VGND sg13cmos5l_decap_8
XFILLER_2_112 VPWR VGND sg13cmos5l_fill_2
XANTENNA__1843__X Tile_X0Y4_FrameData_O[10] VPWR VGND sg13cmos5l_antennanp
XFILLER_305_35 VPWR VGND sg13cmos5l_decap_8
XFILLER_238_239 VPWR VGND sg13cmos5l_decap_8
XFILLER_171_42 VPWR VGND sg13cmos5l_decap_8
XFILLER_65_119 VPWR VGND sg13cmos5l_decap_8
XFILLER_48_74 VPWR VGND sg13cmos5l_decap_8
XFILLER_206_103 VPWR VGND sg13cmos5l_decap_8
XFILLER_273_0 VPWR VGND sg13cmos5l_decap_8
XFILLER_58_182 VPWR VGND sg13cmos5l_decap_8
XFILLER_206_158 VPWR VGND sg13cmos5l_decap_4
XFILLER_64_84 VPWR VGND sg13cmos5l_decap_8
XFILLER_9_35 VPWR VGND sg13cmos5l_decap_8
XFILLER_174_205 VPWR VGND sg13cmos5l_decap_8
X_0820_ _0820_/Q Tile_X0Y3_FrameData[2] VGND VPWR Tile_X0Y5_FrameStrobe[0] latch
X_0751_ _0751_/Q Tile_X0Y2_FrameData[23] VGND VPWR Tile_X0Y5_FrameStrobe[6] latch
XFILLER_346_42 VPWR VGND sg13cmos5l_decap_8
XFILLER_182_271 VPWR VGND sg13cmos5l_fill_2
X_0682_ _0682_/Q Tile_X0Y2_FrameData[28] VGND VPWR Tile_X0Y5_FrameStrobe[4] latch
XANTENNA__1753__X Tile_X0Y2_FrameData_O[13] VPWR VGND sg13cmos5l_antennanp
X_2421_ _2421_/X AXIL_S_SOC_AWADDR4 AXIL_S_SOC_AWADDR8 _2466_/X _2484_/X _0706_/Q
+ _0705_/Q VPWR VGND sg13cmos5l_mux4_1
XFILLER_215_35 VPWR VGND sg13cmos5l_decap_8
X_2352_ _2352_/X _2824_/X _2823_/X _2814_/X _2813_/X _1472_/Q _1471_/Q VPWR VGND sg13cmos5l_mux4_1
XFILLER_296_161 VPWR VGND sg13cmos5l_decap_8
X_1303_ _1303_/Q Tile_X0Y5_FrameData[25] VGND VPWR Tile_X0Y5_FrameStrobe[1] latch
X_2283_ _2283_/X Tile_X0Y3_W1END[2] Tile_X0Y3_WW4END[2] Tile_X0Y3_WW4END[6] Tile_X0Y3_W6END[10]
+ _1000_/Q _0999_/Q VPWR VGND sg13cmos5l_mux4_1
XFILLER_362_63 VPWR VGND sg13cmos5l_decap_8
X_1234_ _1234_/Q Tile_X0Y4_FrameData[20] VGND VPWR Tile_X0Y5_FrameStrobe[6] latch
XFILLER_56_119 VPWR VGND sg13cmos5l_decap_8
XFILLER_49_182 VPWR VGND sg13cmos5l_decap_8
X_1165_ _1165_/Q Tile_X0Y4_FrameData[25] VGND VPWR Tile_X0Y5_FrameStrobe[4] latch
XFILLER_231_56 VPWR VGND sg13cmos5l_decap_8
X_1096_ _1096_/Q Tile_X0Y4_FrameData[30] VGND VPWR Tile_X0Y5_FrameStrobe[2] latch
X_0116_ _0116_/Q Tile_X0Y0_FrameData[18] VGND VPWR Tile_X0Y5_FrameStrobe[1] latch
X_0047_ _2068_/A _2447_/X _2448_/X _0629_/Q VPWR VGND sg13cmos5l_mux2_1
XFILLER_212_139 VPWR VGND sg13cmos5l_decap_8
XANTENNA__1928__X Tile_X0Y1_EE4BEG[9] VPWR VGND sg13cmos5l_antennanp
XFILLER_100_49 VPWR VGND sg13cmos5l_decap_8
XFILLER_109_14 VPWR VGND sg13cmos5l_decap_8
X_1998_ Tile_X0Y5_E6BEG[11] _2768_/X VPWR VGND sg13cmos5l_buf_1
XFILLER_118_154 VPWR VGND sg13cmos5l_decap_8
XFILLER_256_42 VPWR VGND sg13cmos5l_decap_8
X_0949_ _0949_/Q Tile_X0Y3_FrameData[1] VGND VPWR Tile_X0Y5_FrameStrobe[4] latch
XFILLER_173_271 VPWR VGND sg13cmos5l_fill_2
XANTENNA__1663__X Tile_X0Y0_FrameData_O[3] VPWR VGND sg13cmos5l_antennanp
X_2619_ _2619_/X AXIL_S_SOC_WSTRB2 AXIL_S_SOC_WVALID _2710_/X _2683_/X _1216_/Q _1215_/Q
+ VPWR VGND sg13cmos5l_mux4_1
XFILLER_133_179 VPWR VGND sg13cmos5l_fill_1
XFILLER_125_35 VPWR VGND sg13cmos5l_decap_8
XFILLER_272_63 VPWR VGND sg13cmos5l_decap_8
XFILLER_197_7 VPWR VGND sg13cmos5l_decap_8
XFILLER_47_119 VPWR VGND sg13cmos5l_decap_8
XFILLER_228_261 VPWR VGND sg13cmos5l_fill_1
XFILLER_18_77 VPWR VGND sg13cmos5l_decap_8
XFILLER_228_272 VPWR VGND sg13cmos5l_fill_1
XFILLER_141_56 VPWR VGND sg13cmos5l_decap_8
XFILLER_70_133 VPWR VGND sg13cmos5l_decap_8
XFILLER_55_196 VPWR VGND sg13cmos5l_decap_8
XFILLER_34_21 VPWR VGND sg13cmos5l_decap_8
XANTENNA__1838__X Tile_X0Y4_FrameData_O[5] VPWR VGND sg13cmos5l_antennanp
XFILLER_34_98 VPWR VGND sg13cmos5l_decap_8
XFILLER_357_154 VPWR VGND sg13cmos5l_decap_8
XFILLER_50_42 VPWR VGND sg13cmos5l_decap_8
XFILLER_109_154 VPWR VGND sg13cmos5l_decap_8
XFILLER_109_165 VPWR VGND sg13cmos5l_fill_1
XFILLER_119_0 VPWR VGND sg13cmos5l_decap_8
XFILLER_166_42 VPWR VGND sg13cmos5l_decap_8
XANTENNA__1573__X Tile_X0Y3_FrameData_O[19] VPWR VGND sg13cmos5l_antennanp
XFILLER_1_0 VPWR VGND sg13cmos5l_decap_8
XFILLER_316_56 VPWR VGND sg13cmos5l_decap_8
XFILLER_182_63 VPWR VGND sg13cmos5l_decap_8
XFILLER_59_84 VPWR VGND sg13cmos5l_decap_8
XFILLER_38_119 VPWR VGND sg13cmos5l_decap_8
XFILLER_332_77 VPWR VGND sg13cmos5l_decap_8
XFILLER_234_231 VPWR VGND sg13cmos5l_decap_8
XFILLER_234_253 VPWR VGND sg13cmos5l_fill_2
XFILLER_46_163 VPWR VGND sg13cmos5l_fill_2
XFILLER_46_152 VPWR VGND sg13cmos5l_decap_8
XFILLER_61_133 VPWR VGND sg13cmos5l_decap_8
XFILLER_46_196 VPWR VGND sg13cmos5l_decap_8
XFILLER_202_150 VPWR VGND sg13cmos5l_fill_1
X_1921_ Tile_X0Y1_EE4BEG[2] _2311_/X VPWR VGND sg13cmos5l_buf_1
XANTENNA__1748__X Tile_X0Y2_FrameData_O[8] VPWR VGND sg13cmos5l_antennanp
XFILLER_202_172 VPWR VGND sg13cmos5l_decap_4
XFILLER_202_194 VPWR VGND sg13cmos5l_fill_1
X_1852_ Tile_X0Y4_FrameData_O[19] Tile_X0Y4_FrameData[19] VPWR VGND sg13cmos5l_buf_1
XFILLER_348_154 VPWR VGND sg13cmos5l_decap_8
X_0803_ _0803_/Q Tile_X0Y3_FrameData[19] VGND VPWR Tile_X0Y5_FrameStrobe[0] latch
X_1783_ Tile_X0Y2_E2BEG[6] _2407_/X VPWR VGND sg13cmos5l_buf_1
XFILLER_357_63 VPWR VGND sg13cmos5l_decap_8
X_0734_ _0734_/Q Tile_X0Y2_FrameData[8] VGND VPWR Tile_X0Y5_FrameStrobe[5] latch
X_0665_ _0665_/Q Tile_X0Y2_FrameData[13] VGND VPWR Tile_X0Y5_FrameStrobe[3] latch
XFILLER_115_168 VPWR VGND sg13cmos5l_decap_8
XFILLER_115_179 VPWR VGND sg13cmos5l_fill_1
XFILLER_226_78 VPWR VGND sg13cmos5l_decap_8
XFILLER_304_268 VPWR VGND sg13cmos5l_fill_1
X_2404_ _2404_/X AXIL_S_SOC_AWADDR3 AXIL_S_SOC_AWPROT1 _2484_/X _2485_/X _0740_/Q
+ _0739_/Q VPWR VGND sg13cmos5l_mux4_1
X_0596_ _0596_/Q Tile_X0Y2_FrameData[18] VGND VPWR Tile_X0Y5_FrameStrobe[1] latch
XFILLER_34_0 VPWR VGND sg13cmos5l_decap_8
X_2335_ _2335_/X AXIL_S_SOC_WDATA2 _2370_/X _2369_/X _2379_/X _0422_/Q _0421_/Q VPWR
+ VGND sg13cmos5l_mux4_1
XFILLER_29_119 VPWR VGND sg13cmos5l_decap_4
X_2266_ _2266_/X _2367_/X _2365_/X _2350_/X _2349_/X _0517_/Q _0516_/Q VPWR VGND sg13cmos5l_mux4_1
XFILLER_242_77 VPWR VGND sg13cmos5l_decap_8
X_2197_ _2197_/X _0049_/X Tile_X0Y0_S4END[0] _2218_/X _2217_/X _0202_/Q _0201_/Q VPWR
+ VGND sg13cmos5l_mux4_1
X_1217_ _1217_/Q Tile_X0Y4_FrameData[5] VGND VPWR Tile_X0Y5_FrameStrobe[5] latch
XFILLER_1_91 VPWR VGND sg13cmos5l_decap_8
XFILLER_225_242 VPWR VGND sg13cmos5l_decap_8
XFILLER_37_152 VPWR VGND sg13cmos5l_fill_1
XFILLER_197_105 VPWR VGND sg13cmos5l_decap_4
XFILLER_225_264 VPWR VGND sg13cmos5l_decap_8
X_1148_ _1148_/Q Tile_X0Y4_FrameData[10] VGND VPWR Tile_X0Y5_FrameStrobe[3] latch
XFILLER_52_133 VPWR VGND sg13cmos5l_decap_8
XFILLER_197_116 VPWR VGND sg13cmos5l_fill_1
XFILLER_197_138 VPWR VGND sg13cmos5l_decap_8
X_1079_ _1079_/Q Tile_X0Y4_FrameData[15] VGND VPWR Tile_X0Y5_FrameStrobe[1] latch
XANTENNA__1658__X Tile_X0Y0_FrameStrobe_O[18] VPWR VGND sg13cmos5l_antennanp
XFILLER_267_63 VPWR VGND sg13cmos5l_decap_8
XFILLER_354_168 VPWR VGND sg13cmos5l_decap_8
XFILLER_112_7 VPWR VGND sg13cmos5l_decap_8
XFILLER_20_56 VPWR VGND sg13cmos5l_decap_8
XFILLER_121_105 VPWR VGND sg13cmos5l_decap_8
XFILLER_136_56 VPWR VGND sg13cmos5l_decap_8
XFILLER_283_84 VPWR VGND sg13cmos5l_decap_8
XFILLER_96_49 VPWR VGND sg13cmos5l_decap_8
XFILLER_29_21 VPWR VGND sg13cmos5l_decap_8
XFILLER_290_112 VPWR VGND sg13cmos5l_decap_8
XFILLER_29_98 VPWR VGND sg13cmos5l_decap_8
XFILLER_302_14 VPWR VGND sg13cmos5l_decap_8
XFILLER_28_152 VPWR VGND sg13cmos5l_decap_4
XFILLER_290_189 VPWR VGND sg13cmos5l_decap_8
XFILLER_45_42 VPWR VGND sg13cmos5l_decap_8
XFILLER_43_133 VPWR VGND sg13cmos5l_decap_8
XFILLER_188_105 VPWR VGND sg13cmos5l_decap_8
XFILLER_101_70 VPWR VGND sg13cmos5l_decap_8
XANTENNA__1568__X Tile_X0Y3_FrameData_O[14] VPWR VGND sg13cmos5l_antennanp
XFILLER_236_0 VPWR VGND sg13cmos5l_decap_8
XFILLER_129_227 VPWR VGND sg13cmos5l_fill_1
XFILLER_61_63 VPWR VGND sg13cmos5l_decap_8
XFILLER_177_63 VPWR VGND sg13cmos5l_decap_8
XFILLER_6_14 VPWR VGND sg13cmos5l_decap_8
XANTENNA_7 AXIL_S_SOC_WDATA10 VPWR VGND sg13cmos5l_antennanp
XFILLER_144_219 VPWR VGND sg13cmos5l_decap_8
XFILLER_360_127 VPWR VGND sg13cmos5l_decap_8
XFILLER_327_77 VPWR VGND sg13cmos5l_decap_8
XFILLER_112_105 VPWR VGND sg13cmos5l_decap_8
X_0450_ _0450_/Q Tile_X0Y1_FrameData[20] VGND VPWR Tile_X0Y5_FrameStrobe[4] latch
XFILLER_193_84 VPWR VGND sg13cmos5l_decap_8
XFILLER_343_21 VPWR VGND sg13cmos5l_decap_8
X_0381_ _0381_/Q Tile_X0Y1_FrameData[25] VGND VPWR Tile_X0Y5_FrameStrobe[2] latch
XFILLER_120_182 VPWR VGND sg13cmos5l_decap_4
XFILLER_266_153 VPWR VGND sg13cmos5l_fill_1
X_2120_ AXIL_S_SOC_RDATA14 Tile_X0Y2_W2MID[6] Tile_X0Y2_W2END[6] Tile_X0Y2_W6END[6]
+ _2487_/X _0610_/Q _0609_/Q VPWR VGND sg13cmos5l_mux4_1
XFILLER_343_98 VPWR VGND sg13cmos5l_decap_8
XFILLER_212_14 VPWR VGND sg13cmos5l_decap_8
XFILLER_266_186 VPWR VGND sg13cmos5l_decap_4
XFILLER_266_197 VPWR VGND sg13cmos5l_decap_8
XFILLER_281_112 VPWR VGND sg13cmos5l_decap_8
X_2051_ Tile_X0Y5_S2BEG[0] _2773_/X VPWR VGND sg13cmos5l_buf_1
XFILLER_19_163 VPWR VGND sg13cmos5l_decap_4
XFILLER_207_242 VPWR VGND sg13cmos5l_fill_2
X_1002_ _1002_/Q Tile_X0Y3_FrameData[12] VGND VPWR Tile_X0Y5_FrameStrobe[6] latch
XFILLER_222_201 VPWR VGND sg13cmos5l_decap_8
XFILLER_81_239 VPWR VGND sg13cmos5l_fill_2
XFILLER_179_105 VPWR VGND sg13cmos5l_decap_8
XFILLER_34_177 VPWR VGND sg13cmos5l_fill_1
XFILLER_194_119 VPWR VGND sg13cmos5l_fill_1
X_1904_ Tile_X0Y1_FrameData_O[17] Tile_X0Y1_FrameData[17] VPWR VGND sg13cmos5l_buf_1
XFILLER_336_135 VPWR VGND sg13cmos5l_decap_4
X_1835_ Tile_X0Y4_FrameData_O[2] Tile_X0Y4_FrameData[2] VPWR VGND sg13cmos5l_buf_1
XFILLER_128_271 VPWR VGND sg13cmos5l_fill_2
X_1766_ Tile_X0Y2_FrameData_O[26] Tile_X0Y2_FrameData[26] VPWR VGND sg13cmos5l_buf_1
XFILLER_351_105 VPWR VGND sg13cmos5l_decap_8
XFILLER_237_77 VPWR VGND sg13cmos5l_decap_8
X_0717_ _0717_/Q Tile_X0Y2_FrameData[25] VGND VPWR Tile_X0Y5_FrameStrobe[5] latch
XANTENNA__2102__X AXIL_S_SOC_BRESP0 VPWR VGND sg13cmos5l_antennanp
XFILLER_103_105 VPWR VGND sg13cmos5l_decap_4
XFILLER_289_234 VPWR VGND sg13cmos5l_decap_4
X_1697_ Tile_X0Y0_EE4BEG[5] _2186_/X VPWR VGND sg13cmos5l_buf_1
XFILLER_253_21 VPWR VGND sg13cmos5l_decap_8
X_0648_ _0648_/Q Tile_X0Y2_FrameData[30] VGND VPWR Tile_X0Y5_FrameStrobe[3] latch
XANTENNA__1941__X Tile_X0Y1_E6BEG[6] VPWR VGND sg13cmos5l_antennanp
X_0579_ _0579_/Q Tile_X0Y2_FrameData[3] VGND VPWR Tile_X0Y5_FrameStrobe[0] latch
XFILLER_253_98 VPWR VGND sg13cmos5l_decap_8
XFILLER_300_271 VPWR VGND sg13cmos5l_fill_2
X_2318_ _2318_/X AXIL_S_SOC_WDATA5 AXIL_S_SOC_WDATA9 _2366_/X _2379_/X _0456_/Q _0455_/Q
+ VPWR VGND sg13cmos5l_mux4_1
XFILLER_57_203 VPWR VGND sg13cmos5l_decap_4
XFILLER_122_14 VPWR VGND sg13cmos5l_decap_8
XFILLER_257_175 VPWR VGND sg13cmos5l_fill_2
XFILLER_272_112 VPWR VGND sg13cmos5l_fill_1
XFILLER_272_134 VPWR VGND sg13cmos5l_decap_8
X_2249_ _2249_/X Tile_X0Y2_W2MID[7] Tile_X0Y2_W2END[7] Tile_X0Y2_W6END[7] _2481_/X
+ _0782_/Q _0781_/Q VPWR VGND sg13cmos5l_mux4_1
XFILLER_15_56 VPWR VGND sg13cmos5l_decap_8
XFILLER_202_91 VPWR VGND sg13cmos5l_decap_4
XFILLER_359_238 VPWR VGND sg13cmos5l_decap_8
XFILLER_40_158 VPWR VGND sg13cmos5l_decap_8
XFILLER_178_182 VPWR VGND sg13cmos5l_decap_4
XFILLER_278_84 VPWR VGND sg13cmos5l_decap_8
XFILLER_327_7 VPWR VGND sg13cmos5l_decap_8
XFILLER_193_130 VPWR VGND sg13cmos5l_decap_8
XFILLER_31_77 VPWR VGND sg13cmos5l_decap_8
XFILLER_327_168 VPWR VGND sg13cmos5l_fill_2
XFILLER_342_127 VPWR VGND sg13cmos5l_decap_8
XANTENNA__2012__X Tile_X0Y5_EE4BEG[13] VPWR VGND sg13cmos5l_antennanp
XFILLER_163_21 VPWR VGND sg13cmos5l_decap_8
XANTENNA__1851__X Tile_X0Y4_FrameData_O[18] VPWR VGND sg13cmos5l_antennanp
XFILLER_163_98 VPWR VGND sg13cmos5l_decap_8
XFILLER_48_214 VPWR VGND sg13cmos5l_decap_8
XFILLER_186_0 VPWR VGND sg13cmos5l_decap_8
XFILLER_313_35 VPWR VGND sg13cmos5l_decap_8
XFILLER_56_63 VPWR VGND sg13cmos5l_decap_8
XFILLER_16_133 VPWR VGND sg13cmos5l_decap_8
XFILLER_353_0 VPWR VGND sg13cmos5l_decap_8
XFILLER_112_91 VPWR VGND sg13cmos5l_decap_8
XFILLER_71_272 VPWR VGND sg13cmos5l_fill_1
XFILLER_176_119 VPWR VGND sg13cmos5l_decap_8
XFILLER_72_84 VPWR VGND sg13cmos5l_decap_8
XFILLER_169_171 VPWR VGND sg13cmos5l_decap_8
XFILLER_188_84 VPWR VGND sg13cmos5l_decap_8
XFILLER_338_21 VPWR VGND sg13cmos5l_decap_8
XFILLER_75_7 VPWR VGND sg13cmos5l_decap_8
XFILLER_184_163 VPWR VGND sg13cmos5l_decap_4
X_1620_ Tile_X0Y0_N2BEGb[0] _2250_/X VPWR VGND sg13cmos5l_buf_1
XFILLER_326_190 VPWR VGND sg13cmos5l_fill_1
XFILLER_338_98 VPWR VGND sg13cmos5l_decap_8
XFILLER_207_14 VPWR VGND sg13cmos5l_decap_8
X_1551_ Tile_X0Y3_EE4BEG[13] _2538_/X VPWR VGND sg13cmos5l_buf_1
XFILLER_354_42 VPWR VGND sg13cmos5l_decap_8
X_1482_ _1482_/Q Tile_X0Y5_FrameData[6] VGND VPWR Tile_X0Y5_FrameStrobe[6] latch
X_0502_ _0502_/Q Tile_X0Y1_FrameData[0] VGND VPWR Tile_X0Y5_FrameStrobe[5] latch
X_0433_ _0433_/Q Tile_X0Y1_FrameData[5] VGND VPWR Tile_X0Y5_FrameStrobe[3] latch
XFILLER_97_70 VPWR VGND sg13cmos5l_decap_8
XANTENNA__1761__X Tile_X0Y2_FrameData_O[21] VPWR VGND sg13cmos5l_antennanp
XFILLER_39_214 VPWR VGND sg13cmos5l_decap_8
XFILLER_223_35 VPWR VGND sg13cmos5l_decap_8
XFILLER_239_175 VPWR VGND sg13cmos5l_decap_8
XFILLER_254_112 VPWR VGND sg13cmos5l_decap_8
X_2103_ AXIL_S_SOC_BRESP1 Tile_X0Y4_W2MID[3] Tile_X0Y4_W2END[3] Tile_X0Y4_W6END[3]
+ _2711_/X _1090_/Q _1089_/Q VPWR VGND sg13cmos5l_mux4_1
X_0364_ _0364_/Q Tile_X0Y1_FrameData[10] VGND VPWR Tile_X0Y5_FrameStrobe[1] latch
XFILLER_39_258 VPWR VGND sg13cmos5l_fill_1
XFILLER_254_145 VPWR VGND sg13cmos5l_fill_2
X_0295_ _0295_/Q Tile_X0Y0_FrameData[31] VGND VPWR Tile_X0Y5_FrameStrobe[7] latch
XFILLER_54_217 VPWR VGND sg13cmos5l_decap_8
XFILLER_299_28 VPWR VGND sg13cmos5l_decap_8
X_2034_ Tile_X0Y5_FrameData_O[19] Tile_X0Y5_FrameData[19] VPWR VGND sg13cmos5l_buf_1
XFILLER_62_272 VPWR VGND sg13cmos5l_fill_1
XFILLER_167_119 VPWR VGND sg13cmos5l_decap_8
XFILLER_210_259 VPWR VGND sg13cmos5l_decap_8
XFILLER_248_21 VPWR VGND sg13cmos5l_decap_8
XFILLER_349_271 VPWR VGND sg13cmos5l_fill_2
XANTENNA__1936__X Tile_X0Y1_E6BEG[1] VPWR VGND sg13cmos5l_antennanp
XFILLER_108_208 VPWR VGND sg13cmos5l_decap_8
XFILLER_309_168 VPWR VGND sg13cmos5l_decap_8
XFILLER_324_105 VPWR VGND sg13cmos5l_decap_8
X_1818_ Tile_X0Y4_EE4BEG[1] _2634_/X VPWR VGND sg13cmos5l_buf_1
XFILLER_175_196 VPWR VGND sg13cmos5l_decap_8
XFILLER_248_98 VPWR VGND sg13cmos5l_decap_8
X_2798_ _2798_/X Tile_X0Y5_N2MID[6] Tile_X0Y5_N2END[6] _2835_/X _2719_/X _1276_/Q
+ _1275_/Q VPWR VGND sg13cmos5l_mux4_1
XFILLER_117_14 VPWR VGND sg13cmos5l_decap_8
X_1749_ Tile_X0Y2_FrameData_O[9] Tile_X0Y2_FrameData[9] VPWR VGND sg13cmos5l_buf_1
XFILLER_264_42 VPWR VGND sg13cmos5l_decap_8
XFILLER_332_193 VPWR VGND sg13cmos5l_fill_2
XANTENNA__1671__X Tile_X0Y0_FrameData_O[11] VPWR VGND sg13cmos5l_antennanp
XFILLER_133_35 VPWR VGND sg13cmos5l_decap_8
XFILLER_245_112 VPWR VGND sg13cmos5l_decap_8
XFILLER_277_7 VPWR VGND sg13cmos5l_decap_8
XFILLER_280_63 VPWR VGND sg13cmos5l_decap_8
XFILLER_93_28 VPWR VGND sg13cmos5l_decap_8
XANTENNA_205 _2493_/X VPWR VGND sg13cmos5l_antennanp
XANTENNA_216 Tile_X0Y5_FrameStrobe[16] VPWR VGND sg13cmos5l_antennanp
XFILLER_45_239 VPWR VGND sg13cmos5l_decap_8
XANTENNA_227 Tile_X0Y5_N2MID[4] VPWR VGND sg13cmos5l_antennanp
XANTENNA_238 AXIL_S_SOC_WDATA22 VPWR VGND sg13cmos5l_antennanp
XANTENNA_249 AXIL_S_SOC_WDATA22 VPWR VGND sg13cmos5l_antennanp
XFILLER_260_126 VPWR VGND sg13cmos5l_fill_1
XFILLER_260_148 VPWR VGND sg13cmos5l_decap_8
XFILLER_260_159 VPWR VGND sg13cmos5l_fill_1
XFILLER_26_77 VPWR VGND sg13cmos5l_decap_8
XFILLER_158_119 VPWR VGND sg13cmos5l_decap_8
XANTENNA__2007__X Tile_X0Y5_EE4BEG[8] VPWR VGND sg13cmos5l_antennanp
XFILLER_201_237 VPWR VGND sg13cmos5l_decap_8
XFILLER_201_248 VPWR VGND sg13cmos5l_fill_2
XFILLER_158_21 VPWR VGND sg13cmos5l_decap_8
XFILLER_166_130 VPWR VGND sg13cmos5l_fill_2
XFILLER_42_87 VPWR VGND sg13cmos5l_decap_8
XANTENNA__1846__X Tile_X0Y4_FrameData_O[13] VPWR VGND sg13cmos5l_antennanp
XFILLER_315_105 VPWR VGND sg13cmos5l_decap_8
XFILLER_355_252 VPWR VGND sg13cmos5l_decap_4
XFILLER_158_98 VPWR VGND sg13cmos5l_decap_8
XFILLER_166_196 VPWR VGND sg13cmos5l_decap_8
XFILLER_181_133 VPWR VGND sg13cmos5l_decap_8
XFILLER_308_35 VPWR VGND sg13cmos5l_decap_8
XFILLER_101_0 VPWR VGND sg13cmos5l_decap_8
XFILLER_174_42 VPWR VGND sg13cmos5l_decap_8
XANTENNA__1581__X Tile_X0Y3_FrameData_O[27] VPWR VGND sg13cmos5l_antennanp
XFILLER_107_91 VPWR VGND sg13cmos5l_decap_8
XFILLER_324_56 VPWR VGND sg13cmos5l_decap_8
XFILLER_236_112 VPWR VGND sg13cmos5l_decap_8
XFILLER_67_84 VPWR VGND sg13cmos5l_decap_8
XFILLER_190_63 VPWR VGND sg13cmos5l_decap_8
XFILLER_36_217 VPWR VGND sg13cmos5l_decap_8
X_0080_ _0080_/Q Tile_X0Y0_FrameData[22] VGND VPWR Tile_X0Y5_FrameStrobe[0] latch
XFILLER_251_126 VPWR VGND sg13cmos5l_decap_8
XFILLER_340_77 VPWR VGND sg13cmos5l_decap_8
XFILLER_189_222 VPWR VGND sg13cmos5l_decap_8
X_0982_ _0982_/Q Tile_X0Y3_FrameData[0] VGND VPWR Tile_X0Y5_FrameStrobe[5] latch
XFILLER_349_42 VPWR VGND sg13cmos5l_decap_8
X_2721_ _2721_/X Tile_X0Y5_N1END[0] _2793_/X Tile_X0Y5_WW4END[4] AXIL_S_SOC_ARPROT2
+ _1460_/Q _1459_/Q VPWR VGND sg13cmos5l_mux4_1
XFILLER_346_241 VPWR VGND sg13cmos5l_decap_8
XANTENNA__1756__X Tile_X0Y2_FrameData_O[16] VPWR VGND sg13cmos5l_antennanp
XFILLER_157_163 VPWR VGND sg13cmos5l_fill_2
XFILLER_306_105 VPWR VGND sg13cmos5l_decap_8
XFILLER_8_162 VPWR VGND sg13cmos5l_fill_2
XFILLER_218_35 VPWR VGND sg13cmos5l_decap_8
X_2652_ _2652_/X Tile_X0Y5_N4END[7] _0025_/X _2697_/X _2696_/X _1150_/Q _1149_/Q VPWR
+ VGND sg13cmos5l_mux4_1
X_1603_ Tile_X0Y0_UserCLKo Tile_X0Y0_UserCLK VPWR VGND sg13cmos5l_buf_1
X_2583_ _2583_/X _2572_/X Tile_X0Y5_N4END[11] _2571_/X Tile_X0Y0_S4END[15] _0840_/Q
+ _0839_/Q VPWR VGND sg13cmos5l_mux4_1
XFILLER_113_200 VPWR VGND sg13cmos5l_decap_8
X_1534_ Tile_X0Y3_E6BEG[8] _2549_/X VPWR VGND sg13cmos5l_buf_1
XFILLER_113_255 VPWR VGND sg13cmos5l_fill_1
XFILLER_259_237 VPWR VGND sg13cmos5l_fill_1
XFILLER_234_56 VPWR VGND sg13cmos5l_decap_8
X_1465_ _1465_/Q Tile_X0Y5_FrameData[23] VGND VPWR Tile_X0Y5_FrameStrobe[6] latch
XFILLER_227_112 VPWR VGND sg13cmos5l_decap_8
X_1396_ _1396_/Q Tile_X0Y5_FrameData[28] VGND VPWR Tile_X0Y5_FrameStrobe[4] latch
X_0416_ _0416_/Q Tile_X0Y1_FrameData[22] VGND VPWR Tile_X0Y5_FrameStrobe[3] latch
XFILLER_79_180 VPWR VGND sg13cmos5l_decap_8
XFILLER_227_123 VPWR VGND sg13cmos5l_fill_1
X_0347_ _0347_/Q Tile_X0Y1_FrameData[27] VGND VPWR Tile_X0Y5_FrameStrobe[1] latch
XFILLER_103_49 VPWR VGND sg13cmos5l_decap_8
XFILLER_94_183 VPWR VGND sg13cmos5l_decap_8
XFILLER_242_126 VPWR VGND sg13cmos5l_decap_8
XFILLER_250_77 VPWR VGND sg13cmos5l_decap_8
X_2017_ Tile_X0Y5_FrameData_O[2] Tile_X0Y5_FrameData[2] VPWR VGND sg13cmos5l_buf_1
X_0278_ _0278_/Q Tile_X0Y0_FrameData[16] VGND VPWR Tile_X0Y5_FrameStrobe[6] latch
XFILLER_259_42 VPWR VGND sg13cmos5l_decap_8
XFILLER_148_130 VPWR VGND sg13cmos5l_decap_8
XFILLER_195_258 VPWR VGND sg13cmos5l_decap_4
XANTENNA__1666__X Tile_X0Y0_FrameData_O[6] VPWR VGND sg13cmos5l_antennanp
XFILLER_12_35 VPWR VGND sg13cmos5l_decap_8
XFILLER_128_35 VPWR VGND sg13cmos5l_decap_8
XFILLER_163_133 VPWR VGND sg13cmos5l_decap_8
XFILLER_275_63 VPWR VGND sg13cmos5l_decap_8
XFILLER_88_28 VPWR VGND sg13cmos5l_decap_8
XFILLER_5_7 VPWR VGND sg13cmos5l_decap_8
XFILLER_104_255 VPWR VGND sg13cmos5l_fill_1
XFILLER_305_182 VPWR VGND sg13cmos5l_decap_4
XFILLER_144_56 VPWR VGND sg13cmos5l_decap_8
XFILLER_291_84 VPWR VGND sg13cmos5l_decap_8
XFILLER_37_21 VPWR VGND sg13cmos5l_decap_8
XFILLER_85_194 VPWR VGND sg13cmos5l_decap_8
XFILLER_160_77 VPWR VGND sg13cmos5l_decap_8
XFILLER_233_126 VPWR VGND sg13cmos5l_decap_8
XFILLER_37_98 VPWR VGND sg13cmos5l_decap_8
XFILLER_310_14 VPWR VGND sg13cmos5l_decap_8
XFILLER_53_42 VPWR VGND sg13cmos5l_decap_8
XFILLER_41_220 VPWR VGND sg13cmos5l_decap_8
XFILLER_149_0 VPWR VGND sg13cmos5l_decap_8
XFILLER_169_42 VPWR VGND sg13cmos5l_decap_8
XANTENNA__1576__X Tile_X0Y3_FrameData_O[22] VPWR VGND sg13cmos5l_antennanp
XFILLER_316_0 VPWR VGND sg13cmos5l_decap_8
XFILLER_319_56 VPWR VGND sg13cmos5l_decap_8
XFILLER_343_200 VPWR VGND sg13cmos5l_fill_1
XFILLER_154_133 VPWR VGND sg13cmos5l_decap_8
XFILLER_343_211 VPWR VGND sg13cmos5l_decap_4
XFILLER_185_63 VPWR VGND sg13cmos5l_decap_8
XFILLER_303_119 VPWR VGND sg13cmos5l_decap_8
XFILLER_335_77 VPWR VGND sg13cmos5l_decap_8
XFILLER_311_163 VPWR VGND sg13cmos5l_fill_2
XFILLER_38_7 VPWR VGND sg13cmos5l_decap_8
XFILLER_110_247 VPWR VGND sg13cmos5l_decap_8
XFILLER_256_207 VPWR VGND sg13cmos5l_fill_1
XFILLER_256_218 VPWR VGND sg13cmos5l_decap_4
X_1250_ _1250_/Q Tile_X0Y4_FrameData[4] VGND VPWR Tile_X0Y5_FrameStrobe[6] latch
XFILLER_351_21 VPWR VGND sg13cmos5l_decap_8
X_1181_ _1181_/Q Tile_X0Y4_FrameData[9] VGND VPWR Tile_X0Y5_FrameStrobe[4] latch
X_0201_ _0201_/Q Tile_X0Y0_FrameData[29] VGND VPWR Tile_X0Y5_FrameStrobe[4] latch
XFILLER_209_145 VPWR VGND sg13cmos5l_decap_8
XFILLER_209_178 VPWR VGND sg13cmos5l_fill_1
X_0132_ _0132_/Q Tile_X0Y0_FrameData[2] VGND VPWR Tile_X0Y5_FrameStrobe[1] latch
XFILLER_351_98 VPWR VGND sg13cmos5l_decap_8
XFILLER_220_14 VPWR VGND sg13cmos5l_decap_8
XFILLER_224_148 VPWR VGND sg13cmos5l_decap_8
X_0063_ _0063_/X _2351_/X _2352_/X _1470_/Q VPWR VGND sg13cmos5l_mux2_1
XFILLER_232_192 VPWR VGND sg13cmos5l_decap_8
XFILLER_300_91 VPWR VGND sg13cmos5l_decap_8
XFILLER_229_56 VPWR VGND sg13cmos5l_decap_8
X_0965_ _0965_/Q Tile_X0Y3_FrameData[17] VGND VPWR Tile_X0Y5_FrameStrobe[5] latch
X_2704_ _2704_/X _2676_/X Tile_X0Y5_N4END[5] _2675_/X _0071_/X _1076_/Q _1075_/Q VPWR
+ VGND sg13cmos5l_mux4_1
X_0896_ _0896_/Q Tile_X0Y3_FrameData[22] VGND VPWR Tile_X0Y5_FrameStrobe[3] latch
XFILLER_64_0 VPWR VGND sg13cmos5l_decap_8
XFILLER_145_155 VPWR VGND sg13cmos5l_decap_8
X_2635_ _2635_/X Tile_X0Y4_WW4END[6] AXIL_S_SOC_WSTRB2 _2692_/X _2683_/X _1184_/Q
+ _1183_/Q VPWR VGND sg13cmos5l_mux4_1
XFILLER_160_158 VPWR VGND sg13cmos5l_fill_2
X_2566_ _2566_/X Tile_X0Y4_W1END[0] Tile_X0Y4_W6END[4] _2696_/X _2669_/X _1264_/Q
+ _1263_/Q VPWR VGND sg13cmos5l_mux4_1
XFILLER_245_77 VPWR VGND sg13cmos5l_decap_8
X_1517_ _2209_/A3 VPWR VGND sg13cmos5l_tielo
X_2497_ _2497_/X Tile_X0Y1_W1END[0] Tile_X0Y1_W2MID[3] Tile_X0Y1_W2END[3] _2377_/X
+ _0402_/Q _0401_/Q VPWR VGND sg13cmos5l_mux4_1
XANTENNA__2110__X AXIL_S_SOC_RDATA4 VPWR VGND sg13cmos5l_antennanp
XFILLER_261_21 VPWR VGND sg13cmos5l_decap_8
XFILLER_302_196 VPWR VGND sg13cmos5l_decap_8
X_1448_ _1448_/Q Tile_X0Y5_FrameData[8] VGND VPWR Tile_X0Y5_FrameStrobe[5] latch
XFILLER_4_91 VPWR VGND sg13cmos5l_decap_8
XFILLER_101_269 VPWR VGND sg13cmos5l_decap_4
XFILLER_255_251 VPWR VGND sg13cmos5l_fill_2
X_1379_ _1379_/Q Tile_X0Y5_FrameData[13] VGND VPWR Tile_X0Y5_FrameStrobe[3] latch
XFILLER_261_98 VPWR VGND sg13cmos5l_decap_8
XFILLER_130_14 VPWR VGND sg13cmos5l_decap_8
XFILLER_142_7 VPWR VGND sg13cmos5l_decap_8
XFILLER_90_29 VPWR VGND sg13cmos5l_decap_8
XFILLER_23_56 VPWR VGND sg13cmos5l_decap_8
XFILLER_139_56 VPWR VGND sg13cmos5l_decap_8
XFILLER_99_49 VPWR VGND sg13cmos5l_decap_8
XFILLER_191_272 VPWR VGND sg13cmos5l_fill_1
XFILLER_151_147 VPWR VGND sg13cmos5l_decap_4
XFILLER_2_157 VPWR VGND sg13cmos5l_decap_4
XFILLER_305_14 VPWR VGND sg13cmos5l_decap_8
XANTENNA__2020__X Tile_X0Y5_FrameData_O[5] VPWR VGND sg13cmos5l_antennanp
XFILLER_171_21 VPWR VGND sg13cmos5l_decap_8
XFILLER_48_53 VPWR VGND sg13cmos5l_decap_8
XFILLER_58_161 VPWR VGND sg13cmos5l_decap_8
XFILLER_0_49 VPWR VGND sg13cmos5l_decap_8
XFILLER_171_98 VPWR VGND sg13cmos5l_decap_8
XFILLER_321_35 VPWR VGND sg13cmos5l_decap_4
XFILLER_73_142 VPWR VGND sg13cmos5l_decap_4
XFILLER_104_92 VPWR VGND sg13cmos5l_decap_8
XFILLER_206_148 VPWR VGND sg13cmos5l_fill_2
XFILLER_266_0 VPWR VGND sg13cmos5l_decap_8
XFILLER_64_63 VPWR VGND sg13cmos5l_decap_8
XFILLER_221_129 VPWR VGND sg13cmos5l_decap_8
XFILLER_73_197 VPWR VGND sg13cmos5l_decap_8
XFILLER_9_14 VPWR VGND sg13cmos5l_decap_8
XFILLER_120_91 VPWR VGND sg13cmos5l_decap_8
XFILLER_159_258 VPWR VGND sg13cmos5l_decap_8
XFILLER_80_84 VPWR VGND sg13cmos5l_decap_8
XFILLER_127_122 VPWR VGND sg13cmos5l_fill_2
XFILLER_196_84 VPWR VGND sg13cmos5l_decap_8
X_0750_ _0750_/Q Tile_X0Y2_FrameData[24] VGND VPWR Tile_X0Y5_FrameStrobe[6] latch
XFILLER_346_21 VPWR VGND sg13cmos5l_decap_8
XFILLER_127_199 VPWR VGND sg13cmos5l_decap_4
X_2420_ _2420_/X AXIL_S_SOC_AWADDR1 AXIL_S_SOC_AWADDR3 _2471_/X _2485_/X _0708_/Q
+ _0707_/Q VPWR VGND sg13cmos5l_mux4_1
X_0681_ _0681_/Q Tile_X0Y2_FrameData[29] VGND VPWR Tile_X0Y5_FrameStrobe[4] latch
XFILLER_142_147 VPWR VGND sg13cmos5l_decap_8
XFILLER_89_71 VPWR VGND sg13cmos5l_decap_8
XFILLER_346_98 VPWR VGND sg13cmos5l_decap_8
XFILLER_215_14 VPWR VGND sg13cmos5l_decap_8
XFILLER_296_140 VPWR VGND sg13cmos5l_decap_8
X_2351_ _2351_/X Tile_X0Y5_W1END[0] Tile_X0Y5_WW4END[0] Tile_X0Y5_WW4END[6] Tile_X0Y5_W6END[8]
+ _1472_/Q _1471_/Q VPWR VGND sg13cmos5l_mux4_1
XFILLER_150_180 VPWR VGND sg13cmos5l_decap_8
XFILLER_229_229 VPWR VGND sg13cmos5l_decap_8
X_1302_ _1302_/Q Tile_X0Y5_FrameData[26] VGND VPWR Tile_X0Y5_FrameStrobe[1] latch
X_2282_ _2282_/X _2583_/X _2581_/X _2574_/X _2573_/X _0997_/Q _0996_/Q VPWR VGND sg13cmos5l_mux4_1
XFILLER_362_42 VPWR VGND sg13cmos5l_decap_8
X_1233_ _1233_/Q Tile_X0Y4_FrameData[21] VGND VPWR Tile_X0Y5_FrameStrobe[6] latch
XFILLER_237_251 VPWR VGND sg13cmos5l_decap_8
XFILLER_49_161 VPWR VGND sg13cmos5l_decap_8
XFILLER_231_35 VPWR VGND sg13cmos5l_decap_8
XFILLER_252_210 VPWR VGND sg13cmos5l_decap_4
X_1164_ _1164_/Q Tile_X0Y4_FrameData[26] VGND VPWR Tile_X0Y5_FrameStrobe[4] latch
X_1095_ _1095_/Q Tile_X0Y4_FrameData[31] VGND VPWR Tile_X0Y5_FrameStrobe[2] latch
X_0115_ _0115_/Q Tile_X0Y0_FrameData[19] VGND VPWR Tile_X0Y5_FrameStrobe[1] latch
XFILLER_64_186 VPWR VGND sg13cmos5l_decap_8
X_0046_ _2069_/A _2449_/X _2450_/X _0626_/Q VPWR VGND sg13cmos5l_mux2_1
XFILLER_100_28 VPWR VGND sg13cmos5l_decap_8
XFILLER_20_201 VPWR VGND sg13cmos5l_fill_1
XFILLER_20_234 VPWR VGND sg13cmos5l_decap_4
X_1997_ Tile_X0Y5_E6BEG[10] _2767_/X VPWR VGND sg13cmos5l_buf_1
XANTENNA__2105__X AXIL_S_SOC_ARREADY VPWR VGND sg13cmos5l_antennanp
XFILLER_165_239 VPWR VGND sg13cmos5l_decap_8
X_0948_ _0948_/Q Tile_X0Y3_FrameData[2] VGND VPWR Tile_X0Y5_FrameStrobe[4] latch
XFILLER_118_133 VPWR VGND sg13cmos5l_decap_8
XFILLER_256_21 VPWR VGND sg13cmos5l_decap_8
XANTENNA__1944__X Tile_X0Y1_E6BEG[9] VPWR VGND sg13cmos5l_antennanp
X_0879_ _0879_/Q Tile_X0Y3_FrameData[7] VGND VPWR Tile_X0Y5_FrameStrobe[2] latch
XFILLER_256_98 VPWR VGND sg13cmos5l_decap_8
X_2618_ _2618_/X AXIL_S_SOC_WSTRB1 AXIL_S_SOC_WSTRB3 _2709_/X _2682_/X _1218_/Q _1217_/Q
+ VPWR VGND sg13cmos5l_mux4_1
XFILLER_125_14 VPWR VGND sg13cmos5l_decap_8
XFILLER_133_169 VPWR VGND sg13cmos5l_fill_1
XFILLER_287_140 VPWR VGND sg13cmos5l_decap_8
X_2549_ _2549_/X AXIL_S_SOC_ARADDR0 _2583_/X _2581_/X _2593_/X _0906_/Q _0905_/Q VPWR
+ VGND sg13cmos5l_mux4_1
XFILLER_141_191 VPWR VGND sg13cmos5l_decap_8
XFILLER_272_42 VPWR VGND sg13cmos5l_decap_8
XFILLER_85_29 VPWR VGND sg13cmos5l_decap_8
XFILLER_141_35 VPWR VGND sg13cmos5l_decap_8
XFILLER_18_56 VPWR VGND sg13cmos5l_decap_8
XFILLER_141_79 VPWR VGND sg13cmos5l_fill_1
XFILLER_55_175 VPWR VGND sg13cmos5l_decap_8
XFILLER_357_7 VPWR VGND sg13cmos5l_decap_8
XFILLER_357_133 VPWR VGND sg13cmos5l_decap_8
XFILLER_34_77 VPWR VGND sg13cmos5l_decap_8
XANTENNA__2015__X Tile_X0Y5_FrameData_O[0] VPWR VGND sg13cmos5l_antennanp
XFILLER_156_239 VPWR VGND sg13cmos5l_decap_8
XFILLER_50_21 VPWR VGND sg13cmos5l_decap_8
XFILLER_109_133 VPWR VGND sg13cmos5l_decap_8
XFILLER_166_21 VPWR VGND sg13cmos5l_decap_8
XANTENNA__1854__X Tile_X0Y4_FrameData_O[21] VPWR VGND sg13cmos5l_antennanp
XFILLER_50_98 VPWR VGND sg13cmos5l_decap_8
XFILLER_316_35 VPWR VGND sg13cmos5l_decap_8
XFILLER_132_180 VPWR VGND sg13cmos5l_decap_8
XFILLER_182_42 VPWR VGND sg13cmos5l_decap_8
XFILLER_59_63 VPWR VGND sg13cmos5l_decap_8
XFILLER_115_91 VPWR VGND sg13cmos5l_decap_8
XFILLER_332_56 VPWR VGND sg13cmos5l_decap_8
XFILLER_293_187 VPWR VGND sg13cmos5l_decap_4
XFILLER_46_120 VPWR VGND sg13cmos5l_fill_2
XFILLER_75_84 VPWR VGND sg13cmos5l_decap_8
XFILLER_46_175 VPWR VGND sg13cmos5l_decap_8
XFILLER_61_112 VPWR VGND sg13cmos5l_decap_8
XFILLER_201_49 VPWR VGND sg13cmos5l_decap_8
XFILLER_61_167 VPWR VGND sg13cmos5l_decap_4
XFILLER_199_180 VPWR VGND sg13cmos5l_decap_8
XFILLER_202_140 VPWR VGND sg13cmos5l_fill_2
X_1920_ Tile_X0Y1_EE4BEG[1] _2310_/X VPWR VGND sg13cmos5l_buf_1
XFILLER_348_133 VPWR VGND sg13cmos5l_decap_8
X_1851_ Tile_X0Y4_FrameData_O[18] Tile_X0Y4_FrameData[18] VPWR VGND sg13cmos5l_buf_1
X_0802_ _0802_/Q Tile_X0Y3_FrameData[20] VGND VPWR Tile_X0Y5_FrameStrobe[0] latch
XFILLER_357_42 VPWR VGND sg13cmos5l_decap_8
XFILLER_155_250 VPWR VGND sg13cmos5l_decap_8
X_1782_ Tile_X0Y2_E2BEG[5] _2406_/X VPWR VGND sg13cmos5l_buf_1
XANTENNA__1764__X Tile_X0Y2_FrameData_O[24] VPWR VGND sg13cmos5l_antennanp
XFILLER_155_272 VPWR VGND sg13cmos5l_fill_1
X_0733_ _0733_/Q Tile_X0Y2_FrameData[9] VGND VPWR Tile_X0Y5_FrameStrobe[5] latch
XFILLER_115_147 VPWR VGND sg13cmos5l_decap_8
X_0664_ _0664_/Q Tile_X0Y2_FrameData[14] VGND VPWR Tile_X0Y5_FrameStrobe[3] latch
XFILLER_170_264 VPWR VGND sg13cmos5l_fill_2
XFILLER_226_57 VPWR VGND sg13cmos5l_decap_8
X_2403_ _2403_/X AXIL_S_SOC_AWADDR2 AXIL_S_SOC_AWPROT0 _2483_/X _2486_/X _0742_/Q
+ _0741_/Q VPWR VGND sg13cmos5l_mux4_1
X_2334_ _2334_/X AXIL_S_SOC_WDATA1 _2368_/X _2366_/X _2378_/X _0424_/Q _0423_/Q VPWR
+ VGND sg13cmos5l_mux4_1
X_0595_ _0595_/Q Tile_X0Y2_FrameData[19] VGND VPWR Tile_X0Y5_FrameStrobe[1] latch
XFILLER_27_0 VPWR VGND sg13cmos5l_decap_8
XFILLER_242_56 VPWR VGND sg13cmos5l_decap_8
X_2265_ _2265_/X Tile_X0Y1_W1END[3] Tile_X0Y1_WW4END[3] Tile_X0Y1_WW4END[7] Tile_X0Y1_W6END[11]
+ _0517_/Q _0516_/Q VPWR VGND sg13cmos5l_mux4_1
X_2196_ _2196_/X AXIL_S_SOC_WDATA19 AXIL_S_SOC_WDATA31 _2240_/X _2241_/X _0204_/Q
+ _0203_/Q VPWR VGND sg13cmos5l_mux4_1
X_1216_ _1216_/Q Tile_X0Y4_FrameData[6] VGND VPWR Tile_X0Y5_FrameStrobe[5] latch
XFILLER_1_70 VPWR VGND sg13cmos5l_decap_8
X_1147_ _1147_/Q Tile_X0Y4_FrameData[11] VGND VPWR Tile_X0Y5_FrameStrobe[3] latch
XFILLER_92_270 VPWR VGND sg13cmos5l_fill_2
XFILLER_52_112 VPWR VGND sg13cmos5l_decap_8
XFILLER_37_197 VPWR VGND sg13cmos5l_fill_1
XANTENNA__1939__X Tile_X0Y1_E6BEG[4] VPWR VGND sg13cmos5l_antennanp
XFILLER_111_49 VPWR VGND sg13cmos5l_decap_8
X_1078_ _1078_/Q Tile_X0Y4_FrameData[16] VGND VPWR Tile_X0Y5_FrameStrobe[1] latch
X_0029_ _0029_/X _2363_/X _2364_/X _1461_/Q VPWR VGND sg13cmos5l_mux2_1
XFILLER_52_189 VPWR VGND sg13cmos5l_decap_8
XFILLER_138_206 VPWR VGND sg13cmos5l_decap_8
XFILLER_339_144 VPWR VGND sg13cmos5l_decap_8
XFILLER_267_42 VPWR VGND sg13cmos5l_decap_8
XFILLER_339_177 VPWR VGND sg13cmos5l_decap_8
XFILLER_354_147 VPWR VGND sg13cmos5l_decap_8
XANTENNA__1674__X Tile_X0Y0_FrameData_O[14] VPWR VGND sg13cmos5l_antennanp
XFILLER_146_272 VPWR VGND sg13cmos5l_fill_1
XFILLER_105_7 VPWR VGND sg13cmos5l_decap_8
XFILLER_106_147 VPWR VGND sg13cmos5l_fill_2
XFILLER_136_35 VPWR VGND sg13cmos5l_decap_8
XFILLER_20_35 VPWR VGND sg13cmos5l_decap_8
XFILLER_283_63 VPWR VGND sg13cmos5l_decap_8
XFILLER_96_28 VPWR VGND sg13cmos5l_decap_8
XFILLER_275_110 VPWR VGND sg13cmos5l_decap_8
XFILLER_29_77 VPWR VGND sg13cmos5l_decap_8
XFILLER_152_56 VPWR VGND sg13cmos5l_decap_8
XFILLER_216_221 VPWR VGND sg13cmos5l_decap_8
XFILLER_45_21 VPWR VGND sg13cmos5l_decap_8
XFILLER_216_265 VPWR VGND sg13cmos5l_decap_8
XFILLER_290_168 VPWR VGND sg13cmos5l_decap_8
XFILLER_43_112 VPWR VGND sg13cmos5l_decap_8
XANTENNA__1849__X Tile_X0Y4_FrameData_O[16] VPWR VGND sg13cmos5l_antennanp
XFILLER_45_98 VPWR VGND sg13cmos5l_decap_8
XFILLER_231_257 VPWR VGND sg13cmos5l_decap_8
XFILLER_231_268 VPWR VGND sg13cmos5l_decap_4
XFILLER_196_161 VPWR VGND sg13cmos5l_decap_8
XFILLER_61_42 VPWR VGND sg13cmos5l_decap_8
XFILLER_131_0 VPWR VGND sg13cmos5l_decap_8
XFILLER_177_42 VPWR VGND sg13cmos5l_decap_8
XFILLER_229_0 VPWR VGND sg13cmos5l_decap_8
XFILLER_345_147 VPWR VGND sg13cmos5l_decap_8
XANTENNA_8 AXIL_S_SOC_WDATA10 VPWR VGND sg13cmos5l_antennanp
XANTENNA__1584__X Tile_X0Y3_FrameData_O[30] VPWR VGND sg13cmos5l_antennanp
XFILLER_137_272 VPWR VGND sg13cmos5l_fill_1
XFILLER_360_106 VPWR VGND sg13cmos5l_decap_8
XFILLER_327_56 VPWR VGND sg13cmos5l_decap_8
XFILLER_193_63 VPWR VGND sg13cmos5l_decap_8
XFILLER_298_246 VPWR VGND sg13cmos5l_decap_8
XFILLER_301_217 VPWR VGND sg13cmos5l_fill_2
XFILLER_105_191 VPWR VGND sg13cmos5l_decap_8
X_0380_ _0380_/Q Tile_X0Y1_FrameData[26] VGND VPWR Tile_X0Y5_FrameStrobe[2] latch
XFILLER_120_161 VPWR VGND sg13cmos5l_decap_8
XFILLER_20_7 VPWR VGND sg13cmos5l_decap_8
XFILLER_66_204 VPWR VGND sg13cmos5l_decap_8
XFILLER_343_77 VPWR VGND sg13cmos5l_decap_8
X_2050_ Tile_X0Y5_S1BEG[3] _2772_/X VPWR VGND sg13cmos5l_buf_1
X_1001_ _1001_/Q Tile_X0Y3_FrameData[13] VGND VPWR Tile_X0Y5_FrameStrobe[6] latch
XFILLER_34_123 VPWR VGND sg13cmos5l_fill_1
XFILLER_34_112 VPWR VGND sg13cmos5l_decap_8
XANTENNA__1759__X Tile_X0Y2_FrameData_O[19] VPWR VGND sg13cmos5l_antennanp
XFILLER_222_257 VPWR VGND sg13cmos5l_decap_8
X_1903_ Tile_X0Y1_FrameData_O[16] Tile_X0Y1_FrameData[16] VPWR VGND sg13cmos5l_buf_1
X_1834_ Tile_X0Y4_FrameData_O[1] Tile_X0Y4_FrameData[1] VPWR VGND sg13cmos5l_buf_1
X_1765_ Tile_X0Y2_FrameData_O[25] Tile_X0Y2_FrameData[25] VPWR VGND sg13cmos5l_buf_1
XFILLER_237_56 VPWR VGND sg13cmos5l_decap_8
XFILLER_289_213 VPWR VGND sg13cmos5l_decap_8
X_0716_ _0716_/Q Tile_X0Y2_FrameData[26] VGND VPWR Tile_X0Y5_FrameStrobe[5] latch
X_1696_ Tile_X0Y0_EE4BEG[4] _2185_/X VPWR VGND sg13cmos5l_buf_1
XFILLER_103_139 VPWR VGND sg13cmos5l_decap_8
X_0647_ _0647_/Q Tile_X0Y2_FrameData[31] VGND VPWR Tile_X0Y5_FrameStrobe[3] latch
XFILLER_106_49 VPWR VGND sg13cmos5l_decap_8
X_0578_ _0578_/Q Tile_X0Y2_FrameData[4] VGND VPWR Tile_X0Y5_FrameStrobe[0] latch
XFILLER_253_77 VPWR VGND sg13cmos5l_decap_8
X_2317_ _2317_/X AXIL_S_SOC_WDATA4 AXIL_S_SOC_WDATA8 _2365_/X _2380_/X _0458_/Q _0457_/Q
+ VPWR VGND sg13cmos5l_mux4_1
XFILLER_57_226 VPWR VGND sg13cmos5l_fill_1
XFILLER_57_215 VPWR VGND sg13cmos5l_decap_8
XFILLER_257_198 VPWR VGND sg13cmos5l_fill_2
X_2248_ _2248_/X _2264_/X _2263_/X Tile_X0Y0_S2MID[7] Tile_X0Y0_S2END[7] _0080_/Q
+ _0079_/Q VPWR VGND sg13cmos5l_mux4_1
XFILLER_25_112 VPWR VGND sg13cmos5l_decap_4
XFILLER_272_168 VPWR VGND sg13cmos5l_decap_8
X_2179_ _2179_/X AXIL_S_SOC_WDATA22 AXIL_S_SOC_WDATA30 _2242_/X _2247_/X _0238_/Q
+ _0237_/Q VPWR VGND sg13cmos5l_mux4_1
XFILLER_202_70 VPWR VGND sg13cmos5l_decap_8
XFILLER_213_235 VPWR VGND sg13cmos5l_fill_2
XFILLER_359_217 VPWR VGND sg13cmos5l_decap_8
XANTENNA__1669__X Tile_X0Y0_FrameData_O[9] VPWR VGND sg13cmos5l_antennanp
XFILLER_15_35 VPWR VGND sg13cmos5l_decap_8
XFILLER_40_126 VPWR VGND sg13cmos5l_decap_8
XFILLER_178_161 VPWR VGND sg13cmos5l_decap_8
XFILLER_40_137 VPWR VGND sg13cmos5l_fill_1
XFILLER_278_63 VPWR VGND sg13cmos5l_decap_8
XFILLER_327_114 VPWR VGND sg13cmos5l_fill_1
XFILLER_327_125 VPWR VGND sg13cmos5l_decap_8
XFILLER_222_7 VPWR VGND sg13cmos5l_decap_8
XFILLER_193_175 VPWR VGND sg13cmos5l_decap_8
XFILLER_31_56 VPWR VGND sg13cmos5l_decap_8
XFILLER_342_106 VPWR VGND sg13cmos5l_decap_8
XFILLER_147_56 VPWR VGND sg13cmos5l_decap_8
XFILLER_294_84 VPWR VGND sg13cmos5l_decap_8
XFILLER_295_238 VPWR VGND sg13cmos5l_decap_8
XFILLER_102_172 VPWR VGND sg13cmos5l_fill_2
XFILLER_163_77 VPWR VGND sg13cmos5l_decap_8
XFILLER_313_14 VPWR VGND sg13cmos5l_decap_8
XFILLER_56_42 VPWR VGND sg13cmos5l_decap_8
XFILLER_16_112 VPWR VGND sg13cmos5l_decap_8
XFILLER_179_0 VPWR VGND sg13cmos5l_decap_8
XFILLER_112_70 VPWR VGND sg13cmos5l_decap_8
XANTENNA__1579__X Tile_X0Y3_FrameData_O[25] VPWR VGND sg13cmos5l_antennanp
XFILLER_346_0 VPWR VGND sg13cmos5l_decap_8
XFILLER_31_126 VPWR VGND sg13cmos5l_fill_2
XFILLER_72_63 VPWR VGND sg13cmos5l_decap_8
XFILLER_358_250 VPWR VGND sg13cmos5l_decap_8
XFILLER_188_63 VPWR VGND sg13cmos5l_decap_8
XFILLER_358_272 VPWR VGND sg13cmos5l_fill_1
XFILLER_68_7 VPWR VGND sg13cmos5l_decap_8
XFILLER_338_77 VPWR VGND sg13cmos5l_decap_8
X_1550_ Tile_X0Y3_EE4BEG[12] _2537_/X VPWR VGND sg13cmos5l_buf_1
X_0501_ _0501_/Q Tile_X0Y1_FrameData[1] VGND VPWR Tile_X0Y5_FrameStrobe[5] latch
XFILLER_354_21 VPWR VGND sg13cmos5l_decap_8
X_1481_ _1481_/Q Tile_X0Y5_FrameData[7] VGND VPWR Tile_X0Y5_FrameStrobe[6] latch
XFILLER_341_161 VPWR VGND sg13cmos5l_decap_8
X_0432_ _0432_/Q Tile_X0Y1_FrameData[6] VGND VPWR Tile_X0Y5_FrameStrobe[3] latch
XFILLER_354_98 VPWR VGND sg13cmos5l_decap_8
XFILLER_223_14 VPWR VGND sg13cmos5l_decap_8
XFILLER_239_154 VPWR VGND sg13cmos5l_decap_8
X_0363_ _0363_/Q Tile_X0Y1_FrameData[11] VGND VPWR Tile_X0Y5_FrameStrobe[1] latch
XFILLER_294_271 VPWR VGND sg13cmos5l_fill_2
X_2102_ AXIL_S_SOC_BRESP0 Tile_X0Y4_W2MID[2] Tile_X0Y4_W2END[2] Tile_X0Y4_W6END[2]
+ _2710_/X _1092_/Q _1091_/Q VPWR VGND sg13cmos5l_mux4_1
X_0294_ _0294_/Q Tile_X0Y0_FrameData[0] VGND VPWR Tile_X0Y5_FrameStrobe[6] latch
X_2033_ Tile_X0Y5_FrameData_O[18] Tile_X0Y5_FrameData[18] VPWR VGND sg13cmos5l_buf_1
XFILLER_303_91 VPWR VGND sg13cmos5l_decap_8
XFILLER_210_216 VPWR VGND sg13cmos5l_fill_1
XFILLER_94_0 VPWR VGND sg13cmos5l_decap_8
XFILLER_309_147 VPWR VGND sg13cmos5l_decap_8
XFILLER_30_181 VPWR VGND sg13cmos5l_fill_1
XFILLER_175_175 VPWR VGND sg13cmos5l_decap_8
XFILLER_248_77 VPWR VGND sg13cmos5l_decap_8
X_1817_ Tile_X0Y4_EE4BEG[0] _2633_/X VPWR VGND sg13cmos5l_buf_1
XANTENNA__2113__X AXIL_S_SOC_RDATA7 VPWR VGND sg13cmos5l_antennanp
XFILLER_190_134 VPWR VGND sg13cmos5l_decap_8
X_2797_ _2797_/X Tile_X0Y5_N2MID[7] Tile_X0Y5_N2END[7] _2836_/X _2720_/X _1274_/Q
+ _1273_/Q VPWR VGND sg13cmos5l_mux4_1
XFILLER_7_91 VPWR VGND sg13cmos5l_fill_2
XFILLER_116_253 VPWR VGND sg13cmos5l_decap_4
XFILLER_264_21 VPWR VGND sg13cmos5l_decap_8
X_1748_ Tile_X0Y2_FrameData_O[8] Tile_X0Y2_FrameData[8] VPWR VGND sg13cmos5l_buf_1
XANTENNA__1952__X Tile_X0Y1_E2BEGb[5] VPWR VGND sg13cmos5l_antennanp
XFILLER_131_212 VPWR VGND sg13cmos5l_decap_8
X_1679_ Tile_X0Y0_FrameData_O[19] Tile_X0Y0_FrameData[19] VPWR VGND sg13cmos5l_buf_1
XFILLER_264_98 VPWR VGND sg13cmos5l_decap_4
XFILLER_277_216 VPWR VGND sg13cmos5l_decap_8
XFILLER_133_14 VPWR VGND sg13cmos5l_decap_8
XFILLER_280_42 VPWR VGND sg13cmos5l_decap_8
XFILLER_292_219 VPWR VGND sg13cmos5l_decap_8
XFILLER_45_218 VPWR VGND sg13cmos5l_decap_8
XANTENNA_206 _2493_/X VPWR VGND sg13cmos5l_antennanp
XFILLER_172_7 VPWR VGND sg13cmos5l_decap_8
XFILLER_260_105 VPWR VGND sg13cmos5l_decap_8
XANTENNA_217 Tile_X0Y5_FrameStrobe[17] VPWR VGND sg13cmos5l_antennanp
XANTENNA_228 Tile_X0Y5_N2MID[5] VPWR VGND sg13cmos5l_antennanp
XANTENNA_239 AXIL_S_SOC_WDATA22 VPWR VGND sg13cmos5l_antennanp
XFILLER_26_56 VPWR VGND sg13cmos5l_decap_8
XFILLER_13_126 VPWR VGND sg13cmos5l_decap_8
XFILLER_289_84 VPWR VGND sg13cmos5l_decap_8
XFILLER_9_119 VPWR VGND sg13cmos5l_decap_8
XFILLER_42_66 VPWR VGND sg13cmos5l_decap_8
XFILLER_355_231 VPWR VGND sg13cmos5l_decap_8
XFILLER_158_77 VPWR VGND sg13cmos5l_decap_8
XFILLER_166_153 VPWR VGND sg13cmos5l_decap_8
XFILLER_166_164 VPWR VGND sg13cmos5l_fill_1
XANTENNA__2023__X Tile_X0Y5_FrameData_O[8] VPWR VGND sg13cmos5l_antennanp
XFILLER_166_186 VPWR VGND sg13cmos5l_fill_2
XFILLER_181_112 VPWR VGND sg13cmos5l_decap_8
XFILLER_308_14 VPWR VGND sg13cmos5l_decap_8
XFILLER_174_21 VPWR VGND sg13cmos5l_decap_8
XANTENNA__1862__X Tile_X0Y4_FrameData_O[29] VPWR VGND sg13cmos5l_antennanp
XFILLER_174_98 VPWR VGND sg13cmos5l_decap_8
XFILLER_107_70 VPWR VGND sg13cmos5l_decap_8
XFILLER_296_0 VPWR VGND sg13cmos5l_decap_8
XFILLER_324_35 VPWR VGND sg13cmos5l_decap_8
XFILLER_3_49 VPWR VGND sg13cmos5l_decap_8
XFILLER_190_42 VPWR VGND sg13cmos5l_decap_8
XFILLER_276_271 VPWR VGND sg13cmos5l_fill_2
XFILLER_67_63 VPWR VGND sg13cmos5l_decap_8
XFILLER_236_168 VPWR VGND sg13cmos5l_decap_4
XFILLER_251_105 VPWR VGND sg13cmos5l_decap_8
XFILLER_123_91 VPWR VGND sg13cmos5l_decap_8
XFILLER_44_240 VPWR VGND sg13cmos5l_decap_8
XFILLER_340_56 VPWR VGND sg13cmos5l_decap_8
XFILLER_83_84 VPWR VGND sg13cmos5l_decap_8
XFILLER_349_21 VPWR VGND sg13cmos5l_decap_8
X_0981_ _0981_/Q Tile_X0Y3_FrameData[1] VGND VPWR Tile_X0Y5_FrameStrobe[5] latch
XFILLER_157_131 VPWR VGND sg13cmos5l_decap_8
X_2720_ _2720_/X Tile_X0Y3_W1END[3] Tile_X0Y3_W2MID[0] Tile_X0Y3_W2END[0] _2596_/X
+ _0876_/Q _0875_/Q VPWR VGND sg13cmos5l_mux4_1
XFILLER_349_98 VPWR VGND sg13cmos5l_decap_8
X_2651_ _2651_/X Tile_X0Y5_N4END[6] _0024_/X _2693_/X _2692_/X _1152_/Q _1151_/Q VPWR
+ VGND sg13cmos5l_mux4_1
XFILLER_8_141 VPWR VGND sg13cmos5l_decap_8
XFILLER_218_14 VPWR VGND sg13cmos5l_decap_8
X_1602_ Tile_X0Y2_EE4BEG[15] _2432_/X VPWR VGND sg13cmos5l_buf_1
XFILLER_361_212 VPWR VGND sg13cmos5l_decap_8
X_2582_ _2582_/X _2570_/X Tile_X0Y5_N4END[10] _2569_/X Tile_X0Y0_S4END[14] _0834_/Q
+ _0833_/Q VPWR VGND sg13cmos5l_mux4_1
XFILLER_361_245 VPWR VGND sg13cmos5l_fill_2
XANTENNA__1772__X Tile_X0Y2_UserCLKo VPWR VGND sg13cmos5l_antennanp
XFILLER_314_161 VPWR VGND sg13cmos5l_fill_2
X_1533_ Tile_X0Y3_E6BEG[7] _2548_/X VPWR VGND sg13cmos5l_buf_1
X_1464_ _1464_/Q Tile_X0Y5_FrameData[24] VGND VPWR Tile_X0Y5_FrameStrobe[6] latch
XFILLER_234_35 VPWR VGND sg13cmos5l_decap_8
X_0415_ _0415_/Q Tile_X0Y1_FrameData[23] VGND VPWR Tile_X0Y5_FrameStrobe[3] latch
X_1395_ _1395_/Q Tile_X0Y5_FrameData[29] VGND VPWR Tile_X0Y5_FrameStrobe[4] latch
X_0346_ _0346_/Q Tile_X0Y1_FrameData[28] VGND VPWR Tile_X0Y5_FrameStrobe[1] latch
XFILLER_94_162 VPWR VGND sg13cmos5l_decap_8
XFILLER_103_28 VPWR VGND sg13cmos5l_decap_8
XFILLER_242_105 VPWR VGND sg13cmos5l_decap_8
XFILLER_27_218 VPWR VGND sg13cmos5l_decap_8
XFILLER_27_229 VPWR VGND sg13cmos5l_fill_2
XFILLER_282_252 VPWR VGND sg13cmos5l_decap_8
X_0277_ _0277_/Q Tile_X0Y0_FrameData[17] VGND VPWR Tile_X0Y5_FrameStrobe[6] latch
XFILLER_250_56 VPWR VGND sg13cmos5l_decap_8
X_2016_ Tile_X0Y5_FrameData_O[1] Tile_X0Y5_FrameData[1] VPWR VGND sg13cmos5l_buf_1
XANTENNA__2108__X AXIL_S_SOC_RDATA2 VPWR VGND sg13cmos5l_antennanp
XFILLER_250_171 VPWR VGND sg13cmos5l_decap_4
XFILLER_259_21 VPWR VGND sg13cmos5l_decap_8
XANTENNA__1947__X Tile_X0Y1_E2BEGb[0] VPWR VGND sg13cmos5l_antennanp
XFILLER_259_98 VPWR VGND sg13cmos5l_decap_8
XFILLER_12_14 VPWR VGND sg13cmos5l_decap_8
XFILLER_148_153 VPWR VGND sg13cmos5l_decap_8
XFILLER_128_14 VPWR VGND sg13cmos5l_decap_8
XFILLER_163_112 VPWR VGND sg13cmos5l_decap_8
XFILLER_275_42 VPWR VGND sg13cmos5l_decap_8
XFILLER_352_245 VPWR VGND sg13cmos5l_decap_8
XANTENNA__1682__X Tile_X0Y0_FrameData_O[22] VPWR VGND sg13cmos5l_antennanp
XFILLER_104_212 VPWR VGND sg13cmos5l_decap_8
XFILLER_305_161 VPWR VGND sg13cmos5l_decap_8
XFILLER_312_109 VPWR VGND sg13cmos5l_fill_1
XFILLER_208_91 VPWR VGND sg13cmos5l_decap_8
XFILLER_144_35 VPWR VGND sg13cmos5l_decap_8
XFILLER_291_63 VPWR VGND sg13cmos5l_decap_8
XFILLER_218_135 VPWR VGND sg13cmos5l_decap_8
XFILLER_18_229 VPWR VGND sg13cmos5l_fill_1
XFILLER_218_157 VPWR VGND sg13cmos5l_decap_8
XFILLER_85_173 VPWR VGND sg13cmos5l_decap_8
XFILLER_160_56 VPWR VGND sg13cmos5l_decap_8
XFILLER_233_105 VPWR VGND sg13cmos5l_decap_8
XFILLER_37_77 VPWR VGND sg13cmos5l_decap_8
XFILLER_26_251 VPWR VGND sg13cmos5l_decap_8
XANTENNA__2018__X Tile_X0Y5_FrameData_O[3] VPWR VGND sg13cmos5l_antennanp
XFILLER_169_21 VPWR VGND sg13cmos5l_decap_8
XFILLER_53_21 VPWR VGND sg13cmos5l_decap_8
XFILLER_241_182 VPWR VGND sg13cmos5l_decap_8
XANTENNA__1857__X Tile_X0Y4_FrameData_O[24] VPWR VGND sg13cmos5l_antennanp
XFILLER_53_98 VPWR VGND sg13cmos5l_decap_8
XFILLER_139_142 VPWR VGND sg13cmos5l_fill_1
XFILLER_169_98 VPWR VGND sg13cmos5l_decap_8
XFILLER_319_35 VPWR VGND sg13cmos5l_decap_8
XFILLER_154_112 VPWR VGND sg13cmos5l_decap_8
XFILLER_211_0 VPWR VGND sg13cmos5l_decap_8
XFILLER_154_167 VPWR VGND sg13cmos5l_fill_1
XFILLER_185_42 VPWR VGND sg13cmos5l_decap_8
XFILLER_309_0 VPWR VGND sg13cmos5l_decap_8
XANTENNA__1592__X Tile_X0Y2_EE4BEG[5] VPWR VGND sg13cmos5l_antennanp
XFILLER_118_91 VPWR VGND sg13cmos5l_decap_8
XFILLER_335_56 VPWR VGND sg13cmos5l_decap_8
XFILLER_311_142 VPWR VGND sg13cmos5l_decap_8
XFILLER_78_84 VPWR VGND sg13cmos5l_decap_8
XFILLER_204_49 VPWR VGND sg13cmos5l_decap_8
XFILLER_209_124 VPWR VGND sg13cmos5l_decap_8
XFILLER_249_271 VPWR VGND sg13cmos5l_fill_2
X_1180_ _1180_/Q Tile_X0Y4_FrameData[10] VGND VPWR Tile_X0Y5_FrameStrobe[4] latch
X_0200_ _0200_/Q Tile_X0Y0_FrameData[30] VGND VPWR Tile_X0Y5_FrameStrobe[4] latch
XFILLER_76_151 VPWR VGND sg13cmos5l_fill_1
X_0131_ _0131_/Q Tile_X0Y0_FrameData[3] VGND VPWR Tile_X0Y5_FrameStrobe[1] latch
XFILLER_351_77 VPWR VGND sg13cmos5l_decap_8
XFILLER_224_105 VPWR VGND sg13cmos5l_decap_8
X_0062_ _2076_/A _2663_/X _2664_/X _1103_/Q VPWR VGND sg13cmos5l_mux2_1
XANTENNA__1767__X Tile_X0Y2_FrameData_O[27] VPWR VGND sg13cmos5l_antennanp
XFILLER_300_70 VPWR VGND sg13cmos5l_decap_8
XFILLER_229_35 VPWR VGND sg13cmos5l_decap_8
X_0964_ _0964_/Q Tile_X0Y3_FrameData[18] VGND VPWR Tile_X0Y5_FrameStrobe[5] latch
XFILLER_145_112 VPWR VGND sg13cmos5l_fill_1
XFILLER_145_134 VPWR VGND sg13cmos5l_decap_8
X_2703_ _2703_/X _2678_/X Tile_X0Y5_N4END[6] _2677_/X _0024_/X _1082_/Q _1081_/Q VPWR
+ VGND sg13cmos5l_mux4_1
X_0895_ _0895_/Q Tile_X0Y3_FrameData[23] VGND VPWR Tile_X0Y5_FrameStrobe[3] latch
X_2634_ _2634_/X Tile_X0Y4_WW4END[5] AXIL_S_SOC_WSTRB1 _2688_/X _2682_/X _1186_/Q
+ _1185_/Q VPWR VGND sg13cmos5l_mux4_1
X_2565_ _2565_/X Tile_X0Y2_W1END[0] Tile_X0Y2_W6END[8] _2471_/X _2453_/X _0658_/Q
+ _0657_/Q VPWR VGND sg13cmos5l_mux4_1
XFILLER_57_0 VPWR VGND sg13cmos5l_decap_8
XFILLER_160_137 VPWR VGND sg13cmos5l_decap_8
XFILLER_245_56 VPWR VGND sg13cmos5l_decap_8
XFILLER_299_182 VPWR VGND sg13cmos5l_decap_8
X_1516_ _2212_/A3 VPWR VGND sg13cmos5l_tielo
X_2496_ _2496_/X Tile_X0Y4_W2MID[4] Tile_X0Y4_W2END[4] Tile_X0Y4_W6END[4] _2711_/X
+ _1250_/Q _1249_/Q VPWR VGND sg13cmos5l_mux4_1
XFILLER_4_70 VPWR VGND sg13cmos5l_decap_8
XFILLER_302_175 VPWR VGND sg13cmos5l_decap_8
X_1447_ _1447_/Q Tile_X0Y5_FrameData[9] VGND VPWR Tile_X0Y5_FrameStrobe[5] latch
XFILLER_101_259 VPWR VGND sg13cmos5l_fill_2
XFILLER_114_49 VPWR VGND sg13cmos5l_decap_8
X_1378_ _1378_/Q Tile_X0Y5_FrameData[14] VGND VPWR Tile_X0Y5_FrameStrobe[3] latch
XFILLER_67_151 VPWR VGND sg13cmos5l_fill_2
XFILLER_67_140 VPWR VGND sg13cmos5l_decap_8
XFILLER_261_77 VPWR VGND sg13cmos5l_decap_8
X_0329_ _0329_/Q Tile_X0Y1_FrameData[13] VGND VPWR Tile_X0Y5_FrameStrobe[0] latch
XFILLER_270_200 VPWR VGND sg13cmos5l_fill_1
XFILLER_67_195 VPWR VGND sg13cmos5l_decap_8
XFILLER_82_165 VPWR VGND sg13cmos5l_decap_8
XFILLER_82_154 VPWR VGND sg13cmos5l_decap_4
XFILLER_230_119 VPWR VGND sg13cmos5l_decap_8
XFILLER_168_226 VPWR VGND sg13cmos5l_fill_1
XFILLER_223_193 VPWR VGND sg13cmos5l_decap_4
XANTENNA__1677__X Tile_X0Y0_FrameData_O[17] VPWR VGND sg13cmos5l_antennanp
XFILLER_168_248 VPWR VGND sg13cmos5l_fill_2
XFILLER_210_70 VPWR VGND sg13cmos5l_decap_8
XFILLER_23_35 VPWR VGND sg13cmos5l_decap_8
XFILLER_135_7 VPWR VGND sg13cmos5l_decap_8
XFILLER_139_35 VPWR VGND sg13cmos5l_decap_8
XFILLER_286_85 VPWR VGND sg13cmos5l_decap_8
XFILLER_99_28 VPWR VGND sg13cmos5l_decap_8
XFILLER_302_7 VPWR VGND sg13cmos5l_decap_8
XFILLER_340_215 VPWR VGND sg13cmos5l_fill_1
XFILLER_155_56 VPWR VGND sg13cmos5l_decap_8
XFILLER_297_119 VPWR VGND sg13cmos5l_decap_8
XFILLER_2_114 VPWR VGND sg13cmos5l_fill_1
XFILLER_2_125 VPWR VGND sg13cmos5l_fill_2
XFILLER_238_208 VPWR VGND sg13cmos5l_fill_2
XFILLER_48_32 VPWR VGND sg13cmos5l_decap_8
XFILLER_58_140 VPWR VGND sg13cmos5l_decap_8
XFILLER_171_77 VPWR VGND sg13cmos5l_decap_8
XFILLER_0_28 VPWR VGND sg13cmos5l_decap_8
XFILLER_104_71 VPWR VGND sg13cmos5l_decap_8
XFILLER_321_14 VPWR VGND sg13cmos5l_decap_8
XFILLER_161_0 VPWR VGND sg13cmos5l_decap_8
XFILLER_206_138 VPWR VGND sg13cmos5l_fill_2
XFILLER_261_233 VPWR VGND sg13cmos5l_fill_1
XFILLER_321_69 VPWR VGND sg13cmos5l_decap_8
XFILLER_73_176 VPWR VGND sg13cmos5l_decap_8
XFILLER_64_42 VPWR VGND sg13cmos5l_decap_8
XFILLER_259_0 VPWR VGND sg13cmos5l_decap_8
XANTENNA__1587__X Tile_X0Y2_EE4BEG[0] VPWR VGND sg13cmos5l_antennanp
XFILLER_120_70 VPWR VGND sg13cmos5l_decap_8
XFILLER_159_237 VPWR VGND sg13cmos5l_decap_8
XFILLER_80_63 VPWR VGND sg13cmos5l_decap_8
XFILLER_127_112 VPWR VGND sg13cmos5l_fill_2
XFILLER_196_63 VPWR VGND sg13cmos5l_decap_8
X_0680_ _0680_/Q Tile_X0Y2_FrameData[30] VGND VPWR Tile_X0Y5_FrameStrobe[4] latch
XFILLER_127_189 VPWR VGND sg13cmos5l_fill_2
XFILLER_89_50 VPWR VGND sg13cmos5l_decap_8
XFILLER_50_7 VPWR VGND sg13cmos5l_decap_8
XFILLER_346_77 VPWR VGND sg13cmos5l_decap_8
XFILLER_288_119 VPWR VGND sg13cmos5l_decap_8
X_2350_ _2350_/X _2348_/X _0029_/X _2347_/X Tile_X0Y0_S4END[7] _0344_/Q _0343_/Q VPWR
+ VGND sg13cmos5l_mux4_1
XFILLER_362_21 VPWR VGND sg13cmos5l_decap_8
XFILLER_229_208 VPWR VGND sg13cmos5l_fill_1
X_1301_ _1301_/Q Tile_X0Y5_FrameData[27] VGND VPWR Tile_X0Y5_FrameStrobe[1] latch
X_2281_ _2281_/X Tile_X0Y3_W1END[3] Tile_X0Y3_WW4END[3] Tile_X0Y3_WW4END[7] Tile_X0Y3_W6END[11]
+ _0997_/Q _0996_/Q VPWR VGND sg13cmos5l_mux4_1
XFILLER_96_224 VPWR VGND sg13cmos5l_decap_4
XFILLER_296_196 VPWR VGND sg13cmos5l_decap_8
X_1232_ _1232_/Q Tile_X0Y4_FrameData[22] VGND VPWR Tile_X0Y5_FrameStrobe[6] latch
XFILLER_49_140 VPWR VGND sg13cmos5l_decap_8
XFILLER_362_87 VPWR VGND sg13cmos5l_decap_8
XFILLER_231_14 VPWR VGND sg13cmos5l_decap_8
X_1163_ _1163_/Q Tile_X0Y4_FrameData[27] VGND VPWR Tile_X0Y5_FrameStrobe[4] latch
XFILLER_252_255 VPWR VGND sg13cmos5l_fill_2
X_1094_ _1094_/Q Tile_X0Y4_FrameData[0] VGND VPWR Tile_X0Y5_FrameStrobe[1] latch
X_0114_ _0114_/Q Tile_X0Y0_FrameData[20] VGND VPWR Tile_X0Y5_FrameStrobe[1] latch
X_0045_ _2070_/A _2451_/X _2452_/X _0623_/Q VPWR VGND sg13cmos5l_mux2_1
XFILLER_205_171 VPWR VGND sg13cmos5l_decap_8
XFILLER_311_91 VPWR VGND sg13cmos5l_decap_8
XFILLER_165_218 VPWR VGND sg13cmos5l_decap_8
XFILLER_220_174 VPWR VGND sg13cmos5l_decap_4
XFILLER_220_185 VPWR VGND sg13cmos5l_decap_8
X_1996_ Tile_X0Y5_E6BEG[9] _2766_/X VPWR VGND sg13cmos5l_buf_1
XFILLER_118_112 VPWR VGND sg13cmos5l_decap_8
X_0947_ _0947_/Q Tile_X0Y3_FrameData[3] VGND VPWR Tile_X0Y5_FrameStrobe[4] latch
XFILLER_109_49 VPWR VGND sg13cmos5l_decap_8
XFILLER_118_189 VPWR VGND sg13cmos5l_decap_8
XFILLER_256_77 VPWR VGND sg13cmos5l_decap_8
X_0878_ _0878_/Q Tile_X0Y3_FrameData[8] VGND VPWR Tile_X0Y5_FrameStrobe[2] latch
XFILLER_133_148 VPWR VGND sg13cmos5l_fill_2
XFILLER_279_119 VPWR VGND sg13cmos5l_decap_4
X_2617_ _2617_/X AXIL_S_SOC_WSTRB0 AXIL_S_SOC_WSTRB2 _2708_/X _2681_/X _1220_/Q _1219_/Q
+ VPWR VGND sg13cmos5l_mux4_1
XANTENNA__2121__X AXIL_S_SOC_RDATA15 VPWR VGND sg13cmos5l_antennanp
XFILLER_272_21 VPWR VGND sg13cmos5l_decap_8
X_2548_ _2548_/X AXIL_S_SOC_ARADDR7 _2587_/X _2580_/X _2592_/X _0908_/Q _0907_/Q VPWR
+ VGND sg13cmos5l_mux4_1
XFILLER_87_235 VPWR VGND sg13cmos5l_fill_2
XANTENNA__1960__X Tile_X0Y1_E2BEG[5] VPWR VGND sg13cmos5l_antennanp
XFILLER_272_98 VPWR VGND sg13cmos5l_decap_8
X_2479_ _2479_/X _2458_/X Tile_X0Y5_N4END[12] _2457_/X Tile_X0Y0_S4END[8] _0598_/Q
+ _0597_/Q VPWR VGND sg13cmos5l_mux4_1
XFILLER_18_35 VPWR VGND sg13cmos5l_decap_8
XFILLER_205_70 VPWR VGND sg13cmos5l_decap_8
XFILLER_205_81 VPWR VGND sg13cmos5l_fill_1
XFILLER_141_14 VPWR VGND sg13cmos5l_decap_8
XFILLER_243_200 VPWR VGND sg13cmos5l_decap_8
XFILLER_55_154 VPWR VGND sg13cmos5l_decap_8
XFILLER_203_119 VPWR VGND sg13cmos5l_decap_8
XFILLER_252_7 VPWR VGND sg13cmos5l_decap_8
XFILLER_221_91 VPWR VGND sg13cmos5l_fill_2
XFILLER_70_168 VPWR VGND sg13cmos5l_decap_8
XFILLER_211_130 VPWR VGND sg13cmos5l_decap_4
XFILLER_70_179 VPWR VGND sg13cmos5l_fill_2
XFILLER_357_112 VPWR VGND sg13cmos5l_decap_8
XFILLER_34_56 VPWR VGND sg13cmos5l_decap_8
XFILLER_297_84 VPWR VGND sg13cmos5l_decap_8
XFILLER_109_112 VPWR VGND sg13cmos5l_decap_8
XFILLER_357_189 VPWR VGND sg13cmos5l_decap_8
XFILLER_50_77 VPWR VGND sg13cmos5l_decap_8
XFILLER_166_77 VPWR VGND sg13cmos5l_decap_8
XFILLER_316_14 VPWR VGND sg13cmos5l_decap_8
XANTENNA__2031__X Tile_X0Y5_FrameData_O[16] VPWR VGND sg13cmos5l_antennanp
XFILLER_182_21 VPWR VGND sg13cmos5l_decap_8
XFILLER_59_42 VPWR VGND sg13cmos5l_decap_8
XFILLER_78_213 VPWR VGND sg13cmos5l_decap_4
XANTENNA__1870__X Tile_X0Y2_E2BEGb[4] VPWR VGND sg13cmos5l_antennanp
XFILLER_293_133 VPWR VGND sg13cmos5l_fill_2
XFILLER_115_70 VPWR VGND sg13cmos5l_decap_8
XFILLER_182_98 VPWR VGND sg13cmos5l_decap_8
XFILLER_293_166 VPWR VGND sg13cmos5l_decap_8
XFILLER_332_35 VPWR VGND sg13cmos5l_decap_8
XFILLER_93_227 VPWR VGND sg13cmos5l_decap_8
XFILLER_75_63 VPWR VGND sg13cmos5l_decap_8
XFILLER_46_132 VPWR VGND sg13cmos5l_decap_8
XFILLER_201_28 VPWR VGND sg13cmos5l_decap_8
XFILLER_131_91 VPWR VGND sg13cmos5l_decap_8
XFILLER_98_7 VPWR VGND sg13cmos5l_decap_8
XFILLER_91_84 VPWR VGND sg13cmos5l_decap_8
XFILLER_348_112 VPWR VGND sg13cmos5l_decap_8
XFILLER_147_207 VPWR VGND sg13cmos5l_decap_8
X_1850_ Tile_X0Y4_FrameData_O[17] Tile_X0Y4_FrameData[17] VPWR VGND sg13cmos5l_buf_1
X_1781_ Tile_X0Y2_E2BEG[4] _2405_/X VPWR VGND sg13cmos5l_buf_1
X_0801_ _0801_/Q Tile_X0Y3_FrameData[21] VGND VPWR Tile_X0Y5_FrameStrobe[0] latch
XFILLER_357_21 VPWR VGND sg13cmos5l_decap_8
X_0732_ _0732_/Q Tile_X0Y2_FrameData[10] VGND VPWR Tile_X0Y5_FrameStrobe[5] latch
XFILLER_357_98 VPWR VGND sg13cmos5l_decap_8
XFILLER_115_126 VPWR VGND sg13cmos5l_decap_8
XFILLER_304_248 VPWR VGND sg13cmos5l_decap_8
X_0663_ _0663_/Q Tile_X0Y2_FrameData[15] VGND VPWR Tile_X0Y5_FrameStrobe[3] latch
XFILLER_226_36 VPWR VGND sg13cmos5l_decap_8
X_2402_ _2402_/X AXIL_S_SOC_AWADDR1 AXIL_S_SOC_AWADDR9 _2482_/X _2487_/X _0744_/Q
+ _0743_/Q VPWR VGND sg13cmos5l_mux4_1
X_0594_ _0594_/Q Tile_X0Y2_FrameData[20] VGND VPWR Tile_X0Y5_FrameStrobe[1] latch
XFILLER_130_129 VPWR VGND sg13cmos5l_fill_2
XFILLER_269_163 VPWR VGND sg13cmos5l_fill_1
X_2333_ _2333_/X AXIL_S_SOC_WDATA0 _2367_/X _2365_/X _2377_/X _0426_/Q _0425_/Q VPWR
+ VGND sg13cmos5l_mux4_1
XANTENNA__1780__X Tile_X0Y2_E2BEG[3] VPWR VGND sg13cmos5l_antennanp
XFILLER_306_91 VPWR VGND sg13cmos5l_decap_8
XFILLER_242_35 VPWR VGND sg13cmos5l_decap_8
XFILLER_284_133 VPWR VGND sg13cmos5l_decap_8
XFILLER_284_155 VPWR VGND sg13cmos5l_decap_4
X_2264_ _2264_/X Tile_X0Y1_W2MID[0] Tile_X0Y1_W2END[0] Tile_X0Y1_W6END[0] _2380_/X
+ _0528_/Q _0527_/Q VPWR VGND sg13cmos5l_mux4_1
XFILLER_225_200 VPWR VGND sg13cmos5l_decap_8
X_2195_ _2195_/X AXIL_S_SOC_WDATA18 AXIL_S_SOC_WDATA30 _2238_/X _2242_/X _0206_/Q
+ _0205_/Q VPWR VGND sg13cmos5l_mux4_1
X_1215_ _1215_/Q Tile_X0Y4_FrameData[7] VGND VPWR Tile_X0Y5_FrameStrobe[5] latch
X_1146_ _1146_/Q Tile_X0Y4_FrameData[12] VGND VPWR Tile_X0Y5_FrameStrobe[3] latch
XFILLER_111_28 VPWR VGND sg13cmos5l_decap_8
XFILLER_240_203 VPWR VGND sg13cmos5l_decap_8
XFILLER_240_214 VPWR VGND sg13cmos5l_fill_1
X_1077_ _1077_/Q Tile_X0Y4_FrameData[17] VGND VPWR Tile_X0Y5_FrameStrobe[1] latch
XFILLER_52_168 VPWR VGND sg13cmos5l_decap_8
XFILLER_240_269 VPWR VGND sg13cmos5l_decap_4
X_0028_ _2079_/A _2781_/X _2782_/X _1338_/Q VPWR VGND sg13cmos5l_mux2_1
XFILLER_339_112 VPWR VGND sg13cmos5l_decap_8
XANTENNA__2116__X AXIL_S_SOC_RDATA10 VPWR VGND sg13cmos5l_antennanp
XFILLER_267_21 VPWR VGND sg13cmos5l_decap_8
XFILLER_354_126 VPWR VGND sg13cmos5l_decap_8
XFILLER_339_189 VPWR VGND sg13cmos5l_decap_8
XANTENNA__1955__X Tile_X0Y1_E2BEG[0] VPWR VGND sg13cmos5l_antennanp
X_1979_ Tile_X0Y5_E2BEGb[0] _2733_/X VPWR VGND sg13cmos5l_buf_1
XFILLER_20_14 VPWR VGND sg13cmos5l_decap_8
XFILLER_267_98 VPWR VGND sg13cmos5l_decap_8
XFILLER_106_126 VPWR VGND sg13cmos5l_decap_8
XFILLER_136_14 VPWR VGND sg13cmos5l_decap_8
XFILLER_362_192 VPWR VGND sg13cmos5l_decap_8
XFILLER_161_254 VPWR VGND sg13cmos5l_decap_8
XFILLER_283_42 VPWR VGND sg13cmos5l_decap_8
XANTENNA__1690__X Tile_X0Y0_FrameData_O[30] VPWR VGND sg13cmos5l_antennanp
XFILLER_216_91 VPWR VGND sg13cmos5l_decap_8
XFILLER_152_35 VPWR VGND sg13cmos5l_decap_8
XFILLER_275_133 VPWR VGND sg13cmos5l_fill_2
XFILLER_29_56 VPWR VGND sg13cmos5l_decap_8
XFILLER_75_238 VPWR VGND sg13cmos5l_fill_2
XFILLER_216_244 VPWR VGND sg13cmos5l_decap_8
XFILLER_290_147 VPWR VGND sg13cmos5l_decap_8
XFILLER_302_49 VPWR VGND sg13cmos5l_decap_8
XFILLER_45_77 VPWR VGND sg13cmos5l_decap_8
XFILLER_43_168 VPWR VGND sg13cmos5l_decap_8
XANTENNA__2026__X Tile_X0Y5_FrameData_O[11] VPWR VGND sg13cmos5l_antennanp
XFILLER_61_21 VPWR VGND sg13cmos5l_decap_8
XFILLER_177_21 VPWR VGND sg13cmos5l_decap_8
XFILLER_345_126 VPWR VGND sg13cmos5l_decap_8
XANTENNA__1865__X Tile_X0Y4_UserCLKo VPWR VGND sg13cmos5l_antennanp
XFILLER_124_0 VPWR VGND sg13cmos5l_decap_8
XFILLER_61_98 VPWR VGND sg13cmos5l_decap_8
XANTENNA_9 AXIL_S_SOC_WDATA10 VPWR VGND sg13cmos5l_antennanp
XFILLER_177_98 VPWR VGND sg13cmos5l_decap_8
XFILLER_327_35 VPWR VGND sg13cmos5l_decap_8
XFILLER_6_49 VPWR VGND sg13cmos5l_decap_8
XFILLER_298_203 VPWR VGND sg13cmos5l_fill_2
XFILLER_298_225 VPWR VGND sg13cmos5l_decap_8
XFILLER_152_243 VPWR VGND sg13cmos5l_decap_8
XFILLER_193_42 VPWR VGND sg13cmos5l_decap_8
XFILLER_10_91 VPWR VGND sg13cmos5l_decap_8
XFILLER_301_229 VPWR VGND sg13cmos5l_fill_2
XFILLER_126_91 VPWR VGND sg13cmos5l_decap_8
XFILLER_343_56 VPWR VGND sg13cmos5l_decap_8
XFILLER_120_140 VPWR VGND sg13cmos5l_decap_8
XFILLER_13_7 VPWR VGND sg13cmos5l_decap_8
XFILLER_86_84 VPWR VGND sg13cmos5l_decap_8
XFILLER_281_147 VPWR VGND sg13cmos5l_decap_8
X_1000_ _1000_/Q Tile_X0Y3_FrameData[14] VGND VPWR Tile_X0Y5_FrameStrobe[6] latch
XFILLER_212_49 VPWR VGND sg13cmos5l_decap_8
XFILLER_74_271 VPWR VGND sg13cmos5l_fill_2
XFILLER_222_236 VPWR VGND sg13cmos5l_decap_8
XFILLER_34_168 VPWR VGND sg13cmos5l_decap_8
XFILLER_187_140 VPWR VGND sg13cmos5l_decap_8
X_1902_ Tile_X0Y1_FrameData_O[15] Tile_X0Y1_FrameData[15] VPWR VGND sg13cmos5l_buf_1
XANTENNA__1775__X Tile_X0Y2_E1BEG[2] VPWR VGND sg13cmos5l_antennanp
X_1833_ Tile_X0Y4_FrameData_O[0] Tile_X0Y4_FrameData[0] VPWR VGND sg13cmos5l_buf_1
XFILLER_237_35 VPWR VGND sg13cmos5l_decap_8
X_1764_ Tile_X0Y2_FrameData_O[24] Tile_X0Y2_FrameData[24] VPWR VGND sg13cmos5l_buf_1
XFILLER_143_221 VPWR VGND sg13cmos5l_decap_4
X_0715_ _0715_/Q Tile_X0Y2_FrameData[27] VGND VPWR Tile_X0Y5_FrameStrobe[5] latch
XFILLER_289_247 VPWR VGND sg13cmos5l_decap_8
XFILLER_289_258 VPWR VGND sg13cmos5l_fill_1
X_1695_ Tile_X0Y0_EE4BEG[3] _2184_/X VPWR VGND sg13cmos5l_buf_1
X_0646_ _0646_/Q Tile_X0Y2_FrameData[0] VGND VPWR Tile_X0Y5_FrameStrobe[2] latch
XFILLER_106_28 VPWR VGND sg13cmos5l_decap_8
XFILLER_253_56 VPWR VGND sg13cmos5l_decap_8
X_0577_ _0577_/Q Tile_X0Y2_FrameData[5] VGND VPWR Tile_X0Y5_FrameStrobe[0] latch
XFILLER_111_140 VPWR VGND sg13cmos5l_decap_8
XFILLER_300_240 VPWR VGND sg13cmos5l_fill_2
X_2316_ _2316_/X AXIL_S_SOC_WDATA7 AXIL_S_SOC_WDATA11 _2362_/X _2373_/X _0460_/Q _0459_/Q
+ VPWR VGND sg13cmos5l_mux4_1
X_2247_ _2247_/X _2262_/X _2261_/X Tile_X0Y0_S2MID[6] Tile_X0Y0_S2END[6] _0082_/Q
+ _0081_/Q VPWR VGND sg13cmos5l_mux4_1
XFILLER_57_238 VPWR VGND sg13cmos5l_decap_8
XFILLER_122_49 VPWR VGND sg13cmos5l_decap_8
X_2178_ _2178_/X AXIL_S_SOC_WDATA21 AXIL_S_SOC_WDATA29 _2243_/X _2246_/X _0240_/Q
+ _0239_/Q VPWR VGND sg13cmos5l_mux4_1
XFILLER_15_14 VPWR VGND sg13cmos5l_decap_8
XFILLER_213_214 VPWR VGND sg13cmos5l_decap_8
X_1129_ _1129_/Q Tile_X0Y4_FrameData[29] VGND VPWR Tile_X0Y5_FrameStrobe[3] latch
XFILLER_213_258 VPWR VGND sg13cmos5l_decap_8
XFILLER_40_105 VPWR VGND sg13cmos5l_decap_8
XFILLER_178_140 VPWR VGND sg13cmos5l_decap_8
XFILLER_278_42 VPWR VGND sg13cmos5l_decap_8
XFILLER_40_149 VPWR VGND sg13cmos5l_fill_2
XANTENNA__1685__X Tile_X0Y0_FrameData_O[25] VPWR VGND sg13cmos5l_antennanp
XFILLER_31_35 VPWR VGND sg13cmos5l_decap_8
XFILLER_147_35 VPWR VGND sg13cmos5l_decap_8
XFILLER_215_7 VPWR VGND sg13cmos5l_decap_8
XFILLER_294_63 VPWR VGND sg13cmos5l_decap_8
XFILLER_350_184 VPWR VGND sg13cmos5l_decap_8
XFILLER_163_56 VPWR VGND sg13cmos5l_decap_8
XFILLER_295_217 VPWR VGND sg13cmos5l_decap_8
XFILLER_102_195 VPWR VGND sg13cmos5l_decap_8
XFILLER_56_21 VPWR VGND sg13cmos5l_decap_8
XFILLER_56_98 VPWR VGND sg13cmos5l_decap_8
XFILLER_56_260 VPWR VGND sg13cmos5l_fill_1
XFILLER_204_269 VPWR VGND sg13cmos5l_decap_4
XFILLER_31_105 VPWR VGND sg13cmos5l_decap_8
XFILLER_72_42 VPWR VGND sg13cmos5l_decap_8
XFILLER_188_42 VPWR VGND sg13cmos5l_decap_8
XFILLER_241_0 VPWR VGND sg13cmos5l_decap_8
XFILLER_31_149 VPWR VGND sg13cmos5l_decap_4
XFILLER_339_0 VPWR VGND sg13cmos5l_decap_8
XANTENNA__1595__X Tile_X0Y2_EE4BEG[8] VPWR VGND sg13cmos5l_antennanp
XFILLER_318_126 VPWR VGND sg13cmos5l_decap_8
XFILLER_318_137 VPWR VGND sg13cmos5l_fill_1
XFILLER_338_56 VPWR VGND sg13cmos5l_decap_8
XFILLER_333_129 VPWR VGND sg13cmos5l_fill_1
X_0500_ _0500_/Q Tile_X0Y1_FrameData[2] VGND VPWR Tile_X0Y5_FrameStrobe[5] latch
XFILLER_341_140 VPWR VGND sg13cmos5l_decap_8
XFILLER_207_49 VPWR VGND sg13cmos5l_decap_8
X_1480_ _1480_/Q Tile_X0Y5_FrameData[8] VGND VPWR Tile_X0Y5_FrameStrobe[6] latch
XFILLER_98_105 VPWR VGND sg13cmos5l_fill_2
XFILLER_140_257 VPWR VGND sg13cmos5l_fill_2
XFILLER_286_239 VPWR VGND sg13cmos5l_decap_8
X_0431_ _0431_/Q Tile_X0Y1_FrameData[7] VGND VPWR Tile_X0Y5_FrameStrobe[3] latch
XFILLER_354_77 VPWR VGND sg13cmos5l_decap_8
XFILLER_239_133 VPWR VGND sg13cmos5l_decap_8
X_0362_ _0362_/Q Tile_X0Y1_FrameData[12] VGND VPWR Tile_X0Y5_FrameStrobe[1] latch
X_2101_ AXIL_S_SOC_WREADY Tile_X0Y4_W2MID[1] Tile_X0Y4_W2END[1] Tile_X0Y4_W6END[1]
+ _2709_/X _1094_/Q _1093_/Q VPWR VGND sg13cmos5l_mux4_1
XFILLER_39_249 VPWR VGND sg13cmos5l_decap_8
X_2032_ Tile_X0Y5_FrameData_O[17] Tile_X0Y5_FrameData[17] VPWR VGND sg13cmos5l_buf_1
X_0293_ _0293_/Q Tile_X0Y0_FrameData[1] VGND VPWR Tile_X0Y5_FrameStrobe[6] latch
XFILLER_254_158 VPWR VGND sg13cmos5l_fill_2
XFILLER_303_70 VPWR VGND sg13cmos5l_decap_8
XFILLER_47_271 VPWR VGND sg13cmos5l_fill_2
XFILLER_22_105 VPWR VGND sg13cmos5l_decap_8
XFILLER_262_180 VPWR VGND sg13cmos5l_decap_8
XFILLER_87_0 VPWR VGND sg13cmos5l_decap_8
XFILLER_309_126 VPWR VGND sg13cmos5l_decap_8
XFILLER_175_154 VPWR VGND sg13cmos5l_decap_8
XFILLER_248_56 VPWR VGND sg13cmos5l_decap_8
X_1816_ Tile_X0Y4_E6BEG[11] _2660_/X VPWR VGND sg13cmos5l_buf_1
XFILLER_116_210 VPWR VGND sg13cmos5l_decap_8
XFILLER_116_221 VPWR VGND sg13cmos5l_fill_2
XFILLER_317_181 VPWR VGND sg13cmos5l_fill_2
X_2796_ _2796_/X Tile_X0Y4_W1END[3] Tile_X0Y4_W6END[11] _2684_/X _2672_/X _1126_/Q
+ _1125_/Q VPWR VGND sg13cmos5l_mux4_1
XFILLER_7_70 VPWR VGND sg13cmos5l_decap_8
X_1747_ Tile_X0Y2_FrameData_O[7] Tile_X0Y2_FrameData[7] VPWR VGND sg13cmos5l_buf_1
XFILLER_117_49 VPWR VGND sg13cmos5l_decap_8
X_1678_ Tile_X0Y0_FrameData_O[18] Tile_X0Y0_FrameData[18] VPWR VGND sg13cmos5l_buf_1
XFILLER_131_235 VPWR VGND sg13cmos5l_decap_8
XFILLER_264_77 VPWR VGND sg13cmos5l_decap_8
X_0629_ _0629_/Q Tile_X0Y2_FrameData[17] VGND VPWR Tile_X0Y5_FrameStrobe[2] latch
XFILLER_131_268 VPWR VGND sg13cmos5l_decap_4
XFILLER_280_21 VPWR VGND sg13cmos5l_decap_8
XANTENNA_207 _2493_/X VPWR VGND sg13cmos5l_antennanp
XFILLER_213_70 VPWR VGND sg13cmos5l_decap_8
XFILLER_245_147 VPWR VGND sg13cmos5l_decap_8
XFILLER_280_98 VPWR VGND sg13cmos5l_decap_8
XANTENNA_218 Tile_X0Y5_FrameStrobe[18] VPWR VGND sg13cmos5l_antennanp
XANTENNA_229 Tile_X0Y5_N2MID[5] VPWR VGND sg13cmos5l_antennanp
XFILLER_213_81 VPWR VGND sg13cmos5l_fill_1
XFILLER_26_35 VPWR VGND sg13cmos5l_decap_8
XFILLER_13_105 VPWR VGND sg13cmos5l_decap_8
XFILLER_289_63 VPWR VGND sg13cmos5l_decap_8
XFILLER_198_268 VPWR VGND sg13cmos5l_decap_4
XFILLER_201_228 VPWR VGND sg13cmos5l_fill_2
XFILLER_332_7 VPWR VGND sg13cmos5l_decap_8
XFILLER_42_45 VPWR VGND sg13cmos5l_decap_8
XFILLER_355_210 VPWR VGND sg13cmos5l_decap_8
XFILLER_158_56 VPWR VGND sg13cmos5l_decap_8
XFILLER_107_254 VPWR VGND sg13cmos5l_fill_2
XFILLER_181_168 VPWR VGND sg13cmos5l_decap_8
XFILLER_308_181 VPWR VGND sg13cmos5l_fill_1
XFILLER_174_77 VPWR VGND sg13cmos5l_decap_8
XFILLER_324_14 VPWR VGND sg13cmos5l_decap_8
XFILLER_3_28 VPWR VGND sg13cmos5l_decap_8
XFILLER_95_108 VPWR VGND sg13cmos5l_decap_8
XFILLER_190_21 VPWR VGND sg13cmos5l_decap_8
XFILLER_191_0 VPWR VGND sg13cmos5l_decap_8
XFILLER_289_0 VPWR VGND sg13cmos5l_decap_8
XFILLER_88_182 VPWR VGND sg13cmos5l_decap_4
XFILLER_67_42 VPWR VGND sg13cmos5l_decap_8
XFILLER_291_220 VPWR VGND sg13cmos5l_decap_8
XFILLER_123_70 VPWR VGND sg13cmos5l_decap_8
XFILLER_190_98 VPWR VGND sg13cmos5l_decap_8
XFILLER_236_147 VPWR VGND sg13cmos5l_decap_8
XFILLER_291_253 VPWR VGND sg13cmos5l_fill_2
XFILLER_340_35 VPWR VGND sg13cmos5l_decap_8
XFILLER_189_213 VPWR VGND sg13cmos5l_fill_2
XFILLER_199_63 VPWR VGND sg13cmos5l_decap_8
XFILLER_83_63 VPWR VGND sg13cmos5l_decap_8
XFILLER_199_96 VPWR VGND sg13cmos5l_decap_4
X_0980_ _0980_/Q Tile_X0Y3_FrameData[2] VGND VPWR Tile_X0Y5_FrameStrobe[5] latch
XFILLER_80_7 VPWR VGND sg13cmos5l_decap_8
XFILLER_349_77 VPWR VGND sg13cmos5l_decap_8
X_2650_ _2650_/X Tile_X0Y5_N4END[5] _0071_/X _2689_/X _2688_/X _1154_/Q _1153_/Q VPWR
+ VGND sg13cmos5l_mux4_1
XFILLER_157_198 VPWR VGND sg13cmos5l_decap_8
X_1601_ Tile_X0Y2_EE4BEG[14] _2431_/X VPWR VGND sg13cmos5l_buf_1
XFILLER_8_164 VPWR VGND sg13cmos5l_fill_1
XFILLER_172_168 VPWR VGND sg13cmos5l_decap_4
X_2581_ _2581_/X _2572_/X Tile_X0Y5_N4END[11] _2571_/X Tile_X0Y0_S4END[15] _0832_/Q
+ _0831_/Q VPWR VGND sg13cmos5l_mux4_1
X_1532_ Tile_X0Y3_E6BEG[6] _2547_/X VPWR VGND sg13cmos5l_buf_1
XFILLER_113_235 VPWR VGND sg13cmos5l_decap_4
XFILLER_234_14 VPWR VGND sg13cmos5l_decap_8
X_1463_ _1463_/Q Tile_X0Y5_FrameData[25] VGND VPWR Tile_X0Y5_FrameStrobe[6] latch
X_0414_ _0414_/Q Tile_X0Y1_FrameData[24] VGND VPWR Tile_X0Y5_FrameStrobe[3] latch
XFILLER_86_119 VPWR VGND sg13cmos5l_decap_8
XFILLER_79_160 VPWR VGND sg13cmos5l_decap_8
XFILLER_274_209 VPWR VGND sg13cmos5l_decap_4
X_1394_ _1394_/Q Tile_X0Y5_FrameData[30] VGND VPWR Tile_X0Y5_FrameStrobe[4] latch
XFILLER_79_171 VPWR VGND sg13cmos5l_fill_2
X_0345_ _0345_/Q Tile_X0Y1_FrameData[29] VGND VPWR Tile_X0Y5_FrameStrobe[1] latch
XFILLER_94_141 VPWR VGND sg13cmos5l_decap_8
XFILLER_250_35 VPWR VGND sg13cmos5l_decap_8
XFILLER_314_91 VPWR VGND sg13cmos5l_decap_8
X_0276_ _0276_/Q Tile_X0Y0_FrameData[18] VGND VPWR Tile_X0Y5_FrameStrobe[6] latch
X_2015_ Tile_X0Y5_FrameData_O[0] Tile_X0Y5_FrameData[0] VPWR VGND sg13cmos5l_buf_1
XFILLER_50_200 VPWR VGND sg13cmos5l_fill_1
XFILLER_35_241 VPWR VGND sg13cmos5l_fill_2
XFILLER_50_244 VPWR VGND sg13cmos5l_decap_8
XFILLER_10_119 VPWR VGND sg13cmos5l_decap_8
XFILLER_195_249 VPWR VGND sg13cmos5l_fill_2
XFILLER_259_77 VPWR VGND sg13cmos5l_decap_8
XANTENNA__2124__X AXIL_S_SOC_RDATA18 VPWR VGND sg13cmos5l_antennanp
XFILLER_275_21 VPWR VGND sg13cmos5l_decap_8
XFILLER_352_224 VPWR VGND sg13cmos5l_decap_8
XANTENNA__1963__X Tile_X0Y1_E1BEG[0] VPWR VGND sg13cmos5l_antennanp
X_2779_ _2779_/X Tile_X0Y5_W1END[2] Tile_X0Y5_W2MID[1] Tile_X0Y5_W2END[1] _2798_/X
+ _1344_/Q _1343_/Q VPWR VGND sg13cmos5l_mux4_1
XFILLER_275_98 VPWR VGND sg13cmos5l_decap_4
XFILLER_305_140 VPWR VGND sg13cmos5l_decap_8
XFILLER_144_14 VPWR VGND sg13cmos5l_decap_8
XFILLER_208_70 VPWR VGND sg13cmos5l_decap_8
XFILLER_291_42 VPWR VGND sg13cmos5l_decap_8
XFILLER_77_119 VPWR VGND sg13cmos5l_fill_1
XFILLER_258_272 VPWR VGND sg13cmos5l_fill_1
XFILLER_282_7 VPWR VGND sg13cmos5l_decap_8
XFILLER_160_35 VPWR VGND sg13cmos5l_decap_8
XFILLER_224_91 VPWR VGND sg13cmos5l_decap_8
XFILLER_273_231 VPWR VGND sg13cmos5l_decap_8
XFILLER_37_56 VPWR VGND sg13cmos5l_decap_8
XFILLER_226_191 VPWR VGND sg13cmos5l_fill_1
XFILLER_241_161 VPWR VGND sg13cmos5l_decap_8
XFILLER_310_49 VPWR VGND sg13cmos5l_decap_8
XFILLER_53_77 VPWR VGND sg13cmos5l_decap_8
XFILLER_41_255 VPWR VGND sg13cmos5l_decap_8
XFILLER_169_77 VPWR VGND sg13cmos5l_decap_8
XFILLER_319_14 VPWR VGND sg13cmos5l_decap_8
XANTENNA__2034__X Tile_X0Y5_FrameData_O[19] VPWR VGND sg13cmos5l_antennanp
XFILLER_139_176 VPWR VGND sg13cmos5l_decap_8
XFILLER_185_21 VPWR VGND sg13cmos5l_decap_8
XFILLER_5_112 VPWR VGND sg13cmos5l_fill_1
XANTENNA__1873__X Tile_X0Y2_E2BEGb[7] VPWR VGND sg13cmos5l_antennanp
XFILLER_204_0 VPWR VGND sg13cmos5l_decap_8
XFILLER_185_98 VPWR VGND sg13cmos5l_decap_8
XFILLER_118_70 VPWR VGND sg13cmos5l_decap_8
XFILLER_335_35 VPWR VGND sg13cmos5l_decap_8
XFILLER_78_63 VPWR VGND sg13cmos5l_decap_8
XFILLER_68_119 VPWR VGND sg13cmos5l_decap_8
XFILLER_110_216 VPWR VGND sg13cmos5l_fill_2
XFILLER_311_165 VPWR VGND sg13cmos5l_fill_1
XFILLER_204_28 VPWR VGND sg13cmos5l_decap_8
XFILLER_209_103 VPWR VGND sg13cmos5l_decap_8
XFILLER_76_141 VPWR VGND sg13cmos5l_fill_1
XFILLER_134_91 VPWR VGND sg13cmos5l_decap_8
X_0130_ _0130_/Q Tile_X0Y0_FrameData[4] VGND VPWR Tile_X0Y5_FrameStrobe[1] latch
XFILLER_351_56 VPWR VGND sg13cmos5l_decap_8
XFILLER_224_128 VPWR VGND sg13cmos5l_decap_8
X_0061_ _2078_/A _2667_/X _2668_/X _1097_/Q VPWR VGND sg13cmos5l_mux2_1
XFILLER_94_95 VPWR VGND sg13cmos5l_fill_1
XFILLER_94_84 VPWR VGND sg13cmos5l_decap_8
XFILLER_91_133 VPWR VGND sg13cmos5l_decap_8
XFILLER_224_139 VPWR VGND sg13cmos5l_fill_2
XFILLER_220_49 VPWR VGND sg13cmos5l_decap_8
XFILLER_232_161 VPWR VGND sg13cmos5l_decap_8
XFILLER_177_227 VPWR VGND sg13cmos5l_decap_8
XFILLER_232_172 VPWR VGND sg13cmos5l_fill_2
XFILLER_177_238 VPWR VGND sg13cmos5l_fill_2
XFILLER_229_14 VPWR VGND sg13cmos5l_decap_8
X_2702_ _2702_/X _2680_/X Tile_X0Y5_N4END[7] _2679_/X _0025_/X _1080_/Q _1079_/Q VPWR
+ VGND sg13cmos5l_mux4_1
X_0963_ _0963_/Q Tile_X0Y3_FrameData[19] VGND VPWR Tile_X0Y5_FrameStrobe[5] latch
XFILLER_185_271 VPWR VGND sg13cmos5l_fill_2
X_0894_ _0894_/Q Tile_X0Y3_FrameData[24] VGND VPWR Tile_X0Y5_FrameStrobe[3] latch
XANTENNA__1783__X Tile_X0Y2_E2BEG[6] VPWR VGND sg13cmos5l_antennanp
X_2633_ _2633_/X Tile_X0Y4_WW4END[4] AXIL_S_SOC_WSTRB0 _2684_/X _2681_/X _1188_/Q
+ _1187_/Q VPWR VGND sg13cmos5l_mux4_1
XFILLER_160_105 VPWR VGND sg13cmos5l_decap_8
XFILLER_309_91 VPWR VGND sg13cmos5l_decap_8
X_2564_ _2564_/X _2572_/X _2571_/X Tile_X0Y3_W6END[3] _2564_/A3 _0792_/Q _1031_/Q
+ VPWR VGND sg13cmos5l_mux4_1
XFILLER_245_35 VPWR VGND sg13cmos5l_decap_8
XFILLER_299_161 VPWR VGND sg13cmos5l_decap_8
X_1515_ _2211_/A3 VPWR VGND sg13cmos5l_tielo
XFILLER_99_244 VPWR VGND sg13cmos5l_decap_8
XFILLER_302_154 VPWR VGND sg13cmos5l_decap_8
X_2495_ _2495_/X Tile_X0Y1_W2MID[4] Tile_X0Y1_W2END[4] Tile_X0Y1_W6END[11] _2376_/X
+ _0404_/Q _0403_/Q VPWR VGND sg13cmos5l_mux4_1
XFILLER_59_119 VPWR VGND sg13cmos5l_decap_8
XFILLER_101_238 VPWR VGND sg13cmos5l_decap_8
X_1446_ _1446_/Q Tile_X0Y5_FrameData[10] VGND VPWR Tile_X0Y5_FrameStrobe[5] latch
XFILLER_114_28 VPWR VGND sg13cmos5l_decap_8
X_1377_ _1377_/Q Tile_X0Y5_FrameData[15] VGND VPWR Tile_X0Y5_FrameStrobe[3] latch
XFILLER_255_231 VPWR VGND sg13cmos5l_fill_2
XFILLER_261_56 VPWR VGND sg13cmos5l_decap_8
X_0328_ _0328_/Q Tile_X0Y1_FrameData[14] VGND VPWR Tile_X0Y5_FrameStrobe[0] latch
XFILLER_82_133 VPWR VGND sg13cmos5l_decap_8
XANTENNA__2119__X AXIL_S_SOC_RDATA13 VPWR VGND sg13cmos5l_antennanp
X_0259_ _0259_/Q Tile_X0Y0_FrameData[3] VGND VPWR Tile_X0Y5_FrameStrobe[5] latch
XANTENNA__1958__X Tile_X0Y1_E2BEG[3] VPWR VGND sg13cmos5l_antennanp
XFILLER_130_49 VPWR VGND sg13cmos5l_decap_8
XFILLER_23_211 VPWR VGND sg13cmos5l_fill_1
XFILLER_168_205 VPWR VGND sg13cmos5l_decap_8
XFILLER_23_14 VPWR VGND sg13cmos5l_decap_8
XFILLER_139_14 VPWR VGND sg13cmos5l_decap_8
XFILLER_128_7 VPWR VGND sg13cmos5l_decap_8
XFILLER_286_64 VPWR VGND sg13cmos5l_decap_8
XANTENNA__1693__X Tile_X0Y0_EE4BEG[1] VPWR VGND sg13cmos5l_antennanp
XFILLER_136_157 VPWR VGND sg13cmos5l_fill_2
XFILLER_151_105 VPWR VGND sg13cmos5l_decap_8
XFILLER_219_91 VPWR VGND sg13cmos5l_decap_8
XFILLER_155_35 VPWR VGND sg13cmos5l_decap_8
XFILLER_305_49 VPWR VGND sg13cmos5l_decap_8
XFILLER_48_11 VPWR VGND sg13cmos5l_decap_8
XFILLER_246_220 VPWR VGND sg13cmos5l_fill_1
XFILLER_100_271 VPWR VGND sg13cmos5l_fill_2
XFILLER_171_56 VPWR VGND sg13cmos5l_decap_8
XFILLER_246_231 VPWR VGND sg13cmos5l_fill_2
XFILLER_48_88 VPWR VGND sg13cmos5l_decap_8
XFILLER_104_50 VPWR VGND sg13cmos5l_decap_8
XFILLER_206_117 VPWR VGND sg13cmos5l_decap_8
XFILLER_64_21 VPWR VGND sg13cmos5l_decap_8
XANTENNA__2029__X Tile_X0Y5_FrameData_O[14] VPWR VGND sg13cmos5l_antennanp
XFILLER_321_48 VPWR VGND sg13cmos5l_decap_8
XANTENNA__1868__X Tile_X0Y2_E2BEGb[2] VPWR VGND sg13cmos5l_antennanp
XFILLER_154_0 VPWR VGND sg13cmos5l_decap_8
XFILLER_64_98 VPWR VGND sg13cmos5l_decap_8
XFILLER_9_49 VPWR VGND sg13cmos5l_decap_8
XFILLER_80_42 VPWR VGND sg13cmos5l_decap_8
XFILLER_174_219 VPWR VGND sg13cmos5l_decap_8
XFILLER_196_42 VPWR VGND sg13cmos5l_decap_8
XFILLER_321_0 VPWR VGND sg13cmos5l_decap_8
XFILLER_127_124 VPWR VGND sg13cmos5l_fill_1
XFILLER_167_271 VPWR VGND sg13cmos5l_fill_2
XFILLER_13_91 VPWR VGND sg13cmos5l_decap_8
XFILLER_129_91 VPWR VGND sg13cmos5l_decap_8
XFILLER_331_216 VPWR VGND sg13cmos5l_fill_2
XFILLER_346_56 VPWR VGND sg13cmos5l_decap_8
XFILLER_96_203 VPWR VGND sg13cmos5l_decap_8
XFILLER_215_49 VPWR VGND sg13cmos5l_decap_8
X_2280_ _2280_/X _2480_/X _2479_/X _2472_/X _2471_/X _0766_/Q _0765_/Q VPWR VGND sg13cmos5l_mux4_1
X_1300_ _1300_/Q Tile_X0Y5_FrameData[28] VGND VPWR Tile_X0Y5_FrameStrobe[1] latch
XFILLER_296_175 VPWR VGND sg13cmos5l_decap_8
X_1231_ _1231_/Q Tile_X0Y4_FrameData[23] VGND VPWR Tile_X0Y5_FrameStrobe[6] latch
XFILLER_96_269 VPWR VGND sg13cmos5l_decap_4
XFILLER_96_247 VPWR VGND sg13cmos5l_decap_8
XFILLER_362_77 VPWR VGND sg13cmos5l_fill_2
XFILLER_237_231 VPWR VGND sg13cmos5l_decap_4
X_1162_ _1162_/Q Tile_X0Y4_FrameData[28] VGND VPWR Tile_X0Y5_FrameStrobe[4] latch
XFILLER_64_133 VPWR VGND sg13cmos5l_decap_8
XFILLER_49_196 VPWR VGND sg13cmos5l_decap_8
X_1093_ _1093_/Q Tile_X0Y4_FrameData[1] VGND VPWR Tile_X0Y5_FrameStrobe[1] latch
X_0113_ _0113_/Q Tile_X0Y0_FrameData[21] VGND VPWR Tile_X0Y5_FrameStrobe[1] latch
XFILLER_212_109 VPWR VGND sg13cmos5l_decap_8
XFILLER_311_70 VPWR VGND sg13cmos5l_decap_8
X_0044_ _1604_/A _2287_/X _2288_/X _1004_/Q VPWR VGND sg13cmos5l_mux2_1
XANTENNA__1778__X Tile_X0Y2_E2BEG[1] VPWR VGND sg13cmos5l_antennanp
XFILLER_220_153 VPWR VGND sg13cmos5l_decap_8
X_1995_ Tile_X0Y5_E6BEG[8] _2765_/X VPWR VGND sg13cmos5l_buf_1
XFILLER_158_260 VPWR VGND sg13cmos5l_decap_8
XFILLER_158_271 VPWR VGND sg13cmos5l_fill_2
X_0946_ _0946_/Q Tile_X0Y3_FrameData[4] VGND VPWR Tile_X0Y5_FrameStrobe[4] latch
XFILLER_109_28 VPWR VGND sg13cmos5l_decap_8
XFILLER_173_241 VPWR VGND sg13cmos5l_decap_4
XFILLER_118_168 VPWR VGND sg13cmos5l_decap_8
XFILLER_256_56 VPWR VGND sg13cmos5l_decap_8
X_2616_ _2616_/X _2680_/X _2679_/X AXIL_S_SOC_WSTRB1 AXIL_S_SOC_WVALID _1222_/Q _1221_/Q
+ VPWR VGND sg13cmos5l_mux4_1
X_0877_ _0877_/Q Tile_X0Y3_FrameData[9] VGND VPWR Tile_X0Y5_FrameStrobe[2] latch
X_2547_ _2547_/X AXIL_S_SOC_ARADDR6 _2585_/X _2578_/X _2591_/X _0910_/Q _0909_/Q VPWR
+ VGND sg13cmos5l_mux4_1
XFILLER_125_49 VPWR VGND sg13cmos5l_decap_8
XFILLER_141_160 VPWR VGND sg13cmos5l_decap_8
X_2478_ _2478_/X _2460_/X Tile_X0Y5_N4END[13] _2459_/X Tile_X0Y0_S4END[9] _0604_/Q
+ _0603_/Q VPWR VGND sg13cmos5l_mux4_1
XFILLER_87_214 VPWR VGND sg13cmos5l_decap_8
XFILLER_272_77 VPWR VGND sg13cmos5l_decap_8
X_1429_ _1429_/Q Tile_X0Y5_FrameData[27] VGND VPWR Tile_X0Y5_FrameStrobe[5] latch
XFILLER_18_14 VPWR VGND sg13cmos5l_decap_8
XFILLER_228_220 VPWR VGND sg13cmos5l_decap_8
XFILLER_55_133 VPWR VGND sg13cmos5l_decap_8
XANTENNA__1688__X Tile_X0Y0_FrameData_O[28] VPWR VGND sg13cmos5l_antennanp
XFILLER_221_70 VPWR VGND sg13cmos5l_decap_8
XFILLER_70_147 VPWR VGND sg13cmos5l_decap_8
XFILLER_34_35 VPWR VGND sg13cmos5l_decap_8
XFILLER_211_142 VPWR VGND sg13cmos5l_decap_8
XFILLER_245_7 VPWR VGND sg13cmos5l_decap_8
XFILLER_297_63 VPWR VGND sg13cmos5l_decap_8
XFILLER_357_168 VPWR VGND sg13cmos5l_decap_8
XFILLER_211_186 VPWR VGND sg13cmos5l_decap_4
XFILLER_50_56 VPWR VGND sg13cmos5l_decap_8
XFILLER_124_105 VPWR VGND sg13cmos5l_decap_8
XFILLER_166_56 VPWR VGND sg13cmos5l_decap_8
XFILLER_124_127 VPWR VGND sg13cmos5l_decap_4
XFILLER_124_138 VPWR VGND sg13cmos5l_decap_8
XFILLER_313_227 VPWR VGND sg13cmos5l_fill_2
XFILLER_59_21 VPWR VGND sg13cmos5l_decap_8
XFILLER_182_77 VPWR VGND sg13cmos5l_decap_8
XFILLER_293_112 VPWR VGND sg13cmos5l_decap_8
XFILLER_332_14 VPWR VGND sg13cmos5l_decap_8
XFILLER_59_98 VPWR VGND sg13cmos5l_decap_8
XFILLER_219_242 VPWR VGND sg13cmos5l_fill_2
XFILLER_293_145 VPWR VGND sg13cmos5l_decap_8
XFILLER_271_0 VPWR VGND sg13cmos5l_decap_8
XFILLER_75_42 VPWR VGND sg13cmos5l_decap_8
XFILLER_234_245 VPWR VGND sg13cmos5l_fill_1
XANTENNA__1598__X Tile_X0Y2_EE4BEG[11] VPWR VGND sg13cmos5l_antennanp
XFILLER_131_70 VPWR VGND sg13cmos5l_decap_8
XFILLER_61_147 VPWR VGND sg13cmos5l_decap_8
XFILLER_202_142 VPWR VGND sg13cmos5l_fill_1
XFILLER_91_63 VPWR VGND sg13cmos5l_decap_8
X_1780_ Tile_X0Y2_E2BEG[3] _2404_/X VPWR VGND sg13cmos5l_buf_1
X_0800_ _0800_/Q Tile_X0Y3_FrameData[22] VGND VPWR Tile_X0Y5_FrameStrobe[0] latch
XFILLER_348_168 VPWR VGND sg13cmos5l_decap_8
X_0731_ _0731_/Q Tile_X0Y2_FrameData[11] VGND VPWR Tile_X0Y5_FrameStrobe[5] latch
XFILLER_357_77 VPWR VGND sg13cmos5l_decap_8
XFILLER_115_105 VPWR VGND sg13cmos5l_decap_8
XFILLER_226_15 VPWR VGND sg13cmos5l_decap_8
X_0662_ _0662_/Q Tile_X0Y2_FrameData[16] VGND VPWR Tile_X0Y5_FrameStrobe[3] latch
XFILLER_170_244 VPWR VGND sg13cmos5l_decap_4
X_2401_ _2401_/X AXIL_S_SOC_AWADDR0 AXIL_S_SOC_AWADDR8 _2481_/X _2488_/X _0746_/Q
+ _0745_/Q VPWR VGND sg13cmos5l_mux4_1
X_0593_ _0593_/Q Tile_X0Y2_FrameData[21] VGND VPWR Tile_X0Y5_FrameStrobe[1] latch
XFILLER_312_271 VPWR VGND sg13cmos5l_fill_2
X_2332_ _2332_/X AXIL_S_SOC_WDATA7 _2371_/X _2362_/X _2376_/X _0428_/Q _0427_/Q VPWR
+ VGND sg13cmos5l_mux4_1
XFILLER_69_214 VPWR VGND sg13cmos5l_fill_2
XFILLER_284_112 VPWR VGND sg13cmos5l_decap_8
XFILLER_306_70 VPWR VGND sg13cmos5l_decap_8
XFILLER_242_14 VPWR VGND sg13cmos5l_decap_8
X_2263_ _2263_/X Tile_X0Y2_W2MID[0] Tile_X0Y2_W2END[0] Tile_X0Y2_W6END[0] _2488_/X
+ _0768_/Q _0767_/Q VPWR VGND sg13cmos5l_mux4_1
XFILLER_84_217 VPWR VGND sg13cmos5l_decap_8
X_2194_ _2194_/X AXIL_S_SOC_WDATA17 AXIL_S_SOC_WDATA29 _2236_/X _2243_/X _0208_/Q
+ _0207_/Q VPWR VGND sg13cmos5l_mux4_1
X_1214_ _1214_/Q Tile_X0Y4_FrameData[8] VGND VPWR Tile_X0Y5_FrameStrobe[5] latch
XFILLER_37_133 VPWR VGND sg13cmos5l_decap_4
X_1145_ _1145_/Q Tile_X0Y4_FrameData[13] VGND VPWR Tile_X0Y5_FrameStrobe[3] latch
XFILLER_322_91 VPWR VGND sg13cmos5l_decap_8
XFILLER_92_272 VPWR VGND sg13cmos5l_fill_1
XFILLER_37_188 VPWR VGND sg13cmos5l_decap_8
X_1076_ _1076_/Q Tile_X0Y4_FrameData[18] VGND VPWR Tile_X0Y5_FrameStrobe[1] latch
XFILLER_52_147 VPWR VGND sg13cmos5l_decap_8
XFILLER_240_248 VPWR VGND sg13cmos5l_decap_8
X_0027_ _2080_/A _2783_/X _2784_/X _1335_/Q VPWR VGND sg13cmos5l_mux2_1
XFILLER_339_135 VPWR VGND sg13cmos5l_fill_2
XFILLER_354_105 VPWR VGND sg13cmos5l_decap_8
XFILLER_267_77 VPWR VGND sg13cmos5l_decap_8
X_1978_ Tile_X0Y5_E2BEG[7] _2732_/X VPWR VGND sg13cmos5l_buf_1
XFILLER_106_105 VPWR VGND sg13cmos5l_decap_8
XFILLER_161_200 VPWR VGND sg13cmos5l_decap_4
X_0929_ _0929_/Q Tile_X0Y3_FrameData[21] VGND VPWR Tile_X0Y5_FrameStrobe[4] latch
XANTENNA__2132__X AXIL_S_SOC_RDATA26 VPWR VGND sg13cmos5l_antennanp
XFILLER_161_233 VPWR VGND sg13cmos5l_decap_8
XFILLER_283_21 VPWR VGND sg13cmos5l_decap_8
XFILLER_362_171 VPWR VGND sg13cmos5l_decap_8
XANTENNA__1971__X Tile_X0Y5_E2BEG[0] VPWR VGND sg13cmos5l_antennanp
XFILLER_106_149 VPWR VGND sg13cmos5l_fill_1
XFILLER_121_119 VPWR VGND sg13cmos5l_decap_8
XFILLER_283_98 VPWR VGND sg13cmos5l_decap_8
XFILLER_303_260 VPWR VGND sg13cmos5l_fill_2
XFILLER_114_193 VPWR VGND sg13cmos5l_decap_4
XFILLER_216_70 VPWR VGND sg13cmos5l_decap_8
XFILLER_29_35 VPWR VGND sg13cmos5l_decap_8
XFILLER_152_14 VPWR VGND sg13cmos5l_decap_8
XFILLER_195_7 VPWR VGND sg13cmos5l_decap_8
XFILLER_28_144 VPWR VGND sg13cmos5l_fill_1
XFILLER_290_126 VPWR VGND sg13cmos5l_decap_8
XFILLER_302_28 VPWR VGND sg13cmos5l_decap_8
XFILLER_90_209 VPWR VGND sg13cmos5l_decap_8
XFILLER_362_7 VPWR VGND sg13cmos5l_decap_8
XFILLER_232_91 VPWR VGND sg13cmos5l_decap_8
XFILLER_28_199 VPWR VGND sg13cmos5l_fill_1
XFILLER_83_272 VPWR VGND sg13cmos5l_fill_1
XFILLER_45_56 VPWR VGND sg13cmos5l_decap_8
XFILLER_188_119 VPWR VGND sg13cmos5l_decap_8
XFILLER_43_147 VPWR VGND sg13cmos5l_decap_8
XFILLER_101_84 VPWR VGND sg13cmos5l_decap_8
XFILLER_129_219 VPWR VGND sg13cmos5l_fill_1
XFILLER_61_77 VPWR VGND sg13cmos5l_decap_8
XFILLER_345_105 VPWR VGND sg13cmos5l_decap_8
XFILLER_137_230 VPWR VGND sg13cmos5l_fill_1
XFILLER_177_77 VPWR VGND sg13cmos5l_decap_8
XFILLER_117_0 VPWR VGND sg13cmos5l_decap_8
XFILLER_137_263 VPWR VGND sg13cmos5l_fill_2
XFILLER_327_14 VPWR VGND sg13cmos5l_decap_8
XFILLER_6_28 VPWR VGND sg13cmos5l_decap_8
XANTENNA__2042__X Tile_X0Y5_FrameData_O[27] VPWR VGND sg13cmos5l_antennanp
XFILLER_152_200 VPWR VGND sg13cmos5l_decap_8
XFILLER_152_222 VPWR VGND sg13cmos5l_decap_8
XFILLER_193_21 VPWR VGND sg13cmos5l_decap_8
XFILLER_353_182 VPWR VGND sg13cmos5l_decap_8
XFILLER_3_232 VPWR VGND sg13cmos5l_fill_1
XANTENNA__1881__X Tile_X0Y2_E6BEG[7] VPWR VGND sg13cmos5l_antennanp
XFILLER_10_70 VPWR VGND sg13cmos5l_decap_8
XFILLER_112_119 VPWR VGND sg13cmos5l_decap_8
XFILLER_193_98 VPWR VGND sg13cmos5l_decap_8
XFILLER_105_182 VPWR VGND sg13cmos5l_fill_2
XFILLER_126_70 VPWR VGND sg13cmos5l_decap_8
XFILLER_266_112 VPWR VGND sg13cmos5l_decap_8
XFILLER_343_35 VPWR VGND sg13cmos5l_decap_8
XFILLER_86_63 VPWR VGND sg13cmos5l_decap_8
XFILLER_19_133 VPWR VGND sg13cmos5l_decap_8
XFILLER_212_28 VPWR VGND sg13cmos5l_decap_8
XFILLER_281_126 VPWR VGND sg13cmos5l_decap_8
XFILLER_142_91 VPWR VGND sg13cmos5l_decap_8
XFILLER_179_119 VPWR VGND sg13cmos5l_decap_8
XFILLER_222_215 VPWR VGND sg13cmos5l_decap_8
X_1901_ Tile_X0Y1_FrameData_O[14] Tile_X0Y1_FrameData[14] VPWR VGND sg13cmos5l_buf_1
XFILLER_187_163 VPWR VGND sg13cmos5l_decap_4
XFILLER_336_105 VPWR VGND sg13cmos5l_fill_2
X_1832_ Tile_X0Y4_EE4BEG[15] _2648_/X VPWR VGND sg13cmos5l_buf_1
XFILLER_128_230 VPWR VGND sg13cmos5l_decap_8
XFILLER_336_149 VPWR VGND sg13cmos5l_decap_4
XFILLER_128_252 VPWR VGND sg13cmos5l_decap_8
XFILLER_237_14 VPWR VGND sg13cmos5l_decap_8
X_1763_ Tile_X0Y2_FrameData_O[23] Tile_X0Y2_FrameData[23] VPWR VGND sg13cmos5l_buf_1
X_1694_ Tile_X0Y0_EE4BEG[2] _2183_/X VPWR VGND sg13cmos5l_buf_1
X_0714_ _0714_/Q Tile_X0Y2_FrameData[28] VGND VPWR Tile_X0Y5_FrameStrobe[5] latch
XFILLER_351_119 VPWR VGND sg13cmos5l_decap_8
X_0645_ _0645_/Q Tile_X0Y2_FrameData[1] VGND VPWR Tile_X0Y5_FrameStrobe[2] latch
XANTENNA__1791__X Tile_X0Y4_E2BEG[2] VPWR VGND sg13cmos5l_antennanp
XFILLER_317_91 VPWR VGND sg13cmos5l_decap_8
XFILLER_253_35 VPWR VGND sg13cmos5l_decap_8
XFILLER_257_112 VPWR VGND sg13cmos5l_decap_8
XFILLER_32_0 VPWR VGND sg13cmos5l_decap_8
X_0576_ _0576_/Q Tile_X0Y2_FrameData[6] VGND VPWR Tile_X0Y5_FrameStrobe[0] latch
X_2315_ _2315_/X AXIL_S_SOC_WDATA6 AXIL_S_SOC_WDATA10 _2358_/X _2374_/X _0462_/Q _0461_/Q
+ VPWR VGND sg13cmos5l_mux4_1
X_2246_ _2246_/X _2260_/X _2259_/X Tile_X0Y0_S2MID[5] Tile_X0Y0_S2END[5] _0084_/Q
+ _0083_/Q VPWR VGND sg13cmos5l_mux4_1
XFILLER_122_28 VPWR VGND sg13cmos5l_decap_8
XFILLER_272_148 VPWR VGND sg13cmos5l_decap_4
X_2177_ _2177_/X AXIL_S_SOC_WDATA20 AXIL_S_SOC_WDATA28 _2244_/X _2245_/X _0242_/Q
+ _0241_/Q VPWR VGND sg13cmos5l_mux4_1
XFILLER_65_272 VPWR VGND sg13cmos5l_fill_1
XFILLER_213_204 VPWR VGND sg13cmos5l_fill_2
XFILLER_280_181 VPWR VGND sg13cmos5l_fill_1
X_1128_ _1128_/Q Tile_X0Y4_FrameData[30] VGND VPWR Tile_X0Y5_FrameStrobe[3] latch
XANTENNA__2127__X AXIL_S_SOC_RDATA21 VPWR VGND sg13cmos5l_antennanp
X_1059_ _1059_/Q Tile_X0Y4_FrameData[3] VGND VPWR Tile_X0Y5_FrameStrobe[0] latch
XFILLER_278_21 VPWR VGND sg13cmos5l_decap_8
XANTENNA__1966__X Tile_X0Y1_E1BEG[3] VPWR VGND sg13cmos5l_antennanp
XFILLER_327_105 VPWR VGND sg13cmos5l_decap_8
XFILLER_193_122 VPWR VGND sg13cmos5l_fill_1
XFILLER_193_144 VPWR VGND sg13cmos5l_fill_2
XFILLER_278_98 VPWR VGND sg13cmos5l_fill_2
XFILLER_31_14 VPWR VGND sg13cmos5l_decap_8
XFILLER_147_14 VPWR VGND sg13cmos5l_decap_8
XFILLER_110_7 VPWR VGND sg13cmos5l_decap_8
XFILLER_208_7 VPWR VGND sg13cmos5l_decap_8
XFILLER_294_42 VPWR VGND sg13cmos5l_decap_8
XFILLER_335_171 VPWR VGND sg13cmos5l_fill_1
XFILLER_335_193 VPWR VGND sg13cmos5l_fill_2
XFILLER_227_91 VPWR VGND sg13cmos5l_decap_8
XFILLER_350_163 VPWR VGND sg13cmos5l_decap_8
XFILLER_163_35 VPWR VGND sg13cmos5l_decap_8
XFILLER_248_112 VPWR VGND sg13cmos5l_decap_4
XFILLER_248_145 VPWR VGND sg13cmos5l_fill_2
XFILLER_313_49 VPWR VGND sg13cmos5l_decap_8
XFILLER_48_228 VPWR VGND sg13cmos5l_decap_8
XFILLER_263_137 VPWR VGND sg13cmos5l_fill_1
XFILLER_263_148 VPWR VGND sg13cmos5l_decap_8
XFILLER_56_77 VPWR VGND sg13cmos5l_decap_8
XFILLER_56_272 VPWR VGND sg13cmos5l_fill_1
XFILLER_204_226 VPWR VGND sg13cmos5l_decap_8
XANTENNA__2037__X Tile_X0Y5_FrameData_O[22] VPWR VGND sg13cmos5l_antennanp
XFILLER_16_169 VPWR VGND sg13cmos5l_fill_2
XFILLER_271_192 VPWR VGND sg13cmos5l_decap_8
XFILLER_72_21 VPWR VGND sg13cmos5l_decap_8
XFILLER_188_21 VPWR VGND sg13cmos5l_decap_8
XANTENNA__1876__X Tile_X0Y2_E6BEG[2] VPWR VGND sg13cmos5l_antennanp
XFILLER_169_185 VPWR VGND sg13cmos5l_fill_2
XFILLER_234_0 VPWR VGND sg13cmos5l_decap_8
XFILLER_318_105 VPWR VGND sg13cmos5l_decap_8
XFILLER_72_98 VPWR VGND sg13cmos5l_decap_8
XFILLER_184_133 VPWR VGND sg13cmos5l_fill_2
XFILLER_188_98 VPWR VGND sg13cmos5l_decap_8
XFILLER_338_35 VPWR VGND sg13cmos5l_decap_8
XFILLER_184_188 VPWR VGND sg13cmos5l_decap_8
XFILLER_207_28 VPWR VGND sg13cmos5l_decap_8
XFILLER_21_91 VPWR VGND sg13cmos5l_decap_8
XFILLER_137_91 VPWR VGND sg13cmos5l_fill_1
XFILLER_140_214 VPWR VGND sg13cmos5l_decap_8
XFILLER_354_56 VPWR VGND sg13cmos5l_decap_8
X_0430_ _0430_/Q Tile_X0Y1_FrameData[8] VGND VPWR Tile_X0Y5_FrameStrobe[3] latch
XFILLER_341_185 VPWR VGND sg13cmos5l_fill_2
XFILLER_239_112 VPWR VGND sg13cmos5l_decap_8
X_0361_ _0361_/Q Tile_X0Y1_FrameData[13] VGND VPWR Tile_X0Y5_FrameStrobe[1] latch
XFILLER_97_84 VPWR VGND sg13cmos5l_decap_8
XFILLER_39_206 VPWR VGND sg13cmos5l_fill_1
XFILLER_294_240 VPWR VGND sg13cmos5l_decap_4
X_2100_ AXIL_S_SOC_AWREADY Tile_X0Y4_W2MID[0] Tile_X0Y4_W2END[0] Tile_X0Y4_W6END[0]
+ _2708_/X _1096_/Q _1095_/Q VPWR VGND sg13cmos5l_mux4_1
XFILLER_223_49 VPWR VGND sg13cmos5l_decap_8
XFILLER_239_189 VPWR VGND sg13cmos5l_decap_8
XFILLER_254_126 VPWR VGND sg13cmos5l_decap_8
X_2031_ Tile_X0Y5_FrameData_O[16] Tile_X0Y5_FrameData[16] VPWR VGND sg13cmos5l_buf_1
X_0292_ _0292_/Q Tile_X0Y0_FrameData[2] VGND VPWR Tile_X0Y5_FrameStrobe[6] latch
XFILLER_62_242 VPWR VGND sg13cmos5l_decap_4
XFILLER_62_253 VPWR VGND sg13cmos5l_fill_2
XFILLER_210_207 VPWR VGND sg13cmos5l_decap_8
XANTENNA__1786__X Tile_X0Y4_E1BEG[1] VPWR VGND sg13cmos5l_antennanp
XFILLER_309_105 VPWR VGND sg13cmos5l_decap_8
XFILLER_175_133 VPWR VGND sg13cmos5l_decap_8
XFILLER_248_35 VPWR VGND sg13cmos5l_decap_8
XFILLER_30_161 VPWR VGND sg13cmos5l_decap_8
X_1815_ Tile_X0Y4_E6BEG[10] _2659_/X VPWR VGND sg13cmos5l_buf_1
X_2795_ _2795_/X Tile_X0Y4_W1END[2] Tile_X0Y4_W6END[10] _2688_/X _2671_/X _1128_/Q
+ _1127_/Q VPWR VGND sg13cmos5l_mux4_1
XFILLER_324_119 VPWR VGND sg13cmos5l_decap_8
X_1746_ Tile_X0Y2_FrameData_O[6] Tile_X0Y2_FrameData[6] VPWR VGND sg13cmos5l_buf_1
XFILLER_7_93 VPWR VGND sg13cmos5l_fill_1
XFILLER_117_28 VPWR VGND sg13cmos5l_decap_8
XFILLER_264_56 VPWR VGND sg13cmos5l_decap_8
X_1677_ Tile_X0Y0_FrameData_O[17] Tile_X0Y0_FrameData[17] VPWR VGND sg13cmos5l_buf_1
XFILLER_89_128 VPWR VGND sg13cmos5l_decap_8
XFILLER_89_106 VPWR VGND sg13cmos5l_fill_1
X_0628_ _0628_/Q Tile_X0Y2_FrameData[18] VGND VPWR Tile_X0Y5_FrameStrobe[2] latch
X_0559_ _0559_/Q Tile_X0Y2_FrameData[23] VGND VPWR Tile_X0Y5_FrameStrobe[0] latch
XFILLER_285_251 VPWR VGND sg13cmos5l_decap_4
XFILLER_133_49 VPWR VGND sg13cmos5l_decap_8
XFILLER_245_126 VPWR VGND sg13cmos5l_decap_8
XFILLER_280_77 VPWR VGND sg13cmos5l_decap_8
XFILLER_26_14 VPWR VGND sg13cmos5l_decap_8
X_2229_ _2229_/X _2213_/X _0049_/X Tile_X0Y0_S1END[0] Tile_X0Y0_S4END[0] _0102_/Q
+ _0101_/Q VPWR VGND sg13cmos5l_mux4_1
XANTENNA_208 _2493_/X VPWR VGND sg13cmos5l_antennanp
XANTENNA_219 Tile_X0Y5_FrameStrobe[19] VPWR VGND sg13cmos5l_antennanp
XFILLER_165_8 VPWR VGND sg13cmos5l_decap_8
XFILLER_53_231 VPWR VGND sg13cmos5l_decap_8
XFILLER_289_42 VPWR VGND sg13cmos5l_decap_8
XFILLER_158_7 VPWR VGND sg13cmos5l_decap_8
XANTENNA__1696__X Tile_X0Y0_EE4BEG[4] VPWR VGND sg13cmos5l_antennanp
XFILLER_42_24 VPWR VGND sg13cmos5l_decap_8
XFILLER_158_35 VPWR VGND sg13cmos5l_decap_8
XFILLER_325_7 VPWR VGND sg13cmos5l_decap_8
XFILLER_166_188 VPWR VGND sg13cmos5l_fill_1
XFILLER_315_119 VPWR VGND sg13cmos5l_decap_8
XFILLER_107_233 VPWR VGND sg13cmos5l_decap_8
XFILLER_181_147 VPWR VGND sg13cmos5l_decap_8
XFILLER_308_49 VPWR VGND sg13cmos5l_decap_8
XFILLER_174_56 VPWR VGND sg13cmos5l_decap_8
XFILLER_67_21 VPWR VGND sg13cmos5l_decap_8
XFILLER_184_0 VPWR VGND sg13cmos5l_decap_8
XFILLER_190_77 VPWR VGND sg13cmos5l_decap_8
XFILLER_236_126 VPWR VGND sg13cmos5l_decap_8
XFILLER_67_98 VPWR VGND sg13cmos5l_decap_8
XFILLER_29_272 VPWR VGND sg13cmos5l_fill_1
XFILLER_340_14 VPWR VGND sg13cmos5l_decap_8
XFILLER_83_42 VPWR VGND sg13cmos5l_decap_8
XFILLER_199_42 VPWR VGND sg13cmos5l_decap_8
XFILLER_44_264 VPWR VGND sg13cmos5l_fill_1
XFILLER_351_0 VPWR VGND sg13cmos5l_decap_8
XFILLER_16_91 VPWR VGND sg13cmos5l_decap_8
XFILLER_349_56 VPWR VGND sg13cmos5l_decap_8
XFILLER_73_7 VPWR VGND sg13cmos5l_decap_8
XFILLER_306_119 VPWR VGND sg13cmos5l_decap_8
X_1600_ Tile_X0Y2_EE4BEG[13] _2430_/X VPWR VGND sg13cmos5l_buf_1
XFILLER_172_147 VPWR VGND sg13cmos5l_decap_8
XFILLER_218_49 VPWR VGND sg13cmos5l_decap_8
X_2580_ _2580_/X _2566_/X Tile_X0Y5_N4END[8] _2565_/X Tile_X0Y0_S4END[12] _0830_/Q
+ _0829_/Q VPWR VGND sg13cmos5l_mux4_1
XFILLER_361_258 VPWR VGND sg13cmos5l_fill_2
XFILLER_113_214 VPWR VGND sg13cmos5l_decap_8
X_1531_ Tile_X0Y3_E6BEG[5] _2546_/X VPWR VGND sg13cmos5l_buf_1
XFILLER_259_218 VPWR VGND sg13cmos5l_fill_1
X_1462_ _1462_/Q Tile_X0Y5_FrameData[26] VGND VPWR Tile_X0Y5_FrameStrobe[6] latch
X_0413_ _0413_/Q Tile_X0Y1_FrameData[25] VGND VPWR Tile_X0Y5_FrameStrobe[3] latch
X_1393_ _1393_/Q Tile_X0Y5_FrameData[31] VGND VPWR Tile_X0Y5_FrameStrobe[4] latch
XFILLER_79_194 VPWR VGND sg13cmos5l_decap_8
XFILLER_314_70 VPWR VGND sg13cmos5l_decap_8
X_0344_ _0344_/Q Tile_X0Y1_FrameData[30] VGND VPWR Tile_X0Y5_FrameStrobe[1] latch
XFILLER_227_159 VPWR VGND sg13cmos5l_decap_8
XFILLER_250_14 VPWR VGND sg13cmos5l_decap_8
X_0275_ _0275_/Q Tile_X0Y0_FrameData[19] VGND VPWR Tile_X0Y5_FrameStrobe[6] latch
X_2014_ Tile_X0Y5_EE4BEG[15] _2756_/X VPWR VGND sg13cmos5l_buf_1
XFILLER_94_197 VPWR VGND sg13cmos5l_decap_8
XFILLER_330_91 VPWR VGND sg13cmos5l_decap_8
XFILLER_50_212 VPWR VGND sg13cmos5l_decap_8
XFILLER_259_56 VPWR VGND sg13cmos5l_decap_8
XFILLER_148_144 VPWR VGND sg13cmos5l_fill_2
XFILLER_12_49 VPWR VGND sg13cmos5l_decap_8
XFILLER_148_177 VPWR VGND sg13cmos5l_decap_8
XFILLER_352_203 VPWR VGND sg13cmos5l_decap_8
XFILLER_128_49 VPWR VGND sg13cmos5l_decap_8
X_2778_ _2778_/X Tile_X0Y5_W1END[1] Tile_X0Y5_W2MID[2] Tile_X0Y5_W2END[2] _2799_/X
+ _1346_/Q _1345_/Q VPWR VGND sg13cmos5l_mux4_1
XFILLER_104_203 VPWR VGND sg13cmos5l_fill_2
XFILLER_275_77 VPWR VGND sg13cmos5l_decap_8
X_1729_ Tile_X0Y0_E2BEG[1] _2166_/X VPWR VGND sg13cmos5l_buf_1
XANTENNA__2140__X AXIL_S_SOC_RVALID VPWR VGND sg13cmos5l_antennanp
XFILLER_291_21 VPWR VGND sg13cmos5l_decap_8
XFILLER_224_70 VPWR VGND sg13cmos5l_decap_8
XFILLER_291_98 VPWR VGND sg13cmos5l_decap_8
XFILLER_160_14 VPWR VGND sg13cmos5l_decap_8
XFILLER_275_7 VPWR VGND sg13cmos5l_decap_8
XFILLER_37_35 VPWR VGND sg13cmos5l_decap_8
XFILLER_310_28 VPWR VGND sg13cmos5l_decap_8
XFILLER_240_91 VPWR VGND sg13cmos5l_decap_8
XFILLER_241_140 VPWR VGND sg13cmos5l_decap_8
XFILLER_53_56 VPWR VGND sg13cmos5l_decap_8
XFILLER_139_100 VPWR VGND sg13cmos5l_decap_4
XFILLER_169_56 VPWR VGND sg13cmos5l_decap_8
XFILLER_186_239 VPWR VGND sg13cmos5l_decap_8
XFILLER_328_222 VPWR VGND sg13cmos5l_fill_1
XFILLER_139_133 VPWR VGND sg13cmos5l_decap_8
XFILLER_194_272 VPWR VGND sg13cmos5l_fill_1
XFILLER_154_147 VPWR VGND sg13cmos5l_decap_8
XFILLER_185_77 VPWR VGND sg13cmos5l_decap_8
XFILLER_335_14 VPWR VGND sg13cmos5l_decap_8
XANTENNA__2050__X Tile_X0Y5_S1BEG[3] VPWR VGND sg13cmos5l_antennanp
XFILLER_162_191 VPWR VGND sg13cmos5l_fill_2
XFILLER_78_42 VPWR VGND sg13cmos5l_decap_8
XFILLER_134_70 VPWR VGND sg13cmos5l_decap_8
XFILLER_351_35 VPWR VGND sg13cmos5l_decap_8
XFILLER_209_159 VPWR VGND sg13cmos5l_decap_8
XFILLER_94_63 VPWR VGND sg13cmos5l_decap_8
X_0060_ _2077_/A _2665_/X _2666_/X _1100_/Q VPWR VGND sg13cmos5l_mux2_1
XFILLER_76_197 VPWR VGND sg13cmos5l_decap_8
XFILLER_220_28 VPWR VGND sg13cmos5l_decap_8
XFILLER_232_140 VPWR VGND sg13cmos5l_decap_8
XFILLER_177_206 VPWR VGND sg13cmos5l_decap_8
XFILLER_232_184 VPWR VGND sg13cmos5l_fill_1
XFILLER_32_234 VPWR VGND sg13cmos5l_fill_1
X_0962_ _0962_/Q Tile_X0Y3_FrameData[20] VGND VPWR Tile_X0Y5_FrameStrobe[5] latch
X_2701_ _2701_/X _2678_/X Tile_X0Y5_N4END[6] _2677_/X _0024_/X _1074_/Q _1073_/Q VPWR
+ VGND sg13cmos5l_mux4_1
X_0893_ _0893_/Q Tile_X0Y3_FrameData[25] VGND VPWR Tile_X0Y5_FrameStrobe[3] latch
XFILLER_309_70 VPWR VGND sg13cmos5l_decap_8
X_2632_ _2632_/X AXIL_S_SOC_WSTRB1 AXIL_S_SOC_WSTRB3 _2708_/X _2681_/X _1190_/Q _1189_/Q
+ VPWR VGND sg13cmos5l_mux4_1
XFILLER_145_169 VPWR VGND sg13cmos5l_decap_8
XFILLER_245_14 VPWR VGND sg13cmos5l_decap_8
XFILLER_299_140 VPWR VGND sg13cmos5l_decap_8
X_2563_ _2563_/X _2570_/X _2569_/X Tile_X0Y3_W6END[2] _2563_/A3 _0794_/Q _0793_/Q
+ VPWR VGND sg13cmos5l_mux4_1
X_1514_ _2210_/A3 VPWR VGND sg13cmos5l_tielo
XFILLER_99_212 VPWR VGND sg13cmos5l_decap_4
XFILLER_302_133 VPWR VGND sg13cmos5l_decap_8
X_2494_ _2494_/X Tile_X0Y4_W2MID[5] Tile_X0Y4_W2END[5] Tile_X0Y4_W6END[5] _2710_/X
+ _1252_/Q _1251_/Q VPWR VGND sg13cmos5l_mux4_1
XFILLER_325_91 VPWR VGND sg13cmos5l_decap_8
X_1445_ _1445_/Q Tile_X0Y5_FrameData[11] VGND VPWR Tile_X0Y5_FrameStrobe[5] latch
XFILLER_261_35 VPWR VGND sg13cmos5l_decap_8
X_1376_ _1376_/Q Tile_X0Y5_FrameData[16] VGND VPWR Tile_X0Y5_FrameStrobe[3] latch
X_0327_ _0327_/Q Tile_X0Y1_FrameData[15] VGND VPWR Tile_X0Y5_FrameStrobe[0] latch
XFILLER_215_118 VPWR VGND sg13cmos5l_decap_8
XFILLER_82_112 VPWR VGND sg13cmos5l_decap_8
XFILLER_208_181 VPWR VGND sg13cmos5l_decap_8
XFILLER_215_129 VPWR VGND sg13cmos5l_fill_1
X_0258_ _0258_/Q Tile_X0Y0_FrameData[4] VGND VPWR Tile_X0Y5_FrameStrobe[5] latch
XFILLER_130_28 VPWR VGND sg13cmos5l_decap_8
X_0189_ _0189_/Q Tile_X0Y0_FrameData[9] VGND VPWR Tile_X0Y5_FrameStrobe[3] latch
XANTENNA__2135__X AXIL_S_SOC_RDATA29 VPWR VGND sg13cmos5l_antennanp
XANTENNA__1974__X Tile_X0Y5_E2BEG[3] VPWR VGND sg13cmos5l_antennanp
XFILLER_176_272 VPWR VGND sg13cmos5l_fill_1
XFILLER_286_43 VPWR VGND sg13cmos5l_decap_8
XFILLER_219_70 VPWR VGND sg13cmos5l_decap_8
XFILLER_155_14 VPWR VGND sg13cmos5l_decap_8
XFILLER_340_206 VPWR VGND sg13cmos5l_decap_4
XFILLER_144_180 VPWR VGND sg13cmos5l_decap_8
XFILLER_2_105 VPWR VGND sg13cmos5l_decap_8
XFILLER_2_127 VPWR VGND sg13cmos5l_fill_1
XFILLER_2_138 VPWR VGND sg13cmos5l_fill_2
XFILLER_3_7 VPWR VGND sg13cmos5l_decap_8
XFILLER_305_28 VPWR VGND sg13cmos5l_decap_8
XFILLER_171_35 VPWR VGND sg13cmos5l_decap_8
XFILLER_235_91 VPWR VGND sg13cmos5l_decap_8
XFILLER_48_67 VPWR VGND sg13cmos5l_decap_8
XFILLER_58_175 VPWR VGND sg13cmos5l_decap_8
XFILLER_64_77 VPWR VGND sg13cmos5l_decap_8
XFILLER_14_234 VPWR VGND sg13cmos5l_fill_2
XANTENNA__2045__X Tile_X0Y5_FrameData_O[30] VPWR VGND sg13cmos5l_antennanp
XFILLER_147_0 VPWR VGND sg13cmos5l_decap_8
XFILLER_9_28 VPWR VGND sg13cmos5l_decap_8
XFILLER_80_21 VPWR VGND sg13cmos5l_decap_8
XFILLER_167_250 VPWR VGND sg13cmos5l_fill_2
XFILLER_196_21 VPWR VGND sg13cmos5l_decap_8
XANTENNA__1884__X Tile_X0Y2_E6BEG[10] VPWR VGND sg13cmos5l_antennanp
XFILLER_127_114 VPWR VGND sg13cmos5l_fill_1
XFILLER_314_0 VPWR VGND sg13cmos5l_decap_8
XFILLER_13_70 VPWR VGND sg13cmos5l_decap_8
XFILLER_196_98 VPWR VGND sg13cmos5l_decap_8
XFILLER_346_35 VPWR VGND sg13cmos5l_decap_8
XFILLER_129_70 VPWR VGND sg13cmos5l_decap_8
XFILLER_215_28 VPWR VGND sg13cmos5l_decap_8
XFILLER_296_154 VPWR VGND sg13cmos5l_decap_8
XFILLER_36_7 VPWR VGND sg13cmos5l_decap_8
XFILLER_145_91 VPWR VGND sg13cmos5l_decap_8
XFILLER_150_194 VPWR VGND sg13cmos5l_decap_8
XFILLER_237_210 VPWR VGND sg13cmos5l_decap_8
X_1230_ _1230_/Q Tile_X0Y4_FrameData[24] VGND VPWR Tile_X0Y5_FrameStrobe[6] latch
XFILLER_362_56 VPWR VGND sg13cmos5l_decap_8
X_1161_ _1161_/Q Tile_X0Y4_FrameData[29] VGND VPWR Tile_X0Y5_FrameStrobe[4] latch
XFILLER_49_175 VPWR VGND sg13cmos5l_decap_8
X_0112_ _0112_/Q Tile_X0Y0_FrameData[22] VGND VPWR Tile_X0Y5_FrameStrobe[1] latch
XFILLER_64_112 VPWR VGND sg13cmos5l_decap_8
XFILLER_231_49 VPWR VGND sg13cmos5l_decap_8
X_1092_ _1092_/Q Tile_X0Y4_FrameData[2] VGND VPWR Tile_X0Y5_FrameStrobe[1] latch
X_0043_ _1611_/A _2273_/X _2274_/X _0755_/Q VPWR VGND sg13cmos5l_mux2_1
XFILLER_220_132 VPWR VGND sg13cmos5l_decap_8
X_1994_ Tile_X0Y5_E6BEG[7] _2764_/X VPWR VGND sg13cmos5l_buf_1
XANTENNA__1794__X Tile_X0Y4_E2BEG[5] VPWR VGND sg13cmos5l_antennanp
X_0945_ _0945_/Q Tile_X0Y3_FrameData[5] VGND VPWR Tile_X0Y5_FrameStrobe[4] latch
XFILLER_118_147 VPWR VGND sg13cmos5l_decap_8
XFILLER_173_220 VPWR VGND sg13cmos5l_decap_8
X_0876_ _0876_/Q Tile_X0Y3_FrameData[10] VGND VPWR Tile_X0Y5_FrameStrobe[2] latch
XFILLER_9_271 VPWR VGND sg13cmos5l_fill_2
XFILLER_256_35 VPWR VGND sg13cmos5l_decap_8
X_2615_ _2615_/X _2678_/X _2677_/X AXIL_S_SOC_WSTRB0 AXIL_S_SOC_BREADY _1224_/Q _1223_/Q
+ VPWR VGND sg13cmos5l_mux4_1
XFILLER_62_0 VPWR VGND sg13cmos5l_decap_8
XFILLER_133_139 VPWR VGND sg13cmos5l_fill_2
XFILLER_322_239 VPWR VGND sg13cmos5l_fill_2
XFILLER_126_191 VPWR VGND sg13cmos5l_fill_1
X_2546_ _2546_/X AXIL_S_SOC_ARADDR5 _2582_/X _2576_/X _2590_/X _0912_/Q _0911_/Q VPWR
+ VGND sg13cmos5l_mux4_1
XFILLER_125_28 VPWR VGND sg13cmos5l_decap_8
X_2477_ _2477_/X _2460_/X Tile_X0Y5_N4END[13] _2459_/X Tile_X0Y0_S4END[9] _0596_/Q
+ _0595_/Q VPWR VGND sg13cmos5l_mux4_1
XFILLER_272_56 VPWR VGND sg13cmos5l_decap_8
X_1428_ _1428_/Q Tile_X0Y5_FrameData[28] VGND VPWR Tile_X0Y5_FrameStrobe[5] latch
XFILLER_87_237 VPWR VGND sg13cmos5l_fill_1
XFILLER_228_254 VPWR VGND sg13cmos5l_decap_8
X_1359_ _1359_/Q Tile_X0Y5_FrameData[1] VGND VPWR Tile_X0Y5_FrameStrobe[2] latch
XFILLER_55_112 VPWR VGND sg13cmos5l_decap_8
XANTENNA__1969__X Tile_X0Y5_E1BEG[2] VPWR VGND sg13cmos5l_antennanp
XFILLER_141_49 VPWR VGND sg13cmos5l_decap_8
XFILLER_70_126 VPWR VGND sg13cmos5l_decap_8
XFILLER_55_189 VPWR VGND sg13cmos5l_decap_8
XFILLER_221_93 VPWR VGND sg13cmos5l_fill_1
XFILLER_34_14 VPWR VGND sg13cmos5l_decap_8
XFILLER_140_7 VPWR VGND sg13cmos5l_decap_8
XFILLER_297_42 VPWR VGND sg13cmos5l_decap_8
XFILLER_238_7 VPWR VGND sg13cmos5l_decap_8
XFILLER_357_147 VPWR VGND sg13cmos5l_decap_8
XFILLER_149_261 VPWR VGND sg13cmos5l_fill_1
XFILLER_109_147 VPWR VGND sg13cmos5l_decap_8
XFILLER_50_35 VPWR VGND sg13cmos5l_decap_8
XFILLER_166_35 VPWR VGND sg13cmos5l_decap_8
XFILLER_316_49 VPWR VGND sg13cmos5l_decap_8
XFILLER_78_226 VPWR VGND sg13cmos5l_decap_4
XFILLER_59_77 VPWR VGND sg13cmos5l_decap_8
XFILLER_132_194 VPWR VGND sg13cmos5l_decap_8
XFILLER_182_56 VPWR VGND sg13cmos5l_decap_8
XFILLER_278_198 VPWR VGND sg13cmos5l_decap_8
XFILLER_78_237 VPWR VGND sg13cmos5l_decap_4
XFILLER_219_221 VPWR VGND sg13cmos5l_decap_8
XFILLER_75_21 VPWR VGND sg13cmos5l_decap_8
XANTENNA__1879__X Tile_X0Y2_E6BEG[5] VPWR VGND sg13cmos5l_antennanp
XFILLER_234_224 VPWR VGND sg13cmos5l_decap_8
XFILLER_75_98 VPWR VGND sg13cmos5l_decap_4
XFILLER_264_0 VPWR VGND sg13cmos5l_decap_8
XFILLER_61_126 VPWR VGND sg13cmos5l_decap_8
XFILLER_46_189 VPWR VGND sg13cmos5l_decap_8
XFILLER_91_42 VPWR VGND sg13cmos5l_decap_8
XFILLER_348_147 VPWR VGND sg13cmos5l_decap_8
XFILLER_202_187 VPWR VGND sg13cmos5l_decap_8
XFILLER_24_91 VPWR VGND sg13cmos5l_decap_8
X_0730_ _0730_/Q Tile_X0Y2_FrameData[12] VGND VPWR Tile_X0Y5_FrameStrobe[5] latch
XFILLER_357_56 VPWR VGND sg13cmos5l_decap_8
XFILLER_170_212 VPWR VGND sg13cmos5l_decap_8
X_2400_ _2400_/X _2464_/X _2463_/X AXIL_S_SOC_AWADDR1 AXIL_S_SOC_AWADDR4 _0748_/Q
+ _0747_/Q VPWR VGND sg13cmos5l_mux4_1
X_0661_ _0661_/Q Tile_X0Y2_FrameData[17] VGND VPWR Tile_X0Y5_FrameStrobe[3] latch
X_0592_ _0592_/Q Tile_X0Y2_FrameData[22] VGND VPWR Tile_X0Y5_FrameStrobe[1] latch
XFILLER_123_161 VPWR VGND sg13cmos5l_decap_8
XFILLER_269_132 VPWR VGND sg13cmos5l_decap_4
X_2331_ _2331_/X AXIL_S_SOC_WDATA6 _2369_/X _2358_/X _2375_/X _0430_/Q _0429_/Q VPWR
+ VGND sg13cmos5l_mux4_1
X_2262_ _2262_/X Tile_X0Y1_W2MID[1] Tile_X0Y1_W2END[1] Tile_X0Y1_W6END[1] _2379_/X
+ _0530_/Q _0529_/Q VPWR VGND sg13cmos5l_mux4_1
X_1213_ _1213_/Q Tile_X0Y4_FrameData[9] VGND VPWR Tile_X0Y5_FrameStrobe[5] latch
X_2193_ _2193_/X AXIL_S_SOC_WDATA16 AXIL_S_SOC_WDATA28 _2235_/X _2244_/X _0210_/Q
+ _0209_/Q VPWR VGND sg13cmos5l_mux4_1
XFILLER_37_112 VPWR VGND sg13cmos5l_decap_8
XFILLER_225_235 VPWR VGND sg13cmos5l_decap_8
XFILLER_322_70 VPWR VGND sg13cmos5l_decap_8
X_1144_ _1144_/Q Tile_X0Y4_FrameData[14] VGND VPWR Tile_X0Y5_FrameStrobe[3] latch
XANTENNA__1789__X Tile_X0Y4_E2BEG[0] VPWR VGND sg13cmos5l_antennanp
XFILLER_1_84 VPWR VGND sg13cmos5l_decap_8
XFILLER_225_257 VPWR VGND sg13cmos5l_decap_8
X_1075_ _1075_/Q Tile_X0Y4_FrameData[19] VGND VPWR Tile_X0Y5_FrameStrobe[1] latch
X_0026_ _1612_/A _2271_/X _2272_/X _0524_/Q VPWR VGND sg13cmos5l_mux2_1
XFILLER_52_126 VPWR VGND sg13cmos5l_decap_8
XFILLER_339_158 VPWR VGND sg13cmos5l_decap_4
XFILLER_267_56 VPWR VGND sg13cmos5l_decap_8
X_1977_ Tile_X0Y5_E2BEG[6] _2731_/X VPWR VGND sg13cmos5l_buf_1
X_0928_ _0928_/Q Tile_X0Y3_FrameData[22] VGND VPWR Tile_X0Y5_FrameStrobe[4] latch
XFILLER_362_150 VPWR VGND sg13cmos5l_decap_8
XFILLER_161_212 VPWR VGND sg13cmos5l_decap_8
XFILLER_20_49 VPWR VGND sg13cmos5l_decap_8
X_0859_ _0859_/Q Tile_X0Y3_FrameData[27] VGND VPWR Tile_X0Y5_FrameStrobe[2] latch
XFILLER_136_49 VPWR VGND sg13cmos5l_decap_8
XFILLER_114_161 VPWR VGND sg13cmos5l_decap_8
XFILLER_114_172 VPWR VGND sg13cmos5l_decap_8
XFILLER_283_77 VPWR VGND sg13cmos5l_decap_8
X_2529_ _2529_/X AXIL_S_SOC_ARADDR4 AXIL_S_SOC_ARADDR8 _2574_/X _2592_/X _0946_/Q
+ _0945_/Q VPWR VGND sg13cmos5l_mux4_1
XFILLER_275_102 VPWR VGND sg13cmos5l_fill_1
XFILLER_29_14 VPWR VGND sg13cmos5l_decap_8
XFILLER_188_7 VPWR VGND sg13cmos5l_decap_8
XFILLER_290_105 VPWR VGND sg13cmos5l_decap_8
XFILLER_216_202 VPWR VGND sg13cmos5l_fill_1
XFILLER_216_235 VPWR VGND sg13cmos5l_decap_4
XFILLER_232_70 VPWR VGND sg13cmos5l_decap_8
XANTENNA__1699__X Tile_X0Y0_EE4BEG[7] VPWR VGND sg13cmos5l_antennanp
XFILLER_45_35 VPWR VGND sg13cmos5l_decap_8
XFILLER_355_7 VPWR VGND sg13cmos5l_decap_8
XFILLER_43_126 VPWR VGND sg13cmos5l_decap_8
XFILLER_101_63 VPWR VGND sg13cmos5l_decap_8
XFILLER_196_175 VPWR VGND sg13cmos5l_fill_1
XFILLER_61_56 VPWR VGND sg13cmos5l_decap_8
XFILLER_177_56 VPWR VGND sg13cmos5l_decap_8
XFILLER_298_216 VPWR VGND sg13cmos5l_decap_4
XFILLER_353_161 VPWR VGND sg13cmos5l_decap_8
XFILLER_105_161 VPWR VGND sg13cmos5l_decap_8
XFILLER_193_77 VPWR VGND sg13cmos5l_decap_8
XFILLER_343_14 VPWR VGND sg13cmos5l_decap_8
XFILLER_86_42 VPWR VGND sg13cmos5l_decap_8
XFILLER_66_218 VPWR VGND sg13cmos5l_decap_4
XFILLER_120_175 VPWR VGND sg13cmos5l_decap_8
XFILLER_120_186 VPWR VGND sg13cmos5l_fill_1
XFILLER_19_112 VPWR VGND sg13cmos5l_decap_8
XFILLER_266_168 VPWR VGND sg13cmos5l_decap_4
XFILLER_266_179 VPWR VGND sg13cmos5l_decap_8
XFILLER_281_105 VPWR VGND sg13cmos5l_decap_8
XFILLER_19_156 VPWR VGND sg13cmos5l_decap_8
XFILLER_19_91 VPWR VGND sg13cmos5l_decap_8
XFILLER_142_70 VPWR VGND sg13cmos5l_decap_8
XFILLER_19_167 VPWR VGND sg13cmos5l_fill_2
XFILLER_207_235 VPWR VGND sg13cmos5l_decap_8
XFILLER_34_159 VPWR VGND sg13cmos5l_decap_4
X_1900_ Tile_X0Y1_FrameData_O[13] Tile_X0Y1_FrameData[13] VPWR VGND sg13cmos5l_buf_1
XFILLER_187_175 VPWR VGND sg13cmos5l_decap_8
XFILLER_230_271 VPWR VGND sg13cmos5l_fill_2
X_1831_ Tile_X0Y4_EE4BEG[14] _2647_/X VPWR VGND sg13cmos5l_buf_1
XFILLER_336_128 VPWR VGND sg13cmos5l_decap_8
X_1762_ Tile_X0Y2_FrameData_O[22] Tile_X0Y2_FrameData[22] VPWR VGND sg13cmos5l_buf_1
X_1693_ Tile_X0Y0_EE4BEG[1] _2182_/X VPWR VGND sg13cmos5l_buf_1
X_0713_ _0713_/Q Tile_X0Y2_FrameData[29] VGND VPWR Tile_X0Y5_FrameStrobe[5] latch
XFILLER_143_234 VPWR VGND sg13cmos5l_fill_1
XFILLER_289_227 VPWR VGND sg13cmos5l_decap_8
XFILLER_289_238 VPWR VGND sg13cmos5l_fill_1
X_0644_ _0644_/Q Tile_X0Y2_FrameData[2] VGND VPWR Tile_X0Y5_FrameStrobe[2] latch
XFILLER_103_109 VPWR VGND sg13cmos5l_fill_2
XFILLER_253_14 VPWR VGND sg13cmos5l_decap_8
XFILLER_317_70 VPWR VGND sg13cmos5l_decap_8
X_0575_ _0575_/Q Tile_X0Y2_FrameData[7] VGND VPWR Tile_X0Y5_FrameStrobe[0] latch
XFILLER_25_0 VPWR VGND sg13cmos5l_decap_8
XFILLER_300_242 VPWR VGND sg13cmos5l_fill_1
XFILLER_300_253 VPWR VGND sg13cmos5l_fill_2
X_2314_ _2314_/X AXIL_S_SOC_WDATA5 AXIL_S_SOC_WDATA9 _2354_/X _2375_/X _0464_/Q _0463_/Q
+ VPWR VGND sg13cmos5l_mux4_1
XFILLER_57_207 VPWR VGND sg13cmos5l_fill_1
XFILLER_257_168 VPWR VGND sg13cmos5l_decap_8
X_2245_ _2245_/X _2258_/X _2257_/X Tile_X0Y0_S2MID[4] Tile_X0Y0_S2END[4] _0086_/Q
+ _0085_/Q VPWR VGND sg13cmos5l_mux4_1
XFILLER_333_91 VPWR VGND sg13cmos5l_decap_4
X_2176_ _2176_/X AXIL_S_SOC_WDATA19 AXIL_S_SOC_WDATA27 _2244_/X _2245_/X _0244_/Q
+ _0243_/Q VPWR VGND sg13cmos5l_mux4_1
X_1127_ _1127_/Q Tile_X0Y4_FrameData[31] VGND VPWR Tile_X0Y5_FrameStrobe[3] latch
XFILLER_80_232 VPWR VGND sg13cmos5l_fill_1
XFILLER_80_210 VPWR VGND sg13cmos5l_fill_1
XFILLER_202_84 VPWR VGND sg13cmos5l_decap_8
XFILLER_280_193 VPWR VGND sg13cmos5l_decap_8
X_1058_ _1058_/Q Tile_X0Y4_FrameData[4] VGND VPWR Tile_X0Y5_FrameStrobe[0] latch
XFILLER_15_49 VPWR VGND sg13cmos5l_decap_8
XFILLER_178_175 VPWR VGND sg13cmos5l_decap_8
XFILLER_221_271 VPWR VGND sg13cmos5l_fill_2
XFILLER_278_77 VPWR VGND sg13cmos5l_decap_8
XFILLER_178_186 VPWR VGND sg13cmos5l_fill_2
XFILLER_327_139 VPWR VGND sg13cmos5l_decap_4
XFILLER_294_21 VPWR VGND sg13cmos5l_decap_8
XANTENNA__1982__X Tile_X0Y5_E2BEGb[3] VPWR VGND sg13cmos5l_antennanp
XFILLER_335_161 VPWR VGND sg13cmos5l_fill_1
XFILLER_103_7 VPWR VGND sg13cmos5l_decap_8
XFILLER_134_234 VPWR VGND sg13cmos5l_decap_4
XFILLER_294_98 VPWR VGND sg13cmos5l_decap_8
XFILLER_227_70 VPWR VGND sg13cmos5l_decap_8
XFILLER_350_142 VPWR VGND sg13cmos5l_decap_8
XFILLER_163_14 VPWR VGND sg13cmos5l_decap_8
XFILLER_288_271 VPWR VGND sg13cmos5l_fill_2
XFILLER_48_207 VPWR VGND sg13cmos5l_decap_8
XFILLER_248_157 VPWR VGND sg13cmos5l_fill_2
XFILLER_263_105 VPWR VGND sg13cmos5l_decap_4
XFILLER_313_28 VPWR VGND sg13cmos5l_decap_8
XFILLER_243_91 VPWR VGND sg13cmos5l_decap_8
XFILLER_56_56 VPWR VGND sg13cmos5l_decap_8
XFILLER_16_126 VPWR VGND sg13cmos5l_decap_8
XFILLER_271_160 VPWR VGND sg13cmos5l_decap_4
XFILLER_112_84 VPWR VGND sg13cmos5l_decap_8
XFILLER_24_170 VPWR VGND sg13cmos5l_fill_1
XFILLER_72_77 VPWR VGND sg13cmos5l_decap_8
XFILLER_169_164 VPWR VGND sg13cmos5l_decap_8
XFILLER_188_77 VPWR VGND sg13cmos5l_decap_8
XFILLER_24_192 VPWR VGND sg13cmos5l_decap_4
XFILLER_184_112 VPWR VGND sg13cmos5l_decap_8
XFILLER_227_0 VPWR VGND sg13cmos5l_decap_8
XFILLER_338_14 VPWR VGND sg13cmos5l_decap_8
XANTENNA__2053__X Tile_X0Y5_S2BEG[2] VPWR VGND sg13cmos5l_antennanp
XANTENNA__1892__X Tile_X0Y1_FrameData_O[5] VPWR VGND sg13cmos5l_antennanp
XFILLER_21_70 VPWR VGND sg13cmos5l_decap_8
XFILLER_137_70 VPWR VGND sg13cmos5l_decap_8
XFILLER_98_107 VPWR VGND sg13cmos5l_fill_1
XFILLER_354_35 VPWR VGND sg13cmos5l_decap_8
XFILLER_97_63 VPWR VGND sg13cmos5l_decap_8
X_0360_ _0360_/Q Tile_X0Y1_FrameData[14] VGND VPWR Tile_X0Y5_FrameStrobe[1] latch
XFILLER_223_28 VPWR VGND sg13cmos5l_decap_8
XFILLER_239_168 VPWR VGND sg13cmos5l_decap_8
X_0291_ _0291_/Q Tile_X0Y0_FrameData[3] VGND VPWR Tile_X0Y5_FrameStrobe[6] latch
XFILLER_153_91 VPWR VGND sg13cmos5l_fill_2
XFILLER_254_105 VPWR VGND sg13cmos5l_decap_8
X_2030_ Tile_X0Y5_FrameData_O[15] Tile_X0Y5_FrameData[15] VPWR VGND sg13cmos5l_buf_1
XFILLER_62_210 VPWR VGND sg13cmos5l_decap_8
XFILLER_349_242 VPWR VGND sg13cmos5l_decap_8
XFILLER_175_112 VPWR VGND sg13cmos5l_decap_8
XFILLER_248_14 VPWR VGND sg13cmos5l_decap_8
X_1814_ Tile_X0Y4_E6BEG[9] _2658_/X VPWR VGND sg13cmos5l_buf_1
X_2794_ _2794_/X Tile_X0Y4_W1END[1] Tile_X0Y4_W6END[9] _2692_/X _2670_/X _1130_/Q
+ _1129_/Q VPWR VGND sg13cmos5l_mux4_1
XFILLER_175_189 VPWR VGND sg13cmos5l_decap_8
X_1745_ Tile_X0Y2_FrameData_O[5] Tile_X0Y2_FrameData[5] VPWR VGND sg13cmos5l_buf_1
XFILLER_116_234 VPWR VGND sg13cmos5l_decap_4
XFILLER_328_91 VPWR VGND sg13cmos5l_fill_2
XFILLER_264_35 VPWR VGND sg13cmos5l_decap_8
X_1676_ Tile_X0Y0_FrameData_O[16] Tile_X0Y0_FrameData[16] VPWR VGND sg13cmos5l_buf_1
X_0627_ _0627_/Q Tile_X0Y2_FrameData[19] VGND VPWR Tile_X0Y5_FrameStrobe[2] latch
XFILLER_285_230 VPWR VGND sg13cmos5l_decap_8
X_0558_ _0558_/Q Tile_X0Y2_FrameData[24] VGND VPWR Tile_X0Y5_FrameStrobe[0] latch
XFILLER_97_151 VPWR VGND sg13cmos5l_fill_2
XFILLER_97_140 VPWR VGND sg13cmos5l_decap_4
XFILLER_133_28 VPWR VGND sg13cmos5l_decap_8
XFILLER_245_105 VPWR VGND sg13cmos5l_decap_8
XFILLER_280_56 VPWR VGND sg13cmos5l_decap_8
X_0489_ _0489_/Q Tile_X0Y1_FrameData[13] VGND VPWR Tile_X0Y5_FrameStrobe[5] latch
X_2228_ _2228_/X _2701_/X _2689_/X _2688_/X _2710_/X _1234_/Q _1233_/Q VPWR VGND sg13cmos5l_mux4_1
XFILLER_38_240 VPWR VGND sg13cmos5l_fill_2
XANTENNA_209 Tile_X0Y5_FrameStrobe[10] VPWR VGND sg13cmos5l_antennanp
XANTENNA__2138__X AXIL_S_SOC_RRESP0 VPWR VGND sg13cmos5l_antennanp
XFILLER_260_119 VPWR VGND sg13cmos5l_decap_8
X_2159_ _2159_/X Tile_X0Y0_W1END[3] Tile_X0Y0_WW4END[3] Tile_X0Y0_WW4END[7] Tile_X0Y0_W6END[11]
+ _0277_/Q _0276_/Q VPWR VGND sg13cmos5l_mux4_1
XFILLER_53_210 VPWR VGND sg13cmos5l_decap_8
XFILLER_289_21 VPWR VGND sg13cmos5l_decap_8
XANTENNA__1977__X Tile_X0Y5_E2BEG[6] VPWR VGND sg13cmos5l_antennanp
XFILLER_289_98 VPWR VGND sg13cmos5l_decap_8
XFILLER_158_14 VPWR VGND sg13cmos5l_decap_8
XFILLER_220_7 VPWR VGND sg13cmos5l_decap_8
XFILLER_318_7 VPWR VGND sg13cmos5l_decap_8
XFILLER_355_245 VPWR VGND sg13cmos5l_decap_8
XFILLER_107_212 VPWR VGND sg13cmos5l_decap_8
XFILLER_181_126 VPWR VGND sg13cmos5l_decap_8
XFILLER_308_161 VPWR VGND sg13cmos5l_decap_8
XFILLER_308_28 VPWR VGND sg13cmos5l_decap_8
XFILLER_238_91 VPWR VGND sg13cmos5l_decap_8
XFILLER_308_172 VPWR VGND sg13cmos5l_fill_2
XFILLER_107_256 VPWR VGND sg13cmos5l_fill_1
XFILLER_174_35 VPWR VGND sg13cmos5l_decap_8
XFILLER_122_226 VPWR VGND sg13cmos5l_fill_2
XFILLER_107_84 VPWR VGND sg13cmos5l_decap_8
XFILLER_324_49 VPWR VGND sg13cmos5l_decap_8
XFILLER_190_56 VPWR VGND sg13cmos5l_decap_8
XFILLER_236_105 VPWR VGND sg13cmos5l_decap_8
XFILLER_88_195 VPWR VGND sg13cmos5l_decap_8
XFILLER_67_77 VPWR VGND sg13cmos5l_decap_8
XANTENNA__2048__X Tile_X0Y5_S1BEG[1] VPWR VGND sg13cmos5l_antennanp
XFILLER_177_0 VPWR VGND sg13cmos5l_decap_8
XFILLER_251_119 VPWR VGND sg13cmos5l_decap_8
XFILLER_83_21 VPWR VGND sg13cmos5l_decap_8
XFILLER_199_21 VPWR VGND sg13cmos5l_decap_8
XFILLER_244_182 VPWR VGND sg13cmos5l_decap_8
XFILLER_44_254 VPWR VGND sg13cmos5l_fill_2
XANTENNA__1887__X Tile_X0Y1_FrameData_O[0] VPWR VGND sg13cmos5l_antennanp
XFILLER_16_70 VPWR VGND sg13cmos5l_decap_8
XFILLER_83_98 VPWR VGND sg13cmos5l_decap_8
XFILLER_344_0 VPWR VGND sg13cmos5l_decap_8
XFILLER_349_35 VPWR VGND sg13cmos5l_decap_8
XFILLER_12_140 VPWR VGND sg13cmos5l_decap_8
XFILLER_157_112 VPWR VGND sg13cmos5l_decap_4
XFILLER_157_145 VPWR VGND sg13cmos5l_decap_4
XFILLER_157_156 VPWR VGND sg13cmos5l_decap_8
XFILLER_346_234 VPWR VGND sg13cmos5l_decap_8
XFILLER_218_28 VPWR VGND sg13cmos5l_decap_8
XFILLER_32_91 VPWR VGND sg13cmos5l_decap_8
XFILLER_8_155 VPWR VGND sg13cmos5l_decap_8
XFILLER_66_7 VPWR VGND sg13cmos5l_decap_8
XFILLER_148_91 VPWR VGND sg13cmos5l_decap_8
X_1530_ Tile_X0Y3_E6BEG[4] _2545_/X VPWR VGND sg13cmos5l_buf_1
X_1461_ _1461_/Q Tile_X0Y5_FrameData[27] VGND VPWR Tile_X0Y5_FrameStrobe[6] latch
XFILLER_113_248 VPWR VGND sg13cmos5l_decap_8
XFILLER_234_49 VPWR VGND sg13cmos5l_decap_8
X_1392_ _1392_/Q Tile_X0Y5_FrameData[0] VGND VPWR Tile_X0Y5_FrameStrobe[3] latch
X_0412_ _0412_/Q Tile_X0Y1_FrameData[26] VGND VPWR Tile_X0Y5_FrameStrobe[3] latch
XFILLER_79_140 VPWR VGND sg13cmos5l_fill_2
X_0343_ _0343_/Q Tile_X0Y1_FrameData[31] VGND VPWR Tile_X0Y5_FrameStrobe[1] latch
XFILLER_94_110 VPWR VGND sg13cmos5l_fill_2
XFILLER_227_105 VPWR VGND sg13cmos5l_decap_8
X_0274_ _0274_/Q Tile_X0Y0_FrameData[20] VGND VPWR Tile_X0Y5_FrameStrobe[6] latch
XFILLER_94_176 VPWR VGND sg13cmos5l_decap_8
XFILLER_242_119 VPWR VGND sg13cmos5l_decap_8
X_2013_ Tile_X0Y5_EE4BEG[14] _2755_/X VPWR VGND sg13cmos5l_buf_1
XANTENNA__1797__X Tile_X0Y4_E2BEGb[0] VPWR VGND sg13cmos5l_antennanp
XFILLER_330_70 VPWR VGND sg13cmos5l_decap_8
XFILLER_195_218 VPWR VGND sg13cmos5l_fill_2
XFILLER_259_35 VPWR VGND sg13cmos5l_decap_8
XFILLER_92_0 VPWR VGND sg13cmos5l_decap_8
XFILLER_148_112 VPWR VGND sg13cmos5l_decap_4
XFILLER_148_123 VPWR VGND sg13cmos5l_decap_8
XFILLER_337_256 VPWR VGND sg13cmos5l_fill_1
XFILLER_128_28 VPWR VGND sg13cmos5l_decap_8
XFILLER_12_28 VPWR VGND sg13cmos5l_decap_8
XFILLER_148_167 VPWR VGND sg13cmos5l_fill_2
XFILLER_163_126 VPWR VGND sg13cmos5l_decap_8
XFILLER_337_267 VPWR VGND sg13cmos5l_fill_1
XFILLER_275_56 VPWR VGND sg13cmos5l_decap_8
X_2777_ _2777_/X Tile_X0Y5_W1END[0] Tile_X0Y5_W2MID[3] Tile_X0Y5_W2END[3] _2800_/X
+ _1348_/Q _1347_/Q VPWR VGND sg13cmos5l_mux4_1
X_1728_ Tile_X0Y0_E2BEG[0] _2165_/X VPWR VGND sg13cmos5l_buf_1
XFILLER_352_259 VPWR VGND sg13cmos5l_fill_2
XFILLER_305_175 VPWR VGND sg13cmos5l_decap_8
XFILLER_320_112 VPWR VGND sg13cmos5l_decap_4
X_1659_ Tile_X0Y0_FrameStrobe_O[19] Tile_X0Y5_FrameStrobe[19] VPWR VGND sg13cmos5l_buf_1
XFILLER_144_49 VPWR VGND sg13cmos5l_decap_8
XFILLER_291_77 VPWR VGND sg13cmos5l_decap_8
XFILLER_37_14 VPWR VGND sg13cmos5l_decap_8
XFILLER_273_222 VPWR VGND sg13cmos5l_fill_2
XFILLER_170_7 VPWR VGND sg13cmos5l_decap_8
XFILLER_233_119 VPWR VGND sg13cmos5l_decap_8
XFILLER_26_221 VPWR VGND sg13cmos5l_fill_2
XFILLER_268_7 VPWR VGND sg13cmos5l_decap_8
XFILLER_240_70 VPWR VGND sg13cmos5l_decap_8
XFILLER_53_35 VPWR VGND sg13cmos5l_decap_8
XFILLER_169_35 VPWR VGND sg13cmos5l_decap_8
XFILLER_241_196 VPWR VGND sg13cmos5l_decap_8
XFILLER_319_49 VPWR VGND sg13cmos5l_decap_8
XFILLER_343_215 VPWR VGND sg13cmos5l_fill_2
XFILLER_343_204 VPWR VGND sg13cmos5l_decap_8
XFILLER_154_126 VPWR VGND sg13cmos5l_decap_8
XFILLER_185_56 VPWR VGND sg13cmos5l_decap_8
XFILLER_343_248 VPWR VGND sg13cmos5l_decap_4
XFILLER_311_112 VPWR VGND sg13cmos5l_decap_8
XFILLER_78_21 VPWR VGND sg13cmos5l_decap_8
XFILLER_110_218 VPWR VGND sg13cmos5l_fill_1
XFILLER_294_0 VPWR VGND sg13cmos5l_decap_8
XFILLER_311_156 VPWR VGND sg13cmos5l_decap_8
XFILLER_78_98 VPWR VGND sg13cmos5l_decap_8
XFILLER_351_14 VPWR VGND sg13cmos5l_decap_8
XFILLER_209_138 VPWR VGND sg13cmos5l_decap_8
XFILLER_264_233 VPWR VGND sg13cmos5l_decap_4
XFILLER_94_42 VPWR VGND sg13cmos5l_decap_8
XFILLER_217_160 VPWR VGND sg13cmos5l_fill_1
XFILLER_217_193 VPWR VGND sg13cmos5l_fill_1
XFILLER_150_70 VPWR VGND sg13cmos5l_decap_8
XFILLER_150_81 VPWR VGND sg13cmos5l_fill_1
XFILLER_27_91 VPWR VGND sg13cmos5l_decap_8
XFILLER_300_84 VPWR VGND sg13cmos5l_decap_8
X_0961_ _0961_/Q Tile_X0Y3_FrameData[21] VGND VPWR Tile_X0Y5_FrameStrobe[5] latch
X_2700_ _2700_/X _2680_/X Tile_X0Y5_N4END[7] _2679_/X _0025_/X _1072_/Q _1071_/Q VPWR
+ VGND sg13cmos5l_mux4_1
XFILLER_229_49 VPWR VGND sg13cmos5l_decap_8
X_0892_ _0892_/Q Tile_X0Y3_FrameData[26] VGND VPWR Tile_X0Y5_FrameStrobe[3] latch
XFILLER_145_148 VPWR VGND sg13cmos5l_decap_8
X_2631_ _2631_/X AXIL_S_SOC_WSTRB0 AXIL_S_SOC_WSTRB2 _2709_/X _2682_/X _1192_/Q _1191_/Q
+ VPWR VGND sg13cmos5l_mux4_1
X_2562_ _2562_/X _2568_/X _2567_/X Tile_X0Y3_W6END[1] _2562_/A3 _0796_/Q _0795_/Q
+ VPWR VGND sg13cmos5l_mux4_1
XFILLER_302_112 VPWR VGND sg13cmos5l_decap_8
X_1513_ _2789_/A3 VPWR VGND sg13cmos5l_tielo
XFILLER_299_196 VPWR VGND sg13cmos5l_decap_8
X_2493_ _2493_/X Tile_X0Y1_W2MID[5] Tile_X0Y1_W2END[5] Tile_X0Y1_W6END[10] _2375_/X
+ _0406_/Q _0405_/Q VPWR VGND sg13cmos5l_mux4_1
XFILLER_99_268 VPWR VGND sg13cmos5l_decap_4
XFILLER_325_70 VPWR VGND sg13cmos5l_decap_8
X_1444_ _1444_/Q Tile_X0Y5_FrameData[12] VGND VPWR Tile_X0Y5_FrameStrobe[5] latch
XFILLER_4_84 VPWR VGND sg13cmos5l_decap_8
XFILLER_261_14 VPWR VGND sg13cmos5l_decap_8
XFILLER_302_189 VPWR VGND sg13cmos5l_decap_8
X_1375_ _1375_/Q Tile_X0Y5_FrameData[17] VGND VPWR Tile_X0Y5_FrameStrobe[3] latch
X_0326_ _0326_/Q Tile_X0Y1_FrameData[16] VGND VPWR Tile_X0Y5_FrameStrobe[0] latch
X_0257_ _0257_/Q Tile_X0Y0_FrameData[5] VGND VPWR Tile_X0Y5_FrameStrobe[5] latch
XFILLER_208_160 VPWR VGND sg13cmos5l_decap_8
XFILLER_341_91 VPWR VGND sg13cmos5l_decap_8
X_0188_ _0188_/Q Tile_X0Y0_FrameData[10] VGND VPWR Tile_X0Y5_FrameStrobe[3] latch
XFILLER_82_179 VPWR VGND sg13cmos5l_decap_8
XFILLER_23_49 VPWR VGND sg13cmos5l_decap_8
XFILLER_286_22 VPWR VGND sg13cmos5l_decap_8
XFILLER_139_49 VPWR VGND sg13cmos5l_decap_8
XFILLER_136_126 VPWR VGND sg13cmos5l_fill_2
XFILLER_286_99 VPWR VGND sg13cmos5l_decap_8
X_2829_ _2829_/X Tile_X0Y4_W2MID[7] Tile_X0Y4_W2END[7] Tile_X0Y4_W6END[8] _2708_/X
+ _1124_/Q _1123_/Q VPWR VGND sg13cmos5l_mux4_1
XFILLER_136_159 VPWR VGND sg13cmos5l_fill_1
XANTENNA__1990__X Tile_X0Y5_E6BEG[3] VPWR VGND sg13cmos5l_antennanp
XFILLER_235_70 VPWR VGND sg13cmos5l_decap_8
XFILLER_171_14 VPWR VGND sg13cmos5l_decap_8
XFILLER_246_200 VPWR VGND sg13cmos5l_decap_8
XFILLER_246_211 VPWR VGND sg13cmos5l_fill_2
XFILLER_48_46 VPWR VGND sg13cmos5l_decap_8
XFILLER_100_240 VPWR VGND sg13cmos5l_fill_2
XFILLER_246_233 VPWR VGND sg13cmos5l_fill_1
XFILLER_246_244 VPWR VGND sg13cmos5l_fill_2
XFILLER_58_154 VPWR VGND sg13cmos5l_decap_8
XFILLER_321_28 VPWR VGND sg13cmos5l_decap_8
XFILLER_73_135 VPWR VGND sg13cmos5l_decap_8
XFILLER_58_198 VPWR VGND sg13cmos5l_decap_8
XFILLER_104_85 VPWR VGND sg13cmos5l_decap_8
XFILLER_251_91 VPWR VGND sg13cmos5l_decap_8
XFILLER_73_146 VPWR VGND sg13cmos5l_fill_2
XFILLER_64_56 VPWR VGND sg13cmos5l_decap_8
XFILLER_120_84 VPWR VGND sg13cmos5l_decap_8
XFILLER_80_77 VPWR VGND sg13cmos5l_decap_8
XFILLER_196_77 VPWR VGND sg13cmos5l_decap_8
XFILLER_316_237 VPWR VGND sg13cmos5l_fill_1
XFILLER_346_14 VPWR VGND sg13cmos5l_decap_8
XANTENNA__2061__X Tile_X0Y5_S2BEGb[2] VPWR VGND sg13cmos5l_antennanp
XFILLER_307_0 VPWR VGND sg13cmos5l_decap_8
XFILLER_135_181 VPWR VGND sg13cmos5l_fill_1
XFILLER_89_64 VPWR VGND sg13cmos5l_decap_8
XFILLER_145_70 VPWR VGND sg13cmos5l_decap_8
XFILLER_150_173 VPWR VGND sg13cmos5l_decap_8
XFILLER_296_133 VPWR VGND sg13cmos5l_decap_8
XFILLER_362_35 VPWR VGND sg13cmos5l_decap_8
XFILLER_29_7 VPWR VGND sg13cmos5l_decap_8
XFILLER_237_244 VPWR VGND sg13cmos5l_decap_8
X_1160_ _1160_/Q Tile_X0Y4_FrameData[30] VGND VPWR Tile_X0Y5_FrameStrobe[4] latch
XFILLER_49_154 VPWR VGND sg13cmos5l_decap_8
XFILLER_231_28 VPWR VGND sg13cmos5l_decap_8
XFILLER_252_203 VPWR VGND sg13cmos5l_decap_8
X_0111_ _0111_/Q Tile_X0Y0_FrameData[23] VGND VPWR Tile_X0Y5_FrameStrobe[1] latch
XFILLER_161_91 VPWR VGND sg13cmos5l_decap_8
XFILLER_252_225 VPWR VGND sg13cmos5l_fill_2
X_1091_ _1091_/Q Tile_X0Y4_FrameData[3] VGND VPWR Tile_X0Y5_FrameStrobe[1] latch
XFILLER_205_141 VPWR VGND sg13cmos5l_decap_8
X_0042_ _2067_/A _2445_/X _2446_/X _0632_/Q VPWR VGND sg13cmos5l_mux2_1
XFILLER_64_179 VPWR VGND sg13cmos5l_decap_8
X_1993_ Tile_X0Y5_E6BEG[6] _2763_/X VPWR VGND sg13cmos5l_buf_1
XFILLER_220_199 VPWR VGND sg13cmos5l_decap_8
X_0944_ _0944_/Q Tile_X0Y3_FrameData[6] VGND VPWR Tile_X0Y5_FrameStrobe[4] latch
XFILLER_118_126 VPWR VGND sg13cmos5l_decap_8
XFILLER_256_14 VPWR VGND sg13cmos5l_decap_8
X_0875_ _0875_/Q Tile_X0Y3_FrameData[11] VGND VPWR Tile_X0Y5_FrameStrobe[2] latch
X_2614_ _2614_/X _2676_/X _2675_/X AXIL_S_SOC_WSTRB0 AXIL_S_SOC_WSTRB3 _1226_/Q _1225_/Q
+ VPWR VGND sg13cmos5l_mux4_1
XFILLER_55_0 VPWR VGND sg13cmos5l_decap_8
X_2545_ _2545_/X AXIL_S_SOC_ARADDR4 _2581_/X _2574_/X _2589_/X _0914_/Q _0913_/Q VPWR
+ VGND sg13cmos5l_mux4_1
XFILLER_336_91 VPWR VGND sg13cmos5l_decap_8
XFILLER_272_35 VPWR VGND sg13cmos5l_decap_8
XFILLER_287_133 VPWR VGND sg13cmos5l_decap_8
X_2476_ _2476_/X _2462_/X Tile_X0Y5_N4END[14] _2461_/X Tile_X0Y0_S4END[10] _0602_/Q
+ _0601_/Q VPWR VGND sg13cmos5l_mux4_1
XFILLER_87_205 VPWR VGND sg13cmos5l_fill_2
XFILLER_287_177 VPWR VGND sg13cmos5l_decap_4
X_1427_ _1427_/Q Tile_X0Y5_FrameData[29] VGND VPWR Tile_X0Y5_FrameStrobe[5] latch
XFILLER_141_28 VPWR VGND sg13cmos5l_decap_8
XFILLER_18_49 VPWR VGND sg13cmos5l_decap_8
X_1358_ _1358_/Q Tile_X0Y5_FrameData[2] VGND VPWR Tile_X0Y5_FrameStrobe[2] latch
XFILLER_243_214 VPWR VGND sg13cmos5l_fill_2
X_1289_ _1289_/Q Tile_X0Y5_FrameData[7] VGND VPWR Tile_X0Y5_FrameStrobe[0] latch
X_0309_ _0309_/Q Tile_X0Y0_FrameData[17] VGND VPWR Tile_X0Y5_FrameStrobe[7] latch
XFILLER_70_105 VPWR VGND sg13cmos5l_decap_8
XFILLER_55_168 VPWR VGND sg13cmos5l_decap_8
XFILLER_297_21 VPWR VGND sg13cmos5l_decap_8
XANTENNA__1985__X Tile_X0Y5_E2BEGb[6] VPWR VGND sg13cmos5l_antennanp
XFILLER_357_126 VPWR VGND sg13cmos5l_decap_8
XFILLER_133_7 VPWR VGND sg13cmos5l_decap_8
XFILLER_297_98 VPWR VGND sg13cmos5l_decap_8
XFILLER_50_14 VPWR VGND sg13cmos5l_decap_8
XFILLER_109_126 VPWR VGND sg13cmos5l_decap_8
XFILLER_164_232 VPWR VGND sg13cmos5l_decap_8
XFILLER_166_14 VPWR VGND sg13cmos5l_decap_8
XFILLER_300_7 VPWR VGND sg13cmos5l_decap_8
XFILLER_246_91 VPWR VGND sg13cmos5l_decap_8
XFILLER_278_100 VPWR VGND sg13cmos5l_fill_1
XFILLER_316_28 VPWR VGND sg13cmos5l_decap_8
XFILLER_182_35 VPWR VGND sg13cmos5l_decap_8
XFILLER_59_56 VPWR VGND sg13cmos5l_decap_8
XFILLER_115_84 VPWR VGND sg13cmos5l_decap_8
XFILLER_219_244 VPWR VGND sg13cmos5l_fill_1
XFILLER_219_266 VPWR VGND sg13cmos5l_decap_8
XFILLER_332_49 VPWR VGND sg13cmos5l_decap_8
XFILLER_46_113 VPWR VGND sg13cmos5l_decap_8
XFILLER_75_77 VPWR VGND sg13cmos5l_decap_8
XFILLER_46_146 VPWR VGND sg13cmos5l_fill_2
XFILLER_61_105 VPWR VGND sg13cmos5l_decap_8
XFILLER_46_168 VPWR VGND sg13cmos5l_decap_8
XANTENNA__2056__X Tile_X0Y5_S2BEG[5] VPWR VGND sg13cmos5l_antennanp
XFILLER_257_0 VPWR VGND sg13cmos5l_decap_8
XFILLER_91_21 VPWR VGND sg13cmos5l_decap_8
XFILLER_199_173 VPWR VGND sg13cmos5l_decap_8
XANTENNA__1895__X Tile_X0Y1_FrameData_O[8] VPWR VGND sg13cmos5l_antennanp
XFILLER_348_126 VPWR VGND sg13cmos5l_decap_8
XFILLER_24_70 VPWR VGND sg13cmos5l_decap_8
XFILLER_357_35 VPWR VGND sg13cmos5l_decap_8
XFILLER_10_271 VPWR VGND sg13cmos5l_fill_2
XFILLER_155_243 VPWR VGND sg13cmos5l_decap_8
X_0660_ _0660_/Q Tile_X0Y2_FrameData[18] VGND VPWR Tile_X0Y5_FrameStrobe[3] latch
X_0591_ _0591_/Q Tile_X0Y2_FrameData[23] VGND VPWR Tile_X0Y5_FrameStrobe[1] latch
XFILLER_40_91 VPWR VGND sg13cmos5l_decap_8
XFILLER_123_140 VPWR VGND sg13cmos5l_decap_8
XFILLER_156_91 VPWR VGND sg13cmos5l_decap_8
X_2330_ _2330_/X AXIL_S_SOC_WDATA5 _2366_/X _2354_/X _2374_/X _0432_/Q _0431_/Q VPWR
+ VGND sg13cmos5l_mux4_1
XFILLER_69_216 VPWR VGND sg13cmos5l_fill_1
X_2261_ _2261_/X Tile_X0Y2_W2MID[1] Tile_X0Y2_W2END[1] Tile_X0Y2_W6END[1] _2487_/X
+ _0770_/Q _0769_/Q VPWR VGND sg13cmos5l_mux4_1
XFILLER_284_147 VPWR VGND sg13cmos5l_fill_1
X_1212_ _1212_/Q Tile_X0Y4_FrameData[10] VGND VPWR Tile_X0Y5_FrameStrobe[5] latch
XFILLER_242_49 VPWR VGND sg13cmos5l_decap_8
X_2192_ _2192_/X AXIL_S_SOC_WDATA23 AXIL_S_SOC_WDATA27 _2239_/X _2245_/X _0212_/Q
+ _0211_/Q VPWR VGND sg13cmos5l_mux4_1
XFILLER_1_63 VPWR VGND sg13cmos5l_decap_8
X_1143_ _1143_/Q Tile_X0Y4_FrameData[15] VGND VPWR Tile_X0Y5_FrameStrobe[3] latch
XFILLER_92_241 VPWR VGND sg13cmos5l_fill_1
X_1074_ _1074_/Q Tile_X0Y4_FrameData[20] VGND VPWR Tile_X0Y5_FrameStrobe[1] latch
XFILLER_92_263 VPWR VGND sg13cmos5l_decap_8
XFILLER_52_105 VPWR VGND sg13cmos5l_decap_8
X_0025_ _0025_/X _2698_/X _2699_/X _0143_/Q VPWR VGND sg13cmos5l_mux2_1
XFILLER_45_190 VPWR VGND sg13cmos5l_decap_8
XFILLER_60_182 VPWR VGND sg13cmos5l_decap_8
XFILLER_267_35 VPWR VGND sg13cmos5l_decap_8
X_1976_ Tile_X0Y5_E2BEG[5] _2730_/X VPWR VGND sg13cmos5l_buf_1
X_0927_ _0927_/Q Tile_X0Y3_FrameData[23] VGND VPWR Tile_X0Y5_FrameStrobe[4] latch
XFILLER_347_181 VPWR VGND sg13cmos5l_fill_1
XFILLER_20_28 VPWR VGND sg13cmos5l_decap_8
X_0858_ _0858_/Q Tile_X0Y3_FrameData[28] VGND VPWR Tile_X0Y5_FrameStrobe[2] latch
XFILLER_136_28 VPWR VGND sg13cmos5l_decap_8
XFILLER_283_56 VPWR VGND sg13cmos5l_decap_8
X_0789_ _0789_/Q Tile_X0Y2_FrameData[17] VGND VPWR Tile_X0Y5_FrameStrobe[7] latch
XFILLER_114_140 VPWR VGND sg13cmos5l_decap_8
XFILLER_161_268 VPWR VGND sg13cmos5l_decap_4
X_2528_ _2528_/X AXIL_S_SOC_ARADDR3 AXIL_S_SOC_ARADDR5 _2579_/X _2593_/X _0948_/Q
+ _0947_/Q VPWR VGND sg13cmos5l_mux4_1
X_2459_ _2459_/X Tile_X0Y1_W1END[1] Tile_X0Y1_W6END[9] _2357_/X _2338_/X _0416_/Q
+ _0415_/Q VPWR VGND sg13cmos5l_mux4_1
XFILLER_75_208 VPWR VGND sg13cmos5l_fill_2
XFILLER_152_49 VPWR VGND sg13cmos5l_decap_8
XFILLER_216_214 VPWR VGND sg13cmos5l_decap_8
XFILLER_83_230 VPWR VGND sg13cmos5l_decap_8
XFILLER_216_258 VPWR VGND sg13cmos5l_decap_8
XFILLER_283_191 VPWR VGND sg13cmos5l_decap_8
XFILLER_83_252 VPWR VGND sg13cmos5l_fill_2
XFILLER_45_14 VPWR VGND sg13cmos5l_decap_8
XFILLER_43_105 VPWR VGND sg13cmos5l_decap_8
XFILLER_250_7 VPWR VGND sg13cmos5l_decap_8
XFILLER_101_42 VPWR VGND sg13cmos5l_decap_8
XFILLER_348_7 VPWR VGND sg13cmos5l_decap_8
XFILLER_51_182 VPWR VGND sg13cmos5l_decap_8
XFILLER_61_35 VPWR VGND sg13cmos5l_decap_8
XFILLER_137_221 VPWR VGND sg13cmos5l_decap_8
XFILLER_177_35 VPWR VGND sg13cmos5l_decap_8
XFILLER_338_181 VPWR VGND sg13cmos5l_fill_1
XFILLER_353_140 VPWR VGND sg13cmos5l_decap_8
XFILLER_327_49 VPWR VGND sg13cmos5l_decap_8
XFILLER_298_239 VPWR VGND sg13cmos5l_decap_4
XFILLER_105_140 VPWR VGND sg13cmos5l_decap_8
XFILLER_193_56 VPWR VGND sg13cmos5l_decap_8
XFILLER_86_21 VPWR VGND sg13cmos5l_decap_8
XFILLER_120_154 VPWR VGND sg13cmos5l_decap_8
XFILLER_86_98 VPWR VGND sg13cmos5l_decap_8
XFILLER_19_70 VPWR VGND sg13cmos5l_decap_8
XFILLER_274_180 VPWR VGND sg13cmos5l_fill_1
XFILLER_34_105 VPWR VGND sg13cmos5l_decap_8
XFILLER_207_269 VPWR VGND sg13cmos5l_decap_4
XFILLER_96_7 VPWR VGND sg13cmos5l_decap_8
XFILLER_42_182 VPWR VGND sg13cmos5l_fill_2
XFILLER_35_91 VPWR VGND sg13cmos5l_decap_8
X_1830_ Tile_X0Y4_EE4BEG[13] _2646_/X VPWR VGND sg13cmos5l_buf_1
X_1761_ Tile_X0Y2_FrameData_O[21] Tile_X0Y2_FrameData[21] VPWR VGND sg13cmos5l_buf_1
XFILLER_344_140 VPWR VGND sg13cmos5l_decap_8
XFILLER_237_49 VPWR VGND sg13cmos5l_decap_8
XFILLER_289_206 VPWR VGND sg13cmos5l_decap_8
X_1692_ Tile_X0Y0_EE4BEG[0] _2181_/X VPWR VGND sg13cmos5l_buf_1
X_0712_ _0712_/Q Tile_X0Y2_FrameData[30] VGND VPWR Tile_X0Y5_FrameStrobe[5] latch
XFILLER_344_162 VPWR VGND sg13cmos5l_decap_8
X_0643_ _0643_/Q Tile_X0Y2_FrameData[3] VGND VPWR Tile_X0Y5_FrameStrobe[2] latch
XFILLER_297_272 VPWR VGND sg13cmos5l_fill_1
XFILLER_300_210 VPWR VGND sg13cmos5l_decap_8
X_2313_ _2313_/X AXIL_S_SOC_WDATA4 AXIL_S_SOC_WDATA8 _2350_/X _2376_/X _0466_/Q _0465_/Q
+ VPWR VGND sg13cmos5l_mux4_1
X_0574_ _0574_/Q Tile_X0Y2_FrameData[8] VGND VPWR Tile_X0Y5_FrameStrobe[0] latch
XFILLER_111_154 VPWR VGND sg13cmos5l_decap_8
XFILLER_333_70 VPWR VGND sg13cmos5l_decap_8
X_2244_ _2244_/X _2256_/X _2255_/X Tile_X0Y0_S2MID[3] Tile_X0Y0_S2END[3] _0088_/Q
+ _0087_/Q VPWR VGND sg13cmos5l_mux4_1
XFILLER_18_0 VPWR VGND sg13cmos5l_decap_8
X_2175_ _2175_/X AXIL_S_SOC_WDATA18 AXIL_S_SOC_WDATA26 _2243_/X _2246_/X _0246_/Q
+ _0245_/Q VPWR VGND sg13cmos5l_mux4_1
XFILLER_25_105 VPWR VGND sg13cmos5l_decap_8
X_1126_ _1126_/Q Tile_X0Y4_FrameData[0] VGND VPWR Tile_X0Y5_FrameStrobe[2] latch
XFILLER_213_206 VPWR VGND sg13cmos5l_fill_1
XFILLER_25_116 VPWR VGND sg13cmos5l_fill_1
XFILLER_15_28 VPWR VGND sg13cmos5l_decap_8
XFILLER_202_63 VPWR VGND sg13cmos5l_decap_8
XFILLER_213_228 VPWR VGND sg13cmos5l_decap_8
X_1057_ _1057_/Q Tile_X0Y4_FrameData[5] VGND VPWR Tile_X0Y5_FrameStrobe[0] latch
XFILLER_40_119 VPWR VGND sg13cmos5l_decap_8
XFILLER_178_154 VPWR VGND sg13cmos5l_decap_8
XFILLER_278_56 VPWR VGND sg13cmos5l_decap_8
XFILLER_119_254 VPWR VGND sg13cmos5l_fill_1
XFILLER_193_146 VPWR VGND sg13cmos5l_fill_1
XFILLER_31_49 VPWR VGND sg13cmos5l_decap_8
X_1959_ Tile_X0Y1_E2BEG[4] _2297_/X VPWR VGND sg13cmos5l_buf_1
XFILLER_147_49 VPWR VGND sg13cmos5l_decap_8
XFILLER_294_77 VPWR VGND sg13cmos5l_decap_8
XFILLER_350_121 VPWR VGND sg13cmos5l_decap_8
XFILLER_350_198 VPWR VGND sg13cmos5l_fill_2
XFILLER_298_7 VPWR VGND sg13cmos5l_decap_8
XFILLER_243_70 VPWR VGND sg13cmos5l_decap_8
XFILLER_56_35 VPWR VGND sg13cmos5l_decap_8
XFILLER_16_105 VPWR VGND sg13cmos5l_decap_8
XFILLER_112_63 VPWR VGND sg13cmos5l_decap_8
XFILLER_31_119 VPWR VGND sg13cmos5l_decap_8
XFILLER_72_56 VPWR VGND sg13cmos5l_decap_8
XFILLER_358_210 VPWR VGND sg13cmos5l_decap_8
XFILLER_188_56 VPWR VGND sg13cmos5l_decap_8
XFILLER_212_272 VPWR VGND sg13cmos5l_fill_1
XFILLER_358_243 VPWR VGND sg13cmos5l_decap_8
XFILLER_169_187 VPWR VGND sg13cmos5l_fill_1
XFILLER_122_0 VPWR VGND sg13cmos5l_decap_8
XFILLER_125_202 VPWR VGND sg13cmos5l_fill_1
XFILLER_354_14 VPWR VGND sg13cmos5l_decap_8
XFILLER_341_154 VPWR VGND sg13cmos5l_decap_8
XFILLER_97_42 VPWR VGND sg13cmos5l_decap_8
XFILLER_153_70 VPWR VGND sg13cmos5l_decap_8
XFILLER_239_147 VPWR VGND sg13cmos5l_decap_8
X_0290_ _0290_/Q Tile_X0Y0_FrameData[4] VGND VPWR Tile_X0Y5_FrameStrobe[6] latch
XFILLER_11_7 VPWR VGND sg13cmos5l_decap_8
XFILLER_303_84 VPWR VGND sg13cmos5l_decap_8
XFILLER_62_255 VPWR VGND sg13cmos5l_fill_1
XFILLER_15_171 VPWR VGND sg13cmos5l_decap_4
XFILLER_349_210 VPWR VGND sg13cmos5l_decap_8
XFILLER_203_261 VPWR VGND sg13cmos5l_fill_1
XFILLER_203_272 VPWR VGND sg13cmos5l_fill_1
XFILLER_30_130 VPWR VGND sg13cmos5l_fill_2
XFILLER_175_168 VPWR VGND sg13cmos5l_decap_8
X_1813_ Tile_X0Y4_E6BEG[8] _2657_/X VPWR VGND sg13cmos5l_buf_1
X_2793_ _2793_/X Tile_X0Y4_W1END[0] Tile_X0Y4_W6END[8] _2696_/X _2669_/X _1132_/Q
+ _1131_/Q VPWR VGND sg13cmos5l_mux4_1
XFILLER_190_105 VPWR VGND sg13cmos5l_decap_4
XFILLER_190_127 VPWR VGND sg13cmos5l_decap_8
X_1744_ Tile_X0Y2_FrameData_O[4] Tile_X0Y2_FrameData[4] VPWR VGND sg13cmos5l_buf_1
XFILLER_116_246 VPWR VGND sg13cmos5l_decap_8
XFILLER_264_14 VPWR VGND sg13cmos5l_decap_8
XFILLER_328_70 VPWR VGND sg13cmos5l_decap_8
XFILLER_7_84 VPWR VGND sg13cmos5l_decap_8
X_1675_ Tile_X0Y0_FrameData_O[15] Tile_X0Y0_FrameData[15] VPWR VGND sg13cmos5l_buf_1
XFILLER_277_209 VPWR VGND sg13cmos5l_decap_8
X_0626_ _0626_/Q Tile_X0Y2_FrameData[20] VGND VPWR Tile_X0Y5_FrameStrobe[2] latch
X_0557_ _0557_/Q Tile_X0Y2_FrameData[25] VGND VPWR Tile_X0Y5_FrameStrobe[0] latch
XFILLER_280_35 VPWR VGND sg13cmos5l_decap_8
XFILLER_97_174 VPWR VGND sg13cmos5l_decap_4
XFILLER_344_91 VPWR VGND sg13cmos5l_decap_8
X_2227_ _2227_/X Tile_X0Y4_W1END[2] Tile_X0Y4_WW4END[2] Tile_X0Y4_W6END[10] _2703_/X
+ _1234_/Q _1233_/Q VPWR VGND sg13cmos5l_mux4_1
X_0488_ _0488_/Q Tile_X0Y1_FrameData[14] VGND VPWR Tile_X0Y5_FrameStrobe[5] latch
XFILLER_253_161 VPWR VGND sg13cmos5l_fill_1
X_2158_ _2158_/X _2236_/X _2234_/X _2222_/X _2221_/X _0280_/Q _0279_/Q VPWR VGND sg13cmos5l_mux4_1
XFILLER_198_227 VPWR VGND sg13cmos5l_decap_4
XFILLER_26_49 VPWR VGND sg13cmos5l_decap_8
X_2089_ Tile_X0Y3_E2BEG[1] _2510_/X VPWR VGND sg13cmos5l_buf_1
X_1109_ _1109_/Q Tile_X0Y4_FrameData[17] VGND VPWR Tile_X0Y5_FrameStrobe[2] latch
XFILLER_13_119 VPWR VGND sg13cmos5l_decap_8
XFILLER_289_77 VPWR VGND sg13cmos5l_decap_8
XFILLER_42_59 VPWR VGND sg13cmos5l_decap_8
XFILLER_355_224 VPWR VGND sg13cmos5l_decap_8
XANTENNA__1993__X Tile_X0Y5_E6BEG[6] VPWR VGND sg13cmos5l_antennanp
XFILLER_166_146 VPWR VGND sg13cmos5l_decap_8
XFILLER_166_179 VPWR VGND sg13cmos5l_decap_8
XFILLER_181_105 VPWR VGND sg13cmos5l_decap_8
XFILLER_213_7 VPWR VGND sg13cmos5l_decap_8
XFILLER_308_140 VPWR VGND sg13cmos5l_decap_8
XFILLER_174_14 VPWR VGND sg13cmos5l_decap_8
XFILLER_238_70 VPWR VGND sg13cmos5l_decap_8
XFILLER_107_63 VPWR VGND sg13cmos5l_decap_8
XFILLER_324_28 VPWR VGND sg13cmos5l_decap_8
XFILLER_88_141 VPWR VGND sg13cmos5l_decap_4
XFILLER_130_271 VPWR VGND sg13cmos5l_fill_2
XFILLER_254_91 VPWR VGND sg13cmos5l_decap_8
XFILLER_67_56 VPWR VGND sg13cmos5l_decap_8
XFILLER_190_35 VPWR VGND sg13cmos5l_decap_8
XFILLER_123_84 VPWR VGND sg13cmos5l_decap_8
XFILLER_44_211 VPWR VGND sg13cmos5l_decap_4
XFILLER_340_49 VPWR VGND sg13cmos5l_decap_8
XFILLER_244_161 VPWR VGND sg13cmos5l_decap_8
XFILLER_83_77 VPWR VGND sg13cmos5l_decap_8
XFILLER_44_233 VPWR VGND sg13cmos5l_decap_8
XFILLER_199_77 VPWR VGND sg13cmos5l_decap_4
XANTENNA__2064__X Tile_X0Y5_S2BEGb[5] VPWR VGND sg13cmos5l_antennanp
XFILLER_349_14 VPWR VGND sg13cmos5l_decap_8
XFILLER_337_0 VPWR VGND sg13cmos5l_decap_8
XFILLER_157_124 VPWR VGND sg13cmos5l_decap_8
XFILLER_8_134 VPWR VGND sg13cmos5l_decap_8
XFILLER_157_179 VPWR VGND sg13cmos5l_decap_4
XFILLER_172_105 VPWR VGND sg13cmos5l_decap_8
XFILLER_32_70 VPWR VGND sg13cmos5l_decap_8
XFILLER_361_205 VPWR VGND sg13cmos5l_decap_8
XFILLER_148_70 VPWR VGND sg13cmos5l_decap_8
XFILLER_165_190 VPWR VGND sg13cmos5l_decap_8
XFILLER_59_7 VPWR VGND sg13cmos5l_decap_8
XFILLER_180_182 VPWR VGND sg13cmos5l_decap_8
X_1460_ _1460_/Q Tile_X0Y5_FrameData[28] VGND VPWR Tile_X0Y5_FrameStrobe[6] latch
XFILLER_234_28 VPWR VGND sg13cmos5l_decap_8
X_1391_ _1391_/Q Tile_X0Y5_FrameData[1] VGND VPWR Tile_X0Y5_FrameStrobe[3] latch
X_0411_ _0411_/Q Tile_X0Y1_FrameData[27] VGND VPWR Tile_X0Y5_FrameStrobe[3] latch
XFILLER_121_260 VPWR VGND sg13cmos5l_fill_1
XFILLER_121_271 VPWR VGND sg13cmos5l_fill_2
XFILLER_164_91 VPWR VGND sg13cmos5l_decap_8
X_0342_ _0342_/Q Tile_X0Y1_FrameData[0] VGND VPWR Tile_X0Y5_FrameStrobe[0] latch
XFILLER_282_245 VPWR VGND sg13cmos5l_decap_8
X_0273_ _0273_/Q Tile_X0Y0_FrameData[21] VGND VPWR Tile_X0Y5_FrameStrobe[6] latch
XFILLER_94_155 VPWR VGND sg13cmos5l_decap_8
XFILLER_250_49 VPWR VGND sg13cmos5l_decap_8
X_2012_ Tile_X0Y5_EE4BEG[13] _2754_/X VPWR VGND sg13cmos5l_buf_1
XFILLER_235_161 VPWR VGND sg13cmos5l_decap_4
XFILLER_250_164 VPWR VGND sg13cmos5l_decap_8
XFILLER_259_14 VPWR VGND sg13cmos5l_decap_8
XFILLER_50_258 VPWR VGND sg13cmos5l_decap_4
XFILLER_85_0 VPWR VGND sg13cmos5l_decap_4
XFILLER_163_105 VPWR VGND sg13cmos5l_decap_8
XFILLER_339_91 VPWR VGND sg13cmos5l_decap_8
XFILLER_163_149 VPWR VGND sg13cmos5l_decap_4
XFILLER_275_35 VPWR VGND sg13cmos5l_decap_8
X_2776_ _2776_/X Tile_X0Y5_W2MID[4] Tile_X0Y5_W2END[4] Tile_X0Y5_W6END[11] _2828_/X
+ _1350_/Q _1349_/Q VPWR VGND sg13cmos5l_mux4_1
XFILLER_352_238 VPWR VGND sg13cmos5l_decap_8
XFILLER_305_154 VPWR VGND sg13cmos5l_decap_8
X_1727_ Tile_X0Y0_E2BEGb[7] _2180_/X VPWR VGND sg13cmos5l_buf_1
XFILLER_208_84 VPWR VGND sg13cmos5l_decap_8
X_1658_ Tile_X0Y0_FrameStrobe_O[18] Tile_X0Y5_FrameStrobe[18] VPWR VGND sg13cmos5l_buf_1
XFILLER_360_271 VPWR VGND sg13cmos5l_fill_2
XFILLER_144_28 VPWR VGND sg13cmos5l_decap_8
XFILLER_171_193 VPWR VGND sg13cmos5l_decap_8
X_0609_ _0609_/Q Tile_X0Y2_FrameData[5] VGND VPWR Tile_X0Y5_FrameStrobe[1] latch
XFILLER_291_56 VPWR VGND sg13cmos5l_decap_8
X_1589_ Tile_X0Y2_EE4BEG[2] _2419_/X VPWR VGND sg13cmos5l_buf_1
XFILLER_112_271 VPWR VGND sg13cmos5l_fill_2
XFILLER_218_128 VPWR VGND sg13cmos5l_decap_8
XFILLER_85_166 VPWR VGND sg13cmos5l_decap_8
XFILLER_160_49 VPWR VGND sg13cmos5l_decap_8
XFILLER_226_150 VPWR VGND sg13cmos5l_decap_4
XANTENNA__1988__X Tile_X0Y5_E6BEG[1] VPWR VGND sg13cmos5l_antennanp
XFILLER_163_7 VPWR VGND sg13cmos5l_decap_8
XFILLER_53_14 VPWR VGND sg13cmos5l_decap_8
XFILLER_169_14 VPWR VGND sg13cmos5l_decap_8
XFILLER_241_175 VPWR VGND sg13cmos5l_decap_8
XFILLER_179_271 VPWR VGND sg13cmos5l_fill_2
XFILLER_330_7 VPWR VGND sg13cmos5l_decap_8
XFILLER_41_269 VPWR VGND sg13cmos5l_decap_4
XFILLER_139_157 VPWR VGND sg13cmos5l_decap_4
XFILLER_319_28 VPWR VGND sg13cmos5l_decap_8
XFILLER_154_105 VPWR VGND sg13cmos5l_decap_8
XFILLER_249_91 VPWR VGND sg13cmos5l_decap_8
XFILLER_185_35 VPWR VGND sg13cmos5l_decap_8
XFILLER_343_238 VPWR VGND sg13cmos5l_decap_8
XFILLER_118_84 VPWR VGND sg13cmos5l_decap_8
XFILLER_162_182 VPWR VGND sg13cmos5l_decap_4
XFILLER_335_49 VPWR VGND sg13cmos5l_decap_8
XFILLER_351_271 VPWR VGND sg13cmos5l_fill_2
XFILLER_311_135 VPWR VGND sg13cmos5l_decap_8
XFILLER_78_77 VPWR VGND sg13cmos5l_decap_8
XFILLER_209_117 VPWR VGND sg13cmos5l_decap_8
XFILLER_76_133 VPWR VGND sg13cmos5l_fill_1
XANTENNA__2059__X Tile_X0Y5_S2BEGb[0] VPWR VGND sg13cmos5l_antennanp
XFILLER_287_0 VPWR VGND sg13cmos5l_decap_8
XFILLER_94_21 VPWR VGND sg13cmos5l_decap_8
XFILLER_76_166 VPWR VGND sg13cmos5l_decap_4
XFILLER_76_177 VPWR VGND sg13cmos5l_decap_4
XANTENNA__1898__X Tile_X0Y1_FrameData_O[11] VPWR VGND sg13cmos5l_antennanp
XFILLER_27_70 VPWR VGND sg13cmos5l_decap_8
XFILLER_91_147 VPWR VGND sg13cmos5l_decap_8
XFILLER_300_63 VPWR VGND sg13cmos5l_decap_8
X_0960_ _0960_/Q Tile_X0Y3_FrameData[22] VGND VPWR Tile_X0Y5_FrameStrobe[5] latch
XFILLER_229_28 VPWR VGND sg13cmos5l_decap_8
XFILLER_43_91 VPWR VGND sg13cmos5l_decap_8
XFILLER_145_105 VPWR VGND sg13cmos5l_decap_8
XFILLER_159_91 VPWR VGND sg13cmos5l_decap_8
X_2630_ _2630_/X AXIL_S_SOC_WSTRB1 AXIL_S_SOC_BREADY _2710_/X _2683_/X _1194_/Q _1193_/Q
+ VPWR VGND sg13cmos5l_mux4_1
X_0891_ _0891_/Q Tile_X0Y3_FrameData[27] VGND VPWR Tile_X0Y5_FrameStrobe[3] latch
XFILLER_145_127 VPWR VGND sg13cmos5l_decap_8
X_2561_ _2561_/X _2566_/X _2565_/X Tile_X0Y3_W6END[0] _2561_/A3 _0798_/Q _0797_/Q
+ VPWR VGND sg13cmos5l_mux4_1
XFILLER_153_160 VPWR VGND sg13cmos5l_decap_4
XFILLER_245_49 VPWR VGND sg13cmos5l_decap_8
X_1512_ _2339_/A3 VPWR VGND sg13cmos5l_tielo
X_2492_ _2492_/X Tile_X0Y4_W2MID[6] Tile_X0Y4_W2END[6] Tile_X0Y4_W6END[6] _2709_/X
+ _1254_/Q _1253_/Q VPWR VGND sg13cmos5l_mux4_1
XFILLER_299_175 VPWR VGND sg13cmos5l_decap_8
X_1443_ _1443_/Q Tile_X0Y5_FrameData[13] VGND VPWR Tile_X0Y5_FrameStrobe[5] latch
XFILLER_99_258 VPWR VGND sg13cmos5l_fill_2
XFILLER_101_208 VPWR VGND sg13cmos5l_fill_2
XFILLER_302_168 VPWR VGND sg13cmos5l_decap_8
XFILLER_4_63 VPWR VGND sg13cmos5l_decap_8
X_1374_ _1374_/Q Tile_X0Y5_FrameData[18] VGND VPWR Tile_X0Y5_FrameStrobe[3] latch
XFILLER_67_133 VPWR VGND sg13cmos5l_decap_8
X_0325_ _0325_/Q Tile_X0Y1_FrameData[17] VGND VPWR Tile_X0Y5_FrameStrobe[0] latch
X_0256_ _0256_/Q Tile_X0Y0_FrameData[6] VGND VPWR Tile_X0Y5_FrameStrobe[5] latch
XFILLER_82_147 VPWR VGND sg13cmos5l_decap_8
XFILLER_341_70 VPWR VGND sg13cmos5l_decap_8
XANTENNA__1601__X Tile_X0Y2_EE4BEG[14] VPWR VGND sg13cmos5l_antennanp
X_0187_ _0187_/Q Tile_X0Y0_FrameData[11] VGND VPWR Tile_X0Y5_FrameStrobe[3] latch
XFILLER_223_153 VPWR VGND sg13cmos5l_decap_4
XFILLER_90_180 VPWR VGND sg13cmos5l_fill_1
XFILLER_168_219 VPWR VGND sg13cmos5l_decap_8
XFILLER_210_63 VPWR VGND sg13cmos5l_decap_8
XFILLER_223_197 VPWR VGND sg13cmos5l_fill_1
XFILLER_23_28 VPWR VGND sg13cmos5l_decap_8
XFILLER_139_28 VPWR VGND sg13cmos5l_decap_8
XFILLER_286_78 VPWR VGND sg13cmos5l_decap_8
X_2828_ _2828_/X Tile_X0Y5_N2MID[3] Tile_X0Y5_N2END[3] _2832_/X _2716_/X _1282_/Q
+ _1281_/Q VPWR VGND sg13cmos5l_mux4_1
X_2759_ _2759_/X Tile_X0Y5_N4END[2] _0058_/X _2810_/X _2809_/X _1384_/Q _1383_/Q VPWR
+ VGND sg13cmos5l_mux4_1
XFILLER_155_49 VPWR VGND sg13cmos5l_decap_8
XFILLER_2_118 VPWR VGND sg13cmos5l_decap_8
XFILLER_48_25 VPWR VGND sg13cmos5l_decap_8
XFILLER_58_133 VPWR VGND sg13cmos5l_decap_8
XFILLER_280_7 VPWR VGND sg13cmos5l_decap_8
XFILLER_104_64 VPWR VGND sg13cmos5l_decap_8
XFILLER_251_70 VPWR VGND sg13cmos5l_decap_8
XFILLER_261_237 VPWR VGND sg13cmos5l_fill_1
XFILLER_64_35 VPWR VGND sg13cmos5l_decap_8
XFILLER_120_63 VPWR VGND sg13cmos5l_decap_8
XFILLER_80_56 VPWR VGND sg13cmos5l_decap_8
XFILLER_127_105 VPWR VGND sg13cmos5l_decap_8
XFILLER_167_252 VPWR VGND sg13cmos5l_fill_1
XFILLER_196_56 VPWR VGND sg13cmos5l_decap_8
XFILLER_202_0 VPWR VGND sg13cmos5l_decap_8
XFILLER_89_43 VPWR VGND sg13cmos5l_decap_8
XFILLER_296_112 VPWR VGND sg13cmos5l_decap_8
XFILLER_150_152 VPWR VGND sg13cmos5l_decap_8
XFILLER_96_228 VPWR VGND sg13cmos5l_fill_2
XFILLER_96_217 VPWR VGND sg13cmos5l_decap_8
XFILLER_362_14 VPWR VGND sg13cmos5l_decap_8
XFILLER_296_189 VPWR VGND sg13cmos5l_decap_8
XFILLER_49_133 VPWR VGND sg13cmos5l_decap_8
X_0110_ _0110_/Q Tile_X0Y0_FrameData[24] VGND VPWR Tile_X0Y5_FrameStrobe[1] latch
XFILLER_161_70 VPWR VGND sg13cmos5l_decap_8
X_1090_ _1090_/Q Tile_X0Y4_FrameData[4] VGND VPWR Tile_X0Y5_FrameStrobe[1] latch
XFILLER_64_147 VPWR VGND sg13cmos5l_decap_4
XFILLER_38_91 VPWR VGND sg13cmos5l_decap_8
X_0041_ _1615_/A _2265_/X _2266_/X _0515_/Q VPWR VGND sg13cmos5l_mux2_1
XFILLER_311_84 VPWR VGND sg13cmos5l_decap_8
XFILLER_220_167 VPWR VGND sg13cmos5l_decap_8
X_1992_ Tile_X0Y5_E6BEG[5] _2762_/X VPWR VGND sg13cmos5l_buf_1
XFILLER_118_105 VPWR VGND sg13cmos5l_decap_8
X_0943_ _0943_/Q Tile_X0Y3_FrameData[7] VGND VPWR Tile_X0Y5_FrameStrobe[4] latch
X_0874_ _0874_/Q Tile_X0Y3_FrameData[12] VGND VPWR Tile_X0Y5_FrameStrobe[2] latch
XFILLER_173_266 VPWR VGND sg13cmos5l_fill_2
X_2613_ _2613_/X _2674_/X _2673_/X AXIL_S_SOC_WSTRB1 AXIL_S_SOC_WSTRB2 _1228_/Q _1227_/Q
+ VPWR VGND sg13cmos5l_mux4_1
XFILLER_126_171 VPWR VGND sg13cmos5l_fill_1
X_2544_ _2544_/X Tile_X0Y5_N4END[11] Tile_X0Y0_S4END[15] _2580_/X _2579_/X _0916_/Q
+ _0915_/Q VPWR VGND sg13cmos5l_mux4_1
XFILLER_287_112 VPWR VGND sg13cmos5l_decap_8
XFILLER_48_0 VPWR VGND sg13cmos5l_fill_2
XFILLER_336_70 VPWR VGND sg13cmos5l_decap_8
XFILLER_272_14 VPWR VGND sg13cmos5l_decap_8
X_2475_ _2475_/X _2464_/X Tile_X0Y5_N4END[15] _2463_/X Tile_X0Y0_S4END[11] _0600_/Q
+ _0599_/Q VPWR VGND sg13cmos5l_mux4_1
X_1426_ _1426_/Q Tile_X0Y5_FrameData[30] VGND VPWR Tile_X0Y5_FrameStrobe[5] latch
XFILLER_87_228 VPWR VGND sg13cmos5l_decap_8
XFILLER_205_63 VPWR VGND sg13cmos5l_decap_8
X_1357_ _1357_/Q Tile_X0Y5_FrameData[3] VGND VPWR Tile_X0Y5_FrameStrobe[2] latch
XFILLER_18_28 VPWR VGND sg13cmos5l_decap_8
XFILLER_228_245 VPWR VGND sg13cmos5l_fill_2
X_0308_ _0308_/Q Tile_X0Y0_FrameData[18] VGND VPWR Tile_X0Y5_FrameStrobe[7] latch
XFILLER_95_272 VPWR VGND sg13cmos5l_fill_1
XFILLER_95_261 VPWR VGND sg13cmos5l_decap_8
XFILLER_352_91 VPWR VGND sg13cmos5l_decap_8
X_1288_ _1288_/Q Tile_X0Y5_FrameData[8] VGND VPWR Tile_X0Y5_FrameStrobe[0] latch
XFILLER_55_147 VPWR VGND sg13cmos5l_decap_8
X_0239_ _0239_/Q Tile_X0Y0_FrameData[23] VGND VPWR Tile_X0Y5_FrameStrobe[5] latch
XFILLER_221_84 VPWR VGND sg13cmos5l_decap_8
XFILLER_63_180 VPWR VGND sg13cmos5l_fill_2
XFILLER_211_123 VPWR VGND sg13cmos5l_decap_8
XFILLER_211_134 VPWR VGND sg13cmos5l_fill_1
XFILLER_357_105 VPWR VGND sg13cmos5l_decap_8
XFILLER_34_49 VPWR VGND sg13cmos5l_decap_8
XFILLER_297_77 VPWR VGND sg13cmos5l_decap_8
XFILLER_109_105 VPWR VGND sg13cmos5l_decap_8
XFILLER_126_7 VPWR VGND sg13cmos5l_decap_8
XFILLER_117_182 VPWR VGND sg13cmos5l_decap_8
XFILLER_246_70 VPWR VGND sg13cmos5l_decap_8
XFILLER_132_152 VPWR VGND sg13cmos5l_decap_8
XFILLER_182_14 VPWR VGND sg13cmos5l_decap_8
XFILLER_78_217 VPWR VGND sg13cmos5l_fill_2
XFILLER_59_35 VPWR VGND sg13cmos5l_decap_8
XFILLER_278_178 VPWR VGND sg13cmos5l_decap_4
XFILLER_115_63 VPWR VGND sg13cmos5l_decap_8
XFILLER_293_126 VPWR VGND sg13cmos5l_decap_8
XFILLER_332_28 VPWR VGND sg13cmos5l_decap_8
XFILLER_262_91 VPWR VGND sg13cmos5l_decap_8
XFILLER_293_159 VPWR VGND sg13cmos5l_decap_8
XFILLER_86_272 VPWR VGND sg13cmos5l_fill_1
XFILLER_75_56 VPWR VGND sg13cmos5l_decap_8
XFILLER_46_125 VPWR VGND sg13cmos5l_decap_8
XFILLER_131_84 VPWR VGND sg13cmos5l_decap_8
XFILLER_152_0 VPWR VGND sg13cmos5l_decap_8
XFILLER_199_163 VPWR VGND sg13cmos5l_fill_2
XFILLER_348_105 VPWR VGND sg13cmos5l_decap_8
XFILLER_91_77 VPWR VGND sg13cmos5l_decap_8
XFILLER_357_14 VPWR VGND sg13cmos5l_decap_8
XANTENNA__2072__X Tile_X0Y5_S4BEG[5] VPWR VGND sg13cmos5l_antennanp
XFILLER_155_200 VPWR VGND sg13cmos5l_decap_8
XFILLER_155_222 VPWR VGND sg13cmos5l_decap_8
XFILLER_356_182 VPWR VGND sg13cmos5l_decap_8
XFILLER_108_160 VPWR VGND sg13cmos5l_fill_2
XFILLER_115_119 VPWR VGND sg13cmos5l_decap_8
XFILLER_40_70 VPWR VGND sg13cmos5l_decap_8
XFILLER_156_70 VPWR VGND sg13cmos5l_decap_8
XFILLER_226_29 VPWR VGND sg13cmos5l_decap_8
X_0590_ _0590_/Q Tile_X0Y2_FrameData[24] VGND VPWR Tile_X0Y5_FrameStrobe[1] latch
XFILLER_269_178 VPWR VGND sg13cmos5l_decap_4
X_2260_ _2260_/X Tile_X0Y1_W2MID[2] Tile_X0Y1_W2END[2] Tile_X0Y1_W6END[2] _2378_/X
+ _0532_/Q _0531_/Q VPWR VGND sg13cmos5l_mux4_1
XFILLER_242_28 VPWR VGND sg13cmos5l_decap_8
XFILLER_284_126 VPWR VGND sg13cmos5l_decap_8
XFILLER_306_84 VPWR VGND sg13cmos5l_decap_8
X_1211_ _1211_/Q Tile_X0Y4_FrameData[11] VGND VPWR Tile_X0Y5_FrameStrobe[5] latch
XFILLER_172_91 VPWR VGND sg13cmos5l_decap_8
X_2191_ _2191_/X AXIL_S_SOC_WDATA22 AXIL_S_SOC_WDATA26 _2237_/X _2246_/X _0214_/Q
+ _0213_/Q VPWR VGND sg13cmos5l_mux4_1
XFILLER_1_42 VPWR VGND sg13cmos5l_decap_8
XFILLER_225_215 VPWR VGND sg13cmos5l_decap_4
X_1142_ _1142_/Q Tile_X0Y4_FrameData[16] VGND VPWR Tile_X0Y5_FrameStrobe[3] latch
XFILLER_92_231 VPWR VGND sg13cmos5l_fill_1
XFILLER_92_220 VPWR VGND sg13cmos5l_decap_8
X_1073_ _1073_/Q Tile_X0Y4_FrameData[21] VGND VPWR Tile_X0Y5_FrameStrobe[1] latch
XFILLER_240_218 VPWR VGND sg13cmos5l_decap_4
X_0024_ _0024_/X _2694_/X _2695_/X _0146_/Q VPWR VGND sg13cmos5l_mux2_1
XFILLER_339_105 VPWR VGND sg13cmos5l_decap_8
XANTENNA_190 AXIL_S_SOC_WDATA9 VPWR VGND sg13cmos5l_antennanp
XFILLER_60_161 VPWR VGND sg13cmos5l_decap_8
XFILLER_267_14 VPWR VGND sg13cmos5l_decap_8
X_1975_ Tile_X0Y5_E2BEG[4] _2729_/X VPWR VGND sg13cmos5l_buf_1
X_0926_ _0926_/Q Tile_X0Y3_FrameData[24] VGND VPWR Tile_X0Y5_FrameStrobe[4] latch
XFILLER_354_119 VPWR VGND sg13cmos5l_decap_8
XFILLER_146_233 VPWR VGND sg13cmos5l_decap_4
XFILLER_106_119 VPWR VGND sg13cmos5l_decap_8
X_0857_ _0857_/Q Tile_X0Y3_FrameData[29] VGND VPWR Tile_X0Y5_FrameStrobe[2] latch
XFILLER_161_247 VPWR VGND sg13cmos5l_decap_8
XFILLER_283_35 VPWR VGND sg13cmos5l_decap_8
X_0788_ _0788_/Q Tile_X0Y2_FrameData[18] VGND VPWR Tile_X0Y5_FrameStrobe[7] latch
XFILLER_362_185 VPWR VGND sg13cmos5l_decap_8
X_2527_ _2527_/X AXIL_S_SOC_ARADDR2 AXIL_S_SOC_ARADDR4 _2577_/X _2594_/X _0950_/Q
+ _0949_/Q VPWR VGND sg13cmos5l_mux4_1
X_2458_ _2458_/X Tile_X0Y3_W1END[0] Tile_X0Y3_W6END[4] _2579_/X _2561_/X _1030_/Q
+ _1029_/Q VPWR VGND sg13cmos5l_mux4_1
XFILLER_152_28 VPWR VGND sg13cmos5l_decap_8
XFILLER_216_84 VPWR VGND sg13cmos5l_decap_8
XFILLER_275_126 VPWR VGND sg13cmos5l_decap_8
XFILLER_29_49 VPWR VGND sg13cmos5l_decap_8
X_1409_ _1409_/Q Tile_X0Y5_FrameData[15] VGND VPWR Tile_X0Y5_FrameStrobe[4] latch
X_2389_ _2389_/X Tile_X0Y0_W1END[0] Tile_X0Y0_W2MID[3] Tile_X0Y0_W2END[3] _2245_/X
+ _0162_/Q _0161_/Q VPWR VGND sg13cmos5l_mux4_1
XFILLER_68_272 VPWR VGND sg13cmos5l_fill_1
XFILLER_36_180 VPWR VGND sg13cmos5l_decap_8
XANTENNA__1996__X Tile_X0Y5_E6BEG[9] VPWR VGND sg13cmos5l_antennanp
XFILLER_101_21 VPWR VGND sg13cmos5l_decap_8
XFILLER_231_229 VPWR VGND sg13cmos5l_decap_8
XFILLER_196_133 VPWR VGND sg13cmos5l_decap_8
XFILLER_243_7 VPWR VGND sg13cmos5l_decap_8
XFILLER_61_14 VPWR VGND sg13cmos5l_decap_8
XFILLER_51_161 VPWR VGND sg13cmos5l_decap_8
XFILLER_101_98 VPWR VGND sg13cmos5l_decap_8
XFILLER_177_14 VPWR VGND sg13cmos5l_decap_8
XFILLER_137_200 VPWR VGND sg13cmos5l_decap_8
XFILLER_345_119 VPWR VGND sg13cmos5l_decap_8
XFILLER_152_214 VPWR VGND sg13cmos5l_fill_1
XFILLER_257_91 VPWR VGND sg13cmos5l_decap_8
XFILLER_327_28 VPWR VGND sg13cmos5l_decap_8
XFILLER_152_236 VPWR VGND sg13cmos5l_decap_8
XFILLER_193_35 VPWR VGND sg13cmos5l_decap_8
XFILLER_353_196 VPWR VGND sg13cmos5l_decap_8
XFILLER_10_84 VPWR VGND sg13cmos5l_decap_8
XFILLER_120_133 VPWR VGND sg13cmos5l_decap_8
XFILLER_126_84 VPWR VGND sg13cmos5l_decap_8
XFILLER_266_126 VPWR VGND sg13cmos5l_decap_4
XFILLER_266_137 VPWR VGND sg13cmos5l_decap_4
XFILLER_343_49 VPWR VGND sg13cmos5l_decap_8
XFILLER_86_77 VPWR VGND sg13cmos5l_decap_8
XFILLER_59_272 VPWR VGND sg13cmos5l_fill_1
XANTENNA__2067__X Tile_X0Y5_S4BEG[0] VPWR VGND sg13cmos5l_antennanp
XFILLER_222_229 VPWR VGND sg13cmos5l_decap_8
XFILLER_35_70 VPWR VGND sg13cmos5l_decap_8
XFILLER_187_133 VPWR VGND sg13cmos5l_decap_8
XFILLER_42_150 VPWR VGND sg13cmos5l_decap_4
XFILLER_187_155 VPWR VGND sg13cmos5l_fill_1
X_1760_ Tile_X0Y2_FrameData_O[20] Tile_X0Y2_FrameData[20] VPWR VGND sg13cmos5l_buf_1
XFILLER_128_244 VPWR VGND sg13cmos5l_fill_1
X_0711_ _0711_/Q Tile_X0Y2_FrameData[31] VGND VPWR Tile_X0Y5_FrameStrobe[5] latch
XFILLER_51_91 VPWR VGND sg13cmos5l_decap_8
XFILLER_167_91 VPWR VGND sg13cmos5l_decap_8
XFILLER_237_28 VPWR VGND sg13cmos5l_decap_8
X_1691_ Tile_X0Y0_FrameData_O[31] Tile_X0Y0_FrameData[31] VPWR VGND sg13cmos5l_buf_1
XFILLER_143_225 VPWR VGND sg13cmos5l_fill_2
X_0642_ _0642_/Q Tile_X0Y2_FrameData[4] VGND VPWR Tile_X0Y5_FrameStrobe[2] latch
X_0573_ _0573_/Q Tile_X0Y2_FrameData[9] VGND VPWR Tile_X0Y5_FrameStrobe[0] latch
X_2312_ _2312_/X AXIL_S_SOC_WDATA3 AXIL_S_SOC_WDATA15 _2361_/X _2377_/X _0468_/Q _0467_/Q
+ VPWR VGND sg13cmos5l_mux4_1
XFILLER_111_133 VPWR VGND sg13cmos5l_decap_8
XFILLER_253_49 VPWR VGND sg13cmos5l_decap_8
XFILLER_257_126 VPWR VGND sg13cmos5l_decap_4
XFILLER_300_222 VPWR VGND sg13cmos5l_decap_8
XFILLER_300_233 VPWR VGND sg13cmos5l_decap_8
XFILLER_300_255 VPWR VGND sg13cmos5l_fill_1
X_2243_ _2243_/X _2254_/X _2253_/X Tile_X0Y0_S2MID[2] Tile_X0Y0_S2END[2] _0090_/Q
+ _0089_/Q VPWR VGND sg13cmos5l_mux4_1
X_2174_ _2174_/X AXIL_S_SOC_WDATA17 AXIL_S_SOC_WDATA25 _2242_/X _2247_/X _0248_/Q
+ _0247_/Q VPWR VGND sg13cmos5l_mux4_1
X_1125_ _1125_/Q Tile_X0Y4_FrameData[1] VGND VPWR Tile_X0Y5_FrameStrobe[2] latch
XFILLER_202_42 VPWR VGND sg13cmos5l_decap_8
XFILLER_206_270 VPWR VGND sg13cmos5l_fill_2
X_1056_ _1056_/Q Tile_X0Y4_FrameData[6] VGND VPWR Tile_X0Y5_FrameStrobe[0] latch
XFILLER_178_133 VPWR VGND sg13cmos5l_decap_8
XFILLER_221_240 VPWR VGND sg13cmos5l_decap_8
XFILLER_278_35 VPWR VGND sg13cmos5l_decap_8
XFILLER_33_183 VPWR VGND sg13cmos5l_fill_2
XFILLER_178_199 VPWR VGND sg13cmos5l_fill_2
XFILLER_31_28 VPWR VGND sg13cmos5l_decap_8
X_1958_ Tile_X0Y1_E2BEG[3] _2296_/X VPWR VGND sg13cmos5l_buf_1
XFILLER_147_28 VPWR VGND sg13cmos5l_decap_8
XFILLER_294_56 VPWR VGND sg13cmos5l_decap_8
XFILLER_335_152 VPWR VGND sg13cmos5l_decap_8
X_1889_ Tile_X0Y1_FrameData_O[2] Tile_X0Y1_FrameData[2] VPWR VGND sg13cmos5l_buf_1
X_0909_ _0909_/Q Tile_X0Y3_FrameData[9] VGND VPWR Tile_X0Y5_FrameStrobe[3] latch
XFILLER_134_247 VPWR VGND sg13cmos5l_decap_4
XFILLER_350_100 VPWR VGND sg13cmos5l_decap_8
XFILLER_350_177 VPWR VGND sg13cmos5l_decap_8
XFILLER_163_49 VPWR VGND sg13cmos5l_decap_8
XFILLER_193_7 VPWR VGND sg13cmos5l_decap_8
XFILLER_248_159 VPWR VGND sg13cmos5l_fill_1
XFILLER_56_14 VPWR VGND sg13cmos5l_decap_8
XFILLER_56_231 VPWR VGND sg13cmos5l_decap_4
XFILLER_56_242 VPWR VGND sg13cmos5l_decap_8
XFILLER_360_7 VPWR VGND sg13cmos5l_decap_8
XFILLER_112_42 VPWR VGND sg13cmos5l_decap_8
XFILLER_71_234 VPWR VGND sg13cmos5l_fill_2
XFILLER_169_133 VPWR VGND sg13cmos5l_fill_2
XFILLER_188_35 VPWR VGND sg13cmos5l_decap_8
XFILLER_24_161 VPWR VGND sg13cmos5l_decap_8
XFILLER_72_35 VPWR VGND sg13cmos5l_decap_8
XFILLER_212_251 VPWR VGND sg13cmos5l_decap_8
XFILLER_169_199 VPWR VGND sg13cmos5l_decap_8
XFILLER_318_119 VPWR VGND sg13cmos5l_decap_8
XFILLER_338_49 VPWR VGND sg13cmos5l_decap_8
XANTENNA_90 AXIL_S_SOC_WDATA26 VPWR VGND sg13cmos5l_antennanp
XFILLER_115_0 VPWR VGND sg13cmos5l_decap_8
XFILLER_97_21 VPWR VGND sg13cmos5l_decap_8
XFILLER_341_133 VPWR VGND sg13cmos5l_decap_8
XFILLER_140_228 VPWR VGND sg13cmos5l_fill_1
XFILLER_239_126 VPWR VGND sg13cmos5l_decap_8
XFILLER_97_98 VPWR VGND sg13cmos5l_decap_8
XFILLER_303_63 VPWR VGND sg13cmos5l_decap_8
XFILLER_47_253 VPWR VGND sg13cmos5l_fill_2
XFILLER_262_173 VPWR VGND sg13cmos5l_decap_8
XFILLER_349_233 VPWR VGND sg13cmos5l_decap_4
XFILLER_309_119 VPWR VGND sg13cmos5l_decap_8
XFILLER_175_147 VPWR VGND sg13cmos5l_decap_8
XFILLER_248_49 VPWR VGND sg13cmos5l_decap_8
X_1812_ Tile_X0Y4_E6BEG[7] _2656_/X VPWR VGND sg13cmos5l_buf_1
X_2792_ _2792_/X Tile_X0Y5_N1END[3] _2796_/X Tile_X0Y5_W6END[3] _2792_/A3 _1266_/Q
+ _1497_/Q VPWR VGND sg13cmos5l_mux4_1
XFILLER_116_203 VPWR VGND sg13cmos5l_decap_8
XFILLER_317_141 VPWR VGND sg13cmos5l_decap_4
X_1743_ Tile_X0Y2_FrameData_O[3] Tile_X0Y2_FrameData[3] VPWR VGND sg13cmos5l_buf_1
XFILLER_7_63 VPWR VGND sg13cmos5l_decap_8
XFILLER_328_93 VPWR VGND sg13cmos5l_fill_1
X_1674_ Tile_X0Y0_FrameData_O[14] Tile_X0Y0_FrameData[14] VPWR VGND sg13cmos5l_buf_1
X_0625_ _0625_/Q Tile_X0Y2_FrameData[21] VGND VPWR Tile_X0Y5_FrameStrobe[2] latch
XFILLER_131_228 VPWR VGND sg13cmos5l_decap_8
XFILLER_30_0 VPWR VGND sg13cmos5l_decap_8
X_0556_ _0556_/Q Tile_X0Y2_FrameData[26] VGND VPWR Tile_X0Y5_FrameStrobe[0] latch
XFILLER_344_70 VPWR VGND sg13cmos5l_decap_8
XFILLER_280_14 VPWR VGND sg13cmos5l_decap_8
X_0487_ _0487_/Q Tile_X0Y1_FrameData[15] VGND VPWR Tile_X0Y5_FrameStrobe[5] latch
XANTENNA__1604__X Tile_X0Y0_N4BEG[0] VPWR VGND sg13cmos5l_antennanp
X_2226_ _2226_/X _2214_/X _0066_/X Tile_X0Y0_S1END[1] Tile_X0Y0_S4END[1] _0108_/Q
+ _0107_/Q VPWR VGND sg13cmos5l_mux4_1
XFILLER_213_63 VPWR VGND sg13cmos5l_decap_8
XFILLER_213_96 VPWR VGND sg13cmos5l_decap_8
XFILLER_253_140 VPWR VGND sg13cmos5l_fill_2
XFILLER_26_28 VPWR VGND sg13cmos5l_decap_8
X_2157_ _2157_/X Tile_X0Y0_W1END[2] Tile_X0Y0_WW4END[2] Tile_X0Y0_WW4END[6] Tile_X0Y0_W6END[10]
+ _0280_/Q _0279_/Q VPWR VGND sg13cmos5l_mux4_1
XFILLER_360_80 VPWR VGND sg13cmos5l_fill_1
XFILLER_253_173 VPWR VGND sg13cmos5l_decap_4
X_2088_ Tile_X0Y3_E2BEG[0] _2509_/X VPWR VGND sg13cmos5l_buf_1
X_1108_ _1108_/Q Tile_X0Y4_FrameData[18] VGND VPWR Tile_X0Y5_FrameStrobe[2] latch
XFILLER_53_256 VPWR VGND sg13cmos5l_decap_4
XFILLER_53_245 VPWR VGND sg13cmos5l_decap_8
XFILLER_289_56 VPWR VGND sg13cmos5l_decap_8
X_1039_ _1039_/Q Tile_X0Y4_FrameData[23] VGND VPWR Tile_X0Y5_FrameStrobe[0] latch
XFILLER_42_38 VPWR VGND sg13cmos5l_decap_8
XFILLER_355_203 VPWR VGND sg13cmos5l_decap_8
XFILLER_158_49 VPWR VGND sg13cmos5l_decap_8
XFILLER_206_7 VPWR VGND sg13cmos5l_decap_8
XFILLER_308_185 VPWR VGND sg13cmos5l_decap_4
XFILLER_308_196 VPWR VGND sg13cmos5l_fill_1
XFILLER_107_247 VPWR VGND sg13cmos5l_decap_8
XFILLER_122_228 VPWR VGND sg13cmos5l_fill_1
XFILLER_107_42 VPWR VGND sg13cmos5l_decap_8
XFILLER_254_70 VPWR VGND sg13cmos5l_decap_8
XFILLER_190_14 VPWR VGND sg13cmos5l_decap_8
XFILLER_88_175 VPWR VGND sg13cmos5l_decap_8
XFILLER_67_35 VPWR VGND sg13cmos5l_decap_8
XFILLER_291_213 VPWR VGND sg13cmos5l_decap_8
XFILLER_88_186 VPWR VGND sg13cmos5l_fill_2
XFILLER_123_63 VPWR VGND sg13cmos5l_decap_8
XFILLER_244_140 VPWR VGND sg13cmos5l_decap_8
XFILLER_340_28 VPWR VGND sg13cmos5l_decap_8
XFILLER_83_56 VPWR VGND sg13cmos5l_decap_8
XFILLER_44_256 VPWR VGND sg13cmos5l_fill_1
XFILLER_199_56 VPWR VGND sg13cmos5l_decap_8
XFILLER_199_89 VPWR VGND sg13cmos5l_decap_8
XFILLER_197_261 VPWR VGND sg13cmos5l_fill_1
XFILLER_197_272 VPWR VGND sg13cmos5l_fill_1
XFILLER_232_0 VPWR VGND sg13cmos5l_decap_8
XANTENNA__2080__X Tile_X0Y5_S4BEG[13] VPWR VGND sg13cmos5l_antennanp
XFILLER_113_228 VPWR VGND sg13cmos5l_decap_8
XFILLER_180_161 VPWR VGND sg13cmos5l_decap_8
XFILLER_113_239 VPWR VGND sg13cmos5l_fill_2
XFILLER_164_70 VPWR VGND sg13cmos5l_decap_8
X_1390_ _1390_/Q Tile_X0Y5_FrameData[2] VGND VPWR Tile_X0Y5_FrameStrobe[3] latch
X_0410_ _0410_/Q Tile_X0Y1_FrameData[28] VGND VPWR Tile_X0Y5_FrameStrobe[3] latch
XFILLER_267_232 VPWR VGND sg13cmos5l_decap_4
X_0341_ _0341_/Q Tile_X0Y1_FrameData[1] VGND VPWR Tile_X0Y5_FrameStrobe[0] latch
XFILLER_282_213 VPWR VGND sg13cmos5l_decap_4
XFILLER_94_112 VPWR VGND sg13cmos5l_fill_1
XFILLER_314_84 VPWR VGND sg13cmos5l_decap_8
X_2011_ Tile_X0Y5_EE4BEG[12] _2753_/X VPWR VGND sg13cmos5l_buf_1
X_0272_ _0272_/Q Tile_X0Y0_FrameData[22] VGND VPWR Tile_X0Y5_FrameStrobe[6] latch
XFILLER_180_91 VPWR VGND sg13cmos5l_decap_8
XFILLER_235_140 VPWR VGND sg13cmos5l_decap_8
XFILLER_250_28 VPWR VGND sg13cmos5l_decap_8
XFILLER_35_234 VPWR VGND sg13cmos5l_decap_8
XFILLER_235_195 VPWR VGND sg13cmos5l_fill_2
XFILLER_50_237 VPWR VGND sg13cmos5l_fill_2
XFILLER_188_272 VPWR VGND sg13cmos5l_fill_1
XFILLER_148_169 VPWR VGND sg13cmos5l_fill_1
XFILLER_275_14 VPWR VGND sg13cmos5l_decap_8
XFILLER_78_0 VPWR VGND sg13cmos5l_decap_8
XFILLER_339_70 VPWR VGND sg13cmos5l_decap_8
X_2775_ _2775_/X Tile_X0Y5_W2MID[5] Tile_X0Y5_W2END[5] Tile_X0Y5_W6END[10] _2827_/X
+ _1352_/Q _1351_/Q VPWR VGND sg13cmos5l_mux4_1
XFILLER_352_217 VPWR VGND sg13cmos5l_decap_8
XFILLER_305_133 VPWR VGND sg13cmos5l_decap_8
X_1726_ Tile_X0Y0_E2BEGb[6] _2179_/X VPWR VGND sg13cmos5l_buf_1
XFILLER_171_172 VPWR VGND sg13cmos5l_decap_8
XFILLER_208_63 VPWR VGND sg13cmos5l_decap_8
X_1657_ Tile_X0Y0_FrameStrobe_O[17] Tile_X0Y5_FrameStrobe[17] VPWR VGND sg13cmos5l_buf_1
XFILLER_104_239 VPWR VGND sg13cmos5l_fill_2
XFILLER_291_35 VPWR VGND sg13cmos5l_decap_8
XFILLER_320_125 VPWR VGND sg13cmos5l_fill_1
X_1588_ Tile_X0Y2_EE4BEG[1] _2418_/X VPWR VGND sg13cmos5l_buf_1
X_0608_ _0608_/Q Tile_X0Y2_FrameData[6] VGND VPWR Tile_X0Y5_FrameStrobe[1] latch
XFILLER_355_91 VPWR VGND sg13cmos5l_decap_8
X_0539_ _0539_/Q Tile_X0Y1_FrameData[27] VGND VPWR Tile_X0Y5_FrameStrobe[7] latch
XFILLER_85_101 VPWR VGND sg13cmos5l_decap_8
XFILLER_224_84 VPWR VGND sg13cmos5l_decap_8
XFILLER_37_49 VPWR VGND sg13cmos5l_decap_8
XFILLER_160_28 VPWR VGND sg13cmos5l_decap_8
X_2209_ _2209_/X _2213_/X Tile_X0Y0_S1END[0] Tile_X0Y0_W6END[0] _2209_/A3 _0078_/Q
+ _0077_/Q VPWR VGND sg13cmos5l_mux4_1
XFILLER_226_184 VPWR VGND sg13cmos5l_decap_8
XFILLER_41_204 VPWR VGND sg13cmos5l_decap_4
XFILLER_156_7 VPWR VGND sg13cmos5l_decap_8
XFILLER_241_154 VPWR VGND sg13cmos5l_decap_8
XFILLER_323_7 VPWR VGND sg13cmos5l_decap_8
XFILLER_328_214 VPWR VGND sg13cmos5l_fill_1
XFILLER_139_169 VPWR VGND sg13cmos5l_decap_8
XFILLER_185_14 VPWR VGND sg13cmos5l_decap_8
XFILLER_249_70 VPWR VGND sg13cmos5l_decap_8
XFILLER_5_105 VPWR VGND sg13cmos5l_decap_8
XFILLER_118_63 VPWR VGND sg13cmos5l_decap_8
XFILLER_162_161 VPWR VGND sg13cmos5l_decap_8
XFILLER_335_28 VPWR VGND sg13cmos5l_decap_8
XFILLER_351_261 VPWR VGND sg13cmos5l_fill_1
XFILLER_351_250 VPWR VGND sg13cmos5l_decap_8
XFILLER_78_56 VPWR VGND sg13cmos5l_decap_8
XFILLER_110_209 VPWR VGND sg13cmos5l_decap_8
XFILLER_103_272 VPWR VGND sg13cmos5l_fill_1
XFILLER_76_112 VPWR VGND sg13cmos5l_decap_8
XFILLER_134_84 VPWR VGND sg13cmos5l_decap_8
XFILLER_182_0 VPWR VGND sg13cmos5l_decap_8
XFILLER_351_49 VPWR VGND sg13cmos5l_decap_8
XFILLER_94_77 VPWR VGND sg13cmos5l_decap_8
XFILLER_91_126 VPWR VGND sg13cmos5l_decap_8
XANTENNA__2075__X Tile_X0Y5_S4BEG[8] VPWR VGND sg13cmos5l_antennanp
XFILLER_232_154 VPWR VGND sg13cmos5l_decap_8
XFILLER_300_42 VPWR VGND sg13cmos5l_decap_8
X_0890_ _0890_/Q Tile_X0Y3_FrameData[28] VGND VPWR Tile_X0Y5_FrameStrobe[3] latch
XFILLER_43_70 VPWR VGND sg13cmos5l_decap_8
XFILLER_159_70 VPWR VGND sg13cmos5l_decap_8
XFILLER_71_7 VPWR VGND sg13cmos5l_decap_8
XFILLER_309_84 VPWR VGND sg13cmos5l_decap_8
X_2560_ _2560_/X _2583_/X _2581_/X _2574_/X _2573_/X _0865_/Q _0864_/Q VPWR VGND sg13cmos5l_mux4_1
XFILLER_245_28 VPWR VGND sg13cmos5l_decap_8
XFILLER_299_154 VPWR VGND sg13cmos5l_decap_8
X_1511_ _2338_/A3 VPWR VGND sg13cmos5l_tielo
X_2491_ _2491_/X Tile_X0Y1_W2MID[6] Tile_X0Y1_W2END[6] Tile_X0Y1_W6END[9] _2374_/X
+ _0408_/Q _0407_/Q VPWR VGND sg13cmos5l_mux4_1
XFILLER_342_272 VPWR VGND sg13cmos5l_fill_1
XFILLER_153_194 VPWR VGND sg13cmos5l_fill_2
XFILLER_175_91 VPWR VGND sg13cmos5l_decap_8
X_1442_ _1442_/Q Tile_X0Y5_FrameData[14] VGND VPWR Tile_X0Y5_FrameStrobe[5] latch
XFILLER_99_237 VPWR VGND sg13cmos5l_decap_8
XFILLER_4_42 VPWR VGND sg13cmos5l_decap_8
XFILLER_302_147 VPWR VGND sg13cmos5l_decap_8
X_1373_ _1373_/Q Tile_X0Y5_FrameData[19] VGND VPWR Tile_X0Y5_FrameStrobe[3] latch
XFILLER_67_112 VPWR VGND sg13cmos5l_decap_8
XFILLER_261_49 VPWR VGND sg13cmos5l_decap_8
X_0324_ _0324_/Q Tile_X0Y1_FrameData[18] VGND VPWR Tile_X0Y5_FrameStrobe[0] latch
X_0255_ _0255_/Q Tile_X0Y0_FrameData[7] VGND VPWR Tile_X0Y5_FrameStrobe[5] latch
XFILLER_82_126 VPWR VGND sg13cmos5l_decap_8
XFILLER_208_195 VPWR VGND sg13cmos5l_fill_2
XFILLER_223_132 VPWR VGND sg13cmos5l_decap_8
X_0186_ _0186_/Q Tile_X0Y0_FrameData[12] VGND VPWR Tile_X0Y5_FrameStrobe[3] latch
XFILLER_210_42 VPWR VGND sg13cmos5l_decap_8
XFILLER_23_226 VPWR VGND sg13cmos5l_decap_4
XFILLER_23_237 VPWR VGND sg13cmos5l_fill_1
XFILLER_286_57 VPWR VGND sg13cmos5l_decap_8
XFILLER_136_128 VPWR VGND sg13cmos5l_fill_1
X_2827_ _2827_/X Tile_X0Y5_N2MID[2] Tile_X0Y5_N2END[2] _2831_/X _2715_/X _1284_/Q
+ _1283_/Q VPWR VGND sg13cmos5l_mux4_1
XFILLER_129_191 VPWR VGND sg13cmos5l_decap_8
XFILLER_219_84 VPWR VGND sg13cmos5l_decap_8
X_2758_ _2758_/X Tile_X0Y5_N4END[1] _0059_/X _2806_/X _2805_/X _1386_/Q _1385_/Q VPWR
+ VGND sg13cmos5l_mux4_1
XFILLER_155_28 VPWR VGND sg13cmos5l_decap_8
X_1709_ Tile_X0Y0_E6BEG[1] _2198_/X VPWR VGND sg13cmos5l_buf_1
XFILLER_144_194 VPWR VGND sg13cmos5l_decap_4
X_2689_ _2689_/X _2678_/X Tile_X0Y5_N4END[6] _2677_/X _0024_/X _1066_/Q _1065_/Q VPWR
+ VGND sg13cmos5l_mux4_1
XFILLER_58_112 VPWR VGND sg13cmos5l_decap_8
XFILLER_100_242 VPWR VGND sg13cmos5l_fill_1
XFILLER_171_49 VPWR VGND sg13cmos5l_decap_8
XANTENNA__1999__X Tile_X0Y5_EE4BEG[0] VPWR VGND sg13cmos5l_antennanp
XFILLER_104_43 VPWR VGND sg13cmos5l_decap_8
XFILLER_246_246 VPWR VGND sg13cmos5l_fill_1
XFILLER_273_7 VPWR VGND sg13cmos5l_decap_8
XFILLER_58_189 VPWR VGND sg13cmos5l_fill_2
XFILLER_64_14 VPWR VGND sg13cmos5l_decap_8
XFILLER_14_204 VPWR VGND sg13cmos5l_fill_2
XFILLER_120_42 VPWR VGND sg13cmos5l_decap_8
XFILLER_80_35 VPWR VGND sg13cmos5l_decap_8
XFILLER_196_35 VPWR VGND sg13cmos5l_decap_8
XFILLER_13_84 VPWR VGND sg13cmos5l_decap_8
XFILLER_182_201 VPWR VGND sg13cmos5l_fill_2
XFILLER_129_84 VPWR VGND sg13cmos5l_decap_8
XFILLER_89_22 VPWR VGND sg13cmos5l_decap_8
XFILLER_346_49 VPWR VGND sg13cmos5l_decap_8
XFILLER_135_172 VPWR VGND sg13cmos5l_decap_8
XFILLER_150_131 VPWR VGND sg13cmos5l_decap_8
XFILLER_8_0 VPWR VGND sg13cmos5l_decap_8
XFILLER_89_99 VPWR VGND sg13cmos5l_decap_8
XFILLER_296_168 VPWR VGND sg13cmos5l_decap_8
XFILLER_49_112 VPWR VGND sg13cmos5l_decap_8
XFILLER_1_196 VPWR VGND sg13cmos5l_fill_1
XFILLER_237_224 VPWR VGND sg13cmos5l_decap_4
XFILLER_237_235 VPWR VGND sg13cmos5l_fill_1
XFILLER_49_189 VPWR VGND sg13cmos5l_decap_8
XFILLER_38_70 VPWR VGND sg13cmos5l_decap_8
XANTENNA__1702__X Tile_X0Y0_EE4BEG[10] VPWR VGND sg13cmos5l_antennanp
X_0040_ _1614_/A _2267_/X _2268_/X _0518_/Q VPWR VGND sg13cmos5l_mux2_1
XFILLER_64_126 VPWR VGND sg13cmos5l_decap_8
XFILLER_205_110 VPWR VGND sg13cmos5l_fill_2
XFILLER_311_63 VPWR VGND sg13cmos5l_decap_8
XFILLER_260_271 VPWR VGND sg13cmos5l_fill_2
XFILLER_54_91 VPWR VGND sg13cmos5l_decap_8
XFILLER_220_146 VPWR VGND sg13cmos5l_decap_8
X_1991_ Tile_X0Y5_E6BEG[4] _2761_/X VPWR VGND sg13cmos5l_buf_1
XFILLER_158_253 VPWR VGND sg13cmos5l_decap_8
X_0942_ _0942_/Q Tile_X0Y3_FrameData[8] VGND VPWR Tile_X0Y5_FrameStrobe[4] latch
X_0873_ _0873_/Q Tile_X0Y3_FrameData[13] VGND VPWR Tile_X0Y5_FrameStrobe[2] latch
XFILLER_173_234 VPWR VGND sg13cmos5l_decap_8
XFILLER_173_256 VPWR VGND sg13cmos5l_fill_2
XFILLER_256_49 VPWR VGND sg13cmos5l_decap_8
X_2612_ _2612_/X Tile_X0Y5_W2MID[0] Tile_X0Y5_W2END[0] Tile_X0Y5_W6END[0] _2797_/X
+ _1474_/Q _1473_/Q VPWR VGND sg13cmos5l_mux4_1
XFILLER_126_150 VPWR VGND sg13cmos5l_decap_8
X_2543_ _2543_/X Tile_X0Y5_N4END[10] Tile_X0Y0_S4END[14] _2578_/X _2577_/X _0918_/Q
+ _0917_/Q VPWR VGND sg13cmos5l_mux4_1
XFILLER_141_131 VPWR VGND sg13cmos5l_fill_1
X_2474_ _2474_/X _2462_/X Tile_X0Y5_N4END[14] _2461_/X Tile_X0Y0_S4END[10] _0594_/Q
+ _0593_/Q VPWR VGND sg13cmos5l_mux4_1
X_1425_ _1425_/Q Tile_X0Y5_FrameData[31] VGND VPWR Tile_X0Y5_FrameStrobe[5] latch
XFILLER_205_42 VPWR VGND sg13cmos5l_decap_8
X_1356_ _1356_/Q Tile_X0Y5_FrameData[4] VGND VPWR Tile_X0Y5_FrameStrobe[2] latch
XFILLER_95_240 VPWR VGND sg13cmos5l_decap_8
XFILLER_228_268 VPWR VGND sg13cmos5l_decap_4
X_0307_ _0307_/Q Tile_X0Y0_FrameData[19] VGND VPWR Tile_X0Y5_FrameStrobe[7] latch
XFILLER_352_70 VPWR VGND sg13cmos5l_decap_8
XANTENNA__1612__X Tile_X0Y0_N4BEG[8] VPWR VGND sg13cmos5l_antennanp
XFILLER_243_216 VPWR VGND sg13cmos5l_fill_1
X_1287_ _1287_/Q Tile_X0Y5_FrameData[9] VGND VPWR Tile_X0Y5_FrameStrobe[0] latch
XFILLER_55_126 VPWR VGND sg13cmos5l_decap_8
X_0238_ _0238_/Q Tile_X0Y0_FrameData[24] VGND VPWR Tile_X0Y5_FrameStrobe[5] latch
XFILLER_221_63 VPWR VGND sg13cmos5l_decap_8
X_0169_ _0169_/Q Tile_X0Y0_FrameData[29] VGND VPWR Tile_X0Y5_FrameStrobe[3] latch
XFILLER_34_28 VPWR VGND sg13cmos5l_decap_8
XFILLER_211_102 VPWR VGND sg13cmos5l_decap_8
XFILLER_297_56 VPWR VGND sg13cmos5l_decap_8
XFILLER_149_242 VPWR VGND sg13cmos5l_decap_8
XFILLER_50_49 VPWR VGND sg13cmos5l_decap_8
XFILLER_119_7 VPWR VGND sg13cmos5l_decap_8
XFILLER_166_49 VPWR VGND sg13cmos5l_decap_8
XFILLER_117_161 VPWR VGND sg13cmos5l_decap_8
XFILLER_306_272 VPWR VGND sg13cmos5l_fill_1
XFILLER_59_14 VPWR VGND sg13cmos5l_decap_8
XFILLER_1_7 VPWR VGND sg13cmos5l_decap_8
XFILLER_293_105 VPWR VGND sg13cmos5l_decap_8
XFILLER_115_42 VPWR VGND sg13cmos5l_decap_8
XFILLER_293_138 VPWR VGND sg13cmos5l_decap_8
XFILLER_219_235 VPWR VGND sg13cmos5l_decap_8
XFILLER_262_70 VPWR VGND sg13cmos5l_decap_8
XFILLER_75_35 VPWR VGND sg13cmos5l_decap_8
XANTENNA__1522__X Tile_X0Y3_E2BEGb[4] VPWR VGND sg13cmos5l_antennanp
XFILLER_46_148 VPWR VGND sg13cmos5l_fill_1
XFILLER_234_238 VPWR VGND sg13cmos5l_decap_8
XFILLER_46_159 VPWR VGND sg13cmos5l_decap_4
XFILLER_131_63 VPWR VGND sg13cmos5l_decap_8
XFILLER_199_142 VPWR VGND sg13cmos5l_decap_8
XFILLER_91_56 VPWR VGND sg13cmos5l_decap_8
XFILLER_145_0 VPWR VGND sg13cmos5l_decap_8
XFILLER_312_0 VPWR VGND sg13cmos5l_decap_8
XFILLER_356_161 VPWR VGND sg13cmos5l_decap_8
XFILLER_170_226 VPWR VGND sg13cmos5l_decap_4
XFILLER_170_237 VPWR VGND sg13cmos5l_decap_8
XFILLER_170_248 VPWR VGND sg13cmos5l_fill_2
XFILLER_269_102 VPWR VGND sg13cmos5l_fill_2
XFILLER_69_207 VPWR VGND sg13cmos5l_decap_8
XFILLER_123_175 VPWR VGND sg13cmos5l_decap_4
XFILLER_284_105 VPWR VGND sg13cmos5l_decap_8
XFILLER_306_63 VPWR VGND sg13cmos5l_decap_8
XFILLER_34_7 VPWR VGND sg13cmos5l_decap_8
X_2190_ _2190_/X AXIL_S_SOC_WDATA21 AXIL_S_SOC_WDATA25 _2234_/X _2247_/X _0216_/Q
+ _0215_/Q VPWR VGND sg13cmos5l_mux4_1
X_1210_ _1210_/Q Tile_X0Y4_FrameData[12] VGND VPWR Tile_X0Y5_FrameStrobe[5] latch
XFILLER_49_91 VPWR VGND sg13cmos5l_decap_8
XFILLER_172_70 VPWR VGND sg13cmos5l_decap_8
XFILLER_1_21 VPWR VGND sg13cmos5l_decap_8
X_1141_ _1141_/Q Tile_X0Y4_FrameData[17] VGND VPWR Tile_X0Y5_FrameStrobe[3] latch
XFILLER_37_148 VPWR VGND sg13cmos5l_decap_4
XFILLER_37_126 VPWR VGND sg13cmos5l_decap_8
XFILLER_1_98 VPWR VGND sg13cmos5l_decap_8
XFILLER_225_249 VPWR VGND sg13cmos5l_fill_1
XFILLER_292_193 VPWR VGND sg13cmos5l_decap_8
XFILLER_322_84 VPWR VGND sg13cmos5l_decap_8
X_1072_ _1072_/Q Tile_X0Y4_FrameData[22] VGND VPWR Tile_X0Y5_FrameStrobe[1] latch
XFILLER_233_271 VPWR VGND sg13cmos5l_fill_2
XFILLER_60_140 VPWR VGND sg13cmos5l_decap_8
XANTENNA_180 AXIL_S_SOC_WDATA8 VPWR VGND sg13cmos5l_antennanp
XANTENNA_191 AXIL_S_SOC_WDATA9 VPWR VGND sg13cmos5l_antennanp
XFILLER_339_128 VPWR VGND sg13cmos5l_decap_8
X_1974_ Tile_X0Y5_E2BEG[3] _2728_/X VPWR VGND sg13cmos5l_buf_1
X_0925_ _0925_/Q Tile_X0Y3_FrameData[25] VGND VPWR Tile_X0Y5_FrameStrobe[4] latch
XFILLER_347_172 VPWR VGND sg13cmos5l_decap_8
XFILLER_161_204 VPWR VGND sg13cmos5l_fill_1
X_0856_ _0856_/Q Tile_X0Y3_FrameData[30] VGND VPWR Tile_X0Y5_FrameStrobe[2] latch
XFILLER_60_0 VPWR VGND sg13cmos5l_decap_8
XFILLER_362_164 VPWR VGND sg13cmos5l_decap_8
XANTENNA__1607__X Tile_X0Y0_N4BEG[3] VPWR VGND sg13cmos5l_antennanp
XFILLER_161_226 VPWR VGND sg13cmos5l_decap_8
XFILLER_283_14 VPWR VGND sg13cmos5l_decap_8
X_0787_ _0787_/Q Tile_X0Y2_FrameData[19] VGND VPWR Tile_X0Y5_FrameStrobe[7] latch
XFILLER_303_242 VPWR VGND sg13cmos5l_fill_1
XFILLER_303_253 VPWR VGND sg13cmos5l_decap_8
X_2526_ _2526_/X AXIL_S_SOC_ARADDR1 AXIL_S_SOC_ARADDR3 _2575_/X _2595_/X _0952_/Q
+ _0951_/Q VPWR VGND sg13cmos5l_mux4_1
XFILLER_114_186 VPWR VGND sg13cmos5l_decap_8
XFILLER_216_63 VPWR VGND sg13cmos5l_decap_8
X_2457_ _2457_/X Tile_X0Y1_W1END[0] Tile_X0Y1_W6END[8] _2361_/X _2337_/X _0418_/Q
+ _0417_/Q VPWR VGND sg13cmos5l_mux4_1
XFILLER_114_197 VPWR VGND sg13cmos5l_fill_2
XFILLER_29_28 VPWR VGND sg13cmos5l_decap_8
X_1408_ _1408_/Q Tile_X0Y5_FrameData[16] VGND VPWR Tile_X0Y5_FrameStrobe[4] latch
X_2388_ _2388_/X Tile_X0Y3_W2MID[4] Tile_X0Y3_W2END[4] Tile_X0Y3_W6END[4] _2592_/X
+ _1016_/Q _1015_/Q VPWR VGND sg13cmos5l_mux4_1
XFILLER_283_171 VPWR VGND sg13cmos5l_decap_4
XFILLER_290_119 VPWR VGND sg13cmos5l_decap_8
X_1339_ _1339_/Q Tile_X0Y5_FrameData[21] VGND VPWR Tile_X0Y5_FrameStrobe[2] latch
XFILLER_232_84 VPWR VGND sg13cmos5l_decap_8
XFILLER_45_49 VPWR VGND sg13cmos5l_decap_8
XFILLER_196_112 VPWR VGND sg13cmos5l_decap_8
XFILLER_51_140 VPWR VGND sg13cmos5l_decap_8
XFILLER_101_77 VPWR VGND sg13cmos5l_decap_8
XFILLER_236_7 VPWR VGND sg13cmos5l_decap_8
XFILLER_257_70 VPWR VGND sg13cmos5l_decap_8
XFILLER_193_14 VPWR VGND sg13cmos5l_decap_8
XFILLER_353_175 VPWR VGND sg13cmos5l_decap_8
XFILLER_10_63 VPWR VGND sg13cmos5l_decap_8
XFILLER_105_175 VPWR VGND sg13cmos5l_decap_8
XFILLER_120_112 VPWR VGND sg13cmos5l_decap_8
XFILLER_126_63 VPWR VGND sg13cmos5l_decap_8
XFILLER_343_28 VPWR VGND sg13cmos5l_decap_8
XFILLER_266_105 VPWR VGND sg13cmos5l_decap_8
XFILLER_273_91 VPWR VGND sg13cmos5l_decap_8
XFILLER_86_56 VPWR VGND sg13cmos5l_decap_8
XFILLER_266_149 VPWR VGND sg13cmos5l_decap_4
XFILLER_19_126 VPWR VGND sg13cmos5l_decap_8
XFILLER_281_119 VPWR VGND sg13cmos5l_decap_8
XFILLER_74_210 VPWR VGND sg13cmos5l_decap_8
XFILLER_142_84 VPWR VGND sg13cmos5l_decap_8
XFILLER_222_208 VPWR VGND sg13cmos5l_decap_8
XFILLER_262_0 VPWR VGND sg13cmos5l_decap_8
XFILLER_215_271 VPWR VGND sg13cmos5l_fill_2
XFILLER_187_112 VPWR VGND sg13cmos5l_decap_8
XANTENNA__2083__X Tile_X0Y5_UserCLKo VPWR VGND sg13cmos5l_antennanp
XFILLER_187_167 VPWR VGND sg13cmos5l_fill_1
XFILLER_230_252 VPWR VGND sg13cmos5l_decap_8
XFILLER_329_150 VPWR VGND sg13cmos5l_fill_2
XFILLER_89_8 VPWR VGND sg13cmos5l_decap_8
XFILLER_128_223 VPWR VGND sg13cmos5l_decap_8
X_0710_ _0710_/Q Tile_X0Y2_FrameData[0] VGND VPWR Tile_X0Y5_FrameStrobe[4] latch
XFILLER_51_70 VPWR VGND sg13cmos5l_decap_8
XFILLER_167_70 VPWR VGND sg13cmos5l_decap_8
X_1690_ Tile_X0Y0_FrameData_O[30] Tile_X0Y0_FrameData[30] VPWR VGND sg13cmos5l_buf_1
X_0641_ _0641_/Q Tile_X0Y2_FrameData[5] VGND VPWR Tile_X0Y5_FrameStrobe[2] latch
XFILLER_317_84 VPWR VGND sg13cmos5l_decap_8
X_0572_ _0572_/Q Tile_X0Y2_FrameData[10] VGND VPWR Tile_X0Y5_FrameStrobe[0] latch
XFILLER_111_112 VPWR VGND sg13cmos5l_decap_8
XFILLER_253_28 VPWR VGND sg13cmos5l_decap_8
XFILLER_297_252 VPWR VGND sg13cmos5l_fill_2
X_2311_ _2311_/X AXIL_S_SOC_WDATA2 AXIL_S_SOC_WDATA14 _2357_/X _2378_/X _0470_/Q _0469_/Q
+ VPWR VGND sg13cmos5l_mux4_1
XFILLER_183_91 VPWR VGND sg13cmos5l_decap_8
XFILLER_257_105 VPWR VGND sg13cmos5l_decap_8
X_2242_ _2242_/X _2252_/X _2251_/X Tile_X0Y0_S2MID[1] Tile_X0Y0_S2END[1] _0092_/Q
+ _0091_/Q VPWR VGND sg13cmos5l_mux4_1
X_2173_ _2173_/X AXIL_S_SOC_WDATA16 AXIL_S_SOC_WDATA24 _2241_/X _2248_/X _0250_/Q
+ _0249_/Q VPWR VGND sg13cmos5l_mux4_1
X_1124_ _1124_/Q Tile_X0Y4_FrameData[2] VGND VPWR Tile_X0Y5_FrameStrobe[2] latch
XFILLER_18_170 VPWR VGND sg13cmos5l_fill_2
XFILLER_202_21 VPWR VGND sg13cmos5l_decap_8
XFILLER_280_130 VPWR VGND sg13cmos5l_fill_2
X_1055_ _1055_/Q Tile_X0Y4_FrameData[7] VGND VPWR Tile_X0Y5_FrameStrobe[0] latch
XFILLER_178_112 VPWR VGND sg13cmos5l_decap_8
XFILLER_278_14 VPWR VGND sg13cmos5l_decap_8
XFILLER_193_137 VPWR VGND sg13cmos5l_decap_8
X_1957_ Tile_X0Y1_E2BEG[2] _2295_/X VPWR VGND sg13cmos5l_buf_1
XFILLER_358_91 VPWR VGND sg13cmos5l_decap_8
XFILLER_294_35 VPWR VGND sg13cmos5l_decap_8
X_1888_ Tile_X0Y1_FrameData_O[1] Tile_X0Y1_FrameData[1] VPWR VGND sg13cmos5l_buf_1
X_0908_ _0908_/Q Tile_X0Y3_FrameData[10] VGND VPWR Tile_X0Y5_FrameStrobe[3] latch
X_0839_ _0839_/Q Tile_X0Y3_FrameData[15] VGND VPWR Tile_X0Y5_FrameStrobe[1] latch
XFILLER_134_259 VPWR VGND sg13cmos5l_fill_1
XFILLER_350_156 VPWR VGND sg13cmos5l_decap_8
XFILLER_0_217 VPWR VGND sg13cmos5l_fill_2
XFILLER_163_28 VPWR VGND sg13cmos5l_decap_8
XFILLER_227_84 VPWR VGND sg13cmos5l_decap_8
X_2509_ _2509_/X AXIL_S_SOC_ARADDR0 AXIL_S_SOC_ARADDR8 _2589_/X _2596_/X _0986_/Q
+ _0985_/Q VPWR VGND sg13cmos5l_mux4_1
XFILLER_102_112 VPWR VGND sg13cmos5l_decap_4
XFILLER_248_105 VPWR VGND sg13cmos5l_decap_8
XFILLER_248_116 VPWR VGND sg13cmos5l_fill_1
XFILLER_186_7 VPWR VGND sg13cmos5l_decap_8
XFILLER_56_210 VPWR VGND sg13cmos5l_decap_8
XFILLER_112_21 VPWR VGND sg13cmos5l_decap_8
XANTENNA__1800__X Tile_X0Y4_E2BEGb[3] VPWR VGND sg13cmos5l_antennanp
XFILLER_72_14 VPWR VGND sg13cmos5l_decap_8
XFILLER_353_7 VPWR VGND sg13cmos5l_decap_8
XFILLER_112_98 VPWR VGND sg13cmos5l_decap_8
XFILLER_188_14 VPWR VGND sg13cmos5l_decap_8
XFILLER_212_230 VPWR VGND sg13cmos5l_decap_8
XFILLER_169_178 VPWR VGND sg13cmos5l_decap_8
XFILLER_184_126 VPWR VGND sg13cmos5l_decap_8
XFILLER_338_28 VPWR VGND sg13cmos5l_decap_8
XANTENNA_80 AXIL_S_SOC_WDATA25 VPWR VGND sg13cmos5l_antennanp
XANTENNA_91 AXIL_S_SOC_WDATA26 VPWR VGND sg13cmos5l_antennanp
XFILLER_341_112 VPWR VGND sg13cmos5l_decap_8
XFILLER_108_0 VPWR VGND sg13cmos5l_decap_8
XFILLER_21_84 VPWR VGND sg13cmos5l_decap_8
XFILLER_137_84 VPWR VGND sg13cmos5l_decap_8
XFILLER_354_49 VPWR VGND sg13cmos5l_decap_8
XFILLER_341_178 VPWR VGND sg13cmos5l_decap_8
XFILLER_239_105 VPWR VGND sg13cmos5l_decap_8
XFILLER_97_77 VPWR VGND sg13cmos5l_decap_8
XFILLER_294_233 VPWR VGND sg13cmos5l_decap_8
XFILLER_294_244 VPWR VGND sg13cmos5l_fill_2
XANTENNA__2078__X Tile_X0Y5_S4BEG[11] VPWR VGND sg13cmos5l_antennanp
XFILLER_254_119 VPWR VGND sg13cmos5l_decap_8
XFILLER_303_42 VPWR VGND sg13cmos5l_decap_8
XFILLER_47_232 VPWR VGND sg13cmos5l_decap_8
XANTENNA__1710__X Tile_X0Y0_E6BEG[2] VPWR VGND sg13cmos5l_antennanp
XFILLER_62_235 VPWR VGND sg13cmos5l_decap_8
XFILLER_46_92 VPWR VGND sg13cmos5l_decap_8
XFILLER_15_140 VPWR VGND sg13cmos5l_fill_2
XFILLER_203_241 VPWR VGND sg13cmos5l_decap_8
XFILLER_349_256 VPWR VGND sg13cmos5l_decap_4
XFILLER_30_132 VPWR VGND sg13cmos5l_fill_1
X_1811_ Tile_X0Y4_E6BEG[6] _2655_/X VPWR VGND sg13cmos5l_buf_1
XFILLER_62_91 VPWR VGND sg13cmos5l_decap_8
XFILLER_175_126 VPWR VGND sg13cmos5l_decap_8
XFILLER_178_91 VPWR VGND sg13cmos5l_decap_8
XFILLER_248_28 VPWR VGND sg13cmos5l_decap_8
X_2791_ _2791_/X Tile_X0Y5_N1END[2] _2795_/X Tile_X0Y5_W6END[2] _2791_/A3 _1268_/Q
+ _1267_/Q VPWR VGND sg13cmos5l_mux4_1
XFILLER_190_118 VPWR VGND sg13cmos5l_fill_2
X_1742_ Tile_X0Y2_FrameData_O[2] Tile_X0Y2_FrameData[2] VPWR VGND sg13cmos5l_buf_1
XFILLER_7_42 VPWR VGND sg13cmos5l_decap_8
X_1673_ Tile_X0Y0_FrameData_O[13] Tile_X0Y0_FrameData[13] VPWR VGND sg13cmos5l_buf_1
XFILLER_332_123 VPWR VGND sg13cmos5l_decap_4
X_0624_ _0624_/Q Tile_X0Y2_FrameData[22] VGND VPWR Tile_X0Y5_FrameStrobe[2] latch
XFILLER_264_49 VPWR VGND sg13cmos5l_decap_8
X_0555_ _0555_/Q Tile_X0Y2_FrameData[27] VGND VPWR Tile_X0Y5_FrameStrobe[0] latch
XFILLER_23_0 VPWR VGND sg13cmos5l_decap_8
XFILLER_285_244 VPWR VGND sg13cmos5l_decap_8
X_0486_ _0486_/Q Tile_X0Y1_FrameData[16] VGND VPWR Tile_X0Y5_FrameStrobe[5] latch
XFILLER_245_119 VPWR VGND sg13cmos5l_decap_8
X_2225_ _2225_/X _2214_/X _0066_/X Tile_X0Y0_S1END[1] Tile_X0Y0_S4END[1] _0100_/Q
+ _0099_/Q VPWR VGND sg13cmos5l_mux4_1
XFILLER_213_42 VPWR VGND sg13cmos5l_decap_8
XFILLER_238_182 VPWR VGND sg13cmos5l_decap_8
XFILLER_253_152 VPWR VGND sg13cmos5l_decap_8
X_2156_ _2156_/X _2238_/X _2237_/X _2226_/X _2225_/X _0283_/Q _0282_/Q VPWR VGND sg13cmos5l_mux4_1
XFILLER_360_92 VPWR VGND sg13cmos5l_decap_8
XANTENNA__1620__X Tile_X0Y0_N2BEGb[0] VPWR VGND sg13cmos5l_antennanp
XFILLER_289_35 VPWR VGND sg13cmos5l_decap_8
X_2087_ Tile_X0Y3_E1BEG[3] _2508_/X VPWR VGND sg13cmos5l_buf_1
X_1107_ _1107_/Q Tile_X0Y4_FrameData[19] VGND VPWR Tile_X0Y5_FrameStrobe[2] latch
XFILLER_53_224 VPWR VGND sg13cmos5l_decap_8
X_1038_ _1038_/Q Tile_X0Y4_FrameData[24] VGND VPWR Tile_X0Y5_FrameStrobe[0] latch
XFILLER_42_17 VPWR VGND sg13cmos5l_decap_8
XFILLER_158_28 VPWR VGND sg13cmos5l_decap_8
XFILLER_107_226 VPWR VGND sg13cmos5l_decap_8
XFILLER_323_112 VPWR VGND sg13cmos5l_decap_8
XFILLER_101_7 VPWR VGND sg13cmos5l_decap_8
XFILLER_107_21 VPWR VGND sg13cmos5l_decap_8
XFILLER_174_49 VPWR VGND sg13cmos5l_decap_8
XFILLER_323_156 VPWR VGND sg13cmos5l_fill_1
XFILLER_67_14 VPWR VGND sg13cmos5l_decap_8
XFILLER_107_98 VPWR VGND sg13cmos5l_decap_8
XFILLER_130_262 VPWR VGND sg13cmos5l_fill_2
XFILLER_236_119 VPWR VGND sg13cmos5l_decap_8
XFILLER_29_210 VPWR VGND sg13cmos5l_fill_1
XFILLER_123_42 VPWR VGND sg13cmos5l_decap_8
XFILLER_29_243 VPWR VGND sg13cmos5l_fill_1
XFILLER_270_70 VPWR VGND sg13cmos5l_decap_8
XFILLER_83_35 VPWR VGND sg13cmos5l_decap_8
XANTENNA__1530__X Tile_X0Y3_E6BEG[4] VPWR VGND sg13cmos5l_antennanp
XFILLER_199_35 VPWR VGND sg13cmos5l_decap_8
XFILLER_189_229 VPWR VGND sg13cmos5l_fill_2
XFILLER_244_196 VPWR VGND sg13cmos5l_fill_1
XFILLER_16_84 VPWR VGND sg13cmos5l_decap_8
XFILLER_12_154 VPWR VGND sg13cmos5l_decap_4
XFILLER_197_251 VPWR VGND sg13cmos5l_fill_1
XFILLER_200_222 VPWR VGND sg13cmos5l_decap_8
XFILLER_349_49 VPWR VGND sg13cmos5l_decap_8
XFILLER_225_0 VPWR VGND sg13cmos5l_decap_8
XFILLER_346_248 VPWR VGND sg13cmos5l_decap_8
XFILLER_12_198 VPWR VGND sg13cmos5l_fill_1
XFILLER_314_112 VPWR VGND sg13cmos5l_decap_8
XFILLER_180_140 VPWR VGND sg13cmos5l_decap_8
XFILLER_113_207 VPWR VGND sg13cmos5l_decap_8
XANTENNA__1705__X Tile_X0Y0_EE4BEG[13] VPWR VGND sg13cmos5l_antennanp
X_0340_ _0340_/Q Tile_X0Y1_FrameData[2] VGND VPWR Tile_X0Y5_FrameStrobe[0] latch
XFILLER_314_63 VPWR VGND sg13cmos5l_decap_8
X_0271_ _0271_/Q Tile_X0Y0_FrameData[23] VGND VPWR Tile_X0Y5_FrameStrobe[6] latch
XFILLER_79_187 VPWR VGND sg13cmos5l_decap_8
XFILLER_227_119 VPWR VGND sg13cmos5l_decap_4
X_2010_ Tile_X0Y5_EE4BEG[11] _2752_/X VPWR VGND sg13cmos5l_buf_1
XFILLER_180_70 VPWR VGND sg13cmos5l_decap_8
XFILLER_282_269 VPWR VGND sg13cmos5l_decap_4
XFILLER_57_91 VPWR VGND sg13cmos5l_decap_8
XFILLER_330_84 VPWR VGND sg13cmos5l_decap_8
XFILLER_50_205 VPWR VGND sg13cmos5l_decap_8
XFILLER_188_240 VPWR VGND sg13cmos5l_decap_8
XFILLER_259_49 VPWR VGND sg13cmos5l_decap_8
XFILLER_148_137 VPWR VGND sg13cmos5l_decap_8
X_2774_ _2774_/X Tile_X0Y5_W2MID[6] Tile_X0Y5_W2END[6] Tile_X0Y5_W6END[9] _2826_/X
+ _1354_/Q _1353_/Q VPWR VGND sg13cmos5l_mux4_1
X_1725_ Tile_X0Y0_E2BEGb[5] _2178_/X VPWR VGND sg13cmos5l_buf_1
XFILLER_208_42 VPWR VGND sg13cmos5l_decap_8
XFILLER_305_112 VPWR VGND sg13cmos5l_decap_8
XFILLER_171_151 VPWR VGND sg13cmos5l_decap_8
X_1656_ Tile_X0Y0_FrameStrobe_O[16] Tile_X0Y5_FrameStrobe[16] VPWR VGND sg13cmos5l_buf_1
XFILLER_355_70 VPWR VGND sg13cmos5l_decap_8
XANTENNA__1615__X Tile_X0Y0_N4BEG[11] VPWR VGND sg13cmos5l_antennanp
XFILLER_291_14 VPWR VGND sg13cmos5l_decap_8
XFILLER_305_189 VPWR VGND sg13cmos5l_fill_1
X_1587_ Tile_X0Y2_EE4BEG[0] _2417_/X VPWR VGND sg13cmos5l_buf_1
X_0607_ _0607_/Q Tile_X0Y2_FrameData[7] VGND VPWR Tile_X0Y5_FrameStrobe[1] latch
X_0538_ _0538_/Q Tile_X0Y1_FrameData[28] VGND VPWR Tile_X0Y5_FrameStrobe[7] latch
XFILLER_224_63 VPWR VGND sg13cmos5l_decap_8
X_0469_ _0469_/Q Tile_X0Y1_FrameData[1] VGND VPWR Tile_X0Y5_FrameStrobe[4] latch
XFILLER_37_28 VPWR VGND sg13cmos5l_decap_8
XFILLER_226_141 VPWR VGND sg13cmos5l_fill_2
XFILLER_273_269 VPWR VGND sg13cmos5l_decap_4
X_2208_ _2208_/X AXIL_S_SOC_WDATA19 _2240_/X _2239_/X _2248_/X _0180_/Q _0179_/Q VPWR
+ VGND sg13cmos5l_mux4_1
X_2139_ AXIL_S_SOC_RRESP1 Tile_X0Y5_W2MID[2] Tile_X0Y5_W2END[2] Tile_X0Y5_W6END[2]
+ _2827_/X _1324_/Q _1323_/Q VPWR VGND sg13cmos5l_mux4_1
XFILLER_226_196 VPWR VGND sg13cmos5l_fill_1
XFILLER_241_133 VPWR VGND sg13cmos5l_decap_8
XFILLER_240_84 VPWR VGND sg13cmos5l_decap_8
XFILLER_53_49 VPWR VGND sg13cmos5l_decap_8
XFILLER_139_104 VPWR VGND sg13cmos5l_fill_1
XFILLER_149_7 VPWR VGND sg13cmos5l_decap_8
XFILLER_169_49 VPWR VGND sg13cmos5l_decap_8
XFILLER_328_237 VPWR VGND sg13cmos5l_fill_1
XFILLER_316_7 VPWR VGND sg13cmos5l_decap_8
XFILLER_118_42 VPWR VGND sg13cmos5l_decap_8
XFILLER_147_181 VPWR VGND sg13cmos5l_decap_4
XFILLER_162_140 VPWR VGND sg13cmos5l_decap_8
XFILLER_265_70 VPWR VGND sg13cmos5l_decap_8
XFILLER_311_126 VPWR VGND sg13cmos5l_fill_2
XFILLER_78_35 VPWR VGND sg13cmos5l_decap_8
XANTENNA__1525__X Tile_X0Y3_E2BEGb[7] VPWR VGND sg13cmos5l_antennanp
XFILLER_103_251 VPWR VGND sg13cmos5l_decap_8
XFILLER_249_244 VPWR VGND sg13cmos5l_fill_1
XFILLER_351_28 VPWR VGND sg13cmos5l_decap_8
XFILLER_134_63 VPWR VGND sg13cmos5l_decap_8
XFILLER_264_214 VPWR VGND sg13cmos5l_fill_1
XFILLER_264_225 VPWR VGND sg13cmos5l_fill_1
XFILLER_281_91 VPWR VGND sg13cmos5l_decap_8
XFILLER_94_56 VPWR VGND sg13cmos5l_decap_8
XFILLER_175_0 VPWR VGND sg13cmos5l_decap_8
XFILLER_232_133 VPWR VGND sg13cmos5l_decap_8
XFILLER_300_21 VPWR VGND sg13cmos5l_decap_8
XFILLER_342_0 VPWR VGND sg13cmos5l_decap_4
XFILLER_232_177 VPWR VGND sg13cmos5l_decap_8
XFILLER_232_199 VPWR VGND sg13cmos5l_decap_8
XFILLER_300_98 VPWR VGND sg13cmos5l_decap_8
XFILLER_319_237 VPWR VGND sg13cmos5l_fill_2
XFILLER_40_271 VPWR VGND sg13cmos5l_fill_2
XANTENNA__2091__X Tile_X0Y3_E2BEG[3] VPWR VGND sg13cmos5l_antennanp
XFILLER_138_192 VPWR VGND sg13cmos5l_decap_8
XFILLER_309_63 VPWR VGND sg13cmos5l_decap_8
XFILLER_64_7 VPWR VGND sg13cmos5l_decap_8
XFILLER_175_70 VPWR VGND sg13cmos5l_decap_8
XFILLER_299_133 VPWR VGND sg13cmos5l_decap_8
X_1510_ _2340_/A3 VPWR VGND sg13cmos5l_tielo
X_2490_ _2490_/X Tile_X0Y4_W2MID[7] Tile_X0Y4_W2END[7] Tile_X0Y4_W6END[7] _2708_/X
+ _1256_/Q _1255_/Q VPWR VGND sg13cmos5l_mux4_1
XFILLER_99_205 VPWR VGND sg13cmos5l_decap_8
XFILLER_302_126 VPWR VGND sg13cmos5l_decap_8
X_1441_ _1441_/Q Tile_X0Y5_FrameData[15] VGND VPWR Tile_X0Y5_FrameStrobe[5] latch
XFILLER_4_21 VPWR VGND sg13cmos5l_decap_8
XFILLER_4_161 VPWR VGND sg13cmos5l_decap_8
XFILLER_325_84 VPWR VGND sg13cmos5l_decap_8
X_1372_ _1372_/Q Tile_X0Y5_FrameData[20] VGND VPWR Tile_X0Y5_FrameStrobe[3] latch
XFILLER_4_98 VPWR VGND sg13cmos5l_decap_8
XFILLER_191_91 VPWR VGND sg13cmos5l_decap_8
XFILLER_255_236 VPWR VGND sg13cmos5l_fill_2
XFILLER_261_28 VPWR VGND sg13cmos5l_decap_8
X_0323_ _0323_/Q Tile_X0Y1_FrameData[19] VGND VPWR Tile_X0Y5_FrameStrobe[0] latch
X_0254_ _0254_/Q Tile_X0Y0_FrameData[8] VGND VPWR Tile_X0Y5_FrameStrobe[5] latch
XFILLER_82_105 VPWR VGND sg13cmos5l_decap_8
XFILLER_208_174 VPWR VGND sg13cmos5l_decap_8
X_0185_ _0185_/Q Tile_X0Y0_FrameData[13] VGND VPWR Tile_X0Y5_FrameStrobe[3] latch
XFILLER_210_21 VPWR VGND sg13cmos5l_decap_8
XFILLER_90_0 VPWR VGND sg13cmos5l_decap_4
XFILLER_31_271 VPWR VGND sg13cmos5l_fill_2
XFILLER_286_36 VPWR VGND sg13cmos5l_decap_8
X_2826_ _2826_/X Tile_X0Y5_N2MID[1] Tile_X0Y5_N2END[1] _2830_/X _2714_/X _1286_/Q
+ _1285_/Q VPWR VGND sg13cmos5l_mux4_1
XFILLER_219_63 VPWR VGND sg13cmos5l_decap_8
X_2757_ _2757_/X Tile_X0Y5_N4END[0] _0032_/X _2802_/X _2801_/X _1388_/Q _1387_/Q VPWR
+ VGND sg13cmos5l_mux4_1
X_1708_ Tile_X0Y0_E6BEG[0] _2197_/X VPWR VGND sg13cmos5l_buf_1
X_2688_ _2688_/X _2678_/X Tile_X0Y5_N4END[6] _2677_/X _0024_/X _1058_/Q _1057_/Q VPWR
+ VGND sg13cmos5l_mux4_1
X_1639_ Tile_X0Y0_N1BEG[3] _2144_/X VPWR VGND sg13cmos5l_buf_1
XFILLER_235_84 VPWR VGND sg13cmos5l_decap_8
XFILLER_98_271 VPWR VGND sg13cmos5l_fill_2
XFILLER_100_221 VPWR VGND sg13cmos5l_decap_8
XFILLER_100_232 VPWR VGND sg13cmos5l_fill_1
XFILLER_171_28 VPWR VGND sg13cmos5l_decap_8
XFILLER_104_22 VPWR VGND sg13cmos5l_decap_8
XFILLER_73_105 VPWR VGND sg13cmos5l_fill_2
XFILLER_58_168 VPWR VGND sg13cmos5l_decap_8
XFILLER_66_190 VPWR VGND sg13cmos5l_decap_8
XFILLER_104_99 VPWR VGND sg13cmos5l_decap_8
XFILLER_214_133 VPWR VGND sg13cmos5l_fill_2
XFILLER_266_7 VPWR VGND sg13cmos5l_decap_8
XFILLER_120_21 VPWR VGND sg13cmos5l_decap_8
XFILLER_81_171 VPWR VGND sg13cmos5l_fill_1
XFILLER_214_188 VPWR VGND sg13cmos5l_decap_4
XFILLER_80_14 VPWR VGND sg13cmos5l_decap_8
XFILLER_120_98 VPWR VGND sg13cmos5l_decap_8
XFILLER_196_14 VPWR VGND sg13cmos5l_decap_8
XFILLER_167_243 VPWR VGND sg13cmos5l_decap_8
XFILLER_13_63 VPWR VGND sg13cmos5l_decap_8
XFILLER_129_63 VPWR VGND sg13cmos5l_decap_8
XFILLER_346_28 VPWR VGND sg13cmos5l_decap_8
XFILLER_276_91 VPWR VGND sg13cmos5l_decap_8
XFILLER_150_110 VPWR VGND sg13cmos5l_decap_8
XFILLER_296_147 VPWR VGND sg13cmos5l_decap_8
XFILLER_145_84 VPWR VGND sg13cmos5l_decap_8
XFILLER_292_0 VPWR VGND sg13cmos5l_decap_8
XFILLER_362_49 VPWR VGND sg13cmos5l_decap_8
XFILLER_237_203 VPWR VGND sg13cmos5l_decap_8
XFILLER_237_258 VPWR VGND sg13cmos5l_fill_2
XFILLER_64_105 VPWR VGND sg13cmos5l_decap_8
XFILLER_49_168 VPWR VGND sg13cmos5l_decap_8
XANTENNA__2086__X Tile_X0Y3_E1BEG[2] VPWR VGND sg13cmos5l_antennanp
XFILLER_311_42 VPWR VGND sg13cmos5l_decap_8
XFILLER_205_155 VPWR VGND sg13cmos5l_decap_4
XFILLER_220_125 VPWR VGND sg13cmos5l_decap_8
X_1990_ Tile_X0Y5_E6BEG[3] _2760_/X VPWR VGND sg13cmos5l_buf_1
XFILLER_54_70 VPWR VGND sg13cmos5l_decap_8
X_0941_ _0941_/Q Tile_X0Y3_FrameData[9] VGND VPWR Tile_X0Y5_FrameStrobe[4] latch
XFILLER_13_271 VPWR VGND sg13cmos5l_fill_2
XFILLER_158_232 VPWR VGND sg13cmos5l_decap_8
XFILLER_173_213 VPWR VGND sg13cmos5l_decap_8
X_0872_ _0872_/Q Tile_X0Y3_FrameData[14] VGND VPWR Tile_X0Y5_FrameStrobe[2] latch
XFILLER_9_264 VPWR VGND sg13cmos5l_fill_1
XFILLER_256_28 VPWR VGND sg13cmos5l_decap_8
X_2611_ _2611_/X Tile_X0Y2_W1END[3] Tile_X0Y2_W2MID[0] Tile_X0Y2_W2END[0] _2488_/X
+ _0636_/Q _0635_/Q VPWR VGND sg13cmos5l_mux4_1
XFILLER_70_91 VPWR VGND sg13cmos5l_decap_8
XFILLER_126_140 VPWR VGND sg13cmos5l_fill_2
XFILLER_186_91 VPWR VGND sg13cmos5l_decap_8
X_2542_ _2542_/X Tile_X0Y5_N4END[9] Tile_X0Y0_S4END[13] _2576_/X _2575_/X _0920_/Q
+ _0919_/Q VPWR VGND sg13cmos5l_mux4_1
XFILLER_287_147 VPWR VGND sg13cmos5l_fill_2
X_2473_ _2473_/X _2464_/X Tile_X0Y5_N4END[15] _2463_/X Tile_X0Y0_S4END[11] _0592_/Q
+ _0591_/Q VPWR VGND sg13cmos5l_mux4_1
XFILLER_141_198 VPWR VGND sg13cmos5l_decap_4
XFILLER_205_21 VPWR VGND sg13cmos5l_decap_8
XFILLER_272_49 VPWR VGND sg13cmos5l_decap_8
X_1424_ _1424_/Q Tile_X0Y5_FrameData[0] VGND VPWR Tile_X0Y5_FrameStrobe[4] latch
X_1355_ _1355_/Q Tile_X0Y5_FrameData[5] VGND VPWR Tile_X0Y5_FrameStrobe[2] latch
X_0306_ _0306_/Q Tile_X0Y0_FrameData[20] VGND VPWR Tile_X0Y5_FrameStrobe[7] latch
XFILLER_55_105 VPWR VGND sg13cmos5l_decap_8
X_1286_ _1286_/Q Tile_X0Y5_FrameData[10] VGND VPWR Tile_X0Y5_FrameStrobe[0] latch
XFILLER_221_42 VPWR VGND sg13cmos5l_decap_8
X_0237_ _0237_/Q Tile_X0Y0_FrameData[25] VGND VPWR Tile_X0Y5_FrameStrobe[5] latch
X_0168_ _0168_/Q Tile_X0Y0_FrameData[30] VGND VPWR Tile_X0Y5_FrameStrobe[3] latch
XFILLER_70_119 VPWR VGND sg13cmos5l_decap_8
XFILLER_297_35 VPWR VGND sg13cmos5l_decap_8
X_0099_ _0099_/Q Tile_X0Y0_FrameData[3] VGND VPWR Tile_X0Y5_FrameStrobe[0] latch
XFILLER_164_213 VPWR VGND sg13cmos5l_fill_2
XFILLER_50_28 VPWR VGND sg13cmos5l_decap_8
XFILLER_164_246 VPWR VGND sg13cmos5l_fill_2
XFILLER_166_28 VPWR VGND sg13cmos5l_decap_8
X_2809_ _2809_/X Tile_X0Y5_N1END[1] Tile_X0Y5_N4END[1] _2794_/X _0059_/X _1294_/Q
+ _1293_/Q VPWR VGND sg13cmos5l_mux4_1
XFILLER_117_140 VPWR VGND sg13cmos5l_decap_8
XFILLER_321_243 VPWR VGND sg13cmos5l_fill_2
XFILLER_115_21 VPWR VGND sg13cmos5l_decap_8
XFILLER_132_187 VPWR VGND sg13cmos5l_decap_8
XFILLER_182_49 VPWR VGND sg13cmos5l_decap_8
XANTENNA__1803__X Tile_X0Y4_E2BEGb[6] VPWR VGND sg13cmos5l_antennanp
XFILLER_286_191 VPWR VGND sg13cmos5l_fill_1
XFILLER_75_14 VPWR VGND sg13cmos5l_decap_8
XFILLER_115_98 VPWR VGND sg13cmos5l_decap_8
XFILLER_131_42 VPWR VGND sg13cmos5l_decap_8
XFILLER_61_119 VPWR VGND sg13cmos5l_decap_8
XFILLER_199_165 VPWR VGND sg13cmos5l_fill_1
XFILLER_242_272 VPWR VGND sg13cmos5l_fill_1
XFILLER_91_35 VPWR VGND sg13cmos5l_decap_8
XFILLER_54_182 VPWR VGND sg13cmos5l_decap_8
XFILLER_199_187 VPWR VGND sg13cmos5l_fill_2
XFILLER_138_0 VPWR VGND sg13cmos5l_decap_8
XFILLER_24_84 VPWR VGND sg13cmos5l_decap_8
XFILLER_357_49 VPWR VGND sg13cmos5l_decap_8
XFILLER_356_140 VPWR VGND sg13cmos5l_decap_8
XFILLER_155_257 VPWR VGND sg13cmos5l_decap_4
XFILLER_155_268 VPWR VGND sg13cmos5l_decap_4
XFILLER_170_205 VPWR VGND sg13cmos5l_decap_8
XFILLER_305_0 VPWR VGND sg13cmos5l_decap_8
XFILLER_123_154 VPWR VGND sg13cmos5l_decap_8
XFILLER_269_136 VPWR VGND sg13cmos5l_fill_2
XFILLER_306_42 VPWR VGND sg13cmos5l_decap_8
XFILLER_27_7 VPWR VGND sg13cmos5l_decap_8
XFILLER_49_70 VPWR VGND sg13cmos5l_decap_8
XANTENNA__1713__X Tile_X0Y0_E6BEG[5] VPWR VGND sg13cmos5l_antennanp
X_1140_ _1140_/Q Tile_X0Y4_FrameData[18] VGND VPWR Tile_X0Y5_FrameStrobe[3] latch
XFILLER_37_105 VPWR VGND sg13cmos5l_decap_8
XFILLER_1_77 VPWR VGND sg13cmos5l_decap_8
XFILLER_225_228 VPWR VGND sg13cmos5l_decap_8
XFILLER_292_172 VPWR VGND sg13cmos5l_decap_8
XFILLER_322_63 VPWR VGND sg13cmos5l_decap_8
X_1071_ _1071_/Q Tile_X0Y4_FrameData[23] VGND VPWR Tile_X0Y5_FrameStrobe[1] latch
XFILLER_65_91 VPWR VGND sg13cmos5l_decap_8
XFILLER_52_119 VPWR VGND sg13cmos5l_decap_8
XANTENNA_170 AXIL_S_SOC_WDATA8 VPWR VGND sg13cmos5l_antennanp
XANTENNA_181 AXIL_S_SOC_WDATA8 VPWR VGND sg13cmos5l_antennanp
XANTENNA_192 AXIL_S_SOC_WDATA9 VPWR VGND sg13cmos5l_antennanp
X_1973_ Tile_X0Y5_E2BEG[2] _2727_/X VPWR VGND sg13cmos5l_buf_1
XFILLER_60_196 VPWR VGND sg13cmos5l_decap_8
XFILLER_267_49 VPWR VGND sg13cmos5l_decap_8
X_0924_ _0924_/Q Tile_X0Y3_FrameData[26] VGND VPWR Tile_X0Y5_FrameStrobe[4] latch
X_0855_ _0855_/Q Tile_X0Y3_FrameData[31] VGND VPWR Tile_X0Y5_FrameStrobe[2] latch
XFILLER_146_268 VPWR VGND sg13cmos5l_decap_4
XFILLER_362_143 VPWR VGND sg13cmos5l_decap_8
XFILLER_303_210 VPWR VGND sg13cmos5l_fill_1
X_0786_ _0786_/Q Tile_X0Y2_FrameData[20] VGND VPWR Tile_X0Y5_FrameStrobe[7] latch
XFILLER_53_0 VPWR VGND sg13cmos5l_decap_8
XFILLER_347_93 VPWR VGND sg13cmos5l_decap_8
XFILLER_114_154 VPWR VGND sg13cmos5l_decap_8
X_2525_ _2525_/X AXIL_S_SOC_ARADDR0 AXIL_S_SOC_ARADDR2 _2573_/X _2596_/X _0954_/Q
+ _0953_/Q VPWR VGND sg13cmos5l_mux4_1
XFILLER_216_42 VPWR VGND sg13cmos5l_decap_8
XFILLER_303_265 VPWR VGND sg13cmos5l_fill_1
X_2456_ _2456_/X _2464_/X _2463_/X Tile_X0Y2_W6END[3] _2456_/A3 _0552_/Q _0791_/Q
+ VPWR VGND sg13cmos5l_mux4_1
XFILLER_275_117 VPWR VGND sg13cmos5l_fill_2
X_1407_ _1407_/Q Tile_X0Y5_FrameData[17] VGND VPWR Tile_X0Y5_FrameStrobe[4] latch
XANTENNA__1623__X Tile_X0Y0_N2BEGb[3] VPWR VGND sg13cmos5l_antennanp
XFILLER_28_105 VPWR VGND sg13cmos5l_decap_8
X_2387_ _2387_/X Tile_X0Y0_W2MID[4] Tile_X0Y0_W2END[4] Tile_X0Y0_W6END[11] _2244_/X
+ _0164_/Q _0163_/Q VPWR VGND sg13cmos5l_mux4_1
X_1338_ _1338_/Q Tile_X0Y5_FrameData[22] VGND VPWR Tile_X0Y5_FrameStrobe[2] latch
XFILLER_83_200 VPWR VGND sg13cmos5l_fill_2
XFILLER_216_228 VPWR VGND sg13cmos5l_decap_8
XFILLER_216_239 VPWR VGND sg13cmos5l_fill_1
XFILLER_232_63 VPWR VGND sg13cmos5l_decap_8
XFILLER_283_183 VPWR VGND sg13cmos5l_fill_1
X_1269_ _1269_/Q Tile_X0Y5_FrameData[27] VGND VPWR Tile_X0Y5_FrameStrobe[0] latch
XFILLER_45_28 VPWR VGND sg13cmos5l_decap_8
XFILLER_43_119 VPWR VGND sg13cmos5l_decap_8
XFILLER_36_171 VPWR VGND sg13cmos5l_fill_2
XFILLER_36_160 VPWR VGND sg13cmos5l_decap_8
XFILLER_101_56 VPWR VGND sg13cmos5l_decap_8
XFILLER_196_168 VPWR VGND sg13cmos5l_decap_8
XFILLER_61_49 VPWR VGND sg13cmos5l_decap_8
XFILLER_51_196 VPWR VGND sg13cmos5l_decap_8
XFILLER_131_7 VPWR VGND sg13cmos5l_decap_8
XFILLER_177_49 VPWR VGND sg13cmos5l_decap_8
XFILLER_229_7 VPWR VGND sg13cmos5l_decap_8
XFILLER_338_151 VPWR VGND sg13cmos5l_fill_2
XFILLER_137_268 VPWR VGND sg13cmos5l_decap_4
XFILLER_353_154 VPWR VGND sg13cmos5l_decap_8
XFILLER_298_209 VPWR VGND sg13cmos5l_decap_8
XFILLER_10_42 VPWR VGND sg13cmos5l_decap_8
XFILLER_105_154 VPWR VGND sg13cmos5l_decap_8
XFILLER_126_42 VPWR VGND sg13cmos5l_decap_8
XFILLER_160_271 VPWR VGND sg13cmos5l_fill_2
XFILLER_105_198 VPWR VGND sg13cmos5l_fill_2
XFILLER_273_70 VPWR VGND sg13cmos5l_decap_8
XFILLER_86_35 VPWR VGND sg13cmos5l_decap_8
XANTENNA__1533__X Tile_X0Y3_E6BEG[7] VPWR VGND sg13cmos5l_antennanp
XFILLER_120_168 VPWR VGND sg13cmos5l_decap_8
XFILLER_19_105 VPWR VGND sg13cmos5l_decap_8
XFILLER_59_241 VPWR VGND sg13cmos5l_decap_8
XFILLER_207_206 VPWR VGND sg13cmos5l_fill_1
XFILLER_142_63 VPWR VGND sg13cmos5l_decap_8
XFILLER_19_149 VPWR VGND sg13cmos5l_decap_8
XFILLER_19_84 VPWR VGND sg13cmos5l_decap_8
XFILLER_34_119 VPWR VGND sg13cmos5l_decap_4
XFILLER_255_0 VPWR VGND sg13cmos5l_decap_8
XFILLER_230_231 VPWR VGND sg13cmos5l_decap_8
XFILLER_128_202 VPWR VGND sg13cmos5l_decap_8
XFILLER_195_190 VPWR VGND sg13cmos5l_fill_1
XANTENNA__1708__X Tile_X0Y0_E6BEG[0] VPWR VGND sg13cmos5l_antennanp
XFILLER_344_154 VPWR VGND sg13cmos5l_fill_1
X_0640_ _0640_/Q Tile_X0Y2_FrameData[6] VGND VPWR Tile_X0Y5_FrameStrobe[2] latch
XFILLER_317_63 VPWR VGND sg13cmos5l_decap_8
X_0571_ _0571_/Q Tile_X0Y2_FrameData[11] VGND VPWR Tile_X0Y5_FrameStrobe[0] latch
XFILLER_151_271 VPWR VGND sg13cmos5l_fill_2
XFILLER_297_231 VPWR VGND sg13cmos5l_decap_8
X_2310_ _2310_/X AXIL_S_SOC_WDATA1 AXIL_S_SOC_WDATA13 _2353_/X _2379_/X _0472_/Q _0471_/Q
+ VPWR VGND sg13cmos5l_mux4_1
XFILLER_183_70 VPWR VGND sg13cmos5l_decap_8
X_2241_ _2241_/X _2250_/X _2249_/X Tile_X0Y0_S2MID[0] Tile_X0Y0_S2END[0] _0094_/Q
+ _0093_/Q VPWR VGND sg13cmos5l_mux4_1
XFILLER_111_168 VPWR VGND sg13cmos5l_decap_8
XFILLER_300_246 VPWR VGND sg13cmos5l_decap_8
XFILLER_333_84 VPWR VGND sg13cmos5l_decap_8
XFILLER_333_95 VPWR VGND sg13cmos5l_fill_1
X_2172_ _2172_/X AXIL_S_SOC_WDATA23 AXIL_S_SOC_WDATA31 _2241_/X _2248_/X _0252_/Q
+ _0251_/Q VPWR VGND sg13cmos5l_mux4_1
X_1123_ _1123_/Q Tile_X0Y4_FrameData[3] VGND VPWR Tile_X0Y5_FrameStrobe[2] latch
X_1054_ _1054_/Q Tile_X0Y4_FrameData[8] VGND VPWR Tile_X0Y5_FrameStrobe[0] latch
XFILLER_18_193 VPWR VGND sg13cmos5l_decap_4
XFILLER_202_77 VPWR VGND sg13cmos5l_decap_8
XFILLER_206_250 VPWR VGND sg13cmos5l_decap_8
XFILLER_206_272 VPWR VGND sg13cmos5l_fill_1
XFILLER_280_186 VPWR VGND sg13cmos5l_decap_8
XFILLER_119_202 VPWR VGND sg13cmos5l_fill_2
XFILLER_178_168 VPWR VGND sg13cmos5l_decap_8
XFILLER_193_105 VPWR VGND sg13cmos5l_decap_4
X_1956_ Tile_X0Y1_E2BEG[1] _2294_/X VPWR VGND sg13cmos5l_buf_1
XFILLER_335_110 VPWR VGND sg13cmos5l_fill_2
X_0907_ _0907_/Q Tile_X0Y3_FrameData[11] VGND VPWR Tile_X0Y5_FrameStrobe[3] latch
XFILLER_358_70 VPWR VGND sg13cmos5l_decap_8
XANTENNA__1618__X Tile_X0Y0_N4BEG[14] VPWR VGND sg13cmos5l_antennanp
XFILLER_294_14 VPWR VGND sg13cmos5l_decap_8
X_1887_ Tile_X0Y1_FrameData_O[0] Tile_X0Y1_FrameData[0] VPWR VGND sg13cmos5l_buf_1
XFILLER_134_227 VPWR VGND sg13cmos5l_decap_8
XFILLER_134_238 VPWR VGND sg13cmos5l_fill_2
X_0838_ _0838_/Q Tile_X0Y3_FrameData[16] VGND VPWR Tile_X0Y5_FrameStrobe[1] latch
XFILLER_227_63 VPWR VGND sg13cmos5l_decap_8
X_0769_ _0769_/Q Tile_X0Y2_FrameData[5] VGND VPWR Tile_X0Y5_FrameStrobe[6] latch
XFILLER_350_135 VPWR VGND sg13cmos5l_decap_8
X_2508_ _2508_/X _2572_/X _2571_/X AXIL_S_SOC_ARADDR1 AXIL_S_SOC_ARADDR4 _0988_/Q
+ _0987_/Q VPWR VGND sg13cmos5l_mux4_1
XFILLER_102_168 VPWR VGND sg13cmos5l_decap_4
X_2439_ _2439_/X AXIL_S_SOC_AWADDR6 _2477_/X _2470_/X _2483_/X _0670_/Q _0669_/Q VPWR
+ VGND sg13cmos5l_mux4_1
XFILLER_243_84 VPWR VGND sg13cmos5l_decap_8
XFILLER_56_49 VPWR VGND sg13cmos5l_decap_8
XFILLER_16_119 VPWR VGND sg13cmos5l_decap_8
XFILLER_179_7 VPWR VGND sg13cmos5l_decap_8
XFILLER_271_131 VPWR VGND sg13cmos5l_fill_1
XFILLER_112_77 VPWR VGND sg13cmos5l_decap_8
XFILLER_71_236 VPWR VGND sg13cmos5l_fill_1
XFILLER_346_7 VPWR VGND sg13cmos5l_decap_8
XFILLER_169_135 VPWR VGND sg13cmos5l_fill_1
XFILLER_24_185 VPWR VGND sg13cmos5l_decap_8
XFILLER_358_257 VPWR VGND sg13cmos5l_fill_1
XFILLER_358_224 VPWR VGND sg13cmos5l_fill_2
XFILLER_184_105 VPWR VGND sg13cmos5l_decap_8
XFILLER_268_70 VPWR VGND sg13cmos5l_decap_8
XANTENNA_70 AXIL_S_SOC_WDATA23 VPWR VGND sg13cmos5l_antennanp
XANTENNA_81 AXIL_S_SOC_WDATA25 VPWR VGND sg13cmos5l_antennanp
XANTENNA_92 AXIL_S_SOC_WDATA26 VPWR VGND sg13cmos5l_antennanp
XANTENNA__1528__X Tile_X0Y3_E6BEG[2] VPWR VGND sg13cmos5l_antennanp
XFILLER_21_63 VPWR VGND sg13cmos5l_decap_8
XFILLER_137_63 VPWR VGND sg13cmos5l_decap_8
XFILLER_354_28 VPWR VGND sg13cmos5l_decap_8
XFILLER_284_91 VPWR VGND sg13cmos5l_decap_8
XFILLER_97_56 VPWR VGND sg13cmos5l_decap_8
XFILLER_341_168 VPWR VGND sg13cmos5l_fill_2
XFILLER_133_271 VPWR VGND sg13cmos5l_fill_2
XFILLER_153_84 VPWR VGND sg13cmos5l_decap_8
XFILLER_247_150 VPWR VGND sg13cmos5l_decap_8
XFILLER_47_211 VPWR VGND sg13cmos5l_decap_8
XFILLER_303_21 VPWR VGND sg13cmos5l_decap_8
XFILLER_47_255 VPWR VGND sg13cmos5l_fill_1
XFILLER_303_98 VPWR VGND sg13cmos5l_decap_8
XFILLER_46_71 VPWR VGND sg13cmos5l_decap_8
XANTENNA__2094__X Tile_X0Y3_E2BEG[6] VPWR VGND sg13cmos5l_antennanp
XFILLER_262_197 VPWR VGND sg13cmos5l_decap_8
XFILLER_94_7 VPWR VGND sg13cmos5l_decap_8
XFILLER_349_224 VPWR VGND sg13cmos5l_decap_4
XFILLER_175_105 VPWR VGND sg13cmos5l_decap_8
X_1810_ Tile_X0Y4_E6BEG[5] _2654_/X VPWR VGND sg13cmos5l_buf_1
XFILLER_62_70 VPWR VGND sg13cmos5l_decap_8
XFILLER_178_70 VPWR VGND sg13cmos5l_decap_8
XFILLER_30_177 VPWR VGND sg13cmos5l_decap_4
X_2790_ _2790_/X Tile_X0Y5_N1END[1] _2794_/X Tile_X0Y5_W6END[1] _2790_/A3 _1270_/Q
+ _1269_/Q VPWR VGND sg13cmos5l_mux4_1
XFILLER_7_21 VPWR VGND sg13cmos5l_decap_8
X_1741_ Tile_X0Y2_FrameData_O[1] Tile_X0Y2_FrameData[1] VPWR VGND sg13cmos5l_buf_1
XFILLER_116_227 VPWR VGND sg13cmos5l_decap_8
XFILLER_328_84 VPWR VGND sg13cmos5l_decap_8
X_1672_ Tile_X0Y0_FrameData_O[12] Tile_X0Y0_FrameData[12] VPWR VGND sg13cmos5l_buf_1
XFILLER_116_238 VPWR VGND sg13cmos5l_fill_1
XFILLER_264_28 VPWR VGND sg13cmos5l_decap_8
X_0623_ _0623_/Q Tile_X0Y2_FrameData[23] VGND VPWR Tile_X0Y5_FrameStrobe[2] latch
XFILLER_131_219 VPWR VGND sg13cmos5l_fill_2
XFILLER_194_91 VPWR VGND sg13cmos5l_decap_8
XFILLER_124_271 VPWR VGND sg13cmos5l_fill_2
X_0554_ _0554_/Q Tile_X0Y2_FrameData[28] VGND VPWR Tile_X0Y5_FrameStrobe[0] latch
XFILLER_97_133 VPWR VGND sg13cmos5l_decap_8
X_0485_ _0485_/Q Tile_X0Y1_FrameData[17] VGND VPWR Tile_X0Y5_FrameStrobe[5] latch
XFILLER_280_49 VPWR VGND sg13cmos5l_decap_8
X_2224_ _2224_/X _2704_/X _2693_/X _2692_/X _2709_/X _1237_/Q _1236_/Q VPWR VGND sg13cmos5l_mux4_1
XFILLER_16_0 VPWR VGND sg13cmos5l_decap_8
XFILLER_213_21 VPWR VGND sg13cmos5l_decap_8
XFILLER_238_161 VPWR VGND sg13cmos5l_decap_8
X_2155_ _2155_/X Tile_X0Y0_W1END[1] Tile_X0Y0_WW4END[1] Tile_X0Y0_WW4END[5] Tile_X0Y0_W6END[9]
+ _0283_/Q _0282_/Q VPWR VGND sg13cmos5l_mux4_1
XANTENNA__1901__X Tile_X0Y1_FrameData_O[14] VPWR VGND sg13cmos5l_antennanp
X_1106_ _1106_/Q Tile_X0Y4_FrameData[20] VGND VPWR Tile_X0Y5_FrameStrobe[2] latch
XFILLER_53_203 VPWR VGND sg13cmos5l_decap_8
XFILLER_360_71 VPWR VGND sg13cmos5l_decap_4
XFILLER_289_14 VPWR VGND sg13cmos5l_decap_8
X_2086_ Tile_X0Y3_E1BEG[2] _2507_/X VPWR VGND sg13cmos5l_buf_1
X_1037_ _1037_/Q Tile_X0Y4_FrameData[25] VGND VPWR Tile_X0Y5_FrameStrobe[0] latch
XFILLER_355_238 VPWR VGND sg13cmos5l_decap_8
X_1939_ Tile_X0Y1_E6BEG[4] _2329_/X VPWR VGND sg13cmos5l_buf_1
XFILLER_107_205 VPWR VGND sg13cmos5l_decap_8
XFILLER_174_182 VPWR VGND sg13cmos5l_decap_8
XFILLER_181_119 VPWR VGND sg13cmos5l_decap_8
XFILLER_238_84 VPWR VGND sg13cmos5l_decap_8
XFILLER_308_154 VPWR VGND sg13cmos5l_decap_8
XFILLER_174_28 VPWR VGND sg13cmos5l_decap_8
XFILLER_88_100 VPWR VGND sg13cmos5l_decap_8
XFILLER_115_271 VPWR VGND sg13cmos5l_fill_2
XFILLER_107_77 VPWR VGND sg13cmos5l_decap_8
XFILLER_276_234 VPWR VGND sg13cmos5l_fill_2
XFILLER_296_7 VPWR VGND sg13cmos5l_decap_8
XFILLER_190_49 VPWR VGND sg13cmos5l_decap_8
XFILLER_123_21 VPWR VGND sg13cmos5l_decap_8
XANTENNA__1811__X Tile_X0Y4_E6BEG[6] VPWR VGND sg13cmos5l_antennanp
XFILLER_83_14 VPWR VGND sg13cmos5l_decap_8
XFILLER_123_98 VPWR VGND sg13cmos5l_decap_8
XFILLER_199_14 VPWR VGND sg13cmos5l_decap_8
XFILLER_244_175 VPWR VGND sg13cmos5l_decap_8
XFILLER_44_247 VPWR VGND sg13cmos5l_decap_8
XFILLER_16_63 VPWR VGND sg13cmos5l_decap_8
XFILLER_349_28 VPWR VGND sg13cmos5l_decap_8
XFILLER_12_133 VPWR VGND sg13cmos5l_decap_8
XFILLER_157_105 VPWR VGND sg13cmos5l_decap_8
XFILLER_279_91 VPWR VGND sg13cmos5l_decap_8
XFILLER_12_166 VPWR VGND sg13cmos5l_decap_4
XFILLER_157_116 VPWR VGND sg13cmos5l_fill_1
XFILLER_157_138 VPWR VGND sg13cmos5l_decap_8
XFILLER_346_227 VPWR VGND sg13cmos5l_decap_8
XFILLER_120_0 VPWR VGND sg13cmos5l_decap_8
XFILLER_8_148 VPWR VGND sg13cmos5l_decap_8
XFILLER_218_0 VPWR VGND sg13cmos5l_decap_8
XFILLER_32_84 VPWR VGND sg13cmos5l_decap_8
XFILLER_354_271 VPWR VGND sg13cmos5l_fill_2
XFILLER_148_84 VPWR VGND sg13cmos5l_decap_8
XFILLER_180_196 VPWR VGND sg13cmos5l_decap_8
XANTENNA__2089__X Tile_X0Y3_E2BEG[1] VPWR VGND sg13cmos5l_antennanp
XFILLER_121_230 VPWR VGND sg13cmos5l_fill_2
XFILLER_314_42 VPWR VGND sg13cmos5l_decap_8
X_0270_ _0270_/Q Tile_X0Y0_FrameData[24] VGND VPWR Tile_X0Y5_FrameStrobe[6] latch
XFILLER_94_103 VPWR VGND sg13cmos5l_decap_8
XFILLER_57_70 VPWR VGND sg13cmos5l_decap_8
XANTENNA__1721__X Tile_X0Y0_E2BEGb[1] VPWR VGND sg13cmos5l_antennanp
XFILLER_94_169 VPWR VGND sg13cmos5l_decap_8
XFILLER_235_197 VPWR VGND sg13cmos5l_fill_1
XFILLER_250_112 VPWR VGND sg13cmos5l_fill_2
XFILLER_330_63 VPWR VGND sg13cmos5l_decap_8
XFILLER_250_145 VPWR VGND sg13cmos5l_fill_2
XFILLER_259_28 VPWR VGND sg13cmos5l_decap_8
XFILLER_73_91 VPWR VGND sg13cmos5l_decap_8
XFILLER_50_239 VPWR VGND sg13cmos5l_fill_1
XFILLER_148_105 VPWR VGND sg13cmos5l_decap_8
XFILLER_189_91 VPWR VGND sg13cmos5l_decap_8
X_2773_ _2773_/X Tile_X0Y5_W2MID[7] Tile_X0Y5_W2END[7] Tile_X0Y5_W6END[8] _2825_/X
+ _1356_/Q _1355_/Q VPWR VGND sg13cmos5l_mux4_1
XFILLER_163_119 VPWR VGND sg13cmos5l_decap_8
X_1724_ Tile_X0Y0_E2BEGb[4] _2177_/X VPWR VGND sg13cmos5l_buf_1
XFILLER_156_193 VPWR VGND sg13cmos5l_decap_4
XFILLER_208_21 VPWR VGND sg13cmos5l_decap_8
XFILLER_275_49 VPWR VGND sg13cmos5l_decap_8
XFILLER_104_219 VPWR VGND sg13cmos5l_fill_2
XFILLER_305_168 VPWR VGND sg13cmos5l_decap_8
X_1655_ Tile_X0Y0_FrameStrobe_O[15] Tile_X0Y5_FrameStrobe[15] VPWR VGND sg13cmos5l_buf_1
XFILLER_208_98 VPWR VGND sg13cmos5l_decap_8
XFILLER_320_105 VPWR VGND sg13cmos5l_decap_8
XFILLER_320_116 VPWR VGND sg13cmos5l_fill_2
X_1586_ Tile_X0Y3_UserCLKo Tile_X0Y3_UserCLK VPWR VGND sg13cmos5l_buf_1
X_0606_ _0606_/Q Tile_X0Y2_FrameData[8] VGND VPWR Tile_X0Y5_FrameStrobe[1] latch
XFILLER_313_190 VPWR VGND sg13cmos5l_fill_1
X_0537_ _0537_/Q Tile_X0Y1_FrameData[29] VGND VPWR Tile_X0Y5_FrameStrobe[7] latch
XFILLER_224_42 VPWR VGND sg13cmos5l_decap_8
X_2207_ _2207_/X AXIL_S_SOC_WDATA18 _2238_/X _2237_/X _2247_/X _0182_/Q _0181_/Q VPWR
+ VGND sg13cmos5l_mux4_1
X_0468_ _0468_/Q Tile_X0Y1_FrameData[2] VGND VPWR Tile_X0Y5_FrameStrobe[4] latch
XANTENNA__1631__X Tile_X0Y0_N2BEG[3] VPWR VGND sg13cmos5l_antennanp
XFILLER_226_120 VPWR VGND sg13cmos5l_decap_8
X_0399_ _0399_/Q Tile_X0Y1_FrameData[7] VGND VPWR Tile_X0Y5_FrameStrobe[2] latch
X_2138_ AXIL_S_SOC_RRESP0 Tile_X0Y5_W2MID[1] Tile_X0Y5_W2END[1] Tile_X0Y5_W6END[1]
+ _2826_/X _1326_/Q _1325_/Q VPWR VGND sg13cmos5l_mux4_1
XFILLER_240_63 VPWR VGND sg13cmos5l_decap_8
XFILLER_241_112 VPWR VGND sg13cmos5l_decap_8
XFILLER_26_258 VPWR VGND sg13cmos5l_decap_4
X_2069_ Tile_X0Y5_S4BEG[2] _2069_/A VPWR VGND sg13cmos5l_buf_1
XFILLER_53_28 VPWR VGND sg13cmos5l_decap_8
XFILLER_169_28 VPWR VGND sg13cmos5l_decap_8
XFILLER_241_189 VPWR VGND sg13cmos5l_decap_8
XFILLER_194_244 VPWR VGND sg13cmos5l_decap_4
XFILLER_154_119 VPWR VGND sg13cmos5l_decap_8
XFILLER_211_7 VPWR VGND sg13cmos5l_decap_8
XFILLER_118_21 VPWR VGND sg13cmos5l_decap_8
XFILLER_147_193 VPWR VGND sg13cmos5l_decap_8
XFILLER_185_49 VPWR VGND sg13cmos5l_decap_8
XFILLER_309_7 VPWR VGND sg13cmos5l_decap_8
XANTENNA__1806__X Tile_X0Y4_E6BEG[1] VPWR VGND sg13cmos5l_antennanp
XFILLER_78_14 VPWR VGND sg13cmos5l_decap_8
XFILLER_118_98 VPWR VGND sg13cmos5l_decap_8
XFILLER_311_105 VPWR VGND sg13cmos5l_decap_8
XFILLER_103_230 VPWR VGND sg13cmos5l_decap_8
XFILLER_311_149 VPWR VGND sg13cmos5l_decap_8
XFILLER_134_42 VPWR VGND sg13cmos5l_decap_8
XFILLER_281_70 VPWR VGND sg13cmos5l_decap_8
XFILLER_94_35 VPWR VGND sg13cmos5l_decap_8
XANTENNA__1541__X Tile_X0Y3_EE4BEG[3] VPWR VGND sg13cmos5l_antennanp
XFILLER_264_237 VPWR VGND sg13cmos5l_fill_1
XFILLER_150_63 VPWR VGND sg13cmos5l_decap_8
XFILLER_168_0 VPWR VGND sg13cmos5l_decap_8
XFILLER_232_112 VPWR VGND sg13cmos5l_decap_8
XFILLER_27_84 VPWR VGND sg13cmos5l_decap_8
XFILLER_335_0 VPWR VGND sg13cmos5l_decap_8
XFILLER_185_211 VPWR VGND sg13cmos5l_fill_1
XFILLER_300_77 VPWR VGND sg13cmos5l_decap_8
XFILLER_40_261 VPWR VGND sg13cmos5l_fill_2
XFILLER_309_42 VPWR VGND sg13cmos5l_decap_8
XFILLER_299_112 VPWR VGND sg13cmos5l_decap_8
XANTENNA__1716__X Tile_X0Y0_E6BEG[8] VPWR VGND sg13cmos5l_antennanp
XFILLER_57_7 VPWR VGND sg13cmos5l_decap_8
XFILLER_299_189 VPWR VGND sg13cmos5l_decap_8
XFILLER_302_105 VPWR VGND sg13cmos5l_decap_8
X_1440_ _1440_/Q Tile_X0Y5_FrameData[16] VGND VPWR Tile_X0Y5_FrameStrobe[5] latch
XFILLER_325_63 VPWR VGND sg13cmos5l_decap_8
X_1371_ _1371_/Q Tile_X0Y5_FrameData[21] VGND VPWR Tile_X0Y5_FrameStrobe[3] latch
XFILLER_4_77 VPWR VGND sg13cmos5l_decap_8
X_0322_ _0322_/Q Tile_X0Y1_FrameData[20] VGND VPWR Tile_X0Y5_FrameStrobe[0] latch
XFILLER_191_70 VPWR VGND sg13cmos5l_decap_8
XFILLER_68_91 VPWR VGND sg13cmos5l_decap_8
XFILLER_67_147 VPWR VGND sg13cmos5l_decap_4
X_0253_ _0253_/Q Tile_X0Y0_FrameData[9] VGND VPWR Tile_X0Y5_FrameStrobe[5] latch
XFILLER_208_153 VPWR VGND sg13cmos5l_decap_8
X_0184_ _0184_/Q Tile_X0Y0_FrameData[14] VGND VPWR Tile_X0Y5_FrameStrobe[3] latch
XFILLER_341_84 VPWR VGND sg13cmos5l_decap_8
XFILLER_208_197 VPWR VGND sg13cmos5l_fill_1
XFILLER_210_77 VPWR VGND sg13cmos5l_fill_2
XFILLER_286_15 VPWR VGND sg13cmos5l_decap_8
XFILLER_176_233 VPWR VGND sg13cmos5l_fill_2
X_2825_ _2825_/X Tile_X0Y5_N2MID[0] Tile_X0Y5_N2END[0] _2829_/X _2713_/X _1288_/Q
+ _1287_/Q VPWR VGND sg13cmos5l_mux4_1
XFILLER_83_0 VPWR VGND sg13cmos5l_decap_8
XFILLER_219_42 VPWR VGND sg13cmos5l_decap_8
XFILLER_318_271 VPWR VGND sg13cmos5l_fill_2
X_2756_ _2756_/X AXIL_S_SOC_ARPROT0 AXIL_S_SOC_ARVALID _2824_/X _2825_/X _1390_/Q
+ _1389_/Q VPWR VGND sg13cmos5l_mux4_1
XANTENNA__1626__X Tile_X0Y0_N2BEGb[6] VPWR VGND sg13cmos5l_antennanp
X_1707_ Tile_X0Y0_EE4BEG[15] _2196_/X VPWR VGND sg13cmos5l_buf_1
X_2687_ _2687_/X _2240_/X _2239_/X _2230_/X _2229_/X _0154_/Q _0153_/Q VPWR VGND sg13cmos5l_mux4_1
X_1638_ Tile_X0Y0_N1BEG[2] _2143_/X VPWR VGND sg13cmos5l_buf_1
XFILLER_235_63 VPWR VGND sg13cmos5l_decap_8
XFILLER_100_200 VPWR VGND sg13cmos5l_decap_8
X_1569_ Tile_X0Y3_FrameData_O[15] Tile_X0Y3_FrameData[15] VPWR VGND sg13cmos5l_buf_1
XFILLER_48_39 VPWR VGND sg13cmos5l_decap_8
XFILLER_301_182 VPWR VGND sg13cmos5l_decap_8
XFILLER_58_147 VPWR VGND sg13cmos5l_decap_8
XFILLER_104_78 VPWR VGND sg13cmos5l_decap_8
XFILLER_251_84 VPWR VGND sg13cmos5l_decap_8
XFILLER_261_218 VPWR VGND sg13cmos5l_decap_4
XFILLER_161_7 VPWR VGND sg13cmos5l_decap_8
XFILLER_214_112 VPWR VGND sg13cmos5l_decap_8
XFILLER_261_229 VPWR VGND sg13cmos5l_decap_4
XFILLER_64_49 VPWR VGND sg13cmos5l_decap_8
XFILLER_214_156 VPWR VGND sg13cmos5l_fill_1
XFILLER_259_7 VPWR VGND sg13cmos5l_decap_8
XFILLER_120_77 VPWR VGND sg13cmos5l_decap_8
XFILLER_167_222 VPWR VGND sg13cmos5l_decap_8
XFILLER_13_42 VPWR VGND sg13cmos5l_decap_8
XFILLER_22_272 VPWR VGND sg13cmos5l_fill_1
XFILLER_129_42 VPWR VGND sg13cmos5l_decap_8
XFILLER_182_203 VPWR VGND sg13cmos5l_fill_1
XFILLER_276_70 VPWR VGND sg13cmos5l_decap_8
XANTENNA__1536__X Tile_X0Y3_E6BEG[10] VPWR VGND sg13cmos5l_antennanp
XFILLER_89_57 VPWR VGND sg13cmos5l_decap_8
XFILLER_135_196 VPWR VGND sg13cmos5l_decap_8
XFILLER_145_63 VPWR VGND sg13cmos5l_decap_8
XFILLER_296_126 VPWR VGND sg13cmos5l_decap_8
XFILLER_362_28 VPWR VGND sg13cmos5l_decap_8
XFILLER_150_166 VPWR VGND sg13cmos5l_decap_8
XFILLER_292_91 VPWR VGND sg13cmos5l_decap_8
XFILLER_89_272 VPWR VGND sg13cmos5l_fill_1
XFILLER_49_147 VPWR VGND sg13cmos5l_decap_8
XFILLER_285_0 VPWR VGND sg13cmos5l_decap_8
XFILLER_161_84 VPWR VGND sg13cmos5l_decap_8
XFILLER_205_112 VPWR VGND sg13cmos5l_fill_1
XFILLER_311_21 VPWR VGND sg13cmos5l_decap_8
XFILLER_205_178 VPWR VGND sg13cmos5l_decap_8
XFILLER_311_98 VPWR VGND sg13cmos5l_decap_8
XFILLER_158_211 VPWR VGND sg13cmos5l_decap_8
XFILLER_20_209 VPWR VGND sg13cmos5l_decap_4
X_0940_ _0940_/Q Tile_X0Y3_FrameData[10] VGND VPWR Tile_X0Y5_FrameStrobe[4] latch
XFILLER_359_182 VPWR VGND sg13cmos5l_decap_8
XFILLER_118_119 VPWR VGND sg13cmos5l_decap_8
X_0871_ _0871_/Q Tile_X0Y3_FrameData[15] VGND VPWR Tile_X0Y5_FrameStrobe[2] latch
XFILLER_70_70 VPWR VGND sg13cmos5l_decap_8
XFILLER_186_70 VPWR VGND sg13cmos5l_decap_8
X_2610_ _2610_/X Tile_X0Y5_W2MID[1] Tile_X0Y5_W2END[1] Tile_X0Y5_W6END[1] _2798_/X
+ _1476_/Q _1475_/Q VPWR VGND sg13cmos5l_mux4_1
X_2541_ _2541_/X Tile_X0Y5_N4END[8] Tile_X0Y0_S4END[12] _2574_/X _2573_/X _0922_/Q
+ _0921_/Q VPWR VGND sg13cmos5l_mux4_1
X_2472_ _2472_/X _2458_/X Tile_X0Y5_N4END[12] _2457_/X Tile_X0Y0_S4END[8] _0590_/Q
+ _0589_/Q VPWR VGND sg13cmos5l_mux4_1
XFILLER_272_28 VPWR VGND sg13cmos5l_decap_8
XFILLER_287_126 VPWR VGND sg13cmos5l_decap_8
X_1423_ _1423_/Q Tile_X0Y5_FrameData[1] VGND VPWR Tile_X0Y5_FrameStrobe[4] latch
XFILLER_336_84 VPWR VGND sg13cmos5l_decap_8
XFILLER_141_177 VPWR VGND sg13cmos5l_decap_8
X_1354_ _1354_/Q Tile_X0Y5_FrameData[6] VGND VPWR Tile_X0Y5_FrameStrobe[2] latch
XFILLER_205_77 VPWR VGND sg13cmos5l_decap_4
X_1285_ _1285_/Q Tile_X0Y5_FrameData[11] VGND VPWR Tile_X0Y5_FrameStrobe[0] latch
X_0305_ _0305_/Q Tile_X0Y0_FrameData[21] VGND VPWR Tile_X0Y5_FrameStrobe[7] latch
XFILLER_243_207 VPWR VGND sg13cmos5l_decap_8
X_0236_ _0236_/Q Tile_X0Y0_FrameData[26] VGND VPWR Tile_X0Y5_FrameStrobe[5] latch
XFILLER_221_21 VPWR VGND sg13cmos5l_decap_8
X_0167_ _0167_/Q Tile_X0Y0_FrameData[31] VGND VPWR Tile_X0Y5_FrameStrobe[3] latch
XFILLER_63_161 VPWR VGND sg13cmos5l_decap_8
XFILLER_297_14 VPWR VGND sg13cmos5l_decap_8
X_0098_ _0098_/Q Tile_X0Y0_FrameData[4] VGND VPWR Tile_X0Y5_FrameStrobe[0] latch
XFILLER_357_119 VPWR VGND sg13cmos5l_decap_8
XFILLER_109_119 VPWR VGND sg13cmos5l_decap_8
X_2808_ _2808_/X _2370_/X _2369_/X _2358_/X _2357_/X _0391_/Q _0390_/Q VPWR VGND sg13cmos5l_mux4_1
XFILLER_164_269 VPWR VGND sg13cmos5l_decap_4
XFILLER_306_241 VPWR VGND sg13cmos5l_fill_1
X_2739_ _2739_/X AXIL_S_SOC_ARPROT1 AXIL_S_SOC_RREADY _2826_/X _2798_/X _1424_/Q _1423_/Q
+ VPWR VGND sg13cmos5l_mux4_1
XFILLER_117_196 VPWR VGND sg13cmos5l_decap_8
XFILLER_246_84 VPWR VGND sg13cmos5l_decap_8
XFILLER_59_49 VPWR VGND sg13cmos5l_decap_8
XFILLER_182_28 VPWR VGND sg13cmos5l_decap_8
XFILLER_115_77 VPWR VGND sg13cmos5l_decap_8
XFILLER_46_106 VPWR VGND sg13cmos5l_decap_8
XFILLER_46_139 VPWR VGND sg13cmos5l_decap_8
XFILLER_131_21 VPWR VGND sg13cmos5l_decap_8
XFILLER_199_100 VPWR VGND sg13cmos5l_fill_1
XFILLER_91_14 VPWR VGND sg13cmos5l_decap_8
XFILLER_54_161 VPWR VGND sg13cmos5l_decap_8
XFILLER_131_98 VPWR VGND sg13cmos5l_decap_8
XFILLER_348_119 VPWR VGND sg13cmos5l_decap_8
XFILLER_24_63 VPWR VGND sg13cmos5l_decap_8
XFILLER_155_214 VPWR VGND sg13cmos5l_fill_1
XFILLER_287_91 VPWR VGND sg13cmos5l_decap_8
XFILLER_357_28 VPWR VGND sg13cmos5l_decap_8
XFILLER_155_236 VPWR VGND sg13cmos5l_decap_8
XFILLER_210_192 VPWR VGND sg13cmos5l_decap_8
XFILLER_356_196 VPWR VGND sg13cmos5l_decap_8
XFILLER_200_0 VPWR VGND sg13cmos5l_decap_8
XFILLER_40_84 VPWR VGND sg13cmos5l_decap_8
XFILLER_123_133 VPWR VGND sg13cmos5l_decap_8
XFILLER_156_84 VPWR VGND sg13cmos5l_decap_8
XFILLER_306_21 VPWR VGND sg13cmos5l_decap_8
XFILLER_269_159 VPWR VGND sg13cmos5l_decap_4
XFILLER_306_98 VPWR VGND sg13cmos5l_decap_8
XANTENNA__2097__X Tile_X0Y3_E2BEGb[1] VPWR VGND sg13cmos5l_antennanp
XFILLER_1_56 VPWR VGND sg13cmos5l_decap_8
XFILLER_225_207 VPWR VGND sg13cmos5l_fill_1
XFILLER_292_151 VPWR VGND sg13cmos5l_decap_8
XFILLER_322_42 VPWR VGND sg13cmos5l_decap_8
XFILLER_218_270 VPWR VGND sg13cmos5l_fill_2
X_1070_ _1070_/Q Tile_X0Y4_FrameData[24] VGND VPWR Tile_X0Y5_FrameStrobe[1] latch
XFILLER_65_70 VPWR VGND sg13cmos5l_decap_8
XANTENNA_160 AXIL_S_SOC_WDATA31 VPWR VGND sg13cmos5l_antennanp
XFILLER_45_183 VPWR VGND sg13cmos5l_decap_8
XANTENNA_171 AXIL_S_SOC_WDATA8 VPWR VGND sg13cmos5l_antennanp
XANTENNA_182 AXIL_S_SOC_WDATA8 VPWR VGND sg13cmos5l_antennanp
XANTENNA_193 AXIL_S_SOC_WDATA9 VPWR VGND sg13cmos5l_antennanp
XFILLER_339_119 VPWR VGND sg13cmos5l_fill_2
X_1972_ Tile_X0Y5_E2BEG[1] _2726_/X VPWR VGND sg13cmos5l_buf_1
XFILLER_60_175 VPWR VGND sg13cmos5l_decap_8
XFILLER_267_28 VPWR VGND sg13cmos5l_decap_8
X_0923_ _0923_/Q Tile_X0Y3_FrameData[27] VGND VPWR Tile_X0Y5_FrameStrobe[4] latch
XFILLER_347_163 VPWR VGND sg13cmos5l_fill_2
XFILLER_197_91 VPWR VGND sg13cmos5l_decap_8
X_0854_ _0854_/Q Tile_X0Y3_FrameData[0] VGND VPWR Tile_X0Y5_FrameStrobe[1] latch
XFILLER_362_122 VPWR VGND sg13cmos5l_decap_8
XFILLER_347_196 VPWR VGND sg13cmos5l_decap_8
XFILLER_347_72 VPWR VGND sg13cmos5l_decap_8
XFILLER_347_50 VPWR VGND sg13cmos5l_decap_8
X_0785_ _0785_/Q Tile_X0Y2_FrameData[21] VGND VPWR Tile_X0Y5_FrameStrobe[7] latch
XFILLER_362_199 VPWR VGND sg13cmos5l_decap_8
XFILLER_114_133 VPWR VGND sg13cmos5l_decap_8
XFILLER_216_21 VPWR VGND sg13cmos5l_decap_8
XFILLER_283_49 VPWR VGND sg13cmos5l_decap_8
X_2524_ _2524_/X AXIL_S_SOC_ARADDR5 AXIL_S_SOC_ARADDR7 _2589_/X _2596_/X _0956_/Q
+ _0955_/Q VPWR VGND sg13cmos5l_mux4_1
XFILLER_46_0 VPWR VGND sg13cmos5l_fill_2
XANTENNA__1904__X Tile_X0Y1_FrameData_O[17] VPWR VGND sg13cmos5l_antennanp
X_2455_ _2455_/X _2462_/X _2461_/X Tile_X0Y2_W6END[2] _2455_/A3 _0554_/Q _0553_/Q
+ VPWR VGND sg13cmos5l_mux4_1
XFILLER_216_98 VPWR VGND sg13cmos5l_decap_8
X_1406_ _1406_/Q Tile_X0Y5_FrameData[18] VGND VPWR Tile_X0Y5_FrameStrobe[4] latch
X_2386_ _2386_/X Tile_X0Y3_W2MID[5] Tile_X0Y3_W2END[5] Tile_X0Y3_W6END[5] _2591_/X
+ _1018_/Q _1017_/Q VPWR VGND sg13cmos5l_mux4_1
X_1337_ _1337_/Q Tile_X0Y5_FrameData[23] VGND VPWR Tile_X0Y5_FrameStrobe[2] latch
XFILLER_232_42 VPWR VGND sg13cmos5l_decap_8
XFILLER_83_223 VPWR VGND sg13cmos5l_decap_8
X_1268_ _1268_/Q Tile_X0Y5_FrameData[28] VGND VPWR Tile_X0Y5_FrameStrobe[0] latch
X_1199_ _1199_/Q Tile_X0Y4_FrameData[23] VGND VPWR Tile_X0Y5_FrameStrobe[5] latch
X_0219_ _0219_/Q Tile_X0Y0_FrameData[11] VGND VPWR Tile_X0Y5_FrameStrobe[4] latch
XFILLER_101_35 VPWR VGND sg13cmos5l_decap_8
XFILLER_196_147 VPWR VGND sg13cmos5l_decap_8
XFILLER_61_28 VPWR VGND sg13cmos5l_decap_8
XFILLER_51_175 VPWR VGND sg13cmos5l_decap_8
XFILLER_177_28 VPWR VGND sg13cmos5l_decap_8
XFILLER_124_7 VPWR VGND sg13cmos5l_decap_8
XFILLER_137_214 VPWR VGND sg13cmos5l_decap_8
XFILLER_338_174 VPWR VGND sg13cmos5l_decap_4
XFILLER_353_133 VPWR VGND sg13cmos5l_decap_8
XFILLER_10_21 VPWR VGND sg13cmos5l_decap_8
XFILLER_126_21 VPWR VGND sg13cmos5l_decap_8
XFILLER_193_49 VPWR VGND sg13cmos5l_decap_8
XANTENNA__1814__X Tile_X0Y4_E6BEG[9] VPWR VGND sg13cmos5l_antennanp
XFILLER_10_98 VPWR VGND sg13cmos5l_decap_8
XFILLER_86_14 VPWR VGND sg13cmos5l_decap_8
XFILLER_120_147 VPWR VGND sg13cmos5l_decap_8
XFILLER_142_42 VPWR VGND sg13cmos5l_decap_8
XFILLER_19_63 VPWR VGND sg13cmos5l_decap_8
XFILLER_274_195 VPWR VGND sg13cmos5l_decap_8
XFILLER_150_0 VPWR VGND sg13cmos5l_decap_8
XFILLER_248_0 VPWR VGND sg13cmos5l_decap_8
XFILLER_35_84 VPWR VGND sg13cmos5l_decap_8
XFILLER_187_147 VPWR VGND sg13cmos5l_fill_1
XFILLER_195_180 VPWR VGND sg13cmos5l_fill_2
XFILLER_344_133 VPWR VGND sg13cmos5l_decap_8
XFILLER_297_210 VPWR VGND sg13cmos5l_decap_8
XFILLER_317_42 VPWR VGND sg13cmos5l_decap_8
X_0570_ _0570_/Q Tile_X0Y2_FrameData[12] VGND VPWR Tile_X0Y5_FrameStrobe[0] latch
XFILLER_297_254 VPWR VGND sg13cmos5l_fill_1
XANTENNA__1724__X Tile_X0Y0_E2BEGb[4] VPWR VGND sg13cmos5l_antennanp
XFILLER_2_271 VPWR VGND sg13cmos5l_fill_2
XFILLER_300_203 VPWR VGND sg13cmos5l_decap_8
X_2240_ _2240_/X _2213_/X _0049_/X Tile_X0Y0_S1END[0] Tile_X0Y0_S4END[0] _0126_/Q
+ _0125_/Q VPWR VGND sg13cmos5l_mux4_1
XFILLER_111_147 VPWR VGND sg13cmos5l_decap_8
XFILLER_333_63 VPWR VGND sg13cmos5l_decap_8
X_2171_ _2171_/X AXIL_S_SOC_WDATA22 AXIL_S_SOC_WDATA30 _2242_/X _2247_/X _0254_/Q
+ _0253_/Q VPWR VGND sg13cmos5l_mux4_1
X_1122_ _1122_/Q Tile_X0Y4_FrameData[4] VGND VPWR Tile_X0Y5_FrameStrobe[2] latch
XFILLER_76_91 VPWR VGND sg13cmos5l_decap_8
XFILLER_265_195 VPWR VGND sg13cmos5l_decap_4
X_1053_ _1053_/Q Tile_X0Y4_FrameData[9] VGND VPWR Tile_X0Y5_FrameStrobe[0] latch
XFILLER_202_56 VPWR VGND sg13cmos5l_decap_8
XFILLER_33_120 VPWR VGND sg13cmos5l_decap_8
XFILLER_221_221 VPWR VGND sg13cmos5l_decap_8
XFILLER_221_232 VPWR VGND sg13cmos5l_fill_1
XFILLER_178_147 VPWR VGND sg13cmos5l_decap_8
XFILLER_221_254 VPWR VGND sg13cmos5l_fill_2
XFILLER_278_49 VPWR VGND sg13cmos5l_decap_8
X_1955_ Tile_X0Y1_E2BEG[0] _2293_/X VPWR VGND sg13cmos5l_buf_1
X_0906_ _0906_/Q Tile_X0Y3_FrameData[12] VGND VPWR Tile_X0Y5_FrameStrobe[3] latch
X_1886_ Tile_X0Y1_UserCLKo Tile_X0Y1_UserCLK VPWR VGND sg13cmos5l_buf_1
X_0837_ _0837_/Q Tile_X0Y3_FrameData[17] VGND VPWR Tile_X0Y5_FrameStrobe[1] latch
XFILLER_350_114 VPWR VGND sg13cmos5l_decap_8
XFILLER_227_42 VPWR VGND sg13cmos5l_decap_8
X_0768_ _0768_/Q Tile_X0Y2_FrameData[6] VGND VPWR Tile_X0Y5_FrameStrobe[6] latch
XFILLER_142_261 VPWR VGND sg13cmos5l_fill_2
X_2507_ _2507_/X _2570_/X _2569_/X AXIL_S_SOC_ARADDR0 AXIL_S_SOC_ARADDR5 _0990_/Q
+ _0989_/Q VPWR VGND sg13cmos5l_mux4_1
XANTENNA__1634__X Tile_X0Y0_N2BEG[6] VPWR VGND sg13cmos5l_antennanp
X_0699_ _0699_/Q Tile_X0Y2_FrameData[11] VGND VPWR Tile_X0Y5_FrameStrobe[4] latch
X_2438_ _2438_/X AXIL_S_SOC_AWADDR5 _2474_/X _2468_/X _2482_/X _0672_/Q _0671_/Q VPWR
+ VGND sg13cmos5l_mux4_1
XFILLER_243_63 VPWR VGND sg13cmos5l_decap_8
XFILLER_256_140 VPWR VGND sg13cmos5l_decap_8
X_2369_ _2369_/X _2344_/X _0031_/X _2343_/X Tile_X0Y0_S4END[5] _0356_/Q _0355_/Q VPWR
+ VGND sg13cmos5l_mux4_1
XFILLER_56_28 VPWR VGND sg13cmos5l_decap_8
XFILLER_110_180 VPWR VGND sg13cmos5l_decap_8
XFILLER_256_162 VPWR VGND sg13cmos5l_fill_1
XFILLER_56_256 VPWR VGND sg13cmos5l_decap_4
XFILLER_112_56 VPWR VGND sg13cmos5l_decap_8
XFILLER_72_49 VPWR VGND sg13cmos5l_decap_8
XFILLER_358_203 VPWR VGND sg13cmos5l_decap_8
XFILLER_188_49 VPWR VGND sg13cmos5l_decap_8
XFILLER_212_265 VPWR VGND sg13cmos5l_decap_8
XFILLER_241_7 VPWR VGND sg13cmos5l_decap_8
XFILLER_358_236 VPWR VGND sg13cmos5l_decap_8
XFILLER_339_7 VPWR VGND sg13cmos5l_decap_8
XANTENNA__1809__X Tile_X0Y4_E6BEG[4] VPWR VGND sg13cmos5l_antennanp
XANTENNA_60 AXIL_S_SOC_WDATA16 VPWR VGND sg13cmos5l_antennanp
XANTENNA_71 AXIL_S_SOC_WDATA25 VPWR VGND sg13cmos5l_antennanp
XANTENNA_82 AXIL_S_SOC_WDATA25 VPWR VGND sg13cmos5l_antennanp
XANTENNA_93 AXIL_S_SOC_WDATA26 VPWR VGND sg13cmos5l_antennanp
XFILLER_326_144 VPWR VGND sg13cmos5l_fill_1
XFILLER_125_217 VPWR VGND sg13cmos5l_decap_8
XFILLER_21_42 VPWR VGND sg13cmos5l_decap_8
XFILLER_137_42 VPWR VGND sg13cmos5l_decap_8
XFILLER_284_70 VPWR VGND sg13cmos5l_decap_8
XFILLER_341_147 VPWR VGND sg13cmos5l_decap_8
XFILLER_279_243 VPWR VGND sg13cmos5l_fill_2
XFILLER_97_35 VPWR VGND sg13cmos5l_decap_8
XANTENNA__1544__X Tile_X0Y3_EE4BEG[6] VPWR VGND sg13cmos5l_antennanp
XFILLER_153_63 VPWR VGND sg13cmos5l_decap_8
XFILLER_198_0 VPWR VGND sg13cmos5l_decap_8
XFILLER_101_180 VPWR VGND sg13cmos5l_decap_8
XFILLER_247_195 VPWR VGND sg13cmos5l_fill_2
XFILLER_262_132 VPWR VGND sg13cmos5l_decap_4
XFILLER_303_77 VPWR VGND sg13cmos5l_decap_8
XFILLER_46_50 VPWR VGND sg13cmos5l_decap_8
XFILLER_15_142 VPWR VGND sg13cmos5l_fill_1
XFILLER_262_187 VPWR VGND sg13cmos5l_fill_2
XFILLER_349_203 VPWR VGND sg13cmos5l_decap_8
XFILLER_30_112 VPWR VGND sg13cmos5l_decap_8
XFILLER_87_7 VPWR VGND sg13cmos5l_decap_8
XANTENNA__1719__X Tile_X0Y0_E6BEG[11] VPWR VGND sg13cmos5l_antennanp
XFILLER_168_191 VPWR VGND sg13cmos5l_decap_8
XFILLER_190_109 VPWR VGND sg13cmos5l_fill_2
X_1740_ Tile_X0Y2_FrameData_O[0] Tile_X0Y2_FrameData[0] VPWR VGND sg13cmos5l_buf_1
XFILLER_116_217 VPWR VGND sg13cmos5l_decap_4
XFILLER_183_161 VPWR VGND sg13cmos5l_decap_4
XFILLER_317_155 VPWR VGND sg13cmos5l_fill_2
XFILLER_328_63 VPWR VGND sg13cmos5l_decap_8
X_1671_ Tile_X0Y0_FrameData_O[11] Tile_X0Y0_FrameData[11] VPWR VGND sg13cmos5l_buf_1
XFILLER_7_77 VPWR VGND sg13cmos5l_decap_8
XFILLER_194_70 VPWR VGND sg13cmos5l_decap_8
XFILLER_332_136 VPWR VGND sg13cmos5l_fill_2
X_0622_ _0622_/Q Tile_X0Y2_FrameData[24] VGND VPWR Tile_X0Y5_FrameStrobe[2] latch
X_0553_ _0553_/Q Tile_X0Y2_FrameData[29] VGND VPWR Tile_X0Y5_FrameStrobe[0] latch
XFILLER_285_202 VPWR VGND sg13cmos5l_decap_8
XFILLER_97_112 VPWR VGND sg13cmos5l_decap_8
X_0484_ _0484_/Q Tile_X0Y1_FrameData[18] VGND VPWR Tile_X0Y5_FrameStrobe[5] latch
XFILLER_344_84 VPWR VGND sg13cmos5l_decap_8
XFILLER_238_140 VPWR VGND sg13cmos5l_decap_8
XFILLER_280_28 VPWR VGND sg13cmos5l_decap_8
X_2223_ _2223_/X Tile_X0Y4_W1END[1] Tile_X0Y4_WW4END[1] Tile_X0Y4_W6END[9] _2705_/X
+ _1237_/Q _1236_/Q VPWR VGND sg13cmos5l_mux4_1
XFILLER_97_178 VPWR VGND sg13cmos5l_fill_2
X_2154_ _2154_/X _2240_/X _2239_/X _2230_/X _2229_/X _0286_/Q _0285_/Q VPWR VGND sg13cmos5l_mux4_1
XFILLER_38_223 VPWR VGND sg13cmos5l_decap_4
XFILLER_213_77 VPWR VGND sg13cmos5l_decap_4
X_1105_ _1105_/Q Tile_X0Y4_FrameData[21] VGND VPWR Tile_X0Y5_FrameStrobe[2] latch
X_2085_ Tile_X0Y3_E1BEG[1] _2506_/X VPWR VGND sg13cmos5l_buf_1
X_1036_ _1036_/Q Tile_X0Y4_FrameData[26] VGND VPWR Tile_X0Y5_FrameStrobe[0] latch
XFILLER_21_112 VPWR VGND sg13cmos5l_decap_4
XANTENNA__1629__X Tile_X0Y0_N2BEG[1] VPWR VGND sg13cmos5l_antennanp
XFILLER_166_139 VPWR VGND sg13cmos5l_decap_8
XFILLER_355_217 VPWR VGND sg13cmos5l_decap_8
XFILLER_308_133 VPWR VGND sg13cmos5l_decap_8
X_1938_ Tile_X0Y1_E6BEG[3] _2328_/X VPWR VGND sg13cmos5l_buf_1
XFILLER_174_161 VPWR VGND sg13cmos5l_decap_8
XFILLER_238_63 VPWR VGND sg13cmos5l_decap_8
XFILLER_308_177 VPWR VGND sg13cmos5l_decap_4
X_1869_ Tile_X0Y2_E2BEGb[3] _2412_/X VPWR VGND sg13cmos5l_buf_1
XFILLER_115_250 VPWR VGND sg13cmos5l_decap_8
XFILLER_107_56 VPWR VGND sg13cmos5l_decap_8
XFILLER_130_231 VPWR VGND sg13cmos5l_fill_2
XFILLER_254_84 VPWR VGND sg13cmos5l_decap_8
XFILLER_88_145 VPWR VGND sg13cmos5l_fill_2
XFILLER_190_28 VPWR VGND sg13cmos5l_decap_8
XFILLER_191_7 VPWR VGND sg13cmos5l_decap_8
XFILLER_229_140 VPWR VGND sg13cmos5l_decap_8
XFILLER_276_246 VPWR VGND sg13cmos5l_decap_4
XFILLER_67_49 VPWR VGND sg13cmos5l_decap_8
XFILLER_229_173 VPWR VGND sg13cmos5l_decap_8
XFILLER_289_7 VPWR VGND sg13cmos5l_decap_8
XFILLER_291_227 VPWR VGND sg13cmos5l_decap_4
XFILLER_291_238 VPWR VGND sg13cmos5l_decap_8
XFILLER_123_77 VPWR VGND sg13cmos5l_decap_8
XFILLER_291_249 VPWR VGND sg13cmos5l_decap_4
XFILLER_44_204 VPWR VGND sg13cmos5l_decap_8
XFILLER_244_154 VPWR VGND sg13cmos5l_decap_8
XFILLER_44_226 VPWR VGND sg13cmos5l_decap_8
XFILLER_16_42 VPWR VGND sg13cmos5l_decap_8
XFILLER_12_112 VPWR VGND sg13cmos5l_decap_8
XFILLER_197_242 VPWR VGND sg13cmos5l_decap_8
XFILLER_279_70 VPWR VGND sg13cmos5l_decap_8
XANTENNA__1539__X Tile_X0Y3_EE4BEG[1] VPWR VGND sg13cmos5l_antennanp
XFILLER_32_63 VPWR VGND sg13cmos5l_decap_8
XFILLER_148_63 VPWR VGND sg13cmos5l_decap_8
XFILLER_113_0 VPWR VGND sg13cmos5l_decap_8
XFILLER_165_183 VPWR VGND sg13cmos5l_decap_8
XFILLER_295_91 VPWR VGND sg13cmos5l_decap_8
XFILLER_314_147 VPWR VGND sg13cmos5l_decap_4
XFILLER_180_175 VPWR VGND sg13cmos5l_decap_8
XFILLER_79_112 VPWR VGND sg13cmos5l_decap_8
XFILLER_164_84 VPWR VGND sg13cmos5l_decap_8
XFILLER_267_224 VPWR VGND sg13cmos5l_fill_1
XFILLER_314_21 VPWR VGND sg13cmos5l_decap_8
XFILLER_322_191 VPWR VGND sg13cmos5l_fill_2
XFILLER_79_167 VPWR VGND sg13cmos5l_decap_4
XFILLER_94_148 VPWR VGND sg13cmos5l_decap_8
XFILLER_314_98 VPWR VGND sg13cmos5l_decap_8
XFILLER_235_154 VPWR VGND sg13cmos5l_decap_8
XFILLER_235_165 VPWR VGND sg13cmos5l_fill_2
XFILLER_290_271 VPWR VGND sg13cmos5l_fill_2
XFILLER_330_42 VPWR VGND sg13cmos5l_decap_8
XFILLER_73_70 VPWR VGND sg13cmos5l_decap_8
XFILLER_189_70 VPWR VGND sg13cmos5l_decap_8
XFILLER_85_4 VPWR VGND sg13cmos5l_fill_1
XFILLER_337_206 VPWR VGND sg13cmos5l_fill_1
X_2772_ _2772_/X Tile_X0Y5_W1END[3] Tile_X0Y5_W6END[11] _2801_/X _2792_/X _1358_/Q
+ _1357_/Q VPWR VGND sg13cmos5l_mux4_1
XFILLER_339_84 VPWR VGND sg13cmos5l_decap_8
XFILLER_156_172 VPWR VGND sg13cmos5l_decap_8
XFILLER_275_28 VPWR VGND sg13cmos5l_decap_8
X_1723_ Tile_X0Y0_E2BEGb[3] _2176_/X VPWR VGND sg13cmos5l_buf_1
XFILLER_305_147 VPWR VGND sg13cmos5l_decap_8
X_1654_ Tile_X0Y0_FrameStrobe_O[14] Tile_X0Y5_FrameStrobe[14] VPWR VGND sg13cmos5l_buf_1
XFILLER_360_242 VPWR VGND sg13cmos5l_decap_8
XFILLER_171_186 VPWR VGND sg13cmos5l_decap_8
XFILLER_208_77 VPWR VGND sg13cmos5l_decap_8
X_1585_ Tile_X0Y3_FrameData_O[31] Tile_X0Y3_FrameData[31] VPWR VGND sg13cmos5l_buf_1
X_0605_ _0605_/Q Tile_X0Y2_FrameData[9] VGND VPWR Tile_X0Y5_FrameStrobe[1] latch
XFILLER_112_242 VPWR VGND sg13cmos5l_decap_8
XFILLER_291_49 VPWR VGND sg13cmos5l_decap_8
X_0536_ _0536_/Q Tile_X0Y1_FrameData[30] VGND VPWR Tile_X0Y5_FrameStrobe[7] latch
XFILLER_112_264 VPWR VGND sg13cmos5l_fill_1
XFILLER_224_21 VPWR VGND sg13cmos5l_decap_8
X_0467_ _0467_/Q Tile_X0Y1_FrameData[3] VGND VPWR Tile_X0Y5_FrameStrobe[4] latch
XANTENNA__1912__X Tile_X0Y1_FrameData_O[25] VPWR VGND sg13cmos5l_antennanp
X_2206_ _2206_/X AXIL_S_SOC_WDATA17 _2236_/X _2234_/X _2246_/X _0184_/Q _0183_/Q VPWR
+ VGND sg13cmos5l_mux4_1
XFILLER_224_98 VPWR VGND sg13cmos5l_decap_8
X_0398_ _0398_/Q Tile_X0Y1_FrameData[8] VGND VPWR Tile_X0Y5_FrameStrobe[2] latch
XFILLER_226_154 VPWR VGND sg13cmos5l_fill_2
X_2137_ AXIL_S_SOC_RDATA31 Tile_X0Y0_W2MID[7] Tile_X0Y0_W2END[7] Tile_X0Y0_W6END[7]
+ _2248_/X _0128_/Q _0127_/Q VPWR VGND sg13cmos5l_mux4_1
XFILLER_240_42 VPWR VGND sg13cmos5l_decap_8
X_2068_ Tile_X0Y5_S4BEG[1] _2068_/A VPWR VGND sg13cmos5l_buf_1
XFILLER_93_192 VPWR VGND sg13cmos5l_decap_8
XFILLER_241_168 VPWR VGND sg13cmos5l_decap_8
X_1019_ _1019_/Q Tile_X0Y3_FrameData[27] VGND VPWR Tile_X0Y5_FrameStrobe[7] latch
XFILLER_194_212 VPWR VGND sg13cmos5l_decap_4
XFILLER_194_223 VPWR VGND sg13cmos5l_decap_8
XFILLER_194_256 VPWR VGND sg13cmos5l_fill_2
XFILLER_249_84 VPWR VGND sg13cmos5l_decap_8
XFILLER_185_28 VPWR VGND sg13cmos5l_decap_8
XFILLER_204_7 VPWR VGND sg13cmos5l_decap_8
XFILLER_336_272 VPWR VGND sg13cmos5l_fill_1
XFILLER_118_77 VPWR VGND sg13cmos5l_decap_8
XFILLER_162_175 VPWR VGND sg13cmos5l_decap_8
XFILLER_162_186 VPWR VGND sg13cmos5l_fill_1
XFILLER_134_21 VPWR VGND sg13cmos5l_decap_8
XANTENNA__1822__X Tile_X0Y4_EE4BEG[5] VPWR VGND sg13cmos5l_antennanp
XFILLER_94_14 VPWR VGND sg13cmos5l_decap_8
XFILLER_76_126 VPWR VGND sg13cmos5l_decap_8
XFILLER_134_98 VPWR VGND sg13cmos5l_decap_8
XFILLER_76_159 VPWR VGND sg13cmos5l_decap_8
XFILLER_27_63 VPWR VGND sg13cmos5l_decap_8
XFILLER_84_170 VPWR VGND sg13cmos5l_fill_2
XFILLER_150_42 VPWR VGND sg13cmos5l_decap_8
XFILLER_272_271 VPWR VGND sg13cmos5l_fill_2
XFILLER_232_168 VPWR VGND sg13cmos5l_decap_4
XFILLER_300_56 VPWR VGND sg13cmos5l_decap_8
XFILLER_230_0 VPWR VGND sg13cmos5l_decap_8
XFILLER_159_84 VPWR VGND sg13cmos5l_decap_8
XFILLER_328_0 VPWR VGND sg13cmos5l_decap_8
XFILLER_43_84 VPWR VGND sg13cmos5l_decap_8
XFILLER_309_21 VPWR VGND sg13cmos5l_decap_8
XFILLER_138_172 VPWR VGND sg13cmos5l_decap_4
XFILLER_153_142 VPWR VGND sg13cmos5l_decap_8
XFILLER_153_164 VPWR VGND sg13cmos5l_fill_2
XFILLER_309_98 VPWR VGND sg13cmos5l_decap_8
XFILLER_299_168 VPWR VGND sg13cmos5l_decap_8
XFILLER_325_42 VPWR VGND sg13cmos5l_decap_8
X_1370_ _1370_/Q Tile_X0Y5_FrameData[22] VGND VPWR Tile_X0Y5_FrameStrobe[3] latch
XFILLER_4_56 VPWR VGND sg13cmos5l_decap_8
X_0321_ _0321_/Q Tile_X0Y1_FrameData[21] VGND VPWR Tile_X0Y5_FrameStrobe[0] latch
XFILLER_68_70 VPWR VGND sg13cmos5l_decap_8
XANTENNA__1732__X Tile_X0Y0_E2BEG[4] VPWR VGND sg13cmos5l_antennanp
XFILLER_255_227 VPWR VGND sg13cmos5l_decap_4
XFILLER_310_161 VPWR VGND sg13cmos5l_decap_8
XFILLER_310_172 VPWR VGND sg13cmos5l_decap_4
XFILLER_67_126 VPWR VGND sg13cmos5l_decap_8
X_0252_ _0252_/Q Tile_X0Y0_FrameData[10] VGND VPWR Tile_X0Y5_FrameStrobe[5] latch
X_0183_ _0183_/Q Tile_X0Y0_FrameData[15] VGND VPWR Tile_X0Y5_FrameStrobe[3] latch
XFILLER_341_63 VPWR VGND sg13cmos5l_decap_8
XFILLER_223_146 VPWR VGND sg13cmos5l_decap_8
XFILLER_223_157 VPWR VGND sg13cmos5l_fill_1
XFILLER_23_207 VPWR VGND sg13cmos5l_decap_4
XFILLER_90_162 VPWR VGND sg13cmos5l_decap_8
XFILLER_210_56 VPWR VGND sg13cmos5l_decap_8
XFILLER_90_195 VPWR VGND sg13cmos5l_decap_8
XFILLER_176_212 VPWR VGND sg13cmos5l_decap_8
XFILLER_31_240 VPWR VGND sg13cmos5l_decap_4
X_2824_ _2824_/X Tile_X0Y5_N1END[0] Tile_X0Y5_N4END[0] _2793_/X _0032_/X _1320_/Q
+ _1319_/Q VPWR VGND sg13cmos5l_mux4_1
XFILLER_219_21 VPWR VGND sg13cmos5l_decap_8
XFILLER_76_0 VPWR VGND sg13cmos5l_decap_8
XANTENNA__1907__X Tile_X0Y1_FrameData_O[20] VPWR VGND sg13cmos5l_antennanp
X_2755_ _2755_/X AXIL_S_SOC_ARPROT2 AXIL_S_SOC_RREADY _2822_/X _2826_/X _1392_/Q _1391_/Q
+ VPWR VGND sg13cmos5l_mux4_1
XFILLER_219_98 VPWR VGND sg13cmos5l_decap_8
X_1706_ Tile_X0Y0_EE4BEG[14] _2195_/X VPWR VGND sg13cmos5l_buf_1
X_2686_ _2686_/X Tile_X0Y0_W1END[0] Tile_X0Y0_WW4END[8] Tile_X0Y0_WW4END[12] Tile_X0Y0_W6END[4]
+ _0154_/Q _0153_/Q VPWR VGND sg13cmos5l_mux4_1
X_1637_ Tile_X0Y0_N1BEG[1] _2142_/X VPWR VGND sg13cmos5l_buf_1
XFILLER_235_42 VPWR VGND sg13cmos5l_decap_8
X_1568_ Tile_X0Y3_FrameData_O[14] Tile_X0Y3_FrameData[14] VPWR VGND sg13cmos5l_buf_1
XFILLER_48_18 VPWR VGND sg13cmos5l_decap_8
XANTENNA__1642__X Tile_X0Y0_FrameStrobe_O[2] VPWR VGND sg13cmos5l_antennanp
XFILLER_301_161 VPWR VGND sg13cmos5l_decap_8
X_1499_ _2453_/A3 VPWR VGND sg13cmos5l_tielo
X_0519_ _0519_/Q Tile_X0Y1_FrameData[15] VGND VPWR Tile_X0Y5_FrameStrobe[6] latch
XFILLER_58_126 VPWR VGND sg13cmos5l_decap_8
XFILLER_104_57 VPWR VGND sg13cmos5l_decap_8
XFILLER_251_63 VPWR VGND sg13cmos5l_decap_8
XFILLER_64_28 VPWR VGND sg13cmos5l_decap_8
XFILLER_120_56 VPWR VGND sg13cmos5l_decap_8
XFILLER_154_7 VPWR VGND sg13cmos5l_decap_8
XFILLER_13_21 VPWR VGND sg13cmos5l_decap_8
XFILLER_196_49 VPWR VGND sg13cmos5l_decap_8
XFILLER_321_7 VPWR VGND sg13cmos5l_decap_8
XFILLER_80_49 VPWR VGND sg13cmos5l_decap_8
XFILLER_129_21 VPWR VGND sg13cmos5l_decap_8
XANTENNA__1817__X Tile_X0Y4_EE4BEG[0] VPWR VGND sg13cmos5l_antennanp
XFILLER_13_98 VPWR VGND sg13cmos5l_decap_8
XFILLER_129_98 VPWR VGND sg13cmos5l_decap_8
XFILLER_135_131 VPWR VGND sg13cmos5l_decap_8
XFILLER_135_142 VPWR VGND sg13cmos5l_fill_2
XFILLER_89_36 VPWR VGND sg13cmos5l_decap_8
XFILLER_296_105 VPWR VGND sg13cmos5l_decap_8
XFILLER_145_42 VPWR VGND sg13cmos5l_decap_8
XFILLER_150_145 VPWR VGND sg13cmos5l_decap_8
XFILLER_292_70 VPWR VGND sg13cmos5l_decap_8
XANTENNA__1552__X Tile_X0Y3_EE4BEG[14] VPWR VGND sg13cmos5l_antennanp
XFILLER_49_126 VPWR VGND sg13cmos5l_decap_8
XFILLER_161_63 VPWR VGND sg13cmos5l_decap_8
XFILLER_180_0 VPWR VGND sg13cmos5l_decap_8
XFILLER_278_0 VPWR VGND sg13cmos5l_decap_8
XFILLER_38_84 VPWR VGND sg13cmos5l_decap_8
XANTENNA_320 Tile_X0Y0_FrameData[31] VPWR VGND sg13cmos5l_antennanp
XFILLER_220_105 VPWR VGND sg13cmos5l_decap_4
XFILLER_311_77 VPWR VGND sg13cmos5l_decap_8
XFILLER_359_161 VPWR VGND sg13cmos5l_decap_8
XFILLER_213_190 VPWR VGND sg13cmos5l_decap_8
XFILLER_158_267 VPWR VGND sg13cmos5l_decap_4
XFILLER_307_209 VPWR VGND sg13cmos5l_fill_2
X_0870_ _0870_/Q Tile_X0Y3_FrameData[16] VGND VPWR Tile_X0Y5_FrameStrobe[2] latch
XANTENNA__1727__X Tile_X0Y0_E2BEGb[7] VPWR VGND sg13cmos5l_antennanp
XFILLER_173_248 VPWR VGND sg13cmos5l_fill_2
XFILLER_126_142 VPWR VGND sg13cmos5l_fill_1
X_2540_ _2540_/X AXIL_S_SOC_ARADDR3 AXIL_S_SOC_ARADDR5 _2588_/X _2589_/X _0924_/Q
+ _0923_/Q VPWR VGND sg13cmos5l_mux4_1
XFILLER_126_164 VPWR VGND sg13cmos5l_decap_8
XFILLER_141_101 VPWR VGND sg13cmos5l_decap_8
X_2471_ _2471_/X _2458_/X Tile_X0Y5_N4END[12] _2457_/X Tile_X0Y0_S4END[8] _0582_/Q
+ _0581_/Q VPWR VGND sg13cmos5l_mux4_1
XFILLER_336_63 VPWR VGND sg13cmos5l_decap_8
XFILLER_287_105 VPWR VGND sg13cmos5l_decap_8
X_1422_ _1422_/Q Tile_X0Y5_FrameData[2] VGND VPWR Tile_X0Y5_FrameStrobe[4] latch
XFILLER_141_167 VPWR VGND sg13cmos5l_decap_8
XFILLER_79_91 VPWR VGND sg13cmos5l_decap_8
X_1353_ _1353_/Q Tile_X0Y5_FrameData[7] VGND VPWR Tile_X0Y5_FrameStrobe[2] latch
XFILLER_205_56 VPWR VGND sg13cmos5l_decap_8
XFILLER_228_227 VPWR VGND sg13cmos5l_decap_4
XFILLER_228_238 VPWR VGND sg13cmos5l_decap_8
XFILLER_295_182 VPWR VGND sg13cmos5l_decap_8
X_1284_ _1284_/Q Tile_X0Y5_FrameData[12] VGND VPWR Tile_X0Y5_FrameStrobe[0] latch
X_0304_ _0304_/Q Tile_X0Y0_FrameData[22] VGND VPWR Tile_X0Y5_FrameStrobe[7] latch
XFILLER_95_254 VPWR VGND sg13cmos5l_decap_8
XFILLER_352_84 VPWR VGND sg13cmos5l_decap_8
X_0235_ _0235_/Q Tile_X0Y0_FrameData[27] VGND VPWR Tile_X0Y5_FrameStrobe[5] latch
XFILLER_236_271 VPWR VGND sg13cmos5l_fill_2
X_0166_ _0166_/Q Tile_X0Y0_FrameData[0] VGND VPWR Tile_X0Y5_FrameStrobe[2] latch
XFILLER_63_140 VPWR VGND sg13cmos5l_decap_8
XFILLER_221_77 VPWR VGND sg13cmos5l_decap_8
X_0097_ _0097_/Q Tile_X0Y0_FrameData[5] VGND VPWR Tile_X0Y5_FrameStrobe[0] latch
XFILLER_211_149 VPWR VGND sg13cmos5l_fill_2
XANTENNA__1637__X Tile_X0Y0_N1BEG[1] VPWR VGND sg13cmos5l_antennanp
X_2807_ _2807_/X Tile_X0Y1_W1END[1] Tile_X0Y1_WW4END[9] Tile_X0Y1_WW4END[13] Tile_X0Y1_W6END[5]
+ _0391_/Q _0390_/Q VPWR VGND sg13cmos5l_mux4_1
X_0999_ _0999_/Q Tile_X0Y3_FrameData[15] VGND VPWR Tile_X0Y5_FrameStrobe[6] latch
X_2738_ _2738_/X AXIL_S_SOC_ARPROT0 AXIL_S_SOC_ARVALID _2827_/X _2799_/X _1426_/Q
+ _1425_/Q VPWR VGND sg13cmos5l_mux4_1
XFILLER_117_175 VPWR VGND sg13cmos5l_decap_8
XFILLER_246_63 VPWR VGND sg13cmos5l_decap_8
X_2669_ _2669_/X _2674_/X _2673_/X Tile_X0Y4_W6END[0] _2669_/A3 _1038_/Q _1037_/Q
+ VPWR VGND sg13cmos5l_mux4_1
XFILLER_59_28 VPWR VGND sg13cmos5l_decap_8
XFILLER_293_119 VPWR VGND sg13cmos5l_decap_8
XFILLER_115_56 VPWR VGND sg13cmos5l_decap_8
XFILLER_262_84 VPWR VGND sg13cmos5l_decap_8
XFILLER_286_182 VPWR VGND sg13cmos5l_decap_8
XFILLER_271_7 VPWR VGND sg13cmos5l_decap_8
XFILLER_75_49 VPWR VGND sg13cmos5l_decap_8
XFILLER_39_181 VPWR VGND sg13cmos5l_decap_8
XFILLER_54_140 VPWR VGND sg13cmos5l_decap_8
XFILLER_131_77 VPWR VGND sg13cmos5l_decap_8
XFILLER_199_156 VPWR VGND sg13cmos5l_decap_8
XFILLER_242_263 VPWR VGND sg13cmos5l_fill_2
XFILLER_202_116 VPWR VGND sg13cmos5l_fill_2
XFILLER_24_42 VPWR VGND sg13cmos5l_decap_8
XFILLER_287_70 VPWR VGND sg13cmos5l_decap_8
XANTENNA__1547__X Tile_X0Y3_EE4BEG[9] VPWR VGND sg13cmos5l_antennanp
XFILLER_6_203 VPWR VGND sg13cmos5l_fill_2
XFILLER_356_175 VPWR VGND sg13cmos5l_decap_8
XFILLER_108_142 VPWR VGND sg13cmos5l_decap_4
XFILLER_40_63 VPWR VGND sg13cmos5l_decap_8
XFILLER_108_153 VPWR VGND sg13cmos5l_decap_8
XFILLER_108_186 VPWR VGND sg13cmos5l_fill_1
XFILLER_156_63 VPWR VGND sg13cmos5l_decap_8
XFILLER_163_270 VPWR VGND sg13cmos5l_fill_2
XFILLER_123_112 VPWR VGND sg13cmos5l_decap_8
XFILLER_6_0 VPWR VGND sg13cmos5l_decap_8
XFILLER_284_119 VPWR VGND sg13cmos5l_decap_8
XFILLER_306_77 VPWR VGND sg13cmos5l_decap_8
XFILLER_172_84 VPWR VGND sg13cmos5l_decap_8
XFILLER_1_35 VPWR VGND sg13cmos5l_decap_8
XFILLER_322_21 VPWR VGND sg13cmos5l_decap_8
XFILLER_225_219 VPWR VGND sg13cmos5l_fill_2
XFILLER_233_241 VPWR VGND sg13cmos5l_fill_1
XFILLER_322_98 VPWR VGND sg13cmos5l_decap_8
XFILLER_45_162 VPWR VGND sg13cmos5l_decap_8
XFILLER_45_151 VPWR VGND sg13cmos5l_fill_1
XFILLER_45_140 VPWR VGND sg13cmos5l_decap_8
XANTENNA_150 AXIL_S_SOC_WDATA30 VPWR VGND sg13cmos5l_antennanp
XANTENNA_161 AXIL_S_SOC_WDATA31 VPWR VGND sg13cmos5l_antennanp
XANTENNA_172 AXIL_S_SOC_WDATA8 VPWR VGND sg13cmos5l_antennanp
XANTENNA_183 AXIL_S_SOC_WDATA9 VPWR VGND sg13cmos5l_antennanp
XANTENNA_194 AXIL_S_SOC_WDATA9 VPWR VGND sg13cmos5l_antennanp
XFILLER_60_154 VPWR VGND sg13cmos5l_decap_8
X_1971_ Tile_X0Y5_E2BEG[0] _2725_/X VPWR VGND sg13cmos5l_buf_1
XFILLER_197_70 VPWR VGND sg13cmos5l_decap_8
X_0922_ _0922_/Q Tile_X0Y3_FrameData[28] VGND VPWR Tile_X0Y5_FrameStrobe[4] latch
XFILLER_81_92 VPWR VGND sg13cmos5l_fill_1
XFILLER_347_142 VPWR VGND sg13cmos5l_decap_8
XFILLER_146_226 VPWR VGND sg13cmos5l_decap_8
X_0853_ _0853_/Q Tile_X0Y3_FrameData[1] VGND VPWR Tile_X0Y5_FrameStrobe[1] latch
XFILLER_362_101 VPWR VGND sg13cmos5l_decap_8
XFILLER_283_28 VPWR VGND sg13cmos5l_decap_8
X_2523_ _2523_/X AXIL_S_SOC_ARADDR4 AXIL_S_SOC_ARADDR6 _2590_/X _2595_/X _0958_/Q
+ _0957_/Q VPWR VGND sg13cmos5l_mux4_1
X_0784_ _0784_/Q Tile_X0Y2_FrameData[22] VGND VPWR Tile_X0Y5_FrameStrobe[7] latch
XFILLER_362_178 VPWR VGND sg13cmos5l_decap_8
XFILLER_114_112 VPWR VGND sg13cmos5l_decap_8
X_2454_ _2454_/X _2460_/X _2459_/X Tile_X0Y2_W6END[1] _2454_/A3 _0556_/Q _0555_/Q
+ VPWR VGND sg13cmos5l_mux4_1
XFILLER_216_77 VPWR VGND sg13cmos5l_decap_8
X_1405_ _1405_/Q Tile_X0Y5_FrameData[19] VGND VPWR Tile_X0Y5_FrameStrobe[4] latch
X_2385_ _2385_/X Tile_X0Y0_W2MID[5] Tile_X0Y0_W2END[5] Tile_X0Y0_W6END[10] _2243_/X
+ _0166_/Q _0165_/Q VPWR VGND sg13cmos5l_mux4_1
XFILLER_68_221 VPWR VGND sg13cmos5l_decap_4
XFILLER_39_0 VPWR VGND sg13cmos5l_decap_8
X_1336_ _1336_/Q Tile_X0Y5_FrameData[24] VGND VPWR Tile_X0Y5_FrameStrobe[2] latch
XFILLER_232_21 VPWR VGND sg13cmos5l_decap_8
XANTENNA__1920__X Tile_X0Y1_EE4BEG[1] VPWR VGND sg13cmos5l_antennanp
X_1267_ _1267_/Q Tile_X0Y5_FrameData[29] VGND VPWR Tile_X0Y5_FrameStrobe[0] latch
XFILLER_232_98 VPWR VGND sg13cmos5l_decap_8
X_1198_ _1198_/Q Tile_X0Y4_FrameData[24] VGND VPWR Tile_X0Y5_FrameStrobe[5] latch
X_0218_ _0218_/Q Tile_X0Y0_FrameData[12] VGND VPWR Tile_X0Y5_FrameStrobe[4] latch
XFILLER_36_151 VPWR VGND sg13cmos5l_fill_2
XFILLER_101_14 VPWR VGND sg13cmos5l_decap_8
X_0149_ _0149_/Q Tile_X0Y0_FrameData[17] VGND VPWR Tile_X0Y5_FrameStrobe[2] latch
XFILLER_51_154 VPWR VGND sg13cmos5l_decap_8
XFILLER_353_112 VPWR VGND sg13cmos5l_decap_8
XFILLER_117_7 VPWR VGND sg13cmos5l_decap_8
XFILLER_137_259 VPWR VGND sg13cmos5l_decap_4
XFILLER_152_207 VPWR VGND sg13cmos5l_decap_8
XFILLER_152_229 VPWR VGND sg13cmos5l_decap_8
XFILLER_193_28 VPWR VGND sg13cmos5l_decap_8
XFILLER_257_84 VPWR VGND sg13cmos5l_decap_8
XFILLER_353_189 VPWR VGND sg13cmos5l_decap_8
XFILLER_10_77 VPWR VGND sg13cmos5l_decap_8
XFILLER_120_126 VPWR VGND sg13cmos5l_decap_8
XFILLER_126_77 VPWR VGND sg13cmos5l_decap_8
XFILLER_266_119 VPWR VGND sg13cmos5l_decap_8
XFILLER_142_21 VPWR VGND sg13cmos5l_decap_8
XFILLER_19_42 VPWR VGND sg13cmos5l_decap_8
XANTENNA__1830__X Tile_X0Y4_EE4BEG[13] VPWR VGND sg13cmos5l_antennanp
XFILLER_74_224 VPWR VGND sg13cmos5l_fill_1
XFILLER_142_98 VPWR VGND sg13cmos5l_decap_8
XFILLER_27_173 VPWR VGND sg13cmos5l_fill_2
XFILLER_42_143 VPWR VGND sg13cmos5l_decap_8
XFILLER_35_63 VPWR VGND sg13cmos5l_decap_8
XFILLER_143_0 VPWR VGND sg13cmos5l_decap_8
XFILLER_187_126 VPWR VGND sg13cmos5l_decap_8
XFILLER_298_91 VPWR VGND sg13cmos5l_decap_8
XFILLER_128_237 VPWR VGND sg13cmos5l_decap_8
XFILLER_310_0 VPWR VGND sg13cmos5l_decap_8
XFILLER_344_112 VPWR VGND sg13cmos5l_decap_8
XFILLER_128_259 VPWR VGND sg13cmos5l_fill_2
XFILLER_51_84 VPWR VGND sg13cmos5l_decap_8
XFILLER_167_84 VPWR VGND sg13cmos5l_decap_8
XFILLER_317_21 VPWR VGND sg13cmos5l_decap_8
XFILLER_317_98 VPWR VGND sg13cmos5l_decap_8
XFILLER_111_126 VPWR VGND sg13cmos5l_decap_8
XFILLER_257_119 VPWR VGND sg13cmos5l_decap_8
XFILLER_32_7 VPWR VGND sg13cmos5l_decap_8
XFILLER_333_42 VPWR VGND sg13cmos5l_decap_8
XFILLER_265_141 VPWR VGND sg13cmos5l_decap_4
X_2170_ _2170_/X AXIL_S_SOC_WDATA21 AXIL_S_SOC_WDATA29 _2243_/X _2246_/X _0256_/Q
+ _0255_/Q VPWR VGND sg13cmos5l_mux4_1
XFILLER_76_70 VPWR VGND sg13cmos5l_decap_8
XANTENNA__1740__X Tile_X0Y2_FrameData_O[0] VPWR VGND sg13cmos5l_antennanp
X_1121_ _1121_/Q Tile_X0Y4_FrameData[5] VGND VPWR Tile_X0Y5_FrameStrobe[2] latch
XFILLER_18_140 VPWR VGND sg13cmos5l_fill_2
XFILLER_202_35 VPWR VGND sg13cmos5l_decap_8
X_1052_ _1052_/Q Tile_X0Y4_FrameData[10] VGND VPWR Tile_X0Y5_FrameStrobe[0] latch
XFILLER_280_177 VPWR VGND sg13cmos5l_decap_4
XFILLER_178_126 VPWR VGND sg13cmos5l_decap_8
XFILLER_278_28 VPWR VGND sg13cmos5l_decap_8
XFILLER_92_91 VPWR VGND sg13cmos5l_decap_8
XFILLER_33_176 VPWR VGND sg13cmos5l_decap_8
X_1954_ Tile_X0Y1_E2BEGb[7] _2308_/X VPWR VGND sg13cmos5l_buf_1
XFILLER_119_204 VPWR VGND sg13cmos5l_fill_1
XFILLER_193_118 VPWR VGND sg13cmos5l_decap_4
X_0905_ _0905_/Q Tile_X0Y3_FrameData[13] VGND VPWR Tile_X0Y5_FrameStrobe[3] latch
XFILLER_335_123 VPWR VGND sg13cmos5l_fill_1
X_1885_ Tile_X0Y2_E6BEG[11] _2444_/X VPWR VGND sg13cmos5l_buf_1
XFILLER_227_21 VPWR VGND sg13cmos5l_decap_8
XFILLER_294_49 VPWR VGND sg13cmos5l_decap_8
X_0836_ _0836_/Q Tile_X0Y3_FrameData[18] VGND VPWR Tile_X0Y5_FrameStrobe[1] latch
XANTENNA__1915__X Tile_X0Y1_FrameData_O[28] VPWR VGND sg13cmos5l_antennanp
X_0767_ _0767_/Q Tile_X0Y2_FrameData[7] VGND VPWR Tile_X0Y5_FrameStrobe[6] latch
XFILLER_227_98 VPWR VGND sg13cmos5l_decap_8
XFILLER_288_233 VPWR VGND sg13cmos5l_decap_8
X_2506_ _2506_/X _2568_/X _2567_/X AXIL_S_SOC_ARADDR3 AXIL_S_SOC_ARADDR6 _0992_/Q
+ _0991_/Q VPWR VGND sg13cmos5l_mux4_1
X_2437_ _2437_/X AXIL_S_SOC_AWADDR4 _2473_/X _2466_/X _2481_/X _0674_/Q _0673_/Q VPWR
+ VGND sg13cmos5l_mux4_1
X_0698_ _0698_/Q Tile_X0Y2_FrameData[12] VGND VPWR Tile_X0Y5_FrameStrobe[4] latch
XFILLER_243_42 VPWR VGND sg13cmos5l_decap_8
X_2368_ _2368_/X _2346_/X _0030_/X _2345_/X Tile_X0Y0_S4END[6] _0362_/Q _0361_/Q VPWR
+ VGND sg13cmos5l_mux4_1
XANTENNA__1650__X Tile_X0Y0_FrameStrobe_O[10] VPWR VGND sg13cmos5l_antennanp
X_1319_ _1319_/Q Tile_X0Y5_FrameData[9] VGND VPWR Tile_X0Y5_FrameStrobe[1] latch
X_2299_ _2299_/X AXIL_S_SOC_WDATA6 AXIL_S_SOC_WDATA14 _2374_/X _2379_/X _0494_/Q _0493_/Q
+ VPWR VGND sg13cmos5l_mux4_1
XFILLER_56_224 VPWR VGND sg13cmos5l_decap_8
XFILLER_56_268 VPWR VGND sg13cmos5l_decap_4
XFILLER_112_35 VPWR VGND sg13cmos5l_decap_8
XFILLER_271_199 VPWR VGND sg13cmos5l_fill_2
XFILLER_72_28 VPWR VGND sg13cmos5l_decap_8
XFILLER_188_28 VPWR VGND sg13cmos5l_decap_8
XFILLER_212_244 VPWR VGND sg13cmos5l_decap_8
XFILLER_24_154 VPWR VGND sg13cmos5l_decap_8
XFILLER_234_7 VPWR VGND sg13cmos5l_decap_8
XANTENNA_50 AXIL_S_SOC_WDATA15 VPWR VGND sg13cmos5l_antennanp
XANTENNA_61 AXIL_S_SOC_WDATA16 VPWR VGND sg13cmos5l_antennanp
XANTENNA_72 AXIL_S_SOC_WDATA25 VPWR VGND sg13cmos5l_antennanp
XANTENNA_83 AXIL_S_SOC_WDATA25 VPWR VGND sg13cmos5l_antennanp
XFILLER_177_192 VPWR VGND sg13cmos5l_decap_8
XFILLER_192_140 VPWR VGND sg13cmos5l_decap_8
XFILLER_21_21 VPWR VGND sg13cmos5l_decap_8
XANTENNA_94 AXIL_S_SOC_WDATA26 VPWR VGND sg13cmos5l_antennanp
XFILLER_137_21 VPWR VGND sg13cmos5l_decap_8
XANTENNA__1825__X Tile_X0Y4_EE4BEG[8] VPWR VGND sg13cmos5l_antennanp
XFILLER_21_98 VPWR VGND sg13cmos5l_decap_8
XFILLER_97_14 VPWR VGND sg13cmos5l_decap_8
XFILLER_341_126 VPWR VGND sg13cmos5l_decap_8
XFILLER_153_42 VPWR VGND sg13cmos5l_decap_8
XFILLER_239_119 VPWR VGND sg13cmos5l_decap_8
XANTENNA__1560__X Tile_X0Y3_FrameData_O[6] VPWR VGND sg13cmos5l_antennanp
XFILLER_47_246 VPWR VGND sg13cmos5l_decap_8
XFILLER_303_56 VPWR VGND sg13cmos5l_decap_8
XFILLER_260_0 VPWR VGND sg13cmos5l_decap_8
XFILLER_262_166 VPWR VGND sg13cmos5l_decap_8
XFILLER_358_0 VPWR VGND sg13cmos5l_decap_8
XFILLER_70_271 VPWR VGND sg13cmos5l_fill_2
XFILLER_349_237 VPWR VGND sg13cmos5l_fill_1
XFILLER_168_170 VPWR VGND sg13cmos5l_fill_2
XFILLER_30_168 VPWR VGND sg13cmos5l_fill_2
XFILLER_357_270 VPWR VGND sg13cmos5l_fill_2
XFILLER_183_140 VPWR VGND sg13cmos5l_decap_8
XFILLER_317_112 VPWR VGND sg13cmos5l_decap_8
XFILLER_317_134 VPWR VGND sg13cmos5l_decap_4
XFILLER_328_42 VPWR VGND sg13cmos5l_decap_8
X_1670_ Tile_X0Y0_FrameData_O[10] Tile_X0Y0_FrameData[10] VPWR VGND sg13cmos5l_buf_1
XFILLER_7_56 VPWR VGND sg13cmos5l_decap_8
XFILLER_183_184 VPWR VGND sg13cmos5l_fill_2
X_0621_ _0621_/Q Tile_X0Y2_FrameData[25] VGND VPWR Tile_X0Y5_FrameStrobe[2] latch
XANTENNA__1735__X Tile_X0Y0_E2BEG[7] VPWR VGND sg13cmos5l_antennanp
X_0552_ _0552_/Q Tile_X0Y2_FrameData[30] VGND VPWR Tile_X0Y5_FrameStrobe[0] latch
X_0483_ _0483_/Q Tile_X0Y1_FrameData[19] VGND VPWR Tile_X0Y5_FrameStrobe[5] latch
XFILLER_344_63 VPWR VGND sg13cmos5l_decap_8
XFILLER_340_181 VPWR VGND sg13cmos5l_fill_1
XFILLER_285_269 VPWR VGND sg13cmos5l_decap_4
X_2222_ _2222_/X _2215_/X _0064_/X Tile_X0Y0_S1END[2] Tile_X0Y0_S4END[2] _0106_/Q
+ _0105_/Q VPWR VGND sg13cmos5l_mux4_1
XFILLER_87_91 VPWR VGND sg13cmos5l_fill_2
X_2153_ _2153_/X Tile_X0Y0_W1END[0] Tile_X0Y0_WW4END[0] Tile_X0Y0_WW4END[4] Tile_X0Y0_W6END[8]
+ _0286_/Q _0285_/Q VPWR VGND sg13cmos5l_mux4_1
XFILLER_213_56 VPWR VGND sg13cmos5l_decap_8
XFILLER_238_196 VPWR VGND sg13cmos5l_decap_8
X_1104_ _1104_/Q Tile_X0Y4_FrameData[22] VGND VPWR Tile_X0Y5_FrameStrobe[2] latch
XFILLER_213_89 VPWR VGND sg13cmos5l_decap_8
X_2084_ Tile_X0Y3_E1BEG[0] _2505_/X VPWR VGND sg13cmos5l_buf_1
XFILLER_53_238 VPWR VGND sg13cmos5l_decap_8
XFILLER_360_84 VPWR VGND sg13cmos5l_fill_2
XFILLER_253_177 VPWR VGND sg13cmos5l_fill_1
XFILLER_289_49 VPWR VGND sg13cmos5l_decap_8
X_1035_ _1035_/Q Tile_X0Y4_FrameData[27] VGND VPWR Tile_X0Y5_FrameStrobe[0] latch
XFILLER_308_112 VPWR VGND sg13cmos5l_decap_8
X_1937_ Tile_X0Y1_E6BEG[2] _2327_/X VPWR VGND sg13cmos5l_buf_1
XFILLER_174_140 VPWR VGND sg13cmos5l_decap_8
XFILLER_238_42 VPWR VGND sg13cmos5l_decap_8
X_1868_ Tile_X0Y2_E2BEGb[2] _2411_/X VPWR VGND sg13cmos5l_buf_1
X_0819_ _0819_/Q Tile_X0Y3_FrameData[3] VGND VPWR Tile_X0Y5_FrameStrobe[0] latch
XANTENNA__1645__X Tile_X0Y0_FrameStrobe_O[5] VPWR VGND sg13cmos5l_antennanp
X_1799_ Tile_X0Y4_E2BEGb[2] _2627_/X VPWR VGND sg13cmos5l_buf_1
XFILLER_107_35 VPWR VGND sg13cmos5l_decap_8
XFILLER_254_63 VPWR VGND sg13cmos5l_decap_8
XFILLER_67_28 VPWR VGND sg13cmos5l_decap_8
XFILLER_88_168 VPWR VGND sg13cmos5l_decap_8
XFILLER_184_7 VPWR VGND sg13cmos5l_decap_8
XFILLER_123_56 VPWR VGND sg13cmos5l_decap_8
XFILLER_244_133 VPWR VGND sg13cmos5l_decap_8
XFILLER_270_84 VPWR VGND sg13cmos5l_decap_4
XFILLER_83_49 VPWR VGND sg13cmos5l_decap_8
XFILLER_16_21 VPWR VGND sg13cmos5l_decap_8
XFILLER_199_49 VPWR VGND sg13cmos5l_decap_8
XFILLER_351_7 VPWR VGND sg13cmos5l_decap_8
XFILLER_16_98 VPWR VGND sg13cmos5l_decap_8
XFILLER_200_236 VPWR VGND sg13cmos5l_fill_2
XFILLER_32_42 VPWR VGND sg13cmos5l_decap_8
XFILLER_148_42 VPWR VGND sg13cmos5l_decap_8
XFILLER_165_162 VPWR VGND sg13cmos5l_decap_8
XFILLER_295_70 VPWR VGND sg13cmos5l_decap_8
XANTENNA__1555__X Tile_X0Y3_FrameData_O[1] VPWR VGND sg13cmos5l_antennanp
XFILLER_106_0 VPWR VGND sg13cmos5l_decap_8
XFILLER_180_154 VPWR VGND sg13cmos5l_decap_8
XFILLER_121_232 VPWR VGND sg13cmos5l_fill_1
XFILLER_164_63 VPWR VGND sg13cmos5l_decap_8
XFILLER_121_254 VPWR VGND sg13cmos5l_fill_2
XFILLER_267_236 VPWR VGND sg13cmos5l_fill_2
XFILLER_282_206 VPWR VGND sg13cmos5l_decap_8
XFILLER_314_77 VPWR VGND sg13cmos5l_decap_8
XFILLER_235_133 VPWR VGND sg13cmos5l_decap_8
XFILLER_180_84 VPWR VGND sg13cmos5l_decap_8
XFILLER_330_21 VPWR VGND sg13cmos5l_decap_8
XFILLER_330_98 VPWR VGND sg13cmos5l_decap_4
XFILLER_50_219 VPWR VGND sg13cmos5l_decap_8
X_2771_ _2771_/X Tile_X0Y5_W1END[2] Tile_X0Y5_W6END[10] _2805_/X _2791_/X _1360_/Q
+ _1359_/Q VPWR VGND sg13cmos5l_mux4_1
XFILLER_339_63 VPWR VGND sg13cmos5l_decap_8
XFILLER_156_151 VPWR VGND sg13cmos5l_decap_8
X_1722_ Tile_X0Y0_E2BEGb[2] _2175_/X VPWR VGND sg13cmos5l_buf_1
XFILLER_305_126 VPWR VGND sg13cmos5l_decap_8
X_1653_ Tile_X0Y0_FrameStrobe_O[13] Tile_X0Y5_FrameStrobe[13] VPWR VGND sg13cmos5l_buf_1
XFILLER_7_161 VPWR VGND sg13cmos5l_decap_8
XFILLER_171_165 VPWR VGND sg13cmos5l_decap_8
XFILLER_208_56 VPWR VGND sg13cmos5l_decap_8
X_0604_ _0604_/Q Tile_X0Y2_FrameData[10] VGND VPWR Tile_X0Y5_FrameStrobe[1] latch
X_1584_ Tile_X0Y3_FrameData_O[30] Tile_X0Y3_FrameData[30] VPWR VGND sg13cmos5l_buf_1
XFILLER_355_84 VPWR VGND sg13cmos5l_decap_8
XFILLER_112_221 VPWR VGND sg13cmos5l_decap_8
XFILLER_258_203 VPWR VGND sg13cmos5l_decap_4
XFILLER_291_28 VPWR VGND sg13cmos5l_decap_8
X_0535_ _0535_/Q Tile_X0Y1_FrameData[31] VGND VPWR Tile_X0Y5_FrameStrobe[7] latch
XFILLER_21_0 VPWR VGND sg13cmos5l_decap_8
XFILLER_258_236 VPWR VGND sg13cmos5l_fill_2
X_0466_ _0466_/Q Tile_X0Y1_FrameData[4] VGND VPWR Tile_X0Y5_FrameStrobe[4] latch
XFILLER_224_77 VPWR VGND sg13cmos5l_decap_8
X_2205_ _2205_/X AXIL_S_SOC_WDATA16 _2235_/X _2233_/X _2245_/X _0186_/Q _0185_/Q VPWR
+ VGND sg13cmos5l_mux4_1
X_0397_ _0397_/Q Tile_X0Y1_FrameData[9] VGND VPWR Tile_X0Y5_FrameStrobe[2] latch
XFILLER_240_21 VPWR VGND sg13cmos5l_decap_8
X_2136_ AXIL_S_SOC_RDATA30 Tile_X0Y0_W2MID[6] Tile_X0Y0_W2END[6] Tile_X0Y0_W6END[6]
+ _2247_/X _0130_/Q _0129_/Q VPWR VGND sg13cmos5l_mux4_1
XFILLER_93_171 VPWR VGND sg13cmos5l_decap_8
X_2067_ Tile_X0Y5_S4BEG[0] _2067_/A VPWR VGND sg13cmos5l_buf_1
XFILLER_240_98 VPWR VGND sg13cmos5l_decap_8
XFILLER_241_147 VPWR VGND sg13cmos5l_decap_8
X_1018_ _1018_/Q Tile_X0Y3_FrameData[28] VGND VPWR Tile_X0Y5_FrameStrobe[7] latch
XFILLER_41_208 VPWR VGND sg13cmos5l_fill_2
XFILLER_179_243 VPWR VGND sg13cmos5l_decap_4
XFILLER_249_63 VPWR VGND sg13cmos5l_decap_8
XFILLER_351_210 VPWR VGND sg13cmos5l_decap_4
XFILLER_118_56 VPWR VGND sg13cmos5l_decap_8
XFILLER_162_154 VPWR VGND sg13cmos5l_fill_2
XFILLER_351_243 VPWR VGND sg13cmos5l_decap_8
XFILLER_265_84 VPWR VGND sg13cmos5l_decap_4
XFILLER_78_49 VPWR VGND sg13cmos5l_decap_8
XFILLER_103_265 VPWR VGND sg13cmos5l_decap_8
XFILLER_76_105 VPWR VGND sg13cmos5l_decap_8
XFILLER_134_77 VPWR VGND sg13cmos5l_decap_8
XFILLER_76_149 VPWR VGND sg13cmos5l_fill_2
XFILLER_150_21 VPWR VGND sg13cmos5l_decap_8
XFILLER_217_144 VPWR VGND sg13cmos5l_decap_4
XFILLER_27_42 VPWR VGND sg13cmos5l_decap_8
XFILLER_17_238 VPWR VGND sg13cmos5l_fill_1
XFILLER_232_147 VPWR VGND sg13cmos5l_decap_8
XFILLER_300_35 VPWR VGND sg13cmos5l_decap_8
XFILLER_185_224 VPWR VGND sg13cmos5l_decap_4
XFILLER_43_63 VPWR VGND sg13cmos5l_decap_8
XFILLER_159_63 VPWR VGND sg13cmos5l_decap_8
XFILLER_138_151 VPWR VGND sg13cmos5l_decap_8
XFILLER_223_0 VPWR VGND sg13cmos5l_decap_8
XFILLER_309_77 VPWR VGND sg13cmos5l_decap_8
XFILLER_153_187 VPWR VGND sg13cmos5l_decap_8
XFILLER_175_84 VPWR VGND sg13cmos5l_decap_8
XFILLER_299_147 VPWR VGND sg13cmos5l_decap_8
XFILLER_325_21 VPWR VGND sg13cmos5l_decap_8
XFILLER_4_35 VPWR VGND sg13cmos5l_decap_8
XFILLER_310_140 VPWR VGND sg13cmos5l_decap_8
X_0320_ _0320_/Q Tile_X0Y1_FrameData[22] VGND VPWR Tile_X0Y5_FrameStrobe[0] latch
XFILLER_67_105 VPWR VGND sg13cmos5l_decap_8
XFILLER_325_98 VPWR VGND sg13cmos5l_decap_8
X_0251_ _0251_/Q Tile_X0Y0_FrameData[11] VGND VPWR Tile_X0Y5_FrameStrobe[5] latch
XFILLER_341_42 VPWR VGND sg13cmos5l_decap_8
X_0182_ _0182_/Q Tile_X0Y0_FrameData[16] VGND VPWR Tile_X0Y5_FrameStrobe[3] latch
XFILLER_82_119 VPWR VGND sg13cmos5l_decap_8
XFILLER_208_188 VPWR VGND sg13cmos5l_decap_8
XFILLER_263_272 VPWR VGND sg13cmos5l_fill_1
XFILLER_84_70 VPWR VGND sg13cmos5l_decap_8
XFILLER_223_125 VPWR VGND sg13cmos5l_decap_8
XFILLER_23_219 VPWR VGND sg13cmos5l_decap_8
XFILLER_210_35 VPWR VGND sg13cmos5l_decap_8
XFILLER_210_79 VPWR VGND sg13cmos5l_fill_1
XFILLER_176_235 VPWR VGND sg13cmos5l_fill_1
XFILLER_176_246 VPWR VGND sg13cmos5l_fill_1
XFILLER_231_191 VPWR VGND sg13cmos5l_fill_2
X_2823_ _2823_/X Tile_X0Y5_N1END[0] Tile_X0Y5_N4END[0] _2793_/X _0032_/X _1312_/Q
+ _1311_/Q VPWR VGND sg13cmos5l_mux4_1
X_2754_ _2754_/X AXIL_S_SOC_ARPROT1 AXIL_S_SOC_ARVALID _2820_/X _2827_/X _1394_/Q
+ _1393_/Q VPWR VGND sg13cmos5l_mux4_1
XFILLER_129_184 VPWR VGND sg13cmos5l_decap_8
X_1705_ Tile_X0Y0_EE4BEG[13] _2194_/X VPWR VGND sg13cmos5l_buf_1
XFILLER_69_0 VPWR VGND sg13cmos5l_decap_8
XFILLER_219_77 VPWR VGND sg13cmos5l_decap_8
X_2685_ _2685_/X _2680_/X Tile_X0Y5_N4END[7] _2679_/X _0025_/X _1064_/Q _1063_/Q VPWR
+ VGND sg13cmos5l_mux4_1
XFILLER_144_187 VPWR VGND sg13cmos5l_decap_8
XFILLER_235_21 VPWR VGND sg13cmos5l_decap_8
X_1636_ Tile_X0Y0_N1BEG[0] _2141_/X VPWR VGND sg13cmos5l_buf_1
X_1567_ Tile_X0Y3_FrameData_O[13] Tile_X0Y3_FrameData[13] VPWR VGND sg13cmos5l_buf_1
XANTENNA__1923__X Tile_X0Y1_EE4BEG[4] VPWR VGND sg13cmos5l_antennanp
XFILLER_301_140 VPWR VGND sg13cmos5l_decap_8
X_0518_ _0518_/Q Tile_X0Y1_FrameData[16] VGND VPWR Tile_X0Y5_FrameStrobe[6] latch
XFILLER_58_105 VPWR VGND sg13cmos5l_decap_8
XFILLER_235_98 VPWR VGND sg13cmos5l_decap_8
X_1498_ _2564_/A3 VPWR VGND sg13cmos5l_tielo
XFILLER_104_36 VPWR VGND sg13cmos5l_decap_8
X_0449_ _0449_/Q Tile_X0Y1_FrameData[21] VGND VPWR Tile_X0Y5_FrameStrobe[4] latch
XFILLER_251_42 VPWR VGND sg13cmos5l_decap_8
XFILLER_254_272 VPWR VGND sg13cmos5l_fill_1
X_2119_ AXIL_S_SOC_RDATA13 Tile_X0Y2_W2MID[5] Tile_X0Y2_W2END[5] Tile_X0Y2_W6END[5]
+ _2486_/X _0612_/Q _0611_/Q VPWR VGND sg13cmos5l_mux4_1
XFILLER_120_35 VPWR VGND sg13cmos5l_decap_8
XFILLER_147_7 VPWR VGND sg13cmos5l_decap_8
XFILLER_222_180 VPWR VGND sg13cmos5l_decap_8
XFILLER_80_28 VPWR VGND sg13cmos5l_decap_8
XFILLER_196_28 VPWR VGND sg13cmos5l_decap_8
XFILLER_314_7 VPWR VGND sg13cmos5l_decap_8
XFILLER_13_77 VPWR VGND sg13cmos5l_decap_8
XFILLER_89_15 VPWR VGND sg13cmos5l_decap_8
XFILLER_129_77 VPWR VGND sg13cmos5l_decap_8
XFILLER_135_165 VPWR VGND sg13cmos5l_decap_8
XFILLER_145_21 VPWR VGND sg13cmos5l_decap_8
XFILLER_150_124 VPWR VGND sg13cmos5l_decap_8
XANTENNA__1833__X Tile_X0Y4_FrameData_O[0] VPWR VGND sg13cmos5l_antennanp
XFILLER_89_252 VPWR VGND sg13cmos5l_decap_4
XFILLER_49_105 VPWR VGND sg13cmos5l_decap_8
XFILLER_145_98 VPWR VGND sg13cmos5l_decap_8
XFILLER_237_217 VPWR VGND sg13cmos5l_decap_8
XFILLER_237_239 VPWR VGND sg13cmos5l_fill_1
XFILLER_38_63 VPWR VGND sg13cmos5l_decap_8
XFILLER_161_42 VPWR VGND sg13cmos5l_decap_8
XFILLER_64_119 VPWR VGND sg13cmos5l_decap_8
XANTENNA_310 Tile_X0Y0_FrameData[23] VPWR VGND sg13cmos5l_antennanp
XFILLER_173_0 VPWR VGND sg13cmos5l_decap_8
XFILLER_245_272 VPWR VGND sg13cmos5l_fill_1
XFILLER_57_182 VPWR VGND sg13cmos5l_decap_8
XANTENNA_321 Tile_X0Y0_FrameData[31] VPWR VGND sg13cmos5l_antennanp
XFILLER_311_56 VPWR VGND sg13cmos5l_decap_8
XFILLER_54_84 VPWR VGND sg13cmos5l_decap_8
XFILLER_340_0 VPWR VGND sg13cmos5l_decap_8
XFILLER_220_139 VPWR VGND sg13cmos5l_decap_8
XFILLER_359_140 VPWR VGND sg13cmos5l_decap_8
XFILLER_158_246 VPWR VGND sg13cmos5l_decap_8
XFILLER_173_227 VPWR VGND sg13cmos5l_decap_8
XFILLER_315_243 VPWR VGND sg13cmos5l_fill_2
XFILLER_62_7 VPWR VGND sg13cmos5l_decap_8
XFILLER_126_176 VPWR VGND sg13cmos5l_decap_8
XFILLER_126_187 VPWR VGND sg13cmos5l_decap_4
XFILLER_181_260 VPWR VGND sg13cmos5l_fill_2
XFILLER_181_271 VPWR VGND sg13cmos5l_fill_2
X_2470_ _2470_/X _2460_/X Tile_X0Y5_N4END[13] _2459_/X Tile_X0Y0_S4END[9] _0588_/Q
+ _0587_/Q VPWR VGND sg13cmos5l_mux4_1
XFILLER_336_42 VPWR VGND sg13cmos5l_decap_8
X_1421_ _1421_/Q Tile_X0Y5_FrameData[3] VGND VPWR Tile_X0Y5_FrameStrobe[4] latch
XFILLER_79_70 VPWR VGND sg13cmos5l_decap_8
XANTENNA__1743__X Tile_X0Y2_FrameData_O[3] VPWR VGND sg13cmos5l_antennanp
XFILLER_205_35 VPWR VGND sg13cmos5l_decap_8
XFILLER_295_161 VPWR VGND sg13cmos5l_decap_8
X_1352_ _1352_/Q Tile_X0Y5_FrameData[8] VGND VPWR Tile_X0Y5_FrameStrobe[2] latch
XFILLER_95_233 VPWR VGND sg13cmos5l_decap_8
XFILLER_95_200 VPWR VGND sg13cmos5l_decap_8
X_1283_ _1283_/Q Tile_X0Y5_FrameData[13] VGND VPWR Tile_X0Y5_FrameStrobe[0] latch
X_0303_ _0303_/Q Tile_X0Y0_FrameData[23] VGND VPWR Tile_X0Y5_FrameStrobe[7] latch
XFILLER_352_63 VPWR VGND sg13cmos5l_decap_8
X_0234_ _0234_/Q Tile_X0Y0_FrameData[28] VGND VPWR Tile_X0Y5_FrameStrobe[5] latch
XFILLER_55_119 VPWR VGND sg13cmos5l_decap_8
XFILLER_48_193 VPWR VGND sg13cmos5l_decap_8
XFILLER_221_56 VPWR VGND sg13cmos5l_decap_8
X_0165_ _0165_/Q Tile_X0Y0_FrameData[1] VGND VPWR Tile_X0Y5_FrameStrobe[2] latch
X_0096_ _0096_/Q Tile_X0Y0_FrameData[6] VGND VPWR Tile_X0Y5_FrameStrobe[0] latch
XFILLER_297_49 VPWR VGND sg13cmos5l_decap_8
XANTENNA__1918__X Tile_X0Y1_FrameData_O[31] VPWR VGND sg13cmos5l_antennanp
X_2806_ _2806_/X Tile_X0Y5_N1END[2] Tile_X0Y5_N4END[2] _2795_/X _0058_/X _1300_/Q
+ _1299_/Q VPWR VGND sg13cmos5l_mux4_1
X_0998_ _0998_/Q Tile_X0Y3_FrameData[16] VGND VPWR Tile_X0Y5_FrameStrobe[6] latch
X_2737_ _2737_/X AXIL_S_SOC_ARPROT2 AXIL_S_SOC_RREADY _2828_/X _2800_/X _1428_/Q _1427_/Q
+ VPWR VGND sg13cmos5l_mux4_1
XFILLER_117_154 VPWR VGND sg13cmos5l_decap_8
XFILLER_172_271 VPWR VGND sg13cmos5l_fill_2
XFILLER_246_42 VPWR VGND sg13cmos5l_decap_8
X_2668_ _2668_/X _2700_/X _2685_/X _2684_/X _2681_/X _1099_/Q _1098_/Q VPWR VGND sg13cmos5l_mux4_1
XFILLER_132_124 VPWR VGND sg13cmos5l_decap_8
X_1619_ Tile_X0Y0_N4BEG[15] _1619_/A VPWR VGND sg13cmos5l_buf_1
XANTENNA__1653__X Tile_X0Y0_FrameStrobe_O[13] VPWR VGND sg13cmos5l_antennanp
X_2599_ _2599_/X Tile_X0Y2_W2MID[6] Tile_X0Y2_W2END[6] Tile_X0Y2_W6END[9] _2482_/X
+ _0648_/Q _0647_/Q VPWR VGND sg13cmos5l_mux4_1
XFILLER_115_35 VPWR VGND sg13cmos5l_decap_8
XFILLER_86_211 VPWR VGND sg13cmos5l_fill_2
XFILLER_219_228 VPWR VGND sg13cmos5l_decap_8
XFILLER_262_63 VPWR VGND sg13cmos5l_decap_8
XFILLER_75_28 VPWR VGND sg13cmos5l_decap_8
XFILLER_227_261 VPWR VGND sg13cmos5l_fill_1
XFILLER_131_56 VPWR VGND sg13cmos5l_decap_8
XFILLER_264_7 VPWR VGND sg13cmos5l_decap_8
XFILLER_91_49 VPWR VGND sg13cmos5l_decap_8
XFILLER_54_196 VPWR VGND sg13cmos5l_decap_8
XFILLER_24_21 VPWR VGND sg13cmos5l_decap_8
XANTENNA__1828__X Tile_X0Y4_EE4BEG[11] VPWR VGND sg13cmos5l_antennanp
XFILLER_10_211 VPWR VGND sg13cmos5l_fill_2
XFILLER_24_98 VPWR VGND sg13cmos5l_decap_8
XFILLER_356_154 VPWR VGND sg13cmos5l_decap_8
XFILLER_10_255 VPWR VGND sg13cmos5l_fill_1
XFILLER_6_237 VPWR VGND sg13cmos5l_fill_1
XFILLER_40_42 VPWR VGND sg13cmos5l_decap_8
XFILLER_108_176 VPWR VGND sg13cmos5l_fill_2
XFILLER_156_42 VPWR VGND sg13cmos5l_decap_8
XFILLER_170_219 VPWR VGND sg13cmos5l_decap_8
XFILLER_312_235 VPWR VGND sg13cmos5l_fill_1
XANTENNA__1563__X Tile_X0Y3_FrameData_O[9] VPWR VGND sg13cmos5l_antennanp
XFILLER_123_168 VPWR VGND sg13cmos5l_decap_8
XFILLER_306_56 VPWR VGND sg13cmos5l_decap_8
XFILLER_290_0 VPWR VGND sg13cmos5l_decap_8
XFILLER_172_63 VPWR VGND sg13cmos5l_decap_8
XFILLER_1_14 VPWR VGND sg13cmos5l_decap_8
XFILLER_277_172 VPWR VGND sg13cmos5l_decap_8
XFILLER_49_84 VPWR VGND sg13cmos5l_decap_8
XFILLER_37_119 VPWR VGND sg13cmos5l_decap_8
XFILLER_218_272 VPWR VGND sg13cmos5l_fill_1
XFILLER_292_186 VPWR VGND sg13cmos5l_decap_8
XFILLER_322_77 VPWR VGND sg13cmos5l_decap_8
XANTENNA_140 AXIL_S_SOC_WDATA30 VPWR VGND sg13cmos5l_antennanp
XANTENNA_151 AXIL_S_SOC_WDATA31 VPWR VGND sg13cmos5l_antennanp
XANTENNA_162 AXIL_S_SOC_WDATA31 VPWR VGND sg13cmos5l_antennanp
XANTENNA_173 AXIL_S_SOC_WDATA8 VPWR VGND sg13cmos5l_antennanp
XANTENNA_184 AXIL_S_SOC_WDATA9 VPWR VGND sg13cmos5l_antennanp
X_1970_ Tile_X0Y5_E1BEG[3] _2724_/X VPWR VGND sg13cmos5l_buf_1
XFILLER_60_133 VPWR VGND sg13cmos5l_decap_8
XANTENNA_195 AXIL_S_SOC_WDATA9 VPWR VGND sg13cmos5l_antennanp
X_0921_ _0921_/Q Tile_X0Y3_FrameData[29] VGND VPWR Tile_X0Y5_FrameStrobe[4] latch
XFILLER_81_71 VPWR VGND sg13cmos5l_decap_8
XFILLER_347_121 VPWR VGND sg13cmos5l_decap_8
XANTENNA__1738__X Tile_X0Y0_E1BEG[2] VPWR VGND sg13cmos5l_antennanp
XFILLER_201_150 VPWR VGND sg13cmos5l_decap_8
XFILLER_201_161 VPWR VGND sg13cmos5l_fill_1
X_0852_ _0852_/Q Tile_X0Y3_FrameData[2] VGND VPWR Tile_X0Y5_FrameStrobe[1] latch
X_0783_ _0783_/Q Tile_X0Y2_FrameData[23] VGND VPWR Tile_X0Y5_FrameStrobe[7] latch
XFILLER_154_271 VPWR VGND sg13cmos5l_fill_2
XFILLER_161_219 VPWR VGND sg13cmos5l_decap_8
X_2522_ _2522_/X AXIL_S_SOC_ARADDR3 AXIL_S_SOC_ARADDR5 _2591_/X _2594_/X _0960_/Q
+ _0959_/Q VPWR VGND sg13cmos5l_mux4_1
XFILLER_362_157 VPWR VGND sg13cmos5l_decap_8
XFILLER_303_235 VPWR VGND sg13cmos5l_decap_8
XFILLER_114_168 VPWR VGND sg13cmos5l_fill_1
XFILLER_216_56 VPWR VGND sg13cmos5l_decap_8
XFILLER_303_246 VPWR VGND sg13cmos5l_decap_8
X_2453_ _2453_/X _2458_/X _2457_/X Tile_X0Y2_W6END[0] _2453_/A3 _0558_/Q _0557_/Q
+ VPWR VGND sg13cmos5l_mux4_1
XFILLER_114_179 VPWR VGND sg13cmos5l_decap_8
X_1404_ _1404_/Q Tile_X0Y5_FrameData[20] VGND VPWR Tile_X0Y5_FrameStrobe[4] latch
X_2384_ _2384_/X Tile_X0Y3_W2MID[6] Tile_X0Y3_W2END[6] Tile_X0Y3_W6END[6] _2590_/X
+ _1020_/Q _1019_/Q VPWR VGND sg13cmos5l_mux4_1
XFILLER_122_190 VPWR VGND sg13cmos5l_decap_4
X_1335_ _1335_/Q Tile_X0Y5_FrameData[25] VGND VPWR Tile_X0Y5_FrameStrobe[2] latch
XFILLER_68_233 VPWR VGND sg13cmos5l_fill_2
XFILLER_283_164 VPWR VGND sg13cmos5l_decap_8
XFILLER_283_175 VPWR VGND sg13cmos5l_fill_1
X_1266_ _1266_/Q Tile_X0Y5_FrameData[30] VGND VPWR Tile_X0Y5_FrameStrobe[0] latch
XFILLER_232_77 VPWR VGND sg13cmos5l_decap_8
X_1197_ _1197_/Q Tile_X0Y4_FrameData[25] VGND VPWR Tile_X0Y5_FrameStrobe[5] latch
X_0217_ _0217_/Q Tile_X0Y0_FrameData[13] VGND VPWR Tile_X0Y5_FrameStrobe[4] latch
X_0148_ _0148_/Q Tile_X0Y0_FrameData[18] VGND VPWR Tile_X0Y5_FrameStrobe[2] latch
XFILLER_36_196 VPWR VGND sg13cmos5l_decap_8
XFILLER_196_105 VPWR VGND sg13cmos5l_decap_8
XFILLER_51_133 VPWR VGND sg13cmos5l_decap_8
X_0079_ _0079_/Q Tile_X0Y0_FrameData[23] VGND VPWR Tile_X0Y5_FrameStrobe[0] latch
XANTENNA__1648__X Tile_X0Y0_FrameStrobe_O[8] VPWR VGND sg13cmos5l_antennanp
XFILLER_257_63 VPWR VGND sg13cmos5l_decap_8
XFILLER_353_168 VPWR VGND sg13cmos5l_decap_8
XFILLER_105_168 VPWR VGND sg13cmos5l_decap_8
XFILLER_10_56 VPWR VGND sg13cmos5l_decap_8
XFILLER_120_105 VPWR VGND sg13cmos5l_decap_8
XFILLER_126_56 VPWR VGND sg13cmos5l_decap_8
XFILLER_273_84 VPWR VGND sg13cmos5l_decap_8
XFILLER_59_222 VPWR VGND sg13cmos5l_fill_1
XFILLER_19_21 VPWR VGND sg13cmos5l_decap_8
XFILLER_259_183 VPWR VGND sg13cmos5l_decap_4
XFILLER_86_49 VPWR VGND sg13cmos5l_decap_8
XFILLER_19_119 VPWR VGND sg13cmos5l_decap_8
XFILLER_74_203 VPWR VGND sg13cmos5l_decap_8
XFILLER_19_98 VPWR VGND sg13cmos5l_decap_8
XFILLER_142_77 VPWR VGND sg13cmos5l_decap_8
XFILLER_215_220 VPWR VGND sg13cmos5l_decap_8
XFILLER_27_130 VPWR VGND sg13cmos5l_fill_1
XFILLER_35_42 VPWR VGND sg13cmos5l_decap_8
XFILLER_187_105 VPWR VGND sg13cmos5l_decap_8
XFILLER_27_196 VPWR VGND sg13cmos5l_fill_1
XFILLER_42_122 VPWR VGND sg13cmos5l_decap_8
XFILLER_230_245 VPWR VGND sg13cmos5l_decap_8
XFILLER_298_70 VPWR VGND sg13cmos5l_decap_8
XANTENNA__1558__X Tile_X0Y3_FrameData_O[4] VPWR VGND sg13cmos5l_antennanp
XFILLER_128_216 VPWR VGND sg13cmos5l_decap_8
XFILLER_136_0 VPWR VGND sg13cmos5l_decap_8
XFILLER_51_63 VPWR VGND sg13cmos5l_decap_8
XFILLER_167_63 VPWR VGND sg13cmos5l_decap_8
XFILLER_303_0 VPWR VGND sg13cmos5l_decap_8
XFILLER_297_245 VPWR VGND sg13cmos5l_decap_8
XFILLER_317_77 VPWR VGND sg13cmos5l_decap_8
XFILLER_111_105 VPWR VGND sg13cmos5l_decap_8
XFILLER_183_84 VPWR VGND sg13cmos5l_decap_8
XFILLER_104_190 VPWR VGND sg13cmos5l_fill_2
XFILLER_25_7 VPWR VGND sg13cmos5l_decap_8
XFILLER_333_21 VPWR VGND sg13cmos5l_decap_8
X_1120_ _1120_/Q Tile_X0Y4_FrameData[6] VGND VPWR Tile_X0Y5_FrameStrobe[2] latch
XFILLER_202_14 VPWR VGND sg13cmos5l_decap_8
XFILLER_280_112 VPWR VGND sg13cmos5l_decap_8
X_1051_ _1051_/Q Tile_X0Y4_FrameData[11] VGND VPWR Tile_X0Y5_FrameStrobe[0] latch
XFILLER_80_206 VPWR VGND sg13cmos5l_decap_4
XFILLER_280_167 VPWR VGND sg13cmos5l_fill_2
XFILLER_178_105 VPWR VGND sg13cmos5l_decap_8
XFILLER_92_70 VPWR VGND sg13cmos5l_decap_8
XFILLER_221_256 VPWR VGND sg13cmos5l_fill_1
XFILLER_221_267 VPWR VGND sg13cmos5l_decap_4
X_1953_ Tile_X0Y1_E2BEGb[6] _2307_/X VPWR VGND sg13cmos5l_buf_1
XFILLER_186_160 VPWR VGND sg13cmos5l_fill_2
X_1884_ Tile_X0Y2_E6BEG[10] _2443_/X VPWR VGND sg13cmos5l_buf_1
X_0904_ _0904_/Q Tile_X0Y3_FrameData[14] VGND VPWR Tile_X0Y5_FrameStrobe[3] latch
XFILLER_358_84 VPWR VGND sg13cmos5l_decap_8
XFILLER_294_28 VPWR VGND sg13cmos5l_decap_8
X_0835_ _0835_/Q Tile_X0Y3_FrameData[19] VGND VPWR Tile_X0Y5_FrameStrobe[1] latch
X_0766_ _0766_/Q Tile_X0Y2_FrameData[8] VGND VPWR Tile_X0Y5_FrameStrobe[6] latch
XFILLER_51_0 VPWR VGND sg13cmos5l_decap_8
XFILLER_142_230 VPWR VGND sg13cmos5l_fill_1
XFILLER_227_77 VPWR VGND sg13cmos5l_decap_8
X_2505_ _2505_/X _2566_/X _2565_/X AXIL_S_SOC_ARADDR2 AXIL_S_SOC_ARADDR7 _0994_/Q
+ _0993_/Q VPWR VGND sg13cmos5l_mux4_1
X_0697_ _0697_/Q Tile_X0Y2_FrameData[13] VGND VPWR Tile_X0Y5_FrameStrobe[4] latch
XFILLER_350_149 VPWR VGND sg13cmos5l_decap_8
XFILLER_102_116 VPWR VGND sg13cmos5l_fill_2
X_2436_ _2436_/X Tile_X0Y5_N4END[15] Tile_X0Y0_S4END[11] _2472_/X _2471_/X _0676_/Q
+ _0675_/Q VPWR VGND sg13cmos5l_mux4_1
XFILLER_243_21 VPWR VGND sg13cmos5l_decap_8
XANTENNA__1931__X Tile_X0Y1_EE4BEG[12] VPWR VGND sg13cmos5l_antennanp
X_2367_ _2367_/X _2348_/X _0029_/X _2347_/X Tile_X0Y0_S4END[7] _0360_/Q _0359_/Q VPWR
+ VGND sg13cmos5l_mux4_1
XFILLER_56_203 VPWR VGND sg13cmos5l_decap_8
XFILLER_110_160 VPWR VGND sg13cmos5l_fill_2
XFILLER_243_98 VPWR VGND sg13cmos5l_decap_8
X_1318_ _1318_/Q Tile_X0Y5_FrameData[10] VGND VPWR Tile_X0Y5_FrameStrobe[1] latch
X_2298_ _2298_/X AXIL_S_SOC_WDATA5 AXIL_S_SOC_WDATA13 _2375_/X _2378_/X _0496_/Q _0495_/Q
+ VPWR VGND sg13cmos5l_mux4_1
XFILLER_112_14 VPWR VGND sg13cmos5l_decap_8
X_1249_ _1249_/Q Tile_X0Y4_FrameData[5] VGND VPWR Tile_X0Y5_FrameStrobe[6] latch
XFILLER_212_223 VPWR VGND sg13cmos5l_decap_8
XANTENNA_40 AXIL_S_SOC_WDATA15 VPWR VGND sg13cmos5l_antennanp
XFILLER_184_119 VPWR VGND sg13cmos5l_decap_8
XFILLER_227_7 VPWR VGND sg13cmos5l_decap_8
XANTENNA_51 AXIL_S_SOC_WDATA15 VPWR VGND sg13cmos5l_antennanp
XANTENNA_62 AXIL_S_SOC_WDATA16 VPWR VGND sg13cmos5l_antennanp
XANTENNA_73 AXIL_S_SOC_WDATA25 VPWR VGND sg13cmos5l_antennanp
XANTENNA_84 AXIL_S_SOC_WDATA25 VPWR VGND sg13cmos5l_antennanp
XFILLER_268_84 VPWR VGND sg13cmos5l_decap_4
XANTENNA_95 AXIL_S_SOC_WDATA26 VPWR VGND sg13cmos5l_antennanp
XFILLER_192_163 VPWR VGND sg13cmos5l_fill_2
XFILLER_21_77 VPWR VGND sg13cmos5l_decap_8
XFILLER_341_105 VPWR VGND sg13cmos5l_decap_8
XFILLER_137_77 VPWR VGND sg13cmos5l_decap_8
XANTENNA__2002__X Tile_X0Y5_EE4BEG[3] VPWR VGND sg13cmos5l_antennanp
XFILLER_137_99 VPWR VGND sg13cmos5l_decap_8
XFILLER_153_21 VPWR VGND sg13cmos5l_decap_8
XFILLER_294_226 VPWR VGND sg13cmos5l_decap_8
XANTENNA__1841__X Tile_X0Y4_FrameData_O[8] VPWR VGND sg13cmos5l_antennanp
XFILLER_247_142 VPWR VGND sg13cmos5l_decap_4
XFILLER_247_164 VPWR VGND sg13cmos5l_fill_2
XFILLER_303_35 VPWR VGND sg13cmos5l_decap_8
XFILLER_47_225 VPWR VGND sg13cmos5l_decap_8
XFILLER_262_112 VPWR VGND sg13cmos5l_decap_4
XFILLER_62_217 VPWR VGND sg13cmos5l_decap_4
XFILLER_46_85 VPWR VGND sg13cmos5l_decap_8
XFILLER_15_133 VPWR VGND sg13cmos5l_decap_8
XFILLER_203_212 VPWR VGND sg13cmos5l_decap_8
XFILLER_253_0 VPWR VGND sg13cmos5l_decap_8
XFILLER_262_189 VPWR VGND sg13cmos5l_fill_1
XFILLER_102_91 VPWR VGND sg13cmos5l_decap_8
XFILLER_203_234 VPWR VGND sg13cmos5l_decap_8
XFILLER_349_249 VPWR VGND sg13cmos5l_decap_8
XFILLER_175_119 VPWR VGND sg13cmos5l_decap_8
XFILLER_62_84 VPWR VGND sg13cmos5l_decap_8
XFILLER_178_84 VPWR VGND sg13cmos5l_decap_8
XFILLER_328_21 VPWR VGND sg13cmos5l_decap_8
XFILLER_7_35 VPWR VGND sg13cmos5l_decap_8
XFILLER_109_271 VPWR VGND sg13cmos5l_fill_2
XFILLER_332_127 VPWR VGND sg13cmos5l_fill_2
X_0620_ _0620_/Q Tile_X0Y2_FrameData[26] VGND VPWR Tile_X0Y5_FrameStrobe[2] latch
XFILLER_124_252 VPWR VGND sg13cmos5l_decap_4
X_0551_ _0551_/Q Tile_X0Y1_FrameData[31] VGND VPWR Tile_X0Y5_FrameStrobe[0] latch
XFILLER_124_263 VPWR VGND sg13cmos5l_fill_2
XFILLER_344_42 VPWR VGND sg13cmos5l_decap_8
X_2221_ _2221_/X _2215_/X _0064_/X Tile_X0Y0_S1END[2] Tile_X0Y0_S4END[2] _0098_/Q
+ _0097_/Q VPWR VGND sg13cmos5l_mux4_1
X_0482_ _0482_/Q Tile_X0Y1_FrameData[20] VGND VPWR Tile_X0Y5_FrameStrobe[5] latch
XFILLER_87_70 VPWR VGND sg13cmos5l_decap_8
XANTENNA__1751__X Tile_X0Y2_FrameData_O[11] VPWR VGND sg13cmos5l_antennanp
XFILLER_285_237 VPWR VGND sg13cmos5l_decap_8
XFILLER_213_35 VPWR VGND sg13cmos5l_decap_8
XFILLER_238_175 VPWR VGND sg13cmos5l_decap_8
X_2152_ _2152_/X Tile_X0Y0_W2MID[0] Tile_X0Y0_W2END[0] Tile_X0Y0_W6END[0] _2248_/X
+ _0288_/Q _0287_/Q VPWR VGND sg13cmos5l_mux4_1
XFILLER_38_236 VPWR VGND sg13cmos5l_decap_4
X_2083_ Tile_X0Y5_UserCLKo Tile_X0Y5_UserCLK VPWR VGND sg13cmos5l_buf_1
X_1103_ _1103_/Q Tile_X0Y4_FrameData[23] VGND VPWR Tile_X0Y5_FrameStrobe[2] latch
XFILLER_253_145 VPWR VGND sg13cmos5l_decap_8
X_1034_ _1034_/Q Tile_X0Y4_FrameData[28] VGND VPWR Tile_X0Y5_FrameStrobe[0] latch
XFILLER_53_217 VPWR VGND sg13cmos5l_decap_8
XFILLER_289_28 VPWR VGND sg13cmos5l_decap_8
XFILLER_99_0 VPWR VGND sg13cmos5l_decap_8
XFILLER_21_147 VPWR VGND sg13cmos5l_fill_2
XFILLER_348_260 VPWR VGND sg13cmos5l_fill_1
XFILLER_159_182 VPWR VGND sg13cmos5l_decap_8
XFILLER_238_21 VPWR VGND sg13cmos5l_decap_8
X_1936_ Tile_X0Y1_E6BEG[1] _2326_/X VPWR VGND sg13cmos5l_buf_1
XANTENNA__1926__X Tile_X0Y1_EE4BEG[7] VPWR VGND sg13cmos5l_antennanp
XFILLER_107_219 VPWR VGND sg13cmos5l_decap_8
XFILLER_308_168 VPWR VGND sg13cmos5l_decap_4
X_1867_ Tile_X0Y2_E2BEGb[1] _2410_/X VPWR VGND sg13cmos5l_buf_1
XFILLER_238_98 VPWR VGND sg13cmos5l_decap_8
XFILLER_323_105 VPWR VGND sg13cmos5l_decap_8
X_1798_ Tile_X0Y4_E2BEGb[1] _2626_/X VPWR VGND sg13cmos5l_buf_1
X_0818_ _0818_/Q Tile_X0Y3_FrameData[4] VGND VPWR Tile_X0Y5_FrameStrobe[0] latch
XFILLER_107_14 VPWR VGND sg13cmos5l_decap_8
XFILLER_130_200 VPWR VGND sg13cmos5l_decap_8
XFILLER_254_42 VPWR VGND sg13cmos5l_decap_8
X_0749_ _0749_/Q Tile_X0Y2_FrameData[25] VGND VPWR Tile_X0Y5_FrameStrobe[6] latch
XFILLER_88_114 VPWR VGND sg13cmos5l_decap_4
XFILLER_130_233 VPWR VGND sg13cmos5l_fill_1
XFILLER_276_215 VPWR VGND sg13cmos5l_fill_2
XANTENNA__1661__X Tile_X0Y0_FrameData_O[1] VPWR VGND sg13cmos5l_antennanp
X_2419_ _2419_/X AXIL_S_SOC_AWADDR0 AXIL_S_SOC_AWADDR2 _2469_/X _2486_/X _0710_/Q
+ _0709_/Q VPWR VGND sg13cmos5l_mux4_1
XFILLER_123_35 VPWR VGND sg13cmos5l_decap_8
XFILLER_244_112 VPWR VGND sg13cmos5l_decap_8
XFILLER_270_63 VPWR VGND sg13cmos5l_decap_8
XFILLER_177_7 VPWR VGND sg13cmos5l_decap_8
XFILLER_83_28 VPWR VGND sg13cmos5l_decap_8
XFILLER_199_28 VPWR VGND sg13cmos5l_decap_8
XFILLER_244_189 VPWR VGND sg13cmos5l_decap_8
XFILLER_16_77 VPWR VGND sg13cmos5l_decap_8
XFILLER_344_7 VPWR VGND sg13cmos5l_decap_8
XFILLER_12_147 VPWR VGND sg13cmos5l_decap_8
XFILLER_12_158 VPWR VGND sg13cmos5l_fill_1
XFILLER_32_21 VPWR VGND sg13cmos5l_decap_8
XFILLER_339_260 VPWR VGND sg13cmos5l_fill_1
XFILLER_148_21 VPWR VGND sg13cmos5l_decap_8
XFILLER_200_259 VPWR VGND sg13cmos5l_fill_1
XFILLER_339_271 VPWR VGND sg13cmos5l_fill_2
XANTENNA__1836__X Tile_X0Y4_FrameData_O[3] VPWR VGND sg13cmos5l_antennanp
XFILLER_165_141 VPWR VGND sg13cmos5l_decap_8
XFILLER_32_98 VPWR VGND sg13cmos5l_decap_8
XFILLER_148_98 VPWR VGND sg13cmos5l_decap_8
XFILLER_314_105 VPWR VGND sg13cmos5l_decap_8
XFILLER_180_133 VPWR VGND sg13cmos5l_decap_8
XFILLER_164_42 VPWR VGND sg13cmos5l_decap_8
XFILLER_121_222 VPWR VGND sg13cmos5l_fill_1
XANTENNA__1571__X Tile_X0Y3_FrameData_O[17] VPWR VGND sg13cmos5l_antennanp
XFILLER_314_56 VPWR VGND sg13cmos5l_decap_8
XFILLER_180_63 VPWR VGND sg13cmos5l_decap_8
XFILLER_235_112 VPWR VGND sg13cmos5l_decap_8
XFILLER_87_191 VPWR VGND sg13cmos5l_decap_8
XFILLER_57_84 VPWR VGND sg13cmos5l_decap_8
XFILLER_35_206 VPWR VGND sg13cmos5l_decap_8
XFILLER_330_77 VPWR VGND sg13cmos5l_decap_8
XFILLER_92_7 VPWR VGND sg13cmos5l_decap_8
XFILLER_339_42 VPWR VGND sg13cmos5l_decap_8
X_2770_ _2770_/X Tile_X0Y5_W1END[1] Tile_X0Y5_W6END[9] _2809_/X _2790_/X _1362_/Q
+ _1361_/Q VPWR VGND sg13cmos5l_mux4_1
XANTENNA__1746__X Tile_X0Y2_FrameData_O[6] VPWR VGND sg13cmos5l_antennanp
X_1721_ Tile_X0Y0_E2BEGb[1] _2174_/X VPWR VGND sg13cmos5l_buf_1
XFILLER_345_241 VPWR VGND sg13cmos5l_decap_4
XFILLER_305_105 VPWR VGND sg13cmos5l_decap_8
X_1652_ Tile_X0Y0_FrameStrobe_O[12] Tile_X0Y5_FrameStrobe[12] VPWR VGND sg13cmos5l_buf_1
XFILLER_360_211 VPWR VGND sg13cmos5l_decap_8
XFILLER_171_144 VPWR VGND sg13cmos5l_decap_8
XFILLER_208_35 VPWR VGND sg13cmos5l_decap_8
X_0603_ _0603_/Q Tile_X0Y2_FrameData[11] VGND VPWR Tile_X0Y5_FrameStrobe[1] latch
XFILLER_360_255 VPWR VGND sg13cmos5l_fill_2
XFILLER_355_63 VPWR VGND sg13cmos5l_decap_8
X_1583_ Tile_X0Y3_FrameData_O[29] Tile_X0Y3_FrameData[29] VPWR VGND sg13cmos5l_buf_1
XFILLER_313_182 VPWR VGND sg13cmos5l_fill_1
X_0534_ _0534_/Q Tile_X0Y1_FrameData[0] VGND VPWR Tile_X0Y5_FrameStrobe[6] latch
XFILLER_98_91 VPWR VGND sg13cmos5l_decap_8
X_0465_ _0465_/Q Tile_X0Y1_FrameData[5] VGND VPWR Tile_X0Y5_FrameStrobe[4] latch
XFILLER_224_56 VPWR VGND sg13cmos5l_decap_8
X_2204_ _2204_/X AXIL_S_SOC_WDATA23 _2239_/X _2230_/X _2244_/X _0188_/Q _0187_/Q VPWR
+ VGND sg13cmos5l_mux4_1
XFILLER_14_0 VPWR VGND sg13cmos5l_decap_8
X_2135_ AXIL_S_SOC_RDATA29 Tile_X0Y0_W2MID[5] Tile_X0Y0_W2END[5] Tile_X0Y0_W6END[5]
+ _2246_/X _0132_/Q _0131_/Q VPWR VGND sg13cmos5l_mux4_1
X_0396_ _0396_/Q Tile_X0Y1_FrameData[10] VGND VPWR Tile_X0Y5_FrameStrobe[2] latch
XFILLER_226_134 VPWR VGND sg13cmos5l_decap_8
XFILLER_26_217 VPWR VGND sg13cmos5l_decap_4
XFILLER_281_251 VPWR VGND sg13cmos5l_decap_8
XFILLER_93_150 VPWR VGND sg13cmos5l_decap_8
X_2066_ Tile_X0Y5_S2BEGb[7] _2836_/X VPWR VGND sg13cmos5l_buf_1
XFILLER_179_222 VPWR VGND sg13cmos5l_decap_8
XFILLER_240_77 VPWR VGND sg13cmos5l_decap_8
XFILLER_241_126 VPWR VGND sg13cmos5l_decap_8
X_1017_ _1017_/Q Tile_X0Y3_FrameData[29] VGND VPWR Tile_X0Y5_FrameStrobe[7] latch
XFILLER_179_255 VPWR VGND sg13cmos5l_fill_1
XFILLER_34_272 VPWR VGND sg13cmos5l_fill_1
XFILLER_249_42 VPWR VGND sg13cmos5l_decap_8
XFILLER_194_258 VPWR VGND sg13cmos5l_fill_1
XFILLER_147_141 VPWR VGND sg13cmos5l_decap_8
X_1919_ Tile_X0Y1_EE4BEG[0] _2309_/X VPWR VGND sg13cmos5l_buf_1
XANTENNA__1656__X Tile_X0Y0_FrameStrobe_O[16] VPWR VGND sg13cmos5l_antennanp
XFILLER_147_185 VPWR VGND sg13cmos5l_fill_1
XFILLER_118_35 VPWR VGND sg13cmos5l_decap_8
XFILLER_162_133 VPWR VGND sg13cmos5l_decap_8
XFILLER_351_233 VPWR VGND sg13cmos5l_decap_4
XFILLER_103_200 VPWR VGND sg13cmos5l_decap_8
XFILLER_265_63 VPWR VGND sg13cmos5l_decap_8
XFILLER_311_119 VPWR VGND sg13cmos5l_decap_8
XFILLER_78_28 VPWR VGND sg13cmos5l_decap_8
XFILLER_304_182 VPWR VGND sg13cmos5l_decap_8
XFILLER_103_244 VPWR VGND sg13cmos5l_decap_8
XFILLER_249_259 VPWR VGND sg13cmos5l_fill_2
XFILLER_294_7 VPWR VGND sg13cmos5l_decap_8
XFILLER_134_56 VPWR VGND sg13cmos5l_decap_8
XFILLER_264_218 VPWR VGND sg13cmos5l_decap_8
XFILLER_69_180 VPWR VGND sg13cmos5l_decap_8
XFILLER_217_112 VPWR VGND sg13cmos5l_decap_4
XFILLER_281_84 VPWR VGND sg13cmos5l_decap_8
XFILLER_94_49 VPWR VGND sg13cmos5l_decap_8
XFILLER_217_156 VPWR VGND sg13cmos5l_decap_4
XFILLER_27_21 VPWR VGND sg13cmos5l_decap_8
XFILLER_217_189 VPWR VGND sg13cmos5l_decap_4
XFILLER_150_77 VPWR VGND sg13cmos5l_decap_4
XFILLER_232_126 VPWR VGND sg13cmos5l_decap_8
XFILLER_27_98 VPWR VGND sg13cmos5l_decap_8
XFILLER_300_14 VPWR VGND sg13cmos5l_decap_8
XFILLER_32_209 VPWR VGND sg13cmos5l_decap_4
XFILLER_25_272 VPWR VGND sg13cmos5l_fill_1
XFILLER_342_4 VPWR VGND sg13cmos5l_fill_1
XFILLER_319_219 VPWR VGND sg13cmos5l_fill_1
XFILLER_43_42 VPWR VGND sg13cmos5l_decap_8
XFILLER_159_42 VPWR VGND sg13cmos5l_decap_8
XFILLER_138_130 VPWR VGND sg13cmos5l_decap_8
XFILLER_185_258 VPWR VGND sg13cmos5l_fill_1
XANTENNA__1566__X Tile_X0Y3_FrameData_O[12] VPWR VGND sg13cmos5l_antennanp
XFILLER_138_185 VPWR VGND sg13cmos5l_decap_8
XFILLER_153_100 VPWR VGND sg13cmos5l_decap_8
XFILLER_216_0 VPWR VGND sg13cmos5l_decap_8
XFILLER_309_56 VPWR VGND sg13cmos5l_decap_8
XFILLER_299_126 VPWR VGND sg13cmos5l_decap_8
XFILLER_4_121 VPWR VGND sg13cmos5l_fill_1
XFILLER_175_63 VPWR VGND sg13cmos5l_decap_8
XFILLER_302_119 VPWR VGND sg13cmos5l_decap_8
XFILLER_4_14 VPWR VGND sg13cmos5l_decap_8
XFILLER_4_187 VPWR VGND sg13cmos5l_fill_1
XFILLER_325_77 VPWR VGND sg13cmos5l_decap_8
X_0250_ _0250_/Q Tile_X0Y0_FrameData[12] VGND VPWR Tile_X0Y5_FrameStrobe[5] latch
XFILLER_191_84 VPWR VGND sg13cmos5l_decap_8
XFILLER_341_21 VPWR VGND sg13cmos5l_decap_8
X_0181_ _0181_/Q Tile_X0Y0_FrameData[17] VGND VPWR Tile_X0Y5_FrameStrobe[3] latch
XFILLER_75_161 VPWR VGND sg13cmos5l_fill_1
XFILLER_208_167 VPWR VGND sg13cmos5l_decap_8
XFILLER_75_183 VPWR VGND sg13cmos5l_decap_4
XFILLER_341_98 VPWR VGND sg13cmos5l_decap_8
XFILLER_210_14 VPWR VGND sg13cmos5l_decap_8
XFILLER_31_231 VPWR VGND sg13cmos5l_fill_2
XFILLER_90_4 VPWR VGND sg13cmos5l_fill_1
XFILLER_286_29 VPWR VGND sg13cmos5l_decap_8
X_2822_ _2822_/X Tile_X0Y5_N1END[1] Tile_X0Y5_N4END[1] _2794_/X _0059_/X _1318_/Q
+ _1317_/Q VPWR VGND sg13cmos5l_mux4_1
X_2753_ _2753_/X AXIL_S_SOC_ARPROT0 AXIL_S_SOC_ARPROT2 _2819_/X _2828_/X _1396_/Q
+ _1395_/Q VPWR VGND sg13cmos5l_mux4_1
XFILLER_219_56 VPWR VGND sg13cmos5l_decap_8
X_1704_ Tile_X0Y0_EE4BEG[12] _2193_/X VPWR VGND sg13cmos5l_buf_1
X_2684_ _2684_/X _2680_/X Tile_X0Y5_N4END[7] _2679_/X _0025_/X _1056_/Q _1055_/Q VPWR
+ VGND sg13cmos5l_mux4_1
X_1635_ Tile_X0Y0_N2BEG[7] _2152_/X VPWR VGND sg13cmos5l_buf_1
X_1566_ Tile_X0Y3_FrameData_O[12] Tile_X0Y3_FrameData[12] VPWR VGND sg13cmos5l_buf_1
XFILLER_235_77 VPWR VGND sg13cmos5l_decap_8
X_0517_ _0517_/Q Tile_X0Y1_FrameData[17] VGND VPWR Tile_X0Y5_FrameStrobe[6] latch
XFILLER_98_242 VPWR VGND sg13cmos5l_decap_8
XANTENNA__2100__X AXIL_S_SOC_AWREADY VPWR VGND sg13cmos5l_antennanp
XFILLER_100_214 VPWR VGND sg13cmos5l_decap_8
XFILLER_246_207 VPWR VGND sg13cmos5l_decap_4
X_1497_ _1497_/Q Tile_X0Y5_FrameData[31] VGND VPWR Tile_X0Y5_FrameStrobe[0] latch
XFILLER_104_15 VPWR VGND sg13cmos5l_decap_8
XFILLER_251_21 VPWR VGND sg13cmos5l_decap_8
XFILLER_301_196 VPWR VGND sg13cmos5l_decap_8
X_0448_ _0448_/Q Tile_X0Y1_FrameData[22] VGND VPWR Tile_X0Y5_FrameStrobe[4] latch
X_0379_ _0379_/Q Tile_X0Y1_FrameData[27] VGND VPWR Tile_X0Y5_FrameStrobe[2] latch
XFILLER_251_98 VPWR VGND sg13cmos5l_decap_8
X_2118_ AXIL_S_SOC_RDATA12 Tile_X0Y2_W2MID[4] Tile_X0Y2_W2END[4] Tile_X0Y2_W6END[4]
+ _2485_/X _0614_/Q _0613_/Q VPWR VGND sg13cmos5l_mux4_1
XFILLER_66_183 VPWR VGND sg13cmos5l_decap_8
XFILLER_120_14 VPWR VGND sg13cmos5l_decap_8
XFILLER_214_126 VPWR VGND sg13cmos5l_decap_8
X_2049_ Tile_X0Y5_S1BEG[2] _2771_/X VPWR VGND sg13cmos5l_buf_1
XFILLER_167_236 VPWR VGND sg13cmos5l_decap_8
XFILLER_13_56 VPWR VGND sg13cmos5l_decap_8
XFILLER_309_230 VPWR VGND sg13cmos5l_fill_2
XFILLER_129_56 VPWR VGND sg13cmos5l_decap_8
XFILLER_276_84 VPWR VGND sg13cmos5l_decap_8
XFILLER_307_7 VPWR VGND sg13cmos5l_decap_8
XFILLER_150_103 VPWR VGND sg13cmos5l_decap_8
XFILLER_190_272 VPWR VGND sg13cmos5l_fill_1
XFILLER_145_77 VPWR VGND sg13cmos5l_decap_8
XFILLER_289_170 VPWR VGND sg13cmos5l_fill_1
XANTENNA__2010__X Tile_X0Y5_EE4BEG[11] VPWR VGND sg13cmos5l_antennanp
XFILLER_161_21 VPWR VGND sg13cmos5l_decap_8
XFILLER_38_42 VPWR VGND sg13cmos5l_decap_8
XFILLER_57_161 VPWR VGND sg13cmos5l_decap_8
XANTENNA_300 AXIL_S_SOC_WDATA19 VPWR VGND sg13cmos5l_antennanp
XFILLER_161_98 VPWR VGND sg13cmos5l_fill_2
XANTENNA_311 Tile_X0Y0_FrameData[23] VPWR VGND sg13cmos5l_antennanp
XANTENNA_322 Tile_X0Y0_FrameData[31] VPWR VGND sg13cmos5l_antennanp
XFILLER_166_0 VPWR VGND sg13cmos5l_decap_8
XFILLER_205_148 VPWR VGND sg13cmos5l_decap_8
XFILLER_311_35 VPWR VGND sg13cmos5l_decap_8
XFILLER_72_164 VPWR VGND sg13cmos5l_fill_2
XFILLER_205_159 VPWR VGND sg13cmos5l_fill_1
XFILLER_54_63 VPWR VGND sg13cmos5l_decap_8
XFILLER_220_118 VPWR VGND sg13cmos5l_decap_8
XFILLER_333_0 VPWR VGND sg13cmos5l_decap_8
XFILLER_158_225 VPWR VGND sg13cmos5l_decap_8
XFILLER_359_196 VPWR VGND sg13cmos5l_decap_8
XFILLER_110_91 VPWR VGND sg13cmos5l_decap_8
XFILLER_173_206 VPWR VGND sg13cmos5l_decap_8
XFILLER_70_84 VPWR VGND sg13cmos5l_decap_8
XFILLER_126_133 VPWR VGND sg13cmos5l_decap_8
XFILLER_186_84 VPWR VGND sg13cmos5l_decap_8
XFILLER_336_21 VPWR VGND sg13cmos5l_decap_8
XFILLER_55_7 VPWR VGND sg13cmos5l_decap_8
XFILLER_330_214 VPWR VGND sg13cmos5l_fill_1
X_1420_ _1420_/Q Tile_X0Y5_FrameData[4] VGND VPWR Tile_X0Y5_FrameStrobe[4] latch
X_1351_ _1351_/Q Tile_X0Y5_FrameData[9] VGND VPWR Tile_X0Y5_FrameStrobe[2] latch
XFILLER_205_14 VPWR VGND sg13cmos5l_decap_8
XFILLER_295_140 VPWR VGND sg13cmos5l_decap_8
X_0302_ _0302_/Q Tile_X0Y0_FrameData[24] VGND VPWR Tile_X0Y5_FrameStrobe[7] latch
XFILLER_352_42 VPWR VGND sg13cmos5l_decap_8
X_1282_ _1282_/Q Tile_X0Y5_FrameData[14] VGND VPWR Tile_X0Y5_FrameStrobe[0] latch
X_0233_ _0233_/Q Tile_X0Y0_FrameData[29] VGND VPWR Tile_X0Y5_FrameStrobe[5] latch
XFILLER_95_70 VPWR VGND sg13cmos5l_decap_8
X_0164_ _0164_/Q Tile_X0Y0_FrameData[2] VGND VPWR Tile_X0Y5_FrameStrobe[2] latch
XFILLER_48_172 VPWR VGND sg13cmos5l_decap_8
XFILLER_221_35 VPWR VGND sg13cmos5l_decap_8
XFILLER_251_232 VPWR VGND sg13cmos5l_fill_2
X_0095_ _0095_/Q Tile_X0Y0_FrameData[7] VGND VPWR Tile_X0Y5_FrameStrobe[0] latch
XFILLER_297_28 VPWR VGND sg13cmos5l_decap_8
XFILLER_204_181 VPWR VGND sg13cmos5l_decap_8
X_2805_ _2805_/X Tile_X0Y5_N1END[2] Tile_X0Y5_N4END[2] _2795_/X _0058_/X _1292_/Q
+ _1291_/Q VPWR VGND sg13cmos5l_mux4_1
XFILLER_81_0 VPWR VGND sg13cmos5l_decap_4
XFILLER_164_239 VPWR VGND sg13cmos5l_decap_8
X_0997_ _0997_/Q Tile_X0Y3_FrameData[17] VGND VPWR Tile_X0Y5_FrameStrobe[6] latch
XFILLER_117_133 VPWR VGND sg13cmos5l_decap_8
XFILLER_246_21 VPWR VGND sg13cmos5l_decap_8
X_2736_ _2736_/X AXIL_S_SOC_ARPROT1 AXIL_S_SOC_ARVALID _2828_/X _2800_/X _1430_/Q
+ _1429_/Q VPWR VGND sg13cmos5l_mux4_1
X_2667_ _2667_/X Tile_X0Y4_W1END[3] Tile_X0Y4_WW4END[15] Tile_X0Y4_W6END[7] _2702_/X
+ _1099_/Q _1098_/Q VPWR VGND sg13cmos5l_mux4_1
XANTENNA__1934__X Tile_X0Y1_EE4BEG[15] VPWR VGND sg13cmos5l_antennanp
XFILLER_321_225 VPWR VGND sg13cmos5l_fill_2
X_1618_ Tile_X0Y0_N4BEG[14] _1618_/A VPWR VGND sg13cmos5l_buf_1
XFILLER_246_98 VPWR VGND sg13cmos5l_decap_8
X_2598_ _2598_/X Tile_X0Y5_W2MID[7] Tile_X0Y5_W2END[7] Tile_X0Y5_W6END[7] _2825_/X
+ _1488_/Q _1487_/Q VPWR VGND sg13cmos5l_mux4_1
XFILLER_115_14 VPWR VGND sg13cmos5l_decap_8
XFILLER_262_42 VPWR VGND sg13cmos5l_decap_8
X_1549_ Tile_X0Y3_EE4BEG[11] _2536_/X VPWR VGND sg13cmos5l_buf_1
XFILLER_286_162 VPWR VGND sg13cmos5l_decap_4
XFILLER_286_173 VPWR VGND sg13cmos5l_fill_2
XFILLER_86_234 VPWR VGND sg13cmos5l_fill_2
XFILLER_131_35 VPWR VGND sg13cmos5l_decap_8
XFILLER_242_210 VPWR VGND sg13cmos5l_decap_8
XFILLER_257_7 VPWR VGND sg13cmos5l_decap_8
XFILLER_91_28 VPWR VGND sg13cmos5l_decap_8
XFILLER_54_175 VPWR VGND sg13cmos5l_decap_8
XFILLER_202_118 VPWR VGND sg13cmos5l_fill_1
XFILLER_24_77 VPWR VGND sg13cmos5l_decap_8
XFILLER_356_133 VPWR VGND sg13cmos5l_decap_8
XFILLER_6_205 VPWR VGND sg13cmos5l_fill_1
XANTENNA__2005__X Tile_X0Y5_EE4BEG[6] VPWR VGND sg13cmos5l_antennanp
XFILLER_156_21 VPWR VGND sg13cmos5l_decap_8
XFILLER_40_21 VPWR VGND sg13cmos5l_decap_8
XANTENNA__1844__X Tile_X0Y4_FrameData_O[11] VPWR VGND sg13cmos5l_antennanp
XFILLER_163_272 VPWR VGND sg13cmos5l_fill_1
XFILLER_40_98 VPWR VGND sg13cmos5l_decap_8
XFILLER_123_147 VPWR VGND sg13cmos5l_decap_8
XFILLER_156_98 VPWR VGND sg13cmos5l_decap_8
XFILLER_306_35 VPWR VGND sg13cmos5l_decap_8
XFILLER_277_151 VPWR VGND sg13cmos5l_decap_8
XFILLER_49_63 VPWR VGND sg13cmos5l_decap_8
XFILLER_172_42 VPWR VGND sg13cmos5l_decap_8
XFILLER_277_195 VPWR VGND sg13cmos5l_decap_8
XFILLER_283_0 VPWR VGND sg13cmos5l_decap_8
XFILLER_105_91 VPWR VGND sg13cmos5l_decap_8
XFILLER_292_165 VPWR VGND sg13cmos5l_decap_8
XFILLER_322_56 VPWR VGND sg13cmos5l_decap_8
XFILLER_65_84 VPWR VGND sg13cmos5l_decap_8
XANTENNA_130 AXIL_S_SOC_WDATA29 VPWR VGND sg13cmos5l_antennanp
XANTENNA_141 AXIL_S_SOC_WDATA30 VPWR VGND sg13cmos5l_antennanp
XANTENNA_152 AXIL_S_SOC_WDATA31 VPWR VGND sg13cmos5l_antennanp
XFILLER_60_112 VPWR VGND sg13cmos5l_decap_8
XANTENNA_163 AXIL_S_SOC_WDATA31 VPWR VGND sg13cmos5l_antennanp
XANTENNA_174 AXIL_S_SOC_WDATA8 VPWR VGND sg13cmos5l_antennanp
XANTENNA_185 AXIL_S_SOC_WDATA9 VPWR VGND sg13cmos5l_antennanp
XFILLER_45_197 VPWR VGND sg13cmos5l_decap_8
XANTENNA_196 AXIL_S_SOC_WDATA9 VPWR VGND sg13cmos5l_antennanp
X_0920_ _0920_/Q Tile_X0Y3_FrameData[30] VGND VPWR Tile_X0Y5_FrameStrobe[4] latch
XFILLER_81_50 VPWR VGND sg13cmos5l_decap_8
XFILLER_60_189 VPWR VGND sg13cmos5l_decap_8
XFILLER_347_100 VPWR VGND sg13cmos5l_decap_8
X_0851_ _0851_/Q Tile_X0Y3_FrameData[3] VGND VPWR Tile_X0Y5_FrameStrobe[1] latch
X_0782_ _0782_/Q Tile_X0Y2_FrameData[24] VGND VPWR Tile_X0Y5_FrameStrobe[7] latch
XFILLER_362_136 VPWR VGND sg13cmos5l_decap_8
XFILLER_347_64 VPWR VGND sg13cmos5l_decap_4
X_2521_ _2521_/X AXIL_S_SOC_ARADDR2 AXIL_S_SOC_ARADDR4 _2592_/X _2593_/X _0962_/Q
+ _0961_/Q VPWR VGND sg13cmos5l_mux4_1
XFILLER_347_86 VPWR VGND sg13cmos5l_decap_8
XANTENNA__1754__X Tile_X0Y2_FrameData_O[14] VPWR VGND sg13cmos5l_antennanp
XFILLER_303_203 VPWR VGND sg13cmos5l_decap_8
XFILLER_303_225 VPWR VGND sg13cmos5l_decap_4
XFILLER_5_271 VPWR VGND sg13cmos5l_fill_2
XFILLER_114_147 VPWR VGND sg13cmos5l_decap_8
XFILLER_216_35 VPWR VGND sg13cmos5l_decap_8
X_2452_ _2452_/X _2475_/X _2473_/X _2466_/X _2465_/X _0625_/Q _0624_/Q VPWR VGND sg13cmos5l_mux4_1
XFILLER_268_140 VPWR VGND sg13cmos5l_decap_8
XFILLER_303_269 VPWR VGND sg13cmos5l_decap_4
X_1403_ _1403_/Q Tile_X0Y5_FrameData[21] VGND VPWR Tile_X0Y5_FrameStrobe[4] latch
X_2383_ _2383_/X Tile_X0Y0_W2MID[6] Tile_X0Y0_W2END[6] Tile_X0Y0_W6END[9] _2242_/X
+ _0168_/Q _0167_/Q VPWR VGND sg13cmos5l_mux4_1
XFILLER_268_162 VPWR VGND sg13cmos5l_decap_4
X_1334_ _1334_/Q Tile_X0Y5_FrameData[26] VGND VPWR Tile_X0Y5_FrameStrobe[2] latch
X_1265_ _1265_/Q Tile_X0Y4_FrameData[31] VGND VPWR Tile_X0Y5_FrameStrobe[0] latch
XFILLER_232_56 VPWR VGND sg13cmos5l_decap_8
XFILLER_83_237 VPWR VGND sg13cmos5l_fill_1
XFILLER_283_198 VPWR VGND sg13cmos5l_decap_8
X_1196_ _1196_/Q Tile_X0Y4_FrameData[26] VGND VPWR Tile_X0Y5_FrameStrobe[5] latch
X_0216_ _0216_/Q Tile_X0Y0_FrameData[14] VGND VPWR Tile_X0Y5_FrameStrobe[4] latch
XFILLER_224_232 VPWR VGND sg13cmos5l_decap_8
XFILLER_224_243 VPWR VGND sg13cmos5l_fill_2
X_0147_ _0147_/Q Tile_X0Y0_FrameData[19] VGND VPWR Tile_X0Y5_FrameStrobe[2] latch
XFILLER_51_112 VPWR VGND sg13cmos5l_decap_8
XFILLER_101_49 VPWR VGND sg13cmos5l_decap_8
X_0078_ _0078_/Q Tile_X0Y0_FrameData[24] VGND VPWR Tile_X0Y5_FrameStrobe[0] latch
XANTENNA__1929__X Tile_X0Y1_EE4BEG[10] VPWR VGND sg13cmos5l_antennanp
XFILLER_51_189 VPWR VGND sg13cmos5l_decap_8
XFILLER_338_122 VPWR VGND sg13cmos5l_decap_4
XFILLER_137_228 VPWR VGND sg13cmos5l_fill_2
XFILLER_257_42 VPWR VGND sg13cmos5l_decap_8
XFILLER_353_147 VPWR VGND sg13cmos5l_decap_8
XFILLER_145_250 VPWR VGND sg13cmos5l_decap_8
X_2719_ _2719_/X Tile_X0Y3_W1END[2] Tile_X0Y3_W2MID[1] Tile_X0Y3_W2END[1] _2595_/X
+ _0878_/Q _0877_/Q VPWR VGND sg13cmos5l_mux4_1
XANTENNA__1664__X Tile_X0Y0_FrameData_O[4] VPWR VGND sg13cmos5l_antennanp
XFILLER_10_35 VPWR VGND sg13cmos5l_decap_8
XFILLER_145_272 VPWR VGND sg13cmos5l_fill_1
XFILLER_160_220 VPWR VGND sg13cmos5l_decap_8
XFILLER_105_147 VPWR VGND sg13cmos5l_decap_8
XFILLER_126_35 VPWR VGND sg13cmos5l_decap_8
XFILLER_273_63 VPWR VGND sg13cmos5l_decap_8
XFILLER_86_28 VPWR VGND sg13cmos5l_decap_8
XFILLER_259_162 VPWR VGND sg13cmos5l_decap_8
XFILLER_59_234 VPWR VGND sg13cmos5l_decap_8
XFILLER_142_56 VPWR VGND sg13cmos5l_decap_8
XFILLER_19_77 VPWR VGND sg13cmos5l_decap_8
XFILLER_274_176 VPWR VGND sg13cmos5l_decap_4
XFILLER_42_101 VPWR VGND sg13cmos5l_decap_8
XFILLER_35_21 VPWR VGND sg13cmos5l_decap_8
XANTENNA__1839__X Tile_X0Y4_FrameData_O[6] VPWR VGND sg13cmos5l_antennanp
XFILLER_230_224 VPWR VGND sg13cmos5l_decap_8
XFILLER_35_98 VPWR VGND sg13cmos5l_decap_8
XFILLER_51_42 VPWR VGND sg13cmos5l_decap_8
XFILLER_129_0 VPWR VGND sg13cmos5l_decap_8
XFILLER_167_42 VPWR VGND sg13cmos5l_decap_8
XFILLER_344_169 VPWR VGND sg13cmos5l_decap_4
XFILLER_344_147 VPWR VGND sg13cmos5l_decap_8
XANTENNA__1574__X Tile_X0Y3_FrameData_O[20] VPWR VGND sg13cmos5l_antennanp
XFILLER_136_272 VPWR VGND sg13cmos5l_fill_1
XFILLER_317_56 VPWR VGND sg13cmos5l_decap_8
XFILLER_297_224 VPWR VGND sg13cmos5l_decap_8
XFILLER_183_63 VPWR VGND sg13cmos5l_decap_8
XFILLER_300_217 VPWR VGND sg13cmos5l_fill_2
XFILLER_333_77 VPWR VGND sg13cmos5l_decap_8
XFILLER_65_204 VPWR VGND sg13cmos5l_decap_4
XFILLER_18_7 VPWR VGND sg13cmos5l_decap_8
X_1050_ _1050_/Q Tile_X0Y4_FrameData[12] VGND VPWR Tile_X0Y5_FrameStrobe[0] latch
XFILLER_206_243 VPWR VGND sg13cmos5l_decap_8
XFILLER_18_197 VPWR VGND sg13cmos5l_fill_2
XFILLER_33_134 VPWR VGND sg13cmos5l_decap_4
XANTENNA__1749__X Tile_X0Y2_FrameData_O[9] VPWR VGND sg13cmos5l_antennanp
X_1952_ Tile_X0Y1_E2BEGb[5] _2306_/X VPWR VGND sg13cmos5l_buf_1
XFILLER_193_109 VPWR VGND sg13cmos5l_fill_2
X_1883_ Tile_X0Y2_E6BEG[9] _2442_/X VPWR VGND sg13cmos5l_buf_1
X_0903_ _0903_/Q Tile_X0Y3_FrameData[15] VGND VPWR Tile_X0Y5_FrameStrobe[3] latch
XFILLER_358_63 VPWR VGND sg13cmos5l_decap_8
XFILLER_186_183 VPWR VGND sg13cmos5l_decap_4
X_0834_ _0834_/Q Tile_X0Y3_FrameData[20] VGND VPWR Tile_X0Y5_FrameStrobe[1] latch
XFILLER_335_169 VPWR VGND sg13cmos5l_fill_2
XFILLER_227_56 VPWR VGND sg13cmos5l_decap_8
X_0765_ _0765_/Q Tile_X0Y2_FrameData[9] VGND VPWR Tile_X0Y5_FrameStrobe[6] latch
XFILLER_350_128 VPWR VGND sg13cmos5l_decap_8
XFILLER_142_253 VPWR VGND sg13cmos5l_fill_1
X_2504_ _2504_/X Tile_X0Y4_W2MID[0] Tile_X0Y4_W2END[0] Tile_X0Y4_W6END[0] _2681_/X
+ _1242_/Q _1241_/Q VPWR VGND sg13cmos5l_mux4_1
X_0696_ _0696_/Q Tile_X0Y2_FrameData[14] VGND VPWR Tile_X0Y5_FrameStrobe[4] latch
XFILLER_44_0 VPWR VGND sg13cmos5l_fill_2
X_2435_ _2435_/X Tile_X0Y5_N4END[14] Tile_X0Y0_S4END[10] _2470_/X _2469_/X _0678_/Q
+ _0677_/Q VPWR VGND sg13cmos5l_mux4_1
XFILLER_243_77 VPWR VGND sg13cmos5l_decap_8
X_2366_ _2366_/X _2346_/X _0030_/X _2345_/X Tile_X0Y0_S4END[6] _0354_/Q _0353_/Q VPWR
+ VGND sg13cmos5l_mux4_1
X_1317_ _1317_/Q Tile_X0Y5_FrameData[11] VGND VPWR Tile_X0Y5_FrameStrobe[1] latch
X_2297_ _2297_/X AXIL_S_SOC_WDATA4 AXIL_S_SOC_WDATA12 _2376_/X _2377_/X _0498_/Q _0497_/Q
+ VPWR VGND sg13cmos5l_mux4_1
XFILLER_256_198 VPWR VGND sg13cmos5l_decap_8
XFILLER_2_91 VPWR VGND sg13cmos5l_decap_8
X_1248_ _1248_/Q Tile_X0Y4_FrameData[6] VGND VPWR Tile_X0Y5_FrameStrobe[6] latch
X_1179_ _1179_/Q Tile_X0Y4_FrameData[11] VGND VPWR Tile_X0Y5_FrameStrobe[4] latch
XANTENNA__1659__X Tile_X0Y0_FrameStrobe_O[19] VPWR VGND sg13cmos5l_antennanp
XFILLER_24_178 VPWR VGND sg13cmos5l_decap_8
XFILLER_358_217 VPWR VGND sg13cmos5l_decap_8
XANTENNA_30 AXIL_S_SOC_WDATA11 VPWR VGND sg13cmos5l_antennanp
XANTENNA_41 AXIL_S_SOC_WDATA15 VPWR VGND sg13cmos5l_antennanp
XFILLER_177_161 VPWR VGND sg13cmos5l_decap_8
XFILLER_268_63 VPWR VGND sg13cmos5l_decap_8
XANTENNA_52 AXIL_S_SOC_WDATA15 VPWR VGND sg13cmos5l_antennanp
XANTENNA_63 AXIL_S_SOC_WDATA16 VPWR VGND sg13cmos5l_antennanp
XANTENNA_74 AXIL_S_SOC_WDATA25 VPWR VGND sg13cmos5l_antennanp
XFILLER_122_7 VPWR VGND sg13cmos5l_decap_8
XANTENNA_85 AXIL_S_SOC_WDATA25 VPWR VGND sg13cmos5l_antennanp
XANTENNA_96 AXIL_S_SOC_WDATA26 VPWR VGND sg13cmos5l_antennanp
XFILLER_137_56 VPWR VGND sg13cmos5l_decap_8
XFILLER_21_56 VPWR VGND sg13cmos5l_decap_8
XFILLER_284_84 VPWR VGND sg13cmos5l_decap_8
XFILLER_97_49 VPWR VGND sg13cmos5l_decap_8
XFILLER_47_204 VPWR VGND sg13cmos5l_decap_8
XFILLER_101_161 VPWR VGND sg13cmos5l_decap_4
XFILLER_153_77 VPWR VGND sg13cmos5l_decap_8
XFILLER_303_14 VPWR VGND sg13cmos5l_decap_8
XFILLER_101_194 VPWR VGND sg13cmos5l_decap_8
XFILLER_55_270 VPWR VGND sg13cmos5l_fill_2
XFILLER_46_64 VPWR VGND sg13cmos5l_decap_8
XFILLER_15_112 VPWR VGND sg13cmos5l_decap_8
XANTENNA__1569__X Tile_X0Y3_FrameData_O[15] VPWR VGND sg13cmos5l_antennanp
XFILLER_102_70 VPWR VGND sg13cmos5l_decap_8
XFILLER_246_0 VPWR VGND sg13cmos5l_decap_8
XFILLER_70_251 VPWR VGND sg13cmos5l_fill_2
XFILLER_349_228 VPWR VGND sg13cmos5l_fill_1
XFILLER_349_217 VPWR VGND sg13cmos5l_decap_8
XFILLER_62_63 VPWR VGND sg13cmos5l_decap_8
XFILLER_178_63 VPWR VGND sg13cmos5l_decap_8
XFILLER_7_14 VPWR VGND sg13cmos5l_decap_8
XFILLER_357_272 VPWR VGND sg13cmos5l_fill_1
XFILLER_328_77 VPWR VGND sg13cmos5l_decap_8
XFILLER_194_84 VPWR VGND sg13cmos5l_decap_8
X_0550_ _0550_/Q Tile_X0Y1_FrameData[16] VGND VPWR Tile_X0Y5_FrameStrobe[7] latch
XFILLER_344_21 VPWR VGND sg13cmos5l_decap_8
XFILLER_285_216 VPWR VGND sg13cmos5l_decap_8
X_2220_ _2220_/X _2706_/X _2697_/X _2696_/X _2708_/X _1240_/Q _1239_/Q VPWR VGND sg13cmos5l_mux4_1
X_0481_ _0481_/Q Tile_X0Y1_FrameData[21] VGND VPWR Tile_X0Y5_FrameStrobe[5] latch
XFILLER_97_126 VPWR VGND sg13cmos5l_decap_8
XFILLER_344_98 VPWR VGND sg13cmos5l_decap_8
XFILLER_213_14 VPWR VGND sg13cmos5l_decap_8
XFILLER_238_154 VPWR VGND sg13cmos5l_decap_8
X_2151_ _2151_/X Tile_X0Y0_W2MID[1] Tile_X0Y0_W2END[1] Tile_X0Y0_W6END[1] _2247_/X
+ _0290_/Q _0289_/Q VPWR VGND sg13cmos5l_mux4_1
X_2082_ Tile_X0Y5_S4BEG[15] _2082_/A VPWR VGND sg13cmos5l_buf_1
X_1102_ _1102_/Q Tile_X0Y4_FrameData[24] VGND VPWR Tile_X0Y5_FrameStrobe[2] latch
XFILLER_360_64 VPWR VGND sg13cmos5l_decap_8
XFILLER_360_42 VPWR VGND sg13cmos5l_fill_2
XFILLER_253_135 VPWR VGND sg13cmos5l_fill_2
X_1033_ _1033_/Q Tile_X0Y4_FrameData[29] VGND VPWR Tile_X0Y5_FrameStrobe[0] latch
XFILLER_360_75 VPWR VGND sg13cmos5l_fill_2
X_1935_ Tile_X0Y1_E6BEG[0] _2325_/X VPWR VGND sg13cmos5l_buf_1
XFILLER_348_272 VPWR VGND sg13cmos5l_fill_1
XFILLER_308_147 VPWR VGND sg13cmos5l_decap_8
X_1866_ Tile_X0Y2_E2BEGb[0] _2409_/X VPWR VGND sg13cmos5l_buf_1
XFILLER_174_175 VPWR VGND sg13cmos5l_decap_8
XFILLER_238_77 VPWR VGND sg13cmos5l_decap_8
X_1797_ Tile_X0Y4_E2BEGb[0] _2625_/X VPWR VGND sg13cmos5l_buf_1
X_0817_ _0817_/Q Tile_X0Y3_FrameData[5] VGND VPWR Tile_X0Y5_FrameStrobe[0] latch
XANTENNA__2103__X AXIL_S_SOC_BRESP1 VPWR VGND sg13cmos5l_antennanp
X_0748_ _0748_/Q Tile_X0Y2_FrameData[26] VGND VPWR Tile_X0Y5_FrameStrobe[6] latch
XFILLER_254_21 VPWR VGND sg13cmos5l_decap_8
XANTENNA__1942__X Tile_X0Y1_E6BEG[7] VPWR VGND sg13cmos5l_antennanp
XFILLER_276_227 VPWR VGND sg13cmos5l_decap_8
X_0679_ _0679_/Q Tile_X0Y2_FrameData[31] VGND VPWR Tile_X0Y5_FrameStrobe[4] latch
XFILLER_254_98 VPWR VGND sg13cmos5l_decap_8
X_2418_ _2418_/X AXIL_S_SOC_AWADDR1 AXIL_S_SOC_AWVALID _2467_/X _2487_/X _0712_/Q
+ _0711_/Q VPWR VGND sg13cmos5l_mux4_1
XFILLER_123_14 VPWR VGND sg13cmos5l_decap_8
XFILLER_229_154 VPWR VGND sg13cmos5l_decap_4
X_2349_ _2349_/X _2348_/X _0029_/X _2347_/X Tile_X0Y0_S4END[7] _0336_/Q _0335_/Q VPWR
+ VGND sg13cmos5l_mux4_1
XFILLER_229_187 VPWR VGND sg13cmos5l_decap_8
XFILLER_270_42 VPWR VGND sg13cmos5l_decap_8
XFILLER_270_97 VPWR VGND sg13cmos5l_decap_8
XFILLER_203_91 VPWR VGND sg13cmos5l_decap_8
XFILLER_244_168 VPWR VGND sg13cmos5l_decap_8
XFILLER_16_56 VPWR VGND sg13cmos5l_decap_8
XFILLER_12_126 VPWR VGND sg13cmos5l_decap_8
XFILLER_279_84 VPWR VGND sg13cmos5l_decap_8
XFILLER_337_7 VPWR VGND sg13cmos5l_decap_8
XFILLER_165_120 VPWR VGND sg13cmos5l_decap_8
XFILLER_20_170 VPWR VGND sg13cmos5l_fill_1
XFILLER_32_77 VPWR VGND sg13cmos5l_decap_8
XFILLER_354_231 VPWR VGND sg13cmos5l_decap_8
XFILLER_148_77 VPWR VGND sg13cmos5l_decap_8
XFILLER_165_197 VPWR VGND sg13cmos5l_decap_8
XFILLER_180_112 VPWR VGND sg13cmos5l_decap_8
XANTENNA__2013__X Tile_X0Y5_EE4BEG[14] VPWR VGND sg13cmos5l_antennanp
XFILLER_121_201 VPWR VGND sg13cmos5l_decap_8
XFILLER_164_21 VPWR VGND sg13cmos5l_decap_8
XFILLER_180_189 VPWR VGND sg13cmos5l_decap_8
XANTENNA__1852__X Tile_X0Y4_FrameData_O[19] VPWR VGND sg13cmos5l_antennanp
XFILLER_164_98 VPWR VGND sg13cmos5l_decap_4
XFILLER_314_35 VPWR VGND sg13cmos5l_decap_8
XFILLER_196_0 VPWR VGND sg13cmos5l_decap_8
XFILLER_87_170 VPWR VGND sg13cmos5l_decap_8
XFILLER_180_42 VPWR VGND sg13cmos5l_decap_8
XFILLER_57_63 VPWR VGND sg13cmos5l_decap_8
XFILLER_113_91 VPWR VGND sg13cmos5l_decap_8
XFILLER_250_105 VPWR VGND sg13cmos5l_decap_8
XFILLER_28_270 VPWR VGND sg13cmos5l_fill_2
XFILLER_330_56 VPWR VGND sg13cmos5l_decap_8
XFILLER_43_251 VPWR VGND sg13cmos5l_decap_8
XFILLER_188_256 VPWR VGND sg13cmos5l_fill_2
XFILLER_73_84 VPWR VGND sg13cmos5l_decap_8
XFILLER_189_84 VPWR VGND sg13cmos5l_decap_8
XFILLER_339_21 VPWR VGND sg13cmos5l_decap_8
X_1720_ Tile_X0Y0_E2BEGb[0] _2173_/X VPWR VGND sg13cmos5l_buf_1
XFILLER_339_98 VPWR VGND sg13cmos5l_decap_8
XFILLER_156_186 VPWR VGND sg13cmos5l_decap_8
XFILLER_171_112 VPWR VGND sg13cmos5l_decap_8
XFILLER_208_14 VPWR VGND sg13cmos5l_decap_8
X_1651_ Tile_X0Y0_FrameStrobe_O[11] Tile_X0Y5_FrameStrobe[11] VPWR VGND sg13cmos5l_buf_1
X_0602_ _0602_/Q Tile_X0Y2_FrameData[12] VGND VPWR Tile_X0Y5_FrameStrobe[1] latch
XFILLER_355_42 VPWR VGND sg13cmos5l_decap_8
X_1582_ Tile_X0Y3_FrameData_O[28] Tile_X0Y3_FrameData[28] VPWR VGND sg13cmos5l_buf_1
XFILLER_98_70 VPWR VGND sg13cmos5l_decap_8
XANTENNA__1762__X Tile_X0Y2_FrameData_O[22] VPWR VGND sg13cmos5l_antennanp
XFILLER_313_161 VPWR VGND sg13cmos5l_decap_8
X_0533_ _0533_/Q Tile_X0Y1_FrameData[1] VGND VPWR Tile_X0Y5_FrameStrobe[6] latch
XFILLER_224_35 VPWR VGND sg13cmos5l_decap_8
X_0464_ _0464_/Q Tile_X0Y1_FrameData[6] VGND VPWR Tile_X0Y5_FrameStrobe[4] latch
X_2203_ _2203_/X AXIL_S_SOC_WDATA22 _2237_/X _2226_/X _2243_/X _0190_/Q _0189_/Q VPWR
+ VGND sg13cmos5l_mux4_1
XFILLER_226_113 VPWR VGND sg13cmos5l_decap_8
X_2134_ AXIL_S_SOC_RDATA28 Tile_X0Y0_W2MID[4] Tile_X0Y0_W2END[4] Tile_X0Y0_W6END[4]
+ _2245_/X _0134_/Q _0133_/Q VPWR VGND sg13cmos5l_mux4_1
X_0395_ _0395_/Q Tile_X0Y1_FrameData[11] VGND VPWR Tile_X0Y5_FrameStrobe[2] latch
XFILLER_281_230 VPWR VGND sg13cmos5l_decap_8
XFILLER_240_56 VPWR VGND sg13cmos5l_decap_8
XFILLER_241_105 VPWR VGND sg13cmos5l_decap_8
X_2065_ Tile_X0Y5_S2BEGb[6] _2835_/X VPWR VGND sg13cmos5l_buf_1
XFILLER_179_201 VPWR VGND sg13cmos5l_decap_8
X_1016_ _1016_/Q Tile_X0Y3_FrameData[30] VGND VPWR Tile_X0Y5_FrameStrobe[7] latch
XFILLER_179_267 VPWR VGND sg13cmos5l_fill_1
XFILLER_249_21 VPWR VGND sg13cmos5l_decap_8
XANTENNA__1937__X Tile_X0Y1_E6BEG[2] VPWR VGND sg13cmos5l_antennanp
XFILLER_194_237 VPWR VGND sg13cmos5l_decap_8
XFILLER_194_248 VPWR VGND sg13cmos5l_fill_1
XFILLER_249_98 VPWR VGND sg13cmos5l_decap_8
X_1918_ Tile_X0Y1_FrameData_O[31] Tile_X0Y1_FrameData[31] VPWR VGND sg13cmos5l_buf_1
XFILLER_118_14 VPWR VGND sg13cmos5l_decap_8
XFILLER_162_112 VPWR VGND sg13cmos5l_decap_8
XFILLER_336_253 VPWR VGND sg13cmos5l_fill_1
XFILLER_336_264 VPWR VGND sg13cmos5l_fill_1
X_1849_ Tile_X0Y4_FrameData_O[16] Tile_X0Y4_FrameData[16] VPWR VGND sg13cmos5l_buf_1
XFILLER_265_42 VPWR VGND sg13cmos5l_decap_8
XFILLER_162_156 VPWR VGND sg13cmos5l_fill_1
XANTENNA__1672__X Tile_X0Y0_FrameData_O[12] VPWR VGND sg13cmos5l_antennanp
XFILLER_304_161 VPWR VGND sg13cmos5l_decap_8
XFILLER_134_35 VPWR VGND sg13cmos5l_decap_8
XFILLER_281_63 VPWR VGND sg13cmos5l_decap_8
XFILLER_287_7 VPWR VGND sg13cmos5l_decap_8
XFILLER_94_28 VPWR VGND sg13cmos5l_decap_8
XFILLER_150_56 VPWR VGND sg13cmos5l_decap_8
XFILLER_232_105 VPWR VGND sg13cmos5l_decap_8
XFILLER_27_77 VPWR VGND sg13cmos5l_decap_8
XANTENNA__2008__X Tile_X0Y5_EE4BEG[9] VPWR VGND sg13cmos5l_antennanp
XFILLER_43_21 VPWR VGND sg13cmos5l_decap_8
XFILLER_159_21 VPWR VGND sg13cmos5l_decap_8
XFILLER_240_182 VPWR VGND sg13cmos5l_decap_8
XFILLER_40_232 VPWR VGND sg13cmos5l_fill_1
XANTENNA__1847__X Tile_X0Y4_FrameData_O[14] VPWR VGND sg13cmos5l_antennanp
XFILLER_43_98 VPWR VGND sg13cmos5l_decap_8
XFILLER_40_254 VPWR VGND sg13cmos5l_decap_8
XFILLER_159_98 VPWR VGND sg13cmos5l_fill_2
XFILLER_309_35 VPWR VGND sg13cmos5l_decap_8
XFILLER_111_0 VPWR VGND sg13cmos5l_decap_8
XFILLER_175_42 VPWR VGND sg13cmos5l_decap_8
XFILLER_209_0 VPWR VGND sg13cmos5l_decap_8
XFILLER_299_105 VPWR VGND sg13cmos5l_decap_8
XFILLER_342_212 VPWR VGND sg13cmos5l_decap_8
XANTENNA__1582__X Tile_X0Y3_FrameData_O[28] VPWR VGND sg13cmos5l_antennanp
XFILLER_108_91 VPWR VGND sg13cmos5l_decap_8
XFILLER_325_56 VPWR VGND sg13cmos5l_decap_8
XFILLER_191_63 VPWR VGND sg13cmos5l_decap_8
XFILLER_68_84 VPWR VGND sg13cmos5l_decap_8
XFILLER_248_271 VPWR VGND sg13cmos5l_fill_2
XFILLER_208_146 VPWR VGND sg13cmos5l_decap_8
X_0180_ _0180_/Q Tile_X0Y0_FrameData[18] VGND VPWR Tile_X0Y5_FrameStrobe[3] latch
XFILLER_341_77 VPWR VGND sg13cmos5l_decap_8
XFILLER_90_176 VPWR VGND sg13cmos5l_decap_4
XANTENNA__1757__X Tile_X0Y2_FrameData_O[17] VPWR VGND sg13cmos5l_antennanp
XFILLER_176_226 VPWR VGND sg13cmos5l_decap_8
X_2821_ _2821_/X Tile_X0Y5_N1END[1] Tile_X0Y5_N4END[1] _2794_/X _0059_/X _1310_/Q
+ _1309_/Q VPWR VGND sg13cmos5l_mux4_1
X_2752_ _2752_/X AXIL_S_SOC_ARPROT1 AXIL_S_SOC_ARPROT2 _2823_/X _2800_/X _1398_/Q
+ _1397_/Q VPWR VGND sg13cmos5l_mux4_1
XFILLER_219_35 VPWR VGND sg13cmos5l_decap_8
X_1703_ Tile_X0Y0_EE4BEG[11] _2192_/X VPWR VGND sg13cmos5l_buf_1
XFILLER_144_145 VPWR VGND sg13cmos5l_decap_4
X_2683_ _2683_/X _2608_/X Tile_X0Y5_N2MID[5] _2718_/X _2607_/X _1044_/Q _1043_/Q VPWR
+ VGND sg13cmos5l_mux4_1
X_1634_ Tile_X0Y0_N2BEG[6] _2151_/X VPWR VGND sg13cmos5l_buf_1
X_1565_ Tile_X0Y3_FrameData_O[11] Tile_X0Y3_FrameData[11] VPWR VGND sg13cmos5l_buf_1
XFILLER_235_56 VPWR VGND sg13cmos5l_decap_8
XFILLER_298_182 VPWR VGND sg13cmos5l_decap_8
X_0516_ _0516_/Q Tile_X0Y1_FrameData[18] VGND VPWR Tile_X0Y5_FrameStrobe[6] latch
XFILLER_301_175 VPWR VGND sg13cmos5l_decap_8
X_1496_ _1496_/Q Tile_X0Y5_FrameData[24] VGND VPWR Tile_X0Y5_FrameStrobe[7] latch
XFILLER_239_260 VPWR VGND sg13cmos5l_decap_8
XFILLER_239_271 VPWR VGND sg13cmos5l_fill_2
X_0447_ _0447_/Q Tile_X0Y1_FrameData[23] VGND VPWR Tile_X0Y5_FrameStrobe[4] latch
X_0378_ _0378_/Q Tile_X0Y1_FrameData[28] VGND VPWR Tile_X0Y5_FrameStrobe[2] latch
XFILLER_66_140 VPWR VGND sg13cmos5l_decap_8
XFILLER_214_105 VPWR VGND sg13cmos5l_decap_8
XFILLER_251_77 VPWR VGND sg13cmos5l_decap_8
X_2117_ AXIL_S_SOC_RDATA11 Tile_X0Y2_W2MID[3] Tile_X0Y2_W2END[3] Tile_X0Y2_W6END[3]
+ _2484_/X _0616_/Q _0615_/Q VPWR VGND sg13cmos5l_mux4_1
X_2048_ Tile_X0Y5_S1BEG[1] _2770_/X VPWR VGND sg13cmos5l_buf_1
XANTENNA__1667__X Tile_X0Y0_FrameData_O[7] VPWR VGND sg13cmos5l_antennanp
XFILLER_167_215 VPWR VGND sg13cmos5l_decap_8
XFILLER_200_70 VPWR VGND sg13cmos5l_decap_8
XFILLER_13_35 VPWR VGND sg13cmos5l_decap_8
XFILLER_129_35 VPWR VGND sg13cmos5l_decap_8
XFILLER_276_63 VPWR VGND sg13cmos5l_decap_8
XFILLER_135_123 VPWR VGND sg13cmos5l_fill_1
XFILLER_190_240 VPWR VGND sg13cmos5l_fill_2
XFILLER_202_7 VPWR VGND sg13cmos5l_decap_8
XFILLER_135_189 VPWR VGND sg13cmos5l_decap_8
XFILLER_296_119 VPWR VGND sg13cmos5l_decap_8
XFILLER_145_56 VPWR VGND sg13cmos5l_decap_8
XFILLER_150_159 VPWR VGND sg13cmos5l_decap_8
XFILLER_292_84 VPWR VGND sg13cmos5l_decap_8
XFILLER_38_21 VPWR VGND sg13cmos5l_decap_8
XFILLER_57_140 VPWR VGND sg13cmos5l_decap_8
XANTENNA_301 AXIL_S_SOC_WDATA19 VPWR VGND sg13cmos5l_antennanp
XFILLER_161_77 VPWR VGND sg13cmos5l_decap_8
XFILLER_311_14 VPWR VGND sg13cmos5l_decap_8
XFILLER_38_98 VPWR VGND sg13cmos5l_decap_8
XANTENNA_312 Tile_X0Y0_FrameData[23] VPWR VGND sg13cmos5l_antennanp
XANTENNA_323 Tile_X0Y0_FrameData[31] VPWR VGND sg13cmos5l_antennanp
XFILLER_260_211 VPWR VGND sg13cmos5l_decap_4
XFILLER_260_233 VPWR VGND sg13cmos5l_fill_1
XFILLER_72_132 VPWR VGND sg13cmos5l_decap_8
XFILLER_159_0 VPWR VGND sg13cmos5l_decap_8
XFILLER_54_42 VPWR VGND sg13cmos5l_decap_8
XFILLER_13_232 VPWR VGND sg13cmos5l_fill_1
XFILLER_158_204 VPWR VGND sg13cmos5l_decap_8
XFILLER_110_70 VPWR VGND sg13cmos5l_decap_8
XFILLER_359_175 VPWR VGND sg13cmos5l_decap_8
XANTENNA__1577__X Tile_X0Y3_FrameData_O[23] VPWR VGND sg13cmos5l_antennanp
XFILLER_326_0 VPWR VGND sg13cmos5l_decap_8
XFILLER_70_63 VPWR VGND sg13cmos5l_decap_8
XFILLER_186_63 VPWR VGND sg13cmos5l_decap_8
XFILLER_181_251 VPWR VGND sg13cmos5l_fill_2
XFILLER_141_115 VPWR VGND sg13cmos5l_decap_8
XFILLER_287_119 VPWR VGND sg13cmos5l_decap_8
XFILLER_336_77 VPWR VGND sg13cmos5l_decap_8
XFILLER_330_259 VPWR VGND sg13cmos5l_fill_1
X_1350_ _1350_/Q Tile_X0Y5_FrameData[10] VGND VPWR Tile_X0Y5_FrameStrobe[2] latch
X_0301_ _0301_/Q Tile_X0Y0_FrameData[25] VGND VPWR Tile_X0Y5_FrameStrobe[7] latch
XFILLER_352_21 VPWR VGND sg13cmos5l_decap_8
X_1281_ _1281_/Q Tile_X0Y5_FrameData[15] VGND VPWR Tile_X0Y5_FrameStrobe[0] latch
XFILLER_295_196 VPWR VGND sg13cmos5l_decap_8
X_0232_ _0232_/Q Tile_X0Y0_FrameData[30] VGND VPWR Tile_X0Y5_FrameStrobe[5] latch
XFILLER_95_268 VPWR VGND sg13cmos5l_decap_4
XFILLER_48_151 VPWR VGND sg13cmos5l_decap_8
XFILLER_352_98 VPWR VGND sg13cmos5l_decap_8
XFILLER_221_14 VPWR VGND sg13cmos5l_decap_8
XFILLER_236_241 VPWR VGND sg13cmos5l_decap_8
X_0163_ _0163_/Q Tile_X0Y0_FrameData[3] VGND VPWR Tile_X0Y5_FrameStrobe[2] latch
XFILLER_63_154 VPWR VGND sg13cmos5l_decap_8
X_0094_ _0094_/Q Tile_X0Y0_FrameData[8] VGND VPWR Tile_X0Y5_FrameStrobe[0] latch
XFILLER_63_176 VPWR VGND sg13cmos5l_decap_4
XFILLER_301_91 VPWR VGND sg13cmos5l_decap_8
X_2804_ _2804_/X _2372_/X _2371_/X _2362_/X _2361_/X _0394_/Q _0393_/Q VPWR VGND sg13cmos5l_mux4_1
X_0996_ _0996_/Q Tile_X0Y3_FrameData[18] VGND VPWR Tile_X0Y5_FrameStrobe[6] latch
XFILLER_74_0 VPWR VGND sg13cmos5l_decap_8
XFILLER_117_112 VPWR VGND sg13cmos5l_decap_8
X_2735_ _2735_/X AXIL_S_SOC_ARPROT0 AXIL_S_SOC_ARPROT2 _2827_/X _2799_/X _1432_/Q
+ _1431_/Q VPWR VGND sg13cmos5l_mux4_1
XFILLER_306_256 VPWR VGND sg13cmos5l_fill_1
X_2666_ _2666_/X _2701_/X _2689_/X _2688_/X _2682_/X _1102_/Q _1101_/Q VPWR VGND sg13cmos5l_mux4_1
XFILLER_117_189 VPWR VGND sg13cmos5l_decap_8
XFILLER_246_77 VPWR VGND sg13cmos5l_decap_8
X_1617_ Tile_X0Y0_N4BEG[13] _1617_/A VPWR VGND sg13cmos5l_buf_1
XANTENNA__2111__X AXIL_S_SOC_RDATA5 VPWR VGND sg13cmos5l_antennanp
X_2597_ _2597_/X Tile_X0Y2_W2MID[7] Tile_X0Y2_W2END[7] Tile_X0Y2_W6END[8] _2481_/X
+ _0650_/Q _0649_/Q VPWR VGND sg13cmos5l_mux4_1
XFILLER_5_91 VPWR VGND sg13cmos5l_decap_8
XFILLER_262_21 VPWR VGND sg13cmos5l_decap_8
XFILLER_286_141 VPWR VGND sg13cmos5l_decap_8
X_1548_ Tile_X0Y3_EE4BEG[10] _2535_/X VPWR VGND sg13cmos5l_buf_1
XANTENNA__1950__X Tile_X0Y1_E2BEGb[3] VPWR VGND sg13cmos5l_antennanp
X_1479_ _1479_/Q Tile_X0Y5_FrameData[9] VGND VPWR Tile_X0Y5_FrameStrobe[6] latch
XFILLER_262_98 VPWR VGND sg13cmos5l_decap_8
XFILLER_131_14 VPWR VGND sg13cmos5l_decap_8
XFILLER_227_252 VPWR VGND sg13cmos5l_decap_8
XFILLER_39_195 VPWR VGND sg13cmos5l_decap_8
XFILLER_199_115 VPWR VGND sg13cmos5l_decap_4
XFILLER_54_154 VPWR VGND sg13cmos5l_decap_8
XFILLER_152_7 VPWR VGND sg13cmos5l_decap_8
XFILLER_211_91 VPWR VGND sg13cmos5l_decap_4
XFILLER_24_56 VPWR VGND sg13cmos5l_decap_8
XFILLER_356_112 VPWR VGND sg13cmos5l_decap_8
XFILLER_155_207 VPWR VGND sg13cmos5l_decap_8
XFILLER_155_229 VPWR VGND sg13cmos5l_decap_8
XFILLER_210_185 VPWR VGND sg13cmos5l_decap_8
XFILLER_287_84 VPWR VGND sg13cmos5l_decap_8
XFILLER_356_189 VPWR VGND sg13cmos5l_decap_8
XFILLER_40_77 VPWR VGND sg13cmos5l_decap_8
XFILLER_108_178 VPWR VGND sg13cmos5l_fill_1
XFILLER_123_126 VPWR VGND sg13cmos5l_decap_8
XFILLER_156_77 VPWR VGND sg13cmos5l_decap_8
XFILLER_306_14 VPWR VGND sg13cmos5l_decap_8
XFILLER_312_226 VPWR VGND sg13cmos5l_fill_2
XANTENNA__2021__X Tile_X0Y5_FrameData_O[6] VPWR VGND sg13cmos5l_antennanp
XFILLER_172_21 VPWR VGND sg13cmos5l_decap_8
XFILLER_49_42 VPWR VGND sg13cmos5l_decap_8
XANTENNA__1860__X Tile_X0Y4_FrameData_O[27] VPWR VGND sg13cmos5l_antennanp
XFILLER_172_98 VPWR VGND sg13cmos5l_decap_8
XFILLER_292_133 VPWR VGND sg13cmos5l_decap_8
XFILLER_292_144 VPWR VGND sg13cmos5l_decap_8
XFILLER_105_70 VPWR VGND sg13cmos5l_decap_8
XFILLER_1_49 VPWR VGND sg13cmos5l_decap_8
XFILLER_218_263 VPWR VGND sg13cmos5l_decap_8
XFILLER_276_0 VPWR VGND sg13cmos5l_decap_8
XFILLER_322_35 VPWR VGND sg13cmos5l_decap_8
XFILLER_92_227 VPWR VGND sg13cmos5l_decap_4
XFILLER_65_63 VPWR VGND sg13cmos5l_decap_8
XANTENNA_120 AXIL_S_SOC_WDATA29 VPWR VGND sg13cmos5l_antennanp
XANTENNA_131 AXIL_S_SOC_WDATA29 VPWR VGND sg13cmos5l_antennanp
XANTENNA_142 AXIL_S_SOC_WDATA30 VPWR VGND sg13cmos5l_antennanp
XFILLER_233_233 VPWR VGND sg13cmos5l_fill_1
XFILLER_45_176 VPWR VGND sg13cmos5l_decap_8
XANTENNA_153 AXIL_S_SOC_WDATA31 VPWR VGND sg13cmos5l_antennanp
XANTENNA_164 AXIL_S_SOC_WDATA31 VPWR VGND sg13cmos5l_antennanp
XANTENNA_175 AXIL_S_SOC_WDATA8 VPWR VGND sg13cmos5l_antennanp
XANTENNA_186 AXIL_S_SOC_WDATA9 VPWR VGND sg13cmos5l_antennanp
XANTENNA_197 AXIL_S_SOC_WDATA9 VPWR VGND sg13cmos5l_antennanp
XFILLER_121_91 VPWR VGND sg13cmos5l_decap_8
XFILLER_60_168 VPWR VGND sg13cmos5l_decap_8
XFILLER_198_192 VPWR VGND sg13cmos5l_decap_8
XFILLER_197_84 VPWR VGND sg13cmos5l_decap_8
X_0850_ _0850_/Q Tile_X0Y3_FrameData[4] VGND VPWR Tile_X0Y5_FrameStrobe[1] latch
XFILLER_347_156 VPWR VGND sg13cmos5l_decap_8
X_0781_ _0781_/Q Tile_X0Y2_FrameData[25] VGND VPWR Tile_X0Y5_FrameStrobe[7] latch
XFILLER_362_115 VPWR VGND sg13cmos5l_decap_8
XFILLER_347_43 VPWR VGND sg13cmos5l_decap_8
XFILLER_347_189 VPWR VGND sg13cmos5l_decap_8
X_2520_ _2520_/X AXIL_S_SOC_ARADDR1 AXIL_S_SOC_ARADDR3 _2592_/X _2593_/X _0964_/Q
+ _0963_/Q VPWR VGND sg13cmos5l_mux4_1
XFILLER_114_126 VPWR VGND sg13cmos5l_decap_8
X_2451_ _2451_/X Tile_X0Y2_W1END[3] Tile_X0Y2_WW4END[11] Tile_X0Y2_WW4END[15] Tile_X0Y2_W6END[7]
+ _0625_/Q _0624_/Q VPWR VGND sg13cmos5l_mux4_1
XFILLER_216_14 VPWR VGND sg13cmos5l_decap_8
X_1402_ _1402_/Q Tile_X0Y5_FrameData[22] VGND VPWR Tile_X0Y5_FrameStrobe[4] latch
X_2382_ _2382_/X Tile_X0Y3_W2MID[7] Tile_X0Y3_W2END[7] Tile_X0Y3_W6END[7] _2589_/X
+ _1022_/Q _1021_/Q VPWR VGND sg13cmos5l_mux4_1
XANTENNA__1770__X Tile_X0Y2_FrameData_O[30] VPWR VGND sg13cmos5l_antennanp
X_1333_ _1333_/Q Tile_X0Y5_FrameData[27] VGND VPWR Tile_X0Y5_FrameStrobe[2] latch
XFILLER_68_235 VPWR VGND sg13cmos5l_fill_1
XFILLER_268_196 VPWR VGND sg13cmos5l_decap_8
X_1264_ _1264_/Q Tile_X0Y4_FrameData[22] VGND VPWR Tile_X0Y5_FrameStrobe[7] latch
XFILLER_232_35 VPWR VGND sg13cmos5l_decap_8
X_0215_ _0215_/Q Tile_X0Y0_FrameData[15] VGND VPWR Tile_X0Y5_FrameStrobe[4] latch
XFILLER_83_216 VPWR VGND sg13cmos5l_decap_8
XFILLER_224_211 VPWR VGND sg13cmos5l_decap_8
X_1195_ _1195_/Q Tile_X0Y4_FrameData[27] VGND VPWR Tile_X0Y5_FrameStrobe[5] latch
X_0146_ _0146_/Q Tile_X0Y0_FrameData[20] VGND VPWR Tile_X0Y5_FrameStrobe[2] latch
XFILLER_91_271 VPWR VGND sg13cmos5l_fill_2
XFILLER_36_187 VPWR VGND sg13cmos5l_fill_2
XFILLER_101_28 VPWR VGND sg13cmos5l_decap_8
XFILLER_224_266 VPWR VGND sg13cmos5l_decap_8
X_0077_ _0077_/Q Tile_X0Y0_FrameData[25] VGND VPWR Tile_X0Y5_FrameStrobe[0] latch
XFILLER_51_168 VPWR VGND sg13cmos5l_decap_8
XFILLER_338_112 VPWR VGND sg13cmos5l_decap_4
XANTENNA__2106__X AXIL_S_SOC_RDATA0 VPWR VGND sg13cmos5l_antennanp
XFILLER_137_207 VPWR VGND sg13cmos5l_decap_8
XFILLER_257_21 VPWR VGND sg13cmos5l_decap_8
XANTENNA__1945__X Tile_X0Y1_E6BEG[10] VPWR VGND sg13cmos5l_antennanp
X_0979_ _0979_/Q Tile_X0Y3_FrameData[3] VGND VPWR Tile_X0Y5_FrameStrobe[5] latch
XFILLER_353_126 VPWR VGND sg13cmos5l_decap_8
XFILLER_257_98 VPWR VGND sg13cmos5l_decap_8
X_2718_ _2718_/X Tile_X0Y3_W1END[1] Tile_X0Y3_W2MID[2] Tile_X0Y3_W2END[2] _2594_/X
+ _0880_/Q _0879_/Q VPWR VGND sg13cmos5l_mux4_1
XFILLER_10_14 VPWR VGND sg13cmos5l_decap_8
XFILLER_160_210 VPWR VGND sg13cmos5l_fill_2
XFILLER_126_14 VPWR VGND sg13cmos5l_decap_8
XFILLER_273_42 VPWR VGND sg13cmos5l_decap_8
X_2649_ _2649_/X Tile_X0Y5_N4END[4] _0039_/X _2685_/X _2684_/X _1156_/Q _1155_/Q VPWR
+ VGND sg13cmos5l_mux4_1
XFILLER_361_181 VPWR VGND sg13cmos5l_decap_8
XANTENNA__1680__X Tile_X0Y0_FrameData_O[20] VPWR VGND sg13cmos5l_antennanp
XFILLER_19_56 VPWR VGND sg13cmos5l_decap_8
XFILLER_206_91 VPWR VGND sg13cmos5l_decap_4
XFILLER_142_35 VPWR VGND sg13cmos5l_decap_8
XFILLER_274_144 VPWR VGND sg13cmos5l_fill_1
XFILLER_274_166 VPWR VGND sg13cmos5l_fill_2
XFILLER_274_188 VPWR VGND sg13cmos5l_decap_8
XFILLER_35_77 VPWR VGND sg13cmos5l_decap_8
XFILLER_51_21 VPWR VGND sg13cmos5l_decap_8
XANTENNA__2016__X Tile_X0Y5_FrameData_O[1] VPWR VGND sg13cmos5l_antennanp
XFILLER_167_21 VPWR VGND sg13cmos5l_decap_8
XFILLER_195_173 VPWR VGND sg13cmos5l_decap_8
XFILLER_344_126 VPWR VGND sg13cmos5l_decap_8
XANTENNA__1855__X Tile_X0Y4_FrameData_O[22] VPWR VGND sg13cmos5l_antennanp
XFILLER_51_98 VPWR VGND sg13cmos5l_decap_8
XFILLER_167_98 VPWR VGND sg13cmos5l_decap_8
XFILLER_317_35 VPWR VGND sg13cmos5l_decap_8
XFILLER_151_221 VPWR VGND sg13cmos5l_decap_8
XFILLER_183_42 VPWR VGND sg13cmos5l_decap_8
XFILLER_297_203 VPWR VGND sg13cmos5l_decap_8
XFILLER_4_0 VPWR VGND sg13cmos5l_decap_8
XANTENNA__1590__X Tile_X0Y2_EE4BEG[3] VPWR VGND sg13cmos5l_antennanp
XFILLER_300_229 VPWR VGND sg13cmos5l_fill_1
XFILLER_116_91 VPWR VGND sg13cmos5l_decap_8
XFILLER_333_56 VPWR VGND sg13cmos5l_decap_8
XFILLER_76_84 VPWR VGND sg13cmos5l_decap_8
XFILLER_65_216 VPWR VGND sg13cmos5l_decap_8
XFILLER_202_49 VPWR VGND sg13cmos5l_decap_8
XFILLER_206_222 VPWR VGND sg13cmos5l_decap_4
XFILLER_206_233 VPWR VGND sg13cmos5l_fill_2
XFILLER_280_169 VPWR VGND sg13cmos5l_fill_1
XFILLER_33_113 VPWR VGND sg13cmos5l_decap_8
XFILLER_221_247 VPWR VGND sg13cmos5l_decap_8
X_1951_ Tile_X0Y1_E2BEGb[4] _2305_/X VPWR VGND sg13cmos5l_buf_1
X_1882_ Tile_X0Y2_E6BEG[8] _2441_/X VPWR VGND sg13cmos5l_buf_1
X_0902_ _0902_/Q Tile_X0Y3_FrameData[16] VGND VPWR Tile_X0Y5_FrameStrobe[3] latch
XFILLER_358_42 VPWR VGND sg13cmos5l_decap_8
X_0833_ _0833_/Q Tile_X0Y3_FrameData[21] VGND VPWR Tile_X0Y5_FrameStrobe[1] latch
XANTENNA__1765__X Tile_X0Y2_FrameData_O[25] VPWR VGND sg13cmos5l_antennanp
XFILLER_335_159 VPWR VGND sg13cmos5l_fill_2
XFILLER_227_35 VPWR VGND sg13cmos5l_decap_8
X_2503_ _2503_/X Tile_X0Y1_W1END[3] Tile_X0Y1_W2MID[0] Tile_X0Y1_W2END[0] _2380_/X
+ _0396_/Q _0395_/Q VPWR VGND sg13cmos5l_mux4_1
X_0764_ _0764_/Q Tile_X0Y2_FrameData[10] VGND VPWR Tile_X0Y5_FrameStrobe[6] latch
XFILLER_350_107 VPWR VGND sg13cmos5l_decap_8
XFILLER_288_203 VPWR VGND sg13cmos5l_fill_2
X_0695_ _0695_/Q Tile_X0Y2_FrameData[15] VGND VPWR Tile_X0Y5_FrameStrobe[4] latch
XFILLER_343_181 VPWR VGND sg13cmos5l_decap_4
X_2434_ _2434_/X Tile_X0Y5_N4END[13] Tile_X0Y0_S4END[9] _2468_/X _2467_/X _0680_/Q
+ _0679_/Q VPWR VGND sg13cmos5l_mux4_1
XFILLER_102_129 VPWR VGND sg13cmos5l_decap_4
X_2365_ _2365_/X _2348_/X _0029_/X _2347_/X Tile_X0Y0_S4END[7] _0352_/Q _0351_/Q VPWR
+ VGND sg13cmos5l_mux4_1
XFILLER_37_0 VPWR VGND sg13cmos5l_decap_8
XFILLER_243_56 VPWR VGND sg13cmos5l_decap_8
XFILLER_256_133 VPWR VGND sg13cmos5l_decap_4
X_1316_ _1316_/Q Tile_X0Y5_FrameData[12] VGND VPWR Tile_X0Y5_FrameStrobe[1] latch
XFILLER_110_162 VPWR VGND sg13cmos5l_fill_1
XFILLER_110_173 VPWR VGND sg13cmos5l_decap_8
XFILLER_2_70 VPWR VGND sg13cmos5l_decap_8
X_2296_ _2296_/X AXIL_S_SOC_WDATA3 AXIL_S_SOC_WDATA11 _2376_/X _2377_/X _0500_/Q _0499_/Q
+ VPWR VGND sg13cmos5l_mux4_1
X_1247_ _1247_/Q Tile_X0Y4_FrameData[7] VGND VPWR Tile_X0Y5_FrameStrobe[6] latch
XFILLER_56_249 VPWR VGND sg13cmos5l_decap_8
XFILLER_112_49 VPWR VGND sg13cmos5l_decap_8
X_1178_ _1178_/Q Tile_X0Y4_FrameData[12] VGND VPWR Tile_X0Y5_FrameStrobe[4] latch
X_0129_ _0129_/Q Tile_X0Y0_FrameData[5] VGND VPWR Tile_X0Y5_FrameStrobe[1] latch
XFILLER_212_214 VPWR VGND sg13cmos5l_fill_2
XFILLER_24_168 VPWR VGND sg13cmos5l_fill_2
XFILLER_358_229 VPWR VGND sg13cmos5l_decap_8
XFILLER_212_258 VPWR VGND sg13cmos5l_decap_8
XANTENNA_20 AXIL_S_SOC_WDATA10 VPWR VGND sg13cmos5l_antennanp
XANTENNA_31 AXIL_S_SOC_WDATA11 VPWR VGND sg13cmos5l_antennanp
XFILLER_177_140 VPWR VGND sg13cmos5l_decap_8
XFILLER_268_42 VPWR VGND sg13cmos5l_decap_8
XANTENNA_42 AXIL_S_SOC_WDATA15 VPWR VGND sg13cmos5l_antennanp
XANTENNA_53 AXIL_S_SOC_WDATA16 VPWR VGND sg13cmos5l_antennanp
XANTENNA_64 AXIL_S_SOC_WDATA16 VPWR VGND sg13cmos5l_antennanp
XANTENNA_75 AXIL_S_SOC_WDATA25 VPWR VGND sg13cmos5l_antennanp
XANTENNA_86 AXIL_S_SOC_WDATA25 VPWR VGND sg13cmos5l_antennanp
XANTENNA_97 AXIL_S_SOC_WDATA26 VPWR VGND sg13cmos5l_antennanp
XANTENNA__1675__X Tile_X0Y0_FrameData_O[15] VPWR VGND sg13cmos5l_antennanp
XFILLER_118_251 VPWR VGND sg13cmos5l_decap_4
XFILLER_21_35 VPWR VGND sg13cmos5l_decap_8
XFILLER_115_7 VPWR VGND sg13cmos5l_decap_8
XFILLER_118_262 VPWR VGND sg13cmos5l_fill_1
XFILLER_137_35 VPWR VGND sg13cmos5l_decap_8
XFILLER_279_203 VPWR VGND sg13cmos5l_decap_4
XFILLER_284_63 VPWR VGND sg13cmos5l_decap_8
XFILLER_97_28 VPWR VGND sg13cmos5l_decap_8
XFILLER_279_236 VPWR VGND sg13cmos5l_decap_8
XFILLER_101_140 VPWR VGND sg13cmos5l_decap_8
XFILLER_153_56 VPWR VGND sg13cmos5l_decap_8
XFILLER_247_133 VPWR VGND sg13cmos5l_fill_2
XFILLER_101_173 VPWR VGND sg13cmos5l_decap_8
XFILLER_247_166 VPWR VGND sg13cmos5l_fill_1
XFILLER_247_188 VPWR VGND sg13cmos5l_decap_8
XFILLER_46_43 VPWR VGND sg13cmos5l_decap_8
XFILLER_262_136 VPWR VGND sg13cmos5l_fill_2
XFILLER_70_263 VPWR VGND sg13cmos5l_fill_2
XFILLER_141_0 VPWR VGND sg13cmos5l_decap_8
XFILLER_30_105 VPWR VGND sg13cmos5l_decap_8
XFILLER_62_42 VPWR VGND sg13cmos5l_decap_8
XFILLER_178_42 VPWR VGND sg13cmos5l_decap_8
XFILLER_239_0 VPWR VGND sg13cmos5l_decap_8
XFILLER_357_251 VPWR VGND sg13cmos5l_decap_8
XFILLER_317_126 VPWR VGND sg13cmos5l_fill_1
XANTENNA__1585__X Tile_X0Y3_FrameData_O[31] VPWR VGND sg13cmos5l_antennanp
XFILLER_183_154 VPWR VGND sg13cmos5l_decap_8
XFILLER_317_148 VPWR VGND sg13cmos5l_decap_8
XFILLER_328_56 VPWR VGND sg13cmos5l_decap_8
XFILLER_183_176 VPWR VGND sg13cmos5l_fill_1
XFILLER_194_63 VPWR VGND sg13cmos5l_decap_8
XFILLER_325_192 VPWR VGND sg13cmos5l_fill_2
X_0480_ _0480_/Q Tile_X0Y1_FrameData[22] VGND VPWR Tile_X0Y5_FrameStrobe[5] latch
XFILLER_97_105 VPWR VGND sg13cmos5l_decap_8
XFILLER_340_140 VPWR VGND sg13cmos5l_decap_4
XFILLER_30_7 VPWR VGND sg13cmos5l_decap_8
XFILLER_344_77 VPWR VGND sg13cmos5l_decap_8
XFILLER_238_133 VPWR VGND sg13cmos5l_decap_8
X_2150_ _2150_/X Tile_X0Y0_W2MID[2] Tile_X0Y0_W2END[2] Tile_X0Y0_W6END[2] _2246_/X
+ _0292_/Q _0291_/Q VPWR VGND sg13cmos5l_mux4_1
XFILLER_38_227 VPWR VGND sg13cmos5l_fill_2
XFILLER_38_216 VPWR VGND sg13cmos5l_decap_8
XFILLER_360_21 VPWR VGND sg13cmos5l_decap_8
XFILLER_293_272 VPWR VGND sg13cmos5l_fill_1
X_2081_ Tile_X0Y5_S4BEG[14] _2081_/A VPWR VGND sg13cmos5l_buf_1
X_1101_ _1101_/Q Tile_X0Y4_FrameData[25] VGND VPWR Tile_X0Y5_FrameStrobe[2] latch
X_1032_ _1032_/Q Tile_X0Y4_FrameData[30] VGND VPWR Tile_X0Y5_FrameStrobe[0] latch
XFILLER_261_191 VPWR VGND sg13cmos5l_fill_2
XFILLER_21_105 VPWR VGND sg13cmos5l_decap_8
XFILLER_21_116 VPWR VGND sg13cmos5l_fill_2
XFILLER_21_149 VPWR VGND sg13cmos5l_fill_1
X_1934_ Tile_X0Y1_EE4BEG[15] _2324_/X VPWR VGND sg13cmos5l_buf_1
XFILLER_308_126 VPWR VGND sg13cmos5l_decap_8
XFILLER_174_154 VPWR VGND sg13cmos5l_decap_8
XFILLER_238_56 VPWR VGND sg13cmos5l_decap_8
X_1865_ Tile_X0Y4_UserCLKo Tile_X0Y4_UserCLK VPWR VGND sg13cmos5l_buf_1
X_1796_ Tile_X0Y4_E2BEG[7] _2624_/X VPWR VGND sg13cmos5l_buf_1
X_0816_ _0816_/Q Tile_X0Y3_FrameData[6] VGND VPWR Tile_X0Y5_FrameStrobe[0] latch
XFILLER_174_198 VPWR VGND sg13cmos5l_decap_8
X_0747_ _0747_/Q Tile_X0Y2_FrameData[27] VGND VPWR Tile_X0Y5_FrameStrobe[6] latch
XFILLER_115_243 VPWR VGND sg13cmos5l_decap_8
XFILLER_107_49 VPWR VGND sg13cmos5l_decap_8
XFILLER_254_77 VPWR VGND sg13cmos5l_decap_8
X_2417_ _2417_/X AXIL_S_SOC_AWADDR0 AXIL_S_SOC_AWPROT2 _2465_/X _2488_/X _0714_/Q
+ _0713_/Q VPWR VGND sg13cmos5l_mux4_1
X_0678_ _0678_/Q Tile_X0Y2_FrameData[0] VGND VPWR Tile_X0Y5_FrameStrobe[3] latch
XFILLER_276_239 VPWR VGND sg13cmos5l_decap_8
XFILLER_229_133 VPWR VGND sg13cmos5l_decap_8
XFILLER_270_21 VPWR VGND sg13cmos5l_decap_8
X_2348_ _2348_/X Tile_X0Y2_W1END[3] Tile_X0Y2_W6END[7] _2465_/X _2456_/X _0784_/Q
+ _0783_/Q VPWR VGND sg13cmos5l_mux4_1
XFILLER_229_166 VPWR VGND sg13cmos5l_decap_8
XFILLER_284_261 VPWR VGND sg13cmos5l_fill_1
X_2279_ _2279_/X Tile_X0Y2_W1END[0] Tile_X0Y2_WW4END[0] Tile_X0Y2_WW4END[4] Tile_X0Y2_W6END[8]
+ _0766_/Q _0765_/Q VPWR VGND sg13cmos5l_mux4_1
XFILLER_96_182 VPWR VGND sg13cmos5l_decap_8
XFILLER_244_147 VPWR VGND sg13cmos5l_decap_8
XFILLER_44_219 VPWR VGND sg13cmos5l_decap_8
XFILLER_16_35 VPWR VGND sg13cmos5l_decap_8
XFILLER_203_70 VPWR VGND sg13cmos5l_decap_8
XFILLER_52_252 VPWR VGND sg13cmos5l_decap_8
XFILLER_12_105 VPWR VGND sg13cmos5l_decap_8
XFILLER_197_235 VPWR VGND sg13cmos5l_decap_8
XFILLER_279_63 VPWR VGND sg13cmos5l_decap_8
XFILLER_232_7 VPWR VGND sg13cmos5l_decap_8
XFILLER_32_56 VPWR VGND sg13cmos5l_decap_8
XFILLER_354_210 VPWR VGND sg13cmos5l_decap_8
XFILLER_148_56 VPWR VGND sg13cmos5l_decap_8
XFILLER_354_254 VPWR VGND sg13cmos5l_decap_4
XFILLER_165_176 VPWR VGND sg13cmos5l_decap_8
XFILLER_295_84 VPWR VGND sg13cmos5l_decap_8
XFILLER_106_210 VPWR VGND sg13cmos5l_decap_4
XFILLER_106_221 VPWR VGND sg13cmos5l_decap_8
XFILLER_180_168 VPWR VGND sg13cmos5l_decap_8
XFILLER_79_105 VPWR VGND sg13cmos5l_decap_8
XFILLER_164_77 VPWR VGND sg13cmos5l_decap_8
XFILLER_267_217 VPWR VGND sg13cmos5l_decap_8
XFILLER_314_14 VPWR VGND sg13cmos5l_decap_8
XFILLER_79_149 VPWR VGND sg13cmos5l_decap_8
XFILLER_180_21 VPWR VGND sg13cmos5l_decap_8
XFILLER_57_42 VPWR VGND sg13cmos5l_decap_8
XFILLER_189_0 VPWR VGND sg13cmos5l_decap_8
XFILLER_275_272 VPWR VGND sg13cmos5l_fill_1
XFILLER_180_98 VPWR VGND sg13cmos5l_decap_8
XFILLER_235_147 VPWR VGND sg13cmos5l_decap_8
XFILLER_113_70 VPWR VGND sg13cmos5l_decap_8
XFILLER_330_35 VPWR VGND sg13cmos5l_decap_8
XFILLER_356_0 VPWR VGND sg13cmos5l_decap_8
XFILLER_73_63 VPWR VGND sg13cmos5l_decap_8
XFILLER_189_63 VPWR VGND sg13cmos5l_decap_8
XFILLER_85_8 VPWR VGND sg13cmos5l_decap_8
XFILLER_11_182 VPWR VGND sg13cmos5l_decap_4
XFILLER_78_7 VPWR VGND sg13cmos5l_decap_8
XFILLER_339_77 VPWR VGND sg13cmos5l_decap_8
XFILLER_156_165 VPWR VGND sg13cmos5l_decap_8
X_1650_ Tile_X0Y0_FrameStrobe_O[10] Tile_X0Y5_FrameStrobe[10] VPWR VGND sg13cmos5l_buf_1
XFILLER_7_153 VPWR VGND sg13cmos5l_decap_4
X_1581_ Tile_X0Y3_FrameData_O[27] Tile_X0Y3_FrameData[27] VPWR VGND sg13cmos5l_buf_1
X_0601_ _0601_/Q Tile_X0Y2_FrameData[13] VGND VPWR Tile_X0Y5_FrameStrobe[1] latch
XFILLER_355_21 VPWR VGND sg13cmos5l_decap_8
XFILLER_171_179 VPWR VGND sg13cmos5l_decap_8
XFILLER_313_140 VPWR VGND sg13cmos5l_decap_8
X_0532_ _0532_/Q Tile_X0Y1_FrameData[2] VGND VPWR Tile_X0Y5_FrameStrobe[6] latch
XFILLER_360_257 VPWR VGND sg13cmos5l_fill_1
XFILLER_112_213 VPWR VGND sg13cmos5l_fill_1
XFILLER_355_98 VPWR VGND sg13cmos5l_decap_8
XFILLER_112_235 VPWR VGND sg13cmos5l_decap_8
XFILLER_224_14 VPWR VGND sg13cmos5l_decap_8
X_0463_ _0463_/Q Tile_X0Y1_FrameData[7] VGND VPWR Tile_X0Y5_FrameStrobe[4] latch
X_2202_ _2202_/X AXIL_S_SOC_WDATA21 _2234_/X _2222_/X _2242_/X _0192_/Q _0191_/Q VPWR
+ VGND sg13cmos5l_mux4_1
X_0394_ _0394_/Q Tile_X0Y1_FrameData[12] VGND VPWR Tile_X0Y5_FrameStrobe[2] latch
XFILLER_85_108 VPWR VGND sg13cmos5l_fill_2
XFILLER_78_171 VPWR VGND sg13cmos5l_decap_8
XFILLER_266_272 VPWR VGND sg13cmos5l_fill_1
X_2133_ AXIL_S_SOC_RDATA27 Tile_X0Y0_W2MID[3] Tile_X0Y0_W2END[3] Tile_X0Y0_W6END[3]
+ _2244_/X _0136_/Q _0135_/Q VPWR VGND sg13cmos5l_mux4_1
XFILLER_304_91 VPWR VGND sg13cmos5l_decap_8
XFILLER_19_271 VPWR VGND sg13cmos5l_fill_2
XFILLER_240_35 VPWR VGND sg13cmos5l_decap_8
X_2064_ Tile_X0Y5_S2BEGb[5] _2834_/X VPWR VGND sg13cmos5l_buf_1
XFILLER_93_185 VPWR VGND sg13cmos5l_decap_8
X_1015_ _1015_/Q Tile_X0Y3_FrameData[31] VGND VPWR Tile_X0Y5_FrameStrobe[7] latch
XFILLER_249_77 VPWR VGND sg13cmos5l_decap_8
X_1917_ Tile_X0Y1_FrameData_O[30] Tile_X0Y1_FrameData[30] VPWR VGND sg13cmos5l_buf_1
XANTENNA__2114__X AXIL_S_SOC_RDATA8 VPWR VGND sg13cmos5l_antennanp
X_1848_ Tile_X0Y4_FrameData_O[15] Tile_X0Y4_FrameData[15] VPWR VGND sg13cmos5l_buf_1
XFILLER_8_91 VPWR VGND sg13cmos5l_fill_1
XFILLER_265_21 VPWR VGND sg13cmos5l_decap_8
XANTENNA__1953__X Tile_X0Y1_E2BEGb[6] VPWR VGND sg13cmos5l_antennanp
XFILLER_162_168 VPWR VGND sg13cmos5l_decap_8
XFILLER_304_140 VPWR VGND sg13cmos5l_decap_8
X_1779_ Tile_X0Y2_E2BEG[2] _2403_/X VPWR VGND sg13cmos5l_buf_1
XFILLER_351_257 VPWR VGND sg13cmos5l_decap_4
XFILLER_134_14 VPWR VGND sg13cmos5l_decap_8
XFILLER_281_42 VPWR VGND sg13cmos5l_decap_8
XFILLER_76_119 VPWR VGND sg13cmos5l_decap_8
XFILLER_182_7 VPWR VGND sg13cmos5l_decap_8
XFILLER_214_91 VPWR VGND sg13cmos5l_decap_8
XFILLER_84_163 VPWR VGND sg13cmos5l_decap_8
XFILLER_84_141 VPWR VGND sg13cmos5l_decap_8
XFILLER_150_35 VPWR VGND sg13cmos5l_decap_8
XFILLER_27_56 VPWR VGND sg13cmos5l_decap_8
XFILLER_300_49 VPWR VGND sg13cmos5l_decap_8
XFILLER_40_211 VPWR VGND sg13cmos5l_decap_8
XFILLER_240_161 VPWR VGND sg13cmos5l_decap_8
XFILLER_43_77 VPWR VGND sg13cmos5l_decap_8
XFILLER_159_77 VPWR VGND sg13cmos5l_decap_8
XFILLER_309_14 VPWR VGND sg13cmos5l_decap_8
XANTENNA__2024__X Tile_X0Y5_FrameData_O[9] VPWR VGND sg13cmos5l_antennanp
XFILLER_138_165 VPWR VGND sg13cmos5l_decap_8
XFILLER_138_176 VPWR VGND sg13cmos5l_fill_2
XFILLER_175_21 VPWR VGND sg13cmos5l_decap_8
XFILLER_4_112 VPWR VGND sg13cmos5l_decap_8
XANTENNA__1863__X Tile_X0Y4_FrameData_O[30] VPWR VGND sg13cmos5l_antennanp
XFILLER_104_0 VPWR VGND sg13cmos5l_decap_4
XFILLER_108_70 VPWR VGND sg13cmos5l_decap_8
XFILLER_175_98 VPWR VGND sg13cmos5l_decap_8
XFILLER_325_35 VPWR VGND sg13cmos5l_decap_8
XFILLER_4_49 VPWR VGND sg13cmos5l_decap_8
XFILLER_4_178 VPWR VGND sg13cmos5l_fill_2
XFILLER_68_63 VPWR VGND sg13cmos5l_decap_8
XFILLER_191_42 VPWR VGND sg13cmos5l_decap_8
XFILLER_310_154 VPWR VGND sg13cmos5l_decap_8
XFILLER_67_119 VPWR VGND sg13cmos5l_decap_8
XFILLER_124_91 VPWR VGND sg13cmos5l_decap_8
XFILLER_341_56 VPWR VGND sg13cmos5l_decap_8
XFILLER_223_139 VPWR VGND sg13cmos5l_decap_8
XFILLER_90_155 VPWR VGND sg13cmos5l_decap_8
XFILLER_90_188 VPWR VGND sg13cmos5l_decap_8
XFILLER_176_205 VPWR VGND sg13cmos5l_decap_8
XFILLER_210_49 VPWR VGND sg13cmos5l_decap_8
XFILLER_231_161 VPWR VGND sg13cmos5l_decap_8
XFILLER_231_172 VPWR VGND sg13cmos5l_fill_2
XFILLER_31_222 VPWR VGND sg13cmos5l_fill_2
XFILLER_31_244 VPWR VGND sg13cmos5l_fill_2
X_2820_ _2820_/X Tile_X0Y5_N1END[2] Tile_X0Y5_N4END[2] _2795_/X _0058_/X _1316_/Q
+ _1315_/Q VPWR VGND sg13cmos5l_mux4_1
XFILLER_219_14 VPWR VGND sg13cmos5l_decap_8
X_2751_ _2751_/X AXIL_S_SOC_ARPROT0 AXIL_S_SOC_ARPROT1 _2821_/X _2799_/X _1400_/Q
+ _1399_/Q VPWR VGND sg13cmos5l_mux4_1
XFILLER_129_154 VPWR VGND sg13cmos5l_decap_8
XFILLER_144_102 VPWR VGND sg13cmos5l_decap_8
XFILLER_318_243 VPWR VGND sg13cmos5l_fill_1
XFILLER_333_202 VPWR VGND sg13cmos5l_fill_2
X_1702_ Tile_X0Y0_EE4BEG[10] _2191_/X VPWR VGND sg13cmos5l_buf_1
X_2682_ _2682_/X _2610_/X Tile_X0Y5_N2MID[6] _2719_/X _2609_/X _1042_/Q _1041_/Q VPWR
+ VGND sg13cmos5l_mux4_1
XFILLER_129_198 VPWR VGND sg13cmos5l_decap_8
X_1633_ Tile_X0Y0_N2BEG[5] _2150_/X VPWR VGND sg13cmos5l_buf_1
XANTENNA__1773__X Tile_X0Y2_E1BEG[0] VPWR VGND sg13cmos5l_antennanp
XFILLER_144_157 VPWR VGND sg13cmos5l_fill_2
XFILLER_235_35 VPWR VGND sg13cmos5l_decap_8
X_1564_ Tile_X0Y3_FrameData_O[10] Tile_X0Y3_FrameData[10] VPWR VGND sg13cmos5l_buf_1
XFILLER_298_161 VPWR VGND sg13cmos5l_decap_8
X_1495_ _1495_/Q Tile_X0Y5_FrameData[25] VGND VPWR Tile_X0Y5_FrameStrobe[7] latch
X_0515_ _0515_/Q Tile_X0Y1_FrameData[19] VGND VPWR Tile_X0Y5_FrameStrobe[6] latch
XFILLER_301_154 VPWR VGND sg13cmos5l_decap_8
X_0446_ _0446_/Q Tile_X0Y1_FrameData[24] VGND VPWR Tile_X0Y5_FrameStrobe[4] latch
XFILLER_58_119 VPWR VGND sg13cmos5l_decap_8
XFILLER_251_56 VPWR VGND sg13cmos5l_decap_8
X_0377_ _0377_/Q Tile_X0Y1_FrameData[29] VGND VPWR Tile_X0Y5_FrameStrobe[2] latch
X_2116_ AXIL_S_SOC_RDATA10 Tile_X0Y2_W2MID[2] Tile_X0Y2_W2END[2] Tile_X0Y2_W6END[2]
+ _2483_/X _0618_/Q _0617_/Q VPWR VGND sg13cmos5l_mux4_1
XANTENNA__2109__X AXIL_S_SOC_RDATA3 VPWR VGND sg13cmos5l_antennanp
X_2047_ Tile_X0Y5_S1BEG[0] _2769_/X VPWR VGND sg13cmos5l_buf_1
XANTENNA__1948__X Tile_X0Y1_E2BEGb[1] VPWR VGND sg13cmos5l_antennanp
XFILLER_120_49 VPWR VGND sg13cmos5l_decap_8
XFILLER_13_14 VPWR VGND sg13cmos5l_decap_8
XFILLER_222_194 VPWR VGND sg13cmos5l_decap_8
XFILLER_129_14 VPWR VGND sg13cmos5l_decap_8
XFILLER_175_271 VPWR VGND sg13cmos5l_fill_2
XFILLER_276_42 VPWR VGND sg13cmos5l_decap_8
XFILLER_135_113 VPWR VGND sg13cmos5l_fill_2
XFILLER_89_29 VPWR VGND sg13cmos5l_decap_8
XANTENNA__1683__X Tile_X0Y0_FrameData_O[23] VPWR VGND sg13cmos5l_antennanp
XFILLER_190_263 VPWR VGND sg13cmos5l_fill_2
XFILLER_135_179 VPWR VGND sg13cmos5l_fill_2
XFILLER_145_35 VPWR VGND sg13cmos5l_decap_8
XFILLER_150_138 VPWR VGND sg13cmos5l_decap_8
XFILLER_209_91 VPWR VGND sg13cmos5l_decap_4
XFILLER_8_7 VPWR VGND sg13cmos5l_decap_8
XFILLER_289_161 VPWR VGND sg13cmos5l_decap_8
XFILLER_292_63 VPWR VGND sg13cmos5l_decap_8
XFILLER_49_119 VPWR VGND sg13cmos5l_decap_8
XFILLER_161_56 VPWR VGND sg13cmos5l_decap_8
XFILLER_38_77 VPWR VGND sg13cmos5l_decap_8
XFILLER_57_196 VPWR VGND sg13cmos5l_decap_8
XANTENNA_302 AXIL_S_SOC_WDATA19 VPWR VGND sg13cmos5l_antennanp
XANTENNA_313 Tile_X0Y0_FrameData[23] VPWR VGND sg13cmos5l_antennanp
XANTENNA_324 Tile_X0Y0_FrameData[31] VPWR VGND sg13cmos5l_antennanp
XANTENNA__2019__X Tile_X0Y5_FrameData_O[4] VPWR VGND sg13cmos5l_antennanp
XFILLER_54_21 VPWR VGND sg13cmos5l_decap_8
XANTENNA__1858__X Tile_X0Y4_FrameData_O[25] VPWR VGND sg13cmos5l_antennanp
XFILLER_220_109 VPWR VGND sg13cmos5l_fill_2
XFILLER_54_98 VPWR VGND sg13cmos5l_decap_8
XFILLER_359_154 VPWR VGND sg13cmos5l_decap_8
XFILLER_213_183 VPWR VGND sg13cmos5l_decap_8
XFILLER_70_42 VPWR VGND sg13cmos5l_decap_8
XFILLER_186_42 VPWR VGND sg13cmos5l_decap_8
XFILLER_221_0 VPWR VGND sg13cmos5l_decap_8
XFILLER_319_0 VPWR VGND sg13cmos5l_decap_8
XFILLER_166_271 VPWR VGND sg13cmos5l_fill_2
XANTENNA__1593__X Tile_X0Y2_EE4BEG[6] VPWR VGND sg13cmos5l_antennanp
XFILLER_126_157 VPWR VGND sg13cmos5l_decap_8
XFILLER_119_91 VPWR VGND sg13cmos5l_decap_8
XFILLER_336_56 VPWR VGND sg13cmos5l_decap_8
XFILLER_79_84 VPWR VGND sg13cmos5l_decap_8
X_0300_ _0300_/Q Tile_X0Y0_FrameData[26] VGND VPWR Tile_X0Y5_FrameStrobe[7] latch
XFILLER_0_170 VPWR VGND sg13cmos5l_fill_1
XFILLER_205_49 VPWR VGND sg13cmos5l_decap_8
XFILLER_295_175 VPWR VGND sg13cmos5l_decap_8
X_1280_ _1280_/Q Tile_X0Y5_FrameData[16] VGND VPWR Tile_X0Y5_FrameStrobe[0] latch
XFILLER_95_247 VPWR VGND sg13cmos5l_decap_8
X_0231_ _0231_/Q Tile_X0Y0_FrameData[31] VGND VPWR Tile_X0Y5_FrameStrobe[5] latch
XFILLER_48_130 VPWR VGND sg13cmos5l_decap_8
XFILLER_352_77 VPWR VGND sg13cmos5l_decap_8
X_0162_ _0162_/Q Tile_X0Y0_FrameData[4] VGND VPWR Tile_X0Y5_FrameStrobe[2] latch
XFILLER_251_201 VPWR VGND sg13cmos5l_decap_8
XFILLER_63_133 VPWR VGND sg13cmos5l_decap_8
X_0093_ _0093_/Q Tile_X0Y0_FrameData[9] VGND VPWR Tile_X0Y5_FrameStrobe[0] latch
XANTENNA__1768__X Tile_X0Y2_FrameData_O[28] VPWR VGND sg13cmos5l_antennanp
XFILLER_211_109 VPWR VGND sg13cmos5l_decap_8
XFILLER_301_70 VPWR VGND sg13cmos5l_decap_8
XFILLER_149_249 VPWR VGND sg13cmos5l_fill_2
X_2803_ _2803_/X Tile_X0Y1_W1END[0] Tile_X0Y1_WW4END[8] Tile_X0Y1_WW4END[12] Tile_X0Y1_W6END[4]
+ _0394_/Q _0393_/Q VPWR VGND sg13cmos5l_mux4_1
X_0995_ _0995_/Q Tile_X0Y3_FrameData[19] VGND VPWR Tile_X0Y5_FrameStrobe[6] latch
XFILLER_157_271 VPWR VGND sg13cmos5l_fill_2
X_2734_ _2734_/X AXIL_S_SOC_ARPROT1 AXIL_S_SOC_RREADY _2826_/X _2798_/X _1434_/Q _1433_/Q
+ VPWR VGND sg13cmos5l_mux4_1
XFILLER_67_0 VPWR VGND sg13cmos5l_decap_8
XFILLER_117_168 VPWR VGND sg13cmos5l_decap_8
X_2665_ _2665_/X Tile_X0Y4_W1END[2] Tile_X0Y4_WW4END[14] Tile_X0Y4_W6END[6] _2703_/X
+ _1102_/Q _1101_/Q VPWR VGND sg13cmos5l_mux4_1
XFILLER_132_105 VPWR VGND sg13cmos5l_decap_4
XFILLER_246_56 VPWR VGND sg13cmos5l_decap_8
X_1616_ Tile_X0Y0_N4BEG[12] _1616_/A VPWR VGND sg13cmos5l_buf_1
X_2596_ _2596_/X _2504_/X _2612_/X _2611_/X _2503_/X _0800_/Q _0799_/Q VPWR VGND sg13cmos5l_mux4_1
XFILLER_5_70 VPWR VGND sg13cmos5l_decap_8
XFILLER_286_120 VPWR VGND sg13cmos5l_decap_8
X_1547_ Tile_X0Y3_EE4BEG[9] _2534_/X VPWR VGND sg13cmos5l_buf_1
XFILLER_115_49 VPWR VGND sg13cmos5l_decap_8
X_1478_ _1478_/Q Tile_X0Y5_FrameData[10] VGND VPWR Tile_X0Y5_FrameStrobe[6] latch
XFILLER_86_236 VPWR VGND sg13cmos5l_fill_1
XFILLER_262_77 VPWR VGND sg13cmos5l_decap_8
X_0429_ _0429_/Q Tile_X0Y1_FrameData[9] VGND VPWR Tile_X0Y5_FrameStrobe[3] latch
XFILLER_39_130 VPWR VGND sg13cmos5l_fill_2
XFILLER_227_231 VPWR VGND sg13cmos5l_decap_8
XFILLER_54_133 VPWR VGND sg13cmos5l_decap_8
XFILLER_199_149 VPWR VGND sg13cmos5l_decap_8
XANTENNA__1678__X Tile_X0Y0_FrameData_O[18] VPWR VGND sg13cmos5l_antennanp
XFILLER_211_70 VPWR VGND sg13cmos5l_decap_8
XFILLER_145_7 VPWR VGND sg13cmos5l_decap_8
XFILLER_24_35 VPWR VGND sg13cmos5l_decap_8
XFILLER_287_63 VPWR VGND sg13cmos5l_decap_8
XFILLER_312_7 VPWR VGND sg13cmos5l_decap_8
XFILLER_356_168 VPWR VGND sg13cmos5l_decap_8
XFILLER_108_135 VPWR VGND sg13cmos5l_decap_8
XFILLER_40_56 VPWR VGND sg13cmos5l_decap_8
XFILLER_123_105 VPWR VGND sg13cmos5l_decap_8
XFILLER_156_56 VPWR VGND sg13cmos5l_decap_8
XFILLER_163_263 VPWR VGND sg13cmos5l_decap_8
XFILLER_312_205 VPWR VGND sg13cmos5l_decap_4
XFILLER_49_21 VPWR VGND sg13cmos5l_decap_8
XFILLER_131_160 VPWR VGND sg13cmos5l_fill_2
XFILLER_277_131 VPWR VGND sg13cmos5l_decap_8
XFILLER_277_142 VPWR VGND sg13cmos5l_fill_2
XFILLER_77_225 VPWR VGND sg13cmos5l_decap_4
XFILLER_49_98 VPWR VGND sg13cmos5l_decap_8
XFILLER_172_77 VPWR VGND sg13cmos5l_decap_8
XFILLER_1_28 VPWR VGND sg13cmos5l_decap_8
XFILLER_292_112 VPWR VGND sg13cmos5l_decap_8
XFILLER_322_14 VPWR VGND sg13cmos5l_decap_8
XFILLER_218_242 VPWR VGND sg13cmos5l_decap_8
XFILLER_92_239 VPWR VGND sg13cmos5l_fill_2
XFILLER_65_42 VPWR VGND sg13cmos5l_decap_8
XFILLER_171_0 VPWR VGND sg13cmos5l_decap_8
XFILLER_269_0 VPWR VGND sg13cmos5l_decap_8
XFILLER_45_133 VPWR VGND sg13cmos5l_decap_8
XANTENNA_110 AXIL_S_SOC_WDATA27 VPWR VGND sg13cmos5l_antennanp
XANTENNA_121 AXIL_S_SOC_WDATA29 VPWR VGND sg13cmos5l_antennanp
XANTENNA_132 AXIL_S_SOC_WDATA29 VPWR VGND sg13cmos5l_antennanp
XANTENNA_143 AXIL_S_SOC_WDATA30 VPWR VGND sg13cmos5l_antennanp
XFILLER_45_155 VPWR VGND sg13cmos5l_decap_8
XANTENNA_154 AXIL_S_SOC_WDATA31 VPWR VGND sg13cmos5l_antennanp
XANTENNA_165 AXIL_S_SOC_WDATA31 VPWR VGND sg13cmos5l_antennanp
XANTENNA_176 AXIL_S_SOC_WDATA8 VPWR VGND sg13cmos5l_antennanp
XANTENNA__1588__X Tile_X0Y2_EE4BEG[1] VPWR VGND sg13cmos5l_antennanp
XFILLER_121_70 VPWR VGND sg13cmos5l_decap_8
XANTENNA_187 AXIL_S_SOC_WDATA9 VPWR VGND sg13cmos5l_antennanp
XANTENNA_198 AXIL_S_SOC_WDATA9 VPWR VGND sg13cmos5l_antennanp
XFILLER_60_147 VPWR VGND sg13cmos5l_decap_8
XFILLER_197_63 VPWR VGND sg13cmos5l_decap_8
XFILLER_81_85 VPWR VGND sg13cmos5l_decap_8
XFILLER_347_135 VPWR VGND sg13cmos5l_decap_8
XFILLER_146_219 VPWR VGND sg13cmos5l_decap_8
XFILLER_347_22 VPWR VGND sg13cmos5l_decap_8
XFILLER_347_179 VPWR VGND sg13cmos5l_fill_2
XFILLER_201_197 VPWR VGND sg13cmos5l_fill_2
X_0780_ _0780_/Q Tile_X0Y2_FrameData[26] VGND VPWR Tile_X0Y5_FrameStrobe[7] latch
XFILLER_60_7 VPWR VGND sg13cmos5l_decap_8
XFILLER_114_105 VPWR VGND sg13cmos5l_decap_8
X_2450_ _2450_/X _2476_/X _2474_/X _2468_/X _2467_/X _0628_/Q _0627_/Q VPWR VGND sg13cmos5l_mux4_1
X_1401_ _1401_/Q Tile_X0Y5_FrameData[23] VGND VPWR Tile_X0Y5_FrameStrobe[4] latch
XFILLER_268_131 VPWR VGND sg13cmos5l_fill_2
X_2381_ _2381_/X Tile_X0Y0_W2MID[7] Tile_X0Y0_W2END[7] Tile_X0Y0_W6END[8] _2241_/X
+ _0170_/Q _0169_/Q VPWR VGND sg13cmos5l_mux4_1
X_1332_ _1332_/Q Tile_X0Y5_FrameData[28] VGND VPWR Tile_X0Y5_FrameStrobe[2] latch
XFILLER_68_225 VPWR VGND sg13cmos5l_fill_1
XFILLER_68_214 VPWR VGND sg13cmos5l_decap_8
XFILLER_232_14 VPWR VGND sg13cmos5l_decap_8
XFILLER_283_112 VPWR VGND sg13cmos5l_decap_8
X_1263_ _1263_/Q Tile_X0Y4_FrameData[23] VGND VPWR Tile_X0Y5_FrameStrobe[7] latch
XFILLER_209_253 VPWR VGND sg13cmos5l_decap_4
X_0214_ _0214_/Q Tile_X0Y0_FrameData[16] VGND VPWR Tile_X0Y5_FrameStrobe[4] latch
X_1194_ _1194_/Q Tile_X0Y4_FrameData[28] VGND VPWR Tile_X0Y5_FrameStrobe[5] latch
XFILLER_312_91 VPWR VGND sg13cmos5l_decap_8
X_0145_ _0145_/Q Tile_X0Y0_FrameData[21] VGND VPWR Tile_X0Y5_FrameStrobe[2] latch
X_0076_ _0076_/Q Tile_X0Y0_FrameData[26] VGND VPWR Tile_X0Y5_FrameStrobe[0] latch
XFILLER_189_160 VPWR VGND sg13cmos5l_fill_2
XFILLER_196_119 VPWR VGND sg13cmos5l_decap_8
XFILLER_51_147 VPWR VGND sg13cmos5l_decap_8
X_0978_ _0978_/Q Tile_X0Y3_FrameData[4] VGND VPWR Tile_X0Y5_FrameStrobe[5] latch
XFILLER_353_105 VPWR VGND sg13cmos5l_decap_8
XFILLER_257_77 VPWR VGND sg13cmos5l_decap_8
X_2717_ _2717_/X Tile_X0Y3_W1END[0] Tile_X0Y3_W2MID[3] Tile_X0Y3_W2END[3] _2593_/X
+ _0882_/Q _0881_/Q VPWR VGND sg13cmos5l_mux4_1
XANTENNA__2122__X AXIL_S_SOC_RDATA16 VPWR VGND sg13cmos5l_antennanp
XFILLER_105_105 VPWR VGND sg13cmos5l_decap_4
XFILLER_273_21 VPWR VGND sg13cmos5l_decap_8
X_2648_ _2648_/X Tile_X0Y4_WW4END[11] AXIL_S_SOC_WSTRB3 _2707_/X _2708_/X _1158_/Q
+ _1157_/Q VPWR VGND sg13cmos5l_mux4_1
XANTENNA__1961__X Tile_X0Y1_E2BEG[6] VPWR VGND sg13cmos5l_antennanp
XFILLER_120_119 VPWR VGND sg13cmos5l_decap_8
XFILLER_259_131 VPWR VGND sg13cmos5l_fill_2
X_2579_ _2579_/X _2566_/X Tile_X0Y5_N4END[8] _2565_/X Tile_X0Y0_S4END[12] _0822_/Q
+ _0821_/Q VPWR VGND sg13cmos5l_mux4_1
XFILLER_206_70 VPWR VGND sg13cmos5l_decap_8
XFILLER_273_98 VPWR VGND sg13cmos5l_decap_4
XFILLER_113_193 VPWR VGND sg13cmos5l_decap_8
XFILLER_142_14 VPWR VGND sg13cmos5l_decap_8
XFILLER_19_35 VPWR VGND sg13cmos5l_decap_8
XFILLER_274_112 VPWR VGND sg13cmos5l_decap_8
XFILLER_74_239 VPWR VGND sg13cmos5l_fill_2
XFILLER_74_217 VPWR VGND sg13cmos5l_decap_8
XFILLER_215_245 VPWR VGND sg13cmos5l_fill_1
XFILLER_262_7 VPWR VGND sg13cmos5l_decap_8
XFILLER_27_166 VPWR VGND sg13cmos5l_decap_8
XFILLER_215_267 VPWR VGND sg13cmos5l_decap_4
XFILLER_222_91 VPWR VGND sg13cmos5l_decap_8
XFILLER_42_136 VPWR VGND sg13cmos5l_decap_8
XFILLER_35_56 VPWR VGND sg13cmos5l_decap_8
XFILLER_187_119 VPWR VGND sg13cmos5l_decap_8
XFILLER_298_84 VPWR VGND sg13cmos5l_decap_8
XFILLER_51_77 VPWR VGND sg13cmos5l_decap_8
XFILLER_344_105 VPWR VGND sg13cmos5l_decap_8
XFILLER_167_77 VPWR VGND sg13cmos5l_decap_8
XFILLER_317_14 VPWR VGND sg13cmos5l_decap_8
XANTENNA__2032__X Tile_X0Y5_FrameData_O[17] VPWR VGND sg13cmos5l_antennanp
XFILLER_151_200 VPWR VGND sg13cmos5l_decap_8
XFILLER_183_21 VPWR VGND sg13cmos5l_decap_8
XFILLER_352_182 VPWR VGND sg13cmos5l_decap_8
XANTENNA__1871__X Tile_X0Y2_E2BEGb[5] VPWR VGND sg13cmos5l_antennanp
XFILLER_111_119 VPWR VGND sg13cmos5l_decap_8
XFILLER_183_98 VPWR VGND sg13cmos5l_decap_8
XFILLER_333_35 VPWR VGND sg13cmos5l_decap_8
XFILLER_116_70 VPWR VGND sg13cmos5l_decap_8
XFILLER_265_145 VPWR VGND sg13cmos5l_fill_1
XFILLER_76_63 VPWR VGND sg13cmos5l_decap_8
XFILLER_18_133 VPWR VGND sg13cmos5l_decap_8
XFILLER_280_126 VPWR VGND sg13cmos5l_decap_4
XFILLER_202_28 VPWR VGND sg13cmos5l_decap_8
XFILLER_132_91 VPWR VGND sg13cmos5l_decap_8
XFILLER_73_272 VPWR VGND sg13cmos5l_fill_1
XFILLER_178_119 VPWR VGND sg13cmos5l_decap_8
XFILLER_92_84 VPWR VGND sg13cmos5l_decap_8
XFILLER_33_147 VPWR VGND sg13cmos5l_fill_1
X_1950_ Tile_X0Y1_E2BEGb[3] _2304_/X VPWR VGND sg13cmos5l_buf_1
XFILLER_358_21 VPWR VGND sg13cmos5l_decap_8
X_1881_ Tile_X0Y2_E6BEG[7] _2440_/X VPWR VGND sg13cmos5l_buf_1
X_0901_ _0901_/Q Tile_X0Y3_FrameData[17] VGND VPWR Tile_X0Y5_FrameStrobe[3] latch
X_0832_ _0832_/Q Tile_X0Y3_FrameData[22] VGND VPWR Tile_X0Y5_FrameStrobe[1] latch
XFILLER_358_98 VPWR VGND sg13cmos5l_decap_8
XFILLER_227_14 VPWR VGND sg13cmos5l_decap_8
X_2502_ _2502_/X Tile_X0Y4_W2MID[1] Tile_X0Y4_W2END[1] Tile_X0Y4_W6END[1] _2682_/X
+ _1244_/Q _1243_/Q VPWR VGND sg13cmos5l_mux4_1
X_0763_ _0763_/Q Tile_X0Y2_FrameData[11] VGND VPWR Tile_X0Y5_FrameStrobe[6] latch
XFILLER_142_211 VPWR VGND sg13cmos5l_fill_1
X_0694_ _0694_/Q Tile_X0Y2_FrameData[16] VGND VPWR Tile_X0Y5_FrameStrobe[4] latch
XFILLER_343_193 VPWR VGND sg13cmos5l_decap_8
XANTENNA__1781__X Tile_X0Y2_E2BEG[4] VPWR VGND sg13cmos5l_antennanp
X_2433_ _2433_/X Tile_X0Y5_N4END[12] Tile_X0Y0_S4END[8] _2466_/X _2465_/X _0682_/Q
+ _0681_/Q VPWR VGND sg13cmos5l_mux4_1
XFILLER_307_91 VPWR VGND sg13cmos5l_decap_8
X_2364_ _2364_/X _2819_/X _2817_/X _2802_/X _2801_/X _1463_/Q _1462_/Q VPWR VGND sg13cmos5l_mux4_1
XFILLER_110_130 VPWR VGND sg13cmos5l_fill_2
XFILLER_243_35 VPWR VGND sg13cmos5l_decap_8
XFILLER_256_112 VPWR VGND sg13cmos5l_decap_8
X_1315_ _1315_/Q Tile_X0Y5_FrameData[13] VGND VPWR Tile_X0Y5_FrameStrobe[1] latch
X_2295_ _2295_/X AXIL_S_SOC_WDATA2 AXIL_S_SOC_WDATA10 _2375_/X _2378_/X _0502_/Q _0501_/Q
+ VPWR VGND sg13cmos5l_mux4_1
XFILLER_56_217 VPWR VGND sg13cmos5l_decap_8
X_1246_ _1246_/Q Tile_X0Y4_FrameData[8] VGND VPWR Tile_X0Y5_FrameStrobe[6] latch
XFILLER_112_28 VPWR VGND sg13cmos5l_decap_8
X_1177_ _1177_/Q Tile_X0Y4_FrameData[13] VGND VPWR Tile_X0Y5_FrameStrobe[4] latch
X_0128_ _0128_/Q Tile_X0Y0_FrameData[6] VGND VPWR Tile_X0Y5_FrameStrobe[1] latch
XANTENNA__2117__X AXIL_S_SOC_RDATA11 VPWR VGND sg13cmos5l_antennanp
XFILLER_212_237 VPWR VGND sg13cmos5l_decap_8
XFILLER_268_21 VPWR VGND sg13cmos5l_decap_8
X_0059_ _0059_/X _2807_/X _2808_/X _0389_/Q VPWR VGND sg13cmos5l_mux2_1
XANTENNA_10 AXIL_S_SOC_WDATA10 VPWR VGND sg13cmos5l_antennanp
XANTENNA_21 AXIL_S_SOC_WDATA11 VPWR VGND sg13cmos5l_antennanp
XANTENNA_32 AXIL_S_SOC_WDATA11 VPWR VGND sg13cmos5l_antennanp
XANTENNA__1956__X Tile_X0Y1_E2BEG[1] VPWR VGND sg13cmos5l_antennanp
XANTENNA_43 AXIL_S_SOC_WDATA15 VPWR VGND sg13cmos5l_antennanp
XANTENNA_54 AXIL_S_SOC_WDATA16 VPWR VGND sg13cmos5l_antennanp
XANTENNA_65 AXIL_S_SOC_WDATA23 VPWR VGND sg13cmos5l_antennanp
XFILLER_177_185 VPWR VGND sg13cmos5l_decap_8
XFILLER_326_105 VPWR VGND sg13cmos5l_decap_4
XANTENNA_76 AXIL_S_SOC_WDATA25 VPWR VGND sg13cmos5l_antennanp
XANTENNA_87 AXIL_S_SOC_WDATA26 VPWR VGND sg13cmos5l_antennanp
XANTENNA_98 AXIL_S_SOC_WDATA26 VPWR VGND sg13cmos5l_antennanp
XFILLER_118_241 VPWR VGND sg13cmos5l_fill_2
XFILLER_21_14 VPWR VGND sg13cmos5l_decap_8
XFILLER_137_14 VPWR VGND sg13cmos5l_decap_8
XFILLER_284_42 VPWR VGND sg13cmos5l_decap_8
XFILLER_341_119 VPWR VGND sg13cmos5l_decap_8
XFILLER_108_7 VPWR VGND sg13cmos5l_decap_8
XANTENNA__1691__X Tile_X0Y0_FrameData_O[31] VPWR VGND sg13cmos5l_antennanp
XFILLER_217_91 VPWR VGND sg13cmos5l_decap_8
XFILLER_153_35 VPWR VGND sg13cmos5l_decap_8
XFILLER_247_112 VPWR VGND sg13cmos5l_decap_8
XFILLER_99_191 VPWR VGND sg13cmos5l_decap_8
XFILLER_303_49 VPWR VGND sg13cmos5l_decap_8
XFILLER_47_239 VPWR VGND sg13cmos5l_decap_8
XFILLER_46_22 VPWR VGND sg13cmos5l_decap_8
XFILLER_55_272 VPWR VGND sg13cmos5l_fill_1
XFILLER_46_99 VPWR VGND sg13cmos5l_decap_8
XFILLER_203_226 VPWR VGND sg13cmos5l_fill_1
XFILLER_70_231 VPWR VGND sg13cmos5l_decap_4
XFILLER_62_21 VPWR VGND sg13cmos5l_decap_8
XANTENNA__2027__X Tile_X0Y5_FrameData_O[12] VPWR VGND sg13cmos5l_antennanp
XFILLER_178_21 VPWR VGND sg13cmos5l_decap_8
XFILLER_203_248 VPWR VGND sg13cmos5l_decap_4
XFILLER_203_259 VPWR VGND sg13cmos5l_fill_2
XANTENNA__1866__X Tile_X0Y2_E2BEGb[0] VPWR VGND sg13cmos5l_antennanp
XFILLER_168_163 VPWR VGND sg13cmos5l_decap_8
XFILLER_62_98 VPWR VGND sg13cmos5l_decap_8
XFILLER_357_230 VPWR VGND sg13cmos5l_decap_8
XFILLER_134_0 VPWR VGND sg13cmos5l_decap_8
XFILLER_178_98 VPWR VGND sg13cmos5l_decap_8
XFILLER_317_105 VPWR VGND sg13cmos5l_decap_8
XFILLER_183_133 VPWR VGND sg13cmos5l_decap_8
XFILLER_328_35 VPWR VGND sg13cmos5l_decap_8
XFILLER_7_49 VPWR VGND sg13cmos5l_decap_8
XFILLER_194_42 VPWR VGND sg13cmos5l_decap_8
XFILLER_301_0 VPWR VGND sg13cmos5l_decap_8
XFILLER_11_91 VPWR VGND sg13cmos5l_decap_8
XFILLER_127_91 VPWR VGND sg13cmos5l_decap_8
XFILLER_344_56 VPWR VGND sg13cmos5l_decap_8
XFILLER_340_174 VPWR VGND sg13cmos5l_decap_8
XFILLER_238_112 VPWR VGND sg13cmos5l_decap_8
XFILLER_23_7 VPWR VGND sg13cmos5l_decap_8
XFILLER_87_84 VPWR VGND sg13cmos5l_decap_8
XFILLER_340_196 VPWR VGND sg13cmos5l_fill_2
X_1100_ _1100_/Q Tile_X0Y4_FrameData[26] VGND VPWR Tile_X0Y5_FrameStrobe[2] latch
XFILLER_213_49 VPWR VGND sg13cmos5l_decap_8
XFILLER_238_189 VPWR VGND sg13cmos5l_decap_8
X_2080_ Tile_X0Y5_S4BEG[13] _2080_/A VPWR VGND sg13cmos5l_buf_1
X_1031_ _1031_/Q Tile_X0Y3_FrameData[31] VGND VPWR Tile_X0Y5_FrameStrobe[0] latch
XFILLER_360_99 VPWR VGND sg13cmos5l_decap_8
XFILLER_253_159 VPWR VGND sg13cmos5l_fill_2
XFILLER_46_272 VPWR VGND sg13cmos5l_fill_1
XFILLER_261_170 VPWR VGND sg13cmos5l_decap_8
XFILLER_159_141 VPWR VGND sg13cmos5l_fill_1
XFILLER_21_139 VPWR VGND sg13cmos5l_fill_1
X_1933_ Tile_X0Y1_EE4BEG[14] _2323_/X VPWR VGND sg13cmos5l_buf_1
XANTENNA__1776__X Tile_X0Y2_E1BEG[3] VPWR VGND sg13cmos5l_antennanp
XFILLER_159_163 VPWR VGND sg13cmos5l_decap_4
XFILLER_159_196 VPWR VGND sg13cmos5l_decap_4
XFILLER_308_105 VPWR VGND sg13cmos5l_decap_8
XFILLER_174_133 VPWR VGND sg13cmos5l_decap_8
XFILLER_238_35 VPWR VGND sg13cmos5l_decap_8
X_1864_ Tile_X0Y4_FrameData_O[31] Tile_X0Y4_FrameData[31] VPWR VGND sg13cmos5l_buf_1
XFILLER_323_119 VPWR VGND sg13cmos5l_fill_2
X_1795_ Tile_X0Y4_E2BEG[6] _2623_/X VPWR VGND sg13cmos5l_buf_1
X_0815_ _0815_/Q Tile_X0Y3_FrameData[7] VGND VPWR Tile_X0Y5_FrameStrobe[0] latch
XFILLER_115_222 VPWR VGND sg13cmos5l_decap_8
X_0746_ _0746_/Q Tile_X0Y2_FrameData[28] VGND VPWR Tile_X0Y5_FrameStrobe[6] latch
XFILLER_107_28 VPWR VGND sg13cmos5l_decap_8
XFILLER_254_56 VPWR VGND sg13cmos5l_decap_8
X_2416_ _2416_/X AXIL_S_SOC_AWADDR1 AXIL_S_SOC_AWADDR7 _2481_/X _2488_/X _0716_/Q
+ _0715_/Q VPWR VGND sg13cmos5l_mux4_1
X_0677_ _0677_/Q Tile_X0Y2_FrameData[1] VGND VPWR Tile_X0Y5_FrameStrobe[3] latch
XFILLER_229_112 VPWR VGND sg13cmos5l_decap_8
X_2347_ _2347_/X Tile_X0Y0_W1END[3] Tile_X0Y0_W6END[11] _2217_/X _2212_/X _0172_/Q
+ _0171_/Q VPWR VGND sg13cmos5l_mux4_1
XFILLER_123_49 VPWR VGND sg13cmos5l_decap_8
XFILLER_29_239 VPWR VGND sg13cmos5l_decap_4
X_2278_ _2278_/X _2478_/X _2477_/X _2470_/X _2469_/X _0763_/Q _0762_/Q VPWR VGND sg13cmos5l_mux4_1
XFILLER_244_126 VPWR VGND sg13cmos5l_decap_8
XFILLER_270_77 VPWR VGND sg13cmos5l_decap_8
XFILLER_270_88 VPWR VGND sg13cmos5l_fill_2
X_1229_ _1229_/Q Tile_X0Y4_FrameData[25] VGND VPWR Tile_X0Y5_FrameStrobe[6] latch
XFILLER_16_14 VPWR VGND sg13cmos5l_decap_8
XFILLER_37_272 VPWR VGND sg13cmos5l_fill_1
XFILLER_52_231 VPWR VGND sg13cmos5l_decap_8
XFILLER_279_42 VPWR VGND sg13cmos5l_decap_8
XFILLER_200_229 VPWR VGND sg13cmos5l_decap_8
XANTENNA__1686__X Tile_X0Y0_FrameData_O[26] VPWR VGND sg13cmos5l_antennanp
XFILLER_225_7 VPWR VGND sg13cmos5l_decap_8
XFILLER_32_35 VPWR VGND sg13cmos5l_decap_8
XFILLER_148_35 VPWR VGND sg13cmos5l_decap_8
XFILLER_165_155 VPWR VGND sg13cmos5l_decap_8
XFILLER_295_63 VPWR VGND sg13cmos5l_decap_8
XFILLER_180_147 VPWR VGND sg13cmos5l_decap_8
XFILLER_164_56 VPWR VGND sg13cmos5l_decap_8
XFILLER_322_163 VPWR VGND sg13cmos5l_fill_1
XFILLER_57_21 VPWR VGND sg13cmos5l_decap_8
XFILLER_180_77 VPWR VGND sg13cmos5l_decap_8
XFILLER_235_126 VPWR VGND sg13cmos5l_decap_8
XFILLER_28_250 VPWR VGND sg13cmos5l_fill_2
XFILLER_290_210 VPWR VGND sg13cmos5l_fill_1
XFILLER_330_14 VPWR VGND sg13cmos5l_decap_8
XFILLER_57_98 VPWR VGND sg13cmos5l_decap_8
XFILLER_28_272 VPWR VGND sg13cmos5l_fill_1
XFILLER_251_0 VPWR VGND sg13cmos5l_decap_8
XFILLER_73_42 VPWR VGND sg13cmos5l_decap_8
XFILLER_188_247 VPWR VGND sg13cmos5l_fill_2
XFILLER_189_42 VPWR VGND sg13cmos5l_decap_8
XFILLER_349_0 VPWR VGND sg13cmos5l_decap_8
XFILLER_188_258 VPWR VGND sg13cmos5l_fill_1
XANTENNA__1596__X Tile_X0Y2_EE4BEG[9] VPWR VGND sg13cmos5l_antennanp
XFILLER_345_200 VPWR VGND sg13cmos5l_decap_4
XFILLER_339_56 VPWR VGND sg13cmos5l_decap_8
XFILLER_11_161 VPWR VGND sg13cmos5l_decap_8
XFILLER_156_133 VPWR VGND sg13cmos5l_fill_1
XFILLER_208_49 VPWR VGND sg13cmos5l_decap_8
XFILLER_305_119 VPWR VGND sg13cmos5l_decap_8
X_1580_ Tile_X0Y3_FrameData_O[26] Tile_X0Y3_FrameData[26] VPWR VGND sg13cmos5l_buf_1
X_0600_ _0600_/Q Tile_X0Y2_FrameData[14] VGND VPWR Tile_X0Y5_FrameStrobe[1] latch
XFILLER_360_225 VPWR VGND sg13cmos5l_decap_4
XFILLER_171_158 VPWR VGND sg13cmos5l_decap_8
X_0531_ _0531_/Q Tile_X0Y1_FrameData[3] VGND VPWR Tile_X0Y5_FrameStrobe[6] latch
XFILLER_355_77 VPWR VGND sg13cmos5l_decap_8
XFILLER_258_207 VPWR VGND sg13cmos5l_fill_1
XFILLER_258_229 VPWR VGND sg13cmos5l_fill_1
X_0462_ _0462_/Q Tile_X0Y1_FrameData[8] VGND VPWR Tile_X0Y5_FrameStrobe[4] latch
X_2201_ _2201_/X AXIL_S_SOC_WDATA20 _2233_/X _2218_/X _2241_/X _0194_/Q _0193_/Q VPWR
+ VGND sg13cmos5l_mux4_1
X_0393_ _0393_/Q Tile_X0Y1_FrameData[13] VGND VPWR Tile_X0Y5_FrameStrobe[2] latch
XFILLER_78_150 VPWR VGND sg13cmos5l_decap_8
X_2132_ AXIL_S_SOC_RDATA26 Tile_X0Y0_W2MID[2] Tile_X0Y0_W2END[2] Tile_X0Y0_W6END[2]
+ _2243_/X _0138_/Q _0137_/Q VPWR VGND sg13cmos5l_mux4_1
XFILLER_240_14 VPWR VGND sg13cmos5l_decap_8
XFILLER_304_70 VPWR VGND sg13cmos5l_decap_8
XFILLER_93_164 VPWR VGND sg13cmos5l_decap_8
X_2063_ Tile_X0Y5_S2BEGb[4] _2833_/X VPWR VGND sg13cmos5l_buf_1
X_1014_ _1014_/Q Tile_X0Y3_FrameData[0] VGND VPWR Tile_X0Y5_FrameStrobe[6] latch
XFILLER_179_236 VPWR VGND sg13cmos5l_decap_8
XFILLER_179_247 VPWR VGND sg13cmos5l_fill_1
XFILLER_234_192 VPWR VGND sg13cmos5l_decap_8
XFILLER_34_253 VPWR VGND sg13cmos5l_decap_4
XFILLER_320_91 VPWR VGND sg13cmos5l_decap_8
XFILLER_97_0 VPWR VGND sg13cmos5l_decap_8
XFILLER_249_56 VPWR VGND sg13cmos5l_decap_8
X_1916_ Tile_X0Y1_FrameData_O[29] Tile_X0Y1_FrameData[29] VPWR VGND sg13cmos5l_buf_1
XFILLER_147_155 VPWR VGND sg13cmos5l_decap_4
X_1847_ Tile_X0Y4_FrameData_O[14] Tile_X0Y4_FrameData[14] VPWR VGND sg13cmos5l_buf_1
XFILLER_8_70 VPWR VGND sg13cmos5l_decap_8
XFILLER_351_203 VPWR VGND sg13cmos5l_decap_8
XFILLER_351_214 VPWR VGND sg13cmos5l_fill_1
XFILLER_118_49 VPWR VGND sg13cmos5l_decap_8
XFILLER_162_147 VPWR VGND sg13cmos5l_decap_8
XFILLER_265_77 VPWR VGND sg13cmos5l_decap_8
X_1778_ Tile_X0Y2_E2BEG[1] _2402_/X VPWR VGND sg13cmos5l_buf_1
XANTENNA__2130__X AXIL_S_SOC_RDATA24 VPWR VGND sg13cmos5l_antennanp
XFILLER_103_214 VPWR VGND sg13cmos5l_fill_2
X_0729_ _0729_/Q Tile_X0Y2_FrameData[13] VGND VPWR Tile_X0Y5_FrameStrobe[5] latch
XFILLER_103_258 VPWR VGND sg13cmos5l_decap_8
XFILLER_281_21 VPWR VGND sg13cmos5l_decap_8
XFILLER_304_196 VPWR VGND sg13cmos5l_decap_8
XFILLER_281_98 VPWR VGND sg13cmos5l_decap_8
XFILLER_84_120 VPWR VGND sg13cmos5l_decap_8
XFILLER_69_194 VPWR VGND sg13cmos5l_decap_4
XFILLER_214_70 VPWR VGND sg13cmos5l_decap_8
XFILLER_27_35 VPWR VGND sg13cmos5l_decap_8
XFILLER_150_14 VPWR VGND sg13cmos5l_decap_8
XFILLER_175_7 VPWR VGND sg13cmos5l_decap_8
XFILLER_217_148 VPWR VGND sg13cmos5l_fill_1
XFILLER_84_186 VPWR VGND sg13cmos5l_fill_2
XFILLER_300_28 VPWR VGND sg13cmos5l_decap_8
XFILLER_230_91 VPWR VGND sg13cmos5l_decap_8
XFILLER_240_140 VPWR VGND sg13cmos5l_decap_8
XFILLER_43_56 VPWR VGND sg13cmos5l_decap_8
XFILLER_159_56 VPWR VGND sg13cmos5l_decap_8
XFILLER_185_228 VPWR VGND sg13cmos5l_fill_2
XFILLER_40_267 VPWR VGND sg13cmos5l_decap_4
XFILLER_138_144 VPWR VGND sg13cmos5l_decap_8
XFILLER_138_199 VPWR VGND sg13cmos5l_decap_8
XFILLER_153_114 VPWR VGND sg13cmos5l_decap_8
XFILLER_175_77 VPWR VGND sg13cmos5l_decap_8
XFILLER_325_14 VPWR VGND sg13cmos5l_decap_8
XFILLER_4_28 VPWR VGND sg13cmos5l_decap_8
XANTENNA__2040__X Tile_X0Y5_FrameData_O[25] VPWR VGND sg13cmos5l_antennanp
XFILLER_191_21 VPWR VGND sg13cmos5l_decap_8
XFILLER_310_133 VPWR VGND sg13cmos5l_decap_8
XFILLER_68_42 VPWR VGND sg13cmos5l_decap_8
XFILLER_299_0 VPWR VGND sg13cmos5l_decap_8
XFILLER_191_98 VPWR VGND sg13cmos5l_decap_4
XFILLER_124_70 VPWR VGND sg13cmos5l_decap_8
XFILLER_341_35 VPWR VGND sg13cmos5l_decap_8
XFILLER_84_63 VPWR VGND sg13cmos5l_decap_8
XFILLER_210_28 VPWR VGND sg13cmos5l_decap_8
XFILLER_216_181 VPWR VGND sg13cmos5l_decap_8
XFILLER_231_140 VPWR VGND sg13cmos5l_decap_8
XFILLER_231_184 VPWR VGND sg13cmos5l_decap_8
XFILLER_31_267 VPWR VGND sg13cmos5l_decap_4
X_2750_ _2750_/X AXIL_S_SOC_ARPROT0 AXIL_S_SOC_RREADY _2818_/X _2798_/X _1402_/Q _1401_/Q
+ VPWR VGND sg13cmos5l_mux4_1
XFILLER_129_177 VPWR VGND sg13cmos5l_decap_8
XFILLER_184_261 VPWR VGND sg13cmos5l_fill_1
X_1701_ Tile_X0Y0_EE4BEG[9] _2190_/X VPWR VGND sg13cmos5l_buf_1
X_2681_ _2681_/X _2612_/X Tile_X0Y5_N2MID[7] _2720_/X _2611_/X _1040_/Q _1039_/Q VPWR
+ VGND sg13cmos5l_mux4_1
XFILLER_184_272 VPWR VGND sg13cmos5l_fill_1
X_1632_ Tile_X0Y0_N2BEG[4] _2149_/X VPWR VGND sg13cmos5l_buf_1
XFILLER_333_247 VPWR VGND sg13cmos5l_fill_1
XFILLER_235_14 VPWR VGND sg13cmos5l_decap_8
XFILLER_298_140 VPWR VGND sg13cmos5l_decap_8
X_1563_ Tile_X0Y3_FrameData_O[9] Tile_X0Y3_FrameData[9] VPWR VGND sg13cmos5l_buf_1
XFILLER_301_133 VPWR VGND sg13cmos5l_decap_8
X_1494_ _1494_/Q Tile_X0Y5_FrameData[26] VGND VPWR Tile_X0Y5_FrameStrobe[7] latch
X_0514_ _0514_/Q Tile_X0Y1_FrameData[20] VGND VPWR Tile_X0Y5_FrameStrobe[6] latch
XFILLER_98_256 VPWR VGND sg13cmos5l_decap_4
X_0445_ _0445_/Q Tile_X0Y1_FrameData[25] VGND VPWR Tile_X0Y5_FrameStrobe[4] latch
XFILLER_98_267 VPWR VGND sg13cmos5l_decap_4
XFILLER_100_228 VPWR VGND sg13cmos5l_decap_4
XFILLER_315_91 VPWR VGND sg13cmos5l_decap_8
XFILLER_104_29 VPWR VGND sg13cmos5l_decap_8
XFILLER_12_0 VPWR VGND sg13cmos5l_decap_8
XFILLER_251_35 VPWR VGND sg13cmos5l_decap_8
X_0376_ _0376_/Q Tile_X0Y1_FrameData[30] VGND VPWR Tile_X0Y5_FrameStrobe[2] latch
X_2115_ AXIL_S_SOC_RDATA9 Tile_X0Y2_W2MID[1] Tile_X0Y2_W2END[1] Tile_X0Y2_W6END[1]
+ _2482_/X _0620_/Q _0619_/Q VPWR VGND sg13cmos5l_mux4_1
X_2046_ Tile_X0Y5_FrameData_O[31] Tile_X0Y5_FrameData[31] VPWR VGND sg13cmos5l_buf_1
XFILLER_66_197 VPWR VGND sg13cmos5l_decap_8
XFILLER_120_28 VPWR VGND sg13cmos5l_decap_8
XFILLER_22_212 VPWR VGND sg13cmos5l_decap_4
XFILLER_167_206 VPWR VGND sg13cmos5l_fill_2
XFILLER_222_173 VPWR VGND sg13cmos5l_decap_8
XANTENNA__2125__X AXIL_S_SOC_RDATA19 VPWR VGND sg13cmos5l_antennanp
XFILLER_276_21 VPWR VGND sg13cmos5l_decap_8
XANTENNA__1964__X Tile_X0Y1_E1BEG[1] VPWR VGND sg13cmos5l_antennanp
XFILLER_209_70 VPWR VGND sg13cmos5l_decap_8
XFILLER_276_98 VPWR VGND sg13cmos5l_decap_8
XFILLER_145_14 VPWR VGND sg13cmos5l_decap_8
XFILLER_150_117 VPWR VGND sg13cmos5l_decap_8
XFILLER_1_105 VPWR VGND sg13cmos5l_fill_1
XFILLER_289_140 VPWR VGND sg13cmos5l_decap_8
XFILLER_143_191 VPWR VGND sg13cmos5l_decap_8
XFILLER_292_42 VPWR VGND sg13cmos5l_decap_8
XFILLER_89_256 VPWR VGND sg13cmos5l_fill_1
XFILLER_292_7 VPWR VGND sg13cmos5l_decap_8
XFILLER_225_91 VPWR VGND sg13cmos5l_decap_8
XFILLER_161_35 VPWR VGND sg13cmos5l_decap_8
XFILLER_38_56 VPWR VGND sg13cmos5l_decap_8
XFILLER_72_112 VPWR VGND sg13cmos5l_decap_8
XFILLER_57_175 VPWR VGND sg13cmos5l_decap_8
XANTENNA_303 AXIL_S_SOC_WDATA19 VPWR VGND sg13cmos5l_antennanp
XANTENNA_314 Tile_X0Y0_FrameData[23] VPWR VGND sg13cmos5l_antennanp
XANTENNA_325 Tile_X0Y0_FrameData[31] VPWR VGND sg13cmos5l_antennanp
XFILLER_311_49 VPWR VGND sg13cmos5l_decap_8
XFILLER_72_123 VPWR VGND sg13cmos5l_fill_2
XFILLER_13_201 VPWR VGND sg13cmos5l_fill_2
XFILLER_54_77 VPWR VGND sg13cmos5l_decap_8
XFILLER_359_133 VPWR VGND sg13cmos5l_decap_8
XANTENNA__2035__X Tile_X0Y5_FrameData_O[20] VPWR VGND sg13cmos5l_antennanp
XFILLER_158_239 VPWR VGND sg13cmos5l_decap_8
XFILLER_70_21 VPWR VGND sg13cmos5l_decap_8
XFILLER_186_21 VPWR VGND sg13cmos5l_decap_8
XANTENNA__1874__X Tile_X0Y2_E6BEG[0] VPWR VGND sg13cmos5l_antennanp
XFILLER_214_0 VPWR VGND sg13cmos5l_decap_8
XFILLER_70_98 VPWR VGND sg13cmos5l_decap_8
XFILLER_119_70 VPWR VGND sg13cmos5l_decap_8
XFILLER_186_98 VPWR VGND sg13cmos5l_decap_8
XFILLER_336_35 VPWR VGND sg13cmos5l_decap_8
XFILLER_79_63 VPWR VGND sg13cmos5l_decap_8
XFILLER_205_28 VPWR VGND sg13cmos5l_decap_8
XFILLER_135_91 VPWR VGND sg13cmos5l_decap_8
XFILLER_295_154 VPWR VGND sg13cmos5l_decap_8
XFILLER_95_226 VPWR VGND sg13cmos5l_decap_8
XFILLER_352_56 VPWR VGND sg13cmos5l_decap_8
XFILLER_0_182 VPWR VGND sg13cmos5l_fill_2
X_0230_ _0230_/Q Tile_X0Y0_FrameData[0] VGND VPWR Tile_X0Y5_FrameStrobe[4] latch
XFILLER_236_232 VPWR VGND sg13cmos5l_decap_4
X_0161_ _0161_/Q Tile_X0Y0_FrameData[5] VGND VPWR Tile_X0Y5_FrameStrobe[2] latch
XFILLER_63_112 VPWR VGND sg13cmos5l_decap_8
XFILLER_48_186 VPWR VGND sg13cmos5l_decap_8
XFILLER_221_49 VPWR VGND sg13cmos5l_decap_8
X_0092_ _0092_/Q Tile_X0Y0_FrameData[10] VGND VPWR Tile_X0Y5_FrameStrobe[0] latch
XFILLER_204_195 VPWR VGND sg13cmos5l_fill_2
X_2802_ _2802_/X Tile_X0Y5_N1END[3] Tile_X0Y5_N4END[3] _2796_/X _0057_/X _1298_/Q
+ _1297_/Q VPWR VGND sg13cmos5l_mux4_1
XFILLER_164_209 VPWR VGND sg13cmos5l_decap_4
X_2733_ _2733_/X AXIL_S_SOC_ARPROT0 AXIL_S_SOC_ARVALID _2825_/X _2797_/X _1436_/Q
+ _1435_/Q VPWR VGND sg13cmos5l_mux4_1
X_0994_ _0994_/Q Tile_X0Y3_FrameData[20] VGND VPWR Tile_X0Y5_FrameStrobe[6] latch
XANTENNA__1784__X Tile_X0Y2_E2BEG[7] VPWR VGND sg13cmos5l_antennanp
XFILLER_8_260 VPWR VGND sg13cmos5l_fill_2
XFILLER_117_147 VPWR VGND sg13cmos5l_decap_8
XFILLER_246_35 VPWR VGND sg13cmos5l_decap_8
X_2664_ _2664_/X _2704_/X _2693_/X _2692_/X _2683_/X _1105_/Q _1104_/Q VPWR VGND sg13cmos5l_mux4_1
XFILLER_132_117 VPWR VGND sg13cmos5l_decap_8
X_1615_ Tile_X0Y0_N4BEG[11] _1615_/A VPWR VGND sg13cmos5l_buf_1
X_2595_ _2595_/X _2502_/X _2610_/X _2609_/X _2501_/X _0802_/Q _0801_/Q VPWR VGND sg13cmos5l_mux4_1
X_1546_ Tile_X0Y3_EE4BEG[8] _2533_/X VPWR VGND sg13cmos5l_buf_1
XFILLER_115_28 VPWR VGND sg13cmos5l_decap_8
XFILLER_86_204 VPWR VGND sg13cmos5l_decap_8
XFILLER_140_172 VPWR VGND sg13cmos5l_decap_8
XFILLER_262_56 VPWR VGND sg13cmos5l_decap_8
X_1477_ _1477_/Q Tile_X0Y5_FrameData[11] VGND VPWR Tile_X0Y5_FrameStrobe[6] latch
XFILLER_227_210 VPWR VGND sg13cmos5l_decap_8
X_0428_ _0428_/Q Tile_X0Y1_FrameData[10] VGND VPWR Tile_X0Y5_FrameStrobe[3] latch
X_0359_ _0359_/Q Tile_X0Y1_FrameData[15] VGND VPWR Tile_X0Y5_FrameStrobe[1] latch
XFILLER_54_112 VPWR VGND sg13cmos5l_decap_8
XANTENNA__1959__X Tile_X0Y1_E2BEG[4] VPWR VGND sg13cmos5l_antennanp
XFILLER_131_49 VPWR VGND sg13cmos5l_decap_8
XFILLER_242_268 VPWR VGND sg13cmos5l_decap_4
XFILLER_24_14 VPWR VGND sg13cmos5l_decap_8
X_2029_ Tile_X0Y5_FrameData_O[14] Tile_X0Y5_FrameData[14] VPWR VGND sg13cmos5l_buf_1
XFILLER_54_189 VPWR VGND sg13cmos5l_decap_8
XFILLER_210_143 VPWR VGND sg13cmos5l_decap_8
XFILLER_287_42 VPWR VGND sg13cmos5l_decap_8
XFILLER_138_7 VPWR VGND sg13cmos5l_decap_8
XFILLER_356_147 VPWR VGND sg13cmos5l_decap_8
XANTENNA__1694__X Tile_X0Y0_EE4BEG[2] VPWR VGND sg13cmos5l_antennanp
XFILLER_108_125 VPWR VGND sg13cmos5l_fill_2
XFILLER_148_272 VPWR VGND sg13cmos5l_fill_1
XFILLER_40_35 VPWR VGND sg13cmos5l_decap_8
XFILLER_156_35 VPWR VGND sg13cmos5l_decap_8
XFILLER_163_242 VPWR VGND sg13cmos5l_decap_8
XFILLER_305_7 VPWR VGND sg13cmos5l_decap_8
XFILLER_108_169 VPWR VGND sg13cmos5l_decap_8
XFILLER_306_49 VPWR VGND sg13cmos5l_decap_8
XFILLER_172_56 VPWR VGND sg13cmos5l_decap_8
XFILLER_277_165 VPWR VGND sg13cmos5l_decap_8
XFILLER_49_77 VPWR VGND sg13cmos5l_decap_8
XFILLER_218_221 VPWR VGND sg13cmos5l_decap_8
XFILLER_65_21 VPWR VGND sg13cmos5l_decap_8
XANTENNA_100 AXIL_S_SOC_WDATA26 VPWR VGND sg13cmos5l_antennanp
XFILLER_292_179 VPWR VGND sg13cmos5l_decap_8
XFILLER_45_112 VPWR VGND sg13cmos5l_decap_8
XANTENNA_111 AXIL_S_SOC_WDATA27 VPWR VGND sg13cmos5l_antennanp
XANTENNA_122 AXIL_S_SOC_WDATA29 VPWR VGND sg13cmos5l_antennanp
XANTENNA_133 AXIL_S_SOC_WDATA29 VPWR VGND sg13cmos5l_antennanp
XANTENNA__1869__X Tile_X0Y2_E2BEGb[3] VPWR VGND sg13cmos5l_antennanp
XFILLER_164_0 VPWR VGND sg13cmos5l_decap_8
XFILLER_233_246 VPWR VGND sg13cmos5l_decap_4
XFILLER_65_98 VPWR VGND sg13cmos5l_decap_8
XANTENNA_144 AXIL_S_SOC_WDATA30 VPWR VGND sg13cmos5l_antennanp
XANTENNA_155 AXIL_S_SOC_WDATA31 VPWR VGND sg13cmos5l_antennanp
XANTENNA_166 AXIL_S_SOC_WDATA31 VPWR VGND sg13cmos5l_antennanp
XFILLER_60_126 VPWR VGND sg13cmos5l_decap_8
XANTENNA_177 AXIL_S_SOC_WDATA8 VPWR VGND sg13cmos5l_antennanp
XANTENNA_188 AXIL_S_SOC_WDATA9 VPWR VGND sg13cmos5l_antennanp
XANTENNA_199 _2391_/X VPWR VGND sg13cmos5l_antennanp
XFILLER_197_42 VPWR VGND sg13cmos5l_decap_8
XFILLER_201_143 VPWR VGND sg13cmos5l_decap_8
XFILLER_331_0 VPWR VGND sg13cmos5l_decap_8
XFILLER_81_64 VPWR VGND sg13cmos5l_decap_8
XFILLER_347_114 VPWR VGND sg13cmos5l_decap_8
XFILLER_139_272 VPWR VGND sg13cmos5l_fill_1
XFILLER_14_91 VPWR VGND sg13cmos5l_decap_8
XFILLER_303_217 VPWR VGND sg13cmos5l_fill_2
XFILLER_53_7 VPWR VGND sg13cmos5l_decap_8
XFILLER_107_180 VPWR VGND sg13cmos5l_fill_1
X_1400_ _1400_/Q Tile_X0Y5_FrameData[24] VGND VPWR Tile_X0Y5_FrameStrobe[4] latch
XFILLER_216_49 VPWR VGND sg13cmos5l_decap_8
X_2380_ _2380_/X _2263_/X _2396_/X _2395_/X Tile_X0Y0_S2MID[7] _0320_/Q _0319_/Q VPWR
+ VGND sg13cmos5l_mux4_1
XFILLER_122_161 VPWR VGND sg13cmos5l_fill_1
XFILLER_268_154 VPWR VGND sg13cmos5l_fill_1
X_1331_ _1331_/Q Tile_X0Y5_FrameData[29] VGND VPWR Tile_X0Y5_FrameStrobe[2] latch
X_1262_ _1262_/Q Tile_X0Y4_FrameData[24] VGND VPWR Tile_X0Y5_FrameStrobe[7] latch
XFILLER_209_232 VPWR VGND sg13cmos5l_decap_8
XFILLER_283_157 VPWR VGND sg13cmos5l_decap_8
X_0213_ _0213_/Q Tile_X0Y0_FrameData[17] VGND VPWR Tile_X0Y5_FrameStrobe[4] latch
X_1193_ _1193_/Q Tile_X0Y4_FrameData[29] VGND VPWR Tile_X0Y5_FrameStrobe[5] latch
XFILLER_36_112 VPWR VGND sg13cmos5l_decap_8
XANTENNA__1779__X Tile_X0Y2_E2BEG[2] VPWR VGND sg13cmos5l_antennanp
XFILLER_312_70 VPWR VGND sg13cmos5l_decap_8
X_0144_ _0144_/Q Tile_X0Y0_FrameData[22] VGND VPWR Tile_X0Y5_FrameStrobe[2] latch
XFILLER_36_167 VPWR VGND sg13cmos5l_decap_4
X_0075_ _0075_/Q Tile_X0Y0_FrameData[27] VGND VPWR Tile_X0Y5_FrameStrobe[0] latch
XFILLER_51_126 VPWR VGND sg13cmos5l_decap_8
XFILLER_338_147 VPWR VGND sg13cmos5l_decap_4
X_0977_ _0977_/Q Tile_X0Y3_FrameData[5] VGND VPWR Tile_X0Y5_FrameStrobe[5] latch
XFILLER_257_56 VPWR VGND sg13cmos5l_decap_8
X_2716_ _2716_/X Tile_X0Y3_W2MID[4] Tile_X0Y3_W2END[4] Tile_X0Y3_W6END[11] _2592_/X
+ _0884_/Q _0883_/Q VPWR VGND sg13cmos5l_mux4_1
XFILLER_145_264 VPWR VGND sg13cmos5l_fill_1
X_2647_ _2647_/X Tile_X0Y4_WW4END[10] AXIL_S_SOC_WSTRB2 _2705_/X _2709_/X _1160_/Q
+ _1159_/Q VPWR VGND sg13cmos5l_mux4_1
XFILLER_10_49 VPWR VGND sg13cmos5l_decap_8
XFILLER_160_212 VPWR VGND sg13cmos5l_fill_1
XFILLER_160_234 VPWR VGND sg13cmos5l_decap_4
XFILLER_126_49 VPWR VGND sg13cmos5l_decap_8
XFILLER_160_267 VPWR VGND sg13cmos5l_decap_4
X_2578_ _2578_/X _2568_/X Tile_X0Y5_N4END[9] _2567_/X Tile_X0Y0_S4END[13] _0828_/Q
+ _0827_/Q VPWR VGND sg13cmos5l_mux4_1
XFILLER_273_77 VPWR VGND sg13cmos5l_decap_8
XFILLER_302_272 VPWR VGND sg13cmos5l_fill_1
X_1529_ Tile_X0Y3_E6BEG[3] _2544_/X VPWR VGND sg13cmos5l_buf_1
XFILLER_19_14 VPWR VGND sg13cmos5l_decap_8
XFILLER_259_176 VPWR VGND sg13cmos5l_decap_8
XFILLER_59_248 VPWR VGND sg13cmos5l_decap_4
XFILLER_274_135 VPWR VGND sg13cmos5l_fill_2
XFILLER_274_168 VPWR VGND sg13cmos5l_fill_1
XFILLER_215_213 VPWR VGND sg13cmos5l_decap_8
XFILLER_27_112 VPWR VGND sg13cmos5l_decap_8
XANTENNA__1689__X Tile_X0Y0_FrameData_O[29] VPWR VGND sg13cmos5l_antennanp
XFILLER_222_70 VPWR VGND sg13cmos5l_decap_8
XFILLER_230_205 VPWR VGND sg13cmos5l_decap_4
XFILLER_255_7 VPWR VGND sg13cmos5l_decap_8
XFILLER_27_189 VPWR VGND sg13cmos5l_decap_8
XFILLER_42_115 VPWR VGND sg13cmos5l_decap_8
XFILLER_35_35 VPWR VGND sg13cmos5l_decap_8
XFILLER_230_238 VPWR VGND sg13cmos5l_decap_8
XFILLER_298_63 VPWR VGND sg13cmos5l_decap_8
XFILLER_128_209 VPWR VGND sg13cmos5l_decap_8
XFILLER_195_186 VPWR VGND sg13cmos5l_decap_4
XFILLER_51_56 VPWR VGND sg13cmos5l_decap_8
XFILLER_136_220 VPWR VGND sg13cmos5l_decap_4
XFILLER_136_231 VPWR VGND sg13cmos5l_fill_2
XFILLER_167_56 VPWR VGND sg13cmos5l_decap_8
XFILLER_352_161 VPWR VGND sg13cmos5l_decap_8
XFILLER_297_238 VPWR VGND sg13cmos5l_decap_4
XFILLER_104_183 VPWR VGND sg13cmos5l_decap_8
XFILLER_183_77 VPWR VGND sg13cmos5l_decap_8
XFILLER_333_14 VPWR VGND sg13cmos5l_decap_8
XFILLER_76_42 VPWR VGND sg13cmos5l_decap_8
XFILLER_281_0 VPWR VGND sg13cmos5l_decap_8
XFILLER_18_112 VPWR VGND sg13cmos5l_decap_8
XFILLER_280_105 VPWR VGND sg13cmos5l_decap_8
XANTENNA__1599__X Tile_X0Y2_EE4BEG[12] VPWR VGND sg13cmos5l_antennanp
XFILLER_132_70 VPWR VGND sg13cmos5l_decap_8
XFILLER_206_235 VPWR VGND sg13cmos5l_fill_1
XFILLER_73_240 VPWR VGND sg13cmos5l_decap_4
XFILLER_206_257 VPWR VGND sg13cmos5l_fill_2
XFILLER_92_63 VPWR VGND sg13cmos5l_decap_8
X_0900_ _0900_/Q Tile_X0Y3_FrameData[18] VGND VPWR Tile_X0Y5_FrameStrobe[3] latch
X_1880_ Tile_X0Y2_E6BEG[6] _2439_/X VPWR VGND sg13cmos5l_buf_1
XFILLER_335_106 VPWR VGND sg13cmos5l_decap_4
X_0831_ _0831_/Q Tile_X0Y3_FrameData[23] VGND VPWR Tile_X0Y5_FrameStrobe[1] latch
XFILLER_358_77 VPWR VGND sg13cmos5l_decap_8
X_0762_ _0762_/Q Tile_X0Y2_FrameData[12] VGND VPWR Tile_X0Y5_FrameStrobe[6] latch
X_2501_ _2501_/X Tile_X0Y1_W1END[2] Tile_X0Y1_W2MID[1] Tile_X0Y1_W2END[1] _2379_/X
+ _0398_/Q _0397_/Q VPWR VGND sg13cmos5l_mux4_1
X_0693_ _0693_/Q Tile_X0Y2_FrameData[17] VGND VPWR Tile_X0Y5_FrameStrobe[4] latch
XFILLER_142_245 VPWR VGND sg13cmos5l_fill_1
XFILLER_307_70 VPWR VGND sg13cmos5l_decap_8
X_2432_ _2432_/X AXIL_S_SOC_AWADDR1 AXIL_S_SOC_AWADDR3 _2480_/X _2481_/X _0684_/Q
+ _0683_/Q VPWR VGND sg13cmos5l_mux4_1
XFILLER_243_14 VPWR VGND sg13cmos5l_decap_8
X_2363_ _2363_/X Tile_X0Y5_W1END[3] Tile_X0Y5_WW4END[3] Tile_X0Y5_WW4END[9] Tile_X0Y5_W6END[11]
+ _1463_/Q _1462_/Q VPWR VGND sg13cmos5l_mux4_1
XFILLER_296_271 VPWR VGND sg13cmos5l_fill_2
X_1314_ _1314_/Q Tile_X0Y5_FrameData[14] VGND VPWR Tile_X0Y5_FrameStrobe[1] latch
XFILLER_110_153 VPWR VGND sg13cmos5l_decap_8
X_2294_ _2294_/X AXIL_S_SOC_WDATA1 AXIL_S_SOC_WDATA9 _2374_/X _2379_/X _0504_/Q _0503_/Q
+ VPWR VGND sg13cmos5l_mux4_1
XFILLER_323_91 VPWR VGND sg13cmos5l_decap_8
X_1245_ _1245_/Q Tile_X0Y4_FrameData[9] VGND VPWR Tile_X0Y5_FrameStrobe[6] latch
X_1176_ _1176_/Q Tile_X0Y4_FrameData[14] VGND VPWR Tile_X0Y5_FrameStrobe[4] latch
X_0127_ _0127_/Q Tile_X0Y0_FrameData[7] VGND VPWR Tile_X0Y5_FrameStrobe[1] latch
X_0058_ _0058_/X _2811_/X _2812_/X _0386_/Q VPWR VGND sg13cmos5l_mux2_1
XANTENNA_11 AXIL_S_SOC_WDATA10 VPWR VGND sg13cmos5l_antennanp
XANTENNA_22 AXIL_S_SOC_WDATA11 VPWR VGND sg13cmos5l_antennanp
XFILLER_220_260 VPWR VGND sg13cmos5l_fill_1
XANTENNA_33 AXIL_S_SOC_WDATA11 VPWR VGND sg13cmos5l_antennanp
XANTENNA_44 AXIL_S_SOC_WDATA15 VPWR VGND sg13cmos5l_antennanp
XANTENNA_55 AXIL_S_SOC_WDATA16 VPWR VGND sg13cmos5l_antennanp
XANTENNA_66 AXIL_S_SOC_WDATA23 VPWR VGND sg13cmos5l_antennanp
XFILLER_177_175 VPWR VGND sg13cmos5l_decap_4
XFILLER_192_112 VPWR VGND sg13cmos5l_decap_8
XFILLER_268_77 VPWR VGND sg13cmos5l_decap_8
XFILLER_268_88 VPWR VGND sg13cmos5l_fill_1
XANTENNA_77 AXIL_S_SOC_WDATA25 VPWR VGND sg13cmos5l_antennanp
XANTENNA_88 AXIL_S_SOC_WDATA26 VPWR VGND sg13cmos5l_antennanp
XANTENNA_99 AXIL_S_SOC_WDATA26 VPWR VGND sg13cmos5l_antennanp
XANTENNA__2133__X AXIL_S_SOC_RDATA27 VPWR VGND sg13cmos5l_antennanp
XFILLER_192_156 VPWR VGND sg13cmos5l_decap_8
XFILLER_133_201 VPWR VGND sg13cmos5l_decap_4
XFILLER_284_21 VPWR VGND sg13cmos5l_decap_8
XANTENNA__1972__X Tile_X0Y5_E2BEG[1] VPWR VGND sg13cmos5l_antennanp
XFILLER_133_212 VPWR VGND sg13cmos5l_decap_4
XFILLER_133_223 VPWR VGND sg13cmos5l_fill_2
XFILLER_217_70 VPWR VGND sg13cmos5l_decap_8
XFILLER_284_98 VPWR VGND sg13cmos5l_decap_8
XFILLER_153_14 VPWR VGND sg13cmos5l_decap_8
XFILLER_294_219 VPWR VGND sg13cmos5l_decap_8
XFILLER_247_146 VPWR VGND sg13cmos5l_fill_1
XFILLER_247_157 VPWR VGND sg13cmos5l_decap_8
XFILLER_47_218 VPWR VGND sg13cmos5l_decap_8
XFILLER_233_91 VPWR VGND sg13cmos5l_decap_8
XFILLER_262_105 VPWR VGND sg13cmos5l_decap_8
XFILLER_262_116 VPWR VGND sg13cmos5l_fill_2
XFILLER_303_28 VPWR VGND sg13cmos5l_decap_8
XFILLER_15_126 VPWR VGND sg13cmos5l_decap_8
XFILLER_46_78 VPWR VGND sg13cmos5l_decap_8
XFILLER_203_205 VPWR VGND sg13cmos5l_decap_8
XFILLER_102_84 VPWR VGND sg13cmos5l_decap_8
XFILLER_168_142 VPWR VGND sg13cmos5l_decap_8
XFILLER_62_77 VPWR VGND sg13cmos5l_decap_8
XFILLER_168_186 VPWR VGND sg13cmos5l_fill_1
XFILLER_178_77 VPWR VGND sg13cmos5l_decap_8
XFILLER_183_112 VPWR VGND sg13cmos5l_decap_8
XFILLER_328_14 VPWR VGND sg13cmos5l_decap_8
XFILLER_7_28 VPWR VGND sg13cmos5l_decap_8
XANTENNA__2043__X Tile_X0Y5_FrameData_O[28] VPWR VGND sg13cmos5l_antennanp
XFILLER_127_0 VPWR VGND sg13cmos5l_decap_8
XFILLER_109_242 VPWR VGND sg13cmos5l_decap_8
XFILLER_109_253 VPWR VGND sg13cmos5l_fill_1
XFILLER_194_21 VPWR VGND sg13cmos5l_decap_8
XANTENNA__1882__X Tile_X0Y2_E6BEG[8] VPWR VGND sg13cmos5l_antennanp
XFILLER_11_70 VPWR VGND sg13cmos5l_decap_8
XFILLER_127_70 VPWR VGND sg13cmos5l_decap_8
XFILLER_194_98 VPWR VGND sg13cmos5l_decap_4
XFILLER_344_35 VPWR VGND sg13cmos5l_decap_8
XFILLER_87_63 VPWR VGND sg13cmos5l_decap_8
XFILLER_143_80 VPWR VGND sg13cmos5l_decap_8
XFILLER_16_7 VPWR VGND sg13cmos5l_decap_8
XFILLER_213_28 VPWR VGND sg13cmos5l_decap_8
XFILLER_238_168 VPWR VGND sg13cmos5l_decap_8
XFILLER_253_105 VPWR VGND sg13cmos5l_fill_2
X_1030_ _1030_/Q Tile_X0Y3_FrameData[16] VGND VPWR Tile_X0Y5_FrameStrobe[7] latch
XFILLER_261_193 VPWR VGND sg13cmos5l_fill_1
XFILLER_14_192 VPWR VGND sg13cmos5l_decap_4
X_1932_ Tile_X0Y1_EE4BEG[13] _2322_/X VPWR VGND sg13cmos5l_buf_1
XFILLER_348_242 VPWR VGND sg13cmos5l_decap_8
XFILLER_159_175 VPWR VGND sg13cmos5l_decap_8
XFILLER_174_112 VPWR VGND sg13cmos5l_decap_8
XFILLER_238_14 VPWR VGND sg13cmos5l_decap_8
X_1863_ Tile_X0Y4_FrameData_O[30] Tile_X0Y4_FrameData[30] VPWR VGND sg13cmos5l_buf_1
X_0814_ _0814_/Q Tile_X0Y3_FrameData[8] VGND VPWR Tile_X0Y5_FrameStrobe[0] latch
X_1794_ Tile_X0Y4_E2BEG[5] _2622_/X VPWR VGND sg13cmos5l_buf_1
XANTENNA__1792__X Tile_X0Y4_E2BEG[3] VPWR VGND sg13cmos5l_antennanp
XFILLER_115_201 VPWR VGND sg13cmos5l_decap_8
XFILLER_174_189 VPWR VGND sg13cmos5l_fill_2
X_0745_ _0745_/Q Tile_X0Y2_FrameData[29] VGND VPWR Tile_X0Y5_FrameStrobe[6] latch
XFILLER_254_35 VPWR VGND sg13cmos5l_decap_8
XFILLER_318_91 VPWR VGND sg13cmos5l_decap_8
XFILLER_331_120 VPWR VGND sg13cmos5l_decap_8
XFILLER_331_131 VPWR VGND sg13cmos5l_fill_1
X_0676_ _0676_/Q Tile_X0Y2_FrameData[2] VGND VPWR Tile_X0Y5_FrameStrobe[3] latch
XFILLER_42_0 VPWR VGND sg13cmos5l_fill_2
XFILLER_276_208 VPWR VGND sg13cmos5l_decap_8
X_2415_ _2415_/X AXIL_S_SOC_AWADDR0 AXIL_S_SOC_AWADDR6 _2482_/X _2487_/X _0718_/Q
+ _0717_/Q VPWR VGND sg13cmos5l_mux4_1
XFILLER_88_118 VPWR VGND sg13cmos5l_fill_2
XFILLER_88_107 VPWR VGND sg13cmos5l_decap_8
XFILLER_269_271 VPWR VGND sg13cmos5l_fill_2
X_2346_ _2346_/X Tile_X0Y2_W1END[2] Tile_X0Y2_W6END[6] _2467_/X _2455_/X _0786_/Q
+ _0785_/Q VPWR VGND sg13cmos5l_mux4_1
XFILLER_123_28 VPWR VGND sg13cmos5l_decap_8
XFILLER_244_105 VPWR VGND sg13cmos5l_decap_8
X_2277_ _2277_/X Tile_X0Y2_W1END[1] Tile_X0Y2_WW4END[1] Tile_X0Y2_WW4END[5] Tile_X0Y2_W6END[9]
+ _0763_/Q _0762_/Q VPWR VGND sg13cmos5l_mux4_1
XFILLER_270_56 VPWR VGND sg13cmos5l_decap_8
X_1228_ _1228_/Q Tile_X0Y4_FrameData[26] VGND VPWR Tile_X0Y5_FrameStrobe[6] latch
XANTENNA__2128__X AXIL_S_SOC_RDATA22 VPWR VGND sg13cmos5l_antennanp
XFILLER_52_210 VPWR VGND sg13cmos5l_decap_8
XFILLER_279_21 VPWR VGND sg13cmos5l_decap_8
X_1159_ _1159_/Q Tile_X0Y4_FrameData[31] VGND VPWR Tile_X0Y5_FrameStrobe[4] latch
XANTENNA__1967__X Tile_X0Y5_E1BEG[0] VPWR VGND sg13cmos5l_antennanp
XFILLER_197_259 VPWR VGND sg13cmos5l_fill_2
XFILLER_200_208 VPWR VGND sg13cmos5l_decap_8
XFILLER_279_98 VPWR VGND sg13cmos5l_decap_8
XFILLER_148_14 VPWR VGND sg13cmos5l_decap_8
XFILLER_32_14 VPWR VGND sg13cmos5l_decap_8
XFILLER_120_7 VPWR VGND sg13cmos5l_decap_8
XFILLER_165_134 VPWR VGND sg13cmos5l_decap_8
XFILLER_295_42 VPWR VGND sg13cmos5l_decap_8
XFILLER_218_7 VPWR VGND sg13cmos5l_decap_8
XFILLER_354_245 VPWR VGND sg13cmos5l_decap_4
XFILLER_180_126 VPWR VGND sg13cmos5l_decap_8
XFILLER_307_161 VPWR VGND sg13cmos5l_decap_8
XFILLER_106_256 VPWR VGND sg13cmos5l_fill_2
XFILLER_228_91 VPWR VGND sg13cmos5l_decap_8
XFILLER_164_35 VPWR VGND sg13cmos5l_decap_8
XFILLER_314_49 VPWR VGND sg13cmos5l_decap_8
XFILLER_235_105 VPWR VGND sg13cmos5l_decap_8
XFILLER_87_184 VPWR VGND sg13cmos5l_decap_8
XFILLER_57_77 VPWR VGND sg13cmos5l_decap_8
XFILLER_180_56 VPWR VGND sg13cmos5l_decap_8
XANTENNA__2038__X Tile_X0Y5_FrameData_O[23] VPWR VGND sg13cmos5l_antennanp
XFILLER_73_21 VPWR VGND sg13cmos5l_decap_8
XFILLER_189_21 VPWR VGND sg13cmos5l_decap_8
XFILLER_43_221 VPWR VGND sg13cmos5l_decap_8
XANTENNA__1877__X Tile_X0Y2_E6BEG[3] VPWR VGND sg13cmos5l_antennanp
XFILLER_188_226 VPWR VGND sg13cmos5l_decap_8
XFILLER_243_182 VPWR VGND sg13cmos5l_decap_8
XFILLER_73_98 VPWR VGND sg13cmos5l_decap_8
XFILLER_189_98 VPWR VGND sg13cmos5l_decap_8
XFILLER_244_0 VPWR VGND sg13cmos5l_decap_8
XFILLER_11_140 VPWR VGND sg13cmos5l_decap_8
XFILLER_339_35 VPWR VGND sg13cmos5l_decap_8
XFILLER_156_112 VPWR VGND sg13cmos5l_decap_8
XFILLER_345_245 VPWR VGND sg13cmos5l_fill_1
XFILLER_171_126 VPWR VGND sg13cmos5l_decap_4
XFILLER_171_137 VPWR VGND sg13cmos5l_decap_8
XFILLER_208_28 VPWR VGND sg13cmos5l_decap_8
XFILLER_22_91 VPWR VGND sg13cmos5l_decap_8
XFILLER_360_204 VPWR VGND sg13cmos5l_decap_8
XFILLER_138_91 VPWR VGND sg13cmos5l_decap_8
X_0530_ _0530_/Q Tile_X0Y1_FrameData[4] VGND VPWR Tile_X0Y5_FrameStrobe[6] latch
XFILLER_355_56 VPWR VGND sg13cmos5l_decap_8
XFILLER_98_84 VPWR VGND sg13cmos5l_decap_8
X_2200_ _2200_/X _0065_/X Tile_X0Y0_S4END[3] _2230_/X _2229_/X _0196_/Q _0195_/Q VPWR
+ VGND sg13cmos5l_mux4_1
X_0461_ _0461_/Q Tile_X0Y1_FrameData[9] VGND VPWR Tile_X0Y5_FrameStrobe[4] latch
XFILLER_224_49 VPWR VGND sg13cmos5l_decap_8
X_0392_ _0392_/Q Tile_X0Y1_FrameData[14] VGND VPWR Tile_X0Y5_FrameStrobe[2] latch
X_2131_ AXIL_S_SOC_RDATA25 Tile_X0Y0_W2MID[1] Tile_X0Y0_W2END[1] Tile_X0Y0_W6END[1]
+ _2242_/X _0140_/Q _0139_/Q VPWR VGND sg13cmos5l_mux4_1
XFILLER_226_127 VPWR VGND sg13cmos5l_decap_8
X_2062_ Tile_X0Y5_S2BEGb[3] _2832_/X VPWR VGND sg13cmos5l_buf_1
XFILLER_93_143 VPWR VGND sg13cmos5l_decap_8
XFILLER_281_244 VPWR VGND sg13cmos5l_decap_8
X_1013_ _1013_/Q Tile_X0Y3_FrameData[1] VGND VPWR Tile_X0Y5_FrameStrobe[6] latch
XFILLER_241_119 VPWR VGND sg13cmos5l_decap_8
XANTENNA__1787__X Tile_X0Y4_E1BEG[2] VPWR VGND sg13cmos5l_antennanp
XFILLER_179_215 VPWR VGND sg13cmos5l_decap_8
XFILLER_320_70 VPWR VGND sg13cmos5l_decap_8
XFILLER_179_259 VPWR VGND sg13cmos5l_fill_1
XFILLER_249_35 VPWR VGND sg13cmos5l_decap_8
X_1915_ Tile_X0Y1_FrameData_O[28] Tile_X0Y1_FrameData[28] VPWR VGND sg13cmos5l_buf_1
XFILLER_147_134 VPWR VGND sg13cmos5l_decap_8
X_1846_ Tile_X0Y4_FrameData_O[13] Tile_X0Y4_FrameData[13] VPWR VGND sg13cmos5l_buf_1
XFILLER_118_28 VPWR VGND sg13cmos5l_decap_8
XFILLER_162_126 VPWR VGND sg13cmos5l_decap_8
X_1777_ Tile_X0Y2_E2BEG[0] _2401_/X VPWR VGND sg13cmos5l_buf_1
XFILLER_351_226 VPWR VGND sg13cmos5l_decap_8
XFILLER_265_56 VPWR VGND sg13cmos5l_decap_8
X_0728_ _0728_/Q Tile_X0Y2_FrameData[14] VGND VPWR Tile_X0Y5_FrameStrobe[5] latch
XFILLER_351_237 VPWR VGND sg13cmos5l_fill_2
XFILLER_304_175 VPWR VGND sg13cmos5l_decap_8
XFILLER_103_237 VPWR VGND sg13cmos5l_decap_8
X_0659_ _0659_/Q Tile_X0Y2_FrameData[19] VGND VPWR Tile_X0Y5_FrameStrobe[3] latch
XFILLER_134_49 VPWR VGND sg13cmos5l_decap_8
XFILLER_69_151 VPWR VGND sg13cmos5l_fill_1
XFILLER_69_140 VPWR VGND sg13cmos5l_decap_8
XFILLER_217_105 VPWR VGND sg13cmos5l_decap_8
XFILLER_281_77 VPWR VGND sg13cmos5l_decap_8
X_2329_ _2329_/X AXIL_S_SOC_WDATA4 _2365_/X _2350_/X _2373_/X _0434_/Q _0433_/Q VPWR
+ VGND sg13cmos5l_mux4_1
XFILLER_27_14 VPWR VGND sg13cmos5l_decap_8
XFILLER_168_7 VPWR VGND sg13cmos5l_decap_8
XFILLER_232_119 VPWR VGND sg13cmos5l_decap_8
XFILLER_225_193 VPWR VGND sg13cmos5l_decap_8
XFILLER_230_70 VPWR VGND sg13cmos5l_decap_8
XFILLER_342_8 VPWR VGND sg13cmos5l_decap_8
XANTENNA__1697__X Tile_X0Y0_EE4BEG[5] VPWR VGND sg13cmos5l_antennanp
XFILLER_335_7 VPWR VGND sg13cmos5l_decap_8
XFILLER_43_35 VPWR VGND sg13cmos5l_decap_8
XFILLER_159_35 VPWR VGND sg13cmos5l_decap_8
XFILLER_240_196 VPWR VGND sg13cmos5l_decap_8
XFILLER_138_112 VPWR VGND sg13cmos5l_decap_8
XFILLER_309_49 VPWR VGND sg13cmos5l_decap_8
XFILLER_299_119 VPWR VGND sg13cmos5l_decap_8
XFILLER_342_226 VPWR VGND sg13cmos5l_fill_1
XFILLER_175_56 VPWR VGND sg13cmos5l_decap_8
XFILLER_4_136 VPWR VGND sg13cmos5l_fill_1
XFILLER_342_237 VPWR VGND sg13cmos5l_fill_1
XFILLER_310_112 VPWR VGND sg13cmos5l_decap_8
XFILLER_68_21 VPWR VGND sg13cmos5l_decap_8
XFILLER_102_270 VPWR VGND sg13cmos5l_fill_2
XFILLER_191_77 VPWR VGND sg13cmos5l_decap_8
XFILLER_194_0 VPWR VGND sg13cmos5l_decap_8
XFILLER_68_98 VPWR VGND sg13cmos5l_decap_8
XFILLER_341_14 VPWR VGND sg13cmos5l_decap_8
XFILLER_208_105 VPWR VGND sg13cmos5l_decap_4
XFILLER_263_211 VPWR VGND sg13cmos5l_decap_4
XFILLER_84_42 VPWR VGND sg13cmos5l_decap_8
XFILLER_361_0 VPWR VGND sg13cmos5l_fill_2
XFILLER_90_124 VPWR VGND sg13cmos5l_fill_2
XFILLER_140_70 VPWR VGND sg13cmos5l_decap_8
XFILLER_17_91 VPWR VGND sg13cmos5l_decap_8
XFILLER_90_8 VPWR VGND sg13cmos5l_decap_8
XFILLER_129_112 VPWR VGND sg13cmos5l_decap_8
XFILLER_83_7 VPWR VGND sg13cmos5l_decap_8
XFILLER_219_49 VPWR VGND sg13cmos5l_decap_8
X_1700_ Tile_X0Y0_EE4BEG[8] _2189_/X VPWR VGND sg13cmos5l_buf_1
X_2680_ _2680_/X Tile_X0Y5_W1END[3] Tile_X0Y5_W6END[7] _2801_/X _2792_/X _1490_/Q
+ _1489_/Q VPWR VGND sg13cmos5l_mux4_1
X_1631_ Tile_X0Y0_N2BEG[3] _2148_/X VPWR VGND sg13cmos5l_buf_1
X_1562_ Tile_X0Y3_FrameData_O[8] Tile_X0Y3_FrameData[8] VPWR VGND sg13cmos5l_buf_1
XFILLER_98_213 VPWR VGND sg13cmos5l_fill_1
XFILLER_301_112 VPWR VGND sg13cmos5l_decap_8
X_1493_ _1493_/Q Tile_X0Y5_FrameData[27] VGND VPWR Tile_X0Y5_FrameStrobe[7] latch
X_0513_ _0513_/Q Tile_X0Y1_FrameData[21] VGND VPWR Tile_X0Y5_FrameStrobe[6] latch
XFILLER_98_235 VPWR VGND sg13cmos5l_decap_8
XFILLER_298_196 VPWR VGND sg13cmos5l_decap_8
X_0444_ _0444_/Q Tile_X0Y1_FrameData[26] VGND VPWR Tile_X0Y5_FrameStrobe[4] latch
XFILLER_251_14 VPWR VGND sg13cmos5l_decap_8
XFILLER_301_189 VPWR VGND sg13cmos5l_decap_8
XFILLER_315_70 VPWR VGND sg13cmos5l_decap_8
XFILLER_254_211 VPWR VGND sg13cmos5l_decap_4
X_2114_ AXIL_S_SOC_RDATA8 Tile_X0Y2_W2MID[0] Tile_X0Y2_W2END[0] Tile_X0Y2_W6END[0]
+ _2481_/X _0622_/Q _0621_/Q VPWR VGND sg13cmos5l_mux4_1
X_0375_ _0375_/Q Tile_X0Y1_FrameData[31] VGND VPWR Tile_X0Y5_FrameStrobe[2] latch
XFILLER_66_176 VPWR VGND sg13cmos5l_decap_8
XFILLER_207_160 VPWR VGND sg13cmos5l_decap_8
XFILLER_214_119 VPWR VGND sg13cmos5l_decap_8
X_2045_ Tile_X0Y5_FrameData_O[30] Tile_X0Y5_FrameData[30] VPWR VGND sg13cmos5l_buf_1
XFILLER_81_135 VPWR VGND sg13cmos5l_decap_4
XFILLER_331_91 VPWR VGND sg13cmos5l_decap_4
XFILLER_222_152 VPWR VGND sg13cmos5l_decap_8
XFILLER_167_229 VPWR VGND sg13cmos5l_decap_8
XFILLER_200_84 VPWR VGND sg13cmos5l_fill_2
XFILLER_129_49 VPWR VGND sg13cmos5l_decap_8
XFILLER_13_49 VPWR VGND sg13cmos5l_decap_8
XFILLER_135_115 VPWR VGND sg13cmos5l_fill_1
XFILLER_276_77 VPWR VGND sg13cmos5l_decap_8
X_1829_ Tile_X0Y4_EE4BEG[12] _2645_/X VPWR VGND sg13cmos5l_buf_1
XFILLER_292_21 VPWR VGND sg13cmos5l_decap_8
XANTENNA__1980__X Tile_X0Y5_E2BEGb[1] VPWR VGND sg13cmos5l_antennanp
XFILLER_292_98 VPWR VGND sg13cmos5l_decap_8
XFILLER_161_14 VPWR VGND sg13cmos5l_decap_8
XFILLER_225_70 VPWR VGND sg13cmos5l_decap_8
XFILLER_38_35 VPWR VGND sg13cmos5l_decap_8
XFILLER_245_222 VPWR VGND sg13cmos5l_fill_2
XFILLER_285_7 VPWR VGND sg13cmos5l_decap_8
XFILLER_57_154 VPWR VGND sg13cmos5l_decap_8
XANTENNA_304 AXIL_S_SOC_WDATA19 VPWR VGND sg13cmos5l_antennanp
XANTENNA_315 Tile_X0Y0_FrameData[23] VPWR VGND sg13cmos5l_antennanp
XFILLER_311_28 VPWR VGND sg13cmos5l_decap_8
XFILLER_241_91 VPWR VGND sg13cmos5l_decap_8
XFILLER_260_225 VPWR VGND sg13cmos5l_fill_1
XFILLER_72_157 VPWR VGND sg13cmos5l_decap_8
XFILLER_54_56 VPWR VGND sg13cmos5l_decap_8
XFILLER_359_112 VPWR VGND sg13cmos5l_decap_8
XFILLER_13_257 VPWR VGND sg13cmos5l_fill_2
XFILLER_158_218 VPWR VGND sg13cmos5l_decap_8
XFILLER_110_84 VPWR VGND sg13cmos5l_decap_8
XFILLER_359_189 VPWR VGND sg13cmos5l_decap_8
XFILLER_70_77 VPWR VGND sg13cmos5l_decap_8
XFILLER_126_126 VPWR VGND sg13cmos5l_decap_8
XFILLER_186_77 VPWR VGND sg13cmos5l_decap_8
XANTENNA__2051__X Tile_X0Y5_S2BEG[0] VPWR VGND sg13cmos5l_antennanp
XFILLER_207_0 VPWR VGND sg13cmos5l_decap_8
XFILLER_336_14 VPWR VGND sg13cmos5l_decap_8
XFILLER_79_42 VPWR VGND sg13cmos5l_decap_8
XANTENNA__1890__X Tile_X0Y1_FrameData_O[3] VPWR VGND sg13cmos5l_antennanp
XFILLER_134_181 VPWR VGND sg13cmos5l_decap_8
XFILLER_141_129 VPWR VGND sg13cmos5l_fill_2
XFILLER_295_133 VPWR VGND sg13cmos5l_decap_8
XFILLER_135_70 VPWR VGND sg13cmos5l_decap_8
XFILLER_352_35 VPWR VGND sg13cmos5l_decap_8
XFILLER_95_63 VPWR VGND sg13cmos5l_decap_8
XFILLER_236_255 VPWR VGND sg13cmos5l_decap_4
X_0160_ _0160_/Q Tile_X0Y0_FrameData[6] VGND VPWR Tile_X0Y5_FrameStrobe[2] latch
XFILLER_48_165 VPWR VGND sg13cmos5l_decap_8
XFILLER_221_28 VPWR VGND sg13cmos5l_decap_8
X_0091_ _0091_/Q Tile_X0Y0_FrameData[11] VGND VPWR Tile_X0Y5_FrameStrobe[0] latch
XFILLER_151_91 VPWR VGND sg13cmos5l_decap_8
XFILLER_63_168 VPWR VGND sg13cmos5l_fill_1
XFILLER_204_174 VPWR VGND sg13cmos5l_decap_8
X_2801_ _2801_/X Tile_X0Y5_N1END[3] Tile_X0Y5_N4END[3] _2796_/X _0057_/X _1290_/Q
+ _1289_/Q VPWR VGND sg13cmos5l_mux4_1
X_0993_ _0993_/Q Tile_X0Y3_FrameData[21] VGND VPWR Tile_X0Y5_FrameStrobe[6] latch
XFILLER_81_4 VPWR VGND sg13cmos5l_fill_1
X_2732_ _2732_/X AXIL_S_SOC_ARPROT0 AXIL_S_SOC_ARPROT2 _2825_/X _2797_/X _1438_/Q
+ _1437_/Q VPWR VGND sg13cmos5l_mux4_1
XFILLER_117_126 VPWR VGND sg13cmos5l_decap_8
XFILLER_172_254 VPWR VGND sg13cmos5l_fill_1
XFILLER_246_14 VPWR VGND sg13cmos5l_decap_8
XFILLER_306_237 VPWR VGND sg13cmos5l_decap_4
X_2663_ _2663_/X Tile_X0Y4_W1END[1] Tile_X0Y4_WW4END[13] Tile_X0Y4_W6END[5] _2705_/X
+ _1105_/Q _1104_/Q VPWR VGND sg13cmos5l_mux4_1
XFILLER_321_207 VPWR VGND sg13cmos5l_fill_2
X_1614_ Tile_X0Y0_N4BEG[10] _1614_/A VPWR VGND sg13cmos5l_buf_1
X_2594_ _2594_/X _2500_/X _2608_/X _2607_/X _2499_/X _0804_/Q _0803_/Q VPWR VGND sg13cmos5l_mux4_1
X_1545_ Tile_X0Y3_EE4BEG[7] _2532_/X VPWR VGND sg13cmos5l_buf_1
XFILLER_326_91 VPWR VGND sg13cmos5l_decap_8
XFILLER_262_35 VPWR VGND sg13cmos5l_decap_8
XFILLER_286_155 VPWR VGND sg13cmos5l_decap_8
X_1476_ _1476_/Q Tile_X0Y5_FrameData[12] VGND VPWR Tile_X0Y5_FrameStrobe[6] latch
XFILLER_286_199 VPWR VGND sg13cmos5l_decap_4
X_0427_ _0427_/Q Tile_X0Y1_FrameData[11] VGND VPWR Tile_X0Y5_FrameStrobe[3] latch
X_0358_ _0358_/Q Tile_X0Y1_FrameData[16] VGND VPWR Tile_X0Y5_FrameStrobe[1] latch
XFILLER_94_271 VPWR VGND sg13cmos5l_fill_2
XFILLER_131_28 VPWR VGND sg13cmos5l_decap_8
XFILLER_242_203 VPWR VGND sg13cmos5l_decap_8
X_2028_ Tile_X0Y5_FrameData_O[13] Tile_X0Y5_FrameData[13] VPWR VGND sg13cmos5l_buf_1
X_0289_ _0289_/Q Tile_X0Y0_FrameData[5] VGND VPWR Tile_X0Y5_FrameStrobe[6] latch
XFILLER_54_168 VPWR VGND sg13cmos5l_decap_8
XANTENNA__2136__X AXIL_S_SOC_RDATA30 VPWR VGND sg13cmos5l_antennanp
XFILLER_287_21 VPWR VGND sg13cmos5l_decap_8
XFILLER_356_126 VPWR VGND sg13cmos5l_decap_8
XANTENNA__1975__X Tile_X0Y5_E2BEG[4] VPWR VGND sg13cmos5l_antennanp
XFILLER_210_199 VPWR VGND sg13cmos5l_fill_1
XFILLER_287_98 VPWR VGND sg13cmos5l_decap_8
XFILLER_40_14 VPWR VGND sg13cmos5l_decap_8
XFILLER_156_14 VPWR VGND sg13cmos5l_decap_8
XFILLER_163_221 VPWR VGND sg13cmos5l_decap_8
XFILLER_200_7 VPWR VGND sg13cmos5l_decap_8
XFILLER_306_28 VPWR VGND sg13cmos5l_decap_8
XFILLER_236_91 VPWR VGND sg13cmos5l_decap_8
XFILLER_131_173 VPWR VGND sg13cmos5l_decap_4
XFILLER_172_35 VPWR VGND sg13cmos5l_decap_8
XFILLER_49_56 VPWR VGND sg13cmos5l_decap_8
XFILLER_277_188 VPWR VGND sg13cmos5l_decap_8
XFILLER_105_84 VPWR VGND sg13cmos5l_decap_8
XFILLER_292_158 VPWR VGND sg13cmos5l_decap_8
XFILLER_322_49 VPWR VGND sg13cmos5l_decap_8
XANTENNA_101 AXIL_S_SOC_WDATA26 VPWR VGND sg13cmos5l_antennanp
XANTENNA_112 AXIL_S_SOC_WDATA27 VPWR VGND sg13cmos5l_antennanp
XANTENNA_123 AXIL_S_SOC_WDATA29 VPWR VGND sg13cmos5l_antennanp
XANTENNA_134 AXIL_S_SOC_WDATA29 VPWR VGND sg13cmos5l_antennanp
XFILLER_65_77 VPWR VGND sg13cmos5l_decap_8
XANTENNA_145 AXIL_S_SOC_WDATA30 VPWR VGND sg13cmos5l_antennanp
XANTENNA_156 AXIL_S_SOC_WDATA31 VPWR VGND sg13cmos5l_antennanp
XANTENNA_167 AXIL_S_SOC_WDATA8 VPWR VGND sg13cmos5l_antennanp
XFILLER_60_105 VPWR VGND sg13cmos5l_decap_8
XANTENNA_178 AXIL_S_SOC_WDATA8 VPWR VGND sg13cmos5l_antennanp
XANTENNA_189 AXIL_S_SOC_WDATA9 VPWR VGND sg13cmos5l_antennanp
XANTENNA__2046__X Tile_X0Y5_FrameData_O[31] VPWR VGND sg13cmos5l_antennanp
XFILLER_157_0 VPWR VGND sg13cmos5l_decap_8
XFILLER_198_140 VPWR VGND sg13cmos5l_decap_8
XFILLER_201_111 VPWR VGND sg13cmos5l_decap_4
XFILLER_81_43 VPWR VGND sg13cmos5l_decap_8
XFILLER_197_21 VPWR VGND sg13cmos5l_decap_8
XANTENNA__1885__X Tile_X0Y2_E6BEG[11] VPWR VGND sg13cmos5l_antennanp
XFILLER_14_70 VPWR VGND sg13cmos5l_decap_8
XFILLER_324_0 VPWR VGND sg13cmos5l_decap_8
XFILLER_197_98 VPWR VGND sg13cmos5l_decap_8
XFILLER_201_199 VPWR VGND sg13cmos5l_fill_1
XFILLER_362_129 VPWR VGND sg13cmos5l_decap_8
XFILLER_347_79 VPWR VGND sg13cmos5l_decap_8
XFILLER_347_68 VPWR VGND sg13cmos5l_fill_1
XFILLER_347_57 VPWR VGND sg13cmos5l_decap_8
XFILLER_216_28 VPWR VGND sg13cmos5l_decap_8
XFILLER_30_91 VPWR VGND sg13cmos5l_decap_8
XFILLER_122_140 VPWR VGND sg13cmos5l_decap_8
X_1330_ _1330_/Q Tile_X0Y5_FrameData[30] VGND VPWR Tile_X0Y5_FrameStrobe[2] latch
XFILLER_268_166 VPWR VGND sg13cmos5l_fill_2
X_1261_ _1261_/Q Tile_X0Y4_FrameData[25] VGND VPWR Tile_X0Y5_FrameStrobe[7] latch
XFILLER_232_49 VPWR VGND sg13cmos5l_decap_8
X_1192_ _1192_/Q Tile_X0Y4_FrameData[30] VGND VPWR Tile_X0Y5_FrameStrobe[5] latch
X_0212_ _0212_/Q Tile_X0Y0_FrameData[18] VGND VPWR Tile_X0Y5_FrameStrobe[4] latch
X_0143_ _0143_/Q Tile_X0Y0_FrameData[23] VGND VPWR Tile_X0Y5_FrameStrobe[2] latch
XFILLER_224_225 VPWR VGND sg13cmos5l_decap_8
X_0074_ _0074_/Q Tile_X0Y0_FrameData[28] VGND VPWR Tile_X0Y5_FrameStrobe[0] latch
XFILLER_51_105 VPWR VGND sg13cmos5l_decap_8
XFILLER_44_190 VPWR VGND sg13cmos5l_decap_8
XANTENNA__1795__X Tile_X0Y4_E2BEG[6] VPWR VGND sg13cmos5l_antennanp
XFILLER_257_35 VPWR VGND sg13cmos5l_decap_8
X_0976_ _0976_/Q Tile_X0Y3_FrameData[6] VGND VPWR Tile_X0Y5_FrameStrobe[5] latch
XFILLER_72_0 VPWR VGND sg13cmos5l_decap_8
XFILLER_145_243 VPWR VGND sg13cmos5l_decap_8
X_2715_ _2715_/X Tile_X0Y3_W2MID[5] Tile_X0Y3_W2END[5] Tile_X0Y3_W6END[10] _2591_/X
+ _0886_/Q _0885_/Q VPWR VGND sg13cmos5l_mux4_1
XFILLER_10_28 VPWR VGND sg13cmos5l_decap_8
X_2646_ _2646_/X Tile_X0Y4_WW4END[9] AXIL_S_SOC_WSTRB1 _2703_/X _2710_/X _1162_/Q
+ _1161_/Q VPWR VGND sg13cmos5l_mux4_1
XFILLER_105_118 VPWR VGND sg13cmos5l_fill_1
XFILLER_126_28 VPWR VGND sg13cmos5l_decap_8
XFILLER_361_195 VPWR VGND sg13cmos5l_decap_4
XFILLER_113_140 VPWR VGND sg13cmos5l_decap_8
XFILLER_273_56 VPWR VGND sg13cmos5l_decap_8
X_2577_ _2577_/X _2568_/X Tile_X0Y5_N4END[9] _2567_/X Tile_X0Y0_S4END[13] _0820_/Q
+ _0819_/Q VPWR VGND sg13cmos5l_mux4_1
XFILLER_259_133 VPWR VGND sg13cmos5l_fill_1
XFILLER_302_251 VPWR VGND sg13cmos5l_decap_8
X_1528_ Tile_X0Y3_E6BEG[2] _2543_/X VPWR VGND sg13cmos5l_buf_1
XFILLER_59_227 VPWR VGND sg13cmos5l_decap_8
X_1459_ _1459_/Q Tile_X0Y5_FrameData[29] VGND VPWR Tile_X0Y5_FrameStrobe[6] latch
XFILLER_142_49 VPWR VGND sg13cmos5l_decap_8
XFILLER_82_241 VPWR VGND sg13cmos5l_decap_4
XFILLER_35_14 VPWR VGND sg13cmos5l_decap_8
XFILLER_150_7 VPWR VGND sg13cmos5l_decap_8
XFILLER_230_217 VPWR VGND sg13cmos5l_decap_8
XFILLER_248_7 VPWR VGND sg13cmos5l_decap_8
XFILLER_298_42 VPWR VGND sg13cmos5l_decap_8
XFILLER_195_132 VPWR VGND sg13cmos5l_decap_8
XFILLER_195_143 VPWR VGND sg13cmos5l_fill_2
XFILLER_51_35 VPWR VGND sg13cmos5l_decap_8
XFILLER_50_182 VPWR VGND sg13cmos5l_decap_8
XFILLER_167_35 VPWR VGND sg13cmos5l_decap_8
XFILLER_195_198 VPWR VGND sg13cmos5l_decap_4
XFILLER_352_140 VPWR VGND sg13cmos5l_decap_8
XFILLER_151_235 VPWR VGND sg13cmos5l_fill_1
XFILLER_297_217 VPWR VGND sg13cmos5l_decap_8
XFILLER_317_49 VPWR VGND sg13cmos5l_decap_8
XFILLER_183_56 VPWR VGND sg13cmos5l_decap_8
XFILLER_76_21 VPWR VGND sg13cmos5l_decap_8
XFILLER_65_208 VPWR VGND sg13cmos5l_fill_1
XFILLER_274_0 VPWR VGND sg13cmos5l_decap_8
XFILLER_76_98 VPWR VGND sg13cmos5l_decap_8
XFILLER_92_42 VPWR VGND sg13cmos5l_decap_8
XFILLER_33_127 VPWR VGND sg13cmos5l_decap_8
XFILLER_221_228 VPWR VGND sg13cmos5l_decap_4
XFILLER_33_138 VPWR VGND sg13cmos5l_fill_2
XFILLER_25_91 VPWR VGND sg13cmos5l_decap_8
XFILLER_358_56 VPWR VGND sg13cmos5l_decap_8
X_0830_ _0830_/Q Tile_X0Y3_FrameData[24] VGND VPWR Tile_X0Y5_FrameStrobe[1] latch
XFILLER_127_232 VPWR VGND sg13cmos5l_fill_2
XFILLER_328_170 VPWR VGND sg13cmos5l_fill_2
X_0761_ _0761_/Q Tile_X0Y2_FrameData[13] VGND VPWR Tile_X0Y5_FrameStrobe[6] latch
X_2500_ _2500_/X Tile_X0Y4_W2MID[2] Tile_X0Y4_W2END[2] Tile_X0Y4_W6END[2] _2683_/X
+ _1246_/Q _1245_/Q VPWR VGND sg13cmos5l_mux4_1
XFILLER_142_202 VPWR VGND sg13cmos5l_decap_8
XFILLER_227_49 VPWR VGND sg13cmos5l_decap_8
X_2431_ _2431_/X AXIL_S_SOC_AWADDR0 AXIL_S_SOC_AWADDR2 _2478_/X _2482_/X _0686_/Q
+ _0685_/Q VPWR VGND sg13cmos5l_mux4_1
X_0692_ _0692_/Q Tile_X0Y2_FrameData[18] VGND VPWR Tile_X0Y5_FrameStrobe[4] latch
X_2362_ _2362_/X _2342_/X _0063_/X _2341_/X Tile_X0Y0_S4END[4] _0350_/Q _0349_/Q VPWR
+ VGND sg13cmos5l_mux4_1
X_1313_ _1313_/Q Tile_X0Y5_FrameData[15] VGND VPWR Tile_X0Y5_FrameStrobe[1] latch
X_2293_ _2293_/X AXIL_S_SOC_WDATA0 AXIL_S_SOC_WDATA8 _2373_/X _2380_/X _0506_/Q _0505_/Q
+ VPWR VGND sg13cmos5l_mux4_1
XFILLER_256_147 VPWR VGND sg13cmos5l_decap_4
XFILLER_256_158 VPWR VGND sg13cmos5l_decap_4
X_1244_ _1244_/Q Tile_X0Y4_FrameData[10] VGND VPWR Tile_X0Y5_FrameStrobe[6] latch
XFILLER_110_187 VPWR VGND sg13cmos5l_fill_1
XFILLER_271_117 VPWR VGND sg13cmos5l_decap_8
XFILLER_2_84 VPWR VGND sg13cmos5l_decap_8
XFILLER_323_70 VPWR VGND sg13cmos5l_decap_8
XFILLER_49_271 VPWR VGND sg13cmos5l_fill_2
X_1175_ _1175_/Q Tile_X0Y4_FrameData[15] VGND VPWR Tile_X0Y5_FrameStrobe[4] latch
XFILLER_24_105 VPWR VGND sg13cmos5l_decap_8
XFILLER_264_191 VPWR VGND sg13cmos5l_fill_2
X_0126_ _0126_/Q Tile_X0Y0_FrameData[8] VGND VPWR Tile_X0Y5_FrameStrobe[1] latch
X_0057_ _0057_/X _2815_/X _2816_/X _0383_/Q VPWR VGND sg13cmos5l_mux2_1
XANTENNA_12 AXIL_S_SOC_WDATA10 VPWR VGND sg13cmos5l_antennanp
XANTENNA_23 AXIL_S_SOC_WDATA11 VPWR VGND sg13cmos5l_antennanp
XFILLER_177_154 VPWR VGND sg13cmos5l_decap_8
XFILLER_268_56 VPWR VGND sg13cmos5l_decap_8
XANTENNA_34 AXIL_S_SOC_WDATA11 VPWR VGND sg13cmos5l_antennanp
XANTENNA_45 AXIL_S_SOC_WDATA15 VPWR VGND sg13cmos5l_antennanp
XANTENNA_56 AXIL_S_SOC_WDATA16 VPWR VGND sg13cmos5l_antennanp
XFILLER_220_272 VPWR VGND sg13cmos5l_fill_1
XANTENNA_67 AXIL_S_SOC_WDATA23 VPWR VGND sg13cmos5l_antennanp
XANTENNA_78 AXIL_S_SOC_WDATA25 VPWR VGND sg13cmos5l_antennanp
XANTENNA_89 AXIL_S_SOC_WDATA26 VPWR VGND sg13cmos5l_antennanp
XFILLER_118_210 VPWR VGND sg13cmos5l_decap_8
XFILLER_118_243 VPWR VGND sg13cmos5l_fill_1
XFILLER_21_49 VPWR VGND sg13cmos5l_decap_8
X_0959_ _0959_/Q Tile_X0Y3_FrameData[23] VGND VPWR Tile_X0Y5_FrameStrobe[5] latch
XFILLER_137_49 VPWR VGND sg13cmos5l_decap_8
XFILLER_284_77 VPWR VGND sg13cmos5l_decap_8
X_2629_ _2629_/X AXIL_S_SOC_WSTRB0 AXIL_S_SOC_WVALID _2711_/X _2712_/X _1196_/Q _1195_/Q
+ VPWR VGND sg13cmos5l_mux4_1
XFILLER_287_272 VPWR VGND sg13cmos5l_fill_1
XFILLER_101_154 VPWR VGND sg13cmos5l_decap_8
XFILLER_101_165 VPWR VGND sg13cmos5l_fill_1
XFILLER_198_7 VPWR VGND sg13cmos5l_decap_8
XFILLER_101_187 VPWR VGND sg13cmos5l_decap_8
XFILLER_233_70 VPWR VGND sg13cmos5l_decap_8
XFILLER_46_57 VPWR VGND sg13cmos5l_decap_8
XFILLER_15_105 VPWR VGND sg13cmos5l_decap_8
XFILLER_102_63 VPWR VGND sg13cmos5l_decap_8
XFILLER_30_119 VPWR VGND sg13cmos5l_decap_4
XFILLER_357_210 VPWR VGND sg13cmos5l_decap_8
XFILLER_62_56 VPWR VGND sg13cmos5l_decap_8
XFILLER_178_56 VPWR VGND sg13cmos5l_decap_8
XFILLER_211_272 VPWR VGND sg13cmos5l_fill_1
XFILLER_109_221 VPWR VGND sg13cmos5l_decap_8
XFILLER_168_198 VPWR VGND sg13cmos5l_decap_8
XFILLER_325_173 VPWR VGND sg13cmos5l_fill_2
XFILLER_194_77 VPWR VGND sg13cmos5l_decap_8
XFILLER_2_0 VPWR VGND sg13cmos5l_decap_8
XFILLER_344_14 VPWR VGND sg13cmos5l_decap_8
XFILLER_285_209 VPWR VGND sg13cmos5l_decap_8
XFILLER_97_119 VPWR VGND sg13cmos5l_decap_8
XFILLER_87_42 VPWR VGND sg13cmos5l_decap_8
XFILLER_278_272 VPWR VGND sg13cmos5l_fill_1
XFILLER_340_198 VPWR VGND sg13cmos5l_fill_1
XFILLER_238_147 VPWR VGND sg13cmos5l_decap_8
XFILLER_143_70 VPWR VGND sg13cmos5l_fill_2
XFILLER_293_253 VPWR VGND sg13cmos5l_decap_4
XFILLER_360_35 VPWR VGND sg13cmos5l_decap_8
XFILLER_360_57 VPWR VGND sg13cmos5l_decap_8
XFILLER_246_191 VPWR VGND sg13cmos5l_decap_4
XFILLER_46_252 VPWR VGND sg13cmos5l_decap_4
X_1931_ Tile_X0Y1_EE4BEG[12] _2321_/X VPWR VGND sg13cmos5l_buf_1
XFILLER_348_221 VPWR VGND sg13cmos5l_decap_8
XFILLER_202_261 VPWR VGND sg13cmos5l_fill_1
XFILLER_202_272 VPWR VGND sg13cmos5l_fill_1
X_1862_ Tile_X0Y4_FrameData_O[29] Tile_X0Y4_FrameData[29] VPWR VGND sg13cmos5l_buf_1
X_0813_ _0813_/Q Tile_X0Y3_FrameData[9] VGND VPWR Tile_X0Y5_FrameStrobe[0] latch
XFILLER_174_168 VPWR VGND sg13cmos5l_decap_8
X_1793_ Tile_X0Y4_E2BEG[4] _2621_/X VPWR VGND sg13cmos5l_buf_1
XFILLER_318_70 VPWR VGND sg13cmos5l_decap_8
X_0744_ _0744_/Q Tile_X0Y2_FrameData[30] VGND VPWR Tile_X0Y5_FrameStrobe[6] latch
XFILLER_254_14 VPWR VGND sg13cmos5l_decap_8
X_0675_ _0675_/Q Tile_X0Y2_FrameData[3] VGND VPWR Tile_X0Y5_FrameStrobe[3] latch
X_2414_ _2414_/X AXIL_S_SOC_AWADDR5 AXIL_S_SOC_AWVALID _2483_/X _2486_/X _0720_/Q
+ _0719_/Q VPWR VGND sg13cmos5l_mux4_1
XFILLER_35_0 VPWR VGND sg13cmos5l_decap_8
XFILLER_229_147 VPWR VGND sg13cmos5l_decap_8
XFILLER_334_91 VPWR VGND sg13cmos5l_decap_8
X_2345_ _2345_/X Tile_X0Y0_W1END[2] Tile_X0Y0_W6END[10] _2221_/X _2211_/X _0174_/Q
+ _0173_/Q VPWR VGND sg13cmos5l_mux4_1
XFILLER_96_141 VPWR VGND sg13cmos5l_decap_8
XFILLER_229_158 VPWR VGND sg13cmos5l_fill_1
XFILLER_270_35 VPWR VGND sg13cmos5l_decap_8
X_2276_ _2276_/X _2476_/X _2474_/X _2468_/X _2467_/X _0760_/Q _0759_/Q VPWR VGND sg13cmos5l_mux4_1
XFILLER_96_196 VPWR VGND sg13cmos5l_decap_8
X_1227_ _1227_/Q Tile_X0Y4_FrameData[27] VGND VPWR Tile_X0Y5_FrameStrobe[6] latch
X_1158_ _1158_/Q Tile_X0Y4_FrameData[0] VGND VPWR Tile_X0Y5_FrameStrobe[3] latch
XFILLER_16_49 VPWR VGND sg13cmos5l_decap_8
XFILLER_203_84 VPWR VGND sg13cmos5l_decap_8
X_0109_ _0109_/Q Tile_X0Y0_FrameData[25] VGND VPWR Tile_X0Y5_FrameStrobe[1] latch
XFILLER_197_216 VPWR VGND sg13cmos5l_fill_1
X_1089_ _1089_/Q Tile_X0Y4_FrameData[5] VGND VPWR Tile_X0Y5_FrameStrobe[1] latch
XFILLER_12_119 VPWR VGND sg13cmos5l_decap_8
XFILLER_197_249 VPWR VGND sg13cmos5l_fill_2
XFILLER_279_77 VPWR VGND sg13cmos5l_decap_8
XFILLER_165_113 VPWR VGND sg13cmos5l_decap_8
XFILLER_295_21 VPWR VGND sg13cmos5l_decap_8
XFILLER_354_224 VPWR VGND sg13cmos5l_decap_8
XANTENNA__1983__X Tile_X0Y5_E2BEGb[4] VPWR VGND sg13cmos5l_antennanp
XFILLER_180_105 VPWR VGND sg13cmos5l_decap_8
XFILLER_307_140 VPWR VGND sg13cmos5l_decap_8
XFILLER_113_7 VPWR VGND sg13cmos5l_decap_8
XFILLER_228_70 VPWR VGND sg13cmos5l_decap_8
XFILLER_295_98 VPWR VGND sg13cmos5l_decap_8
XFILLER_164_14 VPWR VGND sg13cmos5l_decap_8
XFILLER_79_119 VPWR VGND sg13cmos5l_decap_8
XFILLER_244_91 VPWR VGND sg13cmos5l_decap_8
XFILLER_314_28 VPWR VGND sg13cmos5l_decap_8
XFILLER_87_163 VPWR VGND sg13cmos5l_decap_8
XFILLER_87_141 VPWR VGND sg13cmos5l_fill_1
XFILLER_180_35 VPWR VGND sg13cmos5l_decap_8
XFILLER_57_56 VPWR VGND sg13cmos5l_decap_8
XFILLER_228_191 VPWR VGND sg13cmos5l_fill_1
XFILLER_28_252 VPWR VGND sg13cmos5l_fill_1
XFILLER_43_200 VPWR VGND sg13cmos5l_decap_8
XFILLER_113_84 VPWR VGND sg13cmos5l_decap_8
XFILLER_243_161 VPWR VGND sg13cmos5l_decap_8
XFILLER_330_49 VPWR VGND sg13cmos5l_decap_8
XFILLER_73_77 VPWR VGND sg13cmos5l_decap_8
XFILLER_189_77 VPWR VGND sg13cmos5l_decap_8
XFILLER_339_14 VPWR VGND sg13cmos5l_decap_8
XANTENNA__2054__X Tile_X0Y5_S2BEG[3] VPWR VGND sg13cmos5l_antennanp
XFILLER_196_271 VPWR VGND sg13cmos5l_fill_2
XFILLER_237_0 VPWR VGND sg13cmos5l_decap_8
XFILLER_7_101 VPWR VGND sg13cmos5l_fill_1
XANTENNA__1893__X Tile_X0Y1_FrameData_O[6] VPWR VGND sg13cmos5l_antennanp
XFILLER_22_70 VPWR VGND sg13cmos5l_decap_8
XFILLER_138_70 VPWR VGND sg13cmos5l_decap_8
XFILLER_156_179 VPWR VGND sg13cmos5l_decap_8
XFILLER_171_105 VPWR VGND sg13cmos5l_decap_8
XFILLER_355_35 VPWR VGND sg13cmos5l_decap_8
XFILLER_360_249 VPWR VGND sg13cmos5l_fill_2
XFILLER_313_154 VPWR VGND sg13cmos5l_decap_8
X_0460_ _0460_/Q Tile_X0Y1_FrameData[10] VGND VPWR Tile_X0Y5_FrameStrobe[4] latch
XFILLER_98_63 VPWR VGND sg13cmos5l_decap_8
XFILLER_112_249 VPWR VGND sg13cmos5l_decap_4
XFILLER_154_91 VPWR VGND sg13cmos5l_decap_8
XFILLER_224_28 VPWR VGND sg13cmos5l_decap_8
X_0391_ _0391_/Q Tile_X0Y1_FrameData[15] VGND VPWR Tile_X0Y5_FrameStrobe[2] latch
XFILLER_120_271 VPWR VGND sg13cmos5l_fill_2
XFILLER_266_264 VPWR VGND sg13cmos5l_fill_1
X_2130_ AXIL_S_SOC_RDATA24 Tile_X0Y0_W2MID[0] Tile_X0Y0_W2END[0] Tile_X0Y0_W6END[0]
+ _2241_/X _0142_/Q _0141_/Q VPWR VGND sg13cmos5l_mux4_1
XFILLER_226_106 VPWR VGND sg13cmos5l_decap_8
X_2061_ Tile_X0Y5_S2BEGb[2] _2831_/X VPWR VGND sg13cmos5l_buf_1
X_1012_ _1012_/Q Tile_X0Y3_FrameData[2] VGND VPWR Tile_X0Y5_FrameStrobe[6] latch
XFILLER_234_161 VPWR VGND sg13cmos5l_decap_8
XFILLER_240_49 VPWR VGND sg13cmos5l_decap_8
XFILLER_234_172 VPWR VGND sg13cmos5l_fill_2
XFILLER_249_14 VPWR VGND sg13cmos5l_decap_8
X_1914_ Tile_X0Y1_FrameData_O[27] Tile_X0Y1_FrameData[27] VPWR VGND sg13cmos5l_buf_1
X_1845_ Tile_X0Y4_FrameData_O[12] Tile_X0Y4_FrameData[12] VPWR VGND sg13cmos5l_buf_1
XFILLER_162_105 VPWR VGND sg13cmos5l_decap_8
XFILLER_265_35 VPWR VGND sg13cmos5l_decap_8
XFILLER_329_91 VPWR VGND sg13cmos5l_decap_8
X_1776_ Tile_X0Y2_E1BEG[3] _2400_/X VPWR VGND sg13cmos5l_buf_1
X_0727_ _0727_/Q Tile_X0Y2_FrameData[15] VGND VPWR Tile_X0Y5_FrameStrobe[5] latch
XFILLER_304_154 VPWR VGND sg13cmos5l_decap_8
X_0658_ _0658_/Q Tile_X0Y2_FrameData[20] VGND VPWR Tile_X0Y5_FrameStrobe[3] latch
XFILLER_134_28 VPWR VGND sg13cmos5l_decap_8
XFILLER_281_56 VPWR VGND sg13cmos5l_decap_8
X_0589_ _0589_/Q Tile_X0Y2_FrameData[25] VGND VPWR Tile_X0Y5_FrameStrobe[1] latch
XFILLER_111_271 VPWR VGND sg13cmos5l_fill_2
X_2328_ _2328_/X _0029_/X Tile_X0Y0_S4END[7] _2362_/X _2361_/X _0436_/Q _0435_/Q VPWR
+ VGND sg13cmos5l_mux4_1
XANTENNA__2139__X AXIL_S_SOC_RRESP1 VPWR VGND sg13cmos5l_antennanp
XFILLER_84_155 VPWR VGND sg13cmos5l_fill_1
X_2259_ _2259_/X Tile_X0Y2_W2MID[2] Tile_X0Y2_W2END[2] Tile_X0Y2_W6END[2] _2486_/X
+ _0772_/Q _0771_/Q VPWR VGND sg13cmos5l_mux4_1
XFILLER_84_188 VPWR VGND sg13cmos5l_fill_1
XANTENNA__1978__X Tile_X0Y5_E2BEG[7] VPWR VGND sg13cmos5l_antennanp
XFILLER_150_49 VPWR VGND sg13cmos5l_decap_8
XFILLER_43_14 VPWR VGND sg13cmos5l_decap_8
XFILLER_159_14 VPWR VGND sg13cmos5l_decap_8
XFILLER_40_225 VPWR VGND sg13cmos5l_decap_8
XFILLER_230_7 VPWR VGND sg13cmos5l_decap_8
XFILLER_240_175 VPWR VGND sg13cmos5l_decap_8
XFILLER_328_7 VPWR VGND sg13cmos5l_decap_8
XFILLER_309_28 VPWR VGND sg13cmos5l_decap_8
XFILLER_175_35 VPWR VGND sg13cmos5l_decap_8
XFILLER_239_91 VPWR VGND sg13cmos5l_decap_8
XFILLER_342_205 VPWR VGND sg13cmos5l_decap_8
XFILLER_146_190 VPWR VGND sg13cmos5l_fill_1
XFILLER_153_149 VPWR VGND sg13cmos5l_decap_4
XFILLER_108_84 VPWR VGND sg13cmos5l_decap_8
XFILLER_161_171 VPWR VGND sg13cmos5l_fill_1
XFILLER_255_90 VPWR VGND sg13cmos5l_decap_8
XFILLER_325_49 VPWR VGND sg13cmos5l_decap_8
XFILLER_350_271 VPWR VGND sg13cmos5l_fill_2
XFILLER_68_77 VPWR VGND sg13cmos5l_decap_8
XFILLER_191_56 VPWR VGND sg13cmos5l_decap_8
XANTENNA__2049__X Tile_X0Y5_S1BEG[2] VPWR VGND sg13cmos5l_antennanp
XFILLER_187_0 VPWR VGND sg13cmos5l_decap_8
XFILLER_84_21 VPWR VGND sg13cmos5l_decap_8
XFILLER_208_139 VPWR VGND sg13cmos5l_decap_8
XANTENNA__1888__X Tile_X0Y1_FrameData_O[1] VPWR VGND sg13cmos5l_antennanp
XFILLER_354_0 VPWR VGND sg13cmos5l_decap_8
XFILLER_17_70 VPWR VGND sg13cmos5l_decap_8
XFILLER_90_169 VPWR VGND sg13cmos5l_decap_8
XFILLER_176_219 VPWR VGND sg13cmos5l_decap_8
XFILLER_129_168 VPWR VGND sg13cmos5l_fill_2
XFILLER_219_28 VPWR VGND sg13cmos5l_decap_8
XFILLER_76_7 VPWR VGND sg13cmos5l_decap_8
X_1630_ Tile_X0Y0_N2BEG[2] _2147_/X VPWR VGND sg13cmos5l_buf_1
XFILLER_144_149 VPWR VGND sg13cmos5l_fill_1
XFILLER_333_238 VPWR VGND sg13cmos5l_fill_2
XFILLER_152_160 VPWR VGND sg13cmos5l_decap_8
X_1561_ Tile_X0Y3_FrameData_O[7] Tile_X0Y3_FrameData[7] VPWR VGND sg13cmos5l_buf_1
XFILLER_152_171 VPWR VGND sg13cmos5l_fill_1
XFILLER_152_193 VPWR VGND sg13cmos5l_decap_8
XFILLER_235_49 VPWR VGND sg13cmos5l_decap_8
XFILLER_298_175 VPWR VGND sg13cmos5l_decap_8
X_1492_ _1492_/Q Tile_X0Y5_FrameData[28] VGND VPWR Tile_X0Y5_FrameStrobe[7] latch
X_0512_ _0512_/Q Tile_X0Y1_FrameData[22] VGND VPWR Tile_X0Y5_FrameStrobe[6] latch
X_0443_ _0443_/Q Tile_X0Y1_FrameData[27] VGND VPWR Tile_X0Y5_FrameStrobe[4] latch
XFILLER_239_253 VPWR VGND sg13cmos5l_decap_8
XFILLER_301_168 VPWR VGND sg13cmos5l_decap_8
X_0374_ _0374_/Q Tile_X0Y1_FrameData[0] VGND VPWR Tile_X0Y5_FrameStrobe[1] latch
XFILLER_254_223 VPWR VGND sg13cmos5l_fill_2
X_2113_ AXIL_S_SOC_RDATA7 Tile_X0Y3_W2MID[7] Tile_X0Y3_W2END[7] Tile_X0Y3_W6END[7]
+ _2596_/X _0848_/Q _0847_/Q VPWR VGND sg13cmos5l_mux4_1
XFILLER_66_133 VPWR VGND sg13cmos5l_decap_8
XANTENNA__1798__X Tile_X0Y4_E2BEGb[1] VPWR VGND sg13cmos5l_antennanp
XFILLER_331_70 VPWR VGND sg13cmos5l_decap_8
X_2044_ Tile_X0Y5_FrameData_O[29] Tile_X0Y5_FrameData[29] VPWR VGND sg13cmos5l_buf_1
XFILLER_207_194 VPWR VGND sg13cmos5l_decap_4
XFILLER_81_169 VPWR VGND sg13cmos5l_fill_2
XFILLER_13_28 VPWR VGND sg13cmos5l_decap_8
XFILLER_200_63 VPWR VGND sg13cmos5l_decap_8
XFILLER_129_28 VPWR VGND sg13cmos5l_decap_8
XFILLER_276_56 VPWR VGND sg13cmos5l_decap_8
X_1828_ Tile_X0Y4_EE4BEG[11] _2644_/X VPWR VGND sg13cmos5l_buf_1
XFILLER_135_138 VPWR VGND sg13cmos5l_decap_4
X_1759_ Tile_X0Y2_FrameData_O[19] Tile_X0Y2_FrameData[19] VPWR VGND sg13cmos5l_buf_1
XFILLER_143_160 VPWR VGND sg13cmos5l_decap_8
XFILLER_145_49 VPWR VGND sg13cmos5l_decap_8
XFILLER_292_77 VPWR VGND sg13cmos5l_decap_8
XFILLER_38_14 VPWR VGND sg13cmos5l_decap_8
XFILLER_57_133 VPWR VGND sg13cmos5l_decap_8
XFILLER_180_7 VPWR VGND sg13cmos5l_decap_8
XFILLER_245_256 VPWR VGND sg13cmos5l_fill_2
XFILLER_278_7 VPWR VGND sg13cmos5l_decap_8
XANTENNA_305 AXIL_S_SOC_WDATA19 VPWR VGND sg13cmos5l_antennanp
XANTENNA_316 Tile_X0Y0_FrameData[23] VPWR VGND sg13cmos5l_antennanp
XFILLER_241_70 VPWR VGND sg13cmos5l_decap_8
XFILLER_260_237 VPWR VGND sg13cmos5l_fill_2
XFILLER_54_35 VPWR VGND sg13cmos5l_decap_8
XFILLER_13_203 VPWR VGND sg13cmos5l_fill_1
XFILLER_213_153 VPWR VGND sg13cmos5l_fill_2
XFILLER_359_168 VPWR VGND sg13cmos5l_decap_8
XFILLER_110_63 VPWR VGND sg13cmos5l_decap_8
XFILLER_213_197 VPWR VGND sg13cmos5l_decap_8
XFILLER_70_56 VPWR VGND sg13cmos5l_decap_8
XFILLER_181_211 VPWR VGND sg13cmos5l_decap_8
XFILLER_186_56 VPWR VGND sg13cmos5l_decap_8
XFILLER_181_244 VPWR VGND sg13cmos5l_decap_8
XFILLER_102_0 VPWR VGND sg13cmos5l_decap_8
XFILLER_141_108 VPWR VGND sg13cmos5l_decap_8
XFILLER_79_21 VPWR VGND sg13cmos5l_decap_8
XFILLER_330_219 VPWR VGND sg13cmos5l_fill_2
XFILLER_295_112 VPWR VGND sg13cmos5l_decap_8
XFILLER_79_98 VPWR VGND sg13cmos5l_decap_8
XFILLER_352_14 VPWR VGND sg13cmos5l_decap_8
XFILLER_0_162 VPWR VGND sg13cmos5l_fill_1
XFILLER_236_212 VPWR VGND sg13cmos5l_decap_8
XFILLER_295_189 VPWR VGND sg13cmos5l_decap_8
XFILLER_95_42 VPWR VGND sg13cmos5l_decap_8
XFILLER_48_144 VPWR VGND sg13cmos5l_decap_8
XFILLER_151_70 VPWR VGND sg13cmos5l_decap_8
XFILLER_28_91 VPWR VGND sg13cmos5l_decap_8
X_0090_ _0090_/Q Tile_X0Y0_FrameData[12] VGND VPWR Tile_X0Y5_FrameStrobe[0] latch
XFILLER_251_237 VPWR VGND sg13cmos5l_fill_2
XFILLER_63_147 VPWR VGND sg13cmos5l_decap_8
XFILLER_301_84 VPWR VGND sg13cmos5l_decap_8
XFILLER_204_197 VPWR VGND sg13cmos5l_fill_1
X_2800_ _2800_/X Tile_X0Y5_N2MID[4] Tile_X0Y5_N2END[4] _2833_/X _2717_/X _1280_/Q
+ _1279_/Q VPWR VGND sg13cmos5l_mux4_1
X_0992_ _0992_/Q Tile_X0Y3_FrameData[22] VGND VPWR Tile_X0Y5_FrameStrobe[6] latch
XFILLER_157_230 VPWR VGND sg13cmos5l_fill_1
X_2731_ _2731_/X AXIL_S_SOC_ARPROT1 AXIL_S_SOC_RREADY _2826_/X _2798_/X _1440_/Q _1439_/Q
+ VPWR VGND sg13cmos5l_mux4_1
XFILLER_117_105 VPWR VGND sg13cmos5l_decap_8
X_2662_ _2662_/X _2706_/X _2697_/X _2696_/X _2712_/X _1108_/Q _1107_/Q VPWR VGND sg13cmos5l_mux4_1
X_1613_ Tile_X0Y0_N4BEG[9] _1613_/A VPWR VGND sg13cmos5l_buf_1
X_2593_ _2593_/X _2498_/X _2606_/X _2605_/X _2497_/X _0806_/Q _0805_/Q VPWR VGND sg13cmos5l_mux4_1
X_1544_ Tile_X0Y3_EE4BEG[6] _2531_/X VPWR VGND sg13cmos5l_buf_1
XFILLER_262_14 VPWR VGND sg13cmos5l_decap_8
XFILLER_286_134 VPWR VGND sg13cmos5l_decap_8
XFILLER_326_70 VPWR VGND sg13cmos5l_decap_8
XFILLER_5_84 VPWR VGND sg13cmos5l_decap_8
XFILLER_140_185 VPWR VGND sg13cmos5l_fill_1
X_1475_ _1475_/Q Tile_X0Y5_FrameData[13] VGND VPWR Tile_X0Y5_FrameStrobe[6] latch
XFILLER_227_201 VPWR VGND sg13cmos5l_decap_4
XFILLER_286_189 VPWR VGND sg13cmos5l_fill_2
X_0426_ _0426_/Q Tile_X0Y1_FrameData[12] VGND VPWR Tile_X0Y5_FrameStrobe[3] latch
XFILLER_227_245 VPWR VGND sg13cmos5l_decap_8
X_0357_ _0357_/Q Tile_X0Y1_FrameData[17] VGND VPWR Tile_X0Y5_FrameStrobe[1] latch
X_0288_ _0288_/Q Tile_X0Y0_FrameData[6] VGND VPWR Tile_X0Y5_FrameStrobe[6] latch
XFILLER_39_188 VPWR VGND sg13cmos5l_decap_8
XFILLER_199_108 VPWR VGND sg13cmos5l_decap_8
XFILLER_199_119 VPWR VGND sg13cmos5l_fill_2
X_2027_ Tile_X0Y5_FrameData_O[12] Tile_X0Y5_FrameData[12] VPWR VGND sg13cmos5l_buf_1
XFILLER_54_147 VPWR VGND sg13cmos5l_decap_8
XFILLER_242_259 VPWR VGND sg13cmos5l_decap_4
XFILLER_211_84 VPWR VGND sg13cmos5l_decap_8
XFILLER_24_49 VPWR VGND sg13cmos5l_decap_8
XFILLER_356_105 VPWR VGND sg13cmos5l_decap_8
XFILLER_210_178 VPWR VGND sg13cmos5l_decap_8
XFILLER_287_77 VPWR VGND sg13cmos5l_decap_8
XFILLER_108_105 VPWR VGND sg13cmos5l_decap_4
XFILLER_148_263 VPWR VGND sg13cmos5l_fill_2
XFILLER_108_127 VPWR VGND sg13cmos5l_fill_1
XANTENNA__1991__X Tile_X0Y5_E6BEG[4] VPWR VGND sg13cmos5l_antennanp
XFILLER_116_182 VPWR VGND sg13cmos5l_decap_8
XFILLER_123_119 VPWR VGND sg13cmos5l_decap_8
XFILLER_6_7 VPWR VGND sg13cmos5l_decap_8
XFILLER_172_14 VPWR VGND sg13cmos5l_decap_8
XFILLER_236_70 VPWR VGND sg13cmos5l_decap_8
XFILLER_277_112 VPWR VGND sg13cmos5l_decap_4
XFILLER_320_241 VPWR VGND sg13cmos5l_fill_1
XFILLER_49_35 VPWR VGND sg13cmos5l_decap_8
XFILLER_218_212 VPWR VGND sg13cmos5l_fill_2
XFILLER_292_126 VPWR VGND sg13cmos5l_decap_8
XFILLER_105_63 VPWR VGND sg13cmos5l_decap_8
XFILLER_322_28 VPWR VGND sg13cmos5l_decap_8
XFILLER_218_256 VPWR VGND sg13cmos5l_decap_8
XFILLER_252_91 VPWR VGND sg13cmos5l_decap_8
XFILLER_65_56 VPWR VGND sg13cmos5l_decap_8
XANTENNA_102 AXIL_S_SOC_WDATA26 VPWR VGND sg13cmos5l_antennanp
XANTENNA_113 AXIL_S_SOC_WDATA27 VPWR VGND sg13cmos5l_antennanp
XANTENNA_124 AXIL_S_SOC_WDATA29 VPWR VGND sg13cmos5l_antennanp
XFILLER_233_226 VPWR VGND sg13cmos5l_decap_8
XFILLER_45_169 VPWR VGND sg13cmos5l_decap_8
XFILLER_45_147 VPWR VGND sg13cmos5l_decap_4
XANTENNA_135 AXIL_S_SOC_WDATA30 VPWR VGND sg13cmos5l_antennanp
XANTENNA_146 AXIL_S_SOC_WDATA30 VPWR VGND sg13cmos5l_antennanp
XANTENNA_157 AXIL_S_SOC_WDATA31 VPWR VGND sg13cmos5l_antennanp
XANTENNA_168 AXIL_S_SOC_WDATA8 VPWR VGND sg13cmos5l_antennanp
XANTENNA_179 AXIL_S_SOC_WDATA8 VPWR VGND sg13cmos5l_antennanp
XFILLER_121_84 VPWR VGND sg13cmos5l_decap_8
XFILLER_81_22 VPWR VGND sg13cmos5l_decap_8
XFILLER_201_123 VPWR VGND sg13cmos5l_decap_4
XFILLER_197_77 VPWR VGND sg13cmos5l_decap_8
XFILLER_347_149 VPWR VGND sg13cmos5l_decap_8
XANTENNA__2062__X Tile_X0Y5_S2BEGb[3] VPWR VGND sg13cmos5l_antennanp
XFILLER_317_0 VPWR VGND sg13cmos5l_decap_8
XFILLER_362_108 VPWR VGND sg13cmos5l_decap_8
XFILLER_347_36 VPWR VGND sg13cmos5l_decap_8
XFILLER_355_182 VPWR VGND sg13cmos5l_decap_8
XFILLER_114_119 VPWR VGND sg13cmos5l_decap_8
XFILLER_30_70 VPWR VGND sg13cmos5l_decap_8
XFILLER_146_70 VPWR VGND sg13cmos5l_decap_8
XFILLER_46_8 VPWR VGND sg13cmos5l_decap_8
XFILLER_39_7 VPWR VGND sg13cmos5l_decap_8
XFILLER_268_189 VPWR VGND sg13cmos5l_decap_8
XFILLER_283_126 VPWR VGND sg13cmos5l_fill_2
X_1260_ _1260_/Q Tile_X0Y4_FrameData[26] VGND VPWR Tile_X0Y5_FrameStrobe[7] latch
XFILLER_209_223 VPWR VGND sg13cmos5l_fill_2
XFILLER_232_28 VPWR VGND sg13cmos5l_decap_8
X_1191_ _1191_/Q Tile_X0Y4_FrameData[31] VGND VPWR Tile_X0Y5_FrameStrobe[5] latch
X_0211_ _0211_/Q Tile_X0Y0_FrameData[19] VGND VPWR Tile_X0Y5_FrameStrobe[4] latch
XFILLER_162_91 VPWR VGND sg13cmos5l_decap_8
XFILLER_224_204 VPWR VGND sg13cmos5l_decap_8
X_0142_ _0142_/Q Tile_X0Y0_FrameData[24] VGND VPWR Tile_X0Y5_FrameStrobe[2] latch
XFILLER_91_253 VPWR VGND sg13cmos5l_decap_8
X_0073_ _0073_/Q Tile_X0Y0_FrameData[29] VGND VPWR Tile_X0Y5_FrameStrobe[0] latch
XFILLER_338_116 VPWR VGND sg13cmos5l_fill_2
XFILLER_338_105 VPWR VGND sg13cmos5l_decap_8
XFILLER_257_14 VPWR VGND sg13cmos5l_decap_8
X_0975_ _0975_/Q Tile_X0Y3_FrameData[7] VGND VPWR Tile_X0Y5_FrameStrobe[5] latch
XFILLER_353_119 VPWR VGND sg13cmos5l_decap_8
XFILLER_145_222 VPWR VGND sg13cmos5l_decap_8
X_2714_ _2714_/X Tile_X0Y3_W2MID[6] Tile_X0Y3_W2END[6] Tile_X0Y3_W6END[9] _2590_/X
+ _0888_/Q _0887_/Q VPWR VGND sg13cmos5l_mux4_1
XFILLER_65_0 VPWR VGND sg13cmos5l_decap_8
X_2645_ _2645_/X Tile_X0Y4_WW4END[8] AXIL_S_SOC_WSTRB0 _2702_/X _2711_/X _1164_/Q
+ _1163_/Q VPWR VGND sg13cmos5l_mux4_1
XFILLER_160_203 VPWR VGND sg13cmos5l_decap_8
XFILLER_361_174 VPWR VGND sg13cmos5l_decap_8
XFILLER_337_91 VPWR VGND sg13cmos5l_decap_4
XFILLER_259_112 VPWR VGND sg13cmos5l_decap_4
XFILLER_273_35 VPWR VGND sg13cmos5l_decap_8
X_2576_ _2576_/X _2570_/X Tile_X0Y5_N4END[10] _2569_/X Tile_X0Y0_S4END[14] _0826_/Q
+ _0825_/Q VPWR VGND sg13cmos5l_mux4_1
X_1527_ Tile_X0Y3_E6BEG[1] _2542_/X VPWR VGND sg13cmos5l_buf_1
XFILLER_206_84 VPWR VGND sg13cmos5l_decap_8
X_1458_ _1458_/Q Tile_X0Y5_FrameData[30] VGND VPWR Tile_X0Y5_FrameStrobe[6] latch
XFILLER_142_28 VPWR VGND sg13cmos5l_decap_8
XFILLER_19_49 VPWR VGND sg13cmos5l_decap_8
XFILLER_206_95 VPWR VGND sg13cmos5l_fill_1
XFILLER_274_126 VPWR VGND sg13cmos5l_fill_2
X_0409_ _0409_/Q Tile_X0Y1_FrameData[29] VGND VPWR Tile_X0Y5_FrameStrobe[3] latch
X_1389_ _1389_/Q Tile_X0Y5_FrameData[3] VGND VPWR Tile_X0Y5_FrameStrobe[3] latch
XFILLER_67_272 VPWR VGND sg13cmos5l_fill_1
XFILLER_82_231 VPWR VGND sg13cmos5l_fill_2
XFILLER_298_21 VPWR VGND sg13cmos5l_decap_8
XANTENNA__1986__X Tile_X0Y5_E2BEGb[7] VPWR VGND sg13cmos5l_antennanp
XFILLER_143_7 VPWR VGND sg13cmos5l_decap_8
XFILLER_298_98 VPWR VGND sg13cmos5l_decap_8
XFILLER_329_105 VPWR VGND sg13cmos5l_fill_2
XFILLER_51_14 VPWR VGND sg13cmos5l_decap_8
XFILLER_50_161 VPWR VGND sg13cmos5l_decap_8
XFILLER_167_14 VPWR VGND sg13cmos5l_decap_8
XFILLER_195_166 VPWR VGND sg13cmos5l_fill_2
XFILLER_344_119 VPWR VGND sg13cmos5l_decap_8
XFILLER_310_7 VPWR VGND sg13cmos5l_decap_8
XFILLER_337_160 VPWR VGND sg13cmos5l_decap_4
XFILLER_317_28 VPWR VGND sg13cmos5l_decap_8
XFILLER_151_214 VPWR VGND sg13cmos5l_decap_8
XFILLER_247_91 VPWR VGND sg13cmos5l_decap_8
XFILLER_183_35 VPWR VGND sg13cmos5l_decap_8
XFILLER_352_196 VPWR VGND sg13cmos5l_decap_8
XFILLER_104_141 VPWR VGND sg13cmos5l_decap_8
XFILLER_116_84 VPWR VGND sg13cmos5l_decap_8
XFILLER_333_49 VPWR VGND sg13cmos5l_decap_8
XFILLER_76_77 VPWR VGND sg13cmos5l_decap_8
XFILLER_58_272 VPWR VGND sg13cmos5l_fill_1
XFILLER_206_215 VPWR VGND sg13cmos5l_decap_8
XFILLER_267_0 VPWR VGND sg13cmos5l_decap_8
XFILLER_92_21 VPWR VGND sg13cmos5l_decap_8
XANTENNA__2057__X Tile_X0Y5_S2BEG[6] VPWR VGND sg13cmos5l_antennanp
XFILLER_206_259 VPWR VGND sg13cmos5l_fill_1
XFILLER_33_106 VPWR VGND sg13cmos5l_decap_8
XANTENNA__1896__X Tile_X0Y1_FrameData_O[9] VPWR VGND sg13cmos5l_antennanp
XFILLER_25_70 VPWR VGND sg13cmos5l_decap_8
XFILLER_92_98 VPWR VGND sg13cmos5l_decap_8
XFILLER_358_35 VPWR VGND sg13cmos5l_decap_8
XFILLER_335_119 VPWR VGND sg13cmos5l_decap_4
X_0760_ _0760_/Q Tile_X0Y2_FrameData[14] VGND VPWR Tile_X0Y5_FrameStrobe[6] latch
XFILLER_227_28 VPWR VGND sg13cmos5l_decap_8
X_2430_ _2430_/X AXIL_S_SOC_AWADDR1 AXIL_S_SOC_AWVALID _2476_/X _2483_/X _0688_/Q
+ _0687_/Q VPWR VGND sg13cmos5l_mux4_1
X_0691_ _0691_/Q Tile_X0Y2_FrameData[19] VGND VPWR Tile_X0Y5_FrameStrobe[4] latch
XFILLER_343_185 VPWR VGND sg13cmos5l_fill_1
XFILLER_343_174 VPWR VGND sg13cmos5l_fill_2
X_2361_ _2361_/X _2342_/X _0063_/X _2341_/X Tile_X0Y0_S4END[4] _0342_/Q _0341_/Q VPWR
+ VGND sg13cmos5l_mux4_1
XFILLER_243_49 VPWR VGND sg13cmos5l_decap_8
X_1312_ _1312_/Q Tile_X0Y5_FrameData[16] VGND VPWR Tile_X0Y5_FrameStrobe[1] latch
X_2292_ _2292_/X _2348_/X _2347_/X AXIL_S_SOC_WDATA1 AXIL_S_SOC_WDATA4 _0508_/Q _0507_/Q
+ VPWR VGND sg13cmos5l_mux4_1
XFILLER_256_126 VPWR VGND sg13cmos5l_decap_8
X_1243_ _1243_/Q Tile_X0Y4_FrameData[11] VGND VPWR Tile_X0Y5_FrameStrobe[6] latch
XFILLER_2_63 VPWR VGND sg13cmos5l_decap_8
X_1174_ _1174_/Q Tile_X0Y4_FrameData[16] VGND VPWR Tile_X0Y5_FrameStrobe[4] latch
X_0125_ _0125_/Q Tile_X0Y0_FrameData[9] VGND VPWR Tile_X0Y5_FrameStrobe[1] latch
XFILLER_212_207 VPWR VGND sg13cmos5l_decap_8
X_0056_ _1608_/A _2279_/X _2280_/X _0764_/Q VPWR VGND sg13cmos5l_mux2_1
XANTENNA_13 AXIL_S_SOC_WDATA10 VPWR VGND sg13cmos5l_antennanp
XFILLER_177_133 VPWR VGND sg13cmos5l_decap_8
XFILLER_220_240 VPWR VGND sg13cmos5l_decap_8
XFILLER_220_251 VPWR VGND sg13cmos5l_fill_2
XFILLER_268_35 VPWR VGND sg13cmos5l_decap_8
XFILLER_32_172 VPWR VGND sg13cmos5l_decap_8
XANTENNA_24 AXIL_S_SOC_WDATA11 VPWR VGND sg13cmos5l_antennanp
XANTENNA_35 AXIL_S_SOC_WDATA11 VPWR VGND sg13cmos5l_antennanp
XANTENNA_46 AXIL_S_SOC_WDATA15 VPWR VGND sg13cmos5l_antennanp
XANTENNA_57 AXIL_S_SOC_WDATA16 VPWR VGND sg13cmos5l_antennanp
XANTENNA_68 AXIL_S_SOC_WDATA23 VPWR VGND sg13cmos5l_antennanp
XANTENNA_79 AXIL_S_SOC_WDATA25 VPWR VGND sg13cmos5l_antennanp
XFILLER_177_199 VPWR VGND sg13cmos5l_decap_8
XFILLER_192_147 VPWR VGND sg13cmos5l_fill_2
XFILLER_21_28 VPWR VGND sg13cmos5l_decap_8
X_0958_ _0958_/Q Tile_X0Y3_FrameData[24] VGND VPWR Tile_X0Y5_FrameStrobe[5] latch
XFILLER_137_28 VPWR VGND sg13cmos5l_decap_8
XFILLER_279_207 VPWR VGND sg13cmos5l_fill_1
XFILLER_284_56 VPWR VGND sg13cmos5l_decap_8
X_0889_ _0889_/Q Tile_X0Y3_FrameData[29] VGND VPWR Tile_X0Y5_FrameStrobe[3] latch
XFILLER_279_229 VPWR VGND sg13cmos5l_decap_8
X_2628_ _2628_/X AXIL_S_SOC_WSTRB3 AXIL_S_SOC_BREADY _2711_/X _2712_/X _1198_/Q _1197_/Q
+ VPWR VGND sg13cmos5l_mux4_1
X_2559_ _2559_/X Tile_X0Y3_W1END[3] Tile_X0Y3_WW4END[11] Tile_X0Y3_WW4END[15] Tile_X0Y3_W6END[7]
+ _0865_/Q _0864_/Q VPWR VGND sg13cmos5l_mux4_1
XFILLER_153_49 VPWR VGND sg13cmos5l_decap_8
XFILLER_101_133 VPWR VGND sg13cmos5l_decap_8
XFILLER_247_126 VPWR VGND sg13cmos5l_decap_8
XFILLER_55_231 VPWR VGND sg13cmos5l_decap_8
XFILLER_46_36 VPWR VGND sg13cmos5l_decap_8
XFILLER_260_7 VPWR VGND sg13cmos5l_decap_8
XFILLER_358_7 VPWR VGND sg13cmos5l_decap_8
XFILLER_102_42 VPWR VGND sg13cmos5l_decap_8
XFILLER_70_223 VPWR VGND sg13cmos5l_fill_1
XFILLER_62_35 VPWR VGND sg13cmos5l_decap_8
XFILLER_178_35 VPWR VGND sg13cmos5l_decap_8
XFILLER_357_244 VPWR VGND sg13cmos5l_decap_8
XFILLER_109_200 VPWR VGND sg13cmos5l_decap_8
XFILLER_317_119 VPWR VGND sg13cmos5l_decap_8
XFILLER_183_147 VPWR VGND sg13cmos5l_decap_8
XFILLER_183_169 VPWR VGND sg13cmos5l_decap_8
XFILLER_328_49 VPWR VGND sg13cmos5l_decap_8
XFILLER_194_56 VPWR VGND sg13cmos5l_decap_8
XFILLER_340_133 VPWR VGND sg13cmos5l_decap_8
XFILLER_278_240 VPWR VGND sg13cmos5l_decap_8
XFILLER_87_21 VPWR VGND sg13cmos5l_decap_8
XFILLER_340_144 VPWR VGND sg13cmos5l_fill_2
XFILLER_238_126 VPWR VGND sg13cmos5l_decap_8
XFILLER_360_47 VPWR VGND sg13cmos5l_decap_8
XFILLER_360_14 VPWR VGND sg13cmos5l_decap_8
XFILLER_46_231 VPWR VGND sg13cmos5l_decap_8
XFILLER_61_223 VPWR VGND sg13cmos5l_fill_1
XFILLER_36_91 VPWR VGND sg13cmos5l_decap_8
XFILLER_159_100 VPWR VGND sg13cmos5l_fill_1
XFILLER_261_184 VPWR VGND sg13cmos5l_decap_8
XFILLER_14_161 VPWR VGND sg13cmos5l_fill_1
X_1930_ Tile_X0Y1_EE4BEG[11] _2320_/X VPWR VGND sg13cmos5l_buf_1
X_1861_ Tile_X0Y4_FrameData_O[28] Tile_X0Y4_FrameData[28] VPWR VGND sg13cmos5l_buf_1
XFILLER_308_119 VPWR VGND sg13cmos5l_decap_8
X_0812_ _0812_/Q Tile_X0Y3_FrameData[10] VGND VPWR Tile_X0Y5_FrameStrobe[0] latch
XFILLER_174_147 VPWR VGND sg13cmos5l_decap_8
XFILLER_238_49 VPWR VGND sg13cmos5l_decap_8
X_1792_ Tile_X0Y4_E2BEG[3] _2620_/X VPWR VGND sg13cmos5l_buf_1
X_0743_ _0743_/Q Tile_X0Y2_FrameData[31] VGND VPWR Tile_X0Y5_FrameStrobe[6] latch
XFILLER_115_236 VPWR VGND sg13cmos5l_decap_8
XFILLER_331_111 VPWR VGND sg13cmos5l_fill_2
X_0674_ _0674_/Q Tile_X0Y2_FrameData[4] VGND VPWR Tile_X0Y5_FrameStrobe[3] latch
X_2413_ _2413_/X AXIL_S_SOC_AWADDR4 AXIL_S_SOC_AWPROT2 _2484_/X _2485_/X _0722_/Q
+ _0721_/Q VPWR VGND sg13cmos5l_mux4_1
X_2344_ _2344_/X Tile_X0Y2_W1END[1] Tile_X0Y2_W6END[5] _2469_/X _2454_/X _0788_/Q
+ _0787_/Q VPWR VGND sg13cmos5l_mux4_1
XFILLER_229_126 VPWR VGND sg13cmos5l_decap_8
XFILLER_28_0 VPWR VGND sg13cmos5l_decap_8
XFILLER_334_70 VPWR VGND sg13cmos5l_decap_8
XFILLER_270_14 VPWR VGND sg13cmos5l_decap_8
X_2275_ _2275_/X Tile_X0Y2_W1END[2] Tile_X0Y2_WW4END[2] Tile_X0Y2_WW4END[6] Tile_X0Y2_W6END[10]
+ _0760_/Q _0759_/Q VPWR VGND sg13cmos5l_mux4_1
XFILLER_96_175 VPWR VGND sg13cmos5l_decap_8
X_1226_ _1226_/Q Tile_X0Y4_FrameData[28] VGND VPWR Tile_X0Y5_FrameStrobe[6] latch
XFILLER_203_63 VPWR VGND sg13cmos5l_decap_8
X_1157_ _1157_/Q Tile_X0Y4_FrameData[1] VGND VPWR Tile_X0Y5_FrameStrobe[3] latch
XFILLER_37_253 VPWR VGND sg13cmos5l_decap_4
XFILLER_16_28 VPWR VGND sg13cmos5l_decap_8
X_0108_ _0108_/Q Tile_X0Y0_FrameData[26] VGND VPWR Tile_X0Y5_FrameStrobe[1] latch
XFILLER_350_91 VPWR VGND sg13cmos5l_decap_4
XFILLER_197_206 VPWR VGND sg13cmos5l_fill_2
XFILLER_197_228 VPWR VGND sg13cmos5l_decap_8
XFILLER_252_195 VPWR VGND sg13cmos5l_fill_1
XFILLER_279_56 VPWR VGND sg13cmos5l_decap_8
X_1088_ _1088_/Q Tile_X0Y4_FrameData[6] VGND VPWR Tile_X0Y5_FrameStrobe[1] latch
XFILLER_52_245 VPWR VGND sg13cmos5l_decap_8
XFILLER_339_200 VPWR VGND sg13cmos5l_fill_1
X_0039_ _0039_/X _2686_/X _2687_/X _0152_/Q VPWR VGND sg13cmos5l_mux2_1
XFILLER_339_222 VPWR VGND sg13cmos5l_fill_2
XFILLER_339_211 VPWR VGND sg13cmos5l_fill_1
XFILLER_20_153 VPWR VGND sg13cmos5l_decap_4
XFILLER_32_49 VPWR VGND sg13cmos5l_decap_8
XFILLER_354_203 VPWR VGND sg13cmos5l_decap_8
XFILLER_148_49 VPWR VGND sg13cmos5l_decap_8
XFILLER_165_169 VPWR VGND sg13cmos5l_decap_8
XFILLER_295_77 VPWR VGND sg13cmos5l_decap_8
XFILLER_106_7 VPWR VGND sg13cmos5l_decap_8
XFILLER_173_191 VPWR VGND sg13cmos5l_fill_1
XFILLER_307_185 VPWR VGND sg13cmos5l_fill_1
XFILLER_106_258 VPWR VGND sg13cmos5l_fill_1
XFILLER_244_70 VPWR VGND sg13cmos5l_decap_8
XFILLER_275_210 VPWR VGND sg13cmos5l_decap_8
XFILLER_57_35 VPWR VGND sg13cmos5l_decap_8
XFILLER_180_14 VPWR VGND sg13cmos5l_decap_8
XFILLER_113_63 VPWR VGND sg13cmos5l_decap_8
XFILLER_330_28 VPWR VGND sg13cmos5l_decap_8
XFILLER_243_140 VPWR VGND sg13cmos5l_decap_8
XFILLER_260_91 VPWR VGND sg13cmos5l_decap_8
XFILLER_73_56 VPWR VGND sg13cmos5l_decap_8
XFILLER_189_56 VPWR VGND sg13cmos5l_decap_8
XFILLER_243_195 VPWR VGND sg13cmos5l_fill_2
XFILLER_196_261 VPWR VGND sg13cmos5l_fill_2
XFILLER_132_0 VPWR VGND sg13cmos5l_decap_8
XFILLER_11_175 VPWR VGND sg13cmos5l_fill_2
XFILLER_11_186 VPWR VGND sg13cmos5l_fill_1
XFILLER_156_158 VPWR VGND sg13cmos5l_decap_8
XFILLER_7_157 VPWR VGND sg13cmos5l_fill_1
XFILLER_355_14 VPWR VGND sg13cmos5l_decap_8
XANTENNA__2070__X Tile_X0Y5_S4BEG[3] VPWR VGND sg13cmos5l_antennanp
XFILLER_164_180 VPWR VGND sg13cmos5l_fill_1
XFILLER_98_42 VPWR VGND sg13cmos5l_decap_8
XFILLER_112_206 VPWR VGND sg13cmos5l_decap_8
XFILLER_313_133 VPWR VGND sg13cmos5l_decap_8
XFILLER_112_228 VPWR VGND sg13cmos5l_decap_8
XFILLER_154_70 VPWR VGND sg13cmos5l_decap_8
X_0390_ _0390_/Q Tile_X0Y1_FrameData[16] VGND VPWR Tile_X0Y5_FrameStrobe[2] latch
XFILLER_120_250 VPWR VGND sg13cmos5l_fill_2
XFILLER_21_7 VPWR VGND sg13cmos5l_decap_8
XFILLER_93_112 VPWR VGND sg13cmos5l_decap_8
XFILLER_78_164 VPWR VGND sg13cmos5l_decap_8
XFILLER_304_84 VPWR VGND sg13cmos5l_decap_8
X_2060_ Tile_X0Y5_S2BEGb[1] _2830_/X VPWR VGND sg13cmos5l_buf_1
XFILLER_240_28 VPWR VGND sg13cmos5l_decap_8
X_1011_ _1011_/Q Tile_X0Y3_FrameData[3] VGND VPWR Tile_X0Y5_FrameStrobe[6] latch
XFILLER_93_178 VPWR VGND sg13cmos5l_decap_8
XFILLER_170_91 VPWR VGND sg13cmos5l_decap_8
XFILLER_234_140 VPWR VGND sg13cmos5l_decap_8
XFILLER_234_184 VPWR VGND sg13cmos5l_fill_1
X_1913_ Tile_X0Y1_FrameData_O[26] Tile_X0Y1_FrameData[26] VPWR VGND sg13cmos5l_buf_1
XFILLER_187_272 VPWR VGND sg13cmos5l_fill_1
XFILLER_329_70 VPWR VGND sg13cmos5l_decap_8
X_1844_ Tile_X0Y4_FrameData_O[11] Tile_X0Y4_FrameData[11] VPWR VGND sg13cmos5l_buf_1
XFILLER_8_84 VPWR VGND sg13cmos5l_decap_8
XFILLER_265_14 VPWR VGND sg13cmos5l_decap_8
X_1775_ Tile_X0Y2_E1BEG[2] _2399_/X VPWR VGND sg13cmos5l_buf_1
X_0726_ _0726_/Q Tile_X0Y2_FrameData[16] VGND VPWR Tile_X0Y5_FrameStrobe[5] latch
XFILLER_304_133 VPWR VGND sg13cmos5l_decap_8
X_0657_ _0657_/Q Tile_X0Y2_FrameData[21] VGND VPWR Tile_X0Y5_FrameStrobe[3] latch
XFILLER_345_91 VPWR VGND sg13cmos5l_decap_8
XFILLER_281_35 VPWR VGND sg13cmos5l_decap_8
X_0588_ _0588_/Q Tile_X0Y2_FrameData[26] VGND VPWR Tile_X0Y5_FrameStrobe[1] latch
X_2327_ _2327_/X _0030_/X Tile_X0Y0_S4END[6] _2358_/X _2357_/X _0438_/Q _0437_/Q VPWR
+ VGND sg13cmos5l_mux4_1
X_2258_ _2258_/X Tile_X0Y1_W2MID[3] Tile_X0Y1_W2END[3] Tile_X0Y1_W6END[3] _2377_/X
+ _0534_/Q _0533_/Q VPWR VGND sg13cmos5l_mux4_1
XFILLER_84_134 VPWR VGND sg13cmos5l_decap_8
XFILLER_150_28 VPWR VGND sg13cmos5l_decap_8
XFILLER_214_84 VPWR VGND sg13cmos5l_decap_8
XFILLER_272_235 VPWR VGND sg13cmos5l_fill_1
XFILLER_27_49 VPWR VGND sg13cmos5l_decap_8
X_1209_ _1209_/Q Tile_X0Y4_FrameData[13] VGND VPWR Tile_X0Y5_FrameStrobe[5] latch
XFILLER_225_151 VPWR VGND sg13cmos5l_decap_8
X_2189_ _2189_/X AXIL_S_SOC_WDATA20 AXIL_S_SOC_WDATA24 _2233_/X _2248_/X _0218_/Q
+ _0217_/Q VPWR VGND sg13cmos5l_mux4_1
XFILLER_25_234 VPWR VGND sg13cmos5l_fill_2
XFILLER_240_154 VPWR VGND sg13cmos5l_decap_8
XFILLER_40_204 VPWR VGND sg13cmos5l_decap_8
XFILLER_178_261 VPWR VGND sg13cmos5l_fill_1
XANTENNA__1994__X Tile_X0Y5_E6BEG[7] VPWR VGND sg13cmos5l_antennanp
XFILLER_178_272 VPWR VGND sg13cmos5l_fill_1
XFILLER_138_158 VPWR VGND sg13cmos5l_decap_8
XFILLER_223_7 VPWR VGND sg13cmos5l_decap_8
XFILLER_239_70 VPWR VGND sg13cmos5l_decap_8
XFILLER_175_14 VPWR VGND sg13cmos5l_decap_8
XFILLER_4_105 VPWR VGND sg13cmos5l_decap_8
XFILLER_325_28 VPWR VGND sg13cmos5l_decap_8
XFILLER_108_63 VPWR VGND sg13cmos5l_decap_8
XFILLER_191_35 VPWR VGND sg13cmos5l_decap_8
XFILLER_310_147 VPWR VGND sg13cmos5l_decap_8
XFILLER_68_56 VPWR VGND sg13cmos5l_decap_8
XFILLER_102_272 VPWR VGND sg13cmos5l_fill_1
XFILLER_263_202 VPWR VGND sg13cmos5l_fill_2
XFILLER_124_84 VPWR VGND sg13cmos5l_decap_8
XFILLER_341_49 VPWR VGND sg13cmos5l_decap_8
XFILLER_216_140 VPWR VGND sg13cmos5l_decap_8
XFILLER_90_126 VPWR VGND sg13cmos5l_fill_1
XFILLER_84_77 VPWR VGND sg13cmos5l_fill_1
XFILLER_216_195 VPWR VGND sg13cmos5l_decap_8
XANTENNA__2065__X Tile_X0Y5_S2BEGb[6] VPWR VGND sg13cmos5l_antennanp
XFILLER_231_154 VPWR VGND sg13cmos5l_decap_8
XFILLER_31_215 VPWR VGND sg13cmos5l_decap_8
XFILLER_347_0 VPWR VGND sg13cmos5l_decap_4
XFILLER_169_272 VPWR VGND sg13cmos5l_fill_1
XFILLER_149_70 VPWR VGND sg13cmos5l_decap_8
XFILLER_184_231 VPWR VGND sg13cmos5l_fill_2
XFILLER_33_92 VPWR VGND sg13cmos5l_decap_8
XFILLER_69_7 VPWR VGND sg13cmos5l_decap_8
XFILLER_137_191 VPWR VGND sg13cmos5l_fill_2
X_1560_ Tile_X0Y3_FrameData_O[6] Tile_X0Y3_FrameData[6] VPWR VGND sg13cmos5l_buf_1
X_0511_ _0511_/Q Tile_X0Y1_FrameData[23] VGND VPWR Tile_X0Y5_FrameStrobe[6] latch
XFILLER_235_28 VPWR VGND sg13cmos5l_decap_8
XFILLER_298_154 VPWR VGND sg13cmos5l_decap_8
X_1491_ _1491_/Q Tile_X0Y5_FrameData[29] VGND VPWR Tile_X0Y5_FrameStrobe[7] latch
XFILLER_239_210 VPWR VGND sg13cmos5l_decap_8
XFILLER_239_221 VPWR VGND sg13cmos5l_fill_2
XFILLER_301_147 VPWR VGND sg13cmos5l_decap_8
X_0442_ _0442_/Q Tile_X0Y1_FrameData[28] VGND VPWR Tile_X0Y5_FrameStrobe[4] latch
X_0373_ _0373_/Q Tile_X0Y1_FrameData[1] VGND VPWR Tile_X0Y5_FrameStrobe[1] latch
X_2112_ AXIL_S_SOC_RDATA6 Tile_X0Y3_W2MID[6] Tile_X0Y3_W2END[6] Tile_X0Y3_W6END[6]
+ _2595_/X _0850_/Q _0849_/Q VPWR VGND sg13cmos5l_mux4_1
XFILLER_66_112 VPWR VGND sg13cmos5l_decap_8
XFILLER_251_49 VPWR VGND sg13cmos5l_decap_8
X_2043_ Tile_X0Y5_FrameData_O[28] Tile_X0Y5_FrameData[28] VPWR VGND sg13cmos5l_buf_1
XFILLER_200_42 VPWR VGND sg13cmos5l_decap_8
XFILLER_222_187 VPWR VGND sg13cmos5l_decap_8
XFILLER_22_237 VPWR VGND sg13cmos5l_fill_1
XFILLER_22_259 VPWR VGND sg13cmos5l_fill_1
XFILLER_95_0 VPWR VGND sg13cmos5l_decap_8
XFILLER_200_86 VPWR VGND sg13cmos5l_fill_1
XFILLER_175_242 VPWR VGND sg13cmos5l_fill_1
XFILLER_276_35 VPWR VGND sg13cmos5l_decap_8
XFILLER_135_106 VPWR VGND sg13cmos5l_decap_8
X_1827_ Tile_X0Y4_EE4BEG[10] _2643_/X VPWR VGND sg13cmos5l_buf_1
XFILLER_190_256 VPWR VGND sg13cmos5l_decap_8
XFILLER_209_84 VPWR VGND sg13cmos5l_decap_8
XFILLER_209_95 VPWR VGND sg13cmos5l_fill_1
X_1758_ Tile_X0Y2_FrameData_O[18] Tile_X0Y2_FrameData[18] VPWR VGND sg13cmos5l_buf_1
XFILLER_145_28 VPWR VGND sg13cmos5l_decap_8
XFILLER_289_154 VPWR VGND sg13cmos5l_decap_8
XFILLER_292_56 VPWR VGND sg13cmos5l_decap_8
XFILLER_332_272 VPWR VGND sg13cmos5l_fill_1
X_1689_ Tile_X0Y0_FrameData_O[29] Tile_X0Y0_FrameData[29] VPWR VGND sg13cmos5l_buf_1
X_0709_ _0709_/Q Tile_X0Y2_FrameData[1] VGND VPWR Tile_X0Y5_FrameStrobe[4] latch
XFILLER_57_112 VPWR VGND sg13cmos5l_decap_8
XANTENNA__1989__X Tile_X0Y5_E6BEG[2] VPWR VGND sg13cmos5l_antennanp
XFILLER_161_49 VPWR VGND sg13cmos5l_decap_8
XANTENNA_306 AXIL_S_SOC_WDATA19 VPWR VGND sg13cmos5l_antennanp
XFILLER_173_7 VPWR VGND sg13cmos5l_decap_8
XFILLER_57_189 VPWR VGND sg13cmos5l_decap_8
XFILLER_54_14 VPWR VGND sg13cmos5l_decap_8
XANTENNA_317 Tile_X0Y0_FrameData[31] VPWR VGND sg13cmos5l_antennanp
XFILLER_72_148 VPWR VGND sg13cmos5l_fill_2
XFILLER_340_7 VPWR VGND sg13cmos5l_decap_8
XFILLER_110_42 VPWR VGND sg13cmos5l_decap_8
XFILLER_359_147 VPWR VGND sg13cmos5l_decap_8
XFILLER_70_35 VPWR VGND sg13cmos5l_decap_8
XFILLER_186_35 VPWR VGND sg13cmos5l_decap_8
XFILLER_119_84 VPWR VGND sg13cmos5l_decap_8
XFILLER_134_150 VPWR VGND sg13cmos5l_decap_4
XFILLER_336_49 VPWR VGND sg13cmos5l_decap_8
XFILLER_79_77 VPWR VGND sg13cmos5l_decap_8
XFILLER_0_141 VPWR VGND sg13cmos5l_fill_1
XFILLER_0_152 VPWR VGND sg13cmos5l_fill_1
XFILLER_295_168 VPWR VGND sg13cmos5l_decap_8
XFILLER_297_0 VPWR VGND sg13cmos5l_decap_8
XFILLER_95_21 VPWR VGND sg13cmos5l_decap_8
XFILLER_95_207 VPWR VGND sg13cmos5l_fill_2
XFILLER_48_123 VPWR VGND sg13cmos5l_decap_8
XANTENNA__1899__X Tile_X0Y1_FrameData_O[12] VPWR VGND sg13cmos5l_antennanp
XFILLER_28_70 VPWR VGND sg13cmos5l_decap_8
XFILLER_63_126 VPWR VGND sg13cmos5l_decap_8
XFILLER_301_63 VPWR VGND sg13cmos5l_decap_8
XFILLER_71_192 VPWR VGND sg13cmos5l_decap_8
X_0991_ _0991_/Q Tile_X0Y3_FrameData[23] VGND VPWR Tile_X0Y5_FrameStrobe[6] latch
XFILLER_157_242 VPWR VGND sg13cmos5l_fill_1
X_2730_ _2730_/X AXIL_S_SOC_ARPROT0 AXIL_S_SOC_ARVALID _2827_/X _2799_/X _1442_/Q
+ _1441_/Q VPWR VGND sg13cmos5l_mux4_1
XFILLER_157_264 VPWR VGND sg13cmos5l_decap_8
X_2661_ _2661_/X Tile_X0Y4_W1END[0] Tile_X0Y4_WW4END[12] Tile_X0Y4_W6END[4] _2707_/X
+ _1108_/Q _1107_/Q VPWR VGND sg13cmos5l_mux4_1
X_1612_ Tile_X0Y0_N4BEG[8] _1612_/A VPWR VGND sg13cmos5l_buf_1
XFILLER_132_109 VPWR VGND sg13cmos5l_fill_1
XFILLER_172_267 VPWR VGND sg13cmos5l_fill_1
XFILLER_246_49 VPWR VGND sg13cmos5l_decap_8
X_2592_ _2592_/X _2496_/X _2604_/X _2603_/X _2495_/X _0808_/Q _0807_/Q VPWR VGND sg13cmos5l_mux4_1
X_1543_ Tile_X0Y3_EE4BEG[5] _2530_/X VPWR VGND sg13cmos5l_buf_1
XFILLER_5_63 VPWR VGND sg13cmos5l_decap_8
XFILLER_140_142 VPWR VGND sg13cmos5l_decap_8
XFILLER_286_113 VPWR VGND sg13cmos5l_decap_8
X_1474_ _1474_/Q Tile_X0Y5_FrameData[14] VGND VPWR Tile_X0Y5_FrameStrobe[6] latch
X_0425_ _0425_/Q Tile_X0Y1_FrameData[13] VGND VPWR Tile_X0Y5_FrameStrobe[3] latch
XFILLER_39_112 VPWR VGND sg13cmos5l_decap_8
XFILLER_10_0 VPWR VGND sg13cmos5l_decap_8
XFILLER_227_224 VPWR VGND sg13cmos5l_decap_8
X_0356_ _0356_/Q Tile_X0Y1_FrameData[18] VGND VPWR Tile_X0Y5_FrameStrobe[1] latch
XFILLER_94_240 VPWR VGND sg13cmos5l_decap_8
XANTENNA__1602__X Tile_X0Y2_EE4BEG[15] VPWR VGND sg13cmos5l_antennanp
X_0287_ _0287_/Q Tile_X0Y0_FrameData[7] VGND VPWR Tile_X0Y5_FrameStrobe[6] latch
XFILLER_54_126 VPWR VGND sg13cmos5l_decap_8
XFILLER_342_92 VPWR VGND sg13cmos5l_decap_8
XFILLER_242_227 VPWR VGND sg13cmos5l_fill_1
X_2026_ Tile_X0Y5_FrameData_O[11] Tile_X0Y5_FrameData[11] VPWR VGND sg13cmos5l_buf_1
XFILLER_211_63 VPWR VGND sg13cmos5l_decap_8
XFILLER_24_28 VPWR VGND sg13cmos5l_decap_8
XFILLER_148_242 VPWR VGND sg13cmos5l_decap_8
XFILLER_287_56 VPWR VGND sg13cmos5l_decap_8
XFILLER_40_49 VPWR VGND sg13cmos5l_decap_8
XFILLER_156_49 VPWR VGND sg13cmos5l_decap_8
XFILLER_163_256 VPWR VGND sg13cmos5l_decap_8
XFILLER_116_161 VPWR VGND sg13cmos5l_decap_8
XFILLER_312_209 VPWR VGND sg13cmos5l_fill_2
XFILLER_277_124 VPWR VGND sg13cmos5l_decap_8
XFILLER_49_14 VPWR VGND sg13cmos5l_decap_8
XFILLER_131_142 VPWR VGND sg13cmos5l_decap_8
XFILLER_290_7 VPWR VGND sg13cmos5l_decap_8
XFILLER_77_229 VPWR VGND sg13cmos5l_fill_2
XFILLER_105_42 VPWR VGND sg13cmos5l_decap_8
XFILLER_277_179 VPWR VGND sg13cmos5l_fill_2
XFILLER_292_105 VPWR VGND sg13cmos5l_decap_8
XFILLER_218_235 VPWR VGND sg13cmos5l_decap_8
XFILLER_252_70 VPWR VGND sg13cmos5l_decap_8
XFILLER_85_251 VPWR VGND sg13cmos5l_decap_4
XFILLER_65_35 VPWR VGND sg13cmos5l_decap_8
XFILLER_45_126 VPWR VGND sg13cmos5l_decap_8
XANTENNA_103 AXIL_S_SOC_WDATA27 VPWR VGND sg13cmos5l_antennanp
XANTENNA_114 AXIL_S_SOC_WDATA27 VPWR VGND sg13cmos5l_antennanp
XANTENNA_125 AXIL_S_SOC_WDATA29 VPWR VGND sg13cmos5l_antennanp
XANTENNA_136 AXIL_S_SOC_WDATA30 VPWR VGND sg13cmos5l_antennanp
XANTENNA_147 AXIL_S_SOC_WDATA30 VPWR VGND sg13cmos5l_antennanp
XANTENNA_158 AXIL_S_SOC_WDATA31 VPWR VGND sg13cmos5l_antennanp
XANTENNA_169 AXIL_S_SOC_WDATA8 VPWR VGND sg13cmos5l_antennanp
XFILLER_121_63 VPWR VGND sg13cmos5l_decap_8
XFILLER_201_102 VPWR VGND sg13cmos5l_fill_2
XFILLER_81_78 VPWR VGND sg13cmos5l_decap_8
XFILLER_197_56 VPWR VGND sg13cmos5l_decap_8
XFILLER_201_157 VPWR VGND sg13cmos5l_decap_4
XFILLER_347_128 VPWR VGND sg13cmos5l_decap_8
XFILLER_139_253 VPWR VGND sg13cmos5l_fill_1
XFILLER_347_15 VPWR VGND sg13cmos5l_decap_8
XFILLER_154_212 VPWR VGND sg13cmos5l_decap_8
XFILLER_212_0 VPWR VGND sg13cmos5l_decap_8
XFILLER_355_161 VPWR VGND sg13cmos5l_decap_8
XFILLER_154_267 VPWR VGND sg13cmos5l_decap_4
XFILLER_268_124 VPWR VGND sg13cmos5l_decap_8
XFILLER_283_105 VPWR VGND sg13cmos5l_decap_8
XFILLER_162_70 VPWR VGND sg13cmos5l_decap_8
X_1190_ _1190_/Q Tile_X0Y4_FrameData[0] VGND VPWR Tile_X0Y5_FrameStrobe[4] latch
X_0210_ _0210_/Q Tile_X0Y0_FrameData[20] VGND VPWR Tile_X0Y5_FrameStrobe[4] latch
XFILLER_39_91 VPWR VGND sg13cmos5l_decap_8
XFILLER_209_246 VPWR VGND sg13cmos5l_decap_8
XFILLER_209_257 VPWR VGND sg13cmos5l_fill_1
X_0141_ _0141_/Q Tile_X0Y0_FrameData[25] VGND VPWR Tile_X0Y5_FrameStrobe[2] latch
XFILLER_291_182 VPWR VGND sg13cmos5l_fill_2
XFILLER_91_232 VPWR VGND sg13cmos5l_decap_8
XFILLER_312_84 VPWR VGND sg13cmos5l_decap_8
X_0072_ _0072_/Q Tile_X0Y0_FrameData[30] VGND VPWR Tile_X0Y5_FrameStrobe[0] latch
XFILLER_189_142 VPWR VGND sg13cmos5l_decap_4
XFILLER_232_260 VPWR VGND sg13cmos5l_fill_1
XFILLER_232_271 VPWR VGND sg13cmos5l_fill_2
X_0974_ _0974_/Q Tile_X0Y3_FrameData[8] VGND VPWR Tile_X0Y5_FrameStrobe[5] latch
X_2713_ _2713_/X Tile_X0Y3_W2MID[7] Tile_X0Y3_W2END[7] Tile_X0Y3_W6END[8] _2589_/X
+ _0890_/Q _0889_/Q VPWR VGND sg13cmos5l_mux4_1
X_2644_ _2644_/X AXIL_S_SOC_WSTRB1 AXIL_S_SOC_BREADY _2706_/X _2712_/X _1166_/Q _1165_/Q
+ VPWR VGND sg13cmos5l_mux4_1
XFILLER_337_70 VPWR VGND sg13cmos5l_decap_8
XFILLER_105_109 VPWR VGND sg13cmos5l_fill_2
XFILLER_273_14 VPWR VGND sg13cmos5l_decap_8
X_2575_ _2575_/X _2570_/X Tile_X0Y5_N4END[10] _2569_/X Tile_X0Y0_S4END[14] _0818_/Q
+ _0817_/Q VPWR VGND sg13cmos5l_mux4_1
XFILLER_58_0 VPWR VGND sg13cmos5l_decap_8
XFILLER_302_231 VPWR VGND sg13cmos5l_fill_1
X_1526_ Tile_X0Y3_E6BEG[0] _2541_/X VPWR VGND sg13cmos5l_buf_1
XFILLER_259_124 VPWR VGND sg13cmos5l_decap_8
XFILLER_59_218 VPWR VGND sg13cmos5l_decap_4
XFILLER_19_28 VPWR VGND sg13cmos5l_decap_8
XFILLER_206_63 VPWR VGND sg13cmos5l_decap_8
XFILLER_274_105 VPWR VGND sg13cmos5l_decap_8
X_1457_ _1457_/Q Tile_X0Y5_FrameData[31] VGND VPWR Tile_X0Y5_FrameStrobe[6] latch
X_1388_ _1388_/Q Tile_X0Y5_FrameData[4] VGND VPWR Tile_X0Y5_FrameStrobe[3] latch
X_0408_ _0408_/Q Tile_X0Y1_FrameData[30] VGND VPWR Tile_X0Y5_FrameStrobe[3] latch
XFILLER_353_91 VPWR VGND sg13cmos5l_decap_8
XFILLER_27_126 VPWR VGND sg13cmos5l_decap_4
X_0339_ _0339_/Q Tile_X0Y1_FrameData[3] VGND VPWR Tile_X0Y5_FrameStrobe[0] latch
XFILLER_215_227 VPWR VGND sg13cmos5l_decap_4
XFILLER_82_221 VPWR VGND sg13cmos5l_fill_2
XFILLER_215_238 VPWR VGND sg13cmos5l_decap_8
XFILLER_222_84 VPWR VGND sg13cmos5l_decap_8
XFILLER_35_49 VPWR VGND sg13cmos5l_decap_8
X_2009_ Tile_X0Y5_EE4BEG[10] _2751_/X VPWR VGND sg13cmos5l_buf_1
XFILLER_42_129 VPWR VGND sg13cmos5l_decap_8
XFILLER_35_192 VPWR VGND sg13cmos5l_decap_8
XFILLER_298_77 VPWR VGND sg13cmos5l_decap_8
XFILLER_50_140 VPWR VGND sg13cmos5l_decap_8
XFILLER_136_7 VPWR VGND sg13cmos5l_decap_8
XFILLER_337_172 VPWR VGND sg13cmos5l_fill_2
XFILLER_303_7 VPWR VGND sg13cmos5l_decap_8
XFILLER_183_14 VPWR VGND sg13cmos5l_decap_8
XFILLER_247_70 VPWR VGND sg13cmos5l_decap_8
XFILLER_352_175 VPWR VGND sg13cmos5l_decap_8
XFILLER_104_120 VPWR VGND sg13cmos5l_decap_8
XFILLER_116_63 VPWR VGND sg13cmos5l_decap_8
XFILLER_333_28 VPWR VGND sg13cmos5l_decap_8
XFILLER_263_91 VPWR VGND sg13cmos5l_decap_8
XFILLER_265_116 VPWR VGND sg13cmos5l_decap_4
XFILLER_76_56 VPWR VGND sg13cmos5l_decap_8
XFILLER_58_240 VPWR VGND sg13cmos5l_fill_2
XFILLER_18_126 VPWR VGND sg13cmos5l_decap_8
XFILLER_280_119 VPWR VGND sg13cmos5l_decap_8
XFILLER_73_232 VPWR VGND sg13cmos5l_fill_1
XFILLER_132_84 VPWR VGND sg13cmos5l_decap_8
XFILLER_162_0 VPWR VGND sg13cmos5l_decap_8
XFILLER_273_193 VPWR VGND sg13cmos5l_fill_1
XFILLER_92_77 VPWR VGND sg13cmos5l_decap_8
XFILLER_186_112 VPWR VGND sg13cmos5l_decap_8
XFILLER_214_271 VPWR VGND sg13cmos5l_fill_2
XFILLER_358_14 VPWR VGND sg13cmos5l_decap_8
XANTENNA__2073__X Tile_X0Y5_S4BEG[6] VPWR VGND sg13cmos5l_antennanp
XFILLER_41_184 VPWR VGND sg13cmos5l_fill_1
XFILLER_41_151 VPWR VGND sg13cmos5l_decap_8
XFILLER_186_156 VPWR VGND sg13cmos5l_decap_4
X_0690_ _0690_/Q Tile_X0Y2_FrameData[20] VGND VPWR Tile_X0Y5_FrameStrobe[4] latch
XFILLER_41_81 VPWR VGND sg13cmos5l_decap_8
XFILLER_142_226 VPWR VGND sg13cmos5l_decap_4
XFILLER_157_70 VPWR VGND sg13cmos5l_decap_8
XFILLER_51_7 VPWR VGND sg13cmos5l_decap_8
XFILLER_307_84 VPWR VGND sg13cmos5l_decap_8
X_2360_ _2360_/X _2820_/X _2818_/X _2806_/X _2805_/X _1466_/Q _1465_/Q VPWR VGND sg13cmos5l_mux4_1
XFILLER_110_112 VPWR VGND sg13cmos5l_decap_8
XFILLER_243_28 VPWR VGND sg13cmos5l_decap_8
XFILLER_256_105 VPWR VGND sg13cmos5l_decap_8
X_1311_ _1311_/Q Tile_X0Y5_FrameData[17] VGND VPWR Tile_X0Y5_FrameStrobe[1] latch
X_2291_ _2291_/X _2346_/X _2345_/X AXIL_S_SOC_WDATA0 AXIL_S_SOC_WDATA5 _0510_/Q _0509_/Q
+ VPWR VGND sg13cmos5l_mux4_1
XFILLER_173_91 VPWR VGND sg13cmos5l_decap_8
XFILLER_2_42 VPWR VGND sg13cmos5l_decap_8
X_1242_ _1242_/Q Tile_X0Y4_FrameData[12] VGND VPWR Tile_X0Y5_FrameStrobe[6] latch
X_1173_ _1173_/Q Tile_X0Y4_FrameData[17] VGND VPWR Tile_X0Y5_FrameStrobe[4] latch
XFILLER_64_221 VPWR VGND sg13cmos5l_decap_8
X_0124_ _0124_/Q Tile_X0Y0_FrameData[10] VGND VPWR Tile_X0Y5_FrameStrobe[1] latch
XFILLER_17_181 VPWR VGND sg13cmos5l_fill_1
X_0055_ _1609_/A _2277_/X _2278_/X _0761_/Q VPWR VGND sg13cmos5l_mux2_1
XANTENNA_14 AXIL_S_SOC_WDATA10 VPWR VGND sg13cmos5l_antennanp
XFILLER_177_112 VPWR VGND sg13cmos5l_decap_8
XFILLER_268_14 VPWR VGND sg13cmos5l_decap_8
XANTENNA_25 AXIL_S_SOC_WDATA11 VPWR VGND sg13cmos5l_antennanp
XANTENNA_36 AXIL_S_SOC_WDATA11 VPWR VGND sg13cmos5l_antennanp
XANTENNA_47 AXIL_S_SOC_WDATA15 VPWR VGND sg13cmos5l_antennanp
XANTENNA_58 AXIL_S_SOC_WDATA16 VPWR VGND sg13cmos5l_antennanp
XANTENNA_69 AXIL_S_SOC_WDATA23 VPWR VGND sg13cmos5l_antennanp
X_0957_ _0957_/Q Tile_X0Y3_FrameData[25] VGND VPWR Tile_X0Y5_FrameStrobe[5] latch
XFILLER_118_234 VPWR VGND sg13cmos5l_decap_8
XFILLER_348_91 VPWR VGND sg13cmos5l_decap_8
XFILLER_284_35 VPWR VGND sg13cmos5l_decap_8
X_0888_ _0888_/Q Tile_X0Y3_FrameData[30] VGND VPWR Tile_X0Y5_FrameStrobe[3] latch
XFILLER_334_186 VPWR VGND sg13cmos5l_fill_2
X_2627_ _2627_/X AXIL_S_SOC_WSTRB2 AXIL_S_SOC_WVALID _2710_/X _2683_/X _1200_/Q _1199_/Q
+ VPWR VGND sg13cmos5l_mux4_1
XFILLER_217_84 VPWR VGND sg13cmos5l_decap_8
XFILLER_287_230 VPWR VGND sg13cmos5l_decap_8
X_2558_ _2558_/X _2584_/X _2582_/X _2576_/X _2575_/X _0868_/Q _0867_/Q VPWR VGND sg13cmos5l_mux4_1
XFILLER_99_162 VPWR VGND sg13cmos5l_decap_8
XFILLER_99_140 VPWR VGND sg13cmos5l_decap_8
XFILLER_101_112 VPWR VGND sg13cmos5l_decap_8
XFILLER_153_28 VPWR VGND sg13cmos5l_decap_8
XFILLER_247_105 VPWR VGND sg13cmos5l_decap_8
X_1509_ _2669_/A3 VPWR VGND sg13cmos5l_tielo
X_2489_ _2489_/X Tile_X0Y1_W2MID[7] Tile_X0Y1_W2END[7] Tile_X0Y1_W6END[8] _2373_/X
+ _0410_/Q _0409_/Q VPWR VGND sg13cmos5l_mux4_1
XFILLER_99_184 VPWR VGND sg13cmos5l_decap_8
XFILLER_46_15 VPWR VGND sg13cmos5l_decap_8
XFILLER_55_210 VPWR VGND sg13cmos5l_decap_8
XANTENNA__1997__X Tile_X0Y5_E6BEG[10] VPWR VGND sg13cmos5l_antennanp
XFILLER_102_21 VPWR VGND sg13cmos5l_decap_8
XFILLER_203_219 VPWR VGND sg13cmos5l_decap_8
XFILLER_253_7 VPWR VGND sg13cmos5l_decap_8
XFILLER_270_141 VPWR VGND sg13cmos5l_decap_8
XFILLER_70_235 VPWR VGND sg13cmos5l_fill_2
XFILLER_62_14 VPWR VGND sg13cmos5l_decap_8
XFILLER_102_98 VPWR VGND sg13cmos5l_decap_8
XFILLER_168_112 VPWR VGND sg13cmos5l_decap_8
XFILLER_178_14 VPWR VGND sg13cmos5l_decap_8
XFILLER_168_156 VPWR VGND sg13cmos5l_decap_8
XFILLER_183_126 VPWR VGND sg13cmos5l_decap_8
XFILLER_328_28 VPWR VGND sg13cmos5l_decap_8
XFILLER_258_91 VPWR VGND sg13cmos5l_decap_8
XFILLER_194_35 VPWR VGND sg13cmos5l_decap_8
XFILLER_11_84 VPWR VGND sg13cmos5l_decap_8
XFILLER_340_112 VPWR VGND sg13cmos5l_decap_8
XFILLER_127_84 VPWR VGND sg13cmos5l_decap_8
XFILLER_344_49 VPWR VGND sg13cmos5l_decap_8
XFILLER_132_270 VPWR VGND sg13cmos5l_fill_2
XFILLER_238_105 VPWR VGND sg13cmos5l_decap_8
XFILLER_87_77 VPWR VGND sg13cmos5l_decap_8
XFILLER_340_189 VPWR VGND sg13cmos5l_decap_8
XFILLER_293_200 VPWR VGND sg13cmos5l_decap_8
XFILLER_143_72 VPWR VGND sg13cmos5l_fill_1
XANTENNA__2068__X Tile_X0Y5_S4BEG[1] VPWR VGND sg13cmos5l_antennanp
XFILLER_46_210 VPWR VGND sg13cmos5l_decap_8
XFILLER_261_163 VPWR VGND sg13cmos5l_decap_8
XFILLER_36_70 VPWR VGND sg13cmos5l_decap_8
XANTENNA__1700__X Tile_X0Y0_EE4BEG[8] VPWR VGND sg13cmos5l_antennanp
XFILLER_14_140 VPWR VGND sg13cmos5l_decap_8
XFILLER_199_270 VPWR VGND sg13cmos5l_fill_2
XFILLER_99_7 VPWR VGND sg13cmos5l_decap_8
XFILLER_159_156 VPWR VGND sg13cmos5l_decap_8
XFILLER_159_167 VPWR VGND sg13cmos5l_fill_1
XFILLER_202_252 VPWR VGND sg13cmos5l_decap_8
X_1860_ Tile_X0Y4_FrameData_O[27] Tile_X0Y4_FrameData[27] VPWR VGND sg13cmos5l_buf_1
XFILLER_348_256 VPWR VGND sg13cmos5l_decap_4
XFILLER_159_189 VPWR VGND sg13cmos5l_decap_8
XFILLER_174_126 VPWR VGND sg13cmos5l_decap_8
XFILLER_238_28 VPWR VGND sg13cmos5l_decap_8
X_1791_ Tile_X0Y4_E2BEG[2] _2619_/X VPWR VGND sg13cmos5l_buf_1
X_0811_ _0811_/Q Tile_X0Y3_FrameData[11] VGND VPWR Tile_X0Y5_FrameStrobe[0] latch
XFILLER_52_91 VPWR VGND sg13cmos5l_decap_8
XFILLER_168_91 VPWR VGND sg13cmos5l_decap_8
X_0742_ _0742_/Q Tile_X0Y2_FrameData[0] VGND VPWR Tile_X0Y5_FrameStrobe[5] latch
XFILLER_115_215 VPWR VGND sg13cmos5l_decap_8
XFILLER_182_170 VPWR VGND sg13cmos5l_fill_1
XFILLER_182_181 VPWR VGND sg13cmos5l_decap_8
X_0673_ _0673_/Q Tile_X0Y2_FrameData[5] VGND VPWR Tile_X0Y5_FrameStrobe[3] latch
XFILLER_130_207 VPWR VGND sg13cmos5l_fill_2
XFILLER_254_49 VPWR VGND sg13cmos5l_decap_8
X_2412_ _2412_/X AXIL_S_SOC_AWADDR3 AXIL_S_SOC_AWPROT1 _2484_/X _2485_/X _0724_/Q
+ _0723_/Q VPWR VGND sg13cmos5l_mux4_1
XFILLER_269_241 VPWR VGND sg13cmos5l_decap_8
X_2343_ _2343_/X Tile_X0Y0_W1END[1] Tile_X0Y0_W6END[9] _2225_/X _2210_/X _0176_/Q
+ _0175_/Q VPWR VGND sg13cmos5l_mux4_1
XFILLER_229_105 VPWR VGND sg13cmos5l_decap_8
XFILLER_284_222 VPWR VGND sg13cmos5l_decap_8
X_2274_ _2274_/X _2475_/X _2473_/X _2466_/X _2465_/X _0757_/Q _0756_/Q VPWR VGND sg13cmos5l_mux4_1
XFILLER_244_119 VPWR VGND sg13cmos5l_decap_8
X_1225_ _1225_/Q Tile_X0Y4_FrameData[29] VGND VPWR Tile_X0Y5_FrameStrobe[6] latch
XFILLER_203_42 VPWR VGND sg13cmos5l_decap_8
XFILLER_237_182 VPWR VGND sg13cmos5l_decap_8
X_1156_ _1156_/Q Tile_X0Y4_FrameData[2] VGND VPWR Tile_X0Y5_FrameStrobe[3] latch
XFILLER_37_265 VPWR VGND sg13cmos5l_decap_8
XFILLER_350_70 VPWR VGND sg13cmos5l_decap_8
XFILLER_252_163 VPWR VGND sg13cmos5l_decap_4
X_0107_ _0107_/Q Tile_X0Y0_FrameData[27] VGND VPWR Tile_X0Y5_FrameStrobe[1] latch
XFILLER_52_224 VPWR VGND sg13cmos5l_decap_8
XANTENNA__1610__X Tile_X0Y0_N4BEG[6] VPWR VGND sg13cmos5l_antennanp
XFILLER_279_35 VPWR VGND sg13cmos5l_decap_8
X_1087_ _1087_/Q Tile_X0Y4_FrameData[7] VGND VPWR Tile_X0Y5_FrameStrobe[1] latch
X_0038_ _2081_/A _2785_/X _2786_/X _1332_/Q VPWR VGND sg13cmos5l_mux2_1
XFILLER_32_28 VPWR VGND sg13cmos5l_decap_8
XFILLER_148_28 VPWR VGND sg13cmos5l_decap_8
XFILLER_165_148 VPWR VGND sg13cmos5l_decap_8
XFILLER_295_56 VPWR VGND sg13cmos5l_decap_8
X_1989_ Tile_X0Y5_E6BEG[2] _2759_/X VPWR VGND sg13cmos5l_buf_1
XFILLER_307_175 VPWR VGND sg13cmos5l_decap_8
XFILLER_322_112 VPWR VGND sg13cmos5l_decap_8
XFILLER_164_49 VPWR VGND sg13cmos5l_decap_8
XFILLER_87_121 VPWR VGND sg13cmos5l_decap_8
XFILLER_57_14 VPWR VGND sg13cmos5l_decap_8
XFILLER_235_119 VPWR VGND sg13cmos5l_decap_8
XFILLER_87_198 VPWR VGND sg13cmos5l_decap_8
XFILLER_113_42 VPWR VGND sg13cmos5l_decap_8
XFILLER_28_243 VPWR VGND sg13cmos5l_decap_8
XFILLER_260_70 VPWR VGND sg13cmos5l_decap_8
XFILLER_73_35 VPWR VGND sg13cmos5l_decap_8
XFILLER_189_35 VPWR VGND sg13cmos5l_decap_8
XFILLER_43_235 VPWR VGND sg13cmos5l_decap_4
XFILLER_339_49 VPWR VGND sg13cmos5l_decap_8
XFILLER_11_154 VPWR VGND sg13cmos5l_decap_8
XFILLER_156_126 VPWR VGND sg13cmos5l_decap_8
XFILLER_345_204 VPWR VGND sg13cmos5l_fill_2
XFILLER_125_0 VPWR VGND sg13cmos5l_decap_8
XFILLER_360_218 VPWR VGND sg13cmos5l_decap_8
XFILLER_313_112 VPWR VGND sg13cmos5l_decap_8
XFILLER_98_21 VPWR VGND sg13cmos5l_decap_8
XFILLER_353_270 VPWR VGND sg13cmos5l_fill_2
XFILLER_98_98 VPWR VGND sg13cmos5l_decap_8
XFILLER_266_211 VPWR VGND sg13cmos5l_fill_1
XFILLER_78_143 VPWR VGND sg13cmos5l_decap_8
XFILLER_14_7 VPWR VGND sg13cmos5l_decap_8
XFILLER_304_63 VPWR VGND sg13cmos5l_decap_8
XFILLER_281_258 VPWR VGND sg13cmos5l_fill_1
X_1010_ _1010_/Q Tile_X0Y3_FrameData[4] VGND VPWR Tile_X0Y5_FrameStrobe[6] latch
XFILLER_93_157 VPWR VGND sg13cmos5l_decap_8
XFILLER_47_91 VPWR VGND sg13cmos5l_decap_8
XFILLER_170_70 VPWR VGND sg13cmos5l_decap_8
XFILLER_179_229 VPWR VGND sg13cmos5l_decap_8
XFILLER_34_257 VPWR VGND sg13cmos5l_fill_1
XFILLER_34_246 VPWR VGND sg13cmos5l_decap_8
XFILLER_320_84 VPWR VGND sg13cmos5l_decap_8
XFILLER_34_268 VPWR VGND sg13cmos5l_decap_4
X_1912_ Tile_X0Y1_FrameData_O[25] Tile_X0Y1_FrameData[25] VPWR VGND sg13cmos5l_buf_1
XFILLER_249_49 VPWR VGND sg13cmos5l_decap_8
XFILLER_147_148 VPWR VGND sg13cmos5l_decap_8
XFILLER_147_159 VPWR VGND sg13cmos5l_fill_1
X_1843_ Tile_X0Y4_FrameData_O[10] Tile_X0Y4_FrameData[10] VPWR VGND sg13cmos5l_buf_1
XFILLER_8_63 VPWR VGND sg13cmos5l_decap_8
X_1774_ Tile_X0Y2_E1BEG[1] _2398_/X VPWR VGND sg13cmos5l_buf_1
XFILLER_304_112 VPWR VGND sg13cmos5l_decap_8
X_0725_ _0725_/Q Tile_X0Y2_FrameData[17] VGND VPWR Tile_X0Y5_FrameStrobe[5] latch
XFILLER_103_207 VPWR VGND sg13cmos5l_decap_8
XFILLER_170_140 VPWR VGND sg13cmos5l_decap_8
X_0656_ _0656_/Q Tile_X0Y2_FrameData[22] VGND VPWR Tile_X0Y5_FrameStrobe[3] latch
XFILLER_170_162 VPWR VGND sg13cmos5l_decap_8
XFILLER_170_173 VPWR VGND sg13cmos5l_fill_1
XFILLER_304_189 VPWR VGND sg13cmos5l_decap_4
XFILLER_40_0 VPWR VGND sg13cmos5l_decap_8
XFILLER_345_70 VPWR VGND sg13cmos5l_decap_8
XANTENNA__1605__X Tile_X0Y0_N4BEG[1] VPWR VGND sg13cmos5l_antennanp
XFILLER_257_211 VPWR VGND sg13cmos5l_decap_8
XFILLER_281_14 VPWR VGND sg13cmos5l_decap_8
X_0587_ _0587_/Q Tile_X0Y2_FrameData[27] VGND VPWR Tile_X0Y5_FrameStrobe[1] latch
X_2326_ _2326_/X _0031_/X Tile_X0Y0_S4END[5] _2354_/X _2353_/X _0440_/Q _0439_/Q VPWR
+ VGND sg13cmos5l_mux4_1
XFILLER_214_63 VPWR VGND sg13cmos5l_decap_8
X_2257_ _2257_/X Tile_X0Y2_W2MID[3] Tile_X0Y2_W2END[3] Tile_X0Y2_W6END[3] _2485_/X
+ _0774_/Q _0773_/Q VPWR VGND sg13cmos5l_mux4_1
XFILLER_84_113 VPWR VGND sg13cmos5l_decap_8
XFILLER_69_198 VPWR VGND sg13cmos5l_fill_2
XFILLER_69_187 VPWR VGND sg13cmos5l_decap_8
XFILLER_27_28 VPWR VGND sg13cmos5l_decap_8
X_1208_ _1208_/Q Tile_X0Y4_FrameData[14] VGND VPWR Tile_X0Y5_FrameStrobe[5] latch
XFILLER_84_179 VPWR VGND sg13cmos5l_decap_8
X_2188_ _2188_/X AXIL_S_SOC_WDATA23 AXIL_S_SOC_WDATA27 _2230_/X _2241_/X _0220_/Q
+ _0219_/Q VPWR VGND sg13cmos5l_mux4_1
X_1139_ _1139_/Q Tile_X0Y4_FrameData[19] VGND VPWR Tile_X0Y5_FrameStrobe[3] latch
XFILLER_230_84 VPWR VGND sg13cmos5l_decap_8
XFILLER_240_133 VPWR VGND sg13cmos5l_decap_8
XFILLER_43_49 VPWR VGND sg13cmos5l_decap_8
XFILLER_159_49 VPWR VGND sg13cmos5l_decap_8
XFILLER_138_137 VPWR VGND sg13cmos5l_decap_8
XFILLER_153_107 VPWR VGND sg13cmos5l_decap_8
XFILLER_216_7 VPWR VGND sg13cmos5l_decap_8
XFILLER_146_170 VPWR VGND sg13cmos5l_fill_2
XFILLER_108_42 VPWR VGND sg13cmos5l_decap_8
XFILLER_350_240 VPWR VGND sg13cmos5l_decap_8
XFILLER_255_70 VPWR VGND sg13cmos5l_decap_8
XFILLER_68_35 VPWR VGND sg13cmos5l_decap_8
XFILLER_191_14 VPWR VGND sg13cmos5l_decap_8
XFILLER_310_126 VPWR VGND sg13cmos5l_decap_8
XFILLER_248_255 VPWR VGND sg13cmos5l_fill_2
XFILLER_124_63 VPWR VGND sg13cmos5l_decap_8
XFILLER_341_28 VPWR VGND sg13cmos5l_decap_8
XFILLER_263_225 VPWR VGND sg13cmos5l_fill_2
XFILLER_271_91 VPWR VGND sg13cmos5l_decap_4
XFILLER_84_56 VPWR VGND sg13cmos5l_decap_8
XFILLER_16_213 VPWR VGND sg13cmos5l_fill_2
XFILLER_216_174 VPWR VGND sg13cmos5l_decap_8
XFILLER_140_84 VPWR VGND sg13cmos5l_fill_2
XFILLER_231_133 VPWR VGND sg13cmos5l_decap_8
XFILLER_242_0 VPWR VGND sg13cmos5l_decap_8
XFILLER_33_71 VPWR VGND sg13cmos5l_decap_8
XANTENNA__2081__X Tile_X0Y5_S4BEG[14] VPWR VGND sg13cmos5l_antennanp
XFILLER_298_133 VPWR VGND sg13cmos5l_decap_8
X_0510_ _0510_/Q Tile_X0Y1_FrameData[24] VGND VPWR Tile_X0Y5_FrameStrobe[6] latch
X_1490_ _1490_/Q Tile_X0Y5_FrameData[30] VGND VPWR Tile_X0Y5_FrameStrobe[7] latch
XFILLER_165_92 VPWR VGND sg13cmos5l_decap_8
XFILLER_301_126 VPWR VGND sg13cmos5l_decap_8
X_0441_ _0441_/Q Tile_X0Y1_FrameData[29] VGND VPWR Tile_X0Y5_FrameStrobe[4] latch
XFILLER_98_249 VPWR VGND sg13cmos5l_decap_8
XFILLER_315_84 VPWR VGND sg13cmos5l_decap_8
X_0372_ _0372_/Q Tile_X0Y1_FrameData[2] VGND VPWR Tile_X0Y5_FrameStrobe[1] latch
XFILLER_251_28 VPWR VGND sg13cmos5l_decap_8
X_2111_ AXIL_S_SOC_RDATA5 Tile_X0Y3_W2MID[5] Tile_X0Y3_W2END[5] Tile_X0Y3_W6END[5]
+ _2594_/X _0852_/Q _0851_/Q VPWR VGND sg13cmos5l_mux4_1
XFILLER_181_91 VPWR VGND sg13cmos5l_decap_8
XFILLER_254_225 VPWR VGND sg13cmos5l_fill_1
X_2042_ Tile_X0Y5_FrameData_O[27] Tile_X0Y5_FrameData[27] VPWR VGND sg13cmos5l_buf_1
XFILLER_207_174 VPWR VGND sg13cmos5l_decap_4
XFILLER_22_205 VPWR VGND sg13cmos5l_decap_8
XFILLER_200_21 VPWR VGND sg13cmos5l_decap_8
XFILLER_222_166 VPWR VGND sg13cmos5l_decap_8
XFILLER_175_210 VPWR VGND sg13cmos5l_decap_8
XFILLER_88_0 VPWR VGND sg13cmos5l_decap_8
XFILLER_276_14 VPWR VGND sg13cmos5l_decap_8
X_1826_ Tile_X0Y4_EE4BEG[9] _2642_/X VPWR VGND sg13cmos5l_buf_1
XFILLER_190_213 VPWR VGND sg13cmos5l_decap_4
XFILLER_190_246 VPWR VGND sg13cmos5l_fill_2
XFILLER_209_63 VPWR VGND sg13cmos5l_decap_8
XFILLER_190_268 VPWR VGND sg13cmos5l_decap_4
XFILLER_289_133 VPWR VGND sg13cmos5l_decap_8
X_1757_ Tile_X0Y2_FrameData_O[17] Tile_X0Y2_FrameData[17] VPWR VGND sg13cmos5l_buf_1
XFILLER_356_91 VPWR VGND sg13cmos5l_decap_8
XFILLER_143_184 VPWR VGND sg13cmos5l_decap_8
XFILLER_292_35 VPWR VGND sg13cmos5l_decap_8
X_1688_ Tile_X0Y0_FrameData_O[28] Tile_X0Y0_FrameData[28] VPWR VGND sg13cmos5l_buf_1
X_0708_ _0708_/Q Tile_X0Y2_FrameData[2] VGND VPWR Tile_X0Y5_FrameStrobe[4] latch
XFILLER_89_227 VPWR VGND sg13cmos5l_decap_4
XFILLER_289_199 VPWR VGND sg13cmos5l_decap_8
X_0639_ _0639_/Q Tile_X0Y2_FrameData[7] VGND VPWR Tile_X0Y5_FrameStrobe[2] latch
XFILLER_225_84 VPWR VGND sg13cmos5l_decap_8
XFILLER_161_28 VPWR VGND sg13cmos5l_decap_8
X_2309_ _2309_/X AXIL_S_SOC_WDATA0 AXIL_S_SOC_WDATA12 _2349_/X _2380_/X _0474_/Q _0473_/Q
+ VPWR VGND sg13cmos5l_mux4_1
XFILLER_97_271 VPWR VGND sg13cmos5l_fill_2
XFILLER_38_49 VPWR VGND sg13cmos5l_decap_8
XFILLER_57_168 VPWR VGND sg13cmos5l_decap_8
XANTENNA_307 _1614_/A VPWR VGND sg13cmos5l_antennanp
XFILLER_72_105 VPWR VGND sg13cmos5l_decap_8
XANTENNA_318 Tile_X0Y0_FrameData[31] VPWR VGND sg13cmos5l_antennanp
XFILLER_166_7 VPWR VGND sg13cmos5l_decap_8
XFILLER_359_126 VPWR VGND sg13cmos5l_decap_8
XFILLER_110_21 VPWR VGND sg13cmos5l_decap_8
XFILLER_80_182 VPWR VGND sg13cmos5l_decap_8
XFILLER_166_210 VPWR VGND sg13cmos5l_decap_8
XFILLER_333_7 VPWR VGND sg13cmos5l_decap_8
XFILLER_70_14 VPWR VGND sg13cmos5l_decap_8
XFILLER_110_98 VPWR VGND sg13cmos5l_decap_8
XFILLER_186_14 VPWR VGND sg13cmos5l_decap_8
XFILLER_119_63 VPWR VGND sg13cmos5l_decap_8
XFILLER_336_28 VPWR VGND sg13cmos5l_decap_8
XFILLER_266_91 VPWR VGND sg13cmos5l_decap_8
XFILLER_134_162 VPWR VGND sg13cmos5l_decap_8
XFILLER_134_173 VPWR VGND sg13cmos5l_fill_1
XFILLER_79_56 VPWR VGND sg13cmos5l_decap_8
XFILLER_295_147 VPWR VGND sg13cmos5l_decap_8
XFILLER_95_219 VPWR VGND sg13cmos5l_decap_8
XFILLER_352_49 VPWR VGND sg13cmos5l_decap_8
XFILLER_135_84 VPWR VGND sg13cmos5l_decap_8
XFILLER_192_0 VPWR VGND sg13cmos5l_decap_8
XFILLER_88_271 VPWR VGND sg13cmos5l_fill_2
XFILLER_48_102 VPWR VGND sg13cmos5l_decap_8
XFILLER_236_225 VPWR VGND sg13cmos5l_decap_8
XFILLER_236_236 VPWR VGND sg13cmos5l_fill_1
XFILLER_95_77 VPWR VGND sg13cmos5l_fill_2
XFILLER_63_105 VPWR VGND sg13cmos5l_decap_8
XFILLER_48_179 VPWR VGND sg13cmos5l_decap_8
XANTENNA__2076__X Tile_X0Y5_S4BEG[9] VPWR VGND sg13cmos5l_antennanp
XFILLER_251_217 VPWR VGND sg13cmos5l_decap_4
XFILLER_251_228 VPWR VGND sg13cmos5l_decap_4
XFILLER_204_111 VPWR VGND sg13cmos5l_decap_8
XFILLER_204_144 VPWR VGND sg13cmos5l_fill_2
XFILLER_301_42 VPWR VGND sg13cmos5l_decap_8
XFILLER_71_171 VPWR VGND sg13cmos5l_decap_8
XFILLER_204_188 VPWR VGND sg13cmos5l_decap_8
X_0990_ _0990_/Q Tile_X0Y3_FrameData[24] VGND VPWR Tile_X0Y5_FrameStrobe[6] latch
XFILLER_44_81 VPWR VGND sg13cmos5l_decap_8
XFILLER_172_202 VPWR VGND sg13cmos5l_decap_8
X_2660_ _2660_/X AXIL_S_SOC_WSTRB3 _2707_/X _2706_/X _2681_/X _1134_/Q _1133_/Q VPWR
+ VGND sg13cmos5l_mux4_1
XFILLER_246_28 VPWR VGND sg13cmos5l_decap_8
X_1611_ Tile_X0Y0_N4BEG[7] _1611_/A VPWR VGND sg13cmos5l_buf_1
XFILLER_60_91 VPWR VGND sg13cmos5l_decap_8
XFILLER_125_140 VPWR VGND sg13cmos5l_fill_1
XFILLER_172_246 VPWR VGND sg13cmos5l_fill_2
XFILLER_176_91 VPWR VGND sg13cmos5l_decap_8
X_2591_ _2591_/X _2494_/X _2602_/X _2601_/X _2493_/X _0810_/Q _0809_/Q VPWR VGND sg13cmos5l_mux4_1
XFILLER_125_173 VPWR VGND sg13cmos5l_fill_1
X_1542_ Tile_X0Y3_EE4BEG[4] _2529_/X VPWR VGND sg13cmos5l_buf_1
XFILLER_5_42 VPWR VGND sg13cmos5l_decap_8
XFILLER_125_195 VPWR VGND sg13cmos5l_decap_8
XFILLER_140_121 VPWR VGND sg13cmos5l_decap_8
X_1473_ _1473_/Q Tile_X0Y5_FrameData[15] VGND VPWR Tile_X0Y5_FrameStrobe[6] latch
X_0424_ _0424_/Q Tile_X0Y1_FrameData[14] VGND VPWR Tile_X0Y5_FrameStrobe[3] latch
XFILLER_262_49 VPWR VGND sg13cmos5l_decap_8
X_0355_ _0355_/Q Tile_X0Y1_FrameData[19] VGND VPWR Tile_X0Y5_FrameStrobe[1] latch
XFILLER_342_71 VPWR VGND sg13cmos5l_decap_8
X_0286_ _0286_/Q Tile_X0Y0_FrameData[8] VGND VPWR Tile_X0Y5_FrameStrobe[6] latch
XFILLER_54_105 VPWR VGND sg13cmos5l_decap_8
X_2025_ Tile_X0Y5_FrameData_O[10] Tile_X0Y5_FrameData[10] VPWR VGND sg13cmos5l_buf_1
XFILLER_47_190 VPWR VGND sg13cmos5l_decap_8
XFILLER_211_42 VPWR VGND sg13cmos5l_decap_8
XFILLER_250_272 VPWR VGND sg13cmos5l_fill_1
XFILLER_287_35 VPWR VGND sg13cmos5l_decap_8
XFILLER_108_118 VPWR VGND sg13cmos5l_decap_8
XFILLER_163_235 VPWR VGND sg13cmos5l_decap_8
XFILLER_40_28 VPWR VGND sg13cmos5l_decap_8
XFILLER_116_140 VPWR VGND sg13cmos5l_decap_8
XFILLER_156_28 VPWR VGND sg13cmos5l_decap_8
X_1809_ Tile_X0Y4_E6BEG[4] _2653_/X VPWR VGND sg13cmos5l_buf_1
X_2789_ _2789_/X Tile_X0Y5_N1END[0] _2793_/X Tile_X0Y5_W6END[0] _2789_/A3 _1272_/Q
+ _1271_/Q VPWR VGND sg13cmos5l_mux4_1
XFILLER_131_121 VPWR VGND sg13cmos5l_decap_8
XFILLER_277_158 VPWR VGND sg13cmos5l_decap_8
XFILLER_105_21 VPWR VGND sg13cmos5l_decap_8
XFILLER_172_49 VPWR VGND sg13cmos5l_decap_8
XFILLER_283_7 VPWR VGND sg13cmos5l_decap_8
XFILLER_85_230 VPWR VGND sg13cmos5l_decap_8
XFILLER_65_14 VPWR VGND sg13cmos5l_decap_8
XFILLER_105_98 VPWR VGND sg13cmos5l_decap_8
XFILLER_45_105 VPWR VGND sg13cmos5l_decap_4
XANTENNA_104 AXIL_S_SOC_WDATA27 VPWR VGND sg13cmos5l_antennanp
XANTENNA_115 AXIL_S_SOC_WDATA27 VPWR VGND sg13cmos5l_antennanp
XANTENNA_126 AXIL_S_SOC_WDATA29 VPWR VGND sg13cmos5l_antennanp
XANTENNA_137 AXIL_S_SOC_WDATA30 VPWR VGND sg13cmos5l_antennanp
XANTENNA_148 AXIL_S_SOC_WDATA30 VPWR VGND sg13cmos5l_antennanp
XFILLER_121_42 VPWR VGND sg13cmos5l_decap_8
XFILLER_60_119 VPWR VGND sg13cmos5l_decap_8
XANTENNA_159 AXIL_S_SOC_WDATA31 VPWR VGND sg13cmos5l_antennanp
XFILLER_198_154 VPWR VGND sg13cmos5l_fill_2
XFILLER_53_182 VPWR VGND sg13cmos5l_decap_8
XFILLER_197_35 VPWR VGND sg13cmos5l_decap_8
XFILLER_201_136 VPWR VGND sg13cmos5l_decap_8
XFILLER_241_272 VPWR VGND sg13cmos5l_fill_1
XFILLER_81_57 VPWR VGND sg13cmos5l_decap_8
XFILLER_347_107 VPWR VGND sg13cmos5l_decap_8
XFILLER_139_232 VPWR VGND sg13cmos5l_decap_8
XFILLER_201_169 VPWR VGND sg13cmos5l_decap_8
XFILLER_14_84 VPWR VGND sg13cmos5l_decap_8
XFILLER_355_140 VPWR VGND sg13cmos5l_decap_8
XFILLER_205_0 VPWR VGND sg13cmos5l_decap_8
XFILLER_107_173 VPWR VGND sg13cmos5l_decap_8
XFILLER_107_195 VPWR VGND sg13cmos5l_fill_2
XFILLER_122_154 VPWR VGND sg13cmos5l_decap_8
XFILLER_146_94 VPWR VGND sg13cmos5l_decap_8
XANTENNA__1703__X Tile_X0Y0_EE4BEG[11] VPWR VGND sg13cmos5l_antennanp
XFILLER_283_128 VPWR VGND sg13cmos5l_fill_1
XFILLER_39_70 VPWR VGND sg13cmos5l_decap_8
X_0140_ _0140_/Q Tile_X0Y0_FrameData[26] VGND VPWR Tile_X0Y5_FrameStrobe[2] latch
XFILLER_91_200 VPWR VGND sg13cmos5l_decap_8
XFILLER_36_105 VPWR VGND sg13cmos5l_decap_8
XFILLER_291_161 VPWR VGND sg13cmos5l_decap_8
XFILLER_312_63 VPWR VGND sg13cmos5l_decap_8
X_0071_ _0071_/X _2690_/X _2691_/X _0149_/Q VPWR VGND sg13cmos5l_mux2_1
XFILLER_224_239 VPWR VGND sg13cmos5l_decap_4
XFILLER_51_119 VPWR VGND sg13cmos5l_decap_8
XFILLER_55_91 VPWR VGND sg13cmos5l_decap_8
XFILLER_189_176 VPWR VGND sg13cmos5l_fill_2
X_2712_ _2712_/X _2606_/X Tile_X0Y5_N2MID[4] _2717_/X _2605_/X _1046_/Q _1045_/Q VPWR
+ VGND sg13cmos5l_mux4_1
X_0973_ _0973_/Q Tile_X0Y3_FrameData[9] VGND VPWR Tile_X0Y5_FrameStrobe[5] latch
XFILLER_200_180 VPWR VGND sg13cmos5l_decap_8
XFILLER_257_49 VPWR VGND sg13cmos5l_decap_8
X_2643_ _2643_/X AXIL_S_SOC_WSTRB0 AXIL_S_SOC_WVALID _2704_/X _2683_/X _1168_/Q _1167_/Q
+ VPWR VGND sg13cmos5l_mux4_1
XFILLER_160_227 VPWR VGND sg13cmos5l_decap_8
X_2574_ _2574_/X _2572_/X Tile_X0Y5_N4END[11] _2571_/X Tile_X0Y0_S4END[15] _0824_/Q
+ _0823_/Q VPWR VGND sg13cmos5l_mux4_1
XFILLER_160_238 VPWR VGND sg13cmos5l_fill_1
XFILLER_299_272 VPWR VGND sg13cmos5l_fill_1
XFILLER_302_210 VPWR VGND sg13cmos5l_decap_8
X_1525_ Tile_X0Y3_E2BEGb[7] _2524_/X VPWR VGND sg13cmos5l_buf_1
XFILLER_113_154 VPWR VGND sg13cmos5l_decap_4
XFILLER_206_42 VPWR VGND sg13cmos5l_decap_8
XFILLER_259_169 VPWR VGND sg13cmos5l_decap_8
X_1456_ _1456_/Q Tile_X0Y5_FrameData[0] VGND VPWR Tile_X0Y5_FrameStrobe[5] latch
XFILLER_353_70 VPWR VGND sg13cmos5l_decap_8
XANTENNA__1613__X Tile_X0Y0_N4BEG[9] VPWR VGND sg13cmos5l_antennanp
X_1387_ _1387_/Q Tile_X0Y5_FrameData[5] VGND VPWR Tile_X0Y5_FrameStrobe[3] latch
X_0407_ _0407_/Q Tile_X0Y1_FrameData[31] VGND VPWR Tile_X0Y5_FrameStrobe[3] latch
XFILLER_27_105 VPWR VGND sg13cmos5l_decap_8
X_0338_ _0338_/Q Tile_X0Y1_FrameData[4] VGND VPWR Tile_X0Y5_FrameStrobe[0] latch
XFILLER_215_206 VPWR VGND sg13cmos5l_decap_8
XFILLER_222_63 VPWR VGND sg13cmos5l_decap_8
XFILLER_27_138 VPWR VGND sg13cmos5l_decap_8
XFILLER_282_150 VPWR VGND sg13cmos5l_decap_8
XFILLER_82_233 VPWR VGND sg13cmos5l_fill_1
X_0269_ _0269_/Q Tile_X0Y0_FrameData[25] VGND VPWR Tile_X0Y5_FrameStrobe[6] latch
XFILLER_42_108 VPWR VGND sg13cmos5l_decap_8
XFILLER_35_28 VPWR VGND sg13cmos5l_decap_8
XFILLER_230_209 VPWR VGND sg13cmos5l_fill_1
X_2008_ Tile_X0Y5_EE4BEG[9] _2750_/X VPWR VGND sg13cmos5l_buf_1
XFILLER_298_56 VPWR VGND sg13cmos5l_decap_8
XFILLER_329_107 VPWR VGND sg13cmos5l_fill_1
XFILLER_195_168 VPWR VGND sg13cmos5l_fill_1
XFILLER_51_49 VPWR VGND sg13cmos5l_decap_8
XFILLER_50_196 VPWR VGND sg13cmos5l_decap_4
XFILLER_129_7 VPWR VGND sg13cmos5l_decap_8
XFILLER_167_49 VPWR VGND sg13cmos5l_decap_8
XFILLER_352_154 VPWR VGND sg13cmos5l_decap_8
XFILLER_2_237 VPWR VGND sg13cmos5l_fill_2
XFILLER_116_42 VPWR VGND sg13cmos5l_decap_8
XFILLER_104_176 VPWR VGND sg13cmos5l_decap_8
XFILLER_263_70 VPWR VGND sg13cmos5l_decap_8
XANTENNA__1523__X Tile_X0Y3_E2BEGb[5] VPWR VGND sg13cmos5l_antennanp
XFILLER_76_35 VPWR VGND sg13cmos5l_decap_8
XFILLER_18_105 VPWR VGND sg13cmos5l_decap_8
XFILLER_58_263 VPWR VGND sg13cmos5l_fill_2
XFILLER_132_63 VPWR VGND sg13cmos5l_decap_8
XFILLER_73_211 VPWR VGND sg13cmos5l_decap_8
XFILLER_26_182 VPWR VGND sg13cmos5l_decap_8
XFILLER_92_56 VPWR VGND sg13cmos5l_decap_8
XFILLER_155_0 VPWR VGND sg13cmos5l_decap_8
XFILLER_41_130 VPWR VGND sg13cmos5l_decap_8
XFILLER_322_0 VPWR VGND sg13cmos5l_decap_8
XFILLER_41_196 VPWR VGND sg13cmos5l_fill_1
XFILLER_194_190 VPWR VGND sg13cmos5l_fill_1
XFILLER_41_60 VPWR VGND sg13cmos5l_decap_8
XFILLER_343_176 VPWR VGND sg13cmos5l_fill_1
XFILLER_296_231 VPWR VGND sg13cmos5l_decap_8
XFILLER_307_63 VPWR VGND sg13cmos5l_decap_8
XFILLER_150_260 VPWR VGND sg13cmos5l_decap_8
XFILLER_150_271 VPWR VGND sg13cmos5l_fill_2
XFILLER_173_70 VPWR VGND sg13cmos5l_decap_8
XFILLER_296_242 VPWR VGND sg13cmos5l_fill_1
X_1310_ _1310_/Q Tile_X0Y5_FrameData[18] VGND VPWR Tile_X0Y5_FrameStrobe[1] latch
X_2290_ _2290_/X _2344_/X _2343_/X AXIL_S_SOC_WDATA3 AXIL_S_SOC_WDATA6 _0512_/Q _0511_/Q
+ VPWR VGND sg13cmos5l_mux4_1
XFILLER_110_146 VPWR VGND sg13cmos5l_decap_8
XFILLER_2_21 VPWR VGND sg13cmos5l_decap_8
X_1241_ _1241_/Q Tile_X0Y4_FrameData[13] VGND VPWR Tile_X0Y5_FrameStrobe[6] latch
X_1172_ _1172_/Q Tile_X0Y4_FrameData[18] VGND VPWR Tile_X0Y5_FrameStrobe[4] latch
XFILLER_64_200 VPWR VGND sg13cmos5l_decap_8
XFILLER_2_98 VPWR VGND sg13cmos5l_decap_8
XFILLER_323_84 VPWR VGND sg13cmos5l_decap_8
X_0123_ _0123_/Q Tile_X0Y0_FrameData[11] VGND VPWR Tile_X0Y5_FrameStrobe[1] latch
XFILLER_24_119 VPWR VGND sg13cmos5l_decap_8
X_0054_ _1610_/A _2275_/X _2276_/X _0758_/Q VPWR VGND sg13cmos5l_mux2_1
XANTENNA_15 AXIL_S_SOC_WDATA10 VPWR VGND sg13cmos5l_antennanp
XANTENNA_26 AXIL_S_SOC_WDATA11 VPWR VGND sg13cmos5l_antennanp
XANTENNA_37 AXIL_S_SOC_WDATA15 VPWR VGND sg13cmos5l_antennanp
XANTENNA_48 AXIL_S_SOC_WDATA15 VPWR VGND sg13cmos5l_antennanp
XFILLER_177_168 VPWR VGND sg13cmos5l_decap_8
XFILLER_177_179 VPWR VGND sg13cmos5l_fill_2
XANTENNA_59 AXIL_S_SOC_WDATA16 VPWR VGND sg13cmos5l_antennanp
XFILLER_192_105 VPWR VGND sg13cmos5l_decap_8
X_0956_ _0956_/Q Tile_X0Y3_FrameData[26] VGND VPWR Tile_X0Y5_FrameStrobe[5] latch
XFILLER_70_0 VPWR VGND sg13cmos5l_decap_8
XFILLER_348_70 VPWR VGND sg13cmos5l_decap_8
XFILLER_284_14 VPWR VGND sg13cmos5l_decap_8
XANTENNA__1608__X Tile_X0Y0_N4BEG[4] VPWR VGND sg13cmos5l_antennanp
X_2626_ _2626_/X AXIL_S_SOC_WSTRB1 AXIL_S_SOC_WSTRB3 _2709_/X _2682_/X _1202_/Q _1201_/Q
+ VPWR VGND sg13cmos5l_mux4_1
X_0887_ _0887_/Q Tile_X0Y3_FrameData[31] VGND VPWR Tile_X0Y5_FrameStrobe[3] latch
XFILLER_217_63 VPWR VGND sg13cmos5l_decap_8
X_2557_ _2557_/X Tile_X0Y3_W1END[2] Tile_X0Y3_WW4END[10] Tile_X0Y3_WW4END[14] Tile_X0Y3_W6END[6]
+ _0868_/Q _0867_/Q VPWR VGND sg13cmos5l_mux4_1
X_1508_ _2790_/A3 VPWR VGND sg13cmos5l_tielo
X_2488_ _2488_/X _2396_/X _2504_/X _2503_/X _2395_/X _0560_/Q _0559_/Q VPWR VGND sg13cmos5l_mux4_1
X_1439_ _1439_/Q Tile_X0Y5_FrameData[17] VGND VPWR Tile_X0Y5_FrameStrobe[5] latch
XFILLER_233_84 VPWR VGND sg13cmos5l_decap_8
XFILLER_255_194 VPWR VGND sg13cmos5l_decap_4
XFILLER_55_255 VPWR VGND sg13cmos5l_decap_4
XFILLER_15_119 VPWR VGND sg13cmos5l_decap_8
XFILLER_102_77 VPWR VGND sg13cmos5l_decap_8
XFILLER_168_135 VPWR VGND sg13cmos5l_decap_8
XFILLER_246_7 VPWR VGND sg13cmos5l_decap_8
XFILLER_357_224 VPWR VGND sg13cmos5l_fill_2
XFILLER_211_253 VPWR VGND sg13cmos5l_fill_2
XFILLER_168_179 VPWR VGND sg13cmos5l_decap_8
XFILLER_183_105 VPWR VGND sg13cmos5l_decap_8
XFILLER_258_70 VPWR VGND sg13cmos5l_decap_8
XFILLER_109_235 VPWR VGND sg13cmos5l_decap_8
XFILLER_194_14 VPWR VGND sg13cmos5l_decap_8
XFILLER_124_205 VPWR VGND sg13cmos5l_fill_2
XFILLER_11_63 VPWR VGND sg13cmos5l_decap_8
XFILLER_191_182 VPWR VGND sg13cmos5l_fill_1
XFILLER_127_63 VPWR VGND sg13cmos5l_decap_8
XFILLER_274_91 VPWR VGND sg13cmos5l_decap_8
XFILLER_344_28 VPWR VGND sg13cmos5l_decap_8
XFILLER_87_56 VPWR VGND sg13cmos5l_decap_8
XFILLER_246_161 VPWR VGND sg13cmos5l_decap_4
XFILLER_272_0 VPWR VGND sg13cmos5l_decap_8
XANTENNA__2084__X Tile_X0Y3_E1BEG[0] VPWR VGND sg13cmos5l_antennanp
XFILLER_14_196 VPWR VGND sg13cmos5l_fill_1
XFILLER_348_235 VPWR VGND sg13cmos5l_decap_8
XFILLER_174_105 VPWR VGND sg13cmos5l_decap_8
X_1790_ Tile_X0Y4_E2BEG[1] _2618_/X VPWR VGND sg13cmos5l_buf_1
X_0810_ _0810_/Q Tile_X0Y3_FrameData[12] VGND VPWR Tile_X0Y5_FrameStrobe[0] latch
XFILLER_52_70 VPWR VGND sg13cmos5l_decap_8
XFILLER_168_70 VPWR VGND sg13cmos5l_decap_8
X_0741_ _0741_/Q Tile_X0Y2_FrameData[1] VGND VPWR Tile_X0Y5_FrameStrobe[5] latch
XFILLER_318_84 VPWR VGND sg13cmos5l_decap_8
X_0672_ _0672_/Q Tile_X0Y2_FrameData[6] VGND VPWR Tile_X0Y5_FrameStrobe[3] latch
XFILLER_254_28 VPWR VGND sg13cmos5l_decap_8
X_2411_ _2411_/X AXIL_S_SOC_AWADDR2 AXIL_S_SOC_AWPROT0 _2483_/X _2486_/X _0726_/Q
+ _0725_/Q VPWR VGND sg13cmos5l_mux4_1
XFILLER_123_271 VPWR VGND sg13cmos5l_fill_2
XFILLER_184_91 VPWR VGND sg13cmos5l_decap_8
X_2342_ _2342_/X Tile_X0Y2_W1END[0] Tile_X0Y2_W6END[4] _2471_/X _2453_/X _0790_/Q
+ _0789_/Q VPWR VGND sg13cmos5l_mux4_1
X_2273_ _2273_/X Tile_X0Y2_W1END[3] Tile_X0Y2_WW4END[3] Tile_X0Y2_WW4END[7] Tile_X0Y2_W6END[11]
+ _0757_/Q _0756_/Q VPWR VGND sg13cmos5l_mux4_1
XFILLER_96_155 VPWR VGND sg13cmos5l_decap_4
XFILLER_203_21 VPWR VGND sg13cmos5l_decap_8
XFILLER_237_161 VPWR VGND sg13cmos5l_decap_8
XFILLER_270_49 VPWR VGND sg13cmos5l_decap_8
X_1224_ _1224_/Q Tile_X0Y4_FrameData[30] VGND VPWR Tile_X0Y5_FrameStrobe[6] latch
XFILLER_37_233 VPWR VGND sg13cmos5l_decap_4
X_1155_ _1155_/Q Tile_X0Y4_FrameData[3] VGND VPWR Tile_X0Y5_FrameStrobe[3] latch
XFILLER_203_98 VPWR VGND sg13cmos5l_decap_8
XFILLER_279_14 VPWR VGND sg13cmos5l_decap_8
X_1086_ _1086_/Q Tile_X0Y4_FrameData[8] VGND VPWR Tile_X0Y5_FrameStrobe[1] latch
X_0106_ _0106_/Q Tile_X0Y0_FrameData[28] VGND VPWR Tile_X0Y5_FrameStrobe[1] latch
XFILLER_52_203 VPWR VGND sg13cmos5l_decap_8
XFILLER_197_208 VPWR VGND sg13cmos5l_fill_1
X_0037_ _2082_/A _2787_/X _2788_/X _1329_/Q VPWR VGND sg13cmos5l_mux2_1
XFILLER_165_127 VPWR VGND sg13cmos5l_decap_8
XFILLER_295_35 VPWR VGND sg13cmos5l_decap_8
XFILLER_359_91 VPWR VGND sg13cmos5l_decap_8
XFILLER_20_199 VPWR VGND sg13cmos5l_fill_2
X_1988_ Tile_X0Y5_E6BEG[1] _2758_/X VPWR VGND sg13cmos5l_buf_1
XFILLER_354_249 VPWR VGND sg13cmos5l_fill_1
XFILLER_354_238 VPWR VGND sg13cmos5l_decap_8
XFILLER_180_119 VPWR VGND sg13cmos5l_decap_8
XFILLER_307_154 VPWR VGND sg13cmos5l_decap_8
X_0939_ _0939_/Q Tile_X0Y3_FrameData[11] VGND VPWR Tile_X0Y5_FrameStrobe[4] latch
XFILLER_173_182 VPWR VGND sg13cmos5l_decap_8
XFILLER_228_84 VPWR VGND sg13cmos5l_decap_8
XFILLER_106_249 VPWR VGND sg13cmos5l_decap_8
XFILLER_121_208 VPWR VGND sg13cmos5l_decap_8
XFILLER_164_28 VPWR VGND sg13cmos5l_decap_8
X_2609_ _2609_/X Tile_X0Y2_W1END[2] Tile_X0Y2_W2MID[1] Tile_X0Y2_W2END[1] _2487_/X
+ _0638_/Q _0637_/Q VPWR VGND sg13cmos5l_mux4_1
XFILLER_196_7 VPWR VGND sg13cmos5l_decap_8
XFILLER_275_234 VPWR VGND sg13cmos5l_decap_4
XFILLER_87_177 VPWR VGND sg13cmos5l_decap_8
XFILLER_113_21 VPWR VGND sg13cmos5l_decap_8
XFILLER_180_49 VPWR VGND sg13cmos5l_decap_8
XFILLER_228_161 VPWR VGND sg13cmos5l_decap_4
XFILLER_28_222 VPWR VGND sg13cmos5l_decap_8
XANTENNA__1801__X Tile_X0Y4_E2BEGb[4] VPWR VGND sg13cmos5l_antennanp
XFILLER_113_98 VPWR VGND sg13cmos5l_decap_8
XFILLER_73_14 VPWR VGND sg13cmos5l_decap_8
XFILLER_43_214 VPWR VGND sg13cmos5l_decap_8
XFILLER_189_14 VPWR VGND sg13cmos5l_decap_8
XFILLER_243_175 VPWR VGND sg13cmos5l_decap_8
XFILLER_43_258 VPWR VGND sg13cmos5l_decap_8
XFILLER_43_269 VPWR VGND sg13cmos5l_decap_4
XFILLER_339_28 VPWR VGND sg13cmos5l_decap_8
XFILLER_11_133 VPWR VGND sg13cmos5l_decap_8
XFILLER_269_91 VPWR VGND sg13cmos5l_decap_8
XFILLER_11_177 VPWR VGND sg13cmos5l_fill_1
XFILLER_118_0 VPWR VGND sg13cmos5l_decap_8
XFILLER_171_119 VPWR VGND sg13cmos5l_decap_8
XFILLER_22_84 VPWR VGND sg13cmos5l_decap_8
XFILLER_138_84 VPWR VGND sg13cmos5l_decap_8
XFILLER_355_49 VPWR VGND sg13cmos5l_decap_8
XFILLER_98_77 VPWR VGND sg13cmos5l_decap_8
XFILLER_0_0 VPWR VGND sg13cmos5l_decap_8
XFILLER_105_260 VPWR VGND sg13cmos5l_fill_2
XANTENNA__2079__X Tile_X0Y5_S4BEG[12] VPWR VGND sg13cmos5l_antennanp
XFILLER_281_204 VPWR VGND sg13cmos5l_decap_4
XFILLER_304_42 VPWR VGND sg13cmos5l_decap_8
XFILLER_93_136 VPWR VGND sg13cmos5l_decap_8
XFILLER_281_237 VPWR VGND sg13cmos5l_decap_8
XFILLER_47_70 VPWR VGND sg13cmos5l_decap_8
XANTENNA__1711__X Tile_X0Y0_E6BEG[3] VPWR VGND sg13cmos5l_antennanp
XFILLER_179_208 VPWR VGND sg13cmos5l_decap_8
XFILLER_320_63 VPWR VGND sg13cmos5l_decap_8
XFILLER_249_28 VPWR VGND sg13cmos5l_decap_8
X_1911_ Tile_X0Y1_FrameData_O[24] Tile_X0Y1_FrameData[24] VPWR VGND sg13cmos5l_buf_1
XFILLER_63_91 VPWR VGND sg13cmos5l_decap_8
XFILLER_179_91 VPWR VGND sg13cmos5l_decap_8
X_1842_ Tile_X0Y4_FrameData_O[9] Tile_X0Y4_FrameData[9] VPWR VGND sg13cmos5l_buf_1
XFILLER_8_42 VPWR VGND sg13cmos5l_decap_8
XFILLER_147_127 VPWR VGND sg13cmos5l_decap_8
XFILLER_162_119 VPWR VGND sg13cmos5l_decap_8
X_1773_ Tile_X0Y2_E1BEG[0] _2397_/X VPWR VGND sg13cmos5l_buf_1
XFILLER_155_171 VPWR VGND sg13cmos5l_fill_1
XFILLER_265_49 VPWR VGND sg13cmos5l_decap_8
X_0724_ _0724_/Q Tile_X0Y2_FrameData[18] VGND VPWR Tile_X0Y5_FrameStrobe[5] latch
XFILLER_351_219 VPWR VGND sg13cmos5l_decap_8
XFILLER_344_271 VPWR VGND sg13cmos5l_fill_2
XFILLER_155_193 VPWR VGND sg13cmos5l_decap_8
X_0655_ _0655_/Q Tile_X0Y2_FrameData[23] VGND VPWR Tile_X0Y5_FrameStrobe[3] latch
XFILLER_304_168 VPWR VGND sg13cmos5l_decap_8
X_0586_ _0586_/Q Tile_X0Y2_FrameData[28] VGND VPWR Tile_X0Y5_FrameStrobe[1] latch
XFILLER_69_133 VPWR VGND sg13cmos5l_decap_8
XFILLER_33_0 VPWR VGND sg13cmos5l_decap_4
X_2325_ _2325_/X _0063_/X Tile_X0Y0_S4END[4] _2350_/X _2349_/X _0442_/Q _0441_/Q VPWR
+ VGND sg13cmos5l_mux4_1
XFILLER_214_42 VPWR VGND sg13cmos5l_decap_8
X_2256_ _2256_/X Tile_X0Y1_W2MID[4] Tile_X0Y1_W2END[4] Tile_X0Y1_W6END[4] _2376_/X
+ _0536_/Q _0535_/Q VPWR VGND sg13cmos5l_mux4_1
X_1207_ _1207_/Q Tile_X0Y4_FrameData[15] VGND VPWR Tile_X0Y5_FrameStrobe[5] latch
XANTENNA__1621__X Tile_X0Y0_N2BEGb[1] VPWR VGND sg13cmos5l_antennanp
X_2187_ _2187_/X AXIL_S_SOC_WDATA22 AXIL_S_SOC_WDATA26 _2226_/X _2242_/X _0222_/Q
+ _0221_/Q VPWR VGND sg13cmos5l_mux4_1
XFILLER_225_186 VPWR VGND sg13cmos5l_decap_8
XFILLER_240_112 VPWR VGND sg13cmos5l_decap_8
XFILLER_25_236 VPWR VGND sg13cmos5l_fill_1
X_1138_ _1138_/Q Tile_X0Y4_FrameData[20] VGND VPWR Tile_X0Y5_FrameStrobe[3] latch
XFILLER_92_180 VPWR VGND sg13cmos5l_decap_8
XFILLER_230_63 VPWR VGND sg13cmos5l_decap_8
X_1069_ _1069_/Q Tile_X0Y4_FrameData[25] VGND VPWR Tile_X0Y5_FrameStrobe[1] latch
XFILLER_43_28 VPWR VGND sg13cmos5l_decap_8
XFILLER_159_28 VPWR VGND sg13cmos5l_decap_8
XFILLER_178_241 VPWR VGND sg13cmos5l_decap_8
XFILLER_138_105 VPWR VGND sg13cmos5l_decap_8
XFILLER_240_189 VPWR VGND sg13cmos5l_decap_8
XFILLER_111_7 VPWR VGND sg13cmos5l_decap_8
XFILLER_175_49 VPWR VGND sg13cmos5l_decap_8
XFILLER_209_7 VPWR VGND sg13cmos5l_decap_8
XFILLER_4_129 VPWR VGND sg13cmos5l_decap_8
XFILLER_342_219 VPWR VGND sg13cmos5l_decap_8
XFILLER_108_21 VPWR VGND sg13cmos5l_decap_8
XFILLER_310_105 VPWR VGND sg13cmos5l_decap_8
XFILLER_68_14 VPWR VGND sg13cmos5l_decap_8
XFILLER_108_98 VPWR VGND sg13cmos5l_decap_8
XFILLER_124_42 VPWR VGND sg13cmos5l_decap_8
XFILLER_208_109 VPWR VGND sg13cmos5l_fill_2
XFILLER_271_70 VPWR VGND sg13cmos5l_decap_8
XFILLER_263_237 VPWR VGND sg13cmos5l_fill_1
XFILLER_263_248 VPWR VGND sg13cmos5l_fill_1
XFILLER_84_35 VPWR VGND sg13cmos5l_decap_8
XANTENNA__1531__X Tile_X0Y3_E6BEG[5] VPWR VGND sg13cmos5l_antennanp
XFILLER_216_120 VPWR VGND sg13cmos5l_decap_8
XFILLER_216_131 VPWR VGND sg13cmos5l_fill_2
XFILLER_231_112 VPWR VGND sg13cmos5l_decap_8
XFILLER_271_270 VPWR VGND sg13cmos5l_fill_2
XFILLER_140_63 VPWR VGND sg13cmos5l_decap_8
XFILLER_17_84 VPWR VGND sg13cmos5l_decap_8
XFILLER_129_105 VPWR VGND sg13cmos5l_decap_8
XFILLER_169_252 VPWR VGND sg13cmos5l_decap_4
XFILLER_235_0 VPWR VGND sg13cmos5l_decap_8
XFILLER_33_50 VPWR VGND sg13cmos5l_decap_8
XFILLER_318_227 VPWR VGND sg13cmos5l_fill_1
XFILLER_318_238 VPWR VGND sg13cmos5l_fill_2
XFILLER_298_112 VPWR VGND sg13cmos5l_decap_8
XANTENNA__1706__X Tile_X0Y0_EE4BEG[14] VPWR VGND sg13cmos5l_antennanp
XFILLER_165_71 VPWR VGND sg13cmos5l_decap_8
XFILLER_301_105 VPWR VGND sg13cmos5l_decap_8
XFILLER_98_206 VPWR VGND sg13cmos5l_decap_8
XFILLER_298_189 VPWR VGND sg13cmos5l_decap_8
X_0440_ _0440_/Q Tile_X0Y1_FrameData[30] VGND VPWR Tile_X0Y5_FrameStrobe[4] latch
XFILLER_239_234 VPWR VGND sg13cmos5l_fill_2
XFILLER_315_63 VPWR VGND sg13cmos5l_decap_8
X_0371_ _0371_/Q Tile_X0Y1_FrameData[3] VGND VPWR Tile_X0Y5_FrameStrobe[1] latch
XFILLER_239_267 VPWR VGND sg13cmos5l_decap_4
XFILLER_254_204 VPWR VGND sg13cmos5l_decap_8
X_2110_ AXIL_S_SOC_RDATA4 Tile_X0Y3_W2MID[4] Tile_X0Y3_W2END[4] Tile_X0Y3_W6END[4]
+ _2593_/X _0854_/Q _0853_/Q VPWR VGND sg13cmos5l_mux4_1
XFILLER_58_91 VPWR VGND sg13cmos5l_decap_8
XFILLER_181_70 VPWR VGND sg13cmos5l_decap_8
XFILLER_254_215 VPWR VGND sg13cmos5l_fill_1
X_2041_ Tile_X0Y5_FrameData_O[26] Tile_X0Y5_FrameData[26] VPWR VGND sg13cmos5l_buf_1
XFILLER_66_147 VPWR VGND sg13cmos5l_fill_1
XFILLER_331_84 VPWR VGND sg13cmos5l_decap_8
XFILLER_331_95 VPWR VGND sg13cmos5l_fill_2
XFILLER_81_139 VPWR VGND sg13cmos5l_fill_2
XFILLER_74_191 VPWR VGND sg13cmos5l_decap_4
XFILLER_222_112 VPWR VGND sg13cmos5l_decap_8
XFILLER_222_123 VPWR VGND sg13cmos5l_fill_1
XFILLER_200_77 VPWR VGND sg13cmos5l_decap_8
XFILLER_30_261 VPWR VGND sg13cmos5l_fill_1
X_1825_ Tile_X0Y4_EE4BEG[8] _2641_/X VPWR VGND sg13cmos5l_buf_1
XFILLER_209_42 VPWR VGND sg13cmos5l_decap_8
X_1756_ Tile_X0Y2_FrameData_O[16] Tile_X0Y2_FrameData[16] VPWR VGND sg13cmos5l_buf_1
XFILLER_289_112 VPWR VGND sg13cmos5l_decap_8
XFILLER_292_14 VPWR VGND sg13cmos5l_decap_8
X_0707_ _0707_/Q Tile_X0Y2_FrameData[3] VGND VPWR Tile_X0Y5_FrameStrobe[4] latch
XFILLER_356_70 VPWR VGND sg13cmos5l_decap_8
XANTENNA__1616__X Tile_X0Y0_N4BEG[12] VPWR VGND sg13cmos5l_antennanp
X_1687_ Tile_X0Y0_FrameData_O[27] Tile_X0Y0_FrameData[27] VPWR VGND sg13cmos5l_buf_1
X_0638_ _0638_/Q Tile_X0Y2_FrameData[8] VGND VPWR Tile_X0Y5_FrameStrobe[2] latch
XFILLER_225_63 VPWR VGND sg13cmos5l_decap_8
X_0569_ _0569_/Q Tile_X0Y2_FrameData[13] VGND VPWR Tile_X0Y5_FrameStrobe[0] latch
X_2308_ _2308_/X AXIL_S_SOC_WDATA7 AXIL_S_SOC_WDATA15 _2373_/X _2380_/X _0476_/Q _0475_/Q
+ VPWR VGND sg13cmos5l_mux4_1
XFILLER_38_28 VPWR VGND sg13cmos5l_decap_8
XFILLER_300_182 VPWR VGND sg13cmos5l_decap_8
XFILLER_57_147 VPWR VGND sg13cmos5l_decap_8
X_2239_ _2239_/X _2213_/X _0049_/X Tile_X0Y0_S1END[0] Tile_X0Y0_S4END[0] _0118_/Q
+ _0117_/Q VPWR VGND sg13cmos5l_mux4_1
XANTENNA_308 Tile_X0Y0_FrameData[23] VPWR VGND sg13cmos5l_antennanp
XANTENNA_319 Tile_X0Y0_FrameData[31] VPWR VGND sg13cmos5l_antennanp
XFILLER_241_84 VPWR VGND sg13cmos5l_decap_8
XFILLER_260_218 VPWR VGND sg13cmos5l_decap_8
XFILLER_72_139 VPWR VGND sg13cmos5l_fill_2
XFILLER_54_49 VPWR VGND sg13cmos5l_decap_8
XFILLER_359_105 VPWR VGND sg13cmos5l_decap_8
XFILLER_159_7 VPWR VGND sg13cmos5l_decap_8
XFILLER_213_145 VPWR VGND sg13cmos5l_fill_1
XFILLER_110_77 VPWR VGND sg13cmos5l_decap_8
XFILLER_326_7 VPWR VGND sg13cmos5l_decap_8
XFILLER_166_266 VPWR VGND sg13cmos5l_fill_2
XFILLER_119_42 VPWR VGND sg13cmos5l_decap_8
XFILLER_181_225 VPWR VGND sg13cmos5l_decap_4
XFILLER_308_271 VPWR VGND sg13cmos5l_fill_2
XFILLER_266_70 VPWR VGND sg13cmos5l_decap_8
XFILLER_79_35 VPWR VGND sg13cmos5l_decap_8
XANTENNA__1526__X Tile_X0Y3_E6BEG[0] VPWR VGND sg13cmos5l_antennanp
XFILLER_134_196 VPWR VGND sg13cmos5l_fill_2
XFILLER_135_63 VPWR VGND sg13cmos5l_decap_8
XFILLER_295_126 VPWR VGND sg13cmos5l_decap_8
XFILLER_352_28 VPWR VGND sg13cmos5l_decap_8
XFILLER_282_91 VPWR VGND sg13cmos5l_decap_8
XFILLER_95_56 VPWR VGND sg13cmos5l_decap_8
XFILLER_185_0 VPWR VGND sg13cmos5l_decap_8
XFILLER_48_158 VPWR VGND sg13cmos5l_decap_8
XFILLER_236_248 VPWR VGND sg13cmos5l_decap_8
XFILLER_151_84 VPWR VGND sg13cmos5l_decap_8
XFILLER_301_21 VPWR VGND sg13cmos5l_decap_8
XFILLER_352_0 VPWR VGND sg13cmos5l_decap_8
XFILLER_44_60 VPWR VGND sg13cmos5l_decap_8
XANTENNA__2092__X Tile_X0Y3_E2BEG[4] VPWR VGND sg13cmos5l_antennanp
XFILLER_301_98 VPWR VGND sg13cmos5l_decap_8
XFILLER_81_8 VPWR VGND sg13cmos5l_decap_8
XFILLER_358_182 VPWR VGND sg13cmos5l_decap_8
XFILLER_74_7 VPWR VGND sg13cmos5l_decap_8
XFILLER_117_119 VPWR VGND sg13cmos5l_decap_8
X_1610_ Tile_X0Y0_N4BEG[6] _1610_/A VPWR VGND sg13cmos5l_buf_1
XFILLER_60_70 VPWR VGND sg13cmos5l_decap_8
XFILLER_172_258 VPWR VGND sg13cmos5l_fill_1
XFILLER_176_70 VPWR VGND sg13cmos5l_decap_8
X_2590_ _2590_/X _2492_/X _2600_/X _2599_/X _2491_/X _0812_/Q _0811_/Q VPWR VGND sg13cmos5l_mux4_1
XFILLER_5_21 VPWR VGND sg13cmos5l_decap_8
X_1541_ Tile_X0Y3_EE4BEG[3] _2528_/X VPWR VGND sg13cmos5l_buf_1
XFILLER_326_84 VPWR VGND sg13cmos5l_decap_8
X_1472_ _1472_/Q Tile_X0Y5_FrameData[16] VGND VPWR Tile_X0Y5_FrameStrobe[6] latch
XFILLER_5_98 VPWR VGND sg13cmos5l_decap_8
XFILLER_262_28 VPWR VGND sg13cmos5l_decap_8
XFILLER_286_148 VPWR VGND sg13cmos5l_decap_8
X_0423_ _0423_/Q Tile_X0Y1_FrameData[15] VGND VPWR Tile_X0Y5_FrameStrobe[3] latch
XFILLER_192_91 VPWR VGND sg13cmos5l_decap_8
X_0354_ _0354_/Q Tile_X0Y1_FrameData[20] VGND VPWR Tile_X0Y5_FrameStrobe[1] latch
XFILLER_342_50 VPWR VGND sg13cmos5l_decap_8
XFILLER_227_259 VPWR VGND sg13cmos5l_fill_2
X_0285_ _0285_/Q Tile_X0Y0_FrameData[9] VGND VPWR Tile_X0Y5_FrameStrobe[6] latch
X_2024_ Tile_X0Y5_FrameData_O[9] Tile_X0Y5_FrameData[9] VPWR VGND sg13cmos5l_buf_1
XFILLER_211_21 VPWR VGND sg13cmos5l_decap_8
XFILLER_62_161 VPWR VGND sg13cmos5l_decap_8
XFILLER_210_115 VPWR VGND sg13cmos5l_decap_8
XFILLER_287_14 VPWR VGND sg13cmos5l_decap_8
XFILLER_356_119 VPWR VGND sg13cmos5l_decap_8
XFILLER_148_233 VPWR VGND sg13cmos5l_fill_2
XFILLER_349_182 VPWR VGND sg13cmos5l_decap_8
XFILLER_163_214 VPWR VGND sg13cmos5l_decap_8
X_1808_ Tile_X0Y4_E6BEG[3] _2652_/X VPWR VGND sg13cmos5l_buf_1
X_2788_ _2788_/X _2817_/X _2802_/X _2801_/X _2797_/X _1331_/Q _1330_/Q VPWR VGND sg13cmos5l_mux4_1
X_1739_ Tile_X0Y0_E1BEG[3] _2164_/X VPWR VGND sg13cmos5l_buf_1
XFILLER_116_196 VPWR VGND sg13cmos5l_decap_8
XFILLER_236_84 VPWR VGND sg13cmos5l_decap_8
XFILLER_131_166 VPWR VGND sg13cmos5l_decap_8
XFILLER_172_28 VPWR VGND sg13cmos5l_decap_8
XFILLER_49_49 VPWR VGND sg13cmos5l_decap_8
XFILLER_285_181 VPWR VGND sg13cmos5l_fill_1
XFILLER_105_77 VPWR VGND sg13cmos5l_decap_8
XFILLER_276_7 VPWR VGND sg13cmos5l_decap_8
XANTENNA_105 AXIL_S_SOC_WDATA27 VPWR VGND sg13cmos5l_antennanp
XANTENNA_116 AXIL_S_SOC_WDATA27 VPWR VGND sg13cmos5l_antennanp
XANTENNA_127 AXIL_S_SOC_WDATA29 VPWR VGND sg13cmos5l_antennanp
XANTENNA_138 AXIL_S_SOC_WDATA30 VPWR VGND sg13cmos5l_antennanp
XANTENNA_149 AXIL_S_SOC_WDATA30 VPWR VGND sg13cmos5l_antennanp
XFILLER_121_21 VPWR VGND sg13cmos5l_decap_8
XFILLER_198_133 VPWR VGND sg13cmos5l_decap_8
XFILLER_241_251 VPWR VGND sg13cmos5l_decap_8
XFILLER_81_36 VPWR VGND sg13cmos5l_decap_8
XFILLER_53_161 VPWR VGND sg13cmos5l_decap_8
XFILLER_121_98 VPWR VGND sg13cmos5l_decap_8
XFILLER_197_14 VPWR VGND sg13cmos5l_decap_8
XFILLER_198_177 VPWR VGND sg13cmos5l_fill_1
XFILLER_201_115 VPWR VGND sg13cmos5l_fill_1
XFILLER_139_200 VPWR VGND sg13cmos5l_decap_4
XFILLER_14_63 VPWR VGND sg13cmos5l_decap_8
XFILLER_277_91 VPWR VGND sg13cmos5l_decap_8
XFILLER_355_196 VPWR VGND sg13cmos5l_decap_8
XFILLER_100_0 VPWR VGND sg13cmos5l_decap_8
XFILLER_107_152 VPWR VGND sg13cmos5l_decap_8
XFILLER_146_84 VPWR VGND sg13cmos5l_fill_2
XFILLER_30_84 VPWR VGND sg13cmos5l_decap_8
XFILLER_122_133 VPWR VGND sg13cmos5l_decap_8
XANTENNA__2087__X Tile_X0Y3_E1BEG[3] VPWR VGND sg13cmos5l_antennanp
XFILLER_291_140 VPWR VGND sg13cmos5l_decap_8
XFILLER_224_218 VPWR VGND sg13cmos5l_decap_8
XFILLER_312_42 VPWR VGND sg13cmos5l_decap_8
X_0070_ _1613_/A _2269_/X _2270_/X _0521_/Q VPWR VGND sg13cmos5l_mux2_1
XFILLER_291_184 VPWR VGND sg13cmos5l_fill_1
XFILLER_91_267 VPWR VGND sg13cmos5l_decap_4
XFILLER_55_70 VPWR VGND sg13cmos5l_decap_8
XFILLER_44_183 VPWR VGND sg13cmos5l_decap_8
X_0972_ _0972_/Q Tile_X0Y3_FrameData[10] VGND VPWR Tile_X0Y5_FrameStrobe[5] latch
XFILLER_257_28 VPWR VGND sg13cmos5l_decap_8
X_2711_ _2711_/X _2604_/X Tile_X0Y5_N2MID[3] _2716_/X _2603_/X _1048_/Q _1047_/Q VPWR
+ VGND sg13cmos5l_mux4_1
XFILLER_71_91 VPWR VGND sg13cmos5l_fill_2
XFILLER_187_91 VPWR VGND sg13cmos5l_decap_8
XFILLER_346_163 VPWR VGND sg13cmos5l_fill_1
XFILLER_346_152 VPWR VGND sg13cmos5l_decap_8
XFILLER_145_236 VPWR VGND sg13cmos5l_decap_8
X_2642_ _2642_/X AXIL_S_SOC_WSTRB3 AXIL_S_SOC_BREADY _2701_/X _2682_/X _1170_/Q _1169_/Q
+ VPWR VGND sg13cmos5l_mux4_1
X_2573_ _2573_/X _2572_/X Tile_X0Y5_N4END[11] _2571_/X Tile_X0Y0_S4END[15] _0816_/Q
+ _0815_/Q VPWR VGND sg13cmos5l_mux4_1
XFILLER_361_155 VPWR VGND sg13cmos5l_fill_2
XFILLER_273_49 VPWR VGND sg13cmos5l_decap_8
XFILLER_302_222 VPWR VGND sg13cmos5l_decap_8
X_1524_ Tile_X0Y3_E2BEGb[6] _2523_/X VPWR VGND sg13cmos5l_buf_1
XFILLER_361_199 VPWR VGND sg13cmos5l_fill_2
XFILLER_361_188 VPWR VGND sg13cmos5l_decap_8
XFILLER_113_133 VPWR VGND sg13cmos5l_decap_8
XFILLER_206_21 VPWR VGND sg13cmos5l_decap_8
XFILLER_302_244 VPWR VGND sg13cmos5l_decap_8
X_1455_ _1455_/Q Tile_X0Y5_FrameData[1] VGND VPWR Tile_X0Y5_FrameStrobe[5] latch
XFILLER_267_170 VPWR VGND sg13cmos5l_decap_8
X_1386_ _1386_/Q Tile_X0Y5_FrameData[6] VGND VPWR Tile_X0Y5_FrameStrobe[3] latch
X_0406_ _0406_/Q Tile_X0Y1_FrameData[0] VGND VPWR Tile_X0Y5_FrameStrobe[2] latch
X_0337_ _0337_/Q Tile_X0Y1_FrameData[5] VGND VPWR Tile_X0Y5_FrameStrobe[0] latch
XFILLER_222_42 VPWR VGND sg13cmos5l_decap_8
XFILLER_282_140 VPWR VGND sg13cmos5l_fill_2
XFILLER_82_223 VPWR VGND sg13cmos5l_fill_1
XFILLER_282_184 VPWR VGND sg13cmos5l_fill_1
X_2007_ Tile_X0Y5_EE4BEG[8] _2749_/X VPWR VGND sg13cmos5l_buf_1
X_0268_ _0268_/Q Tile_X0Y0_FrameData[26] VGND VPWR Tile_X0Y5_FrameStrobe[6] latch
XFILLER_298_35 VPWR VGND sg13cmos5l_decap_8
X_0199_ _0199_/Q Tile_X0Y0_FrameData[31] VGND VPWR Tile_X0Y5_FrameStrobe[4] latch
XFILLER_50_175 VPWR VGND sg13cmos5l_decap_8
XFILLER_167_28 VPWR VGND sg13cmos5l_decap_8
XFILLER_51_28 VPWR VGND sg13cmos5l_decap_8
XFILLER_337_174 VPWR VGND sg13cmos5l_fill_1
XFILLER_352_133 VPWR VGND sg13cmos5l_decap_8
XFILLER_151_228 VPWR VGND sg13cmos5l_decap_8
XFILLER_4_7 VPWR VGND sg13cmos5l_decap_8
XFILLER_116_21 VPWR VGND sg13cmos5l_decap_8
XFILLER_183_49 VPWR VGND sg13cmos5l_decap_8
XANTENNA__1804__X Tile_X0Y4_E2BEGb[7] VPWR VGND sg13cmos5l_antennanp
XFILLER_76_14 VPWR VGND sg13cmos5l_decap_8
XFILLER_104_199 VPWR VGND sg13cmos5l_decap_4
XFILLER_116_98 VPWR VGND sg13cmos5l_decap_8
XFILLER_132_42 VPWR VGND sg13cmos5l_decap_8
XFILLER_92_35 VPWR VGND sg13cmos5l_decap_8
XFILLER_148_0 VPWR VGND sg13cmos5l_decap_8
XFILLER_25_84 VPWR VGND sg13cmos5l_decap_8
XFILLER_358_49 VPWR VGND sg13cmos5l_decap_8
XFILLER_127_203 VPWR VGND sg13cmos5l_fill_1
XFILLER_315_0 VPWR VGND sg13cmos5l_decap_8
XFILLER_343_133 VPWR VGND sg13cmos5l_decap_4
XFILLER_343_166 VPWR VGND sg13cmos5l_fill_1
XFILLER_307_42 VPWR VGND sg13cmos5l_decap_8
XANTENNA__1714__X Tile_X0Y0_E6BEG[6] VPWR VGND sg13cmos5l_antennanp
XFILLER_37_7 VPWR VGND sg13cmos5l_decap_8
X_1240_ _1240_/Q Tile_X0Y4_FrameData[14] VGND VPWR Tile_X0Y5_FrameStrobe[6] latch
XFILLER_49_242 VPWR VGND sg13cmos5l_fill_2
XFILLER_49_231 VPWR VGND sg13cmos5l_decap_8
XFILLER_249_181 VPWR VGND sg13cmos5l_decap_4
XFILLER_2_77 VPWR VGND sg13cmos5l_decap_8
XFILLER_323_63 VPWR VGND sg13cmos5l_decap_8
X_1171_ _1171_/Q Tile_X0Y4_FrameData[19] VGND VPWR Tile_X0Y5_FrameStrobe[4] latch
X_0122_ _0122_/Q Tile_X0Y0_FrameData[12] VGND VPWR Tile_X0Y5_FrameStrobe[1] latch
XFILLER_264_173 VPWR VGND sg13cmos5l_decap_8
XFILLER_66_91 VPWR VGND sg13cmos5l_decap_8
XFILLER_205_240 VPWR VGND sg13cmos5l_fill_1
X_0053_ _2071_/A _2553_/X _2554_/X _0872_/Q VPWR VGND sg13cmos5l_mux2_1
XFILLER_205_262 VPWR VGND sg13cmos5l_fill_2
XFILLER_220_210 VPWR VGND sg13cmos5l_fill_2
XFILLER_32_164 VPWR VGND sg13cmos5l_fill_1
XANTENNA_16 AXIL_S_SOC_WDATA10 VPWR VGND sg13cmos5l_antennanp
XANTENNA_27 AXIL_S_SOC_WDATA11 VPWR VGND sg13cmos5l_antennanp
XANTENNA_38 AXIL_S_SOC_WDATA15 VPWR VGND sg13cmos5l_antennanp
XFILLER_177_147 VPWR VGND sg13cmos5l_decap_8
XFILLER_268_49 VPWR VGND sg13cmos5l_decap_8
XFILLER_32_186 VPWR VGND sg13cmos5l_fill_2
XANTENNA_49 AXIL_S_SOC_WDATA15 VPWR VGND sg13cmos5l_antennanp
XFILLER_118_203 VPWR VGND sg13cmos5l_decap_8
X_0955_ _0955_/Q Tile_X0Y3_FrameData[27] VGND VPWR Tile_X0Y5_FrameStrobe[5] latch
X_0886_ _0886_/Q Tile_X0Y3_FrameData[0] VGND VPWR Tile_X0Y5_FrameStrobe[2] latch
X_2625_ _2625_/X AXIL_S_SOC_WSTRB0 AXIL_S_SOC_WSTRB2 _2708_/X _2681_/X _1204_/Q _1203_/Q
+ VPWR VGND sg13cmos5l_mux4_1
XFILLER_63_0 VPWR VGND sg13cmos5l_decap_8
XFILLER_217_42 VPWR VGND sg13cmos5l_decap_8
X_2556_ _2556_/X _2586_/X _2585_/X _2578_/X _2577_/X _0871_/Q _0870_/Q VPWR VGND sg13cmos5l_mux4_1
XFILLER_99_131 VPWR VGND sg13cmos5l_fill_2
XANTENNA__1624__X Tile_X0Y0_N2BEGb[4] VPWR VGND sg13cmos5l_antennanp
X_1507_ _2791_/A3 VPWR VGND sg13cmos5l_tielo
X_2487_ _2487_/X _2394_/X _2502_/X _2501_/X _2393_/X _0562_/Q _0561_/Q VPWR VGND sg13cmos5l_mux4_1
XFILLER_101_147 VPWR VGND sg13cmos5l_decap_8
X_1438_ _1438_/Q Tile_X0Y5_FrameData[18] VGND VPWR Tile_X0Y5_FrameStrobe[5] latch
XFILLER_233_63 VPWR VGND sg13cmos5l_decap_8
X_1369_ _1369_/Q Tile_X0Y5_FrameData[23] VGND VPWR Tile_X0Y5_FrameStrobe[3] latch
XFILLER_55_245 VPWR VGND sg13cmos5l_fill_2
XFILLER_102_56 VPWR VGND sg13cmos5l_decap_8
XFILLER_270_198 VPWR VGND sg13cmos5l_fill_2
XFILLER_141_7 VPWR VGND sg13cmos5l_decap_8
XFILLER_211_232 VPWR VGND sg13cmos5l_decap_8
XFILLER_62_49 VPWR VGND sg13cmos5l_decap_8
XFILLER_357_203 VPWR VGND sg13cmos5l_decap_8
XFILLER_178_49 VPWR VGND sg13cmos5l_decap_8
XFILLER_239_7 VPWR VGND sg13cmos5l_decap_8
XFILLER_23_175 VPWR VGND sg13cmos5l_decap_4
XFILLER_357_258 VPWR VGND sg13cmos5l_fill_2
XFILLER_109_214 VPWR VGND sg13cmos5l_decap_8
XFILLER_176_191 VPWR VGND sg13cmos5l_decap_8
XFILLER_11_42 VPWR VGND sg13cmos5l_decap_8
XFILLER_127_42 VPWR VGND sg13cmos5l_decap_8
XFILLER_274_70 VPWR VGND sg13cmos5l_decap_8
XANTENNA__1534__X Tile_X0Y3_E6BEG[8] VPWR VGND sg13cmos5l_antennanp
XFILLER_132_272 VPWR VGND sg13cmos5l_fill_1
XFILLER_278_254 VPWR VGND sg13cmos5l_decap_4
XFILLER_87_35 VPWR VGND sg13cmos5l_decap_8
XFILLER_143_63 VPWR VGND sg13cmos5l_decap_8
XFILLER_293_246 VPWR VGND sg13cmos5l_decap_8
XFILLER_293_257 VPWR VGND sg13cmos5l_fill_1
XFILLER_360_28 VPWR VGND sg13cmos5l_decap_8
XFILLER_246_140 VPWR VGND sg13cmos5l_decap_8
XFILLER_290_91 VPWR VGND sg13cmos5l_decap_8
XFILLER_246_184 VPWR VGND sg13cmos5l_decap_8
XFILLER_246_195 VPWR VGND sg13cmos5l_fill_2
XFILLER_46_256 VPWR VGND sg13cmos5l_fill_2
XFILLER_46_245 VPWR VGND sg13cmos5l_decap_8
XFILLER_265_0 VPWR VGND sg13cmos5l_decap_8
XFILLER_199_272 VPWR VGND sg13cmos5l_fill_1
XANTENNA__1709__X Tile_X0Y0_E6BEG[1] VPWR VGND sg13cmos5l_antennanp
X_0740_ _0740_/Q Tile_X0Y2_FrameData[2] VGND VPWR Tile_X0Y5_FrameStrobe[5] latch
XFILLER_316_133 VPWR VGND sg13cmos5l_fill_1
XFILLER_316_155 VPWR VGND sg13cmos5l_fill_2
XFILLER_182_161 VPWR VGND sg13cmos5l_decap_8
XFILLER_182_194 VPWR VGND sg13cmos5l_decap_8
XFILLER_318_63 VPWR VGND sg13cmos5l_decap_8
X_2410_ _2410_/X AXIL_S_SOC_AWADDR1 AXIL_S_SOC_AWADDR9 _2482_/X _2487_/X _0728_/Q
+ _0727_/Q VPWR VGND sg13cmos5l_mux4_1
X_0671_ _0671_/Q Tile_X0Y2_FrameData[7] VGND VPWR Tile_X0Y5_FrameStrobe[3] latch
XFILLER_184_70 VPWR VGND sg13cmos5l_decap_8
XFILLER_130_209 VPWR VGND sg13cmos5l_fill_1
X_2341_ _2341_/X Tile_X0Y0_W1END[0] Tile_X0Y0_W6END[8] _2229_/X _2209_/X _0178_/Q
+ _0177_/Q VPWR VGND sg13cmos5l_mux4_1
XFILLER_96_112 VPWR VGND sg13cmos5l_fill_1
X_2272_ _2272_/X _2372_/X _2371_/X _2362_/X _2361_/X _0526_/Q _0525_/Q VPWR VGND sg13cmos5l_mux4_1
XFILLER_270_28 VPWR VGND sg13cmos5l_decap_8
XFILLER_334_84 VPWR VGND sg13cmos5l_decap_8
X_1223_ _1223_/Q Tile_X0Y4_FrameData[31] VGND VPWR Tile_X0Y5_FrameStrobe[6] latch
XFILLER_237_140 VPWR VGND sg13cmos5l_decap_8
XFILLER_96_189 VPWR VGND sg13cmos5l_decap_8
X_1154_ _1154_/Q Tile_X0Y4_FrameData[4] VGND VPWR Tile_X0Y5_FrameStrobe[3] latch
XFILLER_203_77 VPWR VGND sg13cmos5l_decap_8
X_1085_ _1085_/Q Tile_X0Y4_FrameData[9] VGND VPWR Tile_X0Y5_FrameStrobe[1] latch
X_0105_ _0105_/Q Tile_X0Y0_FrameData[29] VGND VPWR Tile_X0Y5_FrameStrobe[1] latch
X_0036_ _1619_/A _2159_/X _2160_/X _0275_/Q VPWR VGND sg13cmos5l_mux2_1
XFILLER_20_112 VPWR VGND sg13cmos5l_decap_8
XFILLER_20_123 VPWR VGND sg13cmos5l_fill_2
XFILLER_359_70 VPWR VGND sg13cmos5l_decap_8
XFILLER_165_106 VPWR VGND sg13cmos5l_decap_8
XFILLER_295_14 VPWR VGND sg13cmos5l_decap_8
X_1987_ Tile_X0Y5_E6BEG[0] _2757_/X VPWR VGND sg13cmos5l_buf_1
XFILLER_354_217 VPWR VGND sg13cmos5l_decap_8
XANTENNA__1619__X Tile_X0Y0_N4BEG[15] VPWR VGND sg13cmos5l_antennanp
X_0938_ _0938_/Q Tile_X0Y3_FrameData[12] VGND VPWR Tile_X0Y5_FrameStrobe[4] latch
XFILLER_307_133 VPWR VGND sg13cmos5l_decap_8
XFILLER_173_161 VPWR VGND sg13cmos5l_decap_8
XFILLER_228_63 VPWR VGND sg13cmos5l_decap_8
X_0869_ _0869_/Q Tile_X0Y3_FrameData[17] VGND VPWR Tile_X0Y5_FrameStrobe[2] latch
XFILLER_362_272 VPWR VGND sg13cmos5l_fill_1
X_2608_ _2608_/X Tile_X0Y5_W2MID[2] Tile_X0Y5_W2END[2] Tile_X0Y5_W6END[2] _2799_/X
+ _1478_/Q _1477_/Q VPWR VGND sg13cmos5l_mux4_1
X_2539_ _2539_/X AXIL_S_SOC_ARADDR2 AXIL_S_SOC_ARADDR4 _2586_/X _2590_/X _0926_/Q
+ _0925_/Q VPWR VGND sg13cmos5l_mux4_1
XFILLER_180_28 VPWR VGND sg13cmos5l_decap_8
XFILLER_244_84 VPWR VGND sg13cmos5l_decap_8
XFILLER_87_156 VPWR VGND sg13cmos5l_decap_8
XFILLER_57_49 VPWR VGND sg13cmos5l_decap_8
XFILLER_189_7 VPWR VGND sg13cmos5l_decap_8
XFILLER_228_140 VPWR VGND sg13cmos5l_decap_8
XFILLER_113_77 VPWR VGND sg13cmos5l_decap_8
XFILLER_243_154 VPWR VGND sg13cmos5l_decap_8
XFILLER_356_7 VPWR VGND sg13cmos5l_decap_8
XFILLER_11_112 VPWR VGND sg13cmos5l_decap_8
XFILLER_269_70 VPWR VGND sg13cmos5l_decap_8
XANTENNA__1529__X Tile_X0Y3_E6BEG[3] VPWR VGND sg13cmos5l_antennanp
XFILLER_149_180 VPWR VGND sg13cmos5l_decap_4
XFILLER_7_116 VPWR VGND sg13cmos5l_fill_2
XFILLER_164_150 VPWR VGND sg13cmos5l_fill_2
XFILLER_22_63 VPWR VGND sg13cmos5l_decap_8
XFILLER_138_63 VPWR VGND sg13cmos5l_decap_8
XFILLER_285_91 VPWR VGND sg13cmos5l_decap_8
XFILLER_355_28 VPWR VGND sg13cmos5l_decap_8
XFILLER_353_272 VPWR VGND sg13cmos5l_fill_1
XFILLER_353_261 VPWR VGND sg13cmos5l_fill_2
XFILLER_313_147 VPWR VGND sg13cmos5l_decap_8
XFILLER_98_56 VPWR VGND sg13cmos5l_decap_8
XFILLER_105_272 VPWR VGND sg13cmos5l_fill_1
XFILLER_78_112 VPWR VGND sg13cmos5l_fill_2
XFILLER_154_84 VPWR VGND sg13cmos5l_decap_8
XFILLER_304_21 VPWR VGND sg13cmos5l_decap_8
XFILLER_78_178 VPWR VGND sg13cmos5l_decap_8
XFILLER_93_126 VPWR VGND sg13cmos5l_fill_2
XFILLER_304_98 VPWR VGND sg13cmos5l_decap_8
XANTENNA__2095__X Tile_X0Y3_E2BEG[7] VPWR VGND sg13cmos5l_antennanp
XFILLER_234_154 VPWR VGND sg13cmos5l_decap_8
XFILLER_320_42 VPWR VGND sg13cmos5l_decap_8
XFILLER_63_70 VPWR VGND sg13cmos5l_decap_8
XFILLER_179_70 VPWR VGND sg13cmos5l_decap_8
X_1910_ Tile_X0Y1_FrameData_O[23] Tile_X0Y1_FrameData[23] VPWR VGND sg13cmos5l_buf_1
X_1841_ Tile_X0Y4_FrameData_O[8] Tile_X0Y4_FrameData[8] VPWR VGND sg13cmos5l_buf_1
XFILLER_8_21 VPWR VGND sg13cmos5l_decap_8
XFILLER_329_84 VPWR VGND sg13cmos5l_decap_8
X_1772_ Tile_X0Y2_UserCLKo Tile_X0Y2_UserCLK VPWR VGND sg13cmos5l_buf_1
XFILLER_195_91 VPWR VGND sg13cmos5l_decap_8
XFILLER_265_28 VPWR VGND sg13cmos5l_decap_8
X_0723_ _0723_/Q Tile_X0Y2_FrameData[19] VGND VPWR Tile_X0Y5_FrameStrobe[5] latch
XFILLER_304_147 VPWR VGND sg13cmos5l_decap_8
X_0654_ _0654_/Q Tile_X0Y2_FrameData[24] VGND VPWR Tile_X0Y5_FrameStrobe[3] latch
X_2324_ _2324_/X AXIL_S_SOC_WDATA3 AXIL_S_SOC_WDATA15 _2372_/X _2373_/X _0444_/Q _0443_/Q
+ VPWR VGND sg13cmos5l_mux4_1
X_0585_ _0585_/Q Tile_X0Y2_FrameData[29] VGND VPWR Tile_X0Y5_FrameStrobe[1] latch
XFILLER_69_112 VPWR VGND sg13cmos5l_decap_8
XFILLER_214_21 VPWR VGND sg13cmos5l_decap_8
XFILLER_26_0 VPWR VGND sg13cmos5l_decap_8
XFILLER_281_49 VPWR VGND sg13cmos5l_decap_8
XFILLER_312_191 VPWR VGND sg13cmos5l_decap_8
XANTENNA__1902__X Tile_X0Y1_FrameData_O[15] VPWR VGND sg13cmos5l_antennanp
X_2255_ _2255_/X Tile_X0Y2_W2MID[4] Tile_X0Y2_W2END[4] Tile_X0Y2_W6END[4] _2484_/X
+ _0776_/Q _0775_/Q VPWR VGND sg13cmos5l_mux4_1
XFILLER_214_98 VPWR VGND sg13cmos5l_decap_8
X_2186_ _2186_/X AXIL_S_SOC_WDATA21 AXIL_S_SOC_WDATA25 _2222_/X _2243_/X _0224_/Q
+ _0223_/Q VPWR VGND sg13cmos5l_mux4_1
X_1206_ _1206_/Q Tile_X0Y4_FrameData[16] VGND VPWR Tile_X0Y5_FrameStrobe[5] latch
XFILLER_84_148 VPWR VGND sg13cmos5l_decap_8
XFILLER_25_204 VPWR VGND sg13cmos5l_decap_4
X_1137_ _1137_/Q Tile_X0Y4_FrameData[21] VGND VPWR Tile_X0Y5_FrameStrobe[3] latch
XFILLER_225_165 VPWR VGND sg13cmos5l_decap_8
XFILLER_230_42 VPWR VGND sg13cmos5l_decap_8
X_1068_ _1068_/Q Tile_X0Y4_FrameData[26] VGND VPWR Tile_X0Y5_FrameStrobe[1] latch
XFILLER_240_168 VPWR VGND sg13cmos5l_decap_8
XFILLER_40_218 VPWR VGND sg13cmos5l_decap_8
XFILLER_33_270 VPWR VGND sg13cmos5l_fill_2
XFILLER_239_84 VPWR VGND sg13cmos5l_decap_8
XFILLER_175_28 VPWR VGND sg13cmos5l_decap_8
XFILLER_335_272 VPWR VGND sg13cmos5l_fill_1
XFILLER_4_119 VPWR VGND sg13cmos5l_fill_2
XFILLER_108_77 VPWR VGND sg13cmos5l_decap_8
XFILLER_255_83 VPWR VGND sg13cmos5l_decap_8
XFILLER_350_264 VPWR VGND sg13cmos5l_fill_1
XFILLER_102_231 VPWR VGND sg13cmos5l_decap_8
XFILLER_124_21 VPWR VGND sg13cmos5l_decap_8
XFILLER_191_49 VPWR VGND sg13cmos5l_decap_8
XANTENNA__1812__X Tile_X0Y4_E6BEG[7] VPWR VGND sg13cmos5l_antennanp
XFILLER_124_98 VPWR VGND sg13cmos5l_decap_8
XFILLER_84_14 VPWR VGND sg13cmos5l_decap_8
XFILLER_16_215 VPWR VGND sg13cmos5l_fill_1
XFILLER_140_42 VPWR VGND sg13cmos5l_decap_8
XFILLER_16_226 VPWR VGND sg13cmos5l_fill_1
XFILLER_17_63 VPWR VGND sg13cmos5l_decap_8
XFILLER_231_168 VPWR VGND sg13cmos5l_decap_4
XFILLER_130_0 VPWR VGND sg13cmos5l_decap_8
XFILLER_228_0 VPWR VGND sg13cmos5l_decap_8
XFILLER_144_109 VPWR VGND sg13cmos5l_fill_1
XFILLER_152_153 VPWR VGND sg13cmos5l_decap_8
XFILLER_165_50 VPWR VGND sg13cmos5l_decap_8
XFILLER_3_163 VPWR VGND sg13cmos5l_decap_8
XFILLER_3_141 VPWR VGND sg13cmos5l_decap_8
XFILLER_152_186 VPWR VGND sg13cmos5l_decap_8
XFILLER_298_168 VPWR VGND sg13cmos5l_decap_8
XFILLER_315_42 VPWR VGND sg13cmos5l_decap_8
X_0370_ _0370_/Q Tile_X0Y1_FrameData[4] VGND VPWR Tile_X0Y5_FrameStrobe[1] latch
XFILLER_239_246 VPWR VGND sg13cmos5l_decap_8
XFILLER_66_126 VPWR VGND sg13cmos5l_decap_8
XFILLER_58_70 VPWR VGND sg13cmos5l_decap_8
XANTENNA__1722__X Tile_X0Y0_E2BEGb[2] VPWR VGND sg13cmos5l_antennanp
X_2040_ Tile_X0Y5_FrameData_O[25] Tile_X0Y5_FrameData[25] VPWR VGND sg13cmos5l_buf_1
XFILLER_207_121 VPWR VGND sg13cmos5l_decap_4
XFILLER_207_132 VPWR VGND sg13cmos5l_decap_8
XFILLER_331_63 VPWR VGND sg13cmos5l_decap_8
XFILLER_207_187 VPWR VGND sg13cmos5l_decap_8
XFILLER_207_198 VPWR VGND sg13cmos5l_fill_1
XFILLER_74_91 VPWR VGND sg13cmos5l_decap_8
XFILLER_200_56 VPWR VGND sg13cmos5l_decap_8
XFILLER_175_234 VPWR VGND sg13cmos5l_fill_2
XFILLER_209_21 VPWR VGND sg13cmos5l_decap_8
XFILLER_276_49 VPWR VGND sg13cmos5l_decap_8
X_1824_ Tile_X0Y4_EE4BEG[7] _2640_/X VPWR VGND sg13cmos5l_buf_1
X_1755_ Tile_X0Y2_FrameData_O[15] Tile_X0Y2_FrameData[15] VPWR VGND sg13cmos5l_buf_1
XFILLER_190_248 VPWR VGND sg13cmos5l_fill_1
X_0706_ _0706_/Q Tile_X0Y2_FrameData[4] VGND VPWR Tile_X0Y5_FrameStrobe[4] latch
XFILLER_143_153 VPWR VGND sg13cmos5l_decap_8
X_1686_ Tile_X0Y0_FrameData_O[26] Tile_X0Y0_FrameData[26] VPWR VGND sg13cmos5l_buf_1
XFILLER_289_168 VPWR VGND sg13cmos5l_fill_2
X_0637_ _0637_/Q Tile_X0Y2_FrameData[9] VGND VPWR Tile_X0Y5_FrameStrobe[2] latch
XFILLER_225_42 VPWR VGND sg13cmos5l_decap_8
X_0568_ _0568_/Q Tile_X0Y2_FrameData[14] VGND VPWR Tile_X0Y5_FrameStrobe[0] latch
XFILLER_300_161 VPWR VGND sg13cmos5l_decap_8
X_2307_ _2307_/X AXIL_S_SOC_WDATA6 AXIL_S_SOC_WDATA14 _2374_/X _2379_/X _0478_/Q _0477_/Q
+ VPWR VGND sg13cmos5l_mux4_1
XFILLER_57_126 VPWR VGND sg13cmos5l_decap_8
XANTENNA__1632__X Tile_X0Y0_N2BEG[4] VPWR VGND sg13cmos5l_antennanp
XFILLER_245_227 VPWR VGND sg13cmos5l_fill_1
X_2238_ _2238_/X _2214_/X _0066_/X Tile_X0Y0_S1END[1] Tile_X0Y0_S4END[1] _0124_/Q
+ _0123_/Q VPWR VGND sg13cmos5l_mux4_1
X_0499_ _0499_/Q Tile_X0Y1_FrameData[3] VGND VPWR Tile_X0Y5_FrameStrobe[5] latch
XANTENNA_309 Tile_X0Y0_FrameData[23] VPWR VGND sg13cmos5l_antennanp
XFILLER_241_63 VPWR VGND sg13cmos5l_decap_8
X_2169_ _2169_/X AXIL_S_SOC_WDATA20 AXIL_S_SOC_WDATA28 _2244_/X _2245_/X _0258_/Q
+ _0257_/Q VPWR VGND sg13cmos5l_mux4_1
XFILLER_54_28 VPWR VGND sg13cmos5l_decap_8
XFILLER_253_271 VPWR VGND sg13cmos5l_fill_2
XFILLER_110_56 VPWR VGND sg13cmos5l_decap_8
XFILLER_70_49 VPWR VGND sg13cmos5l_decap_8
XFILLER_186_49 VPWR VGND sg13cmos5l_decap_8
XFILLER_221_7 VPWR VGND sg13cmos5l_decap_8
XFILLER_319_7 VPWR VGND sg13cmos5l_decap_8
XFILLER_119_161 VPWR VGND sg13cmos5l_decap_8
XFILLER_119_21 VPWR VGND sg13cmos5l_decap_8
XFILLER_181_204 VPWR VGND sg13cmos5l_decap_8
XANTENNA__1807__X Tile_X0Y4_E6BEG[2] VPWR VGND sg13cmos5l_antennanp
XFILLER_79_14 VPWR VGND sg13cmos5l_decap_8
XFILLER_119_98 VPWR VGND sg13cmos5l_decap_8
XFILLER_295_105 VPWR VGND sg13cmos5l_decap_8
XFILLER_0_133 VPWR VGND sg13cmos5l_decap_4
XFILLER_135_42 VPWR VGND sg13cmos5l_decap_8
XFILLER_282_70 VPWR VGND sg13cmos5l_decap_8
XFILLER_0_166 VPWR VGND sg13cmos5l_fill_1
XFILLER_95_35 VPWR VGND sg13cmos5l_decap_8
XANTENNA__1542__X Tile_X0Y3_EE4BEG[4] VPWR VGND sg13cmos5l_antennanp
XFILLER_236_205 VPWR VGND sg13cmos5l_decap_8
XFILLER_95_79 VPWR VGND sg13cmos5l_fill_1
XFILLER_48_137 VPWR VGND sg13cmos5l_decap_8
XFILLER_28_84 VPWR VGND sg13cmos5l_decap_8
XFILLER_151_63 VPWR VGND sg13cmos5l_decap_8
XFILLER_178_0 VPWR VGND sg13cmos5l_decap_8
XFILLER_251_208 VPWR VGND sg13cmos5l_fill_2
XFILLER_244_271 VPWR VGND sg13cmos5l_fill_2
XFILLER_301_77 VPWR VGND sg13cmos5l_decap_8
XFILLER_345_0 VPWR VGND sg13cmos5l_decap_8
XFILLER_157_212 VPWR VGND sg13cmos5l_decap_8
XFILLER_358_161 VPWR VGND sg13cmos5l_decap_8
XFILLER_67_7 VPWR VGND sg13cmos5l_decap_8
XANTENNA__1717__X Tile_X0Y0_E6BEG[9] VPWR VGND sg13cmos5l_antennanp
X_1540_ Tile_X0Y3_EE4BEG[2] _2527_/X VPWR VGND sg13cmos5l_buf_1
XFILLER_326_63 VPWR VGND sg13cmos5l_decap_8
X_1471_ _1471_/Q Tile_X0Y5_FrameData[17] VGND VPWR Tile_X0Y5_FrameStrobe[6] latch
XFILLER_5_77 VPWR VGND sg13cmos5l_decap_8
XFILLER_192_70 VPWR VGND sg13cmos5l_decap_8
XFILLER_286_127 VPWR VGND sg13cmos5l_decap_8
X_0422_ _0422_/Q Tile_X0Y1_FrameData[16] VGND VPWR Tile_X0Y5_FrameStrobe[3] latch
XFILLER_69_91 VPWR VGND sg13cmos5l_decap_8
X_0353_ _0353_/Q Tile_X0Y1_FrameData[21] VGND VPWR Tile_X0Y5_FrameStrobe[1] latch
XFILLER_227_205 VPWR VGND sg13cmos5l_fill_1
XFILLER_294_182 VPWR VGND sg13cmos5l_decap_8
XFILLER_39_126 VPWR VGND sg13cmos5l_decap_4
XFILLER_227_238 VPWR VGND sg13cmos5l_decap_8
X_0284_ _0284_/Q Tile_X0Y0_FrameData[10] VGND VPWR Tile_X0Y5_FrameStrobe[6] latch
XFILLER_94_254 VPWR VGND sg13cmos5l_fill_2
X_2023_ Tile_X0Y5_FrameData_O[8] Tile_X0Y5_FrameData[8] VPWR VGND sg13cmos5l_buf_1
XFILLER_235_271 VPWR VGND sg13cmos5l_fill_2
XFILLER_62_140 VPWR VGND sg13cmos5l_decap_8
XFILLER_211_77 VPWR VGND sg13cmos5l_decap_8
XFILLER_93_0 VPWR VGND sg13cmos5l_decap_8
XFILLER_148_212 VPWR VGND sg13cmos5l_decap_8
XFILLER_349_161 VPWR VGND sg13cmos5l_decap_8
XFILLER_148_256 VPWR VGND sg13cmos5l_decap_8
XFILLER_108_109 VPWR VGND sg13cmos5l_fill_2
X_1807_ Tile_X0Y4_E6BEG[2] _2651_/X VPWR VGND sg13cmos5l_buf_1
XANTENNA__1627__X Tile_X0Y0_N2BEGb[7] VPWR VGND sg13cmos5l_antennanp
X_2787_ _2787_/X Tile_X0Y5_W1END[3] Tile_X0Y5_WW4END[15] Tile_X0Y5_W6END[7] _2819_/X
+ _1331_/Q _1330_/Q VPWR VGND sg13cmos5l_mux4_1
X_1738_ Tile_X0Y0_E1BEG[2] _2163_/X VPWR VGND sg13cmos5l_buf_1
XFILLER_116_175 VPWR VGND sg13cmos5l_decap_8
XFILLER_131_112 VPWR VGND sg13cmos5l_fill_2
XFILLER_236_63 VPWR VGND sg13cmos5l_decap_8
XFILLER_277_105 VPWR VGND sg13cmos5l_decap_8
X_1669_ Tile_X0Y0_FrameData_O[9] Tile_X0Y0_FrameData[9] VPWR VGND sg13cmos5l_buf_1
XFILLER_49_28 VPWR VGND sg13cmos5l_decap_8
XFILLER_131_156 VPWR VGND sg13cmos5l_decap_4
XFILLER_277_116 VPWR VGND sg13cmos5l_fill_1
XFILLER_277_138 VPWR VGND sg13cmos5l_decap_4
XFILLER_105_56 VPWR VGND sg13cmos5l_decap_8
XFILLER_218_205 VPWR VGND sg13cmos5l_decap_8
XFILLER_292_119 VPWR VGND sg13cmos5l_decap_8
XFILLER_218_249 VPWR VGND sg13cmos5l_decap_8
XFILLER_252_84 VPWR VGND sg13cmos5l_decap_8
XFILLER_285_193 VPWR VGND sg13cmos5l_fill_2
XFILLER_65_49 VPWR VGND sg13cmos5l_decap_8
XANTENNA_106 AXIL_S_SOC_WDATA27 VPWR VGND sg13cmos5l_antennanp
XFILLER_171_7 VPWR VGND sg13cmos5l_decap_8
XFILLER_269_7 VPWR VGND sg13cmos5l_decap_8
XANTENNA_117 AXIL_S_SOC_WDATA27 VPWR VGND sg13cmos5l_antennanp
XANTENNA_128 AXIL_S_SOC_WDATA29 VPWR VGND sg13cmos5l_antennanp
XANTENNA_139 AXIL_S_SOC_WDATA30 VPWR VGND sg13cmos5l_antennanp
XFILLER_198_112 VPWR VGND sg13cmos5l_decap_8
XFILLER_53_140 VPWR VGND sg13cmos5l_decap_8
XFILLER_121_77 VPWR VGND sg13cmos5l_decap_8
XFILLER_81_15 VPWR VGND sg13cmos5l_decap_8
XFILLER_201_127 VPWR VGND sg13cmos5l_fill_2
XFILLER_14_42 VPWR VGND sg13cmos5l_decap_8
XFILLER_347_29 VPWR VGND sg13cmos5l_decap_8
XFILLER_277_70 VPWR VGND sg13cmos5l_decap_8
XFILLER_355_175 VPWR VGND sg13cmos5l_decap_8
XANTENNA__1537__X Tile_X0Y3_E6BEG[11] VPWR VGND sg13cmos5l_antennanp
XFILLER_154_226 VPWR VGND sg13cmos5l_fill_2
XFILLER_30_63 VPWR VGND sg13cmos5l_decap_8
XFILLER_107_197 VPWR VGND sg13cmos5l_fill_1
XFILLER_122_112 VPWR VGND sg13cmos5l_decap_8
XFILLER_146_63 VPWR VGND sg13cmos5l_decap_8
XFILLER_293_91 VPWR VGND sg13cmos5l_decap_8
XFILLER_295_0 VPWR VGND sg13cmos5l_decap_8
XFILLER_209_216 VPWR VGND sg13cmos5l_decap_8
XFILLER_283_119 VPWR VGND sg13cmos5l_decap_8
XFILLER_162_84 VPWR VGND sg13cmos5l_decap_8
XFILLER_312_21 VPWR VGND sg13cmos5l_decap_8
XFILLER_91_246 VPWR VGND sg13cmos5l_decap_8
XFILLER_312_98 VPWR VGND sg13cmos5l_decap_8
XFILLER_44_162 VPWR VGND sg13cmos5l_decap_8
X_0971_ _0971_/Q Tile_X0Y3_FrameData[11] VGND VPWR Tile_X0Y5_FrameStrobe[5] latch
X_2710_ _2710_/X _2602_/X Tile_X0Y5_N2MID[2] _2715_/X _2601_/X _1050_/Q _1049_/Q VPWR
+ VGND sg13cmos5l_mux4_1
XFILLER_71_70 VPWR VGND sg13cmos5l_decap_8
XFILLER_346_131 VPWR VGND sg13cmos5l_decap_8
XFILLER_145_215 VPWR VGND sg13cmos5l_decap_8
XFILLER_187_70 VPWR VGND sg13cmos5l_decap_8
X_2641_ _2641_/X AXIL_S_SOC_WSTRB2 AXIL_S_SOC_WVALID _2700_/X _2681_/X _1172_/Q _1171_/Q
+ VPWR VGND sg13cmos5l_mux4_1
XFILLER_361_101 VPWR VGND sg13cmos5l_fill_2
X_2572_ _2572_/X Tile_X0Y4_W1END[3] Tile_X0Y4_W6END[7] _2684_/X _2672_/X _1258_/Q
+ _1257_/Q VPWR VGND sg13cmos5l_mux4_1
XFILLER_337_84 VPWR VGND sg13cmos5l_decap_8
XFILLER_113_112 VPWR VGND sg13cmos5l_decap_8
XFILLER_259_105 VPWR VGND sg13cmos5l_decap_8
XFILLER_273_28 VPWR VGND sg13cmos5l_decap_8
XFILLER_299_252 VPWR VGND sg13cmos5l_decap_8
XFILLER_299_263 VPWR VGND sg13cmos5l_fill_2
X_1523_ Tile_X0Y3_E2BEGb[5] _2522_/X VPWR VGND sg13cmos5l_buf_1
XFILLER_259_116 VPWR VGND sg13cmos5l_fill_1
X_1454_ _1454_/Q Tile_X0Y5_FrameData[2] VGND VPWR Tile_X0Y5_FrameStrobe[5] latch
X_0405_ _0405_/Q Tile_X0Y1_FrameData[1] VGND VPWR Tile_X0Y5_FrameStrobe[2] latch
XFILLER_206_77 VPWR VGND sg13cmos5l_decap_8
XFILLER_274_119 VPWR VGND sg13cmos5l_decap_8
X_1385_ _1385_/Q Tile_X0Y5_FrameData[7] VGND VPWR Tile_X0Y5_FrameStrobe[3] latch
XFILLER_222_21 VPWR VGND sg13cmos5l_decap_8
X_0336_ _0336_/Q Tile_X0Y1_FrameData[6] VGND VPWR Tile_X0Y5_FrameStrobe[0] latch
X_0267_ _0267_/Q Tile_X0Y0_FrameData[27] VGND VPWR Tile_X0Y5_FrameStrobe[6] latch
XANTENNA__1910__X Tile_X0Y1_FrameData_O[23] VPWR VGND sg13cmos5l_antennanp
XFILLER_282_174 VPWR VGND sg13cmos5l_fill_2
X_2006_ Tile_X0Y5_EE4BEG[7] _2748_/X VPWR VGND sg13cmos5l_buf_1
XFILLER_222_98 VPWR VGND sg13cmos5l_decap_8
XFILLER_223_252 VPWR VGND sg13cmos5l_decap_4
XFILLER_298_14 VPWR VGND sg13cmos5l_decap_8
X_0198_ _0198_/Q Tile_X0Y0_FrameData[0] VGND VPWR Tile_X0Y5_FrameStrobe[3] latch
XFILLER_50_154 VPWR VGND sg13cmos5l_decap_8
XFILLER_337_164 VPWR VGND sg13cmos5l_fill_1
XFILLER_337_153 VPWR VGND sg13cmos5l_decap_8
XFILLER_352_112 VPWR VGND sg13cmos5l_decap_8
XFILLER_151_207 VPWR VGND sg13cmos5l_decap_8
XFILLER_247_84 VPWR VGND sg13cmos5l_decap_8
XFILLER_183_28 VPWR VGND sg13cmos5l_decap_8
XFILLER_352_189 VPWR VGND sg13cmos5l_decap_8
XFILLER_104_134 VPWR VGND sg13cmos5l_decap_8
XFILLER_116_77 VPWR VGND sg13cmos5l_decap_8
XFILLER_132_21 VPWR VGND sg13cmos5l_decap_8
XFILLER_206_208 VPWR VGND sg13cmos5l_decap_8
XANTENNA__1820__X Tile_X0Y4_EE4BEG[3] VPWR VGND sg13cmos5l_antennanp
XFILLER_92_14 VPWR VGND sg13cmos5l_decap_8
XFILLER_132_98 VPWR VGND sg13cmos5l_decap_8
XFILLER_25_63 VPWR VGND sg13cmos5l_decap_8
XFILLER_186_126 VPWR VGND sg13cmos5l_fill_2
XFILLER_41_165 VPWR VGND sg13cmos5l_decap_4
XFILLER_358_28 VPWR VGND sg13cmos5l_decap_8
XFILLER_288_91 VPWR VGND sg13cmos5l_decap_8
XFILLER_210_0 VPWR VGND sg13cmos5l_decap_8
XFILLER_343_112 VPWR VGND sg13cmos5l_decap_8
XFILLER_157_84 VPWR VGND sg13cmos5l_decap_8
XFILLER_308_0 VPWR VGND sg13cmos5l_decap_8
XFILLER_41_95 VPWR VGND sg13cmos5l_decap_8
XFILLER_307_21 VPWR VGND sg13cmos5l_decap_8
XFILLER_307_98 VPWR VGND sg13cmos5l_decap_8
XANTENNA__2098__X Tile_X0Y3_E2BEGb[2] VPWR VGND sg13cmos5l_antennanp
XFILLER_110_126 VPWR VGND sg13cmos5l_decap_4
XFILLER_256_119 VPWR VGND sg13cmos5l_decap_8
XFILLER_49_210 VPWR VGND sg13cmos5l_decap_8
XFILLER_2_56 VPWR VGND sg13cmos5l_decap_8
XFILLER_323_42 VPWR VGND sg13cmos5l_decap_8
X_1170_ _1170_/Q Tile_X0Y4_FrameData[20] VGND VPWR Tile_X0Y5_FrameStrobe[4] latch
XFILLER_264_130 VPWR VGND sg13cmos5l_fill_2
X_0121_ _0121_/Q Tile_X0Y0_FrameData[13] VGND VPWR Tile_X0Y5_FrameStrobe[1] latch
XFILLER_66_70 VPWR VGND sg13cmos5l_decap_8
XANTENNA__1730__X Tile_X0Y0_E2BEG[2] VPWR VGND sg13cmos5l_antennanp
XFILLER_64_235 VPWR VGND sg13cmos5l_decap_4
XFILLER_17_140 VPWR VGND sg13cmos5l_decap_8
X_0052_ _1605_/A _2285_/X _2286_/X _1001_/Q VPWR VGND sg13cmos5l_mux2_1
XFILLER_177_126 VPWR VGND sg13cmos5l_decap_8
XFILLER_220_233 VPWR VGND sg13cmos5l_decap_8
XFILLER_268_28 VPWR VGND sg13cmos5l_decap_8
XFILLER_82_91 VPWR VGND sg13cmos5l_decap_8
XANTENNA_17 AXIL_S_SOC_WDATA10 VPWR VGND sg13cmos5l_antennanp
XANTENNA_28 AXIL_S_SOC_WDATA11 VPWR VGND sg13cmos5l_antennanp
XANTENNA_39 AXIL_S_SOC_WDATA15 VPWR VGND sg13cmos5l_antennanp
XFILLER_198_91 VPWR VGND sg13cmos5l_decap_8
X_0954_ _0954_/Q Tile_X0Y3_FrameData[28] VGND VPWR Tile_X0Y5_FrameStrobe[5] latch
X_0885_ _0885_/Q Tile_X0Y3_FrameData[1] VGND VPWR Tile_X0Y5_FrameStrobe[2] latch
XFILLER_284_49 VPWR VGND sg13cmos5l_decap_8
X_2624_ _2624_/X AXIL_S_SOC_WSTRB1 AXIL_S_SOC_WSTRB3 _2708_/X _2681_/X _1206_/Q _1205_/Q
+ VPWR VGND sg13cmos5l_mux4_1
XFILLER_217_21 VPWR VGND sg13cmos5l_decap_8
XFILLER_56_0 VPWR VGND sg13cmos5l_decap_8
XANTENNA__1905__X Tile_X0Y1_FrameData_O[18] VPWR VGND sg13cmos5l_antennanp
X_2555_ _2555_/X Tile_X0Y3_W1END[1] Tile_X0Y3_WW4END[9] Tile_X0Y3_WW4END[13] Tile_X0Y3_W6END[5]
+ _0871_/Q _0870_/Q VPWR VGND sg13cmos5l_mux4_1
XFILLER_217_98 VPWR VGND sg13cmos5l_decap_8
X_1506_ _2792_/A3 VPWR VGND sg13cmos5l_tielo
X_2486_ _2486_/X _2392_/X _2500_/X _2499_/X _2391_/X _0564_/Q _0563_/Q VPWR VGND sg13cmos5l_mux4_1
XFILLER_99_176 VPWR VGND sg13cmos5l_decap_4
XFILLER_101_126 VPWR VGND sg13cmos5l_decap_8
XFILLER_247_119 VPWR VGND sg13cmos5l_decap_8
X_1437_ _1437_/Q Tile_X0Y5_FrameData[19] VGND VPWR Tile_X0Y5_FrameStrobe[5] latch
XFILLER_99_198 VPWR VGND sg13cmos5l_decap_8
XFILLER_233_42 VPWR VGND sg13cmos5l_decap_8
X_1368_ _1368_/Q Tile_X0Y5_FrameData[24] VGND VPWR Tile_X0Y5_FrameStrobe[3] latch
X_0319_ _0319_/Q Tile_X0Y1_FrameData[23] VGND VPWR Tile_X0Y5_FrameStrobe[0] latch
XFILLER_55_224 VPWR VGND sg13cmos5l_decap_8
XFILLER_46_29 VPWR VGND sg13cmos5l_decap_8
XANTENNA__1640__X Tile_X0Y0_FrameStrobe_O[0] VPWR VGND sg13cmos5l_antennanp
X_1299_ _1299_/Q Tile_X0Y5_FrameData[29] VGND VPWR Tile_X0Y5_FrameStrobe[1] latch
XFILLER_102_35 VPWR VGND sg13cmos5l_decap_8
XFILLER_70_216 VPWR VGND sg13cmos5l_decap_8
XFILLER_62_28 VPWR VGND sg13cmos5l_decap_8
XFILLER_178_28 VPWR VGND sg13cmos5l_decap_8
XFILLER_211_211 VPWR VGND sg13cmos5l_decap_8
XFILLER_357_237 VPWR VGND sg13cmos5l_decap_8
XFILLER_134_7 VPWR VGND sg13cmos5l_decap_8
XFILLER_325_112 VPWR VGND sg13cmos5l_decap_8
XFILLER_11_21 VPWR VGND sg13cmos5l_decap_8
XFILLER_124_207 VPWR VGND sg13cmos5l_fill_1
XFILLER_194_49 VPWR VGND sg13cmos5l_decap_8
XFILLER_301_7 VPWR VGND sg13cmos5l_decap_8
XFILLER_124_229 VPWR VGND sg13cmos5l_fill_2
XFILLER_127_21 VPWR VGND sg13cmos5l_decap_8
XANTENNA__1815__X Tile_X0Y4_E6BEG[10] VPWR VGND sg13cmos5l_antennanp
XFILLER_11_98 VPWR VGND sg13cmos5l_decap_8
XFILLER_87_14 VPWR VGND sg13cmos5l_decap_8
XFILLER_340_126 VPWR VGND sg13cmos5l_decap_8
XFILLER_127_98 VPWR VGND sg13cmos5l_decap_8
XFILLER_278_233 VPWR VGND sg13cmos5l_decap_8
XFILLER_238_119 VPWR VGND sg13cmos5l_decap_8
XFILLER_143_42 VPWR VGND sg13cmos5l_decap_8
XFILLER_143_97 VPWR VGND sg13cmos5l_decap_8
XFILLER_290_70 VPWR VGND sg13cmos5l_decap_8
XFILLER_46_224 VPWR VGND sg13cmos5l_decap_8
XANTENNA__1550__X Tile_X0Y3_EE4BEG[12] VPWR VGND sg13cmos5l_antennanp
XFILLER_246_174 VPWR VGND sg13cmos5l_fill_2
XFILLER_160_0 VPWR VGND sg13cmos5l_decap_8
XFILLER_261_155 VPWR VGND sg13cmos5l_fill_1
XFILLER_61_216 VPWR VGND sg13cmos5l_fill_2
XFILLER_258_0 VPWR VGND sg13cmos5l_decap_8
XFILLER_36_84 VPWR VGND sg13cmos5l_decap_8
XFILLER_14_154 VPWR VGND sg13cmos5l_decap_8
XFILLER_159_137 VPWR VGND sg13cmos5l_decap_4
XFILLER_316_112 VPWR VGND sg13cmos5l_decap_8
XFILLER_182_140 VPWR VGND sg13cmos5l_decap_8
XFILLER_318_42 VPWR VGND sg13cmos5l_decap_8
X_0670_ _0670_/Q Tile_X0Y2_FrameData[8] VGND VPWR Tile_X0Y5_FrameStrobe[3] latch
XFILLER_115_229 VPWR VGND sg13cmos5l_decap_8
XFILLER_316_167 VPWR VGND sg13cmos5l_fill_2
XFILLER_331_104 VPWR VGND sg13cmos5l_decap_8
XANTENNA__1725__X Tile_X0Y0_E2BEGb[5] VPWR VGND sg13cmos5l_antennanp
XFILLER_123_240 VPWR VGND sg13cmos5l_fill_2
X_2340_ _2340_/X _2348_/X _2347_/X Tile_X0Y1_W6END[3] _2340_/A3 _0312_/Q _0551_/Q
+ VPWR VGND sg13cmos5l_mux4_1
XFILLER_229_119 VPWR VGND sg13cmos5l_decap_8
XFILLER_334_63 VPWR VGND sg13cmos5l_decap_8
X_2271_ _2271_/X Tile_X0Y1_W1END[0] Tile_X0Y1_WW4END[0] Tile_X0Y1_WW4END[4] Tile_X0Y1_W6END[8]
+ _0526_/Q _0525_/Q VPWR VGND sg13cmos5l_mux4_1
X_1222_ _1222_/Q Tile_X0Y4_FrameData[0] VGND VPWR Tile_X0Y5_FrameStrobe[5] latch
XFILLER_96_168 VPWR VGND sg13cmos5l_decap_8
XFILLER_77_91 VPWR VGND sg13cmos5l_decap_8
XFILLER_284_269 VPWR VGND sg13cmos5l_decap_4
XFILLER_203_56 VPWR VGND sg13cmos5l_decap_8
X_1153_ _1153_/Q Tile_X0Y4_FrameData[5] VGND VPWR Tile_X0Y5_FrameStrobe[3] latch
XFILLER_37_257 VPWR VGND sg13cmos5l_fill_1
XFILLER_37_246 VPWR VGND sg13cmos5l_decap_8
XFILLER_237_196 VPWR VGND sg13cmos5l_decap_8
XFILLER_252_133 VPWR VGND sg13cmos5l_fill_2
X_1084_ _1084_/Q Tile_X0Y4_FrameData[10] VGND VPWR Tile_X0Y5_FrameStrobe[1] latch
X_0104_ _0104_/Q Tile_X0Y0_FrameData[30] VGND VPWR Tile_X0Y5_FrameStrobe[1] latch
XFILLER_350_84 VPWR VGND sg13cmos5l_decap_8
XFILLER_252_188 VPWR VGND sg13cmos5l_decap_8
X_0035_ _1618_/A _2157_/X _2158_/X _0278_/Q VPWR VGND sg13cmos5l_mux2_1
XFILLER_52_238 VPWR VGND sg13cmos5l_decap_8
XFILLER_350_95 VPWR VGND sg13cmos5l_fill_2
XFILLER_279_49 VPWR VGND sg13cmos5l_decap_8
XFILLER_60_271 VPWR VGND sg13cmos5l_fill_2
XFILLER_60_260 VPWR VGND sg13cmos5l_fill_2
X_1986_ Tile_X0Y5_E2BEGb[7] _2740_/X VPWR VGND sg13cmos5l_buf_1
XFILLER_20_168 VPWR VGND sg13cmos5l_fill_2
XFILLER_307_112 VPWR VGND sg13cmos5l_decap_8
X_0937_ _0937_/Q Tile_X0Y3_FrameData[13] VGND VPWR Tile_X0Y5_FrameStrobe[4] latch
XFILLER_173_140 VPWR VGND sg13cmos5l_decap_8
XFILLER_228_42 VPWR VGND sg13cmos5l_decap_8
X_0868_ _0868_/Q Tile_X0Y3_FrameData[18] VGND VPWR Tile_X0Y5_FrameStrobe[2] latch
XANTENNA__1635__X Tile_X0Y0_N2BEG[7] VPWR VGND sg13cmos5l_antennanp
XFILLER_322_148 VPWR VGND sg13cmos5l_fill_1
X_2607_ _2607_/X Tile_X0Y2_W1END[1] Tile_X0Y2_W2MID[2] Tile_X0Y2_W2END[2] _2486_/X
+ _0640_/Q _0639_/Q VPWR VGND sg13cmos5l_mux4_1
X_0799_ _0799_/Q Tile_X0Y3_FrameData[23] VGND VPWR Tile_X0Y5_FrameStrobe[0] latch
X_2538_ _2538_/X AXIL_S_SOC_ARADDR1 AXIL_S_SOC_ARADDR3 _2584_/X _2591_/X _0928_/Q
+ _0927_/Q VPWR VGND sg13cmos5l_mux4_1
XFILLER_244_63 VPWR VGND sg13cmos5l_decap_8
XFILLER_275_203 VPWR VGND sg13cmos5l_decap_8
XFILLER_275_225 VPWR VGND sg13cmos5l_fill_2
X_2469_ _2469_/X _2460_/X Tile_X0Y5_N4END[13] _2459_/X Tile_X0Y0_S4END[9] _0580_/Q
+ _0579_/Q VPWR VGND sg13cmos5l_mux4_1
XFILLER_57_28 VPWR VGND sg13cmos5l_decap_8
XFILLER_290_239 VPWR VGND sg13cmos5l_decap_8
XFILLER_95_190 VPWR VGND sg13cmos5l_fill_2
XFILLER_113_56 VPWR VGND sg13cmos5l_decap_8
XFILLER_243_133 VPWR VGND sg13cmos5l_decap_8
XFILLER_260_84 VPWR VGND sg13cmos5l_decap_8
XFILLER_251_7 VPWR VGND sg13cmos5l_decap_8
XFILLER_73_49 VPWR VGND sg13cmos5l_decap_8
XFILLER_189_49 VPWR VGND sg13cmos5l_decap_8
XFILLER_349_7 VPWR VGND sg13cmos5l_decap_8
XFILLER_196_232 VPWR VGND sg13cmos5l_fill_1
XFILLER_11_168 VPWR VGND sg13cmos5l_decap_8
XFILLER_22_42 VPWR VGND sg13cmos5l_decap_8
XFILLER_138_42 VPWR VGND sg13cmos5l_decap_8
XFILLER_164_173 VPWR VGND sg13cmos5l_decap_8
XFILLER_285_70 VPWR VGND sg13cmos5l_decap_8
XFILLER_98_35 VPWR VGND sg13cmos5l_decap_8
XANTENNA__1545__X Tile_X0Y3_EE4BEG[7] VPWR VGND sg13cmos5l_antennanp
XFILLER_313_126 VPWR VGND sg13cmos5l_decap_8
XFILLER_154_63 VPWR VGND sg13cmos5l_decap_8
XFILLER_120_243 VPWR VGND sg13cmos5l_decap_8
XFILLER_78_157 VPWR VGND sg13cmos5l_decap_8
XFILLER_93_105 VPWR VGND sg13cmos5l_decap_8
XFILLER_304_77 VPWR VGND sg13cmos5l_decap_8
XFILLER_170_84 VPWR VGND sg13cmos5l_decap_8
XFILLER_234_133 VPWR VGND sg13cmos5l_decap_8
XFILLER_34_216 VPWR VGND sg13cmos5l_fill_2
XFILLER_234_177 VPWR VGND sg13cmos5l_decap_8
XFILLER_320_21 VPWR VGND sg13cmos5l_decap_8
XFILLER_234_199 VPWR VGND sg13cmos5l_decap_4
XFILLER_320_98 VPWR VGND sg13cmos5l_decap_8
XFILLER_97_7 VPWR VGND sg13cmos5l_decap_8
XFILLER_42_271 VPWR VGND sg13cmos5l_fill_2
X_1840_ Tile_X0Y4_FrameData_O[7] Tile_X0Y4_FrameData[7] VPWR VGND sg13cmos5l_buf_1
XFILLER_329_63 VPWR VGND sg13cmos5l_decap_8
X_1771_ Tile_X0Y2_FrameData_O[31] Tile_X0Y2_FrameData[31] VPWR VGND sg13cmos5l_buf_1
XFILLER_8_77 VPWR VGND sg13cmos5l_decap_8
XFILLER_344_240 VPWR VGND sg13cmos5l_decap_8
XFILLER_195_70 VPWR VGND sg13cmos5l_decap_8
X_0722_ _0722_/Q Tile_X0Y2_FrameData[20] VGND VPWR Tile_X0Y5_FrameStrobe[5] latch
XFILLER_6_150 VPWR VGND sg13cmos5l_decap_4
XFILLER_304_126 VPWR VGND sg13cmos5l_decap_8
X_0653_ _0653_/Q Tile_X0Y2_FrameData[25] VGND VPWR Tile_X0Y5_FrameStrobe[3] latch
XFILLER_170_154 VPWR VGND sg13cmos5l_fill_1
X_0584_ _0584_/Q Tile_X0Y2_FrameData[30] VGND VPWR Tile_X0Y5_FrameStrobe[1] latch
XFILLER_111_210 VPWR VGND sg13cmos5l_decap_8
XFILLER_281_28 VPWR VGND sg13cmos5l_decap_8
X_2323_ _2323_/X AXIL_S_SOC_WDATA2 AXIL_S_SOC_WDATA14 _2370_/X _2374_/X _0446_/Q _0445_/Q
+ VPWR VGND sg13cmos5l_mux4_1
XFILLER_345_84 VPWR VGND sg13cmos5l_decap_8
XFILLER_257_236 VPWR VGND sg13cmos5l_fill_2
XFILLER_272_206 VPWR VGND sg13cmos5l_fill_1
X_2254_ _2254_/X Tile_X0Y1_W2MID[5] Tile_X0Y1_W2END[5] Tile_X0Y1_W6END[5] _2375_/X
+ _0538_/Q _0537_/Q VPWR VGND sg13cmos5l_mux4_1
XFILLER_84_127 VPWR VGND sg13cmos5l_decap_8
XFILLER_19_0 VPWR VGND sg13cmos5l_decap_8
XFILLER_214_77 VPWR VGND sg13cmos5l_decap_8
XFILLER_272_228 VPWR VGND sg13cmos5l_decap_8
XFILLER_272_239 VPWR VGND sg13cmos5l_fill_1
X_2185_ _2185_/X AXIL_S_SOC_WDATA20 AXIL_S_SOC_WDATA24 _2218_/X _2244_/X _0226_/Q
+ _0225_/Q VPWR VGND sg13cmos5l_mux4_1
X_1205_ _1205_/Q Tile_X0Y4_FrameData[17] VGND VPWR Tile_X0Y5_FrameStrobe[5] latch
X_1136_ _1136_/Q Tile_X0Y4_FrameData[22] VGND VPWR Tile_X0Y5_FrameStrobe[3] latch
XFILLER_230_21 VPWR VGND sg13cmos5l_decap_8
XFILLER_25_227 VPWR VGND sg13cmos5l_decap_8
XFILLER_280_272 VPWR VGND sg13cmos5l_fill_1
X_1067_ _1067_/Q Tile_X0Y4_FrameData[27] VGND VPWR Tile_X0Y5_FrameStrobe[1] latch
XFILLER_178_232 VPWR VGND sg13cmos5l_decap_4
XFILLER_230_98 VPWR VGND sg13cmos5l_decap_8
XFILLER_240_147 VPWR VGND sg13cmos5l_decap_8
XFILLER_239_63 VPWR VGND sg13cmos5l_decap_8
X_1969_ Tile_X0Y5_E1BEG[2] _2723_/X VPWR VGND sg13cmos5l_buf_1
XFILLER_104_8 VPWR VGND sg13cmos5l_decap_8
XFILLER_108_56 VPWR VGND sg13cmos5l_decap_8
XFILLER_350_254 VPWR VGND sg13cmos5l_fill_2
XFILLER_191_28 VPWR VGND sg13cmos5l_decap_8
XFILLER_68_49 VPWR VGND sg13cmos5l_decap_8
XFILLER_299_7 VPWR VGND sg13cmos5l_decap_8
XFILLER_124_77 VPWR VGND sg13cmos5l_decap_8
XFILLER_68_190 VPWR VGND sg13cmos5l_fill_2
XFILLER_140_21 VPWR VGND sg13cmos5l_decap_8
XFILLER_17_42 VPWR VGND sg13cmos5l_decap_8
XFILLER_83_182 VPWR VGND sg13cmos5l_decap_8
XFILLER_271_272 VPWR VGND sg13cmos5l_fill_1
XFILLER_231_147 VPWR VGND sg13cmos5l_decap_8
XFILLER_24_271 VPWR VGND sg13cmos5l_fill_2
XFILLER_33_85 VPWR VGND sg13cmos5l_decap_8
XFILLER_123_0 VPWR VGND sg13cmos5l_decap_8
XFILLER_149_63 VPWR VGND sg13cmos5l_decap_8
XFILLER_149_85 VPWR VGND sg13cmos5l_decap_8
XFILLER_296_91 VPWR VGND sg13cmos5l_decap_8
XFILLER_326_251 VPWR VGND sg13cmos5l_fill_1
XFILLER_298_147 VPWR VGND sg13cmos5l_decap_8
XFILLER_239_203 VPWR VGND sg13cmos5l_fill_2
XFILLER_315_21 VPWR VGND sg13cmos5l_decap_8
XFILLER_315_98 VPWR VGND sg13cmos5l_decap_8
XFILLER_66_105 VPWR VGND sg13cmos5l_decap_8
XFILLER_12_7 VPWR VGND sg13cmos5l_decap_8
XFILLER_331_42 VPWR VGND sg13cmos5l_decap_8
XFILLER_74_70 VPWR VGND sg13cmos5l_decap_8
XFILLER_15_271 VPWR VGND sg13cmos5l_fill_2
XFILLER_200_35 VPWR VGND sg13cmos5l_decap_8
XFILLER_175_224 VPWR VGND sg13cmos5l_fill_2
XFILLER_230_191 VPWR VGND sg13cmos5l_decap_8
XFILLER_276_28 VPWR VGND sg13cmos5l_decap_8
X_1823_ Tile_X0Y4_EE4BEG[6] _2639_/X VPWR VGND sg13cmos5l_buf_1
XFILLER_128_151 VPWR VGND sg13cmos5l_decap_4
X_1754_ Tile_X0Y2_FrameData_O[14] Tile_X0Y2_FrameData[14] VPWR VGND sg13cmos5l_buf_1
XFILLER_143_132 VPWR VGND sg13cmos5l_decap_8
XFILLER_209_77 VPWR VGND sg13cmos5l_decap_8
X_0705_ _0705_/Q Tile_X0Y2_FrameData[5] VGND VPWR Tile_X0Y5_FrameStrobe[4] latch
XFILLER_289_147 VPWR VGND sg13cmos5l_decap_8
X_1685_ Tile_X0Y0_FrameData_O[25] Tile_X0Y0_FrameData[25] VPWR VGND sg13cmos5l_buf_1
XFILLER_143_198 VPWR VGND sg13cmos5l_fill_2
XFILLER_225_21 VPWR VGND sg13cmos5l_decap_8
XFILLER_292_49 VPWR VGND sg13cmos5l_decap_8
X_0636_ _0636_/Q Tile_X0Y2_FrameData[10] VGND VPWR Tile_X0Y5_FrameStrobe[2] latch
XANTENNA__1913__X Tile_X0Y1_FrameData_O[26] VPWR VGND sg13cmos5l_antennanp
X_0567_ _0567_/Q Tile_X0Y2_FrameData[15] VGND VPWR Tile_X0Y5_FrameStrobe[0] latch
XFILLER_225_98 VPWR VGND sg13cmos5l_decap_8
XFILLER_300_140 VPWR VGND sg13cmos5l_decap_8
X_2306_ _2306_/X AXIL_S_SOC_WDATA5 AXIL_S_SOC_WDATA13 _2375_/X _2378_/X _0480_/Q _0479_/Q
+ VPWR VGND sg13cmos5l_mux4_1
XFILLER_57_105 VPWR VGND sg13cmos5l_decap_8
X_2237_ _2237_/X _2214_/X _0066_/X Tile_X0Y0_S1END[1] Tile_X0Y0_S4END[1] _0116_/Q
+ _0115_/Q VPWR VGND sg13cmos5l_mux4_1
X_0498_ _0498_/Q Tile_X0Y1_FrameData[4] VGND VPWR Tile_X0Y5_FrameStrobe[5] latch
XFILLER_241_42 VPWR VGND sg13cmos5l_decap_8
XFILLER_72_119 VPWR VGND sg13cmos5l_decap_4
X_2168_ _2168_/X AXIL_S_SOC_WDATA19 AXIL_S_SOC_WDATA27 _2244_/X _2245_/X _0260_/Q
+ _0259_/Q VPWR VGND sg13cmos5l_mux4_1
XFILLER_213_103 VPWR VGND sg13cmos5l_decap_8
X_2099_ Tile_X0Y3_E2BEGb[3] _2520_/X VPWR VGND sg13cmos5l_buf_1
X_1119_ _1119_/Q Tile_X0Y4_FrameData[7] VGND VPWR Tile_X0Y5_FrameStrobe[2] latch
XFILLER_110_35 VPWR VGND sg13cmos5l_decap_8
XFILLER_70_28 VPWR VGND sg13cmos5l_decap_8
XFILLER_186_28 VPWR VGND sg13cmos5l_decap_8
XFILLER_119_140 VPWR VGND sg13cmos5l_decap_8
XFILLER_214_7 VPWR VGND sg13cmos5l_decap_8
XFILLER_119_195 VPWR VGND sg13cmos5l_decap_8
XFILLER_119_77 VPWR VGND sg13cmos5l_decap_8
XFILLER_134_143 VPWR VGND sg13cmos5l_decap_8
XFILLER_134_154 VPWR VGND sg13cmos5l_fill_1
XFILLER_0_112 VPWR VGND sg13cmos5l_decap_4
XFILLER_134_198 VPWR VGND sg13cmos5l_fill_1
XFILLER_135_21 VPWR VGND sg13cmos5l_decap_8
XANTENNA__1823__X Tile_X0Y4_EE4BEG[6] VPWR VGND sg13cmos5l_antennanp
XFILLER_0_145 VPWR VGND sg13cmos5l_fill_2
XFILLER_95_14 VPWR VGND sg13cmos5l_decap_8
XFILLER_0_178 VPWR VGND sg13cmos5l_fill_1
XFILLER_135_98 VPWR VGND sg13cmos5l_fill_1
XFILLER_48_116 VPWR VGND sg13cmos5l_decap_8
XFILLER_151_42 VPWR VGND sg13cmos5l_decap_8
XFILLER_28_63 VPWR VGND sg13cmos5l_decap_8
XFILLER_63_119 VPWR VGND sg13cmos5l_decap_8
XFILLER_56_182 VPWR VGND sg13cmos5l_decap_8
XFILLER_204_125 VPWR VGND sg13cmos5l_decap_4
XFILLER_301_56 VPWR VGND sg13cmos5l_decap_8
XFILLER_71_185 VPWR VGND sg13cmos5l_decap_8
XFILLER_240_0 VPWR VGND sg13cmos5l_decap_8
XFILLER_44_95 VPWR VGND sg13cmos5l_decap_8
XFILLER_358_140 VPWR VGND sg13cmos5l_decap_8
XFILLER_338_0 VPWR VGND sg13cmos5l_decap_8
XFILLER_172_216 VPWR VGND sg13cmos5l_fill_2
XFILLER_326_42 VPWR VGND sg13cmos5l_decap_8
XFILLER_286_106 VPWR VGND sg13cmos5l_decap_8
X_1470_ _1470_/Q Tile_X0Y5_FrameData[18] VGND VPWR Tile_X0Y5_FrameStrobe[6] latch
XFILLER_5_56 VPWR VGND sg13cmos5l_decap_8
XANTENNA__1733__X Tile_X0Y0_E2BEG[5] VPWR VGND sg13cmos5l_antennanp
XFILLER_140_135 VPWR VGND sg13cmos5l_decap_8
X_0421_ _0421_/Q Tile_X0Y1_FrameData[17] VGND VPWR Tile_X0Y5_FrameStrobe[3] latch
XFILLER_69_70 VPWR VGND sg13cmos5l_decap_8
XFILLER_140_179 VPWR VGND sg13cmos5l_fill_2
X_0352_ _0352_/Q Tile_X0Y1_FrameData[22] VGND VPWR Tile_X0Y5_FrameStrobe[1] latch
XFILLER_39_105 VPWR VGND sg13cmos5l_decap_8
XFILLER_227_217 VPWR VGND sg13cmos5l_decap_8
XFILLER_294_161 VPWR VGND sg13cmos5l_decap_8
XFILLER_94_233 VPWR VGND sg13cmos5l_decap_8
X_0283_ _0283_/Q Tile_X0Y0_FrameData[11] VGND VPWR Tile_X0Y5_FrameStrobe[6] latch
XFILLER_342_85 VPWR VGND sg13cmos5l_decap_8
XFILLER_235_250 VPWR VGND sg13cmos5l_decap_4
X_2022_ Tile_X0Y5_FrameData_O[7] Tile_X0Y5_FrameData[7] VPWR VGND sg13cmos5l_buf_1
XFILLER_54_119 VPWR VGND sg13cmos5l_decap_8
XFILLER_211_56 VPWR VGND sg13cmos5l_decap_8
XFILLER_250_231 VPWR VGND sg13cmos5l_fill_2
XFILLER_349_140 VPWR VGND sg13cmos5l_decap_8
XFILLER_287_49 VPWR VGND sg13cmos5l_decap_8
XFILLER_86_0 VPWR VGND sg13cmos5l_decap_8
XANTENNA__1908__X Tile_X0Y1_FrameData_O[21] VPWR VGND sg13cmos5l_antennanp
XFILLER_148_268 VPWR VGND sg13cmos5l_decap_4
X_1806_ Tile_X0Y4_E6BEG[1] _2650_/X VPWR VGND sg13cmos5l_buf_1
XFILLER_163_249 VPWR VGND sg13cmos5l_decap_8
XFILLER_305_210 VPWR VGND sg13cmos5l_fill_1
X_2786_ _2786_/X _2818_/X _2806_/X _2805_/X _2798_/X _1334_/Q _1333_/Q VPWR VGND sg13cmos5l_mux4_1
XFILLER_116_154 VPWR VGND sg13cmos5l_decap_8
XFILLER_236_42 VPWR VGND sg13cmos5l_decap_8
X_1737_ Tile_X0Y0_E1BEG[1] _2162_/X VPWR VGND sg13cmos5l_buf_1
XFILLER_320_213 VPWR VGND sg13cmos5l_fill_1
X_1668_ Tile_X0Y0_FrameData_O[8] Tile_X0Y0_FrameData[8] VPWR VGND sg13cmos5l_buf_1
XFILLER_131_135 VPWR VGND sg13cmos5l_decap_8
X_0619_ _0619_/Q Tile_X0Y2_FrameData[27] VGND VPWR Tile_X0Y5_FrameStrobe[2] latch
XANTENNA__1643__X Tile_X0Y0_FrameStrobe_O[3] VPWR VGND sg13cmos5l_antennanp
X_1599_ Tile_X0Y2_EE4BEG[12] _2429_/X VPWR VGND sg13cmos5l_buf_1
XFILLER_105_35 VPWR VGND sg13cmos5l_decap_8
XFILLER_285_172 VPWR VGND sg13cmos5l_decap_8
XFILLER_85_244 VPWR VGND sg13cmos5l_decap_8
XFILLER_85_222 VPWR VGND sg13cmos5l_fill_1
XFILLER_218_228 VPWR VGND sg13cmos5l_decap_8
XFILLER_252_63 VPWR VGND sg13cmos5l_decap_8
XFILLER_85_255 VPWR VGND sg13cmos5l_fill_2
XFILLER_65_28 VPWR VGND sg13cmos5l_decap_8
XANTENNA_107 AXIL_S_SOC_WDATA27 VPWR VGND sg13cmos5l_antennanp
XFILLER_45_119 VPWR VGND sg13cmos5l_decap_8
XFILLER_38_182 VPWR VGND sg13cmos5l_decap_8
XANTENNA_118 AXIL_S_SOC_WDATA27 VPWR VGND sg13cmos5l_antennanp
XANTENNA_129 AXIL_S_SOC_WDATA29 VPWR VGND sg13cmos5l_antennanp
XFILLER_164_7 VPWR VGND sg13cmos5l_decap_8
XFILLER_38_193 VPWR VGND sg13cmos5l_fill_2
XFILLER_121_56 VPWR VGND sg13cmos5l_decap_8
XFILLER_53_196 VPWR VGND sg13cmos5l_decap_8
XFILLER_14_21 VPWR VGND sg13cmos5l_decap_8
XFILLER_197_49 VPWR VGND sg13cmos5l_decap_8
XFILLER_331_7 VPWR VGND sg13cmos5l_decap_8
XFILLER_139_246 VPWR VGND sg13cmos5l_decap_8
XANTENNA__1818__X Tile_X0Y4_EE4BEG[1] VPWR VGND sg13cmos5l_antennanp
XFILLER_14_98 VPWR VGND sg13cmos5l_decap_8
XFILLER_154_205 VPWR VGND sg13cmos5l_decap_8
XFILLER_355_154 VPWR VGND sg13cmos5l_decap_8
XFILLER_30_42 VPWR VGND sg13cmos5l_decap_8
XFILLER_146_42 VPWR VGND sg13cmos5l_decap_8
XFILLER_293_70 VPWR VGND sg13cmos5l_decap_8
XFILLER_146_86 VPWR VGND sg13cmos5l_fill_1
XFILLER_268_117 VPWR VGND sg13cmos5l_decap_8
XANTENNA__1553__X Tile_X0Y3_EE4BEG[15] VPWR VGND sg13cmos5l_antennanp
XFILLER_190_0 VPWR VGND sg13cmos5l_decap_8
XFILLER_276_150 VPWR VGND sg13cmos5l_decap_4
XFILLER_276_172 VPWR VGND sg13cmos5l_fill_1
XFILLER_76_222 VPWR VGND sg13cmos5l_fill_2
XFILLER_76_211 VPWR VGND sg13cmos5l_decap_8
XFILLER_39_84 VPWR VGND sg13cmos5l_decap_8
XFILLER_162_63 VPWR VGND sg13cmos5l_decap_8
XFILLER_209_239 VPWR VGND sg13cmos5l_decap_8
XFILLER_288_0 VPWR VGND sg13cmos5l_decap_8
XFILLER_91_225 VPWR VGND sg13cmos5l_decap_8
XFILLER_36_119 VPWR VGND sg13cmos5l_decap_4
XFILLER_291_175 VPWR VGND sg13cmos5l_decap_8
XFILLER_312_77 VPWR VGND sg13cmos5l_decap_8
XFILLER_44_130 VPWR VGND sg13cmos5l_decap_8
XFILLER_232_253 VPWR VGND sg13cmos5l_decap_8
X_0970_ _0970_/Q Tile_X0Y3_FrameData[12] VGND VPWR Tile_X0Y5_FrameStrobe[5] latch
XANTENNA__1728__X Tile_X0Y0_E2BEG[0] VPWR VGND sg13cmos5l_antennanp
X_2640_ _2640_/X AXIL_S_SOC_WSTRB1 AXIL_S_SOC_BREADY _2697_/X _2708_/X _1174_/Q _1173_/Q
+ VPWR VGND sg13cmos5l_mux4_1
XFILLER_361_124 VPWR VGND sg13cmos5l_fill_1
XFILLER_361_113 VPWR VGND sg13cmos5l_fill_1
XFILLER_299_231 VPWR VGND sg13cmos5l_decap_8
X_2571_ _2571_/X Tile_X0Y2_W1END[3] Tile_X0Y2_W6END[11] _2465_/X _2456_/X _0652_/Q
+ _0651_/Q VPWR VGND sg13cmos5l_mux4_1
XFILLER_361_168 VPWR VGND sg13cmos5l_fill_2
XFILLER_337_63 VPWR VGND sg13cmos5l_decap_8
X_1522_ Tile_X0Y3_E2BEGb[4] _2521_/X VPWR VGND sg13cmos5l_buf_1
XFILLER_302_235 VPWR VGND sg13cmos5l_decap_4
X_1453_ _1453_/Q Tile_X0Y5_FrameData[3] VGND VPWR Tile_X0Y5_FrameStrobe[5] latch
XFILLER_206_56 VPWR VGND sg13cmos5l_decap_8
XFILLER_302_268 VPWR VGND sg13cmos5l_decap_4
X_0404_ _0404_/Q Tile_X0Y1_FrameData[2] VGND VPWR Tile_X0Y5_FrameStrobe[2] latch
X_1384_ _1384_/Q Tile_X0Y5_FrameData[8] VGND VPWR Tile_X0Y5_FrameStrobe[3] latch
XFILLER_353_84 VPWR VGND sg13cmos5l_decap_8
X_0335_ _0335_/Q Tile_X0Y1_FrameData[7] VGND VPWR Tile_X0Y5_FrameStrobe[0] latch
XFILLER_27_119 VPWR VGND sg13cmos5l_decap_8
XFILLER_282_142 VPWR VGND sg13cmos5l_fill_1
XFILLER_282_164 VPWR VGND sg13cmos5l_fill_2
X_0266_ _0266_/Q Tile_X0Y0_FrameData[28] VGND VPWR Tile_X0Y5_FrameStrobe[6] latch
XFILLER_82_214 VPWR VGND sg13cmos5l_decap_8
XFILLER_208_272 VPWR VGND sg13cmos5l_fill_1
XFILLER_222_77 VPWR VGND sg13cmos5l_decap_8
X_2005_ Tile_X0Y5_EE4BEG[6] _2747_/X VPWR VGND sg13cmos5l_buf_1
XFILLER_82_269 VPWR VGND sg13cmos5l_decap_4
XFILLER_223_231 VPWR VGND sg13cmos5l_decap_8
X_0197_ _0197_/Q Tile_X0Y0_FrameData[1] VGND VPWR Tile_X0Y5_FrameStrobe[3] latch
XFILLER_50_133 VPWR VGND sg13cmos5l_decap_8
XFILLER_35_185 VPWR VGND sg13cmos5l_decap_8
XFILLER_195_105 VPWR VGND sg13cmos5l_decap_4
XFILLER_188_190 VPWR VGND sg13cmos5l_fill_1
XFILLER_337_110 VPWR VGND sg13cmos5l_fill_1
XANTENNA__1638__X Tile_X0Y0_N1BEG[2] VPWR VGND sg13cmos5l_antennanp
XFILLER_247_63 VPWR VGND sg13cmos5l_decap_8
X_2769_ _2769_/X Tile_X0Y5_W1END[0] Tile_X0Y5_W6END[8] _2813_/X _2789_/X _1364_/Q
+ _1363_/Q VPWR VGND sg13cmos5l_mux4_1
XFILLER_104_113 VPWR VGND sg13cmos5l_decap_8
XFILLER_144_271 VPWR VGND sg13cmos5l_fill_2
XFILLER_352_168 VPWR VGND sg13cmos5l_decap_8
XFILLER_360_190 VPWR VGND sg13cmos5l_decap_8
XFILLER_116_56 VPWR VGND sg13cmos5l_decap_8
XFILLER_263_84 VPWR VGND sg13cmos5l_decap_8
XFILLER_76_49 VPWR VGND sg13cmos5l_decap_8
XFILLER_58_233 VPWR VGND sg13cmos5l_decap_8
XFILLER_281_7 VPWR VGND sg13cmos5l_decap_8
XFILLER_18_119 VPWR VGND sg13cmos5l_decap_8
XFILLER_273_164 VPWR VGND sg13cmos5l_fill_1
XFILLER_132_77 VPWR VGND sg13cmos5l_decap_8
XFILLER_26_141 VPWR VGND sg13cmos5l_decap_4
XFILLER_26_152 VPWR VGND sg13cmos5l_decap_8
XFILLER_214_253 VPWR VGND sg13cmos5l_decap_4
XFILLER_214_264 VPWR VGND sg13cmos5l_decap_8
XFILLER_25_42 VPWR VGND sg13cmos5l_decap_8
XFILLER_186_105 VPWR VGND sg13cmos5l_decap_8
XFILLER_41_144 VPWR VGND sg13cmos5l_decap_8
XFILLER_288_70 VPWR VGND sg13cmos5l_decap_8
XFILLER_41_177 VPWR VGND sg13cmos5l_decap_8
XANTENNA__1548__X Tile_X0Y3_EE4BEG[10] VPWR VGND sg13cmos5l_antennanp
XFILLER_328_143 VPWR VGND sg13cmos5l_fill_2
XFILLER_41_74 VPWR VGND sg13cmos5l_decap_8
XFILLER_157_63 VPWR VGND sg13cmos5l_decap_8
XFILLER_203_0 VPWR VGND sg13cmos5l_decap_8
XFILLER_142_219 VPWR VGND sg13cmos5l_decap_8
XFILLER_150_230 VPWR VGND sg13cmos5l_fill_2
XFILLER_307_77 VPWR VGND sg13cmos5l_decap_8
XFILLER_110_105 VPWR VGND sg13cmos5l_decap_8
XFILLER_173_84 VPWR VGND sg13cmos5l_decap_8
XFILLER_2_35 VPWR VGND sg13cmos5l_decap_8
XFILLER_323_21 VPWR VGND sg13cmos5l_decap_8
XFILLER_49_255 VPWR VGND sg13cmos5l_decap_4
XFILLER_323_98 VPWR VGND sg13cmos5l_decap_8
X_0120_ _0120_/Q Tile_X0Y0_FrameData[14] VGND VPWR Tile_X0Y5_FrameStrobe[1] latch
XFILLER_64_214 VPWR VGND sg13cmos5l_decap_8
X_0051_ _1607_/A _2281_/X _2282_/X _0995_/Q VPWR VGND sg13cmos5l_mux2_1
XFILLER_64_247 VPWR VGND sg13cmos5l_fill_2
XFILLER_205_231 VPWR VGND sg13cmos5l_decap_8
XFILLER_205_264 VPWR VGND sg13cmos5l_fill_1
XFILLER_177_105 VPWR VGND sg13cmos5l_decap_8
XFILLER_82_70 VPWR VGND sg13cmos5l_decap_8
XANTENNA_18 AXIL_S_SOC_WDATA10 VPWR VGND sg13cmos5l_antennanp
XANTENNA_29 AXIL_S_SOC_WDATA11 VPWR VGND sg13cmos5l_antennanp
XFILLER_198_70 VPWR VGND sg13cmos5l_decap_8
X_0953_ _0953_/Q Tile_X0Y3_FrameData[29] VGND VPWR Tile_X0Y5_FrameStrobe[5] latch
XFILLER_185_160 VPWR VGND sg13cmos5l_fill_2
X_0884_ _0884_/Q Tile_X0Y3_FrameData[2] VGND VPWR Tile_X0Y5_FrameStrobe[2] latch
XFILLER_348_84 VPWR VGND sg13cmos5l_decap_8
XFILLER_284_28 VPWR VGND sg13cmos5l_decap_8
XFILLER_334_157 VPWR VGND sg13cmos5l_fill_1
X_2623_ _2623_/X AXIL_S_SOC_WSTRB0 AXIL_S_SOC_WSTRB2 _2709_/X _2682_/X _1208_/Q _1207_/Q
+ VPWR VGND sg13cmos5l_mux4_1
XFILLER_126_271 VPWR VGND sg13cmos5l_fill_2
X_2554_ _2554_/X _2588_/X _2587_/X _2580_/X _2579_/X _0874_/Q _0873_/Q VPWR VGND sg13cmos5l_mux4_1
XFILLER_217_77 VPWR VGND sg13cmos5l_decap_8
X_1505_ _2671_/A3 VPWR VGND sg13cmos5l_tielo
XFILLER_49_0 VPWR VGND sg13cmos5l_decap_8
XFILLER_101_105 VPWR VGND sg13cmos5l_decap_8
XFILLER_287_245 VPWR VGND sg13cmos5l_fill_2
X_2485_ _2485_/X _2390_/X _2498_/X _2497_/X _2389_/X _0566_/Q _0565_/Q VPWR VGND sg13cmos5l_mux4_1
XFILLER_99_155 VPWR VGND sg13cmos5l_decap_8
XFILLER_233_21 VPWR VGND sg13cmos5l_decap_8
X_1436_ _1436_/Q Tile_X0Y5_FrameData[20] VGND VPWR Tile_X0Y5_FrameStrobe[5] latch
X_1367_ _1367_/Q Tile_X0Y5_FrameData[25] VGND VPWR Tile_X0Y5_FrameStrobe[3] latch
XANTENNA__1921__X Tile_X0Y1_EE4BEG[2] VPWR VGND sg13cmos5l_antennanp
X_0318_ _0318_/Q Tile_X0Y1_FrameData[24] VGND VPWR Tile_X0Y5_FrameStrobe[0] latch
XFILLER_55_203 VPWR VGND sg13cmos5l_decap_8
XFILLER_233_98 VPWR VGND sg13cmos5l_decap_8
XFILLER_270_112 VPWR VGND sg13cmos5l_decap_8
X_1298_ _1298_/Q Tile_X0Y5_FrameData[30] VGND VPWR Tile_X0Y5_FrameStrobe[1] latch
XFILLER_55_247 VPWR VGND sg13cmos5l_fill_1
XFILLER_102_14 VPWR VGND sg13cmos5l_decap_8
XFILLER_270_134 VPWR VGND sg13cmos5l_decap_8
X_0249_ _0249_/Q Tile_X0Y0_FrameData[13] VGND VPWR Tile_X0Y5_FrameStrobe[5] latch
XFILLER_270_167 VPWR VGND sg13cmos5l_fill_2
XFILLER_168_105 VPWR VGND sg13cmos5l_decap_8
XFILLER_168_149 VPWR VGND sg13cmos5l_decap_8
XFILLER_183_119 VPWR VGND sg13cmos5l_decap_8
XFILLER_127_7 VPWR VGND sg13cmos5l_decap_8
XFILLER_258_84 VPWR VGND sg13cmos5l_decap_8
XFILLER_109_249 VPWR VGND sg13cmos5l_decap_4
XFILLER_191_152 VPWR VGND sg13cmos5l_fill_2
XFILLER_194_28 VPWR VGND sg13cmos5l_decap_8
XFILLER_117_271 VPWR VGND sg13cmos5l_fill_2
XFILLER_340_105 VPWR VGND sg13cmos5l_decap_8
XFILLER_11_77 VPWR VGND sg13cmos5l_decap_8
XFILLER_127_77 VPWR VGND sg13cmos5l_decap_8
XFILLER_143_21 VPWR VGND sg13cmos5l_decap_8
XANTENNA__1831__X Tile_X0Y4_EE4BEG[14] VPWR VGND sg13cmos5l_antennanp
XFILLER_143_87 VPWR VGND sg13cmos5l_fill_2
XFILLER_46_203 VPWR VGND sg13cmos5l_decap_8
XFILLER_261_112 VPWR VGND sg13cmos5l_decap_8
XFILLER_261_123 VPWR VGND sg13cmos5l_fill_1
XFILLER_36_63 VPWR VGND sg13cmos5l_decap_8
XFILLER_14_133 VPWR VGND sg13cmos5l_decap_8
XFILLER_153_0 VPWR VGND sg13cmos5l_decap_8
XFILLER_299_91 VPWR VGND sg13cmos5l_decap_8
XFILLER_159_149 VPWR VGND sg13cmos5l_decap_8
XFILLER_202_245 VPWR VGND sg13cmos5l_decap_8
XFILLER_348_249 VPWR VGND sg13cmos5l_decap_8
XFILLER_174_119 VPWR VGND sg13cmos5l_decap_8
XFILLER_320_0 VPWR VGND sg13cmos5l_decap_8
XFILLER_52_84 VPWR VGND sg13cmos5l_decap_8
XFILLER_167_171 VPWR VGND sg13cmos5l_decap_8
XFILLER_168_84 VPWR VGND sg13cmos5l_decap_8
XFILLER_356_271 VPWR VGND sg13cmos5l_fill_2
XFILLER_318_21 VPWR VGND sg13cmos5l_decap_8
XFILLER_115_208 VPWR VGND sg13cmos5l_decap_8
XFILLER_182_174 VPWR VGND sg13cmos5l_decap_8
XFILLER_318_98 VPWR VGND sg13cmos5l_decap_8
XFILLER_331_127 VPWR VGND sg13cmos5l_decap_4
XFILLER_334_42 VPWR VGND sg13cmos5l_decap_8
X_2270_ _2270_/X _2370_/X _2369_/X _2358_/X _2357_/X _0523_/Q _0522_/Q VPWR VGND sg13cmos5l_mux4_1
XFILLER_284_215 VPWR VGND sg13cmos5l_decap_8
X_1221_ _1221_/Q Tile_X0Y4_FrameData[1] VGND VPWR Tile_X0Y5_FrameStrobe[5] latch
XFILLER_77_70 VPWR VGND sg13cmos5l_decap_8
XANTENNA__1741__X Tile_X0Y2_FrameData_O[1] VPWR VGND sg13cmos5l_antennanp
XFILLER_203_35 VPWR VGND sg13cmos5l_decap_8
XFILLER_237_175 VPWR VGND sg13cmos5l_decap_8
XFILLER_252_112 VPWR VGND sg13cmos5l_decap_8
X_1152_ _1152_/Q Tile_X0Y4_FrameData[6] VGND VPWR Tile_X0Y5_FrameStrobe[3] latch
X_1083_ _1083_/Q Tile_X0Y4_FrameData[11] VGND VPWR Tile_X0Y5_FrameStrobe[1] latch
X_0103_ _0103_/Q Tile_X0Y0_FrameData[31] VGND VPWR Tile_X0Y5_FrameStrobe[1] latch
XFILLER_52_217 VPWR VGND sg13cmos5l_decap_8
XFILLER_350_63 VPWR VGND sg13cmos5l_decap_8
XFILLER_279_28 VPWR VGND sg13cmos5l_decap_8
X_0034_ _1617_/A _2155_/X _2156_/X _0281_/Q VPWR VGND sg13cmos5l_mux2_1
XFILLER_93_91 VPWR VGND sg13cmos5l_decap_8
XANTENNA_290 AXIL_S_SOC_WDATA22 VPWR VGND sg13cmos5l_antennanp
X_1985_ Tile_X0Y5_E2BEGb[6] _2739_/X VPWR VGND sg13cmos5l_buf_1
XFILLER_295_49 VPWR VGND sg13cmos5l_decap_8
X_0936_ _0936_/Q Tile_X0Y3_FrameData[14] VGND VPWR Tile_X0Y5_FrameStrobe[4] latch
XFILLER_347_271 VPWR VGND sg13cmos5l_fill_2
XFILLER_228_21 VPWR VGND sg13cmos5l_decap_8
XANTENNA__1916__X Tile_X0Y1_FrameData_O[29] VPWR VGND sg13cmos5l_antennanp
XFILLER_307_168 VPWR VGND sg13cmos5l_decap_8
XFILLER_322_105 VPWR VGND sg13cmos5l_decap_8
X_2606_ _2606_/X Tile_X0Y5_W2MID[3] Tile_X0Y5_W2END[3] Tile_X0Y5_W6END[3] _2800_/X
+ _1480_/Q _1479_/Q VPWR VGND sg13cmos5l_mux4_1
X_0867_ _0867_/Q Tile_X0Y3_FrameData[19] VGND VPWR Tile_X0Y5_FrameStrobe[2] latch
XFILLER_228_98 VPWR VGND sg13cmos5l_decap_8
X_0798_ _0798_/Q Tile_X0Y3_FrameData[24] VGND VPWR Tile_X0Y5_FrameStrobe[0] latch
X_2537_ _2537_/X AXIL_S_SOC_ARADDR0 AXIL_S_SOC_ARADDR2 _2583_/X _2592_/X _0930_/Q
+ _0929_/Q VPWR VGND sg13cmos5l_mux4_1
XFILLER_244_42 VPWR VGND sg13cmos5l_decap_8
X_2468_ _2468_/X _2462_/X Tile_X0Y5_N4END[14] _2461_/X Tile_X0Y0_S4END[10] _0586_/Q
+ _0585_/Q VPWR VGND sg13cmos5l_mux4_1
X_1419_ _1419_/Q Tile_X0Y5_FrameData[5] VGND VPWR Tile_X0Y5_FrameStrobe[4] latch
XANTENNA__1651__X Tile_X0Y0_FrameStrobe_O[11] VPWR VGND sg13cmos5l_antennanp
X_2399_ _2399_/X _2462_/X _2461_/X AXIL_S_SOC_AWADDR0 AXIL_S_SOC_AWADDR5 _0750_/Q
+ _0749_/Q VPWR VGND sg13cmos5l_mux4_1
XFILLER_113_35 VPWR VGND sg13cmos5l_decap_8
XFILLER_28_236 VPWR VGND sg13cmos5l_decap_8
XFILLER_243_112 VPWR VGND sg13cmos5l_decap_8
XFILLER_260_63 VPWR VGND sg13cmos5l_decap_8
XFILLER_73_28 VPWR VGND sg13cmos5l_decap_8
XFILLER_189_28 VPWR VGND sg13cmos5l_decap_8
XFILLER_43_239 VPWR VGND sg13cmos5l_fill_2
XFILLER_43_228 VPWR VGND sg13cmos5l_decap_8
XFILLER_243_189 VPWR VGND sg13cmos5l_fill_2
XFILLER_244_7 VPWR VGND sg13cmos5l_decap_8
XFILLER_51_272 VPWR VGND sg13cmos5l_fill_1
XFILLER_11_147 VPWR VGND sg13cmos5l_decap_8
XFILLER_156_119 VPWR VGND sg13cmos5l_decap_8
XFILLER_22_21 VPWR VGND sg13cmos5l_decap_8
XFILLER_138_21 VPWR VGND sg13cmos5l_decap_8
XANTENNA__1826__X Tile_X0Y4_EE4BEG[9] VPWR VGND sg13cmos5l_antennanp
XFILLER_22_98 VPWR VGND sg13cmos5l_decap_8
XFILLER_313_105 VPWR VGND sg13cmos5l_decap_8
XFILLER_98_14 VPWR VGND sg13cmos5l_decap_8
XFILLER_353_252 VPWR VGND sg13cmos5l_fill_1
XFILLER_138_98 VPWR VGND sg13cmos5l_decap_8
XFILLER_120_222 VPWR VGND sg13cmos5l_decap_8
XFILLER_154_42 VPWR VGND sg13cmos5l_decap_8
XFILLER_266_204 VPWR VGND sg13cmos5l_decap_8
XFILLER_78_114 VPWR VGND sg13cmos5l_fill_1
XFILLER_266_226 VPWR VGND sg13cmos5l_decap_4
XFILLER_266_237 VPWR VGND sg13cmos5l_fill_1
XANTENNA__1561__X Tile_X0Y3_FrameData_O[7] VPWR VGND sg13cmos5l_antennanp
XFILLER_266_259 VPWR VGND sg13cmos5l_fill_2
XFILLER_304_56 VPWR VGND sg13cmos5l_decap_8
XFILLER_93_128 VPWR VGND sg13cmos5l_fill_1
XFILLER_19_236 VPWR VGND sg13cmos5l_fill_2
XFILLER_219_164 VPWR VGND sg13cmos5l_fill_1
XFILLER_270_0 VPWR VGND sg13cmos5l_decap_8
XFILLER_170_63 VPWR VGND sg13cmos5l_decap_8
XFILLER_219_186 VPWR VGND sg13cmos5l_decap_8
XFILLER_234_112 VPWR VGND sg13cmos5l_decap_8
XFILLER_47_84 VPWR VGND sg13cmos5l_decap_8
XFILLER_320_77 VPWR VGND sg13cmos5l_decap_8
XFILLER_42_261 VPWR VGND sg13cmos5l_fill_2
XFILLER_42_250 VPWR VGND sg13cmos5l_decap_8
XFILLER_329_42 VPWR VGND sg13cmos5l_decap_8
X_1770_ Tile_X0Y2_FrameData_O[30] Tile_X0Y2_FrameData[30] VPWR VGND sg13cmos5l_buf_1
XFILLER_8_56 VPWR VGND sg13cmos5l_decap_8
X_0721_ _0721_/Q Tile_X0Y2_FrameData[21] VGND VPWR Tile_X0Y5_FrameStrobe[5] latch
XANTENNA__1736__X Tile_X0Y0_E1BEG[0] VPWR VGND sg13cmos5l_antennanp
XFILLER_304_105 VPWR VGND sg13cmos5l_decap_8
XFILLER_170_133 VPWR VGND sg13cmos5l_decap_8
X_0652_ _0652_/Q Tile_X0Y2_FrameData[26] VGND VPWR Tile_X0Y5_FrameStrobe[3] latch
X_0583_ _0583_/Q Tile_X0Y2_FrameData[31] VGND VPWR Tile_X0Y5_FrameStrobe[1] latch
XFILLER_345_63 VPWR VGND sg13cmos5l_decap_8
X_2322_ _2322_/X AXIL_S_SOC_WDATA1 AXIL_S_SOC_WDATA13 _2368_/X _2375_/X _0448_/Q _0447_/Q
+ VPWR VGND sg13cmos5l_mux4_1
XFILLER_69_147 VPWR VGND sg13cmos5l_decap_4
XFILLER_214_56 VPWR VGND sg13cmos5l_decap_8
X_2253_ _2253_/X Tile_X0Y2_W2MID[5] Tile_X0Y2_W2END[5] Tile_X0Y2_W6END[5] _2483_/X
+ _0778_/Q _0777_/Q VPWR VGND sg13cmos5l_mux4_1
XFILLER_84_106 VPWR VGND sg13cmos5l_decap_8
X_2184_ _2184_/X AXIL_S_SOC_WDATA19 AXIL_S_SOC_WDATA31 _2229_/X _2245_/X _0228_/Q
+ _0227_/Q VPWR VGND sg13cmos5l_mux4_1
X_1204_ _1204_/Q Tile_X0Y4_FrameData[18] VGND VPWR Tile_X0Y5_FrameStrobe[5] latch
XFILLER_361_62 VPWR VGND sg13cmos5l_fill_2
XFILLER_225_112 VPWR VGND sg13cmos5l_decap_8
X_1135_ _1135_/Q Tile_X0Y4_FrameData[23] VGND VPWR Tile_X0Y5_FrameStrobe[3] latch
XFILLER_92_194 VPWR VGND sg13cmos5l_decap_4
XFILLER_230_77 VPWR VGND sg13cmos5l_decap_8
XFILLER_240_126 VPWR VGND sg13cmos5l_decap_8
X_1066_ _1066_/Q Tile_X0Y4_FrameData[28] VGND VPWR Tile_X0Y5_FrameStrobe[1] latch
XFILLER_178_211 VPWR VGND sg13cmos5l_decap_8
XFILLER_33_272 VPWR VGND sg13cmos5l_fill_1
XFILLER_138_119 VPWR VGND sg13cmos5l_decap_4
XFILLER_239_42 VPWR VGND sg13cmos5l_decap_8
XFILLER_193_269 VPWR VGND sg13cmos5l_decap_4
X_1968_ Tile_X0Y5_E1BEG[1] _2722_/X VPWR VGND sg13cmos5l_buf_1
XANTENNA__1646__X Tile_X0Y0_FrameStrobe_O[6] VPWR VGND sg13cmos5l_antennanp
XFILLER_146_163 VPWR VGND sg13cmos5l_decap_8
X_1899_ Tile_X0Y1_FrameData_O[12] Tile_X0Y1_FrameData[12] VPWR VGND sg13cmos5l_buf_1
X_0919_ _0919_/Q Tile_X0Y3_FrameData[31] VGND VPWR Tile_X0Y5_FrameStrobe[4] latch
XFILLER_108_35 VPWR VGND sg13cmos5l_decap_8
XFILLER_350_211 VPWR VGND sg13cmos5l_decap_8
XFILLER_255_63 VPWR VGND sg13cmos5l_decap_8
XFILLER_350_233 VPWR VGND sg13cmos5l_decap_8
XFILLER_310_119 VPWR VGND sg13cmos5l_decap_8
XFILLER_68_28 VPWR VGND sg13cmos5l_decap_8
XFILLER_303_182 VPWR VGND sg13cmos5l_decap_8
XFILLER_124_56 VPWR VGND sg13cmos5l_decap_8
XFILLER_194_7 VPWR VGND sg13cmos5l_decap_8
XFILLER_271_84 VPWR VGND sg13cmos5l_decap_8
XFILLER_271_95 VPWR VGND sg13cmos5l_fill_1
XFILLER_17_21 VPWR VGND sg13cmos5l_decap_8
XFILLER_84_49 VPWR VGND sg13cmos5l_decap_8
XFILLER_216_167 VPWR VGND sg13cmos5l_decap_8
XFILLER_271_262 VPWR VGND sg13cmos5l_fill_1
XFILLER_17_98 VPWR VGND sg13cmos5l_decap_8
XFILLER_231_126 VPWR VGND sg13cmos5l_decap_8
XFILLER_140_77 VPWR VGND sg13cmos5l_decap_8
XFILLER_129_119 VPWR VGND sg13cmos5l_decap_8
XFILLER_149_42 VPWR VGND sg13cmos5l_decap_8
XFILLER_33_64 VPWR VGND sg13cmos5l_decap_8
XFILLER_296_70 VPWR VGND sg13cmos5l_decap_8
XANTENNA__1556__X Tile_X0Y3_FrameData_O[2] VPWR VGND sg13cmos5l_antennanp
XFILLER_116_0 VPWR VGND sg13cmos5l_decap_8
XFILLER_137_163 VPWR VGND sg13cmos5l_fill_1
XFILLER_137_185 VPWR VGND sg13cmos5l_fill_2
XFILLER_298_126 VPWR VGND sg13cmos5l_decap_8
XFILLER_165_85 VPWR VGND sg13cmos5l_decap_8
XFILLER_301_119 VPWR VGND sg13cmos5l_decap_8
XFILLER_315_77 VPWR VGND sg13cmos5l_decap_8
XFILLER_181_84 VPWR VGND sg13cmos5l_decap_8
XFILLER_331_21 VPWR VGND sg13cmos5l_decap_8
XFILLER_207_167 VPWR VGND sg13cmos5l_decap_8
XFILLER_207_178 VPWR VGND sg13cmos5l_fill_2
XFILLER_200_14 VPWR VGND sg13cmos5l_decap_8
XFILLER_222_159 VPWR VGND sg13cmos5l_decap_8
XFILLER_175_203 VPWR VGND sg13cmos5l_decap_8
XFILLER_30_242 VPWR VGND sg13cmos5l_decap_8
XFILLER_30_253 VPWR VGND sg13cmos5l_fill_1
X_1822_ Tile_X0Y4_EE4BEG[5] _2638_/X VPWR VGND sg13cmos5l_buf_1
XFILLER_190_217 VPWR VGND sg13cmos5l_fill_2
X_1753_ Tile_X0Y2_FrameData_O[13] Tile_X0Y2_FrameData[13] VPWR VGND sg13cmos5l_buf_1
XFILLER_143_111 VPWR VGND sg13cmos5l_decap_8
XFILLER_209_56 VPWR VGND sg13cmos5l_decap_8
XFILLER_332_222 VPWR VGND sg13cmos5l_fill_2
X_1684_ Tile_X0Y0_FrameData_O[24] Tile_X0Y0_FrameData[24] VPWR VGND sg13cmos5l_buf_1
X_0704_ _0704_/Q Tile_X0Y2_FrameData[6] VGND VPWR Tile_X0Y5_FrameStrobe[4] latch
XFILLER_356_84 VPWR VGND sg13cmos5l_decap_8
XFILLER_289_126 VPWR VGND sg13cmos5l_decap_8
XFILLER_292_28 VPWR VGND sg13cmos5l_decap_8
X_0635_ _0635_/Q Tile_X0Y2_FrameData[11] VGND VPWR Tile_X0Y5_FrameStrobe[2] latch
XFILLER_143_177 VPWR VGND sg13cmos5l_decap_8
XFILLER_31_0 VPWR VGND sg13cmos5l_decap_8
X_0566_ _0566_/Q Tile_X0Y2_FrameData[16] VGND VPWR Tile_X0Y5_FrameStrobe[0] latch
XFILLER_225_77 VPWR VGND sg13cmos5l_decap_8
X_2305_ _2305_/X AXIL_S_SOC_WDATA4 AXIL_S_SOC_WDATA12 _2376_/X _2377_/X _0482_/Q _0481_/Q
+ VPWR VGND sg13cmos5l_mux4_1
X_0497_ _0497_/Q Tile_X0Y1_FrameData[5] VGND VPWR Tile_X0Y5_FrameStrobe[5] latch
XFILLER_245_218 VPWR VGND sg13cmos5l_decap_4
XFILLER_300_196 VPWR VGND sg13cmos5l_decap_8
X_2236_ _2236_/X _2215_/X _0064_/X Tile_X0Y0_S1END[2] Tile_X0Y0_S4END[2] _0122_/Q
+ _0121_/Q VPWR VGND sg13cmos5l_mux4_1
XFILLER_241_21 VPWR VGND sg13cmos5l_decap_8
X_2167_ _2167_/X AXIL_S_SOC_WDATA18 AXIL_S_SOC_WDATA26 _2243_/X _2246_/X _0262_/Q
+ _0261_/Q VPWR VGND sg13cmos5l_mux4_1
XFILLER_65_172 VPWR VGND sg13cmos5l_decap_4
XFILLER_65_161 VPWR VGND sg13cmos5l_decap_4
XFILLER_241_98 VPWR VGND sg13cmos5l_decap_8
X_2098_ Tile_X0Y3_E2BEGb[2] _2519_/X VPWR VGND sg13cmos5l_buf_1
X_1118_ _1118_/Q Tile_X0Y4_FrameData[8] VGND VPWR Tile_X0Y5_FrameStrobe[2] latch
XFILLER_110_14 VPWR VGND sg13cmos5l_decap_8
X_1049_ _1049_/Q Tile_X0Y4_FrameData[13] VGND VPWR Tile_X0Y5_FrameStrobe[0] latch
XFILLER_80_153 VPWR VGND sg13cmos5l_fill_1
XFILLER_359_119 VPWR VGND sg13cmos5l_decap_8
XFILLER_166_203 VPWR VGND sg13cmos5l_decap_8
XFILLER_119_56 VPWR VGND sg13cmos5l_decap_8
XFILLER_207_7 VPWR VGND sg13cmos5l_decap_8
XFILLER_134_133 VPWR VGND sg13cmos5l_fill_2
XFILLER_266_84 VPWR VGND sg13cmos5l_decap_8
XFILLER_79_49 VPWR VGND sg13cmos5l_decap_8
XFILLER_134_188 VPWR VGND sg13cmos5l_fill_1
XFILLER_88_231 VPWR VGND sg13cmos5l_fill_1
XFILLER_135_77 VPWR VGND sg13cmos5l_decap_8
XANTENNA__2000__X Tile_X0Y5_EE4BEG[1] VPWR VGND sg13cmos5l_antennanp
XFILLER_151_21 VPWR VGND sg13cmos5l_decap_8
XFILLER_28_42 VPWR VGND sg13cmos5l_decap_8
XFILLER_56_161 VPWR VGND sg13cmos5l_decap_8
XFILLER_151_98 VPWR VGND sg13cmos5l_decap_8
XFILLER_204_104 VPWR VGND sg13cmos5l_decap_8
XFILLER_301_35 VPWR VGND sg13cmos5l_decap_8
XFILLER_71_142 VPWR VGND sg13cmos5l_decap_8
XFILLER_204_137 VPWR VGND sg13cmos5l_decap_8
XFILLER_71_164 VPWR VGND sg13cmos5l_decap_8
XFILLER_44_74 VPWR VGND sg13cmos5l_decap_8
XFILLER_212_181 VPWR VGND sg13cmos5l_decap_4
XFILLER_233_0 VPWR VGND sg13cmos5l_decap_8
XFILLER_8_202 VPWR VGND sg13cmos5l_fill_2
XFILLER_100_91 VPWR VGND sg13cmos5l_decap_8
XFILLER_358_196 VPWR VGND sg13cmos5l_decap_8
XFILLER_172_239 VPWR VGND sg13cmos5l_decap_8
XFILLER_60_84 VPWR VGND sg13cmos5l_decap_8
XFILLER_176_84 VPWR VGND sg13cmos5l_decap_8
XFILLER_314_233 VPWR VGND sg13cmos5l_fill_2
XFILLER_326_21 VPWR VGND sg13cmos5l_decap_8
XFILLER_5_35 VPWR VGND sg13cmos5l_decap_8
XFILLER_140_114 VPWR VGND sg13cmos5l_decap_8
XFILLER_180_272 VPWR VGND sg13cmos5l_fill_1
XFILLER_326_98 VPWR VGND sg13cmos5l_decap_8
X_0420_ _0420_/Q Tile_X0Y1_FrameData[18] VGND VPWR Tile_X0Y5_FrameStrobe[3] latch
XFILLER_79_231 VPWR VGND sg13cmos5l_fill_1
X_0351_ _0351_/Q Tile_X0Y1_FrameData[23] VGND VPWR Tile_X0Y5_FrameStrobe[1] latch
XFILLER_79_253 VPWR VGND sg13cmos5l_fill_2
XFILLER_294_140 VPWR VGND sg13cmos5l_decap_8
X_2021_ Tile_X0Y5_FrameData_O[6] Tile_X0Y5_FrameData[6] VPWR VGND sg13cmos5l_buf_1
X_0282_ _0282_/Q Tile_X0Y0_FrameData[12] VGND VPWR Tile_X0Y5_FrameStrobe[6] latch
XFILLER_94_267 VPWR VGND sg13cmos5l_decap_4
XFILLER_94_256 VPWR VGND sg13cmos5l_fill_1
XFILLER_342_64 VPWR VGND sg13cmos5l_decap_8
XFILLER_85_92 VPWR VGND sg13cmos5l_fill_2
XFILLER_211_35 VPWR VGND sg13cmos5l_decap_8
XFILLER_47_183 VPWR VGND sg13cmos5l_decap_8
XFILLER_62_175 VPWR VGND sg13cmos5l_fill_2
XFILLER_287_28 VPWR VGND sg13cmos5l_decap_8
XFILLER_349_196 VPWR VGND sg13cmos5l_decap_8
X_1805_ Tile_X0Y4_E6BEG[0] _2649_/X VPWR VGND sg13cmos5l_buf_1
X_2785_ _2785_/X Tile_X0Y5_W1END[2] Tile_X0Y5_WW4END[14] Tile_X0Y5_W6END[6] _2820_/X
+ _1334_/Q _1333_/Q VPWR VGND sg13cmos5l_mux4_1
XFILLER_79_0 VPWR VGND sg13cmos5l_decap_8
XFILLER_163_228 VPWR VGND sg13cmos5l_decap_8
X_1736_ Tile_X0Y0_E1BEG[0] _2161_/X VPWR VGND sg13cmos5l_buf_1
XFILLER_116_133 VPWR VGND sg13cmos5l_decap_8
XFILLER_236_21 VPWR VGND sg13cmos5l_decap_8
XANTENNA__1924__X Tile_X0Y1_EE4BEG[5] VPWR VGND sg13cmos5l_antennanp
XFILLER_171_272 VPWR VGND sg13cmos5l_fill_1
X_1667_ Tile_X0Y0_FrameData_O[7] Tile_X0Y0_FrameData[7] VPWR VGND sg13cmos5l_buf_1
XFILLER_236_98 VPWR VGND sg13cmos5l_decap_8
X_1598_ Tile_X0Y2_EE4BEG[11] _2428_/X VPWR VGND sg13cmos5l_buf_1
X_0618_ _0618_/Q Tile_X0Y2_FrameData[28] VGND VPWR Tile_X0Y5_FrameStrobe[2] latch
XFILLER_105_14 VPWR VGND sg13cmos5l_decap_8
X_0549_ _0549_/Q Tile_X0Y1_FrameData[17] VGND VPWR Tile_X0Y5_FrameStrobe[7] latch
XFILLER_85_201 VPWR VGND sg13cmos5l_decap_8
XFILLER_252_42 VPWR VGND sg13cmos5l_decap_8
X_2219_ _2219_/X Tile_X0Y4_W1END[0] Tile_X0Y4_WW4END[0] Tile_X0Y4_W6END[8] _2707_/X
+ _1240_/Q _1239_/Q VPWR VGND sg13cmos5l_mux4_1
XANTENNA_108 AXIL_S_SOC_WDATA27 VPWR VGND sg13cmos5l_antennanp
XANTENNA_119 AXIL_S_SOC_WDATA29 VPWR VGND sg13cmos5l_antennanp
XFILLER_121_35 VPWR VGND sg13cmos5l_decap_8
XFILLER_241_210 VPWR VGND sg13cmos5l_decap_8
XFILLER_53_175 VPWR VGND sg13cmos5l_decap_8
XFILLER_157_7 VPWR VGND sg13cmos5l_decap_8
XFILLER_198_147 VPWR VGND sg13cmos5l_decap_8
XFILLER_197_28 VPWR VGND sg13cmos5l_decap_8
XFILLER_139_225 VPWR VGND sg13cmos5l_decap_8
XFILLER_14_77 VPWR VGND sg13cmos5l_decap_8
XFILLER_324_7 VPWR VGND sg13cmos5l_decap_8
XFILLER_355_133 VPWR VGND sg13cmos5l_decap_8
XFILLER_154_228 VPWR VGND sg13cmos5l_fill_1
XFILLER_30_21 VPWR VGND sg13cmos5l_decap_8
XFILLER_5_227 VPWR VGND sg13cmos5l_fill_1
XFILLER_146_21 VPWR VGND sg13cmos5l_decap_8
XANTENNA__1834__X Tile_X0Y4_FrameData_O[1] VPWR VGND sg13cmos5l_antennanp
XFILLER_107_166 VPWR VGND sg13cmos5l_decap_8
XFILLER_107_188 VPWR VGND sg13cmos5l_decap_8
XFILLER_30_98 VPWR VGND sg13cmos5l_decap_8
XFILLER_122_147 VPWR VGND sg13cmos5l_decap_8
XFILLER_162_42 VPWR VGND sg13cmos5l_decap_8
XFILLER_209_207 VPWR VGND sg13cmos5l_fill_2
XFILLER_39_63 VPWR VGND sg13cmos5l_decap_8
XFILLER_183_0 VPWR VGND sg13cmos5l_decap_8
XFILLER_291_154 VPWR VGND sg13cmos5l_decap_8
XFILLER_312_56 VPWR VGND sg13cmos5l_decap_8
XFILLER_232_232 VPWR VGND sg13cmos5l_decap_8
XFILLER_55_84 VPWR VGND sg13cmos5l_decap_8
XFILLER_350_0 VPWR VGND sg13cmos5l_decap_8
XFILLER_189_169 VPWR VGND sg13cmos5l_decap_8
XFILLER_44_197 VPWR VGND sg13cmos5l_decap_8
XFILLER_200_173 VPWR VGND sg13cmos5l_decap_8
XFILLER_72_7 VPWR VGND sg13cmos5l_decap_8
XFILLER_337_42 VPWR VGND sg13cmos5l_decap_8
XFILLER_299_210 VPWR VGND sg13cmos5l_fill_2
X_2570_ _2570_/X Tile_X0Y4_W1END[2] Tile_X0Y4_W6END[6] _2688_/X _2671_/X _1260_/Q
+ _1259_/Q VPWR VGND sg13cmos5l_mux4_1
XANTENNA__1744__X Tile_X0Y2_FrameData_O[4] VPWR VGND sg13cmos5l_antennanp
XFILLER_302_203 VPWR VGND sg13cmos5l_decap_8
X_1521_ _2454_/A3 VPWR VGND sg13cmos5l_tielo
XFILLER_113_147 VPWR VGND sg13cmos5l_decap_8
X_1452_ _1452_/Q Tile_X0Y5_FrameData[4] VGND VPWR Tile_X0Y5_FrameStrobe[5] latch
XFILLER_113_158 VPWR VGND sg13cmos5l_fill_1
XFILLER_206_35 VPWR VGND sg13cmos5l_decap_8
XFILLER_302_258 VPWR VGND sg13cmos5l_decap_8
X_0403_ _0403_/Q Tile_X0Y1_FrameData[3] VGND VPWR Tile_X0Y5_FrameStrobe[2] latch
XFILLER_353_63 VPWR VGND sg13cmos5l_decap_8
X_1383_ _1383_/Q Tile_X0Y5_FrameData[9] VGND VPWR Tile_X0Y5_FrameStrobe[3] latch
XFILLER_267_184 VPWR VGND sg13cmos5l_decap_4
X_0334_ _0334_/Q Tile_X0Y1_FrameData[8] VGND VPWR Tile_X0Y5_FrameStrobe[0] latch
XFILLER_96_91 VPWR VGND sg13cmos5l_decap_8
X_0265_ _0265_/Q Tile_X0Y0_FrameData[29] VGND VPWR Tile_X0Y5_FrameStrobe[6] latch
XFILLER_222_56 VPWR VGND sg13cmos5l_decap_8
XFILLER_282_176 VPWR VGND sg13cmos5l_fill_1
X_2004_ Tile_X0Y5_EE4BEG[5] _2746_/X VPWR VGND sg13cmos5l_buf_1
X_0196_ _0196_/Q Tile_X0Y0_FrameData[2] VGND VPWR Tile_X0Y5_FrameStrobe[3] latch
XFILLER_298_49 VPWR VGND sg13cmos5l_decap_8
XFILLER_90_270 VPWR VGND sg13cmos5l_fill_2
XFILLER_50_112 VPWR VGND sg13cmos5l_decap_8
XANTENNA__1919__X Tile_X0Y1_EE4BEG[0] VPWR VGND sg13cmos5l_antennanp
XFILLER_195_139 VPWR VGND sg13cmos5l_decap_4
XFILLER_50_189 VPWR VGND sg13cmos5l_decap_8
XFILLER_337_100 VPWR VGND sg13cmos5l_fill_1
XFILLER_247_42 VPWR VGND sg13cmos5l_decap_8
X_2768_ _2768_/X AXIL_S_SOC_ARVALID _2824_/X _2823_/X _2797_/X _1366_/Q _1365_/Q VPWR
+ VGND sg13cmos5l_mux4_1
XFILLER_352_147 VPWR VGND sg13cmos5l_decap_8
XANTENNA__1654__X Tile_X0Y0_FrameStrobe_O[14] VPWR VGND sg13cmos5l_antennanp
XFILLER_144_261 VPWR VGND sg13cmos5l_fill_2
X_1719_ Tile_X0Y0_E6BEG[11] _2208_/X VPWR VGND sg13cmos5l_buf_1
X_2699_ _2699_/X _2235_/X _2233_/X _2218_/X _2217_/X _0145_/Q _0144_/Q VPWR VGND sg13cmos5l_mux4_1
XFILLER_104_169 VPWR VGND sg13cmos5l_decap_8
XFILLER_116_35 VPWR VGND sg13cmos5l_decap_8
XFILLER_263_63 VPWR VGND sg13cmos5l_decap_8
XFILLER_76_28 VPWR VGND sg13cmos5l_decap_8
XFILLER_58_212 VPWR VGND sg13cmos5l_decap_8
XFILLER_273_132 VPWR VGND sg13cmos5l_decap_4
XFILLER_274_7 VPWR VGND sg13cmos5l_decap_8
XFILLER_73_204 VPWR VGND sg13cmos5l_decap_8
XFILLER_132_56 VPWR VGND sg13cmos5l_decap_8
XFILLER_214_232 VPWR VGND sg13cmos5l_decap_8
XFILLER_25_21 VPWR VGND sg13cmos5l_decap_8
XFILLER_92_49 VPWR VGND sg13cmos5l_decap_8
XFILLER_26_175 VPWR VGND sg13cmos5l_decap_8
XFILLER_41_123 VPWR VGND sg13cmos5l_decap_8
XANTENNA__1829__X Tile_X0Y4_EE4BEG[12] VPWR VGND sg13cmos5l_antennanp
XFILLER_25_98 VPWR VGND sg13cmos5l_decap_8
XFILLER_157_42 VPWR VGND sg13cmos5l_decap_8
XFILLER_41_53 VPWR VGND sg13cmos5l_decap_8
XFILLER_135_272 VPWR VGND sg13cmos5l_fill_1
XFILLER_142_209 VPWR VGND sg13cmos5l_fill_2
XANTENNA__1564__X Tile_X0Y3_FrameData_O[10] VPWR VGND sg13cmos5l_antennanp
XFILLER_307_56 VPWR VGND sg13cmos5l_decap_8
XFILLER_9_0 VPWR VGND sg13cmos5l_decap_8
XFILLER_150_253 VPWR VGND sg13cmos5l_decap_8
XFILLER_296_224 VPWR VGND sg13cmos5l_decap_8
XFILLER_296_246 VPWR VGND sg13cmos5l_decap_8
XFILLER_110_139 VPWR VGND sg13cmos5l_decap_8
XFILLER_173_63 VPWR VGND sg13cmos5l_decap_8
XFILLER_2_14 VPWR VGND sg13cmos5l_decap_8
XFILLER_264_143 VPWR VGND sg13cmos5l_fill_2
XFILLER_323_77 VPWR VGND sg13cmos5l_decap_8
XFILLER_264_187 VPWR VGND sg13cmos5l_decap_4
X_0050_ _1606_/A _2283_/X _2284_/X _0998_/Q VPWR VGND sg13cmos5l_mux2_1
XFILLER_32_112 VPWR VGND sg13cmos5l_fill_2
XANTENNA_19 AXIL_S_SOC_WDATA10 VPWR VGND sg13cmos5l_antennanp
XANTENNA__1739__X Tile_X0Y0_E1BEG[3] VPWR VGND sg13cmos5l_antennanp
XFILLER_220_268 VPWR VGND sg13cmos5l_decap_4
X_0952_ _0952_/Q Tile_X0Y3_FrameData[30] VGND VPWR Tile_X0Y5_FrameStrobe[5] latch
XFILLER_319_144 VPWR VGND sg13cmos5l_fill_1
XFILLER_319_155 VPWR VGND sg13cmos5l_fill_2
XFILLER_118_217 VPWR VGND sg13cmos5l_fill_2
XFILLER_319_188 VPWR VGND sg13cmos5l_fill_1
X_0883_ _0883_/Q Tile_X0Y3_FrameData[3] VGND VPWR Tile_X0Y5_FrameStrobe[2] latch
XFILLER_348_63 VPWR VGND sg13cmos5l_decap_8
X_2622_ _2622_/X AXIL_S_SOC_WSTRB1 AXIL_S_SOC_BREADY _2710_/X _2683_/X _1210_/Q _1209_/Q
+ VPWR VGND sg13cmos5l_mux4_1
X_2553_ _2553_/X Tile_X0Y3_W1END[0] Tile_X0Y3_WW4END[8] Tile_X0Y3_WW4END[12] Tile_X0Y3_W6END[4]
+ _0874_/Q _0873_/Q VPWR VGND sg13cmos5l_mux4_1
XFILLER_217_56 VPWR VGND sg13cmos5l_decap_8
XFILLER_287_202 VPWR VGND sg13cmos5l_decap_8
X_1504_ _2672_/A3 VPWR VGND sg13cmos5l_tielo
XFILLER_99_112 VPWR VGND sg13cmos5l_decap_8
X_2484_ _2484_/X _2388_/X _2496_/X _2495_/X _2387_/X _0568_/Q _0567_/Q VPWR VGND sg13cmos5l_mux4_1
X_1435_ _1435_/Q Tile_X0Y5_FrameData[21] VGND VPWR Tile_X0Y5_FrameStrobe[5] latch
X_1366_ _1366_/Q Tile_X0Y5_FrameData[26] VGND VPWR Tile_X0Y5_FrameStrobe[3] latch
XFILLER_233_77 VPWR VGND sg13cmos5l_decap_8
X_0317_ _0317_/Q Tile_X0Y1_FrameData[25] VGND VPWR Tile_X0Y5_FrameStrobe[0] latch
XFILLER_255_187 VPWR VGND sg13cmos5l_decap_8
X_1297_ _1297_/Q Tile_X0Y5_FrameData[31] VGND VPWR Tile_X0Y5_FrameStrobe[1] latch
XFILLER_255_198 VPWR VGND sg13cmos5l_fill_1
X_0248_ _0248_/Q Tile_X0Y0_FrameData[14] VGND VPWR Tile_X0Y5_FrameStrobe[5] latch
XFILLER_55_259 VPWR VGND sg13cmos5l_fill_1
XFILLER_23_112 VPWR VGND sg13cmos5l_decap_8
XFILLER_270_157 VPWR VGND sg13cmos5l_fill_2
X_0179_ _0179_/Q Tile_X0Y0_FrameData[19] VGND VPWR Tile_X0Y5_FrameStrobe[3] latch
XFILLER_23_134 VPWR VGND sg13cmos5l_decap_4
XFILLER_357_217 VPWR VGND sg13cmos5l_decap_8
XANTENNA__1649__X Tile_X0Y0_FrameStrobe_O[9] VPWR VGND sg13cmos5l_antennanp
XFILLER_168_128 VPWR VGND sg13cmos5l_decap_8
XFILLER_211_246 VPWR VGND sg13cmos5l_decap_8
XFILLER_109_228 VPWR VGND sg13cmos5l_decap_8
XFILLER_176_161 VPWR VGND sg13cmos5l_decap_8
XFILLER_176_183 VPWR VGND sg13cmos5l_decap_4
XFILLER_258_63 VPWR VGND sg13cmos5l_decap_8
XFILLER_191_131 VPWR VGND sg13cmos5l_decap_8
XFILLER_11_56 VPWR VGND sg13cmos5l_decap_8
XFILLER_127_56 VPWR VGND sg13cmos5l_decap_8
XFILLER_132_231 VPWR VGND sg13cmos5l_fill_2
XFILLER_274_84 VPWR VGND sg13cmos5l_decap_8
XFILLER_2_7 VPWR VGND sg13cmos5l_decap_8
XFILLER_87_49 VPWR VGND sg13cmos5l_decap_8
XFILLER_246_154 VPWR VGND sg13cmos5l_decap_8
XFILLER_246_165 VPWR VGND sg13cmos5l_fill_2
XFILLER_246_176 VPWR VGND sg13cmos5l_fill_1
XFILLER_36_42 VPWR VGND sg13cmos5l_decap_8
XFILLER_14_112 VPWR VGND sg13cmos5l_decap_8
XFILLER_299_70 VPWR VGND sg13cmos5l_decap_8
XFILLER_61_218 VPWR VGND sg13cmos5l_fill_1
XFILLER_202_202 VPWR VGND sg13cmos5l_decap_8
XANTENNA__1559__X Tile_X0Y3_FrameData_O[5] VPWR VGND sg13cmos5l_antennanp
XFILLER_146_0 VPWR VGND sg13cmos5l_decap_8
XFILLER_14_178 VPWR VGND sg13cmos5l_decap_8
XFILLER_348_228 VPWR VGND sg13cmos5l_decap_8
XFILLER_52_63 VPWR VGND sg13cmos5l_decap_8
XFILLER_168_63 VPWR VGND sg13cmos5l_decap_8
XFILLER_313_0 VPWR VGND sg13cmos5l_decap_8
XFILLER_316_169 VPWR VGND sg13cmos5l_fill_1
XFILLER_318_77 VPWR VGND sg13cmos5l_decap_8
XFILLER_108_272 VPWR VGND sg13cmos5l_fill_1
XFILLER_269_202 VPWR VGND sg13cmos5l_decap_4
XFILLER_123_242 VPWR VGND sg13cmos5l_fill_1
XFILLER_184_84 VPWR VGND sg13cmos5l_decap_8
XFILLER_334_21 VPWR VGND sg13cmos5l_decap_8
XFILLER_35_7 VPWR VGND sg13cmos5l_decap_8
XFILLER_334_98 VPWR VGND sg13cmos5l_fill_2
X_1220_ _1220_/Q Tile_X0Y4_FrameData[2] VGND VPWR Tile_X0Y5_FrameStrobe[5] latch
XFILLER_96_159 VPWR VGND sg13cmos5l_fill_2
XFILLER_96_148 VPWR VGND sg13cmos5l_decap_8
X_1151_ _1151_/Q Tile_X0Y4_FrameData[7] VGND VPWR Tile_X0Y5_FrameStrobe[3] latch
XFILLER_203_14 VPWR VGND sg13cmos5l_decap_8
XFILLER_237_154 VPWR VGND sg13cmos5l_decap_8
X_0102_ _0102_/Q Tile_X0Y0_FrameData[0] VGND VPWR Tile_X0Y5_FrameStrobe[0] latch
XFILLER_37_237 VPWR VGND sg13cmos5l_fill_2
XFILLER_37_226 VPWR VGND sg13cmos5l_decap_8
XFILLER_350_42 VPWR VGND sg13cmos5l_decap_8
X_1082_ _1082_/Q Tile_X0Y4_FrameData[12] VGND VPWR Tile_X0Y5_FrameStrobe[1] latch
X_0033_ _1616_/A _2153_/X _2154_/X _0284_/Q VPWR VGND sg13cmos5l_mux2_1
XFILLER_93_70 VPWR VGND sg13cmos5l_decap_8
XANTENNA_280 AXIL_S_SOC_WDATA22 VPWR VGND sg13cmos5l_antennanp
XANTENNA_291 AXIL_S_SOC_WDATA19 VPWR VGND sg13cmos5l_antennanp
XFILLER_260_190 VPWR VGND sg13cmos5l_decap_8
X_1984_ Tile_X0Y5_E2BEGb[5] _2738_/X VPWR VGND sg13cmos5l_buf_1
XFILLER_359_84 VPWR VGND sg13cmos5l_decap_8
XFILLER_295_28 VPWR VGND sg13cmos5l_decap_8
X_0935_ _0935_/Q Tile_X0Y3_FrameData[15] VGND VPWR Tile_X0Y5_FrameStrobe[4] latch
XFILLER_307_147 VPWR VGND sg13cmos5l_decap_8
X_0866_ _0866_/Q Tile_X0Y3_FrameData[20] VGND VPWR Tile_X0Y5_FrameStrobe[2] latch
XFILLER_362_220 VPWR VGND sg13cmos5l_decap_8
XFILLER_173_175 VPWR VGND sg13cmos5l_decap_8
XFILLER_228_77 VPWR VGND sg13cmos5l_decap_8
X_2605_ _2605_/X Tile_X0Y2_W1END[0] Tile_X0Y2_W2MID[3] Tile_X0Y2_W2END[3] _2485_/X
+ _0642_/Q _0641_/Q VPWR VGND sg13cmos5l_mux4_1
XFILLER_61_0 VPWR VGND sg13cmos5l_decap_8
XFILLER_362_253 VPWR VGND sg13cmos5l_decap_4
X_0797_ _0797_/Q Tile_X0Y3_FrameData[25] VGND VPWR Tile_X0Y5_FrameStrobe[0] latch
XFILLER_114_253 VPWR VGND sg13cmos5l_fill_2
XFILLER_244_21 VPWR VGND sg13cmos5l_decap_8
X_2536_ _2536_/X AXIL_S_SOC_ARADDR1 AXIL_S_SOC_ARADDR7 _2587_/X _2593_/X _0932_/Q
+ _0931_/Q VPWR VGND sg13cmos5l_mux4_1
X_2467_ _2467_/X _2462_/X Tile_X0Y5_N4END[14] _2461_/X Tile_X0Y0_S4END[10] _0578_/Q
+ _0577_/Q VPWR VGND sg13cmos5l_mux4_1
XANTENNA__1932__X Tile_X0Y1_EE4BEG[13] VPWR VGND sg13cmos5l_antennanp
XFILLER_244_98 VPWR VGND sg13cmos5l_decap_8
X_1418_ _1418_/Q Tile_X0Y5_FrameData[6] VGND VPWR Tile_X0Y5_FrameStrobe[4] latch
XFILLER_87_137 VPWR VGND sg13cmos5l_decap_4
X_2398_ _2398_/X _2460_/X _2459_/X AXIL_S_SOC_AWADDR3 AXIL_S_SOC_AWADDR6 _0752_/Q
+ _0751_/Q VPWR VGND sg13cmos5l_mux4_1
XFILLER_113_14 VPWR VGND sg13cmos5l_decap_8
XFILLER_228_154 VPWR VGND sg13cmos5l_decap_8
XFILLER_228_165 VPWR VGND sg13cmos5l_fill_1
XFILLER_260_42 VPWR VGND sg13cmos5l_decap_8
XFILLER_28_215 VPWR VGND sg13cmos5l_decap_8
X_1349_ _1349_/Q Tile_X0Y5_FrameData[11] VGND VPWR Tile_X0Y5_FrameStrobe[2] latch
XFILLER_95_192 VPWR VGND sg13cmos5l_fill_1
XFILLER_95_170 VPWR VGND sg13cmos5l_fill_2
XFILLER_228_187 VPWR VGND sg13cmos5l_decap_4
XFILLER_43_207 VPWR VGND sg13cmos5l_decap_8
XFILLER_243_168 VPWR VGND sg13cmos5l_decap_8
XFILLER_11_126 VPWR VGND sg13cmos5l_decap_8
XFILLER_237_7 VPWR VGND sg13cmos5l_decap_8
XFILLER_269_84 VPWR VGND sg13cmos5l_decap_8
XFILLER_353_231 VPWR VGND sg13cmos5l_decap_8
XFILLER_138_77 VPWR VGND sg13cmos5l_decap_8
XFILLER_22_77 VPWR VGND sg13cmos5l_decap_8
XANTENNA__2003__X Tile_X0Y5_EE4BEG[4] VPWR VGND sg13cmos5l_antennanp
XFILLER_105_242 VPWR VGND sg13cmos5l_decap_8
XFILLER_154_21 VPWR VGND sg13cmos5l_decap_8
XANTENNA__1842__X Tile_X0Y4_FrameData_O[9] VPWR VGND sg13cmos5l_antennanp
XFILLER_154_98 VPWR VGND sg13cmos5l_decap_8
XFILLER_304_35 VPWR VGND sg13cmos5l_decap_8
XFILLER_170_42 VPWR VGND sg13cmos5l_decap_8
XFILLER_219_154 VPWR VGND sg13cmos5l_fill_2
XFILLER_281_208 VPWR VGND sg13cmos5l_fill_1
XFILLER_47_63 VPWR VGND sg13cmos5l_decap_8
XFILLER_234_168 VPWR VGND sg13cmos5l_decap_4
XFILLER_263_0 VPWR VGND sg13cmos5l_decap_8
XFILLER_103_91 VPWR VGND sg13cmos5l_decap_8
XFILLER_320_56 VPWR VGND sg13cmos5l_decap_8
XFILLER_63_84 VPWR VGND sg13cmos5l_decap_8
XFILLER_179_84 VPWR VGND sg13cmos5l_decap_8
XFILLER_329_21 VPWR VGND sg13cmos5l_decap_8
XFILLER_8_35 VPWR VGND sg13cmos5l_decap_8
X_0720_ _0720_/Q Tile_X0Y2_FrameData[22] VGND VPWR Tile_X0Y5_FrameStrobe[5] latch
XFILLER_329_98 VPWR VGND sg13cmos5l_decap_8
XFILLER_170_112 VPWR VGND sg13cmos5l_decap_8
X_0651_ _0651_/Q Tile_X0Y2_FrameData[27] VGND VPWR Tile_X0Y5_FrameStrobe[3] latch
X_0582_ _0582_/Q Tile_X0Y2_FrameData[0] VGND VPWR Tile_X0Y5_FrameStrobe[0] latch
XFILLER_345_42 VPWR VGND sg13cmos5l_decap_8
X_2321_ _2321_/X AXIL_S_SOC_WDATA0 AXIL_S_SOC_WDATA12 _2367_/X _2376_/X _0450_/Q _0449_/Q
+ VPWR VGND sg13cmos5l_mux4_1
XFILLER_88_70 VPWR VGND sg13cmos5l_decap_8
XFILLER_69_126 VPWR VGND sg13cmos5l_decap_8
XANTENNA__1752__X Tile_X0Y2_FrameData_O[12] VPWR VGND sg13cmos5l_antennanp
X_2252_ _2252_/X Tile_X0Y1_W2MID[6] Tile_X0Y1_W2END[6] Tile_X0Y1_W6END[6] _2374_/X
+ _0540_/Q _0539_/Q VPWR VGND sg13cmos5l_mux4_1
XFILLER_33_4 VPWR VGND sg13cmos5l_fill_1
XFILLER_214_35 VPWR VGND sg13cmos5l_decap_8
X_1203_ _1203_/Q Tile_X0Y4_FrameData[19] VGND VPWR Tile_X0Y5_FrameStrobe[5] latch
X_2183_ _2183_/X AXIL_S_SOC_WDATA18 AXIL_S_SOC_WDATA30 _2225_/X _2246_/X _0230_/Q
+ _0229_/Q VPWR VGND sg13cmos5l_mux4_1
XFILLER_265_271 VPWR VGND sg13cmos5l_fill_2
X_1134_ _1134_/Q Tile_X0Y4_FrameData[24] VGND VPWR Tile_X0Y5_FrameStrobe[3] latch
X_1065_ _1065_/Q Tile_X0Y4_FrameData[29] VGND VPWR Tile_X0Y5_FrameStrobe[1] latch
XFILLER_92_173 VPWR VGND sg13cmos5l_decap_8
XFILLER_225_179 VPWR VGND sg13cmos5l_decap_8
XFILLER_230_56 VPWR VGND sg13cmos5l_decap_8
XFILLER_240_105 VPWR VGND sg13cmos5l_decap_8
XFILLER_239_21 VPWR VGND sg13cmos5l_decap_8
XANTENNA__1927__X Tile_X0Y1_EE4BEG[8] VPWR VGND sg13cmos5l_antennanp
XFILLER_193_259 VPWR VGND sg13cmos5l_fill_2
X_1967_ Tile_X0Y5_E1BEG[0] _2721_/X VPWR VGND sg13cmos5l_buf_1
XFILLER_239_98 VPWR VGND sg13cmos5l_decap_8
X_1898_ Tile_X0Y1_FrameData_O[11] Tile_X0Y1_FrameData[11] VPWR VGND sg13cmos5l_buf_1
X_0918_ _0918_/Q Tile_X0Y3_FrameData[0] VGND VPWR Tile_X0Y5_FrameStrobe[3] latch
XFILLER_108_14 VPWR VGND sg13cmos5l_decap_8
XFILLER_146_186 VPWR VGND sg13cmos5l_decap_4
X_0849_ _0849_/Q Tile_X0Y3_FrameData[5] VGND VPWR Tile_X0Y5_FrameStrobe[1] latch
XFILLER_161_145 VPWR VGND sg13cmos5l_fill_2
XFILLER_255_42 VPWR VGND sg13cmos5l_decap_8
XFILLER_350_256 VPWR VGND sg13cmos5l_fill_1
XFILLER_255_97 VPWR VGND sg13cmos5l_decap_8
XFILLER_303_161 VPWR VGND sg13cmos5l_decap_8
X_2519_ _2519_/X AXIL_S_SOC_ARADDR0 AXIL_S_SOC_ARADDR2 _2591_/X _2594_/X _0966_/Q
+ _0965_/Q VPWR VGND sg13cmos5l_mux4_1
XANTENNA__1662__X Tile_X0Y0_FrameData_O[2] VPWR VGND sg13cmos5l_antennanp
XFILLER_248_216 VPWR VGND sg13cmos5l_decap_8
XFILLER_124_35 VPWR VGND sg13cmos5l_decap_8
XFILLER_187_7 VPWR VGND sg13cmos5l_decap_8
XFILLER_271_63 VPWR VGND sg13cmos5l_decap_8
XFILLER_84_28 VPWR VGND sg13cmos5l_decap_8
XFILLER_216_113 VPWR VGND sg13cmos5l_decap_8
XFILLER_256_271 VPWR VGND sg13cmos5l_fill_2
XFILLER_83_151 VPWR VGND sg13cmos5l_fill_2
XFILLER_68_192 VPWR VGND sg13cmos5l_fill_1
XFILLER_216_157 VPWR VGND sg13cmos5l_fill_2
XFILLER_271_241 VPWR VGND sg13cmos5l_decap_8
XFILLER_140_56 VPWR VGND sg13cmos5l_decap_8
XFILLER_17_77 VPWR VGND sg13cmos5l_decap_8
XFILLER_231_105 VPWR VGND sg13cmos5l_decap_8
XFILLER_354_7 VPWR VGND sg13cmos5l_decap_8
XFILLER_224_190 VPWR VGND sg13cmos5l_decap_8
XFILLER_169_245 VPWR VGND sg13cmos5l_decap_8
XFILLER_169_256 VPWR VGND sg13cmos5l_fill_1
XFILLER_33_43 VPWR VGND sg13cmos5l_decap_8
XFILLER_149_21 VPWR VGND sg13cmos5l_decap_8
XANTENNA__1837__X Tile_X0Y4_FrameData_O[4] VPWR VGND sg13cmos5l_antennanp
XFILLER_137_131 VPWR VGND sg13cmos5l_decap_8
XFILLER_298_105 VPWR VGND sg13cmos5l_decap_8
XFILLER_109_0 VPWR VGND sg13cmos5l_decap_8
XFILLER_165_64 VPWR VGND sg13cmos5l_decap_8
XFILLER_3_133 VPWR VGND sg13cmos5l_fill_1
XFILLER_152_167 VPWR VGND sg13cmos5l_decap_4
XANTENNA__1572__X Tile_X0Y3_FrameData_O[18] VPWR VGND sg13cmos5l_antennanp
XFILLER_239_205 VPWR VGND sg13cmos5l_fill_1
XFILLER_315_56 VPWR VGND sg13cmos5l_decap_8
XFILLER_181_63 VPWR VGND sg13cmos5l_decap_8
XFILLER_58_84 VPWR VGND sg13cmos5l_decap_8
XFILLER_331_77 VPWR VGND sg13cmos5l_decap_8
XFILLER_74_184 VPWR VGND sg13cmos5l_decap_8
XFILLER_222_105 VPWR VGND sg13cmos5l_decap_8
XFILLER_74_195 VPWR VGND sg13cmos5l_fill_1
XFILLER_15_262 VPWR VGND sg13cmos5l_fill_1
XFILLER_30_210 VPWR VGND sg13cmos5l_decap_4
XFILLER_175_226 VPWR VGND sg13cmos5l_fill_1
X_1821_ Tile_X0Y4_EE4BEG[4] _2637_/X VPWR VGND sg13cmos5l_buf_1
XFILLER_90_71 VPWR VGND sg13cmos5l_decap_8
XANTENNA__1747__X Tile_X0Y2_FrameData_O[7] VPWR VGND sg13cmos5l_antennanp
XFILLER_175_259 VPWR VGND sg13cmos5l_fill_2
XFILLER_209_35 VPWR VGND sg13cmos5l_decap_8
X_1752_ Tile_X0Y2_FrameData_O[12] Tile_X0Y2_FrameData[12] VPWR VGND sg13cmos5l_buf_1
XFILLER_289_105 VPWR VGND sg13cmos5l_decap_8
X_1683_ Tile_X0Y0_FrameData_O[23] Tile_X0Y0_FrameData[23] VPWR VGND sg13cmos5l_buf_1
X_0703_ _0703_/Q Tile_X0Y2_FrameData[7] VGND VPWR Tile_X0Y5_FrameStrobe[4] latch
XFILLER_356_63 VPWR VGND sg13cmos5l_decap_8
X_0634_ _0634_/Q Tile_X0Y2_FrameData[12] VGND VPWR Tile_X0Y5_FrameStrobe[2] latch
XFILLER_99_91 VPWR VGND sg13cmos5l_decap_8
XFILLER_225_56 VPWR VGND sg13cmos5l_decap_8
X_0565_ _0565_/Q Tile_X0Y2_FrameData[17] VGND VPWR Tile_X0Y5_FrameStrobe[0] latch
XFILLER_97_243 VPWR VGND sg13cmos5l_fill_2
XFILLER_24_0 VPWR VGND sg13cmos5l_decap_8
XFILLER_297_182 VPWR VGND sg13cmos5l_decap_8
X_2304_ _2304_/X AXIL_S_SOC_WDATA3 AXIL_S_SOC_WDATA11 _2376_/X _2377_/X _0484_/Q _0483_/Q
+ VPWR VGND sg13cmos5l_mux4_1
X_0496_ _0496_/Q Tile_X0Y1_FrameData[6] VGND VPWR Tile_X0Y5_FrameStrobe[5] latch
XFILLER_300_175 VPWR VGND sg13cmos5l_decap_8
X_2235_ _2235_/X _2216_/X _0065_/X Tile_X0Y0_S1END[3] Tile_X0Y0_S4END[3] _0120_/Q
+ _0119_/Q VPWR VGND sg13cmos5l_mux4_1
XFILLER_238_271 VPWR VGND sg13cmos5l_fill_2
X_2166_ _2166_/X AXIL_S_SOC_WDATA17 AXIL_S_SOC_WDATA25 _2242_/X _2247_/X _0264_/Q
+ _0263_/Q VPWR VGND sg13cmos5l_mux4_1
XFILLER_65_140 VPWR VGND sg13cmos5l_decap_8
XFILLER_241_77 VPWR VGND sg13cmos5l_decap_8
X_1117_ _1117_/Q Tile_X0Y4_FrameData[9] VGND VPWR Tile_X0Y5_FrameStrobe[2] latch
X_2097_ Tile_X0Y3_E2BEGb[1] _2518_/X VPWR VGND sg13cmos5l_buf_1
XFILLER_0_91 VPWR VGND sg13cmos5l_decap_8
XFILLER_206_190 VPWR VGND sg13cmos5l_decap_8
XFILLER_213_138 VPWR VGND sg13cmos5l_decap_8
X_1048_ _1048_/Q Tile_X0Y4_FrameData[14] VGND VPWR Tile_X0Y5_FrameStrobe[0] latch
XFILLER_80_198 VPWR VGND sg13cmos5l_decap_4
XANTENNA__1657__X Tile_X0Y0_FrameStrobe_O[17] VPWR VGND sg13cmos5l_antennanp
XFILLER_119_35 VPWR VGND sg13cmos5l_decap_8
XFILLER_181_218 VPWR VGND sg13cmos5l_decap_8
XFILLER_119_175 VPWR VGND sg13cmos5l_decap_4
XFILLER_134_112 VPWR VGND sg13cmos5l_decap_8
XFILLER_181_229 VPWR VGND sg13cmos5l_fill_1
XFILLER_266_63 VPWR VGND sg13cmos5l_decap_8
XFILLER_102_7 VPWR VGND sg13cmos5l_decap_8
XFILLER_323_223 VPWR VGND sg13cmos5l_fill_1
XFILLER_79_28 VPWR VGND sg13cmos5l_decap_8
XFILLER_135_56 VPWR VGND sg13cmos5l_decap_8
XFILLER_295_119 VPWR VGND sg13cmos5l_decap_8
XFILLER_0_147 VPWR VGND sg13cmos5l_fill_1
XFILLER_282_84 VPWR VGND sg13cmos5l_decap_8
XFILLER_288_182 VPWR VGND sg13cmos5l_decap_8
XFILLER_236_219 VPWR VGND sg13cmos5l_fill_2
XFILLER_28_21 VPWR VGND sg13cmos5l_decap_8
XFILLER_95_49 VPWR VGND sg13cmos5l_decap_8
XFILLER_229_260 VPWR VGND sg13cmos5l_fill_1
XFILLER_56_140 VPWR VGND sg13cmos5l_decap_8
XFILLER_151_77 VPWR VGND sg13cmos5l_decap_8
XFILLER_28_98 VPWR VGND sg13cmos5l_decap_8
XFILLER_301_14 VPWR VGND sg13cmos5l_decap_8
XFILLER_71_121 VPWR VGND sg13cmos5l_decap_8
XFILLER_44_53 VPWR VGND sg13cmos5l_decap_8
XFILLER_212_160 VPWR VGND sg13cmos5l_decap_8
XANTENNA__1567__X Tile_X0Y3_FrameData_O[13] VPWR VGND sg13cmos5l_antennanp
XFILLER_100_70 VPWR VGND sg13cmos5l_decap_8
XFILLER_157_226 VPWR VGND sg13cmos5l_decap_4
XFILLER_226_0 VPWR VGND sg13cmos5l_decap_4
XFILLER_358_175 VPWR VGND sg13cmos5l_decap_8
XFILLER_60_63 VPWR VGND sg13cmos5l_decap_8
XFILLER_176_63 VPWR VGND sg13cmos5l_decap_8
XFILLER_5_14 VPWR VGND sg13cmos5l_decap_8
XFILLER_326_77 VPWR VGND sg13cmos5l_decap_8
XFILLER_79_221 VPWR VGND sg13cmos5l_fill_1
XFILLER_192_84 VPWR VGND sg13cmos5l_decap_8
X_0350_ _0350_/Q Tile_X0Y1_FrameData[24] VGND VPWR Tile_X0Y5_FrameStrobe[1] latch
X_0281_ _0281_/Q Tile_X0Y0_FrameData[13] VGND VPWR Tile_X0Y5_FrameStrobe[6] latch
XFILLER_94_224 VPWR VGND sg13cmos5l_fill_2
XFILLER_342_43 VPWR VGND sg13cmos5l_decap_8
XFILLER_294_196 VPWR VGND sg13cmos5l_fill_2
X_2020_ Tile_X0Y5_FrameData_O[5] Tile_X0Y5_FrameData[5] VPWR VGND sg13cmos5l_buf_1
XFILLER_85_71 VPWR VGND sg13cmos5l_decap_8
XFILLER_47_140 VPWR VGND sg13cmos5l_fill_2
XFILLER_211_14 VPWR VGND sg13cmos5l_decap_8
XFILLER_250_233 VPWR VGND sg13cmos5l_fill_1
XFILLER_62_154 VPWR VGND sg13cmos5l_decap_8
XFILLER_210_108 VPWR VGND sg13cmos5l_decap_8
XFILLER_148_226 VPWR VGND sg13cmos5l_decap_8
XFILLER_349_175 VPWR VGND sg13cmos5l_decap_8
XFILLER_163_207 VPWR VGND sg13cmos5l_decap_8
X_1804_ Tile_X0Y4_E2BEGb[7] _2632_/X VPWR VGND sg13cmos5l_buf_1
X_2784_ _2784_/X _2822_/X _2821_/X _2810_/X _2809_/X _1337_/Q _1336_/Q VPWR VGND sg13cmos5l_mux4_1
XFILLER_116_112 VPWR VGND sg13cmos5l_decap_8
X_1735_ Tile_X0Y0_E2BEG[7] _2172_/X VPWR VGND sg13cmos5l_buf_1
XFILLER_116_189 VPWR VGND sg13cmos5l_decap_8
X_1666_ Tile_X0Y0_FrameData_O[6] Tile_X0Y0_FrameData[6] VPWR VGND sg13cmos5l_buf_1
XFILLER_236_77 VPWR VGND sg13cmos5l_decap_8
XFILLER_320_237 VPWR VGND sg13cmos5l_fill_1
X_1597_ Tile_X0Y2_EE4BEG[10] _2427_/X VPWR VGND sg13cmos5l_buf_1
X_0617_ _0617_/Q Tile_X0Y2_FrameData[29] VGND VPWR Tile_X0Y5_FrameStrobe[2] latch
XANTENNA__2101__X AXIL_S_SOC_WREADY VPWR VGND sg13cmos5l_antennanp
X_0548_ _0548_/Q Tile_X0Y1_FrameData[18] VGND VPWR Tile_X0Y5_FrameStrobe[7] latch
XFILLER_252_21 VPWR VGND sg13cmos5l_decap_8
XANTENNA__1940__X Tile_X0Y1_E6BEG[5] VPWR VGND sg13cmos5l_antennanp
X_0479_ _0479_/Q Tile_X0Y1_FrameData[23] VGND VPWR Tile_X0Y5_FrameStrobe[5] latch
XFILLER_252_98 VPWR VGND sg13cmos5l_decap_8
X_2218_ _2218_/X _2216_/X _0065_/X Tile_X0Y0_S1END[3] Tile_X0Y0_S4END[3] _0104_/Q
+ _0103_/Q VPWR VGND sg13cmos5l_mux4_1
XANTENNA_109 AXIL_S_SOC_WDATA27 VPWR VGND sg13cmos5l_antennanp
XFILLER_121_14 VPWR VGND sg13cmos5l_decap_8
X_2149_ _2149_/X Tile_X0Y0_W2MID[3] Tile_X0Y0_W2END[3] Tile_X0Y0_W6END[3] _2245_/X
+ _0294_/Q _0293_/Q VPWR VGND sg13cmos5l_mux4_1
XFILLER_198_126 VPWR VGND sg13cmos5l_decap_8
XFILLER_241_244 VPWR VGND sg13cmos5l_decap_8
XFILLER_53_154 VPWR VGND sg13cmos5l_decap_8
XFILLER_81_29 VPWR VGND sg13cmos5l_decap_8
XFILLER_14_56 VPWR VGND sg13cmos5l_decap_8
XFILLER_355_112 VPWR VGND sg13cmos5l_decap_8
XFILLER_277_84 VPWR VGND sg13cmos5l_decap_8
XFILLER_317_7 VPWR VGND sg13cmos5l_decap_8
XFILLER_107_112 VPWR VGND sg13cmos5l_decap_4
XFILLER_355_189 VPWR VGND sg13cmos5l_decap_8
XFILLER_107_145 VPWR VGND sg13cmos5l_decap_8
XFILLER_162_262 VPWR VGND sg13cmos5l_decap_8
XFILLER_30_77 VPWR VGND sg13cmos5l_decap_8
XFILLER_122_126 VPWR VGND sg13cmos5l_decap_8
XFILLER_146_77 VPWR VGND sg13cmos5l_decap_8
XANTENNA__2011__X Tile_X0Y5_EE4BEG[12] VPWR VGND sg13cmos5l_antennanp
XFILLER_39_42 VPWR VGND sg13cmos5l_decap_8
XFILLER_162_21 VPWR VGND sg13cmos5l_decap_8
XANTENNA__1850__X Tile_X0Y4_FrameData_O[17] VPWR VGND sg13cmos5l_antennanp
XFILLER_130_181 VPWR VGND sg13cmos5l_fill_1
XFILLER_162_98 VPWR VGND sg13cmos5l_decap_8
XFILLER_291_133 VPWR VGND sg13cmos5l_decap_8
XFILLER_312_35 VPWR VGND sg13cmos5l_decap_8
XFILLER_176_0 VPWR VGND sg13cmos5l_decap_8
XFILLER_55_63 VPWR VGND sg13cmos5l_decap_8
XFILLER_44_176 VPWR VGND sg13cmos5l_decap_8
XFILLER_343_0 VPWR VGND sg13cmos5l_decap_8
XFILLER_111_91 VPWR VGND sg13cmos5l_decap_8
XFILLER_346_112 VPWR VGND sg13cmos5l_decap_8
XFILLER_187_84 VPWR VGND sg13cmos5l_decap_8
XFILLER_71_84 VPWR VGND sg13cmos5l_decap_8
XFILLER_346_145 VPWR VGND sg13cmos5l_decap_8
XFILLER_145_229 VPWR VGND sg13cmos5l_decap_8
XFILLER_65_7 VPWR VGND sg13cmos5l_decap_8
XFILLER_337_21 VPWR VGND sg13cmos5l_decap_8
XFILLER_299_222 VPWR VGND sg13cmos5l_decap_4
XFILLER_153_240 VPWR VGND sg13cmos5l_fill_1
X_1520_ _2337_/A3 VPWR VGND sg13cmos5l_tielo
XFILLER_337_98 VPWR VGND sg13cmos5l_fill_2
XFILLER_113_126 VPWR VGND sg13cmos5l_decap_8
XFILLER_206_14 VPWR VGND sg13cmos5l_decap_8
X_1451_ _1451_/Q Tile_X0Y5_FrameData[5] VGND VPWR Tile_X0Y5_FrameStrobe[5] latch
X_1382_ _1382_/Q Tile_X0Y5_FrameData[10] VGND VPWR Tile_X0Y5_FrameStrobe[3] latch
X_0402_ _0402_/Q Tile_X0Y1_FrameData[4] VGND VPWR Tile_X0Y5_FrameStrobe[2] latch
XFILLER_353_42 VPWR VGND sg13cmos5l_decap_8
XFILLER_267_141 VPWR VGND sg13cmos5l_fill_1
XFILLER_96_70 VPWR VGND sg13cmos5l_decap_8
XFILLER_67_213 VPWR VGND sg13cmos5l_fill_2
XANTENNA__1760__X Tile_X0Y2_FrameData_O[20] VPWR VGND sg13cmos5l_antennanp
XFILLER_267_163 VPWR VGND sg13cmos5l_decap_8
X_0333_ _0333_/Q Tile_X0Y1_FrameData[9] VGND VPWR Tile_X0Y5_FrameStrobe[0] latch
XFILLER_67_257 VPWR VGND sg13cmos5l_fill_1
XFILLER_222_35 VPWR VGND sg13cmos5l_decap_8
XFILLER_282_133 VPWR VGND sg13cmos5l_decap_8
X_0264_ _0264_/Q Tile_X0Y0_FrameData[30] VGND VPWR Tile_X0Y5_FrameStrobe[6] latch
XFILLER_282_166 VPWR VGND sg13cmos5l_fill_1
X_2003_ Tile_X0Y5_EE4BEG[4] _2745_/X VPWR VGND sg13cmos5l_buf_1
X_0195_ _0195_/Q Tile_X0Y0_FrameData[3] VGND VPWR Tile_X0Y5_FrameStrobe[3] latch
XFILLER_298_28 VPWR VGND sg13cmos5l_decap_8
XFILLER_223_266 VPWR VGND sg13cmos5l_decap_8
XFILLER_91_0 VPWR VGND sg13cmos5l_decap_8
XFILLER_50_168 VPWR VGND sg13cmos5l_decap_8
X_2836_ _2836_/X Tile_X0Y4_W1END[3] Tile_X0Y4_W2MID[0] Tile_X0Y4_W2END[0] _2681_/X
+ _1110_/Q _1109_/Q VPWR VGND sg13cmos5l_mux4_1
XFILLER_247_21 VPWR VGND sg13cmos5l_decap_8
XANTENNA__1935__X Tile_X0Y1_E6BEG[0] VPWR VGND sg13cmos5l_antennanp
X_2767_ _2767_/X AXIL_S_SOC_ARPROT2 _2822_/X _2821_/X _2798_/X _1368_/Q _1367_/Q VPWR
+ VGND sg13cmos5l_mux4_1
XFILLER_352_126 VPWR VGND sg13cmos5l_decap_8
XFILLER_247_98 VPWR VGND sg13cmos5l_decap_8
X_1718_ Tile_X0Y0_E6BEG[10] _2207_/X VPWR VGND sg13cmos5l_buf_1
X_2698_ _2698_/X Tile_X0Y0_W1END[3] Tile_X0Y0_WW4END[11] Tile_X0Y0_WW4END[15] Tile_X0Y0_W6END[7]
+ _0145_/Q _0144_/Q VPWR VGND sg13cmos5l_mux4_1
XFILLER_116_14 VPWR VGND sg13cmos5l_decap_8
X_1649_ Tile_X0Y0_FrameStrobe_O[9] Tile_X0Y5_FrameStrobe[9] VPWR VGND sg13cmos5l_buf_1
XFILLER_263_42 VPWR VGND sg13cmos5l_decap_8
XFILLER_258_152 VPWR VGND sg13cmos5l_decap_8
XANTENNA__1670__X Tile_X0Y0_FrameData_O[10] VPWR VGND sg13cmos5l_antennanp
XFILLER_132_35 VPWR VGND sg13cmos5l_decap_8
XFILLER_258_196 VPWR VGND sg13cmos5l_decap_8
XFILLER_58_268 VPWR VGND sg13cmos5l_decap_4
XFILLER_267_7 VPWR VGND sg13cmos5l_decap_8
XFILLER_92_28 VPWR VGND sg13cmos5l_decap_8
XFILLER_41_102 VPWR VGND sg13cmos5l_decap_8
XFILLER_25_77 VPWR VGND sg13cmos5l_decap_8
XANTENNA__2006__X Tile_X0Y5_EE4BEG[7] VPWR VGND sg13cmos5l_antennanp
XFILLER_41_32 VPWR VGND sg13cmos5l_decap_8
XFILLER_157_21 VPWR VGND sg13cmos5l_decap_8
XANTENNA__1845__X Tile_X0Y4_FrameData_O[12] VPWR VGND sg13cmos5l_antennanp
XFILLER_343_137 VPWR VGND sg13cmos5l_fill_1
XFILLER_343_126 VPWR VGND sg13cmos5l_decap_8
XFILLER_135_251 VPWR VGND sg13cmos5l_decap_8
XFILLER_157_98 VPWR VGND sg13cmos5l_decap_8
XFILLER_307_35 VPWR VGND sg13cmos5l_decap_8
XFILLER_150_210 VPWR VGND sg13cmos5l_decap_4
XFILLER_296_203 VPWR VGND sg13cmos5l_decap_8
XFILLER_173_42 VPWR VGND sg13cmos5l_decap_8
XFILLER_249_130 VPWR VGND sg13cmos5l_fill_2
XFILLER_293_0 VPWR VGND sg13cmos5l_decap_8
XFILLER_49_224 VPWR VGND sg13cmos5l_decap_8
XANTENNA__1580__X Tile_X0Y3_FrameData_O[26] VPWR VGND sg13cmos5l_antennanp
XFILLER_249_174 VPWR VGND sg13cmos5l_decap_8
XFILLER_264_111 VPWR VGND sg13cmos5l_decap_4
XFILLER_106_91 VPWR VGND sg13cmos5l_decap_8
XFILLER_323_56 VPWR VGND sg13cmos5l_decap_8
XFILLER_264_155 VPWR VGND sg13cmos5l_decap_4
XFILLER_264_166 VPWR VGND sg13cmos5l_decap_8
XFILLER_66_84 VPWR VGND sg13cmos5l_decap_8
XFILLER_17_154 VPWR VGND sg13cmos5l_fill_2
XFILLER_72_271 VPWR VGND sg13cmos5l_fill_2
XFILLER_220_247 VPWR VGND sg13cmos5l_decap_4
XFILLER_319_112 VPWR VGND sg13cmos5l_decap_8
XFILLER_32_157 VPWR VGND sg13cmos5l_decap_8
XFILLER_32_179 VPWR VGND sg13cmos5l_decap_8
X_0951_ _0951_/Q Tile_X0Y3_FrameData[31] VGND VPWR Tile_X0Y5_FrameStrobe[5] latch
XFILLER_348_42 VPWR VGND sg13cmos5l_decap_8
XFILLER_185_151 VPWR VGND sg13cmos5l_fill_2
X_0882_ _0882_/Q Tile_X0Y3_FrameData[4] VGND VPWR Tile_X0Y5_FrameStrobe[2] latch
XANTENNA__1755__X Tile_X0Y2_FrameData_O[15] VPWR VGND sg13cmos5l_antennanp
X_2621_ _2621_/X AXIL_S_SOC_WSTRB0 AXIL_S_SOC_WVALID _2711_/X _2712_/X _1212_/Q _1211_/Q
+ VPWR VGND sg13cmos5l_mux4_1
X_2552_ _2552_/X AXIL_S_SOC_ARADDR3 _2588_/X _2587_/X _2596_/X _0900_/Q _0899_/Q VPWR
+ VGND sg13cmos5l_mux4_1
XFILLER_217_35 VPWR VGND sg13cmos5l_decap_8
X_1503_ _2561_/A3 VPWR VGND sg13cmos5l_tielo
X_2483_ _2483_/X _2386_/X _2494_/X _2493_/X _2385_/X _0570_/Q _0569_/Q VPWR VGND sg13cmos5l_mux4_1
X_1434_ _1434_/Q Tile_X0Y5_FrameData[22] VGND VPWR Tile_X0Y5_FrameStrobe[5] latch
XFILLER_255_111 VPWR VGND sg13cmos5l_decap_8
X_1365_ _1365_/Q Tile_X0Y5_FrameData[27] VGND VPWR Tile_X0Y5_FrameStrobe[3] latch
XFILLER_233_56 VPWR VGND sg13cmos5l_decap_8
X_0316_ _0316_/Q Tile_X0Y1_FrameData[26] VGND VPWR Tile_X0Y5_FrameStrobe[0] latch
X_1296_ _1296_/Q Tile_X0Y5_FrameData[0] VGND VPWR Tile_X0Y5_FrameStrobe[0] latch
XFILLER_55_238 VPWR VGND sg13cmos5l_decap_8
X_0247_ _0247_/Q Tile_X0Y0_FrameData[15] VGND VPWR Tile_X0Y5_FrameStrobe[5] latch
XFILLER_102_49 VPWR VGND sg13cmos5l_decap_8
XFILLER_270_169 VPWR VGND sg13cmos5l_fill_1
X_0178_ _0178_/Q Tile_X0Y0_FrameData[20] VGND VPWR Tile_X0Y5_FrameStrobe[3] latch
XFILLER_63_271 VPWR VGND sg13cmos5l_fill_2
XFILLER_63_260 VPWR VGND sg13cmos5l_fill_2
XFILLER_211_225 VPWR VGND sg13cmos5l_decap_8
XFILLER_23_168 VPWR VGND sg13cmos5l_decap_8
XFILLER_176_140 VPWR VGND sg13cmos5l_decap_8
XFILLER_258_42 VPWR VGND sg13cmos5l_decap_8
XFILLER_109_207 VPWR VGND sg13cmos5l_decap_8
XANTENNA__1665__X Tile_X0Y0_FrameData_O[5] VPWR VGND sg13cmos5l_antennanp
X_2819_ _2819_/X Tile_X0Y5_N1END[3] Tile_X0Y5_N4END[3] _2796_/X _0057_/X _1314_/Q
+ _1313_/Q VPWR VGND sg13cmos5l_mux4_1
XFILLER_11_35 VPWR VGND sg13cmos5l_decap_8
XFILLER_127_35 VPWR VGND sg13cmos5l_decap_8
XFILLER_191_187 VPWR VGND sg13cmos5l_decap_4
XFILLER_191_198 VPWR VGND sg13cmos5l_fill_1
XFILLER_274_63 VPWR VGND sg13cmos5l_decap_8
XFILLER_132_254 VPWR VGND sg13cmos5l_decap_4
XFILLER_278_247 VPWR VGND sg13cmos5l_decap_8
XFILLER_87_28 VPWR VGND sg13cmos5l_decap_8
XFILLER_293_239 VPWR VGND sg13cmos5l_decap_8
XFILLER_143_56 VPWR VGND sg13cmos5l_decap_8
XFILLER_246_133 VPWR VGND sg13cmos5l_decap_8
XFILLER_290_84 VPWR VGND sg13cmos5l_decap_8
XFILLER_143_89 VPWR VGND sg13cmos5l_fill_1
XFILLER_46_238 VPWR VGND sg13cmos5l_decap_8
XFILLER_36_21 VPWR VGND sg13cmos5l_decap_8
XFILLER_199_210 VPWR VGND sg13cmos5l_decap_8
XFILLER_54_271 VPWR VGND sg13cmos5l_fill_2
XFILLER_36_98 VPWR VGND sg13cmos5l_decap_8
XFILLER_159_129 VPWR VGND sg13cmos5l_fill_1
XFILLER_52_42 VPWR VGND sg13cmos5l_decap_8
XFILLER_139_0 VPWR VGND sg13cmos5l_decap_8
XFILLER_168_42 VPWR VGND sg13cmos5l_decap_8
XANTENNA__1575__X Tile_X0Y3_FrameData_O[21] VPWR VGND sg13cmos5l_antennanp
XFILLER_316_126 VPWR VGND sg13cmos5l_decap_8
XFILLER_182_154 VPWR VGND sg13cmos5l_decap_8
XFILLER_306_0 VPWR VGND sg13cmos5l_decap_8
XFILLER_318_56 VPWR VGND sg13cmos5l_decap_8
XFILLER_184_63 VPWR VGND sg13cmos5l_decap_8
XFILLER_269_236 VPWR VGND sg13cmos5l_fill_2
XFILLER_96_105 VPWR VGND sg13cmos5l_decap_8
XFILLER_28_7 VPWR VGND sg13cmos5l_decap_8
XFILLER_334_77 VPWR VGND sg13cmos5l_decap_8
XFILLER_237_133 VPWR VGND sg13cmos5l_decap_8
X_1150_ _1150_/Q Tile_X0Y4_FrameData[8] VGND VPWR Tile_X0Y5_FrameStrobe[3] latch
X_0101_ _0101_/Q Tile_X0Y0_FrameData[1] VGND VPWR Tile_X0Y5_FrameStrobe[0] latch
XFILLER_350_21 VPWR VGND sg13cmos5l_decap_8
XFILLER_292_272 VPWR VGND sg13cmos5l_fill_1
X_1081_ _1081_/Q Tile_X0Y4_FrameData[13] VGND VPWR Tile_X0Y5_FrameStrobe[1] latch
X_0032_ _0032_/X _2803_/X _2804_/X _0392_/Q VPWR VGND sg13cmos5l_mux2_1
XANTENNA_270 AXIL_S_SOC_WDATA22 VPWR VGND sg13cmos5l_antennanp
XANTENNA_281 AXIL_S_SOC_WDATA22 VPWR VGND sg13cmos5l_antennanp
XANTENNA_292 AXIL_S_SOC_WDATA19 VPWR VGND sg13cmos5l_antennanp
XFILLER_20_105 VPWR VGND sg13cmos5l_decap_8
X_1983_ Tile_X0Y5_E2BEGb[4] _2737_/X VPWR VGND sg13cmos5l_buf_1
XFILLER_359_63 VPWR VGND sg13cmos5l_decap_8
X_0934_ _0934_/Q Tile_X0Y3_FrameData[16] VGND VPWR Tile_X0Y5_FrameStrobe[4] latch
XFILLER_9_161 VPWR VGND sg13cmos5l_decap_8
XFILLER_347_240 VPWR VGND sg13cmos5l_fill_1
XFILLER_307_126 VPWR VGND sg13cmos5l_decap_8
X_0865_ _0865_/Q Tile_X0Y3_FrameData[21] VGND VPWR Tile_X0Y5_FrameStrobe[2] latch
XFILLER_173_154 VPWR VGND sg13cmos5l_decap_8
XFILLER_228_56 VPWR VGND sg13cmos5l_decap_8
X_2604_ _2604_/X Tile_X0Y5_W2MID[4] Tile_X0Y5_W2END[4] Tile_X0Y5_W6END[4] _2828_/X
+ _1482_/Q _1481_/Q VPWR VGND sg13cmos5l_mux4_1
X_0796_ _0796_/Q Tile_X0Y3_FrameData[26] VGND VPWR Tile_X0Y5_FrameStrobe[0] latch
XFILLER_54_0 VPWR VGND sg13cmos5l_decap_8
XFILLER_114_232 VPWR VGND sg13cmos5l_decap_8
X_2535_ _2535_/X AXIL_S_SOC_ARADDR0 AXIL_S_SOC_ARADDR6 _2585_/X _2594_/X _0934_/Q
+ _0933_/Q VPWR VGND sg13cmos5l_mux4_1
X_2466_ _2466_/X _2464_/X Tile_X0Y5_N4END[15] _2463_/X Tile_X0Y0_S4END[11] _0584_/Q
+ _0583_/Q VPWR VGND sg13cmos5l_mux4_1
XFILLER_244_77 VPWR VGND sg13cmos5l_decap_8
XFILLER_275_217 VPWR VGND sg13cmos5l_fill_1
X_1417_ _1417_/Q Tile_X0Y5_FrameData[7] VGND VPWR Tile_X0Y5_FrameStrobe[4] latch
XFILLER_87_149 VPWR VGND sg13cmos5l_decap_8
XFILLER_228_133 VPWR VGND sg13cmos5l_decap_8
X_2397_ _2397_/X _2458_/X _2457_/X AXIL_S_SOC_AWADDR2 AXIL_S_SOC_AWADDR7 _0754_/Q
+ _0753_/Q VPWR VGND sg13cmos5l_mux4_1
XFILLER_3_91 VPWR VGND sg13cmos5l_decap_8
XFILLER_260_21 VPWR VGND sg13cmos5l_decap_8
X_1348_ _1348_/Q Tile_X0Y5_FrameData[12] VGND VPWR Tile_X0Y5_FrameStrobe[2] latch
XFILLER_283_272 VPWR VGND sg13cmos5l_fill_1
X_1279_ _1279_/Q Tile_X0Y5_FrameData[17] VGND VPWR Tile_X0Y5_FrameStrobe[0] latch
XFILLER_243_147 VPWR VGND sg13cmos5l_decap_8
XFILLER_260_98 VPWR VGND sg13cmos5l_decap_8
XFILLER_11_105 VPWR VGND sg13cmos5l_decap_8
XFILLER_269_63 VPWR VGND sg13cmos5l_decap_8
XFILLER_132_7 VPWR VGND sg13cmos5l_decap_8
XFILLER_149_184 VPWR VGND sg13cmos5l_fill_2
XFILLER_22_56 VPWR VGND sg13cmos5l_decap_8
XFILLER_353_210 VPWR VGND sg13cmos5l_decap_8
XFILLER_138_56 VPWR VGND sg13cmos5l_decap_8
XFILLER_285_84 VPWR VGND sg13cmos5l_decap_8
XFILLER_98_49 VPWR VGND sg13cmos5l_decap_8
XFILLER_105_221 VPWR VGND sg13cmos5l_decap_8
XFILLER_78_105 VPWR VGND sg13cmos5l_decap_8
XFILLER_154_77 VPWR VGND sg13cmos5l_decap_8
XFILLER_304_14 VPWR VGND sg13cmos5l_decap_8
XFILLER_93_119 VPWR VGND sg13cmos5l_decap_8
XFILLER_170_21 VPWR VGND sg13cmos5l_decap_8
XFILLER_274_250 VPWR VGND sg13cmos5l_fill_2
XFILLER_47_42 VPWR VGND sg13cmos5l_decap_8
XFILLER_170_98 VPWR VGND sg13cmos5l_decap_8
XFILLER_234_147 VPWR VGND sg13cmos5l_decap_8
XFILLER_320_35 VPWR VGND sg13cmos5l_decap_8
XFILLER_103_70 VPWR VGND sg13cmos5l_decap_8
XFILLER_256_0 VPWR VGND sg13cmos5l_decap_8
XFILLER_63_63 VPWR VGND sg13cmos5l_decap_8
XFILLER_179_63 VPWR VGND sg13cmos5l_decap_8
XFILLER_8_14 VPWR VGND sg13cmos5l_decap_8
XFILLER_329_77 VPWR VGND sg13cmos5l_decap_8
XFILLER_6_131 VPWR VGND sg13cmos5l_fill_1
XFILLER_195_84 VPWR VGND sg13cmos5l_decap_8
X_0650_ _0650_/Q Tile_X0Y2_FrameData[28] VGND VPWR Tile_X0Y5_FrameStrobe[3] latch
XFILLER_345_21 VPWR VGND sg13cmos5l_decap_8
X_0581_ _0581_/Q Tile_X0Y2_FrameData[1] VGND VPWR Tile_X0Y5_FrameStrobe[0] latch
X_2320_ _2320_/X AXIL_S_SOC_WDATA7 AXIL_S_SOC_WDATA11 _2371_/X _2377_/X _0452_/Q _0451_/Q
+ VPWR VGND sg13cmos5l_mux4_1
XFILLER_69_105 VPWR VGND sg13cmos5l_decap_8
XFILLER_345_98 VPWR VGND sg13cmos5l_decap_8
XFILLER_111_224 VPWR VGND sg13cmos5l_fill_1
XFILLER_111_246 VPWR VGND sg13cmos5l_decap_4
XFILLER_214_14 VPWR VGND sg13cmos5l_decap_8
X_2251_ _2251_/X Tile_X0Y2_W2MID[6] Tile_X0Y2_W2END[6] Tile_X0Y2_W6END[6] _2482_/X
+ _0780_/Q _0779_/Q VPWR VGND sg13cmos5l_mux4_1
XFILLER_88_93 VPWR VGND sg13cmos5l_decap_8
X_1202_ _1202_/Q Tile_X0Y4_FrameData[20] VGND VPWR Tile_X0Y5_FrameStrobe[5] latch
X_2182_ _2182_/X AXIL_S_SOC_WDATA17 AXIL_S_SOC_WDATA29 _2221_/X _2247_/X _0232_/Q
+ _0231_/Q VPWR VGND sg13cmos5l_mux4_1
XFILLER_361_64 VPWR VGND sg13cmos5l_fill_1
X_1133_ _1133_/Q Tile_X0Y4_FrameData[25] VGND VPWR Tile_X0Y5_FrameStrobe[3] latch
XFILLER_92_130 VPWR VGND sg13cmos5l_decap_8
XFILLER_225_158 VPWR VGND sg13cmos5l_decap_8
XFILLER_25_208 VPWR VGND sg13cmos5l_fill_2
X_1064_ _1064_/Q Tile_X0Y4_FrameData[30] VGND VPWR Tile_X0Y5_FrameStrobe[1] latch
XFILLER_18_271 VPWR VGND sg13cmos5l_fill_2
XFILLER_230_35 VPWR VGND sg13cmos5l_decap_8
XFILLER_33_252 VPWR VGND sg13cmos5l_decap_8
XFILLER_178_257 VPWR VGND sg13cmos5l_fill_1
XFILLER_193_227 VPWR VGND sg13cmos5l_decap_4
X_1966_ Tile_X0Y1_E1BEG[3] _2292_/X VPWR VGND sg13cmos5l_buf_1
XFILLER_239_77 VPWR VGND sg13cmos5l_decap_8
X_0917_ _0917_/Q Tile_X0Y3_FrameData[1] VGND VPWR Tile_X0Y5_FrameStrobe[3] latch
XANTENNA__2104__X AXIL_S_SOC_BVALID VPWR VGND sg13cmos5l_antennanp
X_1897_ Tile_X0Y1_FrameData_O[10] Tile_X0Y1_FrameData[10] VPWR VGND sg13cmos5l_buf_1
XFILLER_255_21 VPWR VGND sg13cmos5l_decap_8
X_0848_ _0848_/Q Tile_X0Y3_FrameData[6] VGND VPWR Tile_X0Y5_FrameStrobe[1] latch
XANTENNA__1943__X Tile_X0Y1_E6BEG[8] VPWR VGND sg13cmos5l_antennanp
XFILLER_161_135 VPWR VGND sg13cmos5l_fill_2
X_0779_ _0779_/Q Tile_X0Y2_FrameData[27] VGND VPWR Tile_X0Y5_FrameStrobe[7] latch
XFILLER_102_202 VPWR VGND sg13cmos5l_decap_8
XFILLER_303_140 VPWR VGND sg13cmos5l_decap_8
X_2518_ _2518_/X AXIL_S_SOC_ARADDR1 AXIL_S_SOC_ARADDR9 _2590_/X _2595_/X _0968_/Q
+ _0967_/Q VPWR VGND sg13cmos5l_mux4_1
XFILLER_124_14 VPWR VGND sg13cmos5l_decap_8
XFILLER_271_42 VPWR VGND sg13cmos5l_decap_8
X_2449_ _2449_/X Tile_X0Y2_W1END[2] Tile_X0Y2_WW4END[10] Tile_X0Y2_WW4END[14] Tile_X0Y2_W6END[6]
+ _0628_/Q _0627_/Q VPWR VGND sg13cmos5l_mux4_1
XFILLER_17_56 VPWR VGND sg13cmos5l_decap_8
XFILLER_204_91 VPWR VGND sg13cmos5l_decap_4
XFILLER_140_35 VPWR VGND sg13cmos5l_decap_8
XFILLER_83_196 VPWR VGND sg13cmos5l_decap_4
XFILLER_169_213 VPWR VGND sg13cmos5l_decap_4
XFILLER_24_241 VPWR VGND sg13cmos5l_fill_1
XFILLER_33_22 VPWR VGND sg13cmos5l_decap_8
XFILLER_169_268 VPWR VGND sg13cmos5l_fill_1
XFILLER_149_77 VPWR VGND sg13cmos5l_fill_1
XFILLER_33_99 VPWR VGND sg13cmos5l_decap_8
XFILLER_137_154 VPWR VGND sg13cmos5l_fill_2
XFILLER_149_99 VPWR VGND sg13cmos5l_decap_8
XANTENNA__2014__X Tile_X0Y5_EE4BEG[15] VPWR VGND sg13cmos5l_antennanp
XFILLER_192_271 VPWR VGND sg13cmos5l_fill_2
XFILLER_152_146 VPWR VGND sg13cmos5l_decap_8
XFILLER_165_43 VPWR VGND sg13cmos5l_decap_8
XFILLER_3_112 VPWR VGND sg13cmos5l_decap_8
XANTENNA__1853__X Tile_X0Y4_FrameData_O[20] VPWR VGND sg13cmos5l_antennanp
XFILLER_152_179 VPWR VGND sg13cmos5l_decap_8
XFILLER_3_156 VPWR VGND sg13cmos5l_decap_8
XFILLER_239_217 VPWR VGND sg13cmos5l_decap_4
XFILLER_315_35 VPWR VGND sg13cmos5l_decap_8
XFILLER_181_42 VPWR VGND sg13cmos5l_decap_8
XFILLER_239_239 VPWR VGND sg13cmos5l_decap_8
XFILLER_58_63 VPWR VGND sg13cmos5l_decap_8
XFILLER_66_119 VPWR VGND sg13cmos5l_decap_8
XFILLER_59_182 VPWR VGND sg13cmos5l_decap_8
XFILLER_207_114 VPWR VGND sg13cmos5l_decap_8
XFILLER_74_130 VPWR VGND sg13cmos5l_fill_2
XFILLER_114_91 VPWR VGND sg13cmos5l_decap_8
XFILLER_331_56 VPWR VGND sg13cmos5l_decap_8
XFILLER_74_174 VPWR VGND sg13cmos5l_fill_2
XFILLER_74_84 VPWR VGND sg13cmos5l_decap_8
XFILLER_215_191 VPWR VGND sg13cmos5l_fill_1
XFILLER_200_49 VPWR VGND sg13cmos5l_decap_8
XFILLER_95_7 VPWR VGND sg13cmos5l_decap_8
X_1820_ Tile_X0Y4_EE4BEG[3] _2636_/X VPWR VGND sg13cmos5l_buf_1
XFILLER_90_50 VPWR VGND sg13cmos5l_decap_8
XFILLER_128_132 VPWR VGND sg13cmos5l_decap_8
XFILLER_128_143 VPWR VGND sg13cmos5l_fill_1
XFILLER_209_14 VPWR VGND sg13cmos5l_decap_8
X_1751_ Tile_X0Y2_FrameData_O[11] Tile_X0Y2_FrameData[11] VPWR VGND sg13cmos5l_buf_1
X_1682_ Tile_X0Y0_FrameData_O[22] Tile_X0Y0_FrameData[22] VPWR VGND sg13cmos5l_buf_1
X_0702_ _0702_/Q Tile_X0Y2_FrameData[8] VGND VPWR Tile_X0Y5_FrameStrobe[4] latch
XFILLER_356_42 VPWR VGND sg13cmos5l_decap_8
XFILLER_143_146 VPWR VGND sg13cmos5l_decap_8
X_0633_ _0633_/Q Tile_X0Y2_FrameData[13] VGND VPWR Tile_X0Y5_FrameStrobe[2] latch
XFILLER_99_70 VPWR VGND sg13cmos5l_decap_8
XANTENNA__1763__X Tile_X0Y2_FrameData_O[23] VPWR VGND sg13cmos5l_antennanp
XFILLER_225_35 VPWR VGND sg13cmos5l_decap_8
XFILLER_297_161 VPWR VGND sg13cmos5l_decap_8
X_2303_ _2303_/X AXIL_S_SOC_WDATA2 AXIL_S_SOC_WDATA10 _2375_/X _2378_/X _0486_/Q _0485_/Q
+ VPWR VGND sg13cmos5l_mux4_1
X_0564_ _0564_/Q Tile_X0Y2_FrameData[18] VGND VPWR Tile_X0Y5_FrameStrobe[0] latch
XFILLER_97_222 VPWR VGND sg13cmos5l_decap_8
X_0495_ _0495_/Q Tile_X0Y1_FrameData[7] VGND VPWR Tile_X0Y5_FrameStrobe[5] latch
XFILLER_300_154 VPWR VGND sg13cmos5l_decap_8
X_2234_ _2234_/X _2215_/X _0064_/X Tile_X0Y0_S1END[2] Tile_X0Y0_S4END[2] _0114_/Q
+ _0113_/Q VPWR VGND sg13cmos5l_mux4_1
XFILLER_57_119 VPWR VGND sg13cmos5l_decap_8
XFILLER_17_0 VPWR VGND sg13cmos5l_decap_8
X_2165_ _2165_/X AXIL_S_SOC_WDATA16 AXIL_S_SOC_WDATA24 _2241_/X _2248_/X _0266_/Q
+ _0265_/Q VPWR VGND sg13cmos5l_mux4_1
XFILLER_241_56 VPWR VGND sg13cmos5l_decap_8
X_1116_ _1116_/Q Tile_X0Y4_FrameData[10] VGND VPWR Tile_X0Y5_FrameStrobe[2] latch
XFILLER_0_70 VPWR VGND sg13cmos5l_decap_8
X_2096_ Tile_X0Y3_E2BEGb[0] _2517_/X VPWR VGND sg13cmos5l_buf_1
XFILLER_80_122 VPWR VGND sg13cmos5l_fill_2
X_1047_ _1047_/Q Tile_X0Y4_FrameData[15] VGND VPWR Tile_X0Y5_FrameStrobe[0] latch
XFILLER_110_49 VPWR VGND sg13cmos5l_decap_8
XANTENNA__1938__X Tile_X0Y1_E6BEG[3] VPWR VGND sg13cmos5l_antennanp
XFILLER_21_255 VPWR VGND sg13cmos5l_fill_1
XFILLER_119_14 VPWR VGND sg13cmos5l_decap_8
XFILLER_119_154 VPWR VGND sg13cmos5l_decap_8
X_1949_ Tile_X0Y1_E2BEGb[2] _2303_/X VPWR VGND sg13cmos5l_buf_1
XFILLER_174_271 VPWR VGND sg13cmos5l_fill_2
XFILLER_266_42 VPWR VGND sg13cmos5l_decap_8
XFILLER_134_135 VPWR VGND sg13cmos5l_fill_1
XANTENNA__1673__X Tile_X0Y0_FrameData_O[13] VPWR VGND sg13cmos5l_antennanp
XFILLER_0_126 VPWR VGND sg13cmos5l_fill_1
XFILLER_135_35 VPWR VGND sg13cmos5l_decap_8
XFILLER_288_161 VPWR VGND sg13cmos5l_decap_8
XFILLER_0_137 VPWR VGND sg13cmos5l_fill_1
XFILLER_282_63 VPWR VGND sg13cmos5l_decap_8
XFILLER_297_7 VPWR VGND sg13cmos5l_decap_8
XFILLER_95_28 VPWR VGND sg13cmos5l_decap_8
XFILLER_229_272 VPWR VGND sg13cmos5l_fill_1
XFILLER_151_56 VPWR VGND sg13cmos5l_decap_8
XFILLER_28_77 VPWR VGND sg13cmos5l_decap_8
XFILLER_56_196 VPWR VGND sg13cmos5l_decap_8
XANTENNA__2009__X Tile_X0Y5_EE4BEG[10] VPWR VGND sg13cmos5l_antennanp
XFILLER_44_32 VPWR VGND sg13cmos5l_decap_8
XFILLER_71_199 VPWR VGND sg13cmos5l_decap_8
XANTENNA__1848__X Tile_X0Y4_FrameData_O[15] VPWR VGND sg13cmos5l_antennanp
XFILLER_12_222 VPWR VGND sg13cmos5l_fill_1
XFILLER_157_205 VPWR VGND sg13cmos5l_decap_8
XFILLER_358_154 VPWR VGND sg13cmos5l_decap_8
XFILLER_157_238 VPWR VGND sg13cmos5l_decap_4
XFILLER_121_0 VPWR VGND sg13cmos5l_decap_8
XFILLER_60_42 VPWR VGND sg13cmos5l_decap_8
XFILLER_176_42 VPWR VGND sg13cmos5l_decap_8
XFILLER_219_0 VPWR VGND sg13cmos5l_decap_8
XANTENNA__1583__X Tile_X0Y3_FrameData_O[29] VPWR VGND sg13cmos5l_antennanp
XFILLER_109_91 VPWR VGND sg13cmos5l_decap_8
XFILLER_180_252 VPWR VGND sg13cmos5l_fill_1
XFILLER_326_56 VPWR VGND sg13cmos5l_decap_8
XFILLER_140_149 VPWR VGND sg13cmos5l_fill_2
XFILLER_69_84 VPWR VGND sg13cmos5l_decap_8
XFILLER_192_63 VPWR VGND sg13cmos5l_decap_8
XFILLER_79_255 VPWR VGND sg13cmos5l_fill_1
X_0280_ _0280_/Q Tile_X0Y0_FrameData[14] VGND VPWR Tile_X0Y5_FrameStrobe[6] latch
XFILLER_39_119 VPWR VGND sg13cmos5l_decap_8
XFILLER_342_22 VPWR VGND sg13cmos5l_decap_8
XFILLER_10_7 VPWR VGND sg13cmos5l_decap_8
XFILLER_294_175 VPWR VGND sg13cmos5l_decap_8
XFILLER_94_247 VPWR VGND sg13cmos5l_decap_8
XFILLER_85_50 VPWR VGND sg13cmos5l_decap_8
XFILLER_47_152 VPWR VGND sg13cmos5l_decap_8
XFILLER_342_99 VPWR VGND sg13cmos5l_decap_8
XFILLER_62_133 VPWR VGND sg13cmos5l_decap_8
XFILLER_250_256 VPWR VGND sg13cmos5l_fill_1
XFILLER_62_199 VPWR VGND sg13cmos5l_decap_8
XFILLER_62_188 VPWR VGND sg13cmos5l_decap_4
XANTENNA__1758__X Tile_X0Y2_FrameData_O[18] VPWR VGND sg13cmos5l_antennanp
XFILLER_203_161 VPWR VGND sg13cmos5l_decap_8
XFILLER_349_154 VPWR VGND sg13cmos5l_decap_8
XFILLER_148_249 VPWR VGND sg13cmos5l_decap_8
X_1803_ Tile_X0Y4_E2BEGb[6] _2631_/X VPWR VGND sg13cmos5l_buf_1
X_2783_ _2783_/X Tile_X0Y5_W1END[1] Tile_X0Y5_WW4END[11] Tile_X0Y5_WW4END[13] Tile_X0Y5_W6END[5]
+ _1337_/Q _1336_/Q VPWR VGND sg13cmos5l_mux4_1
XFILLER_156_271 VPWR VGND sg13cmos5l_fill_2
X_1734_ Tile_X0Y0_E2BEG[6] _2171_/X VPWR VGND sg13cmos5l_buf_1
XFILLER_305_235 VPWR VGND sg13cmos5l_fill_2
XFILLER_116_168 VPWR VGND sg13cmos5l_decap_8
XFILLER_131_105 VPWR VGND sg13cmos5l_decap_8
XFILLER_171_241 VPWR VGND sg13cmos5l_decap_8
XFILLER_236_56 VPWR VGND sg13cmos5l_decap_8
XFILLER_305_257 VPWR VGND sg13cmos5l_fill_2
XFILLER_305_268 VPWR VGND sg13cmos5l_fill_2
X_1665_ Tile_X0Y0_FrameData_O[5] Tile_X0Y0_FrameData[5] VPWR VGND sg13cmos5l_buf_1
X_1596_ Tile_X0Y2_EE4BEG[9] _2426_/X VPWR VGND sg13cmos5l_buf_1
X_0616_ _0616_/Q Tile_X0Y2_FrameData[30] VGND VPWR Tile_X0Y5_FrameStrobe[2] latch
X_0547_ _0547_/Q Tile_X0Y1_FrameData[19] VGND VPWR Tile_X0Y5_FrameStrobe[7] latch
XFILLER_105_49 VPWR VGND sg13cmos5l_decap_8
XFILLER_252_77 VPWR VGND sg13cmos5l_decap_8
X_2217_ _2217_/X _2216_/X _0065_/X Tile_X0Y0_S1END[3] Tile_X0Y0_S4END[3] _0096_/Q
+ _0095_/Q VPWR VGND sg13cmos5l_mux4_1
X_0478_ _0478_/Q Tile_X0Y1_FrameData[24] VGND VPWR Tile_X0Y5_FrameStrobe[5] latch
XFILLER_85_269 VPWR VGND sg13cmos5l_decap_4
XFILLER_38_163 VPWR VGND sg13cmos5l_decap_4
X_2148_ _2148_/X Tile_X0Y0_W2MID[4] Tile_X0Y0_W2END[4] Tile_X0Y0_W6END[4] _2244_/X
+ _0296_/Q _0295_/Q VPWR VGND sg13cmos5l_mux4_1
XFILLER_198_105 VPWR VGND sg13cmos5l_decap_8
X_2079_ Tile_X0Y5_S4BEG[12] _2079_/A VPWR VGND sg13cmos5l_buf_1
XFILLER_53_133 VPWR VGND sg13cmos5l_decap_8
XANTENNA__1668__X Tile_X0Y0_FrameData_O[8] VPWR VGND sg13cmos5l_antennanp
XFILLER_14_35 VPWR VGND sg13cmos5l_decap_8
XFILLER_201_70 VPWR VGND sg13cmos5l_decap_8
XFILLER_277_63 VPWR VGND sg13cmos5l_decap_8
XFILLER_154_219 VPWR VGND sg13cmos5l_decap_8
XFILLER_212_7 VPWR VGND sg13cmos5l_decap_8
XFILLER_355_168 VPWR VGND sg13cmos5l_decap_8
XFILLER_30_56 VPWR VGND sg13cmos5l_decap_8
XFILLER_122_105 VPWR VGND sg13cmos5l_decap_8
XFILLER_146_56 VPWR VGND sg13cmos5l_decap_8
XFILLER_293_84 VPWR VGND sg13cmos5l_decap_8
XFILLER_39_21 VPWR VGND sg13cmos5l_decap_8
XFILLER_130_193 VPWR VGND sg13cmos5l_decap_8
XFILLER_162_77 VPWR VGND sg13cmos5l_decap_8
XFILLER_291_112 VPWR VGND sg13cmos5l_decap_8
XFILLER_39_98 VPWR VGND sg13cmos5l_decap_8
XFILLER_312_14 VPWR VGND sg13cmos5l_decap_8
XFILLER_29_185 VPWR VGND sg13cmos5l_decap_4
XFILLER_91_239 VPWR VGND sg13cmos5l_decap_8
XFILLER_55_42 VPWR VGND sg13cmos5l_decap_8
XFILLER_169_0 VPWR VGND sg13cmos5l_decap_8
XFILLER_189_105 VPWR VGND sg13cmos5l_fill_2
XFILLER_44_155 VPWR VGND sg13cmos5l_decap_8
XFILLER_44_144 VPWR VGND sg13cmos5l_fill_1
XANTENNA__1578__X Tile_X0Y3_FrameData_O[24] VPWR VGND sg13cmos5l_antennanp
XFILLER_111_70 VPWR VGND sg13cmos5l_decap_8
XFILLER_336_0 VPWR VGND sg13cmos5l_decap_8
XFILLER_71_63 VPWR VGND sg13cmos5l_decap_8
XFILLER_187_63 VPWR VGND sg13cmos5l_decap_8
XFILLER_138_271 VPWR VGND sg13cmos5l_fill_2
XFILLER_145_208 VPWR VGND sg13cmos5l_decap_8
XFILLER_299_245 VPWR VGND sg13cmos5l_decap_8
XFILLER_58_7 VPWR VGND sg13cmos5l_decap_8
XFILLER_337_77 VPWR VGND sg13cmos5l_decap_8
XFILLER_113_105 VPWR VGND sg13cmos5l_decap_8
X_1450_ _1450_/Q Tile_X0Y5_FrameData[6] VGND VPWR Tile_X0Y5_FrameStrobe[5] latch
XFILLER_353_21 VPWR VGND sg13cmos5l_decap_8
X_1381_ _1381_/Q Tile_X0Y5_FrameData[11] VGND VPWR Tile_X0Y5_FrameStrobe[3] latch
X_0401_ _0401_/Q Tile_X0Y1_FrameData[5] VGND VPWR Tile_X0Y5_FrameStrobe[2] latch
XFILLER_121_160 VPWR VGND sg13cmos5l_decap_8
X_0332_ _0332_/Q Tile_X0Y1_FrameData[10] VGND VPWR Tile_X0Y5_FrameStrobe[0] latch
XFILLER_282_112 VPWR VGND sg13cmos5l_decap_8
XFILLER_353_98 VPWR VGND sg13cmos5l_decap_8
XFILLER_222_14 VPWR VGND sg13cmos5l_decap_8
X_0263_ _0263_/Q Tile_X0Y0_FrameData[31] VGND VPWR Tile_X0Y5_FrameStrobe[6] latch
XFILLER_208_264 VPWR VGND sg13cmos5l_fill_1
X_2002_ Tile_X0Y5_EE4BEG[3] _2744_/X VPWR VGND sg13cmos5l_buf_1
X_0194_ _0194_/Q Tile_X0Y0_FrameData[4] VGND VPWR Tile_X0Y5_FrameStrobe[3] latch
XFILLER_35_155 VPWR VGND sg13cmos5l_fill_2
XFILLER_223_245 VPWR VGND sg13cmos5l_decap_8
XFILLER_302_91 VPWR VGND sg13cmos5l_decap_8
XFILLER_90_272 VPWR VGND sg13cmos5l_fill_1
XFILLER_50_147 VPWR VGND sg13cmos5l_decap_8
XFILLER_35_199 VPWR VGND sg13cmos5l_decap_8
XFILLER_188_182 VPWR VGND sg13cmos5l_fill_1
X_2835_ _2835_/X Tile_X0Y4_W1END[2] Tile_X0Y4_W2MID[1] Tile_X0Y4_W2END[1] _2682_/X
+ _1112_/Q _1111_/Q VPWR VGND sg13cmos5l_mux4_1
XFILLER_84_0 VPWR VGND sg13cmos5l_decap_8
XFILLER_129_260 VPWR VGND sg13cmos5l_fill_1
XFILLER_129_271 VPWR VGND sg13cmos5l_fill_2
XFILLER_352_105 VPWR VGND sg13cmos5l_decap_8
X_2766_ _2766_/X AXIL_S_SOC_ARPROT1 _2820_/X _2818_/X _2799_/X _1370_/Q _1369_/Q VPWR
+ VGND sg13cmos5l_mux4_1
XFILLER_247_77 VPWR VGND sg13cmos5l_decap_8
X_1717_ Tile_X0Y0_E6BEG[9] _2206_/X VPWR VGND sg13cmos5l_buf_1
X_2697_ _2697_/X _2674_/X Tile_X0Y5_N4END[4] _2673_/X _0039_/X _1070_/Q _1069_/Q VPWR
+ VGND sg13cmos5l_mux4_1
XANTENNA__2112__X AXIL_S_SOC_RDATA6 VPWR VGND sg13cmos5l_antennanp
XFILLER_104_127 VPWR VGND sg13cmos5l_decap_8
X_1648_ Tile_X0Y0_FrameStrobe_O[8] Tile_X0Y5_FrameStrobe[8] VPWR VGND sg13cmos5l_buf_1
XFILLER_6_91 VPWR VGND sg13cmos5l_decap_8
XFILLER_263_21 VPWR VGND sg13cmos5l_decap_8
XANTENNA__1951__X Tile_X0Y1_E2BEGb[4] VPWR VGND sg13cmos5l_antennanp
X_1579_ Tile_X0Y3_FrameData_O[25] Tile_X0Y3_FrameData[25] VPWR VGND sg13cmos5l_buf_1
XFILLER_263_98 VPWR VGND sg13cmos5l_decap_8
XFILLER_301_271 VPWR VGND sg13cmos5l_fill_2
XFILLER_132_14 VPWR VGND sg13cmos5l_decap_8
XFILLER_162_7 VPWR VGND sg13cmos5l_decap_8
XFILLER_25_56 VPWR VGND sg13cmos5l_decap_8
XFILLER_179_182 VPWR VGND sg13cmos5l_decap_8
XFILLER_186_119 VPWR VGND sg13cmos5l_decap_8
XFILLER_288_84 VPWR VGND sg13cmos5l_decap_8
XFILLER_41_169 VPWR VGND sg13cmos5l_fill_1
XFILLER_41_158 VPWR VGND sg13cmos5l_decap_8
XFILLER_194_141 VPWR VGND sg13cmos5l_decap_4
XFILLER_41_11 VPWR VGND sg13cmos5l_decap_8
XFILLER_343_105 VPWR VGND sg13cmos5l_decap_8
XFILLER_41_88 VPWR VGND sg13cmos5l_decap_8
XFILLER_157_77 VPWR VGND sg13cmos5l_decap_8
XFILLER_307_14 VPWR VGND sg13cmos5l_decap_8
XANTENNA__2022__X Tile_X0Y5_FrameData_O[7] VPWR VGND sg13cmos5l_antennanp
XFILLER_173_21 VPWR VGND sg13cmos5l_decap_8
XFILLER_1_221 VPWR VGND sg13cmos5l_fill_2
XFILLER_351_182 VPWR VGND sg13cmos5l_decap_8
XANTENNA__1861__X Tile_X0Y4_FrameData_O[28] VPWR VGND sg13cmos5l_antennanp
XFILLER_103_160 VPWR VGND sg13cmos5l_decap_8
XFILLER_110_119 VPWR VGND sg13cmos5l_decap_8
XFILLER_49_203 VPWR VGND sg13cmos5l_decap_8
XFILLER_103_171 VPWR VGND sg13cmos5l_fill_1
XFILLER_106_70 VPWR VGND sg13cmos5l_decap_8
XFILLER_173_98 VPWR VGND sg13cmos5l_decap_8
XFILLER_2_49 VPWR VGND sg13cmos5l_decap_8
XFILLER_323_35 VPWR VGND sg13cmos5l_decap_8
XFILLER_264_123 VPWR VGND sg13cmos5l_decap_8
XFILLER_286_0 VPWR VGND sg13cmos5l_decap_4
XFILLER_66_63 VPWR VGND sg13cmos5l_decap_8
XFILLER_64_239 VPWR VGND sg13cmos5l_fill_1
XFILLER_64_228 VPWR VGND sg13cmos5l_decap_8
XFILLER_17_133 VPWR VGND sg13cmos5l_decap_8
XFILLER_122_91 VPWR VGND sg13cmos5l_decap_8
XFILLER_17_177 VPWR VGND sg13cmos5l_decap_4
XFILLER_32_114 VPWR VGND sg13cmos5l_fill_1
XFILLER_82_84 VPWR VGND sg13cmos5l_decap_8
XFILLER_177_119 VPWR VGND sg13cmos5l_decap_8
XFILLER_198_84 VPWR VGND sg13cmos5l_decap_8
XFILLER_220_226 VPWR VGND sg13cmos5l_decap_8
X_0950_ _0950_/Q Tile_X0Y3_FrameData[0] VGND VPWR Tile_X0Y5_FrameStrobe[4] latch
XFILLER_359_271 VPWR VGND sg13cmos5l_fill_2
XFILLER_348_21 VPWR VGND sg13cmos5l_decap_8
XFILLER_118_219 VPWR VGND sg13cmos5l_fill_1
X_2620_ _2620_/X AXIL_S_SOC_WSTRB3 AXIL_S_SOC_BREADY _2711_/X _2712_/X _1214_/Q _1213_/Q
+ VPWR VGND sg13cmos5l_mux4_1
X_0881_ _0881_/Q Tile_X0Y3_FrameData[5] VGND VPWR Tile_X0Y5_FrameStrobe[2] latch
XFILLER_348_98 VPWR VGND sg13cmos5l_decap_8
XFILLER_217_14 VPWR VGND sg13cmos5l_decap_8
X_2551_ _2551_/X AXIL_S_SOC_ARADDR2 _2586_/X _2585_/X _2595_/X _0902_/Q _0901_/Q VPWR
+ VGND sg13cmos5l_mux4_1
XFILLER_141_211 VPWR VGND sg13cmos5l_fill_2
X_1502_ _2670_/A3 VPWR VGND sg13cmos5l_tielo
X_2482_ _2482_/X _2384_/X _2492_/X _2491_/X _2383_/X _0572_/Q _0571_/Q VPWR VGND sg13cmos5l_mux4_1
XFILLER_287_237 VPWR VGND sg13cmos5l_fill_1
X_1433_ _1433_/Q Tile_X0Y5_FrameData[23] VGND VPWR Tile_X0Y5_FrameStrobe[5] latch
XFILLER_99_169 VPWR VGND sg13cmos5l_decap_8
XFILLER_99_147 VPWR VGND sg13cmos5l_fill_1
XANTENNA__1771__X Tile_X0Y2_FrameData_O[31] VPWR VGND sg13cmos5l_antennanp
XFILLER_101_119 VPWR VGND sg13cmos5l_decap_8
XFILLER_233_35 VPWR VGND sg13cmos5l_decap_8
X_1364_ _1364_/Q Tile_X0Y5_FrameData[28] VGND VPWR Tile_X0Y5_FrameStrobe[3] latch
X_1295_ _1295_/Q Tile_X0Y5_FrameData[1] VGND VPWR Tile_X0Y5_FrameStrobe[0] latch
X_0315_ _0315_/Q Tile_X0Y1_FrameData[27] VGND VPWR Tile_X0Y5_FrameStrobe[0] latch
XFILLER_270_104 VPWR VGND sg13cmos5l_fill_1
X_0246_ _0246_/Q Tile_X0Y0_FrameData[16] VGND VPWR Tile_X0Y5_FrameStrobe[5] latch
XFILLER_55_217 VPWR VGND sg13cmos5l_decap_8
XFILLER_102_28 VPWR VGND sg13cmos5l_decap_8
XFILLER_270_126 VPWR VGND sg13cmos5l_fill_1
XFILLER_70_209 VPWR VGND sg13cmos5l_decap_8
XFILLER_270_148 VPWR VGND sg13cmos5l_fill_2
XFILLER_270_159 VPWR VGND sg13cmos5l_fill_1
X_0177_ _0177_/Q Tile_X0Y0_FrameData[21] VGND VPWR Tile_X0Y5_FrameStrobe[3] latch
XANTENNA__2107__X AXIL_S_SOC_RDATA1 VPWR VGND sg13cmos5l_antennanp
XFILLER_168_119 VPWR VGND sg13cmos5l_fill_2
XFILLER_258_21 VPWR VGND sg13cmos5l_decap_8
XANTENNA__1946__X Tile_X0Y1_E6BEG[11] VPWR VGND sg13cmos5l_antennanp
XFILLER_325_105 VPWR VGND sg13cmos5l_decap_8
XFILLER_11_14 VPWR VGND sg13cmos5l_decap_8
XFILLER_258_98 VPWR VGND sg13cmos5l_decap_8
X_2818_ _2818_/X Tile_X0Y5_N1END[2] Tile_X0Y5_N4END[2] _2795_/X _0058_/X _1308_/Q
+ _1307_/Q VPWR VGND sg13cmos5l_mux4_1
XFILLER_117_252 VPWR VGND sg13cmos5l_decap_4
XFILLER_127_14 VPWR VGND sg13cmos5l_decap_8
X_2749_ _2749_/X AXIL_S_SOC_ARVALID AXIL_S_SOC_RREADY _2817_/X _2797_/X _1404_/Q _1403_/Q
+ VPWR VGND sg13cmos5l_mux4_1
XFILLER_274_42 VPWR VGND sg13cmos5l_decap_8
XFILLER_340_119 VPWR VGND sg13cmos5l_decap_8
XANTENNA__1681__X Tile_X0Y0_FrameData_O[21] VPWR VGND sg13cmos5l_antennanp
XFILLER_143_35 VPWR VGND sg13cmos5l_decap_8
XFILLER_293_207 VPWR VGND sg13cmos5l_decap_4
XFILLER_246_112 VPWR VGND sg13cmos5l_decap_8
XFILLER_290_63 VPWR VGND sg13cmos5l_decap_8
XFILLER_100_163 VPWR VGND sg13cmos5l_fill_2
XFILLER_46_217 VPWR VGND sg13cmos5l_decap_8
XFILLER_261_148 VPWR VGND sg13cmos5l_decap_8
XFILLER_36_77 VPWR VGND sg13cmos5l_decap_8
XANTENNA__2017__X Tile_X0Y5_FrameData_O[2] VPWR VGND sg13cmos5l_antennanp
XFILLER_14_147 VPWR VGND sg13cmos5l_decap_8
XFILLER_14_169 VPWR VGND sg13cmos5l_fill_2
XFILLER_52_21 VPWR VGND sg13cmos5l_decap_8
XFILLER_168_21 VPWR VGND sg13cmos5l_decap_8
XFILLER_202_259 VPWR VGND sg13cmos5l_fill_2
XANTENNA__1856__X Tile_X0Y4_FrameData_O[23] VPWR VGND sg13cmos5l_antennanp
XFILLER_22_180 VPWR VGND sg13cmos5l_decap_8
XFILLER_52_98 VPWR VGND sg13cmos5l_decap_8
XFILLER_356_263 VPWR VGND sg13cmos5l_fill_2
XFILLER_356_252 VPWR VGND sg13cmos5l_decap_4
XFILLER_168_98 VPWR VGND sg13cmos5l_decap_8
XFILLER_182_133 VPWR VGND sg13cmos5l_decap_8
XFILLER_316_105 VPWR VGND sg13cmos5l_decap_8
XFILLER_318_35 VPWR VGND sg13cmos5l_decap_8
XFILLER_182_188 VPWR VGND sg13cmos5l_fill_2
XFILLER_184_42 VPWR VGND sg13cmos5l_decap_8
XFILLER_201_0 VPWR VGND sg13cmos5l_decap_8
XANTENNA__1591__X Tile_X0Y2_EE4BEG[4] VPWR VGND sg13cmos5l_antennanp
XFILLER_334_56 VPWR VGND sg13cmos5l_decap_8
XFILLER_117_91 VPWR VGND sg13cmos5l_decap_8
XFILLER_284_229 VPWR VGND sg13cmos5l_decap_4
XFILLER_237_112 VPWR VGND sg13cmos5l_decap_8
XFILLER_77_84 VPWR VGND sg13cmos5l_decap_8
X_0100_ _0100_/Q Tile_X0Y0_FrameData[2] VGND VPWR Tile_X0Y5_FrameStrobe[0] latch
XFILLER_203_49 VPWR VGND sg13cmos5l_decap_8
XFILLER_237_189 VPWR VGND sg13cmos5l_decap_8
X_1080_ _1080_/Q Tile_X0Y4_FrameData[14] VGND VPWR Tile_X0Y5_FrameStrobe[1] latch
X_0031_ _0031_/X _2355_/X _2356_/X _1467_/Q VPWR VGND sg13cmos5l_mux2_1
XFILLER_45_272 VPWR VGND sg13cmos5l_fill_1
XFILLER_350_77 VPWR VGND sg13cmos5l_decap_8
XANTENNA_260 AXIL_S_SOC_WDATA22 VPWR VGND sg13cmos5l_antennanp
XFILLER_60_231 VPWR VGND sg13cmos5l_fill_1
XFILLER_60_220 VPWR VGND sg13cmos5l_decap_8
XANTENNA_271 AXIL_S_SOC_WDATA22 VPWR VGND sg13cmos5l_antennanp
XANTENNA_282 AXIL_S_SOC_WDATA22 VPWR VGND sg13cmos5l_antennanp
XANTENNA_293 AXIL_S_SOC_WDATA19 VPWR VGND sg13cmos5l_antennanp
XFILLER_359_42 VPWR VGND sg13cmos5l_decap_8
X_1982_ Tile_X0Y5_E2BEGb[3] _2736_/X VPWR VGND sg13cmos5l_buf_1
XANTENNA__1766__X Tile_X0Y2_FrameData_O[26] VPWR VGND sg13cmos5l_antennanp
X_0933_ _0933_/Q Tile_X0Y3_FrameData[17] VGND VPWR Tile_X0Y5_FrameStrobe[4] latch
XFILLER_9_140 VPWR VGND sg13cmos5l_decap_8
XFILLER_347_252 VPWR VGND sg13cmos5l_decap_8
XFILLER_173_133 VPWR VGND sg13cmos5l_decap_8
XFILLER_228_35 VPWR VGND sg13cmos5l_decap_8
XFILLER_307_105 VPWR VGND sg13cmos5l_decap_8
X_0864_ _0864_/Q Tile_X0Y3_FrameData[22] VGND VPWR Tile_X0Y5_FrameStrobe[2] latch
X_2603_ _2603_/X Tile_X0Y2_W2MID[4] Tile_X0Y2_W2END[4] Tile_X0Y2_W6END[11] _2484_/X
+ _0644_/Q _0643_/Q VPWR VGND sg13cmos5l_mux4_1
XFILLER_173_199 VPWR VGND sg13cmos5l_decap_8
XFILLER_322_119 VPWR VGND sg13cmos5l_fill_1
X_2534_ _2534_/X AXIL_S_SOC_ARADDR5 AXIL_S_SOC_ARADDR9 _2582_/X _2595_/X _0936_/Q
+ _0935_/Q VPWR VGND sg13cmos5l_mux4_1
X_0795_ _0795_/Q Tile_X0Y3_FrameData[27] VGND VPWR Tile_X0Y5_FrameStrobe[0] latch
XFILLER_47_0 VPWR VGND sg13cmos5l_fill_2
X_2465_ _2465_/X _2464_/X Tile_X0Y5_N4END[15] _2463_/X Tile_X0Y0_S4END[11] _0576_/Q
+ _0575_/Q VPWR VGND sg13cmos5l_mux4_1
XFILLER_244_56 VPWR VGND sg13cmos5l_decap_8
X_1416_ _1416_/Q Tile_X0Y5_FrameData[8] VGND VPWR Tile_X0Y5_FrameStrobe[4] latch
X_2396_ _2396_/X Tile_X0Y3_W2MID[0] Tile_X0Y3_W2END[0] Tile_X0Y3_W6END[0] _2596_/X
+ _1008_/Q _1007_/Q VPWR VGND sg13cmos5l_mux4_1
XFILLER_87_128 VPWR VGND sg13cmos5l_fill_2
XFILLER_228_112 VPWR VGND sg13cmos5l_decap_8
X_1347_ _1347_/Q Tile_X0Y5_FrameData[13] VGND VPWR Tile_X0Y5_FrameStrobe[2] latch
XFILLER_3_70 VPWR VGND sg13cmos5l_decap_8
XFILLER_95_172 VPWR VGND sg13cmos5l_fill_1
XFILLER_113_49 VPWR VGND sg13cmos5l_decap_8
XFILLER_243_126 VPWR VGND sg13cmos5l_decap_8
X_1278_ _1278_/Q Tile_X0Y5_FrameData[18] VGND VPWR Tile_X0Y5_FrameStrobe[0] latch
XFILLER_260_77 VPWR VGND sg13cmos5l_decap_8
X_0229_ _0229_/Q Tile_X0Y0_FrameData[1] VGND VPWR Tile_X0Y5_FrameStrobe[4] latch
XFILLER_196_225 VPWR VGND sg13cmos5l_decap_8
XFILLER_269_42 VPWR VGND sg13cmos5l_decap_8
XFILLER_51_264 VPWR VGND sg13cmos5l_fill_1
XFILLER_51_242 VPWR VGND sg13cmos5l_decap_8
XANTENNA__1676__X Tile_X0Y0_FrameData_O[16] VPWR VGND sg13cmos5l_antennanp
XFILLER_125_7 VPWR VGND sg13cmos5l_decap_8
XFILLER_22_35 VPWR VGND sg13cmos5l_decap_8
XFILLER_138_35 VPWR VGND sg13cmos5l_decap_8
XFILLER_285_63 VPWR VGND sg13cmos5l_decap_8
XFILLER_313_119 VPWR VGND sg13cmos5l_decap_8
XFILLER_98_28 VPWR VGND sg13cmos5l_decap_8
XFILLER_321_141 VPWR VGND sg13cmos5l_decap_4
XFILLER_321_152 VPWR VGND sg13cmos5l_decap_4
XFILLER_120_236 VPWR VGND sg13cmos5l_decap_8
XFILLER_154_56 VPWR VGND sg13cmos5l_decap_8
XFILLER_47_21 VPWR VGND sg13cmos5l_decap_8
XFILLER_219_156 VPWR VGND sg13cmos5l_fill_1
XFILLER_234_126 VPWR VGND sg13cmos5l_decap_8
XFILLER_47_98 VPWR VGND sg13cmos5l_decap_8
XFILLER_170_77 VPWR VGND sg13cmos5l_decap_8
XFILLER_320_14 VPWR VGND sg13cmos5l_decap_8
XFILLER_63_42 VPWR VGND sg13cmos5l_decap_8
XFILLER_151_0 VPWR VGND sg13cmos5l_decap_8
XFILLER_179_42 VPWR VGND sg13cmos5l_decap_8
XFILLER_249_0 VPWR VGND sg13cmos5l_decap_8
XFILLER_42_242 VPWR VGND sg13cmos5l_fill_1
XFILLER_42_231 VPWR VGND sg13cmos5l_decap_8
XANTENNA__1586__X Tile_X0Y3_UserCLKo VPWR VGND sg13cmos5l_antennanp
XFILLER_329_56 VPWR VGND sg13cmos5l_decap_8
XFILLER_344_222 VPWR VGND sg13cmos5l_decap_8
XFILLER_10_183 VPWR VGND sg13cmos5l_decap_4
XFILLER_195_63 VPWR VGND sg13cmos5l_decap_8
XFILLER_344_233 VPWR VGND sg13cmos5l_decap_8
XFILLER_304_119 VPWR VGND sg13cmos5l_decap_8
XFILLER_6_154 VPWR VGND sg13cmos5l_fill_1
XFILLER_170_147 VPWR VGND sg13cmos5l_decap_8
X_0580_ _0580_/Q Tile_X0Y2_FrameData[2] VGND VPWR Tile_X0Y5_FrameStrobe[0] latch
XFILLER_170_169 VPWR VGND sg13cmos5l_decap_4
XFILLER_312_152 VPWR VGND sg13cmos5l_decap_8
XFILLER_40_7 VPWR VGND sg13cmos5l_decap_8
XFILLER_345_77 VPWR VGND sg13cmos5l_decap_8
XFILLER_257_207 VPWR VGND sg13cmos5l_fill_1
XFILLER_257_218 VPWR VGND sg13cmos5l_fill_1
X_2250_ _2250_/X Tile_X0Y1_W2MID[7] Tile_X0Y1_W2END[7] Tile_X0Y1_W6END[7] _2373_/X
+ _0542_/Q _0541_/Q VPWR VGND sg13cmos5l_mux4_1
X_1201_ _1201_/Q Tile_X0Y4_FrameData[21] VGND VPWR Tile_X0Y5_FrameStrobe[5] latch
X_2181_ _2181_/X AXIL_S_SOC_WDATA16 AXIL_S_SOC_WDATA28 _2217_/X _2248_/X _0234_/Q
+ _0233_/Q VPWR VGND sg13cmos5l_mux4_1
XFILLER_77_183 VPWR VGND sg13cmos5l_fill_1
X_1132_ _1132_/Q Tile_X0Y4_FrameData[26] VGND VPWR Tile_X0Y5_FrameStrobe[3] latch
XFILLER_230_14 VPWR VGND sg13cmos5l_decap_8
XFILLER_280_221 VPWR VGND sg13cmos5l_decap_8
XFILLER_280_232 VPWR VGND sg13cmos5l_fill_2
X_1063_ _1063_/Q Tile_X0Y4_FrameData[31] VGND VPWR Tile_X0Y5_FrameStrobe[1] latch
XFILLER_178_225 VPWR VGND sg13cmos5l_decap_8
XFILLER_178_236 VPWR VGND sg13cmos5l_fill_1
XFILLER_310_91 VPWR VGND sg13cmos5l_decap_8
X_1965_ Tile_X0Y1_E1BEG[2] _2291_/X VPWR VGND sg13cmos5l_buf_1
XFILLER_239_56 VPWR VGND sg13cmos5l_decap_8
X_0916_ _0916_/Q Tile_X0Y3_FrameData[2] VGND VPWR Tile_X0Y5_FrameStrobe[3] latch
X_1896_ Tile_X0Y1_FrameData_O[9] Tile_X0Y1_FrameData[9] VPWR VGND sg13cmos5l_buf_1
X_0847_ _0847_/Q Tile_X0Y3_FrameData[7] VGND VPWR Tile_X0Y5_FrameStrobe[1] latch
XFILLER_108_49 VPWR VGND sg13cmos5l_decap_8
XFILLER_161_147 VPWR VGND sg13cmos5l_fill_1
X_0778_ _0778_/Q Tile_X0Y2_FrameData[28] VGND VPWR Tile_X0Y5_FrameStrobe[7] latch
XFILLER_350_247 VPWR VGND sg13cmos5l_decap_8
XFILLER_350_225 VPWR VGND sg13cmos5l_decap_4
XFILLER_161_169 VPWR VGND sg13cmos5l_fill_2
XFILLER_255_77 VPWR VGND sg13cmos5l_fill_2
X_2517_ _2517_/X AXIL_S_SOC_ARADDR0 AXIL_S_SOC_ARADDR8 _2589_/X _2596_/X _0970_/Q
+ _0969_/Q VPWR VGND sg13cmos5l_mux4_1
XANTENNA__2120__X AXIL_S_SOC_RDATA14 VPWR VGND sg13cmos5l_antennanp
X_2448_ _2448_/X _2478_/X _2477_/X _2470_/X _2469_/X _0631_/Q _0630_/Q VPWR VGND sg13cmos5l_mux4_1
XFILLER_271_21 VPWR VGND sg13cmos5l_decap_8
XFILLER_303_196 VPWR VGND sg13cmos5l_decap_8
X_2379_ _2379_/X _2261_/X _2394_/X _2393_/X Tile_X0Y0_S2MID[6] _0322_/Q _0321_/Q VPWR
+ VGND sg13cmos5l_mux4_1
XFILLER_68_161 VPWR VGND sg13cmos5l_decap_8
XFILLER_204_70 VPWR VGND sg13cmos5l_decap_8
XFILLER_68_183 VPWR VGND sg13cmos5l_decap_8
XFILLER_140_14 VPWR VGND sg13cmos5l_decap_8
XFILLER_17_35 VPWR VGND sg13cmos5l_decap_8
XFILLER_216_159 VPWR VGND sg13cmos5l_fill_1
XFILLER_83_153 VPWR VGND sg13cmos5l_fill_1
XFILLER_347_8 VPWR VGND sg13cmos5l_decap_8
XFILLER_220_91 VPWR VGND sg13cmos5l_decap_8
XFILLER_242_7 VPWR VGND sg13cmos5l_decap_8
XFILLER_149_56 VPWR VGND sg13cmos5l_decap_8
XFILLER_33_78 VPWR VGND sg13cmos5l_decap_8
XFILLER_296_84 VPWR VGND sg13cmos5l_decap_8
XFILLER_165_22 VPWR VGND sg13cmos5l_decap_8
XFILLER_152_125 VPWR VGND sg13cmos5l_decap_8
XFILLER_315_14 VPWR VGND sg13cmos5l_decap_8
XANTENNA__2030__X Tile_X0Y5_FrameData_O[15] VPWR VGND sg13cmos5l_antennanp
XFILLER_165_99 VPWR VGND sg13cmos5l_decap_8
XFILLER_181_21 VPWR VGND sg13cmos5l_decap_8
XFILLER_58_42 VPWR VGND sg13cmos5l_decap_8
XFILLER_199_0 VPWR VGND sg13cmos5l_decap_8
XFILLER_59_161 VPWR VGND sg13cmos5l_decap_8
XFILLER_114_70 VPWR VGND sg13cmos5l_decap_8
XFILLER_181_98 VPWR VGND sg13cmos5l_decap_8
XFILLER_331_35 VPWR VGND sg13cmos5l_decap_8
XFILLER_74_63 VPWR VGND sg13cmos5l_decap_8
XFILLER_200_28 VPWR VGND sg13cmos5l_decap_8
XFILLER_230_140 VPWR VGND sg13cmos5l_decap_8
XFILLER_130_91 VPWR VGND sg13cmos5l_decap_4
XFILLER_175_217 VPWR VGND sg13cmos5l_decap_8
XFILLER_230_184 VPWR VGND sg13cmos5l_decap_8
XFILLER_88_7 VPWR VGND sg13cmos5l_decap_8
X_1750_ Tile_X0Y2_FrameData_O[10] Tile_X0Y2_FrameData[10] VPWR VGND sg13cmos5l_buf_1
XFILLER_128_155 VPWR VGND sg13cmos5l_fill_1
X_0701_ _0701_/Q Tile_X0Y2_FrameData[9] VGND VPWR Tile_X0Y5_FrameStrobe[4] latch
XFILLER_356_21 VPWR VGND sg13cmos5l_decap_8
XFILLER_183_272 VPWR VGND sg13cmos5l_fill_1
X_1681_ Tile_X0Y0_FrameData_O[21] Tile_X0Y0_FrameData[21] VPWR VGND sg13cmos5l_buf_1
XFILLER_143_125 VPWR VGND sg13cmos5l_decap_8
X_0632_ _0632_/Q Tile_X0Y2_FrameData[14] VGND VPWR Tile_X0Y5_FrameStrobe[2] latch
XFILLER_356_98 VPWR VGND sg13cmos5l_decap_8
XFILLER_225_14 VPWR VGND sg13cmos5l_decap_8
X_0563_ _0563_/Q Tile_X0Y2_FrameData[19] VGND VPWR Tile_X0Y5_FrameStrobe[0] latch
XFILLER_151_180 VPWR VGND sg13cmos5l_fill_2
XFILLER_297_140 VPWR VGND sg13cmos5l_decap_8
X_2302_ _2302_/X AXIL_S_SOC_WDATA1 AXIL_S_SOC_WDATA9 _2374_/X _2379_/X _0488_/Q _0487_/Q
+ VPWR VGND sg13cmos5l_mux4_1
XFILLER_300_133 VPWR VGND sg13cmos5l_decap_8
X_0494_ _0494_/Q Tile_X0Y1_FrameData[8] VGND VPWR Tile_X0Y5_FrameStrobe[5] latch
XFILLER_97_267 VPWR VGND sg13cmos5l_decap_4
XFILLER_97_245 VPWR VGND sg13cmos5l_fill_1
X_2233_ _2233_/X _2216_/X _0065_/X Tile_X0Y0_S1END[3] Tile_X0Y0_S4END[3] _0112_/Q
+ _0111_/Q VPWR VGND sg13cmos5l_mux4_1
XFILLER_241_35 VPWR VGND sg13cmos5l_decap_8
XFILLER_305_91 VPWR VGND sg13cmos5l_decap_8
X_2164_ _2164_/X _2216_/X Tile_X0Y0_S1END[3] AXIL_S_SOC_WDATA17 AXIL_S_SOC_WDATA20
+ _0268_/Q _0267_/Q VPWR VGND sg13cmos5l_mux4_1
X_1115_ _1115_/Q Tile_X0Y4_FrameData[11] VGND VPWR Tile_X0Y5_FrameStrobe[2] latch
X_2095_ Tile_X0Y3_E2BEG[7] _2516_/X VPWR VGND sg13cmos5l_buf_1
XFILLER_80_101 VPWR VGND sg13cmos5l_decap_4
XFILLER_321_90 VPWR VGND sg13cmos5l_decap_8
X_1046_ _1046_/Q Tile_X0Y4_FrameData[16] VGND VPWR Tile_X0Y5_FrameStrobe[0] latch
XFILLER_110_28 VPWR VGND sg13cmos5l_decap_8
XFILLER_221_140 VPWR VGND sg13cmos5l_fill_2
XFILLER_80_189 VPWR VGND sg13cmos5l_fill_2
XANTENNA__2115__X AXIL_S_SOC_RDATA9 VPWR VGND sg13cmos5l_antennanp
XFILLER_166_217 VPWR VGND sg13cmos5l_fill_2
XFILLER_119_133 VPWR VGND sg13cmos5l_decap_8
XFILLER_266_21 VPWR VGND sg13cmos5l_decap_8
X_1948_ Tile_X0Y1_E2BEGb[1] _2302_/X VPWR VGND sg13cmos5l_buf_1
XFILLER_9_91 VPWR VGND sg13cmos5l_decap_8
XANTENNA__1954__X Tile_X0Y1_E2BEGb[7] VPWR VGND sg13cmos5l_antennanp
XFILLER_119_188 VPWR VGND sg13cmos5l_decap_8
X_1879_ Tile_X0Y2_E6BEG[5] _2438_/X VPWR VGND sg13cmos5l_buf_1
XFILLER_266_98 VPWR VGND sg13cmos5l_decap_8
XFILLER_134_169 VPWR VGND sg13cmos5l_decap_4
XFILLER_135_14 VPWR VGND sg13cmos5l_decap_8
XFILLER_0_105 VPWR VGND sg13cmos5l_decap_8
XFILLER_282_42 VPWR VGND sg13cmos5l_decap_8
XFILLER_288_140 VPWR VGND sg13cmos5l_decap_8
XFILLER_192_7 VPWR VGND sg13cmos5l_decap_8
XFILLER_48_109 VPWR VGND sg13cmos5l_decap_8
XFILLER_28_56 VPWR VGND sg13cmos5l_decap_8
XFILLER_151_35 VPWR VGND sg13cmos5l_decap_8
XFILLER_56_175 VPWR VGND sg13cmos5l_decap_8
XFILLER_204_118 VPWR VGND sg13cmos5l_decap_8
XFILLER_204_129 VPWR VGND sg13cmos5l_fill_1
XFILLER_301_49 VPWR VGND sg13cmos5l_decap_8
XFILLER_44_11 VPWR VGND sg13cmos5l_decap_8
XFILLER_44_88 VPWR VGND sg13cmos5l_decap_8
XFILLER_358_133 VPWR VGND sg13cmos5l_decap_8
XANTENNA__2025__X Tile_X0Y5_FrameData_O[10] VPWR VGND sg13cmos5l_antennanp
XFILLER_60_21 VPWR VGND sg13cmos5l_decap_8
XFILLER_176_21 VPWR VGND sg13cmos5l_decap_8
XANTENNA__1864__X Tile_X0Y4_FrameData_O[31] VPWR VGND sg13cmos5l_antennanp
XFILLER_165_272 VPWR VGND sg13cmos5l_fill_1
XFILLER_172_209 VPWR VGND sg13cmos5l_decap_8
XFILLER_60_98 VPWR VGND sg13cmos5l_decap_8
XFILLER_114_0 VPWR VGND sg13cmos5l_decap_8
XFILLER_176_98 VPWR VGND sg13cmos5l_decap_8
XFILLER_180_231 VPWR VGND sg13cmos5l_decap_8
XFILLER_109_70 VPWR VGND sg13cmos5l_decap_8
XFILLER_125_169 VPWR VGND sg13cmos5l_decap_4
XFILLER_326_35 VPWR VGND sg13cmos5l_decap_8
XFILLER_5_49 VPWR VGND sg13cmos5l_decap_8
XFILLER_140_128 VPWR VGND sg13cmos5l_decap_8
XFILLER_192_42 VPWR VGND sg13cmos5l_decap_8
XFILLER_69_63 VPWR VGND sg13cmos5l_decap_8
XFILLER_279_195 VPWR VGND sg13cmos5l_fill_1
XFILLER_294_154 VPWR VGND sg13cmos5l_decap_8
XFILLER_94_204 VPWR VGND sg13cmos5l_decap_4
XFILLER_125_91 VPWR VGND sg13cmos5l_decap_8
XFILLER_342_78 VPWR VGND sg13cmos5l_decap_8
XFILLER_235_243 VPWR VGND sg13cmos5l_decap_8
XFILLER_235_254 VPWR VGND sg13cmos5l_fill_2
XFILLER_62_112 VPWR VGND sg13cmos5l_decap_8
XFILLER_47_197 VPWR VGND sg13cmos5l_decap_8
XFILLER_211_49 VPWR VGND sg13cmos5l_decap_8
XFILLER_203_140 VPWR VGND sg13cmos5l_decap_8
XFILLER_349_133 VPWR VGND sg13cmos5l_decap_8
X_1802_ Tile_X0Y4_E2BEGb[5] _2630_/X VPWR VGND sg13cmos5l_buf_1
X_2782_ _2782_/X _2824_/X _2823_/X _2814_/X _2813_/X _1340_/Q _1339_/Q VPWR VGND sg13cmos5l_mux4_1
XANTENNA__1774__X Tile_X0Y2_E1BEG[1] VPWR VGND sg13cmos5l_antennanp
X_1733_ Tile_X0Y0_E2BEG[5] _2170_/X VPWR VGND sg13cmos5l_buf_1
XFILLER_116_147 VPWR VGND sg13cmos5l_decap_8
XFILLER_236_35 VPWR VGND sg13cmos5l_decap_8
XFILLER_305_247 VPWR VGND sg13cmos5l_decap_8
X_1664_ Tile_X0Y0_FrameData_O[4] Tile_X0Y0_FrameData[4] VPWR VGND sg13cmos5l_buf_1
XFILLER_131_128 VPWR VGND sg13cmos5l_decap_8
X_1595_ Tile_X0Y2_EE4BEG[8] _2425_/X VPWR VGND sg13cmos5l_buf_1
X_0615_ _0615_/Q Tile_X0Y2_FrameData[31] VGND VPWR Tile_X0Y5_FrameStrobe[2] latch
XFILLER_124_191 VPWR VGND sg13cmos5l_decap_8
X_0546_ _0546_/Q Tile_X0Y1_FrameData[20] VGND VPWR Tile_X0Y5_FrameStrobe[7] latch
XFILLER_105_28 VPWR VGND sg13cmos5l_decap_8
X_0477_ _0477_/Q Tile_X0Y1_FrameData[25] VGND VPWR Tile_X0Y5_FrameStrobe[5] latch
XFILLER_85_215 VPWR VGND sg13cmos5l_decap_8
XFILLER_252_56 VPWR VGND sg13cmos5l_decap_8
XFILLER_285_165 VPWR VGND sg13cmos5l_decap_8
X_2216_ _2216_/X Tile_X0Y1_W1END[3] Tile_X0Y1_W6END[7] _2349_/X _2340_/X _0544_/Q
+ _0543_/Q VPWR VGND sg13cmos5l_mux4_1
XFILLER_85_237 VPWR VGND sg13cmos5l_decap_8
XFILLER_226_232 VPWR VGND sg13cmos5l_decap_4
X_2147_ _2147_/X Tile_X0Y0_W2MID[5] Tile_X0Y0_W2END[5] Tile_X0Y0_W6END[5] _2243_/X
+ _0298_/Q _0297_/Q VPWR VGND sg13cmos5l_mux4_1
XFILLER_53_112 VPWR VGND sg13cmos5l_decap_8
XFILLER_38_175 VPWR VGND sg13cmos5l_decap_8
XFILLER_121_49 VPWR VGND sg13cmos5l_decap_8
X_2078_ Tile_X0Y5_S4BEG[11] _2078_/A VPWR VGND sg13cmos5l_buf_1
XANTENNA__1949__X Tile_X0Y1_E2BEGb[2] VPWR VGND sg13cmos5l_antennanp
XFILLER_241_268 VPWR VGND sg13cmos5l_decap_4
X_1029_ _1029_/Q Tile_X0Y3_FrameData[17] VGND VPWR Tile_X0Y5_FrameStrobe[7] latch
XFILLER_53_189 VPWR VGND sg13cmos5l_decap_8
XFILLER_14_14 VPWR VGND sg13cmos5l_decap_8
XFILLER_139_239 VPWR VGND sg13cmos5l_decap_8
XFILLER_277_42 VPWR VGND sg13cmos5l_decap_8
XFILLER_355_147 VPWR VGND sg13cmos5l_decap_8
XFILLER_147_272 VPWR VGND sg13cmos5l_fill_1
XANTENNA__1684__X Tile_X0Y0_FrameData_O[24] VPWR VGND sg13cmos5l_antennanp
XFILLER_205_7 VPWR VGND sg13cmos5l_decap_8
XFILLER_30_35 VPWR VGND sg13cmos5l_decap_8
XFILLER_146_35 VPWR VGND sg13cmos5l_decap_8
XFILLER_293_63 VPWR VGND sg13cmos5l_decap_8
XFILLER_115_191 VPWR VGND sg13cmos5l_fill_1
XFILLER_276_143 VPWR VGND sg13cmos5l_decap_8
XFILLER_76_204 VPWR VGND sg13cmos5l_decap_8
XFILLER_162_56 VPWR VGND sg13cmos5l_decap_8
XFILLER_39_77 VPWR VGND sg13cmos5l_decap_8
XFILLER_29_153 VPWR VGND sg13cmos5l_decap_4
XFILLER_91_218 VPWR VGND sg13cmos5l_decap_8
XFILLER_91_207 VPWR VGND sg13cmos5l_decap_4
XFILLER_291_168 VPWR VGND sg13cmos5l_decap_8
XFILLER_55_21 VPWR VGND sg13cmos5l_decap_8
XFILLER_232_213 VPWR VGND sg13cmos5l_decap_4
XFILLER_44_123 VPWR VGND sg13cmos5l_decap_8
XANTENNA__1859__X Tile_X0Y4_FrameData_O[26] VPWR VGND sg13cmos5l_antennanp
XFILLER_232_246 VPWR VGND sg13cmos5l_decap_8
XFILLER_55_98 VPWR VGND sg13cmos5l_decap_8
XFILLER_231_0 VPWR VGND sg13cmos5l_decap_8
XFILLER_71_42 VPWR VGND sg13cmos5l_decap_8
XFILLER_187_42 VPWR VGND sg13cmos5l_decap_8
XFILLER_329_0 VPWR VGND sg13cmos5l_decap_8
XANTENNA__1594__X Tile_X0Y2_EE4BEG[7] VPWR VGND sg13cmos5l_antennanp
XFILLER_337_56 VPWR VGND sg13cmos5l_decap_8
XFILLER_153_231 VPWR VGND sg13cmos5l_decap_8
XFILLER_299_268 VPWR VGND sg13cmos5l_decap_4
XFILLER_302_217 VPWR VGND sg13cmos5l_fill_2
XFILLER_206_49 VPWR VGND sg13cmos5l_decap_8
XFILLER_302_239 VPWR VGND sg13cmos5l_fill_2
X_1380_ _1380_/Q Tile_X0Y5_FrameData[12] VGND VPWR Tile_X0Y5_FrameStrobe[3] latch
X_0400_ _0400_/Q Tile_X0Y1_FrameData[6] VGND VPWR Tile_X0Y5_FrameStrobe[2] latch
X_0331_ _0331_/Q Tile_X0Y1_FrameData[11] VGND VPWR Tile_X0Y5_FrameStrobe[0] latch
XFILLER_353_77 VPWR VGND sg13cmos5l_decap_8
XFILLER_121_194 VPWR VGND sg13cmos5l_decap_8
X_2001_ Tile_X0Y5_EE4BEG[2] _2743_/X VPWR VGND sg13cmos5l_buf_1
X_0262_ _0262_/Q Tile_X0Y0_FrameData[0] VGND VPWR Tile_X0Y5_FrameStrobe[5] latch
XFILLER_282_157 VPWR VGND sg13cmos5l_decap_8
X_0193_ _0193_/Q Tile_X0Y0_FrameData[5] VGND VPWR Tile_X0Y5_FrameStrobe[3] latch
XFILLER_35_112 VPWR VGND sg13cmos5l_decap_8
XANTENNA__1769__X Tile_X0Y2_FrameData_O[29] VPWR VGND sg13cmos5l_antennanp
XFILLER_302_70 VPWR VGND sg13cmos5l_decap_8
XFILLER_35_178 VPWR VGND sg13cmos5l_decap_8
XFILLER_195_109 VPWR VGND sg13cmos5l_fill_2
XFILLER_50_126 VPWR VGND sg13cmos5l_decap_8
X_2834_ _2834_/X Tile_X0Y4_W1END[1] Tile_X0Y4_W2MID[2] Tile_X0Y4_W2END[2] _2683_/X
+ _1114_/Q _1113_/Q VPWR VGND sg13cmos5l_mux4_1
XFILLER_77_0 VPWR VGND sg13cmos5l_decap_8
XFILLER_247_56 VPWR VGND sg13cmos5l_decap_8
X_2765_ _2765_/X AXIL_S_SOC_ARPROT0 _2819_/X _2817_/X _2800_/X _1372_/Q _1371_/Q VPWR
+ VGND sg13cmos5l_mux4_1
X_1716_ Tile_X0Y0_E6BEG[8] _2205_/X VPWR VGND sg13cmos5l_buf_1
X_2696_ _2696_/X _2674_/X Tile_X0Y5_N4END[4] _2673_/X _0039_/X _1062_/Q _1061_/Q VPWR
+ VGND sg13cmos5l_mux4_1
XFILLER_6_70 VPWR VGND sg13cmos5l_decap_8
XFILLER_104_106 VPWR VGND sg13cmos5l_decap_8
X_1647_ Tile_X0Y0_FrameStrobe_O[7] Tile_X0Y5_FrameStrobe[7] VPWR VGND sg13cmos5l_buf_1
XFILLER_116_49 VPWR VGND sg13cmos5l_decap_8
XFILLER_360_183 VPWR VGND sg13cmos5l_decap_8
XFILLER_112_161 VPWR VGND sg13cmos5l_decap_8
XFILLER_263_77 VPWR VGND sg13cmos5l_decap_8
X_1578_ Tile_X0Y3_FrameData_O[24] Tile_X0Y3_FrameData[24] VPWR VGND sg13cmos5l_buf_1
XFILLER_112_172 VPWR VGND sg13cmos5l_decap_8
XFILLER_112_194 VPWR VGND sg13cmos5l_decap_4
XFILLER_273_102 VPWR VGND sg13cmos5l_fill_2
X_0529_ _0529_/Q Tile_X0Y1_FrameData[5] VGND VPWR Tile_X0Y5_FrameStrobe[6] latch
XFILLER_58_226 VPWR VGND sg13cmos5l_decap_8
XFILLER_26_112 VPWR VGND sg13cmos5l_fill_1
XFILLER_73_218 VPWR VGND sg13cmos5l_decap_8
XFILLER_214_202 VPWR VGND sg13cmos5l_fill_2
XANTENNA__1679__X Tile_X0Y0_FrameData_O[19] VPWR VGND sg13cmos5l_antennanp
XFILLER_212_70 VPWR VGND sg13cmos5l_decap_8
XFILLER_214_246 VPWR VGND sg13cmos5l_decap_8
XFILLER_25_35 VPWR VGND sg13cmos5l_decap_8
XFILLER_155_7 VPWR VGND sg13cmos5l_decap_8
XFILLER_41_137 VPWR VGND sg13cmos5l_decap_8
XFILLER_179_161 VPWR VGND sg13cmos5l_decap_8
XFILLER_288_63 VPWR VGND sg13cmos5l_decap_8
XFILLER_179_194 VPWR VGND sg13cmos5l_decap_8
XFILLER_322_7 VPWR VGND sg13cmos5l_decap_8
XFILLER_157_56 VPWR VGND sg13cmos5l_decap_8
XFILLER_194_186 VPWR VGND sg13cmos5l_decap_4
XFILLER_41_67 VPWR VGND sg13cmos5l_decap_8
XFILLER_150_201 VPWR VGND sg13cmos5l_fill_2
XFILLER_351_161 VPWR VGND sg13cmos5l_decap_8
XFILLER_150_223 VPWR VGND sg13cmos5l_decap_8
XFILLER_296_238 VPWR VGND sg13cmos5l_decap_4
XFILLER_150_267 VPWR VGND sg13cmos5l_decap_4
XFILLER_173_77 VPWR VGND sg13cmos5l_decap_8
XFILLER_264_102 VPWR VGND sg13cmos5l_fill_2
XFILLER_2_28 VPWR VGND sg13cmos5l_decap_8
XFILLER_323_14 VPWR VGND sg13cmos5l_decap_8
XFILLER_49_248 VPWR VGND sg13cmos5l_decap_8
XFILLER_181_0 VPWR VGND sg13cmos5l_decap_8
XFILLER_66_42 VPWR VGND sg13cmos5l_decap_8
XFILLER_64_207 VPWR VGND sg13cmos5l_decap_8
XFILLER_49_259 VPWR VGND sg13cmos5l_fill_2
XFILLER_17_112 VPWR VGND sg13cmos5l_decap_8
XFILLER_279_0 VPWR VGND sg13cmos5l_decap_8
XFILLER_205_213 VPWR VGND sg13cmos5l_decap_4
XFILLER_205_224 VPWR VGND sg13cmos5l_decap_8
XANTENNA__1589__X Tile_X0Y2_EE4BEG[2] VPWR VGND sg13cmos5l_antennanp
XFILLER_122_70 VPWR VGND sg13cmos5l_decap_8
XFILLER_82_63 VPWR VGND sg13cmos5l_decap_8
XFILLER_198_63 VPWR VGND sg13cmos5l_decap_8
X_0880_ _0880_/Q Tile_X0Y3_FrameData[6] VGND VPWR Tile_X0Y5_FrameStrobe[2] latch
XFILLER_70_7 VPWR VGND sg13cmos5l_decap_8
XFILLER_348_77 VPWR VGND sg13cmos5l_decap_8
XFILLER_126_220 VPWR VGND sg13cmos5l_fill_1
XFILLER_334_128 VPWR VGND sg13cmos5l_fill_1
X_2550_ _2550_/X AXIL_S_SOC_ARADDR1 _2584_/X _2582_/X _2594_/X _0904_/Q _0903_/Q VPWR
+ VGND sg13cmos5l_mux4_1
X_1501_ _2562_/A3 VPWR VGND sg13cmos5l_tielo
X_2481_ _2481_/X _2382_/X _2490_/X _2489_/X _2381_/X _0574_/Q _0573_/Q VPWR VGND sg13cmos5l_mux4_1
XFILLER_287_216 VPWR VGND sg13cmos5l_decap_8
X_1432_ _1432_/Q Tile_X0Y5_FrameData[24] VGND VPWR Tile_X0Y5_FrameStrobe[5] latch
XFILLER_233_14 VPWR VGND sg13cmos5l_decap_8
XFILLER_295_271 VPWR VGND sg13cmos5l_fill_2
X_1363_ _1363_/Q Tile_X0Y5_FrameData[29] VGND VPWR Tile_X0Y5_FrameStrobe[3] latch
X_1294_ _1294_/Q Tile_X0Y5_FrameData[2] VGND VPWR Tile_X0Y5_FrameStrobe[0] latch
X_0314_ _0314_/Q Tile_X0Y1_FrameData[28] VGND VPWR Tile_X0Y5_FrameStrobe[0] latch
X_0245_ _0245_/Q Tile_X0Y0_FrameData[17] VGND VPWR Tile_X0Y5_FrameStrobe[5] latch
XFILLER_313_91 VPWR VGND sg13cmos5l_decap_8
X_0176_ _0176_/Q Tile_X0Y0_FrameData[22] VGND VPWR Tile_X0Y5_FrameStrobe[3] latch
XFILLER_31_181 VPWR VGND sg13cmos5l_decap_8
XFILLER_258_77 VPWR VGND sg13cmos5l_decap_8
X_2817_ _2817_/X Tile_X0Y5_N1END[3] Tile_X0Y5_N4END[3] _2796_/X _0057_/X _1306_/Q
+ _1305_/Q VPWR VGND sg13cmos5l_mux4_1
XANTENNA__2123__X AXIL_S_SOC_RDATA17 VPWR VGND sg13cmos5l_antennanp
XFILLER_117_231 VPWR VGND sg13cmos5l_decap_8
XFILLER_191_145 VPWR VGND sg13cmos5l_decap_8
XFILLER_274_21 VPWR VGND sg13cmos5l_decap_8
X_2748_ _2748_/X AXIL_S_SOC_ARPROT1 AXIL_S_SOC_ARPROT2 _2814_/X _2825_/X _1406_/Q
+ _1405_/Q VPWR VGND sg13cmos5l_mux4_1
XFILLER_132_201 VPWR VGND sg13cmos5l_decap_8
XANTENNA__1962__X Tile_X0Y1_E2BEG[7] VPWR VGND sg13cmos5l_antennanp
X_2679_ _2679_/X Tile_X0Y3_W1END[3] Tile_X0Y3_W6END[11] _2573_/X _2564_/X _0892_/Q
+ _0891_/Q VPWR VGND sg13cmos5l_mux4_1
XFILLER_207_70 VPWR VGND sg13cmos5l_decap_8
XFILLER_274_98 VPWR VGND sg13cmos5l_decap_8
XFILLER_143_14 VPWR VGND sg13cmos5l_decap_8
XFILLER_98_192 VPWR VGND sg13cmos5l_decap_8
XFILLER_290_42 VPWR VGND sg13cmos5l_decap_8
XFILLER_272_7 VPWR VGND sg13cmos5l_decap_8
XFILLER_223_91 VPWR VGND sg13cmos5l_decap_4
XFILLER_261_105 VPWR VGND sg13cmos5l_decap_8
XFILLER_36_56 VPWR VGND sg13cmos5l_decap_8
XFILLER_14_126 VPWR VGND sg13cmos5l_decap_8
XFILLER_299_84 VPWR VGND sg13cmos5l_decap_8
XFILLER_202_238 VPWR VGND sg13cmos5l_decap_8
XFILLER_356_231 VPWR VGND sg13cmos5l_decap_8
XFILLER_167_164 VPWR VGND sg13cmos5l_decap_8
XFILLER_52_77 VPWR VGND sg13cmos5l_decap_8
XFILLER_168_77 VPWR VGND sg13cmos5l_decap_8
XFILLER_182_112 VPWR VGND sg13cmos5l_decap_8
XFILLER_318_14 VPWR VGND sg13cmos5l_decap_8
XANTENNA__2033__X Tile_X0Y5_FrameData_O[18] VPWR VGND sg13cmos5l_antennanp
XFILLER_184_21 VPWR VGND sg13cmos5l_decap_8
XANTENNA__1872__X Tile_X0Y2_E2BEGb[6] VPWR VGND sg13cmos5l_antennanp
XFILLER_7_0 VPWR VGND sg13cmos5l_decap_8
XFILLER_117_70 VPWR VGND sg13cmos5l_decap_8
XFILLER_184_98 VPWR VGND sg13cmos5l_decap_8
XFILLER_334_35 VPWR VGND sg13cmos5l_decap_8
XFILLER_77_63 VPWR VGND sg13cmos5l_decap_8
XFILLER_203_28 VPWR VGND sg13cmos5l_decap_8
XFILLER_237_168 VPWR VGND sg13cmos5l_decap_8
XFILLER_292_230 VPWR VGND sg13cmos5l_fill_1
XFILLER_133_91 VPWR VGND sg13cmos5l_decap_4
XFILLER_252_105 VPWR VGND sg13cmos5l_decap_8
X_0030_ _0030_/X _2359_/X _2360_/X _1464_/Q VPWR VGND sg13cmos5l_mux2_1
XFILLER_350_56 VPWR VGND sg13cmos5l_decap_8
XFILLER_93_84 VPWR VGND sg13cmos5l_decap_8
XANTENNA_250 AXIL_S_SOC_WDATA22 VPWR VGND sg13cmos5l_antennanp
XANTENNA_261 AXIL_S_SOC_WDATA22 VPWR VGND sg13cmos5l_antennanp
XANTENNA_272 AXIL_S_SOC_WDATA22 VPWR VGND sg13cmos5l_antennanp
XANTENNA_283 AXIL_S_SOC_WDATA22 VPWR VGND sg13cmos5l_antennanp
XANTENNA_294 AXIL_S_SOC_WDATA19 VPWR VGND sg13cmos5l_antennanp
XFILLER_359_21 VPWR VGND sg13cmos5l_decap_8
X_1981_ Tile_X0Y5_E2BEGb[2] _2735_/X VPWR VGND sg13cmos5l_buf_1
XFILLER_13_170 VPWR VGND sg13cmos5l_fill_2
X_0932_ _0932_/Q Tile_X0Y3_FrameData[18] VGND VPWR Tile_X0Y5_FrameStrobe[4] latch
XFILLER_359_98 VPWR VGND sg13cmos5l_decap_8
XFILLER_173_112 VPWR VGND sg13cmos5l_decap_8
XFILLER_228_14 VPWR VGND sg13cmos5l_decap_8
X_0863_ _0863_/Q Tile_X0Y3_FrameData[23] VGND VPWR Tile_X0Y5_FrameStrobe[2] latch
X_2602_ _2602_/X Tile_X0Y5_W2MID[5] Tile_X0Y5_W2END[5] Tile_X0Y5_W6END[5] _2827_/X
+ _1484_/Q _1483_/Q VPWR VGND sg13cmos5l_mux4_1
XFILLER_173_189 VPWR VGND sg13cmos5l_fill_2
X_2533_ _2533_/X AXIL_S_SOC_ARADDR4 AXIL_S_SOC_ARADDR8 _2581_/X _2596_/X _0938_/Q
+ _0937_/Q VPWR VGND sg13cmos5l_mux4_1
X_0794_ _0794_/Q Tile_X0Y3_FrameData[28] VGND VPWR Tile_X0Y5_FrameStrobe[0] latch
XANTENNA__1782__X Tile_X0Y2_E2BEG[5] VPWR VGND sg13cmos5l_antennanp
XFILLER_308_91 VPWR VGND sg13cmos5l_decap_8
XFILLER_315_172 VPWR VGND sg13cmos5l_fill_1
XFILLER_315_183 VPWR VGND sg13cmos5l_decap_4
XFILLER_244_35 VPWR VGND sg13cmos5l_decap_8
XFILLER_330_131 VPWR VGND sg13cmos5l_decap_4
X_2464_ _2464_/X Tile_X0Y3_W1END[3] Tile_X0Y3_W6END[7] _2573_/X _2564_/X _1024_/Q
+ _1023_/Q VPWR VGND sg13cmos5l_mux4_1
X_1415_ _1415_/Q Tile_X0Y5_FrameData[9] VGND VPWR Tile_X0Y5_FrameStrobe[4] latch
X_2395_ _2395_/X Tile_X0Y0_W1END[3] Tile_X0Y0_W2MID[0] Tile_X0Y0_W2END[0] _2248_/X
+ _0156_/Q _0155_/Q VPWR VGND sg13cmos5l_mux4_1
XFILLER_268_271 VPWR VGND sg13cmos5l_fill_2
X_1346_ _1346_/Q Tile_X0Y5_FrameData[14] VGND VPWR Tile_X0Y5_FrameStrobe[2] latch
XFILLER_113_28 VPWR VGND sg13cmos5l_decap_8
XFILLER_28_207 VPWR VGND sg13cmos5l_fill_1
XFILLER_243_105 VPWR VGND sg13cmos5l_decap_8
XFILLER_260_56 VPWR VGND sg13cmos5l_decap_8
X_1277_ _1277_/Q Tile_X0Y5_FrameData[19] VGND VPWR Tile_X0Y5_FrameStrobe[0] latch
X_0228_ _0228_/Q Tile_X0Y0_FrameData[2] VGND VPWR Tile_X0Y5_FrameStrobe[4] latch
XANTENNA__2118__X AXIL_S_SOC_RDATA12 VPWR VGND sg13cmos5l_antennanp
X_0159_ _0159_/Q Tile_X0Y0_FrameData[7] VGND VPWR Tile_X0Y5_FrameStrobe[2] latch
XFILLER_269_21 VPWR VGND sg13cmos5l_decap_8
XANTENNA__1957__X Tile_X0Y1_E2BEG[2] VPWR VGND sg13cmos5l_antennanp
XFILLER_149_142 VPWR VGND sg13cmos5l_decap_8
XFILLER_22_14 VPWR VGND sg13cmos5l_decap_8
XFILLER_269_98 VPWR VGND sg13cmos5l_decap_4
XFILLER_138_14 VPWR VGND sg13cmos5l_decap_8
XFILLER_118_7 VPWR VGND sg13cmos5l_decap_8
XFILLER_285_42 VPWR VGND sg13cmos5l_decap_8
XFILLER_353_245 VPWR VGND sg13cmos5l_decap_8
XFILLER_306_161 VPWR VGND sg13cmos5l_decap_8
XANTENNA__1692__X Tile_X0Y0_EE4BEG[0] VPWR VGND sg13cmos5l_antennanp
XFILLER_218_91 VPWR VGND sg13cmos5l_fill_2
XFILLER_0_7 VPWR VGND sg13cmos5l_decap_8
XFILLER_105_256 VPWR VGND sg13cmos5l_decap_4
XFILLER_154_35 VPWR VGND sg13cmos5l_decap_8
XFILLER_120_215 VPWR VGND sg13cmos5l_decap_8
XFILLER_266_219 VPWR VGND sg13cmos5l_decap_8
XFILLER_219_124 VPWR VGND sg13cmos5l_fill_2
XFILLER_304_49 VPWR VGND sg13cmos5l_decap_8
XFILLER_170_56 VPWR VGND sg13cmos5l_decap_8
XFILLER_234_105 VPWR VGND sg13cmos5l_decap_8
XFILLER_47_77 VPWR VGND sg13cmos5l_decap_8
XANTENNA__2028__X Tile_X0Y5_FrameData_O[13] VPWR VGND sg13cmos5l_antennanp
XFILLER_63_21 VPWR VGND sg13cmos5l_decap_8
XFILLER_179_21 VPWR VGND sg13cmos5l_decap_8
XFILLER_242_182 VPWR VGND sg13cmos5l_decap_8
XANTENNA__1867__X Tile_X0Y2_E2BEGb[1] VPWR VGND sg13cmos5l_antennanp
XFILLER_144_0 VPWR VGND sg13cmos5l_decap_8
XFILLER_63_98 VPWR VGND sg13cmos5l_decap_8
XFILLER_179_98 VPWR VGND sg13cmos5l_decap_8
XFILLER_329_35 VPWR VGND sg13cmos5l_decap_8
XFILLER_8_49 VPWR VGND sg13cmos5l_decap_8
XFILLER_10_140 VPWR VGND sg13cmos5l_decap_8
XFILLER_311_0 VPWR VGND sg13cmos5l_decap_8
XFILLER_344_201 VPWR VGND sg13cmos5l_decap_8
XFILLER_195_42 VPWR VGND sg13cmos5l_decap_8
XFILLER_128_91 VPWR VGND sg13cmos5l_decap_4
XFILLER_12_91 VPWR VGND sg13cmos5l_decap_8
XFILLER_170_126 VPWR VGND sg13cmos5l_decap_8
XFILLER_345_56 VPWR VGND sg13cmos5l_decap_8
X_2180_ _2180_/X AXIL_S_SOC_WDATA23 AXIL_S_SOC_WDATA31 _2241_/X _2248_/X _0236_/Q
+ _0235_/Q VPWR VGND sg13cmos5l_mux4_1
X_1200_ _1200_/Q Tile_X0Y4_FrameData[22] VGND VPWR Tile_X0Y5_FrameStrobe[5] latch
XFILLER_361_11 VPWR VGND sg13cmos5l_decap_4
XFILLER_214_49 VPWR VGND sg13cmos5l_decap_8
XFILLER_225_105 VPWR VGND sg13cmos5l_decap_8
XFILLER_280_200 VPWR VGND sg13cmos5l_decap_8
X_1131_ _1131_/Q Tile_X0Y4_FrameData[27] VGND VPWR Tile_X0Y5_FrameStrobe[3] latch
XFILLER_77_195 VPWR VGND sg13cmos5l_fill_2
X_1062_ _1062_/Q Tile_X0Y4_FrameData[0] VGND VPWR Tile_X0Y5_FrameStrobe[0] latch
XFILLER_240_119 VPWR VGND sg13cmos5l_decap_8
XFILLER_92_198 VPWR VGND sg13cmos5l_fill_1
XFILLER_92_187 VPWR VGND sg13cmos5l_decap_8
XFILLER_178_204 VPWR VGND sg13cmos5l_decap_8
XANTENNA__1777__X Tile_X0Y2_E2BEG[0] VPWR VGND sg13cmos5l_antennanp
XFILLER_310_70 VPWR VGND sg13cmos5l_decap_8
XFILLER_239_35 VPWR VGND sg13cmos5l_decap_8
X_1964_ Tile_X0Y1_E1BEG[1] _2290_/X VPWR VGND sg13cmos5l_buf_1
XFILLER_146_101 VPWR VGND sg13cmos5l_decap_8
X_0915_ _0915_/Q Tile_X0Y3_FrameData[3] VGND VPWR Tile_X0Y5_FrameStrobe[3] latch
XFILLER_146_156 VPWR VGND sg13cmos5l_decap_8
XFILLER_335_245 VPWR VGND sg13cmos5l_fill_2
X_1895_ Tile_X0Y1_FrameData_O[8] Tile_X0Y1_FrameData[8] VPWR VGND sg13cmos5l_buf_1
X_0846_ _0846_/Q Tile_X0Y3_FrameData[8] VGND VPWR Tile_X0Y5_FrameStrobe[1] latch
XFILLER_350_204 VPWR VGND sg13cmos5l_decap_8
XFILLER_108_28 VPWR VGND sg13cmos5l_decap_8
XFILLER_161_137 VPWR VGND sg13cmos5l_fill_1
XFILLER_255_56 VPWR VGND sg13cmos5l_decap_8
X_0777_ _0777_/Q Tile_X0Y2_FrameData[29] VGND VPWR Tile_X0Y5_FrameStrobe[7] latch
X_2516_ _2516_/X AXIL_S_SOC_ARADDR5 AXIL_S_SOC_ARADDR7 _2589_/X _2596_/X _0972_/Q
+ _0971_/Q VPWR VGND sg13cmos5l_mux4_1
XFILLER_303_175 VPWR VGND sg13cmos5l_decap_8
X_2447_ _2447_/X Tile_X0Y2_W1END[1] Tile_X0Y2_WW4END[9] Tile_X0Y2_WW4END[13] Tile_X0Y2_W6END[5]
+ _0631_/Q _0630_/Q VPWR VGND sg13cmos5l_mux4_1
XFILLER_68_140 VPWR VGND sg13cmos5l_decap_8
XFILLER_124_49 VPWR VGND sg13cmos5l_decap_8
XFILLER_271_77 VPWR VGND sg13cmos5l_decap_8
X_2378_ _2378_/X _2259_/X _2392_/X _2391_/X Tile_X0Y0_S2MID[5] _0324_/Q _0323_/Q VPWR
+ VGND sg13cmos5l_mux4_1
XFILLER_17_14 VPWR VGND sg13cmos5l_decap_8
XFILLER_216_105 VPWR VGND sg13cmos5l_fill_1
X_1329_ _1329_/Q Tile_X0Y5_FrameData[31] VGND VPWR Tile_X0Y5_FrameStrobe[2] latch
XFILLER_216_127 VPWR VGND sg13cmos5l_decap_4
XFILLER_271_222 VPWR VGND sg13cmos5l_decap_8
XFILLER_24_210 VPWR VGND sg13cmos5l_fill_2
XFILLER_271_255 VPWR VGND sg13cmos5l_decap_8
XFILLER_231_119 VPWR VGND sg13cmos5l_decap_8
XANTENNA__1687__X Tile_X0Y0_FrameData_O[27] VPWR VGND sg13cmos5l_antennanp
XFILLER_220_70 VPWR VGND sg13cmos5l_decap_8
XFILLER_149_35 VPWR VGND sg13cmos5l_decap_8
XFILLER_235_7 VPWR VGND sg13cmos5l_decap_8
XFILLER_33_57 VPWR VGND sg13cmos5l_decap_8
XFILLER_296_63 VPWR VGND sg13cmos5l_decap_8
XFILLER_298_119 VPWR VGND sg13cmos5l_decap_8
XFILLER_341_226 VPWR VGND sg13cmos5l_fill_1
XFILLER_341_215 VPWR VGND sg13cmos5l_decap_4
XFILLER_165_78 VPWR VGND sg13cmos5l_decap_8
XFILLER_160_181 VPWR VGND sg13cmos5l_decap_8
XFILLER_58_21 VPWR VGND sg13cmos5l_decap_8
XFILLER_59_140 VPWR VGND sg13cmos5l_decap_8
XFILLER_58_98 VPWR VGND sg13cmos5l_decap_8
XFILLER_181_77 VPWR VGND sg13cmos5l_decap_8
XFILLER_331_14 VPWR VGND sg13cmos5l_decap_8
XFILLER_74_42 VPWR VGND sg13cmos5l_decap_8
XFILLER_15_210 VPWR VGND sg13cmos5l_fill_2
XFILLER_261_0 VPWR VGND sg13cmos5l_decap_8
XFILLER_74_176 VPWR VGND sg13cmos5l_fill_1
XFILLER_359_0 VPWR VGND sg13cmos5l_decap_8
XFILLER_222_119 VPWR VGND sg13cmos5l_decap_4
XANTENNA__1597__X Tile_X0Y2_EE4BEG[10] VPWR VGND sg13cmos5l_antennanp
XFILLER_130_70 VPWR VGND sg13cmos5l_decap_8
XFILLER_90_85 VPWR VGND sg13cmos5l_decap_4
XFILLER_183_240 VPWR VGND sg13cmos5l_decap_8
X_0700_ _0700_/Q Tile_X0Y2_FrameData[10] VGND VPWR Tile_X0Y5_FrameStrobe[4] latch
XFILLER_143_104 VPWR VGND sg13cmos5l_decap_8
XFILLER_183_251 VPWR VGND sg13cmos5l_fill_1
XFILLER_209_49 VPWR VGND sg13cmos5l_decap_8
X_1680_ Tile_X0Y0_FrameData_O[20] Tile_X0Y0_FrameData[20] VPWR VGND sg13cmos5l_buf_1
XFILLER_289_119 VPWR VGND sg13cmos5l_decap_8
X_0631_ _0631_/Q Tile_X0Y2_FrameData[15] VGND VPWR Tile_X0Y5_FrameStrobe[2] latch
XFILLER_356_77 VPWR VGND sg13cmos5l_decap_8
X_0562_ _0562_/Q Tile_X0Y2_FrameData[20] VGND VPWR Tile_X0Y5_FrameStrobe[0] latch
X_2301_ _2301_/X AXIL_S_SOC_WDATA0 AXIL_S_SOC_WDATA8 _2373_/X _2380_/X _0490_/Q _0489_/Q
+ VPWR VGND sg13cmos5l_mux4_1
XFILLER_297_196 VPWR VGND sg13cmos5l_decap_8
XFILLER_300_112 VPWR VGND sg13cmos5l_decap_8
X_0493_ _0493_/Q Tile_X0Y1_FrameData[9] VGND VPWR Tile_X0Y5_FrameStrobe[5] latch
XFILLER_305_70 VPWR VGND sg13cmos5l_decap_8
X_2232_ _2232_/X _2700_/X _2685_/X _2684_/X _2711_/X _1231_/Q _1230_/Q VPWR VGND sg13cmos5l_mux4_1
XFILLER_238_263 VPWR VGND sg13cmos5l_fill_2
XFILLER_241_14 VPWR VGND sg13cmos5l_decap_8
XFILLER_300_189 VPWR VGND sg13cmos5l_decap_8
X_2163_ _2163_/X _2215_/X Tile_X0Y0_S1END[2] AXIL_S_SOC_WDATA16 AXIL_S_SOC_WDATA21
+ _0270_/Q _0269_/Q VPWR VGND sg13cmos5l_mux4_1
X_1114_ _1114_/Q Tile_X0Y4_FrameData[12] VGND VPWR Tile_X0Y5_FrameStrobe[2] latch
XFILLER_65_154 VPWR VGND sg13cmos5l_decap_8
X_2094_ Tile_X0Y3_E2BEG[6] _2515_/X VPWR VGND sg13cmos5l_buf_1
XFILLER_80_124 VPWR VGND sg13cmos5l_fill_1
XFILLER_80_113 VPWR VGND sg13cmos5l_fill_2
X_1045_ _1045_/Q Tile_X0Y4_FrameData[17] VGND VPWR Tile_X0Y5_FrameStrobe[0] latch
XFILLER_119_112 VPWR VGND sg13cmos5l_decap_8
XFILLER_9_70 VPWR VGND sg13cmos5l_decap_8
X_1947_ Tile_X0Y1_E2BEGb[0] _2301_/X VPWR VGND sg13cmos5l_buf_1
XFILLER_119_49 VPWR VGND sg13cmos5l_decap_8
X_1878_ Tile_X0Y2_E6BEG[4] _2437_/X VPWR VGND sg13cmos5l_buf_1
XFILLER_134_126 VPWR VGND sg13cmos5l_decap_8
XFILLER_266_77 VPWR VGND sg13cmos5l_decap_8
X_0829_ _0829_/Q Tile_X0Y3_FrameData[25] VGND VPWR Tile_X0Y5_FrameStrobe[1] latch
XANTENNA__2131__X AXIL_S_SOC_RDATA25 VPWR VGND sg13cmos5l_antennanp
XFILLER_282_21 VPWR VGND sg13cmos5l_decap_8
XFILLER_88_202 VPWR VGND sg13cmos5l_decap_8
XANTENNA__1970__X Tile_X0Y5_E1BEG[3] VPWR VGND sg13cmos5l_antennanp
XFILLER_288_196 VPWR VGND sg13cmos5l_decap_8
XFILLER_215_70 VPWR VGND sg13cmos5l_decap_8
XFILLER_282_98 VPWR VGND sg13cmos5l_decap_8
XFILLER_151_14 VPWR VGND sg13cmos5l_decap_8
XFILLER_185_7 VPWR VGND sg13cmos5l_decap_8
XFILLER_28_35 VPWR VGND sg13cmos5l_decap_8
XFILLER_56_154 VPWR VGND sg13cmos5l_decap_8
XFILLER_231_91 VPWR VGND sg13cmos5l_decap_8
XFILLER_301_28 VPWR VGND sg13cmos5l_decap_8
XFILLER_71_157 VPWR VGND sg13cmos5l_decap_8
XFILLER_71_135 VPWR VGND sg13cmos5l_decap_8
XFILLER_352_7 VPWR VGND sg13cmos5l_decap_8
XFILLER_44_67 VPWR VGND sg13cmos5l_decap_8
XFILLER_358_112 VPWR VGND sg13cmos5l_decap_8
XFILLER_212_174 VPWR VGND sg13cmos5l_decap_8
XFILLER_212_185 VPWR VGND sg13cmos5l_fill_1
XFILLER_358_189 VPWR VGND sg13cmos5l_decap_8
XFILLER_100_84 VPWR VGND sg13cmos5l_decap_8
XFILLER_60_77 VPWR VGND sg13cmos5l_decap_8
XFILLER_176_77 VPWR VGND sg13cmos5l_decap_8
XFILLER_180_210 VPWR VGND sg13cmos5l_decap_8
XFILLER_326_14 VPWR VGND sg13cmos5l_decap_8
XFILLER_5_28 VPWR VGND sg13cmos5l_decap_8
XANTENNA__2041__X Tile_X0Y5_FrameData_O[26] VPWR VGND sg13cmos5l_antennanp
XFILLER_107_0 VPWR VGND sg13cmos5l_decap_8
XFILLER_140_107 VPWR VGND sg13cmos5l_decap_8
XFILLER_192_21 VPWR VGND sg13cmos5l_decap_8
XFILLER_279_152 VPWR VGND sg13cmos5l_fill_1
XFILLER_69_42 VPWR VGND sg13cmos5l_decap_8
XANTENNA__1880__X Tile_X0Y2_E6BEG[6] VPWR VGND sg13cmos5l_antennanp
XFILLER_125_70 VPWR VGND sg13cmos5l_decap_8
XFILLER_192_98 VPWR VGND sg13cmos5l_decap_8
XFILLER_294_133 VPWR VGND sg13cmos5l_decap_8
XFILLER_342_57 VPWR VGND sg13cmos5l_decap_8
XFILLER_235_222 VPWR VGND sg13cmos5l_decap_8
XFILLER_85_85 VPWR VGND sg13cmos5l_decap_8
XFILLER_47_176 VPWR VGND sg13cmos5l_decap_8
XFILLER_211_28 VPWR VGND sg13cmos5l_decap_8
XFILLER_62_168 VPWR VGND sg13cmos5l_decap_8
XFILLER_349_112 VPWR VGND sg13cmos5l_decap_8
X_1801_ Tile_X0Y4_E2BEGb[4] _2629_/X VPWR VGND sg13cmos5l_buf_1
XFILLER_349_189 VPWR VGND sg13cmos5l_decap_8
X_2781_ _2781_/X Tile_X0Y5_W1END[0] Tile_X0Y5_WW4END[10] Tile_X0Y5_WW4END[12] Tile_X0Y5_W6END[4]
+ _1340_/Q _1339_/Q VPWR VGND sg13cmos5l_mux4_1
X_1732_ Tile_X0Y0_E2BEG[4] _2169_/X VPWR VGND sg13cmos5l_buf_1
XFILLER_116_126 VPWR VGND sg13cmos5l_decap_8
XFILLER_236_14 VPWR VGND sg13cmos5l_decap_8
X_1663_ Tile_X0Y0_FrameData_O[3] Tile_X0Y0_FrameData[3] VPWR VGND sg13cmos5l_buf_1
X_0614_ _0614_/Q Tile_X0Y2_FrameData[0] VGND VPWR Tile_X0Y5_FrameStrobe[1] latch
X_1594_ Tile_X0Y2_EE4BEG[7] _2424_/X VPWR VGND sg13cmos5l_buf_1
XANTENNA__1790__X Tile_X0Y4_E2BEG[1] VPWR VGND sg13cmos5l_antennanp
X_0545_ _0545_/Q Tile_X0Y1_FrameData[21] VGND VPWR Tile_X0Y5_FrameStrobe[7] latch
XFILLER_22_0 VPWR VGND sg13cmos5l_decap_8
XFILLER_252_35 VPWR VGND sg13cmos5l_decap_8
XFILLER_316_91 VPWR VGND sg13cmos5l_decap_8
X_0476_ _0476_/Q Tile_X0Y1_FrameData[26] VGND VPWR Tile_X0Y5_FrameStrobe[5] latch
X_2215_ _2215_/X Tile_X0Y1_W1END[2] Tile_X0Y1_W6END[6] _2353_/X _2339_/X _0546_/Q
+ _0545_/Q VPWR VGND sg13cmos5l_mux4_1
X_2146_ _2146_/X Tile_X0Y0_W2MID[6] Tile_X0Y0_W2END[6] Tile_X0Y0_W6END[6] _2242_/X
+ _0300_/Q _0299_/Q VPWR VGND sg13cmos5l_mux4_1
XFILLER_93_271 VPWR VGND sg13cmos5l_fill_2
XFILLER_121_28 VPWR VGND sg13cmos5l_decap_8
XFILLER_241_203 VPWR VGND sg13cmos5l_decap_8
X_2077_ Tile_X0Y5_S4BEG[10] _2077_/A VPWR VGND sg13cmos5l_buf_1
XFILLER_241_258 VPWR VGND sg13cmos5l_decap_8
X_1028_ _1028_/Q Tile_X0Y3_FrameData[18] VGND VPWR Tile_X0Y5_FrameStrobe[7] latch
XFILLER_53_168 VPWR VGND sg13cmos5l_decap_8
XANTENNA__2126__X AXIL_S_SOC_RDATA20 VPWR VGND sg13cmos5l_antennanp
XFILLER_277_21 VPWR VGND sg13cmos5l_decap_8
XANTENNA__1965__X Tile_X0Y1_E1BEG[2] VPWR VGND sg13cmos5l_antennanp
XFILLER_355_126 VPWR VGND sg13cmos5l_decap_8
XFILLER_147_251 VPWR VGND sg13cmos5l_decap_8
XFILLER_147_262 VPWR VGND sg13cmos5l_fill_2
XFILLER_277_98 VPWR VGND sg13cmos5l_decap_8
XFILLER_30_14 VPWR VGND sg13cmos5l_decap_8
XFILLER_146_14 VPWR VGND sg13cmos5l_decap_8
XFILLER_162_221 VPWR VGND sg13cmos5l_decap_8
XFILLER_100_7 VPWR VGND sg13cmos5l_decap_8
XFILLER_107_159 VPWR VGND sg13cmos5l_decap_8
XFILLER_162_232 VPWR VGND sg13cmos5l_fill_2
XFILLER_293_42 VPWR VGND sg13cmos5l_decap_8
XFILLER_162_35 VPWR VGND sg13cmos5l_decap_8
XFILLER_39_56 VPWR VGND sg13cmos5l_decap_8
XFILLER_217_222 VPWR VGND sg13cmos5l_decap_8
XFILLER_291_147 VPWR VGND sg13cmos5l_decap_8
XFILLER_217_266 VPWR VGND sg13cmos5l_decap_8
XFILLER_312_49 VPWR VGND sg13cmos5l_decap_8
XFILLER_44_102 VPWR VGND sg13cmos5l_decap_8
XFILLER_232_225 VPWR VGND sg13cmos5l_decap_8
XFILLER_55_77 VPWR VGND sg13cmos5l_decap_8
XANTENNA__2036__X Tile_X0Y5_FrameData_O[21] VPWR VGND sg13cmos5l_antennanp
XFILLER_71_21 VPWR VGND sg13cmos5l_decap_8
XFILLER_187_21 VPWR VGND sg13cmos5l_decap_8
XANTENNA__1875__X Tile_X0Y2_E6BEG[1] VPWR VGND sg13cmos5l_antennanp
XFILLER_197_195 VPWR VGND sg13cmos5l_decap_4
XFILLER_200_144 VPWR VGND sg13cmos5l_fill_1
XFILLER_224_0 VPWR VGND sg13cmos5l_decap_8
XFILLER_346_126 VPWR VGND sg13cmos5l_fill_1
XFILLER_187_98 VPWR VGND sg13cmos5l_decap_8
XFILLER_346_159 VPWR VGND sg13cmos5l_decap_4
XFILLER_299_203 VPWR VGND sg13cmos5l_decap_8
XFILLER_361_118 VPWR VGND sg13cmos5l_fill_2
XFILLER_337_35 VPWR VGND sg13cmos5l_decap_8
XFILLER_206_28 VPWR VGND sg13cmos5l_decap_8
XFILLER_20_91 VPWR VGND sg13cmos5l_decap_8
XFILLER_302_229 VPWR VGND sg13cmos5l_fill_2
XFILLER_121_140 VPWR VGND sg13cmos5l_decap_8
X_0330_ _0330_/Q Tile_X0Y1_FrameData[12] VGND VPWR Tile_X0Y5_FrameStrobe[0] latch
XFILLER_353_56 VPWR VGND sg13cmos5l_decap_8
XFILLER_96_84 VPWR VGND sg13cmos5l_decap_8
XFILLER_267_188 VPWR VGND sg13cmos5l_fill_1
X_2000_ Tile_X0Y5_EE4BEG[1] _2742_/X VPWR VGND sg13cmos5l_buf_1
X_0261_ _0261_/Q Tile_X0Y0_FrameData[1] VGND VPWR Tile_X0Y5_FrameStrobe[5] latch
XFILLER_208_255 VPWR VGND sg13cmos5l_fill_2
XFILLER_222_49 VPWR VGND sg13cmos5l_decap_8
X_0192_ _0192_/Q Tile_X0Y0_FrameData[6] VGND VPWR Tile_X0Y5_FrameStrobe[3] latch
XFILLER_75_271 VPWR VGND sg13cmos5l_fill_2
XFILLER_90_241 VPWR VGND sg13cmos5l_fill_1
XFILLER_90_230 VPWR VGND sg13cmos5l_decap_8
XFILLER_90_263 VPWR VGND sg13cmos5l_decap_8
XFILLER_50_105 VPWR VGND sg13cmos5l_decap_8
XANTENNA__1785__X Tile_X0Y4_E1BEG[0] VPWR VGND sg13cmos5l_antennanp
X_2833_ _2833_/X Tile_X0Y4_W1END[0] Tile_X0Y4_W2MID[3] Tile_X0Y4_W2END[3] _2712_/X
+ _1116_/Q _1115_/Q VPWR VGND sg13cmos5l_mux4_1
X_2764_ _2764_/X AXIL_S_SOC_ARPROT2 _2823_/X _2814_/X _2828_/X _1374_/Q _1373_/Q VPWR
+ VGND sg13cmos5l_mux4_1
XFILLER_247_35 VPWR VGND sg13cmos5l_decap_8
X_1715_ Tile_X0Y0_E6BEG[7] _2204_/X VPWR VGND sg13cmos5l_buf_1
XFILLER_144_254 VPWR VGND sg13cmos5l_decap_8
X_2695_ _2695_/X _2236_/X _2234_/X _2222_/X _2221_/X _0148_/Q _0147_/Q VPWR VGND sg13cmos5l_mux4_1
X_1646_ Tile_X0Y0_FrameStrobe_O[6] Tile_X0Y5_FrameStrobe[6] VPWR VGND sg13cmos5l_buf_1
XFILLER_360_162 VPWR VGND sg13cmos5l_decap_8
XFILLER_116_28 VPWR VGND sg13cmos5l_decap_8
X_1577_ Tile_X0Y3_FrameData_O[23] Tile_X0Y3_FrameData[23] VPWR VGND sg13cmos5l_buf_1
XFILLER_112_140 VPWR VGND sg13cmos5l_decap_8
XFILLER_263_56 VPWR VGND sg13cmos5l_decap_8
X_0528_ _0528_/Q Tile_X0Y1_FrameData[6] VGND VPWR Tile_X0Y5_FrameStrobe[6] latch
XFILLER_58_205 VPWR VGND sg13cmos5l_decap_8
XFILLER_258_188 VPWR VGND sg13cmos5l_fill_1
X_0459_ _0459_/Q Tile_X0Y1_FrameData[11] VGND VPWR Tile_X0Y5_FrameStrobe[4] latch
XFILLER_132_49 VPWR VGND sg13cmos5l_decap_8
X_2129_ AXIL_S_SOC_RDATA23 Tile_X0Y1_W2MID[7] Tile_X0Y1_W2END[7] Tile_X0Y1_W6END[7]
+ _2380_/X _0368_/Q _0367_/Q VPWR VGND sg13cmos5l_mux4_1
XFILLER_214_225 VPWR VGND sg13cmos5l_decap_8
XFILLER_25_14 VPWR VGND sg13cmos5l_decap_8
XFILLER_26_168 VPWR VGND sg13cmos5l_decap_8
XFILLER_179_140 VPWR VGND sg13cmos5l_decap_8
XFILLER_288_42 VPWR VGND sg13cmos5l_decap_8
XFILLER_41_116 VPWR VGND sg13cmos5l_decap_8
XFILLER_148_7 VPWR VGND sg13cmos5l_decap_8
XANTENNA__1695__X Tile_X0Y0_EE4BEG[3] VPWR VGND sg13cmos5l_antennanp
XFILLER_315_7 VPWR VGND sg13cmos5l_decap_8
XFILLER_328_159 VPWR VGND sg13cmos5l_fill_1
XFILLER_41_46 VPWR VGND sg13cmos5l_decap_8
XFILLER_157_35 VPWR VGND sg13cmos5l_decap_8
XFILLER_307_49 VPWR VGND sg13cmos5l_decap_8
XFILLER_351_140 VPWR VGND sg13cmos5l_decap_8
XFILLER_150_246 VPWR VGND sg13cmos5l_decap_8
XFILLER_296_217 VPWR VGND sg13cmos5l_decap_8
XFILLER_173_56 VPWR VGND sg13cmos5l_decap_8
XFILLER_49_238 VPWR VGND sg13cmos5l_decap_4
XFILLER_66_21 VPWR VGND sg13cmos5l_decap_8
XFILLER_174_0 VPWR VGND sg13cmos5l_decap_8
XFILLER_66_98 VPWR VGND sg13cmos5l_decap_8
XFILLER_32_105 VPWR VGND sg13cmos5l_decap_8
XFILLER_205_269 VPWR VGND sg13cmos5l_decap_4
XFILLER_220_206 VPWR VGND sg13cmos5l_decap_4
XFILLER_82_42 VPWR VGND sg13cmos5l_decap_8
XFILLER_341_0 VPWR VGND sg13cmos5l_decap_8
XFILLER_198_42 VPWR VGND sg13cmos5l_decap_8
XFILLER_25_190 VPWR VGND sg13cmos5l_decap_8
XFILLER_15_91 VPWR VGND sg13cmos5l_decap_8
XFILLER_348_56 VPWR VGND sg13cmos5l_decap_8
XFILLER_63_7 VPWR VGND sg13cmos5l_decap_8
XFILLER_141_202 VPWR VGND sg13cmos5l_fill_2
XFILLER_217_49 VPWR VGND sg13cmos5l_decap_8
X_1500_ _2563_/A3 VPWR VGND sg13cmos5l_tielo
X_2480_ _2480_/X _2458_/X Tile_X0Y5_N4END[12] _2457_/X Tile_X0Y0_S4END[8] _0606_/Q
+ _0605_/Q VPWR VGND sg13cmos5l_mux4_1
XFILLER_99_105 VPWR VGND sg13cmos5l_decap_8
X_1431_ _1431_/Q Tile_X0Y5_FrameData[25] VGND VPWR Tile_X0Y5_FrameStrobe[5] latch
XFILLER_99_127 VPWR VGND sg13cmos5l_decap_4
X_1362_ _1362_/Q Tile_X0Y5_FrameData[30] VGND VPWR Tile_X0Y5_FrameStrobe[3] latch
XFILLER_255_125 VPWR VGND sg13cmos5l_decap_4
X_1293_ _1293_/Q Tile_X0Y5_FrameData[3] VGND VPWR Tile_X0Y5_FrameStrobe[0] latch
X_0313_ _0313_/Q Tile_X0Y1_FrameData[29] VGND VPWR Tile_X0Y5_FrameStrobe[0] latch
XFILLER_255_158 VPWR VGND sg13cmos5l_fill_1
X_0244_ _0244_/Q Tile_X0Y0_FrameData[18] VGND VPWR Tile_X0Y5_FrameStrobe[5] latch
XFILLER_48_271 VPWR VGND sg13cmos5l_fill_2
XFILLER_313_70 VPWR VGND sg13cmos5l_decap_8
XFILLER_263_191 VPWR VGND sg13cmos5l_decap_8
X_0175_ _0175_/Q Tile_X0Y0_FrameData[23] VGND VPWR Tile_X0Y5_FrameStrobe[3] latch
XFILLER_23_105 VPWR VGND sg13cmos5l_decap_8
XFILLER_23_138 VPWR VGND sg13cmos5l_fill_2
XFILLER_211_239 VPWR VGND sg13cmos5l_decap_8
XFILLER_176_154 VPWR VGND sg13cmos5l_decap_8
XFILLER_258_56 VPWR VGND sg13cmos5l_decap_8
X_2816_ _2816_/X _2367_/X _2365_/X _2350_/X _2349_/X _0385_/Q _0384_/Q VPWR VGND sg13cmos5l_mux4_1
XFILLER_117_210 VPWR VGND sg13cmos5l_decap_8
XFILLER_176_176 VPWR VGND sg13cmos5l_decap_8
XFILLER_176_198 VPWR VGND sg13cmos5l_decap_8
XFILLER_191_102 VPWR VGND sg13cmos5l_fill_1
XFILLER_11_49 VPWR VGND sg13cmos5l_decap_8
X_2747_ _2747_/X AXIL_S_SOC_ARPROT0 AXIL_S_SOC_ARPROT1 _2810_/X _2826_/X _1408_/Q
+ _1407_/Q VPWR VGND sg13cmos5l_mux4_1
XFILLER_127_49 VPWR VGND sg13cmos5l_decap_8
XFILLER_333_162 VPWR VGND sg13cmos5l_fill_2
X_2678_ _2678_/X Tile_X0Y5_W1END[2] Tile_X0Y5_W6END[6] _2805_/X _2791_/X _1492_/Q
+ _1491_/Q VPWR VGND sg13cmos5l_mux4_1
XFILLER_274_77 VPWR VGND sg13cmos5l_decap_8
X_1629_ Tile_X0Y0_N2BEG[1] _2146_/X VPWR VGND sg13cmos5l_buf_1
XFILLER_290_21 VPWR VGND sg13cmos5l_decap_8
XFILLER_98_171 VPWR VGND sg13cmos5l_decap_8
XFILLER_100_132 VPWR VGND sg13cmos5l_decap_4
XFILLER_286_272 VPWR VGND sg13cmos5l_fill_1
XFILLER_246_147 VPWR VGND sg13cmos5l_decap_8
XFILLER_290_98 VPWR VGND sg13cmos5l_decap_8
XFILLER_223_70 VPWR VGND sg13cmos5l_decap_8
XFILLER_36_35 VPWR VGND sg13cmos5l_decap_8
XFILLER_265_7 VPWR VGND sg13cmos5l_decap_8
XFILLER_54_241 VPWR VGND sg13cmos5l_decap_8
XFILLER_14_105 VPWR VGND sg13cmos5l_decap_8
XFILLER_299_63 VPWR VGND sg13cmos5l_decap_8
XFILLER_52_56 VPWR VGND sg13cmos5l_decap_8
XFILLER_356_210 VPWR VGND sg13cmos5l_decap_8
XFILLER_168_56 VPWR VGND sg13cmos5l_decap_8
XFILLER_108_243 VPWR VGND sg13cmos5l_decap_4
XFILLER_182_168 VPWR VGND sg13cmos5l_fill_2
XFILLER_184_77 VPWR VGND sg13cmos5l_decap_8
XFILLER_269_206 VPWR VGND sg13cmos5l_fill_2
XFILLER_334_14 VPWR VGND sg13cmos5l_decap_8
XFILLER_291_0 VPWR VGND sg13cmos5l_decap_8
XFILLER_77_42 VPWR VGND sg13cmos5l_decap_8
XFILLER_277_272 VPWR VGND sg13cmos5l_fill_1
XFILLER_237_147 VPWR VGND sg13cmos5l_decap_8
XFILLER_37_219 VPWR VGND sg13cmos5l_decap_8
XFILLER_133_70 VPWR VGND sg13cmos5l_decap_8
XFILLER_350_35 VPWR VGND sg13cmos5l_decap_8
XFILLER_93_63 VPWR VGND sg13cmos5l_decap_8
XANTENNA_240 AXIL_S_SOC_WDATA22 VPWR VGND sg13cmos5l_antennanp
XANTENNA_251 AXIL_S_SOC_WDATA22 VPWR VGND sg13cmos5l_antennanp
XANTENNA_262 AXIL_S_SOC_WDATA22 VPWR VGND sg13cmos5l_antennanp
XANTENNA_273 AXIL_S_SOC_WDATA22 VPWR VGND sg13cmos5l_antennanp
XANTENNA_284 AXIL_S_SOC_WDATA22 VPWR VGND sg13cmos5l_antennanp
XANTENNA_295 AXIL_S_SOC_WDATA19 VPWR VGND sg13cmos5l_antennanp
X_1980_ Tile_X0Y5_E2BEGb[1] _2734_/X VPWR VGND sg13cmos5l_buf_1
XFILLER_20_119 VPWR VGND sg13cmos5l_decap_4
X_0931_ _0931_/Q Tile_X0Y3_FrameData[19] VGND VPWR Tile_X0Y5_FrameStrobe[4] latch
XFILLER_359_77 VPWR VGND sg13cmos5l_decap_8
XFILLER_201_261 VPWR VGND sg13cmos5l_fill_1
X_0862_ _0862_/Q Tile_X0Y3_FrameData[24] VGND VPWR Tile_X0Y5_FrameStrobe[2] latch
XFILLER_9_175 VPWR VGND sg13cmos5l_decap_4
XFILLER_362_213 VPWR VGND sg13cmos5l_decap_8
X_2601_ _2601_/X Tile_X0Y2_W2MID[5] Tile_X0Y2_W2END[5] Tile_X0Y2_W6END[10] _2483_/X
+ _0646_/Q _0645_/Q VPWR VGND sg13cmos5l_mux4_1
X_0793_ _0793_/Q Tile_X0Y3_FrameData[29] VGND VPWR Tile_X0Y5_FrameStrobe[0] latch
XFILLER_362_246 VPWR VGND sg13cmos5l_decap_8
XFILLER_173_168 VPWR VGND sg13cmos5l_decap_8
XFILLER_315_140 VPWR VGND sg13cmos5l_decap_4
X_2532_ _2532_/X AXIL_S_SOC_ARADDR1 AXIL_S_SOC_ARADDR7 _2580_/X _2589_/X _0940_/Q
+ _0939_/Q VPWR VGND sg13cmos5l_mux4_1
XFILLER_362_268 VPWR VGND sg13cmos5l_decap_4
XFILLER_362_257 VPWR VGND sg13cmos5l_fill_2
XFILLER_114_213 VPWR VGND sg13cmos5l_fill_2
XFILLER_181_190 VPWR VGND sg13cmos5l_decap_8
XFILLER_308_70 VPWR VGND sg13cmos5l_decap_8
XFILLER_114_246 VPWR VGND sg13cmos5l_decap_8
XFILLER_244_14 VPWR VGND sg13cmos5l_decap_8
X_2463_ _2463_/X Tile_X0Y1_W1END[3] Tile_X0Y1_W6END[11] _2349_/X _2340_/X _0412_/Q
+ _0411_/Q VPWR VGND sg13cmos5l_mux4_1
XFILLER_330_165 VPWR VGND sg13cmos5l_fill_1
X_1414_ _1414_/Q Tile_X0Y5_FrameData[10] VGND VPWR Tile_X0Y5_FrameStrobe[4] latch
X_2394_ _2394_/X Tile_X0Y3_W2MID[1] Tile_X0Y3_W2END[1] Tile_X0Y3_W6END[1] _2595_/X
+ _1010_/Q _1009_/Q VPWR VGND sg13cmos5l_mux4_1
X_1345_ _1345_/Q Tile_X0Y5_FrameData[15] VGND VPWR Tile_X0Y5_FrameStrobe[2] latch
XFILLER_228_147 VPWR VGND sg13cmos5l_decap_8
XFILLER_283_242 VPWR VGND sg13cmos5l_decap_4
XFILLER_324_91 VPWR VGND sg13cmos5l_decap_8
XFILLER_260_35 VPWR VGND sg13cmos5l_decap_8
X_1276_ _1276_/Q Tile_X0Y5_FrameData[20] VGND VPWR Tile_X0Y5_FrameStrobe[0] latch
XFILLER_236_191 VPWR VGND sg13cmos5l_decap_8
X_0227_ _0227_/Q Tile_X0Y0_FrameData[3] VGND VPWR Tile_X0Y5_FrameStrobe[4] latch
XFILLER_251_150 VPWR VGND sg13cmos5l_fill_1
X_0158_ _0158_/Q Tile_X0Y0_FrameData[8] VGND VPWR Tile_X0Y5_FrameStrobe[2] latch
XFILLER_51_211 VPWR VGND sg13cmos5l_decap_8
XFILLER_11_119 VPWR VGND sg13cmos5l_decap_8
XFILLER_269_77 VPWR VGND sg13cmos5l_decap_8
X_0089_ _0089_/Q Tile_X0Y0_FrameData[13] VGND VPWR Tile_X0Y5_FrameStrobe[0] latch
XANTENNA__2134__X AXIL_S_SOC_RDATA28 VPWR VGND sg13cmos5l_antennanp
XFILLER_164_102 VPWR VGND sg13cmos5l_fill_2
XFILLER_285_21 VPWR VGND sg13cmos5l_decap_8
XFILLER_353_224 VPWR VGND sg13cmos5l_decap_8
XANTENNA__1973__X Tile_X0Y5_E2BEG[2] VPWR VGND sg13cmos5l_antennanp
XFILLER_285_98 VPWR VGND sg13cmos5l_decap_8
XFILLER_306_140 VPWR VGND sg13cmos5l_decap_8
XFILLER_353_257 VPWR VGND sg13cmos5l_decap_4
XFILLER_105_235 VPWR VGND sg13cmos5l_decap_8
XFILLER_218_70 VPWR VGND sg13cmos5l_decap_8
XFILLER_154_14 VPWR VGND sg13cmos5l_decap_8
XFILLER_321_132 VPWR VGND sg13cmos5l_fill_2
XFILLER_259_272 VPWR VGND sg13cmos5l_fill_1
XFILLER_304_28 VPWR VGND sg13cmos5l_decap_8
XFILLER_86_141 VPWR VGND sg13cmos5l_decap_8
XFILLER_234_91 VPWR VGND sg13cmos5l_decap_8
XFILLER_274_220 VPWR VGND sg13cmos5l_decap_8
XFILLER_86_152 VPWR VGND sg13cmos5l_fill_1
XFILLER_170_35 VPWR VGND sg13cmos5l_decap_8
XFILLER_47_56 VPWR VGND sg13cmos5l_decap_8
XFILLER_227_180 VPWR VGND sg13cmos5l_decap_8
XFILLER_103_84 VPWR VGND sg13cmos5l_decap_8
XFILLER_320_49 VPWR VGND sg13cmos5l_decap_8
XFILLER_242_161 VPWR VGND sg13cmos5l_decap_8
XFILLER_63_77 VPWR VGND sg13cmos5l_decap_8
XFILLER_137_0 VPWR VGND sg13cmos5l_decap_8
XFILLER_179_77 VPWR VGND sg13cmos5l_decap_8
XFILLER_329_14 VPWR VGND sg13cmos5l_decap_8
XFILLER_329_243 VPWR VGND sg13cmos5l_fill_1
XFILLER_8_28 VPWR VGND sg13cmos5l_decap_8
XANTENNA__2044__X Tile_X0Y5_FrameData_O[29] VPWR VGND sg13cmos5l_antennanp
XFILLER_195_21 VPWR VGND sg13cmos5l_decap_8
XFILLER_329_265 VPWR VGND sg13cmos5l_fill_1
XANTENNA__1883__X Tile_X0Y2_E6BEG[9] VPWR VGND sg13cmos5l_antennanp
XFILLER_10_196 VPWR VGND sg13cmos5l_fill_1
XFILLER_12_70 VPWR VGND sg13cmos5l_decap_8
XFILLER_170_105 VPWR VGND sg13cmos5l_decap_8
XFILLER_304_0 VPWR VGND sg13cmos5l_decap_8
XFILLER_128_70 VPWR VGND sg13cmos5l_decap_8
XFILLER_195_98 VPWR VGND sg13cmos5l_decap_8
XFILLER_345_35 VPWR VGND sg13cmos5l_decap_8
XFILLER_88_63 VPWR VGND sg13cmos5l_decap_8
XFILLER_69_119 VPWR VGND sg13cmos5l_decap_8
XFILLER_33_8 VPWR VGND sg13cmos5l_decap_8
XFILLER_214_28 VPWR VGND sg13cmos5l_decap_8
XFILLER_26_7 VPWR VGND sg13cmos5l_decap_8
XFILLER_312_198 VPWR VGND sg13cmos5l_decap_8
XFILLER_265_220 VPWR VGND sg13cmos5l_fill_1
X_1130_ _1130_/Q Tile_X0Y4_FrameData[28] VGND VPWR Tile_X0Y5_FrameStrobe[3] latch
XFILLER_361_56 VPWR VGND sg13cmos5l_fill_2
X_1061_ _1061_/Q Tile_X0Y4_FrameData[1] VGND VPWR Tile_X0Y5_FrameStrobe[0] latch
XFILLER_92_166 VPWR VGND sg13cmos5l_decap_8
XFILLER_218_191 VPWR VGND sg13cmos5l_decap_8
XFILLER_230_49 VPWR VGND sg13cmos5l_decap_8
XFILLER_233_161 VPWR VGND sg13cmos5l_decap_4
XFILLER_239_14 VPWR VGND sg13cmos5l_decap_8
X_1963_ Tile_X0Y1_E1BEG[0] _2289_/X VPWR VGND sg13cmos5l_buf_1
XFILLER_186_271 VPWR VGND sg13cmos5l_fill_2
X_1894_ Tile_X0Y1_FrameData_O[7] Tile_X0Y1_FrameData[7] VPWR VGND sg13cmos5l_buf_1
X_0914_ _0914_/Q Tile_X0Y3_FrameData[4] VGND VPWR Tile_X0Y5_FrameStrobe[3] latch
X_0845_ _0845_/Q Tile_X0Y3_FrameData[9] VGND VPWR Tile_X0Y5_FrameStrobe[1] latch
XANTENNA__1793__X Tile_X0Y4_E2BEG[4] VPWR VGND sg13cmos5l_antennanp
XFILLER_146_179 VPWR VGND sg13cmos5l_decap_8
XFILLER_319_91 VPWR VGND sg13cmos5l_decap_8
XFILLER_255_35 VPWR VGND sg13cmos5l_decap_8
X_0776_ _0776_/Q Tile_X0Y2_FrameData[30] VGND VPWR Tile_X0Y5_FrameStrobe[7] latch
XFILLER_52_0 VPWR VGND sg13cmos5l_decap_8
X_2515_ _2515_/X AXIL_S_SOC_ARADDR4 AXIL_S_SOC_ARADDR6 _2590_/X _2595_/X _0974_/Q
+ _0973_/Q VPWR VGND sg13cmos5l_mux4_1
XFILLER_248_209 VPWR VGND sg13cmos5l_decap_8
XFILLER_303_154 VPWR VGND sg13cmos5l_decap_8
X_2446_ _2446_/X _2480_/X _2479_/X _2472_/X _2471_/X _0634_/Q _0633_/Q VPWR VGND sg13cmos5l_mux4_1
XFILLER_102_238 VPWR VGND sg13cmos5l_decap_4
XFILLER_124_28 VPWR VGND sg13cmos5l_decap_8
XFILLER_271_56 VPWR VGND sg13cmos5l_decap_8
X_2377_ _2377_/X _2257_/X _2390_/X _2389_/X Tile_X0Y0_S2MID[4] _0326_/Q _0325_/Q VPWR
+ VGND sg13cmos5l_mux4_1
X_1328_ _1328_/Q Tile_X0Y5_FrameData[0] VGND VPWR Tile_X0Y5_FrameStrobe[1] latch
XANTENNA__2129__X AXIL_S_SOC_RDATA23 VPWR VGND sg13cmos5l_antennanp
X_1259_ _1259_/Q Tile_X0Y4_FrameData[27] VGND VPWR Tile_X0Y5_FrameStrobe[7] latch
XFILLER_140_49 VPWR VGND sg13cmos5l_decap_8
XANTENNA__1968__X Tile_X0Y5_E1BEG[1] VPWR VGND sg13cmos5l_antennanp
XFILLER_169_238 VPWR VGND sg13cmos5l_decap_8
XFILLER_224_183 VPWR VGND sg13cmos5l_decap_8
XFILLER_149_14 VPWR VGND sg13cmos5l_decap_8
XFILLER_33_36 VPWR VGND sg13cmos5l_decap_8
XFILLER_130_7 VPWR VGND sg13cmos5l_decap_8
XFILLER_177_271 VPWR VGND sg13cmos5l_fill_2
XFILLER_228_7 VPWR VGND sg13cmos5l_decap_8
XFILLER_296_42 VPWR VGND sg13cmos5l_decap_8
XFILLER_137_124 VPWR VGND sg13cmos5l_decap_8
XFILLER_192_241 VPWR VGND sg13cmos5l_decap_8
XFILLER_152_105 VPWR VGND sg13cmos5l_decap_4
XFILLER_229_91 VPWR VGND sg13cmos5l_decap_8
XFILLER_3_126 VPWR VGND sg13cmos5l_decap_8
XFILLER_165_57 VPWR VGND sg13cmos5l_decap_8
XFILLER_3_148 VPWR VGND sg13cmos5l_fill_1
XFILLER_315_49 VPWR VGND sg13cmos5l_decap_8
XFILLER_181_56 VPWR VGND sg13cmos5l_decap_8
XFILLER_247_231 VPWR VGND sg13cmos5l_fill_2
XFILLER_58_77 VPWR VGND sg13cmos5l_decap_8
XFILLER_59_196 VPWR VGND sg13cmos5l_fill_1
XANTENNA__2039__X Tile_X0Y5_FrameData_O[24] VPWR VGND sg13cmos5l_antennanp
XFILLER_74_21 VPWR VGND sg13cmos5l_decap_8
XANTENNA__1878__X Tile_X0Y2_E6BEG[4] VPWR VGND sg13cmos5l_antennanp
XFILLER_254_0 VPWR VGND sg13cmos5l_decap_8
XFILLER_74_98 VPWR VGND sg13cmos5l_decap_8
XFILLER_90_64 VPWR VGND sg13cmos5l_decap_8
XFILLER_168_271 VPWR VGND sg13cmos5l_fill_2
XFILLER_30_269 VPWR VGND sg13cmos5l_decap_4
XFILLER_23_91 VPWR VGND sg13cmos5l_decap_8
XFILLER_139_91 VPWR VGND sg13cmos5l_fill_2
XFILLER_209_28 VPWR VGND sg13cmos5l_decap_8
XFILLER_356_56 VPWR VGND sg13cmos5l_decap_8
X_0630_ _0630_/Q Tile_X0Y2_FrameData[16] VGND VPWR Tile_X0Y5_FrameStrobe[2] latch
X_0561_ _0561_/Q Tile_X0Y2_FrameData[21] VGND VPWR Tile_X0Y5_FrameStrobe[0] latch
XFILLER_99_84 VPWR VGND sg13cmos5l_decap_8
X_2300_ _2300_/X AXIL_S_SOC_WDATA7 AXIL_S_SOC_WDATA15 _2373_/X _2380_/X _0492_/Q _0491_/Q
+ VPWR VGND sg13cmos5l_mux4_1
XFILLER_151_182 VPWR VGND sg13cmos5l_fill_1
XFILLER_225_49 VPWR VGND sg13cmos5l_decap_8
XFILLER_297_175 VPWR VGND sg13cmos5l_decap_8
X_2231_ _2231_/X Tile_X0Y4_W1END[3] Tile_X0Y4_WW4END[3] Tile_X0Y4_W6END[11] _2702_/X
+ _1231_/Q _1230_/Q VPWR VGND sg13cmos5l_mux4_1
X_0492_ _0492_/Q Tile_X0Y1_FrameData[10] VGND VPWR Tile_X0Y5_FrameStrobe[5] latch
XFILLER_97_236 VPWR VGND sg13cmos5l_decap_8
XFILLER_238_220 VPWR VGND sg13cmos5l_decap_8
XFILLER_300_168 VPWR VGND sg13cmos5l_decap_8
XFILLER_238_253 VPWR VGND sg13cmos5l_decap_4
X_2162_ _2162_/X _2214_/X Tile_X0Y0_S1END[1] AXIL_S_SOC_WDATA19 AXIL_S_SOC_WDATA22
+ _0272_/Q _0271_/Q VPWR VGND sg13cmos5l_mux4_1
X_2093_ Tile_X0Y3_E2BEG[5] _2514_/X VPWR VGND sg13cmos5l_buf_1
X_1113_ _1113_/Q Tile_X0Y4_FrameData[13] VGND VPWR Tile_X0Y5_FrameStrobe[2] latch
XFILLER_65_133 VPWR VGND sg13cmos5l_decap_8
X_1044_ _1044_/Q Tile_X0Y4_FrameData[18] VGND VPWR Tile_X0Y5_FrameStrobe[0] latch
XANTENNA__1788__X Tile_X0Y4_E1BEG[3] VPWR VGND sg13cmos5l_antennanp
XFILLER_0_84 VPWR VGND sg13cmos5l_decap_8
XFILLER_206_150 VPWR VGND sg13cmos5l_fill_1
XFILLER_166_219 VPWR VGND sg13cmos5l_fill_1
XFILLER_221_186 VPWR VGND sg13cmos5l_decap_8
XFILLER_174_230 VPWR VGND sg13cmos5l_fill_2
X_1946_ Tile_X0Y1_E6BEG[11] _2336_/X VPWR VGND sg13cmos5l_buf_1
XFILLER_119_168 VPWR VGND sg13cmos5l_decap_8
XFILLER_119_179 VPWR VGND sg13cmos5l_fill_2
XFILLER_119_28 VPWR VGND sg13cmos5l_decap_8
XFILLER_134_105 VPWR VGND sg13cmos5l_decap_8
XFILLER_266_56 VPWR VGND sg13cmos5l_decap_8
X_1877_ Tile_X0Y2_E6BEG[3] _2436_/X VPWR VGND sg13cmos5l_buf_1
X_0828_ _0828_/Q Tile_X0Y3_FrameData[26] VGND VPWR Tile_X0Y5_FrameStrobe[1] latch
X_0759_ _0759_/Q Tile_X0Y2_FrameData[15] VGND VPWR Tile_X0Y5_FrameStrobe[6] latch
XFILLER_135_49 VPWR VGND sg13cmos5l_decap_8
XFILLER_282_77 VPWR VGND sg13cmos5l_decap_8
XFILLER_288_175 VPWR VGND sg13cmos5l_decap_8
XFILLER_28_14 VPWR VGND sg13cmos5l_decap_8
X_2429_ _2429_/X AXIL_S_SOC_AWADDR0 AXIL_S_SOC_AWPROT2 _2475_/X _2484_/X _0690_/Q
+ _0689_/Q VPWR VGND sg13cmos5l_mux4_1
XFILLER_244_223 VPWR VGND sg13cmos5l_fill_1
XFILLER_56_133 VPWR VGND sg13cmos5l_decap_8
XFILLER_178_7 VPWR VGND sg13cmos5l_decap_8
XANTENNA__1698__X Tile_X0Y0_EE4BEG[6] VPWR VGND sg13cmos5l_antennanp
XFILLER_231_70 VPWR VGND sg13cmos5l_decap_8
XFILLER_44_46 VPWR VGND sg13cmos5l_decap_8
XFILLER_345_7 VPWR VGND sg13cmos5l_decap_8
XFILLER_212_153 VPWR VGND sg13cmos5l_decap_8
XFILLER_100_63 VPWR VGND sg13cmos5l_decap_8
XFILLER_157_219 VPWR VGND sg13cmos5l_decap_8
XFILLER_358_168 VPWR VGND sg13cmos5l_decap_8
XFILLER_176_56 VPWR VGND sg13cmos5l_decap_8
XFILLER_60_56 VPWR VGND sg13cmos5l_decap_8
XFILLER_125_105 VPWR VGND sg13cmos5l_decap_8
XFILLER_69_21 VPWR VGND sg13cmos5l_decap_8
XFILLER_192_77 VPWR VGND sg13cmos5l_decap_8
XFILLER_294_112 VPWR VGND sg13cmos5l_decap_8
XFILLER_69_98 VPWR VGND sg13cmos5l_decap_8
XFILLER_94_217 VPWR VGND sg13cmos5l_decap_8
XFILLER_342_36 VPWR VGND sg13cmos5l_decap_8
XFILLER_235_212 VPWR VGND sg13cmos5l_fill_2
XFILLER_294_189 VPWR VGND sg13cmos5l_decap_8
XFILLER_85_64 VPWR VGND sg13cmos5l_decap_8
XFILLER_47_133 VPWR VGND sg13cmos5l_decap_8
XFILLER_141_70 VPWR VGND sg13cmos5l_decap_8
XFILLER_18_91 VPWR VGND sg13cmos5l_decap_8
XFILLER_62_147 VPWR VGND sg13cmos5l_decap_8
XFILLER_250_237 VPWR VGND sg13cmos5l_fill_2
XFILLER_93_7 VPWR VGND sg13cmos5l_decap_8
XFILLER_148_219 VPWR VGND sg13cmos5l_decap_8
XFILLER_203_175 VPWR VGND sg13cmos5l_fill_2
X_1800_ Tile_X0Y4_E2BEGb[3] _2628_/X VPWR VGND sg13cmos5l_buf_1
XFILLER_349_168 VPWR VGND sg13cmos5l_decap_8
X_2780_ _2780_/X Tile_X0Y5_W1END[3] Tile_X0Y5_W2MID[0] Tile_X0Y5_W2END[0] _2797_/X
+ _1342_/Q _1341_/Q VPWR VGND sg13cmos5l_mux4_1
X_1731_ Tile_X0Y0_E2BEG[3] _2168_/X VPWR VGND sg13cmos5l_buf_1
XFILLER_116_105 VPWR VGND sg13cmos5l_decap_8
XFILLER_171_200 VPWR VGND sg13cmos5l_decap_8
X_1662_ Tile_X0Y0_FrameData_O[2] Tile_X0Y0_FrameData[2] VPWR VGND sg13cmos5l_buf_1
XFILLER_171_255 VPWR VGND sg13cmos5l_fill_1
X_0613_ _0613_/Q Tile_X0Y2_FrameData[1] VGND VPWR Tile_X0Y5_FrameStrobe[1] latch
X_1593_ Tile_X0Y2_EE4BEG[6] _2423_/X VPWR VGND sg13cmos5l_buf_1
XFILLER_124_182 VPWR VGND sg13cmos5l_fill_2
XFILLER_285_112 VPWR VGND sg13cmos5l_decap_8
XFILLER_316_70 VPWR VGND sg13cmos5l_decap_8
X_0544_ _0544_/Q Tile_X0Y1_FrameData[22] VGND VPWR Tile_X0Y5_FrameStrobe[7] latch
XFILLER_252_14 VPWR VGND sg13cmos5l_decap_8
X_0475_ _0475_/Q Tile_X0Y1_FrameData[27] VGND VPWR Tile_X0Y5_FrameStrobe[5] latch
X_2214_ _2214_/X Tile_X0Y1_W1END[1] Tile_X0Y1_W6END[5] _2357_/X _2338_/X _0548_/Q
+ _0547_/Q VPWR VGND sg13cmos5l_mux4_1
XFILLER_15_0 VPWR VGND sg13cmos5l_decap_8
XFILLER_285_189 VPWR VGND sg13cmos5l_decap_4
X_2145_ _2145_/X Tile_X0Y0_W2MID[7] Tile_X0Y0_W2END[7] Tile_X0Y0_W6END[7] _2241_/X
+ _0302_/Q _0301_/Q VPWR VGND sg13cmos5l_mux4_1
XFILLER_38_155 VPWR VGND sg13cmos5l_fill_1
XFILLER_332_91 VPWR VGND sg13cmos5l_decap_8
X_2076_ Tile_X0Y5_S4BEG[9] _2076_/A VPWR VGND sg13cmos5l_buf_1
XFILLER_53_147 VPWR VGND sg13cmos5l_decap_8
XFILLER_198_119 VPWR VGND sg13cmos5l_decap_8
XFILLER_241_237 VPWR VGND sg13cmos5l_decap_8
X_1027_ _1027_/Q Tile_X0Y3_FrameData[19] VGND VPWR Tile_X0Y5_FrameStrobe[7] latch
XFILLER_14_49 VPWR VGND sg13cmos5l_decap_8
XFILLER_201_84 VPWR VGND sg13cmos5l_decap_4
XFILLER_201_95 VPWR VGND sg13cmos5l_decap_8
XFILLER_355_105 VPWR VGND sg13cmos5l_decap_8
XFILLER_277_77 VPWR VGND sg13cmos5l_decap_8
X_1929_ Tile_X0Y1_EE4BEG[10] _2319_/X VPWR VGND sg13cmos5l_buf_1
XFILLER_107_105 VPWR VGND sg13cmos5l_decap_8
XFILLER_107_116 VPWR VGND sg13cmos5l_fill_1
XFILLER_107_138 VPWR VGND sg13cmos5l_decap_8
XFILLER_162_255 VPWR VGND sg13cmos5l_decap_8
XFILLER_293_21 VPWR VGND sg13cmos5l_decap_8
XANTENNA__1981__X Tile_X0Y5_E2BEGb[2] VPWR VGND sg13cmos5l_antennanp
XFILLER_122_119 VPWR VGND sg13cmos5l_decap_8
XFILLER_293_98 VPWR VGND sg13cmos5l_decap_8
XFILLER_304_260 VPWR VGND sg13cmos5l_fill_2
XFILLER_162_14 VPWR VGND sg13cmos5l_decap_8
XFILLER_226_92 VPWR VGND sg13cmos5l_decap_8
XFILLER_295_7 VPWR VGND sg13cmos5l_decap_8
XFILLER_39_35 VPWR VGND sg13cmos5l_decap_8
XFILLER_291_126 VPWR VGND sg13cmos5l_decap_8
XFILLER_312_28 VPWR VGND sg13cmos5l_decap_8
XFILLER_242_91 VPWR VGND sg13cmos5l_decap_8
XFILLER_84_272 VPWR VGND sg13cmos5l_fill_1
XFILLER_84_261 VPWR VGND sg13cmos5l_fill_1
XFILLER_55_56 VPWR VGND sg13cmos5l_decap_8
XFILLER_44_169 VPWR VGND sg13cmos5l_decap_8
XFILLER_111_84 VPWR VGND sg13cmos5l_decap_8
XFILLER_346_105 VPWR VGND sg13cmos5l_decap_8
XFILLER_200_123 VPWR VGND sg13cmos5l_decap_8
XFILLER_71_77 VPWR VGND sg13cmos5l_decap_8
XFILLER_346_138 VPWR VGND sg13cmos5l_decap_8
XFILLER_187_77 VPWR VGND sg13cmos5l_decap_8
XFILLER_337_14 VPWR VGND sg13cmos5l_decap_8
XANTENNA__2052__X Tile_X0Y5_S2BEG[1] VPWR VGND sg13cmos5l_antennanp
XFILLER_217_0 VPWR VGND sg13cmos5l_decap_8
XFILLER_299_215 VPWR VGND sg13cmos5l_decap_8
XFILLER_299_226 VPWR VGND sg13cmos5l_fill_2
XFILLER_354_182 VPWR VGND sg13cmos5l_decap_8
XANTENNA__1891__X Tile_X0Y1_FrameData_O[4] VPWR VGND sg13cmos5l_antennanp
XFILLER_113_119 VPWR VGND sg13cmos5l_decap_8
XFILLER_20_70 VPWR VGND sg13cmos5l_decap_8
XFILLER_299_259 VPWR VGND sg13cmos5l_decap_4
XFILLER_136_70 VPWR VGND sg13cmos5l_decap_8
XFILLER_353_35 VPWR VGND sg13cmos5l_decap_8
XFILLER_121_174 VPWR VGND sg13cmos5l_decap_4
X_0260_ _0260_/Q Tile_X0Y0_FrameData[2] VGND VPWR Tile_X0Y5_FrameStrobe[5] latch
XFILLER_96_63 VPWR VGND sg13cmos5l_decap_8
XFILLER_208_212 VPWR VGND sg13cmos5l_fill_2
XFILLER_282_126 VPWR VGND sg13cmos5l_decap_8
XFILLER_222_28 VPWR VGND sg13cmos5l_decap_8
X_0191_ _0191_/Q Tile_X0Y0_FrameData[7] VGND VPWR Tile_X0Y5_FrameStrobe[3] latch
X_2832_ _2832_/X Tile_X0Y4_W2MID[4] Tile_X0Y4_W2END[4] Tile_X0Y4_W6END[11] _2711_/X
+ _1118_/Q _1117_/Q VPWR VGND sg13cmos5l_mux4_1
XFILLER_247_14 VPWR VGND sg13cmos5l_decap_8
X_2763_ _2763_/X AXIL_S_SOC_ARPROT1 _2821_/X _2810_/X _2827_/X _1376_/Q _1375_/Q VPWR
+ VGND sg13cmos5l_mux4_1
X_1714_ Tile_X0Y0_E6BEG[6] _2203_/X VPWR VGND sg13cmos5l_buf_1
XFILLER_352_119 VPWR VGND sg13cmos5l_decap_8
X_2694_ _2694_/X Tile_X0Y0_W1END[2] Tile_X0Y0_WW4END[10] Tile_X0Y0_WW4END[14] Tile_X0Y0_W6END[6]
+ _0148_/Q _0147_/Q VPWR VGND sg13cmos5l_mux4_1
X_1645_ Tile_X0Y0_FrameStrobe_O[5] Tile_X0Y5_FrameStrobe[5] VPWR VGND sg13cmos5l_buf_1
XFILLER_360_141 VPWR VGND sg13cmos5l_decap_8
XFILLER_263_35 VPWR VGND sg13cmos5l_decap_8
XFILLER_327_91 VPWR VGND sg13cmos5l_decap_8
X_1576_ Tile_X0Y3_FrameData_O[22] Tile_X0Y3_FrameData[22] VPWR VGND sg13cmos5l_buf_1
XFILLER_258_112 VPWR VGND sg13cmos5l_decap_8
XFILLER_258_123 VPWR VGND sg13cmos5l_fill_1
X_0527_ _0527_/Q Tile_X0Y1_FrameData[7] VGND VPWR Tile_X0Y5_FrameStrobe[6] latch
XFILLER_301_252 VPWR VGND sg13cmos5l_decap_8
XFILLER_301_263 VPWR VGND sg13cmos5l_fill_2
X_0458_ _0458_/Q Tile_X0Y1_FrameData[12] VGND VPWR Tile_X0Y5_FrameStrobe[4] latch
XFILLER_132_28 VPWR VGND sg13cmos5l_decap_8
X_0389_ _0389_/Q Tile_X0Y1_FrameData[17] VGND VPWR Tile_X0Y5_FrameStrobe[2] latch
X_2128_ AXIL_S_SOC_RDATA22 Tile_X0Y1_W2MID[6] Tile_X0Y1_W2END[6] Tile_X0Y1_W6END[6]
+ _2379_/X _0370_/Q _0369_/Q VPWR VGND sg13cmos5l_mux4_1
XANTENNA__2137__X AXIL_S_SOC_RDATA31 VPWR VGND sg13cmos5l_antennanp
X_2059_ Tile_X0Y5_S2BEGb[0] _2829_/X VPWR VGND sg13cmos5l_buf_1
XFILLER_288_21 VPWR VGND sg13cmos5l_decap_8
XANTENNA__1976__X Tile_X0Y5_E2BEG[5] VPWR VGND sg13cmos5l_antennanp
XFILLER_194_111 VPWR VGND sg13cmos5l_decap_4
XFILLER_288_98 VPWR VGND sg13cmos5l_decap_8
XFILLER_157_14 VPWR VGND sg13cmos5l_decap_8
XFILLER_194_155 VPWR VGND sg13cmos5l_fill_2
XFILLER_41_25 VPWR VGND sg13cmos5l_decap_8
XFILLER_210_7 VPWR VGND sg13cmos5l_decap_8
XFILLER_343_119 VPWR VGND sg13cmos5l_decap_8
XFILLER_308_7 VPWR VGND sg13cmos5l_decap_8
XFILLER_307_28 VPWR VGND sg13cmos5l_decap_8
XFILLER_150_214 VPWR VGND sg13cmos5l_fill_2
XFILLER_173_35 VPWR VGND sg13cmos5l_decap_8
XFILLER_237_91 VPWR VGND sg13cmos5l_decap_8
XFILLER_351_196 VPWR VGND sg13cmos5l_decap_8
XFILLER_249_112 VPWR VGND sg13cmos5l_decap_8
XFILLER_49_217 VPWR VGND sg13cmos5l_decap_8
XFILLER_106_84 VPWR VGND sg13cmos5l_decap_8
XFILLER_264_115 VPWR VGND sg13cmos5l_fill_1
XFILLER_323_49 VPWR VGND sg13cmos5l_decap_8
XFILLER_66_77 VPWR VGND sg13cmos5l_decap_8
XFILLER_57_272 VPWR VGND sg13cmos5l_fill_1
XANTENNA__2047__X Tile_X0Y5_S1BEG[0] VPWR VGND sg13cmos5l_antennanp
XFILLER_167_0 VPWR VGND sg13cmos5l_decap_8
XFILLER_17_147 VPWR VGND sg13cmos5l_decap_8
XFILLER_82_21 VPWR VGND sg13cmos5l_decap_8
XFILLER_198_21 VPWR VGND sg13cmos5l_decap_8
XANTENNA__1886__X Tile_X0Y1_UserCLKo VPWR VGND sg13cmos5l_antennanp
XFILLER_334_0 VPWR VGND sg13cmos5l_decap_8
XFILLER_82_98 VPWR VGND sg13cmos5l_decap_8
XFILLER_359_252 VPWR VGND sg13cmos5l_decap_4
XFILLER_15_70 VPWR VGND sg13cmos5l_decap_8
XFILLER_198_98 VPWR VGND sg13cmos5l_decap_8
XFILLER_319_105 VPWR VGND sg13cmos5l_decap_8
XFILLER_348_35 VPWR VGND sg13cmos5l_decap_8
XFILLER_126_244 VPWR VGND sg13cmos5l_decap_4
XFILLER_217_28 VPWR VGND sg13cmos5l_decap_8
XFILLER_31_91 VPWR VGND sg13cmos5l_decap_8
XFILLER_56_7 VPWR VGND sg13cmos5l_decap_8
XFILLER_342_141 VPWR VGND sg13cmos5l_decap_8
X_1430_ _1430_/Q Tile_X0Y5_FrameData[26] VGND VPWR Tile_X0Y5_FrameStrobe[5] latch
X_1361_ _1361_/Q Tile_X0Y5_FrameData[31] VGND VPWR Tile_X0Y5_FrameStrobe[3] latch
XFILLER_295_262 VPWR VGND sg13cmos5l_fill_2
X_0312_ _0312_/Q Tile_X0Y1_FrameData[30] VGND VPWR Tile_X0Y5_FrameStrobe[0] latch
XFILLER_233_49 VPWR VGND sg13cmos5l_decap_8
XFILLER_255_104 VPWR VGND sg13cmos5l_decap_8
X_1292_ _1292_/Q Tile_X0Y5_FrameData[4] VGND VPWR Tile_X0Y5_FrameStrobe[0] latch
X_0243_ _0243_/Q Tile_X0Y0_FrameData[19] VGND VPWR Tile_X0Y5_FrameStrobe[5] latch
XFILLER_48_261 VPWR VGND sg13cmos5l_fill_1
XFILLER_48_250 VPWR VGND sg13cmos5l_decap_8
X_0174_ _0174_/Q Tile_X0Y0_FrameData[24] VGND VPWR Tile_X0Y5_FrameStrobe[3] latch
XANTENNA__1796__X Tile_X0Y4_E2BEG[7] VPWR VGND sg13cmos5l_antennanp
XFILLER_211_218 VPWR VGND sg13cmos5l_decap_8
XFILLER_176_133 VPWR VGND sg13cmos5l_decap_8
XFILLER_258_35 VPWR VGND sg13cmos5l_decap_8
X_2815_ _2815_/X Tile_X0Y1_W1END[3] Tile_X0Y1_WW4END[11] Tile_X0Y1_WW4END[15] Tile_X0Y1_W6END[7]
+ _0385_/Q _0384_/Q VPWR VGND sg13cmos5l_mux4_1
XFILLER_82_0 VPWR VGND sg13cmos5l_decap_8
XFILLER_325_119 VPWR VGND sg13cmos5l_fill_2
XFILLER_11_28 VPWR VGND sg13cmos5l_decap_8
X_2746_ _2746_/X AXIL_S_SOC_ARPROT0 AXIL_S_SOC_RREADY _2806_/X _2827_/X _1410_/Q _1409_/Q
+ VPWR VGND sg13cmos5l_mux4_1
XFILLER_127_28 VPWR VGND sg13cmos5l_decap_8
X_2677_ _2677_/X Tile_X0Y3_W1END[2] Tile_X0Y3_W6END[10] _2575_/X _2563_/X _0894_/Q
+ _0893_/Q VPWR VGND sg13cmos5l_mux4_1
XFILLER_274_56 VPWR VGND sg13cmos5l_decap_8
X_1628_ Tile_X0Y0_N2BEG[0] _2145_/X VPWR VGND sg13cmos5l_buf_1
XFILLER_132_258 VPWR VGND sg13cmos5l_fill_2
X_1559_ Tile_X0Y3_FrameData_O[5] Tile_X0Y3_FrameData[5] VPWR VGND sg13cmos5l_buf_1
XFILLER_98_150 VPWR VGND sg13cmos5l_decap_8
XFILLER_143_49 VPWR VGND sg13cmos5l_decap_8
XFILLER_246_126 VPWR VGND sg13cmos5l_decap_8
XFILLER_286_262 VPWR VGND sg13cmos5l_fill_2
XFILLER_290_77 VPWR VGND sg13cmos5l_decap_8
XFILLER_36_14 VPWR VGND sg13cmos5l_decap_8
XFILLER_299_42 VPWR VGND sg13cmos5l_decap_8
XFILLER_54_231 VPWR VGND sg13cmos5l_decap_4
XFILLER_160_7 VPWR VGND sg13cmos5l_decap_8
XFILLER_258_7 VPWR VGND sg13cmos5l_decap_8
XFILLER_52_35 VPWR VGND sg13cmos5l_decap_8
XFILLER_167_133 VPWR VGND sg13cmos5l_fill_2
XFILLER_168_35 VPWR VGND sg13cmos5l_decap_8
XFILLER_167_199 VPWR VGND sg13cmos5l_decap_8
XFILLER_316_119 VPWR VGND sg13cmos5l_decap_8
XFILLER_182_147 VPWR VGND sg13cmos5l_decap_8
XFILLER_318_49 VPWR VGND sg13cmos5l_decap_8
XFILLER_123_214 VPWR VGND sg13cmos5l_decap_4
XFILLER_184_56 VPWR VGND sg13cmos5l_decap_8
XFILLER_324_185 VPWR VGND sg13cmos5l_fill_1
XFILLER_269_229 VPWR VGND sg13cmos5l_decap_8
XFILLER_324_196 VPWR VGND sg13cmos5l_fill_1
XFILLER_77_21 VPWR VGND sg13cmos5l_decap_8
XFILLER_237_126 VPWR VGND sg13cmos5l_decap_8
XFILLER_284_0 VPWR VGND sg13cmos5l_decap_8
XFILLER_77_98 VPWR VGND sg13cmos5l_decap_8
XFILLER_350_14 VPWR VGND sg13cmos5l_decap_8
XFILLER_292_254 VPWR VGND sg13cmos5l_decap_4
XFILLER_93_42 VPWR VGND sg13cmos5l_decap_8
XFILLER_245_170 VPWR VGND sg13cmos5l_decap_8
XFILLER_45_253 VPWR VGND sg13cmos5l_decap_4
XANTENNA_230 Tile_X0Y5_N2MID[5] VPWR VGND sg13cmos5l_antennanp
XANTENNA_241 AXIL_S_SOC_WDATA22 VPWR VGND sg13cmos5l_antennanp
XANTENNA_252 AXIL_S_SOC_WDATA22 VPWR VGND sg13cmos5l_antennanp
XANTENNA_263 AXIL_S_SOC_WDATA22 VPWR VGND sg13cmos5l_antennanp
XANTENNA_274 AXIL_S_SOC_WDATA22 VPWR VGND sg13cmos5l_antennanp
XANTENNA_285 AXIL_S_SOC_WDATA22 VPWR VGND sg13cmos5l_antennanp
XFILLER_26_91 VPWR VGND sg13cmos5l_decap_8
XANTENNA_296 AXIL_S_SOC_WDATA19 VPWR VGND sg13cmos5l_antennanp
X_0930_ _0930_/Q Tile_X0Y3_FrameData[20] VGND VPWR Tile_X0Y5_FrameStrobe[4] latch
XFILLER_359_56 VPWR VGND sg13cmos5l_decap_8
XFILLER_13_172 VPWR VGND sg13cmos5l_fill_1
XFILLER_158_133 VPWR VGND sg13cmos5l_fill_1
XFILLER_307_119 VPWR VGND sg13cmos5l_decap_8
X_0861_ _0861_/Q Tile_X0Y3_FrameData[25] VGND VPWR Tile_X0Y5_FrameStrobe[2] latch
XFILLER_9_154 VPWR VGND sg13cmos5l_decap_8
XFILLER_173_147 VPWR VGND sg13cmos5l_decap_8
XFILLER_228_49 VPWR VGND sg13cmos5l_decap_8
X_2600_ _2600_/X Tile_X0Y5_W2MID[6] Tile_X0Y5_W2END[6] Tile_X0Y5_W6END[6] _2826_/X
+ _1486_/Q _1485_/Q VPWR VGND sg13cmos5l_mux4_1
X_0792_ _0792_/Q Tile_X0Y3_FrameData[30] VGND VPWR Tile_X0Y5_FrameStrobe[0] latch
X_2531_ _2531_/X AXIL_S_SOC_ARADDR0 AXIL_S_SOC_ARADDR6 _2578_/X _2590_/X _0942_/Q
+ _0941_/Q VPWR VGND sg13cmos5l_mux4_1
X_2462_ _2462_/X Tile_X0Y3_W1END[2] Tile_X0Y3_W6END[6] _2575_/X _2563_/X _1026_/Q
+ _1025_/Q VPWR VGND sg13cmos5l_mux4_1
X_1413_ _1413_/Q Tile_X0Y5_FrameData[11] VGND VPWR Tile_X0Y5_FrameStrobe[4] latch
X_2393_ _2393_/X Tile_X0Y0_W1END[2] Tile_X0Y0_W2MID[1] Tile_X0Y0_W2END[1] _2247_/X
+ _0158_/Q _0157_/Q VPWR VGND sg13cmos5l_mux4_1
XFILLER_324_70 VPWR VGND sg13cmos5l_decap_8
X_1344_ _1344_/Q Tile_X0Y5_FrameData[16] VGND VPWR Tile_X0Y5_FrameStrobe[2] latch
XFILLER_228_126 VPWR VGND sg13cmos5l_decap_8
XFILLER_260_14 VPWR VGND sg13cmos5l_decap_8
X_1275_ _1275_/Q Tile_X0Y5_FrameData[21] VGND VPWR Tile_X0Y5_FrameStrobe[0] latch
XFILLER_95_142 VPWR VGND sg13cmos5l_decap_8
XFILLER_3_84 VPWR VGND sg13cmos5l_decap_8
X_0226_ _0226_/Q Tile_X0Y0_FrameData[4] VGND VPWR Tile_X0Y5_FrameStrobe[4] latch
XFILLER_36_231 VPWR VGND sg13cmos5l_decap_8
XFILLER_251_140 VPWR VGND sg13cmos5l_fill_2
X_0157_ _0157_/Q Tile_X0Y0_FrameData[9] VGND VPWR Tile_X0Y5_FrameStrobe[2] latch
X_0088_ _0088_/Q Tile_X0Y0_FrameData[14] VGND VPWR Tile_X0Y5_FrameStrobe[0] latch
XFILLER_340_91 VPWR VGND sg13cmos5l_decap_8
XFILLER_269_56 VPWR VGND sg13cmos5l_decap_8
XFILLER_22_49 VPWR VGND sg13cmos5l_decap_8
XFILLER_353_203 VPWR VGND sg13cmos5l_decap_8
XFILLER_138_49 VPWR VGND sg13cmos5l_decap_8
XFILLER_285_77 VPWR VGND sg13cmos5l_decap_8
X_2729_ _2729_/X AXIL_S_SOC_ARPROT2 AXIL_S_SOC_RREADY _2828_/X _2800_/X _1444_/Q _1443_/Q
+ VPWR VGND sg13cmos5l_mux4_1
XFILLER_105_214 VPWR VGND sg13cmos5l_decap_8
XFILLER_321_111 VPWR VGND sg13cmos5l_decap_8
XFILLER_170_14 VPWR VGND sg13cmos5l_decap_8
XFILLER_234_70 VPWR VGND sg13cmos5l_decap_8
XFILLER_86_164 VPWR VGND sg13cmos5l_decap_4
XFILLER_47_35 VPWR VGND sg13cmos5l_decap_8
XFILLER_86_197 VPWR VGND sg13cmos5l_decap_8
XFILLER_103_63 VPWR VGND sg13cmos5l_decap_8
XFILLER_242_140 VPWR VGND sg13cmos5l_decap_8
XFILLER_320_28 VPWR VGND sg13cmos5l_decap_8
XFILLER_250_91 VPWR VGND sg13cmos5l_decap_8
XFILLER_63_56 VPWR VGND sg13cmos5l_decap_8
XFILLER_42_223 VPWR VGND sg13cmos5l_fill_1
XFILLER_179_56 VPWR VGND sg13cmos5l_decap_8
XFILLER_42_267 VPWR VGND sg13cmos5l_decap_4
XFILLER_195_272 VPWR VGND sg13cmos5l_fill_1
XFILLER_155_136 VPWR VGND sg13cmos5l_decap_8
XFILLER_195_77 VPWR VGND sg13cmos5l_decap_8
XFILLER_345_14 VPWR VGND sg13cmos5l_decap_8
XFILLER_344_247 VPWR VGND sg13cmos5l_fill_2
XANTENNA__2060__X Tile_X0Y5_S2BEGb[1] VPWR VGND sg13cmos5l_antennanp
XFILLER_88_42 VPWR VGND sg13cmos5l_decap_8
XFILLER_111_217 VPWR VGND sg13cmos5l_decap_8
XFILLER_88_86 VPWR VGND sg13cmos5l_decap_8
XFILLER_77_131 VPWR VGND sg13cmos5l_fill_1
XFILLER_361_24 VPWR VGND sg13cmos5l_fill_2
XFILLER_144_70 VPWR VGND sg13cmos5l_decap_8
XFILLER_77_153 VPWR VGND sg13cmos5l_decap_4
XFILLER_19_7 VPWR VGND sg13cmos5l_decap_8
XFILLER_92_123 VPWR VGND sg13cmos5l_decap_8
XFILLER_92_112 VPWR VGND sg13cmos5l_decap_4
X_1060_ _1060_/Q Tile_X0Y4_FrameData[2] VGND VPWR Tile_X0Y5_FrameStrobe[0] latch
XFILLER_230_28 VPWR VGND sg13cmos5l_decap_8
XFILLER_233_140 VPWR VGND sg13cmos5l_decap_8
XFILLER_160_91 VPWR VGND sg13cmos5l_decap_8
XFILLER_233_173 VPWR VGND sg13cmos5l_fill_1
XFILLER_33_245 VPWR VGND sg13cmos5l_decap_8
XFILLER_233_195 VPWR VGND sg13cmos5l_fill_2
X_1962_ Tile_X0Y1_E2BEG[7] _2300_/X VPWR VGND sg13cmos5l_buf_1
X_1893_ Tile_X0Y1_FrameData_O[6] Tile_X0Y1_FrameData[6] VPWR VGND sg13cmos5l_buf_1
X_0913_ _0913_/Q Tile_X0Y3_FrameData[5] VGND VPWR Tile_X0Y5_FrameStrobe[3] latch
XFILLER_146_147 VPWR VGND sg13cmos5l_fill_2
X_0844_ _0844_/Q Tile_X0Y3_FrameData[10] VGND VPWR Tile_X0Y5_FrameStrobe[1] latch
XFILLER_319_70 VPWR VGND sg13cmos5l_decap_8
XFILLER_161_128 VPWR VGND sg13cmos5l_decap_8
XFILLER_255_14 VPWR VGND sg13cmos5l_decap_8
X_0775_ _0775_/Q Tile_X0Y2_FrameData[31] VGND VPWR Tile_X0Y5_FrameStrobe[7] latch
XFILLER_154_191 VPWR VGND sg13cmos5l_decap_8
XFILLER_303_133 VPWR VGND sg13cmos5l_decap_8
X_2514_ _2514_/X AXIL_S_SOC_ARADDR3 AXIL_S_SOC_ARADDR5 _2591_/X _2594_/X _0976_/Q
+ _0975_/Q VPWR VGND sg13cmos5l_mux4_1
XFILLER_45_0 VPWR VGND sg13cmos5l_fill_2
X_2445_ _2445_/X Tile_X0Y2_W1END[0] Tile_X0Y2_WW4END[8] Tile_X0Y2_WW4END[12] Tile_X0Y2_W6END[4]
+ _0634_/Q _0633_/Q VPWR VGND sg13cmos5l_mux4_1
XFILLER_335_91 VPWR VGND sg13cmos5l_decap_8
XFILLER_271_35 VPWR VGND sg13cmos5l_decap_8
X_2376_ _2376_/X _2255_/X _2388_/X _2387_/X Tile_X0Y0_S2MID[3] _0328_/Q _0327_/Q VPWR
+ VGND sg13cmos5l_mux4_1
XFILLER_110_272 VPWR VGND sg13cmos5l_fill_1
XFILLER_256_254 VPWR VGND sg13cmos5l_fill_1
X_1327_ _1327_/Q Tile_X0Y5_FrameData[1] VGND VPWR Tile_X0Y5_FrameStrobe[1] latch
XFILLER_83_112 VPWR VGND sg13cmos5l_decap_4
XFILLER_204_84 VPWR VGND sg13cmos5l_decap_8
XFILLER_204_95 VPWR VGND sg13cmos5l_fill_2
X_1258_ _1258_/Q Tile_X0Y4_FrameData[28] VGND VPWR Tile_X0Y5_FrameStrobe[7] latch
XFILLER_140_28 VPWR VGND sg13cmos5l_decap_8
XFILLER_17_49 VPWR VGND sg13cmos5l_decap_8
X_1189_ _1189_/Q Tile_X0Y4_FrameData[1] VGND VPWR Tile_X0Y5_FrameStrobe[4] latch
X_0209_ _0209_/Q Tile_X0Y0_FrameData[21] VGND VPWR Tile_X0Y5_FrameStrobe[4] latch
XFILLER_83_189 VPWR VGND sg13cmos5l_decap_8
XFILLER_169_206 VPWR VGND sg13cmos5l_decap_8
XFILLER_224_162 VPWR VGND sg13cmos5l_decap_8
XFILLER_24_212 VPWR VGND sg13cmos5l_fill_1
XFILLER_33_15 VPWR VGND sg13cmos5l_decap_8
XFILLER_296_21 VPWR VGND sg13cmos5l_decap_8
XANTENNA__1984__X Tile_X0Y5_E2BEGb[5] VPWR VGND sg13cmos5l_antennanp
XFILLER_123_7 VPWR VGND sg13cmos5l_decap_8
XFILLER_296_98 VPWR VGND sg13cmos5l_decap_8
XFILLER_326_236 VPWR VGND sg13cmos5l_fill_1
XFILLER_137_147 VPWR VGND sg13cmos5l_decap_8
XFILLER_229_70 VPWR VGND sg13cmos5l_decap_8
XFILLER_152_139 VPWR VGND sg13cmos5l_decap_8
XFILLER_165_36 VPWR VGND sg13cmos5l_decap_8
XFILLER_3_105 VPWR VGND sg13cmos5l_decap_8
XFILLER_315_28 VPWR VGND sg13cmos5l_decap_8
XFILLER_245_91 VPWR VGND sg13cmos5l_decap_8
XFILLER_58_56 VPWR VGND sg13cmos5l_decap_8
XFILLER_181_35 VPWR VGND sg13cmos5l_decap_8
XFILLER_101_261 VPWR VGND sg13cmos5l_fill_1
XFILLER_207_107 VPWR VGND sg13cmos5l_decap_8
XFILLER_74_112 VPWR VGND sg13cmos5l_decap_8
XFILLER_59_175 VPWR VGND sg13cmos5l_decap_8
XFILLER_114_84 VPWR VGND sg13cmos5l_decap_8
XFILLER_262_213 VPWR VGND sg13cmos5l_fill_2
XFILLER_331_49 VPWR VGND sg13cmos5l_decap_8
XFILLER_74_77 VPWR VGND sg13cmos5l_decap_8
XFILLER_74_167 VPWR VGND sg13cmos5l_decap_8
XFILLER_15_212 VPWR VGND sg13cmos5l_fill_1
XFILLER_247_0 VPWR VGND sg13cmos5l_decap_8
XANTENNA__2055__X Tile_X0Y5_S2BEG[4] VPWR VGND sg13cmos5l_antennanp
XFILLER_230_154 VPWR VGND sg13cmos5l_fill_2
XFILLER_90_43 VPWR VGND sg13cmos5l_decap_8
XFILLER_168_250 VPWR VGND sg13cmos5l_fill_1
XFILLER_230_198 VPWR VGND sg13cmos5l_decap_8
XANTENNA__1894__X Tile_X0Y1_FrameData_O[7] VPWR VGND sg13cmos5l_antennanp
XFILLER_128_125 VPWR VGND sg13cmos5l_decap_8
XFILLER_23_70 VPWR VGND sg13cmos5l_decap_8
XFILLER_139_70 VPWR VGND sg13cmos5l_decap_8
XFILLER_356_35 VPWR VGND sg13cmos5l_decap_8
XFILLER_143_139 VPWR VGND sg13cmos5l_decap_8
XFILLER_99_63 VPWR VGND sg13cmos5l_decap_8
X_0560_ _0560_/Q Tile_X0Y2_FrameData[22] VGND VPWR Tile_X0Y5_FrameStrobe[0] latch
XFILLER_225_28 VPWR VGND sg13cmos5l_decap_8
XFILLER_297_154 VPWR VGND sg13cmos5l_decap_8
X_0491_ _0491_/Q Tile_X0Y1_FrameData[11] VGND VPWR Tile_X0Y5_FrameStrobe[5] latch
XFILLER_97_215 VPWR VGND sg13cmos5l_decap_8
X_2230_ _2230_/X _2213_/X _0049_/X Tile_X0Y0_S1END[0] Tile_X0Y0_S4END[0] _0110_/Q
+ _0109_/Q VPWR VGND sg13cmos5l_mux4_1
XFILLER_340_272 VPWR VGND sg13cmos5l_fill_1
XFILLER_300_147 VPWR VGND sg13cmos5l_decap_8
X_2161_ _2161_/X _2213_/X Tile_X0Y0_S1END[0] AXIL_S_SOC_WDATA18 AXIL_S_SOC_WDATA23
+ _0274_/Q _0273_/Q VPWR VGND sg13cmos5l_mux4_1
XFILLER_65_112 VPWR VGND sg13cmos5l_decap_8
XFILLER_241_49 VPWR VGND sg13cmos5l_decap_8
X_2092_ Tile_X0Y3_E2BEG[4] _2513_/X VPWR VGND sg13cmos5l_buf_1
X_1112_ _1112_/Q Tile_X0Y4_FrameData[14] VGND VPWR Tile_X0Y5_FrameStrobe[2] latch
X_1043_ _1043_/Q Tile_X0Y4_FrameData[19] VGND VPWR Tile_X0Y5_FrameStrobe[0] latch
XFILLER_0_63 VPWR VGND sg13cmos5l_decap_8
XFILLER_206_140 VPWR VGND sg13cmos5l_fill_1
X_1945_ Tile_X0Y1_E6BEG[10] _2335_/X VPWR VGND sg13cmos5l_buf_1
XFILLER_159_272 VPWR VGND sg13cmos5l_fill_1
XFILLER_119_147 VPWR VGND sg13cmos5l_decap_8
XFILLER_266_35 VPWR VGND sg13cmos5l_decap_8
X_1876_ Tile_X0Y2_E6BEG[2] _2435_/X VPWR VGND sg13cmos5l_buf_1
X_0827_ _0827_/Q Tile_X0Y3_FrameData[27] VGND VPWR Tile_X0Y5_FrameStrobe[1] latch
XFILLER_127_191 VPWR VGND sg13cmos5l_fill_1
X_0758_ _0758_/Q Tile_X0Y2_FrameData[16] VGND VPWR Tile_X0Y5_FrameStrobe[6] latch
XFILLER_135_28 VPWR VGND sg13cmos5l_decap_8
XFILLER_142_161 VPWR VGND sg13cmos5l_fill_1
XFILLER_0_119 VPWR VGND sg13cmos5l_decap_8
XFILLER_282_56 VPWR VGND sg13cmos5l_decap_8
XFILLER_288_154 VPWR VGND sg13cmos5l_decap_8
XFILLER_331_272 VPWR VGND sg13cmos5l_fill_1
X_0689_ _0689_/Q Tile_X0Y2_FrameData[21] VGND VPWR Tile_X0Y5_FrameStrobe[4] latch
X_2428_ _2428_/X AXIL_S_SOC_AWADDR7 AXIL_S_SOC_AWPROT1 _2479_/X _2485_/X _0692_/Q
+ _0691_/Q VPWR VGND sg13cmos5l_mux4_1
X_2359_ _2359_/X Tile_X0Y5_W1END[2] Tile_X0Y5_WW4END[2] Tile_X0Y5_WW4END[8] Tile_X0Y5_W6END[10]
+ _1466_/Q _1465_/Q VPWR VGND sg13cmos5l_mux4_1
XFILLER_56_112 VPWR VGND sg13cmos5l_decap_8
XFILLER_151_49 VPWR VGND sg13cmos5l_decap_8
XANTENNA__1979__X Tile_X0Y5_E2BEGb[0] VPWR VGND sg13cmos5l_antennanp
XFILLER_56_189 VPWR VGND sg13cmos5l_decap_8
XFILLER_44_25 VPWR VGND sg13cmos5l_decap_8
XFILLER_212_132 VPWR VGND sg13cmos5l_decap_8
XFILLER_240_7 VPWR VGND sg13cmos5l_decap_8
XFILLER_358_147 VPWR VGND sg13cmos5l_decap_8
XFILLER_338_7 VPWR VGND sg13cmos5l_decap_8
XFILLER_100_42 VPWR VGND sg13cmos5l_decap_8
XFILLER_12_237 VPWR VGND sg13cmos5l_fill_1
XFILLER_60_35 VPWR VGND sg13cmos5l_decap_8
XFILLER_165_253 VPWR VGND sg13cmos5l_fill_2
XFILLER_176_35 VPWR VGND sg13cmos5l_decap_8
XFILLER_180_245 VPWR VGND sg13cmos5l_decap_8
XFILLER_326_49 VPWR VGND sg13cmos5l_decap_8
XFILLER_109_84 VPWR VGND sg13cmos5l_decap_8
XFILLER_133_150 VPWR VGND sg13cmos5l_fill_1
XFILLER_279_132 VPWR VGND sg13cmos5l_decap_4
XFILLER_192_56 VPWR VGND sg13cmos5l_decap_8
XFILLER_69_77 VPWR VGND sg13cmos5l_decap_8
XFILLER_342_15 VPWR VGND sg13cmos5l_decap_8
XFILLER_197_0 VPWR VGND sg13cmos5l_decap_8
XFILLER_294_168 VPWR VGND sg13cmos5l_decap_8
XFILLER_85_43 VPWR VGND sg13cmos5l_decap_8
XFILLER_47_112 VPWR VGND sg13cmos5l_decap_8
XFILLER_47_145 VPWR VGND sg13cmos5l_decap_8
XANTENNA__1889__X Tile_X0Y1_FrameData_O[2] VPWR VGND sg13cmos5l_antennanp
XFILLER_18_70 VPWR VGND sg13cmos5l_decap_8
XFILLER_62_126 VPWR VGND sg13cmos5l_decap_8
XFILLER_203_154 VPWR VGND sg13cmos5l_decap_8
XFILLER_349_147 VPWR VGND sg13cmos5l_decap_8
XFILLER_34_91 VPWR VGND sg13cmos5l_decap_8
XFILLER_86_7 VPWR VGND sg13cmos5l_decap_8
X_1730_ Tile_X0Y0_E2BEG[2] _2167_/X VPWR VGND sg13cmos5l_buf_1
X_1661_ Tile_X0Y0_FrameData_O[1] Tile_X0Y0_FrameData[1] VPWR VGND sg13cmos5l_buf_1
X_0612_ _0612_/Q Tile_X0Y2_FrameData[2] VGND VPWR Tile_X0Y5_FrameStrobe[1] latch
XFILLER_236_49 VPWR VGND sg13cmos5l_decap_8
X_1592_ Tile_X0Y2_EE4BEG[5] _2422_/X VPWR VGND sg13cmos5l_buf_1
X_0543_ _0543_/Q Tile_X0Y1_FrameData[23] VGND VPWR Tile_X0Y5_FrameStrobe[7] latch
X_0474_ _0474_/Q Tile_X0Y1_FrameData[28] VGND VPWR Tile_X0Y5_FrameStrobe[5] latch
XFILLER_285_179 VPWR VGND sg13cmos5l_fill_2
X_2213_ _2213_/X Tile_X0Y1_W1END[0] Tile_X0Y1_W6END[4] _2361_/X _2337_/X _0550_/Q
+ _0549_/Q VPWR VGND sg13cmos5l_mux4_1
XFILLER_38_112 VPWR VGND sg13cmos5l_decap_8
X_2144_ _2144_/X Tile_X0Y0_W1END[3] Tile_X0Y0_W6END[7] _2217_/X _2212_/X _0304_/Q
+ _0303_/Q VPWR VGND sg13cmos5l_mux4_1
XANTENNA__1799__X Tile_X0Y4_E2BEGb[2] VPWR VGND sg13cmos5l_antennanp
XFILLER_332_70 VPWR VGND sg13cmos5l_decap_8
XFILLER_38_167 VPWR VGND sg13cmos5l_fill_1
X_2075_ Tile_X0Y5_S4BEG[8] _2075_/A VPWR VGND sg13cmos5l_buf_1
XFILLER_53_126 VPWR VGND sg13cmos5l_decap_8
XFILLER_38_189 VPWR VGND sg13cmos5l_decap_4
XFILLER_241_227 VPWR VGND sg13cmos5l_decap_4
X_1026_ _1026_/Q Tile_X0Y3_FrameData[20] VGND VPWR Tile_X0Y5_FrameStrobe[7] latch
XFILLER_201_63 VPWR VGND sg13cmos5l_decap_8
XFILLER_14_28 VPWR VGND sg13cmos5l_decap_8
XFILLER_277_56 VPWR VGND sg13cmos5l_decap_8
X_1928_ Tile_X0Y1_EE4BEG[9] _2318_/X VPWR VGND sg13cmos5l_buf_1
X_1859_ Tile_X0Y4_FrameData_O[26] Tile_X0Y4_FrameData[26] VPWR VGND sg13cmos5l_buf_1
XFILLER_30_49 VPWR VGND sg13cmos5l_decap_8
XFILLER_146_49 VPWR VGND sg13cmos5l_decap_8
XFILLER_293_77 VPWR VGND sg13cmos5l_decap_8
XFILLER_115_161 VPWR VGND sg13cmos5l_decap_8
XFILLER_226_71 VPWR VGND sg13cmos5l_decap_8
XFILLER_304_272 VPWR VGND sg13cmos5l_fill_1
XFILLER_39_14 VPWR VGND sg13cmos5l_decap_8
XFILLER_130_186 VPWR VGND sg13cmos5l_decap_8
XFILLER_190_7 VPWR VGND sg13cmos5l_decap_8
XFILLER_276_168 VPWR VGND sg13cmos5l_decap_4
XFILLER_29_112 VPWR VGND sg13cmos5l_decap_8
XFILLER_76_218 VPWR VGND sg13cmos5l_decap_4
XFILLER_288_7 VPWR VGND sg13cmos5l_decap_8
XFILLER_291_105 VPWR VGND sg13cmos5l_decap_8
XFILLER_29_123 VPWR VGND sg13cmos5l_fill_2
XFILLER_242_70 VPWR VGND sg13cmos5l_decap_8
XFILLER_55_35 VPWR VGND sg13cmos5l_decap_8
XFILLER_44_137 VPWR VGND sg13cmos5l_decap_8
XFILLER_44_148 VPWR VGND sg13cmos5l_decap_8
XFILLER_111_63 VPWR VGND sg13cmos5l_decap_8
XFILLER_71_56 VPWR VGND sg13cmos5l_decap_8
XFILLER_187_56 VPWR VGND sg13cmos5l_decap_8
XFILLER_354_161 VPWR VGND sg13cmos5l_decap_8
XFILLER_112_0 VPWR VGND sg13cmos5l_decap_8
XFILLER_299_238 VPWR VGND sg13cmos5l_decap_4
XFILLER_353_14 VPWR VGND sg13cmos5l_decap_8
XFILLER_96_42 VPWR VGND sg13cmos5l_decap_8
XFILLER_282_105 VPWR VGND sg13cmos5l_decap_8
XFILLER_152_70 VPWR VGND sg13cmos5l_decap_8
XFILLER_208_235 VPWR VGND sg13cmos5l_decap_4
XFILLER_29_91 VPWR VGND sg13cmos5l_decap_8
X_0190_ _0190_/Q Tile_X0Y0_FrameData[8] VGND VPWR Tile_X0Y5_FrameStrobe[3] latch
XFILLER_208_268 VPWR VGND sg13cmos5l_decap_4
XFILLER_223_205 VPWR VGND sg13cmos5l_decap_4
XFILLER_223_238 VPWR VGND sg13cmos5l_decap_8
XFILLER_290_182 VPWR VGND sg13cmos5l_decap_8
XFILLER_302_84 VPWR VGND sg13cmos5l_decap_8
X_2831_ _2831_/X Tile_X0Y4_W2MID[5] Tile_X0Y4_W2END[5] Tile_X0Y4_W6END[10] _2710_/X
+ _1120_/Q _1119_/Q VPWR VGND sg13cmos5l_mux4_1
X_2762_ _2762_/X AXIL_S_SOC_ARPROT0 _2818_/X _2806_/X _2826_/X _1378_/Q _1377_/Q VPWR
+ VGND sg13cmos5l_mux4_1
XFILLER_144_212 VPWR VGND sg13cmos5l_decap_8
X_1713_ Tile_X0Y0_E6BEG[5] _2202_/X VPWR VGND sg13cmos5l_buf_1
X_2693_ _2693_/X _2676_/X Tile_X0Y5_N4END[5] _2675_/X _0071_/X _1068_/Q _1067_/Q VPWR
+ VGND sg13cmos5l_mux4_1
XFILLER_360_120 VPWR VGND sg13cmos5l_decap_8
XFILLER_144_267 VPWR VGND sg13cmos5l_decap_4
XFILLER_327_70 VPWR VGND sg13cmos5l_decap_8
X_1644_ Tile_X0Y0_FrameStrobe_O[4] Tile_X0Y5_FrameStrobe[4] VPWR VGND sg13cmos5l_buf_1
XFILLER_6_84 VPWR VGND sg13cmos5l_decap_8
XFILLER_263_14 VPWR VGND sg13cmos5l_decap_8
XFILLER_298_260 VPWR VGND sg13cmos5l_fill_2
X_1575_ Tile_X0Y3_FrameData_O[21] Tile_X0Y3_FrameData[21] VPWR VGND sg13cmos5l_buf_1
XFILLER_360_197 VPWR VGND sg13cmos5l_decap_8
XFILLER_301_231 VPWR VGND sg13cmos5l_fill_1
X_0526_ _0526_/Q Tile_X0Y1_FrameData[8] VGND VPWR Tile_X0Y5_FrameStrobe[6] latch
X_0457_ _0457_/Q Tile_X0Y1_FrameData[13] VGND VPWR Tile_X0Y5_FrameStrobe[4] latch
XFILLER_343_91 VPWR VGND sg13cmos5l_decap_8
X_0388_ _0388_/Q Tile_X0Y1_FrameData[18] VGND VPWR Tile_X0Y5_FrameStrobe[2] latch
X_2127_ AXIL_S_SOC_RDATA21 Tile_X0Y1_W2MID[5] Tile_X0Y1_W2END[5] Tile_X0Y1_W6END[5]
+ _2378_/X _0372_/Q _0371_/Q VPWR VGND sg13cmos5l_mux4_1
XFILLER_212_84 VPWR VGND sg13cmos5l_decap_4
XFILLER_26_159 VPWR VGND sg13cmos5l_fill_2
X_2058_ Tile_X0Y5_S2BEG[7] _2780_/X VPWR VGND sg13cmos5l_buf_1
XFILLER_25_49 VPWR VGND sg13cmos5l_decap_8
X_1009_ _1009_/Q Tile_X0Y3_FrameData[5] VGND VPWR Tile_X0Y5_FrameStrobe[6] latch
XFILLER_222_271 VPWR VGND sg13cmos5l_fill_2
XFILLER_34_192 VPWR VGND sg13cmos5l_decap_8
XFILLER_179_175 VPWR VGND sg13cmos5l_decap_8
XFILLER_288_77 VPWR VGND sg13cmos5l_decap_8
XANTENNA__1992__X Tile_X0Y5_E6BEG[5] VPWR VGND sg13cmos5l_antennanp
XFILLER_203_7 VPWR VGND sg13cmos5l_decap_8
XFILLER_237_70 VPWR VGND sg13cmos5l_decap_8
XFILLER_173_14 VPWR VGND sg13cmos5l_decap_8
XFILLER_351_175 VPWR VGND sg13cmos5l_decap_8
XFILLER_103_153 VPWR VGND sg13cmos5l_decap_8
XFILLER_106_63 VPWR VGND sg13cmos5l_decap_8
XFILLER_249_146 VPWR VGND sg13cmos5l_fill_1
XFILLER_249_168 VPWR VGND sg13cmos5l_fill_2
XFILLER_323_28 VPWR VGND sg13cmos5l_decap_8
XFILLER_253_91 VPWR VGND sg13cmos5l_decap_8
XFILLER_66_56 VPWR VGND sg13cmos5l_decap_8
XFILLER_17_126 VPWR VGND sg13cmos5l_decap_8
XFILLER_205_238 VPWR VGND sg13cmos5l_fill_2
XFILLER_122_84 VPWR VGND sg13cmos5l_decap_8
XFILLER_220_219 VPWR VGND sg13cmos5l_decap_8
XFILLER_82_77 VPWR VGND sg13cmos5l_decap_8
XFILLER_359_231 VPWR VGND sg13cmos5l_decap_8
XFILLER_185_112 VPWR VGND sg13cmos5l_decap_4
XFILLER_198_77 VPWR VGND sg13cmos5l_decap_8
XFILLER_348_14 VPWR VGND sg13cmos5l_decap_8
XANTENNA__2063__X Tile_X0Y5_S2BEGb[4] VPWR VGND sg13cmos5l_antennanp
XFILLER_327_0 VPWR VGND sg13cmos5l_decap_8
XFILLER_185_178 VPWR VGND sg13cmos5l_fill_2
XFILLER_31_70 VPWR VGND sg13cmos5l_decap_8
XFILLER_342_120 VPWR VGND sg13cmos5l_decap_8
XFILLER_147_70 VPWR VGND sg13cmos5l_fill_1
XFILLER_49_7 VPWR VGND sg13cmos5l_decap_8
X_1360_ _1360_/Q Tile_X0Y5_FrameData[0] VGND VPWR Tile_X0Y5_FrameStrobe[2] latch
XFILLER_233_28 VPWR VGND sg13cmos5l_decap_8
XFILLER_295_252 VPWR VGND sg13cmos5l_fill_2
X_0311_ _0311_/Q Tile_X0Y0_FrameData[31] VGND VPWR Tile_X0Y5_FrameStrobe[0] latch
XFILLER_163_91 VPWR VGND sg13cmos5l_decap_8
X_1291_ _1291_/Q Tile_X0Y5_FrameData[5] VGND VPWR Tile_X0Y5_FrameStrobe[0] latch
X_0242_ _0242_/Q Tile_X0Y0_FrameData[20] VGND VPWR Tile_X0Y5_FrameStrobe[5] latch
XFILLER_270_119 VPWR VGND sg13cmos5l_decap_8
X_0173_ _0173_/Q Tile_X0Y0_FrameData[25] VGND VPWR Tile_X0Y5_FrameStrobe[3] latch
XFILLER_176_112 VPWR VGND sg13cmos5l_decap_8
XFILLER_258_14 VPWR VGND sg13cmos5l_decap_8
XFILLER_31_195 VPWR VGND sg13cmos5l_decap_4
X_2814_ _2814_/X Tile_X0Y5_N1END[0] Tile_X0Y5_N4END[0] _2793_/X _0032_/X _1304_/Q
+ _1303_/Q VPWR VGND sg13cmos5l_mux4_1
XFILLER_75_0 VPWR VGND sg13cmos5l_decap_8
X_2745_ _2745_/X AXIL_S_SOC_ARVALID AXIL_S_SOC_RREADY _2802_/X _2828_/X _1412_/Q _1411_/Q
+ VPWR VGND sg13cmos5l_mux4_1
XFILLER_338_91 VPWR VGND sg13cmos5l_decap_8
XFILLER_117_245 VPWR VGND sg13cmos5l_decap_8
XFILLER_117_256 VPWR VGND sg13cmos5l_fill_1
XFILLER_274_35 VPWR VGND sg13cmos5l_decap_8
XFILLER_333_120 VPWR VGND sg13cmos5l_fill_2
X_2676_ _2676_/X Tile_X0Y5_W1END[1] Tile_X0Y5_W6END[5] _2809_/X _2790_/X _1494_/Q
+ _1493_/Q VPWR VGND sg13cmos5l_mux4_1
X_1627_ Tile_X0Y0_N2BEGb[7] _2264_/X VPWR VGND sg13cmos5l_buf_1
X_1558_ Tile_X0Y3_FrameData_O[4] Tile_X0Y3_FrameData[4] VPWR VGND sg13cmos5l_buf_1
XFILLER_143_28 VPWR VGND sg13cmos5l_decap_8
XFILLER_246_105 VPWR VGND sg13cmos5l_decap_8
XFILLER_290_56 VPWR VGND sg13cmos5l_decap_8
X_1489_ _1489_/Q Tile_X0Y5_FrameData[31] VGND VPWR Tile_X0Y5_FrameStrobe[7] latch
X_0509_ _0509_/Q Tile_X0Y1_FrameData[25] VGND VPWR Tile_X0Y5_FrameStrobe[6] latch
XFILLER_261_119 VPWR VGND sg13cmos5l_decap_4
XFILLER_54_210 VPWR VGND sg13cmos5l_decap_8
XFILLER_254_171 VPWR VGND sg13cmos5l_fill_2
XFILLER_299_21 VPWR VGND sg13cmos5l_decap_8
XANTENNA__1987__X Tile_X0Y5_E6BEG[0] VPWR VGND sg13cmos5l_antennanp
XFILLER_199_248 VPWR VGND sg13cmos5l_decap_8
XFILLER_153_7 VPWR VGND sg13cmos5l_decap_8
XFILLER_299_98 VPWR VGND sg13cmos5l_decap_8
XFILLER_52_14 VPWR VGND sg13cmos5l_decap_8
XFILLER_167_112 VPWR VGND sg13cmos5l_decap_8
XFILLER_168_14 VPWR VGND sg13cmos5l_decap_8
XFILLER_210_252 VPWR VGND sg13cmos5l_decap_8
XFILLER_22_173 VPWR VGND sg13cmos5l_decap_8
XFILLER_320_7 VPWR VGND sg13cmos5l_decap_8
XFILLER_356_245 VPWR VGND sg13cmos5l_decap_8
XFILLER_182_126 VPWR VGND sg13cmos5l_decap_8
XFILLER_309_161 VPWR VGND sg13cmos5l_decap_8
XFILLER_318_28 VPWR VGND sg13cmos5l_decap_8
XFILLER_184_35 VPWR VGND sg13cmos5l_decap_8
XFILLER_248_91 VPWR VGND sg13cmos5l_decap_8
XFILLER_117_84 VPWR VGND sg13cmos5l_decap_8
XFILLER_277_230 VPWR VGND sg13cmos5l_decap_4
XFILLER_334_49 VPWR VGND sg13cmos5l_decap_8
XFILLER_237_105 VPWR VGND sg13cmos5l_decap_8
XFILLER_292_200 VPWR VGND sg13cmos5l_fill_1
XFILLER_77_77 VPWR VGND sg13cmos5l_decap_8
XANTENNA__2058__X Tile_X0Y5_S2BEG[7] VPWR VGND sg13cmos5l_antennanp
XFILLER_277_0 VPWR VGND sg13cmos5l_decap_8
XFILLER_93_21 VPWR VGND sg13cmos5l_decap_8
XFILLER_252_119 VPWR VGND sg13cmos5l_decap_8
XFILLER_45_232 VPWR VGND sg13cmos5l_decap_8
XANTENNA_220 Tile_X0Y5_FrameStrobe[8] VPWR VGND sg13cmos5l_antennanp
XANTENNA_231 Tile_X0Y5_N2MID[5] VPWR VGND sg13cmos5l_antennanp
XANTENNA_242 AXIL_S_SOC_WDATA22 VPWR VGND sg13cmos5l_antennanp
XANTENNA__1897__X Tile_X0Y1_FrameData_O[10] VPWR VGND sg13cmos5l_antennanp
XFILLER_260_141 VPWR VGND sg13cmos5l_decap_4
XFILLER_93_98 VPWR VGND sg13cmos5l_decap_8
XFILLER_60_213 VPWR VGND sg13cmos5l_decap_8
XANTENNA_253 AXIL_S_SOC_WDATA22 VPWR VGND sg13cmos5l_antennanp
XANTENNA_264 AXIL_S_SOC_WDATA22 VPWR VGND sg13cmos5l_antennanp
XANTENNA_275 AXIL_S_SOC_WDATA22 VPWR VGND sg13cmos5l_antennanp
XANTENNA_286 AXIL_S_SOC_WDATA22 VPWR VGND sg13cmos5l_antennanp
XFILLER_26_70 VPWR VGND sg13cmos5l_decap_8
XFILLER_359_35 VPWR VGND sg13cmos5l_decap_8
XANTENNA_297 AXIL_S_SOC_WDATA19 VPWR VGND sg13cmos5l_antennanp
XFILLER_13_140 VPWR VGND sg13cmos5l_fill_2
XFILLER_158_112 VPWR VGND sg13cmos5l_decap_8
XFILLER_9_133 VPWR VGND sg13cmos5l_decap_8
X_0860_ _0860_/Q Tile_X0Y3_FrameData[26] VGND VPWR Tile_X0Y5_FrameStrobe[2] latch
XFILLER_42_80 VPWR VGND sg13cmos5l_decap_8
XFILLER_347_267 VPWR VGND sg13cmos5l_decap_4
XFILLER_173_126 VPWR VGND sg13cmos5l_decap_8
XFILLER_228_28 VPWR VGND sg13cmos5l_decap_8
X_0791_ _0791_/Q Tile_X0Y2_FrameData[31] VGND VPWR Tile_X0Y5_FrameStrobe[0] latch
XFILLER_158_91 VPWR VGND sg13cmos5l_decap_8
X_2530_ _2530_/X AXIL_S_SOC_ARADDR5 AXIL_S_SOC_ARADDR9 _2576_/X _2591_/X _0944_/Q
+ _0943_/Q VPWR VGND sg13cmos5l_mux4_1
X_2461_ _2461_/X Tile_X0Y1_W1END[2] Tile_X0Y1_W6END[10] _2353_/X _2339_/X _0414_/Q
+ _0413_/Q VPWR VGND sg13cmos5l_mux4_1
X_1412_ _1412_/Q Tile_X0Y5_FrameData[12] VGND VPWR Tile_X0Y5_FrameStrobe[4] latch
XFILLER_244_49 VPWR VGND sg13cmos5l_decap_8
X_2392_ _2392_/X Tile_X0Y3_W2MID[2] Tile_X0Y3_W2END[2] Tile_X0Y3_W6END[2] _2594_/X
+ _1012_/Q _1011_/Q VPWR VGND sg13cmos5l_mux4_1
XFILLER_228_105 VPWR VGND sg13cmos5l_decap_8
X_1343_ _1343_/Q Tile_X0Y5_FrameData[17] VGND VPWR Tile_X0Y5_FrameStrobe[2] latch
XFILLER_3_63 VPWR VGND sg13cmos5l_decap_8
X_1274_ _1274_/Q Tile_X0Y5_FrameData[22] VGND VPWR Tile_X0Y5_FrameStrobe[0] latch
X_0225_ _0225_/Q Tile_X0Y0_FrameData[5] VGND VPWR Tile_X0Y5_FrameStrobe[4] latch
XFILLER_36_210 VPWR VGND sg13cmos5l_decap_8
XFILLER_243_119 VPWR VGND sg13cmos5l_decap_8
X_0156_ _0156_/Q Tile_X0Y0_FrameData[10] VGND VPWR Tile_X0Y5_FrameStrobe[2] latch
XFILLER_340_70 VPWR VGND sg13cmos5l_decap_8
XANTENNA__1600__X Tile_X0Y2_EE4BEG[13] VPWR VGND sg13cmos5l_antennanp
X_0087_ _0087_/Q Tile_X0Y0_FrameData[15] VGND VPWR Tile_X0Y5_FrameStrobe[0] latch
XFILLER_51_235 VPWR VGND sg13cmos5l_decap_8
XFILLER_269_35 VPWR VGND sg13cmos5l_decap_8
XFILLER_51_268 VPWR VGND sg13cmos5l_decap_4
XFILLER_149_156 VPWR VGND sg13cmos5l_fill_2
XFILLER_22_28 VPWR VGND sg13cmos5l_decap_8
XFILLER_138_28 VPWR VGND sg13cmos5l_decap_8
X_0989_ _0989_/Q Tile_X0Y3_FrameData[25] VGND VPWR Tile_X0Y5_FrameStrobe[6] latch
XFILLER_285_56 VPWR VGND sg13cmos5l_decap_8
X_2728_ _2728_/X AXIL_S_SOC_ARPROT1 AXIL_S_SOC_ARVALID _2828_/X _2800_/X _1446_/Q
+ _1445_/Q VPWR VGND sg13cmos5l_mux4_1
XFILLER_306_175 VPWR VGND sg13cmos5l_fill_2
X_2659_ _2659_/X AXIL_S_SOC_WSTRB2 _2705_/X _2704_/X _2682_/X _1136_/Q _1135_/Q VPWR
+ VGND sg13cmos5l_mux4_1
XFILLER_154_49 VPWR VGND sg13cmos5l_decap_8
XFILLER_321_156 VPWR VGND sg13cmos5l_fill_2
XFILLER_120_229 VPWR VGND sg13cmos5l_decap_8
XFILLER_219_105 VPWR VGND sg13cmos5l_decap_4
XFILLER_47_14 VPWR VGND sg13cmos5l_decap_8
XFILLER_270_7 VPWR VGND sg13cmos5l_decap_8
XFILLER_103_42 VPWR VGND sg13cmos5l_decap_8
XFILLER_234_119 VPWR VGND sg13cmos5l_decap_8
XFILLER_250_70 VPWR VGND sg13cmos5l_decap_8
XFILLER_63_35 VPWR VGND sg13cmos5l_decap_8
XFILLER_179_35 VPWR VGND sg13cmos5l_decap_8
XFILLER_242_196 VPWR VGND sg13cmos5l_decap_8
XFILLER_42_257 VPWR VGND sg13cmos5l_decap_4
XFILLER_329_49 VPWR VGND sg13cmos5l_decap_8
XFILLER_10_176 VPWR VGND sg13cmos5l_decap_8
XFILLER_344_215 VPWR VGND sg13cmos5l_decap_8
XFILLER_10_187 VPWR VGND sg13cmos5l_fill_2
XFILLER_195_56 VPWR VGND sg13cmos5l_decap_8
XFILLER_88_21 VPWR VGND sg13cmos5l_decap_8
XFILLER_163_181 VPWR VGND sg13cmos5l_decap_4
XFILLER_5_0 VPWR VGND sg13cmos5l_decap_8
XFILLER_312_145 VPWR VGND sg13cmos5l_decap_8
XFILLER_104_270 VPWR VGND sg13cmos5l_fill_2
XFILLER_218_171 VPWR VGND sg13cmos5l_decap_4
XFILLER_225_119 VPWR VGND sg13cmos5l_decap_4
XFILLER_280_214 VPWR VGND sg13cmos5l_decap_8
XFILLER_160_70 VPWR VGND sg13cmos5l_decap_8
XFILLER_37_91 VPWR VGND sg13cmos5l_decap_8
XFILLER_33_213 VPWR VGND sg13cmos5l_decap_4
XFILLER_178_218 VPWR VGND sg13cmos5l_decap_8
XFILLER_310_84 VPWR VGND sg13cmos5l_decap_8
X_1961_ Tile_X0Y1_E2BEG[6] _2299_/X VPWR VGND sg13cmos5l_buf_1
XFILLER_239_49 VPWR VGND sg13cmos5l_decap_8
X_1892_ Tile_X0Y1_FrameData_O[5] Tile_X0Y1_FrameData[5] VPWR VGND sg13cmos5l_buf_1
X_0912_ _0912_/Q Tile_X0Y3_FrameData[6] VGND VPWR Tile_X0Y5_FrameStrobe[3] latch
XFILLER_146_115 VPWR VGND sg13cmos5l_decap_4
XFILLER_335_226 VPWR VGND sg13cmos5l_fill_2
X_0843_ _0843_/Q Tile_X0Y3_FrameData[11] VGND VPWR Tile_X0Y5_FrameStrobe[1] latch
X_2513_ _2513_/X AXIL_S_SOC_ARADDR2 AXIL_S_SOC_ARADDR4 _2592_/X _2593_/X _0978_/Q
+ _0977_/Q VPWR VGND sg13cmos5l_mux4_1
X_0774_ _0774_/Q Tile_X0Y2_FrameData[0] VGND VPWR Tile_X0Y5_FrameStrobe[6] latch
XFILLER_303_112 VPWR VGND sg13cmos5l_decap_8
XFILLER_335_70 VPWR VGND sg13cmos5l_decap_8
X_2444_ _2444_/X AXIL_S_SOC_AWADDR3 _2480_/X _2479_/X _2488_/X _0660_/Q _0659_/Q VPWR
+ VGND sg13cmos5l_mux4_1
XFILLER_271_14 VPWR VGND sg13cmos5l_decap_8
XFILLER_303_189 VPWR VGND sg13cmos5l_decap_4
X_2375_ _2375_/X _2253_/X _2386_/X _2385_/X Tile_X0Y0_S2MID[2] _0330_/Q _0329_/Q VPWR
+ VGND sg13cmos5l_mux4_1
XFILLER_38_0 VPWR VGND sg13cmos5l_decap_8
XFILLER_110_240 VPWR VGND sg13cmos5l_decap_8
XFILLER_256_211 VPWR VGND sg13cmos5l_decap_8
XFILLER_256_222 VPWR VGND sg13cmos5l_fill_1
X_1326_ _1326_/Q Tile_X0Y5_FrameData[2] VGND VPWR Tile_X0Y5_FrameStrobe[1] latch
XFILLER_68_154 VPWR VGND sg13cmos5l_decap_8
XFILLER_256_266 VPWR VGND sg13cmos5l_fill_1
XFILLER_68_176 VPWR VGND sg13cmos5l_decap_8
XFILLER_17_28 VPWR VGND sg13cmos5l_decap_8
XFILLER_204_63 VPWR VGND sg13cmos5l_decap_8
X_1257_ _1257_/Q Tile_X0Y4_FrameData[29] VGND VPWR Tile_X0Y5_FrameStrobe[7] latch
XFILLER_351_91 VPWR VGND sg13cmos5l_decap_8
XFILLER_271_236 VPWR VGND sg13cmos5l_fill_2
X_1188_ _1188_/Q Tile_X0Y4_FrameData[2] VGND VPWR Tile_X0Y5_FrameStrobe[4] latch
X_0208_ _0208_/Q Tile_X0Y0_FrameData[22] VGND VPWR Tile_X0Y5_FrameStrobe[4] latch
XFILLER_24_224 VPWR VGND sg13cmos5l_decap_4
X_0139_ _0139_/Q Tile_X0Y0_FrameData[27] VGND VPWR Tile_X0Y5_FrameStrobe[2] latch
XFILLER_220_84 VPWR VGND sg13cmos5l_decap_8
XFILLER_149_49 VPWR VGND sg13cmos5l_decap_8
XFILLER_296_77 VPWR VGND sg13cmos5l_decap_8
XFILLER_116_7 VPWR VGND sg13cmos5l_decap_8
XFILLER_152_118 VPWR VGND sg13cmos5l_decap_8
XFILLER_165_15 VPWR VGND sg13cmos5l_decap_8
XFILLER_160_151 VPWR VGND sg13cmos5l_decap_8
XFILLER_245_70 VPWR VGND sg13cmos5l_decap_8
XFILLER_181_14 VPWR VGND sg13cmos5l_decap_8
XFILLER_58_35 VPWR VGND sg13cmos5l_decap_8
XFILLER_247_200 VPWR VGND sg13cmos5l_decap_8
XFILLER_247_233 VPWR VGND sg13cmos5l_fill_1
XFILLER_59_154 VPWR VGND sg13cmos5l_decap_8
XFILLER_114_63 VPWR VGND sg13cmos5l_decap_8
XFILLER_331_28 VPWR VGND sg13cmos5l_decap_8
XFILLER_261_91 VPWR VGND sg13cmos5l_decap_8
XFILLER_262_236 VPWR VGND sg13cmos5l_fill_2
XFILLER_74_56 VPWR VGND sg13cmos5l_decap_8
XFILLER_130_84 VPWR VGND sg13cmos5l_decap_8
XFILLER_130_95 VPWR VGND sg13cmos5l_fill_2
XFILLER_142_0 VPWR VGND sg13cmos5l_decap_8
XFILLER_230_133 VPWR VGND sg13cmos5l_decap_8
XFILLER_90_22 VPWR VGND sg13cmos5l_decap_8
XFILLER_30_249 VPWR VGND sg13cmos5l_decap_4
XFILLER_356_14 VPWR VGND sg13cmos5l_decap_8
XANTENNA__2071__X Tile_X0Y5_S4BEG[4] VPWR VGND sg13cmos5l_antennanp
XFILLER_317_237 VPWR VGND sg13cmos5l_fill_1
XFILLER_143_118 VPWR VGND sg13cmos5l_decap_8
XFILLER_99_42 VPWR VGND sg13cmos5l_decap_8
XFILLER_136_192 VPWR VGND sg13cmos5l_decap_8
XFILLER_151_140 VPWR VGND sg13cmos5l_decap_8
XFILLER_151_151 VPWR VGND sg13cmos5l_fill_1
XFILLER_297_133 VPWR VGND sg13cmos5l_decap_8
X_0490_ _0490_/Q Tile_X0Y1_FrameData[12] VGND VPWR Tile_X0Y5_FrameStrobe[5] latch
XFILLER_151_173 VPWR VGND sg13cmos5l_decap_8
XFILLER_155_70 VPWR VGND sg13cmos5l_decap_8
XFILLER_300_126 VPWR VGND sg13cmos5l_decap_8
XFILLER_31_7 VPWR VGND sg13cmos5l_decap_8
XFILLER_305_84 VPWR VGND sg13cmos5l_decap_8
X_2160_ _2160_/X _2235_/X _2233_/X _2218_/X _2217_/X _0277_/Q _0276_/Q VPWR VGND sg13cmos5l_mux4_1
XFILLER_241_28 VPWR VGND sg13cmos5l_decap_8
X_2091_ Tile_X0Y3_E2BEG[3] _2512_/X VPWR VGND sg13cmos5l_buf_1
X_1111_ _1111_/Q Tile_X0Y4_FrameData[15] VGND VPWR Tile_X0Y5_FrameStrobe[2] latch
XFILLER_0_42 VPWR VGND sg13cmos5l_decap_8
XFILLER_171_91 VPWR VGND sg13cmos5l_decap_8
X_1042_ _1042_/Q Tile_X0Y4_FrameData[20] VGND VPWR Tile_X0Y5_FrameStrobe[0] latch
XFILLER_80_105 VPWR VGND sg13cmos5l_fill_1
XFILLER_321_83 VPWR VGND sg13cmos5l_decap_8
XFILLER_221_122 VPWR VGND sg13cmos5l_decap_8
XFILLER_73_190 VPWR VGND sg13cmos5l_decap_8
XFILLER_159_251 VPWR VGND sg13cmos5l_decap_8
X_1944_ Tile_X0Y1_E6BEG[9] _2334_/X VPWR VGND sg13cmos5l_buf_1
XFILLER_119_126 VPWR VGND sg13cmos5l_decap_8
XFILLER_266_14 VPWR VGND sg13cmos5l_decap_8
XFILLER_308_204 VPWR VGND sg13cmos5l_fill_2
XFILLER_9_84 VPWR VGND sg13cmos5l_decap_8
X_1875_ Tile_X0Y2_E6BEG[1] _2434_/X VPWR VGND sg13cmos5l_buf_1
X_0826_ _0826_/Q Tile_X0Y3_FrameData[28] VGND VPWR Tile_X0Y5_FrameStrobe[1] latch
X_0757_ _0757_/Q Tile_X0Y2_FrameData[17] VGND VPWR Tile_X0Y5_FrameStrobe[6] latch
XFILLER_142_140 VPWR VGND sg13cmos5l_decap_8
XFILLER_288_133 VPWR VGND sg13cmos5l_decap_8
XFILLER_88_216 VPWR VGND sg13cmos5l_fill_1
XFILLER_346_91 VPWR VGND sg13cmos5l_decap_8
XFILLER_282_35 VPWR VGND sg13cmos5l_decap_8
X_2427_ _2427_/X AXIL_S_SOC_AWADDR6 AXIL_S_SOC_AWPROT0 _2477_/X _2486_/X _0694_/Q
+ _0693_/Q VPWR VGND sg13cmos5l_mux4_1
X_0688_ _0688_/Q Tile_X0Y2_FrameData[22] VGND VPWR Tile_X0Y5_FrameStrobe[4] latch
XFILLER_229_222 VPWR VGND sg13cmos5l_fill_2
XFILLER_215_84 VPWR VGND sg13cmos5l_decap_4
X_2358_ _2358_/X _2344_/X _0031_/X _2343_/X Tile_X0Y0_S4END[5] _0348_/Q _0347_/Q VPWR
+ VGND sg13cmos5l_mux4_1
XFILLER_151_28 VPWR VGND sg13cmos5l_decap_8
XFILLER_244_214 VPWR VGND sg13cmos5l_fill_1
XFILLER_28_49 VPWR VGND sg13cmos5l_decap_8
X_1309_ _1309_/Q Tile_X0Y5_FrameData[19] VGND VPWR Tile_X0Y5_FrameStrobe[1] latch
X_2289_ _2289_/X _2342_/X _2341_/X AXIL_S_SOC_WDATA2 AXIL_S_SOC_WDATA7 _0514_/Q _0513_/Q
+ VPWR VGND sg13cmos5l_mux4_1
XFILLER_244_258 VPWR VGND sg13cmos5l_fill_1
XFILLER_56_168 VPWR VGND sg13cmos5l_decap_8
XFILLER_71_149 VPWR VGND sg13cmos5l_fill_1
XANTENNA__1995__X Tile_X0Y5_E6BEG[8] VPWR VGND sg13cmos5l_antennanp
XFILLER_100_21 VPWR VGND sg13cmos5l_decap_8
XFILLER_358_126 VPWR VGND sg13cmos5l_decap_8
XFILLER_233_7 VPWR VGND sg13cmos5l_decap_8
XFILLER_100_98 VPWR VGND sg13cmos5l_decap_4
XFILLER_60_14 VPWR VGND sg13cmos5l_decap_8
XFILLER_165_232 VPWR VGND sg13cmos5l_decap_8
XFILLER_176_14 VPWR VGND sg13cmos5l_decap_8
XFILLER_109_63 VPWR VGND sg13cmos5l_decap_8
XFILLER_180_224 VPWR VGND sg13cmos5l_decap_8
XFILLER_326_28 VPWR VGND sg13cmos5l_decap_8
XFILLER_256_91 VPWR VGND sg13cmos5l_decap_8
XFILLER_69_56 VPWR VGND sg13cmos5l_decap_8
XFILLER_133_162 VPWR VGND sg13cmos5l_decap_8
XFILLER_192_35 VPWR VGND sg13cmos5l_decap_8
XFILLER_94_208 VPWR VGND sg13cmos5l_fill_2
XFILLER_125_84 VPWR VGND sg13cmos5l_decap_8
XFILLER_294_147 VPWR VGND sg13cmos5l_decap_8
XFILLER_85_22 VPWR VGND sg13cmos5l_decap_8
XFILLER_235_214 VPWR VGND sg13cmos5l_fill_1
XFILLER_235_236 VPWR VGND sg13cmos5l_decap_8
XFILLER_62_105 VPWR VGND sg13cmos5l_decap_8
XFILLER_357_0 VPWR VGND sg13cmos5l_decap_8
XANTENNA__2066__X Tile_X0Y5_S2BEGb[7] VPWR VGND sg13cmos5l_antennanp
XFILLER_141_94 VPWR VGND sg13cmos5l_decap_8
XFILLER_203_133 VPWR VGND sg13cmos5l_decap_8
XFILLER_349_126 VPWR VGND sg13cmos5l_decap_8
XFILLER_34_70 VPWR VGND sg13cmos5l_decap_8
XFILLER_11_271 VPWR VGND sg13cmos5l_fill_2
XFILLER_156_232 VPWR VGND sg13cmos5l_decap_8
XFILLER_79_7 VPWR VGND sg13cmos5l_decap_8
X_1660_ Tile_X0Y0_FrameData_O[0] Tile_X0Y0_FrameData[0] VPWR VGND sg13cmos5l_buf_1
XFILLER_236_28 VPWR VGND sg13cmos5l_decap_8
X_1591_ Tile_X0Y2_EE4BEG[4] _2421_/X VPWR VGND sg13cmos5l_buf_1
X_0611_ _0611_/Q Tile_X0Y2_FrameData[3] VGND VPWR Tile_X0Y5_FrameStrobe[1] latch
XFILLER_50_91 VPWR VGND sg13cmos5l_decap_8
XFILLER_166_91 VPWR VGND sg13cmos5l_decap_4
X_0542_ _0542_/Q Tile_X0Y1_FrameData[24] VGND VPWR Tile_X0Y5_FrameStrobe[7] latch
X_0473_ _0473_/Q Tile_X0Y1_FrameData[29] VGND VPWR Tile_X0Y5_FrameStrobe[5] latch
XFILLER_252_49 VPWR VGND sg13cmos5l_decap_8
XFILLER_285_158 VPWR VGND sg13cmos5l_decap_8
X_2212_ _2212_/X _2216_/X Tile_X0Y0_S1END[3] Tile_X0Y0_W6END[3] _2212_/A3 _0072_/Q
+ _0311_/Q VPWR VGND sg13cmos5l_mux4_1
XFILLER_85_208 VPWR VGND sg13cmos5l_decap_8
X_2143_ _2143_/X Tile_X0Y0_W1END[2] Tile_X0Y0_W6END[6] _2221_/X _2211_/X _0306_/Q
+ _0305_/Q VPWR VGND sg13cmos5l_mux4_1
XFILLER_226_225 VPWR VGND sg13cmos5l_decap_8
XFILLER_226_236 VPWR VGND sg13cmos5l_fill_2
XFILLER_293_180 VPWR VGND sg13cmos5l_decap_8
XFILLER_293_191 VPWR VGND sg13cmos5l_fill_2
XFILLER_93_241 VPWR VGND sg13cmos5l_fill_2
XFILLER_53_105 VPWR VGND sg13cmos5l_decap_8
XFILLER_226_269 VPWR VGND sg13cmos5l_decap_4
XFILLER_241_217 VPWR VGND sg13cmos5l_decap_8
X_2074_ Tile_X0Y5_S4BEG[7] _2074_/A VPWR VGND sg13cmos5l_buf_1
X_1025_ _1025_/Q Tile_X0Y3_FrameData[21] VGND VPWR Tile_X0Y5_FrameStrobe[7] latch
XFILLER_201_42 VPWR VGND sg13cmos5l_decap_8
XFILLER_61_171 VPWR VGND sg13cmos5l_fill_2
XFILLER_277_35 VPWR VGND sg13cmos5l_decap_8
X_1927_ Tile_X0Y1_EE4BEG[8] _2317_/X VPWR VGND sg13cmos5l_buf_1
XFILLER_30_28 VPWR VGND sg13cmos5l_decap_8
X_1858_ Tile_X0Y4_FrameData_O[25] Tile_X0Y4_FrameData[25] VPWR VGND sg13cmos5l_buf_1
XFILLER_146_28 VPWR VGND sg13cmos5l_decap_8
X_0809_ _0809_/Q Tile_X0Y3_FrameData[13] VGND VPWR Tile_X0Y5_FrameStrobe[0] latch
XFILLER_115_140 VPWR VGND sg13cmos5l_decap_8
XFILLER_293_56 VPWR VGND sg13cmos5l_decap_8
X_1789_ Tile_X0Y4_E2BEG[0] _2617_/X VPWR VGND sg13cmos5l_buf_1
XFILLER_115_184 VPWR VGND sg13cmos5l_decap_8
XFILLER_226_50 VPWR VGND sg13cmos5l_decap_8
XFILLER_276_136 VPWR VGND sg13cmos5l_decap_8
XFILLER_162_49 VPWR VGND sg13cmos5l_decap_8
XFILLER_183_7 VPWR VGND sg13cmos5l_decap_8
XFILLER_217_236 VPWR VGND sg13cmos5l_fill_2
XFILLER_55_14 VPWR VGND sg13cmos5l_decap_8
XFILLER_232_206 VPWR VGND sg13cmos5l_decap_8
XFILLER_44_116 VPWR VGND sg13cmos5l_decap_8
XFILLER_232_217 VPWR VGND sg13cmos5l_fill_1
XFILLER_232_239 VPWR VGND sg13cmos5l_decap_8
XFILLER_350_7 VPWR VGND sg13cmos5l_decap_8
XFILLER_111_42 VPWR VGND sg13cmos5l_decap_8
XFILLER_71_35 VPWR VGND sg13cmos5l_decap_8
XFILLER_52_182 VPWR VGND sg13cmos5l_decap_8
XFILLER_187_35 VPWR VGND sg13cmos5l_decap_8
XFILLER_339_170 VPWR VGND sg13cmos5l_decap_8
XFILLER_354_140 VPWR VGND sg13cmos5l_decap_8
XFILLER_337_49 VPWR VGND sg13cmos5l_decap_8
XFILLER_153_224 VPWR VGND sg13cmos5l_decap_8
XFILLER_105_0 VPWR VGND sg13cmos5l_decap_8
XFILLER_106_140 VPWR VGND sg13cmos5l_decap_8
XFILLER_96_21 VPWR VGND sg13cmos5l_decap_8
XFILLER_121_154 VPWR VGND sg13cmos5l_fill_2
XFILLER_121_187 VPWR VGND sg13cmos5l_decap_8
XFILLER_29_70 VPWR VGND sg13cmos5l_decap_8
XFILLER_96_98 VPWR VGND sg13cmos5l_decap_8
XFILLER_290_161 VPWR VGND sg13cmos5l_decap_8
XFILLER_35_105 VPWR VGND sg13cmos5l_decap_8
XFILLER_302_63 VPWR VGND sg13cmos5l_decap_8
XFILLER_50_119 VPWR VGND sg13cmos5l_decap_8
XFILLER_45_91 VPWR VGND sg13cmos5l_decap_8
XFILLER_231_272 VPWR VGND sg13cmos5l_fill_1
X_2830_ _2830_/X Tile_X0Y4_W2MID[6] Tile_X0Y4_W2END[6] Tile_X0Y4_W6END[9] _2709_/X
+ _1122_/Q _1121_/Q VPWR VGND sg13cmos5l_mux4_1
XFILLER_43_193 VPWR VGND sg13cmos5l_decap_8
X_2761_ _2761_/X AXIL_S_SOC_RREADY _2817_/X _2802_/X _2825_/X _1380_/Q _1379_/Q VPWR
+ VGND sg13cmos5l_mux4_1
XFILLER_247_49 VPWR VGND sg13cmos5l_decap_8
X_1712_ Tile_X0Y0_E6BEG[4] _2201_/X VPWR VGND sg13cmos5l_buf_1
X_2692_ _2692_/X _2676_/X Tile_X0Y5_N4END[5] _2675_/X _0071_/X _1060_/Q _1059_/Q VPWR
+ VGND sg13cmos5l_mux4_1
XFILLER_345_140 VPWR VGND sg13cmos5l_decap_8
XANTENNA_1 AXIL_S_SOC_AWPROT1 VPWR VGND sg13cmos5l_antennanp
X_1643_ Tile_X0Y0_FrameStrobe_O[3] Tile_X0Y5_FrameStrobe[3] VPWR VGND sg13cmos5l_buf_1
XFILLER_6_63 VPWR VGND sg13cmos5l_decap_8
X_1574_ Tile_X0Y3_FrameData_O[20] Tile_X0Y3_FrameData[20] VPWR VGND sg13cmos5l_buf_1
XFILLER_360_176 VPWR VGND sg13cmos5l_decap_8
XFILLER_298_272 VPWR VGND sg13cmos5l_fill_1
XFILLER_301_210 VPWR VGND sg13cmos5l_decap_8
X_0525_ _0525_/Q Tile_X0Y1_FrameData[9] VGND VPWR Tile_X0Y5_FrameStrobe[6] latch
XFILLER_112_154 VPWR VGND sg13cmos5l_decap_8
X_0456_ _0456_/Q Tile_X0Y1_FrameData[14] VGND VPWR Tile_X0Y5_FrameStrobe[4] latch
XFILLER_58_219 VPWR VGND sg13cmos5l_decap_8
XFILLER_112_187 VPWR VGND sg13cmos5l_decap_8
XFILLER_112_198 VPWR VGND sg13cmos5l_fill_1
XFILLER_20_0 VPWR VGND sg13cmos5l_decap_8
XFILLER_343_70 VPWR VGND sg13cmos5l_decap_8
XANTENNA__1603__X Tile_X0Y0_UserCLKo VPWR VGND sg13cmos5l_antennanp
X_0387_ _0387_/Q Tile_X0Y1_FrameData[19] VGND VPWR Tile_X0Y5_FrameStrobe[2] latch
XFILLER_26_105 VPWR VGND sg13cmos5l_decap_8
X_2126_ AXIL_S_SOC_RDATA20 Tile_X0Y1_W2MID[4] Tile_X0Y1_W2END[4] Tile_X0Y1_W6END[4]
+ _2377_/X _0374_/Q _0373_/Q VPWR VGND sg13cmos5l_mux4_1
XFILLER_81_200 VPWR VGND sg13cmos5l_decap_8
XFILLER_212_63 VPWR VGND sg13cmos5l_decap_8
XFILLER_214_239 VPWR VGND sg13cmos5l_decap_8
XFILLER_281_194 VPWR VGND sg13cmos5l_fill_2
X_2057_ Tile_X0Y5_S2BEG[6] _2779_/X VPWR VGND sg13cmos5l_buf_1
XFILLER_25_28 VPWR VGND sg13cmos5l_decap_8
X_1008_ _1008_/Q Tile_X0Y3_FrameData[6] VGND VPWR Tile_X0Y5_FrameStrobe[6] latch
XFILLER_179_154 VPWR VGND sg13cmos5l_decap_8
XFILLER_222_250 VPWR VGND sg13cmos5l_decap_8
XFILLER_288_56 VPWR VGND sg13cmos5l_decap_8
XFILLER_194_102 VPWR VGND sg13cmos5l_fill_2
XFILLER_194_157 VPWR VGND sg13cmos5l_fill_1
XFILLER_135_224 VPWR VGND sg13cmos5l_decap_4
XFILLER_157_49 VPWR VGND sg13cmos5l_decap_8
XFILLER_135_268 VPWR VGND sg13cmos5l_decap_4
XFILLER_351_154 VPWR VGND sg13cmos5l_decap_8
XFILLER_9_7 VPWR VGND sg13cmos5l_decap_8
XFILLER_103_132 VPWR VGND sg13cmos5l_decap_8
XFILLER_289_272 VPWR VGND sg13cmos5l_fill_1
XFILLER_106_42 VPWR VGND sg13cmos5l_decap_8
XFILLER_253_70 VPWR VGND sg13cmos5l_decap_8
XFILLER_66_35 VPWR VGND sg13cmos5l_decap_8
XFILLER_257_191 VPWR VGND sg13cmos5l_decap_8
XFILLER_264_139 VPWR VGND sg13cmos5l_decap_4
XFILLER_57_252 VPWR VGND sg13cmos5l_fill_2
XFILLER_17_105 VPWR VGND sg13cmos5l_decap_8
XFILLER_122_63 VPWR VGND sg13cmos5l_decap_8
XFILLER_82_56 VPWR VGND sg13cmos5l_decap_8
XFILLER_359_210 VPWR VGND sg13cmos5l_decap_8
XFILLER_198_56 VPWR VGND sg13cmos5l_decap_8
XFILLER_213_272 VPWR VGND sg13cmos5l_fill_1
XFILLER_222_0 VPWR VGND sg13cmos5l_decap_8
XFILLER_287_209 VPWR VGND sg13cmos5l_decap_8
XFILLER_99_119 VPWR VGND sg13cmos5l_fill_1
XFILLER_295_231 VPWR VGND sg13cmos5l_decap_8
X_0310_ _0310_/Q Tile_X0Y0_FrameData[16] VGND VPWR Tile_X0Y5_FrameStrobe[7] latch
XFILLER_163_70 VPWR VGND sg13cmos5l_decap_8
X_1290_ _1290_/Q Tile_X0Y5_FrameData[6] VGND VPWR Tile_X0Y5_FrameStrobe[0] latch
X_0241_ _0241_/Q Tile_X0Y0_FrameData[21] VGND VPWR Tile_X0Y5_FrameStrobe[5] latch
XFILLER_313_84 VPWR VGND sg13cmos5l_decap_8
X_0172_ _0172_/Q Tile_X0Y0_FrameData[26] VGND VPWR Tile_X0Y5_FrameStrobe[3] latch
XFILLER_23_119 VPWR VGND sg13cmos5l_fill_1
XFILLER_204_261 VPWR VGND sg13cmos5l_decap_4
X_2813_ _2813_/X Tile_X0Y5_N1END[0] Tile_X0Y5_N4END[0] _2793_/X _0032_/X _1296_/Q
+ _1295_/Q VPWR VGND sg13cmos5l_mux4_1
XFILLER_176_168 VPWR VGND sg13cmos5l_decap_4
XFILLER_117_224 VPWR VGND sg13cmos5l_decap_8
XFILLER_318_173 VPWR VGND sg13cmos5l_fill_2
XFILLER_333_110 VPWR VGND sg13cmos5l_fill_2
X_2744_ _2744_/X AXIL_S_SOC_ARPROT0 AXIL_S_SOC_ARVALID _2813_/X _2800_/X _1414_/Q
+ _1413_/Q VPWR VGND sg13cmos5l_mux4_1
XFILLER_68_0 VPWR VGND sg13cmos5l_decap_8
XFILLER_338_70 VPWR VGND sg13cmos5l_decap_8
XFILLER_274_14 VPWR VGND sg13cmos5l_decap_8
X_2675_ _2675_/X Tile_X0Y3_W1END[1] Tile_X0Y3_W6END[9] _2577_/X _2562_/X _0896_/Q
+ _0895_/Q VPWR VGND sg13cmos5l_mux4_1
X_1626_ Tile_X0Y0_N2BEGb[6] _2262_/X VPWR VGND sg13cmos5l_buf_1
XFILLER_207_63 VPWR VGND sg13cmos5l_decap_8
X_1557_ Tile_X0Y3_FrameData_O[3] Tile_X0Y3_FrameData[3] VPWR VGND sg13cmos5l_buf_1
X_0508_ _0508_/Q Tile_X0Y1_FrameData[26] VGND VPWR Tile_X0Y5_FrameStrobe[6] latch
XFILLER_354_91 VPWR VGND sg13cmos5l_decap_8
XFILLER_100_102 VPWR VGND sg13cmos5l_fill_2
XFILLER_140_271 VPWR VGND sg13cmos5l_fill_2
XFILLER_286_253 VPWR VGND sg13cmos5l_fill_2
XFILLER_286_264 VPWR VGND sg13cmos5l_fill_1
XFILLER_290_35 VPWR VGND sg13cmos5l_decap_8
X_1488_ _1488_/Q Tile_X0Y5_FrameData[0] VGND VPWR Tile_X0Y5_FrameStrobe[6] latch
XFILLER_98_185 VPWR VGND sg13cmos5l_decap_8
X_0439_ _0439_/Q Tile_X0Y1_FrameData[31] VGND VPWR Tile_X0Y5_FrameStrobe[4] latch
XFILLER_223_84 VPWR VGND sg13cmos5l_decap_8
XFILLER_223_95 VPWR VGND sg13cmos5l_fill_2
X_2109_ AXIL_S_SOC_RDATA3 Tile_X0Y3_W2MID[3] Tile_X0Y3_W2END[3] Tile_X0Y3_W6END[3]
+ _2592_/X _0856_/Q _0855_/Q VPWR VGND sg13cmos5l_mux4_1
XFILLER_36_49 VPWR VGND sg13cmos5l_decap_8
XFILLER_14_119 VPWR VGND sg13cmos5l_decap_8
XFILLER_254_194 VPWR VGND sg13cmos5l_fill_2
XFILLER_54_255 VPWR VGND sg13cmos5l_fill_2
XFILLER_202_209 VPWR VGND sg13cmos5l_fill_1
XFILLER_299_77 VPWR VGND sg13cmos5l_decap_8
XFILLER_146_7 VPWR VGND sg13cmos5l_decap_8
XFILLER_167_135 VPWR VGND sg13cmos5l_fill_1
XFILLER_356_224 VPWR VGND sg13cmos5l_decap_8
XFILLER_182_105 VPWR VGND sg13cmos5l_decap_8
XFILLER_309_140 VPWR VGND sg13cmos5l_decap_8
XFILLER_313_7 VPWR VGND sg13cmos5l_decap_8
XFILLER_248_70 VPWR VGND sg13cmos5l_decap_8
XFILLER_184_14 VPWR VGND sg13cmos5l_decap_8
XFILLER_117_63 VPWR VGND sg13cmos5l_decap_8
XFILLER_334_28 VPWR VGND sg13cmos5l_decap_8
XFILLER_264_91 VPWR VGND sg13cmos5l_decap_8
XFILLER_89_152 VPWR VGND sg13cmos5l_decap_4
XFILLER_89_196 VPWR VGND sg13cmos5l_fill_2
XFILLER_77_56 VPWR VGND sg13cmos5l_decap_8
XFILLER_292_212 VPWR VGND sg13cmos5l_decap_8
XFILLER_133_84 VPWR VGND sg13cmos5l_decap_8
XFILLER_292_245 VPWR VGND sg13cmos5l_decap_4
XFILLER_45_211 VPWR VGND sg13cmos5l_decap_8
XFILLER_350_49 VPWR VGND sg13cmos5l_decap_8
XFILLER_172_0 VPWR VGND sg13cmos5l_decap_8
XFILLER_245_161 VPWR VGND sg13cmos5l_decap_4
XANTENNA_210 Tile_X0Y5_FrameStrobe[11] VPWR VGND sg13cmos5l_antennanp
XANTENNA_221 Tile_X0Y5_FrameStrobe[9] VPWR VGND sg13cmos5l_antennanp
XANTENNA_232 Tile_X0Y5_N2MID[5] VPWR VGND sg13cmos5l_antennanp
XANTENNA_243 AXIL_S_SOC_WDATA22 VPWR VGND sg13cmos5l_antennanp
XFILLER_93_77 VPWR VGND sg13cmos5l_decap_8
XFILLER_60_203 VPWR VGND sg13cmos5l_fill_2
XANTENNA_254 AXIL_S_SOC_WDATA22 VPWR VGND sg13cmos5l_antennanp
XANTENNA_265 AXIL_S_SOC_WDATA22 VPWR VGND sg13cmos5l_antennanp
XANTENNA_276 AXIL_S_SOC_WDATA22 VPWR VGND sg13cmos5l_antennanp
XFILLER_359_14 VPWR VGND sg13cmos5l_decap_8
XANTENNA_287 AXIL_S_SOC_WDATA22 VPWR VGND sg13cmos5l_antennanp
XANTENNA_298 AXIL_S_SOC_WDATA19 VPWR VGND sg13cmos5l_antennanp
XANTENNA__2074__X Tile_X0Y5_S4BEG[7] VPWR VGND sg13cmos5l_antennanp
XFILLER_198_260 VPWR VGND sg13cmos5l_fill_2
XFILLER_260_197 VPWR VGND sg13cmos5l_decap_4
XFILLER_9_112 VPWR VGND sg13cmos5l_decap_8
XFILLER_173_105 VPWR VGND sg13cmos5l_decap_8
XFILLER_158_70 VPWR VGND sg13cmos5l_decap_8
X_0790_ _0790_/Q Tile_X0Y2_FrameData[16] VGND VPWR Tile_X0Y5_FrameStrobe[7] latch
XFILLER_61_7 VPWR VGND sg13cmos5l_decap_8
XFILLER_330_102 VPWR VGND sg13cmos5l_fill_1
X_2460_ _2460_/X Tile_X0Y3_W1END[1] Tile_X0Y3_W6END[5] _2577_/X _2562_/X _1028_/Q
+ _1027_/Q VPWR VGND sg13cmos5l_mux4_1
XFILLER_181_182 VPWR VGND sg13cmos5l_decap_4
XFILLER_244_28 VPWR VGND sg13cmos5l_decap_8
XFILLER_308_84 VPWR VGND sg13cmos5l_decap_8
XFILLER_315_187 VPWR VGND sg13cmos5l_fill_2
XFILLER_330_124 VPWR VGND sg13cmos5l_decap_8
XFILLER_330_135 VPWR VGND sg13cmos5l_fill_1
X_1411_ _1411_/Q Tile_X0Y5_FrameData[13] VGND VPWR Tile_X0Y5_FrameStrobe[4] latch
XFILLER_174_91 VPWR VGND sg13cmos5l_decap_8
XFILLER_330_157 VPWR VGND sg13cmos5l_fill_1
X_2391_ _2391_/X Tile_X0Y0_W1END[1] Tile_X0Y0_W2MID[2] Tile_X0Y0_W2END[2] _2246_/X
+ _0160_/Q _0159_/Q VPWR VGND sg13cmos5l_mux4_1
X_1342_ _1342_/Q Tile_X0Y5_FrameData[18] VGND VPWR Tile_X0Y5_FrameStrobe[2] latch
XFILLER_95_122 VPWR VGND sg13cmos5l_decap_4
XFILLER_3_42 VPWR VGND sg13cmos5l_decap_8
XFILLER_283_212 VPWR VGND sg13cmos5l_decap_4
X_1273_ _1273_/Q Tile_X0Y5_FrameData[23] VGND VPWR Tile_X0Y5_FrameStrobe[0] latch
XFILLER_260_49 VPWR VGND sg13cmos5l_decap_8
X_0224_ _0224_/Q Tile_X0Y0_FrameData[6] VGND VPWR Tile_X0Y5_FrameStrobe[4] latch
XFILLER_236_161 VPWR VGND sg13cmos5l_decap_8
XFILLER_236_172 VPWR VGND sg13cmos5l_fill_2
X_0155_ _0155_/Q Tile_X0Y0_FrameData[11] VGND VPWR Tile_X0Y5_FrameStrobe[2] latch
XFILLER_51_203 VPWR VGND sg13cmos5l_decap_4
XFILLER_269_14 VPWR VGND sg13cmos5l_decap_8
X_0086_ _0086_/Q Tile_X0Y0_FrameData[16] VGND VPWR Tile_X0Y5_FrameStrobe[0] latch
XFILLER_51_225 VPWR VGND sg13cmos5l_decap_8
XFILLER_349_91 VPWR VGND sg13cmos5l_decap_8
XFILLER_285_35 VPWR VGND sg13cmos5l_decap_8
X_0988_ _0988_/Q Tile_X0Y3_FrameData[26] VGND VPWR Tile_X0Y5_FrameStrobe[6] latch
XFILLER_353_238 VPWR VGND sg13cmos5l_decap_8
X_2727_ _2727_/X AXIL_S_SOC_ARPROT0 AXIL_S_SOC_ARPROT2 _2827_/X _2799_/X _1448_/Q
+ _1447_/Q VPWR VGND sg13cmos5l_mux4_1
XFILLER_306_154 VPWR VGND sg13cmos5l_decap_8
XFILLER_105_249 VPWR VGND sg13cmos5l_decap_8
XFILLER_154_28 VPWR VGND sg13cmos5l_decap_8
XFILLER_218_84 VPWR VGND sg13cmos5l_decap_8
X_2658_ _2658_/X AXIL_S_SOC_WSTRB1 _2703_/X _2701_/X _2683_/X _1138_/Q _1137_/Q VPWR
+ VGND sg13cmos5l_mux4_1
XFILLER_120_208 VPWR VGND sg13cmos5l_decap_8
X_1609_ Tile_X0Y0_N4BEG[5] _1609_/A VPWR VGND sg13cmos5l_buf_1
X_2589_ _2589_/X _2490_/X _2598_/X _2597_/X _2489_/X _0814_/Q _0813_/Q VPWR VGND sg13cmos5l_mux4_1
XFILLER_113_271 VPWR VGND sg13cmos5l_fill_2
XFILLER_219_117 VPWR VGND sg13cmos5l_decap_8
XANTENNA__1998__X Tile_X0Y5_E6BEG[11] VPWR VGND sg13cmos5l_antennanp
XFILLER_103_21 VPWR VGND sg13cmos5l_decap_8
XFILLER_170_49 VPWR VGND sg13cmos5l_decap_8
XFILLER_263_7 VPWR VGND sg13cmos5l_decap_8
XFILLER_27_266 VPWR VGND sg13cmos5l_decap_8
XFILLER_63_14 VPWR VGND sg13cmos5l_decap_8
XFILLER_103_98 VPWR VGND sg13cmos5l_decap_8
XFILLER_179_14 VPWR VGND sg13cmos5l_decap_8
XFILLER_242_175 VPWR VGND sg13cmos5l_decap_8
XFILLER_10_133 VPWR VGND sg13cmos5l_decap_8
XFILLER_155_105 VPWR VGND sg13cmos5l_fill_2
XFILLER_259_91 VPWR VGND sg13cmos5l_decap_8
XFILLER_329_28 VPWR VGND sg13cmos5l_decap_8
XFILLER_195_35 VPWR VGND sg13cmos5l_decap_8
XFILLER_344_249 VPWR VGND sg13cmos5l_fill_1
XFILLER_12_84 VPWR VGND sg13cmos5l_decap_8
XFILLER_170_119 VPWR VGND sg13cmos5l_decap_8
XFILLER_128_84 VPWR VGND sg13cmos5l_decap_8
XFILLER_128_95 VPWR VGND sg13cmos5l_fill_2
XFILLER_163_193 VPWR VGND sg13cmos5l_decap_8
XFILLER_352_271 VPWR VGND sg13cmos5l_fill_2
XFILLER_345_49 VPWR VGND sg13cmos5l_decap_8
XFILLER_88_77 VPWR VGND sg13cmos5l_fill_2
XANTENNA__2069__X Tile_X0Y5_S4BEG[2] VPWR VGND sg13cmos5l_antennanp
XFILLER_77_188 VPWR VGND sg13cmos5l_decap_8
XFILLER_218_150 VPWR VGND sg13cmos5l_decap_8
XANTENNA__1701__X Tile_X0Y0_EE4BEG[9] VPWR VGND sg13cmos5l_antennanp
XFILLER_37_70 VPWR VGND sg13cmos5l_decap_8
XFILLER_233_197 VPWR VGND sg13cmos5l_fill_1
XFILLER_310_63 VPWR VGND sg13cmos5l_decap_8
X_1960_ Tile_X0Y1_E2BEG[5] _2298_/X VPWR VGND sg13cmos5l_buf_1
XFILLER_239_28 VPWR VGND sg13cmos5l_decap_8
X_1891_ Tile_X0Y1_FrameData_O[4] Tile_X0Y1_FrameData[4] VPWR VGND sg13cmos5l_buf_1
X_0911_ _0911_/Q Tile_X0Y3_FrameData[7] VGND VPWR Tile_X0Y5_FrameStrobe[3] latch
XFILLER_53_91 VPWR VGND sg13cmos5l_decap_8
XFILLER_169_91 VPWR VGND sg13cmos5l_decap_8
X_0842_ _0842_/Q Tile_X0Y3_FrameData[12] VGND VPWR Tile_X0Y5_FrameStrobe[1] latch
XFILLER_139_190 VPWR VGND sg13cmos5l_fill_2
X_0773_ _0773_/Q Tile_X0Y2_FrameData[1] VGND VPWR Tile_X0Y5_FrameStrobe[6] latch
X_2512_ _2512_/X AXIL_S_SOC_ARADDR1 AXIL_S_SOC_ARADDR3 _2592_/X _2593_/X _0980_/Q
+ _0979_/Q VPWR VGND sg13cmos5l_mux4_1
XFILLER_154_182 VPWR VGND sg13cmos5l_fill_2
XFILLER_255_49 VPWR VGND sg13cmos5l_decap_8
XFILLER_303_168 VPWR VGND sg13cmos5l_decap_8
X_2443_ _2443_/X AXIL_S_SOC_AWADDR2 _2478_/X _2477_/X _2487_/X _0662_/Q _0661_/Q VPWR
+ VGND sg13cmos5l_mux4_1
X_2374_ _2374_/X _2251_/X _2384_/X _2383_/X Tile_X0Y0_S2MID[1] _0332_/Q _0331_/Q VPWR
+ VGND sg13cmos5l_mux4_1
X_1325_ _1325_/Q Tile_X0Y5_FrameData[3] VGND VPWR Tile_X0Y5_FrameStrobe[1] latch
XFILLER_68_133 VPWR VGND sg13cmos5l_decap_8
XFILLER_204_42 VPWR VGND sg13cmos5l_decap_8
XFILLER_271_215 VPWR VGND sg13cmos5l_decap_8
X_1256_ _1256_/Q Tile_X0Y4_FrameData[30] VGND VPWR Tile_X0Y5_FrameStrobe[7] latch
XFILLER_351_70 VPWR VGND sg13cmos5l_decap_8
XANTENNA__1611__X Tile_X0Y0_N4BEG[7] VPWR VGND sg13cmos5l_antennanp
XFILLER_271_248 VPWR VGND sg13cmos5l_decap_8
X_1187_ _1187_/Q Tile_X0Y4_FrameData[3] VGND VPWR Tile_X0Y5_FrameStrobe[4] latch
X_0207_ _0207_/Q Tile_X0Y0_FrameData[23] VGND VPWR Tile_X0Y5_FrameStrobe[4] latch
XFILLER_24_203 VPWR VGND sg13cmos5l_decap_8
X_0138_ _0138_/Q Tile_X0Y0_FrameData[28] VGND VPWR Tile_X0Y5_FrameStrobe[2] latch
XFILLER_220_63 VPWR VGND sg13cmos5l_decap_8
XFILLER_224_197 VPWR VGND sg13cmos5l_decap_8
X_0069_ _2074_/A _2559_/X _2560_/X _0863_/Q VPWR VGND sg13cmos5l_mux2_1
XFILLER_149_28 VPWR VGND sg13cmos5l_decap_8
XFILLER_296_56 VPWR VGND sg13cmos5l_decap_8
XFILLER_137_138 VPWR VGND sg13cmos5l_fill_2
XFILLER_341_208 VPWR VGND sg13cmos5l_decap_8
XFILLER_109_7 VPWR VGND sg13cmos5l_decap_8
XFILLER_160_130 VPWR VGND sg13cmos5l_decap_8
XFILLER_160_174 VPWR VGND sg13cmos5l_decap_8
XFILLER_160_196 VPWR VGND sg13cmos5l_decap_8
XFILLER_58_14 VPWR VGND sg13cmos5l_decap_8
XFILLER_59_133 VPWR VGND sg13cmos5l_decap_8
XFILLER_101_252 VPWR VGND sg13cmos5l_decap_8
XFILLER_114_42 VPWR VGND sg13cmos5l_decap_8
XFILLER_261_70 VPWR VGND sg13cmos5l_decap_8
XFILLER_262_204 VPWR VGND sg13cmos5l_fill_2
XFILLER_74_35 VPWR VGND sg13cmos5l_decap_8
XFILLER_130_63 VPWR VGND sg13cmos5l_decap_8
XFILLER_230_112 VPWR VGND sg13cmos5l_decap_8
XFILLER_168_241 VPWR VGND sg13cmos5l_decap_8
XFILLER_90_78 VPWR VGND sg13cmos5l_decap_8
XFILLER_135_0 VPWR VGND sg13cmos5l_decap_8
XFILLER_183_233 VPWR VGND sg13cmos5l_decap_8
XFILLER_99_21 VPWR VGND sg13cmos5l_decap_8
XFILLER_302_0 VPWR VGND sg13cmos5l_decap_8
XFILLER_99_98 VPWR VGND sg13cmos5l_decap_8
XFILLER_297_112 VPWR VGND sg13cmos5l_decap_8
XFILLER_300_105 VPWR VGND sg13cmos5l_decap_8
XFILLER_24_7 VPWR VGND sg13cmos5l_decap_8
XFILLER_297_189 VPWR VGND sg13cmos5l_decap_8
XFILLER_238_234 VPWR VGND sg13cmos5l_fill_2
XFILLER_305_63 VPWR VGND sg13cmos5l_decap_8
X_1110_ _1110_/Q Tile_X0Y4_FrameData[16] VGND VPWR Tile_X0Y5_FrameStrobe[2] latch
XFILLER_171_70 VPWR VGND sg13cmos5l_decap_8
X_2090_ Tile_X0Y3_E2BEG[2] _2511_/X VPWR VGND sg13cmos5l_buf_1
XFILLER_65_147 VPWR VGND sg13cmos5l_decap_8
XFILLER_0_21 VPWR VGND sg13cmos5l_decap_8
XFILLER_253_237 VPWR VGND sg13cmos5l_fill_1
X_1041_ _1041_/Q Tile_X0Y4_FrameData[21] VGND VPWR Tile_X0Y5_FrameStrobe[0] latch
XFILLER_206_131 VPWR VGND sg13cmos5l_decap_8
XFILLER_321_62 VPWR VGND sg13cmos5l_decap_8
XFILLER_0_98 VPWR VGND sg13cmos5l_decap_8
XFILLER_206_197 VPWR VGND sg13cmos5l_decap_4
XFILLER_221_156 VPWR VGND sg13cmos5l_fill_2
XFILLER_159_230 VPWR VGND sg13cmos5l_decap_8
X_1943_ Tile_X0Y1_E6BEG[8] _2333_/X VPWR VGND sg13cmos5l_buf_1
XFILLER_9_63 VPWR VGND sg13cmos5l_decap_8
XFILLER_119_105 VPWR VGND sg13cmos5l_decap_8
X_1874_ Tile_X0Y2_E6BEG[0] _2433_/X VPWR VGND sg13cmos5l_buf_1
XFILLER_127_160 VPWR VGND sg13cmos5l_decap_4
XFILLER_134_119 VPWR VGND sg13cmos5l_decap_8
X_0825_ _0825_/Q Tile_X0Y3_FrameData[29] VGND VPWR Tile_X0Y5_FrameStrobe[1] latch
XFILLER_127_182 VPWR VGND sg13cmos5l_decap_8
X_0756_ _0756_/Q Tile_X0Y2_FrameData[18] VGND VPWR Tile_X0Y5_FrameStrobe[6] latch
XFILLER_50_0 VPWR VGND sg13cmos5l_decap_8
XFILLER_346_70 VPWR VGND sg13cmos5l_decap_8
XFILLER_282_14 VPWR VGND sg13cmos5l_decap_8
XFILLER_288_112 VPWR VGND sg13cmos5l_decap_8
X_0687_ _0687_/Q Tile_X0Y2_FrameData[23] VGND VPWR Tile_X0Y5_FrameStrobe[4] latch
XANTENNA__1606__X Tile_X0Y0_N4BEG[2] VPWR VGND sg13cmos5l_antennanp
X_2426_ _2426_/X AXIL_S_SOC_AWADDR5 AXIL_S_SOC_AWADDR9 _2474_/X _2487_/X _0696_/Q
+ _0695_/Q VPWR VGND sg13cmos5l_mux4_1
XFILLER_88_239 VPWR VGND sg13cmos5l_fill_1
XFILLER_229_201 VPWR VGND sg13cmos5l_decap_8
XFILLER_215_63 VPWR VGND sg13cmos5l_decap_8
XFILLER_28_28 VPWR VGND sg13cmos5l_decap_8
X_2357_ _2357_/X _2344_/X _0031_/X _2343_/X Tile_X0Y0_S4END[5] _0340_/Q _0339_/Q VPWR
+ VGND sg13cmos5l_mux4_1
XFILLER_244_204 VPWR VGND sg13cmos5l_fill_2
X_1308_ _1308_/Q Tile_X0Y5_FrameData[20] VGND VPWR Tile_X0Y5_FrameStrobe[1] latch
X_2288_ _2288_/X _2588_/X _2587_/X _2580_/X _2579_/X _1006_/Q _1005_/Q VPWR VGND sg13cmos5l_mux4_1
XFILLER_56_147 VPWR VGND sg13cmos5l_decap_8
X_1239_ _1239_/Q Tile_X0Y4_FrameData[15] VGND VPWR Tile_X0Y5_FrameStrobe[6] latch
XFILLER_71_128 VPWR VGND sg13cmos5l_decap_8
XFILLER_231_84 VPWR VGND sg13cmos5l_decap_8
XFILLER_358_105 VPWR VGND sg13cmos5l_decap_8
XFILLER_12_206 VPWR VGND sg13cmos5l_fill_2
XFILLER_212_123 VPWR VGND sg13cmos5l_fill_2
XFILLER_212_167 VPWR VGND sg13cmos5l_decap_8
XFILLER_100_77 VPWR VGND sg13cmos5l_decap_8
XFILLER_165_211 VPWR VGND sg13cmos5l_decap_8
XFILLER_165_255 VPWR VGND sg13cmos5l_fill_1
XFILLER_180_203 VPWR VGND sg13cmos5l_decap_8
XFILLER_314_219 VPWR VGND sg13cmos5l_fill_1
XFILLER_109_42 VPWR VGND sg13cmos5l_decap_8
XFILLER_118_182 VPWR VGND sg13cmos5l_decap_8
XFILLER_256_70 VPWR VGND sg13cmos5l_decap_4
XFILLER_307_271 VPWR VGND sg13cmos5l_fill_2
XFILLER_192_14 VPWR VGND sg13cmos5l_decap_8
XFILLER_279_112 VPWR VGND sg13cmos5l_decap_8
XFILLER_279_123 VPWR VGND sg13cmos5l_fill_2
XFILLER_69_35 VPWR VGND sg13cmos5l_decap_8
XFILLER_279_145 VPWR VGND sg13cmos5l_decap_8
XFILLER_79_217 VPWR VGND sg13cmos5l_decap_4
XFILLER_294_126 VPWR VGND sg13cmos5l_decap_8
XFILLER_125_63 VPWR VGND sg13cmos5l_decap_8
XFILLER_272_91 VPWR VGND sg13cmos5l_decap_8
XFILLER_85_78 VPWR VGND sg13cmos5l_decap_8
XFILLER_47_169 VPWR VGND sg13cmos5l_decap_8
XFILLER_203_112 VPWR VGND sg13cmos5l_decap_8
XFILLER_252_0 VPWR VGND sg13cmos5l_decap_8
XFILLER_70_161 VPWR VGND sg13cmos5l_decap_8
XFILLER_349_105 VPWR VGND sg13cmos5l_decap_8
XANTENNA__2082__X Tile_X0Y5_S4BEG[15] VPWR VGND sg13cmos5l_antennanp
XFILLER_7_210 VPWR VGND sg13cmos5l_fill_2
XFILLER_357_182 VPWR VGND sg13cmos5l_decap_8
XFILLER_116_119 VPWR VGND sg13cmos5l_decap_8
XFILLER_166_70 VPWR VGND sg13cmos5l_decap_8
XFILLER_171_214 VPWR VGND sg13cmos5l_decap_4
X_1590_ Tile_X0Y2_EE4BEG[3] _2420_/X VPWR VGND sg13cmos5l_buf_1
X_0610_ _0610_/Q Tile_X0Y2_FrameData[4] VGND VPWR Tile_X0Y5_FrameStrobe[1] latch
XFILLER_50_70 VPWR VGND sg13cmos5l_decap_8
XFILLER_109_193 VPWR VGND sg13cmos5l_fill_2
XFILLER_124_152 VPWR VGND sg13cmos5l_decap_4
X_0541_ _0541_/Q Tile_X0Y1_FrameData[25] VGND VPWR Tile_X0Y5_FrameStrobe[7] latch
XFILLER_285_126 VPWR VGND sg13cmos5l_decap_4
XFILLER_316_84 VPWR VGND sg13cmos5l_decap_8
X_0472_ _0472_/Q Tile_X0Y1_FrameData[30] VGND VPWR Tile_X0Y5_FrameStrobe[5] latch
XFILLER_182_91 VPWR VGND sg13cmos5l_decap_8
XFILLER_252_28 VPWR VGND sg13cmos5l_decap_8
X_2211_ _2211_/X _2215_/X Tile_X0Y0_S1END[2] Tile_X0Y0_W6END[2] _2211_/A3 _0074_/Q
+ _0073_/Q VPWR VGND sg13cmos5l_mux4_1
XFILLER_78_250 VPWR VGND sg13cmos5l_decap_4
X_2142_ _2142_/X Tile_X0Y0_W1END[1] Tile_X0Y0_W6END[5] _2225_/X _2210_/X _0308_/Q
+ _0307_/Q VPWR VGND sg13cmos5l_mux4_1
XFILLER_93_220 VPWR VGND sg13cmos5l_decap_8
X_2073_ Tile_X0Y5_S4BEG[6] _2073_/A VPWR VGND sg13cmos5l_buf_1
XFILLER_93_264 VPWR VGND sg13cmos5l_decap_8
X_1024_ _1024_/Q Tile_X0Y3_FrameData[22] VGND VPWR Tile_X0Y5_FrameStrobe[7] latch
XFILLER_201_21 VPWR VGND sg13cmos5l_decap_8
XFILLER_61_161 VPWR VGND sg13cmos5l_fill_2
XFILLER_277_14 VPWR VGND sg13cmos5l_decap_8
XFILLER_98_0 VPWR VGND sg13cmos5l_decap_8
XFILLER_61_183 VPWR VGND sg13cmos5l_decap_4
XFILLER_147_200 VPWR VGND sg13cmos5l_decap_8
XFILLER_355_119 VPWR VGND sg13cmos5l_decap_8
XFILLER_147_244 VPWR VGND sg13cmos5l_decap_8
X_1926_ Tile_X0Y1_EE4BEG[7] _2316_/X VPWR VGND sg13cmos5l_buf_1
X_1857_ Tile_X0Y4_FrameData_O[24] Tile_X0Y4_FrameData[24] VPWR VGND sg13cmos5l_buf_1
XFILLER_162_214 VPWR VGND sg13cmos5l_decap_8
XFILLER_293_35 VPWR VGND sg13cmos5l_decap_8
X_0808_ _0808_/Q Tile_X0Y3_FrameData[14] VGND VPWR Tile_X0Y5_FrameStrobe[0] latch
XFILLER_357_91 VPWR VGND sg13cmos5l_decap_8
XFILLER_162_269 VPWR VGND sg13cmos5l_decap_4
X_1788_ Tile_X0Y4_E1BEG[3] _2616_/X VPWR VGND sg13cmos5l_buf_1
X_0739_ _0739_/Q Tile_X0Y2_FrameData[3] VGND VPWR Tile_X0Y5_FrameStrobe[5] latch
XFILLER_115_196 VPWR VGND sg13cmos5l_fill_1
XFILLER_162_28 VPWR VGND sg13cmos5l_decap_8
X_2409_ _2409_/X AXIL_S_SOC_AWADDR0 AXIL_S_SOC_AWADDR8 _2481_/X _2488_/X _0730_/Q
+ _0729_/Q VPWR VGND sg13cmos5l_mux4_1
XFILLER_39_49 VPWR VGND sg13cmos5l_decap_8
XFILLER_217_215 VPWR VGND sg13cmos5l_decap_8
XFILLER_84_231 VPWR VGND sg13cmos5l_fill_2
XFILLER_176_7 VPWR VGND sg13cmos5l_decap_8
XFILLER_217_259 VPWR VGND sg13cmos5l_decap_8
XFILLER_111_21 VPWR VGND sg13cmos5l_decap_8
XFILLER_240_240 VPWR VGND sg13cmos5l_decap_4
XFILLER_52_161 VPWR VGND sg13cmos5l_decap_8
XFILLER_343_7 VPWR VGND sg13cmos5l_decap_8
XFILLER_111_98 VPWR VGND sg13cmos5l_decap_8
XFILLER_187_14 VPWR VGND sg13cmos5l_decap_8
XFILLER_240_262 VPWR VGND sg13cmos5l_decap_8
XFILLER_71_14 VPWR VGND sg13cmos5l_decap_8
XFILLER_197_188 VPWR VGND sg13cmos5l_decap_8
XFILLER_200_115 VPWR VGND sg13cmos5l_fill_1
XFILLER_200_137 VPWR VGND sg13cmos5l_decap_8
XFILLER_346_119 VPWR VGND sg13cmos5l_decap_8
XFILLER_138_222 VPWR VGND sg13cmos5l_decap_4
XFILLER_337_28 VPWR VGND sg13cmos5l_decap_8
XFILLER_267_91 VPWR VGND sg13cmos5l_decap_8
XFILLER_354_196 VPWR VGND sg13cmos5l_decap_8
XFILLER_153_269 VPWR VGND sg13cmos5l_decap_4
XFILLER_20_84 VPWR VGND sg13cmos5l_decap_8
XFILLER_121_133 VPWR VGND sg13cmos5l_decap_8
XFILLER_353_49 VPWR VGND sg13cmos5l_decap_8
XFILLER_96_77 VPWR VGND sg13cmos5l_decap_8
XFILLER_67_209 VPWR VGND sg13cmos5l_decap_4
XANTENNA__2077__X Tile_X0Y5_S4BEG[10] VPWR VGND sg13cmos5l_antennanp
XFILLER_275_181 VPWR VGND sg13cmos5l_fill_1
XFILLER_208_248 VPWR VGND sg13cmos5l_decap_8
XFILLER_290_140 VPWR VGND sg13cmos5l_decap_8
XFILLER_302_42 VPWR VGND sg13cmos5l_decap_8
XFILLER_90_223 VPWR VGND sg13cmos5l_decap_8
XFILLER_90_256 VPWR VGND sg13cmos5l_decap_8
XFILLER_45_70 VPWR VGND sg13cmos5l_decap_8
XFILLER_43_161 VPWR VGND sg13cmos5l_decap_8
XFILLER_91_7 VPWR VGND sg13cmos5l_decap_8
XFILLER_337_108 VPWR VGND sg13cmos5l_fill_2
X_2760_ _2760_/X Tile_X0Y5_N4END[3] _0057_/X _2814_/X _2813_/X _1382_/Q _1381_/Q VPWR
+ VGND sg13cmos5l_mux4_1
XFILLER_247_28 VPWR VGND sg13cmos5l_decap_8
X_1711_ Tile_X0Y0_E6BEG[3] _2200_/X VPWR VGND sg13cmos5l_buf_1
X_2691_ _2691_/X _2238_/X _2237_/X _2226_/X _2225_/X _0151_/Q _0150_/Q VPWR VGND sg13cmos5l_mux4_1
XFILLER_61_91 VPWR VGND sg13cmos5l_decap_8
XANTENNA_2 AXIL_S_SOC_AWPROT1 VPWR VGND sg13cmos5l_antennanp
XFILLER_177_91 VPWR VGND sg13cmos5l_decap_8
X_1642_ Tile_X0Y0_FrameStrobe_O[2] Tile_X0Y5_FrameStrobe[2] VPWR VGND sg13cmos5l_buf_1
XFILLER_6_42 VPWR VGND sg13cmos5l_decap_8
XFILLER_360_155 VPWR VGND sg13cmos5l_decap_8
X_1573_ Tile_X0Y3_FrameData_O[19] Tile_X0Y3_FrameData[19] VPWR VGND sg13cmos5l_buf_1
XFILLER_112_133 VPWR VGND sg13cmos5l_decap_8
XFILLER_263_49 VPWR VGND sg13cmos5l_decap_8
XFILLER_301_222 VPWR VGND sg13cmos5l_decap_8
X_0524_ _0524_/Q Tile_X0Y1_FrameData[10] VGND VPWR Tile_X0Y5_FrameStrobe[6] latch
XFILLER_258_159 VPWR VGND sg13cmos5l_fill_1
X_0455_ _0455_/Q Tile_X0Y1_FrameData[15] VGND VPWR Tile_X0Y5_FrameStrobe[4] latch
XFILLER_13_0 VPWR VGND sg13cmos5l_decap_8
X_0386_ _0386_/Q Tile_X0Y1_FrameData[20] VGND VPWR Tile_X0Y5_FrameStrobe[2] latch
XFILLER_66_231 VPWR VGND sg13cmos5l_decap_4
XFILLER_281_140 VPWR VGND sg13cmos5l_decap_8
X_2125_ AXIL_S_SOC_RDATA19 Tile_X0Y1_W2MID[3] Tile_X0Y1_W2END[3] Tile_X0Y1_W6END[3]
+ _2376_/X _0376_/Q _0375_/Q VPWR VGND sg13cmos5l_mux4_1
XFILLER_212_42 VPWR VGND sg13cmos5l_decap_8
X_2056_ Tile_X0Y5_S2BEG[5] _2778_/X VPWR VGND sg13cmos5l_buf_1
X_1007_ _1007_/Q Tile_X0Y3_FrameData[7] VGND VPWR Tile_X0Y5_FrameStrobe[6] latch
XFILLER_41_109 VPWR VGND sg13cmos5l_decap_8
XFILLER_179_133 VPWR VGND sg13cmos5l_decap_8
XFILLER_288_35 VPWR VGND sg13cmos5l_decap_8
XFILLER_41_39 VPWR VGND sg13cmos5l_decap_8
XFILLER_157_28 VPWR VGND sg13cmos5l_decap_8
X_1909_ Tile_X0Y1_FrameData_O[22] Tile_X0Y1_FrameData[22] VPWR VGND sg13cmos5l_buf_1
XFILLER_135_203 VPWR VGND sg13cmos5l_decap_8
XFILLER_135_258 VPWR VGND sg13cmos5l_decap_4
XFILLER_351_133 VPWR VGND sg13cmos5l_decap_8
XFILLER_150_239 VPWR VGND sg13cmos5l_decap_8
XFILLER_173_49 VPWR VGND sg13cmos5l_decap_8
XFILLER_106_21 VPWR VGND sg13cmos5l_decap_8
XFILLER_249_126 VPWR VGND sg13cmos5l_decap_4
XFILLER_293_7 VPWR VGND sg13cmos5l_decap_8
XFILLER_66_14 VPWR VGND sg13cmos5l_decap_8
XFILLER_106_98 VPWR VGND sg13cmos5l_decap_8
XFILLER_57_231 VPWR VGND sg13cmos5l_decap_8
XFILLER_122_42 VPWR VGND sg13cmos5l_decap_8
XFILLER_82_35 VPWR VGND sg13cmos5l_decap_8
XFILLER_198_35 VPWR VGND sg13cmos5l_decap_8
XFILLER_25_183 VPWR VGND sg13cmos5l_decap_8
XFILLER_15_84 VPWR VGND sg13cmos5l_decap_8
XFILLER_319_119 VPWR VGND sg13cmos5l_decap_4
XFILLER_348_49 VPWR VGND sg13cmos5l_decap_8
XFILLER_185_169 VPWR VGND sg13cmos5l_fill_2
XFILLER_40_197 VPWR VGND sg13cmos5l_decap_8
XFILLER_215_0 VPWR VGND sg13cmos5l_decap_8
XFILLER_295_210 VPWR VGND sg13cmos5l_decap_8
XANTENNA__1704__X Tile_X0Y0_EE4BEG[12] VPWR VGND sg13cmos5l_antennanp
XFILLER_295_254 VPWR VGND sg13cmos5l_fill_1
X_0240_ _0240_/Q Tile_X0Y0_FrameData[22] VGND VPWR Tile_X0Y5_FrameStrobe[5] latch
XFILLER_248_170 VPWR VGND sg13cmos5l_decap_4
XFILLER_248_181 VPWR VGND sg13cmos5l_decap_8
XFILLER_255_118 VPWR VGND sg13cmos5l_decap_8
XFILLER_255_129 VPWR VGND sg13cmos5l_fill_1
XFILLER_313_63 VPWR VGND sg13cmos5l_decap_8
X_0171_ _0171_/Q Tile_X0Y0_FrameData[27] VGND VPWR Tile_X0Y5_FrameStrobe[3] latch
XFILLER_263_162 VPWR VGND sg13cmos5l_fill_1
XFILLER_56_91 VPWR VGND sg13cmos5l_decap_8
XFILLER_176_147 VPWR VGND sg13cmos5l_decap_8
XFILLER_258_49 VPWR VGND sg13cmos5l_decap_8
X_2812_ _2812_/X _2368_/X _2366_/X _2354_/X _2353_/X _0388_/Q _0387_/Q VPWR VGND sg13cmos5l_mux4_1
X_2743_ _2743_/X AXIL_S_SOC_ARPROT2 AXIL_S_SOC_RREADY _2809_/X _2799_/X _1416_/Q _1415_/Q
+ VPWR VGND sg13cmos5l_mux4_1
XFILLER_117_203 VPWR VGND sg13cmos5l_decap_8
XFILLER_333_144 VPWR VGND sg13cmos5l_decap_4
X_2674_ _2674_/X Tile_X0Y5_W1END[0] Tile_X0Y5_W6END[4] _2813_/X _2789_/X _1496_/Q
+ _1495_/Q VPWR VGND sg13cmos5l_mux4_1
XFILLER_333_155 VPWR VGND sg13cmos5l_decap_8
X_1625_ Tile_X0Y0_N2BEGb[5] _2260_/X VPWR VGND sg13cmos5l_buf_1
XFILLER_207_42 VPWR VGND sg13cmos5l_decap_8
X_1556_ Tile_X0Y3_FrameData_O[2] Tile_X0Y3_FrameData[2] VPWR VGND sg13cmos5l_buf_1
XFILLER_286_232 VPWR VGND sg13cmos5l_decap_8
XFILLER_290_14 VPWR VGND sg13cmos5l_decap_8
X_0507_ _0507_/Q Tile_X0Y1_FrameData[27] VGND VPWR Tile_X0Y5_FrameStrobe[6] latch
XFILLER_98_164 VPWR VGND sg13cmos5l_decap_8
XFILLER_354_70 VPWR VGND sg13cmos5l_decap_8
XANTENNA__1614__X Tile_X0Y0_N4BEG[10] VPWR VGND sg13cmos5l_antennanp
X_1487_ _1487_/Q Tile_X0Y5_FrameData[1] VGND VPWR Tile_X0Y5_FrameStrobe[6] latch
XFILLER_100_136 VPWR VGND sg13cmos5l_fill_2
X_0438_ _0438_/Q Tile_X0Y1_FrameData[0] VGND VPWR Tile_X0Y5_FrameStrobe[3] latch
XFILLER_223_63 VPWR VGND sg13cmos5l_decap_8
XFILLER_254_140 VPWR VGND sg13cmos5l_fill_2
X_0369_ _0369_/Q Tile_X0Y1_FrameData[5] VGND VPWR Tile_X0Y5_FrameStrobe[1] latch
XFILLER_36_28 VPWR VGND sg13cmos5l_decap_8
X_2108_ AXIL_S_SOC_RDATA2 Tile_X0Y3_W2MID[2] Tile_X0Y3_W2END[2] Tile_X0Y3_W6END[2]
+ _2591_/X _0858_/Q _0857_/Q VPWR VGND sg13cmos5l_mux4_1
XFILLER_199_217 VPWR VGND sg13cmos5l_fill_2
XFILLER_299_56 VPWR VGND sg13cmos5l_decap_8
X_2039_ Tile_X0Y5_FrameData_O[24] Tile_X0Y5_FrameData[24] VPWR VGND sg13cmos5l_buf_1
XFILLER_356_203 VPWR VGND sg13cmos5l_decap_8
XFILLER_139_7 VPWR VGND sg13cmos5l_decap_8
XFILLER_168_49 VPWR VGND sg13cmos5l_decap_8
XFILLER_52_49 VPWR VGND sg13cmos5l_decap_8
XFILLER_108_247 VPWR VGND sg13cmos5l_fill_1
XFILLER_306_7 VPWR VGND sg13cmos5l_decap_8
XFILLER_324_133 VPWR VGND sg13cmos5l_decap_4
XFILLER_190_172 VPWR VGND sg13cmos5l_fill_2
XFILLER_117_42 VPWR VGND sg13cmos5l_decap_8
XFILLER_131_250 VPWR VGND sg13cmos5l_decap_4
XFILLER_264_70 VPWR VGND sg13cmos5l_decap_8
XFILLER_89_164 VPWR VGND sg13cmos5l_decap_4
XFILLER_89_142 VPWR VGND sg13cmos5l_fill_2
XFILLER_77_35 VPWR VGND sg13cmos5l_decap_8
XANTENNA__1524__X Tile_X0Y3_E2BEGb[6] VPWR VGND sg13cmos5l_antennanp
XFILLER_131_261 VPWR VGND sg13cmos5l_fill_1
XFILLER_131_272 VPWR VGND sg13cmos5l_fill_1
XFILLER_133_63 VPWR VGND sg13cmos5l_decap_8
XFILLER_245_140 VPWR VGND sg13cmos5l_decap_8
XFILLER_350_28 VPWR VGND sg13cmos5l_decap_8
XANTENNA_200 _2391_/X VPWR VGND sg13cmos5l_antennanp
XFILLER_280_91 VPWR VGND sg13cmos5l_decap_8
XFILLER_93_56 VPWR VGND sg13cmos5l_decap_8
XANTENNA_211 Tile_X0Y5_FrameStrobe[12] VPWR VGND sg13cmos5l_antennanp
XANTENNA_222 Tile_X0Y5_N2MID[2] VPWR VGND sg13cmos5l_antennanp
XANTENNA_233 Tile_X0Y5_N2MID[5] VPWR VGND sg13cmos5l_antennanp
XFILLER_165_0 VPWR VGND sg13cmos5l_decap_4
XFILLER_245_184 VPWR VGND sg13cmos5l_decap_4
XANTENNA_244 AXIL_S_SOC_WDATA22 VPWR VGND sg13cmos5l_antennanp
XANTENNA_255 AXIL_S_SOC_WDATA22 VPWR VGND sg13cmos5l_antennanp
XANTENNA_266 AXIL_S_SOC_WDATA22 VPWR VGND sg13cmos5l_antennanp
XANTENNA_277 AXIL_S_SOC_WDATA22 VPWR VGND sg13cmos5l_antennanp
XANTENNA_288 AXIL_S_SOC_WDATA22 VPWR VGND sg13cmos5l_antennanp
XANTENNA_299 AXIL_S_SOC_WDATA19 VPWR VGND sg13cmos5l_antennanp
XFILLER_198_272 VPWR VGND sg13cmos5l_fill_1
XFILLER_332_0 VPWR VGND sg13cmos5l_decap_8
XFILLER_347_203 VPWR VGND sg13cmos5l_fill_2
XFILLER_201_221 VPWR VGND sg13cmos5l_decap_8
XANTENNA__2090__X Tile_X0Y3_E2BEG[2] VPWR VGND sg13cmos5l_antennanp
XFILLER_9_179 VPWR VGND sg13cmos5l_fill_1
XFILLER_9_168 VPWR VGND sg13cmos5l_decap_8
XFILLER_362_206 VPWR VGND sg13cmos5l_decap_8
XFILLER_315_133 VPWR VGND sg13cmos5l_decap_8
XFILLER_362_239 VPWR VGND sg13cmos5l_decap_8
XFILLER_114_206 VPWR VGND sg13cmos5l_decap_8
XFILLER_181_161 VPWR VGND sg13cmos5l_decap_8
XFILLER_308_63 VPWR VGND sg13cmos5l_decap_8
XFILLER_54_7 VPWR VGND sg13cmos5l_decap_8
XFILLER_114_239 VPWR VGND sg13cmos5l_decap_8
X_1410_ _1410_/Q Tile_X0Y5_FrameData[14] VGND VPWR Tile_X0Y5_FrameStrobe[4] latch
XFILLER_174_70 VPWR VGND sg13cmos5l_decap_8
XFILLER_268_221 VPWR VGND sg13cmos5l_decap_8
X_2390_ _2390_/X Tile_X0Y3_W2MID[3] Tile_X0Y3_W2END[3] Tile_X0Y3_W6END[3] _2593_/X
+ _1014_/Q _1013_/Q VPWR VGND sg13cmos5l_mux4_1
XFILLER_3_21 VPWR VGND sg13cmos5l_decap_8
XFILLER_122_272 VPWR VGND sg13cmos5l_fill_1
X_1341_ _1341_/Q Tile_X0Y5_FrameData[19] VGND VPWR Tile_X0Y5_FrameStrobe[2] latch
XFILLER_283_235 VPWR VGND sg13cmos5l_decap_8
XFILLER_324_84 VPWR VGND sg13cmos5l_decap_8
X_1272_ _1272_/Q Tile_X0Y5_FrameData[24] VGND VPWR Tile_X0Y5_FrameStrobe[0] latch
XFILLER_3_98 VPWR VGND sg13cmos5l_decap_8
XFILLER_260_28 VPWR VGND sg13cmos5l_decap_8
XFILLER_283_246 VPWR VGND sg13cmos5l_fill_1
XFILLER_283_268 VPWR VGND sg13cmos5l_decap_4
X_0223_ _0223_/Q Tile_X0Y0_FrameData[7] VGND VPWR Tile_X0Y5_FrameStrobe[4] latch
XFILLER_190_91 VPWR VGND sg13cmos5l_decap_8
XFILLER_236_140 VPWR VGND sg13cmos5l_decap_8
X_0154_ _0154_/Q Tile_X0Y0_FrameData[12] VGND VPWR Tile_X0Y5_FrameStrobe[2] latch
XFILLER_236_184 VPWR VGND sg13cmos5l_decap_8
XFILLER_251_165 VPWR VGND sg13cmos5l_fill_1
X_0085_ _0085_/Q Tile_X0Y0_FrameData[17] VGND VPWR Tile_X0Y5_FrameStrobe[0] latch
XFILLER_149_158 VPWR VGND sg13cmos5l_fill_1
XFILLER_80_0 VPWR VGND sg13cmos5l_decap_8
XFILLER_349_70 VPWR VGND sg13cmos5l_decap_8
XANTENNA__1609__X Tile_X0Y0_N4BEG[5] VPWR VGND sg13cmos5l_antennanp
XFILLER_164_139 VPWR VGND sg13cmos5l_decap_4
XFILLER_285_14 VPWR VGND sg13cmos5l_decap_8
X_0987_ _0987_/Q Tile_X0Y3_FrameData[27] VGND VPWR Tile_X0Y5_FrameStrobe[6] latch
XFILLER_353_217 VPWR VGND sg13cmos5l_decap_8
XFILLER_157_191 VPWR VGND sg13cmos5l_decap_8
XFILLER_306_133 VPWR VGND sg13cmos5l_decap_8
X_2726_ _2726_/X AXIL_S_SOC_ARPROT1 AXIL_S_SOC_RREADY _2826_/X _2798_/X _1450_/Q _1449_/Q
+ VPWR VGND sg13cmos5l_mux4_1
XFILLER_172_161 VPWR VGND sg13cmos5l_decap_8
XFILLER_218_63 VPWR VGND sg13cmos5l_decap_8
X_2657_ _2657_/X AXIL_S_SOC_WSTRB0 _2702_/X _2700_/X _2712_/X _1140_/Q _1139_/Q VPWR
+ VGND sg13cmos5l_mux4_1
XFILLER_105_228 VPWR VGND sg13cmos5l_decap_8
XFILLER_172_172 VPWR VGND sg13cmos5l_fill_2
XFILLER_321_125 VPWR VGND sg13cmos5l_decap_8
X_1608_ Tile_X0Y0_N4BEG[4] _1608_/A VPWR VGND sg13cmos5l_buf_1
X_2588_ _2588_/X _2566_/X Tile_X0Y5_N4END[8] _2565_/X Tile_X0Y0_S4END[12] _0846_/Q
+ _0845_/Q VPWR VGND sg13cmos5l_mux4_1
X_1539_ Tile_X0Y3_EE4BEG[1] _2526_/X VPWR VGND sg13cmos5l_buf_1
XFILLER_234_84 VPWR VGND sg13cmos5l_decap_8
XFILLER_274_202 VPWR VGND sg13cmos5l_decap_8
XFILLER_86_134 VPWR VGND sg13cmos5l_decap_8
XFILLER_170_28 VPWR VGND sg13cmos5l_decap_8
XFILLER_274_246 VPWR VGND sg13cmos5l_decap_4
XFILLER_47_49 VPWR VGND sg13cmos5l_decap_8
XFILLER_227_173 VPWR VGND sg13cmos5l_decap_8
XFILLER_103_77 VPWR VGND sg13cmos5l_decap_8
XFILLER_242_154 VPWR VGND sg13cmos5l_decap_8
XFILLER_256_7 VPWR VGND sg13cmos5l_decap_8
XFILLER_195_220 VPWR VGND sg13cmos5l_fill_1
XFILLER_10_112 VPWR VGND sg13cmos5l_decap_8
XFILLER_195_242 VPWR VGND sg13cmos5l_decap_8
XFILLER_259_70 VPWR VGND sg13cmos5l_decap_8
XFILLER_195_14 VPWR VGND sg13cmos5l_decap_8
XFILLER_12_63 VPWR VGND sg13cmos5l_decap_8
XFILLER_128_63 VPWR VGND sg13cmos5l_decap_8
XFILLER_352_261 VPWR VGND sg13cmos5l_fill_1
XFILLER_345_28 VPWR VGND sg13cmos5l_decap_8
XFILLER_275_91 VPWR VGND sg13cmos5l_decap_8
XFILLER_88_56 VPWR VGND sg13cmos5l_decap_8
XFILLER_104_272 VPWR VGND sg13cmos5l_fill_1
XFILLER_77_112 VPWR VGND sg13cmos5l_decap_8
XFILLER_320_191 VPWR VGND sg13cmos5l_fill_1
XFILLER_265_235 VPWR VGND sg13cmos5l_fill_1
XFILLER_282_0 VPWR VGND sg13cmos5l_decap_8
XFILLER_92_137 VPWR VGND sg13cmos5l_fill_1
XFILLER_218_184 VPWR VGND sg13cmos5l_decap_8
XANTENNA__2085__X Tile_X0Y3_E1BEG[1] VPWR VGND sg13cmos5l_antennanp
XFILLER_233_154 VPWR VGND sg13cmos5l_decap_8
XFILLER_233_165 VPWR VGND sg13cmos5l_fill_1
XFILLER_310_42 VPWR VGND sg13cmos5l_decap_8
XFILLER_33_259 VPWR VGND sg13cmos5l_decap_4
X_0910_ _0910_/Q Tile_X0Y3_FrameData[8] VGND VPWR Tile_X0Y5_FrameStrobe[3] latch
XFILLER_53_70 VPWR VGND sg13cmos5l_decap_8
XFILLER_169_70 VPWR VGND sg13cmos5l_decap_8
X_1890_ Tile_X0Y1_FrameData_O[3] Tile_X0Y1_FrameData[3] VPWR VGND sg13cmos5l_buf_1
X_0841_ _0841_/Q Tile_X0Y3_FrameData[13] VGND VPWR Tile_X0Y5_FrameStrobe[1] latch
X_0772_ _0772_/Q Tile_X0Y2_FrameData[2] VGND VPWR Tile_X0Y5_FrameStrobe[6] latch
XFILLER_255_28 VPWR VGND sg13cmos5l_decap_8
XFILLER_319_84 VPWR VGND sg13cmos5l_decap_8
X_2511_ _2511_/X AXIL_S_SOC_ARADDR0 AXIL_S_SOC_ARADDR2 _2591_/X _2594_/X _0982_/Q
+ _0981_/Q VPWR VGND sg13cmos5l_mux4_1
XFILLER_185_91 VPWR VGND sg13cmos5l_decap_8
XFILLER_102_209 VPWR VGND sg13cmos5l_fill_1
XFILLER_303_147 VPWR VGND sg13cmos5l_decap_8
X_2442_ _2442_/X AXIL_S_SOC_AWADDR1 _2476_/X _2474_/X _2486_/X _0664_/Q _0663_/Q VPWR
+ VGND sg13cmos5l_mux4_1
X_2373_ _2373_/X _2249_/X _2382_/X _2381_/X Tile_X0Y0_S2MID[0] _0334_/Q _0333_/Q VPWR
+ VGND sg13cmos5l_mux4_1
XFILLER_68_112 VPWR VGND sg13cmos5l_decap_8
XFILLER_271_49 VPWR VGND sg13cmos5l_decap_8
X_1324_ _1324_/Q Tile_X0Y5_FrameData[4] VGND VPWR Tile_X0Y5_FrameStrobe[1] latch
XFILLER_110_264 VPWR VGND sg13cmos5l_fill_1
XFILLER_204_21 VPWR VGND sg13cmos5l_decap_8
X_1255_ _1255_/Q Tile_X0Y4_FrameData[31] VGND VPWR Tile_X0Y5_FrameStrobe[7] latch
XFILLER_224_121 VPWR VGND sg13cmos5l_decap_8
X_1186_ _1186_/Q Tile_X0Y4_FrameData[4] VGND VPWR Tile_X0Y5_FrameStrobe[4] latch
X_0206_ _0206_/Q Tile_X0Y0_FrameData[24] VGND VPWR Tile_X0Y5_FrameStrobe[4] latch
X_0137_ _0137_/Q Tile_X0Y0_FrameData[29] VGND VPWR Tile_X0Y5_FrameStrobe[2] latch
XFILLER_220_42 VPWR VGND sg13cmos5l_decap_8
XFILLER_224_176 VPWR VGND sg13cmos5l_decap_8
XFILLER_24_237 VPWR VGND sg13cmos5l_decap_4
X_0068_ _2073_/A _2557_/X _2558_/X _0866_/Q VPWR VGND sg13cmos5l_mux2_1
XFILLER_177_220 VPWR VGND sg13cmos5l_decap_8
XFILLER_33_29 VPWR VGND sg13cmos5l_decap_8
XFILLER_296_35 VPWR VGND sg13cmos5l_decap_8
XFILLER_137_106 VPWR VGND sg13cmos5l_decap_8
XFILLER_137_117 VPWR VGND sg13cmos5l_decap_8
XFILLER_192_223 VPWR VGND sg13cmos5l_decap_4
XFILLER_192_234 VPWR VGND sg13cmos5l_decap_8
XFILLER_152_109 VPWR VGND sg13cmos5l_fill_2
XFILLER_229_84 VPWR VGND sg13cmos5l_decap_8
X_2709_ _2709_/X _2600_/X Tile_X0Y5_N2MID[1] _2714_/X _2599_/X _1052_/Q _1051_/Q VPWR
+ VGND sg13cmos5l_mux4_1
XFILLER_334_272 VPWR VGND sg13cmos5l_fill_1
XFILLER_3_119 VPWR VGND sg13cmos5l_decap_8
XFILLER_59_112 VPWR VGND sg13cmos5l_decap_8
XFILLER_101_231 VPWR VGND sg13cmos5l_decap_8
XFILLER_181_49 VPWR VGND sg13cmos5l_decap_8
XFILLER_114_21 VPWR VGND sg13cmos5l_decap_8
XANTENNA__1802__X Tile_X0Y4_E2BEGb[5] VPWR VGND sg13cmos5l_antennanp
XFILLER_74_14 VPWR VGND sg13cmos5l_decap_8
XFILLER_59_189 VPWR VGND sg13cmos5l_decap_8
XFILLER_114_98 VPWR VGND sg13cmos5l_decap_8
XFILLER_130_42 VPWR VGND sg13cmos5l_decap_8
XFILLER_215_165 VPWR VGND sg13cmos5l_decap_4
XFILLER_215_187 VPWR VGND sg13cmos5l_decap_4
XFILLER_90_57 VPWR VGND sg13cmos5l_decap_8
XFILLER_168_264 VPWR VGND sg13cmos5l_fill_1
XFILLER_128_0 VPWR VGND sg13cmos5l_decap_8
XFILLER_128_139 VPWR VGND sg13cmos5l_decap_4
XFILLER_23_84 VPWR VGND sg13cmos5l_decap_8
XFILLER_136_150 VPWR VGND sg13cmos5l_decap_8
XFILLER_139_84 VPWR VGND sg13cmos5l_decap_8
XFILLER_356_49 VPWR VGND sg13cmos5l_decap_8
XFILLER_99_77 VPWR VGND sg13cmos5l_decap_8
XFILLER_297_168 VPWR VGND sg13cmos5l_decap_8
XFILLER_97_229 VPWR VGND sg13cmos5l_decap_8
XFILLER_238_213 VPWR VGND sg13cmos5l_decap_8
XFILLER_305_42 VPWR VGND sg13cmos5l_decap_8
XFILLER_238_246 VPWR VGND sg13cmos5l_decap_8
XFILLER_238_257 VPWR VGND sg13cmos5l_fill_2
XANTENNA__1712__X Tile_X0Y0_E6BEG[4] VPWR VGND sg13cmos5l_antennanp
XFILLER_17_7 VPWR VGND sg13cmos5l_decap_8
XFILLER_65_126 VPWR VGND sg13cmos5l_decap_8
XFILLER_48_81 VPWR VGND sg13cmos5l_decap_8
XFILLER_206_110 VPWR VGND sg13cmos5l_decap_8
X_1040_ _1040_/Q Tile_X0Y4_FrameData[22] VGND VPWR Tile_X0Y5_FrameStrobe[0] latch
XFILLER_0_77 VPWR VGND sg13cmos5l_decap_8
XFILLER_64_91 VPWR VGND sg13cmos5l_decap_8
X_1942_ Tile_X0Y1_E6BEG[7] _2332_/X VPWR VGND sg13cmos5l_buf_1
XFILLER_9_42 VPWR VGND sg13cmos5l_decap_8
X_1873_ Tile_X0Y2_E2BEGb[7] _2416_/X VPWR VGND sg13cmos5l_buf_1
X_0824_ _0824_/Q Tile_X0Y3_FrameData[30] VGND VPWR Tile_X0Y5_FrameStrobe[1] latch
XFILLER_266_49 VPWR VGND sg13cmos5l_decap_8
X_0755_ _0755_/Q Tile_X0Y2_FrameData[19] VGND VPWR Tile_X0Y5_FrameStrobe[6] latch
X_0686_ _0686_/Q Tile_X0Y2_FrameData[24] VGND VPWR Tile_X0Y5_FrameStrobe[4] latch
XFILLER_43_0 VPWR VGND sg13cmos5l_fill_1
XFILLER_288_168 VPWR VGND sg13cmos5l_decap_8
X_2425_ _2425_/X AXIL_S_SOC_AWADDR4 AXIL_S_SOC_AWADDR8 _2473_/X _2488_/X _0698_/Q
+ _0697_/Q VPWR VGND sg13cmos5l_mux4_1
XFILLER_215_42 VPWR VGND sg13cmos5l_decap_8
XFILLER_229_213 VPWR VGND sg13cmos5l_fill_2
XFILLER_229_224 VPWR VGND sg13cmos5l_fill_1
X_2356_ _2356_/X _2822_/X _2821_/X _2810_/X _2809_/X _1469_/Q _1468_/Q VPWR VGND sg13cmos5l_mux4_1
XFILLER_96_240 VPWR VGND sg13cmos5l_decap_8
XFILLER_362_70 VPWR VGND sg13cmos5l_decap_8
XANTENNA__1622__X Tile_X0Y0_N2BEGb[2] VPWR VGND sg13cmos5l_antennanp
X_1307_ _1307_/Q Tile_X0Y5_FrameData[21] VGND VPWR Tile_X0Y5_FrameStrobe[1] latch
X_2287_ _2287_/X Tile_X0Y3_W1END[0] Tile_X0Y3_WW4END[0] Tile_X0Y3_WW4END[4] Tile_X0Y3_W6END[8]
+ _1006_/Q _1005_/Q VPWR VGND sg13cmos5l_mux4_1
XFILLER_56_126 VPWR VGND sg13cmos5l_decap_8
XFILLER_244_227 VPWR VGND sg13cmos5l_fill_1
X_1238_ _1238_/Q Tile_X0Y4_FrameData[16] VGND VPWR Tile_X0Y5_FrameStrobe[6] latch
XFILLER_231_63 VPWR VGND sg13cmos5l_decap_8
X_1169_ _1169_/Q Tile_X0Y4_FrameData[21] VGND VPWR Tile_X0Y5_FrameStrobe[4] latch
XFILLER_44_39 VPWR VGND sg13cmos5l_decap_8
XFILLER_212_146 VPWR VGND sg13cmos5l_decap_8
XFILLER_100_56 VPWR VGND sg13cmos5l_decap_8
XFILLER_121_7 VPWR VGND sg13cmos5l_decap_8
XFILLER_226_8 VPWR VGND sg13cmos5l_decap_8
XFILLER_60_49 VPWR VGND sg13cmos5l_decap_8
XFILLER_109_21 VPWR VGND sg13cmos5l_decap_8
XFILLER_176_49 VPWR VGND sg13cmos5l_decap_8
XFILLER_219_7 VPWR VGND sg13cmos5l_decap_8
XFILLER_118_161 VPWR VGND sg13cmos5l_decap_8
XFILLER_69_14 VPWR VGND sg13cmos5l_decap_8
XFILLER_109_98 VPWR VGND sg13cmos5l_decap_8
XFILLER_79_229 VPWR VGND sg13cmos5l_fill_2
XFILLER_125_42 VPWR VGND sg13cmos5l_decap_8
XFILLER_294_105 VPWR VGND sg13cmos5l_decap_8
XFILLER_272_70 VPWR VGND sg13cmos5l_decap_8
XFILLER_342_29 VPWR VGND sg13cmos5l_decap_8
XANTENNA__1532__X Tile_X0Y3_E6BEG[6] VPWR VGND sg13cmos5l_antennanp
XFILLER_235_205 VPWR VGND sg13cmos5l_decap_8
XFILLER_85_57 VPWR VGND sg13cmos5l_decap_8
XFILLER_47_126 VPWR VGND sg13cmos5l_decap_8
XFILLER_47_159 VPWR VGND sg13cmos5l_decap_8
XFILLER_141_63 VPWR VGND sg13cmos5l_decap_8
XFILLER_18_84 VPWR VGND sg13cmos5l_decap_8
XFILLER_245_0 VPWR VGND sg13cmos5l_decap_8
XFILLER_70_140 VPWR VGND sg13cmos5l_decap_8
XFILLER_357_161 VPWR VGND sg13cmos5l_decap_8
XFILLER_156_267 VPWR VGND sg13cmos5l_decap_4
XFILLER_7_233 VPWR VGND sg13cmos5l_fill_2
XANTENNA__1707__X Tile_X0Y0_EE4BEG[15] VPWR VGND sg13cmos5l_antennanp
XFILLER_109_161 VPWR VGND sg13cmos5l_decap_4
XFILLER_124_120 VPWR VGND sg13cmos5l_decap_8
XFILLER_171_248 VPWR VGND sg13cmos5l_decap_8
XFILLER_171_259 VPWR VGND sg13cmos5l_fill_2
X_0540_ _0540_/Q Tile_X0Y1_FrameData[26] VGND VPWR Tile_X0Y5_FrameStrobe[7] latch
XFILLER_316_63 VPWR VGND sg13cmos5l_decap_8
XFILLER_285_105 VPWR VGND sg13cmos5l_decap_8
X_2210_ _2210_/X _2214_/X Tile_X0Y0_S1END[1] Tile_X0Y0_W6END[1] _2210_/A3 _0076_/Q
+ _0075_/Q VPWR VGND sg13cmos5l_mux4_1
X_0471_ _0471_/Q Tile_X0Y1_FrameData[31] VGND VPWR Tile_X0Y5_FrameStrobe[5] latch
XFILLER_182_70 VPWR VGND sg13cmos5l_decap_8
XFILLER_59_91 VPWR VGND sg13cmos5l_decap_8
X_2141_ _2141_/X Tile_X0Y0_W1END[0] Tile_X0Y0_W6END[4] _2229_/X _2209_/X _0310_/Q
+ _0309_/Q VPWR VGND sg13cmos5l_mux4_1
XFILLER_38_126 VPWR VGND sg13cmos5l_fill_1
X_2072_ Tile_X0Y5_S4BEG[5] _2072_/A VPWR VGND sg13cmos5l_buf_1
XFILLER_332_84 VPWR VGND sg13cmos5l_decap_8
X_1023_ _1023_/Q Tile_X0Y3_FrameData[23] VGND VPWR Tile_X0Y5_FrameStrobe[7] latch
XFILLER_61_140 VPWR VGND sg13cmos5l_decap_8
XFILLER_201_77 VPWR VGND sg13cmos5l_decap_8
X_1925_ Tile_X0Y1_EE4BEG[6] _2315_/X VPWR VGND sg13cmos5l_buf_1
XFILLER_348_161 VPWR VGND sg13cmos5l_decap_8
X_1856_ Tile_X0Y4_FrameData_O[23] Tile_X0Y4_FrameData[23] VPWR VGND sg13cmos5l_buf_1
XFILLER_357_70 VPWR VGND sg13cmos5l_decap_8
XFILLER_293_14 VPWR VGND sg13cmos5l_decap_8
X_1787_ Tile_X0Y4_E1BEG[2] _2615_/X VPWR VGND sg13cmos5l_buf_1
X_0807_ _0807_/Q Tile_X0Y3_FrameData[15] VGND VPWR Tile_X0Y5_FrameStrobe[0] latch
XANTENNA__1617__X Tile_X0Y0_N4BEG[13] VPWR VGND sg13cmos5l_antennanp
X_0738_ _0738_/Q Tile_X0Y2_FrameData[4] VGND VPWR Tile_X0Y5_FrameStrobe[5] latch
XFILLER_115_175 VPWR VGND sg13cmos5l_decap_4
XFILLER_226_85 VPWR VGND sg13cmos5l_decap_8
XFILLER_276_105 VPWR VGND sg13cmos5l_fill_2
X_0669_ _0669_/Q Tile_X0Y2_FrameData[9] VGND VPWR Tile_X0Y5_FrameStrobe[3] latch
XFILLER_39_28 VPWR VGND sg13cmos5l_decap_8
X_2408_ _2408_/X AXIL_S_SOC_AWADDR1 AXIL_S_SOC_AWADDR7 _2481_/X _2488_/X _0732_/Q
+ _0731_/Q VPWR VGND sg13cmos5l_mux4_1
XFILLER_69_251 VPWR VGND sg13cmos5l_fill_1
XFILLER_291_119 VPWR VGND sg13cmos5l_decap_8
X_2339_ _2339_/X _2346_/X _2345_/X Tile_X0Y1_W6END[2] _2339_/A3 _0314_/Q _0313_/Q
+ VPWR VGND sg13cmos5l_mux4_1
XFILLER_84_254 VPWR VGND sg13cmos5l_decap_8
XFILLER_242_84 VPWR VGND sg13cmos5l_decap_8
XFILLER_55_49 VPWR VGND sg13cmos5l_decap_8
XFILLER_169_7 VPWR VGND sg13cmos5l_decap_8
XFILLER_225_271 VPWR VGND sg13cmos5l_fill_2
XFILLER_52_140 VPWR VGND sg13cmos5l_decap_8
XFILLER_111_77 VPWR VGND sg13cmos5l_decap_8
XFILLER_197_145 VPWR VGND sg13cmos5l_decap_4
XFILLER_197_156 VPWR VGND sg13cmos5l_decap_4
XFILLER_336_7 VPWR VGND sg13cmos5l_decap_8
XFILLER_138_256 VPWR VGND sg13cmos5l_decap_4
XFILLER_267_70 VPWR VGND sg13cmos5l_decap_8
XFILLER_354_175 VPWR VGND sg13cmos5l_decap_8
XANTENNA__1527__X Tile_X0Y3_E6BEG[1] VPWR VGND sg13cmos5l_antennanp
XFILLER_20_63 VPWR VGND sg13cmos5l_decap_8
XFILLER_121_112 VPWR VGND sg13cmos5l_decap_8
XFILLER_136_63 VPWR VGND sg13cmos5l_decap_8
XFILLER_267_105 VPWR VGND sg13cmos5l_fill_1
XFILLER_283_91 VPWR VGND sg13cmos5l_decap_8
XFILLER_353_28 VPWR VGND sg13cmos5l_decap_8
XFILLER_121_167 VPWR VGND sg13cmos5l_decap_8
XFILLER_96_56 VPWR VGND sg13cmos5l_decap_8
XFILLER_121_178 VPWR VGND sg13cmos5l_fill_2
XFILLER_195_0 VPWR VGND sg13cmos5l_decap_8
XFILLER_282_119 VPWR VGND sg13cmos5l_decap_8
XFILLER_302_21 VPWR VGND sg13cmos5l_decap_8
XFILLER_90_202 VPWR VGND sg13cmos5l_decap_8
XFILLER_362_0 VPWR VGND sg13cmos5l_decap_8
XFILLER_28_192 VPWR VGND sg13cmos5l_decap_8
XFILLER_188_112 VPWR VGND sg13cmos5l_decap_8
XFILLER_290_196 VPWR VGND sg13cmos5l_decap_8
XFILLER_302_98 VPWR VGND sg13cmos5l_decap_8
XFILLER_43_140 VPWR VGND sg13cmos5l_decap_8
XANTENNA__2093__X Tile_X0Y3_E2BEG[5] VPWR VGND sg13cmos5l_antennanp
XFILLER_188_134 VPWR VGND sg13cmos5l_fill_1
XFILLER_188_156 VPWR VGND sg13cmos5l_fill_1
XFILLER_188_178 VPWR VGND sg13cmos5l_decap_4
XFILLER_129_212 VPWR VGND sg13cmos5l_decap_8
XFILLER_84_7 VPWR VGND sg13cmos5l_decap_8
XFILLER_61_70 VPWR VGND sg13cmos5l_decap_8
XFILLER_129_256 VPWR VGND sg13cmos5l_decap_4
XFILLER_177_70 VPWR VGND sg13cmos5l_decap_8
X_1710_ Tile_X0Y0_E6BEG[2] _2199_/X VPWR VGND sg13cmos5l_buf_1
X_2690_ _2690_/X Tile_X0Y0_W1END[1] Tile_X0Y0_WW4END[9] Tile_X0Y0_WW4END[13] Tile_X0Y0_W6END[5]
+ _0151_/Q _0150_/Q VPWR VGND sg13cmos5l_mux4_1
XANTENNA_3 AXIL_S_SOC_AWPROT1 VPWR VGND sg13cmos5l_antennanp
X_1641_ Tile_X0Y0_FrameStrobe_O[1] Tile_X0Y5_FrameStrobe[1] VPWR VGND sg13cmos5l_buf_1
XFILLER_6_21 VPWR VGND sg13cmos5l_decap_8
XFILLER_360_134 VPWR VGND sg13cmos5l_decap_8
XFILLER_327_84 VPWR VGND sg13cmos5l_decap_8
X_1572_ Tile_X0Y3_FrameData_O[18] Tile_X0Y3_FrameData[18] VPWR VGND sg13cmos5l_buf_1
XFILLER_6_98 VPWR VGND sg13cmos5l_fill_2
XFILLER_112_112 VPWR VGND sg13cmos5l_decap_8
XFILLER_193_91 VPWR VGND sg13cmos5l_decap_8
XFILLER_258_105 VPWR VGND sg13cmos5l_decap_8
XFILLER_263_28 VPWR VGND sg13cmos5l_decap_8
X_0523_ _0523_/Q Tile_X0Y1_FrameData[11] VGND VPWR Tile_X0Y5_FrameStrobe[6] latch
XFILLER_301_245 VPWR VGND sg13cmos5l_decap_8
X_0454_ _0454_/Q Tile_X0Y1_FrameData[16] VGND VPWR Tile_X0Y5_FrameStrobe[4] latch
X_2124_ AXIL_S_SOC_RDATA18 Tile_X0Y1_W2MID[2] Tile_X0Y1_W2END[2] Tile_X0Y1_W6END[2]
+ _2375_/X _0378_/Q _0377_/Q VPWR VGND sg13cmos5l_mux4_1
X_0385_ _0385_/Q Tile_X0Y1_FrameData[21] VGND VPWR Tile_X0Y5_FrameStrobe[2] latch
XFILLER_212_21 VPWR VGND sg13cmos5l_decap_8
XANTENNA__1900__X Tile_X0Y1_FrameData_O[13] VPWR VGND sg13cmos5l_antennanp
X_2055_ Tile_X0Y5_S2BEG[4] _2777_/X VPWR VGND sg13cmos5l_buf_1
XFILLER_81_235 VPWR VGND sg13cmos5l_decap_4
XFILLER_179_112 VPWR VGND sg13cmos5l_decap_8
XFILLER_281_196 VPWR VGND sg13cmos5l_fill_1
XFILLER_288_14 VPWR VGND sg13cmos5l_decap_8
X_1006_ _1006_/Q Tile_X0Y3_FrameData[8] VGND VPWR Tile_X0Y5_FrameStrobe[6] latch
XFILLER_179_189 VPWR VGND sg13cmos5l_fill_1
XFILLER_41_18 VPWR VGND sg13cmos5l_decap_8
X_1908_ Tile_X0Y1_FrameData_O[21] Tile_X0Y1_FrameData[21] VPWR VGND sg13cmos5l_buf_1
X_1839_ Tile_X0Y4_FrameData_O[6] Tile_X0Y4_FrameData[6] VPWR VGND sg13cmos5l_buf_1
XFILLER_351_112 VPWR VGND sg13cmos5l_decap_8
XFILLER_237_84 VPWR VGND sg13cmos5l_decap_8
XFILLER_173_28 VPWR VGND sg13cmos5l_decap_8
XFILLER_249_105 VPWR VGND sg13cmos5l_decap_8
XFILLER_351_189 VPWR VGND sg13cmos5l_decap_8
XFILLER_103_167 VPWR VGND sg13cmos5l_decap_4
XFILLER_106_77 VPWR VGND sg13cmos5l_decap_8
XFILLER_57_254 VPWR VGND sg13cmos5l_fill_1
XFILLER_122_21 VPWR VGND sg13cmos5l_decap_8
XFILLER_272_141 VPWR VGND sg13cmos5l_decap_8
XANTENNA__1810__X Tile_X0Y4_E6BEG[5] VPWR VGND sg13cmos5l_antennanp
XFILLER_272_152 VPWR VGND sg13cmos5l_fill_2
XFILLER_82_14 VPWR VGND sg13cmos5l_decap_8
XFILLER_122_98 VPWR VGND sg13cmos5l_decap_8
XFILLER_198_14 VPWR VGND sg13cmos5l_decap_8
XFILLER_272_196 VPWR VGND sg13cmos5l_fill_2
XFILLER_359_245 VPWR VGND sg13cmos5l_decap_8
XFILLER_15_63 VPWR VGND sg13cmos5l_decap_8
XFILLER_359_256 VPWR VGND sg13cmos5l_fill_1
XFILLER_40_165 VPWR VGND sg13cmos5l_decap_4
XFILLER_348_28 VPWR VGND sg13cmos5l_decap_8
XFILLER_278_91 VPWR VGND sg13cmos5l_decap_8
XFILLER_110_0 VPWR VGND sg13cmos5l_decap_8
XFILLER_126_237 VPWR VGND sg13cmos5l_decap_8
XFILLER_126_248 VPWR VGND sg13cmos5l_fill_2
XFILLER_208_0 VPWR VGND sg13cmos5l_decap_8
XFILLER_31_84 VPWR VGND sg13cmos5l_decap_8
XFILLER_342_134 VPWR VGND sg13cmos5l_decap_8
XFILLER_134_270 VPWR VGND sg13cmos5l_fill_2
XANTENNA__2088__X Tile_X0Y3_E2BEG[0] VPWR VGND sg13cmos5l_antennanp
XFILLER_313_42 VPWR VGND sg13cmos5l_decap_8
XFILLER_48_243 VPWR VGND sg13cmos5l_decap_8
XFILLER_48_221 VPWR VGND sg13cmos5l_decap_8
X_0170_ _0170_/Q Tile_X0Y0_FrameData[28] VGND VPWR Tile_X0Y5_FrameStrobe[3] latch
XANTENNA__1720__X Tile_X0Y0_E2BEGb[0] VPWR VGND sg13cmos5l_antennanp
XFILLER_56_70 VPWR VGND sg13cmos5l_decap_8
XFILLER_16_140 VPWR VGND sg13cmos5l_fill_1
XFILLER_176_126 VPWR VGND sg13cmos5l_decap_8
XFILLER_258_28 VPWR VGND sg13cmos5l_decap_8
X_2811_ _2811_/X Tile_X0Y1_W1END[2] Tile_X0Y1_WW4END[10] Tile_X0Y1_WW4END[14] Tile_X0Y1_W6END[6]
+ _0388_/Q _0387_/Q VPWR VGND sg13cmos5l_mux4_1
XFILLER_72_91 VPWR VGND sg13cmos5l_decap_8
XFILLER_188_91 VPWR VGND sg13cmos5l_decap_8
X_2742_ _2742_/X AXIL_S_SOC_ARPROT1 AXIL_S_SOC_ARVALID _2805_/X _2798_/X _1418_/Q
+ _1417_/Q VPWR VGND sg13cmos5l_mux4_1
XFILLER_333_112 VPWR VGND sg13cmos5l_fill_1
X_2673_ _2673_/X Tile_X0Y3_W1END[0] Tile_X0Y3_W6END[8] _2579_/X _2561_/X _0898_/Q
+ _0897_/Q VPWR VGND sg13cmos5l_mux4_1
XFILLER_207_21 VPWR VGND sg13cmos5l_decap_8
XFILLER_274_49 VPWR VGND sg13cmos5l_decap_8
X_1624_ Tile_X0Y0_N2BEGb[4] _2258_/X VPWR VGND sg13cmos5l_buf_1
X_1555_ Tile_X0Y3_FrameData_O[1] Tile_X0Y3_FrameData[1] VPWR VGND sg13cmos5l_buf_1
X_0506_ _0506_/Q Tile_X0Y1_FrameData[28] VGND VPWR Tile_X0Y5_FrameStrobe[6] latch
XFILLER_98_143 VPWR VGND sg13cmos5l_decap_8
X_1486_ _1486_/Q Tile_X0Y5_FrameData[2] VGND VPWR Tile_X0Y5_FrameStrobe[6] latch
XFILLER_100_159 VPWR VGND sg13cmos5l_decap_4
XFILLER_223_42 VPWR VGND sg13cmos5l_decap_8
XFILLER_246_119 VPWR VGND sg13cmos5l_decap_8
X_0437_ _0437_/Q Tile_X0Y1_FrameData[1] VGND VPWR Tile_X0Y5_FrameStrobe[3] latch
XFILLER_39_221 VPWR VGND sg13cmos5l_decap_8
XFILLER_239_182 VPWR VGND sg13cmos5l_decap_8
X_0368_ _0368_/Q Tile_X0Y1_FrameData[6] VGND VPWR Tile_X0Y5_FrameStrobe[1] latch
X_2107_ AXIL_S_SOC_RDATA1 Tile_X0Y3_W2MID[1] Tile_X0Y3_W2END[1] Tile_X0Y3_W6END[1]
+ _2590_/X _0860_/Q _0859_/Q VPWR VGND sg13cmos5l_mux4_1
XFILLER_54_235 VPWR VGND sg13cmos5l_fill_2
XFILLER_54_224 VPWR VGND sg13cmos5l_decap_8
XANTENNA__1630__X Tile_X0Y0_N2BEG[2] VPWR VGND sg13cmos5l_antennanp
XFILLER_254_196 VPWR VGND sg13cmos5l_fill_1
XFILLER_299_35 VPWR VGND sg13cmos5l_decap_8
X_2038_ Tile_X0Y5_FrameData_O[23] Tile_X0Y5_FrameData[23] VPWR VGND sg13cmos5l_buf_1
X_0299_ _0299_/Q Tile_X0Y0_FrameData[27] VGND VPWR Tile_X0Y5_FrameStrobe[7] latch
XFILLER_54_257 VPWR VGND sg13cmos5l_fill_1
XFILLER_52_28 VPWR VGND sg13cmos5l_decap_8
XFILLER_167_126 VPWR VGND sg13cmos5l_decap_8
XFILLER_168_28 VPWR VGND sg13cmos5l_decap_8
XFILLER_210_266 VPWR VGND sg13cmos5l_decap_8
XFILLER_22_187 VPWR VGND sg13cmos5l_decap_4
XFILLER_22_198 VPWR VGND sg13cmos5l_decap_8
XFILLER_108_215 VPWR VGND sg13cmos5l_decap_8
XFILLER_324_112 VPWR VGND sg13cmos5l_decap_8
XFILLER_117_21 VPWR VGND sg13cmos5l_decap_8
XFILLER_123_207 VPWR VGND sg13cmos5l_decap_8
XFILLER_123_218 VPWR VGND sg13cmos5l_fill_1
XFILLER_184_49 VPWR VGND sg13cmos5l_decap_8
XFILLER_201_7 VPWR VGND sg13cmos5l_decap_8
XFILLER_89_121 VPWR VGND sg13cmos5l_decap_8
XANTENNA__1805__X Tile_X0Y4_E6BEG[0] VPWR VGND sg13cmos5l_antennanp
XFILLER_77_14 VPWR VGND sg13cmos5l_decap_8
XFILLER_117_98 VPWR VGND sg13cmos5l_decap_8
XFILLER_89_198 VPWR VGND sg13cmos5l_fill_1
XFILLER_237_119 VPWR VGND sg13cmos5l_decap_8
XFILLER_133_42 VPWR VGND sg13cmos5l_decap_8
XFILLER_280_70 VPWR VGND sg13cmos5l_decap_8
XFILLER_93_35 VPWR VGND sg13cmos5l_decap_8
XANTENNA_201 _2391_/X VPWR VGND sg13cmos5l_antennanp
XANTENNA_212 Tile_X0Y5_FrameStrobe[12] VPWR VGND sg13cmos5l_antennanp
XANTENNA_223 Tile_X0Y5_N2MID[2] VPWR VGND sg13cmos5l_antennanp
XANTENNA_234 Tile_X0Y5_N2MID[5] VPWR VGND sg13cmos5l_antennanp
XANTENNA__1540__X Tile_X0Y3_EE4BEG[2] VPWR VGND sg13cmos5l_antennanp
XFILLER_45_257 VPWR VGND sg13cmos5l_fill_1
XFILLER_45_246 VPWR VGND sg13cmos5l_decap_8
XANTENNA_245 AXIL_S_SOC_WDATA22 VPWR VGND sg13cmos5l_antennanp
XANTENNA_256 AXIL_S_SOC_WDATA22 VPWR VGND sg13cmos5l_antennanp
XANTENNA_267 AXIL_S_SOC_WDATA22 VPWR VGND sg13cmos5l_antennanp
XFILLER_260_155 VPWR VGND sg13cmos5l_decap_4
XFILLER_26_84 VPWR VGND sg13cmos5l_decap_8
XFILLER_60_227 VPWR VGND sg13cmos5l_decap_4
XFILLER_60_205 VPWR VGND sg13cmos5l_fill_1
XANTENNA_278 AXIL_S_SOC_WDATA22 VPWR VGND sg13cmos5l_antennanp
XANTENNA_289 AXIL_S_SOC_WDATA22 VPWR VGND sg13cmos5l_antennanp
XFILLER_158_0 VPWR VGND sg13cmos5l_decap_8
XFILLER_359_49 VPWR VGND sg13cmos5l_decap_8
XFILLER_158_126 VPWR VGND sg13cmos5l_decap_8
XFILLER_201_244 VPWR VGND sg13cmos5l_decap_4
XFILLER_325_0 VPWR VGND sg13cmos5l_decap_8
XFILLER_9_147 VPWR VGND sg13cmos5l_decap_8
XFILLER_347_259 VPWR VGND sg13cmos5l_fill_1
XFILLER_42_94 VPWR VGND sg13cmos5l_decap_8
XFILLER_315_112 VPWR VGND sg13cmos5l_decap_8
XFILLER_181_140 VPWR VGND sg13cmos5l_decap_8
XFILLER_308_42 VPWR VGND sg13cmos5l_decap_8
XANTENNA__1715__X Tile_X0Y0_E6BEG[7] VPWR VGND sg13cmos5l_antennanp
X_1340_ _1340_/Q Tile_X0Y5_FrameData[20] VGND VPWR Tile_X0Y5_FrameStrobe[2] latch
XFILLER_228_119 VPWR VGND sg13cmos5l_decap_8
XFILLER_324_63 VPWR VGND sg13cmos5l_decap_8
X_1271_ _1271_/Q Tile_X0Y5_FrameData[25] VGND VPWR Tile_X0Y5_FrameStrobe[0] latch
XFILLER_95_135 VPWR VGND sg13cmos5l_decap_8
XFILLER_3_77 VPWR VGND sg13cmos5l_decap_8
XFILLER_190_70 VPWR VGND sg13cmos5l_decap_8
X_0222_ _0222_/Q Tile_X0Y0_FrameData[8] VGND VPWR Tile_X0Y5_FrameStrobe[4] latch
XFILLER_67_91 VPWR VGND sg13cmos5l_decap_8
X_0153_ _0153_/Q Tile_X0Y0_FrameData[13] VGND VPWR Tile_X0Y5_FrameStrobe[2] latch
XFILLER_36_224 VPWR VGND sg13cmos5l_decap_8
XFILLER_36_246 VPWR VGND sg13cmos5l_fill_2
XFILLER_251_133 VPWR VGND sg13cmos5l_decap_8
X_0084_ _0084_/Q Tile_X0Y0_FrameData[18] VGND VPWR Tile_X0Y5_FrameStrobe[0] latch
XFILLER_340_84 VPWR VGND sg13cmos5l_decap_8
XFILLER_269_49 VPWR VGND sg13cmos5l_decap_8
XFILLER_51_249 VPWR VGND sg13cmos5l_decap_8
X_0986_ _0986_/Q Tile_X0Y3_FrameData[28] VGND VPWR Tile_X0Y5_FrameStrobe[6] latch
XFILLER_73_0 VPWR VGND sg13cmos5l_decap_8
XFILLER_306_112 VPWR VGND sg13cmos5l_decap_8
X_2725_ _2725_/X AXIL_S_SOC_ARPROT0 AXIL_S_SOC_ARVALID _2825_/X _2797_/X _1452_/Q
+ _1451_/Q VPWR VGND sg13cmos5l_mux4_1
XFILLER_105_207 VPWR VGND sg13cmos5l_decap_8
XFILLER_172_140 VPWR VGND sg13cmos5l_decap_8
XFILLER_218_42 VPWR VGND sg13cmos5l_decap_8
X_2656_ _2656_/X AXIL_S_SOC_WSTRB1 _2706_/X _2697_/X _2711_/X _1142_/Q _1141_/Q VPWR
+ VGND sg13cmos5l_mux4_1
XFILLER_361_251 VPWR VGND sg13cmos5l_decap_8
XFILLER_361_240 VPWR VGND sg13cmos5l_fill_1
XFILLER_321_104 VPWR VGND sg13cmos5l_decap_8
X_1607_ Tile_X0Y0_N4BEG[3] _1607_/A VPWR VGND sg13cmos5l_buf_1
XANTENNA__1625__X Tile_X0Y0_N2BEGb[5] VPWR VGND sg13cmos5l_antennanp
XFILLER_259_211 VPWR VGND sg13cmos5l_decap_8
X_2587_ _2587_/X _2566_/X Tile_X0Y5_N4END[8] _2565_/X Tile_X0Y0_S4END[12] _0838_/Q
+ _0837_/Q VPWR VGND sg13cmos5l_mux4_1
X_1538_ Tile_X0Y3_EE4BEG[0] _2525_/X VPWR VGND sg13cmos5l_buf_1
XFILLER_234_63 VPWR VGND sg13cmos5l_decap_8
X_1469_ _1469_/Q Tile_X0Y5_FrameData[19] VGND VPWR Tile_X0Y5_FrameStrobe[6] latch
XFILLER_47_28 VPWR VGND sg13cmos5l_decap_8
XFILLER_86_168 VPWR VGND sg13cmos5l_fill_1
XFILLER_86_157 VPWR VGND sg13cmos5l_decap_8
XFILLER_227_152 VPWR VGND sg13cmos5l_decap_8
XFILLER_103_56 VPWR VGND sg13cmos5l_decap_8
XFILLER_94_190 VPWR VGND sg13cmos5l_decap_8
XFILLER_242_133 VPWR VGND sg13cmos5l_decap_8
XFILLER_250_84 VPWR VGND sg13cmos5l_decap_8
XFILLER_63_49 VPWR VGND sg13cmos5l_decap_8
XFILLER_42_205 VPWR VGND sg13cmos5l_decap_8
XFILLER_151_7 VPWR VGND sg13cmos5l_decap_8
XFILLER_179_49 VPWR VGND sg13cmos5l_decap_8
XFILLER_249_7 VPWR VGND sg13cmos5l_decap_8
XFILLER_42_238 VPWR VGND sg13cmos5l_decap_4
XFILLER_329_215 VPWR VGND sg13cmos5l_fill_1
XFILLER_155_107 VPWR VGND sg13cmos5l_fill_1
XFILLER_155_129 VPWR VGND sg13cmos5l_decap_8
XFILLER_12_42 VPWR VGND sg13cmos5l_decap_8
XFILLER_6_139 VPWR VGND sg13cmos5l_decap_4
XFILLER_344_229 VPWR VGND sg13cmos5l_fill_1
XFILLER_128_42 VPWR VGND sg13cmos5l_decap_8
XFILLER_163_140 VPWR VGND sg13cmos5l_fill_2
XFILLER_275_70 VPWR VGND sg13cmos5l_decap_8
XFILLER_88_35 VPWR VGND sg13cmos5l_decap_8
XANTENNA__1535__X Tile_X0Y3_E6BEG[9] VPWR VGND sg13cmos5l_antennanp
XFILLER_312_159 VPWR VGND sg13cmos5l_decap_4
XFILLER_104_251 VPWR VGND sg13cmos5l_decap_4
XFILLER_144_63 VPWR VGND sg13cmos5l_decap_8
XFILLER_291_91 VPWR VGND sg13cmos5l_decap_8
XFILLER_92_105 VPWR VGND sg13cmos5l_decap_8
XFILLER_77_179 VPWR VGND sg13cmos5l_decap_4
XFILLER_77_157 VPWR VGND sg13cmos5l_fill_1
XFILLER_275_0 VPWR VGND sg13cmos5l_decap_8
XFILLER_280_228 VPWR VGND sg13cmos5l_decap_4
XFILLER_160_84 VPWR VGND sg13cmos5l_decap_8
XFILLER_233_133 VPWR VGND sg13cmos5l_decap_8
XFILLER_310_21 VPWR VGND sg13cmos5l_decap_8
XFILLER_33_238 VPWR VGND sg13cmos5l_decap_8
XFILLER_310_98 VPWR VGND sg13cmos5l_decap_8
XFILLER_186_232 VPWR VGND sg13cmos5l_decap_8
XFILLER_186_254 VPWR VGND sg13cmos5l_fill_2
X_0840_ _0840_/Q Tile_X0Y3_FrameData[14] VGND VPWR Tile_X0Y5_FrameStrobe[1] latch
XFILLER_139_192 VPWR VGND sg13cmos5l_fill_1
XFILLER_319_63 VPWR VGND sg13cmos5l_decap_8
X_0771_ _0771_/Q Tile_X0Y2_FrameData[3] VGND VPWR Tile_X0Y5_FrameStrobe[6] latch
XFILLER_154_140 VPWR VGND sg13cmos5l_decap_8
X_2510_ _2510_/X AXIL_S_SOC_ARADDR1 AXIL_S_SOC_ARADDR9 _2590_/X _2595_/X _0984_/Q
+ _0983_/Q VPWR VGND sg13cmos5l_mux4_1
XFILLER_185_70 VPWR VGND sg13cmos5l_decap_8
X_2441_ _2441_/X AXIL_S_SOC_AWADDR0 _2475_/X _2473_/X _2485_/X _0666_/Q _0665_/Q VPWR
+ VGND sg13cmos5l_mux4_1
XFILLER_303_126 VPWR VGND sg13cmos5l_decap_8
XFILLER_335_84 VPWR VGND sg13cmos5l_decap_8
X_2372_ _2372_/X _2342_/X _0063_/X _2341_/X Tile_X0Y0_S4END[4] _0366_/Q _0365_/Q VPWR
+ VGND sg13cmos5l_mux4_1
XFILLER_271_28 VPWR VGND sg13cmos5l_decap_8
X_1323_ _1323_/Q Tile_X0Y5_FrameData[5] VGND VPWR Tile_X0Y5_FrameStrobe[1] latch
XFILLER_110_254 VPWR VGND sg13cmos5l_fill_2
X_1254_ _1254_/Q Tile_X0Y4_FrameData[0] VGND VPWR Tile_X0Y5_FrameStrobe[6] latch
XFILLER_83_105 VPWR VGND sg13cmos5l_decap_8
XFILLER_68_168 VPWR VGND sg13cmos5l_fill_1
XFILLER_204_77 VPWR VGND sg13cmos5l_decap_8
XFILLER_209_152 VPWR VGND sg13cmos5l_decap_8
X_0205_ _0205_/Q Tile_X0Y0_FrameData[25] VGND VPWR Tile_X0Y5_FrameStrobe[4] latch
XFILLER_209_174 VPWR VGND sg13cmos5l_decap_4
X_1185_ _1185_/Q Tile_X0Y4_FrameData[5] VGND VPWR Tile_X0Y5_FrameStrobe[4] latch
XFILLER_76_190 VPWR VGND sg13cmos5l_decap_8
XFILLER_220_21 VPWR VGND sg13cmos5l_decap_8
XFILLER_224_155 VPWR VGND sg13cmos5l_decap_8
X_0136_ _0136_/Q Tile_X0Y0_FrameData[30] VGND VPWR Tile_X0Y5_FrameStrobe[2] latch
X_0067_ _2075_/A _2661_/X _2662_/X _1106_/Q VPWR VGND sg13cmos5l_mux2_1
XFILLER_91_193 VPWR VGND sg13cmos5l_decap_8
XFILLER_220_98 VPWR VGND sg13cmos5l_decap_8
XFILLER_296_14 VPWR VGND sg13cmos5l_decap_8
XFILLER_229_63 VPWR VGND sg13cmos5l_decap_8
X_0969_ _0969_/Q Tile_X0Y3_FrameData[13] VGND VPWR Tile_X0Y5_FrameStrobe[5] latch
X_2708_ _2708_/X _2598_/X Tile_X0Y5_N2MID[0] _2713_/X _2597_/X _1054_/Q _1053_/Q VPWR
+ VGND sg13cmos5l_mux4_1
XFILLER_145_162 VPWR VGND sg13cmos5l_decap_8
XFILLER_165_29 VPWR VGND sg13cmos5l_decap_8
X_2639_ _2639_/X AXIL_S_SOC_WSTRB0 AXIL_S_SOC_WVALID _2693_/X _2709_/X _1176_/Q _1175_/Q
+ VPWR VGND sg13cmos5l_mux4_1
XFILLER_245_84 VPWR VGND sg13cmos5l_decap_8
XFILLER_99_260 VPWR VGND sg13cmos5l_fill_1
XFILLER_181_28 VPWR VGND sg13cmos5l_decap_8
XFILLER_58_49 VPWR VGND sg13cmos5l_decap_8
XFILLER_199_7 VPWR VGND sg13cmos5l_decap_8
XFILLER_74_105 VPWR VGND sg13cmos5l_decap_8
XFILLER_59_168 VPWR VGND sg13cmos5l_decap_8
XFILLER_114_77 VPWR VGND sg13cmos5l_decap_8
XFILLER_130_21 VPWR VGND sg13cmos5l_decap_8
XFILLER_215_199 VPWR VGND sg13cmos5l_decap_8
XFILLER_230_147 VPWR VGND sg13cmos5l_decap_8
XFILLER_90_36 VPWR VGND sg13cmos5l_decap_8
XFILLER_23_63 VPWR VGND sg13cmos5l_decap_8
XFILLER_139_63 VPWR VGND sg13cmos5l_decap_8
XFILLER_356_28 VPWR VGND sg13cmos5l_decap_8
XFILLER_99_56 VPWR VGND sg13cmos5l_decap_8
XFILLER_340_210 VPWR VGND sg13cmos5l_fill_2
XFILLER_2_131 VPWR VGND sg13cmos5l_decap_8
XFILLER_3_0 VPWR VGND sg13cmos5l_decap_8
XFILLER_297_147 VPWR VGND sg13cmos5l_decap_8
XFILLER_2_153 VPWR VGND sg13cmos5l_fill_1
XFILLER_238_203 VPWR VGND sg13cmos5l_fill_1
XFILLER_305_21 VPWR VGND sg13cmos5l_decap_8
XFILLER_65_105 VPWR VGND sg13cmos5l_decap_8
XFILLER_48_60 VPWR VGND sg13cmos5l_decap_8
XFILLER_305_98 VPWR VGND sg13cmos5l_decap_8
XANTENNA__2096__X Tile_X0Y3_E2BEGb[0] VPWR VGND sg13cmos5l_antennanp
XFILLER_0_56 VPWR VGND sg13cmos5l_decap_8
XFILLER_321_42 VPWR VGND sg13cmos5l_fill_2
XFILLER_321_97 VPWR VGND sg13cmos5l_decap_8
XFILLER_64_70 VPWR VGND sg13cmos5l_decap_8
XFILLER_221_136 VPWR VGND sg13cmos5l_decap_4
XFILLER_9_21 VPWR VGND sg13cmos5l_decap_8
XFILLER_14_271 VPWR VGND sg13cmos5l_fill_2
X_1941_ Tile_X0Y1_E6BEG[6] _2331_/X VPWR VGND sg13cmos5l_buf_1
XFILLER_159_265 VPWR VGND sg13cmos5l_decap_8
X_1872_ Tile_X0Y2_E2BEGb[6] _2415_/X VPWR VGND sg13cmos5l_buf_1
XFILLER_266_28 VPWR VGND sg13cmos5l_decap_8
X_0823_ _0823_/Q Tile_X0Y3_FrameData[31] VGND VPWR Tile_X0Y5_FrameStrobe[1] latch
XFILLER_9_98 VPWR VGND sg13cmos5l_decap_8
XFILLER_80_91 VPWR VGND sg13cmos5l_fill_2
XFILLER_174_257 VPWR VGND sg13cmos5l_fill_2
XFILLER_196_91 VPWR VGND sg13cmos5l_decap_8
XFILLER_127_173 VPWR VGND sg13cmos5l_fill_2
X_0754_ _0754_/Q Tile_X0Y2_FrameData[20] VGND VPWR Tile_X0Y5_FrameStrobe[6] latch
X_0685_ _0685_/Q Tile_X0Y2_FrameData[25] VGND VPWR Tile_X0Y5_FrameStrobe[4] latch
XFILLER_282_49 VPWR VGND sg13cmos5l_decap_8
XFILLER_288_147 VPWR VGND sg13cmos5l_decap_8
X_2424_ _2424_/X AXIL_S_SOC_AWADDR7 AXIL_S_SOC_AWPROT1 _2472_/X _2481_/X _0700_/Q
+ _0699_/Q VPWR VGND sg13cmos5l_mux4_1
XFILLER_215_21 VPWR VGND sg13cmos5l_decap_8
X_2355_ _2355_/X Tile_X0Y5_W1END[1] Tile_X0Y5_WW4END[1] Tile_X0Y5_WW4END[7] Tile_X0Y5_W6END[9]
+ _1469_/Q _1468_/Q VPWR VGND sg13cmos5l_mux4_1
XFILLER_36_0 VPWR VGND sg13cmos5l_decap_8
XANTENNA__1903__X Tile_X0Y1_FrameData_O[16] VPWR VGND sg13cmos5l_antennanp
XFILLER_229_236 VPWR VGND sg13cmos5l_fill_2
X_1306_ _1306_/Q Tile_X0Y5_FrameData[22] VGND VPWR Tile_X0Y5_FrameStrobe[1] latch
XFILLER_96_263 VPWR VGND sg13cmos5l_fill_2
XFILLER_362_82 VPWR VGND sg13cmos5l_fill_2
XFILLER_244_206 VPWR VGND sg13cmos5l_fill_1
X_2286_ _2286_/X _2586_/X _2585_/X _2578_/X _2577_/X _1003_/Q _1002_/Q VPWR VGND sg13cmos5l_mux4_1
XFILLER_56_105 VPWR VGND sg13cmos5l_decap_8
X_1237_ _1237_/Q Tile_X0Y4_FrameData[17] VGND VPWR Tile_X0Y5_FrameStrobe[6] latch
XFILLER_231_42 VPWR VGND sg13cmos5l_decap_8
X_1168_ _1168_/Q Tile_X0Y4_FrameData[22] VGND VPWR Tile_X0Y5_FrameStrobe[4] latch
X_0119_ _0119_/Q Tile_X0Y0_FrameData[15] VGND VPWR Tile_X0Y5_FrameStrobe[1] latch
XFILLER_44_18 VPWR VGND sg13cmos5l_decap_8
X_1099_ _1099_/Q Tile_X0Y4_FrameData[27] VGND VPWR Tile_X0Y5_FrameStrobe[2] latch
XFILLER_100_35 VPWR VGND sg13cmos5l_decap_8
XFILLER_60_28 VPWR VGND sg13cmos5l_decap_8
XFILLER_165_246 VPWR VGND sg13cmos5l_decap_8
XFILLER_176_28 VPWR VGND sg13cmos5l_decap_8
XFILLER_118_140 VPWR VGND sg13cmos5l_decap_8
XFILLER_114_7 VPWR VGND sg13cmos5l_decap_8
XFILLER_180_238 VPWR VGND sg13cmos5l_decap_8
XFILLER_109_77 VPWR VGND sg13cmos5l_decap_8
XFILLER_133_132 VPWR VGND sg13cmos5l_decap_8
XFILLER_192_49 VPWR VGND sg13cmos5l_decap_8
XFILLER_279_136 VPWR VGND sg13cmos5l_fill_2
XFILLER_79_208 VPWR VGND sg13cmos5l_fill_2
XFILLER_125_21 VPWR VGND sg13cmos5l_decap_8
XANTENNA__1813__X Tile_X0Y4_E6BEG[8] VPWR VGND sg13cmos5l_antennanp
XFILLER_125_98 VPWR VGND sg13cmos5l_decap_8
XFILLER_85_36 VPWR VGND sg13cmos5l_decap_8
XFILLER_47_105 VPWR VGND sg13cmos5l_decap_8
XFILLER_141_42 VPWR VGND sg13cmos5l_decap_8
XFILLER_18_63 VPWR VGND sg13cmos5l_decap_8
XFILLER_62_119 VPWR VGND sg13cmos5l_decap_8
XFILLER_243_272 VPWR VGND sg13cmos5l_fill_1
XFILLER_55_182 VPWR VGND sg13cmos5l_decap_8
XFILLER_140_0 VPWR VGND sg13cmos5l_decap_8
XFILLER_203_147 VPWR VGND sg13cmos5l_decap_8
XFILLER_238_0 VPWR VGND sg13cmos5l_decap_8
XFILLER_357_140 VPWR VGND sg13cmos5l_decap_8
XFILLER_34_84 VPWR VGND sg13cmos5l_decap_8
XFILLER_109_140 VPWR VGND sg13cmos5l_decap_8
XFILLER_156_246 VPWR VGND sg13cmos5l_decap_4
XFILLER_109_195 VPWR VGND sg13cmos5l_fill_1
XFILLER_124_165 VPWR VGND sg13cmos5l_fill_2
XFILLER_316_42 VPWR VGND sg13cmos5l_decap_8
X_0470_ _0470_/Q Tile_X0Y1_FrameData[0] VGND VPWR Tile_X0Y5_FrameStrobe[4] latch
XFILLER_124_198 VPWR VGND sg13cmos5l_decap_8
XFILLER_59_70 VPWR VGND sg13cmos5l_decap_8
XANTENNA__1723__X Tile_X0Y0_E2BEGb[3] VPWR VGND sg13cmos5l_antennanp
XFILLER_278_191 VPWR VGND sg13cmos5l_decap_8
XFILLER_78_241 VPWR VGND sg13cmos5l_fill_2
X_2140_ AXIL_S_SOC_RVALID Tile_X0Y5_W2MID[3] Tile_X0Y5_W2END[3] Tile_X0Y5_W6END[3]
+ _2828_/X _1322_/Q _1321_/Q VPWR VGND sg13cmos5l_mux4_1
XFILLER_38_105 VPWR VGND sg13cmos5l_decap_8
XFILLER_332_63 VPWR VGND sg13cmos5l_decap_8
X_2071_ Tile_X0Y5_S4BEG[4] _2071_/A VPWR VGND sg13cmos5l_buf_1
X_1022_ _1022_/Q Tile_X0Y3_FrameData[24] VGND VPWR Tile_X0Y5_FrameStrobe[7] latch
XFILLER_75_91 VPWR VGND sg13cmos5l_decap_8
XFILLER_53_119 VPWR VGND sg13cmos5l_decap_8
XFILLER_46_182 VPWR VGND sg13cmos5l_decap_8
XFILLER_201_56 VPWR VGND sg13cmos5l_decap_8
X_1924_ Tile_X0Y1_EE4BEG[5] _2314_/X VPWR VGND sg13cmos5l_buf_1
XFILLER_348_140 VPWR VGND sg13cmos5l_decap_8
XFILLER_202_180 VPWR VGND sg13cmos5l_decap_8
XFILLER_277_49 VPWR VGND sg13cmos5l_decap_8
XFILLER_147_268 VPWR VGND sg13cmos5l_decap_4
X_1855_ Tile_X0Y4_FrameData_O[22] Tile_X0Y4_FrameData[22] VPWR VGND sg13cmos5l_buf_1
X_1786_ Tile_X0Y4_E1BEG[1] _2614_/X VPWR VGND sg13cmos5l_buf_1
X_0806_ _0806_/Q Tile_X0Y3_FrameData[16] VGND VPWR Tile_X0Y5_FrameStrobe[0] latch
X_0737_ _0737_/Q Tile_X0Y2_FrameData[5] VGND VPWR Tile_X0Y5_FrameStrobe[5] latch
XFILLER_115_154 VPWR VGND sg13cmos5l_decap_8
XFILLER_226_64 VPWR VGND sg13cmos5l_decap_8
X_0668_ _0668_/Q Tile_X0Y2_FrameData[10] VGND VPWR Tile_X0Y5_FrameStrobe[3] latch
XANTENNA__1633__X Tile_X0Y0_N2BEG[5] VPWR VGND sg13cmos5l_antennanp
X_2407_ _2407_/X AXIL_S_SOC_AWADDR0 AXIL_S_SOC_AWADDR6 _2482_/X _2487_/X _0734_/Q
+ _0733_/Q VPWR VGND sg13cmos5l_mux4_1
X_0599_ _0599_/Q Tile_X0Y2_FrameData[15] VGND VPWR Tile_X0Y5_FrameStrobe[1] latch
XFILLER_29_105 VPWR VGND sg13cmos5l_decap_8
X_2338_ _2338_/X _2344_/X _2343_/X Tile_X0Y1_W6END[1] _2338_/A3 _0316_/Q _0315_/Q
+ VPWR VGND sg13cmos5l_mux4_1
XFILLER_242_63 VPWR VGND sg13cmos5l_decap_8
X_2269_ _2269_/X Tile_X0Y1_W1END[1] Tile_X0Y1_WW4END[1] Tile_X0Y1_WW4END[5] Tile_X0Y1_W6END[9]
+ _0523_/Q _0522_/Q VPWR VGND sg13cmos5l_mux4_1
XFILLER_55_28 VPWR VGND sg13cmos5l_decap_8
XFILLER_111_56 VPWR VGND sg13cmos5l_decap_8
XFILLER_231_7 VPWR VGND sg13cmos5l_decap_8
XFILLER_71_49 VPWR VGND sg13cmos5l_decap_8
XFILLER_52_196 VPWR VGND sg13cmos5l_decap_8
XFILLER_339_151 VPWR VGND sg13cmos5l_decap_8
XFILLER_138_213 VPWR VGND sg13cmos5l_fill_2
XFILLER_187_49 VPWR VGND sg13cmos5l_decap_8
XFILLER_329_7 VPWR VGND sg13cmos5l_decap_8
XFILLER_339_184 VPWR VGND sg13cmos5l_fill_2
XFILLER_339_162 VPWR VGND sg13cmos5l_fill_1
XANTENNA__1808__X Tile_X0Y4_E6BEG[3] VPWR VGND sg13cmos5l_antennanp
XFILLER_354_154 VPWR VGND sg13cmos5l_decap_8
XFILLER_153_238 VPWR VGND sg13cmos5l_fill_2
XFILLER_20_42 VPWR VGND sg13cmos5l_decap_8
XFILLER_4_237 VPWR VGND sg13cmos5l_fill_1
XFILLER_136_42 VPWR VGND sg13cmos5l_decap_8
XFILLER_283_70 VPWR VGND sg13cmos5l_decap_8
XFILLER_96_35 VPWR VGND sg13cmos5l_decap_8
XANTENNA__1543__X Tile_X0Y3_EE4BEG[5] VPWR VGND sg13cmos5l_antennanp
XFILLER_310_235 VPWR VGND sg13cmos5l_fill_2
XFILLER_152_63 VPWR VGND sg13cmos5l_decap_8
XFILLER_188_0 VPWR VGND sg13cmos5l_decap_8
XFILLER_29_84 VPWR VGND sg13cmos5l_decap_8
XFILLER_208_239 VPWR VGND sg13cmos5l_fill_2
XFILLER_35_119 VPWR VGND sg13cmos5l_fill_1
XFILLER_223_209 VPWR VGND sg13cmos5l_fill_1
XFILLER_290_175 VPWR VGND sg13cmos5l_decap_8
XFILLER_355_0 VPWR VGND sg13cmos5l_decap_8
XFILLER_216_272 VPWR VGND sg13cmos5l_fill_1
XFILLER_302_77 VPWR VGND sg13cmos5l_decap_8
XFILLER_231_264 VPWR VGND sg13cmos5l_fill_1
XANTENNA__1718__X Tile_X0Y0_E6BEG[10] VPWR VGND sg13cmos5l_antennanp
XFILLER_77_7 VPWR VGND sg13cmos5l_decap_8
XFILLER_144_205 VPWR VGND sg13cmos5l_decap_8
X_1640_ Tile_X0Y0_FrameStrobe_O[0] Tile_X0Y5_FrameStrobe[0] VPWR VGND sg13cmos5l_buf_1
XFILLER_345_154 VPWR VGND sg13cmos5l_decap_8
XANTENNA_4 AXIL_S_SOC_AWPROT1 VPWR VGND sg13cmos5l_antennanp
XFILLER_327_63 VPWR VGND sg13cmos5l_decap_8
X_1571_ Tile_X0Y3_FrameData_O[17] Tile_X0Y3_FrameData[17] VPWR VGND sg13cmos5l_buf_1
XFILLER_360_113 VPWR VGND sg13cmos5l_decap_8
XFILLER_298_220 VPWR VGND sg13cmos5l_fill_1
X_0522_ _0522_/Q Tile_X0Y1_FrameData[12] VGND VPWR Tile_X0Y5_FrameStrobe[6] latch
XFILLER_6_77 VPWR VGND sg13cmos5l_decap_8
XFILLER_193_70 VPWR VGND sg13cmos5l_decap_8
XFILLER_298_253 VPWR VGND sg13cmos5l_decap_8
XFILLER_112_168 VPWR VGND sg13cmos5l_fill_1
XFILLER_301_235 VPWR VGND sg13cmos5l_decap_8
X_0453_ _0453_/Q Tile_X0Y1_FrameData[17] VGND VPWR Tile_X0Y5_FrameStrobe[4] latch
XFILLER_112_179 VPWR VGND sg13cmos5l_fill_1
X_0384_ _0384_/Q Tile_X0Y1_FrameData[22] VGND VPWR Tile_X0Y5_FrameStrobe[2] latch
XFILLER_66_211 VPWR VGND sg13cmos5l_decap_8
XFILLER_343_84 VPWR VGND sg13cmos5l_decap_8
XFILLER_266_161 VPWR VGND sg13cmos5l_decap_8
X_2123_ AXIL_S_SOC_RDATA17 Tile_X0Y1_W2MID[1] Tile_X0Y1_W2END[1] Tile_X0Y1_W6END[1]
+ _2374_/X _0380_/Q _0379_/Q VPWR VGND sg13cmos5l_mux4_1
XFILLER_66_222 VPWR VGND sg13cmos5l_fill_2
X_2054_ Tile_X0Y5_S2BEG[3] _2776_/X VPWR VGND sg13cmos5l_buf_1
XFILLER_212_77 VPWR VGND sg13cmos5l_decap_8
X_1005_ _1005_/Q Tile_X0Y3_FrameData[9] VGND VPWR Tile_X0Y5_FrameStrobe[6] latch
XFILLER_34_185 VPWR VGND sg13cmos5l_decap_8
XFILLER_34_163 VPWR VGND sg13cmos5l_fill_1
XFILLER_179_168 VPWR VGND sg13cmos5l_decap_8
XFILLER_222_264 VPWR VGND sg13cmos5l_decap_8
XANTENNA__1628__X Tile_X0Y0_N2BEG[0] VPWR VGND sg13cmos5l_antennanp
X_1907_ Tile_X0Y1_FrameData_O[20] Tile_X0Y1_FrameData[20] VPWR VGND sg13cmos5l_buf_1
X_1838_ Tile_X0Y4_FrameData_O[5] Tile_X0Y4_FrameData[5] VPWR VGND sg13cmos5l_buf_1
XFILLER_237_63 VPWR VGND sg13cmos5l_decap_8
XFILLER_289_220 VPWR VGND sg13cmos5l_decap_8
X_1769_ Tile_X0Y2_FrameData_O[29] Tile_X0Y2_FrameData[29] VPWR VGND sg13cmos5l_buf_1
XFILLER_351_168 VPWR VGND sg13cmos5l_decap_8
XFILLER_103_146 VPWR VGND sg13cmos5l_decap_8
XFILLER_249_139 VPWR VGND sg13cmos5l_decap_8
XFILLER_106_56 VPWR VGND sg13cmos5l_decap_8
XFILLER_253_84 VPWR VGND sg13cmos5l_decap_8
XFILLER_286_8 VPWR VGND sg13cmos5l_decap_8
XFILLER_66_49 VPWR VGND sg13cmos5l_decap_8
XFILLER_57_222 VPWR VGND sg13cmos5l_decap_4
XFILLER_181_7 VPWR VGND sg13cmos5l_decap_8
XFILLER_279_7 VPWR VGND sg13cmos5l_decap_8
XFILLER_17_119 VPWR VGND sg13cmos5l_decap_8
XFILLER_122_77 VPWR VGND sg13cmos5l_decap_8
XFILLER_72_258 VPWR VGND sg13cmos5l_fill_2
XFILLER_25_152 VPWR VGND sg13cmos5l_fill_2
XFILLER_359_224 VPWR VGND sg13cmos5l_decap_8
XFILLER_15_42 VPWR VGND sg13cmos5l_decap_8
XFILLER_185_105 VPWR VGND sg13cmos5l_decap_8
XFILLER_40_133 VPWR VGND sg13cmos5l_decap_4
XFILLER_278_70 VPWR VGND sg13cmos5l_decap_8
XFILLER_327_143 VPWR VGND sg13cmos5l_fill_1
XANTENNA__1538__X Tile_X0Y3_EE4BEG[0] VPWR VGND sg13cmos5l_antennanp
XFILLER_193_182 VPWR VGND sg13cmos5l_fill_2
XFILLER_31_63 VPWR VGND sg13cmos5l_decap_8
XFILLER_342_113 VPWR VGND sg13cmos5l_decap_8
XFILLER_103_0 VPWR VGND sg13cmos5l_decap_8
XFILLER_147_63 VPWR VGND sg13cmos5l_decap_8
XFILLER_294_91 VPWR VGND sg13cmos5l_decap_8
XFILLER_295_245 VPWR VGND sg13cmos5l_decap_8
XFILLER_48_200 VPWR VGND sg13cmos5l_decap_8
XFILLER_163_84 VPWR VGND sg13cmos5l_decap_8
XFILLER_248_150 VPWR VGND sg13cmos5l_decap_8
XFILLER_313_21 VPWR VGND sg13cmos5l_decap_8
XFILLER_313_98 VPWR VGND sg13cmos5l_decap_8
XFILLER_176_105 VPWR VGND sg13cmos5l_decap_8
XFILLER_72_70 VPWR VGND sg13cmos5l_decap_8
XFILLER_188_70 VPWR VGND sg13cmos5l_decap_8
X_2810_ _2810_/X Tile_X0Y5_N1END[1] Tile_X0Y5_N4END[1] _2794_/X _0059_/X _1302_/Q
+ _1301_/Q VPWR VGND sg13cmos5l_mux4_1
XFILLER_31_188 VPWR VGND sg13cmos5l_decap_8
XFILLER_31_199 VPWR VGND sg13cmos5l_fill_2
X_2741_ _2741_/X AXIL_S_SOC_ARPROT0 AXIL_S_SOC_ARPROT2 _2801_/X _2797_/X _1420_/Q
+ _1419_/Q VPWR VGND sg13cmos5l_mux4_1
XFILLER_117_238 VPWR VGND sg13cmos5l_decap_8
X_2672_ _2672_/X _2680_/X _2679_/X Tile_X0Y4_W6END[3] _2672_/A3 _1032_/Q _1265_/Q
+ VPWR VGND sg13cmos5l_mux4_1
XFILLER_338_84 VPWR VGND sg13cmos5l_decap_8
XFILLER_132_208 VPWR VGND sg13cmos5l_fill_2
XFILLER_274_28 VPWR VGND sg13cmos5l_decap_8
X_1623_ Tile_X0Y0_N2BEGb[3] _2256_/X VPWR VGND sg13cmos5l_buf_1
X_1554_ Tile_X0Y3_FrameData_O[0] Tile_X0Y3_FrameData[0] VPWR VGND sg13cmos5l_buf_1
XFILLER_207_77 VPWR VGND sg13cmos5l_fill_2
X_1485_ _1485_/Q Tile_X0Y5_FrameData[3] VGND VPWR Tile_X0Y5_FrameStrobe[6] latch
X_0505_ _0505_/Q Tile_X0Y1_FrameData[29] VGND VPWR Tile_X0Y5_FrameStrobe[6] latch
X_0436_ _0436_/Q Tile_X0Y1_FrameData[2] VGND VPWR Tile_X0Y5_FrameStrobe[3] latch
XFILLER_98_199 VPWR VGND sg13cmos5l_decap_8
.ends
