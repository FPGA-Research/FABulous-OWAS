* NGSPICE file created from AXI_M_IO_W.ext - technology: ihp-sg13cmos5l

* Black-box entry subcircuit for sg13cmos5l_decap_8 abstract view
.subckt sg13cmos5l_decap_8 VDD VSS
.ends

* Black-box entry subcircuit for latch abstract view
.subckt latch Q D VSS VDD GATE
.ends

* Black-box entry subcircuit for sg13cmos5l_buf_1 abstract view
.subckt sg13cmos5l_buf_1 X A VDD VSS
.ends

* Black-box entry subcircuit for sg13cmos5l_fill_1 abstract view
.subckt sg13cmos5l_fill_1 VDD VSS
.ends

* Black-box entry subcircuit for sg13cmos5l_antennanp abstract view
.subckt sg13cmos5l_antennanp A VDD VSS
.ends

* Black-box entry subcircuit for sg13cmos5l_fill_2 abstract view
.subckt sg13cmos5l_fill_2 VDD VSS
.ends

* Black-box entry subcircuit for sg13cmos5l_mux4_1 abstract view
.subckt sg13cmos5l_mux4_1 X A0 A1 A2 A3 S0 S1 VDD VSS
.ends

* Black-box entry subcircuit for sg13cmos5l_decap_4 abstract view
.subckt sg13cmos5l_decap_4 VDD VSS
.ends

* Black-box entry subcircuit for sg13cmos5l_mux2_1 abstract view
.subckt sg13cmos5l_mux2_1 X A0 A1 S VDD VSS
.ends

* Black-box entry subcircuit for sg13cmos5l_tielo abstract view
.subckt sg13cmos5l_tielo L_LO VDD VSS
.ends

* Black-box entry subcircuit for sg13cmos5l_nor2b_1 abstract view
.subckt sg13cmos5l_nor2b_1 Y A B_N VDD VSS
.ends

* Black-box entry subcircuit for sg13cmos5l_or2_1 abstract view
.subckt sg13cmos5l_or2_1 X A B VDD VSS
.ends

.subckt AXI_M_IO_W AXI_M_SOC_ARADDR0 AXI_M_SOC_ARADDR1 AXI_M_SOC_ARADDR10 AXI_M_SOC_ARADDR11
+ AXI_M_SOC_ARADDR12 AXI_M_SOC_ARADDR13 AXI_M_SOC_ARADDR14 AXI_M_SOC_ARADDR15 AXI_M_SOC_ARADDR16
+ AXI_M_SOC_ARADDR17 AXI_M_SOC_ARADDR18 AXI_M_SOC_ARADDR19 AXI_M_SOC_ARADDR2 AXI_M_SOC_ARADDR20
+ AXI_M_SOC_ARADDR21 AXI_M_SOC_ARADDR22 AXI_M_SOC_ARADDR23 AXI_M_SOC_ARADDR24 AXI_M_SOC_ARADDR25
+ AXI_M_SOC_ARADDR26 AXI_M_SOC_ARADDR27 AXI_M_SOC_ARADDR28 AXI_M_SOC_ARADDR29 AXI_M_SOC_ARADDR3
+ AXI_M_SOC_ARADDR30 AXI_M_SOC_ARADDR31 AXI_M_SOC_ARADDR4 AXI_M_SOC_ARADDR5 AXI_M_SOC_ARADDR6
+ AXI_M_SOC_ARADDR7 AXI_M_SOC_ARADDR8 AXI_M_SOC_ARADDR9 AXI_M_SOC_ARBURST0 AXI_M_SOC_ARBURST1
+ AXI_M_SOC_ARCACHE0 AXI_M_SOC_ARCACHE1 AXI_M_SOC_ARCACHE2 AXI_M_SOC_ARCACHE3 AXI_M_SOC_ARLEN0
+ AXI_M_SOC_ARLEN1 AXI_M_SOC_ARLEN2 AXI_M_SOC_ARLEN3 AXI_M_SOC_ARLEN4 AXI_M_SOC_ARLEN5
+ AXI_M_SOC_ARLEN6 AXI_M_SOC_ARLEN7 AXI_M_SOC_ARLOCK AXI_M_SOC_ARREADY AXI_M_SOC_ARSIZE0
+ AXI_M_SOC_ARSIZE1 AXI_M_SOC_ARSIZE2 AXI_M_SOC_ARVALID AXI_M_SOC_AWADDR0 AXI_M_SOC_AWADDR1
+ AXI_M_SOC_AWADDR10 AXI_M_SOC_AWADDR11 AXI_M_SOC_AWADDR12 AXI_M_SOC_AWADDR13 AXI_M_SOC_AWADDR14
+ AXI_M_SOC_AWADDR15 AXI_M_SOC_AWADDR16 AXI_M_SOC_AWADDR17 AXI_M_SOC_AWADDR18 AXI_M_SOC_AWADDR19
+ AXI_M_SOC_AWADDR2 AXI_M_SOC_AWADDR20 AXI_M_SOC_AWADDR21 AXI_M_SOC_AWADDR22 AXI_M_SOC_AWADDR23
+ AXI_M_SOC_AWADDR24 AXI_M_SOC_AWADDR25 AXI_M_SOC_AWADDR26 AXI_M_SOC_AWADDR27 AXI_M_SOC_AWADDR28
+ AXI_M_SOC_AWADDR29 AXI_M_SOC_AWADDR3 AXI_M_SOC_AWADDR30 AXI_M_SOC_AWADDR31 AXI_M_SOC_AWADDR4
+ AXI_M_SOC_AWADDR5 AXI_M_SOC_AWADDR6 AXI_M_SOC_AWADDR7 AXI_M_SOC_AWADDR8 AXI_M_SOC_AWADDR9
+ AXI_M_SOC_AWBURST0 AXI_M_SOC_AWBURST1 AXI_M_SOC_AWCACHE0 AXI_M_SOC_AWCACHE1 AXI_M_SOC_AWCACHE2
+ AXI_M_SOC_AWCACHE3 AXI_M_SOC_AWLEN0 AXI_M_SOC_AWLEN1 AXI_M_SOC_AWLEN2 AXI_M_SOC_AWLEN3
+ AXI_M_SOC_AWLEN4 AXI_M_SOC_AWLEN5 AXI_M_SOC_AWLEN6 AXI_M_SOC_AWLEN7 AXI_M_SOC_AWLOCK
+ AXI_M_SOC_AWREADY AXI_M_SOC_AWSIZE0 AXI_M_SOC_AWSIZE1 AXI_M_SOC_AWSIZE2 AXI_M_SOC_AWVALID
+ AXI_M_SOC_BREADY AXI_M_SOC_BRESP0 AXI_M_SOC_BRESP1 AXI_M_SOC_BVALID AXI_M_SOC_RDATA0
+ AXI_M_SOC_RDATA1 AXI_M_SOC_RDATA10 AXI_M_SOC_RDATA11 AXI_M_SOC_RDATA12 AXI_M_SOC_RDATA13
+ AXI_M_SOC_RDATA14 AXI_M_SOC_RDATA15 AXI_M_SOC_RDATA16 AXI_M_SOC_RDATA17 AXI_M_SOC_RDATA18
+ AXI_M_SOC_RDATA19 AXI_M_SOC_RDATA2 AXI_M_SOC_RDATA20 AXI_M_SOC_RDATA21 AXI_M_SOC_RDATA22
+ AXI_M_SOC_RDATA23 AXI_M_SOC_RDATA24 AXI_M_SOC_RDATA25 AXI_M_SOC_RDATA26 AXI_M_SOC_RDATA27
+ AXI_M_SOC_RDATA28 AXI_M_SOC_RDATA29 AXI_M_SOC_RDATA3 AXI_M_SOC_RDATA30 AXI_M_SOC_RDATA31
+ AXI_M_SOC_RDATA4 AXI_M_SOC_RDATA5 AXI_M_SOC_RDATA6 AXI_M_SOC_RDATA7 AXI_M_SOC_RDATA8
+ AXI_M_SOC_RDATA9 AXI_M_SOC_RLAST AXI_M_SOC_RREADY AXI_M_SOC_RRESP0 AXI_M_SOC_RRESP1
+ AXI_M_SOC_RVALID AXI_M_SOC_WDATA0 AXI_M_SOC_WDATA1 AXI_M_SOC_WDATA10 AXI_M_SOC_WDATA11
+ AXI_M_SOC_WDATA12 AXI_M_SOC_WDATA13 AXI_M_SOC_WDATA14 AXI_M_SOC_WDATA15 AXI_M_SOC_WDATA16
+ AXI_M_SOC_WDATA17 AXI_M_SOC_WDATA18 AXI_M_SOC_WDATA19 AXI_M_SOC_WDATA2 AXI_M_SOC_WDATA20
+ AXI_M_SOC_WDATA21 AXI_M_SOC_WDATA22 AXI_M_SOC_WDATA23 AXI_M_SOC_WDATA24 AXI_M_SOC_WDATA25
+ AXI_M_SOC_WDATA26 AXI_M_SOC_WDATA27 AXI_M_SOC_WDATA28 AXI_M_SOC_WDATA29 AXI_M_SOC_WDATA3
+ AXI_M_SOC_WDATA30 AXI_M_SOC_WDATA31 AXI_M_SOC_WDATA4 AXI_M_SOC_WDATA5 AXI_M_SOC_WDATA6
+ AXI_M_SOC_WDATA7 AXI_M_SOC_WDATA8 AXI_M_SOC_WDATA9 AXI_M_SOC_WLAST AXI_M_SOC_WREADY
+ AXI_M_SOC_WSTRB0 AXI_M_SOC_WSTRB1 AXI_M_SOC_WSTRB2 AXI_M_SOC_WSTRB3 AXI_M_SOC_WVALID
+ Tile_X0Y0_E1BEG[0] Tile_X0Y0_E1BEG[1] Tile_X0Y0_E1BEG[2] Tile_X0Y0_E1BEG[3] Tile_X0Y0_E2BEG[0]
+ Tile_X0Y0_E2BEG[1] Tile_X0Y0_E2BEG[2] Tile_X0Y0_E2BEG[3] Tile_X0Y0_E2BEG[4] Tile_X0Y0_E2BEG[5]
+ Tile_X0Y0_E2BEG[6] Tile_X0Y0_E2BEG[7] Tile_X0Y0_E2BEGb[0] Tile_X0Y0_E2BEGb[1] Tile_X0Y0_E2BEGb[2]
+ Tile_X0Y0_E2BEGb[3] Tile_X0Y0_E2BEGb[4] Tile_X0Y0_E2BEGb[5] Tile_X0Y0_E2BEGb[6]
+ Tile_X0Y0_E2BEGb[7] Tile_X0Y0_E6BEG[0] Tile_X0Y0_E6BEG[10] Tile_X0Y0_E6BEG[11] Tile_X0Y0_E6BEG[1]
+ Tile_X0Y0_E6BEG[2] Tile_X0Y0_E6BEG[3] Tile_X0Y0_E6BEG[4] Tile_X0Y0_E6BEG[5] Tile_X0Y0_E6BEG[6]
+ Tile_X0Y0_E6BEG[7] Tile_X0Y0_E6BEG[8] Tile_X0Y0_E6BEG[9] Tile_X0Y0_EE4BEG[0] Tile_X0Y0_EE4BEG[10]
+ Tile_X0Y0_EE4BEG[11] Tile_X0Y0_EE4BEG[12] Tile_X0Y0_EE4BEG[13] Tile_X0Y0_EE4BEG[14]
+ Tile_X0Y0_EE4BEG[15] Tile_X0Y0_EE4BEG[1] Tile_X0Y0_EE4BEG[2] Tile_X0Y0_EE4BEG[3]
+ Tile_X0Y0_EE4BEG[4] Tile_X0Y0_EE4BEG[5] Tile_X0Y0_EE4BEG[6] Tile_X0Y0_EE4BEG[7]
+ Tile_X0Y0_EE4BEG[8] Tile_X0Y0_EE4BEG[9] Tile_X0Y0_FrameData[0] Tile_X0Y0_FrameData[10]
+ Tile_X0Y0_FrameData[11] Tile_X0Y0_FrameData[12] Tile_X0Y0_FrameData[13] Tile_X0Y0_FrameData[14]
+ Tile_X0Y0_FrameData[15] Tile_X0Y0_FrameData[16] Tile_X0Y0_FrameData[17] Tile_X0Y0_FrameData[18]
+ Tile_X0Y0_FrameData[19] Tile_X0Y0_FrameData[1] Tile_X0Y0_FrameData[20] Tile_X0Y0_FrameData[21]
+ Tile_X0Y0_FrameData[22] Tile_X0Y0_FrameData[23] Tile_X0Y0_FrameData[24] Tile_X0Y0_FrameData[25]
+ Tile_X0Y0_FrameData[26] Tile_X0Y0_FrameData[27] Tile_X0Y0_FrameData[28] Tile_X0Y0_FrameData[29]
+ Tile_X0Y0_FrameData[2] Tile_X0Y0_FrameData[30] Tile_X0Y0_FrameData[31] Tile_X0Y0_FrameData[3]
+ Tile_X0Y0_FrameData[4] Tile_X0Y0_FrameData[5] Tile_X0Y0_FrameData[6] Tile_X0Y0_FrameData[7]
+ Tile_X0Y0_FrameData[8] Tile_X0Y0_FrameData[9] Tile_X0Y0_FrameData_O[0] Tile_X0Y0_FrameData_O[10]
+ Tile_X0Y0_FrameData_O[11] Tile_X0Y0_FrameData_O[12] Tile_X0Y0_FrameData_O[13] Tile_X0Y0_FrameData_O[14]
+ Tile_X0Y0_FrameData_O[15] Tile_X0Y0_FrameData_O[16] Tile_X0Y0_FrameData_O[17] Tile_X0Y0_FrameData_O[18]
+ Tile_X0Y0_FrameData_O[19] Tile_X0Y0_FrameData_O[1] Tile_X0Y0_FrameData_O[20] Tile_X0Y0_FrameData_O[21]
+ Tile_X0Y0_FrameData_O[22] Tile_X0Y0_FrameData_O[23] Tile_X0Y0_FrameData_O[24] Tile_X0Y0_FrameData_O[25]
+ Tile_X0Y0_FrameData_O[26] Tile_X0Y0_FrameData_O[27] Tile_X0Y0_FrameData_O[28] Tile_X0Y0_FrameData_O[29]
+ Tile_X0Y0_FrameData_O[2] Tile_X0Y0_FrameData_O[30] Tile_X0Y0_FrameData_O[31] Tile_X0Y0_FrameData_O[3]
+ Tile_X0Y0_FrameData_O[4] Tile_X0Y0_FrameData_O[5] Tile_X0Y0_FrameData_O[6] Tile_X0Y0_FrameData_O[7]
+ Tile_X0Y0_FrameData_O[8] Tile_X0Y0_FrameData_O[9] Tile_X0Y0_FrameStrobe_O[0] Tile_X0Y0_FrameStrobe_O[10]
+ Tile_X0Y0_FrameStrobe_O[11] Tile_X0Y0_FrameStrobe_O[12] Tile_X0Y0_FrameStrobe_O[13]
+ Tile_X0Y0_FrameStrobe_O[14] Tile_X0Y0_FrameStrobe_O[15] Tile_X0Y0_FrameStrobe_O[16]
+ Tile_X0Y0_FrameStrobe_O[17] Tile_X0Y0_FrameStrobe_O[18] Tile_X0Y0_FrameStrobe_O[19]
+ Tile_X0Y0_FrameStrobe_O[1] Tile_X0Y0_FrameStrobe_O[2] Tile_X0Y0_FrameStrobe_O[3]
+ Tile_X0Y0_FrameStrobe_O[4] Tile_X0Y0_FrameStrobe_O[5] Tile_X0Y0_FrameStrobe_O[6]
+ Tile_X0Y0_FrameStrobe_O[7] Tile_X0Y0_FrameStrobe_O[8] Tile_X0Y0_FrameStrobe_O[9]
+ Tile_X0Y0_N1BEG[0] Tile_X0Y0_N1BEG[1] Tile_X0Y0_N1BEG[2] Tile_X0Y0_N1BEG[3] Tile_X0Y0_N2BEG[0]
+ Tile_X0Y0_N2BEG[1] Tile_X0Y0_N2BEG[2] Tile_X0Y0_N2BEG[3] Tile_X0Y0_N2BEG[4] Tile_X0Y0_N2BEG[5]
+ Tile_X0Y0_N2BEG[6] Tile_X0Y0_N2BEG[7] Tile_X0Y0_N2BEGb[0] Tile_X0Y0_N2BEGb[1] Tile_X0Y0_N2BEGb[2]
+ Tile_X0Y0_N2BEGb[3] Tile_X0Y0_N2BEGb[4] Tile_X0Y0_N2BEGb[5] Tile_X0Y0_N2BEGb[6]
+ Tile_X0Y0_N2BEGb[7] Tile_X0Y0_N4BEG[0] Tile_X0Y0_N4BEG[10] Tile_X0Y0_N4BEG[11] Tile_X0Y0_N4BEG[12]
+ Tile_X0Y0_N4BEG[13] Tile_X0Y0_N4BEG[14] Tile_X0Y0_N4BEG[15] Tile_X0Y0_N4BEG[1] Tile_X0Y0_N4BEG[2]
+ Tile_X0Y0_N4BEG[3] Tile_X0Y0_N4BEG[4] Tile_X0Y0_N4BEG[5] Tile_X0Y0_N4BEG[6] Tile_X0Y0_N4BEG[7]
+ Tile_X0Y0_N4BEG[8] Tile_X0Y0_N4BEG[9] Tile_X0Y0_S1END[0] Tile_X0Y0_S1END[1] Tile_X0Y0_S1END[2]
+ Tile_X0Y0_S1END[3] Tile_X0Y0_S2END[0] Tile_X0Y0_S2END[1] Tile_X0Y0_S2END[2] Tile_X0Y0_S2END[3]
+ Tile_X0Y0_S2END[4] Tile_X0Y0_S2END[5] Tile_X0Y0_S2END[6] Tile_X0Y0_S2END[7] Tile_X0Y0_S2MID[0]
+ Tile_X0Y0_S2MID[1] Tile_X0Y0_S2MID[2] Tile_X0Y0_S2MID[3] Tile_X0Y0_S2MID[4] Tile_X0Y0_S2MID[5]
+ Tile_X0Y0_S2MID[6] Tile_X0Y0_S2MID[7] Tile_X0Y0_S4END[0] Tile_X0Y0_S4END[10] Tile_X0Y0_S4END[11]
+ Tile_X0Y0_S4END[12] Tile_X0Y0_S4END[13] Tile_X0Y0_S4END[14] Tile_X0Y0_S4END[15]
+ Tile_X0Y0_S4END[1] Tile_X0Y0_S4END[2] Tile_X0Y0_S4END[3] Tile_X0Y0_S4END[4] Tile_X0Y0_S4END[5]
+ Tile_X0Y0_S4END[6] Tile_X0Y0_S4END[7] Tile_X0Y0_S4END[8] Tile_X0Y0_S4END[9] Tile_X0Y0_UserCLK
+ Tile_X0Y0_UserCLKo Tile_X0Y0_W1END[0] Tile_X0Y0_W1END[1] Tile_X0Y0_W1END[2] Tile_X0Y0_W1END[3]
+ Tile_X0Y0_W2END[0] Tile_X0Y0_W2END[1] Tile_X0Y0_W2END[2] Tile_X0Y0_W2END[3] Tile_X0Y0_W2END[4]
+ Tile_X0Y0_W2END[5] Tile_X0Y0_W2END[6] Tile_X0Y0_W2END[7] Tile_X0Y0_W2MID[0] Tile_X0Y0_W2MID[1]
+ Tile_X0Y0_W2MID[2] Tile_X0Y0_W2MID[3] Tile_X0Y0_W2MID[4] Tile_X0Y0_W2MID[5] Tile_X0Y0_W2MID[6]
+ Tile_X0Y0_W2MID[7] Tile_X0Y0_W6END[0] Tile_X0Y0_W6END[10] Tile_X0Y0_W6END[11] Tile_X0Y0_W6END[1]
+ Tile_X0Y0_W6END[2] Tile_X0Y0_W6END[3] Tile_X0Y0_W6END[4] Tile_X0Y0_W6END[5] Tile_X0Y0_W6END[6]
+ Tile_X0Y0_W6END[7] Tile_X0Y0_W6END[8] Tile_X0Y0_W6END[9] Tile_X0Y0_WW4END[0] Tile_X0Y0_WW4END[10]
+ Tile_X0Y0_WW4END[11] Tile_X0Y0_WW4END[12] Tile_X0Y0_WW4END[13] Tile_X0Y0_WW4END[14]
+ Tile_X0Y0_WW4END[15] Tile_X0Y0_WW4END[1] Tile_X0Y0_WW4END[2] Tile_X0Y0_WW4END[3]
+ Tile_X0Y0_WW4END[4] Tile_X0Y0_WW4END[5] Tile_X0Y0_WW4END[6] Tile_X0Y0_WW4END[7]
+ Tile_X0Y0_WW4END[8] Tile_X0Y0_WW4END[9] Tile_X0Y1_E1BEG[0] Tile_X0Y1_E1BEG[1] Tile_X0Y1_E1BEG[2]
+ Tile_X0Y1_E1BEG[3] Tile_X0Y1_E2BEG[0] Tile_X0Y1_E2BEG[1] Tile_X0Y1_E2BEG[2] Tile_X0Y1_E2BEG[3]
+ Tile_X0Y1_E2BEG[4] Tile_X0Y1_E2BEG[5] Tile_X0Y1_E2BEG[6] Tile_X0Y1_E2BEG[7] Tile_X0Y1_E2BEGb[0]
+ Tile_X0Y1_E2BEGb[1] Tile_X0Y1_E2BEGb[2] Tile_X0Y1_E2BEGb[3] Tile_X0Y1_E2BEGb[4]
+ Tile_X0Y1_E2BEGb[5] Tile_X0Y1_E2BEGb[6] Tile_X0Y1_E2BEGb[7] Tile_X0Y1_E6BEG[0] Tile_X0Y1_E6BEG[10]
+ Tile_X0Y1_E6BEG[11] Tile_X0Y1_E6BEG[1] Tile_X0Y1_E6BEG[2] Tile_X0Y1_E6BEG[3] Tile_X0Y1_E6BEG[4]
+ Tile_X0Y1_E6BEG[5] Tile_X0Y1_E6BEG[6] Tile_X0Y1_E6BEG[7] Tile_X0Y1_E6BEG[8] Tile_X0Y1_E6BEG[9]
+ Tile_X0Y1_EE4BEG[0] Tile_X0Y1_EE4BEG[10] Tile_X0Y1_EE4BEG[11] Tile_X0Y1_EE4BEG[12]
+ Tile_X0Y1_EE4BEG[13] Tile_X0Y1_EE4BEG[14] Tile_X0Y1_EE4BEG[15] Tile_X0Y1_EE4BEG[1]
+ Tile_X0Y1_EE4BEG[2] Tile_X0Y1_EE4BEG[3] Tile_X0Y1_EE4BEG[4] Tile_X0Y1_EE4BEG[5]
+ Tile_X0Y1_EE4BEG[6] Tile_X0Y1_EE4BEG[7] Tile_X0Y1_EE4BEG[8] Tile_X0Y1_EE4BEG[9]
+ Tile_X0Y1_FrameData[0] Tile_X0Y1_FrameData[10] Tile_X0Y1_FrameData[11] Tile_X0Y1_FrameData[12]
+ Tile_X0Y1_FrameData[13] Tile_X0Y1_FrameData[14] Tile_X0Y1_FrameData[15] Tile_X0Y1_FrameData[16]
+ Tile_X0Y1_FrameData[17] Tile_X0Y1_FrameData[18] Tile_X0Y1_FrameData[19] Tile_X0Y1_FrameData[1]
+ Tile_X0Y1_FrameData[20] Tile_X0Y1_FrameData[21] Tile_X0Y1_FrameData[22] Tile_X0Y1_FrameData[23]
+ Tile_X0Y1_FrameData[24] Tile_X0Y1_FrameData[25] Tile_X0Y1_FrameData[26] Tile_X0Y1_FrameData[27]
+ Tile_X0Y1_FrameData[28] Tile_X0Y1_FrameData[29] Tile_X0Y1_FrameData[2] Tile_X0Y1_FrameData[30]
+ Tile_X0Y1_FrameData[31] Tile_X0Y1_FrameData[3] Tile_X0Y1_FrameData[4] Tile_X0Y1_FrameData[5]
+ Tile_X0Y1_FrameData[6] Tile_X0Y1_FrameData[7] Tile_X0Y1_FrameData[8] Tile_X0Y1_FrameData[9]
+ Tile_X0Y1_FrameData_O[0] Tile_X0Y1_FrameData_O[10] Tile_X0Y1_FrameData_O[11] Tile_X0Y1_FrameData_O[12]
+ Tile_X0Y1_FrameData_O[13] Tile_X0Y1_FrameData_O[14] Tile_X0Y1_FrameData_O[15] Tile_X0Y1_FrameData_O[16]
+ Tile_X0Y1_FrameData_O[17] Tile_X0Y1_FrameData_O[18] Tile_X0Y1_FrameData_O[19] Tile_X0Y1_FrameData_O[1]
+ Tile_X0Y1_FrameData_O[20] Tile_X0Y1_FrameData_O[21] Tile_X0Y1_FrameData_O[22] Tile_X0Y1_FrameData_O[23]
+ Tile_X0Y1_FrameData_O[24] Tile_X0Y1_FrameData_O[25] Tile_X0Y1_FrameData_O[26] Tile_X0Y1_FrameData_O[27]
+ Tile_X0Y1_FrameData_O[28] Tile_X0Y1_FrameData_O[29] Tile_X0Y1_FrameData_O[2] Tile_X0Y1_FrameData_O[30]
+ Tile_X0Y1_FrameData_O[31] Tile_X0Y1_FrameData_O[3] Tile_X0Y1_FrameData_O[4] Tile_X0Y1_FrameData_O[5]
+ Tile_X0Y1_FrameData_O[6] Tile_X0Y1_FrameData_O[7] Tile_X0Y1_FrameData_O[8] Tile_X0Y1_FrameData_O[9]
+ Tile_X0Y1_UserCLK Tile_X0Y1_UserCLKo Tile_X0Y1_W1END[0] Tile_X0Y1_W1END[1] Tile_X0Y1_W1END[2]
+ Tile_X0Y1_W1END[3] Tile_X0Y1_W2END[0] Tile_X0Y1_W2END[1] Tile_X0Y1_W2END[2] Tile_X0Y1_W2END[3]
+ Tile_X0Y1_W2END[4] Tile_X0Y1_W2END[5] Tile_X0Y1_W2END[6] Tile_X0Y1_W2END[7] Tile_X0Y1_W2MID[0]
+ Tile_X0Y1_W2MID[1] Tile_X0Y1_W2MID[2] Tile_X0Y1_W2MID[3] Tile_X0Y1_W2MID[4] Tile_X0Y1_W2MID[5]
+ Tile_X0Y1_W2MID[6] Tile_X0Y1_W2MID[7] Tile_X0Y1_W6END[0] Tile_X0Y1_W6END[10] Tile_X0Y1_W6END[11]
+ Tile_X0Y1_W6END[1] Tile_X0Y1_W6END[2] Tile_X0Y1_W6END[3] Tile_X0Y1_W6END[4] Tile_X0Y1_W6END[5]
+ Tile_X0Y1_W6END[6] Tile_X0Y1_W6END[7] Tile_X0Y1_W6END[8] Tile_X0Y1_W6END[9] Tile_X0Y1_WW4END[0]
+ Tile_X0Y1_WW4END[10] Tile_X0Y1_WW4END[11] Tile_X0Y1_WW4END[12] Tile_X0Y1_WW4END[13]
+ Tile_X0Y1_WW4END[14] Tile_X0Y1_WW4END[15] Tile_X0Y1_WW4END[1] Tile_X0Y1_WW4END[2]
+ Tile_X0Y1_WW4END[3] Tile_X0Y1_WW4END[4] Tile_X0Y1_WW4END[5] Tile_X0Y1_WW4END[6]
+ Tile_X0Y1_WW4END[7] Tile_X0Y1_WW4END[8] Tile_X0Y1_WW4END[9] Tile_X0Y2_E1BEG[0] Tile_X0Y2_E1BEG[1]
+ Tile_X0Y2_E1BEG[2] Tile_X0Y2_E1BEG[3] Tile_X0Y2_E2BEG[0] Tile_X0Y2_E2BEG[1] Tile_X0Y2_E2BEG[2]
+ Tile_X0Y2_E2BEG[3] Tile_X0Y2_E2BEG[4] Tile_X0Y2_E2BEG[5] Tile_X0Y2_E2BEG[6] Tile_X0Y2_E2BEG[7]
+ Tile_X0Y2_E2BEGb[0] Tile_X0Y2_E2BEGb[1] Tile_X0Y2_E2BEGb[2] Tile_X0Y2_E2BEGb[3]
+ Tile_X0Y2_E2BEGb[4] Tile_X0Y2_E2BEGb[5] Tile_X0Y2_E2BEGb[6] Tile_X0Y2_E2BEGb[7]
+ Tile_X0Y2_E6BEG[0] Tile_X0Y2_E6BEG[10] Tile_X0Y2_E6BEG[11] Tile_X0Y2_E6BEG[1] Tile_X0Y2_E6BEG[2]
+ Tile_X0Y2_E6BEG[3] Tile_X0Y2_E6BEG[4] Tile_X0Y2_E6BEG[5] Tile_X0Y2_E6BEG[6] Tile_X0Y2_E6BEG[7]
+ Tile_X0Y2_E6BEG[8] Tile_X0Y2_E6BEG[9] Tile_X0Y2_EE4BEG[0] Tile_X0Y2_EE4BEG[10] Tile_X0Y2_EE4BEG[11]
+ Tile_X0Y2_EE4BEG[12] Tile_X0Y2_EE4BEG[13] Tile_X0Y2_EE4BEG[14] Tile_X0Y2_EE4BEG[15]
+ Tile_X0Y2_EE4BEG[1] Tile_X0Y2_EE4BEG[2] Tile_X0Y2_EE4BEG[3] Tile_X0Y2_EE4BEG[4]
+ Tile_X0Y2_EE4BEG[5] Tile_X0Y2_EE4BEG[6] Tile_X0Y2_EE4BEG[7] Tile_X0Y2_EE4BEG[8]
+ Tile_X0Y2_EE4BEG[9] Tile_X0Y2_FrameData[0] Tile_X0Y2_FrameData[10] Tile_X0Y2_FrameData[11]
+ Tile_X0Y2_FrameData[12] Tile_X0Y2_FrameData[13] Tile_X0Y2_FrameData[14] Tile_X0Y2_FrameData[15]
+ Tile_X0Y2_FrameData[16] Tile_X0Y2_FrameData[17] Tile_X0Y2_FrameData[18] Tile_X0Y2_FrameData[19]
+ Tile_X0Y2_FrameData[1] Tile_X0Y2_FrameData[20] Tile_X0Y2_FrameData[21] Tile_X0Y2_FrameData[22]
+ Tile_X0Y2_FrameData[23] Tile_X0Y2_FrameData[24] Tile_X0Y2_FrameData[25] Tile_X0Y2_FrameData[26]
+ Tile_X0Y2_FrameData[27] Tile_X0Y2_FrameData[28] Tile_X0Y2_FrameData[29] Tile_X0Y2_FrameData[2]
+ Tile_X0Y2_FrameData[30] Tile_X0Y2_FrameData[31] Tile_X0Y2_FrameData[3] Tile_X0Y2_FrameData[4]
+ Tile_X0Y2_FrameData[5] Tile_X0Y2_FrameData[6] Tile_X0Y2_FrameData[7] Tile_X0Y2_FrameData[8]
+ Tile_X0Y2_FrameData[9] Tile_X0Y2_FrameData_O[0] Tile_X0Y2_FrameData_O[10] Tile_X0Y2_FrameData_O[11]
+ Tile_X0Y2_FrameData_O[12] Tile_X0Y2_FrameData_O[13] Tile_X0Y2_FrameData_O[14] Tile_X0Y2_FrameData_O[15]
+ Tile_X0Y2_FrameData_O[16] Tile_X0Y2_FrameData_O[17] Tile_X0Y2_FrameData_O[18] Tile_X0Y2_FrameData_O[19]
+ Tile_X0Y2_FrameData_O[1] Tile_X0Y2_FrameData_O[20] Tile_X0Y2_FrameData_O[21] Tile_X0Y2_FrameData_O[22]
+ Tile_X0Y2_FrameData_O[23] Tile_X0Y2_FrameData_O[24] Tile_X0Y2_FrameData_O[25] Tile_X0Y2_FrameData_O[26]
+ Tile_X0Y2_FrameData_O[27] Tile_X0Y2_FrameData_O[28] Tile_X0Y2_FrameData_O[29] Tile_X0Y2_FrameData_O[2]
+ Tile_X0Y2_FrameData_O[30] Tile_X0Y2_FrameData_O[31] Tile_X0Y2_FrameData_O[3] Tile_X0Y2_FrameData_O[4]
+ Tile_X0Y2_FrameData_O[5] Tile_X0Y2_FrameData_O[6] Tile_X0Y2_FrameData_O[7] Tile_X0Y2_FrameData_O[8]
+ Tile_X0Y2_FrameData_O[9] Tile_X0Y2_UserCLK Tile_X0Y2_UserCLKo Tile_X0Y2_W1END[0]
+ Tile_X0Y2_W1END[1] Tile_X0Y2_W1END[2] Tile_X0Y2_W1END[3] Tile_X0Y2_W2END[0] Tile_X0Y2_W2END[1]
+ Tile_X0Y2_W2END[2] Tile_X0Y2_W2END[3] Tile_X0Y2_W2END[4] Tile_X0Y2_W2END[5] Tile_X0Y2_W2END[6]
+ Tile_X0Y2_W2END[7] Tile_X0Y2_W2MID[0] Tile_X0Y2_W2MID[1] Tile_X0Y2_W2MID[2] Tile_X0Y2_W2MID[3]
+ Tile_X0Y2_W2MID[4] Tile_X0Y2_W2MID[5] Tile_X0Y2_W2MID[6] Tile_X0Y2_W2MID[7] Tile_X0Y2_W6END[0]
+ Tile_X0Y2_W6END[10] Tile_X0Y2_W6END[11] Tile_X0Y2_W6END[1] Tile_X0Y2_W6END[2] Tile_X0Y2_W6END[3]
+ Tile_X0Y2_W6END[4] Tile_X0Y2_W6END[5] Tile_X0Y2_W6END[6] Tile_X0Y2_W6END[7] Tile_X0Y2_W6END[8]
+ Tile_X0Y2_W6END[9] Tile_X0Y2_WW4END[0] Tile_X0Y2_WW4END[10] Tile_X0Y2_WW4END[11]
+ Tile_X0Y2_WW4END[12] Tile_X0Y2_WW4END[13] Tile_X0Y2_WW4END[14] Tile_X0Y2_WW4END[15]
+ Tile_X0Y2_WW4END[1] Tile_X0Y2_WW4END[2] Tile_X0Y2_WW4END[3] Tile_X0Y2_WW4END[4]
+ Tile_X0Y2_WW4END[5] Tile_X0Y2_WW4END[6] Tile_X0Y2_WW4END[7] Tile_X0Y2_WW4END[8]
+ Tile_X0Y2_WW4END[9] Tile_X0Y3_E1BEG[0] Tile_X0Y3_E1BEG[1] Tile_X0Y3_E1BEG[2] Tile_X0Y3_E1BEG[3]
+ Tile_X0Y3_E2BEG[0] Tile_X0Y3_E2BEG[1] Tile_X0Y3_E2BEG[2] Tile_X0Y3_E2BEG[3] Tile_X0Y3_E2BEG[4]
+ Tile_X0Y3_E2BEG[5] Tile_X0Y3_E2BEG[6] Tile_X0Y3_E2BEG[7] Tile_X0Y3_E2BEGb[0] Tile_X0Y3_E2BEGb[1]
+ Tile_X0Y3_E2BEGb[2] Tile_X0Y3_E2BEGb[3] Tile_X0Y3_E2BEGb[4] Tile_X0Y3_E2BEGb[5]
+ Tile_X0Y3_E2BEGb[6] Tile_X0Y3_E2BEGb[7] Tile_X0Y3_E6BEG[0] Tile_X0Y3_E6BEG[10] Tile_X0Y3_E6BEG[11]
+ Tile_X0Y3_E6BEG[1] Tile_X0Y3_E6BEG[2] Tile_X0Y3_E6BEG[3] Tile_X0Y3_E6BEG[4] Tile_X0Y3_E6BEG[5]
+ Tile_X0Y3_E6BEG[6] Tile_X0Y3_E6BEG[7] Tile_X0Y3_E6BEG[8] Tile_X0Y3_E6BEG[9] Tile_X0Y3_EE4BEG[0]
+ Tile_X0Y3_EE4BEG[10] Tile_X0Y3_EE4BEG[11] Tile_X0Y3_EE4BEG[12] Tile_X0Y3_EE4BEG[13]
+ Tile_X0Y3_EE4BEG[14] Tile_X0Y3_EE4BEG[15] Tile_X0Y3_EE4BEG[1] Tile_X0Y3_EE4BEG[2]
+ Tile_X0Y3_EE4BEG[3] Tile_X0Y3_EE4BEG[4] Tile_X0Y3_EE4BEG[5] Tile_X0Y3_EE4BEG[6]
+ Tile_X0Y3_EE4BEG[7] Tile_X0Y3_EE4BEG[8] Tile_X0Y3_EE4BEG[9] Tile_X0Y3_FrameData[0]
+ Tile_X0Y3_FrameData[10] Tile_X0Y3_FrameData[11] Tile_X0Y3_FrameData[12] Tile_X0Y3_FrameData[13]
+ Tile_X0Y3_FrameData[14] Tile_X0Y3_FrameData[15] Tile_X0Y3_FrameData[16] Tile_X0Y3_FrameData[17]
+ Tile_X0Y3_FrameData[18] Tile_X0Y3_FrameData[19] Tile_X0Y3_FrameData[1] Tile_X0Y3_FrameData[20]
+ Tile_X0Y3_FrameData[21] Tile_X0Y3_FrameData[22] Tile_X0Y3_FrameData[23] Tile_X0Y3_FrameData[24]
+ Tile_X0Y3_FrameData[25] Tile_X0Y3_FrameData[26] Tile_X0Y3_FrameData[27] Tile_X0Y3_FrameData[28]
+ Tile_X0Y3_FrameData[29] Tile_X0Y3_FrameData[2] Tile_X0Y3_FrameData[30] Tile_X0Y3_FrameData[31]
+ Tile_X0Y3_FrameData[3] Tile_X0Y3_FrameData[4] Tile_X0Y3_FrameData[5] Tile_X0Y3_FrameData[6]
+ Tile_X0Y3_FrameData[7] Tile_X0Y3_FrameData[8] Tile_X0Y3_FrameData[9] Tile_X0Y3_FrameData_O[0]
+ Tile_X0Y3_FrameData_O[10] Tile_X0Y3_FrameData_O[11] Tile_X0Y3_FrameData_O[12] Tile_X0Y3_FrameData_O[13]
+ Tile_X0Y3_FrameData_O[14] Tile_X0Y3_FrameData_O[15] Tile_X0Y3_FrameData_O[16] Tile_X0Y3_FrameData_O[17]
+ Tile_X0Y3_FrameData_O[18] Tile_X0Y3_FrameData_O[19] Tile_X0Y3_FrameData_O[1] Tile_X0Y3_FrameData_O[20]
+ Tile_X0Y3_FrameData_O[21] Tile_X0Y3_FrameData_O[22] Tile_X0Y3_FrameData_O[23] Tile_X0Y3_FrameData_O[24]
+ Tile_X0Y3_FrameData_O[25] Tile_X0Y3_FrameData_O[26] Tile_X0Y3_FrameData_O[27] Tile_X0Y3_FrameData_O[28]
+ Tile_X0Y3_FrameData_O[29] Tile_X0Y3_FrameData_O[2] Tile_X0Y3_FrameData_O[30] Tile_X0Y3_FrameData_O[31]
+ Tile_X0Y3_FrameData_O[3] Tile_X0Y3_FrameData_O[4] Tile_X0Y3_FrameData_O[5] Tile_X0Y3_FrameData_O[6]
+ Tile_X0Y3_FrameData_O[7] Tile_X0Y3_FrameData_O[8] Tile_X0Y3_FrameData_O[9] Tile_X0Y3_UserCLK
+ Tile_X0Y3_UserCLKo Tile_X0Y3_W1END[0] Tile_X0Y3_W1END[1] Tile_X0Y3_W1END[2] Tile_X0Y3_W1END[3]
+ Tile_X0Y3_W2END[0] Tile_X0Y3_W2END[1] Tile_X0Y3_W2END[2] Tile_X0Y3_W2END[3] Tile_X0Y3_W2END[4]
+ Tile_X0Y3_W2END[5] Tile_X0Y3_W2END[6] Tile_X0Y3_W2END[7] Tile_X0Y3_W2MID[0] Tile_X0Y3_W2MID[1]
+ Tile_X0Y3_W2MID[2] Tile_X0Y3_W2MID[3] Tile_X0Y3_W2MID[4] Tile_X0Y3_W2MID[5] Tile_X0Y3_W2MID[6]
+ Tile_X0Y3_W2MID[7] Tile_X0Y3_W6END[0] Tile_X0Y3_W6END[10] Tile_X0Y3_W6END[11] Tile_X0Y3_W6END[1]
+ Tile_X0Y3_W6END[2] Tile_X0Y3_W6END[3] Tile_X0Y3_W6END[4] Tile_X0Y3_W6END[5] Tile_X0Y3_W6END[6]
+ Tile_X0Y3_W6END[7] Tile_X0Y3_W6END[8] Tile_X0Y3_W6END[9] Tile_X0Y3_WW4END[0] Tile_X0Y3_WW4END[10]
+ Tile_X0Y3_WW4END[11] Tile_X0Y3_WW4END[12] Tile_X0Y3_WW4END[13] Tile_X0Y3_WW4END[14]
+ Tile_X0Y3_WW4END[15] Tile_X0Y3_WW4END[1] Tile_X0Y3_WW4END[2] Tile_X0Y3_WW4END[3]
+ Tile_X0Y3_WW4END[4] Tile_X0Y3_WW4END[5] Tile_X0Y3_WW4END[6] Tile_X0Y3_WW4END[7]
+ Tile_X0Y3_WW4END[8] Tile_X0Y3_WW4END[9] Tile_X0Y4_E1BEG[0] Tile_X0Y4_E1BEG[1] Tile_X0Y4_E1BEG[2]
+ Tile_X0Y4_E1BEG[3] Tile_X0Y4_E2BEG[0] Tile_X0Y4_E2BEG[1] Tile_X0Y4_E2BEG[2] Tile_X0Y4_E2BEG[3]
+ Tile_X0Y4_E2BEG[4] Tile_X0Y4_E2BEG[5] Tile_X0Y4_E2BEG[6] Tile_X0Y4_E2BEG[7] Tile_X0Y4_E2BEGb[0]
+ Tile_X0Y4_E2BEGb[1] Tile_X0Y4_E2BEGb[2] Tile_X0Y4_E2BEGb[3] Tile_X0Y4_E2BEGb[4]
+ Tile_X0Y4_E2BEGb[5] Tile_X0Y4_E2BEGb[6] Tile_X0Y4_E2BEGb[7] Tile_X0Y4_E6BEG[0] Tile_X0Y4_E6BEG[10]
+ Tile_X0Y4_E6BEG[11] Tile_X0Y4_E6BEG[1] Tile_X0Y4_E6BEG[2] Tile_X0Y4_E6BEG[3] Tile_X0Y4_E6BEG[4]
+ Tile_X0Y4_E6BEG[5] Tile_X0Y4_E6BEG[6] Tile_X0Y4_E6BEG[7] Tile_X0Y4_E6BEG[8] Tile_X0Y4_E6BEG[9]
+ Tile_X0Y4_EE4BEG[0] Tile_X0Y4_EE4BEG[10] Tile_X0Y4_EE4BEG[11] Tile_X0Y4_EE4BEG[12]
+ Tile_X0Y4_EE4BEG[13] Tile_X0Y4_EE4BEG[14] Tile_X0Y4_EE4BEG[15] Tile_X0Y4_EE4BEG[1]
+ Tile_X0Y4_EE4BEG[2] Tile_X0Y4_EE4BEG[3] Tile_X0Y4_EE4BEG[4] Tile_X0Y4_EE4BEG[5]
+ Tile_X0Y4_EE4BEG[6] Tile_X0Y4_EE4BEG[7] Tile_X0Y4_EE4BEG[8] Tile_X0Y4_EE4BEG[9]
+ Tile_X0Y4_FrameData[0] Tile_X0Y4_FrameData[10] Tile_X0Y4_FrameData[11] Tile_X0Y4_FrameData[12]
+ Tile_X0Y4_FrameData[13] Tile_X0Y4_FrameData[14] Tile_X0Y4_FrameData[15] Tile_X0Y4_FrameData[16]
+ Tile_X0Y4_FrameData[17] Tile_X0Y4_FrameData[18] Tile_X0Y4_FrameData[19] Tile_X0Y4_FrameData[1]
+ Tile_X0Y4_FrameData[20] Tile_X0Y4_FrameData[21] Tile_X0Y4_FrameData[22] Tile_X0Y4_FrameData[23]
+ Tile_X0Y4_FrameData[24] Tile_X0Y4_FrameData[25] Tile_X0Y4_FrameData[26] Tile_X0Y4_FrameData[27]
+ Tile_X0Y4_FrameData[28] Tile_X0Y4_FrameData[29] Tile_X0Y4_FrameData[2] Tile_X0Y4_FrameData[30]
+ Tile_X0Y4_FrameData[31] Tile_X0Y4_FrameData[3] Tile_X0Y4_FrameData[4] Tile_X0Y4_FrameData[5]
+ Tile_X0Y4_FrameData[6] Tile_X0Y4_FrameData[7] Tile_X0Y4_FrameData[8] Tile_X0Y4_FrameData[9]
+ Tile_X0Y4_FrameData_O[0] Tile_X0Y4_FrameData_O[10] Tile_X0Y4_FrameData_O[11] Tile_X0Y4_FrameData_O[12]
+ Tile_X0Y4_FrameData_O[13] Tile_X0Y4_FrameData_O[14] Tile_X0Y4_FrameData_O[15] Tile_X0Y4_FrameData_O[16]
+ Tile_X0Y4_FrameData_O[17] Tile_X0Y4_FrameData_O[18] Tile_X0Y4_FrameData_O[19] Tile_X0Y4_FrameData_O[1]
+ Tile_X0Y4_FrameData_O[20] Tile_X0Y4_FrameData_O[21] Tile_X0Y4_FrameData_O[22] Tile_X0Y4_FrameData_O[23]
+ Tile_X0Y4_FrameData_O[24] Tile_X0Y4_FrameData_O[25] Tile_X0Y4_FrameData_O[26] Tile_X0Y4_FrameData_O[27]
+ Tile_X0Y4_FrameData_O[28] Tile_X0Y4_FrameData_O[29] Tile_X0Y4_FrameData_O[2] Tile_X0Y4_FrameData_O[30]
+ Tile_X0Y4_FrameData_O[31] Tile_X0Y4_FrameData_O[3] Tile_X0Y4_FrameData_O[4] Tile_X0Y4_FrameData_O[5]
+ Tile_X0Y4_FrameData_O[6] Tile_X0Y4_FrameData_O[7] Tile_X0Y4_FrameData_O[8] Tile_X0Y4_FrameData_O[9]
+ Tile_X0Y4_UserCLK Tile_X0Y4_UserCLKo Tile_X0Y4_W1END[0] Tile_X0Y4_W1END[1] Tile_X0Y4_W1END[2]
+ Tile_X0Y4_W1END[3] Tile_X0Y4_W2END[0] Tile_X0Y4_W2END[1] Tile_X0Y4_W2END[2] Tile_X0Y4_W2END[3]
+ Tile_X0Y4_W2END[4] Tile_X0Y4_W2END[5] Tile_X0Y4_W2END[6] Tile_X0Y4_W2END[7] Tile_X0Y4_W2MID[0]
+ Tile_X0Y4_W2MID[1] Tile_X0Y4_W2MID[2] Tile_X0Y4_W2MID[3] Tile_X0Y4_W2MID[4] Tile_X0Y4_W2MID[5]
+ Tile_X0Y4_W2MID[6] Tile_X0Y4_W2MID[7] Tile_X0Y4_W6END[0] Tile_X0Y4_W6END[10] Tile_X0Y4_W6END[11]
+ Tile_X0Y4_W6END[1] Tile_X0Y4_W6END[2] Tile_X0Y4_W6END[3] Tile_X0Y4_W6END[4] Tile_X0Y4_W6END[5]
+ Tile_X0Y4_W6END[6] Tile_X0Y4_W6END[7] Tile_X0Y4_W6END[8] Tile_X0Y4_W6END[9] Tile_X0Y4_WW4END[0]
+ Tile_X0Y4_WW4END[10] Tile_X0Y4_WW4END[11] Tile_X0Y4_WW4END[12] Tile_X0Y4_WW4END[13]
+ Tile_X0Y4_WW4END[14] Tile_X0Y4_WW4END[15] Tile_X0Y4_WW4END[1] Tile_X0Y4_WW4END[2]
+ Tile_X0Y4_WW4END[3] Tile_X0Y4_WW4END[4] Tile_X0Y4_WW4END[5] Tile_X0Y4_WW4END[6]
+ Tile_X0Y4_WW4END[7] Tile_X0Y4_WW4END[8] Tile_X0Y4_WW4END[9] Tile_X0Y5_E1BEG[0] Tile_X0Y5_E1BEG[1]
+ Tile_X0Y5_E1BEG[2] Tile_X0Y5_E1BEG[3] Tile_X0Y5_E2BEG[0] Tile_X0Y5_E2BEG[1] Tile_X0Y5_E2BEG[2]
+ Tile_X0Y5_E2BEG[3] Tile_X0Y5_E2BEG[4] Tile_X0Y5_E2BEG[5] Tile_X0Y5_E2BEG[6] Tile_X0Y5_E2BEG[7]
+ Tile_X0Y5_E2BEGb[0] Tile_X0Y5_E2BEGb[1] Tile_X0Y5_E2BEGb[2] Tile_X0Y5_E2BEGb[3]
+ Tile_X0Y5_E2BEGb[4] Tile_X0Y5_E2BEGb[5] Tile_X0Y5_E2BEGb[6] Tile_X0Y5_E2BEGb[7]
+ Tile_X0Y5_E6BEG[0] Tile_X0Y5_E6BEG[10] Tile_X0Y5_E6BEG[11] Tile_X0Y5_E6BEG[1] Tile_X0Y5_E6BEG[2]
+ Tile_X0Y5_E6BEG[3] Tile_X0Y5_E6BEG[4] Tile_X0Y5_E6BEG[5] Tile_X0Y5_E6BEG[6] Tile_X0Y5_E6BEG[7]
+ Tile_X0Y5_E6BEG[8] Tile_X0Y5_E6BEG[9] Tile_X0Y5_EE4BEG[0] Tile_X0Y5_EE4BEG[10] Tile_X0Y5_EE4BEG[11]
+ Tile_X0Y5_EE4BEG[12] Tile_X0Y5_EE4BEG[13] Tile_X0Y5_EE4BEG[14] Tile_X0Y5_EE4BEG[15]
+ Tile_X0Y5_EE4BEG[1] Tile_X0Y5_EE4BEG[2] Tile_X0Y5_EE4BEG[3] Tile_X0Y5_EE4BEG[4]
+ Tile_X0Y5_EE4BEG[5] Tile_X0Y5_EE4BEG[6] Tile_X0Y5_EE4BEG[7] Tile_X0Y5_EE4BEG[8]
+ Tile_X0Y5_EE4BEG[9] Tile_X0Y5_FrameData[0] Tile_X0Y5_FrameData[10] Tile_X0Y5_FrameData[11]
+ Tile_X0Y5_FrameData[12] Tile_X0Y5_FrameData[13] Tile_X0Y5_FrameData[14] Tile_X0Y5_FrameData[15]
+ Tile_X0Y5_FrameData[16] Tile_X0Y5_FrameData[17] Tile_X0Y5_FrameData[18] Tile_X0Y5_FrameData[19]
+ Tile_X0Y5_FrameData[1] Tile_X0Y5_FrameData[20] Tile_X0Y5_FrameData[21] Tile_X0Y5_FrameData[22]
+ Tile_X0Y5_FrameData[23] Tile_X0Y5_FrameData[24] Tile_X0Y5_FrameData[25] Tile_X0Y5_FrameData[26]
+ Tile_X0Y5_FrameData[27] Tile_X0Y5_FrameData[28] Tile_X0Y5_FrameData[29] Tile_X0Y5_FrameData[2]
+ Tile_X0Y5_FrameData[30] Tile_X0Y5_FrameData[31] Tile_X0Y5_FrameData[3] Tile_X0Y5_FrameData[4]
+ Tile_X0Y5_FrameData[5] Tile_X0Y5_FrameData[6] Tile_X0Y5_FrameData[7] Tile_X0Y5_FrameData[8]
+ Tile_X0Y5_FrameData[9] Tile_X0Y5_FrameData_O[0] Tile_X0Y5_FrameData_O[10] Tile_X0Y5_FrameData_O[11]
+ Tile_X0Y5_FrameData_O[12] Tile_X0Y5_FrameData_O[13] Tile_X0Y5_FrameData_O[14] Tile_X0Y5_FrameData_O[15]
+ Tile_X0Y5_FrameData_O[16] Tile_X0Y5_FrameData_O[17] Tile_X0Y5_FrameData_O[18] Tile_X0Y5_FrameData_O[19]
+ Tile_X0Y5_FrameData_O[1] Tile_X0Y5_FrameData_O[20] Tile_X0Y5_FrameData_O[21] Tile_X0Y5_FrameData_O[22]
+ Tile_X0Y5_FrameData_O[23] Tile_X0Y5_FrameData_O[24] Tile_X0Y5_FrameData_O[25] Tile_X0Y5_FrameData_O[26]
+ Tile_X0Y5_FrameData_O[27] Tile_X0Y5_FrameData_O[28] Tile_X0Y5_FrameData_O[29] Tile_X0Y5_FrameData_O[2]
+ Tile_X0Y5_FrameData_O[30] Tile_X0Y5_FrameData_O[31] Tile_X0Y5_FrameData_O[3] Tile_X0Y5_FrameData_O[4]
+ Tile_X0Y5_FrameData_O[5] Tile_X0Y5_FrameData_O[6] Tile_X0Y5_FrameData_O[7] Tile_X0Y5_FrameData_O[8]
+ Tile_X0Y5_FrameData_O[9] Tile_X0Y5_UserCLK Tile_X0Y5_UserCLKo Tile_X0Y5_W1END[0]
+ Tile_X0Y5_W1END[1] Tile_X0Y5_W1END[2] Tile_X0Y5_W1END[3] Tile_X0Y5_W2END[0] Tile_X0Y5_W2END[1]
+ Tile_X0Y5_W2END[2] Tile_X0Y5_W2END[3] Tile_X0Y5_W2END[4] Tile_X0Y5_W2END[5] Tile_X0Y5_W2END[6]
+ Tile_X0Y5_W2END[7] Tile_X0Y5_W2MID[0] Tile_X0Y5_W2MID[1] Tile_X0Y5_W2MID[2] Tile_X0Y5_W2MID[3]
+ Tile_X0Y5_W2MID[4] Tile_X0Y5_W2MID[5] Tile_X0Y5_W2MID[6] Tile_X0Y5_W2MID[7] Tile_X0Y5_W6END[0]
+ Tile_X0Y5_W6END[10] Tile_X0Y5_W6END[11] Tile_X0Y5_W6END[1] Tile_X0Y5_W6END[2] Tile_X0Y5_W6END[3]
+ Tile_X0Y5_W6END[4] Tile_X0Y5_W6END[5] Tile_X0Y5_W6END[6] Tile_X0Y5_W6END[7] Tile_X0Y5_W6END[8]
+ Tile_X0Y5_W6END[9] Tile_X0Y5_WW4END[0] Tile_X0Y5_WW4END[10] Tile_X0Y5_WW4END[11]
+ Tile_X0Y5_WW4END[12] Tile_X0Y5_WW4END[13] Tile_X0Y5_WW4END[14] Tile_X0Y5_WW4END[15]
+ Tile_X0Y5_WW4END[1] Tile_X0Y5_WW4END[2] Tile_X0Y5_WW4END[3] Tile_X0Y5_WW4END[4]
+ Tile_X0Y5_WW4END[5] Tile_X0Y5_WW4END[6] Tile_X0Y5_WW4END[7] Tile_X0Y5_WW4END[8]
+ Tile_X0Y5_WW4END[9] Tile_X0Y6_E1BEG[0] Tile_X0Y6_E1BEG[1] Tile_X0Y6_E1BEG[2] Tile_X0Y6_E1BEG[3]
+ Tile_X0Y6_E2BEG[0] Tile_X0Y6_E2BEG[1] Tile_X0Y6_E2BEG[2] Tile_X0Y6_E2BEG[3] Tile_X0Y6_E2BEG[4]
+ Tile_X0Y6_E2BEG[5] Tile_X0Y6_E2BEG[6] Tile_X0Y6_E2BEG[7] Tile_X0Y6_E2BEGb[0] Tile_X0Y6_E2BEGb[1]
+ Tile_X0Y6_E2BEGb[2] Tile_X0Y6_E2BEGb[3] Tile_X0Y6_E2BEGb[4] Tile_X0Y6_E2BEGb[5]
+ Tile_X0Y6_E2BEGb[6] Tile_X0Y6_E2BEGb[7] Tile_X0Y6_E6BEG[0] Tile_X0Y6_E6BEG[10] Tile_X0Y6_E6BEG[11]
+ Tile_X0Y6_E6BEG[1] Tile_X0Y6_E6BEG[2] Tile_X0Y6_E6BEG[3] Tile_X0Y6_E6BEG[4] Tile_X0Y6_E6BEG[5]
+ Tile_X0Y6_E6BEG[6] Tile_X0Y6_E6BEG[7] Tile_X0Y6_E6BEG[8] Tile_X0Y6_E6BEG[9] Tile_X0Y6_EE4BEG[0]
+ Tile_X0Y6_EE4BEG[10] Tile_X0Y6_EE4BEG[11] Tile_X0Y6_EE4BEG[12] Tile_X0Y6_EE4BEG[13]
+ Tile_X0Y6_EE4BEG[14] Tile_X0Y6_EE4BEG[15] Tile_X0Y6_EE4BEG[1] Tile_X0Y6_EE4BEG[2]
+ Tile_X0Y6_EE4BEG[3] Tile_X0Y6_EE4BEG[4] Tile_X0Y6_EE4BEG[5] Tile_X0Y6_EE4BEG[6]
+ Tile_X0Y6_EE4BEG[7] Tile_X0Y6_EE4BEG[8] Tile_X0Y6_EE4BEG[9] Tile_X0Y6_FrameData[0]
+ Tile_X0Y6_FrameData[10] Tile_X0Y6_FrameData[11] Tile_X0Y6_FrameData[12] Tile_X0Y6_FrameData[13]
+ Tile_X0Y6_FrameData[14] Tile_X0Y6_FrameData[15] Tile_X0Y6_FrameData[16] Tile_X0Y6_FrameData[17]
+ Tile_X0Y6_FrameData[18] Tile_X0Y6_FrameData[19] Tile_X0Y6_FrameData[1] Tile_X0Y6_FrameData[20]
+ Tile_X0Y6_FrameData[21] Tile_X0Y6_FrameData[22] Tile_X0Y6_FrameData[23] Tile_X0Y6_FrameData[24]
+ Tile_X0Y6_FrameData[25] Tile_X0Y6_FrameData[26] Tile_X0Y6_FrameData[27] Tile_X0Y6_FrameData[28]
+ Tile_X0Y6_FrameData[29] Tile_X0Y6_FrameData[2] Tile_X0Y6_FrameData[30] Tile_X0Y6_FrameData[31]
+ Tile_X0Y6_FrameData[3] Tile_X0Y6_FrameData[4] Tile_X0Y6_FrameData[5] Tile_X0Y6_FrameData[6]
+ Tile_X0Y6_FrameData[7] Tile_X0Y6_FrameData[8] Tile_X0Y6_FrameData[9] Tile_X0Y6_FrameData_O[0]
+ Tile_X0Y6_FrameData_O[10] Tile_X0Y6_FrameData_O[11] Tile_X0Y6_FrameData_O[12] Tile_X0Y6_FrameData_O[13]
+ Tile_X0Y6_FrameData_O[14] Tile_X0Y6_FrameData_O[15] Tile_X0Y6_FrameData_O[16] Tile_X0Y6_FrameData_O[17]
+ Tile_X0Y6_FrameData_O[18] Tile_X0Y6_FrameData_O[19] Tile_X0Y6_FrameData_O[1] Tile_X0Y6_FrameData_O[20]
+ Tile_X0Y6_FrameData_O[21] Tile_X0Y6_FrameData_O[22] Tile_X0Y6_FrameData_O[23] Tile_X0Y6_FrameData_O[24]
+ Tile_X0Y6_FrameData_O[25] Tile_X0Y6_FrameData_O[26] Tile_X0Y6_FrameData_O[27] Tile_X0Y6_FrameData_O[28]
+ Tile_X0Y6_FrameData_O[29] Tile_X0Y6_FrameData_O[2] Tile_X0Y6_FrameData_O[30] Tile_X0Y6_FrameData_O[31]
+ Tile_X0Y6_FrameData_O[3] Tile_X0Y6_FrameData_O[4] Tile_X0Y6_FrameData_O[5] Tile_X0Y6_FrameData_O[6]
+ Tile_X0Y6_FrameData_O[7] Tile_X0Y6_FrameData_O[8] Tile_X0Y6_FrameData_O[9] Tile_X0Y6_UserCLK
+ Tile_X0Y6_UserCLKo Tile_X0Y6_W1END[0] Tile_X0Y6_W1END[1] Tile_X0Y6_W1END[2] Tile_X0Y6_W1END[3]
+ Tile_X0Y6_W2END[0] Tile_X0Y6_W2END[1] Tile_X0Y6_W2END[2] Tile_X0Y6_W2END[3] Tile_X0Y6_W2END[4]
+ Tile_X0Y6_W2END[5] Tile_X0Y6_W2END[6] Tile_X0Y6_W2END[7] Tile_X0Y6_W2MID[0] Tile_X0Y6_W2MID[1]
+ Tile_X0Y6_W2MID[2] Tile_X0Y6_W2MID[3] Tile_X0Y6_W2MID[4] Tile_X0Y6_W2MID[5] Tile_X0Y6_W2MID[6]
+ Tile_X0Y6_W2MID[7] Tile_X0Y6_W6END[0] Tile_X0Y6_W6END[10] Tile_X0Y6_W6END[11] Tile_X0Y6_W6END[1]
+ Tile_X0Y6_W6END[2] Tile_X0Y6_W6END[3] Tile_X0Y6_W6END[4] Tile_X0Y6_W6END[5] Tile_X0Y6_W6END[6]
+ Tile_X0Y6_W6END[7] Tile_X0Y6_W6END[8] Tile_X0Y6_W6END[9] Tile_X0Y6_WW4END[0] Tile_X0Y6_WW4END[10]
+ Tile_X0Y6_WW4END[11] Tile_X0Y6_WW4END[12] Tile_X0Y6_WW4END[13] Tile_X0Y6_WW4END[14]
+ Tile_X0Y6_WW4END[15] Tile_X0Y6_WW4END[1] Tile_X0Y6_WW4END[2] Tile_X0Y6_WW4END[3]
+ Tile_X0Y6_WW4END[4] Tile_X0Y6_WW4END[5] Tile_X0Y6_WW4END[6] Tile_X0Y6_WW4END[7]
+ Tile_X0Y6_WW4END[8] Tile_X0Y6_WW4END[9] Tile_X0Y7_E1BEG[0] Tile_X0Y7_E1BEG[1] Tile_X0Y7_E1BEG[2]
+ Tile_X0Y7_E1BEG[3] Tile_X0Y7_E2BEG[0] Tile_X0Y7_E2BEG[1] Tile_X0Y7_E2BEG[2] Tile_X0Y7_E2BEG[3]
+ Tile_X0Y7_E2BEG[4] Tile_X0Y7_E2BEG[5] Tile_X0Y7_E2BEG[6] Tile_X0Y7_E2BEG[7] Tile_X0Y7_E2BEGb[0]
+ Tile_X0Y7_E2BEGb[1] Tile_X0Y7_E2BEGb[2] Tile_X0Y7_E2BEGb[3] Tile_X0Y7_E2BEGb[4]
+ Tile_X0Y7_E2BEGb[5] Tile_X0Y7_E2BEGb[6] Tile_X0Y7_E2BEGb[7] Tile_X0Y7_E6BEG[0] Tile_X0Y7_E6BEG[10]
+ Tile_X0Y7_E6BEG[11] Tile_X0Y7_E6BEG[1] Tile_X0Y7_E6BEG[2] Tile_X0Y7_E6BEG[3] Tile_X0Y7_E6BEG[4]
+ Tile_X0Y7_E6BEG[5] Tile_X0Y7_E6BEG[6] Tile_X0Y7_E6BEG[7] Tile_X0Y7_E6BEG[8] Tile_X0Y7_E6BEG[9]
+ Tile_X0Y7_EE4BEG[0] Tile_X0Y7_EE4BEG[10] Tile_X0Y7_EE4BEG[11] Tile_X0Y7_EE4BEG[12]
+ Tile_X0Y7_EE4BEG[13] Tile_X0Y7_EE4BEG[14] Tile_X0Y7_EE4BEG[15] Tile_X0Y7_EE4BEG[1]
+ Tile_X0Y7_EE4BEG[2] Tile_X0Y7_EE4BEG[3] Tile_X0Y7_EE4BEG[4] Tile_X0Y7_EE4BEG[5]
+ Tile_X0Y7_EE4BEG[6] Tile_X0Y7_EE4BEG[7] Tile_X0Y7_EE4BEG[8] Tile_X0Y7_EE4BEG[9]
+ Tile_X0Y7_FrameData[0] Tile_X0Y7_FrameData[10] Tile_X0Y7_FrameData[11] Tile_X0Y7_FrameData[12]
+ Tile_X0Y7_FrameData[13] Tile_X0Y7_FrameData[14] Tile_X0Y7_FrameData[15] Tile_X0Y7_FrameData[16]
+ Tile_X0Y7_FrameData[17] Tile_X0Y7_FrameData[18] Tile_X0Y7_FrameData[19] Tile_X0Y7_FrameData[1]
+ Tile_X0Y7_FrameData[20] Tile_X0Y7_FrameData[21] Tile_X0Y7_FrameData[22] Tile_X0Y7_FrameData[23]
+ Tile_X0Y7_FrameData[24] Tile_X0Y7_FrameData[25] Tile_X0Y7_FrameData[26] Tile_X0Y7_FrameData[27]
+ Tile_X0Y7_FrameData[28] Tile_X0Y7_FrameData[29] Tile_X0Y7_FrameData[2] Tile_X0Y7_FrameData[30]
+ Tile_X0Y7_FrameData[31] Tile_X0Y7_FrameData[3] Tile_X0Y7_FrameData[4] Tile_X0Y7_FrameData[5]
+ Tile_X0Y7_FrameData[6] Tile_X0Y7_FrameData[7] Tile_X0Y7_FrameData[8] Tile_X0Y7_FrameData[9]
+ Tile_X0Y7_FrameData_O[0] Tile_X0Y7_FrameData_O[10] Tile_X0Y7_FrameData_O[11] Tile_X0Y7_FrameData_O[12]
+ Tile_X0Y7_FrameData_O[13] Tile_X0Y7_FrameData_O[14] Tile_X0Y7_FrameData_O[15] Tile_X0Y7_FrameData_O[16]
+ Tile_X0Y7_FrameData_O[17] Tile_X0Y7_FrameData_O[18] Tile_X0Y7_FrameData_O[19] Tile_X0Y7_FrameData_O[1]
+ Tile_X0Y7_FrameData_O[20] Tile_X0Y7_FrameData_O[21] Tile_X0Y7_FrameData_O[22] Tile_X0Y7_FrameData_O[23]
+ Tile_X0Y7_FrameData_O[24] Tile_X0Y7_FrameData_O[25] Tile_X0Y7_FrameData_O[26] Tile_X0Y7_FrameData_O[27]
+ Tile_X0Y7_FrameData_O[28] Tile_X0Y7_FrameData_O[29] Tile_X0Y7_FrameData_O[2] Tile_X0Y7_FrameData_O[30]
+ Tile_X0Y7_FrameData_O[31] Tile_X0Y7_FrameData_O[3] Tile_X0Y7_FrameData_O[4] Tile_X0Y7_FrameData_O[5]
+ Tile_X0Y7_FrameData_O[6] Tile_X0Y7_FrameData_O[7] Tile_X0Y7_FrameData_O[8] Tile_X0Y7_FrameData_O[9]
+ Tile_X0Y7_UserCLK Tile_X0Y7_UserCLKo Tile_X0Y7_W1END[0] Tile_X0Y7_W1END[1] Tile_X0Y7_W1END[2]
+ Tile_X0Y7_W1END[3] Tile_X0Y7_W2END[0] Tile_X0Y7_W2END[1] Tile_X0Y7_W2END[2] Tile_X0Y7_W2END[3]
+ Tile_X0Y7_W2END[4] Tile_X0Y7_W2END[5] Tile_X0Y7_W2END[6] Tile_X0Y7_W2END[7] Tile_X0Y7_W2MID[0]
+ Tile_X0Y7_W2MID[1] Tile_X0Y7_W2MID[2] Tile_X0Y7_W2MID[3] Tile_X0Y7_W2MID[4] Tile_X0Y7_W2MID[5]
+ Tile_X0Y7_W2MID[6] Tile_X0Y7_W2MID[7] Tile_X0Y7_W6END[0] Tile_X0Y7_W6END[10] Tile_X0Y7_W6END[11]
+ Tile_X0Y7_W6END[1] Tile_X0Y7_W6END[2] Tile_X0Y7_W6END[3] Tile_X0Y7_W6END[4] Tile_X0Y7_W6END[5]
+ Tile_X0Y7_W6END[6] Tile_X0Y7_W6END[7] Tile_X0Y7_W6END[8] Tile_X0Y7_W6END[9] Tile_X0Y7_WW4END[0]
+ Tile_X0Y7_WW4END[10] Tile_X0Y7_WW4END[11] Tile_X0Y7_WW4END[12] Tile_X0Y7_WW4END[13]
+ Tile_X0Y7_WW4END[14] Tile_X0Y7_WW4END[15] Tile_X0Y7_WW4END[1] Tile_X0Y7_WW4END[2]
+ Tile_X0Y7_WW4END[3] Tile_X0Y7_WW4END[4] Tile_X0Y7_WW4END[5] Tile_X0Y7_WW4END[6]
+ Tile_X0Y7_WW4END[7] Tile_X0Y7_WW4END[8] Tile_X0Y7_WW4END[9] Tile_X0Y8_E1BEG[0] Tile_X0Y8_E1BEG[1]
+ Tile_X0Y8_E1BEG[2] Tile_X0Y8_E1BEG[3] Tile_X0Y8_E2BEG[0] Tile_X0Y8_E2BEG[1] Tile_X0Y8_E2BEG[2]
+ Tile_X0Y8_E2BEG[3] Tile_X0Y8_E2BEG[4] Tile_X0Y8_E2BEG[5] Tile_X0Y8_E2BEG[6] Tile_X0Y8_E2BEG[7]
+ Tile_X0Y8_E2BEGb[0] Tile_X0Y8_E2BEGb[1] Tile_X0Y8_E2BEGb[2] Tile_X0Y8_E2BEGb[3]
+ Tile_X0Y8_E2BEGb[4] Tile_X0Y8_E2BEGb[5] Tile_X0Y8_E2BEGb[6] Tile_X0Y8_E2BEGb[7]
+ Tile_X0Y8_E6BEG[0] Tile_X0Y8_E6BEG[10] Tile_X0Y8_E6BEG[11] Tile_X0Y8_E6BEG[1] Tile_X0Y8_E6BEG[2]
+ Tile_X0Y8_E6BEG[3] Tile_X0Y8_E6BEG[4] Tile_X0Y8_E6BEG[5] Tile_X0Y8_E6BEG[6] Tile_X0Y8_E6BEG[7]
+ Tile_X0Y8_E6BEG[8] Tile_X0Y8_E6BEG[9] Tile_X0Y8_EE4BEG[0] Tile_X0Y8_EE4BEG[10] Tile_X0Y8_EE4BEG[11]
+ Tile_X0Y8_EE4BEG[12] Tile_X0Y8_EE4BEG[13] Tile_X0Y8_EE4BEG[14] Tile_X0Y8_EE4BEG[15]
+ Tile_X0Y8_EE4BEG[1] Tile_X0Y8_EE4BEG[2] Tile_X0Y8_EE4BEG[3] Tile_X0Y8_EE4BEG[4]
+ Tile_X0Y8_EE4BEG[5] Tile_X0Y8_EE4BEG[6] Tile_X0Y8_EE4BEG[7] Tile_X0Y8_EE4BEG[8]
+ Tile_X0Y8_EE4BEG[9] Tile_X0Y8_FrameData[0] Tile_X0Y8_FrameData[10] Tile_X0Y8_FrameData[11]
+ Tile_X0Y8_FrameData[12] Tile_X0Y8_FrameData[13] Tile_X0Y8_FrameData[14] Tile_X0Y8_FrameData[15]
+ Tile_X0Y8_FrameData[16] Tile_X0Y8_FrameData[17] Tile_X0Y8_FrameData[18] Tile_X0Y8_FrameData[19]
+ Tile_X0Y8_FrameData[1] Tile_X0Y8_FrameData[20] Tile_X0Y8_FrameData[21] Tile_X0Y8_FrameData[22]
+ Tile_X0Y8_FrameData[23] Tile_X0Y8_FrameData[24] Tile_X0Y8_FrameData[25] Tile_X0Y8_FrameData[26]
+ Tile_X0Y8_FrameData[27] Tile_X0Y8_FrameData[28] Tile_X0Y8_FrameData[29] Tile_X0Y8_FrameData[2]
+ Tile_X0Y8_FrameData[30] Tile_X0Y8_FrameData[31] Tile_X0Y8_FrameData[3] Tile_X0Y8_FrameData[4]
+ Tile_X0Y8_FrameData[5] Tile_X0Y8_FrameData[6] Tile_X0Y8_FrameData[7] Tile_X0Y8_FrameData[8]
+ Tile_X0Y8_FrameData[9] Tile_X0Y8_FrameData_O[0] Tile_X0Y8_FrameData_O[10] Tile_X0Y8_FrameData_O[11]
+ Tile_X0Y8_FrameData_O[12] Tile_X0Y8_FrameData_O[13] Tile_X0Y8_FrameData_O[14] Tile_X0Y8_FrameData_O[15]
+ Tile_X0Y8_FrameData_O[16] Tile_X0Y8_FrameData_O[17] Tile_X0Y8_FrameData_O[18] Tile_X0Y8_FrameData_O[19]
+ Tile_X0Y8_FrameData_O[1] Tile_X0Y8_FrameData_O[20] Tile_X0Y8_FrameData_O[21] Tile_X0Y8_FrameData_O[22]
+ Tile_X0Y8_FrameData_O[23] Tile_X0Y8_FrameData_O[24] Tile_X0Y8_FrameData_O[25] Tile_X0Y8_FrameData_O[26]
+ Tile_X0Y8_FrameData_O[27] Tile_X0Y8_FrameData_O[28] Tile_X0Y8_FrameData_O[29] Tile_X0Y8_FrameData_O[2]
+ Tile_X0Y8_FrameData_O[30] Tile_X0Y8_FrameData_O[31] Tile_X0Y8_FrameData_O[3] Tile_X0Y8_FrameData_O[4]
+ Tile_X0Y8_FrameData_O[5] Tile_X0Y8_FrameData_O[6] Tile_X0Y8_FrameData_O[7] Tile_X0Y8_FrameData_O[8]
+ Tile_X0Y8_FrameData_O[9] Tile_X0Y8_UserCLK Tile_X0Y8_UserCLKo Tile_X0Y8_W1END[0]
+ Tile_X0Y8_W1END[1] Tile_X0Y8_W1END[2] Tile_X0Y8_W1END[3] Tile_X0Y8_W2END[0] Tile_X0Y8_W2END[1]
+ Tile_X0Y8_W2END[2] Tile_X0Y8_W2END[3] Tile_X0Y8_W2END[4] Tile_X0Y8_W2END[5] Tile_X0Y8_W2END[6]
+ Tile_X0Y8_W2END[7] Tile_X0Y8_W2MID[0] Tile_X0Y8_W2MID[1] Tile_X0Y8_W2MID[2] Tile_X0Y8_W2MID[3]
+ Tile_X0Y8_W2MID[4] Tile_X0Y8_W2MID[5] Tile_X0Y8_W2MID[6] Tile_X0Y8_W2MID[7] Tile_X0Y8_W6END[0]
+ Tile_X0Y8_W6END[10] Tile_X0Y8_W6END[11] Tile_X0Y8_W6END[1] Tile_X0Y8_W6END[2] Tile_X0Y8_W6END[3]
+ Tile_X0Y8_W6END[4] Tile_X0Y8_W6END[5] Tile_X0Y8_W6END[6] Tile_X0Y8_W6END[7] Tile_X0Y8_W6END[8]
+ Tile_X0Y8_W6END[9] Tile_X0Y8_WW4END[0] Tile_X0Y8_WW4END[10] Tile_X0Y8_WW4END[11]
+ Tile_X0Y8_WW4END[12] Tile_X0Y8_WW4END[13] Tile_X0Y8_WW4END[14] Tile_X0Y8_WW4END[15]
+ Tile_X0Y8_WW4END[1] Tile_X0Y8_WW4END[2] Tile_X0Y8_WW4END[3] Tile_X0Y8_WW4END[4]
+ Tile_X0Y8_WW4END[5] Tile_X0Y8_WW4END[6] Tile_X0Y8_WW4END[7] Tile_X0Y8_WW4END[8]
+ Tile_X0Y8_WW4END[9] Tile_X0Y9_E1BEG[0] Tile_X0Y9_E1BEG[1] Tile_X0Y9_E1BEG[2] Tile_X0Y9_E1BEG[3]
+ Tile_X0Y9_E2BEG[0] Tile_X0Y9_E2BEG[1] Tile_X0Y9_E2BEG[2] Tile_X0Y9_E2BEG[3] Tile_X0Y9_E2BEG[4]
+ Tile_X0Y9_E2BEG[5] Tile_X0Y9_E2BEG[6] Tile_X0Y9_E2BEG[7] Tile_X0Y9_E2BEGb[0] Tile_X0Y9_E2BEGb[1]
+ Tile_X0Y9_E2BEGb[2] Tile_X0Y9_E2BEGb[3] Tile_X0Y9_E2BEGb[4] Tile_X0Y9_E2BEGb[5]
+ Tile_X0Y9_E2BEGb[6] Tile_X0Y9_E2BEGb[7] Tile_X0Y9_E6BEG[0] Tile_X0Y9_E6BEG[10] Tile_X0Y9_E6BEG[11]
+ Tile_X0Y9_E6BEG[1] Tile_X0Y9_E6BEG[2] Tile_X0Y9_E6BEG[3] Tile_X0Y9_E6BEG[4] Tile_X0Y9_E6BEG[5]
+ Tile_X0Y9_E6BEG[6] Tile_X0Y9_E6BEG[7] Tile_X0Y9_E6BEG[8] Tile_X0Y9_E6BEG[9] Tile_X0Y9_EE4BEG[0]
+ Tile_X0Y9_EE4BEG[10] Tile_X0Y9_EE4BEG[11] Tile_X0Y9_EE4BEG[12] Tile_X0Y9_EE4BEG[13]
+ Tile_X0Y9_EE4BEG[14] Tile_X0Y9_EE4BEG[15] Tile_X0Y9_EE4BEG[1] Tile_X0Y9_EE4BEG[2]
+ Tile_X0Y9_EE4BEG[3] Tile_X0Y9_EE4BEG[4] Tile_X0Y9_EE4BEG[5] Tile_X0Y9_EE4BEG[6]
+ Tile_X0Y9_EE4BEG[7] Tile_X0Y9_EE4BEG[8] Tile_X0Y9_EE4BEG[9] Tile_X0Y9_FrameData[0]
+ Tile_X0Y9_FrameData[10] Tile_X0Y9_FrameData[11] Tile_X0Y9_FrameData[12] Tile_X0Y9_FrameData[13]
+ Tile_X0Y9_FrameData[14] Tile_X0Y9_FrameData[15] Tile_X0Y9_FrameData[16] Tile_X0Y9_FrameData[17]
+ Tile_X0Y9_FrameData[18] Tile_X0Y9_FrameData[19] Tile_X0Y9_FrameData[1] Tile_X0Y9_FrameData[20]
+ Tile_X0Y9_FrameData[21] Tile_X0Y9_FrameData[22] Tile_X0Y9_FrameData[23] Tile_X0Y9_FrameData[24]
+ Tile_X0Y9_FrameData[25] Tile_X0Y9_FrameData[26] Tile_X0Y9_FrameData[27] Tile_X0Y9_FrameData[28]
+ Tile_X0Y9_FrameData[29] Tile_X0Y9_FrameData[2] Tile_X0Y9_FrameData[30] Tile_X0Y9_FrameData[31]
+ Tile_X0Y9_FrameData[3] Tile_X0Y9_FrameData[4] Tile_X0Y9_FrameData[5] Tile_X0Y9_FrameData[6]
+ Tile_X0Y9_FrameData[7] Tile_X0Y9_FrameData[8] Tile_X0Y9_FrameData[9] Tile_X0Y9_FrameData_O[0]
+ Tile_X0Y9_FrameData_O[10] Tile_X0Y9_FrameData_O[11] Tile_X0Y9_FrameData_O[12] Tile_X0Y9_FrameData_O[13]
+ Tile_X0Y9_FrameData_O[14] Tile_X0Y9_FrameData_O[15] Tile_X0Y9_FrameData_O[16] Tile_X0Y9_FrameData_O[17]
+ Tile_X0Y9_FrameData_O[18] Tile_X0Y9_FrameData_O[19] Tile_X0Y9_FrameData_O[1] Tile_X0Y9_FrameData_O[20]
+ Tile_X0Y9_FrameData_O[21] Tile_X0Y9_FrameData_O[22] Tile_X0Y9_FrameData_O[23] Tile_X0Y9_FrameData_O[24]
+ Tile_X0Y9_FrameData_O[25] Tile_X0Y9_FrameData_O[26] Tile_X0Y9_FrameData_O[27] Tile_X0Y9_FrameData_O[28]
+ Tile_X0Y9_FrameData_O[29] Tile_X0Y9_FrameData_O[2] Tile_X0Y9_FrameData_O[30] Tile_X0Y9_FrameData_O[31]
+ Tile_X0Y9_FrameData_O[3] Tile_X0Y9_FrameData_O[4] Tile_X0Y9_FrameData_O[5] Tile_X0Y9_FrameData_O[6]
+ Tile_X0Y9_FrameData_O[7] Tile_X0Y9_FrameData_O[8] Tile_X0Y9_FrameData_O[9] Tile_X0Y9_FrameStrobe[0]
+ Tile_X0Y9_FrameStrobe[10] Tile_X0Y9_FrameStrobe[11] Tile_X0Y9_FrameStrobe[12] Tile_X0Y9_FrameStrobe[13]
+ Tile_X0Y9_FrameStrobe[14] Tile_X0Y9_FrameStrobe[15] Tile_X0Y9_FrameStrobe[16] Tile_X0Y9_FrameStrobe[17]
+ Tile_X0Y9_FrameStrobe[18] Tile_X0Y9_FrameStrobe[19] Tile_X0Y9_FrameStrobe[1] Tile_X0Y9_FrameStrobe[2]
+ Tile_X0Y9_FrameStrobe[3] Tile_X0Y9_FrameStrobe[4] Tile_X0Y9_FrameStrobe[5] Tile_X0Y9_FrameStrobe[6]
+ Tile_X0Y9_FrameStrobe[7] Tile_X0Y9_FrameStrobe[8] Tile_X0Y9_FrameStrobe[9] Tile_X0Y9_N1END[0]
+ Tile_X0Y9_N1END[1] Tile_X0Y9_N1END[2] Tile_X0Y9_N1END[3] Tile_X0Y9_N2END[0] Tile_X0Y9_N2END[1]
+ Tile_X0Y9_N2END[2] Tile_X0Y9_N2END[3] Tile_X0Y9_N2END[4] Tile_X0Y9_N2END[5] Tile_X0Y9_N2END[6]
+ Tile_X0Y9_N2END[7] Tile_X0Y9_N2MID[0] Tile_X0Y9_N2MID[1] Tile_X0Y9_N2MID[2] Tile_X0Y9_N2MID[3]
+ Tile_X0Y9_N2MID[4] Tile_X0Y9_N2MID[5] Tile_X0Y9_N2MID[6] Tile_X0Y9_N2MID[7] Tile_X0Y9_N4END[0]
+ Tile_X0Y9_N4END[10] Tile_X0Y9_N4END[11] Tile_X0Y9_N4END[12] Tile_X0Y9_N4END[13]
+ Tile_X0Y9_N4END[14] Tile_X0Y9_N4END[15] Tile_X0Y9_N4END[1] Tile_X0Y9_N4END[2] Tile_X0Y9_N4END[3]
+ Tile_X0Y9_N4END[4] Tile_X0Y9_N4END[5] Tile_X0Y9_N4END[6] Tile_X0Y9_N4END[7] Tile_X0Y9_N4END[8]
+ Tile_X0Y9_N4END[9] Tile_X0Y9_S1BEG[0] Tile_X0Y9_S1BEG[1] Tile_X0Y9_S1BEG[2] Tile_X0Y9_S1BEG[3]
+ Tile_X0Y9_S2BEG[0] Tile_X0Y9_S2BEG[1] Tile_X0Y9_S2BEG[2] Tile_X0Y9_S2BEG[3] Tile_X0Y9_S2BEG[4]
+ Tile_X0Y9_S2BEG[5] Tile_X0Y9_S2BEG[6] Tile_X0Y9_S2BEG[7] Tile_X0Y9_S2BEGb[0] Tile_X0Y9_S2BEGb[1]
+ Tile_X0Y9_S2BEGb[2] Tile_X0Y9_S2BEGb[3] Tile_X0Y9_S2BEGb[4] Tile_X0Y9_S2BEGb[5]
+ Tile_X0Y9_S2BEGb[6] Tile_X0Y9_S2BEGb[7] Tile_X0Y9_S4BEG[0] Tile_X0Y9_S4BEG[10] Tile_X0Y9_S4BEG[11]
+ Tile_X0Y9_S4BEG[12] Tile_X0Y9_S4BEG[13] Tile_X0Y9_S4BEG[14] Tile_X0Y9_S4BEG[15]
+ Tile_X0Y9_S4BEG[1] Tile_X0Y9_S4BEG[2] Tile_X0Y9_S4BEG[3] Tile_X0Y9_S4BEG[4] Tile_X0Y9_S4BEG[5]
+ Tile_X0Y9_S4BEG[6] Tile_X0Y9_S4BEG[7] Tile_X0Y9_S4BEG[8] Tile_X0Y9_S4BEG[9] Tile_X0Y9_UserCLK
+ Tile_X0Y9_UserCLKo Tile_X0Y9_W1END[0] Tile_X0Y9_W1END[1] Tile_X0Y9_W1END[2] Tile_X0Y9_W1END[3]
+ Tile_X0Y9_W2END[0] Tile_X0Y9_W2END[1] Tile_X0Y9_W2END[2] Tile_X0Y9_W2END[3] Tile_X0Y9_W2END[4]
+ Tile_X0Y9_W2END[5] Tile_X0Y9_W2END[6] Tile_X0Y9_W2END[7] Tile_X0Y9_W2MID[0] Tile_X0Y9_W2MID[1]
+ Tile_X0Y9_W2MID[2] Tile_X0Y9_W2MID[3] Tile_X0Y9_W2MID[4] Tile_X0Y9_W2MID[5] Tile_X0Y9_W2MID[6]
+ Tile_X0Y9_W2MID[7] Tile_X0Y9_W6END[0] Tile_X0Y9_W6END[10] Tile_X0Y9_W6END[11] Tile_X0Y9_W6END[1]
+ Tile_X0Y9_W6END[2] Tile_X0Y9_W6END[3] Tile_X0Y9_W6END[4] Tile_X0Y9_W6END[5] Tile_X0Y9_W6END[6]
+ Tile_X0Y9_W6END[7] Tile_X0Y9_W6END[8] Tile_X0Y9_W6END[9] Tile_X0Y9_WW4END[0] Tile_X0Y9_WW4END[10]
+ Tile_X0Y9_WW4END[11] Tile_X0Y9_WW4END[12] Tile_X0Y9_WW4END[13] Tile_X0Y9_WW4END[14]
+ Tile_X0Y9_WW4END[15] Tile_X0Y9_WW4END[1] Tile_X0Y9_WW4END[2] Tile_X0Y9_WW4END[3]
+ Tile_X0Y9_WW4END[4] Tile_X0Y9_WW4END[5] Tile_X0Y9_WW4END[6] Tile_X0Y9_WW4END[7]
+ Tile_X0Y9_WW4END[8] Tile_X0Y9_WW4END[9] VGND VPWR
XFILLER_290_49 VPWR VGND sg13cmos5l_decap_8
XFILLER_651_70 VPWR VGND sg13cmos5l_decap_8
XFILLER_223_21 VPWR VGND sg13cmos5l_decap_8
XFILLER_239_172 VPWR VGND sg13cmos5l_decap_8
X_0367_ _0367_/Q Tile_X0Y7_FrameData[16] VGND VPWR Tile_X0Y9_FrameStrobe[6] latch
X_3155_ Tile_X0Y7_FrameData_O[25] Tile_X0Y7_FrameData[25] VPWR VGND sg13cmos5l_buf_1
XFILLER_239_194 VPWR VGND sg13cmos5l_decap_8
X_2106_ _2106_/Q Tile_X0Y4_FrameData[11] VGND VPWR Tile_X0Y9_FrameStrobe[5] latch
X_3086_ Tile_X0Y7_E2BEG[0] _4612_/X VPWR VGND sg13cmos5l_buf_1
XFILLER_299_14 VPWR VGND sg13cmos5l_decap_8
XFILLER_223_98 VPWR VGND sg13cmos5l_decap_8
X_0298_ _0298_/Q Tile_X0Y7_FrameData[21] VGND VPWR Tile_X0Y9_FrameStrobe[4] latch
X_2037_ _2037_/Q Tile_X0Y4_FrameData[16] VGND VPWR Tile_X0Y9_FrameStrobe[3] latch
XFILLER_520_63 VPWR VGND sg13cmos5l_decap_8
XFILLER_449_28 VPWR VGND sg13cmos5l_decap_8
XFILLER_557_143 VPWR VGND sg13cmos5l_fill_1
XFILLER_596_56 VPWR VGND sg13cmos5l_decap_8
XANTENNA__2742__X Tile_X0Y3_FrameData_O[0] VPWR VGND sg13cmos5l_antennanp
XFILLER_167_105 VPWR VGND sg13cmos5l_fill_1
XFILLER_22_166 VPWR VGND sg13cmos5l_fill_1
XFILLER_167_127 VPWR VGND sg13cmos5l_fill_2
X_3988_ _3988_/X _3902_/X _4035_/X _4034_/X Tile_X0Y0_S2MID[7] _1187_/Q _1186_/Q VPWR
+ VGND sg13cmos5l_mux4_1
X_2939_ Tile_X0Y8_E6BEG[7] _4767_/X VPWR VGND sg13cmos5l_buf_1
XFILLER_572_168 VPWR VGND sg13cmos5l_decap_8
XFILLER_465_49 VPWR VGND sg13cmos5l_decap_8
XFILLER_324_102 VPWR VGND sg13cmos5l_decap_4
XFILLER_714_162 VPWR VGND sg13cmos5l_decap_8
X_4609_ _4609_/X _4663_/X _4662_/X AXI_M_SOC_RDATA18 AXI_M_SOC_RDATA22 _0341_/Q _0340_/Q
+ VPWR VGND sg13cmos5l_mux4_1
XFILLER_184_28 VPWR VGND sg13cmos5l_decap_8
XFILLER_324_146 VPWR VGND sg13cmos5l_decap_8
XANTENNA__3573__X Tile_X0Y9_FrameData_O[3] VPWR VGND sg13cmos5l_antennanp
XFILLER_89_100 VPWR VGND sg13cmos5l_fill_2
XFILLER_7_7 VPWR VGND sg13cmos5l_decap_8
XFILLER_117_77 VPWR VGND sg13cmos5l_decap_8
XFILLER_627_114 VPWR VGND sg13cmos5l_fill_1
XFILLER_396_7 VPWR VGND sg13cmos5l_decap_8
XFILLER_627_136 VPWR VGND sg13cmos5l_decap_4
XFILLER_414_42 VPWR VGND sg13cmos5l_decap_8
XFILLER_561_70 VPWR VGND sg13cmos5l_decap_8
XFILLER_133_21 VPWR VGND sg13cmos5l_decap_8
XFILLER_493_175 VPWR VGND sg13cmos5l_decap_8
XANTENNA__2917__X Tile_X0Y8_E2BEG[1] VPWR VGND sg13cmos5l_antennanp
XFILLER_563_7 VPWR VGND sg13cmos5l_decap_8
XFILLER_93_14 VPWR VGND sg13cmos5l_decap_8
XFILLER_133_98 VPWR VGND sg13cmos5l_decap_8
XFILLER_711_84 VPWR VGND sg13cmos5l_decap_8
XFILLER_650_161 VPWR VGND sg13cmos5l_decap_8
XFILLER_430_63 VPWR VGND sg13cmos5l_decap_8
XFILLER_60_206 VPWR VGND sg13cmos5l_fill_2
XFILLER_595_216 VPWR VGND sg13cmos5l_fill_2
XFILLER_26_63 VPWR VGND sg13cmos5l_decap_8
XFILLER_60_228 VPWR VGND sg13cmos5l_fill_1
XFILLER_359_28 VPWR VGND sg13cmos5l_decap_8
XANTENNA__3748__X AXI_M_SOC_ARADDR20 VPWR VGND sg13cmos5l_antennanp
XFILLER_289_91 VPWR VGND sg13cmos5l_decap_8
XFILLER_158_105 VPWR VGND sg13cmos5l_decap_8
XFILLER_220_0 VPWR VGND sg13cmos5l_decap_8
XFILLER_173_108 VPWR VGND sg13cmos5l_decap_4
XFILLER_318_0 VPWR VGND sg13cmos5l_decap_8
XFILLER_563_179 VPWR VGND sg13cmos5l_decap_4
XFILLER_166_171 VPWR VGND sg13cmos5l_decap_4
XFILLER_375_49 VPWR VGND sg13cmos5l_decap_8
XFILLER_308_21 VPWR VGND sg13cmos5l_decap_8
XFILLER_705_195 VPWR VGND sg13cmos5l_fill_2
XFILLER_672_14 VPWR VGND sg13cmos5l_decap_8
XFILLER_181_163 VPWR VGND sg13cmos5l_decap_8
XANTENNA__3483__X Tile_X0Y1_EE4BEG[9] VPWR VGND sg13cmos5l_antennanp
XFILLER_687_0 VPWR VGND sg13cmos5l_decap_8
XFILLER_605_63 VPWR VGND sg13cmos5l_decap_8
XFILLER_268_223 VPWR VGND sg13cmos5l_decap_4
XFILLER_95_114 VPWR VGND sg13cmos5l_decap_8
XFILLER_3_56 VPWR VGND sg13cmos5l_decap_8
XFILLER_324_42 VPWR VGND sg13cmos5l_decap_8
X_1270_ _1270_/Q Tile_X0Y1_FrameData[3] VGND VPWR Tile_X0Y9_FrameStrobe[2] latch
XFILLER_471_70 VPWR VGND sg13cmos5l_decap_8
X_0221_ _0221_/Q Tile_X0Y7_FrameData[2] VGND VPWR Tile_X0Y9_FrameStrobe[1] latch
XFILLER_67_70 VPWR VGND sg13cmos5l_decap_8
XANTENNA__2827__X Tile_X0Y4_E2BEG[5] VPWR VGND sg13cmos5l_antennanp
XFILLER_36_214 VPWR VGND sg13cmos5l_fill_1
X_0152_ _0152_/X _4560_/X _4561_/X _1611_/Q VPWR VGND sg13cmos5l_mux2_1
XFILLER_621_84 VPWR VGND sg13cmos5l_decap_8
XFILLER_440_201 VPWR VGND sg13cmos5l_fill_1
XFILLER_641_161 VPWR VGND sg13cmos5l_decap_8
X_0083_ _0083_/X _4908_/X _4909_/X _2377_/Q VPWR VGND sg13cmos5l_mux2_1
XFILLER_397_116 VPWR VGND sg13cmos5l_decap_8
XFILLER_397_127 VPWR VGND sg13cmos5l_fill_1
XFILLER_51_228 VPWR VGND sg13cmos5l_fill_1
XFILLER_340_96 VPWR VGND sg13cmos5l_fill_1
X_3911_ _3911_/X _4012_/X _4016_/X _4005_/X _3989_/X _1401_/Q _1400_/Q VPWR VGND sg13cmos5l_mux4_1
XFILLER_697_77 VPWR VGND sg13cmos5l_decap_8
XFILLER_400_109 VPWR VGND sg13cmos5l_decap_8
XFILLER_269_28 VPWR VGND sg13cmos5l_decap_8
X_4891_ _4891_/X AXI_M_SOC_RDATA7 _4916_/X _4920_/X _4900_/X _0761_/Q _0760_/Q VPWR
+ VGND sg13cmos5l_mux4_1
XANTENNA__3658__X AXI_M_SOC_AWADDR19 VPWR VGND sg13cmos5l_antennanp
XFILLER_199_91 VPWR VGND sg13cmos5l_decap_8
X_3842_ _3842_/X Tile_X0Y0_W6END[9] _3886_/X _3872_/X _3857_/X _1021_/Q _1020_/Q VPWR
+ VGND sg13cmos5l_mux4_1
XFILLER_554_135 VPWR VGND sg13cmos5l_fill_1
X_3773_ _3773_/X Tile_X0Y0_WW4END[2] Tile_X0Y0_WW4END[10] Tile_X0Y0_W6END[2] _3883_/X
+ _1005_/Q _1004_/Q VPWR VGND sg13cmos5l_mux4_1
X_0985_ _0985_/Q Tile_X0Y0_FrameData[18] VGND VPWR Tile_X0Y9_FrameStrobe[1] latch
X_2724_ _4658_/A3 VPWR VGND sg13cmos5l_tielo
XFILLER_716_29 VPWR VGND sg13cmos5l_decap_8
XFILLER_285_49 VPWR VGND sg13cmos5l_decap_8
XFILLER_646_70 VPWR VGND sg13cmos5l_decap_8
XFILLER_66_0 VPWR VGND sg13cmos5l_fill_1
XFILLER_218_21 VPWR VGND sg13cmos5l_decap_8
XFILLER_8_192 VPWR VGND sg13cmos5l_fill_1
XFILLER_582_14 VPWR VGND sg13cmos5l_decap_8
X_2655_ _2655_/Q Tile_X0Y6_FrameData[8] VGND VPWR Tile_X0Y9_FrameStrobe[6] latch
XANTENNA__3393__X Tile_X0Y2_E2BEGb[4] VPWR VGND sg13cmos5l_antennanp
XFILLER_306_157 VPWR VGND sg13cmos5l_decap_8
XFILLER_711_154 VPWR VGND sg13cmos5l_decap_8
X_1606_ _1606_/Q Tile_X0Y2_FrameData[11] VGND VPWR Tile_X0Y9_FrameStrobe[5] latch
XFILLER_218_98 VPWR VGND sg13cmos5l_decap_8
XFILLER_172_196 VPWR VGND sg13cmos5l_decap_8
X_2586_ _2586_/Q Tile_X0Y6_FrameData[13] VGND VPWR Tile_X0Y9_FrameStrobe[4] latch
X_4325_ _4325_/X _3886_/X _3872_/X _3871_/X _3856_/X _1114_/Q _1113_/Q VPWR VGND sg13cmos5l_mux4_1
X_1537_ _1537_/Q Tile_X0Y2_FrameData[16] VGND VPWR Tile_X0Y9_FrameStrobe[3] latch
XFILLER_515_63 VPWR VGND sg13cmos5l_decap_8
XFILLER_609_125 VPWR VGND sg13cmos5l_fill_2
XFILLER_662_91 VPWR VGND sg13cmos5l_decap_8
XFILLER_86_114 VPWR VGND sg13cmos5l_fill_2
XFILLER_234_42 VPWR VGND sg13cmos5l_decap_8
X_4256_ _4256_/X Tile_X0Y4_W2MID[7] AXI_M_SOC_BRESP0 _4313_/X _4312_/X _2101_/Q _2100_/Q
+ VPWR VGND sg13cmos5l_mux4_1
XFILLER_219_109 VPWR VGND sg13cmos5l_fill_2
X_1468_ _1468_/Q Tile_X0Y2_FrameData[21] VGND VPWR Tile_X0Y9_FrameStrobe[1] latch
XFILLER_475_164 VPWR VGND sg13cmos5l_decap_4
XFILLER_381_70 VPWR VGND sg13cmos5l_decap_8
XFILLER_86_158 VPWR VGND sg13cmos5l_fill_2
X_3207_ Tile_X0Y0_N2BEG[7] _3791_/X VPWR VGND sg13cmos5l_buf_1
XFILLER_490_112 VPWR VGND sg13cmos5l_decap_8
XANTENNA__2737__X Tile_X0Y4_E1BEG[0] VPWR VGND sg13cmos5l_antennanp
X_0419_ _0419_/Q Tile_X0Y8_FrameData[28] VGND VPWR Tile_X0Y9_FrameStrobe[0] latch
X_1399_ _1399_/Q Tile_X0Y1_FrameData[2] VGND VPWR Tile_X0Y9_FrameStrobe[6] latch
X_4187_ _4187_/X AXI_M_SOC_BVALID _4226_/X _4230_/X _4211_/X _1767_/Q _1766_/Q VPWR
+ VGND sg13cmos5l_mux4_1
X_3138_ Tile_X0Y7_FrameData_O[8] Tile_X0Y7_FrameData[8] VPWR VGND sg13cmos5l_buf_1
XFILLER_27_225 VPWR VGND sg13cmos5l_decap_4
XFILLER_227_164 VPWR VGND sg13cmos5l_decap_4
XFILLER_103_35 VPWR VGND sg13cmos5l_decap_8
XFILLER_227_175 VPWR VGND sg13cmos5l_decap_8
XFILLER_632_161 VPWR VGND sg13cmos5l_decap_4
XFILLER_250_63 VPWR VGND sg13cmos5l_decap_8
XFILLER_388_116 VPWR VGND sg13cmos5l_fill_1
X_3069_ Tile_X0Y5_FrameData_O[28] Tile_X0Y5_FrameData[28] VPWR VGND sg13cmos5l_buf_1
XFILLER_63_28 VPWR VGND sg13cmos5l_decap_8
XFILLER_577_216 VPWR VGND sg13cmos5l_fill_1
XFILLER_388_138 VPWR VGND sg13cmos5l_decap_4
XFILLER_179_28 VPWR VGND sg13cmos5l_decap_8
XANTENNA__3568__X Tile_X0Y9_EE4BEG[14] VPWR VGND sg13cmos5l_antennanp
XFILLER_400_77 VPWR VGND sg13cmos5l_decap_4
XFILLER_396_160 VPWR VGND sg13cmos5l_decap_8
XFILLER_144_7 VPWR VGND sg13cmos5l_decap_8
XFILLER_259_83 VPWR VGND sg13cmos5l_fill_2
XFILLER_12_21 VPWR VGND sg13cmos5l_decap_8
XFILLER_560_105 VPWR VGND sg13cmos5l_decap_8
XFILLER_409_42 VPWR VGND sg13cmos5l_decap_8
XFILLER_311_7 VPWR VGND sg13cmos5l_decap_8
XFILLER_409_7 VPWR VGND sg13cmos5l_decap_8
XFILLER_195_49 VPWR VGND sg13cmos5l_decap_8
XFILLER_556_70 VPWR VGND sg13cmos5l_decap_8
XFILLER_128_21 VPWR VGND sg13cmos5l_decap_8
XFILLER_498_212 VPWR VGND sg13cmos5l_fill_2
XFILLER_492_14 VPWR VGND sg13cmos5l_decap_8
XFILLER_409_97 VPWR VGND sg13cmos5l_decap_8
XFILLER_88_14 VPWR VGND sg13cmos5l_decap_8
XFILLER_706_84 VPWR VGND sg13cmos5l_decap_8
XFILLER_680_7 VPWR VGND sg13cmos5l_decap_8
XFILLER_642_28 VPWR VGND sg13cmos5l_decap_8
XFILLER_425_63 VPWR VGND sg13cmos5l_decap_8
XFILLER_572_91 VPWR VGND sg13cmos5l_decap_8
XFILLER_144_42 VPWR VGND sg13cmos5l_decap_8
XFILLER_466_142 VPWR VGND sg13cmos5l_decap_8
XFILLER_291_70 VPWR VGND sg13cmos5l_decap_8
XFILLER_265_215 VPWR VGND sg13cmos5l_decap_8
XFILLER_481_112 VPWR VGND sg13cmos5l_decap_8
XFILLER_481_167 VPWR VGND sg13cmos5l_decap_8
XFILLER_441_84 VPWR VGND sg13cmos5l_decap_8
XFILLER_623_150 VPWR VGND sg13cmos5l_decap_8
XFILLER_37_73 VPWR VGND sg13cmos5l_decap_8
XFILLER_170_0 VPWR VGND sg13cmos5l_decap_8
XFILLER_268_0 VPWR VGND sg13cmos5l_decap_8
XFILLER_160_63 VPWR VGND sg13cmos5l_decap_4
XFILLER_33_228 VPWR VGND sg13cmos5l_fill_1
XFILLER_667_14 VPWR VGND sg13cmos5l_decap_8
XFILLER_435_0 VPWR VGND sg13cmos5l_decap_8
XANTENNA__3478__X Tile_X0Y1_EE4BEG[4] VPWR VGND sg13cmos5l_antennanp
XFILLER_387_182 VPWR VGND sg13cmos5l_decap_8
XFILLER_186_222 VPWR VGND sg13cmos5l_decap_8
XFILLER_602_0 VPWR VGND sg13cmos5l_decap_8
XFILLER_551_105 VPWR VGND sg13cmos5l_decap_4
XFILLER_319_42 VPWR VGND sg13cmos5l_decap_8
XFILLER_551_116 VPWR VGND sg13cmos5l_fill_2
X_0770_ _0770_/Q Tile_X0Y9_FrameData[29] VGND VPWR Tile_X0Y9_FrameStrobe[3] latch
XFILLER_683_35 VPWR VGND sg13cmos5l_decap_8
XFILLER_139_182 VPWR VGND sg13cmos5l_decap_8
XFILLER_466_70 VPWR VGND sg13cmos5l_fill_2
XFILLER_319_86 VPWR VGND sg13cmos5l_fill_1
XFILLER_154_130 VPWR VGND sg13cmos5l_decap_8
X_2440_ _2440_/Q Tile_X0Y5_FrameData[31] VGND VPWR Tile_X0Y9_FrameStrobe[0] latch
XFILLER_449_109 VPWR VGND sg13cmos5l_fill_2
XFILLER_616_84 VPWR VGND sg13cmos5l_decap_8
XFILLER_303_149 VPWR VGND sg13cmos5l_decap_4
XFILLER_552_28 VPWR VGND sg13cmos5l_decap_8
XFILLER_335_63 VPWR VGND sg13cmos5l_decap_8
X_2371_ _2371_/Q Tile_X0Y5_FrameData[2] VGND VPWR Tile_X0Y9_FrameStrobe[5] latch
XFILLER_482_91 VPWR VGND sg13cmos5l_decap_8
X_4110_ _4110_/X _4091_/X _0064_/X _4090_/X Tile_X0Y0_S4END[9] _1455_/Q _1454_/Q VPWR
+ VGND sg13cmos5l_mux4_1
XFILLER_68_114 VPWR VGND sg13cmos5l_decap_8
XFILLER_311_160 VPWR VGND sg13cmos5l_fill_2
X_1322_ _1322_/Q Tile_X0Y1_FrameData[15] VGND VPWR Tile_X0Y9_FrameStrobe[4] latch
XFILLER_110_222 VPWR VGND sg13cmos5l_decap_8
XFILLER_256_215 VPWR VGND sg13cmos5l_decap_8
X_1253_ _1253_/Q Tile_X0Y1_FrameData[20] VGND VPWR Tile_X0Y9_FrameStrobe[2] latch
X_4041_ _4041_/X Tile_X0Y2_W2MID[6] AXI_M_SOC_AWREADY _4099_/X _4098_/X _1591_/Q _1590_/Q
+ VPWR VGND sg13cmos5l_mux4_1
XFILLER_271_207 VPWR VGND sg13cmos5l_fill_1
XFILLER_204_56 VPWR VGND sg13cmos5l_decap_8
X_0204_ _0204_/Q Tile_X0Y7_FrameData[19] VGND VPWR Tile_X0Y9_FrameStrobe[1] latch
XFILLER_472_167 VPWR VGND sg13cmos5l_decap_8
X_1184_ _1184_/Q Tile_X0Y1_FrameData[25] VGND VPWR Tile_X0Y9_FrameStrobe[0] latch
XFILLER_351_84 VPWR VGND sg13cmos5l_decap_8
XFILLER_209_175 VPWR VGND sg13cmos5l_decap_8
XFILLER_501_21 VPWR VGND sg13cmos5l_decap_8
X_0135_ AXI_M_SOC_AWLEN5 _0940_/Q _3676_/X VPWR VGND sg13cmos5l_nor2b_1
XFILLER_559_216 VPWR VGND sg13cmos5l_decap_4
XFILLER_24_228 VPWR VGND sg13cmos5l_fill_1
XFILLER_224_167 VPWR VGND sg13cmos5l_decap_8
X_0066_ _3635_/A _4838_/X _4839_/X _0862_/Q VPWR VGND sg13cmos5l_mux2_1
XFILLER_501_98 VPWR VGND sg13cmos5l_decap_8
XFILLER_577_14 VPWR VGND sg13cmos5l_decap_8
XFILLER_224_189 VPWR VGND sg13cmos5l_decap_8
XANTENNA__3388__X Tile_X0Y2_E6BEG[11] VPWR VGND sg13cmos5l_antennanp
XFILLER_220_77 VPWR VGND sg13cmos5l_decap_8
X_4874_ _4874_/X Tile_X0Y9_WW4END[5] AXI_M_SOC_RDATA5 _4921_/X _4904_/X _0795_/Q _0794_/Q
+ VPWR VGND sg13cmos5l_mux4_1
XFILLER_177_222 VPWR VGND sg13cmos5l_decap_8
X_3825_ _3825_/X Tile_X0Y0_WW4END[10] Tile_X0Y0_WW4END[15] _3868_/X _3857_/X _1055_/Q
+ _1054_/Q VPWR VGND sg13cmos5l_mux4_1
XFILLER_137_119 VPWR VGND sg13cmos5l_decap_8
XFILLER_657_91 VPWR VGND sg13cmos5l_decap_8
XFILLER_229_42 VPWR VGND sg13cmos5l_decap_8
X_3756_ AXI_M_SOC_ARADDR28 Tile_X0Y8_W1END[0] Tile_X0Y8_WW4END[4] Tile_X0Y8_WW4END[12]
+ _4812_/X _0479_/Q _0478_/Q VPWR VGND sg13cmos5l_mux4_1
X_0968_ _0968_/Q Tile_X0Y0_FrameData[3] VGND VPWR Tile_X0Y9_FrameStrobe[0] latch
XFILLER_593_35 VPWR VGND sg13cmos5l_decap_8
XFILLER_376_70 VPWR VGND sg13cmos5l_decap_4
XFILLER_376_81 VPWR VGND sg13cmos5l_decap_8
XFILLER_145_130 VPWR VGND sg13cmos5l_decap_4
X_2707_ _4306_/A3 VPWR VGND sg13cmos5l_tielo
X_3687_ _3687_/X Tile_X0Y3_WW4END[5] Tile_X0Y3_WW4END[13] Tile_X0Y3_W6END[5] _4227_/X
+ _1747_/Q _1746_/Q VPWR VGND sg13cmos5l_mux4_1
X_0899_ _0899_/Q Tile_X0Y9_FrameData[28] VGND VPWR Tile_X0Y9_FrameStrobe[7] latch
XFILLER_145_163 VPWR VGND sg13cmos5l_decap_4
XFILLER_160_111 VPWR VGND sg13cmos5l_decap_8
X_2638_ _2638_/Q Tile_X0Y6_FrameData[25] VGND VPWR Tile_X0Y9_FrameStrobe[6] latch
XFILLER_462_28 VPWR VGND sg13cmos5l_decap_8
XFILLER_58_17 VPWR VGND sg13cmos5l_decap_8
XFILLER_245_63 VPWR VGND sg13cmos5l_decap_8
X_2569_ _2569_/Q Tile_X0Y6_FrameData[30] VGND VPWR Tile_X0Y9_FrameStrobe[4] latch
X_4308_ _4308_/X Tile_X0Y5_W1END[2] Tile_X0Y5_W6END[6] _4465_/X _4422_/X _2435_/Q
+ _2434_/Q VPWR VGND sg13cmos5l_mux4_1
XFILLER_59_125 VPWR VGND sg13cmos5l_decap_8
XFILLER_302_171 VPWR VGND sg13cmos5l_decap_8
XFILLER_302_182 VPWR VGND sg13cmos5l_fill_1
X_4239_ _4239_/X Tile_X0Y5_W2MID[6] Tile_X0Y5_W2END[6] Tile_X0Y5_W6END[6] _4430_/X
+ _2429_/Q _2428_/Q VPWR VGND sg13cmos5l_mux4_1
XFILLER_74_117 VPWR VGND sg13cmos5l_fill_1
XFILLER_114_56 VPWR VGND sg13cmos5l_decap_8
XFILLER_463_167 VPWR VGND sg13cmos5l_fill_1
XFILLER_67_191 VPWR VGND sg13cmos5l_decap_8
XFILLER_463_189 VPWR VGND sg13cmos5l_decap_8
XFILLER_411_21 VPWR VGND sg13cmos5l_decap_8
XFILLER_74_49 VPWR VGND sg13cmos5l_decap_8
XFILLER_215_112 VPWR VGND sg13cmos5l_decap_8
XFILLER_261_7 VPWR VGND sg13cmos5l_decap_8
XFILLER_82_161 VPWR VGND sg13cmos5l_decap_8
XFILLER_359_7 VPWR VGND sg13cmos5l_decap_8
XFILLER_15_228 VPWR VGND sg13cmos5l_fill_1
XFILLER_215_167 VPWR VGND sg13cmos5l_decap_8
XFILLER_487_14 VPWR VGND sg13cmos5l_decap_8
XANTENNA__3298__X Tile_X0Y0_E2BEGb[6] VPWR VGND sg13cmos5l_antennanp
XFILLER_130_77 VPWR VGND sg13cmos5l_decap_8
XFILLER_526_7 VPWR VGND sg13cmos5l_decap_8
XFILLER_637_28 VPWR VGND sg13cmos5l_decap_8
XFILLER_23_42 VPWR VGND sg13cmos5l_decap_8
XFILLER_128_119 VPWR VGND sg13cmos5l_fill_2
XFILLER_567_91 VPWR VGND sg13cmos5l_decap_8
XANTENNA__2930__X Tile_X0Y8_E2BEGb[6] VPWR VGND sg13cmos5l_antennanp
XFILLER_139_42 VPWR VGND sg13cmos5l_decap_8
XFILLER_286_70 VPWR VGND sg13cmos5l_decap_8
XFILLER_99_35 VPWR VGND sg13cmos5l_decap_8
XFILLER_687_131 VPWR VGND sg13cmos5l_decap_4
XFILLER_653_49 VPWR VGND sg13cmos5l_decap_8
XFILLER_436_84 VPWR VGND sg13cmos5l_decap_8
XFILLER_2_110 VPWR VGND sg13cmos5l_decap_8
XFILLER_136_196 VPWR VGND sg13cmos5l_fill_1
XFILLER_541_182 VPWR VGND sg13cmos5l_decap_8
XFILLER_2_121 VPWR VGND sg13cmos5l_fill_2
XFILLER_97_209 VPWR VGND sg13cmos5l_fill_2
XFILLER_372_28 VPWR VGND sg13cmos5l_decap_8
XFILLER_687_197 VPWR VGND sg13cmos5l_fill_1
XFILLER_155_63 VPWR VGND sg13cmos5l_decap_8
XFILLER_155_74 VPWR VGND sg13cmos5l_fill_2
XFILLER_643_212 VPWR VGND sg13cmos5l_fill_1
XFILLER_452_72 VPWR VGND sg13cmos5l_fill_1
XFILLER_385_0 VPWR VGND sg13cmos5l_decap_8
XFILLER_305_77 VPWR VGND sg13cmos5l_decap_8
XFILLER_65_106 VPWR VGND sg13cmos5l_decap_8
XFILLER_602_42 VPWR VGND sg13cmos5l_decap_8
XFILLER_454_156 VPWR VGND sg13cmos5l_decap_4
XFILLER_58_180 VPWR VGND sg13cmos5l_decap_8
XFILLER_171_84 VPWR VGND sg13cmos5l_decap_8
XFILLER_321_21 VPWR VGND sg13cmos5l_decap_8
XFILLER_552_0 VPWR VGND sg13cmos5l_decap_8
XFILLER_206_112 VPWR VGND sg13cmos5l_decap_8
XFILLER_0_35 VPWR VGND sg13cmos5l_decap_8
XFILLER_80_109 VPWR VGND sg13cmos5l_decap_4
XFILLER_678_35 VPWR VGND sg13cmos5l_decap_8
XFILLER_611_131 VPWR VGND sg13cmos5l_decap_4
XFILLER_73_194 VPWR VGND sg13cmos5l_decap_8
XFILLER_397_14 VPWR VGND sg13cmos5l_decap_8
XFILLER_206_189 VPWR VGND sg13cmos5l_decap_8
XFILLER_367_119 VPWR VGND sg13cmos5l_decap_8
XFILLER_221_137 VPWR VGND sg13cmos5l_fill_2
X_1940_ _1940_/Q Tile_X0Y4_FrameData[17] VGND VPWR Tile_X0Y9_FrameStrobe[0] latch
XANTENNA__3001__X Tile_X0Y5_E2BEG[4] VPWR VGND sg13cmos5l_antennanp
XFILLER_509_135 VPWR VGND sg13cmos5l_fill_1
XFILLER_547_28 VPWR VGND sg13cmos5l_decap_8
XFILLER_9_77 VPWR VGND sg13cmos5l_decap_8
X_1871_ _1871_/Q Tile_X0Y3_FrameData[26] VGND VPWR Tile_X0Y9_FrameStrobe[6] latch
XFILLER_694_56 VPWR VGND sg13cmos5l_decap_8
XFILLER_375_163 VPWR VGND sg13cmos5l_fill_2
XFILLER_174_214 VPWR VGND sg13cmos5l_decap_8
XANTENNA__2840__X Tile_X0Y6_E2BEG[5] VPWR VGND sg13cmos5l_antennanp
XFILLER_80_81 VPWR VGND sg13cmos5l_decap_8
X_3610_ Tile_X0Y9_S2BEG[4] _4832_/X VPWR VGND sg13cmos5l_buf_1
XFILLER_390_100 VPWR VGND sg13cmos5l_decap_8
X_0822_ _0822_/Q Tile_X0Y9_FrameData[9] VGND VPWR Tile_X0Y9_FrameStrobe[4] latch
X_4590_ _4590_/X Tile_X0Y5_W2MID[4] Tile_X0Y5_W2END[4] Tile_X0Y5_W6END[11] _4434_/X
+ _2389_/Q _2388_/Q VPWR VGND sg13cmos5l_mux4_1
XFILLER_524_149 VPWR VGND sg13cmos5l_decap_8
X_3541_ Tile_X0Y9_E2BEGb[7] _4863_/X VPWR VGND sg13cmos5l_buf_1
X_0753_ _0753_/Q Tile_X0Y9_FrameData[14] VGND VPWR Tile_X0Y9_FrameStrobe[2] latch
XFILLER_390_166 VPWR VGND sg13cmos5l_decap_8
XFILLER_331_211 VPWR VGND sg13cmos5l_decap_8
X_3472_ Tile_X0Y1_FrameData_O[30] Tile_X0Y1_FrameData[30] VPWR VGND sg13cmos5l_buf_1
XFILLER_563_49 VPWR VGND sg13cmos5l_decap_8
X_0684_ _0684_/Q Tile_X0Y9_FrameData[19] VGND VPWR Tile_X0Y9_FrameStrobe[0] latch
XFILLER_346_84 VPWR VGND sg13cmos5l_decap_8
XFILLER_142_133 VPWR VGND sg13cmos5l_decap_8
XFILLER_693_112 VPWR VGND sg13cmos5l_decap_8
X_2423_ _2423_/Q Tile_X0Y5_FrameData[14] VGND VPWR Tile_X0Y9_FrameStrobe[7] latch
XFILLER_282_28 VPWR VGND sg13cmos5l_decap_8
XFILLER_288_159 VPWR VGND sg13cmos5l_fill_2
X_2354_ _2354_/Q Tile_X0Y5_FrameData[19] VGND VPWR Tile_X0Y9_FrameStrobe[5] latch
XFILLER_634_201 VPWR VGND sg13cmos5l_fill_2
XFILLER_29_0 VPWR VGND sg13cmos5l_decap_8
XFILLER_296_181 VPWR VGND sg13cmos5l_decap_4
X_1305_ _1305_/Q Tile_X0Y1_FrameData[0] VGND VPWR Tile_X0Y9_FrameStrobe[3] latch
XFILLER_215_77 VPWR VGND sg13cmos5l_decap_8
X_2285_ _2285_/Q Tile_X0Y5_FrameData[24] VGND VPWR Tile_X0Y9_FrameStrobe[3] latch
XFILLER_512_42 VPWR VGND sg13cmos5l_decap_8
X_4024_ _4024_/X Tile_X0Y0_W2MID[5] Tile_X0Y0_W2END[5] Tile_X0Y0_W6END[10] _3857_/X
+ _1129_/Q _1128_/Q VPWR VGND sg13cmos5l_mux4_1
X_1236_ _1236_/Q Tile_X0Y1_FrameData[5] VGND VPWR Tile_X0Y9_FrameStrobe[1] latch
XFILLER_231_21 VPWR VGND sg13cmos5l_decap_8
XFILLER_64_150 VPWR VGND sg13cmos5l_decap_8
X_1167_ _1167_/Q Tile_X0Y0_FrameData[28] VGND VPWR Tile_X0Y9_FrameStrobe[7] latch
XFILLER_588_35 VPWR VGND sg13cmos5l_decap_8
X_0118_ AXI_M_SOC_ARBURST1 _0931_/Q _3772_/X VPWR VGND sg13cmos5l_nor2b_1
X_1098_ _1098_/Q Tile_X0Y0_FrameData[1] VGND VPWR Tile_X0Y9_FrameStrobe[4] latch
XFILLER_358_119 VPWR VGND sg13cmos5l_decap_8
XFILLER_212_126 VPWR VGND sg13cmos5l_decap_8
XFILLER_547_219 VPWR VGND sg13cmos5l_decap_8
X_0049_ AXI_M_SOC_AWCACHE0 _0936_/Q _3685_/X VPWR VGND sg13cmos5l_or2_1
X_4926_ _4926_/X Tile_X0Y9_N1END[2] Tile_X0Y9_N4END[2] _4898_/X _0081_/X _0707_/Q
+ _0706_/Q VPWR VGND sg13cmos5l_mux4_1
XFILLER_100_14 VPWR VGND sg13cmos5l_decap_8
XFILLER_457_28 VPWR VGND sg13cmos5l_decap_8
X_4857_ _4857_/X Tile_X0Y9_W2END[6] AXI_M_SOC_RDATA6 _4903_/X _4902_/X _0829_/Q _0828_/Q
+ VPWR VGND sg13cmos5l_mux4_1
XFILLER_515_105 VPWR VGND sg13cmos5l_decap_4
XANTENNA__2750__X Tile_X0Y3_FrameData_O[8] VPWR VGND sg13cmos5l_antennanp
X_3808_ _3808_/X Tile_X0Y0_W2MID[3] Tile_X0Y0_WW4END[8] _3859_/X _3858_/X _1089_/Q
+ _1088_/Q VPWR VGND sg13cmos5l_mux4_1
XFILLER_366_185 VPWR VGND sg13cmos5l_decap_8
X_4788_ _4788_/X _4711_/X Tile_X0Y9_N2MID[5] _4821_/X _4710_/X _0429_/Q _0428_/Q VPWR
+ VGND sg13cmos5l_mux4_1
XFILLER_381_122 VPWR VGND sg13cmos5l_fill_1
X_3739_ AXI_M_SOC_ARADDR11 Tile_X0Y9_WW4END[3] Tile_X0Y9_WW4END[11] Tile_X0Y9_W6END[11]
+ _4927_/X _0737_/Q _0736_/Q VPWR VGND sg13cmos5l_mux4_1
XFILLER_118_174 VPWR VGND sg13cmos5l_decap_8
XFILLER_109_56 VPWR VGND sg13cmos5l_decap_8
XFILLER_107_7 VPWR VGND sg13cmos5l_decap_8
XFILLER_473_49 VPWR VGND sg13cmos5l_decap_8
XFILLER_256_84 VPWR VGND sg13cmos5l_decap_4
XFILLER_406_21 VPWR VGND sg13cmos5l_decap_8
XFILLER_279_126 VPWR VGND sg13cmos5l_decap_8
XFILLER_133_133 VPWR VGND sg13cmos5l_decap_8
XFILLER_69_49 VPWR VGND sg13cmos5l_decap_8
XFILLER_192_28 VPWR VGND sg13cmos5l_decap_8
XFILLER_684_145 VPWR VGND sg13cmos5l_fill_2
XANTENNA__3581__X Tile_X0Y9_FrameData_O[11] VPWR VGND sg13cmos5l_antennanp
XFILLER_684_189 VPWR VGND sg13cmos5l_decap_4
XFILLER_436_112 VPWR VGND sg13cmos5l_decap_8
XFILLER_703_63 VPWR VGND sg13cmos5l_decap_8
XFILLER_476_7 VPWR VGND sg13cmos5l_decap_8
XFILLER_436_134 VPWR VGND sg13cmos5l_fill_1
XFILLER_125_99 VPWR VGND sg13cmos5l_decap_8
XFILLER_422_42 VPWR VGND sg13cmos5l_decap_8
XFILLER_18_42 VPWR VGND sg13cmos5l_decap_8
XFILLER_141_21 VPWR VGND sg13cmos5l_decap_8
XFILLER_451_137 VPWR VGND sg13cmos5l_decap_8
XANTENNA__2925__X Tile_X0Y8_E2BEGb[1] VPWR VGND sg13cmos5l_antennanp
XFILLER_643_7 VPWR VGND sg13cmos5l_decap_8
XFILLER_498_35 VPWR VGND sg13cmos5l_decap_8
XFILLER_451_159 VPWR VGND sg13cmos5l_decap_4
XFILLER_141_98 VPWR VGND sg13cmos5l_decap_8
XFILLER_349_119 VPWR VGND sg13cmos5l_decap_8
XFILLER_203_137 VPWR VGND sg13cmos5l_decap_8
XFILLER_70_175 VPWR VGND sg13cmos5l_decap_8
XFILLER_648_49 VPWR VGND sg13cmos5l_decap_8
XFILLER_34_85 VPWR VGND sg13cmos5l_decap_8
XFILLER_367_28 VPWR VGND sg13cmos5l_decap_8
XFILLER_211_170 VPWR VGND sg13cmos5l_decap_8
XFILLER_133_0 VPWR VGND sg13cmos5l_decap_8
XANTENNA__3756__X AXI_M_SOC_ARADDR28 VPWR VGND sg13cmos5l_antennanp
XFILLER_297_91 VPWR VGND sg13cmos5l_decap_4
XFILLER_506_105 VPWR VGND sg13cmos5l_decap_8
XFILLER_357_196 VPWR VGND sg13cmos5l_decap_8
XFILLER_300_0 VPWR VGND sg13cmos5l_decap_8
XFILLER_171_217 VPWR VGND sg13cmos5l_decap_8
XFILLER_372_188 VPWR VGND sg13cmos5l_decap_8
XFILLER_171_228 VPWR VGND sg13cmos5l_fill_1
XFILLER_514_171 VPWR VGND sg13cmos5l_decap_4
XFILLER_383_49 VPWR VGND sg13cmos5l_decap_8
XFILLER_166_84 VPWR VGND sg13cmos5l_decap_4
XFILLER_459_215 VPWR VGND sg13cmos5l_fill_2
XFILLER_316_21 VPWR VGND sg13cmos5l_decap_8
XFILLER_124_155 VPWR VGND sg13cmos5l_decap_8
XFILLER_680_14 VPWR VGND sg13cmos5l_decap_8
XANTENNA__3491__X Tile_X0Y1_E6BEG[1] VPWR VGND sg13cmos5l_antennanp
XFILLER_675_167 VPWR VGND sg13cmos5l_decap_8
XFILLER_463_93 VPWR VGND sg13cmos5l_decap_4
XFILLER_680_69 VPWR VGND sg13cmos5l_decap_8
XFILLER_675_189 VPWR VGND sg13cmos5l_decap_8
XFILLER_427_112 VPWR VGND sg13cmos5l_decap_8
XFILLER_22_7 VPWR VGND sg13cmos5l_decap_8
XFILLER_690_137 VPWR VGND sg13cmos5l_decap_4
XFILLER_613_63 VPWR VGND sg13cmos5l_decap_8
XFILLER_332_42 VPWR VGND sg13cmos5l_decap_8
X_2070_ _2070_/Q Tile_X0Y4_FrameData[15] VGND VPWR Tile_X0Y9_FrameStrobe[4] latch
XFILLER_427_189 VPWR VGND sg13cmos5l_decap_8
XFILLER_75_70 VPWR VGND sg13cmos5l_decap_8
XFILLER_588_119 VPWR VGND sg13cmos5l_fill_2
XANTENNA__2835__X Tile_X0Y6_E2BEG[0] VPWR VGND sg13cmos5l_antennanp
X_1021_ _1021_/Q Tile_X0Y0_FrameData[14] VGND VPWR Tile_X0Y9_FrameStrobe[2] latch
XFILLER_689_67 VPWR VGND sg13cmos5l_decap_8
XFILLER_201_35 VPWR VGND sg13cmos5l_decap_8
XFILLER_529_208 VPWR VGND sg13cmos5l_decap_4
XFILLER_61_153 VPWR VGND sg13cmos5l_decap_8
X_2972_ Tile_X0Y8_FrameData_O[12] Tile_X0Y8_FrameData[12] VPWR VGND sg13cmos5l_buf_1
XFILLER_558_49 VPWR VGND sg13cmos5l_decap_8
X_4711_ _4711_/X Tile_X0Y9_W2MID[2] Tile_X0Y9_W2END[2] Tile_X0Y9_W6END[2] _4904_/X
+ _0909_/Q _0908_/Q VPWR VGND sg13cmos5l_mux4_1
X_1923_ _1923_/Q Tile_X0Y3_FrameData[6] VGND VPWR Tile_X0Y9_FrameStrobe[7] latch
XFILLER_277_28 VPWR VGND sg13cmos5l_decap_8
XANTENNA__3666__X AXI_M_SOC_AWADDR27 VPWR VGND sg13cmos5l_antennanp
X_4642_ _4642_/X Tile_X0Y7_WW4END[1] AXI_M_SOC_RDATA17 _4685_/X _4671_/X _0275_/Q
+ _0274_/Q VPWR VGND sg13cmos5l_mux4_1
X_1854_ _1854_/Q Tile_X0Y3_FrameData[11] VGND VPWR Tile_X0Y9_FrameStrobe[5] latch
XFILLER_698_226 VPWR VGND sg13cmos5l_fill_2
X_0805_ _0805_/Q Tile_X0Y9_FrameData[26] VGND VPWR Tile_X0Y9_FrameStrobe[4] latch
X_4573_ _4573_/X _4547_/X Tile_X0Y9_N4END[13] _4546_/X _0153_/X _2485_/Q _2484_/Q
+ VPWR VGND sg13cmos5l_mux4_1
X_1785_ _1785_/Q Tile_X0Y3_FrameData[16] VGND VPWR Tile_X0Y9_FrameStrobe[3] latch
XFILLER_363_188 VPWR VGND sg13cmos5l_decap_8
X_3524_ Tile_X0Y9_E1BEG[2] _4846_/X VPWR VGND sg13cmos5l_buf_1
XFILLER_507_42 VPWR VGND sg13cmos5l_decap_8
X_0736_ _0736_/Q Tile_X0Y9_FrameData[31] VGND VPWR Tile_X0Y9_FrameStrobe[2] latch
XFILLER_293_49 VPWR VGND sg13cmos5l_decap_8
XFILLER_654_70 VPWR VGND sg13cmos5l_decap_8
XFILLER_505_182 VPWR VGND sg13cmos5l_decap_8
XFILLER_226_21 VPWR VGND sg13cmos5l_decap_8
X_3455_ Tile_X0Y1_FrameData_O[13] Tile_X0Y1_FrameData[13] VPWR VGND sg13cmos5l_buf_1
XFILLER_590_14 VPWR VGND sg13cmos5l_decap_8
X_0667_ _0667_/Q Tile_X0Y8_FrameData[4] VGND VPWR Tile_X0Y9_FrameStrobe[7] latch
XFILLER_666_145 VPWR VGND sg13cmos5l_decap_8
XFILLER_666_156 VPWR VGND sg13cmos5l_fill_1
X_2406_ _2406_/Q Tile_X0Y5_FrameData[31] VGND VPWR Tile_X0Y9_FrameStrobe[7] latch
XFILLER_465_207 VPWR VGND sg13cmos5l_decap_8
XFILLER_520_185 VPWR VGND sg13cmos5l_decap_8
X_3386_ Tile_X0Y2_E6BEG[9] _4081_/X VPWR VGND sg13cmos5l_buf_1
X_0598_ _0598_/Q Tile_X0Y8_FrameData[9] VGND VPWR Tile_X0Y9_FrameStrobe[5] latch
XFILLER_666_189 VPWR VGND sg13cmos5l_fill_2
X_2337_ _2337_/Q Tile_X0Y5_FrameData[4] VGND VPWR Tile_X0Y9_FrameStrobe[4] latch
XFILLER_681_137 VPWR VGND sg13cmos5l_decap_8
XFILLER_523_63 VPWR VGND sg13cmos5l_decap_8
XFILLER_284_140 VPWR VGND sg13cmos5l_decap_8
XFILLER_670_91 VPWR VGND sg13cmos5l_fill_2
XFILLER_242_42 VPWR VGND sg13cmos5l_decap_8
X_2268_ _2268_/Q Tile_X0Y5_FrameData[9] VGND VPWR Tile_X0Y9_FrameStrobe[2] latch
XFILLER_418_189 VPWR VGND sg13cmos5l_decap_8
XFILLER_433_126 VPWR VGND sg13cmos5l_decap_8
X_4007_ _4007_/X _4458_/X _4462_/X _4466_/X _4434_/X _2406_/Q _2405_/Q VPWR VGND sg13cmos5l_mux4_1
XFILLER_599_56 VPWR VGND sg13cmos5l_decap_8
XFILLER_579_119 VPWR VGND sg13cmos5l_decap_8
XANTENNA__2745__X Tile_X0Y3_FrameData_O[3] VPWR VGND sg13cmos5l_antennanp
X_1219_ _1219_/Q Tile_X0Y1_FrameData[22] VGND VPWR Tile_X0Y9_FrameStrobe[1] latch
X_2199_ _2199_/Q Tile_X0Y5_FrameData[14] VGND VPWR Tile_X0Y9_FrameStrobe[0] latch
XFILLER_37_172 VPWR VGND sg13cmos5l_fill_2
XFILLER_111_35 VPWR VGND sg13cmos5l_decap_8
XFILLER_52_153 VPWR VGND sg13cmos5l_decap_8
XFILLER_386_225 VPWR VGND sg13cmos5l_decap_4
XFILLER_71_28 VPWR VGND sg13cmos5l_decap_8
XFILLER_468_49 VPWR VGND sg13cmos5l_decap_8
XFILLER_187_28 VPWR VGND sg13cmos5l_decap_8
X_4909_ _4909_/X _4455_/X _4459_/X _4463_/X _4433_/X _2379_/Q _2378_/Q VPWR VGND sg13cmos5l_mux4_1
XANTENNA__3576__X Tile_X0Y9_FrameData_O[6] VPWR VGND sg13cmos5l_antennanp
XFILLER_224_7 VPWR VGND sg13cmos5l_decap_8
XFILLER_484_26 VPWR VGND sg13cmos5l_decap_8
XFILLER_354_133 VPWR VGND sg13cmos5l_decap_8
XFILLER_503_119 VPWR VGND sg13cmos5l_decap_8
XFILLER_4_227 VPWR VGND sg13cmos5l_fill_2
XFILLER_417_42 VPWR VGND sg13cmos5l_decap_8
XFILLER_20_21 VPWR VGND sg13cmos5l_decap_8
XFILLER_564_70 VPWR VGND sg13cmos5l_decap_8
XFILLER_136_21 VPWR VGND sg13cmos5l_decap_8
XFILLER_657_112 VPWR VGND sg13cmos5l_decap_8
XFILLER_657_123 VPWR VGND sg13cmos5l_fill_2
XFILLER_593_7 VPWR VGND sg13cmos5l_decap_8
XFILLER_96_14 VPWR VGND sg13cmos5l_decap_8
XFILLER_310_225 VPWR VGND sg13cmos5l_decap_4
XFILLER_136_98 VPWR VGND sg13cmos5l_decap_8
XFILLER_121_158 VPWR VGND sg13cmos5l_fill_1
XFILLER_650_28 VPWR VGND sg13cmos5l_decap_8
XFILLER_433_63 VPWR VGND sg13cmos5l_decap_8
XFILLER_275_140 VPWR VGND sg13cmos5l_decap_8
XFILLER_580_91 VPWR VGND sg13cmos5l_decap_8
XFILLER_29_63 VPWR VGND sg13cmos5l_decap_8
XFILLER_275_151 VPWR VGND sg13cmos5l_fill_2
XFILLER_152_42 VPWR VGND sg13cmos5l_decap_8
XFILLER_424_126 VPWR VGND sg13cmos5l_decap_8
XFILLER_28_150 VPWR VGND sg13cmos5l_fill_1
XFILLER_290_154 VPWR VGND sg13cmos5l_decap_8
XFILLER_302_56 VPWR VGND sg13cmos5l_decap_8
XFILLER_45_73 VPWR VGND sg13cmos5l_decap_8
XFILLER_250_0 VPWR VGND sg13cmos5l_decap_8
XFILLER_377_214 VPWR VGND sg13cmos5l_decap_8
XFILLER_348_0 VPWR VGND sg13cmos5l_decap_8
XFILLER_578_196 VPWR VGND sg13cmos5l_decap_8
XFILLER_378_49 VPWR VGND sg13cmos5l_decap_8
XFILLER_593_133 VPWR VGND sg13cmos5l_decap_4
XFILLER_675_14 VPWR VGND sg13cmos5l_decap_8
XANTENNA__3486__X Tile_X0Y1_EE4BEG[12] VPWR VGND sg13cmos5l_antennanp
XFILLER_515_0 VPWR VGND sg13cmos5l_decap_8
XFILLER_458_82 VPWR VGND sg13cmos5l_decap_8
XFILLER_61_83 VPWR VGND sg13cmos5l_decap_8
XFILLER_345_133 VPWR VGND sg13cmos5l_decap_8
XFILLER_608_63 VPWR VGND sg13cmos5l_decap_8
XFILLER_144_228 VPWR VGND sg13cmos5l_fill_1
XANTENNA_5 AXI_M_SOC_RDATA13 VPWR VGND sg13cmos5l_antennanp
XFILLER_327_42 VPWR VGND sg13cmos5l_decap_8
XFILLER_6_56 VPWR VGND sg13cmos5l_decap_8
X_1570_ _1570_/Q Tile_X0Y2_FrameData[15] VGND VPWR Tile_X0Y9_FrameStrobe[4] latch
XFILLER_691_35 VPWR VGND sg13cmos5l_decap_8
XFILLER_474_70 VPWR VGND sg13cmos5l_decap_8
XFILLER_360_158 VPWR VGND sg13cmos5l_fill_2
XFILLER_648_112 VPWR VGND sg13cmos5l_decap_8
X_0521_ _0521_/Q Tile_X0Y8_FrameData[22] VGND VPWR Tile_X0Y9_FrameStrobe[3] latch
X_3240_ Tile_X0Y0_FrameData_O[8] Tile_X0Y0_FrameData[8] VPWR VGND sg13cmos5l_buf_1
XFILLER_648_167 VPWR VGND sg13cmos5l_decap_8
XFILLER_301_225 VPWR VGND sg13cmos5l_decap_4
X_0452_ _0452_/Q Tile_X0Y8_FrameData[27] VGND VPWR Tile_X0Y9_FrameStrobe[1] latch
XFILLER_447_218 VPWR VGND sg13cmos5l_fill_1
XFILLER_624_84 VPWR VGND sg13cmos5l_decap_8
XFILLER_502_196 VPWR VGND sg13cmos5l_decap_8
XFILLER_560_28 VPWR VGND sg13cmos5l_decap_8
XFILLER_343_63 VPWR VGND sg13cmos5l_decap_8
X_3171_ Tile_X0Y4_E6BEG[8] _4296_/X VPWR VGND sg13cmos5l_buf_1
X_0383_ _0383_/Q Tile_X0Y7_FrameData[0] VGND VPWR Tile_X0Y9_FrameStrobe[6] latch
XFILLER_266_140 VPWR VGND sg13cmos5l_fill_1
XFILLER_66_212 VPWR VGND sg13cmos5l_fill_2
XFILLER_490_91 VPWR VGND sg13cmos5l_decap_8
X_2122_ _2122_/Q Tile_X0Y4_FrameData[27] VGND VPWR Tile_X0Y9_FrameStrobe[6] latch
XFILLER_266_162 VPWR VGND sg13cmos5l_decap_8
X_2053_ _2053_/Q Tile_X0Y4_FrameData[0] VGND VPWR Tile_X0Y9_FrameStrobe[3] latch
XFILLER_415_148 VPWR VGND sg13cmos5l_fill_1
XFILLER_281_154 VPWR VGND sg13cmos5l_decap_8
XFILLER_212_56 VPWR VGND sg13cmos5l_decap_8
X_1004_ _1004_/Q Tile_X0Y0_FrameData[31] VGND VPWR Tile_X0Y9_FrameStrobe[2] latch
XFILLER_19_194 VPWR VGND sg13cmos5l_decap_4
XFILLER_34_131 VPWR VGND sg13cmos5l_fill_1
XFILLER_281_198 VPWR VGND sg13cmos5l_fill_1
XFILLER_423_170 VPWR VGND sg13cmos5l_decap_8
XFILLER_569_196 VPWR VGND sg13cmos5l_decap_8
XFILLER_288_49 VPWR VGND sg13cmos5l_decap_8
XFILLER_96_0 VPWR VGND sg13cmos5l_decap_8
XFILLER_649_70 VPWR VGND sg13cmos5l_decap_8
X_2955_ Tile_X0Y8_EE4BEG[11] _4755_/X VPWR VGND sg13cmos5l_buf_1
XFILLER_585_14 VPWR VGND sg13cmos5l_decap_8
XANTENNA__3396__X Tile_X0Y2_E2BEGb[7] VPWR VGND sg13cmos5l_antennanp
X_1906_ _1906_/Q Tile_X0Y3_FrameData[23] VGND VPWR Tile_X0Y9_FrameStrobe[7] latch
X_2886_ Tile_X0Y6_FrameData_O[7] Tile_X0Y6_FrameData[7] VPWR VGND sg13cmos5l_buf_1
XFILLER_336_133 VPWR VGND sg13cmos5l_fill_1
X_4625_ _4625_/X Tile_X0Y7_W2END[2] AXI_M_SOC_RDATA18 _4673_/X _4672_/X _0309_/Q _0308_/Q
+ VPWR VGND sg13cmos5l_mux4_1
X_1837_ _1837_/Q Tile_X0Y3_FrameData[28] VGND VPWR Tile_X0Y9_FrameStrobe[5] latch
XFILLER_518_63 VPWR VGND sg13cmos5l_decap_8
XFILLER_336_166 VPWR VGND sg13cmos5l_fill_1
XFILLER_540_203 VPWR VGND sg13cmos5l_decap_8
XFILLER_135_228 VPWR VGND sg13cmos5l_fill_1
XFILLER_665_91 VPWR VGND sg13cmos5l_decap_8
XFILLER_336_188 VPWR VGND sg13cmos5l_fill_2
XFILLER_237_42 VPWR VGND sg13cmos5l_decap_8
X_4556_ _4556_/X _4479_/X _4595_/X _4594_/X _4478_/X _2453_/Q _2452_/Q VPWR VGND sg13cmos5l_mux4_1
X_1768_ _1768_/Q Tile_X0Y3_FrameData[1] VGND VPWR Tile_X0Y9_FrameStrobe[2] latch
XFILLER_384_70 VPWR VGND sg13cmos5l_fill_1
XFILLER_351_147 VPWR VGND sg13cmos5l_decap_8
XFILLER_639_112 VPWR VGND sg13cmos5l_decap_8
XFILLER_237_86 VPWR VGND sg13cmos5l_decap_8
X_3507_ Tile_X0Y1_E2BEGb[5] _3945_/X VPWR VGND sg13cmos5l_buf_1
X_0719_ _0719_/Q Tile_X0Y9_FrameData[16] VGND VPWR Tile_X0Y9_FrameStrobe[1] latch
X_4487_ _4487_/X _4573_/X _4577_/X _4581_/X _4556_/X _2632_/Q _2631_/Q VPWR VGND sg13cmos5l_mux4_1
X_1699_ _1699_/Q Tile_X0Y3_FrameData[6] VGND VPWR Tile_X0Y9_FrameStrobe[0] latch
XFILLER_103_114 VPWR VGND sg13cmos5l_decap_4
XFILLER_103_125 VPWR VGND sg13cmos5l_fill_2
X_3438_ Tile_X0Y4_FrameData_O[29] Tile_X0Y4_FrameData[29] VPWR VGND sg13cmos5l_buf_1
XFILLER_639_189 VPWR VGND sg13cmos5l_fill_2
XFILLER_106_35 VPWR VGND sg13cmos5l_decap_8
XFILLER_654_126 VPWR VGND sg13cmos5l_decap_8
XFILLER_470_28 VPWR VGND sg13cmos5l_decap_8
XFILLER_253_63 VPWR VGND sg13cmos5l_decap_8
X_3369_ Tile_X0Y2_EE4BEG[8] _4064_/X VPWR VGND sg13cmos5l_buf_1
XFILLER_57_201 VPWR VGND sg13cmos5l_decap_8
XFILLER_57_212 VPWR VGND sg13cmos5l_fill_1
XFILLER_257_151 VPWR VGND sg13cmos5l_fill_2
XFILLER_406_104 VPWR VGND sg13cmos5l_decap_8
XFILLER_111_191 VPWR VGND sg13cmos5l_decap_4
XFILLER_403_77 VPWR VGND sg13cmos5l_decap_8
XFILLER_174_7 VPWR VGND sg13cmos5l_decap_8
XFILLER_272_165 VPWR VGND sg13cmos5l_fill_1
XFILLER_122_56 VPWR VGND sg13cmos5l_decap_8
XFILLER_82_49 VPWR VGND sg13cmos5l_decap_8
XFILLER_700_86 VPWR VGND sg13cmos5l_decap_8
XFILLER_709_105 VPWR VGND sg13cmos5l_decap_8
XFILLER_359_225 VPWR VGND sg13cmos5l_decap_4
XFILLER_341_7 VPWR VGND sg13cmos5l_decap_8
XFILLER_15_21 VPWR VGND sg13cmos5l_decap_8
XFILLER_439_7 VPWR VGND sg13cmos5l_decap_8
XFILLER_198_49 VPWR VGND sg13cmos5l_decap_8
XFILLER_575_133 VPWR VGND sg13cmos5l_decap_8
XFILLER_559_70 VPWR VGND sg13cmos5l_decap_8
XFILLER_495_14 VPWR VGND sg13cmos5l_decap_8
XFILLER_15_98 VPWR VGND sg13cmos5l_decap_4
XFILLER_606_7 VPWR VGND sg13cmos5l_decap_8
XFILLER_590_125 VPWR VGND sg13cmos5l_decap_8
XFILLER_40_189 VPWR VGND sg13cmos5l_decap_8
XFILLER_709_84 VPWR VGND sg13cmos5l_decap_8
XFILLER_31_31 VPWR VGND sg13cmos5l_decap_8
XFILLER_645_28 VPWR VGND sg13cmos5l_decap_8
XFILLER_428_63 VPWR VGND sg13cmos5l_decap_8
XFILLER_126_228 VPWR VGND sg13cmos5l_fill_1
XFILLER_575_91 VPWR VGND sg13cmos5l_decap_8
XFILLER_193_183 VPWR VGND sg13cmos5l_decap_8
XFILLER_342_125 VPWR VGND sg13cmos5l_fill_1
XFILLER_147_42 VPWR VGND sg13cmos5l_decap_8
XFILLER_342_147 VPWR VGND sg13cmos5l_decap_4
XFILLER_294_70 VPWR VGND sg13cmos5l_decap_8
XFILLER_496_140 VPWR VGND sg13cmos5l_decap_8
XFILLER_295_213 VPWR VGND sg13cmos5l_fill_1
XFILLER_661_49 VPWR VGND sg13cmos5l_decap_8
XFILLER_444_84 VPWR VGND sg13cmos5l_decap_8
XFILLER_645_126 VPWR VGND sg13cmos5l_decap_8
XFILLER_380_28 VPWR VGND sg13cmos5l_decap_8
XFILLER_298_0 VPWR VGND sg13cmos5l_decap_8
XFILLER_163_63 VPWR VGND sg13cmos5l_decap_4
XFILLER_48_223 VPWR VGND sg13cmos5l_decap_4
XFILLER_248_173 VPWR VGND sg13cmos5l_decap_8
XFILLER_102_180 VPWR VGND sg13cmos5l_decap_8
XFILLER_248_195 VPWR VGND sg13cmos5l_fill_1
XFILLER_465_0 VPWR VGND sg13cmos5l_decap_8
XFILLER_598_225 VPWR VGND sg13cmos5l_decap_4
XFILLER_610_42 VPWR VGND sg13cmos5l_decap_8
XFILLER_56_94 VPWR VGND sg13cmos5l_decap_8
XFILLER_601_218 VPWR VGND sg13cmos5l_decap_4
XFILLER_632_0 VPWR VGND sg13cmos5l_decap_8
XFILLER_686_35 VPWR VGND sg13cmos5l_decap_8
XFILLER_469_70 VPWR VGND sg13cmos5l_decap_8
XFILLER_566_133 VPWR VGND sg13cmos5l_decap_8
XFILLER_31_167 VPWR VGND sg13cmos5l_decap_8
X_2740_ Tile_X0Y4_E1BEG[3] _4255_/X VPWR VGND sg13cmos5l_buf_1
XFILLER_169_191 VPWR VGND sg13cmos5l_decap_8
XFILLER_708_182 VPWR VGND sg13cmos5l_decap_4
XFILLER_619_84 VPWR VGND sg13cmos5l_decap_8
XFILLER_581_147 VPWR VGND sg13cmos5l_decap_8
XFILLER_708_193 VPWR VGND sg13cmos5l_decap_8
XFILLER_555_28 VPWR VGND sg13cmos5l_decap_8
X_2671_ _2671_/Q Tile_X0Y6_FrameData[24] VGND VPWR Tile_X0Y9_FrameStrobe[7] latch
XFILLER_338_63 VPWR VGND sg13cmos5l_decap_8
XFILLER_184_172 VPWR VGND sg13cmos5l_decap_8
X_4410_ _4410_/X AXI_M_SOC_RRESP0 _4456_/X _4460_/X _4432_/X _2283_/Q _2282_/Q VPWR
+ VGND sg13cmos5l_mux4_1
XFILLER_522_214 VPWR VGND sg13cmos5l_decap_4
XFILLER_485_91 VPWR VGND sg13cmos5l_decap_8
X_1622_ _1622_/Q Tile_X0Y2_FrameData[27] VGND VPWR Tile_X0Y9_FrameStrobe[6] latch
X_4341_ _4341_/X _4305_/X _0158_/X _4304_/X _0111_/X _1971_/Q _1970_/Q VPWR VGND sg13cmos5l_mux4_1
X_1553_ _1553_/Q Tile_X0Y2_FrameData[0] VGND VPWR Tile_X0Y9_FrameStrobe[3] latch
XFILLER_207_56 VPWR VGND sg13cmos5l_decap_8
XFILLER_98_134 VPWR VGND sg13cmos5l_decap_4
X_0504_ _0504_/Q Tile_X0Y8_FrameData[7] VGND VPWR Tile_X0Y9_FrameStrobe[2] latch
X_4272_ _4272_/X Tile_X0Y4_WW4END[15] AXI_M_SOC_BRESP0 _4351_/X _4312_/X _2069_/Q
+ _2068_/Q VPWR VGND sg13cmos5l_mux4_1
X_1484_ _1484_/Q Tile_X0Y2_FrameData[5] VGND VPWR Tile_X0Y9_FrameStrobe[1] latch
XFILLER_571_49 VPWR VGND sg13cmos5l_decap_8
XFILLER_354_84 VPWR VGND sg13cmos5l_decap_8
XFILLER_504_21 VPWR VGND sg13cmos5l_decap_8
XFILLER_636_126 VPWR VGND sg13cmos5l_decap_4
X_3223_ Tile_X0Y0_FrameStrobe_O[11] Tile_X0Y9_FrameStrobe[11] VPWR VGND sg13cmos5l_buf_1
XFILLER_290_28 VPWR VGND sg13cmos5l_decap_8
X_0435_ _0435_/Q Tile_X0Y8_FrameData[12] VGND VPWR Tile_X0Y9_FrameStrobe[0] latch
XFILLER_39_223 VPWR VGND sg13cmos5l_decap_4
XFILLER_100_139 VPWR VGND sg13cmos5l_fill_1
X_3154_ Tile_X0Y7_FrameData_O[24] Tile_X0Y7_FrameData[24] VPWR VGND sg13cmos5l_buf_1
X_0366_ _0366_/Q Tile_X0Y7_FrameData[17] VGND VPWR Tile_X0Y9_FrameStrobe[6] latch
XFILLER_504_98 VPWR VGND sg13cmos5l_decap_8
XFILLER_11_0 VPWR VGND sg13cmos5l_decap_8
X_2105_ _2105_/Q Tile_X0Y4_FrameData[12] VGND VPWR Tile_X0Y9_FrameStrobe[5] latch
XFILLER_223_77 VPWR VGND sg13cmos5l_decap_8
XFILLER_589_225 VPWR VGND sg13cmos5l_decap_4
X_3085_ Tile_X0Y7_E1BEG[3] _4611_/X VPWR VGND sg13cmos5l_buf_1
X_0297_ _0297_/Q Tile_X0Y7_FrameData[22] VGND VPWR Tile_X0Y9_FrameStrobe[4] latch
XFILLER_520_42 VPWR VGND sg13cmos5l_decap_8
X_2036_ _2036_/Q Tile_X0Y4_FrameData[17] VGND VPWR Tile_X0Y9_FrameStrobe[3] latch
XFILLER_596_35 VPWR VGND sg13cmos5l_decap_8
XFILLER_557_133 VPWR VGND sg13cmos5l_fill_1
XFILLER_379_70 VPWR VGND sg13cmos5l_decap_8
XFILLER_379_92 VPWR VGND sg13cmos5l_decap_4
XFILLER_210_213 VPWR VGND sg13cmos5l_decap_4
X_3987_ _3987_/X Tile_X0Y2_W1END[3] Tile_X0Y2_W6END[7] _4104_/X _4087_/X _1667_/Q
+ _1666_/Q VPWR VGND sg13cmos5l_mux4_1
XFILLER_356_217 VPWR VGND sg13cmos5l_fill_2
XFILLER_706_119 VPWR VGND sg13cmos5l_decap_8
XFILLER_309_100 VPWR VGND sg13cmos5l_decap_8
X_2938_ Tile_X0Y8_E6BEG[6] _4766_/X VPWR VGND sg13cmos5l_buf_1
XFILLER_572_147 VPWR VGND sg13cmos5l_decap_8
XFILLER_714_141 VPWR VGND sg13cmos5l_decap_8
XFILLER_465_28 VPWR VGND sg13cmos5l_decap_8
XFILLER_248_63 VPWR VGND sg13cmos5l_decap_8
X_2869_ Tile_X0Y6_EE4BEG[6] _4518_/X VPWR VGND sg13cmos5l_buf_1
XFILLER_309_188 VPWR VGND sg13cmos5l_fill_2
X_4608_ _4608_/X _4661_/X _4660_/X AXI_M_SOC_RDATA19 AXI_M_SOC_RDATA23 _0343_/Q _0342_/Q
+ VPWR VGND sg13cmos5l_mux4_1
XFILLER_324_136 VPWR VGND sg13cmos5l_fill_2
X_4539_ _4539_/X AXI_M_SOC_RDATA31 _4568_/X _4572_/X _4552_/X _2529_/Q _2528_/Q VPWR
+ VGND sg13cmos5l_mux4_1
XFILLER_190_197 VPWR VGND sg13cmos5l_decap_8
XFILLER_277_202 VPWR VGND sg13cmos5l_fill_1
XFILLER_117_56 VPWR VGND sg13cmos5l_decap_8
XFILLER_481_49 VPWR VGND sg13cmos5l_decap_8
XFILLER_77_49 VPWR VGND sg13cmos5l_decap_8
XFILLER_414_21 VPWR VGND sg13cmos5l_decap_8
XFILLER_291_7 VPWR VGND sg13cmos5l_decap_8
XFILLER_627_148 VPWR VGND sg13cmos5l_decap_4
XFILLER_493_154 VPWR VGND sg13cmos5l_decap_8
XFILLER_389_7 VPWR VGND sg13cmos5l_decap_8
XFILLER_292_216 VPWR VGND sg13cmos5l_fill_1
XFILLER_414_98 VPWR VGND sg13cmos5l_fill_2
XFILLER_711_63 VPWR VGND sg13cmos5l_decap_8
XFILLER_635_192 VPWR VGND sg13cmos5l_fill_2
XFILLER_133_77 VPWR VGND sg13cmos5l_decap_8
XFILLER_556_7 VPWR VGND sg13cmos5l_decap_8
XFILLER_650_140 VPWR VGND sg13cmos5l_decap_8
XFILLER_430_42 VPWR VGND sg13cmos5l_decap_8
XFILLER_26_42 VPWR VGND sg13cmos5l_decap_8
XFILLER_260_124 VPWR VGND sg13cmos5l_decap_4
XFILLER_260_135 VPWR VGND sg13cmos5l_decap_8
XFILLER_595_228 VPWR VGND sg13cmos5l_fill_1
XANTENNA__2933__X Tile_X0Y8_E6BEG[1] VPWR VGND sg13cmos5l_antennanp
XFILLER_289_70 VPWR VGND sg13cmos5l_decap_8
XFILLER_548_144 VPWR VGND sg13cmos5l_decap_4
XFILLER_201_213 VPWR VGND sg13cmos5l_fill_2
XFILLER_402_173 VPWR VGND sg13cmos5l_decap_8
XFILLER_9_105 VPWR VGND sg13cmos5l_decap_8
XFILLER_347_217 VPWR VGND sg13cmos5l_decap_4
XFILLER_548_177 VPWR VGND sg13cmos5l_fill_1
XFILLER_548_199 VPWR VGND sg13cmos5l_decap_8
XFILLER_656_49 VPWR VGND sg13cmos5l_decap_8
XFILLER_439_84 VPWR VGND sg13cmos5l_decap_8
XFILLER_42_63 VPWR VGND sg13cmos5l_decap_8
XFILLER_375_28 VPWR VGND sg13cmos5l_decap_8
XFILLER_158_63 VPWR VGND sg13cmos5l_decap_4
XFILLER_158_74 VPWR VGND sg13cmos5l_decap_8
XFILLER_213_0 VPWR VGND sg13cmos5l_decap_8
XFILLER_181_120 VPWR VGND sg13cmos5l_fill_1
XFILLER_330_106 VPWR VGND sg13cmos5l_decap_8
XFILLER_330_117 VPWR VGND sg13cmos5l_fill_2
XFILLER_605_42 VPWR VGND sg13cmos5l_decap_8
XFILLER_391_49 VPWR VGND sg13cmos5l_decap_8
XFILLER_323_191 VPWR VGND sg13cmos5l_decap_4
XFILLER_582_0 VPWR VGND sg13cmos5l_decap_8
XFILLER_3_35 VPWR VGND sg13cmos5l_decap_8
XFILLER_324_21 VPWR VGND sg13cmos5l_decap_8
X_0220_ _0220_/Q Tile_X0Y7_FrameData[3] VGND VPWR Tile_X0Y9_FrameStrobe[1] latch
XFILLER_67_93 VPWR VGND sg13cmos5l_decap_8
XFILLER_236_121 VPWR VGND sg13cmos5l_decap_8
XFILLER_236_143 VPWR VGND sg13cmos5l_fill_1
X_0151_ AXI_M_SOC_AWLEN2 _0940_/Q _3673_/X VPWR VGND sg13cmos5l_nor2b_1
XFILLER_621_63 VPWR VGND sg13cmos5l_decap_8
XANTENNA__3004__X Tile_X0Y5_E2BEG[7] VPWR VGND sg13cmos5l_antennanp
XFILLER_641_140 VPWR VGND sg13cmos5l_decap_8
XFILLER_236_165 VPWR VGND sg13cmos5l_decap_8
XFILLER_251_113 VPWR VGND sg13cmos5l_decap_4
X_0082_ _0082_/X _4910_/X _4911_/X _2374_/Q VPWR VGND sg13cmos5l_mux2_1
XFILLER_51_207 VPWR VGND sg13cmos5l_decap_8
XFILLER_340_75 VPWR VGND sg13cmos5l_decap_8
XFILLER_697_56 VPWR VGND sg13cmos5l_decap_8
XANTENNA__2843__X Tile_X0Y6_E2BEGb[0] VPWR VGND sg13cmos5l_antennanp
X_3910_ _3910_/X Tile_X0Y1_W1END[0] Tile_X0Y1_WW4END[0] Tile_X0Y1_W6END[8] _4008_/X
+ _1401_/Q _1400_/Q VPWR VGND sg13cmos5l_mux4_1
X_4890_ _4890_/X AXI_M_SOC_RDATA6 _4917_/X _4921_/X _4902_/X _0763_/Q _0762_/Q VPWR
+ VGND sg13cmos5l_mux4_1
XFILLER_539_122 VPWR VGND sg13cmos5l_fill_2
XFILLER_199_70 VPWR VGND sg13cmos5l_decap_8
X_3841_ _3841_/X Tile_X0Y0_W6END[1] _3887_/X _3868_/X _3855_/X _1023_/Q _1022_/Q VPWR
+ VGND sg13cmos5l_mux4_1
XFILLER_149_117 VPWR VGND sg13cmos5l_fill_1
XFILLER_338_228 VPWR VGND sg13cmos5l_fill_1
XFILLER_539_199 VPWR VGND sg13cmos5l_fill_1
X_3772_ _3772_/X Tile_X0Y0_WW4END[1] Tile_X0Y0_WW4END[9] Tile_X0Y0_W6END[1] _3882_/X
+ _1007_/Q _1006_/Q VPWR VGND sg13cmos5l_mux4_1
X_0984_ _0984_/Q Tile_X0Y0_FrameData[19] VGND VPWR Tile_X0Y9_FrameStrobe[1] latch
XFILLER_566_49 VPWR VGND sg13cmos5l_decap_8
XFILLER_349_84 VPWR VGND sg13cmos5l_decap_8
XFILLER_353_209 VPWR VGND sg13cmos5l_fill_1
X_2723_ _4540_/A3 VPWR VGND sg13cmos5l_tielo
XFILLER_285_28 VPWR VGND sg13cmos5l_decap_8
XFILLER_157_172 VPWR VGND sg13cmos5l_decap_4
X_2654_ _2654_/Q Tile_X0Y6_FrameData[9] VGND VPWR Tile_X0Y9_FrameStrobe[6] latch
XFILLER_711_133 VPWR VGND sg13cmos5l_decap_8
XFILLER_59_0 VPWR VGND sg13cmos5l_fill_1
X_1605_ _1605_/Q Tile_X0Y2_FrameData[12] VGND VPWR Tile_X0Y9_FrameStrobe[5] latch
XFILLER_218_77 VPWR VGND sg13cmos5l_decap_8
X_2585_ _2585_/Q Tile_X0Y6_FrameData[14] VGND VPWR Tile_X0Y9_FrameStrobe[4] latch
X_4324_ _4324_/X Tile_X0Y0_W1END[1] Tile_X0Y0_WW4END[13] Tile_X0Y0_W6END[5] _3882_/X
+ _1114_/Q _1113_/Q VPWR VGND sg13cmos5l_mux4_1
XFILLER_515_42 VPWR VGND sg13cmos5l_decap_8
X_1536_ _1536_/Q Tile_X0Y2_FrameData[17] VGND VPWR Tile_X0Y9_FrameStrobe[3] latch
XFILLER_662_70 VPWR VGND sg13cmos5l_decap_8
XFILLER_234_21 VPWR VGND sg13cmos5l_decap_8
X_4255_ _4255_/X _4311_/X _4310_/X AXI_M_SOC_BRESP0 _4309_/X _2103_/Q _2102_/Q VPWR
+ VGND sg13cmos5l_mux4_1
X_1467_ _1467_/Q Tile_X0Y2_FrameData[22] VGND VPWR Tile_X0Y9_FrameStrobe[1] latch
X_3206_ Tile_X0Y0_N2BEG[6] _3790_/X VPWR VGND sg13cmos5l_buf_1
X_0418_ _0418_/Q Tile_X0Y8_FrameData[29] VGND VPWR Tile_X0Y9_FrameStrobe[0] latch
X_4186_ _4186_/X AXI_M_SOC_WREADY _4227_/X _4231_/X _4209_/X _1769_/Q _1768_/Q VPWR
+ VGND sg13cmos5l_mux4_1
X_1398_ _1398_/Q Tile_X0Y1_FrameData[3] VGND VPWR Tile_X0Y9_FrameStrobe[6] latch
XFILLER_416_210 VPWR VGND sg13cmos5l_fill_2
X_3137_ Tile_X0Y7_FrameData_O[7] Tile_X0Y7_FrameData[7] VPWR VGND sg13cmos5l_buf_1
XFILLER_531_63 VPWR VGND sg13cmos5l_decap_8
X_0349_ _0349_/Q Tile_X0Y7_FrameData[2] VGND VPWR Tile_X0Y9_FrameStrobe[5] latch
XFILLER_227_154 VPWR VGND sg13cmos5l_fill_2
XFILLER_103_14 VPWR VGND sg13cmos5l_decap_8
XFILLER_250_42 VPWR VGND sg13cmos5l_decap_8
X_3068_ Tile_X0Y5_FrameData_O[27] Tile_X0Y5_FrameData[27] VPWR VGND sg13cmos5l_buf_1
XANTENNA__2753__X Tile_X0Y3_FrameData_O[11] VPWR VGND sg13cmos5l_antennanp
X_2019_ _2019_/Q Tile_X0Y4_FrameData[2] VGND VPWR Tile_X0Y9_FrameStrobe[2] latch
XFILLER_400_56 VPWR VGND sg13cmos5l_decap_8
XFILLER_545_136 VPWR VGND sg13cmos5l_decap_8
XFILLER_476_49 VPWR VGND sg13cmos5l_decap_8
XFILLER_137_7 VPWR VGND sg13cmos5l_decap_8
XFILLER_10_126 VPWR VGND sg13cmos5l_fill_1
XFILLER_409_21 VPWR VGND sg13cmos5l_decap_8
XFILLER_195_28 VPWR VGND sg13cmos5l_decap_8
XANTENNA__3584__X Tile_X0Y9_FrameData_O[14] VPWR VGND sg13cmos5l_antennanp
XFILLER_304_7 VPWR VGND sg13cmos5l_decap_8
XFILLER_553_191 VPWR VGND sg13cmos5l_decap_4
XFILLER_12_77 VPWR VGND sg13cmos5l_decap_8
XFILLER_163_175 VPWR VGND sg13cmos5l_fill_1
XFILLER_706_63 VPWR VGND sg13cmos5l_decap_8
XFILLER_501_217 VPWR VGND sg13cmos5l_decap_8
XFILLER_501_228 VPWR VGND sg13cmos5l_fill_1
XFILLER_425_42 VPWR VGND sg13cmos5l_decap_8
XFILLER_655_210 VPWR VGND sg13cmos5l_decap_4
XFILLER_572_70 VPWR VGND sg13cmos5l_decap_8
XFILLER_655_221 VPWR VGND sg13cmos5l_fill_1
XFILLER_144_21 VPWR VGND sg13cmos5l_decap_8
XANTENNA__2928__X Tile_X0Y8_E2BEGb[4] VPWR VGND sg13cmos5l_antennanp
XFILLER_673_7 VPWR VGND sg13cmos5l_decap_8
XFILLER_77_148 VPWR VGND sg13cmos5l_fill_1
XFILLER_466_176 VPWR VGND sg13cmos5l_decap_8
XFILLER_144_98 VPWR VGND sg13cmos5l_decap_8
XFILLER_18_204 VPWR VGND sg13cmos5l_decap_8
XFILLER_441_63 VPWR VGND sg13cmos5l_decap_8
XFILLER_85_170 VPWR VGND sg13cmos5l_fill_2
XFILLER_37_52 VPWR VGND sg13cmos5l_decap_8
XFILLER_233_102 VPWR VGND sg13cmos5l_decap_8
XFILLER_160_42 VPWR VGND sg13cmos5l_decap_8
XFILLER_623_173 VPWR VGND sg13cmos5l_decap_4
XFILLER_163_0 VPWR VGND sg13cmos5l_decap_8
XANTENNA__3759__X AXI_M_SOC_ARADDR31 VPWR VGND sg13cmos5l_antennanp
XFILLER_160_97 VPWR VGND sg13cmos5l_decap_8
XFILLER_310_56 VPWR VGND sg13cmos5l_decap_8
XFILLER_330_0 VPWR VGND sg13cmos5l_decap_8
XFILLER_428_0 VPWR VGND sg13cmos5l_decap_8
XFILLER_386_49 VPWR VGND sg13cmos5l_decap_8
XFILLER_169_84 VPWR VGND sg13cmos5l_decap_8
XFILLER_319_21 VPWR VGND sg13cmos5l_decap_8
XFILLER_139_161 VPWR VGND sg13cmos5l_decap_8
XFILLER_683_14 VPWR VGND sg13cmos5l_decap_8
XANTENNA__3494__X Tile_X0Y1_E6BEG[4] VPWR VGND sg13cmos5l_antennanp
XFILLER_489_213 VPWR VGND sg13cmos5l_fill_2
XFILLER_343_220 VPWR VGND sg13cmos5l_fill_2
XFILLER_303_106 VPWR VGND sg13cmos5l_fill_1
XFILLER_154_175 VPWR VGND sg13cmos5l_fill_2
XFILLER_616_63 VPWR VGND sg13cmos5l_decap_8
XFILLER_335_42 VPWR VGND sg13cmos5l_decap_8
X_2370_ _2370_/Q Tile_X0Y5_FrameData[3] VGND VPWR Tile_X0Y9_FrameStrobe[5] latch
XFILLER_482_70 VPWR VGND sg13cmos5l_decap_8
XFILLER_646_210 VPWR VGND sg13cmos5l_decap_8
XFILLER_457_121 VPWR VGND sg13cmos5l_decap_4
X_1321_ _1321_/Q Tile_X0Y1_FrameData[16] VGND VPWR Tile_X0Y9_FrameStrobe[4] latch
XANTENNA__2838__X Tile_X0Y6_E2BEG[3] VPWR VGND sg13cmos5l_antennanp
X_4040_ _4040_/X Tile_X0Y2_W2MID[7] AXI_M_SOC_AWREADY _4097_/X _4096_/X _1593_/Q _1592_/Q
+ VPWR VGND sg13cmos5l_mux4_1
X_1252_ _1252_/Q Tile_X0Y1_FrameData[21] VGND VPWR Tile_X0Y9_FrameStrobe[2] latch
XFILLER_457_187 VPWR VGND sg13cmos5l_fill_2
XFILLER_632_84 VPWR VGND sg13cmos5l_decap_8
XFILLER_204_35 VPWR VGND sg13cmos5l_decap_8
X_0203_ _0203_/Q Tile_X0Y7_FrameData[20] VGND VPWR Tile_X0Y9_FrameStrobe[1] latch
XFILLER_351_63 VPWR VGND sg13cmos5l_decap_8
X_1183_ _1183_/Q Tile_X0Y1_FrameData[26] VGND VPWR Tile_X0Y9_FrameStrobe[0] latch
XFILLER_209_154 VPWR VGND sg13cmos5l_decap_8
XFILLER_94_91 VPWR VGND sg13cmos5l_decap_8
X_0134_ AXI_M_SOC_AWLEN4 _0940_/Q _3675_/X VPWR VGND sg13cmos5l_nor2b_1
XANTENNA__3669__X AXI_M_SOC_AWADDR30 VPWR VGND sg13cmos5l_antennanp
XFILLER_501_77 VPWR VGND sg13cmos5l_decap_8
X_0065_ _3627_/A _4602_/X _4603_/X _0350_/Q VPWR VGND sg13cmos5l_mux2_1
XFILLER_220_56 VPWR VGND sg13cmos5l_decap_8
XFILLER_177_201 VPWR VGND sg13cmos5l_decap_8
X_4873_ _4873_/X Tile_X0Y9_WW4END[6] AXI_M_SOC_RDATA6 _4922_/X _4902_/X _0797_/Q _0796_/Q
+ VPWR VGND sg13cmos5l_mux4_1
X_3824_ _3824_/X Tile_X0Y0_WW4END[8] Tile_X0Y0_WW4END[11] _3864_/X _3859_/X _1057_/Q
+ _1056_/Q VPWR VGND sg13cmos5l_mux4_1
XFILLER_527_147 VPWR VGND sg13cmos5l_fill_2
XFILLER_296_49 VPWR VGND sg13cmos5l_decap_8
XFILLER_657_70 VPWR VGND sg13cmos5l_decap_8
XFILLER_229_21 VPWR VGND sg13cmos5l_decap_8
XFILLER_192_215 VPWR VGND sg13cmos5l_decap_8
X_3755_ AXI_M_SOC_ARADDR27 Tile_X0Y8_WW4END[3] Tile_X0Y8_WW4END[11] Tile_X0Y8_W6END[11]
+ _4811_/X _0481_/Q _0480_/Q VPWR VGND sg13cmos5l_mux4_1
XFILLER_593_14 VPWR VGND sg13cmos5l_decap_8
X_0967_ _0967_/Q Tile_X0Y0_FrameData[4] VGND VPWR Tile_X0Y9_FrameStrobe[0] latch
X_2706_ _4198_/A3 VPWR VGND sg13cmos5l_tielo
X_3686_ _3686_/X Tile_X0Y3_WW4END[4] Tile_X0Y3_WW4END[12] Tile_X0Y3_W6END[4] _4226_/X
+ _1749_/Q _1748_/Q VPWR VGND sg13cmos5l_mux4_1
X_0898_ _0898_/Q Tile_X0Y9_FrameData[29] VGND VPWR Tile_X0Y9_FrameStrobe[7] latch
X_2637_ _2637_/Q Tile_X0Y6_FrameData[26] VGND VPWR Tile_X0Y9_FrameStrobe[6] latch
XFILLER_526_63 VPWR VGND sg13cmos5l_decap_8
XFILLER_495_205 VPWR VGND sg13cmos5l_decap_8
XFILLER_245_42 VPWR VGND sg13cmos5l_decap_8
X_2568_ _2568_/Q Tile_X0Y6_FrameData[31] VGND VPWR Tile_X0Y9_FrameStrobe[4] latch
XFILLER_448_110 VPWR VGND sg13cmos5l_decap_8
XFILLER_59_104 VPWR VGND sg13cmos5l_decap_8
XANTENNA__2748__X Tile_X0Y3_FrameData_O[6] VPWR VGND sg13cmos5l_antennanp
X_1519_ _1519_/Q Tile_X0Y2_FrameData[2] VGND VPWR Tile_X0Y9_FrameStrobe[2] latch
X_4307_ _4307_/X Tile_X0Y3_W1END[2] Tile_X0Y3_W6END[10] _4215_/X _4192_/X _1885_/Q
+ _1884_/Q VPWR VGND sg13cmos5l_mux4_1
X_2499_ _2499_/Q Tile_X0Y6_FrameData[4] VGND VPWR Tile_X0Y9_FrameStrobe[1] latch
X_4238_ _4238_/X Tile_X0Y2_W2MID[6] Tile_X0Y2_W2END[6] Tile_X0Y2_W6END[9] _4099_/X
+ _1627_/Q _1626_/Q VPWR VGND sg13cmos5l_mux4_1
XFILLER_542_84 VPWR VGND sg13cmos5l_fill_2
XFILLER_114_35 VPWR VGND sg13cmos5l_decap_8
XFILLER_262_208 VPWR VGND sg13cmos5l_fill_2
XFILLER_261_63 VPWR VGND sg13cmos5l_decap_8
X_4169_ _4169_/X Tile_X0Y3_WW4END[10] AXI_M_SOC_BVALID _4232_/X _4209_/X _1803_/Q
+ _1802_/Q VPWR VGND sg13cmos5l_mux4_1
XFILLER_67_170 VPWR VGND sg13cmos5l_decap_8
XFILLER_74_28 VPWR VGND sg13cmos5l_decap_8
XFILLER_471_190 VPWR VGND sg13cmos5l_fill_1
XANTENNA__3579__X Tile_X0Y9_FrameData_O[9] VPWR VGND sg13cmos5l_antennanp
XFILLER_411_77 VPWR VGND sg13cmos5l_decap_8
XFILLER_411_88 VPWR VGND sg13cmos5l_fill_2
XFILLER_254_7 VPWR VGND sg13cmos5l_decap_8
XFILLER_620_154 VPWR VGND sg13cmos5l_decap_4
XFILLER_130_56 VPWR VGND sg13cmos5l_decap_8
XFILLER_90_49 VPWR VGND sg13cmos5l_decap_4
XFILLER_369_183 VPWR VGND sg13cmos5l_decap_8
XFILLER_421_7 VPWR VGND sg13cmos5l_decap_8
XFILLER_23_21 VPWR VGND sg13cmos5l_decap_8
XFILLER_519_7 VPWR VGND sg13cmos5l_decap_8
XFILLER_567_70 VPWR VGND sg13cmos5l_decap_8
XFILLER_317_209 VPWR VGND sg13cmos5l_fill_2
XFILLER_183_204 VPWR VGND sg13cmos5l_fill_1
XFILLER_139_21 VPWR VGND sg13cmos5l_decap_8
XFILLER_384_186 VPWR VGND sg13cmos5l_fill_2
XFILLER_183_226 VPWR VGND sg13cmos5l_fill_2
XFILLER_99_14 VPWR VGND sg13cmos5l_decap_8
XFILLER_325_220 VPWR VGND sg13cmos5l_decap_8
XFILLER_139_98 VPWR VGND sg13cmos5l_decap_8
XFILLER_717_95 VPWR VGND sg13cmos5l_decap_8
XFILLER_653_28 VPWR VGND sg13cmos5l_decap_8
XFILLER_151_101 VPWR VGND sg13cmos5l_fill_2
XFILLER_136_175 VPWR VGND sg13cmos5l_decap_8
XFILLER_541_161 VPWR VGND sg13cmos5l_decap_8
XFILLER_436_63 VPWR VGND sg13cmos5l_decap_8
XFILLER_340_212 VPWR VGND sg13cmos5l_decap_8
XFILLER_687_165 VPWR VGND sg13cmos5l_fill_1
XFILLER_583_91 VPWR VGND sg13cmos5l_decap_8
XFILLER_155_42 VPWR VGND sg13cmos5l_decap_8
XFILLER_238_216 VPWR VGND sg13cmos5l_fill_2
XFILLER_454_102 VPWR VGND sg13cmos5l_decap_4
XFILLER_305_56 VPWR VGND sg13cmos5l_decap_8
XFILLER_602_21 VPWR VGND sg13cmos5l_decap_8
XFILLER_48_73 VPWR VGND sg13cmos5l_decap_8
XFILLER_280_0 VPWR VGND sg13cmos5l_decap_8
XFILLER_48_84 VPWR VGND sg13cmos5l_fill_2
XFILLER_378_0 VPWR VGND sg13cmos5l_decap_8
XFILLER_171_63 VPWR VGND sg13cmos5l_decap_8
XFILLER_0_14 VPWR VGND sg13cmos5l_decap_8
XFILLER_678_14 VPWR VGND sg13cmos5l_decap_8
XFILLER_602_98 VPWR VGND sg13cmos5l_decap_4
XFILLER_73_162 VPWR VGND sg13cmos5l_decap_4
XFILLER_545_0 VPWR VGND sg13cmos5l_decap_8
XANTENNA__3489__X Tile_X0Y1_EE4BEG[15] VPWR VGND sg13cmos5l_antennanp
XFILLER_321_77 VPWR VGND sg13cmos5l_decap_8
XFILLER_206_168 VPWR VGND sg13cmos5l_decap_8
XFILLER_221_105 VPWR VGND sg13cmos5l_decap_4
XFILLER_410_227 VPWR VGND sg13cmos5l_fill_2
XFILLER_159_201 VPWR VGND sg13cmos5l_fill_1
XFILLER_712_0 VPWR VGND sg13cmos5l_decap_8
XFILLER_9_56 VPWR VGND sg13cmos5l_decap_8
X_1870_ _1870_/Q Tile_X0Y3_FrameData[27] VGND VPWR Tile_X0Y9_FrameStrobe[6] latch
XFILLER_694_35 VPWR VGND sg13cmos5l_decap_8
XFILLER_477_70 VPWR VGND sg13cmos5l_decap_8
X_0821_ _0821_/Q Tile_X0Y9_FrameData[10] VGND VPWR Tile_X0Y9_FrameStrobe[4] latch
XFILLER_524_128 VPWR VGND sg13cmos5l_decap_8
XFILLER_713_228 VPWR VGND sg13cmos5l_fill_1
XFILLER_127_120 VPWR VGND sg13cmos5l_decap_8
X_3540_ Tile_X0Y9_E2BEGb[6] _4862_/X VPWR VGND sg13cmos5l_buf_1
XFILLER_196_82 VPWR VGND sg13cmos5l_decap_8
X_0752_ _0752_/Q Tile_X0Y9_FrameData[15] VGND VPWR Tile_X0Y9_FrameStrobe[2] latch
XFILLER_627_84 VPWR VGND sg13cmos5l_decap_8
XFILLER_390_156 VPWR VGND sg13cmos5l_fill_2
X_3471_ Tile_X0Y1_FrameData_O[29] Tile_X0Y1_FrameData[29] VPWR VGND sg13cmos5l_buf_1
XFILLER_563_28 VPWR VGND sg13cmos5l_decap_8
XFILLER_346_63 VPWR VGND sg13cmos5l_decap_8
XFILLER_142_112 VPWR VGND sg13cmos5l_decap_8
X_0683_ _0683_/Q Tile_X0Y9_FrameData[20] VGND VPWR Tile_X0Y9_FrameStrobe[0] latch
XFILLER_288_105 VPWR VGND sg13cmos5l_decap_8
XFILLER_127_197 VPWR VGND sg13cmos5l_decap_4
XFILLER_493_91 VPWR VGND sg13cmos5l_decap_8
X_2422_ _2422_/Q Tile_X0Y5_FrameData[15] VGND VPWR Tile_X0Y9_FrameStrobe[7] latch
XFILLER_678_187 VPWR VGND sg13cmos5l_decap_4
XFILLER_678_198 VPWR VGND sg13cmos5l_decap_8
XFILLER_693_135 VPWR VGND sg13cmos5l_fill_1
XFILLER_142_189 VPWR VGND sg13cmos5l_decap_8
X_2353_ _2353_/Q Tile_X0Y5_FrameData[20] VGND VPWR Tile_X0Y9_FrameStrobe[5] latch
XFILLER_96_221 VPWR VGND sg13cmos5l_fill_1
XFILLER_215_56 VPWR VGND sg13cmos5l_decap_8
X_1304_ _1304_/Q Tile_X0Y1_FrameData[1] VGND VPWR Tile_X0Y9_FrameStrobe[3] latch
XFILLER_445_113 VPWR VGND sg13cmos5l_fill_1
X_2284_ _2284_/Q Tile_X0Y5_FrameData[25] VGND VPWR Tile_X0Y9_FrameStrobe[3] latch
XFILLER_362_84 VPWR VGND sg13cmos5l_decap_8
XFILLER_512_21 VPWR VGND sg13cmos5l_decap_8
X_4023_ _4023_/X Tile_X0Y3_W2MID[6] Tile_X0Y3_W2END[6] Tile_X0Y3_W6END[6] _4207_/X
+ _1915_/Q _1914_/Q VPWR VGND sg13cmos5l_mux4_1
XFILLER_56_129 VPWR VGND sg13cmos5l_decap_8
X_1235_ _1235_/Q Tile_X0Y1_FrameData[6] VGND VPWR Tile_X0Y9_FrameStrobe[1] latch
XFILLER_445_168 VPWR VGND sg13cmos5l_fill_2
XFILLER_244_219 VPWR VGND sg13cmos5l_decap_8
X_1166_ _1166_/Q Tile_X0Y0_FrameData[29] VGND VPWR Tile_X0Y9_FrameStrobe[7] latch
XFILLER_588_14 VPWR VGND sg13cmos5l_decap_8
XFILLER_512_98 VPWR VGND sg13cmos5l_decap_8
XANTENNA__3399__X Tile_X0Y2_E2BEG[2] VPWR VGND sg13cmos5l_antennanp
XFILLER_231_77 VPWR VGND sg13cmos5l_decap_8
X_0117_ AXI_M_SOC_ARCACHE0 _3774_/X _0929_/Q VPWR VGND sg13cmos5l_or2_1
X_1097_ _1097_/Q Tile_X0Y0_FrameData[2] VGND VPWR Tile_X0Y9_FrameStrobe[4] latch
XFILLER_401_205 VPWR VGND sg13cmos5l_decap_4
XFILLER_212_105 VPWR VGND sg13cmos5l_decap_8
XFILLER_602_165 VPWR VGND sg13cmos5l_decap_8
XFILLER_401_216 VPWR VGND sg13cmos5l_decap_4
X_0048_ AXI_M_SOC_AWCACHE1 _0936_/Q _3686_/X VPWR VGND sg13cmos5l_or2_1
X_4925_ _4925_/X Tile_X0Y9_N1END[1] Tile_X0Y9_N4END[1] _4897_/X _0082_/X _0709_/Q
+ _0708_/Q VPWR VGND sg13cmos5l_mux4_1
XFILLER_668_91 VPWR VGND sg13cmos5l_decap_8
X_4856_ _4856_/X Tile_X0Y9_W2END[7] AXI_M_SOC_RDATA7 _4901_/X _4900_/X _0831_/Q _0830_/Q
+ VPWR VGND sg13cmos5l_mux4_1
XFILLER_387_70 VPWR VGND sg13cmos5l_decap_4
XFILLER_387_81 VPWR VGND sg13cmos5l_decap_8
XFILLER_387_92 VPWR VGND sg13cmos5l_fill_2
X_3807_ _3807_/X Tile_X0Y0_W2MID[4] Tile_X0Y0_WW4END[1] _3859_/X _3858_/X _1091_/Q
+ _1090_/Q VPWR VGND sg13cmos5l_mux4_1
X_1999_ _1999_/Q Tile_X0Y4_FrameData[22] VGND VPWR Tile_X0Y9_FrameStrobe[2] latch
X_4787_ _4787_/X _4703_/X Tile_X0Y9_N2MID[1] _4817_/X _4702_/X _0437_/Q _0436_/Q VPWR
+ VGND sg13cmos5l_mux4_1
XFILLER_381_134 VPWR VGND sg13cmos5l_fill_2
X_3738_ AXI_M_SOC_ARADDR10 Tile_X0Y9_WW4END[2] Tile_X0Y9_WW4END[10] Tile_X0Y9_W6END[10]
+ _4926_/X _0739_/Q _0738_/Q VPWR VGND sg13cmos5l_mux4_1
XFILLER_118_142 VPWR VGND sg13cmos5l_decap_4
XFILLER_537_84 VPWR VGND sg13cmos5l_decap_8
XFILLER_118_153 VPWR VGND sg13cmos5l_decap_8
XFILLER_109_35 VPWR VGND sg13cmos5l_decap_8
XFILLER_523_150 VPWR VGND sg13cmos5l_decap_4
XFILLER_473_28 VPWR VGND sg13cmos5l_decap_8
XFILLER_381_189 VPWR VGND sg13cmos5l_decap_8
XFILLER_256_63 VPWR VGND sg13cmos5l_decap_8
XFILLER_133_112 VPWR VGND sg13cmos5l_decap_8
X_3669_ AXI_M_SOC_AWADDR30 Tile_X0Y4_W1END[2] Tile_X0Y4_WW4END[6] Tile_X0Y4_WW4END[14]
+ _4350_/X _1985_/Q _1984_/Q VPWR VGND sg13cmos5l_mux4_1
XFILLER_69_28 VPWR VGND sg13cmos5l_decap_8
XFILLER_279_105 VPWR VGND sg13cmos5l_decap_8
XFILLER_523_183 VPWR VGND sg13cmos5l_decap_4
XFILLER_468_227 VPWR VGND sg13cmos5l_fill_2
XFILLER_87_210 VPWR VGND sg13cmos5l_decap_4
XFILLER_406_77 VPWR VGND sg13cmos5l_decap_4
XFILLER_406_88 VPWR VGND sg13cmos5l_decap_8
XFILLER_703_42 VPWR VGND sg13cmos5l_decap_8
XFILLER_125_56 VPWR VGND sg13cmos5l_decap_8
XFILLER_272_84 VPWR VGND sg13cmos5l_decap_8
XFILLER_422_21 VPWR VGND sg13cmos5l_decap_8
XFILLER_85_49 VPWR VGND sg13cmos5l_decap_8
XFILLER_47_129 VPWR VGND sg13cmos5l_decap_8
XFILLER_371_7 VPWR VGND sg13cmos5l_decap_8
XFILLER_18_21 VPWR VGND sg13cmos5l_decap_8
XFILLER_469_7 VPWR VGND sg13cmos5l_decap_8
XFILLER_640_216 VPWR VGND sg13cmos5l_fill_1
XFILLER_422_98 VPWR VGND sg13cmos5l_decap_8
XFILLER_498_14 VPWR VGND sg13cmos5l_decap_8
XFILLER_141_77 VPWR VGND sg13cmos5l_decap_8
XFILLER_636_7 VPWR VGND sg13cmos5l_decap_8
XFILLER_55_195 VPWR VGND sg13cmos5l_decap_4
XFILLER_203_105 VPWR VGND sg13cmos5l_decap_8
XANTENNA__3102__X Tile_X0Y7_E6BEG[0] VPWR VGND sg13cmos5l_antennanp
XFILLER_203_116 VPWR VGND sg13cmos5l_fill_2
XFILLER_70_154 VPWR VGND sg13cmos5l_decap_8
XFILLER_34_31 VPWR VGND sg13cmos5l_decap_8
XFILLER_648_28 VPWR VGND sg13cmos5l_decap_8
XFILLER_34_64 VPWR VGND sg13cmos5l_decap_8
XFILLER_578_91 VPWR VGND sg13cmos5l_decap_8
XANTENNA__2941__X Tile_X0Y8_E6BEG[9] VPWR VGND sg13cmos5l_antennanp
XFILLER_297_70 VPWR VGND sg13cmos5l_decap_8
XFILLER_357_175 VPWR VGND sg13cmos5l_decap_8
XFILLER_372_112 VPWR VGND sg13cmos5l_fill_2
XFILLER_126_0 VPWR VGND sg13cmos5l_decap_8
XFILLER_664_49 VPWR VGND sg13cmos5l_decap_8
XFILLER_447_84 VPWR VGND sg13cmos5l_decap_8
XFILLER_521_109 VPWR VGND sg13cmos5l_decap_8
XFILLER_50_85 VPWR VGND sg13cmos5l_decap_8
XFILLER_383_28 VPWR VGND sg13cmos5l_decap_8
XFILLER_166_63 VPWR VGND sg13cmos5l_decap_8
XFILLER_124_134 VPWR VGND sg13cmos5l_decap_8
XFILLER_675_146 VPWR VGND sg13cmos5l_fill_1
XFILLER_495_0 VPWR VGND sg13cmos5l_decap_8
XFILLER_680_48 VPWR VGND sg13cmos5l_decap_8
XFILLER_316_77 VPWR VGND sg13cmos5l_fill_1
XFILLER_675_157 VPWR VGND sg13cmos5l_fill_2
XFILLER_285_119 VPWR VGND sg13cmos5l_decap_8
XFILLER_690_105 VPWR VGND sg13cmos5l_decap_8
XFILLER_59_83 VPWR VGND sg13cmos5l_decap_8
XFILLER_613_42 VPWR VGND sg13cmos5l_decap_8
XFILLER_616_224 VPWR VGND sg13cmos5l_decap_4
XFILLER_662_0 VPWR VGND sg13cmos5l_decap_8
XFILLER_332_21 VPWR VGND sg13cmos5l_decap_8
XFILLER_293_130 VPWR VGND sg13cmos5l_decap_8
XFILLER_93_213 VPWR VGND sg13cmos5l_decap_4
XFILLER_427_168 VPWR VGND sg13cmos5l_decap_8
XFILLER_15_7 VPWR VGND sg13cmos5l_decap_8
XFILLER_442_105 VPWR VGND sg13cmos5l_decap_8
XFILLER_442_116 VPWR VGND sg13cmos5l_fill_1
X_1020_ _1020_/Q Tile_X0Y0_FrameData[15] VGND VPWR Tile_X0Y9_FrameStrobe[2] latch
XFILLER_689_46 VPWR VGND sg13cmos5l_decap_8
XFILLER_46_151 VPWR VGND sg13cmos5l_decap_8
XFILLER_75_93 VPWR VGND sg13cmos5l_fill_1
XFILLER_201_14 VPWR VGND sg13cmos5l_decap_8
XANTENNA__3012__X Tile_X0Y5_E2BEGb[7] VPWR VGND sg13cmos5l_antennanp
XFILLER_61_132 VPWR VGND sg13cmos5l_decap_8
XFILLER_450_182 VPWR VGND sg13cmos5l_fill_2
X_2971_ Tile_X0Y8_FrameData_O[11] Tile_X0Y8_FrameData[11] VPWR VGND sg13cmos5l_buf_1
XFILLER_596_175 VPWR VGND sg13cmos5l_decap_8
XFILLER_558_28 VPWR VGND sg13cmos5l_decap_8
XFILLER_596_186 VPWR VGND sg13cmos5l_fill_1
XFILLER_91_70 VPWR VGND sg13cmos5l_decap_8
XFILLER_488_91 VPWR VGND sg13cmos5l_decap_8
XANTENNA__2851__X Tile_X0Y6_E6BEG[0] VPWR VGND sg13cmos5l_antennanp
X_4710_ _4710_/X Tile_X0Y6_W1END[1] Tile_X0Y6_W2MID[2] Tile_X0Y6_W2END[2] _4556_/X
+ _2641_/Q _2640_/Q VPWR VGND sg13cmos5l_mux4_1
X_1922_ _1922_/Q Tile_X0Y3_FrameData[7] VGND VPWR Tile_X0Y9_FrameStrobe[7] latch
X_1853_ _1853_/Q Tile_X0Y3_FrameData[12] VGND VPWR Tile_X0Y9_FrameStrobe[5] latch
X_4641_ _4641_/X Tile_X0Y7_WW4END[2] AXI_M_SOC_RDATA18 _4686_/X _4673_/X _0277_/Q
+ _0276_/Q VPWR VGND sg13cmos5l_mux4_1
XFILLER_552_201 VPWR VGND sg13cmos5l_fill_1
XFILLER_363_112 VPWR VGND sg13cmos5l_decap_8
XFILLER_552_223 VPWR VGND sg13cmos5l_decap_4
X_0804_ _0804_/Q Tile_X0Y9_FrameData[27] VGND VPWR Tile_X0Y9_FrameStrobe[4] latch
X_4572_ _4572_/X _4545_/X Tile_X0Y9_N4END[12] _4544_/X _0152_/X _2487_/Q _2486_/Q
+ VPWR VGND sg13cmos5l_mux4_1
X_1784_ _1784_/Q Tile_X0Y3_FrameData[17] VGND VPWR Tile_X0Y9_FrameStrobe[3] latch
XFILLER_574_49 VPWR VGND sg13cmos5l_decap_8
XFILLER_357_84 VPWR VGND sg13cmos5l_decap_8
XFILLER_363_167 VPWR VGND sg13cmos5l_decap_8
XFILLER_512_109 VPWR VGND sg13cmos5l_fill_1
XFILLER_507_21 VPWR VGND sg13cmos5l_decap_8
XFILLER_293_28 VPWR VGND sg13cmos5l_decap_8
X_0735_ _0735_/Q Tile_X0Y9_FrameData[0] VGND VPWR Tile_X0Y9_FrameStrobe[1] latch
X_3523_ Tile_X0Y9_E1BEG[1] _4845_/X VPWR VGND sg13cmos5l_buf_1
XFILLER_505_161 VPWR VGND sg13cmos5l_decap_8
XFILLER_115_112 VPWR VGND sg13cmos5l_fill_2
X_3454_ Tile_X0Y1_FrameData_O[12] Tile_X0Y1_FrameData[12] VPWR VGND sg13cmos5l_buf_1
X_0666_ _0666_/Q Tile_X0Y8_FrameData[5] VGND VPWR Tile_X0Y9_FrameStrobe[7] latch
XFILLER_507_98 VPWR VGND sg13cmos5l_decap_8
XFILLER_41_0 VPWR VGND sg13cmos5l_fill_1
XFILLER_115_178 VPWR VGND sg13cmos5l_decap_8
X_2405_ _2405_/Q Tile_X0Y5_FrameData[0] VGND VPWR Tile_X0Y9_FrameStrobe[6] latch
XFILLER_69_210 VPWR VGND sg13cmos5l_decap_8
XFILLER_226_77 VPWR VGND sg13cmos5l_decap_8
XFILLER_130_126 VPWR VGND sg13cmos5l_decap_8
X_3385_ Tile_X0Y2_E6BEG[8] _4080_/X VPWR VGND sg13cmos5l_buf_1
XFILLER_276_119 VPWR VGND sg13cmos5l_decap_8
X_0597_ _0597_/Q Tile_X0Y8_FrameData[10] VGND VPWR Tile_X0Y9_FrameStrobe[5] latch
XFILLER_681_105 VPWR VGND sg13cmos5l_decap_4
XFILLER_666_179 VPWR VGND sg13cmos5l_fill_2
XFILLER_418_102 VPWR VGND sg13cmos5l_fill_1
XFILLER_523_42 VPWR VGND sg13cmos5l_decap_8
X_2336_ _2336_/Q Tile_X0Y5_FrameData[5] VGND VPWR Tile_X0Y9_FrameStrobe[4] latch
XFILLER_670_70 VPWR VGND sg13cmos5l_decap_8
XFILLER_242_21 VPWR VGND sg13cmos5l_decap_8
X_2267_ _2267_/Q Tile_X0Y5_FrameData[10] VGND VPWR Tile_X0Y9_FrameStrobe[2] latch
XFILLER_433_105 VPWR VGND sg13cmos5l_decap_8
XFILLER_599_35 VPWR VGND sg13cmos5l_decap_8
X_4006_ _4006_/X Tile_X0Y5_W1END[3] Tile_X0Y5_WW4END[3] Tile_X0Y5_W6END[11] _4454_/X
+ _2406_/Q _2405_/Q VPWR VGND sg13cmos5l_mux4_1
XFILLER_284_196 VPWR VGND sg13cmos5l_decap_8
X_1218_ _1218_/Q Tile_X0Y1_FrameData[23] VGND VPWR Tile_X0Y9_FrameStrobe[1] latch
X_2198_ _2198_/Q Tile_X0Y5_FrameData[15] VGND VPWR Tile_X0Y9_FrameStrobe[0] latch
X_1149_ _1149_/Q Tile_X0Y0_FrameData[14] VGND VPWR Tile_X0Y9_FrameStrobe[6] latch
XFILLER_111_14 VPWR VGND sg13cmos5l_decap_8
XFILLER_240_200 VPWR VGND sg13cmos5l_fill_2
XFILLER_52_132 VPWR VGND sg13cmos5l_decap_8
XFILLER_468_28 VPWR VGND sg13cmos5l_decap_8
XANTENNA__2761__X Tile_X0Y3_FrameData_O[19] VPWR VGND sg13cmos5l_antennanp
X_4908_ _4908_/X Tile_X0Y5_W1END[0] Tile_X0Y5_WW4END[12] Tile_X0Y5_W6END[4] _4451_/X
+ _2379_/Q _2378_/Q VPWR VGND sg13cmos5l_mux4_1
XFILLER_339_131 VPWR VGND sg13cmos5l_decap_4
X_4839_ _4839_/X _4921_/X _4925_/X _4929_/X _4904_/X _0864_/Q _0863_/Q VPWR VGND sg13cmos5l_mux4_1
XFILLER_354_112 VPWR VGND sg13cmos5l_decap_8
XFILLER_339_197 VPWR VGND sg13cmos5l_decap_4
XFILLER_689_227 VPWR VGND sg13cmos5l_fill_2
XFILLER_217_7 VPWR VGND sg13cmos5l_decap_8
XFILLER_267_84 VPWR VGND sg13cmos5l_decap_8
XFILLER_417_21 VPWR VGND sg13cmos5l_decap_8
XFILLER_4_217 VPWR VGND sg13cmos5l_fill_2
XFILLER_106_101 VPWR VGND sg13cmos5l_decap_8
XFILLER_354_189 VPWR VGND sg13cmos5l_decap_8
XANTENNA__3592__X Tile_X0Y9_FrameData_O[22] VPWR VGND sg13cmos5l_antennanp
XFILLER_106_145 VPWR VGND sg13cmos5l_decap_8
XFILLER_20_77 VPWR VGND sg13cmos5l_decap_4
XFILLER_417_98 VPWR VGND sg13cmos5l_decap_8
XFILLER_106_167 VPWR VGND sg13cmos5l_decap_8
XFILLER_106_189 VPWR VGND sg13cmos5l_decap_4
XFILLER_136_77 VPWR VGND sg13cmos5l_decap_8
XFILLER_586_7 VPWR VGND sg13cmos5l_decap_8
XFILLER_121_137 VPWR VGND sg13cmos5l_decap_8
XFILLER_714_85 VPWR VGND sg13cmos5l_decap_8
XFILLER_511_197 VPWR VGND sg13cmos5l_fill_2
XFILLER_433_42 VPWR VGND sg13cmos5l_decap_8
XFILLER_580_70 VPWR VGND sg13cmos5l_decap_8
XFILLER_409_135 VPWR VGND sg13cmos5l_fill_1
XFILLER_29_42 VPWR VGND sg13cmos5l_decap_8
XFILLER_152_21 VPWR VGND sg13cmos5l_decap_8
XANTENNA__2936__X Tile_X0Y8_E6BEG[4] VPWR VGND sg13cmos5l_antennanp
XFILLER_424_105 VPWR VGND sg13cmos5l_decap_8
XFILLER_409_179 VPWR VGND sg13cmos5l_decap_8
XFILLER_275_185 VPWR VGND sg13cmos5l_decap_8
XFILLER_613_227 VPWR VGND sg13cmos5l_fill_2
XFILLER_275_196 VPWR VGND sg13cmos5l_fill_1
XFILLER_290_133 VPWR VGND sg13cmos5l_decap_8
XFILLER_302_35 VPWR VGND sg13cmos5l_decap_8
XFILLER_90_227 VPWR VGND sg13cmos5l_fill_2
XFILLER_45_52 VPWR VGND sg13cmos5l_decap_8
XFILLER_659_49 VPWR VGND sg13cmos5l_decap_8
XFILLER_290_199 VPWR VGND sg13cmos5l_decap_8
XFILLER_578_175 VPWR VGND sg13cmos5l_decap_8
XFILLER_432_182 VPWR VGND sg13cmos5l_decap_8
XFILLER_378_28 VPWR VGND sg13cmos5l_decap_8
XFILLER_243_0 VPWR VGND sg13cmos5l_decap_8
XFILLER_593_178 VPWR VGND sg13cmos5l_decap_8
XFILLER_61_62 VPWR VGND sg13cmos5l_decap_8
XFILLER_345_112 VPWR VGND sg13cmos5l_decap_8
XFILLER_534_212 VPWR VGND sg13cmos5l_decap_8
XFILLER_410_0 VPWR VGND sg13cmos5l_decap_8
XFILLER_196_192 VPWR VGND sg13cmos5l_fill_1
XFILLER_508_0 VPWR VGND sg13cmos5l_decap_8
XFILLER_608_42 VPWR VGND sg13cmos5l_decap_8
XFILLER_394_49 VPWR VGND sg13cmos5l_decap_8
XFILLER_327_21 VPWR VGND sg13cmos5l_decap_8
XFILLER_6_35 VPWR VGND sg13cmos5l_decap_8
XANTENNA_6 AXI_M_SOC_RDATA13 VPWR VGND sg13cmos5l_antennanp
XFILLER_691_14 VPWR VGND sg13cmos5l_decap_8
X_0520_ _0520_/Q Tile_X0Y8_FrameData[23] VGND VPWR Tile_X0Y9_FrameStrobe[3] latch
XFILLER_499_182 VPWR VGND sg13cmos5l_decap_8
XFILLER_301_215 VPWR VGND sg13cmos5l_decap_4
X_0451_ _0451_/Q Tile_X0Y8_FrameData[28] VGND VPWR Tile_X0Y9_FrameStrobe[1] latch
XFILLER_624_63 VPWR VGND sg13cmos5l_decap_8
XFILLER_502_175 VPWR VGND sg13cmos5l_decap_8
XANTENNA__3007__X Tile_X0Y5_E2BEGb[2] VPWR VGND sg13cmos5l_antennanp
XFILLER_663_105 VPWR VGND sg13cmos5l_decap_8
XFILLER_112_148 VPWR VGND sg13cmos5l_fill_2
XFILLER_343_42 VPWR VGND sg13cmos5l_decap_8
X_3170_ Tile_X0Y4_E6BEG[7] _4295_/X VPWR VGND sg13cmos5l_buf_1
XFILLER_663_127 VPWR VGND sg13cmos5l_decap_4
X_0382_ _0382_/Q Tile_X0Y7_FrameData[1] VGND VPWR Tile_X0Y9_FrameStrobe[6] latch
XFILLER_490_70 VPWR VGND sg13cmos5l_decap_8
X_2121_ _2121_/Q Tile_X0Y4_FrameData[28] VGND VPWR Tile_X0Y9_FrameStrobe[6] latch
XANTENNA__2846__X Tile_X0Y6_E2BEGb[3] VPWR VGND sg13cmos5l_antennanp
XFILLER_415_105 VPWR VGND sg13cmos5l_decap_4
X_2052_ _2052_/Q Tile_X0Y4_FrameData[1] VGND VPWR Tile_X0Y9_FrameStrobe[3] latch
XFILLER_604_227 VPWR VGND sg13cmos5l_fill_2
XFILLER_281_133 VPWR VGND sg13cmos5l_decap_8
XFILLER_640_84 VPWR VGND sg13cmos5l_decap_8
XFILLER_212_35 VPWR VGND sg13cmos5l_decap_8
X_1003_ _1003_/Q Tile_X0Y0_FrameData[0] VGND VPWR Tile_X0Y9_FrameStrobe[1] latch
XFILLER_569_49 VPWR VGND sg13cmos5l_decap_8
XFILLER_430_119 VPWR VGND sg13cmos5l_decap_8
XFILLER_222_211 VPWR VGND sg13cmos5l_fill_2
XFILLER_368_204 VPWR VGND sg13cmos5l_decap_4
XFILLER_368_215 VPWR VGND sg13cmos5l_decap_4
XFILLER_569_175 VPWR VGND sg13cmos5l_decap_8
XFILLER_368_226 VPWR VGND sg13cmos5l_fill_2
XFILLER_288_28 VPWR VGND sg13cmos5l_decap_8
XFILLER_179_126 VPWR VGND sg13cmos5l_decap_4
XFILLER_584_112 VPWR VGND sg13cmos5l_decap_4
XFILLER_179_159 VPWR VGND sg13cmos5l_decap_8
X_2954_ Tile_X0Y8_EE4BEG[10] _4754_/X VPWR VGND sg13cmos5l_buf_1
XFILLER_194_118 VPWR VGND sg13cmos5l_fill_2
XFILLER_89_0 VPWR VGND sg13cmos5l_decap_8
X_1905_ _1905_/Q Tile_X0Y3_FrameData[24] VGND VPWR Tile_X0Y9_FrameStrobe[7] latch
X_2885_ Tile_X0Y6_FrameData_O[6] Tile_X0Y6_FrameData[6] VPWR VGND sg13cmos5l_buf_1
XFILLER_187_192 VPWR VGND sg13cmos5l_fill_1
XFILLER_518_42 VPWR VGND sg13cmos5l_decap_8
X_4624_ _4624_/X Tile_X0Y7_W2END[3] AXI_M_SOC_RDATA19 _4675_/X _4674_/X _0311_/Q _0310_/Q
+ VPWR VGND sg13cmos5l_mux4_1
X_1836_ _1836_/Q Tile_X0Y3_FrameData[29] VGND VPWR Tile_X0Y9_FrameStrobe[5] latch
XFILLER_665_70 VPWR VGND sg13cmos5l_decap_8
XFILLER_237_21 VPWR VGND sg13cmos5l_decap_8
X_1767_ _1767_/Q Tile_X0Y3_FrameData[2] VGND VPWR Tile_X0Y9_FrameStrobe[2] latch
X_4555_ _4555_/X _4471_/X _4587_/X _4586_/X _4470_/X _2461_/Q _2460_/Q VPWR VGND sg13cmos5l_mux4_1
XFILLER_540_226 VPWR VGND sg13cmos5l_fill_2
XFILLER_497_119 VPWR VGND sg13cmos5l_decap_8
XFILLER_351_126 VPWR VGND sg13cmos5l_decap_8
X_0718_ _0718_/Q Tile_X0Y9_FrameData[17] VGND VPWR Tile_X0Y9_FrameStrobe[1] latch
X_3506_ Tile_X0Y1_E2BEGb[4] _3944_/X VPWR VGND sg13cmos5l_buf_1
X_1698_ _1698_/Q Tile_X0Y3_FrameData[7] VGND VPWR Tile_X0Y9_FrameStrobe[0] latch
X_4486_ _4486_/X Tile_X0Y6_W1END[1] Tile_X0Y6_WW4END[13] Tile_X0Y6_W6END[5] _4569_/X
+ _2632_/Q _2631_/Q VPWR VGND sg13cmos5l_mux4_1
XFILLER_534_63 VPWR VGND sg13cmos5l_decap_8
X_0649_ _0649_/Q Tile_X0Y8_FrameData[22] VGND VPWR Tile_X0Y9_FrameStrobe[7] latch
X_3437_ Tile_X0Y4_FrameData_O[28] Tile_X0Y4_FrameData[28] VPWR VGND sg13cmos5l_buf_1
XFILLER_639_168 VPWR VGND sg13cmos5l_decap_8
XFILLER_106_14 VPWR VGND sg13cmos5l_decap_8
XFILLER_654_105 VPWR VGND sg13cmos5l_decap_8
XFILLER_681_91 VPWR VGND sg13cmos5l_decap_8
XFILLER_103_148 VPWR VGND sg13cmos5l_decap_4
XFILLER_253_42 VPWR VGND sg13cmos5l_decap_8
X_3368_ Tile_X0Y2_EE4BEG[7] _4063_/X VPWR VGND sg13cmos5l_buf_1
XFILLER_257_130 VPWR VGND sg13cmos5l_decap_8
XFILLER_253_86 VPWR VGND sg13cmos5l_fill_1
XANTENNA__2756__X Tile_X0Y3_FrameData_O[14] VPWR VGND sg13cmos5l_antennanp
X_2319_ _2319_/Q Tile_X0Y5_FrameData[22] VGND VPWR Tile_X0Y9_FrameStrobe[4] latch
X_3299_ Tile_X0Y0_E2BEGb[7] _3819_/X VPWR VGND sg13cmos5l_buf_1
XFILLER_272_100 VPWR VGND sg13cmos5l_fill_1
XFILLER_403_56 VPWR VGND sg13cmos5l_decap_8
XFILLER_272_133 VPWR VGND sg13cmos5l_fill_2
XFILLER_550_84 VPWR VGND sg13cmos5l_decap_8
XFILLER_406_149 VPWR VGND sg13cmos5l_decap_8
XFILLER_122_35 VPWR VGND sg13cmos5l_decap_8
XFILLER_82_28 VPWR VGND sg13cmos5l_decap_8
XFILLER_610_219 VPWR VGND sg13cmos5l_fill_2
XFILLER_421_119 VPWR VGND sg13cmos5l_decap_8
XFILLER_167_7 VPWR VGND sg13cmos5l_decap_8
XFILLER_700_65 VPWR VGND sg13cmos5l_decap_8
XFILLER_479_49 VPWR VGND sg13cmos5l_decap_8
XFILLER_213_222 VPWR VGND sg13cmos5l_decap_8
XFILLER_25_154 VPWR VGND sg13cmos5l_fill_2
XFILLER_198_28 VPWR VGND sg13cmos5l_decap_8
XFILLER_575_112 VPWR VGND sg13cmos5l_decap_8
XANTENNA__3587__X Tile_X0Y9_FrameData_O[17] VPWR VGND sg13cmos5l_antennanp
XFILLER_334_7 VPWR VGND sg13cmos5l_decap_8
XFILLER_15_77 VPWR VGND sg13cmos5l_decap_8
XFILLER_40_168 VPWR VGND sg13cmos5l_decap_4
XFILLER_575_189 VPWR VGND sg13cmos5l_decap_8
XFILLER_40_179 VPWR VGND sg13cmos5l_fill_2
XFILLER_709_63 VPWR VGND sg13cmos5l_decap_8
XFILLER_717_161 VPWR VGND sg13cmos5l_decap_8
XFILLER_516_212 VPWR VGND sg13cmos5l_fill_1
XFILLER_327_123 VPWR VGND sg13cmos5l_decap_8
XFILLER_717_183 VPWR VGND sg13cmos5l_fill_2
XFILLER_31_10 VPWR VGND sg13cmos5l_decap_8
XFILLER_590_148 VPWR VGND sg13cmos5l_fill_1
XFILLER_501_7 VPWR VGND sg13cmos5l_decap_8
XFILLER_428_42 VPWR VGND sg13cmos5l_decap_8
XFILLER_575_70 VPWR VGND sg13cmos5l_decap_8
XFILLER_147_21 VPWR VGND sg13cmos5l_decap_8
XFILLER_531_226 VPWR VGND sg13cmos5l_fill_2
XFILLER_488_119 VPWR VGND sg13cmos5l_decap_8
XFILLER_147_98 VPWR VGND sg13cmos5l_decap_4
XFILLER_661_28 VPWR VGND sg13cmos5l_decap_8
XFILLER_444_63 VPWR VGND sg13cmos5l_decap_8
XFILLER_645_105 VPWR VGND sg13cmos5l_decap_8
XFILLER_591_91 VPWR VGND sg13cmos5l_fill_2
XFILLER_163_42 VPWR VGND sg13cmos5l_decap_8
XFILLER_496_196 VPWR VGND sg13cmos5l_decap_8
XFILLER_193_0 VPWR VGND sg13cmos5l_decap_8
XFILLER_660_119 VPWR VGND sg13cmos5l_decap_4
XFILLER_263_111 VPWR VGND sg13cmos5l_decap_8
XFILLER_313_56 VPWR VGND sg13cmos5l_decap_8
XFILLER_452_222 VPWR VGND sg13cmos5l_decap_8
XFILLER_653_182 VPWR VGND sg13cmos5l_decap_8
XFILLER_460_84 VPWR VGND sg13cmos5l_decap_4
XFILLER_610_21 VPWR VGND sg13cmos5l_decap_8
XFILLER_56_73 VPWR VGND sg13cmos5l_decap_8
XFILLER_360_0 VPWR VGND sg13cmos5l_fill_2
XFILLER_458_0 VPWR VGND sg13cmos5l_decap_8
XFILLER_389_49 VPWR VGND sg13cmos5l_decap_8
XFILLER_686_14 VPWR VGND sg13cmos5l_decap_8
XFILLER_610_98 VPWR VGND sg13cmos5l_decap_8
XFILLER_566_112 VPWR VGND sg13cmos5l_decap_8
XFILLER_420_130 VPWR VGND sg13cmos5l_decap_8
XFILLER_16_176 VPWR VGND sg13cmos5l_decap_4
XFILLER_625_0 VPWR VGND sg13cmos5l_decap_8
XFILLER_16_187 VPWR VGND sg13cmos5l_fill_2
XANTENNA__3497__X Tile_X0Y1_E6BEG[7] VPWR VGND sg13cmos5l_antennanp
XFILLER_82_7 VPWR VGND sg13cmos5l_decap_8
XFILLER_708_161 VPWR VGND sg13cmos5l_decap_8
XFILLER_619_63 VPWR VGND sg13cmos5l_decap_8
XFILLER_581_126 VPWR VGND sg13cmos5l_decap_8
XFILLER_338_42 VPWR VGND sg13cmos5l_decap_8
X_2670_ _2670_/Q Tile_X0Y6_FrameData[25] VGND VPWR Tile_X0Y9_FrameStrobe[7] latch
XFILLER_485_70 VPWR VGND sg13cmos5l_decap_8
X_1621_ _1621_/Q Tile_X0Y2_FrameData[28] VGND VPWR Tile_X0Y9_FrameStrobe[6] latch
XFILLER_668_208 VPWR VGND sg13cmos5l_fill_2
XFILLER_479_108 VPWR VGND sg13cmos5l_decap_4
XFILLER_522_226 VPWR VGND sg13cmos5l_fill_2
XFILLER_333_148 VPWR VGND sg13cmos5l_decap_4
X_1552_ _1552_/Q Tile_X0Y2_FrameData[1] VGND VPWR Tile_X0Y9_FrameStrobe[3] latch
X_4340_ _4340_/X _4302_/X _0099_/X _4301_/X _0112_/X _1973_/Q _1972_/Q VPWR VGND sg13cmos5l_mux4_1
XFILLER_635_84 VPWR VGND sg13cmos5l_decap_8
XFILLER_207_35 VPWR VGND sg13cmos5l_decap_8
XFILLER_98_113 VPWR VGND sg13cmos5l_decap_8
X_0503_ _0503_/Q Tile_X0Y8_FrameData[8] VGND VPWR Tile_X0Y9_FrameStrobe[2] latch
X_4271_ _4271_/X Tile_X0Y4_W2END[0] AXI_M_SOC_BRESP0 _4313_/X _4312_/X _2071_/Q _2070_/Q
+ VPWR VGND sg13cmos5l_mux4_1
XFILLER_571_28 VPWR VGND sg13cmos5l_decap_8
XFILLER_354_63 VPWR VGND sg13cmos5l_decap_8
XFILLER_286_203 VPWR VGND sg13cmos5l_decap_8
X_1483_ _1483_/Q Tile_X0Y2_FrameData[6] VGND VPWR Tile_X0Y9_FrameStrobe[1] latch
XFILLER_341_181 VPWR VGND sg13cmos5l_decap_8
XFILLER_636_105 VPWR VGND sg13cmos5l_decap_8
XFILLER_487_185 VPWR VGND sg13cmos5l_fill_1
XFILLER_98_168 VPWR VGND sg13cmos5l_fill_2
X_3222_ Tile_X0Y0_FrameStrobe_O[10] Tile_X0Y9_FrameStrobe[10] VPWR VGND sg13cmos5l_buf_1
X_0434_ _0434_/Q Tile_X0Y8_FrameData[13] VGND VPWR Tile_X0Y9_FrameStrobe[0] latch
XFILLER_39_213 VPWR VGND sg13cmos5l_fill_2
X_3153_ Tile_X0Y7_FrameData_O[23] Tile_X0Y7_FrameData[23] VPWR VGND sg13cmos5l_buf_1
XFILLER_504_77 VPWR VGND sg13cmos5l_decap_8
X_0365_ _0365_/Q Tile_X0Y7_FrameData[18] VGND VPWR Tile_X0Y9_FrameStrobe[6] latch
XFILLER_651_119 VPWR VGND sg13cmos5l_decap_8
XFILLER_223_56 VPWR VGND sg13cmos5l_decap_8
X_2104_ _2104_/Q Tile_X0Y4_FrameData[13] VGND VPWR Tile_X0Y9_FrameStrobe[5] latch
XFILLER_644_182 VPWR VGND sg13cmos5l_decap_8
X_3084_ Tile_X0Y7_E1BEG[2] _4610_/X VPWR VGND sg13cmos5l_buf_1
XFILLER_370_84 VPWR VGND sg13cmos5l_decap_8
X_0296_ _0296_/Q Tile_X0Y7_FrameData[23] VGND VPWR Tile_X0Y9_FrameStrobe[4] latch
XFILLER_520_21 VPWR VGND sg13cmos5l_decap_8
X_2035_ _2035_/Q Tile_X0Y4_FrameData[18] VGND VPWR Tile_X0Y9_FrameStrobe[3] latch
XFILLER_299_49 VPWR VGND sg13cmos5l_decap_8
XFILLER_596_14 VPWR VGND sg13cmos5l_decap_8
XFILLER_557_112 VPWR VGND sg13cmos5l_decap_8
XANTENNA__3200__X Tile_X0Y0_N2BEG[0] VPWR VGND sg13cmos5l_antennanp
X_3986_ _3986_/X Tile_X0Y0_W1END[3] Tile_X0Y0_W6END[11] _3863_/X _3880_/X _1135_/Q
+ _1134_/Q VPWR VGND sg13cmos5l_mux4_1
X_2937_ Tile_X0Y8_E6BEG[5] _4765_/X VPWR VGND sg13cmos5l_buf_1
XFILLER_572_126 VPWR VGND sg13cmos5l_decap_8
XFILLER_529_63 VPWR VGND sg13cmos5l_decap_8
XFILLER_714_120 VPWR VGND sg13cmos5l_decap_8
XFILLER_676_91 VPWR VGND sg13cmos5l_decap_8
XFILLER_248_42 VPWR VGND sg13cmos5l_decap_8
X_2868_ Tile_X0Y6_EE4BEG[5] _4517_/X VPWR VGND sg13cmos5l_buf_1
XFILLER_395_70 VPWR VGND sg13cmos5l_fill_1
XFILLER_108_218 VPWR VGND sg13cmos5l_decap_4
XFILLER_324_115 VPWR VGND sg13cmos5l_decap_8
X_4607_ _4607_/X _4691_/X _4695_/X _4699_/X _4668_/X _0346_/Q _0345_/Q VPWR VGND sg13cmos5l_mux4_1
XFILLER_513_215 VPWR VGND sg13cmos5l_fill_2
XFILLER_248_97 VPWR VGND sg13cmos5l_decap_8
X_1819_ _1819_/Q Tile_X0Y3_FrameData[14] VGND VPWR Tile_X0Y9_FrameStrobe[4] latch
XFILLER_714_197 VPWR VGND sg13cmos5l_decap_4
X_2799_ Tile_X0Y3_E6BEG[9] _4189_/X VPWR VGND sg13cmos5l_buf_1
XFILLER_190_143 VPWR VGND sg13cmos5l_decap_4
X_4538_ _4538_/X AXI_M_SOC_RDATA30 _4569_/X _4573_/X _4554_/X _2531_/Q _2530_/Q VPWR
+ VGND sg13cmos5l_mux4_1
XFILLER_190_176 VPWR VGND sg13cmos5l_decap_8
XFILLER_89_102 VPWR VGND sg13cmos5l_fill_1
XFILLER_545_84 VPWR VGND sg13cmos5l_decap_8
XFILLER_117_35 VPWR VGND sg13cmos5l_decap_8
XFILLER_481_28 VPWR VGND sg13cmos5l_decap_8
XFILLER_264_63 VPWR VGND sg13cmos5l_fill_2
XFILLER_89_135 VPWR VGND sg13cmos5l_decap_8
XFILLER_77_28 VPWR VGND sg13cmos5l_decap_8
XFILLER_89_146 VPWR VGND sg13cmos5l_fill_1
X_4469_ _4469_/X Tile_X0Y7_W2MID[7] Tile_X0Y7_W2END[7] Tile_X0Y7_W6END[7] _4669_/X
+ _0407_/Q _0406_/Q VPWR VGND sg13cmos5l_mux4_1
XFILLER_627_105 VPWR VGND sg13cmos5l_decap_8
XFILLER_277_225 VPWR VGND sg13cmos5l_fill_1
XFILLER_89_168 VPWR VGND sg13cmos5l_decap_8
XFILLER_493_133 VPWR VGND sg13cmos5l_decap_8
XFILLER_414_77 VPWR VGND sg13cmos5l_decap_8
XFILLER_292_228 VPWR VGND sg13cmos5l_fill_1
XFILLER_642_119 VPWR VGND sg13cmos5l_decap_8
XFILLER_284_7 VPWR VGND sg13cmos5l_decap_8
XFILLER_133_56 VPWR VGND sg13cmos5l_decap_8
XFILLER_711_42 VPWR VGND sg13cmos5l_decap_8
XFILLER_245_133 VPWR VGND sg13cmos5l_decap_8
XFILLER_280_84 VPWR VGND sg13cmos5l_decap_8
XFILLER_45_227 VPWR VGND sg13cmos5l_fill_2
XFILLER_430_21 VPWR VGND sg13cmos5l_decap_8
XFILLER_93_49 VPWR VGND sg13cmos5l_decap_4
XFILLER_245_166 VPWR VGND sg13cmos5l_decap_8
XFILLER_26_21 VPWR VGND sg13cmos5l_decap_8
XFILLER_451_7 VPWR VGND sg13cmos5l_decap_8
XFILLER_260_103 VPWR VGND sg13cmos5l_decap_8
XFILLER_245_188 VPWR VGND sg13cmos5l_decap_8
XFILLER_549_7 VPWR VGND sg13cmos5l_decap_8
XFILLER_650_196 VPWR VGND sg13cmos5l_decap_8
XFILLER_60_208 VPWR VGND sg13cmos5l_fill_1
XFILLER_430_98 VPWR VGND sg13cmos5l_decap_8
XFILLER_399_181 VPWR VGND sg13cmos5l_decap_8
XFILLER_402_130 VPWR VGND sg13cmos5l_fill_1
XFILLER_548_134 VPWR VGND sg13cmos5l_fill_2
XFILLER_402_152 VPWR VGND sg13cmos5l_decap_8
XFILLER_716_7 VPWR VGND sg13cmos5l_decap_8
XANTENNA__3110__X Tile_X0Y7_E6BEG[8] VPWR VGND sg13cmos5l_antennanp
XFILLER_656_28 VPWR VGND sg13cmos5l_decap_8
XFILLER_439_63 VPWR VGND sg13cmos5l_decap_8
XFILLER_42_42 VPWR VGND sg13cmos5l_decap_8
XFILLER_42_53 VPWR VGND sg13cmos5l_decap_8
XFILLER_586_91 VPWR VGND sg13cmos5l_decap_8
XFILLER_158_42 VPWR VGND sg13cmos5l_decap_8
XFILLER_705_164 VPWR VGND sg13cmos5l_fill_2
XFILLER_504_215 VPWR VGND sg13cmos5l_fill_2
XFILLER_315_126 VPWR VGND sg13cmos5l_decap_8
XFILLER_315_137 VPWR VGND sg13cmos5l_fill_1
XFILLER_705_197 VPWR VGND sg13cmos5l_fill_1
XFILLER_308_56 VPWR VGND sg13cmos5l_decap_8
XFILLER_206_0 VPWR VGND sg13cmos5l_decap_8
XFILLER_672_49 VPWR VGND sg13cmos5l_decap_8
XFILLER_469_130 VPWR VGND sg13cmos5l_decap_4
XFILLER_605_21 VPWR VGND sg13cmos5l_decap_8
XFILLER_391_28 VPWR VGND sg13cmos5l_decap_8
XFILLER_268_203 VPWR VGND sg13cmos5l_decap_4
XFILLER_174_63 VPWR VGND sg13cmos5l_decap_8
XFILLER_618_105 VPWR VGND sg13cmos5l_decap_8
XFILLER_3_14 VPWR VGND sg13cmos5l_decap_8
XFILLER_618_116 VPWR VGND sg13cmos5l_fill_2
XFILLER_618_149 VPWR VGND sg13cmos5l_decap_8
XFILLER_575_0 VPWR VGND sg13cmos5l_decap_8
XFILLER_484_166 VPWR VGND sg13cmos5l_decap_4
XFILLER_95_149 VPWR VGND sg13cmos5l_decap_4
XFILLER_633_119 VPWR VGND sg13cmos5l_decap_8
XFILLER_484_199 VPWR VGND sg13cmos5l_decap_8
XFILLER_621_42 VPWR VGND sg13cmos5l_decap_8
X_0150_ _0150_/X _4566_/X _4567_/X _1602_/Q VPWR VGND sg13cmos5l_mux2_1
XFILLER_36_205 VPWR VGND sg13cmos5l_decap_8
X_0081_ _0081_/X _4912_/X _4913_/X _2371_/Q VPWR VGND sg13cmos5l_mux2_1
XFILLER_340_54 VPWR VGND sg13cmos5l_decap_8
XFILLER_697_35 VPWR VGND sg13cmos5l_decap_8
XFILLER_83_60 VPWR VGND sg13cmos5l_fill_1
XFILLER_641_196 VPWR VGND sg13cmos5l_decap_8
XFILLER_251_147 VPWR VGND sg13cmos5l_decap_8
X_3840_ _3840_/X Tile_X0Y0_WW4END[11] _3879_/X _3864_/X _3853_/X _1025_/Q _1024_/Q
+ VPWR VGND sg13cmos5l_mux4_1
XANTENNA__3020__X Tile_X0Y5_E6BEG[7] VPWR VGND sg13cmos5l_antennanp
XFILLER_566_28 VPWR VGND sg13cmos5l_decap_8
XFILLER_349_63 VPWR VGND sg13cmos5l_decap_8
X_0983_ _0983_/Q Tile_X0Y0_FrameData[20] VGND VPWR Tile_X0Y9_FrameStrobe[1] latch
X_3771_ _3771_/X Tile_X0Y0_WW4END[0] Tile_X0Y0_WW4END[8] Tile_X0Y0_W6END[0] _3881_/X
+ _1009_/Q _1008_/Q VPWR VGND sg13cmos5l_mux4_1
XFILLER_554_126 VPWR VGND sg13cmos5l_decap_8
XFILLER_496_91 VPWR VGND sg13cmos5l_decap_8
X_2722_ _4657_/A3 VPWR VGND sg13cmos5l_tielo
XFILLER_157_151 VPWR VGND sg13cmos5l_decap_8
X_2653_ _2653_/Q Tile_X0Y6_FrameData[10] VGND VPWR Tile_X0Y9_FrameStrobe[6] latch
XFILLER_562_181 VPWR VGND sg13cmos5l_decap_8
XFILLER_711_112 VPWR VGND sg13cmos5l_decap_8
XFILLER_218_56 VPWR VGND sg13cmos5l_decap_8
X_1604_ _1604_/Q Tile_X0Y2_FrameData[13] VGND VPWR Tile_X0Y9_FrameStrobe[5] latch
X_2584_ _2584_/Q Tile_X0Y6_FrameData[15] VGND VPWR Tile_X0Y9_FrameStrobe[4] latch
XFILLER_582_49 VPWR VGND sg13cmos5l_decap_8
XFILLER_365_84 VPWR VGND sg13cmos5l_decap_8
XFILLER_515_21 VPWR VGND sg13cmos5l_decap_8
XFILLER_711_189 VPWR VGND sg13cmos5l_decap_8
X_4323_ _4323_/X _4804_/X _4808_/X _4812_/X _4785_/X _0647_/Q _0646_/Q VPWR VGND sg13cmos5l_mux4_1
X_1535_ _1535_/Q Tile_X0Y2_FrameData[18] VGND VPWR Tile_X0Y9_FrameStrobe[3] latch
XFILLER_259_225 VPWR VGND sg13cmos5l_decap_4
XANTENNA__3690__X AXI_M_SOC_WDATA0 VPWR VGND sg13cmos5l_antennanp
XFILLER_609_127 VPWR VGND sg13cmos5l_fill_1
X_1466_ _1466_/Q Tile_X0Y2_FrameData[23] VGND VPWR Tile_X0Y9_FrameStrobe[1] latch
X_4254_ _4254_/X _4308_/X _4307_/X AXI_M_SOC_BRESP1 _4306_/X _2105_/Q _2104_/Q VPWR
+ VGND sg13cmos5l_mux4_1
XFILLER_515_98 VPWR VGND sg13cmos5l_decap_8
XFILLER_86_116 VPWR VGND sg13cmos5l_fill_1
XFILLER_86_138 VPWR VGND sg13cmos5l_fill_2
X_0417_ _0417_/Q Tile_X0Y8_FrameData[30] VGND VPWR Tile_X0Y9_FrameStrobe[0] latch
X_3205_ Tile_X0Y0_N2BEG[5] _3789_/X VPWR VGND sg13cmos5l_buf_1
XFILLER_234_77 VPWR VGND sg13cmos5l_fill_1
XFILLER_274_228 VPWR VGND sg13cmos5l_fill_1
X_1397_ _1397_/Q Tile_X0Y1_FrameData[4] VGND VPWR Tile_X0Y9_FrameStrobe[6] latch
X_4185_ _4185_/X AXI_M_SOC_BVALID _4228_/X _4232_/X _4207_/X _1771_/Q _1770_/Q VPWR
+ VGND sg13cmos5l_mux4_1
XFILLER_531_42 VPWR VGND sg13cmos5l_decap_8
XFILLER_490_147 VPWR VGND sg13cmos5l_fill_1
X_0348_ _0348_/Q Tile_X0Y7_FrameData[3] VGND VPWR Tile_X0Y9_FrameStrobe[5] latch
X_3136_ Tile_X0Y7_FrameData_O[6] Tile_X0Y7_FrameData[6] VPWR VGND sg13cmos5l_buf_1
XFILLER_250_21 VPWR VGND sg13cmos5l_decap_8
XFILLER_632_152 VPWR VGND sg13cmos5l_fill_2
X_3067_ Tile_X0Y5_FrameData_O[26] Tile_X0Y5_FrameData[26] VPWR VGND sg13cmos5l_buf_1
X_0279_ _0279_/Q Tile_X0Y7_FrameData[8] VGND VPWR Tile_X0Y9_FrameStrobe[3] latch
XFILLER_431_225 VPWR VGND sg13cmos5l_decap_4
X_2018_ _2018_/Q Tile_X0Y4_FrameData[3] VGND VPWR Tile_X0Y9_FrameStrobe[2] latch
XFILLER_400_35 VPWR VGND sg13cmos5l_decap_8
XFILLER_476_28 VPWR VGND sg13cmos5l_decap_8
XFILLER_10_105 VPWR VGND sg13cmos5l_decap_8
XFILLER_545_126 VPWR VGND sg13cmos5l_fill_2
XFILLER_396_195 VPWR VGND sg13cmos5l_decap_8
XFILLER_259_63 VPWR VGND sg13cmos5l_decap_4
X_3969_ _3969_/X AXI_M_SOC_ARREADY _4014_/X _4018_/X _3991_/X _1271_/Q _1270_/Q VPWR
+ VGND sg13cmos5l_mux4_1
XFILLER_148_184 VPWR VGND sg13cmos5l_decap_8
XFILLER_553_170 VPWR VGND sg13cmos5l_decap_8
XFILLER_498_203 VPWR VGND sg13cmos5l_fill_1
XFILLER_352_210 VPWR VGND sg13cmos5l_fill_1
XFILLER_12_56 VPWR VGND sg13cmos5l_decap_8
XFILLER_702_101 VPWR VGND sg13cmos5l_decap_8
XFILLER_409_77 VPWR VGND sg13cmos5l_decap_8
XFILLER_409_88 VPWR VGND sg13cmos5l_fill_2
XFILLER_128_56 VPWR VGND sg13cmos5l_decap_8
XFILLER_706_42 VPWR VGND sg13cmos5l_decap_8
XFILLER_492_49 VPWR VGND sg13cmos5l_decap_8
XFILLER_275_84 VPWR VGND sg13cmos5l_decap_8
XFILLER_425_21 VPWR VGND sg13cmos5l_decap_8
XFILLER_312_118 VPWR VGND sg13cmos5l_decap_8
XFILLER_88_49 VPWR VGND sg13cmos5l_decap_8
XFILLER_499_7 VPWR VGND sg13cmos5l_decap_8
XFILLER_320_140 VPWR VGND sg13cmos5l_decap_4
XFILLER_320_151 VPWR VGND sg13cmos5l_decap_8
XFILLER_425_98 VPWR VGND sg13cmos5l_decap_8
XFILLER_320_162 VPWR VGND sg13cmos5l_fill_2
XFILLER_144_77 VPWR VGND sg13cmos5l_decap_8
XFILLER_666_7 VPWR VGND sg13cmos5l_decap_8
XANTENNA__3105__X Tile_X0Y7_E6BEG[3] VPWR VGND sg13cmos5l_antennanp
XFILLER_441_42 VPWR VGND sg13cmos5l_decap_8
XFILLER_85_160 VPWR VGND sg13cmos5l_fill_2
XFILLER_92_119 VPWR VGND sg13cmos5l_decap_4
XFILLER_37_31 VPWR VGND sg13cmos5l_decap_8
XFILLER_481_158 VPWR VGND sg13cmos5l_fill_2
XFILLER_160_21 VPWR VGND sg13cmos5l_decap_8
XANTENNA__2944__X Tile_X0Y8_EE4BEG[0] VPWR VGND sg13cmos5l_antennanp
XFILLER_422_203 VPWR VGND sg13cmos5l_decap_8
XFILLER_33_219 VPWR VGND sg13cmos5l_decap_8
XFILLER_310_35 VPWR VGND sg13cmos5l_decap_8
XFILLER_156_0 VPWR VGND sg13cmos5l_decap_8
XFILLER_667_49 VPWR VGND sg13cmos5l_decap_8
XFILLER_53_63 VPWR VGND sg13cmos5l_decap_8
XFILLER_186_213 VPWR VGND sg13cmos5l_fill_2
XFILLER_241_191 VPWR VGND sg13cmos5l_fill_1
XFILLER_53_96 VPWR VGND sg13cmos5l_decap_8
XFILLER_386_28 VPWR VGND sg13cmos5l_decap_8
XFILLER_169_63 VPWR VGND sg13cmos5l_decap_8
XFILLER_323_0 VPWR VGND sg13cmos5l_decap_8
XFILLER_139_140 VPWR VGND sg13cmos5l_decap_8
XFILLER_551_118 VPWR VGND sg13cmos5l_fill_1
XFILLER_466_72 VPWR VGND sg13cmos5l_fill_1
XFILLER_544_181 VPWR VGND sg13cmos5l_decap_8
XFILLER_616_42 VPWR VGND sg13cmos5l_decap_8
XFILLER_185_95 VPWR VGND sg13cmos5l_decap_8
XFILLER_692_0 VPWR VGND sg13cmos5l_decap_8
XFILLER_335_21 VPWR VGND sg13cmos5l_decap_8
XFILLER_457_100 VPWR VGND sg13cmos5l_decap_8
X_1320_ _1320_/Q Tile_X0Y1_FrameData[17] VGND VPWR Tile_X0Y9_FrameStrobe[4] latch
XFILLER_457_166 VPWR VGND sg13cmos5l_decap_8
X_1251_ _1251_/Q Tile_X0Y1_FrameData[22] VGND VPWR Tile_X0Y9_FrameStrobe[2] latch
XFILLER_68_149 VPWR VGND sg13cmos5l_decap_8
XFILLER_632_63 VPWR VGND sg13cmos5l_decap_8
XFILLER_606_119 VPWR VGND sg13cmos5l_fill_2
XFILLER_472_114 VPWR VGND sg13cmos5l_decap_8
XFILLER_204_14 VPWR VGND sg13cmos5l_decap_8
XANTENNA__3015__X Tile_X0Y5_E6BEG[2] VPWR VGND sg13cmos5l_antennanp
X_0202_ _0202_/Q Tile_X0Y7_FrameData[21] VGND VPWR Tile_X0Y9_FrameStrobe[1] latch
XFILLER_351_42 VPWR VGND sg13cmos5l_decap_8
XFILLER_209_133 VPWR VGND sg13cmos5l_decap_8
X_1182_ _1182_/Q Tile_X0Y1_FrameData[27] VGND VPWR Tile_X0Y9_FrameStrobe[0] latch
XFILLER_94_70 VPWR VGND sg13cmos5l_decap_8
XFILLER_614_141 VPWR VGND sg13cmos5l_decap_8
XANTENNA__2854__X Tile_X0Y6_E6BEG[3] VPWR VGND sg13cmos5l_antennanp
X_0133_ AXI_M_SOC_AWSIZE2 _0939_/Q _3681_/X VPWR VGND sg13cmos5l_nor2b_1
XFILLER_224_125 VPWR VGND sg13cmos5l_decap_4
XFILLER_614_185 VPWR VGND sg13cmos5l_fill_1
XFILLER_413_225 VPWR VGND sg13cmos5l_decap_4
XFILLER_501_56 VPWR VGND sg13cmos5l_decap_8
XFILLER_24_208 VPWR VGND sg13cmos5l_decap_8
XFILLER_91_174 VPWR VGND sg13cmos5l_decap_4
X_0064_ _0064_/X _4108_/X _4109_/X _2666_/Q VPWR VGND sg13cmos5l_mux2_1
XFILLER_220_35 VPWR VGND sg13cmos5l_decap_8
X_4872_ _4872_/X Tile_X0Y9_WW4END[7] AXI_M_SOC_RDATA7 _4923_/X _4900_/X _0799_/Q _0798_/Q
+ VPWR VGND sg13cmos5l_mux4_1
XFILLER_577_49 VPWR VGND sg13cmos5l_decap_8
X_3823_ _3823_/X Tile_X0Y0_WW4END[6] Tile_X0Y0_WW4END[12] _3875_/X _3858_/X _1059_/Q
+ _1058_/Q VPWR VGND sg13cmos5l_mux4_1
XFILLER_296_28 VPWR VGND sg13cmos5l_decap_8
X_3754_ AXI_M_SOC_ARADDR26 Tile_X0Y8_WW4END[2] Tile_X0Y8_WW4END[10] Tile_X0Y8_W6END[10]
+ _4810_/X _0483_/Q _0482_/Q VPWR VGND sg13cmos5l_mux4_1
XFILLER_393_176 VPWR VGND sg13cmos5l_decap_8
XFILLER_71_0 VPWR VGND sg13cmos5l_decap_8
X_0966_ _0966_/Q Tile_X0Y0_FrameData[5] VGND VPWR Tile_X0Y9_FrameStrobe[0] latch
X_2705_ _4309_/A3 VPWR VGND sg13cmos5l_tielo
XFILLER_229_77 VPWR VGND sg13cmos5l_fill_1
X_3685_ _3685_/X Tile_X0Y3_WW4END[3] Tile_X0Y3_WW4END[11] Tile_X0Y3_W6END[3] _4225_/X
+ _1751_/Q _1750_/Q VPWR VGND sg13cmos5l_mux4_1
X_0897_ _0897_/Q Tile_X0Y9_FrameData[30] VGND VPWR Tile_X0Y9_FrameStrobe[7] latch
XFILLER_526_42 VPWR VGND sg13cmos5l_decap_8
X_2636_ _2636_/Q Tile_X0Y6_FrameData[27] VGND VPWR Tile_X0Y9_FrameStrobe[6] latch
XFILLER_673_70 VPWR VGND sg13cmos5l_decap_8
XFILLER_245_21 VPWR VGND sg13cmos5l_decap_8
XFILLER_550_184 VPWR VGND sg13cmos5l_decap_8
XFILLER_495_228 VPWR VGND sg13cmos5l_fill_1
X_2567_ _2567_/Q Tile_X0Y6_FrameData[0] VGND VPWR Tile_X0Y9_FrameStrobe[3] latch
XFILLER_696_199 VPWR VGND sg13cmos5l_fill_2
XFILLER_637_211 VPWR VGND sg13cmos5l_fill_1
X_4306_ _4306_/X _4308_/X Tile_X0Y4_W6END[2] _4307_/X _4306_/A3 _1929_/Q _1928_/Q
+ VPWR VGND sg13cmos5l_mux4_1
X_1518_ _1518_/Q Tile_X0Y2_FrameData[3] VGND VPWR Tile_X0Y9_FrameStrobe[2] latch
XFILLER_245_98 VPWR VGND sg13cmos5l_decap_8
X_2498_ _2498_/Q Tile_X0Y6_FrameData[5] VGND VPWR Tile_X0Y9_FrameStrobe[1] latch
XFILLER_247_206 VPWR VGND sg13cmos5l_decap_8
X_4237_ _4237_/X Tile_X0Y5_W2MID[7] Tile_X0Y5_W2END[7] Tile_X0Y5_W6END[7] _4467_/X
+ _2431_/Q _2430_/Q VPWR VGND sg13cmos5l_mux4_1
XFILLER_542_63 VPWR VGND sg13cmos5l_decap_8
XFILLER_114_14 VPWR VGND sg13cmos5l_decap_8
X_1449_ _1449_/Q Tile_X0Y2_FrameData[8] VGND VPWR Tile_X0Y9_FrameStrobe[0] latch
XFILLER_463_125 VPWR VGND sg13cmos5l_decap_8
XFILLER_261_42 VPWR VGND sg13cmos5l_decap_8
X_4168_ _4168_/X Tile_X0Y3_WW4END[11] AXI_M_SOC_WREADY _4233_/X _4211_/X _1805_/Q
+ _1804_/Q VPWR VGND sg13cmos5l_mux4_1
XANTENNA__2764__X Tile_X0Y3_FrameData_O[22] VPWR VGND sg13cmos5l_antennanp
X_3119_ Tile_X0Y7_EE4BEG[5] _4633_/X VPWR VGND sg13cmos5l_buf_1
XFILLER_82_141 VPWR VGND sg13cmos5l_fill_1
XFILLER_404_214 VPWR VGND sg13cmos5l_decap_8
X_4099_ _4099_/X _4023_/X _4131_/X _4130_/X _4022_/X _1447_/Q _1446_/Q VPWR VGND sg13cmos5l_mux4_1
XFILLER_404_225 VPWR VGND sg13cmos5l_decap_4
XFILLER_411_56 VPWR VGND sg13cmos5l_decap_8
XFILLER_215_147 VPWR VGND sg13cmos5l_decap_4
XFILLER_130_35 VPWR VGND sg13cmos5l_decap_8
XFILLER_230_117 VPWR VGND sg13cmos5l_decap_8
XFILLER_230_128 VPWR VGND sg13cmos5l_fill_1
XFILLER_90_28 VPWR VGND sg13cmos5l_decap_8
XFILLER_247_7 VPWR VGND sg13cmos5l_decap_8
XFILLER_487_49 VPWR VGND sg13cmos5l_decap_8
XFILLER_573_210 VPWR VGND sg13cmos5l_decap_8
XFILLER_518_115 VPWR VGND sg13cmos5l_decap_4
XANTENNA__3595__X Tile_X0Y9_FrameData_O[25] VPWR VGND sg13cmos5l_antennanp
XFILLER_384_154 VPWR VGND sg13cmos5l_fill_2
XFILLER_414_7 VPWR VGND sg13cmos5l_decap_8
XFILLER_23_77 VPWR VGND sg13cmos5l_decap_8
XFILLER_23_99 VPWR VGND sg13cmos5l_decap_8
XFILLER_526_170 VPWR VGND sg13cmos5l_fill_2
XFILLER_139_77 VPWR VGND sg13cmos5l_decap_8
XFILLER_136_154 VPWR VGND sg13cmos5l_decap_8
XFILLER_436_42 VPWR VGND sg13cmos5l_decap_8
XFILLER_583_70 VPWR VGND sg13cmos5l_decap_8
XFILLER_155_21 VPWR VGND sg13cmos5l_decap_8
XANTENNA__2939__X Tile_X0Y8_E6BEG[7] VPWR VGND sg13cmos5l_antennanp
XFILLER_628_200 VPWR VGND sg13cmos5l_fill_1
XFILLER_628_222 VPWR VGND sg13cmos5l_decap_8
XFILLER_439_133 VPWR VGND sg13cmos5l_decap_8
XFILLER_305_35 VPWR VGND sg13cmos5l_decap_8
XFILLER_643_203 VPWR VGND sg13cmos5l_decap_8
XFILLER_452_63 VPWR VGND sg13cmos5l_decap_8
XFILLER_48_52 VPWR VGND sg13cmos5l_decap_8
XFILLER_171_42 VPWR VGND sg13cmos5l_decap_8
XFILLER_273_0 VPWR VGND sg13cmos5l_decap_8
XFILLER_602_77 VPWR VGND sg13cmos5l_decap_8
XFILLER_73_141 VPWR VGND sg13cmos5l_decap_8
XFILLER_321_56 VPWR VGND sg13cmos5l_decap_8
XFILLER_206_147 VPWR VGND sg13cmos5l_decap_8
XFILLER_440_0 VPWR VGND sg13cmos5l_decap_8
XFILLER_538_0 VPWR VGND sg13cmos5l_decap_8
XFILLER_397_49 VPWR VGND sg13cmos5l_decap_8
XFILLER_9_35 VPWR VGND sg13cmos5l_decap_8
XFILLER_694_14 VPWR VGND sg13cmos5l_decap_8
XFILLER_509_126 VPWR VGND sg13cmos5l_decap_8
XFILLER_375_121 VPWR VGND sg13cmos5l_decap_4
XFILLER_375_132 VPWR VGND sg13cmos5l_fill_2
XFILLER_705_0 VPWR VGND sg13cmos5l_decap_8
XFILLER_477_82 VPWR VGND sg13cmos5l_decap_8
X_0820_ _0820_/Q Tile_X0Y9_FrameData[11] VGND VPWR Tile_X0Y9_FrameStrobe[4] latch
XFILLER_375_176 VPWR VGND sg13cmos5l_decap_4
XFILLER_375_187 VPWR VGND sg13cmos5l_decap_8
XFILLER_375_198 VPWR VGND sg13cmos5l_decap_8
XFILLER_196_61 VPWR VGND sg13cmos5l_decap_8
XFILLER_390_135 VPWR VGND sg13cmos5l_decap_8
XFILLER_316_221 VPWR VGND sg13cmos5l_decap_8
X_0751_ _0751_/Q Tile_X0Y9_FrameData[16] VGND VPWR Tile_X0Y9_FrameStrobe[2] latch
XFILLER_627_63 VPWR VGND sg13cmos5l_decap_8
XFILLER_346_42 VPWR VGND sg13cmos5l_decap_8
X_0682_ _0682_/Q Tile_X0Y9_FrameData[21] VGND VPWR Tile_X0Y9_FrameStrobe[0] latch
X_3470_ Tile_X0Y1_FrameData_O[28] Tile_X0Y1_FrameData[28] VPWR VGND sg13cmos5l_buf_1
XFILLER_532_151 VPWR VGND sg13cmos5l_decap_8
XFILLER_493_70 VPWR VGND sg13cmos5l_decap_8
XFILLER_89_70 VPWR VGND sg13cmos5l_fill_2
XFILLER_288_117 VPWR VGND sg13cmos5l_decap_8
X_2421_ _2421_/Q Tile_X0Y5_FrameData[16] VGND VPWR Tile_X0Y9_FrameStrobe[7] latch
XFILLER_678_177 VPWR VGND sg13cmos5l_fill_2
XANTENNA__2849__X Tile_X0Y6_E2BEGb[6] VPWR VGND sg13cmos5l_antennanp
XFILLER_142_168 VPWR VGND sg13cmos5l_decap_8
X_2352_ _2352_/Q Tile_X0Y5_FrameData[21] VGND VPWR Tile_X0Y9_FrameStrobe[5] latch
XFILLER_643_84 VPWR VGND sg13cmos5l_decap_8
XFILLER_215_35 VPWR VGND sg13cmos5l_decap_8
X_1303_ _1303_/Q Tile_X0Y1_FrameData[2] VGND VPWR Tile_X0Y9_FrameStrobe[3] latch
XFILLER_362_63 VPWR VGND sg13cmos5l_decap_8
XFILLER_296_172 VPWR VGND sg13cmos5l_fill_2
X_2283_ _2283_/Q Tile_X0Y5_FrameData[26] VGND VPWR Tile_X0Y9_FrameStrobe[3] latch
XFILLER_634_203 VPWR VGND sg13cmos5l_fill_1
XFILLER_56_108 VPWR VGND sg13cmos5l_decap_4
X_1234_ _1234_/Q Tile_X0Y1_FrameData[7] VGND VPWR Tile_X0Y9_FrameStrobe[1] latch
X_4022_ _4022_/X Tile_X0Y0_W2MID[6] Tile_X0Y0_W2END[6] Tile_X0Y0_W6END[9] _3855_/X
+ _1131_/Q _1130_/Q VPWR VGND sg13cmos5l_mux4_1
XFILLER_512_77 VPWR VGND sg13cmos5l_decap_8
X_1165_ _1165_/Q Tile_X0Y0_FrameData[30] VGND VPWR Tile_X0Y9_FrameStrobe[7] latch
XFILLER_252_220 VPWR VGND sg13cmos5l_decap_8
XFILLER_231_56 VPWR VGND sg13cmos5l_decap_8
X_0116_ AXI_M_SOC_ARLEN7 _0933_/Q _3767_/X VPWR VGND sg13cmos5l_nor2b_1
X_1096_ _1096_/Q Tile_X0Y0_FrameData[3] VGND VPWR Tile_X0Y9_FrameStrobe[4] latch
XFILLER_64_185 VPWR VGND sg13cmos5l_decap_8
X_0047_ AXI_M_SOC_AWCACHE2 _0936_/Q _3687_/X VPWR VGND sg13cmos5l_nor2b_1
X_4924_ _4924_/X Tile_X0Y9_N1END[0] Tile_X0Y9_N4END[0] _4896_/X _0083_/X _0711_/Q
+ _0710_/Q VPWR VGND sg13cmos5l_mux4_1
XFILLER_668_70 VPWR VGND sg13cmos5l_decap_8
X_4855_ _4855_/X Tile_X0Y9_W2MID[0] AXI_M_SOC_RDATA7 _4901_/X _4900_/X _0833_/Q _0832_/Q
+ VPWR VGND sg13cmos5l_mux4_1
XFILLER_555_221 VPWR VGND sg13cmos5l_decap_8
XFILLER_100_49 VPWR VGND sg13cmos5l_decap_8
X_3806_ _3806_/X Tile_X0Y0_W2MID[5] Tile_X0Y0_W2END[2] _3857_/X _3856_/X _1093_/Q
+ _1092_/Q VPWR VGND sg13cmos5l_mux4_1
X_4786_ _4786_/X _4713_/X Tile_X0Y9_N2MID[6] _4822_/X _4712_/X _0427_/Q _0426_/Q VPWR
+ VGND sg13cmos5l_mux4_1
XFILLER_381_102 VPWR VGND sg13cmos5l_decap_4
XFILLER_165_227 VPWR VGND sg13cmos5l_fill_2
X_1998_ _1998_/Q Tile_X0Y4_FrameData[23] VGND VPWR Tile_X0Y9_FrameStrobe[2] latch
XFILLER_307_221 VPWR VGND sg13cmos5l_fill_1
X_3737_ AXI_M_SOC_ARADDR9 Tile_X0Y9_WW4END[1] Tile_X0Y9_WW4END[9] Tile_X0Y9_W6END[9]
+ _4925_/X _0741_/Q _0740_/Q VPWR VGND sg13cmos5l_mux4_1
XFILLER_537_63 VPWR VGND sg13cmos5l_decap_8
XFILLER_109_14 VPWR VGND sg13cmos5l_decap_8
X_0949_ _0949_/Q Tile_X0Y0_FrameData[22] VGND VPWR Tile_X0Y9_FrameStrobe[0] latch
XFILLER_684_91 VPWR VGND sg13cmos5l_decap_8
XFILLER_256_42 VPWR VGND sg13cmos5l_decap_8
X_3668_ AXI_M_SOC_AWADDR29 Tile_X0Y4_W1END[1] Tile_X0Y4_WW4END[5] Tile_X0Y4_WW4END[13]
+ _4349_/X _1987_/Q _1986_/Q VPWR VGND sg13cmos5l_mux4_1
XFILLER_669_166 VPWR VGND sg13cmos5l_decap_8
XFILLER_256_97 VPWR VGND sg13cmos5l_decap_8
XANTENNA__2759__X Tile_X0Y3_FrameData_O[17] VPWR VGND sg13cmos5l_antennanp
X_2619_ _2619_/Q Tile_X0Y6_FrameData[12] VGND VPWR Tile_X0Y9_FrameStrobe[5] latch
X_3599_ Tile_X0Y9_FrameData_O[29] Tile_X0Y9_FrameData[29] VPWR VGND sg13cmos5l_buf_1
XFILLER_406_56 VPWR VGND sg13cmos5l_decap_8
XFILLER_553_84 VPWR VGND sg13cmos5l_decap_8
XFILLER_125_35 VPWR VGND sg13cmos5l_decap_8
XFILLER_703_21 VPWR VGND sg13cmos5l_decap_8
XFILLER_287_183 VPWR VGND sg13cmos5l_decap_8
XFILLER_272_63 VPWR VGND sg13cmos5l_decap_8
XFILLER_85_28 VPWR VGND sg13cmos5l_decap_8
XFILLER_287_194 VPWR VGND sg13cmos5l_fill_1
XFILLER_197_7 VPWR VGND sg13cmos5l_decap_8
XFILLER_703_98 VPWR VGND sg13cmos5l_decap_8
XFILLER_422_77 VPWR VGND sg13cmos5l_decap_8
XFILLER_640_228 VPWR VGND sg13cmos5l_fill_1
XFILLER_364_7 VPWR VGND sg13cmos5l_decap_8
XFILLER_18_77 VPWR VGND sg13cmos5l_decap_4
XFILLER_141_56 VPWR VGND sg13cmos5l_decap_8
XFILLER_55_174 VPWR VGND sg13cmos5l_decap_8
XFILLER_34_10 VPWR VGND sg13cmos5l_decap_8
XFILLER_70_133 VPWR VGND sg13cmos5l_decap_8
XFILLER_531_7 VPWR VGND sg13cmos5l_decap_8
XFILLER_629_7 VPWR VGND sg13cmos5l_decap_8
XFILLER_34_43 VPWR VGND sg13cmos5l_decap_8
XFILLER_578_70 VPWR VGND sg13cmos5l_decap_8
XFILLER_34_98 VPWR VGND sg13cmos5l_fill_2
XFILLER_357_154 VPWR VGND sg13cmos5l_decap_8
XFILLER_561_213 VPWR VGND sg13cmos5l_fill_1
XFILLER_664_28 VPWR VGND sg13cmos5l_decap_8
XFILLER_447_63 VPWR VGND sg13cmos5l_decap_8
XFILLER_50_64 VPWR VGND sg13cmos5l_decap_8
XFILLER_594_91 VPWR VGND sg13cmos5l_decap_8
XFILLER_372_168 VPWR VGND sg13cmos5l_fill_2
XFILLER_166_42 VPWR VGND sg13cmos5l_decap_8
XFILLER_119_0 VPWR VGND sg13cmos5l_decap_8
XFILLER_109_165 VPWR VGND sg13cmos5l_decap_4
XFILLER_313_213 VPWR VGND sg13cmos5l_decap_8
XFILLER_124_124 VPWR VGND sg13cmos5l_fill_2
XFILLER_459_228 VPWR VGND sg13cmos5l_fill_1
XFILLER_1_0 VPWR VGND sg13cmos5l_decap_8
XFILLER_680_27 VPWR VGND sg13cmos5l_decap_8
XFILLER_316_56 VPWR VGND sg13cmos5l_decap_8
XFILLER_59_62 VPWR VGND sg13cmos5l_decap_8
XFILLER_613_21 VPWR VGND sg13cmos5l_decap_8
XFILLER_390_0 VPWR VGND sg13cmos5l_decap_8
XFILLER_278_161 VPWR VGND sg13cmos5l_decap_8
XFILLER_488_0 VPWR VGND sg13cmos5l_decap_8
XFILLER_182_63 VPWR VGND sg13cmos5l_decap_8
XFILLER_683_191 VPWR VGND sg13cmos5l_fill_2
XFILLER_427_147 VPWR VGND sg13cmos5l_decap_8
XFILLER_613_98 VPWR VGND sg13cmos5l_decap_8
XFILLER_689_14 VPWR VGND sg13cmos5l_decap_8
XFILLER_689_25 VPWR VGND sg13cmos5l_decap_8
XFILLER_655_0 VPWR VGND sg13cmos5l_decap_8
XFILLER_631_228 VPWR VGND sg13cmos5l_fill_1
XFILLER_596_143 VPWR VGND sg13cmos5l_decap_8
X_2970_ Tile_X0Y8_FrameData_O[10] Tile_X0Y8_FrameData[10] VPWR VGND sg13cmos5l_buf_1
XFILLER_488_70 VPWR VGND sg13cmos5l_decap_8
XFILLER_450_194 VPWR VGND sg13cmos5l_decap_8
XFILLER_61_188 VPWR VGND sg13cmos5l_decap_8
X_1921_ _1921_/Q Tile_X0Y3_FrameData[8] VGND VPWR Tile_X0Y9_FrameStrobe[7] latch
XFILLER_537_221 VPWR VGND sg13cmos5l_decap_8
XFILLER_348_154 VPWR VGND sg13cmos5l_decap_8
X_4640_ _4640_/X Tile_X0Y7_WW4END[3] AXI_M_SOC_RDATA19 _4687_/X _4675_/X _0279_/Q
+ _0278_/Q VPWR VGND sg13cmos5l_mux4_1
XFILLER_348_165 VPWR VGND sg13cmos5l_fill_1
X_1852_ _1852_/Q Tile_X0Y3_FrameData[13] VGND VPWR Tile_X0Y9_FrameStrobe[5] latch
XFILLER_638_84 VPWR VGND sg13cmos5l_decap_8
XFILLER_348_187 VPWR VGND sg13cmos5l_decap_8
XFILLER_348_198 VPWR VGND sg13cmos5l_fill_1
X_0803_ _0803_/Q Tile_X0Y9_FrameData[28] VGND VPWR Tile_X0Y9_FrameStrobe[4] latch
XFILLER_574_28 VPWR VGND sg13cmos5l_decap_8
X_4571_ _4571_/X _4551_/X Tile_X0Y9_N4END[15] _4550_/X _0150_/X _2489_/Q _2488_/Q
+ VPWR VGND sg13cmos5l_mux4_1
XFILLER_698_228 VPWR VGND sg13cmos5l_fill_1
XFILLER_357_63 VPWR VGND sg13cmos5l_decap_8
X_1783_ _1783_/Q Tile_X0Y3_FrameData[18] VGND VPWR Tile_X0Y9_FrameStrobe[3] latch
X_3522_ Tile_X0Y9_E1BEG[0] _4844_/X VPWR VGND sg13cmos5l_buf_1
XFILLER_505_140 VPWR VGND sg13cmos5l_decap_8
X_0734_ _0734_/Q Tile_X0Y9_FrameData[1] VGND VPWR Tile_X0Y9_FrameStrobe[1] latch
XFILLER_507_77 VPWR VGND sg13cmos5l_decap_8
X_3453_ Tile_X0Y1_FrameData_O[11] Tile_X0Y1_FrameData[11] VPWR VGND sg13cmos5l_buf_1
X_0665_ _0665_/Q Tile_X0Y8_FrameData[6] VGND VPWR Tile_X0Y9_FrameStrobe[7] latch
XFILLER_115_157 VPWR VGND sg13cmos5l_decap_8
XFILLER_226_56 VPWR VGND sg13cmos5l_decap_8
XFILLER_130_105 VPWR VGND sg13cmos5l_decap_8
X_2404_ _2404_/Q Tile_X0Y5_FrameData[1] VGND VPWR Tile_X0Y9_FrameStrobe[6] latch
XFILLER_590_49 VPWR VGND sg13cmos5l_decap_8
X_0596_ _0596_/Q Tile_X0Y8_FrameData[11] VGND VPWR Tile_X0Y9_FrameStrobe[5] latch
X_3384_ Tile_X0Y2_E6BEG[7] _4079_/X VPWR VGND sg13cmos5l_buf_1
XFILLER_373_84 VPWR VGND sg13cmos5l_decap_8
XFILLER_523_21 VPWR VGND sg13cmos5l_decap_8
XFILLER_34_0 VPWR VGND sg13cmos5l_fill_1
X_2335_ _2335_/Q Tile_X0Y5_FrameData[6] VGND VPWR Tile_X0Y9_FrameStrobe[4] latch
XFILLER_418_114 VPWR VGND sg13cmos5l_fill_2
XFILLER_674_191 VPWR VGND sg13cmos5l_fill_2
XFILLER_29_119 VPWR VGND sg13cmos5l_decap_8
X_2266_ _2266_/Q Tile_X0Y5_FrameData[11] VGND VPWR Tile_X0Y9_FrameStrobe[2] latch
XFILLER_599_14 VPWR VGND sg13cmos5l_decap_8
XFILLER_284_175 VPWR VGND sg13cmos5l_decap_8
X_4005_ _4005_/X _3981_/X _0073_/X _3980_/X Tile_X0Y0_S4END[4] _1209_/Q _1208_/Q VPWR
+ VGND sg13cmos5l_mux4_1
XFILLER_242_77 VPWR VGND sg13cmos5l_decap_4
X_1217_ _1217_/Q Tile_X0Y1_FrameData[24] VGND VPWR Tile_X0Y9_FrameStrobe[1] latch
X_2197_ _2197_/Q Tile_X0Y5_FrameData[16] VGND VPWR Tile_X0Y9_FrameStrobe[0] latch
XANTENNA__3203__X Tile_X0Y0_N2BEG[3] VPWR VGND sg13cmos5l_antennanp
XFILLER_37_174 VPWR VGND sg13cmos5l_fill_1
X_1148_ _1148_/Q Tile_X0Y0_FrameData[15] VGND VPWR Tile_X0Y9_FrameStrobe[6] latch
XFILLER_52_111 VPWR VGND sg13cmos5l_decap_8
XFILLER_679_91 VPWR VGND sg13cmos5l_decap_8
XFILLER_197_105 VPWR VGND sg13cmos5l_decap_4
XFILLER_441_172 VPWR VGND sg13cmos5l_decap_8
X_1079_ _1079_/Q Tile_X0Y0_FrameData[20] VGND VPWR Tile_X0Y9_FrameStrobe[4] latch
XFILLER_441_194 VPWR VGND sg13cmos5l_decap_8
XFILLER_587_198 VPWR VGND sg13cmos5l_fill_2
X_4907_ _4907_/X Tile_X0Y9_N2MID[3] Tile_X0Y9_N2END[3] _4935_/X _4819_/X _0689_/Q
+ _0688_/Q VPWR VGND sg13cmos5l_mux4_1
XFILLER_339_143 VPWR VGND sg13cmos5l_decap_4
X_4838_ _4838_/X Tile_X0Y9_W1END[1] Tile_X0Y9_WW4END[13] Tile_X0Y9_W6END[5] _4917_/X
+ _0864_/Q _0863_/Q VPWR VGND sg13cmos5l_mux4_1
XFILLER_339_176 VPWR VGND sg13cmos5l_decap_8
XFILLER_548_84 VPWR VGND sg13cmos5l_decap_8
XFILLER_543_213 VPWR VGND sg13cmos5l_decap_8
XFILLER_548_95 VPWR VGND sg13cmos5l_fill_2
XFILLER_267_63 VPWR VGND sg13cmos5l_decap_8
X_4769_ _4769_/X AXI_M_SOC_RDATA13 _4802_/X _4806_/X _4788_/X _0509_/Q _0508_/Q VPWR
+ VGND sg13cmos5l_mux4_1
XFILLER_354_168 VPWR VGND sg13cmos5l_decap_8
XFILLER_112_7 VPWR VGND sg13cmos5l_decap_8
XFILLER_20_56 VPWR VGND sg13cmos5l_decap_8
XFILLER_417_77 VPWR VGND sg13cmos5l_decap_8
XFILLER_657_136 VPWR VGND sg13cmos5l_fill_2
XFILLER_20_89 VPWR VGND sg13cmos5l_fill_2
XFILLER_136_56 VPWR VGND sg13cmos5l_decap_8
XFILLER_310_216 VPWR VGND sg13cmos5l_decap_4
XFILLER_121_116 VPWR VGND sg13cmos5l_decap_8
XFILLER_714_64 VPWR VGND sg13cmos5l_decap_8
XFILLER_283_84 VPWR VGND sg13cmos5l_decap_8
XFILLER_433_21 VPWR VGND sg13cmos5l_decap_8
XFILLER_96_49 VPWR VGND sg13cmos5l_decap_8
XFILLER_481_7 VPWR VGND sg13cmos5l_decap_8
XFILLER_29_21 VPWR VGND sg13cmos5l_decap_8
XFILLER_579_7 VPWR VGND sg13cmos5l_decap_8
XFILLER_433_98 VPWR VGND sg13cmos5l_decap_8
XFILLER_275_164 VPWR VGND sg13cmos5l_decap_8
XFILLER_290_112 VPWR VGND sg13cmos5l_decap_8
XFILLER_152_77 VPWR VGND sg13cmos5l_fill_2
XFILLER_302_14 VPWR VGND sg13cmos5l_decap_8
XANTENNA__3113__X Tile_X0Y7_E6BEG[11] VPWR VGND sg13cmos5l_antennanp
XFILLER_417_191 VPWR VGND sg13cmos5l_decap_8
XFILLER_45_31 VPWR VGND sg13cmos5l_decap_8
XFILLER_43_100 VPWR VGND sg13cmos5l_decap_8
XFILLER_659_28 VPWR VGND sg13cmos5l_decap_8
XFILLER_589_91 VPWR VGND sg13cmos5l_decap_8
XFILLER_43_133 VPWR VGND sg13cmos5l_decap_8
XFILLER_432_161 VPWR VGND sg13cmos5l_decap_8
XANTENNA__2952__X Tile_X0Y8_EE4BEG[8] VPWR VGND sg13cmos5l_antennanp
XFILLER_578_154 VPWR VGND sg13cmos5l_decap_8
XFILLER_519_210 VPWR VGND sg13cmos5l_decap_8
XFILLER_236_0 VPWR VGND sg13cmos5l_decap_8
XFILLER_61_41 VPWR VGND sg13cmos5l_decap_8
XFILLER_392_219 VPWR VGND sg13cmos5l_fill_2
XFILLER_675_49 VPWR VGND sg13cmos5l_decap_8
XFILLER_608_21 VPWR VGND sg13cmos5l_decap_8
XFILLER_394_28 VPWR VGND sg13cmos5l_decap_8
XFILLER_177_63 VPWR VGND sg13cmos5l_decap_8
XFILLER_6_14 VPWR VGND sg13cmos5l_decap_8
XFILLER_403_0 VPWR VGND sg13cmos5l_decap_8
XFILLER_177_85 VPWR VGND sg13cmos5l_decap_8
XANTENNA_7 AXI_M_SOC_RDATA13 VPWR VGND sg13cmos5l_antennanp
XFILLER_608_98 VPWR VGND sg13cmos5l_fill_1
XFILLER_360_127 VPWR VGND sg13cmos5l_decap_4
XFILLER_360_138 VPWR VGND sg13cmos5l_fill_2
XFILLER_499_161 VPWR VGND sg13cmos5l_decap_8
XFILLER_298_212 VPWR VGND sg13cmos5l_fill_1
XFILLER_327_88 VPWR VGND sg13cmos5l_decap_8
XFILLER_624_42 VPWR VGND sg13cmos5l_decap_8
XFILLER_502_154 VPWR VGND sg13cmos5l_decap_8
XFILLER_112_105 VPWR VGND sg13cmos5l_decap_4
X_0450_ _0450_/Q Tile_X0Y8_FrameData[29] VGND VPWR Tile_X0Y9_FrameStrobe[1] latch
XFILLER_193_84 VPWR VGND sg13cmos5l_decap_8
XFILLER_447_209 VPWR VGND sg13cmos5l_decap_8
XFILLER_343_21 VPWR VGND sg13cmos5l_decap_8
X_0381_ _0381_/Q Tile_X0Y7_FrameData[2] VGND VPWR Tile_X0Y9_FrameStrobe[6] latch
XFILLER_266_131 VPWR VGND sg13cmos5l_decap_8
X_2120_ _2120_/Q Tile_X0Y4_FrameData[29] VGND VPWR Tile_X0Y9_FrameStrobe[6] latch
XFILLER_343_98 VPWR VGND sg13cmos5l_decap_8
XFILLER_281_112 VPWR VGND sg13cmos5l_decap_8
X_2051_ _2051_/Q Tile_X0Y4_FrameData[2] VGND VPWR Tile_X0Y9_FrameStrobe[3] latch
XFILLER_640_63 VPWR VGND sg13cmos5l_decap_8
XFILLER_470_223 VPWR VGND sg13cmos5l_decap_4
XFILLER_212_14 VPWR VGND sg13cmos5l_decap_8
XANTENNA__3023__X Tile_X0Y5_E6BEG[10] VPWR VGND sg13cmos5l_antennanp
X_1002_ _1002_/Q Tile_X0Y0_FrameData[1] VGND VPWR Tile_X0Y9_FrameStrobe[1] latch
XFILLER_34_100 VPWR VGND sg13cmos5l_fill_1
XFILLER_569_28 VPWR VGND sg13cmos5l_decap_8
XFILLER_34_122 VPWR VGND sg13cmos5l_decap_8
XFILLER_281_189 VPWR VGND sg13cmos5l_decap_8
XFILLER_423_161 VPWR VGND sg13cmos5l_decap_4
XFILLER_569_154 VPWR VGND sg13cmos5l_decap_8
XFILLER_499_91 VPWR VGND sg13cmos5l_decap_8
XANTENNA__2862__X Tile_X0Y6_E6BEG[11] VPWR VGND sg13cmos5l_antennanp
X_2953_ Tile_X0Y8_EE4BEG[9] _4753_/X VPWR VGND sg13cmos5l_buf_1
X_1904_ _1904_/Q Tile_X0Y3_FrameData[25] VGND VPWR Tile_X0Y9_FrameStrobe[7] latch
XFILLER_336_102 VPWR VGND sg13cmos5l_fill_1
X_2884_ Tile_X0Y6_FrameData_O[5] Tile_X0Y6_FrameData[5] VPWR VGND sg13cmos5l_buf_1
XFILLER_585_49 VPWR VGND sg13cmos5l_decap_8
XFILLER_368_84 VPWR VGND sg13cmos5l_decap_8
XFILLER_525_213 VPWR VGND sg13cmos5l_decap_4
XFILLER_518_21 VPWR VGND sg13cmos5l_decap_8
XFILLER_336_124 VPWR VGND sg13cmos5l_decap_8
X_4623_ _4623_/X Tile_X0Y7_W2END[4] AXI_M_SOC_RDATA20 _4675_/X _4674_/X _0313_/Q _0312_/Q
+ VPWR VGND sg13cmos5l_mux4_1
X_1835_ _1835_/Q Tile_X0Y3_FrameData[30] VGND VPWR Tile_X0Y9_FrameStrobe[5] latch
XANTENNA__3693__X AXI_M_SOC_WDATA3 VPWR VGND sg13cmos5l_antennanp
XFILLER_351_105 VPWR VGND sg13cmos5l_decap_8
X_4554_ _4554_/X _4481_/X _4597_/X _4596_/X _4480_/X _2451_/Q _2450_/Q VPWR VGND sg13cmos5l_mux4_1
X_1766_ _1766_/Q Tile_X0Y3_FrameData[3] VGND VPWR Tile_X0Y9_FrameStrobe[2] latch
XFILLER_289_201 VPWR VGND sg13cmos5l_decap_8
X_3505_ Tile_X0Y1_E2BEGb[3] _3943_/X VPWR VGND sg13cmos5l_buf_1
XFILLER_237_77 VPWR VGND sg13cmos5l_fill_2
X_0717_ _0717_/Q Tile_X0Y9_FrameData[18] VGND VPWR Tile_X0Y9_FrameStrobe[1] latch
X_4485_ _4485_/X _4572_/X _4576_/X _4580_/X _4558_/X _2635_/Q _2634_/Q VPWR VGND sg13cmos5l_mux4_1
X_1697_ _1697_/Q Tile_X0Y3_FrameData[8] VGND VPWR Tile_X0Y9_FrameStrobe[0] latch
XFILLER_639_147 VPWR VGND sg13cmos5l_decap_8
XFILLER_534_42 VPWR VGND sg13cmos5l_decap_8
X_3436_ Tile_X0Y4_FrameData_O[27] Tile_X0Y4_FrameData[27] VPWR VGND sg13cmos5l_buf_1
X_0648_ _0648_/Q Tile_X0Y8_FrameData[23] VGND VPWR Tile_X0Y9_FrameStrobe[7] latch
XFILLER_681_70 VPWR VGND sg13cmos5l_decap_8
XFILLER_253_21 VPWR VGND sg13cmos5l_decap_8
X_3367_ Tile_X0Y2_EE4BEG[6] _4062_/X VPWR VGND sg13cmos5l_buf_1
X_0579_ _0579_/Q Tile_X0Y8_FrameData[28] VGND VPWR Tile_X0Y9_FrameStrobe[5] latch
X_2318_ _2318_/Q Tile_X0Y5_FrameData[23] VGND VPWR Tile_X0Y9_FrameStrobe[4] latch
XFILLER_257_153 VPWR VGND sg13cmos5l_fill_1
X_3298_ Tile_X0Y0_E2BEGb[6] _3818_/X VPWR VGND sg13cmos5l_buf_1
XFILLER_403_35 VPWR VGND sg13cmos5l_decap_8
XFILLER_461_201 VPWR VGND sg13cmos5l_decap_8
XFILLER_461_212 VPWR VGND sg13cmos5l_fill_1
XFILLER_550_63 VPWR VGND sg13cmos5l_decap_8
XFILLER_122_14 VPWR VGND sg13cmos5l_decap_8
X_2249_ _2249_/Q Tile_X0Y5_FrameData[28] VGND VPWR Tile_X0Y9_FrameStrobe[2] latch
XFILLER_406_139 VPWR VGND sg13cmos5l_fill_2
XFILLER_72_228 VPWR VGND sg13cmos5l_fill_1
XFILLER_272_156 VPWR VGND sg13cmos5l_decap_8
XFILLER_700_44 VPWR VGND sg13cmos5l_decap_8
XFILLER_479_28 VPWR VGND sg13cmos5l_decap_8
XFILLER_414_150 VPWR VGND sg13cmos5l_decap_8
XFILLER_414_161 VPWR VGND sg13cmos5l_fill_1
XANTENNA__2772__X Tile_X0Y3_FrameData_O[30] VPWR VGND sg13cmos5l_antennanp
XFILLER_202_91 VPWR VGND sg13cmos5l_decap_8
XFILLER_15_56 VPWR VGND sg13cmos5l_decap_8
XFILLER_575_168 VPWR VGND sg13cmos5l_decap_8
XFILLER_709_42 VPWR VGND sg13cmos5l_decap_8
XFILLER_590_105 VPWR VGND sg13cmos5l_decap_4
XFILLER_327_102 VPWR VGND sg13cmos5l_decap_8
XFILLER_495_49 VPWR VGND sg13cmos5l_decap_8
XFILLER_327_7 VPWR VGND sg13cmos5l_decap_8
XFILLER_278_84 VPWR VGND sg13cmos5l_decap_8
XFILLER_178_182 VPWR VGND sg13cmos5l_decap_8
XFILLER_428_21 VPWR VGND sg13cmos5l_decap_8
XFILLER_583_190 VPWR VGND sg13cmos5l_fill_2
XFILLER_327_146 VPWR VGND sg13cmos5l_decap_8
XFILLER_342_105 VPWR VGND sg13cmos5l_decap_8
XFILLER_531_205 VPWR VGND sg13cmos5l_decap_8
XFILLER_342_116 VPWR VGND sg13cmos5l_fill_2
XFILLER_31_66 VPWR VGND sg13cmos5l_decap_8
XFILLER_428_98 VPWR VGND sg13cmos5l_decap_8
XFILLER_335_190 VPWR VGND sg13cmos5l_fill_2
XFILLER_147_77 VPWR VGND sg13cmos5l_decap_8
XFILLER_696_7 VPWR VGND sg13cmos5l_decap_8
XANTENNA__3108__X Tile_X0Y7_E6BEG[6] VPWR VGND sg13cmos5l_antennanp
XFILLER_444_42 VPWR VGND sg13cmos5l_decap_8
XFILLER_591_70 VPWR VGND sg13cmos5l_decap_8
XFILLER_163_21 VPWR VGND sg13cmos5l_decap_8
XFILLER_496_175 VPWR VGND sg13cmos5l_decap_8
XANTENNA__2947__X Tile_X0Y8_EE4BEG[3] VPWR VGND sg13cmos5l_antennanp
XFILLER_163_76 VPWR VGND sg13cmos5l_decap_8
XFILLER_102_160 VPWR VGND sg13cmos5l_decap_8
XFILLER_163_98 VPWR VGND sg13cmos5l_decap_8
XFILLER_102_171 VPWR VGND sg13cmos5l_fill_2
XFILLER_313_35 VPWR VGND sg13cmos5l_decap_8
XFILLER_653_161 VPWR VGND sg13cmos5l_decap_8
XFILLER_186_0 VPWR VGND sg13cmos5l_decap_8
XFILLER_56_52 VPWR VGND sg13cmos5l_decap_8
XFILLER_63_206 VPWR VGND sg13cmos5l_decap_8
XFILLER_63_228 VPWR VGND sg13cmos5l_fill_1
XFILLER_389_28 VPWR VGND sg13cmos5l_decap_8
XFILLER_16_122 VPWR VGND sg13cmos5l_fill_2
XFILLER_263_189 VPWR VGND sg13cmos5l_fill_1
XFILLER_353_0 VPWR VGND sg13cmos5l_decap_8
XANTENNA__3778__X AXI_M_SOC_ARVALID VPWR VGND sg13cmos5l_antennanp
XFILLER_610_77 VPWR VGND sg13cmos5l_decap_8
XFILLER_112_91 VPWR VGND sg13cmos5l_decap_8
XFILLER_520_0 VPWR VGND sg13cmos5l_decap_8
XFILLER_72_84 VPWR VGND sg13cmos5l_decap_8
XFILLER_566_168 VPWR VGND sg13cmos5l_decap_8
XFILLER_420_175 VPWR VGND sg13cmos5l_decap_8
XFILLER_72_95 VPWR VGND sg13cmos5l_fill_1
XFILLER_618_0 VPWR VGND sg13cmos5l_decap_8
XFILLER_708_140 VPWR VGND sg13cmos5l_decap_8
XFILLER_619_42 VPWR VGND sg13cmos5l_decap_8
XFILLER_581_105 VPWR VGND sg13cmos5l_decap_8
XFILLER_420_197 VPWR VGND sg13cmos5l_fill_2
XFILLER_188_84 VPWR VGND sg13cmos5l_decap_8
XFILLER_338_21 VPWR VGND sg13cmos5l_decap_8
XFILLER_75_7 VPWR VGND sg13cmos5l_decap_8
X_1620_ _1620_/Q Tile_X0Y2_FrameData[29] VGND VPWR Tile_X0Y9_FrameStrobe[6] latch
XFILLER_522_205 VPWR VGND sg13cmos5l_fill_2
XFILLER_333_116 VPWR VGND sg13cmos5l_decap_8
XFILLER_338_98 VPWR VGND sg13cmos5l_fill_2
X_1551_ _1551_/Q Tile_X0Y2_FrameData[2] VGND VPWR Tile_X0Y9_FrameStrobe[3] latch
XFILLER_635_63 VPWR VGND sg13cmos5l_decap_8
XFILLER_207_14 VPWR VGND sg13cmos5l_decap_8
XANTENNA__3018__X Tile_X0Y5_E6BEG[5] VPWR VGND sg13cmos5l_antennanp
XFILLER_354_42 VPWR VGND sg13cmos5l_decap_8
X_0502_ _0502_/Q Tile_X0Y8_FrameData[9] VGND VPWR Tile_X0Y9_FrameStrobe[2] latch
X_4270_ _4270_/X Tile_X0Y4_W2END[1] AXI_M_SOC_BRESP1 _4315_/X _4314_/X _2073_/Q _2072_/Q
+ VPWR VGND sg13cmos5l_mux4_1
X_1482_ _1482_/Q Tile_X0Y2_FrameData[7] VGND VPWR Tile_X0Y9_FrameStrobe[1] latch
XFILLER_487_164 VPWR VGND sg13cmos5l_decap_8
XFILLER_286_226 VPWR VGND sg13cmos5l_fill_2
XFILLER_97_70 VPWR VGND sg13cmos5l_decap_8
X_3221_ Tile_X0Y0_FrameStrobe_O[9] Tile_X0Y9_FrameStrobe[9] VPWR VGND sg13cmos5l_buf_1
XANTENNA__2857__X Tile_X0Y6_E6BEG[6] VPWR VGND sg13cmos5l_antennanp
X_0433_ _0433_/Q Tile_X0Y8_FrameData[14] VGND VPWR Tile_X0Y9_FrameStrobe[0] latch
XFILLER_239_131 VPWR VGND sg13cmos5l_decap_4
XFILLER_504_56 VPWR VGND sg13cmos5l_decap_8
X_3152_ Tile_X0Y7_FrameData_O[22] Tile_X0Y7_FrameData[22] VPWR VGND sg13cmos5l_buf_1
X_0364_ _0364_/Q Tile_X0Y7_FrameData[19] VGND VPWR Tile_X0Y9_FrameStrobe[6] latch
XFILLER_651_84 VPWR VGND sg13cmos5l_decap_8
XFILLER_239_164 VPWR VGND sg13cmos5l_fill_1
XFILLER_223_35 VPWR VGND sg13cmos5l_decap_8
XFILLER_644_161 VPWR VGND sg13cmos5l_decap_8
X_2103_ _2103_/Q Tile_X0Y4_FrameData[14] VGND VPWR Tile_X0Y9_FrameStrobe[5] latch
XFILLER_370_63 VPWR VGND sg13cmos5l_decap_8
X_0295_ _0295_/Q Tile_X0Y7_FrameData[24] VGND VPWR Tile_X0Y9_FrameStrobe[4] latch
X_3083_ Tile_X0Y7_E1BEG[1] _4609_/X VPWR VGND sg13cmos5l_buf_1
XFILLER_589_216 VPWR VGND sg13cmos5l_fill_2
X_2034_ _2034_/Q Tile_X0Y4_FrameData[19] VGND VPWR Tile_X0Y9_FrameStrobe[3] latch
XFILLER_299_28 VPWR VGND sg13cmos5l_decap_8
XFILLER_254_178 VPWR VGND sg13cmos5l_decap_8
XFILLER_520_77 VPWR VGND sg13cmos5l_decap_8
XFILLER_520_88 VPWR VGND sg13cmos5l_fill_2
XFILLER_411_131 VPWR VGND sg13cmos5l_decap_4
X_3985_ _3985_/X Tile_X0Y2_W1END[2] Tile_X0Y2_W6END[6] _4107_/X _4086_/X _1669_/Q
+ _1668_/Q VPWR VGND sg13cmos5l_mux4_1
XFILLER_572_105 VPWR VGND sg13cmos5l_decap_8
XFILLER_529_42 VPWR VGND sg13cmos5l_decap_8
X_2936_ Tile_X0Y8_E6BEG[4] _4764_/X VPWR VGND sg13cmos5l_buf_1
XFILLER_676_70 VPWR VGND sg13cmos5l_decap_8
XFILLER_248_21 VPWR VGND sg13cmos5l_decap_8
XFILLER_175_130 VPWR VGND sg13cmos5l_decap_4
X_2867_ Tile_X0Y6_EE4BEG[4] _4516_/X VPWR VGND sg13cmos5l_buf_1
X_4606_ _4606_/X Tile_X0Y7_W1END[3] Tile_X0Y7_WW4END[15] Tile_X0Y7_W6END[7] _4687_/X
+ _0346_/Q _0345_/Q VPWR VGND sg13cmos5l_mux4_1
X_1818_ _1818_/Q Tile_X0Y3_FrameData[15] VGND VPWR Tile_X0Y9_FrameStrobe[4] latch
XFILLER_714_176 VPWR VGND sg13cmos5l_decap_8
X_2798_ Tile_X0Y3_E6BEG[8] _4188_/X VPWR VGND sg13cmos5l_buf_1
XFILLER_580_182 VPWR VGND sg13cmos5l_decap_8
XFILLER_324_138 VPWR VGND sg13cmos5l_fill_1
XFILLER_317_190 VPWR VGND sg13cmos5l_decap_4
X_4537_ _4537_/X AXI_M_SOC_RDATA29 _4570_/X _4574_/X _4556_/X _2533_/Q _2532_/Q VPWR
+ VGND sg13cmos5l_mux4_1
XFILLER_545_63 VPWR VGND sg13cmos5l_decap_8
XFILLER_190_155 VPWR VGND sg13cmos5l_decap_8
X_1749_ _1749_/Q Tile_X0Y3_FrameData[20] VGND VPWR Tile_X0Y9_FrameStrobe[2] latch
XFILLER_117_14 VPWR VGND sg13cmos5l_decap_8
XFILLER_692_91 VPWR VGND sg13cmos5l_decap_8
XFILLER_264_42 VPWR VGND sg13cmos5l_decap_8
X_4468_ _4468_/X Tile_X0Y4_W2MID[7] Tile_X0Y4_W2END[7] Tile_X0Y4_W6END[8] _4313_/X
+ _2137_/Q _2136_/Q VPWR VGND sg13cmos5l_mux4_1
XFILLER_332_171 VPWR VGND sg13cmos5l_decap_8
XFILLER_493_112 VPWR VGND sg13cmos5l_decap_8
XFILLER_478_186 VPWR VGND sg13cmos5l_decap_8
XANTENNA__2767__X Tile_X0Y3_FrameData_O[25] VPWR VGND sg13cmos5l_antennanp
X_3419_ Tile_X0Y4_FrameData_O[10] Tile_X0Y4_FrameData[10] VPWR VGND sg13cmos5l_buf_1
X_4399_ _4399_/X Tile_X0Y5_WW4END[4] AXI_M_SOC_RVALID _4455_/X _4433_/X _2305_/Q _2304_/Q
+ VPWR VGND sg13cmos5l_mux4_1
XFILLER_414_56 VPWR VGND sg13cmos5l_decap_8
XFILLER_561_84 VPWR VGND sg13cmos5l_decap_8
XFILLER_97_191 VPWR VGND sg13cmos5l_decap_8
XFILLER_133_35 VPWR VGND sg13cmos5l_decap_8
XFILLER_711_21 VPWR VGND sg13cmos5l_decap_8
XFILLER_493_189 VPWR VGND sg13cmos5l_decap_8
XFILLER_434_201 VPWR VGND sg13cmos5l_decap_8
XFILLER_245_112 VPWR VGND sg13cmos5l_decap_8
XFILLER_280_63 VPWR VGND sg13cmos5l_decap_8
XFILLER_93_28 VPWR VGND sg13cmos5l_decap_8
XFILLER_635_194 VPWR VGND sg13cmos5l_fill_1
XFILLER_277_7 VPWR VGND sg13cmos5l_decap_8
XFILLER_711_98 VPWR VGND sg13cmos5l_decap_8
XANTENNA__3598__X Tile_X0Y9_FrameData_O[28] VPWR VGND sg13cmos5l_antennanp
XFILLER_650_175 VPWR VGND sg13cmos5l_decap_8
XFILLER_430_77 VPWR VGND sg13cmos5l_decap_8
XFILLER_444_7 VPWR VGND sg13cmos5l_decap_8
XFILLER_26_77 VPWR VGND sg13cmos5l_decap_8
XFILLER_158_119 VPWR VGND sg13cmos5l_fill_2
XFILLER_611_7 VPWR VGND sg13cmos5l_decap_8
XFILLER_563_105 VPWR VGND sg13cmos5l_decap_8
XFILLER_439_42 VPWR VGND sg13cmos5l_decap_8
XFILLER_42_21 VPWR VGND sg13cmos5l_decap_8
XFILLER_709_7 VPWR VGND sg13cmos5l_decap_8
XFILLER_586_70 VPWR VGND sg13cmos5l_decap_8
XFILLER_158_21 VPWR VGND sg13cmos5l_decap_8
XFILLER_158_98 VPWR VGND sg13cmos5l_decap_8
XFILLER_571_182 VPWR VGND sg13cmos5l_decap_8
XFILLER_308_35 VPWR VGND sg13cmos5l_decap_8
XFILLER_672_28 VPWR VGND sg13cmos5l_decap_8
XFILLER_455_63 VPWR VGND sg13cmos5l_decap_4
XFILLER_181_177 VPWR VGND sg13cmos5l_decap_8
XFILLER_101_0 VPWR VGND sg13cmos5l_decap_8
XFILLER_455_96 VPWR VGND sg13cmos5l_decap_8
XFILLER_174_42 VPWR VGND sg13cmos5l_decap_8
XFILLER_673_212 VPWR VGND sg13cmos5l_decap_8
XFILLER_605_77 VPWR VGND sg13cmos5l_decap_8
XFILLER_469_197 VPWR VGND sg13cmos5l_decap_8
XFILLER_95_128 VPWR VGND sg13cmos5l_decap_8
XFILLER_324_56 VPWR VGND sg13cmos5l_decap_4
XFILLER_484_178 VPWR VGND sg13cmos5l_decap_8
XFILLER_471_84 VPWR VGND sg13cmos5l_decap_8
XFILLER_621_21 VPWR VGND sg13cmos5l_decap_8
XFILLER_470_0 VPWR VGND sg13cmos5l_decap_8
XFILLER_568_0 VPWR VGND sg13cmos5l_decap_8
XFILLER_340_33 VPWR VGND sg13cmos5l_decap_8
X_0080_ _0080_/X _4914_/X _4915_/X _2368_/Q VPWR VGND sg13cmos5l_mux2_1
XFILLER_697_14 VPWR VGND sg13cmos5l_decap_8
XFILLER_621_98 VPWR VGND sg13cmos5l_decap_8
XFILLER_641_175 VPWR VGND sg13cmos5l_decap_8
XFILLER_251_126 VPWR VGND sg13cmos5l_decap_8
XFILLER_189_211 VPWR VGND sg13cmos5l_decap_8
XANTENNA__3301__X Tile_X0Y0_E2BEG[1] VPWR VGND sg13cmos5l_antennanp
XFILLER_554_105 VPWR VGND sg13cmos5l_decap_8
XFILLER_349_42 VPWR VGND sg13cmos5l_decap_8
X_3770_ _3770_/X Tile_X0Y1_WW4END[3] Tile_X0Y1_WW4END[11] Tile_X0Y1_W6END[11] _4019_/X
+ _1235_/Q _1234_/Q VPWR VGND sg13cmos5l_mux4_1
X_0982_ _0982_/Q Tile_X0Y0_FrameData[21] VGND VPWR Tile_X0Y9_FrameStrobe[1] latch
XFILLER_496_70 VPWR VGND sg13cmos5l_decap_8
XFILLER_157_130 VPWR VGND sg13cmos5l_decap_8
X_2721_ _4659_/A3 VPWR VGND sg13cmos5l_tielo
XFILLER_172_100 VPWR VGND sg13cmos5l_decap_8
XFILLER_562_160 VPWR VGND sg13cmos5l_decap_8
XFILLER_157_185 VPWR VGND sg13cmos5l_fill_1
X_2652_ _2652_/Q Tile_X0Y6_FrameData[11] VGND VPWR Tile_X0Y9_FrameStrobe[6] latch
XFILLER_306_116 VPWR VGND sg13cmos5l_decap_8
XFILLER_646_84 VPWR VGND sg13cmos5l_decap_8
XFILLER_306_127 VPWR VGND sg13cmos5l_fill_2
XFILLER_218_35 VPWR VGND sg13cmos5l_decap_8
XFILLER_172_144 VPWR VGND sg13cmos5l_decap_8
X_1603_ _1603_/Q Tile_X0Y2_FrameData[14] VGND VPWR Tile_X0Y9_FrameStrobe[5] latch
XFILLER_582_28 VPWR VGND sg13cmos5l_decap_8
XFILLER_365_63 VPWR VGND sg13cmos5l_decap_8
X_2583_ _2583_/Q Tile_X0Y6_FrameData[16] VGND VPWR Tile_X0Y9_FrameStrobe[4] latch
XFILLER_321_108 VPWR VGND sg13cmos5l_decap_8
XFILLER_711_168 VPWR VGND sg13cmos5l_decap_8
X_4322_ _4322_/X Tile_X0Y8_W1END[0] Tile_X0Y8_WW4END[0] Tile_X0Y8_W6END[8] _4800_/X
+ _0647_/Q _0646_/Q VPWR VGND sg13cmos5l_mux4_1
X_1534_ _1534_/Q Tile_X0Y2_FrameData[19] VGND VPWR Tile_X0Y9_FrameStrobe[3] latch
XFILLER_259_215 VPWR VGND sg13cmos5l_fill_1
X_4253_ _4253_/X _4305_/X _4304_/X AXI_M_SOC_BRESP0 _4303_/X _2107_/Q _2106_/Q VPWR
+ VGND sg13cmos5l_mux4_1
XFILLER_515_77 VPWR VGND sg13cmos5l_decap_8
X_1465_ _1465_/Q Tile_X0Y2_FrameData[24] VGND VPWR Tile_X0Y9_FrameStrobe[1] latch
XFILLER_234_56 VPWR VGND sg13cmos5l_decap_8
X_3204_ Tile_X0Y0_N2BEG[4] _3788_/X VPWR VGND sg13cmos5l_buf_1
XFILLER_274_207 VPWR VGND sg13cmos5l_decap_8
X_0416_ _0416_/Q Tile_X0Y7_FrameData[31] VGND VPWR Tile_X0Y9_FrameStrobe[0] latch
X_4184_ _4184_/X AXI_M_SOC_WREADY _4229_/X _4233_/X _4205_/X _1773_/Q _1772_/Q VPWR
+ VGND sg13cmos5l_mux4_1
XFILLER_381_84 VPWR VGND sg13cmos5l_decap_8
X_1396_ _1396_/Q Tile_X0Y1_FrameData[5] VGND VPWR Tile_X0Y9_FrameStrobe[6] latch
XFILLER_531_21 VPWR VGND sg13cmos5l_decap_8
XFILLER_490_126 VPWR VGND sg13cmos5l_decap_8
XFILLER_416_212 VPWR VGND sg13cmos5l_fill_1
XFILLER_94_150 VPWR VGND sg13cmos5l_fill_2
X_3135_ Tile_X0Y7_FrameData_O[5] Tile_X0Y7_FrameData[5] VPWR VGND sg13cmos5l_buf_1
X_0347_ _0347_/Q Tile_X0Y7_FrameData[4] VGND VPWR Tile_X0Y9_FrameStrobe[5] latch
XFILLER_617_183 VPWR VGND sg13cmos5l_decap_8
XFILLER_227_156 VPWR VGND sg13cmos5l_fill_1
XFILLER_94_194 VPWR VGND sg13cmos5l_decap_8
X_3066_ Tile_X0Y5_FrameData_O[25] Tile_X0Y5_FrameData[25] VPWR VGND sg13cmos5l_buf_1
XFILLER_103_49 VPWR VGND sg13cmos5l_decap_8
X_0278_ _0278_/Q Tile_X0Y7_FrameData[9] VGND VPWR Tile_X0Y9_FrameStrobe[3] latch
XFILLER_242_126 VPWR VGND sg13cmos5l_decap_8
XFILLER_250_77 VPWR VGND sg13cmos5l_fill_2
XFILLER_242_137 VPWR VGND sg13cmos5l_fill_1
X_2017_ _2017_/Q Tile_X0Y4_FrameData[4] VGND VPWR Tile_X0Y9_FrameStrobe[2] latch
XFILLER_400_14 VPWR VGND sg13cmos5l_decap_8
XANTENNA__3211__X Tile_X0Y0_N1BEG[3] VPWR VGND sg13cmos5l_antennanp
XFILLER_242_159 VPWR VGND sg13cmos5l_decap_8
XFILLER_329_208 VPWR VGND sg13cmos5l_decap_4
XFILLER_687_91 VPWR VGND sg13cmos5l_decap_8
XFILLER_396_174 VPWR VGND sg13cmos5l_decap_8
XFILLER_259_42 VPWR VGND sg13cmos5l_decap_8
XFILLER_250_192 VPWR VGND sg13cmos5l_decap_8
X_3968_ _3968_/X AXI_M_SOC_ARREADY _4015_/X _4019_/X _3989_/X _1273_/Q _1272_/Q VPWR
+ VGND sg13cmos5l_mux4_1
X_2919_ Tile_X0Y8_E2BEG[3] _4731_/X VPWR VGND sg13cmos5l_buf_1
XFILLER_538_190 VPWR VGND sg13cmos5l_decap_4
X_3899_ _3899_/X Tile_X0Y1_W2MID[2] Tile_X0Y1_W2END[2] Tile_X0Y1_W6END[2] _3992_/X
+ _1407_/Q _1406_/Q VPWR VGND sg13cmos5l_mux4_1
XFILLER_12_35 VPWR VGND sg13cmos5l_decap_8
XFILLER_560_119 VPWR VGND sg13cmos5l_decap_4
XFILLER_409_56 VPWR VGND sg13cmos5l_decap_8
XFILLER_556_84 VPWR VGND sg13cmos5l_decap_8
XFILLER_163_133 VPWR VGND sg13cmos5l_decap_8
XFILLER_128_35 VPWR VGND sg13cmos5l_decap_8
XFILLER_706_21 VPWR VGND sg13cmos5l_decap_8
XFILLER_492_28 VPWR VGND sg13cmos5l_decap_8
XFILLER_275_63 VPWR VGND sg13cmos5l_decap_8
XFILLER_88_28 VPWR VGND sg13cmos5l_decap_8
XFILLER_706_98 VPWR VGND sg13cmos5l_decap_8
XFILLER_5_7 VPWR VGND sg13cmos5l_decap_8
XFILLER_425_77 VPWR VGND sg13cmos5l_decap_8
XFILLER_394_7 VPWR VGND sg13cmos5l_decap_8
XFILLER_144_56 VPWR VGND sg13cmos5l_decap_8
XFILLER_320_185 VPWR VGND sg13cmos5l_decap_8
XFILLER_291_84 VPWR VGND sg13cmos5l_decap_8
XFILLER_441_21 VPWR VGND sg13cmos5l_decap_8
XFILLER_407_201 VPWR VGND sg13cmos5l_decap_8
XFILLER_37_10 VPWR VGND sg13cmos5l_decap_8
XFILLER_561_7 VPWR VGND sg13cmos5l_decap_8
XFILLER_481_137 VPWR VGND sg13cmos5l_decap_8
XFILLER_659_7 VPWR VGND sg13cmos5l_decap_8
XFILLER_85_172 VPWR VGND sg13cmos5l_fill_1
XFILLER_441_98 VPWR VGND sg13cmos5l_decap_4
XFILLER_37_87 VPWR VGND sg13cmos5l_decap_8
XFILLER_310_14 VPWR VGND sg13cmos5l_decap_8
XANTENNA__3121__X Tile_X0Y7_EE4BEG[7] VPWR VGND sg13cmos5l_antennanp
XFILLER_667_28 VPWR VGND sg13cmos5l_decap_8
XFILLER_53_42 VPWR VGND sg13cmos5l_decap_8
XFILLER_387_141 VPWR VGND sg13cmos5l_decap_8
XANTENNA__2960__X Tile_X0Y8_FrameData_O[0] VPWR VGND sg13cmos5l_antennanp
XFILLER_597_91 VPWR VGND sg13cmos5l_fill_2
XFILLER_536_105 VPWR VGND sg13cmos5l_decap_8
XFILLER_169_42 VPWR VGND sg13cmos5l_decap_8
XFILLER_149_0 VPWR VGND sg13cmos5l_decap_8
XFILLER_536_116 VPWR VGND sg13cmos5l_fill_1
XFILLER_316_0 VPWR VGND sg13cmos5l_decap_8
XFILLER_319_56 VPWR VGND sg13cmos5l_decap_8
XFILLER_139_196 VPWR VGND sg13cmos5l_decap_8
XFILLER_683_49 VPWR VGND sg13cmos5l_decap_8
XFILLER_616_21 VPWR VGND sg13cmos5l_decap_8
XFILLER_489_215 VPWR VGND sg13cmos5l_fill_1
XFILLER_466_95 VPWR VGND sg13cmos5l_decap_4
XFILLER_154_144 VPWR VGND sg13cmos5l_decap_4
XFILLER_154_155 VPWR VGND sg13cmos5l_decap_4
XFILLER_616_98 VPWR VGND sg13cmos5l_decap_4
XFILLER_685_0 VPWR VGND sg13cmos5l_decap_8
XFILLER_335_77 VPWR VGND sg13cmos5l_decap_8
XFILLER_38_7 VPWR VGND sg13cmos5l_decap_8
XFILLER_457_134 VPWR VGND sg13cmos5l_decap_4
XFILLER_68_128 VPWR VGND sg13cmos5l_decap_8
XFILLER_632_42 VPWR VGND sg13cmos5l_decap_8
X_1250_ _1250_/Q Tile_X0Y1_FrameData[23] VGND VPWR Tile_X0Y9_FrameStrobe[2] latch
XFILLER_457_189 VPWR VGND sg13cmos5l_fill_1
XFILLER_351_21 VPWR VGND sg13cmos5l_decap_8
XFILLER_209_112 VPWR VGND sg13cmos5l_decap_8
X_0201_ _0201_/Q Tile_X0Y7_FrameData[22] VGND VPWR Tile_X0Y9_FrameStrobe[1] latch
X_1181_ _1181_/Q Tile_X0Y1_FrameData[28] VGND VPWR Tile_X0Y9_FrameStrobe[0] latch
X_0132_ AXI_M_SOC_AWLEN7 _0940_/Q _3678_/X VPWR VGND sg13cmos5l_nor2b_1
XFILLER_351_98 VPWR VGND sg13cmos5l_decap_8
XFILLER_413_204 VPWR VGND sg13cmos5l_decap_8
XFILLER_209_189 VPWR VGND sg13cmos5l_decap_8
XFILLER_501_35 VPWR VGND sg13cmos5l_decap_8
XFILLER_91_153 VPWR VGND sg13cmos5l_decap_8
X_0063_ _3628_/A _4604_/X _4605_/X _0347_/Q VPWR VGND sg13cmos5l_mux2_1
X_4940_ _4940_/X Tile_X0Y3_WW4END[3] Tile_X0Y3_WW4END[11] Tile_X0Y3_W6END[11] _4233_/X
+ _1735_/Q _1734_/Q VPWR VGND sg13cmos5l_mux4_1
XFILLER_220_14 VPWR VGND sg13cmos5l_decap_8
XANTENNA__3031__X Tile_X0Y5_EE4BEG[6] VPWR VGND sg13cmos5l_antennanp
X_4871_ _4871_/X Tile_X0Y9_WW4END[8] AXI_M_SOC_RDATA7 _4924_/X _4901_/X _0801_/Q _0800_/Q
+ VPWR VGND sg13cmos5l_mux4_1
XFILLER_577_28 VPWR VGND sg13cmos5l_decap_8
XANTENNA__2870__X Tile_X0Y6_EE4BEG[7] VPWR VGND sg13cmos5l_antennanp
X_3822_ _3822_/X Tile_X0Y0_WW4END[5] Tile_X0Y0_WW4END[13] _3871_/X _3856_/X _1061_/Q
+ _1060_/Q VPWR VGND sg13cmos5l_mux4_1
XFILLER_378_185 VPWR VGND sg13cmos5l_fill_2
X_3753_ AXI_M_SOC_ARADDR25 Tile_X0Y8_WW4END[1] Tile_X0Y8_WW4END[9] Tile_X0Y8_W6END[9]
+ _4809_/X _0485_/Q _0484_/Q VPWR VGND sg13cmos5l_mux4_1
X_0965_ _0965_/Q Tile_X0Y0_FrameData[6] VGND VPWR Tile_X0Y9_FrameStrobe[0] latch
XFILLER_229_56 VPWR VGND sg13cmos5l_decap_8
X_2704_ _4193_/A3 VPWR VGND sg13cmos5l_tielo
X_3684_ _3684_/X Tile_X0Y3_WW4END[2] Tile_X0Y3_WW4END[10] Tile_X0Y3_W6END[2] _4224_/X
+ _1753_/Q _1752_/Q VPWR VGND sg13cmos5l_mux4_1
XFILLER_593_49 VPWR VGND sg13cmos5l_decap_8
XFILLER_535_171 VPWR VGND sg13cmos5l_fill_1
X_0896_ _0896_/Q Tile_X0Y9_FrameData[31] VGND VPWR Tile_X0Y9_FrameStrobe[7] latch
XFILLER_64_0 VPWR VGND sg13cmos5l_decap_8
XFILLER_526_21 VPWR VGND sg13cmos5l_decap_8
XFILLER_696_112 VPWR VGND sg13cmos5l_decap_8
X_2635_ _2635_/Q Tile_X0Y6_FrameData[28] VGND VPWR Tile_X0Y9_FrameStrobe[6] latch
XFILLER_160_125 VPWR VGND sg13cmos5l_decap_8
X_2566_ _2566_/Q Tile_X0Y6_FrameData[1] VGND VPWR Tile_X0Y9_FrameStrobe[3] latch
XFILLER_637_201 VPWR VGND sg13cmos5l_fill_1
X_4305_ _4305_/X Tile_X0Y5_W1END[1] Tile_X0Y5_W6END[5] _4464_/X _4419_/X _2437_/Q
+ _2436_/Q VPWR VGND sg13cmos5l_mux4_1
X_1517_ _1517_/Q Tile_X0Y2_FrameData[4] VGND VPWR Tile_X0Y9_FrameStrobe[2] latch
XFILLER_245_77 VPWR VGND sg13cmos5l_decap_8
X_2497_ _2497_/Q Tile_X0Y6_FrameData[6] VGND VPWR Tile_X0Y9_FrameStrobe[1] latch
XANTENNA__3206__X Tile_X0Y0_N2BEG[6] VPWR VGND sg13cmos5l_antennanp
XFILLER_302_163 VPWR VGND sg13cmos5l_fill_1
XFILLER_542_42 VPWR VGND sg13cmos5l_decap_8
X_4236_ _4236_/X Tile_X0Y2_W2MID[7] Tile_X0Y2_W2END[7] Tile_X0Y2_W6END[8] _4097_/X
+ _1629_/Q _1628_/Q VPWR VGND sg13cmos5l_mux4_1
XFILLER_59_139 VPWR VGND sg13cmos5l_decap_8
XFILLER_4_91 VPWR VGND sg13cmos5l_decap_8
X_1448_ _1448_/Q Tile_X0Y2_FrameData[9] VGND VPWR Tile_X0Y9_FrameStrobe[0] latch
XFILLER_652_204 VPWR VGND sg13cmos5l_decap_8
XFILLER_261_21 VPWR VGND sg13cmos5l_decap_8
XFILLER_74_109 VPWR VGND sg13cmos5l_fill_1
X_4167_ _4167_/X Tile_X0Y3_WW4END[12] AXI_M_SOC_BVALID _4234_/X _4210_/X _1807_/Q
+ _1806_/Q VPWR VGND sg13cmos5l_mux4_1
X_1379_ _1379_/Q Tile_X0Y1_FrameData[22] VGND VPWR Tile_X0Y9_FrameStrobe[6] latch
X_3118_ Tile_X0Y7_EE4BEG[4] _4632_/X VPWR VGND sg13cmos5l_buf_1
X_4098_ _4098_/X _4033_/X _4141_/X _4140_/X _4032_/X _1437_/Q _1436_/Q VPWR VGND sg13cmos5l_mux4_1
XFILLER_411_35 VPWR VGND sg13cmos5l_decap_8
XFILLER_215_126 VPWR VGND sg13cmos5l_decap_8
XFILLER_82_153 VPWR VGND sg13cmos5l_fill_1
X_3049_ Tile_X0Y5_FrameData_O[8] Tile_X0Y5_FrameData[8] VPWR VGND sg13cmos5l_buf_1
XFILLER_130_14 VPWR VGND sg13cmos5l_decap_8
XFILLER_82_186 VPWR VGND sg13cmos5l_decap_4
XFILLER_487_28 VPWR VGND sg13cmos5l_decap_8
XANTENNA__2780__X Tile_X0Y3_EE4BEG[6] VPWR VGND sg13cmos5l_antennanp
XFILLER_168_225 VPWR VGND sg13cmos5l_decap_4
XFILLER_142_7 VPWR VGND sg13cmos5l_decap_8
XFILLER_210_91 VPWR VGND sg13cmos5l_decap_8
XFILLER_23_56 VPWR VGND sg13cmos5l_decap_8
XFILLER_183_228 VPWR VGND sg13cmos5l_fill_1
XFILLER_139_56 VPWR VGND sg13cmos5l_decap_8
XFILLER_407_7 VPWR VGND sg13cmos5l_decap_8
XFILLER_286_84 VPWR VGND sg13cmos5l_decap_8
XFILLER_136_133 VPWR VGND sg13cmos5l_decap_8
XFILLER_436_21 VPWR VGND sg13cmos5l_decap_8
XFILLER_99_49 VPWR VGND sg13cmos5l_decap_8
XFILLER_297_118 VPWR VGND sg13cmos5l_decap_8
XFILLER_436_98 VPWR VGND sg13cmos5l_decap_8
XFILLER_541_196 VPWR VGND sg13cmos5l_decap_8
XFILLER_305_14 VPWR VGND sg13cmos5l_decap_8
XANTENNA__3116__X Tile_X0Y7_EE4BEG[2] VPWR VGND sg13cmos5l_antennanp
XFILLER_452_42 VPWR VGND sg13cmos5l_decap_8
XFILLER_238_207 VPWR VGND sg13cmos5l_decap_4
XFILLER_48_31 VPWR VGND sg13cmos5l_decap_8
XFILLER_171_21 VPWR VGND sg13cmos5l_decap_8
XFILLER_454_137 VPWR VGND sg13cmos5l_fill_1
XANTENNA__2955__X Tile_X0Y8_EE4BEG[11] VPWR VGND sg13cmos5l_antennanp
XFILLER_602_56 VPWR VGND sg13cmos5l_decap_8
XFILLER_73_120 VPWR VGND sg13cmos5l_decap_8
XFILLER_58_194 VPWR VGND sg13cmos5l_fill_2
XFILLER_171_98 VPWR VGND sg13cmos5l_decap_8
XFILLER_321_35 VPWR VGND sg13cmos5l_decap_8
XFILLER_206_126 VPWR VGND sg13cmos5l_decap_8
XFILLER_104_70 VPWR VGND sg13cmos5l_fill_1
XFILLER_0_49 VPWR VGND sg13cmos5l_decap_8
XFILLER_266_0 VPWR VGND sg13cmos5l_decap_8
XFILLER_678_49 VPWR VGND sg13cmos5l_decap_8
XFILLER_64_63 VPWR VGND sg13cmos5l_decap_8
XFILLER_64_74 VPWR VGND sg13cmos5l_fill_1
XFILLER_64_85 VPWR VGND sg13cmos5l_decap_8
XFILLER_397_28 VPWR VGND sg13cmos5l_decap_8
XFILLER_9_14 VPWR VGND sg13cmos5l_decap_8
XFILLER_433_0 VPWR VGND sg13cmos5l_decap_8
XFILLER_509_105 VPWR VGND sg13cmos5l_decap_8
XFILLER_564_211 VPWR VGND sg13cmos5l_fill_2
XFILLER_120_91 VPWR VGND sg13cmos5l_fill_2
XFILLER_80_73 VPWR VGND sg13cmos5l_fill_1
XFILLER_600_0 VPWR VGND sg13cmos5l_decap_8
XFILLER_196_40 VPWR VGND sg13cmos5l_decap_8
XFILLER_174_228 VPWR VGND sg13cmos5l_fill_1
XFILLER_80_95 VPWR VGND sg13cmos5l_decap_8
XFILLER_390_114 VPWR VGND sg13cmos5l_decap_8
XFILLER_627_42 VPWR VGND sg13cmos5l_decap_8
X_0750_ _0750_/Q Tile_X0Y9_FrameData[17] VGND VPWR Tile_X0Y9_FrameStrobe[2] latch
XFILLER_346_21 VPWR VGND sg13cmos5l_decap_8
XFILLER_390_158 VPWR VGND sg13cmos5l_fill_1
XFILLER_678_112 VPWR VGND sg13cmos5l_decap_8
X_0681_ _0681_/Q Tile_X0Y9_FrameData[22] VGND VPWR Tile_X0Y9_FrameStrobe[0] latch
X_2420_ _2420_/Q Tile_X0Y5_FrameData[17] VGND VPWR Tile_X0Y9_FrameStrobe[7] latch
XFILLER_331_225 VPWR VGND sg13cmos5l_decap_4
XFILLER_346_98 VPWR VGND sg13cmos5l_decap_8
XFILLER_142_147 VPWR VGND sg13cmos5l_decap_8
XFILLER_89_93 VPWR VGND sg13cmos5l_decap_8
XFILLER_619_201 VPWR VGND sg13cmos5l_decap_8
XFILLER_693_126 VPWR VGND sg13cmos5l_decap_8
X_2351_ _2351_/Q Tile_X0Y5_FrameData[22] VGND VPWR Tile_X0Y9_FrameStrobe[5] latch
XFILLER_643_63 VPWR VGND sg13cmos5l_decap_8
XFILLER_215_14 VPWR VGND sg13cmos5l_decap_8
XANTENNA__3026__X Tile_X0Y5_EE4BEG[1] VPWR VGND sg13cmos5l_antennanp
XFILLER_362_42 VPWR VGND sg13cmos5l_decap_8
X_1302_ _1302_/Q Tile_X0Y1_FrameData[3] VGND VPWR Tile_X0Y9_FrameStrobe[3] latch
X_2282_ _2282_/Q Tile_X0Y5_FrameData[27] VGND VPWR Tile_X0Y9_FrameStrobe[3] latch
XFILLER_445_104 VPWR VGND sg13cmos5l_decap_8
X_4021_ _4021_/X Tile_X0Y3_W2MID[7] Tile_X0Y3_W2END[7] Tile_X0Y3_W6END[7] _4205_/X
+ _1917_/Q _1916_/Q VPWR VGND sg13cmos5l_mux4_1
XANTENNA__2865__X Tile_X0Y6_EE4BEG[2] VPWR VGND sg13cmos5l_antennanp
X_1233_ _1233_/Q Tile_X0Y1_FrameData[8] VGND VPWR Tile_X0Y9_FrameStrobe[1] latch
XFILLER_512_56 VPWR VGND sg13cmos5l_decap_8
XFILLER_64_120 VPWR VGND sg13cmos5l_decap_8
XFILLER_599_130 VPWR VGND sg13cmos5l_fill_1
X_1164_ _1164_/Q Tile_X0Y0_FrameData[31] VGND VPWR Tile_X0Y9_FrameStrobe[7] latch
XFILLER_460_118 VPWR VGND sg13cmos5l_decap_8
XFILLER_231_35 VPWR VGND sg13cmos5l_decap_8
X_0115_ AXI_M_SOC_ARSIZE0 _0932_/Q _3768_/X VPWR VGND sg13cmos5l_nor2b_1
XFILLER_64_164 VPWR VGND sg13cmos5l_decap_8
XFILLER_602_123 VPWR VGND sg13cmos5l_decap_4
XFILLER_398_225 VPWR VGND sg13cmos5l_decap_4
X_1095_ _1095_/Q Tile_X0Y0_FrameData[4] VGND VPWR Tile_X0Y9_FrameStrobe[4] latch
XFILLER_588_49 VPWR VGND sg13cmos5l_decap_8
X_0046_ _0046_/X _4220_/X _4221_/X _0380_/Q VPWR VGND sg13cmos5l_mux2_1
X_4923_ _4923_/X Tile_X0Y9_N1END[3] Tile_X0Y9_N4END[3] _4899_/X _0080_/X _0713_/Q
+ _0712_/Q VPWR VGND sg13cmos5l_mux4_1
XANTENNA__3696__X AXI_M_SOC_WDATA6 VPWR VGND sg13cmos5l_antennanp
XFILLER_100_28 VPWR VGND sg13cmos5l_decap_8
X_4854_ _4854_/X Tile_X0Y9_W2MID[1] AXI_M_SOC_RDATA6 _4903_/X _4902_/X _0835_/Q _0834_/Q
+ VPWR VGND sg13cmos5l_mux4_1
XFILLER_220_162 VPWR VGND sg13cmos5l_decap_8
X_3805_ _3805_/X Tile_X0Y0_W2MID[3] Tile_X0Y0_W2MID[6] _3855_/X _3854_/X _1095_/Q
+ _1094_/Q VPWR VGND sg13cmos5l_mux4_1
XFILLER_366_155 VPWR VGND sg13cmos5l_decap_4
X_4785_ _4785_/X _4701_/X Tile_X0Y9_N2MID[0] _4816_/X _4700_/X _0439_/Q _0438_/Q VPWR
+ VGND sg13cmos5l_mux4_1
X_1997_ _1997_/Q Tile_X0Y4_FrameData[24] VGND VPWR Tile_X0Y9_FrameStrobe[2] latch
XFILLER_570_203 VPWR VGND sg13cmos5l_decap_8
XFILLER_537_42 VPWR VGND sg13cmos5l_decap_8
XFILLER_366_199 VPWR VGND sg13cmos5l_decap_8
XFILLER_118_111 VPWR VGND sg13cmos5l_fill_2
X_3736_ AXI_M_SOC_ARADDR8 Tile_X0Y9_WW4END[0] Tile_X0Y9_WW4END[8] Tile_X0Y9_W6END[8]
+ _4924_/X _0743_/Q _0742_/Q VPWR VGND sg13cmos5l_mux4_1
X_0948_ _0948_/Q Tile_X0Y0_FrameData[23] VGND VPWR Tile_X0Y9_FrameStrobe[0] latch
XFILLER_684_70 VPWR VGND sg13cmos5l_decap_8
XFILLER_381_158 VPWR VGND sg13cmos5l_decap_4
XFILLER_256_21 VPWR VGND sg13cmos5l_decap_8
XFILLER_180_209 VPWR VGND sg13cmos5l_decap_8
XFILLER_669_123 VPWR VGND sg13cmos5l_fill_1
X_3667_ AXI_M_SOC_AWADDR28 Tile_X0Y4_W1END[0] Tile_X0Y4_WW4END[4] Tile_X0Y4_WW4END[12]
+ _4348_/X _1989_/Q _1988_/Q VPWR VGND sg13cmos5l_mux4_1
XFILLER_523_141 VPWR VGND sg13cmos5l_fill_2
X_0879_ _0879_/Q Tile_X0Y9_FrameData[16] VGND VPWR Tile_X0Y9_FrameStrobe[6] latch
XFILLER_669_145 VPWR VGND sg13cmos5l_decap_8
XFILLER_322_214 VPWR VGND sg13cmos5l_fill_2
XFILLER_118_188 VPWR VGND sg13cmos5l_decap_8
X_2618_ _2618_/Q Tile_X0Y6_FrameData[13] VGND VPWR Tile_X0Y9_FrameStrobe[5] latch
X_3598_ Tile_X0Y9_FrameData_O[28] Tile_X0Y9_FrameData[28] VPWR VGND sg13cmos5l_buf_1
XFILLER_406_35 VPWR VGND sg13cmos5l_decap_8
XFILLER_133_147 VPWR VGND sg13cmos5l_decap_8
XFILLER_133_158 VPWR VGND sg13cmos5l_fill_1
XFILLER_553_63 VPWR VGND sg13cmos5l_decap_8
X_2549_ _2549_/Q Tile_X0Y6_FrameData[18] VGND VPWR Tile_X0Y9_FrameStrobe[3] latch
XFILLER_125_14 VPWR VGND sg13cmos5l_decap_8
XFILLER_287_162 VPWR VGND sg13cmos5l_decap_8
XFILLER_272_42 VPWR VGND sg13cmos5l_decap_8
XFILLER_625_226 VPWR VGND sg13cmos5l_fill_2
XANTENNA__2775__X Tile_X0Y3_EE4BEG[1] VPWR VGND sg13cmos5l_antennanp
X_4219_ _4219_/X _4690_/X _4694_/X _4698_/X _4673_/X _0385_/Q _0384_/Q VPWR VGND sg13cmos5l_mux4_1
XFILLER_703_77 VPWR VGND sg13cmos5l_decap_8
XFILLER_422_56 VPWR VGND sg13cmos5l_decap_8
XFILLER_205_91 VPWR VGND sg13cmos5l_decap_8
XFILLER_18_56 VPWR VGND sg13cmos5l_decap_8
XFILLER_141_35 VPWR VGND sg13cmos5l_decap_8
XFILLER_243_221 VPWR VGND sg13cmos5l_decap_8
XFILLER_55_153 VPWR VGND sg13cmos5l_decap_8
XFILLER_389_225 VPWR VGND sg13cmos5l_decap_4
XFILLER_498_49 VPWR VGND sg13cmos5l_decap_8
XFILLER_357_7 VPWR VGND sg13cmos5l_decap_8
XFILLER_70_112 VPWR VGND sg13cmos5l_decap_8
XFILLER_203_129 VPWR VGND sg13cmos5l_fill_1
XFILLER_70_189 VPWR VGND sg13cmos5l_decap_8
XFILLER_524_7 VPWR VGND sg13cmos5l_decap_8
XFILLER_357_133 VPWR VGND sg13cmos5l_decap_8
XFILLER_211_184 VPWR VGND sg13cmos5l_decap_8
XFILLER_109_100 VPWR VGND sg13cmos5l_decap_8
XFILLER_7_227 VPWR VGND sg13cmos5l_fill_2
XFILLER_506_119 VPWR VGND sg13cmos5l_decap_8
XFILLER_447_42 VPWR VGND sg13cmos5l_decap_8
XFILLER_372_114 VPWR VGND sg13cmos5l_fill_1
XFILLER_594_70 VPWR VGND sg13cmos5l_decap_8
XFILLER_50_43 VPWR VGND sg13cmos5l_decap_8
XFILLER_166_21 VPWR VGND sg13cmos5l_decap_8
XFILLER_124_103 VPWR VGND sg13cmos5l_decap_8
XFILLER_313_225 VPWR VGND sg13cmos5l_decap_4
XFILLER_380_180 VPWR VGND sg13cmos5l_decap_8
XFILLER_316_35 VPWR VGND sg13cmos5l_decap_8
XFILLER_675_126 VPWR VGND sg13cmos5l_decap_4
XFILLER_59_41 VPWR VGND sg13cmos5l_decap_8
XFILLER_278_140 VPWR VGND sg13cmos5l_decap_8
XFILLER_675_159 VPWR VGND sg13cmos5l_fill_1
XFILLER_182_42 VPWR VGND sg13cmos5l_decap_8
XFILLER_427_126 VPWR VGND sg13cmos5l_decap_8
XFILLER_383_0 VPWR VGND sg13cmos5l_decap_8
XFILLER_613_77 VPWR VGND sg13cmos5l_decap_8
XFILLER_332_56 VPWR VGND sg13cmos5l_decap_8
XFILLER_550_0 VPWR VGND sg13cmos5l_decap_8
XFILLER_75_84 VPWR VGND sg13cmos5l_decap_8
XFILLER_648_0 VPWR VGND sg13cmos5l_fill_2
XFILLER_596_133 VPWR VGND sg13cmos5l_fill_2
XFILLER_201_49 VPWR VGND sg13cmos5l_decap_8
XFILLER_61_167 VPWR VGND sg13cmos5l_decap_8
X_1920_ _1920_/Q Tile_X0Y3_FrameData[9] VGND VPWR Tile_X0Y9_FrameStrobe[7] latch
XFILLER_537_200 VPWR VGND sg13cmos5l_decap_8
XFILLER_202_140 VPWR VGND sg13cmos5l_fill_2
XFILLER_348_133 VPWR VGND sg13cmos5l_decap_8
X_1851_ _1851_/Q Tile_X0Y3_FrameData[14] VGND VPWR Tile_X0Y9_FrameStrobe[5] latch
XFILLER_638_63 VPWR VGND sg13cmos5l_decap_8
X_0802_ _0802_/Q Tile_X0Y9_FrameData[29] VGND VPWR Tile_X0Y9_FrameStrobe[4] latch
XFILLER_357_42 VPWR VGND sg13cmos5l_decap_8
X_4570_ _4570_/X _4549_/X Tile_X0Y9_N4END[14] _4548_/X _0155_/X _2491_/Q _2490_/Q
+ VPWR VGND sg13cmos5l_mux4_1
X_1782_ _1782_/Q Tile_X0Y3_FrameData[19] VGND VPWR Tile_X0Y9_FrameStrobe[3] latch
XFILLER_363_158 VPWR VGND sg13cmos5l_fill_2
X_3521_ Tile_X0Y1_E1BEG[3] _3931_/X VPWR VGND sg13cmos5l_buf_1
X_0733_ _0733_/Q Tile_X0Y9_FrameData[2] VGND VPWR Tile_X0Y9_FrameStrobe[1] latch
XFILLER_115_114 VPWR VGND sg13cmos5l_fill_1
XFILLER_507_56 VPWR VGND sg13cmos5l_decap_8
X_3452_ Tile_X0Y1_FrameData_O[10] Tile_X0Y1_FrameData[10] VPWR VGND sg13cmos5l_buf_1
XFILLER_520_111 VPWR VGND sg13cmos5l_decap_8
X_0664_ _0664_/Q Tile_X0Y8_FrameData[7] VGND VPWR Tile_X0Y9_FrameStrobe[7] latch
XFILLER_654_84 VPWR VGND sg13cmos5l_decap_8
XFILLER_505_196 VPWR VGND sg13cmos5l_decap_8
XFILLER_226_35 VPWR VGND sg13cmos5l_decap_8
X_2403_ _2403_/Q Tile_X0Y5_FrameData[2] VGND VPWR Tile_X0Y9_FrameStrobe[6] latch
XFILLER_590_28 VPWR VGND sg13cmos5l_decap_8
XFILLER_373_63 VPWR VGND sg13cmos5l_decap_8
X_3383_ Tile_X0Y2_E6BEG[6] _4078_/X VPWR VGND sg13cmos5l_buf_1
X_0595_ _0595_/Q Tile_X0Y8_FrameData[12] VGND VPWR Tile_X0Y9_FrameStrobe[5] latch
XFILLER_269_151 VPWR VGND sg13cmos5l_fill_2
X_2334_ _2334_/Q Tile_X0Y5_FrameData[7] VGND VPWR Tile_X0Y9_FrameStrobe[4] latch
XFILLER_520_199 VPWR VGND sg13cmos5l_decap_8
XFILLER_607_204 VPWR VGND sg13cmos5l_decap_8
XFILLER_27_0 VPWR VGND sg13cmos5l_decap_8
XFILLER_269_195 VPWR VGND sg13cmos5l_fill_2
XFILLER_523_77 VPWR VGND sg13cmos5l_decap_8
XFILLER_418_148 VPWR VGND sg13cmos5l_fill_1
X_2265_ _2265_/Q Tile_X0Y5_FrameData[12] VGND VPWR Tile_X0Y9_FrameStrobe[2] latch
XFILLER_284_154 VPWR VGND sg13cmos5l_decap_8
XFILLER_242_56 VPWR VGND sg13cmos5l_decap_8
X_4004_ _4004_/X _4457_/X _4461_/X _4465_/X _4432_/X _2409_/Q _2408_/Q VPWR VGND sg13cmos5l_mux4_1
X_1216_ _1216_/Q Tile_X0Y1_FrameData[25] VGND VPWR Tile_X0Y9_FrameStrobe[1] latch
XFILLER_622_218 VPWR VGND sg13cmos5l_decap_8
X_2196_ _2196_/Q Tile_X0Y5_FrameData[17] VGND VPWR Tile_X0Y9_FrameStrobe[0] latch
XFILLER_37_153 VPWR VGND sg13cmos5l_decap_4
XFILLER_1_70 VPWR VGND sg13cmos5l_decap_8
X_1147_ _1147_/Q Tile_X0Y0_FrameData[16] VGND VPWR Tile_X0Y9_FrameStrobe[6] latch
XFILLER_679_70 VPWR VGND sg13cmos5l_decap_8
XFILLER_587_133 VPWR VGND sg13cmos5l_fill_2
X_1078_ _1078_/Q Tile_X0Y0_FrameData[21] VGND VPWR Tile_X0Y9_FrameStrobe[4] latch
XFILLER_111_49 VPWR VGND sg13cmos5l_decap_8
XFILLER_197_139 VPWR VGND sg13cmos5l_fill_1
XFILLER_528_200 VPWR VGND sg13cmos5l_decap_4
X_4906_ _4906_/X Tile_X0Y9_N2MID[4] Tile_X0Y9_N2END[4] _4936_/X _4820_/X _0687_/Q
+ _0686_/Q VPWR VGND sg13cmos5l_mux4_1
XFILLER_528_211 VPWR VGND sg13cmos5l_fill_1
XFILLER_138_206 VPWR VGND sg13cmos5l_decap_8
X_4837_ _4837_/X _4920_/X _4924_/X _4928_/X _4906_/X _0867_/Q _0866_/Q VPWR VGND sg13cmos5l_mux4_1
XFILLER_548_63 VPWR VGND sg13cmos5l_decap_8
XFILLER_138_228 VPWR VGND sg13cmos5l_fill_1
XFILLER_695_91 VPWR VGND sg13cmos5l_decap_8
XFILLER_267_42 VPWR VGND sg13cmos5l_decap_8
X_4768_ _4768_/X AXI_M_SOC_RDATA12 _4803_/X _4807_/X _4790_/X _0511_/Q _0510_/Q VPWR
+ VGND sg13cmos5l_mux4_1
XFILLER_354_147 VPWR VGND sg13cmos5l_decap_8
X_3719_ AXI_M_SOC_WDATA29 Tile_X0Y6_W1END[1] Tile_X0Y6_WW4END[5] Tile_X0Y6_WW4END[13]
+ _4581_/X _2501_/Q _2500_/Q VPWR VGND sg13cmos5l_mux4_1
X_4699_ _4699_/X _4667_/X Tile_X0Y9_N4END[11] _4666_/X _0053_/X _0185_/Q _0184_/Q
+ VPWR VGND sg13cmos5l_mux4_1
XFILLER_417_56 VPWR VGND sg13cmos5l_decap_8
XFILLER_20_35 VPWR VGND sg13cmos5l_decap_8
XFILLER_105_7 VPWR VGND sg13cmos5l_decap_8
XFILLER_564_84 VPWR VGND sg13cmos5l_decap_8
XFILLER_136_35 VPWR VGND sg13cmos5l_decap_8
XFILLER_283_63 VPWR VGND sg13cmos5l_decap_8
XFILLER_714_43 VPWR VGND sg13cmos5l_decap_8
XFILLER_96_28 VPWR VGND sg13cmos5l_decap_8
XFILLER_511_199 VPWR VGND sg13cmos5l_fill_1
XFILLER_409_104 VPWR VGND sg13cmos5l_decap_8
XFILLER_672_129 VPWR VGND sg13cmos5l_decap_4
XFILLER_409_115 VPWR VGND sg13cmos5l_fill_2
XFILLER_433_77 VPWR VGND sg13cmos5l_decap_8
XFILLER_474_7 VPWR VGND sg13cmos5l_decap_8
XFILLER_29_77 VPWR VGND sg13cmos5l_decap_8
XFILLER_152_56 VPWR VGND sg13cmos5l_decap_8
XFILLER_680_173 VPWR VGND sg13cmos5l_decap_8
XFILLER_45_10 VPWR VGND sg13cmos5l_decap_8
XFILLER_641_7 VPWR VGND sg13cmos5l_decap_8
XFILLER_43_112 VPWR VGND sg13cmos5l_decap_8
XFILLER_432_140 VPWR VGND sg13cmos5l_decap_8
XFILLER_589_70 VPWR VGND sg13cmos5l_decap_8
XFILLER_578_133 VPWR VGND sg13cmos5l_decap_8
XFILLER_188_117 VPWR VGND sg13cmos5l_decap_4
XFILLER_43_156 VPWR VGND sg13cmos5l_fill_1
XFILLER_377_228 VPWR VGND sg13cmos5l_fill_1
XFILLER_43_178 VPWR VGND sg13cmos5l_decap_4
XFILLER_61_20 VPWR VGND sg13cmos5l_decap_8
XFILLER_593_158 VPWR VGND sg13cmos5l_decap_4
XFILLER_675_28 VPWR VGND sg13cmos5l_decap_8
XFILLER_458_63 VPWR VGND sg13cmos5l_decap_8
XFILLER_131_0 VPWR VGND sg13cmos5l_decap_8
XFILLER_129_228 VPWR VGND sg13cmos5l_fill_1
XFILLER_229_0 VPWR VGND sg13cmos5l_decap_8
XFILLER_177_42 VPWR VGND sg13cmos5l_decap_8
XFILLER_534_225 VPWR VGND sg13cmos5l_decap_4
XFILLER_61_97 VPWR VGND sg13cmos5l_decap_8
XFILLER_345_147 VPWR VGND sg13cmos5l_fill_2
XFILLER_144_209 VPWR VGND sg13cmos5l_decap_4
XFILLER_608_77 VPWR VGND sg13cmos5l_decap_8
XFILLER_360_106 VPWR VGND sg13cmos5l_decap_8
XANTENNA_8 Tile_X0Y0_S2MID[0] VPWR VGND sg13cmos5l_antennanp
XFILLER_499_140 VPWR VGND sg13cmos5l_decap_8
XFILLER_327_56 VPWR VGND sg13cmos5l_decap_4
XFILLER_152_220 VPWR VGND sg13cmos5l_fill_2
XFILLER_691_49 VPWR VGND sg13cmos5l_decap_8
XFILLER_474_84 VPWR VGND sg13cmos5l_decap_8
XFILLER_502_133 VPWR VGND sg13cmos5l_decap_8
XFILLER_474_95 VPWR VGND sg13cmos5l_fill_2
XFILLER_648_126 VPWR VGND sg13cmos5l_decap_8
XFILLER_624_21 VPWR VGND sg13cmos5l_decap_8
XFILLER_598_0 VPWR VGND sg13cmos5l_decap_8
XFILLER_193_63 VPWR VGND sg13cmos5l_decap_8
XFILLER_648_148 VPWR VGND sg13cmos5l_fill_2
X_0380_ _0380_/Q Tile_X0Y7_FrameData[3] VGND VPWR Tile_X0Y9_FrameStrobe[6] latch
XFILLER_624_98 VPWR VGND sg13cmos5l_decap_8
XFILLER_656_170 VPWR VGND sg13cmos5l_decap_4
XFILLER_455_221 VPWR VGND sg13cmos5l_fill_1
XFILLER_343_77 VPWR VGND sg13cmos5l_decap_8
XFILLER_20_7 VPWR VGND sg13cmos5l_decap_8
XANTENNA__3304__X Tile_X0Y0_E2BEG[4] VPWR VGND sg13cmos5l_antennanp
XFILLER_640_42 VPWR VGND sg13cmos5l_decap_8
XFILLER_266_176 VPWR VGND sg13cmos5l_decap_8
X_2050_ _2050_/Q Tile_X0Y4_FrameData[3] VGND VPWR Tile_X0Y9_FrameStrobe[3] latch
XFILLER_207_210 VPWR VGND sg13cmos5l_decap_4
XFILLER_408_170 VPWR VGND sg13cmos5l_fill_1
X_1001_ _1001_/Q Tile_X0Y0_FrameData[2] VGND VPWR Tile_X0Y9_FrameStrobe[1] latch
XFILLER_408_192 VPWR VGND sg13cmos5l_decap_8
XFILLER_281_168 VPWR VGND sg13cmos5l_decap_8
XFILLER_423_140 VPWR VGND sg13cmos5l_decap_8
XFILLER_569_133 VPWR VGND sg13cmos5l_decap_8
XFILLER_499_70 VPWR VGND sg13cmos5l_decap_8
XFILLER_222_213 VPWR VGND sg13cmos5l_fill_1
XFILLER_423_184 VPWR VGND sg13cmos5l_decap_8
XFILLER_368_228 VPWR VGND sg13cmos5l_fill_1
XFILLER_34_167 VPWR VGND sg13cmos5l_decap_8
X_2952_ Tile_X0Y8_EE4BEG[8] _4752_/X VPWR VGND sg13cmos5l_buf_1
XFILLER_34_189 VPWR VGND sg13cmos5l_decap_4
XFILLER_649_84 VPWR VGND sg13cmos5l_decap_8
X_1903_ _1903_/Q Tile_X0Y3_FrameData[26] VGND VPWR Tile_X0Y9_FrameStrobe[7] latch
XFILLER_585_28 VPWR VGND sg13cmos5l_decap_8
XFILLER_368_63 VPWR VGND sg13cmos5l_decap_8
X_2883_ Tile_X0Y6_FrameData_O[4] Tile_X0Y6_FrameData[4] VPWR VGND sg13cmos5l_buf_1
X_1834_ _1834_/Q Tile_X0Y3_FrameData[31] VGND VPWR Tile_X0Y9_FrameStrobe[5] latch
X_4622_ _4622_/X Tile_X0Y7_W2END[5] AXI_M_SOC_RDATA21 _4673_/X _4672_/X _0315_/Q _0314_/Q
+ VPWR VGND sg13cmos5l_mux4_1
XFILLER_135_209 VPWR VGND sg13cmos5l_fill_2
X_4553_ _4553_/X _4469_/X _4585_/X _4584_/X _4468_/X _2463_/Q _2462_/Q VPWR VGND sg13cmos5l_mux4_1
XFILLER_518_77 VPWR VGND sg13cmos5l_decap_8
X_1765_ _1765_/Q Tile_X0Y3_FrameData[4] VGND VPWR Tile_X0Y9_FrameStrobe[2] latch
XFILLER_540_228 VPWR VGND sg13cmos5l_fill_1
XFILLER_237_56 VPWR VGND sg13cmos5l_decap_8
X_0716_ _0716_/Q Tile_X0Y9_FrameData[19] VGND VPWR Tile_X0Y9_FrameStrobe[1] latch
X_3504_ Tile_X0Y1_E2BEGb[2] _3942_/X VPWR VGND sg13cmos5l_buf_1
X_4484_ _4484_/X Tile_X0Y6_W1END[0] Tile_X0Y6_WW4END[12] Tile_X0Y6_W6END[4] _4568_/X
+ _2635_/Q _2634_/Q VPWR VGND sg13cmos5l_mux4_1
X_1696_ _1696_/Q Tile_X0Y3_FrameData[9] VGND VPWR Tile_X0Y9_FrameStrobe[0] latch
XFILLER_639_126 VPWR VGND sg13cmos5l_decap_8
XFILLER_534_21 VPWR VGND sg13cmos5l_decap_8
X_3435_ Tile_X0Y4_FrameData_O[26] Tile_X0Y4_FrameData[26] VPWR VGND sg13cmos5l_buf_1
X_0647_ _0647_/Q Tile_X0Y8_FrameData[24] VGND VPWR Tile_X0Y9_FrameStrobe[7] latch
X_3366_ Tile_X0Y2_EE4BEG[5] _4061_/X VPWR VGND sg13cmos5l_buf_1
X_0578_ _0578_/Q Tile_X0Y8_FrameData[29] VGND VPWR Tile_X0Y9_FrameStrobe[5] latch
XFILLER_106_49 VPWR VGND sg13cmos5l_decap_8
X_2317_ _2317_/Q Tile_X0Y5_FrameData[24] VGND VPWR Tile_X0Y9_FrameStrobe[4] latch
XFILLER_253_77 VPWR VGND sg13cmos5l_decap_8
XFILLER_403_14 VPWR VGND sg13cmos5l_decap_8
XFILLER_111_161 VPWR VGND sg13cmos5l_fill_2
X_3297_ Tile_X0Y0_E2BEGb[5] _3817_/X VPWR VGND sg13cmos5l_buf_1
XANTENNA__3214__X Tile_X0Y0_FrameStrobe_O[2] VPWR VGND sg13cmos5l_antennanp
XFILLER_550_42 VPWR VGND sg13cmos5l_decap_8
XFILLER_406_118 VPWR VGND sg13cmos5l_decap_8
X_2248_ _2248_/Q Tile_X0Y5_FrameData[29] VGND VPWR Tile_X0Y9_FrameStrobe[2] latch
XFILLER_700_23 VPWR VGND sg13cmos5l_decap_8
X_2179_ _2179_/Q Tile_X0Y4_FrameData[2] VGND VPWR Tile_X0Y9_FrameStrobe[7] latch
XFILLER_25_156 VPWR VGND sg13cmos5l_fill_1
XFILLER_202_70 VPWR VGND sg13cmos5l_decap_8
XFILLER_709_119 VPWR VGND sg13cmos5l_decap_8
XFILLER_15_35 VPWR VGND sg13cmos5l_decap_8
XFILLER_25_189 VPWR VGND sg13cmos5l_fill_1
XFILLER_575_147 VPWR VGND sg13cmos5l_decap_8
XFILLER_559_84 VPWR VGND sg13cmos5l_decap_8
XFILLER_709_21 VPWR VGND sg13cmos5l_decap_8
XFILLER_185_109 VPWR VGND sg13cmos5l_decap_8
XFILLER_717_130 VPWR VGND sg13cmos5l_decap_4
XFILLER_495_28 VPWR VGND sg13cmos5l_decap_8
XFILLER_278_63 VPWR VGND sg13cmos5l_decap_8
XFILLER_222_7 VPWR VGND sg13cmos5l_decap_8
XFILLER_709_98 VPWR VGND sg13cmos5l_decap_8
XFILLER_31_45 VPWR VGND sg13cmos5l_decap_8
XFILLER_428_77 VPWR VGND sg13cmos5l_decap_8
XFILLER_193_197 VPWR VGND sg13cmos5l_decap_8
XFILLER_531_228 VPWR VGND sg13cmos5l_fill_1
XFILLER_147_56 VPWR VGND sg13cmos5l_decap_8
XFILLER_294_84 VPWR VGND sg13cmos5l_decap_8
XFILLER_444_21 VPWR VGND sg13cmos5l_decap_8
XFILLER_591_7 VPWR VGND sg13cmos5l_decap_8
XFILLER_496_154 VPWR VGND sg13cmos5l_decap_8
XFILLER_689_7 VPWR VGND sg13cmos5l_decap_8
XFILLER_638_192 VPWR VGND sg13cmos5l_decap_8
XFILLER_313_14 VPWR VGND sg13cmos5l_decap_8
XFILLER_248_154 VPWR VGND sg13cmos5l_decap_8
XANTENNA__3124__X Tile_X0Y7_EE4BEG[10] VPWR VGND sg13cmos5l_antennanp
XFILLER_653_140 VPWR VGND sg13cmos5l_decap_8
XFILLER_248_165 VPWR VGND sg13cmos5l_fill_1
XFILLER_460_42 VPWR VGND sg13cmos5l_decap_8
XFILLER_102_194 VPWR VGND sg13cmos5l_fill_1
XFILLER_56_31 VPWR VGND sg13cmos5l_decap_8
XFILLER_598_217 VPWR VGND sg13cmos5l_fill_1
XFILLER_360_2 VPWR VGND sg13cmos5l_fill_1
XANTENNA__2963__X Tile_X0Y8_FrameData_O[3] VPWR VGND sg13cmos5l_antennanp
XFILLER_179_0 VPWR VGND sg13cmos5l_decap_8
XFILLER_16_112 VPWR VGND sg13cmos5l_fill_2
XFILLER_610_56 VPWR VGND sg13cmos5l_decap_8
XFILLER_204_202 VPWR VGND sg13cmos5l_decap_8
XFILLER_112_70 VPWR VGND sg13cmos5l_decap_8
XFILLER_346_0 VPWR VGND sg13cmos5l_decap_8
XFILLER_72_63 VPWR VGND sg13cmos5l_decap_8
XFILLER_686_49 VPWR VGND sg13cmos5l_decap_8
XFILLER_469_84 VPWR VGND sg13cmos5l_fill_2
XFILLER_566_147 VPWR VGND sg13cmos5l_decap_8
XFILLER_420_165 VPWR VGND sg13cmos5l_fill_2
XFILLER_619_21 VPWR VGND sg13cmos5l_decap_8
XFILLER_188_63 VPWR VGND sg13cmos5l_decap_8
XFILLER_513_0 VPWR VGND sg13cmos5l_decap_8
XFILLER_318_114 VPWR VGND sg13cmos5l_decap_8
XFILLER_184_120 VPWR VGND sg13cmos5l_decap_4
XFILLER_619_98 VPWR VGND sg13cmos5l_decap_8
XFILLER_184_164 VPWR VGND sg13cmos5l_fill_1
XFILLER_318_169 VPWR VGND sg13cmos5l_fill_2
XFILLER_338_77 VPWR VGND sg13cmos5l_decap_8
XFILLER_68_7 VPWR VGND sg13cmos5l_decap_8
XFILLER_184_186 VPWR VGND sg13cmos5l_decap_8
XFILLER_522_228 VPWR VGND sg13cmos5l_fill_1
XFILLER_635_42 VPWR VGND sg13cmos5l_decap_8
X_1550_ _1550_/Q Tile_X0Y2_FrameData[3] VGND VPWR Tile_X0Y9_FrameStrobe[3] latch
XFILLER_354_21 VPWR VGND sg13cmos5l_decap_8
X_0501_ _0501_/Q Tile_X0Y8_FrameData[10] VGND VPWR Tile_X0Y9_FrameStrobe[2] latch
XFILLER_140_201 VPWR VGND sg13cmos5l_decap_8
X_1481_ _1481_/Q Tile_X0Y2_FrameData[8] VGND VPWR Tile_X0Y9_FrameStrobe[1] latch
X_3220_ Tile_X0Y0_FrameStrobe_O[8] Tile_X0Y9_FrameStrobe[8] VPWR VGND sg13cmos5l_buf_1
X_0432_ _0432_/Q Tile_X0Y8_FrameData[15] VGND VPWR Tile_X0Y9_FrameStrobe[0] latch
XFILLER_691_202 VPWR VGND sg13cmos5l_fill_2
XFILLER_354_98 VPWR VGND sg13cmos5l_decap_8
XFILLER_504_35 VPWR VGND sg13cmos5l_decap_8
XFILLER_428_210 VPWR VGND sg13cmos5l_fill_2
X_3151_ Tile_X0Y7_FrameData_O[21] Tile_X0Y7_FrameData[21] VPWR VGND sg13cmos5l_buf_1
XFILLER_651_63 VPWR VGND sg13cmos5l_decap_8
XFILLER_39_215 VPWR VGND sg13cmos5l_fill_1
X_0363_ _0363_/Q Tile_X0Y7_FrameData[20] VGND VPWR Tile_X0Y9_FrameStrobe[6] latch
XFILLER_223_14 VPWR VGND sg13cmos5l_decap_8
XANTENNA__3034__X Tile_X0Y5_EE4BEG[9] VPWR VGND sg13cmos5l_antennanp
XFILLER_644_140 VPWR VGND sg13cmos5l_decap_8
X_2102_ _2102_/Q Tile_X0Y4_FrameData[15] VGND VPWR Tile_X0Y9_FrameStrobe[5] latch
XFILLER_370_42 VPWR VGND sg13cmos5l_decap_8
XFILLER_443_213 VPWR VGND sg13cmos5l_fill_2
XFILLER_254_113 VPWR VGND sg13cmos5l_fill_2
XFILLER_239_187 VPWR VGND sg13cmos5l_decap_8
X_3082_ Tile_X0Y7_E1BEG[0] _4608_/X VPWR VGND sg13cmos5l_buf_1
X_0294_ _0294_/Q Tile_X0Y7_FrameData[25] VGND VPWR Tile_X0Y9_FrameStrobe[4] latch
XANTENNA__2873__X Tile_X0Y6_EE4BEG[10] VPWR VGND sg13cmos5l_antennanp
X_2033_ _2033_/Q Tile_X0Y4_FrameData[20] VGND VPWR Tile_X0Y9_FrameStrobe[3] latch
XFILLER_254_157 VPWR VGND sg13cmos5l_decap_8
XFILLER_520_56 VPWR VGND sg13cmos5l_decap_8
XFILLER_600_210 VPWR VGND sg13cmos5l_decap_4
XFILLER_596_49 VPWR VGND sg13cmos5l_decap_8
X_3984_ _3984_/X Tile_X0Y0_W1END[2] Tile_X0Y0_W6END[10] _3867_/X _3861_/X _1137_/Q
+ _1136_/Q VPWR VGND sg13cmos5l_mux4_1
XFILLER_94_0 VPWR VGND sg13cmos5l_decap_8
XFILLER_529_21 VPWR VGND sg13cmos5l_decap_8
X_2935_ Tile_X0Y8_E6BEG[3] _4763_/X VPWR VGND sg13cmos5l_buf_1
X_2866_ Tile_X0Y6_EE4BEG[3] _4515_/X VPWR VGND sg13cmos5l_buf_1
XFILLER_529_98 VPWR VGND sg13cmos5l_decap_8
XFILLER_714_155 VPWR VGND sg13cmos5l_decap_8
X_4605_ _4605_/X _4690_/X _4694_/X _4698_/X _4670_/X _0349_/Q _0348_/Q VPWR VGND sg13cmos5l_mux4_1
XFILLER_324_106 VPWR VGND sg13cmos5l_fill_2
X_1817_ _1817_/Q Tile_X0Y3_FrameData[16] VGND VPWR Tile_X0Y9_FrameStrobe[4] latch
XFILLER_580_161 VPWR VGND sg13cmos5l_decap_8
X_2797_ Tile_X0Y3_E6BEG[7] _4187_/X VPWR VGND sg13cmos5l_buf_1
XANTENNA__3209__X Tile_X0Y0_N1BEG[1] VPWR VGND sg13cmos5l_antennanp
XFILLER_513_228 VPWR VGND sg13cmos5l_fill_1
XFILLER_545_42 VPWR VGND sg13cmos5l_decap_8
XFILLER_7_91 VPWR VGND sg13cmos5l_decap_8
XFILLER_317_180 VPWR VGND sg13cmos5l_fill_2
X_1748_ _1748_/Q Tile_X0Y3_FrameData[21] VGND VPWR Tile_X0Y9_FrameStrobe[2] latch
X_4536_ _4536_/X AXI_M_SOC_RDATA28 _4571_/X _4575_/X _4558_/X _2535_/Q _2534_/Q VPWR
+ VGND sg13cmos5l_mux4_1
XFILLER_692_70 VPWR VGND sg13cmos5l_decap_8
XFILLER_264_21 VPWR VGND sg13cmos5l_decap_8
X_1679_ _1679_/Q Tile_X0Y3_FrameData[26] VGND VPWR Tile_X0Y9_FrameStrobe[0] latch
X_4467_ _4467_/X _4353_/X _4469_/X _4468_/X _4352_/X _2205_/Q _2204_/Q VPWR VGND sg13cmos5l_mux4_1
XFILLER_478_154 VPWR VGND sg13cmos5l_decap_4
XFILLER_478_165 VPWR VGND sg13cmos5l_decap_8
XFILLER_264_65 VPWR VGND sg13cmos5l_fill_1
X_3418_ Tile_X0Y4_FrameData_O[9] Tile_X0Y4_FrameData[9] VPWR VGND sg13cmos5l_buf_1
X_4398_ _4398_/X Tile_X0Y5_WW4END[5] AXI_M_SOC_RLAST _4456_/X _4431_/X _2307_/Q _2306_/Q
+ VPWR VGND sg13cmos5l_mux4_1
XFILLER_414_35 VPWR VGND sg13cmos5l_decap_8
X_3349_ Tile_X0Y2_FrameData_O[20] Tile_X0Y2_FrameData[20] VPWR VGND sg13cmos5l_buf_1
XFILLER_561_63 VPWR VGND sg13cmos5l_decap_8
XFILLER_133_14 VPWR VGND sg13cmos5l_decap_8
XFILLER_493_168 VPWR VGND sg13cmos5l_decap_8
XFILLER_635_140 VPWR VGND sg13cmos5l_decap_4
XFILLER_280_42 VPWR VGND sg13cmos5l_decap_8
XFILLER_635_184 VPWR VGND sg13cmos5l_fill_1
XFILLER_711_77 VPWR VGND sg13cmos5l_decap_8
XANTENNA__2783__X Tile_X0Y3_EE4BEG[9] VPWR VGND sg13cmos5l_antennanp
XFILLER_172_7 VPWR VGND sg13cmos5l_decap_8
XFILLER_650_154 VPWR VGND sg13cmos5l_decap_8
XFILLER_430_56 VPWR VGND sg13cmos5l_decap_8
XFILLER_213_91 VPWR VGND sg13cmos5l_decap_8
XFILLER_595_209 VPWR VGND sg13cmos5l_decap_8
XFILLER_26_56 VPWR VGND sg13cmos5l_decap_8
XFILLER_260_149 VPWR VGND sg13cmos5l_fill_2
XFILLER_548_136 VPWR VGND sg13cmos5l_fill_1
XFILLER_437_7 VPWR VGND sg13cmos5l_decap_8
XFILLER_289_84 VPWR VGND sg13cmos5l_decap_8
XFILLER_439_21 VPWR VGND sg13cmos5l_decap_8
XFILLER_347_209 VPWR VGND sg13cmos5l_decap_4
XFILLER_402_187 VPWR VGND sg13cmos5l_decap_4
XFILLER_9_119 VPWR VGND sg13cmos5l_fill_2
XFILLER_604_7 VPWR VGND sg13cmos5l_decap_8
XFILLER_439_98 VPWR VGND sg13cmos5l_decap_8
XFILLER_42_77 VPWR VGND sg13cmos5l_fill_2
XFILLER_705_133 VPWR VGND sg13cmos5l_fill_2
XFILLER_166_175 VPWR VGND sg13cmos5l_fill_1
XFILLER_705_166 VPWR VGND sg13cmos5l_fill_1
XFILLER_571_161 VPWR VGND sg13cmos5l_decap_8
XFILLER_308_14 VPWR VGND sg13cmos5l_decap_8
XANTENNA__3119__X Tile_X0Y7_EE4BEG[5] VPWR VGND sg13cmos5l_antennanp
XFILLER_166_197 VPWR VGND sg13cmos5l_decap_8
XFILLER_504_228 VPWR VGND sg13cmos5l_fill_1
XFILLER_107_220 VPWR VGND sg13cmos5l_decap_8
XFILLER_455_42 VPWR VGND sg13cmos5l_decap_8
XFILLER_181_156 VPWR VGND sg13cmos5l_decap_8
XFILLER_174_21 VPWR VGND sg13cmos5l_decap_8
XFILLER_469_121 VPWR VGND sg13cmos5l_fill_2
XFILLER_323_150 VPWR VGND sg13cmos5l_decap_8
XANTENNA__2958__X Tile_X0Y8_EE4BEG[14] VPWR VGND sg13cmos5l_antennanp
XFILLER_469_143 VPWR VGND sg13cmos5l_decap_4
XFILLER_268_216 VPWR VGND sg13cmos5l_decap_8
XFILLER_605_56 VPWR VGND sg13cmos5l_decap_8
XFILLER_469_176 VPWR VGND sg13cmos5l_decap_8
XFILLER_268_227 VPWR VGND sg13cmos5l_fill_2
XFILLER_324_35 VPWR VGND sg13cmos5l_decap_8
XFILLER_107_70 VPWR VGND sg13cmos5l_decap_8
XFILLER_3_49 VPWR VGND sg13cmos5l_decap_8
XFILLER_296_0 VPWR VGND sg13cmos5l_decap_8
XFILLER_471_63 VPWR VGND sg13cmos5l_decap_8
XFILLER_67_63 VPWR VGND sg13cmos5l_decap_8
XFILLER_190_42 VPWR VGND sg13cmos5l_decap_8
XFILLER_425_213 VPWR VGND sg13cmos5l_decap_4
XFILLER_463_0 VPWR VGND sg13cmos5l_decap_8
XFILLER_340_12 VPWR VGND sg13cmos5l_decap_8
XFILLER_190_97 VPWR VGND sg13cmos5l_decap_8
XFILLER_621_77 VPWR VGND sg13cmos5l_decap_8
XFILLER_641_154 VPWR VGND sg13cmos5l_decap_8
XFILLER_236_179 VPWR VGND sg13cmos5l_decap_4
XFILLER_440_216 VPWR VGND sg13cmos5l_fill_1
XFILLER_397_109 VPWR VGND sg13cmos5l_decap_8
XFILLER_630_0 VPWR VGND sg13cmos5l_decap_8
XFILLER_340_89 VPWR VGND sg13cmos5l_decap_8
XFILLER_199_84 VPWR VGND sg13cmos5l_decap_8
XFILLER_349_21 VPWR VGND sg13cmos5l_decap_8
XFILLER_338_209 VPWR VGND sg13cmos5l_decap_4
X_0981_ _0981_/Q Tile_X0Y0_FrameData[22] VGND VPWR Tile_X0Y9_FrameStrobe[1] latch
X_2720_ _4775_/A3 VPWR VGND sg13cmos5l_tielo
XFILLER_349_98 VPWR VGND sg13cmos5l_decap_8
XFILLER_8_163 VPWR VGND sg13cmos5l_fill_2
X_2651_ _2651_/Q Tile_X0Y6_FrameData[12] VGND VPWR Tile_X0Y9_FrameStrobe[6] latch
XFILLER_646_63 VPWR VGND sg13cmos5l_decap_8
XFILLER_218_14 VPWR VGND sg13cmos5l_decap_8
XFILLER_361_212 VPWR VGND sg13cmos5l_fill_2
XFILLER_157_197 VPWR VGND sg13cmos5l_decap_8
XANTENNA__3029__X Tile_X0Y5_EE4BEG[4] VPWR VGND sg13cmos5l_antennanp
X_1602_ _1602_/Q Tile_X0Y2_FrameData[15] VGND VPWR Tile_X0Y9_FrameStrobe[5] latch
XFILLER_365_42 VPWR VGND sg13cmos5l_decap_8
X_2582_ _2582_/Q Tile_X0Y6_FrameData[17] VGND VPWR Tile_X0Y9_FrameStrobe[4] latch
XFILLER_711_147 VPWR VGND sg13cmos5l_decap_8
XANTENNA__2868__X Tile_X0Y6_EE4BEG[5] VPWR VGND sg13cmos5l_antennanp
X_1533_ _1533_/Q Tile_X0Y2_FrameData[20] VGND VPWR Tile_X0Y9_FrameStrobe[3] latch
X_4321_ _4321_/X _3885_/X _3876_/X _3875_/X _3858_/X _1117_/Q _1116_/Q VPWR VGND sg13cmos5l_mux4_1
XFILLER_172_189 VPWR VGND sg13cmos5l_decap_8
XFILLER_314_172 VPWR VGND sg13cmos5l_decap_4
XFILLER_515_56 VPWR VGND sg13cmos5l_decap_8
X_4252_ _4252_/X _4302_/X _4301_/X AXI_M_SOC_BRESP1 _4300_/X _2109_/Q _2108_/Q VPWR
+ VGND sg13cmos5l_mux4_1
X_1464_ _1464_/Q Tile_X0Y2_FrameData[25] VGND VPWR Tile_X0Y9_FrameStrobe[1] latch
XFILLER_662_84 VPWR VGND sg13cmos5l_decap_8
XFILLER_234_35 VPWR VGND sg13cmos5l_decap_8
XFILLER_86_107 VPWR VGND sg13cmos5l_decap_8
X_3203_ Tile_X0Y0_N2BEG[3] _3787_/X VPWR VGND sg13cmos5l_buf_1
X_0415_ _0415_/Q Tile_X0Y7_FrameData[0] VGND VPWR Tile_X0Y9_FrameStrobe[7] latch
XFILLER_381_63 VPWR VGND sg13cmos5l_decap_8
X_4183_ _4183_/X _0046_/X Tile_X0Y0_S4END[15] _4230_/X _4234_/X _1775_/Q _1774_/Q
+ VPWR VGND sg13cmos5l_mux4_1
XFILLER_475_168 VPWR VGND sg13cmos5l_fill_1
X_1395_ _1395_/Q Tile_X0Y1_FrameData[6] VGND VPWR Tile_X0Y9_FrameStrobe[6] latch
XFILLER_490_105 VPWR VGND sg13cmos5l_decap_8
X_3134_ Tile_X0Y7_FrameData_O[4] Tile_X0Y7_FrameData[4] VPWR VGND sg13cmos5l_buf_1
X_0346_ _0346_/Q Tile_X0Y7_FrameData[5] VGND VPWR Tile_X0Y9_FrameStrobe[5] latch
XANTENNA__3699__X AXI_M_SOC_WDATA9 VPWR VGND sg13cmos5l_antennanp
XFILLER_531_77 VPWR VGND sg13cmos5l_decap_4
X_3065_ Tile_X0Y5_FrameData_O[24] Tile_X0Y5_FrameData[24] VPWR VGND sg13cmos5l_buf_1
XFILLER_103_28 VPWR VGND sg13cmos5l_decap_8
X_0277_ _0277_/Q Tile_X0Y7_FrameData[10] VGND VPWR Tile_X0Y9_FrameStrobe[3] latch
XFILLER_431_216 VPWR VGND sg13cmos5l_fill_2
XFILLER_388_109 VPWR VGND sg13cmos5l_decap_8
XFILLER_250_56 VPWR VGND sg13cmos5l_decap_8
X_2016_ _2016_/Q Tile_X0Y4_FrameData[5] VGND VPWR Tile_X0Y9_FrameStrobe[2] latch
XFILLER_577_209 VPWR VGND sg13cmos5l_decap_4
XFILLER_687_70 VPWR VGND sg13cmos5l_decap_8
XFILLER_396_153 VPWR VGND sg13cmos5l_decap_8
XFILLER_259_21 VPWR VGND sg13cmos5l_decap_8
XFILLER_250_171 VPWR VGND sg13cmos5l_decap_8
XFILLER_195_226 VPWR VGND sg13cmos5l_fill_2
X_3967_ _3967_/X _0084_/X Tile_X0Y0_S4END[7] _4016_/X _4005_/X _1275_/Q _1274_/Q VPWR
+ VGND sg13cmos5l_mux4_1
XFILLER_545_128 VPWR VGND sg13cmos5l_fill_1
XFILLER_259_76 VPWR VGND sg13cmos5l_decap_8
X_2918_ Tile_X0Y8_E2BEG[2] _4730_/X VPWR VGND sg13cmos5l_buf_1
XFILLER_699_110 VPWR VGND sg13cmos5l_decap_8
X_3898_ _3898_/X Tile_X0Y2_W2MID[2] Tile_X0Y2_W2END[2] Tile_X0Y2_W6END[2] _4100_/X
+ _1655_/Q _1654_/Q VPWR VGND sg13cmos5l_mux4_1
XFILLER_409_35 VPWR VGND sg13cmos5l_decap_8
XFILLER_12_14 VPWR VGND sg13cmos5l_decap_8
XFILLER_699_121 VPWR VGND sg13cmos5l_decap_8
XFILLER_699_132 VPWR VGND sg13cmos5l_fill_2
XFILLER_556_63 VPWR VGND sg13cmos5l_decap_8
XFILLER_352_201 VPWR VGND sg13cmos5l_decap_8
XFILLER_128_14 VPWR VGND sg13cmos5l_decap_8
X_2849_ Tile_X0Y6_E2BEGb[6] _4510_/X VPWR VGND sg13cmos5l_buf_1
XFILLER_275_42 VPWR VGND sg13cmos5l_decap_8
XANTENNA__2778__X Tile_X0Y3_EE4BEG[4] VPWR VGND sg13cmos5l_antennanp
XFILLER_706_77 VPWR VGND sg13cmos5l_decap_8
X_4519_ _4519_/X Tile_X0Y6_WW4END[8] AXI_M_SOC_RDATA31 _4576_/X _4553_/X _2569_/Q
+ _2568_/Q VPWR VGND sg13cmos5l_mux4_1
XFILLER_425_56 VPWR VGND sg13cmos5l_decap_8
XFILLER_208_91 VPWR VGND sg13cmos5l_decap_8
XFILLER_572_84 VPWR VGND sg13cmos5l_decap_8
XFILLER_144_35 VPWR VGND sg13cmos5l_decap_8
XFILLER_291_63 VPWR VGND sg13cmos5l_decap_8
XFILLER_265_208 VPWR VGND sg13cmos5l_decap_8
XFILLER_481_105 VPWR VGND sg13cmos5l_decap_8
XFILLER_387_7 VPWR VGND sg13cmos5l_decap_8
XFILLER_85_162 VPWR VGND sg13cmos5l_fill_1
XFILLER_608_195 VPWR VGND sg13cmos5l_decap_8
XFILLER_18_218 VPWR VGND sg13cmos5l_fill_1
XFILLER_441_77 VPWR VGND sg13cmos5l_decap_8
XFILLER_554_7 VPWR VGND sg13cmos5l_decap_8
XFILLER_37_66 VPWR VGND sg13cmos5l_decap_8
XANTENNA__3402__X Tile_X0Y2_E2BEG[5] VPWR VGND sg13cmos5l_antennanp
XFILLER_233_116 VPWR VGND sg13cmos5l_decap_4
XFILLER_160_56 VPWR VGND sg13cmos5l_decap_8
XFILLER_568_209 VPWR VGND sg13cmos5l_fill_2
XFILLER_160_67 VPWR VGND sg13cmos5l_fill_2
XFILLER_576_220 VPWR VGND sg13cmos5l_fill_2
XFILLER_53_21 VPWR VGND sg13cmos5l_decap_8
XFILLER_597_70 VPWR VGND sg13cmos5l_decap_8
XFILLER_169_21 VPWR VGND sg13cmos5l_decap_8
XFILLER_387_175 VPWR VGND sg13cmos5l_decap_8
XFILLER_591_212 VPWR VGND sg13cmos5l_fill_1
XFILLER_319_35 VPWR VGND sg13cmos5l_decap_8
XFILLER_139_175 VPWR VGND sg13cmos5l_decap_8
XFILLER_683_28 VPWR VGND sg13cmos5l_decap_8
XFILLER_466_63 VPWR VGND sg13cmos5l_decap_8
XFILLER_544_172 VPWR VGND sg13cmos5l_fill_2
XFILLER_211_0 VPWR VGND sg13cmos5l_decap_8
XFILLER_309_0 VPWR VGND sg13cmos5l_decap_8
XFILLER_185_42 VPWR VGND sg13cmos5l_decap_8
XFILLER_616_77 VPWR VGND sg13cmos5l_decap_8
XFILLER_335_56 VPWR VGND sg13cmos5l_decap_8
XFILLER_482_84 VPWR VGND sg13cmos5l_decap_8
XFILLER_68_107 VPWR VGND sg13cmos5l_decap_8
XFILLER_646_224 VPWR VGND sg13cmos5l_decap_4
XFILLER_632_21 VPWR VGND sg13cmos5l_decap_8
XFILLER_580_0 VPWR VGND sg13cmos5l_decap_8
XFILLER_678_0 VPWR VGND sg13cmos5l_decap_8
XFILLER_110_215 VPWR VGND sg13cmos5l_decap_8
XFILLER_256_208 VPWR VGND sg13cmos5l_decap_8
X_0200_ _0200_/Q Tile_X0Y7_FrameData[23] VGND VPWR Tile_X0Y9_FrameStrobe[1] latch
X_1180_ _1180_/Q Tile_X0Y1_FrameData[29] VGND VPWR Tile_X0Y9_FrameStrobe[0] latch
XFILLER_632_98 VPWR VGND sg13cmos5l_decap_8
XFILLER_204_49 VPWR VGND sg13cmos5l_decap_8
XFILLER_76_184 VPWR VGND sg13cmos5l_decap_8
X_0131_ AXI_M_SOC_AWSIZE1 _0939_/Q _3680_/X VPWR VGND sg13cmos5l_or2_1
XFILLER_351_77 VPWR VGND sg13cmos5l_decap_8
XFILLER_501_14 VPWR VGND sg13cmos5l_decap_8
XFILLER_209_168 VPWR VGND sg13cmos5l_decap_8
XANTENNA__3312__X Tile_X0Y4_EE4BEG[0] VPWR VGND sg13cmos5l_antennanp
XFILLER_91_132 VPWR VGND sg13cmos5l_decap_8
X_0062_ _3629_/A _4606_/X _4607_/X _0344_/Q VPWR VGND sg13cmos5l_mux2_1
XFILLER_480_193 VPWR VGND sg13cmos5l_fill_2
XFILLER_91_187 VPWR VGND sg13cmos5l_decap_4
X_4870_ _4870_/X Tile_X0Y9_WW4END[9] AXI_M_SOC_RDATA6 _4925_/X _4903_/X _0803_/Q _0802_/Q
+ VPWR VGND sg13cmos5l_mux4_1
XFILLER_177_215 VPWR VGND sg13cmos5l_decap_8
X_3821_ _3821_/X Tile_X0Y0_WW4END[4] Tile_X0Y0_WW4END[14] _3867_/X _3854_/X _1063_/Q
+ _1062_/Q VPWR VGND sg13cmos5l_mux4_1
XFILLER_393_101 VPWR VGND sg13cmos5l_decap_8
XFILLER_232_193 VPWR VGND sg13cmos5l_decap_8
XFILLER_300_70 VPWR VGND sg13cmos5l_decap_8
XFILLER_716_228 VPWR VGND sg13cmos5l_fill_1
X_0964_ _0964_/Q Tile_X0Y0_FrameData[7] VGND VPWR Tile_X0Y9_FrameStrobe[0] latch
X_3752_ AXI_M_SOC_ARADDR24 Tile_X0Y8_WW4END[0] Tile_X0Y8_WW4END[8] Tile_X0Y8_W6END[8]
+ _4808_/X _0487_/Q _0486_/Q VPWR VGND sg13cmos5l_mux4_1
XFILLER_657_84 VPWR VGND sg13cmos5l_decap_8
XFILLER_229_35 VPWR VGND sg13cmos5l_decap_8
X_2703_ _4192_/A3 VPWR VGND sg13cmos5l_tielo
XFILLER_593_28 VPWR VGND sg13cmos5l_decap_8
XFILLER_376_63 VPWR VGND sg13cmos5l_decap_8
X_0895_ _0895_/Q Tile_X0Y9_FrameData[0] VGND VPWR Tile_X0Y9_FrameStrobe[6] latch
X_3683_ _3683_/X Tile_X0Y3_WW4END[1] Tile_X0Y3_WW4END[9] Tile_X0Y3_W6END[1] _4223_/X
+ _1755_/Q _1754_/Q VPWR VGND sg13cmos5l_mux4_1
XFILLER_145_134 VPWR VGND sg13cmos5l_fill_1
X_2634_ _2634_/Q Tile_X0Y6_FrameData[29] VGND VPWR Tile_X0Y9_FrameStrobe[6] latch
XFILLER_145_167 VPWR VGND sg13cmos5l_fill_1
XFILLER_696_135 VPWR VGND sg13cmos5l_fill_2
XFILLER_550_153 VPWR VGND sg13cmos5l_fill_2
XFILLER_160_104 VPWR VGND sg13cmos5l_decap_8
XFILLER_57_0 VPWR VGND sg13cmos5l_fill_1
XFILLER_145_189 VPWR VGND sg13cmos5l_fill_1
XFILLER_526_77 VPWR VGND sg13cmos5l_fill_2
X_2565_ _2565_/Q Tile_X0Y6_FrameData[2] VGND VPWR Tile_X0Y9_FrameStrobe[3] latch
XFILLER_245_56 VPWR VGND sg13cmos5l_decap_8
X_1516_ _1516_/Q Tile_X0Y2_FrameData[5] VGND VPWR Tile_X0Y9_FrameStrobe[2] latch
X_4304_ _4304_/X Tile_X0Y3_W1END[1] Tile_X0Y3_W6END[9] _4235_/X _4201_/X _1887_/Q
+ _1886_/Q VPWR VGND sg13cmos5l_mux4_1
XFILLER_299_193 VPWR VGND sg13cmos5l_decap_8
X_2496_ _2496_/Q Tile_X0Y6_FrameData[7] VGND VPWR Tile_X0Y9_FrameStrobe[1] latch
XFILLER_542_21 VPWR VGND sg13cmos5l_decap_8
XFILLER_59_118 VPWR VGND sg13cmos5l_decap_8
XFILLER_4_70 VPWR VGND sg13cmos5l_decap_8
X_1447_ _1447_/Q Tile_X0Y2_FrameData[10] VGND VPWR Tile_X0Y9_FrameStrobe[0] latch
X_4235_ _4235_/X _4197_/X _0088_/X _4196_/X Tile_X0Y0_S4END[13] _1703_/Q _1702_/Q
+ VPWR VGND sg13cmos5l_mux4_1
X_4166_ _4166_/X Tile_X0Y3_WW4END[13] AXI_M_SOC_WREADY _4235_/X _4208_/X _1809_/Q
+ _1808_/Q VPWR VGND sg13cmos5l_mux4_1
X_1378_ _1378_/Q Tile_X0Y1_FrameData[23] VGND VPWR Tile_X0Y9_FrameStrobe[6] latch
XFILLER_114_49 VPWR VGND sg13cmos5l_decap_8
XFILLER_605_132 VPWR VGND sg13cmos5l_fill_2
XFILLER_261_77 VPWR VGND sg13cmos5l_decap_4
X_0329_ _0329_/Q Tile_X0Y7_FrameData[22] VGND VPWR Tile_X0Y9_FrameStrobe[5] latch
X_3117_ Tile_X0Y7_EE4BEG[3] _4631_/X VPWR VGND sg13cmos5l_buf_1
XFILLER_67_184 VPWR VGND sg13cmos5l_decap_8
XFILLER_411_14 VPWR VGND sg13cmos5l_decap_8
X_4097_ _4097_/X _4021_/X _4129_/X _4128_/X _4020_/X _1449_/Q _1448_/Q VPWR VGND sg13cmos5l_mux4_1
XFILLER_215_105 VPWR VGND sg13cmos5l_decap_8
XANTENNA__3222__X Tile_X0Y0_FrameStrobe_O[10] VPWR VGND sg13cmos5l_antennanp
X_3048_ Tile_X0Y5_FrameData_O[7] Tile_X0Y5_FrameData[7] VPWR VGND sg13cmos5l_buf_1
XFILLER_605_198 VPWR VGND sg13cmos5l_fill_2
XFILLER_698_91 VPWR VGND sg13cmos5l_decap_8
XFILLER_168_215 VPWR VGND sg13cmos5l_decap_4
XFILLER_210_70 VPWR VGND sg13cmos5l_decap_8
XFILLER_369_197 VPWR VGND sg13cmos5l_decap_8
XFILLER_23_35 VPWR VGND sg13cmos5l_decap_8
XFILLER_135_7 VPWR VGND sg13cmos5l_decap_8
XFILLER_567_84 VPWR VGND sg13cmos5l_decap_8
XFILLER_384_156 VPWR VGND sg13cmos5l_fill_1
XFILLER_139_35 VPWR VGND sg13cmos5l_decap_8
XFILLER_384_178 VPWR VGND sg13cmos5l_fill_1
XFILLER_286_63 VPWR VGND sg13cmos5l_decap_8
XFILLER_136_112 VPWR VGND sg13cmos5l_decap_8
XFILLER_99_28 VPWR VGND sg13cmos5l_decap_8
XFILLER_687_102 VPWR VGND sg13cmos5l_fill_1
XFILLER_541_120 VPWR VGND sg13cmos5l_decap_8
XFILLER_302_7 VPWR VGND sg13cmos5l_decap_8
XFILLER_687_135 VPWR VGND sg13cmos5l_fill_2
XFILLER_136_189 VPWR VGND sg13cmos5l_decap_8
XFILLER_541_175 VPWR VGND sg13cmos5l_decap_8
XFILLER_436_77 VPWR VGND sg13cmos5l_decap_8
XFILLER_340_226 VPWR VGND sg13cmos5l_fill_2
XFILLER_155_56 VPWR VGND sg13cmos5l_decap_8
XFILLER_452_21 VPWR VGND sg13cmos5l_decap_8
XFILLER_48_10 VPWR VGND sg13cmos5l_decap_8
XFILLER_671_7 VPWR VGND sg13cmos5l_decap_8
XFILLER_602_35 VPWR VGND sg13cmos5l_decap_8
XFILLER_454_149 VPWR VGND sg13cmos5l_decap_8
XFILLER_58_173 VPWR VGND sg13cmos5l_decap_8
XFILLER_171_77 VPWR VGND sg13cmos5l_decap_8
XFILLER_321_14 VPWR VGND sg13cmos5l_decap_8
XFILLER_0_28 VPWR VGND sg13cmos5l_decap_8
XANTENNA__3132__X Tile_X0Y7_FrameData_O[2] VPWR VGND sg13cmos5l_antennanp
XFILLER_206_105 VPWR VGND sg13cmos5l_decap_8
XFILLER_611_102 VPWR VGND sg13cmos5l_fill_1
XFILLER_462_182 VPWR VGND sg13cmos5l_decap_8
XFILLER_678_28 VPWR VGND sg13cmos5l_decap_8
XFILLER_64_42 VPWR VGND sg13cmos5l_decap_8
XFILLER_611_135 VPWR VGND sg13cmos5l_fill_1
XFILLER_161_0 VPWR VGND sg13cmos5l_decap_8
XANTENNA__2971__X Tile_X0Y8_FrameData_O[11] VPWR VGND sg13cmos5l_antennanp
XFILLER_611_157 VPWR VGND sg13cmos5l_decap_4
XFILLER_259_0 VPWR VGND sg13cmos5l_decap_8
XFILLER_214_182 VPWR VGND sg13cmos5l_decap_8
XFILLER_120_70 VPWR VGND sg13cmos5l_decap_8
XFILLER_426_0 VPWR VGND sg13cmos5l_decap_8
XFILLER_375_134 VPWR VGND sg13cmos5l_fill_1
XFILLER_694_49 VPWR VGND sg13cmos5l_decap_8
XFILLER_174_207 VPWR VGND sg13cmos5l_decap_8
XFILLER_627_21 VPWR VGND sg13cmos5l_decap_8
XFILLER_127_134 VPWR VGND sg13cmos5l_decap_4
XFILLER_517_194 VPWR VGND sg13cmos5l_decap_4
XFILLER_196_96 VPWR VGND sg13cmos5l_decap_8
X_0680_ _0680_/Q Tile_X0Y9_FrameData[23] VGND VPWR Tile_X0Y9_FrameStrobe[0] latch
XFILLER_627_98 VPWR VGND sg13cmos5l_decap_8
XFILLER_331_204 VPWR VGND sg13cmos5l_decap_8
XFILLER_346_77 VPWR VGND sg13cmos5l_decap_8
XFILLER_142_126 VPWR VGND sg13cmos5l_decap_8
XANTENNA__3307__X Tile_X0Y0_E2BEG[7] VPWR VGND sg13cmos5l_antennanp
XFILLER_693_105 VPWR VGND sg13cmos5l_decap_8
XFILLER_678_179 VPWR VGND sg13cmos5l_fill_1
XFILLER_532_197 VPWR VGND sg13cmos5l_decap_8
XFILLER_643_42 VPWR VGND sg13cmos5l_decap_8
X_2350_ _2350_/Q Tile_X0Y5_FrameData[23] VGND VPWR Tile_X0Y9_FrameStrobe[5] latch
XFILLER_619_224 VPWR VGND sg13cmos5l_decap_4
XFILLER_362_21 VPWR VGND sg13cmos5l_decap_8
X_1301_ _1301_/Q Tile_X0Y1_FrameData[4] VGND VPWR Tile_X0Y9_FrameStrobe[3] latch
X_2281_ _2281_/Q Tile_X0Y5_FrameData[28] VGND VPWR Tile_X0Y9_FrameStrobe[3] latch
XFILLER_296_185 VPWR VGND sg13cmos5l_fill_2
X_4020_ _4020_/X Tile_X0Y0_W2MID[7] Tile_X0Y0_W2END[7] Tile_X0Y0_W6END[8] _3853_/X
+ _1133_/Q _1132_/Q VPWR VGND sg13cmos5l_mux4_1
XFILLER_634_216 VPWR VGND sg13cmos5l_fill_1
X_1232_ _1232_/Q Tile_X0Y1_FrameData[9] VGND VPWR Tile_X0Y9_FrameStrobe[1] latch
XFILLER_49_140 VPWR VGND sg13cmos5l_decap_8
XFILLER_362_98 VPWR VGND sg13cmos5l_decap_8
XFILLER_49_151 VPWR VGND sg13cmos5l_fill_1
XFILLER_512_35 VPWR VGND sg13cmos5l_decap_8
X_1163_ _1163_/Q Tile_X0Y0_FrameData[0] VGND VPWR Tile_X0Y9_FrameStrobe[6] latch
XFILLER_231_14 VPWR VGND sg13cmos5l_decap_8
XANTENNA__3042__X Tile_X0Y5_FrameData_O[1] VPWR VGND sg13cmos5l_antennanp
XFILLER_64_143 VPWR VGND sg13cmos5l_decap_8
X_0114_ AXI_M_SOC_ARLOCK _0930_/Q _3773_/X VPWR VGND sg13cmos5l_nor2b_1
XFILLER_588_28 VPWR VGND sg13cmos5l_decap_8
X_1094_ _1094_/Q Tile_X0Y0_FrameData[5] VGND VPWR Tile_X0Y9_FrameStrobe[4] latch
XFILLER_453_193 VPWR VGND sg13cmos5l_decap_8
XANTENNA__2881__X Tile_X0Y6_FrameData_O[2] VPWR VGND sg13cmos5l_antennanp
X_0045_ _3626_/A _4600_/X _4601_/X _0353_/Q VPWR VGND sg13cmos5l_mux2_1
X_4922_ _4922_/X Tile_X0Y9_N1END[2] Tile_X0Y9_N4END[2] _4898_/X _0081_/X _0715_/Q
+ _0714_/Q VPWR VGND sg13cmos5l_mux4_1
XFILLER_212_119 VPWR VGND sg13cmos5l_decap_8
XFILLER_602_179 VPWR VGND sg13cmos5l_decap_4
XFILLER_311_91 VPWR VGND sg13cmos5l_decap_8
X_4853_ _4853_/X Tile_X0Y9_W2MID[2] AXI_M_SOC_RDATA5 _4905_/X _4904_/X _0837_/Q _0836_/Q
+ VPWR VGND sg13cmos5l_mux4_1
XFILLER_366_112 VPWR VGND sg13cmos5l_decap_8
XFILLER_220_141 VPWR VGND sg13cmos5l_decap_8
XFILLER_366_134 VPWR VGND sg13cmos5l_fill_2
X_3804_ _3804_/X Tile_X0Y0_W2MID[0] Tile_X0Y0_W2MID[7] _3853_/X _3852_/X _1097_/Q
+ _1096_/Q VPWR VGND sg13cmos5l_mux4_1
X_4784_ _4784_/X _4715_/X Tile_X0Y9_N2MID[7] _4823_/X _4714_/X _0425_/Q _0424_/Q VPWR
+ VGND sg13cmos5l_mux4_1
X_1996_ _1996_/Q Tile_X0Y4_FrameData[25] VGND VPWR Tile_X0Y9_FrameStrobe[2] latch
XFILLER_537_21 VPWR VGND sg13cmos5l_decap_8
XFILLER_366_178 VPWR VGND sg13cmos5l_decap_8
XFILLER_381_115 VPWR VGND sg13cmos5l_decap_8
X_3735_ AXI_M_SOC_ARADDR7 Tile_X0Y9_WW4END[7] Tile_X0Y9_WW4END[15] Tile_X0Y9_W6END[7]
+ _4923_/X _0745_/Q _0744_/Q VPWR VGND sg13cmos5l_mux4_1
X_0947_ _0947_/Q Tile_X0Y0_FrameData[24] VGND VPWR Tile_X0Y9_FrameStrobe[0] latch
X_3666_ AXI_M_SOC_AWADDR27 Tile_X0Y4_WW4END[3] Tile_X0Y4_WW4END[11] Tile_X0Y4_W6END[11]
+ _4347_/X _1991_/Q _1990_/Q VPWR VGND sg13cmos5l_mux4_1
XFILLER_537_98 VPWR VGND sg13cmos5l_decap_4
XFILLER_118_167 VPWR VGND sg13cmos5l_decap_8
XFILLER_109_49 VPWR VGND sg13cmos5l_decap_8
X_0878_ _0878_/Q Tile_X0Y9_FrameData[17] VGND VPWR Tile_X0Y9_FrameStrobe[6] latch
XFILLER_256_77 VPWR VGND sg13cmos5l_decap_8
X_2617_ _2617_/Q Tile_X0Y6_FrameData[14] VGND VPWR Tile_X0Y9_FrameStrobe[5] latch
XFILLER_256_88 VPWR VGND sg13cmos5l_fill_2
XFILLER_133_126 VPWR VGND sg13cmos5l_decap_8
XFILLER_406_14 VPWR VGND sg13cmos5l_decap_8
XFILLER_279_119 VPWR VGND sg13cmos5l_decap_8
XANTENNA__3217__X Tile_X0Y0_FrameStrobe_O[5] VPWR VGND sg13cmos5l_antennanp
X_3597_ Tile_X0Y9_FrameData_O[27] Tile_X0Y9_FrameData[27] VPWR VGND sg13cmos5l_buf_1
XFILLER_553_42 VPWR VGND sg13cmos5l_decap_8
X_2548_ _2548_/Q Tile_X0Y6_FrameData[19] VGND VPWR Tile_X0Y9_FrameStrobe[3] latch
XFILLER_684_138 VPWR VGND sg13cmos5l_decap_8
XFILLER_272_21 VPWR VGND sg13cmos5l_decap_8
X_2479_ _2479_/Q Tile_X0Y6_FrameData[24] VGND VPWR Tile_X0Y9_FrameStrobe[1] latch
XFILLER_436_105 VPWR VGND sg13cmos5l_decap_8
XFILLER_703_56 VPWR VGND sg13cmos5l_decap_8
X_4218_ _4218_/X Tile_X0Y7_W1END[2] Tile_X0Y7_WW4END[2] Tile_X0Y7_W6END[10] _4686_/X
+ _0385_/Q _0384_/Q VPWR VGND sg13cmos5l_mux4_1
XFILLER_272_98 VPWR VGND sg13cmos5l_fill_2
XFILLER_422_35 VPWR VGND sg13cmos5l_decap_8
XFILLER_205_70 VPWR VGND sg13cmos5l_decap_8
XFILLER_18_35 VPWR VGND sg13cmos5l_decap_8
XFILLER_141_14 VPWR VGND sg13cmos5l_decap_8
X_4149_ _4149_/X Tile_X0Y3_W2MID[6] AXI_M_SOC_BVALID _4207_/X _4206_/X _1843_/Q _1842_/Q
+ VPWR VGND sg13cmos5l_mux4_1
XFILLER_55_132 VPWR VGND sg13cmos5l_decap_8
XFILLER_498_28 VPWR VGND sg13cmos5l_decap_8
XANTENNA__2791__X Tile_X0Y3_E6BEG[1] VPWR VGND sg13cmos5l_antennanp
XFILLER_252_7 VPWR VGND sg13cmos5l_decap_8
XFILLER_221_91 VPWR VGND sg13cmos5l_decap_8
XFILLER_70_168 VPWR VGND sg13cmos5l_decap_8
XFILLER_357_112 VPWR VGND sg13cmos5l_decap_8
XFILLER_34_78 VPWR VGND sg13cmos5l_decap_8
XFILLER_517_7 VPWR VGND sg13cmos5l_decap_8
XFILLER_211_163 VPWR VGND sg13cmos5l_decap_8
XFILLER_297_84 VPWR VGND sg13cmos5l_decap_8
XFILLER_297_95 VPWR VGND sg13cmos5l_fill_2
XFILLER_447_21 VPWR VGND sg13cmos5l_decap_8
XFILLER_211_196 VPWR VGND sg13cmos5l_decap_8
XFILLER_357_189 VPWR VGND sg13cmos5l_decap_8
XFILLER_50_22 VPWR VGND sg13cmos5l_decap_8
XFILLER_50_99 VPWR VGND sg13cmos5l_decap_8
XFILLER_514_175 VPWR VGND sg13cmos5l_fill_2
XFILLER_459_208 VPWR VGND sg13cmos5l_decap_8
XFILLER_166_77 VPWR VGND sg13cmos5l_decap_8
XFILLER_124_126 VPWR VGND sg13cmos5l_fill_1
XFILLER_316_14 VPWR VGND sg13cmos5l_decap_8
XFILLER_166_88 VPWR VGND sg13cmos5l_fill_1
XANTENNA__3127__X Tile_X0Y7_EE4BEG[13] VPWR VGND sg13cmos5l_antennanp
XFILLER_124_148 VPWR VGND sg13cmos5l_decap_8
XFILLER_59_20 VPWR VGND sg13cmos5l_decap_8
XFILLER_463_42 VPWR VGND sg13cmos5l_decap_8
XFILLER_182_21 VPWR VGND sg13cmos5l_decap_8
XFILLER_463_86 VPWR VGND sg13cmos5l_decap_8
XANTENNA__2966__X Tile_X0Y8_FrameData_O[6] VPWR VGND sg13cmos5l_antennanp
XFILLER_690_119 VPWR VGND sg13cmos5l_decap_4
XFILLER_59_97 VPWR VGND sg13cmos5l_decap_8
XFILLER_427_105 VPWR VGND sg13cmos5l_decap_8
XFILLER_613_56 VPWR VGND sg13cmos5l_decap_8
XFILLER_278_196 VPWR VGND sg13cmos5l_fill_2
XFILLER_332_35 VPWR VGND sg13cmos5l_decap_8
XFILLER_115_70 VPWR VGND sg13cmos5l_decap_8
XFILLER_376_0 VPWR VGND sg13cmos5l_decap_8
XFILLER_75_63 VPWR VGND sg13cmos5l_decap_8
XFILLER_543_0 VPWR VGND sg13cmos5l_decap_8
XFILLER_201_28 VPWR VGND sg13cmos5l_decap_8
XFILLER_61_146 VPWR VGND sg13cmos5l_decap_8
XFILLER_131_91 VPWR VGND sg13cmos5l_decap_8
XFILLER_98_7 VPWR VGND sg13cmos5l_decap_8
XFILLER_348_112 VPWR VGND sg13cmos5l_decap_8
XFILLER_199_181 VPWR VGND sg13cmos5l_decap_8
XFILLER_710_0 VPWR VGND sg13cmos5l_decap_8
XFILLER_91_84 VPWR VGND sg13cmos5l_decap_4
XFILLER_638_42 VPWR VGND sg13cmos5l_decap_8
X_1850_ _1850_/Q Tile_X0Y3_FrameData[15] VGND VPWR Tile_X0Y9_FrameStrobe[5] latch
XFILLER_357_21 VPWR VGND sg13cmos5l_decap_8
XFILLER_202_196 VPWR VGND sg13cmos5l_decap_4
X_0801_ _0801_/Q Tile_X0Y9_FrameData[30] VGND VPWR Tile_X0Y9_FrameStrobe[4] latch
X_1781_ _1781_/Q Tile_X0Y3_FrameData[20] VGND VPWR Tile_X0Y9_FrameStrobe[3] latch
XFILLER_363_126 VPWR VGND sg13cmos5l_decap_8
X_3520_ Tile_X0Y1_E1BEG[2] _3930_/X VPWR VGND sg13cmos5l_buf_1
X_0732_ _0732_/Q Tile_X0Y9_FrameData[3] VGND VPWR Tile_X0Y9_FrameStrobe[1] latch
XFILLER_357_98 VPWR VGND sg13cmos5l_decap_8
XFILLER_507_35 VPWR VGND sg13cmos5l_decap_8
XFILLER_505_175 VPWR VGND sg13cmos5l_decap_8
X_0663_ _0663_/Q Tile_X0Y8_FrameData[8] VGND VPWR Tile_X0Y9_FrameStrobe[7] latch
X_3451_ Tile_X0Y1_FrameData_O[9] Tile_X0Y1_FrameData[9] VPWR VGND sg13cmos5l_buf_1
XFILLER_654_63 VPWR VGND sg13cmos5l_decap_8
XFILLER_226_14 VPWR VGND sg13cmos5l_decap_8
XANTENNA__3037__X Tile_X0Y5_EE4BEG[12] VPWR VGND sg13cmos5l_antennanp
XFILLER_666_105 VPWR VGND sg13cmos5l_decap_4
XFILLER_666_116 VPWR VGND sg13cmos5l_fill_1
XFILLER_373_42 VPWR VGND sg13cmos5l_decap_8
X_2402_ _2402_/Q Tile_X0Y5_FrameData[3] VGND VPWR Tile_X0Y9_FrameStrobe[6] latch
X_3382_ Tile_X0Y2_E6BEG[5] _4077_/X VPWR VGND sg13cmos5l_buf_1
X_0594_ _0594_/Q Tile_X0Y8_FrameData[13] VGND VPWR Tile_X0Y9_FrameStrobe[5] latch
XFILLER_69_224 VPWR VGND sg13cmos5l_decap_4
XANTENNA__2876__X Tile_X0Y6_EE4BEG[13] VPWR VGND sg13cmos5l_antennanp
X_2333_ _2333_/Q Tile_X0Y5_FrameData[8] VGND VPWR Tile_X0Y9_FrameStrobe[4] latch
XFILLER_523_56 VPWR VGND sg13cmos5l_decap_8
XFILLER_84_205 VPWR VGND sg13cmos5l_decap_4
X_2264_ _2264_/Q Tile_X0Y5_FrameData[13] VGND VPWR Tile_X0Y9_FrameStrobe[2] latch
XFILLER_284_133 VPWR VGND sg13cmos5l_decap_8
XFILLER_670_84 VPWR VGND sg13cmos5l_decap_8
XFILLER_242_35 VPWR VGND sg13cmos5l_decap_8
XFILLER_84_227 VPWR VGND sg13cmos5l_fill_2
X_1215_ _1215_/Q Tile_X0Y1_FrameData[26] VGND VPWR Tile_X0Y9_FrameStrobe[1] latch
X_4003_ _4003_/X Tile_X0Y5_W1END[2] Tile_X0Y5_WW4END[2] Tile_X0Y5_W6END[10] _4453_/X
+ _2409_/Q _2408_/Q VPWR VGND sg13cmos5l_mux4_1
X_2195_ _2195_/Q Tile_X0Y5_FrameData[18] VGND VPWR Tile_X0Y9_FrameStrobe[0] latch
XFILLER_433_119 VPWR VGND sg13cmos5l_decap_8
XFILLER_599_49 VPWR VGND sg13cmos5l_decap_8
XFILLER_37_132 VPWR VGND sg13cmos5l_decap_8
XFILLER_225_211 VPWR VGND sg13cmos5l_fill_1
XFILLER_426_182 VPWR VGND sg13cmos5l_decap_8
X_1146_ _1146_/Q Tile_X0Y0_FrameData[17] VGND VPWR Tile_X0Y9_FrameStrobe[6] latch
XFILLER_37_165 VPWR VGND sg13cmos5l_decap_8
XFILLER_587_112 VPWR VGND sg13cmos5l_decap_8
XFILLER_37_187 VPWR VGND sg13cmos5l_decap_4
XFILLER_37_198 VPWR VGND sg13cmos5l_decap_4
XFILLER_111_28 VPWR VGND sg13cmos5l_decap_8
X_1077_ _1077_/Q Tile_X0Y0_FrameData[22] VGND VPWR Tile_X0Y9_FrameStrobe[4] latch
XFILLER_52_146 VPWR VGND sg13cmos5l_decap_8
XFILLER_386_207 VPWR VGND sg13cmos5l_decap_8
XANTENNA__3500__X Tile_X0Y1_E6BEG[10] VPWR VGND sg13cmos5l_antennanp
XFILLER_587_178 VPWR VGND sg13cmos5l_decap_4
X_4905_ _4905_/X Tile_X0Y9_N2MID[2] Tile_X0Y9_N2END[2] _4934_/X _4818_/X _0691_/Q
+ _0690_/Q VPWR VGND sg13cmos5l_mux4_1
XFILLER_339_112 VPWR VGND sg13cmos5l_decap_4
XFILLER_548_42 VPWR VGND sg13cmos5l_decap_8
X_4836_ _4836_/X Tile_X0Y9_W1END[0] Tile_X0Y9_WW4END[12] Tile_X0Y9_W6END[4] _4916_/X
+ _0867_/Q _0866_/Q VPWR VGND sg13cmos5l_mux4_1
XFILLER_695_70 VPWR VGND sg13cmos5l_decap_8
XFILLER_267_21 VPWR VGND sg13cmos5l_decap_8
XFILLER_484_19 VPWR VGND sg13cmos5l_decap_8
XFILLER_354_126 VPWR VGND sg13cmos5l_decap_8
X_4767_ _4767_/X AXI_M_SOC_RDATA11 _4804_/X _4808_/X _4791_/X _0513_/Q _0512_/Q VPWR
+ VGND sg13cmos5l_mux4_1
X_1979_ _1979_/Q Tile_X0Y4_FrameData[10] VGND VPWR Tile_X0Y9_FrameStrobe[1] latch
X_3718_ AXI_M_SOC_WDATA28 Tile_X0Y6_W1END[0] Tile_X0Y6_WW4END[4] Tile_X0Y6_WW4END[12]
+ _4580_/X _2503_/Q _2502_/Q VPWR VGND sg13cmos5l_mux4_1
XFILLER_4_209 VPWR VGND sg13cmos5l_fill_1
XFILLER_267_98 VPWR VGND sg13cmos5l_decap_8
X_4698_ _4698_/X _4665_/X Tile_X0Y9_N4END[10] _4664_/X _0054_/X _0187_/Q _0186_/Q
+ VPWR VGND sg13cmos5l_mux4_1
XFILLER_417_35 VPWR VGND sg13cmos5l_decap_8
XFILLER_20_14 VPWR VGND sg13cmos5l_decap_8
XFILLER_564_63 VPWR VGND sg13cmos5l_decap_8
XFILLER_161_221 VPWR VGND sg13cmos5l_fill_1
X_3649_ AXI_M_SOC_AWADDR10 Tile_X0Y5_WW4END[2] Tile_X0Y5_WW4END[10] Tile_X0Y5_W6END[10]
+ _4461_/X _2251_/Q _2250_/Q VPWR VGND sg13cmos5l_mux4_1
XFILLER_511_112 VPWR VGND sg13cmos5l_decap_8
XFILLER_136_14 VPWR VGND sg13cmos5l_decap_8
XFILLER_657_105 VPWR VGND sg13cmos5l_decap_8
XFILLER_283_42 VPWR VGND sg13cmos5l_decap_8
XFILLER_714_22 VPWR VGND sg13cmos5l_decap_8
XFILLER_511_134 VPWR VGND sg13cmos5l_decap_8
XANTENNA__2786__X Tile_X0Y3_EE4BEG[12] VPWR VGND sg13cmos5l_antennanp
XFILLER_714_99 VPWR VGND sg13cmos5l_decap_8
XFILLER_114_192 VPWR VGND sg13cmos5l_decap_8
XFILLER_433_56 VPWR VGND sg13cmos5l_decap_8
XFILLER_665_171 VPWR VGND sg13cmos5l_fill_1
XFILLER_216_91 VPWR VGND sg13cmos5l_decap_8
XFILLER_275_133 VPWR VGND sg13cmos5l_decap_8
XFILLER_665_193 VPWR VGND sg13cmos5l_fill_2
XFILLER_580_84 VPWR VGND sg13cmos5l_decap_8
XFILLER_29_56 VPWR VGND sg13cmos5l_decap_8
XFILLER_152_35 VPWR VGND sg13cmos5l_decap_8
XFILLER_424_119 VPWR VGND sg13cmos5l_decap_8
XFILLER_467_7 VPWR VGND sg13cmos5l_decap_8
XFILLER_290_147 VPWR VGND sg13cmos5l_decap_8
XFILLER_578_112 VPWR VGND sg13cmos5l_decap_8
XFILLER_302_49 VPWR VGND sg13cmos5l_decap_8
XFILLER_634_7 VPWR VGND sg13cmos5l_decap_8
XFILLER_45_66 VPWR VGND sg13cmos5l_decap_8
XANTENNA__3410__X Tile_X0Y4_FrameData_O[1] VPWR VGND sg13cmos5l_antennanp
XFILLER_578_189 VPWR VGND sg13cmos5l_decap_8
XFILLER_432_196 VPWR VGND sg13cmos5l_decap_8
XFILLER_593_126 VPWR VGND sg13cmos5l_decap_8
XFILLER_458_42 VPWR VGND sg13cmos5l_decap_8
XFILLER_129_207 VPWR VGND sg13cmos5l_decap_4
XFILLER_177_21 VPWR VGND sg13cmos5l_decap_8
XFILLER_61_76 VPWR VGND sg13cmos5l_decap_4
XFILLER_345_126 VPWR VGND sg13cmos5l_decap_8
XFILLER_124_0 VPWR VGND sg13cmos5l_decap_8
XFILLER_608_56 VPWR VGND sg13cmos5l_decap_8
XFILLER_327_35 VPWR VGND sg13cmos5l_decap_8
XANTENNA_9 Tile_X0Y0_S2MID[0] VPWR VGND sg13cmos5l_antennanp
XFILLER_6_49 VPWR VGND sg13cmos5l_decap_8
XFILLER_691_28 VPWR VGND sg13cmos5l_decap_8
XFILLER_474_63 VPWR VGND sg13cmos5l_decap_8
XFILLER_502_112 VPWR VGND sg13cmos5l_decap_8
XFILLER_648_105 VPWR VGND sg13cmos5l_decap_8
XFILLER_499_196 VPWR VGND sg13cmos5l_decap_8
XFILLER_193_42 VPWR VGND sg13cmos5l_decap_8
XFILLER_493_0 VPWR VGND sg13cmos5l_decap_8
XFILLER_624_77 VPWR VGND sg13cmos5l_decap_8
XFILLER_502_189 VPWR VGND sg13cmos5l_decap_8
XFILLER_10_91 VPWR VGND sg13cmos5l_decap_8
XFILLER_343_56 VPWR VGND sg13cmos5l_decap_8
XFILLER_126_91 VPWR VGND sg13cmos5l_decap_8
XFILLER_656_182 VPWR VGND sg13cmos5l_fill_2
XFILLER_66_205 VPWR VGND sg13cmos5l_decap_8
XFILLER_490_84 VPWR VGND sg13cmos5l_decap_8
XFILLER_660_0 VPWR VGND sg13cmos5l_decap_8
XFILLER_640_21 VPWR VGND sg13cmos5l_decap_8
XFILLER_266_155 VPWR VGND sg13cmos5l_decap_8
XFILLER_13_7 VPWR VGND sg13cmos5l_decap_8
X_1000_ _1000_/Q Tile_X0Y0_FrameData[3] VGND VPWR Tile_X0Y9_FrameStrobe[1] latch
XFILLER_281_147 VPWR VGND sg13cmos5l_decap_8
XFILLER_640_98 VPWR VGND sg13cmos5l_decap_8
XFILLER_569_112 VPWR VGND sg13cmos5l_decap_8
XFILLER_212_49 VPWR VGND sg13cmos5l_decap_8
XFILLER_19_198 VPWR VGND sg13cmos5l_fill_1
XANTENNA__3320__X Tile_X0Y4_EE4BEG[8] VPWR VGND sg13cmos5l_antennanp
XFILLER_222_225 VPWR VGND sg13cmos5l_decap_4
XFILLER_569_189 VPWR VGND sg13cmos5l_decap_8
X_2951_ Tile_X0Y8_EE4BEG[7] _4751_/X VPWR VGND sg13cmos5l_buf_1
XFILLER_649_63 VPWR VGND sg13cmos5l_decap_8
XFILLER_368_42 VPWR VGND sg13cmos5l_decap_8
X_1902_ _1902_/Q Tile_X0Y3_FrameData[27] VGND VPWR Tile_X0Y9_FrameStrobe[7] latch
X_2882_ Tile_X0Y6_FrameData_O[3] Tile_X0Y6_FrameData[3] VPWR VGND sg13cmos5l_buf_1
X_4621_ _4621_/X Tile_X0Y7_W2END[6] AXI_M_SOC_RDATA22 _4671_/X _4670_/X _0317_/Q _0316_/Q
+ VPWR VGND sg13cmos5l_mux4_1
X_1833_ _1833_/Q Tile_X0Y3_FrameData[0] VGND VPWR Tile_X0Y9_FrameStrobe[4] latch
XFILLER_518_56 VPWR VGND sg13cmos5l_decap_8
X_4552_ _4552_/X _4483_/X _4599_/X _4598_/X _4482_/X _2449_/Q _2448_/Q VPWR VGND sg13cmos5l_mux4_1
X_1764_ _1764_/Q Tile_X0Y3_FrameData[5] VGND VPWR Tile_X0Y9_FrameStrobe[2] latch
XFILLER_665_84 VPWR VGND sg13cmos5l_decap_8
XFILLER_237_35 VPWR VGND sg13cmos5l_decap_8
X_3503_ Tile_X0Y1_E2BEGb[1] _3941_/X VPWR VGND sg13cmos5l_buf_1
XFILLER_143_210 VPWR VGND sg13cmos5l_decap_8
X_0715_ _0715_/Q Tile_X0Y9_FrameData[20] VGND VPWR Tile_X0Y9_FrameStrobe[1] latch
XFILLER_384_63 VPWR VGND sg13cmos5l_decap_8
XFILLER_344_181 VPWR VGND sg13cmos5l_fill_1
X_4483_ _4483_/X Tile_X0Y7_W2MID[0] Tile_X0Y7_W2END[0] Tile_X0Y7_W6END[0] _4668_/X
+ _0393_/Q _0392_/Q VPWR VGND sg13cmos5l_mux4_1
X_1695_ _1695_/Q Tile_X0Y3_FrameData[10] VGND VPWR Tile_X0Y9_FrameStrobe[0] latch
XFILLER_694_200 VPWR VGND sg13cmos5l_fill_1
XFILLER_639_105 VPWR VGND sg13cmos5l_decap_8
X_3434_ Tile_X0Y4_FrameData_O[25] Tile_X0Y4_FrameData[25] VPWR VGND sg13cmos5l_buf_1
X_0646_ _0646_/Q Tile_X0Y8_FrameData[25] VGND VPWR Tile_X0Y9_FrameStrobe[7] latch
XFILLER_103_107 VPWR VGND sg13cmos5l_decap_8
XFILLER_534_77 VPWR VGND sg13cmos5l_decap_4
XFILLER_106_28 VPWR VGND sg13cmos5l_decap_8
X_0577_ _0577_/Q Tile_X0Y8_FrameData[30] VGND VPWR Tile_X0Y9_FrameStrobe[5] latch
X_3365_ Tile_X0Y2_EE4BEG[4] _4060_/X VPWR VGND sg13cmos5l_buf_1
XFILLER_654_119 VPWR VGND sg13cmos5l_decap_8
XFILLER_257_100 VPWR VGND sg13cmos5l_decap_8
XFILLER_253_56 VPWR VGND sg13cmos5l_decap_8
X_2316_ _2316_/Q Tile_X0Y5_FrameData[25] VGND VPWR Tile_X0Y9_FrameStrobe[4] latch
XFILLER_647_182 VPWR VGND sg13cmos5l_decap_8
XFILLER_257_144 VPWR VGND sg13cmos5l_decap_8
X_3296_ Tile_X0Y0_E2BEGb[4] _3816_/X VPWR VGND sg13cmos5l_buf_1
XFILLER_550_21 VPWR VGND sg13cmos5l_decap_8
XFILLER_111_195 VPWR VGND sg13cmos5l_fill_2
X_2247_ _2247_/Q Tile_X0Y5_FrameData[30] VGND VPWR Tile_X0Y9_FrameStrobe[2] latch
X_2178_ _2178_/Q Tile_X0Y4_FrameData[3] VGND VPWR Tile_X0Y9_FrameStrobe[7] latch
XFILLER_550_98 VPWR VGND sg13cmos5l_decap_8
XFILLER_122_49 VPWR VGND sg13cmos5l_decap_8
X_1129_ _1129_/Q Tile_X0Y0_FrameData[2] VGND VPWR Tile_X0Y9_FrameStrobe[5] latch
XFILLER_213_203 VPWR VGND sg13cmos5l_fill_1
XANTENNA__3230__X Tile_X0Y0_FrameStrobe_O[18] VPWR VGND sg13cmos5l_antennanp
XFILLER_700_79 VPWR VGND sg13cmos5l_decap_8
XFILLER_15_14 VPWR VGND sg13cmos5l_decap_8
XFILLER_280_191 VPWR VGND sg13cmos5l_fill_1
XFILLER_575_126 VPWR VGND sg13cmos5l_decap_8
XFILLER_559_63 VPWR VGND sg13cmos5l_decap_8
XFILLER_278_42 VPWR VGND sg13cmos5l_decap_8
XFILLER_717_153 VPWR VGND sg13cmos5l_decap_4
XFILLER_590_118 VPWR VGND sg13cmos5l_decap_8
XFILLER_709_77 VPWR VGND sg13cmos5l_decap_8
XFILLER_717_175 VPWR VGND sg13cmos5l_decap_4
X_4819_ _4819_/X Tile_X0Y7_W2MID[4] Tile_X0Y7_W2END[4] Tile_X0Y7_W6END[11] _4675_/X
+ _0365_/Q _0364_/Q VPWR VGND sg13cmos5l_mux4_1
XFILLER_327_137 VPWR VGND sg13cmos5l_fill_2
XFILLER_31_24 VPWR VGND sg13cmos5l_decap_8
XFILLER_428_56 VPWR VGND sg13cmos5l_decap_8
XFILLER_215_7 VPWR VGND sg13cmos5l_decap_8
XFILLER_575_84 VPWR VGND sg13cmos5l_decap_8
XFILLER_147_35 VPWR VGND sg13cmos5l_decap_8
XFILLER_335_170 VPWR VGND sg13cmos5l_decap_4
XFILLER_294_63 VPWR VGND sg13cmos5l_decap_8
XFILLER_134_221 VPWR VGND sg13cmos5l_fill_1
XFILLER_496_133 VPWR VGND sg13cmos5l_decap_8
XFILLER_350_140 VPWR VGND sg13cmos5l_decap_8
XFILLER_295_206 VPWR VGND sg13cmos5l_decap_8
XFILLER_444_77 VPWR VGND sg13cmos5l_decap_8
XFILLER_584_7 VPWR VGND sg13cmos5l_decap_8
XFILLER_645_119 VPWR VGND sg13cmos5l_decap_8
XFILLER_444_99 VPWR VGND sg13cmos5l_fill_1
XFILLER_163_56 VPWR VGND sg13cmos5l_decap_8
XANTENNA__3405__X Tile_X0Y2_E1BEG[0] VPWR VGND sg13cmos5l_antennanp
XFILLER_638_171 VPWR VGND sg13cmos5l_decap_8
XFILLER_163_67 VPWR VGND sg13cmos5l_fill_2
XFILLER_48_216 VPWR VGND sg13cmos5l_decap_8
XFILLER_48_227 VPWR VGND sg13cmos5l_fill_2
XFILLER_460_21 VPWR VGND sg13cmos5l_decap_8
XFILLER_56_10 VPWR VGND sg13cmos5l_decap_8
XFILLER_263_103 VPWR VGND sg13cmos5l_fill_1
XFILLER_248_188 VPWR VGND sg13cmos5l_decap_8
XFILLER_598_207 VPWR VGND sg13cmos5l_decap_4
XFILLER_653_196 VPWR VGND sg13cmos5l_decap_8
XFILLER_610_35 VPWR VGND sg13cmos5l_decap_8
XFILLER_56_87 VPWR VGND sg13cmos5l_decap_8
XFILLER_405_141 VPWR VGND sg13cmos5l_decap_4
XFILLER_16_124 VPWR VGND sg13cmos5l_fill_1
XANTENNA__3140__X Tile_X0Y7_FrameData_O[10] VPWR VGND sg13cmos5l_antennanp
XFILLER_405_196 VPWR VGND sg13cmos5l_decap_8
XFILLER_72_42 VPWR VGND sg13cmos5l_decap_8
XFILLER_686_28 VPWR VGND sg13cmos5l_decap_8
XFILLER_566_126 VPWR VGND sg13cmos5l_decap_8
XFILLER_469_63 VPWR VGND sg13cmos5l_decap_8
XFILLER_241_0 VPWR VGND sg13cmos5l_decap_8
XFILLER_339_0 VPWR VGND sg13cmos5l_decap_8
XFILLER_188_42 VPWR VGND sg13cmos5l_decap_8
XFILLER_169_162 VPWR VGND sg13cmos5l_decap_8
XFILLER_169_184 VPWR VGND sg13cmos5l_decap_8
XFILLER_708_175 VPWR VGND sg13cmos5l_decap_8
XFILLER_619_77 VPWR VGND sg13cmos5l_decap_8
XFILLER_506_0 VPWR VGND sg13cmos5l_decap_8
XFILLER_318_148 VPWR VGND sg13cmos5l_fill_2
XFILLER_338_56 VPWR VGND sg13cmos5l_decap_8
XFILLER_485_84 VPWR VGND sg13cmos5l_decap_8
XFILLER_635_21 VPWR VGND sg13cmos5l_decap_8
XFILLER_522_218 VPWR VGND sg13cmos5l_fill_1
XFILLER_125_221 VPWR VGND sg13cmos5l_fill_1
X_0500_ _0500_/Q Tile_X0Y8_FrameData[11] VGND VPWR Tile_X0Y9_FrameStrobe[2] latch
X_1480_ _1480_/Q Tile_X0Y2_FrameData[9] VGND VPWR Tile_X0Y9_FrameStrobe[1] latch
XFILLER_341_151 VPWR VGND sg13cmos5l_decap_8
XFILLER_635_98 VPWR VGND sg13cmos5l_decap_8
XFILLER_207_49 VPWR VGND sg13cmos5l_decap_8
XFILLER_98_127 VPWR VGND sg13cmos5l_decap_8
XFILLER_487_155 VPWR VGND sg13cmos5l_fill_2
XFILLER_98_138 VPWR VGND sg13cmos5l_fill_1
X_0431_ _0431_/Q Tile_X0Y8_FrameData[16] VGND VPWR Tile_X0Y9_FrameStrobe[0] latch
XFILLER_354_77 VPWR VGND sg13cmos5l_decap_8
XFILLER_286_217 VPWR VGND sg13cmos5l_fill_2
XFILLER_286_228 VPWR VGND sg13cmos5l_fill_1
XFILLER_636_119 VPWR VGND sg13cmos5l_decap_8
XFILLER_504_14 VPWR VGND sg13cmos5l_decap_8
XANTENNA__3315__X Tile_X0Y4_EE4BEG[3] VPWR VGND sg13cmos5l_antennanp
XFILLER_239_111 VPWR VGND sg13cmos5l_decap_8
XFILLER_691_225 VPWR VGND sg13cmos5l_decap_4
XFILLER_651_42 VPWR VGND sg13cmos5l_decap_8
XFILLER_239_122 VPWR VGND sg13cmos5l_fill_2
X_0362_ _0362_/Q Tile_X0Y7_FrameData[21] VGND VPWR Tile_X0Y9_FrameStrobe[6] latch
X_3150_ Tile_X0Y7_FrameData_O[20] Tile_X0Y7_FrameData[20] VPWR VGND sg13cmos5l_buf_1
XFILLER_39_227 VPWR VGND sg13cmos5l_fill_2
XFILLER_370_21 VPWR VGND sg13cmos5l_decap_8
X_2101_ _2101_/Q Tile_X0Y4_FrameData[16] VGND VPWR Tile_X0Y9_FrameStrobe[5] latch
X_3081_ Tile_X0Y4_E2BEGb[7] _4271_/X VPWR VGND sg13cmos5l_buf_1
XFILLER_443_203 VPWR VGND sg13cmos5l_fill_2
X_0293_ _0293_/Q Tile_X0Y7_FrameData[26] VGND VPWR Tile_X0Y9_FrameStrobe[4] latch
XFILLER_589_218 VPWR VGND sg13cmos5l_fill_1
XFILLER_54_208 VPWR VGND sg13cmos5l_decap_4
XFILLER_254_136 VPWR VGND sg13cmos5l_decap_8
X_2032_ _2032_/Q Tile_X0Y4_FrameData[21] VGND VPWR Tile_X0Y9_FrameStrobe[3] latch
XFILLER_644_196 VPWR VGND sg13cmos5l_decap_8
XFILLER_520_35 VPWR VGND sg13cmos5l_decap_8
XANTENNA__3050__X Tile_X0Y5_FrameData_O[9] VPWR VGND sg13cmos5l_antennanp
XFILLER_596_28 VPWR VGND sg13cmos5l_decap_8
XFILLER_557_126 VPWR VGND sg13cmos5l_decap_8
XFILLER_379_63 VPWR VGND sg13cmos5l_decap_8
X_3983_ _3983_/X Tile_X0Y2_W1END[1] Tile_X0Y2_W6END[5] _4110_/X _4085_/X _1671_/Q
+ _1670_/Q VPWR VGND sg13cmos5l_mux4_1
XFILLER_379_85 VPWR VGND sg13cmos5l_decap_8
XFILLER_210_206 VPWR VGND sg13cmos5l_decap_8
XFILLER_379_96 VPWR VGND sg13cmos5l_fill_1
XFILLER_210_217 VPWR VGND sg13cmos5l_fill_2
X_2934_ Tile_X0Y8_E6BEG[2] _4762_/X VPWR VGND sg13cmos5l_buf_1
XFILLER_411_188 VPWR VGND sg13cmos5l_decap_4
XFILLER_87_0 VPWR VGND sg13cmos5l_decap_8
XFILLER_529_77 VPWR VGND sg13cmos5l_decap_4
X_2865_ Tile_X0Y6_EE4BEG[2] _4514_/X VPWR VGND sg13cmos5l_buf_1
XFILLER_248_56 VPWR VGND sg13cmos5l_decap_8
XFILLER_714_134 VPWR VGND sg13cmos5l_decap_8
X_4604_ _4604_/X Tile_X0Y7_W1END[2] Tile_X0Y7_WW4END[14] Tile_X0Y7_W6END[6] _4686_/X
+ _0349_/Q _0348_/Q VPWR VGND sg13cmos5l_mux4_1
X_1816_ _1816_/Q Tile_X0Y3_FrameData[17] VGND VPWR Tile_X0Y9_FrameStrobe[4] latch
XFILLER_580_140 VPWR VGND sg13cmos5l_decap_8
X_2796_ Tile_X0Y3_E6BEG[6] _4186_/X VPWR VGND sg13cmos5l_buf_1
XFILLER_545_21 VPWR VGND sg13cmos5l_decap_8
XFILLER_7_70 VPWR VGND sg13cmos5l_decap_8
XFILLER_324_129 VPWR VGND sg13cmos5l_decap_8
X_4535_ _4535_/X AXI_M_SOC_RDATA27 _4572_/X _4576_/X _4559_/X _2537_/Q _2536_/Q VPWR
+ VGND sg13cmos5l_mux4_1
X_1747_ _1747_/Q Tile_X0Y3_FrameData[22] VGND VPWR Tile_X0Y9_FrameStrobe[2] latch
XFILLER_667_211 VPWR VGND sg13cmos5l_fill_1
X_4466_ _4466_/X _4427_/X _0097_/X _4426_/X _0156_/X _2207_/Q _2206_/Q VPWR VGND sg13cmos5l_mux4_1
XFILLER_545_98 VPWR VGND sg13cmos5l_decap_8
X_1678_ _1678_/Q Tile_X0Y3_FrameData[27] VGND VPWR Tile_X0Y9_FrameStrobe[0] latch
XFILLER_117_49 VPWR VGND sg13cmos5l_decap_8
X_3417_ Tile_X0Y4_FrameData_O[8] Tile_X0Y4_FrameData[8] VPWR VGND sg13cmos5l_buf_1
X_0629_ _0629_/Q Tile_X0Y8_FrameData[10] VGND VPWR Tile_X0Y9_FrameStrobe[6] latch
XFILLER_414_14 VPWR VGND sg13cmos5l_decap_8
XANTENNA__3225__X Tile_X0Y0_FrameStrobe_O[13] VPWR VGND sg13cmos5l_antennanp
X_4397_ _4397_/X Tile_X0Y5_WW4END[6] AXI_M_SOC_RRESP0 _4457_/X _4429_/X _2309_/Q _2308_/Q
+ VPWR VGND sg13cmos5l_mux4_1
XFILLER_419_211 VPWR VGND sg13cmos5l_decap_8
XFILLER_561_42 VPWR VGND sg13cmos5l_decap_8
XFILLER_493_147 VPWR VGND sg13cmos5l_decap_8
X_3348_ Tile_X0Y2_FrameData_O[19] Tile_X0Y2_FrameData[19] VPWR VGND sg13cmos5l_buf_1
XFILLER_280_21 VPWR VGND sg13cmos5l_decap_8
X_3279_ Tile_X0Y0_EE4BEG[15] _3835_/X VPWR VGND sg13cmos5l_buf_1
XFILLER_635_174 VPWR VGND sg13cmos5l_fill_2
XFILLER_711_56 VPWR VGND sg13cmos5l_decap_8
XFILLER_245_147 VPWR VGND sg13cmos5l_decap_4
XFILLER_650_133 VPWR VGND sg13cmos5l_decap_8
XFILLER_280_98 VPWR VGND sg13cmos5l_decap_8
XFILLER_430_35 VPWR VGND sg13cmos5l_decap_8
XFILLER_213_70 VPWR VGND sg13cmos5l_decap_8
XFILLER_26_35 VPWR VGND sg13cmos5l_decap_8
XFILLER_260_117 VPWR VGND sg13cmos5l_decap_8
XFILLER_165_7 VPWR VGND sg13cmos5l_decap_8
XFILLER_399_173 VPWR VGND sg13cmos5l_fill_1
XFILLER_399_195 VPWR VGND sg13cmos5l_decap_8
XFILLER_289_63 VPWR VGND sg13cmos5l_decap_8
XFILLER_548_148 VPWR VGND sg13cmos5l_fill_1
XFILLER_402_166 VPWR VGND sg13cmos5l_decap_8
XFILLER_332_7 VPWR VGND sg13cmos5l_decap_8
XFILLER_201_228 VPWR VGND sg13cmos5l_fill_1
XFILLER_439_77 VPWR VGND sg13cmos5l_decap_8
XFILLER_166_121 VPWR VGND sg13cmos5l_fill_2
XFILLER_705_112 VPWR VGND sg13cmos5l_decap_8
XFILLER_158_56 VPWR VGND sg13cmos5l_decap_8
XFILLER_571_140 VPWR VGND sg13cmos5l_decap_8
XFILLER_181_102 VPWR VGND sg13cmos5l_decap_8
XFILLER_315_118 VPWR VGND sg13cmos5l_fill_1
XFILLER_455_21 VPWR VGND sg13cmos5l_decap_8
XFILLER_605_35 VPWR VGND sg13cmos5l_decap_8
XFILLER_484_103 VPWR VGND sg13cmos5l_decap_8
XFILLER_174_77 VPWR VGND sg13cmos5l_decap_8
XFILLER_673_203 VPWR VGND sg13cmos5l_fill_2
XFILLER_324_14 VPWR VGND sg13cmos5l_decap_8
XFILLER_323_195 VPWR VGND sg13cmos5l_fill_2
XFILLER_3_28 VPWR VGND sg13cmos5l_decap_8
XANTENNA__3135__X Tile_X0Y7_FrameData_O[5] VPWR VGND sg13cmos5l_antennanp
XFILLER_673_225 VPWR VGND sg13cmos5l_decap_4
XFILLER_471_42 VPWR VGND sg13cmos5l_decap_8
XFILLER_88_160 VPWR VGND sg13cmos5l_decap_8
XFILLER_67_42 VPWR VGND sg13cmos5l_decap_8
XFILLER_190_21 VPWR VGND sg13cmos5l_decap_8
XFILLER_191_0 VPWR VGND sg13cmos5l_decap_8
XFILLER_425_203 VPWR VGND sg13cmos5l_fill_1
XFILLER_289_0 VPWR VGND sg13cmos5l_decap_8
XANTENNA__2974__X Tile_X0Y8_FrameData_O[14] VPWR VGND sg13cmos5l_antennanp
XFILLER_236_114 VPWR VGND sg13cmos5l_decap_8
XFILLER_621_56 VPWR VGND sg13cmos5l_decap_8
XFILLER_236_136 VPWR VGND sg13cmos5l_decap_8
XFILLER_641_133 VPWR VGND sg13cmos5l_decap_8
XFILLER_236_158 VPWR VGND sg13cmos5l_decap_8
XFILLER_123_70 VPWR VGND sg13cmos5l_decap_4
XFILLER_456_0 VPWR VGND sg13cmos5l_decap_8
XFILLER_251_117 VPWR VGND sg13cmos5l_fill_2
XFILLER_340_68 VPWR VGND sg13cmos5l_decap_8
XFILLER_440_228 VPWR VGND sg13cmos5l_fill_1
XFILLER_697_49 VPWR VGND sg13cmos5l_decap_8
XFILLER_244_191 VPWR VGND sg13cmos5l_decap_8
XFILLER_83_96 VPWR VGND sg13cmos5l_fill_2
XFILLER_199_63 VPWR VGND sg13cmos5l_decap_8
XFILLER_623_0 VPWR VGND sg13cmos5l_decap_8
X_0980_ _0980_/Q Tile_X0Y0_FrameData[23] VGND VPWR Tile_X0Y9_FrameStrobe[1] latch
XFILLER_80_7 VPWR VGND sg13cmos5l_decap_8
XFILLER_349_77 VPWR VGND sg13cmos5l_decap_8
XFILLER_646_42 VPWR VGND sg13cmos5l_decap_8
XFILLER_157_165 VPWR VGND sg13cmos5l_decap_8
X_2650_ _2650_/Q Tile_X0Y6_FrameData[13] VGND VPWR Tile_X0Y9_FrameStrobe[6] latch
XFILLER_157_176 VPWR VGND sg13cmos5l_fill_2
XFILLER_365_21 VPWR VGND sg13cmos5l_decap_8
X_1601_ _1601_/Q Tile_X0Y2_FrameData[16] VGND VPWR Tile_X0Y9_FrameStrobe[5] latch
XFILLER_562_195 VPWR VGND sg13cmos5l_decap_8
XFILLER_711_126 VPWR VGND sg13cmos5l_decap_8
X_2581_ _2581_/Q Tile_X0Y6_FrameData[18] VGND VPWR Tile_X0Y9_FrameStrobe[4] latch
X_4320_ _4320_/X Tile_X0Y0_W1END[0] Tile_X0Y0_WW4END[12] Tile_X0Y0_W6END[4] _3881_/X
+ _1117_/Q _1116_/Q VPWR VGND sg13cmos5l_mux4_1
X_1532_ _1532_/Q Tile_X0Y2_FrameData[21] VGND VPWR Tile_X0Y9_FrameStrobe[3] latch
XFILLER_314_151 VPWR VGND sg13cmos5l_decap_8
XFILLER_365_98 VPWR VGND sg13cmos5l_decap_8
XFILLER_515_35 VPWR VGND sg13cmos5l_decap_8
XFILLER_314_184 VPWR VGND sg13cmos5l_decap_4
X_4251_ _4251_/X Tile_X0Y5_W2MID[0] Tile_X0Y5_W2END[0] Tile_X0Y5_W6END[0] _4428_/X
+ _2417_/Q _2416_/Q VPWR VGND sg13cmos5l_mux4_1
XFILLER_662_63 VPWR VGND sg13cmos5l_decap_8
XFILLER_234_14 VPWR VGND sg13cmos5l_decap_8
X_1463_ _1463_/Q Tile_X0Y2_FrameData[26] VGND VPWR Tile_X0Y9_FrameStrobe[1] latch
XANTENNA__3045__X Tile_X0Y5_FrameData_O[4] VPWR VGND sg13cmos5l_antennanp
XFILLER_381_42 VPWR VGND sg13cmos5l_decap_8
X_3202_ Tile_X0Y0_N2BEG[2] _3786_/X VPWR VGND sg13cmos5l_buf_1
X_0414_ _0414_/Q Tile_X0Y7_FrameData[1] VGND VPWR Tile_X0Y9_FrameStrobe[7] latch
X_1394_ _1394_/Q Tile_X0Y1_FrameData[7] VGND VPWR Tile_X0Y9_FrameStrobe[6] latch
X_4182_ _4182_/X _0087_/X Tile_X0Y0_S4END[14] _4231_/X _4235_/X _1777_/Q _1776_/Q
+ VPWR VGND sg13cmos5l_mux4_1
XANTENNA__2884__X Tile_X0Y6_FrameData_O[5] VPWR VGND sg13cmos5l_antennanp
X_3133_ Tile_X0Y7_FrameData_O[3] Tile_X0Y7_FrameData[3] VPWR VGND sg13cmos5l_buf_1
XFILLER_416_203 VPWR VGND sg13cmos5l_decap_8
X_0345_ _0345_/Q Tile_X0Y7_FrameData[6] VGND VPWR Tile_X0Y9_FrameStrobe[5] latch
XFILLER_531_56 VPWR VGND sg13cmos5l_decap_8
X_0276_ _0276_/Q Tile_X0Y7_FrameData[11] VGND VPWR Tile_X0Y9_FrameStrobe[3] latch
X_3064_ Tile_X0Y5_FrameData_O[23] Tile_X0Y5_FrameData[23] VPWR VGND sg13cmos5l_buf_1
XFILLER_250_35 VPWR VGND sg13cmos5l_decap_8
X_2015_ _2015_/Q Tile_X0Y4_FrameData[6] VGND VPWR Tile_X0Y9_FrameStrobe[2] latch
XFILLER_50_211 VPWR VGND sg13cmos5l_decap_8
XFILLER_400_49 VPWR VGND sg13cmos5l_decap_8
XFILLER_396_132 VPWR VGND sg13cmos5l_decap_8
XFILLER_195_205 VPWR VGND sg13cmos5l_decap_8
X_3966_ _3966_/X _0095_/X Tile_X0Y0_S4END[6] _4017_/X _4002_/X _1277_/Q _1276_/Q VPWR
+ VGND sg13cmos5l_mux4_1
XFILLER_538_170 VPWR VGND sg13cmos5l_decap_8
XFILLER_337_210 VPWR VGND sg13cmos5l_decap_8
XFILLER_10_119 VPWR VGND sg13cmos5l_decap_8
X_2917_ Tile_X0Y8_E2BEG[1] _4729_/X VPWR VGND sg13cmos5l_buf_1
XFILLER_538_181 VPWR VGND sg13cmos5l_fill_2
XFILLER_409_14 VPWR VGND sg13cmos5l_decap_8
X_3897_ _3897_/X Tile_X0Y1_W2MID[3] Tile_X0Y1_W2END[3] Tile_X0Y1_W6END[3] _3994_/X
+ _1409_/Q _1408_/Q VPWR VGND sg13cmos5l_mux4_1
XFILLER_259_99 VPWR VGND sg13cmos5l_decap_8
XFILLER_148_154 VPWR VGND sg13cmos5l_decap_4
XFILLER_556_42 VPWR VGND sg13cmos5l_decap_8
X_2848_ Tile_X0Y6_E2BEGb[5] _4509_/X VPWR VGND sg13cmos5l_buf_1
XFILLER_275_21 VPWR VGND sg13cmos5l_decap_8
XFILLER_148_198 VPWR VGND sg13cmos5l_decap_8
XFILLER_553_184 VPWR VGND sg13cmos5l_decap_8
XFILLER_702_115 VPWR VGND sg13cmos5l_decap_4
XFILLER_553_195 VPWR VGND sg13cmos5l_fill_2
XFILLER_498_228 VPWR VGND sg13cmos5l_fill_1
X_2779_ Tile_X0Y3_EE4BEG[5] _4169_/X VPWR VGND sg13cmos5l_buf_1
XFILLER_163_168 VPWR VGND sg13cmos5l_decap_8
XFILLER_706_56 VPWR VGND sg13cmos5l_decap_8
X_4518_ _4518_/X Tile_X0Y6_WW4END[9] AXI_M_SOC_RDATA30 _4577_/X _4555_/X _2571_/Q
+ _2570_/Q VPWR VGND sg13cmos5l_mux4_1
XFILLER_275_98 VPWR VGND sg13cmos5l_decap_8
XFILLER_425_35 VPWR VGND sg13cmos5l_decap_8
XFILLER_208_70 VPWR VGND sg13cmos5l_decap_8
XFILLER_572_63 VPWR VGND sg13cmos5l_decap_8
X_4449_ _4449_/X Tile_X0Y9_W1END[3] Tile_X0Y9_WW4END[3] Tile_X0Y9_W6END[11] _4919_/X
+ _0894_/Q _0893_/Q VPWR VGND sg13cmos5l_mux4_1
XFILLER_655_203 VPWR VGND sg13cmos5l_decap_8
XFILLER_144_14 VPWR VGND sg13cmos5l_decap_8
XFILLER_291_42 VPWR VGND sg13cmos5l_decap_8
XFILLER_466_169 VPWR VGND sg13cmos5l_decap_8
XANTENNA__2794__X Tile_X0Y3_E6BEG[4] VPWR VGND sg13cmos5l_antennanp
XFILLER_282_7 VPWR VGND sg13cmos5l_decap_8
XFILLER_670_228 VPWR VGND sg13cmos5l_fill_1
XFILLER_407_225 VPWR VGND sg13cmos5l_decap_4
XFILLER_441_56 VPWR VGND sg13cmos5l_decap_8
XFILLER_37_45 VPWR VGND sg13cmos5l_decap_8
XFILLER_160_35 VPWR VGND sg13cmos5l_decap_8
XFILLER_623_177 VPWR VGND sg13cmos5l_fill_2
XFILLER_422_228 VPWR VGND sg13cmos5l_fill_1
XFILLER_233_128 VPWR VGND sg13cmos5l_decap_8
XFILLER_547_7 VPWR VGND sg13cmos5l_decap_8
XFILLER_310_49 VPWR VGND sg13cmos5l_decap_8
XFILLER_41_222 VPWR VGND sg13cmos5l_decap_8
XFILLER_714_7 VPWR VGND sg13cmos5l_decap_8
XFILLER_53_77 VPWR VGND sg13cmos5l_decap_8
XFILLER_529_170 VPWR VGND sg13cmos5l_decap_8
XFILLER_169_77 VPWR VGND sg13cmos5l_decap_8
XFILLER_319_14 VPWR VGND sg13cmos5l_decap_8
XFILLER_139_154 VPWR VGND sg13cmos5l_decap_8
XFILLER_466_42 VPWR VGND sg13cmos5l_decap_8
XFILLER_343_213 VPWR VGND sg13cmos5l_fill_2
XFILLER_185_21 VPWR VGND sg13cmos5l_decap_8
XFILLER_5_112 VPWR VGND sg13cmos5l_decap_8
XANTENNA__2969__X Tile_X0Y8_FrameData_O[9] VPWR VGND sg13cmos5l_antennanp
XFILLER_489_228 VPWR VGND sg13cmos5l_fill_1
XFILLER_204_0 VPWR VGND sg13cmos5l_decap_8
XFILLER_154_168 VPWR VGND sg13cmos5l_decap_8
XFILLER_616_56 VPWR VGND sg13cmos5l_decap_8
XFILLER_335_35 VPWR VGND sg13cmos5l_decap_8
XFILLER_500_210 VPWR VGND sg13cmos5l_decap_8
XFILLER_646_203 VPWR VGND sg13cmos5l_decap_8
XFILLER_482_63 VPWR VGND sg13cmos5l_decap_8
XFILLER_457_114 VPWR VGND sg13cmos5l_decap_8
XFILLER_78_63 VPWR VGND sg13cmos5l_decap_8
XFILLER_457_125 VPWR VGND sg13cmos5l_fill_2
XFILLER_110_205 VPWR VGND sg13cmos5l_fill_2
XFILLER_573_0 VPWR VGND sg13cmos5l_decap_8
XFILLER_632_77 VPWR VGND sg13cmos5l_decap_8
XFILLER_472_128 VPWR VGND sg13cmos5l_fill_1
XFILLER_204_28 VPWR VGND sg13cmos5l_decap_8
XFILLER_351_56 VPWR VGND sg13cmos5l_decap_8
XFILLER_134_91 VPWR VGND sg13cmos5l_decap_8
XFILLER_76_163 VPWR VGND sg13cmos5l_decap_8
X_0130_ AXI_M_SOC_AWSIZE0 _0939_/Q _3679_/X VPWR VGND sg13cmos5l_nor2b_1
XFILLER_209_147 VPWR VGND sg13cmos5l_decap_8
XFILLER_91_111 VPWR VGND sg13cmos5l_decap_8
XFILLER_94_84 VPWR VGND sg13cmos5l_decap_8
X_0061_ _3176_/A _3926_/X _3927_/X _1899_/Q VPWR VGND sg13cmos5l_mux2_1
XFILLER_480_172 VPWR VGND sg13cmos5l_decap_8
XFILLER_220_49 VPWR VGND sg13cmos5l_decap_8
X_3820_ _3820_/X Tile_X0Y0_WW4END[7] Tile_X0Y0_WW4END[15] _3863_/X _3852_/X _1065_/Q
+ _1064_/Q VPWR VGND sg13cmos5l_mux4_1
XFILLER_232_183 VPWR VGND sg13cmos5l_fill_2
XFILLER_378_198 VPWR VGND sg13cmos5l_decap_4
X_3751_ AXI_M_SOC_ARADDR23 Tile_X0Y8_WW4END[7] Tile_X0Y8_WW4END[15] Tile_X0Y8_W6END[7]
+ _4807_/X _0489_/Q _0488_/Q VPWR VGND sg13cmos5l_mux4_1
XFILLER_657_63 VPWR VGND sg13cmos5l_decap_8
X_0963_ _0963_/Q Tile_X0Y0_FrameData[8] VGND VPWR Tile_X0Y9_FrameStrobe[0] latch
XFILLER_229_14 VPWR VGND sg13cmos5l_decap_8
XFILLER_192_208 VPWR VGND sg13cmos5l_decap_8
X_2702_ _4201_/A3 VPWR VGND sg13cmos5l_tielo
XFILLER_376_42 VPWR VGND sg13cmos5l_decap_8
X_3682_ _3682_/X Tile_X0Y3_WW4END[0] Tile_X0Y3_WW4END[8] Tile_X0Y3_W6END[0] _4222_/X
+ _1757_/Q _1756_/Q VPWR VGND sg13cmos5l_mux4_1
XFILLER_334_202 VPWR VGND sg13cmos5l_decap_8
X_0894_ _0894_/Q Tile_X0Y9_FrameData[1] VGND VPWR Tile_X0Y9_FrameStrobe[6] latch
XANTENNA__2879__X Tile_X0Y6_FrameData_O[0] VPWR VGND sg13cmos5l_antennanp
X_2633_ _2633_/Q Tile_X0Y6_FrameData[30] VGND VPWR Tile_X0Y9_FrameStrobe[6] latch
XFILLER_376_97 VPWR VGND sg13cmos5l_decap_8
XFILLER_526_56 VPWR VGND sg13cmos5l_decap_8
XFILLER_99_200 VPWR VGND sg13cmos5l_fill_2
X_2564_ _2564_/Q Tile_X0Y6_FrameData[3] VGND VPWR Tile_X0Y9_FrameStrobe[3] latch
XFILLER_696_158 VPWR VGND sg13cmos5l_decap_4
XFILLER_673_84 VPWR VGND sg13cmos5l_decap_4
XFILLER_245_35 VPWR VGND sg13cmos5l_decap_8
X_4303_ _4303_/X _4305_/X Tile_X0Y4_W6END[1] _4304_/X _4303_/A3 _1931_/Q _1930_/Q
+ VPWR VGND sg13cmos5l_mux4_1
X_1515_ _1515_/Q Tile_X0Y2_FrameData[6] VGND VPWR Tile_X0Y9_FrameStrobe[2] latch
XFILLER_448_103 VPWR VGND sg13cmos5l_decap_8
X_2495_ _2495_/Q Tile_X0Y6_FrameData[8] VGND VPWR Tile_X0Y9_FrameStrobe[1] latch
X_4234_ _4234_/X _4195_/X _0089_/X _4194_/X Tile_X0Y0_S4END[12] _1705_/Q _1704_/Q
+ VPWR VGND sg13cmos5l_mux4_1
X_1446_ _1446_/Q Tile_X0Y2_FrameData[11] VGND VPWR Tile_X0Y9_FrameStrobe[0] latch
XFILLER_101_227 VPWR VGND sg13cmos5l_fill_2
XFILLER_542_77 VPWR VGND sg13cmos5l_decap_8
XFILLER_114_28 VPWR VGND sg13cmos5l_decap_8
X_4165_ _4165_/X Tile_X0Y3_WW4END[14] AXI_M_SOC_BVALID _4215_/X _4206_/X _1811_/Q
+ _1810_/Q VPWR VGND sg13cmos5l_mux4_1
XFILLER_652_228 VPWR VGND sg13cmos5l_fill_1
X_1377_ _1377_/Q Tile_X0Y1_FrameData[24] VGND VPWR Tile_X0Y9_FrameStrobe[6] latch
XFILLER_261_56 VPWR VGND sg13cmos5l_decap_8
XANTENNA__3503__X Tile_X0Y1_E2BEGb[1] VPWR VGND sg13cmos5l_antennanp
XFILLER_67_163 VPWR VGND sg13cmos5l_decap_8
X_3116_ Tile_X0Y7_EE4BEG[2] _4630_/X VPWR VGND sg13cmos5l_buf_1
X_0328_ _0328_/Q Tile_X0Y7_FrameData[23] VGND VPWR Tile_X0Y9_FrameStrobe[5] latch
X_4096_ _4096_/X _4035_/X _4143_/X _4142_/X _4034_/X _1435_/Q _1434_/Q VPWR VGND sg13cmos5l_mux4_1
XFILLER_605_155 VPWR VGND sg13cmos5l_decap_8
XFILLER_270_212 VPWR VGND sg13cmos5l_decap_8
X_3047_ Tile_X0Y5_FrameData_O[6] Tile_X0Y5_FrameData[6] VPWR VGND sg13cmos5l_buf_1
XFILLER_471_183 VPWR VGND sg13cmos5l_decap_8
X_0259_ _0259_/Q Tile_X0Y7_FrameData[28] VGND VPWR Tile_X0Y9_FrameStrobe[3] latch
XFILLER_698_70 VPWR VGND sg13cmos5l_decap_8
XFILLER_208_191 VPWR VGND sg13cmos5l_fill_1
XFILLER_620_147 VPWR VGND sg13cmos5l_decap_8
XFILLER_23_200 VPWR VGND sg13cmos5l_decap_4
XFILLER_130_49 VPWR VGND sg13cmos5l_decap_8
XFILLER_369_154 VPWR VGND sg13cmos5l_fill_1
XFILLER_369_176 VPWR VGND sg13cmos5l_decap_8
XFILLER_223_194 VPWR VGND sg13cmos5l_decap_8
XFILLER_384_113 VPWR VGND sg13cmos5l_decap_4
XFILLER_23_14 VPWR VGND sg13cmos5l_decap_8
XFILLER_573_224 VPWR VGND sg13cmos5l_decap_4
XFILLER_567_63 VPWR VGND sg13cmos5l_decap_8
X_3949_ _3949_/X Tile_X0Y1_WW4END[14] AXI_M_SOC_ARREADY _3999_/X _3990_/X _1311_/Q
+ _1310_/Q VPWR VGND sg13cmos5l_mux4_1
XFILLER_384_146 VPWR VGND sg13cmos5l_fill_1
XFILLER_139_14 VPWR VGND sg13cmos5l_decap_8
XFILLER_286_42 VPWR VGND sg13cmos5l_decap_8
XFILLER_183_219 VPWR VGND sg13cmos5l_decap_8
XFILLER_128_7 VPWR VGND sg13cmos5l_decap_8
XANTENNA__2789__X Tile_X0Y3_EE4BEG[15] VPWR VGND sg13cmos5l_antennanp
XFILLER_717_88 VPWR VGND sg13cmos5l_decap_8
XFILLER_136_168 VPWR VGND sg13cmos5l_decap_8
XFILLER_541_154 VPWR VGND sg13cmos5l_decap_8
XFILLER_436_56 VPWR VGND sg13cmos5l_decap_8
XFILLER_219_91 VPWR VGND sg13cmos5l_decap_8
XFILLER_340_205 VPWR VGND sg13cmos5l_decap_8
XFILLER_687_158 VPWR VGND sg13cmos5l_decap_8
XFILLER_583_84 VPWR VGND sg13cmos5l_decap_8
XFILLER_486_209 VPWR VGND sg13cmos5l_decap_4
XFILLER_155_35 VPWR VGND sg13cmos5l_decap_8
XFILLER_2_126 VPWR VGND sg13cmos5l_fill_1
XFILLER_151_138 VPWR VGND sg13cmos5l_decap_4
XFILLER_151_149 VPWR VGND sg13cmos5l_decap_4
XFILLER_497_7 VPWR VGND sg13cmos5l_decap_8
XFILLER_305_49 VPWR VGND sg13cmos5l_decap_8
XFILLER_454_106 VPWR VGND sg13cmos5l_fill_1
XFILLER_664_7 VPWR VGND sg13cmos5l_decap_8
XFILLER_602_14 VPWR VGND sg13cmos5l_decap_8
XFILLER_48_66 VPWR VGND sg13cmos5l_decap_8
XFILLER_643_228 VPWR VGND sg13cmos5l_fill_1
XFILLER_246_220 VPWR VGND sg13cmos5l_decap_8
XFILLER_58_152 VPWR VGND sg13cmos5l_decap_8
XFILLER_171_56 VPWR VGND sg13cmos5l_decap_8
XANTENNA__3413__X Tile_X0Y4_FrameData_O[4] VPWR VGND sg13cmos5l_antennanp
XFILLER_447_191 VPWR VGND sg13cmos5l_decap_8
XFILLER_58_196 VPWR VGND sg13cmos5l_fill_1
XFILLER_462_161 VPWR VGND sg13cmos5l_decap_8
XFILLER_64_21 VPWR VGND sg13cmos5l_decap_8
XFILLER_73_155 VPWR VGND sg13cmos5l_decap_8
XFILLER_549_221 VPWR VGND sg13cmos5l_fill_1
XFILLER_401_70 VPWR VGND sg13cmos5l_decap_4
XFILLER_214_161 VPWR VGND sg13cmos5l_decap_8
XFILLER_154_0 VPWR VGND sg13cmos5l_decap_8
XFILLER_564_202 VPWR VGND sg13cmos5l_decap_4
XFILLER_9_49 VPWR VGND sg13cmos5l_decap_8
XFILLER_80_42 VPWR VGND sg13cmos5l_decap_8
XFILLER_694_28 VPWR VGND sg13cmos5l_decap_8
XFILLER_477_63 VPWR VGND sg13cmos5l_decap_8
XFILLER_321_0 VPWR VGND sg13cmos5l_decap_8
XFILLER_419_0 VPWR VGND sg13cmos5l_decap_8
XFILLER_517_151 VPWR VGND sg13cmos5l_fill_2
XFILLER_127_113 VPWR VGND sg13cmos5l_decap_8
XFILLER_196_75 VPWR VGND sg13cmos5l_decap_8
XFILLER_390_149 VPWR VGND sg13cmos5l_decap_8
XFILLER_627_77 VPWR VGND sg13cmos5l_decap_8
XFILLER_13_91 VPWR VGND sg13cmos5l_decap_8
XFILLER_127_146 VPWR VGND sg13cmos5l_fill_2
XFILLER_346_56 VPWR VGND sg13cmos5l_decap_8
XFILLER_142_105 VPWR VGND sg13cmos5l_decap_8
XFILLER_493_84 VPWR VGND sg13cmos5l_decap_8
XFILLER_690_0 VPWR VGND sg13cmos5l_decap_8
XFILLER_643_21 VPWR VGND sg13cmos5l_decap_8
XFILLER_43_7 VPWR VGND sg13cmos5l_decap_8
X_1300_ _1300_/Q Tile_X0Y1_FrameData[5] VGND VPWR Tile_X0Y9_FrameStrobe[3] latch
XFILLER_96_225 VPWR VGND sg13cmos5l_decap_4
X_2280_ _2280_/Q Tile_X0Y5_FrameData[29] VGND VPWR Tile_X0Y9_FrameStrobe[3] latch
XFILLER_643_98 VPWR VGND sg13cmos5l_decap_8
XFILLER_215_49 VPWR VGND sg13cmos5l_decap_8
XFILLER_362_77 VPWR VGND sg13cmos5l_decap_8
X_1231_ _1231_/Q Tile_X0Y1_FrameData[10] VGND VPWR Tile_X0Y9_FrameStrobe[1] latch
XFILLER_1_192 VPWR VGND sg13cmos5l_fill_1
XFILLER_634_228 VPWR VGND sg13cmos5l_fill_1
XFILLER_512_14 VPWR VGND sg13cmos5l_decap_8
XANTENNA__3323__X Tile_X0Y4_EE4BEG[11] VPWR VGND sg13cmos5l_antennanp
X_1162_ _1162_/Q Tile_X0Y0_FrameData[1] VGND VPWR Tile_X0Y9_FrameStrobe[6] latch
X_0113_ _3185_/A _3908_/X _3909_/X _1396_/Q VPWR VGND sg13cmos5l_mux2_1
X_1093_ _1093_/Q Tile_X0Y0_FrameData[6] VGND VPWR Tile_X0Y9_FrameStrobe[4] latch
XFILLER_602_114 VPWR VGND sg13cmos5l_fill_2
XFILLER_599_187 VPWR VGND sg13cmos5l_fill_2
X_0044_ _3633_/A _4722_/X _4723_/X _0600_/Q VPWR VGND sg13cmos5l_mux2_1
X_4921_ _4921_/X Tile_X0Y9_N1END[1] Tile_X0Y9_N4END[1] _4897_/X _0082_/X _0717_/Q
+ _0716_/Q VPWR VGND sg13cmos5l_mux4_1
XFILLER_64_199 VPWR VGND sg13cmos5l_decap_8
XFILLER_311_70 VPWR VGND sg13cmos5l_decap_8
XFILLER_205_161 VPWR VGND sg13cmos5l_decap_8
XFILLER_205_172 VPWR VGND sg13cmos5l_fill_1
X_4852_ _4852_/X Tile_X0Y9_W2MID[3] AXI_M_SOC_RDATA4 _4907_/X _4906_/X _0839_/Q _0838_/Q
+ VPWR VGND sg13cmos5l_mux4_1
XFILLER_205_194 VPWR VGND sg13cmos5l_decap_8
XFILLER_668_84 VPWR VGND sg13cmos5l_decap_8
X_3803_ _3803_/X _3851_/X Tile_X0Y0_WW4END[4] Tile_X0Y0_WW4END[5] Tile_X0Y0_S1END[3]
+ _1099_/Q _1098_/Q VPWR VGND sg13cmos5l_mux4_1
XFILLER_387_63 VPWR VGND sg13cmos5l_decap_8
X_4783_ _4783_/X Tile_X0Y9_W1END[3] Tile_X0Y9_W6END[7] _4931_/X _4895_/X _0921_/Q
+ _0920_/Q VPWR VGND sg13cmos5l_mux4_1
X_1995_ _1995_/Q Tile_X0Y4_FrameData[26] VGND VPWR Tile_X0Y9_FrameStrobe[2] latch
XFILLER_508_140 VPWR VGND sg13cmos5l_decap_8
X_3734_ AXI_M_SOC_ARADDR6 Tile_X0Y9_WW4END[6] Tile_X0Y9_WW4END[14] Tile_X0Y9_W6END[6]
+ _4922_/X _0747_/Q _0746_/Q VPWR VGND sg13cmos5l_mux4_1
X_0946_ _0946_/Q Tile_X0Y0_FrameData[25] VGND VPWR Tile_X0Y9_FrameStrobe[0] latch
XFILLER_307_202 VPWR VGND sg13cmos5l_decap_8
XFILLER_118_113 VPWR VGND sg13cmos5l_fill_1
XFILLER_118_135 VPWR VGND sg13cmos5l_decap_8
XFILLER_712_210 VPWR VGND sg13cmos5l_decap_8
XFILLER_537_77 VPWR VGND sg13cmos5l_decap_8
XFILLER_523_121 VPWR VGND sg13cmos5l_fill_2
X_3665_ AXI_M_SOC_AWADDR26 Tile_X0Y4_WW4END[2] Tile_X0Y4_WW4END[10] Tile_X0Y4_W6END[10]
+ _4346_/X _1993_/Q _1992_/Q VPWR VGND sg13cmos5l_mux4_1
XFILLER_109_28 VPWR VGND sg13cmos5l_decap_8
X_0877_ _0877_/Q Tile_X0Y9_FrameData[18] VGND VPWR Tile_X0Y9_FrameStrobe[6] latch
XFILLER_256_56 VPWR VGND sg13cmos5l_decap_8
XFILLER_523_154 VPWR VGND sg13cmos5l_fill_1
XFILLER_322_205 VPWR VGND sg13cmos5l_fill_2
XFILLER_133_105 VPWR VGND sg13cmos5l_decap_8
X_2616_ _2616_/Q Tile_X0Y6_FrameData[15] VGND VPWR Tile_X0Y9_FrameStrobe[5] latch
X_3596_ Tile_X0Y9_FrameData_O[26] Tile_X0Y9_FrameData[26] VPWR VGND sg13cmos5l_buf_1
XFILLER_322_227 VPWR VGND sg13cmos5l_fill_2
XFILLER_553_21 VPWR VGND sg13cmos5l_decap_8
XFILLER_523_187 VPWR VGND sg13cmos5l_fill_1
X_2547_ _2547_/Q Tile_X0Y6_FrameData[20] VGND VPWR Tile_X0Y9_FrameStrobe[3] latch
XFILLER_476_220 VPWR VGND sg13cmos5l_decap_8
XFILLER_87_214 VPWR VGND sg13cmos5l_fill_1
XFILLER_553_98 VPWR VGND sg13cmos5l_decap_8
X_2478_ _2478_/Q Tile_X0Y6_FrameData[25] VGND VPWR Tile_X0Y9_FrameStrobe[1] latch
XFILLER_141_182 VPWR VGND sg13cmos5l_decap_8
XFILLER_125_49 VPWR VGND sg13cmos5l_decap_8
XFILLER_703_35 VPWR VGND sg13cmos5l_decap_8
X_4217_ _4217_/X _4689_/X _4693_/X _4697_/X _4671_/X _0388_/Q _0387_/Q VPWR VGND sg13cmos5l_mux4_1
XFILLER_491_212 VPWR VGND sg13cmos5l_fill_2
XFILLER_272_77 VPWR VGND sg13cmos5l_decap_8
X_1429_ _1429_/Q Tile_X0Y2_FrameData[28] VGND VPWR Tile_X0Y9_FrameStrobe[0] latch
XFILLER_625_228 VPWR VGND sg13cmos5l_fill_1
XFILLER_422_14 VPWR VGND sg13cmos5l_decap_8
XANTENNA__3233__X Tile_X0Y0_FrameData_O[1] VPWR VGND sg13cmos5l_antennanp
XFILLER_18_14 VPWR VGND sg13cmos5l_decap_8
XFILLER_55_100 VPWR VGND sg13cmos5l_fill_1
X_4148_ _4148_/X Tile_X0Y3_W2MID[7] AXI_M_SOC_WREADY _4205_/X _4204_/X _1845_/Q _1844_/Q
+ VPWR VGND sg13cmos5l_mux4_1
XFILLER_55_111 VPWR VGND sg13cmos5l_decap_8
X_4079_ _4079_/X AXI_M_SOC_AWREADY _4120_/X _4124_/X _4103_/X _1515_/Q _1514_/Q VPWR
+ VGND sg13cmos5l_mux4_1
XFILLER_502_91 VPWR VGND sg13cmos5l_decap_8
XFILLER_55_188 VPWR VGND sg13cmos5l_decap_8
XFILLER_55_199 VPWR VGND sg13cmos5l_fill_2
XFILLER_221_70 VPWR VGND sg13cmos5l_decap_8
XFILLER_70_147 VPWR VGND sg13cmos5l_decap_8
XFILLER_34_24 VPWR VGND sg13cmos5l_decap_8
XFILLER_34_57 VPWR VGND sg13cmos5l_decap_8
XFILLER_245_7 VPWR VGND sg13cmos5l_decap_8
XFILLER_578_84 VPWR VGND sg13cmos5l_decap_8
XFILLER_546_202 VPWR VGND sg13cmos5l_decap_8
XFILLER_400_220 VPWR VGND sg13cmos5l_decap_8
XFILLER_546_224 VPWR VGND sg13cmos5l_decap_4
XFILLER_211_142 VPWR VGND sg13cmos5l_decap_8
XFILLER_297_63 VPWR VGND sg13cmos5l_decap_8
XFILLER_357_168 VPWR VGND sg13cmos5l_decap_8
XFILLER_412_7 VPWR VGND sg13cmos5l_fill_2
XFILLER_372_105 VPWR VGND sg13cmos5l_decap_8
XFILLER_447_77 VPWR VGND sg13cmos5l_decap_8
XFILLER_50_78 VPWR VGND sg13cmos5l_decap_8
XFILLER_447_99 VPWR VGND sg13cmos5l_fill_2
XANTENNA__3408__X Tile_X0Y2_E1BEG[3] VPWR VGND sg13cmos5l_antennanp
XFILLER_166_56 VPWR VGND sg13cmos5l_decap_8
XFILLER_463_21 VPWR VGND sg13cmos5l_decap_8
XFILLER_514_198 VPWR VGND sg13cmos5l_decap_8
XFILLER_59_76 VPWR VGND sg13cmos5l_decap_8
XFILLER_613_35 VPWR VGND sg13cmos5l_decap_8
XFILLER_482_212 VPWR VGND sg13cmos5l_decap_8
XFILLER_293_112 VPWR VGND sg13cmos5l_decap_8
XFILLER_616_228 VPWR VGND sg13cmos5l_fill_1
XFILLER_332_14 VPWR VGND sg13cmos5l_decap_8
XANTENNA__3143__X Tile_X0Y7_FrameData_O[13] VPWR VGND sg13cmos5l_antennanp
XFILLER_93_228 VPWR VGND sg13cmos5l_fill_1
XFILLER_75_42 VPWR VGND sg13cmos5l_decap_8
XFILLER_115_93 VPWR VGND sg13cmos5l_decap_4
XFILLER_689_39 VPWR VGND sg13cmos5l_decap_8
XFILLER_435_161 VPWR VGND sg13cmos5l_decap_8
XFILLER_271_0 VPWR VGND sg13cmos5l_decap_8
XFILLER_46_144 VPWR VGND sg13cmos5l_decap_8
XANTENNA__2982__X Tile_X0Y8_FrameData_O[22] VPWR VGND sg13cmos5l_antennanp
XFILLER_369_0 VPWR VGND sg13cmos5l_decap_8
XFILLER_648_2 VPWR VGND sg13cmos5l_fill_1
XFILLER_596_135 VPWR VGND sg13cmos5l_fill_1
XFILLER_450_142 VPWR VGND sg13cmos5l_decap_8
XFILLER_131_70 VPWR VGND sg13cmos5l_decap_8
XFILLER_596_157 VPWR VGND sg13cmos5l_decap_4
XFILLER_536_0 VPWR VGND sg13cmos5l_decap_8
XFILLER_91_63 VPWR VGND sg13cmos5l_decap_8
XFILLER_488_84 VPWR VGND sg13cmos5l_decap_8
XFILLER_638_21 VPWR VGND sg13cmos5l_decap_8
XFILLER_703_0 VPWR VGND sg13cmos5l_decap_8
X_0800_ _0800_/Q Tile_X0Y9_FrameData[31] VGND VPWR Tile_X0Y9_FrameStrobe[4] latch
XFILLER_363_105 VPWR VGND sg13cmos5l_decap_8
X_1780_ _1780_/Q Tile_X0Y3_FrameData[21] VGND VPWR Tile_X0Y9_FrameStrobe[3] latch
XFILLER_638_98 VPWR VGND sg13cmos5l_decap_8
XFILLER_552_227 VPWR VGND sg13cmos5l_fill_2
X_0731_ _0731_/Q Tile_X0Y9_FrameData[4] VGND VPWR Tile_X0Y9_FrameStrobe[1] latch
XFILLER_357_77 VPWR VGND sg13cmos5l_decap_8
XFILLER_507_14 VPWR VGND sg13cmos5l_decap_8
XANTENNA__3318__X Tile_X0Y4_EE4BEG[6] VPWR VGND sg13cmos5l_antennanp
XFILLER_654_42 VPWR VGND sg13cmos5l_decap_8
XFILLER_505_154 VPWR VGND sg13cmos5l_decap_8
XFILLER_115_105 VPWR VGND sg13cmos5l_decap_8
X_3450_ Tile_X0Y1_FrameData_O[8] Tile_X0Y1_FrameData[8] VPWR VGND sg13cmos5l_buf_1
X_0662_ _0662_/Q Tile_X0Y8_FrameData[9] VGND VPWR Tile_X0Y9_FrameStrobe[7] latch
XFILLER_373_21 VPWR VGND sg13cmos5l_decap_8
XFILLER_371_182 VPWR VGND sg13cmos5l_decap_8
XFILLER_304_227 VPWR VGND sg13cmos5l_fill_2
X_2401_ _2401_/Q Tile_X0Y5_FrameData[4] VGND VPWR Tile_X0Y9_FrameStrobe[6] latch
X_3381_ Tile_X0Y2_E6BEG[4] _4076_/X VPWR VGND sg13cmos5l_buf_1
X_0593_ _0593_/Q Tile_X0Y8_FrameData[14] VGND VPWR Tile_X0Y9_FrameStrobe[5] latch
XFILLER_69_203 VPWR VGND sg13cmos5l_decap_8
XFILLER_130_119 VPWR VGND sg13cmos5l_decap_8
XFILLER_269_142 VPWR VGND sg13cmos5l_fill_2
X_2332_ _2332_/Q Tile_X0Y5_FrameData[9] VGND VPWR Tile_X0Y9_FrameStrobe[4] latch
XFILLER_373_98 VPWR VGND sg13cmos5l_decap_8
XFILLER_523_35 VPWR VGND sg13cmos5l_decap_8
XFILLER_674_150 VPWR VGND sg13cmos5l_decap_4
XFILLER_306_70 VPWR VGND sg13cmos5l_decap_8
XFILLER_284_112 VPWR VGND sg13cmos5l_decap_8
XFILLER_670_63 VPWR VGND sg13cmos5l_decap_8
X_2263_ _2263_/Q Tile_X0Y5_FrameData[14] VGND VPWR Tile_X0Y9_FrameStrobe[2] latch
XFILLER_242_14 VPWR VGND sg13cmos5l_decap_8
XANTENNA__3053__X Tile_X0Y5_FrameData_O[12] VPWR VGND sg13cmos5l_antennanp
X_4002_ _4002_/X _3983_/X _0096_/X _3982_/X Tile_X0Y0_S4END[5] _1207_/Q _1206_/Q VPWR
+ VGND sg13cmos5l_mux4_1
X_1214_ _1214_/Q Tile_X0Y1_FrameData[27] VGND VPWR Tile_X0Y9_FrameStrobe[1] latch
XFILLER_599_28 VPWR VGND sg13cmos5l_decap_8
X_2194_ _2194_/Q Tile_X0Y5_FrameData[19] VGND VPWR Tile_X0Y9_FrameStrobe[0] latch
XFILLER_37_122 VPWR VGND sg13cmos5l_fill_2
XFILLER_284_189 VPWR VGND sg13cmos5l_decap_8
XFILLER_426_161 VPWR VGND sg13cmos5l_decap_8
XANTENNA__2892__X Tile_X0Y6_FrameData_O[13] VPWR VGND sg13cmos5l_antennanp
X_1145_ _1145_/Q Tile_X0Y0_FrameData[18] VGND VPWR Tile_X0Y9_FrameStrobe[6] latch
XFILLER_52_125 VPWR VGND sg13cmos5l_decap_8
X_1076_ _1076_/Q Tile_X0Y0_FrameData[23] VGND VPWR Tile_X0Y9_FrameStrobe[4] latch
XFILLER_441_186 VPWR VGND sg13cmos5l_fill_1
X_4904_ _4904_/X Tile_X0Y9_N2MID[5] Tile_X0Y9_N2END[5] _4937_/X _4821_/X _0685_/Q
+ _0684_/Q VPWR VGND sg13cmos5l_mux4_1
XFILLER_52_169 VPWR VGND sg13cmos5l_fill_2
XFILLER_548_21 VPWR VGND sg13cmos5l_decap_8
XFILLER_339_124 VPWR VGND sg13cmos5l_decap_8
XFILLER_339_135 VPWR VGND sg13cmos5l_fill_1
X_4835_ _4835_/X Tile_X0Y9_W1END[3] Tile_X0Y9_W2MID[0] Tile_X0Y9_W2END[0] _4900_/X
+ _0869_/Q _0868_/Q VPWR VGND sg13cmos5l_mux4_1
XFILLER_354_105 VPWR VGND sg13cmos5l_decap_8
X_4766_ _4766_/X AXI_M_SOC_RDATA10 _4805_/X _4809_/X _4789_/X _0515_/Q _0514_/Q VPWR
+ VGND sg13cmos5l_mux4_1
X_1978_ _1978_/Q Tile_X0Y4_FrameData[11] VGND VPWR Tile_X0Y9_FrameStrobe[1] latch
XFILLER_543_227 VPWR VGND sg13cmos5l_fill_2
X_3717_ AXI_M_SOC_WDATA27 Tile_X0Y6_WW4END[3] Tile_X0Y6_WW4END[11] Tile_X0Y6_W6END[11]
+ _4579_/X _2505_/Q _2504_/Q VPWR VGND sg13cmos5l_mux4_1
XFILLER_267_77 VPWR VGND sg13cmos5l_decap_8
X_0929_ _0929_/Q Tile_X0Y9_FrameData[20] VGND VPWR Tile_X0Y9_FrameStrobe[8] latch
XFILLER_417_14 VPWR VGND sg13cmos5l_decap_8
X_4697_ _4697_/X _4663_/X Tile_X0Y9_N4END[9] _4662_/X _0055_/X _0189_/Q _0188_/Q VPWR
+ VGND sg13cmos5l_mux4_1
XANTENNA__3228__X Tile_X0Y0_FrameStrobe_O[16] VPWR VGND sg13cmos5l_antennanp
XFILLER_564_42 VPWR VGND sg13cmos5l_decap_8
XFILLER_161_200 VPWR VGND sg13cmos5l_fill_2
X_3648_ AXI_M_SOC_AWADDR9 Tile_X0Y5_WW4END[1] Tile_X0Y5_WW4END[9] Tile_X0Y5_W6END[9]
+ _4460_/X _2253_/Q _2252_/Q VPWR VGND sg13cmos5l_mux4_1
XFILLER_283_21 VPWR VGND sg13cmos5l_decap_8
XFILLER_106_138 VPWR VGND sg13cmos5l_decap_8
X_3579_ Tile_X0Y9_FrameData_O[9] Tile_X0Y9_FrameData[9] VPWR VGND sg13cmos5l_buf_1
XFILLER_283_98 VPWR VGND sg13cmos5l_decap_8
XFILLER_714_78 VPWR VGND sg13cmos5l_decap_8
XFILLER_433_35 VPWR VGND sg13cmos5l_decap_8
XFILLER_216_70 VPWR VGND sg13cmos5l_decap_8
XFILLER_275_112 VPWR VGND sg13cmos5l_decap_8
XFILLER_580_63 VPWR VGND sg13cmos5l_decap_8
XFILLER_29_35 VPWR VGND sg13cmos5l_decap_8
XFILLER_152_14 VPWR VGND sg13cmos5l_decap_8
XFILLER_195_7 VPWR VGND sg13cmos5l_decap_8
XFILLER_75_228 VPWR VGND sg13cmos5l_fill_1
XFILLER_28_100 VPWR VGND sg13cmos5l_fill_1
XFILLER_275_178 VPWR VGND sg13cmos5l_decap_8
XFILLER_417_150 VPWR VGND sg13cmos5l_decap_8
XFILLER_290_126 VPWR VGND sg13cmos5l_decap_8
XFILLER_362_7 VPWR VGND sg13cmos5l_decap_8
XFILLER_302_28 VPWR VGND sg13cmos5l_decap_8
XFILLER_45_45 VPWR VGND sg13cmos5l_decap_8
XFILLER_231_215 VPWR VGND sg13cmos5l_decap_4
XFILLER_43_147 VPWR VGND sg13cmos5l_decap_4
XFILLER_432_175 VPWR VGND sg13cmos5l_decap_8
XFILLER_231_226 VPWR VGND sg13cmos5l_fill_2
XFILLER_578_168 VPWR VGND sg13cmos5l_decap_8
XFILLER_627_7 VPWR VGND sg13cmos5l_decap_8
XFILLER_458_21 VPWR VGND sg13cmos5l_decap_8
XFILLER_61_55 VPWR VGND sg13cmos5l_decap_8
XFILLER_534_205 VPWR VGND sg13cmos5l_decap_8
XFILLER_345_105 VPWR VGND sg13cmos5l_decap_8
XFILLER_608_35 VPWR VGND sg13cmos5l_decap_8
XFILLER_177_77 VPWR VGND sg13cmos5l_fill_1
XFILLER_6_28 VPWR VGND sg13cmos5l_decap_8
XFILLER_327_14 VPWR VGND sg13cmos5l_decap_8
XANTENNA__3138__X Tile_X0Y7_FrameData_O[8] VPWR VGND sg13cmos5l_antennanp
XFILLER_177_99 VPWR VGND sg13cmos5l_decap_8
XFILLER_474_42 VPWR VGND sg13cmos5l_decap_8
XFILLER_117_0 VPWR VGND sg13cmos5l_decap_8
XFILLER_353_182 VPWR VGND sg13cmos5l_decap_8
XFILLER_193_21 VPWR VGND sg13cmos5l_decap_8
XFILLER_499_175 VPWR VGND sg13cmos5l_decap_8
XFILLER_298_226 VPWR VGND sg13cmos5l_fill_2
XANTENNA__2977__X Tile_X0Y8_FrameData_O[17] VPWR VGND sg13cmos5l_antennanp
XFILLER_624_56 VPWR VGND sg13cmos5l_decap_8
XFILLER_502_168 VPWR VGND sg13cmos5l_decap_8
XFILLER_10_70 VPWR VGND sg13cmos5l_decap_8
XFILLER_193_98 VPWR VGND sg13cmos5l_decap_8
XFILLER_343_35 VPWR VGND sg13cmos5l_decap_8
XFILLER_126_70 VPWR VGND sg13cmos5l_decap_8
XFILLER_105_193 VPWR VGND sg13cmos5l_decap_8
XFILLER_486_0 VPWR VGND sg13cmos5l_decap_8
XFILLER_490_63 VPWR VGND sg13cmos5l_decap_8
XFILLER_66_228 VPWR VGND sg13cmos5l_fill_1
XFILLER_415_109 VPWR VGND sg13cmos5l_fill_2
XFILLER_653_0 VPWR VGND sg13cmos5l_decap_8
XFILLER_281_126 VPWR VGND sg13cmos5l_decap_8
XFILLER_640_77 VPWR VGND sg13cmos5l_decap_8
XFILLER_212_28 VPWR VGND sg13cmos5l_decap_8
XFILLER_142_91 VPWR VGND sg13cmos5l_decap_8
XANTENNA__3601__X Tile_X0Y9_FrameData_O[31] VPWR VGND sg13cmos5l_antennanp
XFILLER_569_168 VPWR VGND sg13cmos5l_decap_8
XFILLER_179_119 VPWR VGND sg13cmos5l_decap_8
XFILLER_649_42 VPWR VGND sg13cmos5l_decap_8
XFILLER_584_105 VPWR VGND sg13cmos5l_decap_8
X_2950_ Tile_X0Y8_EE4BEG[6] _4750_/X VPWR VGND sg13cmos5l_buf_1
XFILLER_584_116 VPWR VGND sg13cmos5l_fill_2
XFILLER_368_21 VPWR VGND sg13cmos5l_decap_8
X_1901_ _1901_/Q Tile_X0Y3_FrameData[28] VGND VPWR Tile_X0Y9_FrameStrobe[7] latch
XFILLER_577_190 VPWR VGND sg13cmos5l_fill_2
X_2881_ Tile_X0Y6_FrameData_O[2] Tile_X0Y6_FrameData[2] VPWR VGND sg13cmos5l_buf_1
X_4620_ _4620_/X Tile_X0Y7_W2END[7] AXI_M_SOC_RDATA23 _4669_/X _4668_/X _0319_/Q _0318_/Q
+ VPWR VGND sg13cmos5l_mux4_1
X_1832_ _1832_/Q Tile_X0Y3_FrameData[1] VGND VPWR Tile_X0Y9_FrameStrobe[4] latch
XFILLER_368_98 VPWR VGND sg13cmos5l_decap_8
XFILLER_518_35 VPWR VGND sg13cmos5l_decap_8
X_4551_ _4551_/X Tile_X0Y7_W1END[3] Tile_X0Y7_W6END[7] _4699_/X _4659_/X _0409_/Q
+ _0408_/Q VPWR VGND sg13cmos5l_mux4_1
XFILLER_665_63 VPWR VGND sg13cmos5l_decap_8
X_1763_ _1763_/Q Tile_X0Y3_FrameData[6] VGND VPWR Tile_X0Y9_FrameStrobe[2] latch
XFILLER_237_14 VPWR VGND sg13cmos5l_decap_8
XANTENNA__3048__X Tile_X0Y5_FrameData_O[7] VPWR VGND sg13cmos5l_antennanp
X_3502_ Tile_X0Y1_E2BEGb[0] _3940_/X VPWR VGND sg13cmos5l_buf_1
XFILLER_540_219 VPWR VGND sg13cmos5l_decap_8
XFILLER_384_42 VPWR VGND sg13cmos5l_decap_8
XFILLER_351_119 VPWR VGND sg13cmos5l_decap_8
X_0714_ _0714_/Q Tile_X0Y9_FrameData[21] VGND VPWR Tile_X0Y9_FrameStrobe[1] latch
X_4482_ _4482_/X Tile_X0Y4_W1END[3] Tile_X0Y4_W2MID[0] Tile_X0Y4_W2END[0] _4312_/X
+ _2123_/Q _2122_/Q VPWR VGND sg13cmos5l_mux4_1
X_1694_ _1694_/Q Tile_X0Y3_FrameData[11] VGND VPWR Tile_X0Y9_FrameStrobe[0] latch
XFILLER_289_215 VPWR VGND sg13cmos5l_fill_2
XANTENNA__2887__X Tile_X0Y6_FrameData_O[8] VPWR VGND sg13cmos5l_antennanp
X_3433_ Tile_X0Y4_FrameData_O[24] Tile_X0Y4_FrameData[24] VPWR VGND sg13cmos5l_buf_1
X_0645_ _0645_/Q Tile_X0Y8_FrameData[26] VGND VPWR Tile_X0Y9_FrameStrobe[7] latch
XFILLER_534_56 VPWR VGND sg13cmos5l_decap_8
XFILLER_317_91 VPWR VGND sg13cmos5l_fill_2
X_3364_ Tile_X0Y2_EE4BEG[3] _4059_/X VPWR VGND sg13cmos5l_buf_1
X_0576_ _0576_/Q Tile_X0Y8_FrameData[31] VGND VPWR Tile_X0Y9_FrameStrobe[5] latch
XFILLER_681_84 VPWR VGND sg13cmos5l_decap_8
XFILLER_32_0 VPWR VGND sg13cmos5l_fill_1
XFILLER_253_35 VPWR VGND sg13cmos5l_decap_8
XFILLER_647_161 VPWR VGND sg13cmos5l_decap_8
X_2315_ _2315_/Q Tile_X0Y5_FrameData[26] VGND VPWR Tile_X0Y9_FrameStrobe[4] latch
X_3295_ Tile_X0Y0_E2BEGb[3] _3815_/X VPWR VGND sg13cmos5l_buf_1
XFILLER_57_228 VPWR VGND sg13cmos5l_fill_1
X_2246_ _2246_/Q Tile_X0Y5_FrameData[31] VGND VPWR Tile_X0Y9_FrameStrobe[2] latch
XFILLER_403_49 VPWR VGND sg13cmos5l_decap_8
XFILLER_257_189 VPWR VGND sg13cmos5l_decap_4
XFILLER_662_164 VPWR VGND sg13cmos5l_decap_4
XFILLER_461_226 VPWR VGND sg13cmos5l_fill_2
XFILLER_550_77 VPWR VGND sg13cmos5l_decap_8
XFILLER_700_14 VPWR VGND sg13cmos5l_decap_4
XFILLER_122_28 VPWR VGND sg13cmos5l_decap_8
X_2177_ _2177_/Q Tile_X0Y4_FrameData[4] VGND VPWR Tile_X0Y9_FrameStrobe[7] latch
XANTENNA__3511__X Tile_X0Y1_E2BEG[1] VPWR VGND sg13cmos5l_antennanp
XFILLER_414_142 VPWR VGND sg13cmos5l_fill_1
X_1128_ _1128_/Q Tile_X0Y0_FrameData[3] VGND VPWR Tile_X0Y9_FrameStrobe[5] latch
XFILLER_700_58 VPWR VGND sg13cmos5l_decap_8
XFILLER_213_215 VPWR VGND sg13cmos5l_decap_8
XFILLER_559_42 VPWR VGND sg13cmos5l_decap_8
XFILLER_575_105 VPWR VGND sg13cmos5l_decap_8
X_1059_ _1059_/Q Tile_X0Y0_FrameData[8] VGND VPWR Tile_X0Y9_FrameStrobe[3] latch
XFILLER_278_21 VPWR VGND sg13cmos5l_decap_8
XFILLER_178_152 VPWR VGND sg13cmos5l_fill_2
XFILLER_709_56 VPWR VGND sg13cmos5l_decap_8
XFILLER_583_160 VPWR VGND sg13cmos5l_decap_8
XFILLER_327_116 VPWR VGND sg13cmos5l_decap_8
X_4818_ _4818_/X Tile_X0Y7_W2MID[5] Tile_X0Y7_W2END[5] Tile_X0Y7_W6END[10] _4673_/X
+ _0367_/Q _0366_/Q VPWR VGND sg13cmos5l_mux4_1
XFILLER_278_98 VPWR VGND sg13cmos5l_decap_8
XFILLER_178_196 VPWR VGND sg13cmos5l_decap_8
XFILLER_428_35 VPWR VGND sg13cmos5l_decap_8
XFILLER_575_63 VPWR VGND sg13cmos5l_decap_8
XFILLER_147_14 VPWR VGND sg13cmos5l_decap_8
X_4749_ _4749_/X Tile_X0Y8_WW4END[10] AXI_M_SOC_RDATA13 _4810_/X _4789_/X _0549_/Q
+ _0548_/Q VPWR VGND sg13cmos5l_mux4_1
XFILLER_294_42 VPWR VGND sg13cmos5l_decap_8
XFILLER_134_200 VPWR VGND sg13cmos5l_decap_8
XFILLER_531_219 VPWR VGND sg13cmos5l_decap_8
XFILLER_134_211 VPWR VGND sg13cmos5l_fill_2
XFILLER_110_7 VPWR VGND sg13cmos5l_decap_8
XFILLER_208_7 VPWR VGND sg13cmos5l_decap_8
XFILLER_685_201 VPWR VGND sg13cmos5l_decap_8
XFILLER_496_112 VPWR VGND sg13cmos5l_decap_8
XANTENNA__2797__X Tile_X0Y3_E6BEG[7] VPWR VGND sg13cmos5l_antennanp
XFILLER_444_56 VPWR VGND sg13cmos5l_decap_8
XFILLER_227_91 VPWR VGND sg13cmos5l_decap_8
XFILLER_591_84 VPWR VGND sg13cmos5l_decap_8
XFILLER_163_35 VPWR VGND sg13cmos5l_decap_8
XFILLER_496_189 VPWR VGND sg13cmos5l_decap_8
XFILLER_638_161 VPWR VGND sg13cmos5l_fill_2
XFILLER_577_7 VPWR VGND sg13cmos5l_decap_8
XFILLER_313_49 VPWR VGND sg13cmos5l_decap_8
XFILLER_452_215 VPWR VGND sg13cmos5l_decap_8
XFILLER_653_175 VPWR VGND sg13cmos5l_decap_8
XFILLER_263_126 VPWR VGND sg13cmos5l_decap_4
XFILLER_263_137 VPWR VGND sg13cmos5l_decap_8
XFILLER_56_66 VPWR VGND sg13cmos5l_decap_8
XFILLER_460_88 VPWR VGND sg13cmos5l_fill_2
XFILLER_610_14 VPWR VGND sg13cmos5l_decap_8
XANTENNA__3421__X Tile_X0Y4_FrameData_O[12] VPWR VGND sg13cmos5l_antennanp
XFILLER_16_114 VPWR VGND sg13cmos5l_fill_1
XFILLER_72_21 VPWR VGND sg13cmos5l_decap_8
XFILLER_420_112 VPWR VGND sg13cmos5l_decap_8
XFILLER_566_105 VPWR VGND sg13cmos5l_decap_8
XFILLER_469_42 VPWR VGND sg13cmos5l_decap_8
XFILLER_420_123 VPWR VGND sg13cmos5l_decap_8
XFILLER_16_169 VPWR VGND sg13cmos5l_decap_8
XFILLER_188_21 VPWR VGND sg13cmos5l_decap_8
XFILLER_420_167 VPWR VGND sg13cmos5l_fill_1
XFILLER_234_0 VPWR VGND sg13cmos5l_decap_8
XFILLER_708_154 VPWR VGND sg13cmos5l_decap_8
XFILLER_619_56 VPWR VGND sg13cmos5l_decap_8
XFILLER_581_119 VPWR VGND sg13cmos5l_decap_8
XFILLER_507_216 VPWR VGND sg13cmos5l_fill_1
XFILLER_188_98 VPWR VGND sg13cmos5l_decap_4
XFILLER_574_182 VPWR VGND sg13cmos5l_decap_8
XFILLER_338_35 VPWR VGND sg13cmos5l_decap_8
XFILLER_485_63 VPWR VGND sg13cmos5l_decap_8
XFILLER_401_0 VPWR VGND sg13cmos5l_decap_8
XFILLER_326_160 VPWR VGND sg13cmos5l_decap_8
XFILLER_326_171 VPWR VGND sg13cmos5l_fill_1
XFILLER_326_193 VPWR VGND sg13cmos5l_decap_8
XFILLER_487_112 VPWR VGND sg13cmos5l_decap_8
XFILLER_635_77 VPWR VGND sg13cmos5l_decap_8
XFILLER_207_28 VPWR VGND sg13cmos5l_decap_8
XFILLER_98_106 VPWR VGND sg13cmos5l_decap_8
XFILLER_354_56 VPWR VGND sg13cmos5l_decap_8
XFILLER_341_174 VPWR VGND sg13cmos5l_decap_8
XFILLER_137_91 VPWR VGND sg13cmos5l_decap_8
X_0430_ _0430_/Q Tile_X0Y8_FrameData[17] VGND VPWR Tile_X0Y9_FrameStrobe[0] latch
XFILLER_140_225 VPWR VGND sg13cmos5l_decap_4
XFILLER_487_178 VPWR VGND sg13cmos5l_decap_8
XFILLER_651_21 VPWR VGND sg13cmos5l_decap_8
XFILLER_97_84 VPWR VGND sg13cmos5l_decap_4
XFILLER_428_212 VPWR VGND sg13cmos5l_fill_1
X_0361_ _0361_/Q Tile_X0Y7_FrameData[22] VGND VPWR Tile_X0Y9_FrameStrobe[6] latch
XFILLER_39_206 VPWR VGND sg13cmos5l_decap_8
X_2100_ _2100_/Q Tile_X0Y4_FrameData[17] VGND VPWR Tile_X0Y9_FrameStrobe[5] latch
X_3080_ Tile_X0Y4_E2BEGb[6] _4270_/X VPWR VGND sg13cmos5l_buf_1
XFILLER_651_98 VPWR VGND sg13cmos5l_decap_8
X_0292_ _0292_/Q Tile_X0Y7_FrameData[27] VGND VPWR Tile_X0Y9_FrameStrobe[4] latch
XFILLER_223_49 VPWR VGND sg13cmos5l_decap_8
XFILLER_644_175 VPWR VGND sg13cmos5l_decap_8
X_2031_ _2031_/Q Tile_X0Y4_FrameData[22] VGND VPWR Tile_X0Y9_FrameStrobe[3] latch
XFILLER_370_77 VPWR VGND sg13cmos5l_decap_8
XFILLER_520_14 VPWR VGND sg13cmos5l_decap_8
XANTENNA__3331__X Tile_X0Y2_FrameData_O[2] VPWR VGND sg13cmos5l_antennanp
XFILLER_411_101 VPWR VGND sg13cmos5l_fill_2
XFILLER_557_105 VPWR VGND sg13cmos5l_decap_8
XFILLER_379_42 VPWR VGND sg13cmos5l_decap_8
X_3982_ _3982_/X Tile_X0Y0_W1END[1] Tile_X0Y0_W6END[9] _3871_/X _3860_/X _1139_/Q
+ _1138_/Q VPWR VGND sg13cmos5l_mux4_1
XFILLER_22_128 VPWR VGND sg13cmos5l_decap_4
X_2933_ Tile_X0Y8_E6BEG[1] _4761_/X VPWR VGND sg13cmos5l_buf_1
XFILLER_15_180 VPWR VGND sg13cmos5l_decap_8
XFILLER_572_119 VPWR VGND sg13cmos5l_decap_8
XFILLER_529_56 VPWR VGND sg13cmos5l_decap_8
X_2864_ Tile_X0Y6_EE4BEG[1] _4513_/X VPWR VGND sg13cmos5l_buf_1
XFILLER_676_84 VPWR VGND sg13cmos5l_decap_8
XFILLER_248_35 VPWR VGND sg13cmos5l_decap_8
XFILLER_714_113 VPWR VGND sg13cmos5l_decap_8
XFILLER_309_149 VPWR VGND sg13cmos5l_decap_8
X_1815_ _1815_/Q Tile_X0Y3_FrameData[18] VGND VPWR Tile_X0Y9_FrameStrobe[4] latch
X_4603_ _4603_/X _4689_/X _4693_/X _4697_/X _4672_/X _0352_/Q _0351_/Q VPWR VGND sg13cmos5l_mux4_1
XFILLER_395_63 VPWR VGND sg13cmos5l_decap_8
X_2795_ Tile_X0Y3_E6BEG[5] _4185_/X VPWR VGND sg13cmos5l_buf_1
X_4534_ _4534_/X AXI_M_SOC_RDATA26 _4573_/X _4577_/X _4557_/X _2539_/Q _2538_/Q VPWR
+ VGND sg13cmos5l_mux4_1
XFILLER_175_199 VPWR VGND sg13cmos5l_decap_8
X_1746_ _1746_/Q Tile_X0Y3_FrameData[23] VGND VPWR Tile_X0Y9_FrameStrobe[2] latch
XFILLER_190_136 VPWR VGND sg13cmos5l_decap_8
XFILLER_116_222 VPWR VGND sg13cmos5l_decap_8
XFILLER_580_196 VPWR VGND sg13cmos5l_decap_8
XFILLER_317_182 VPWR VGND sg13cmos5l_fill_1
XFILLER_190_147 VPWR VGND sg13cmos5l_fill_1
XFILLER_545_77 VPWR VGND sg13cmos5l_decap_8
XFILLER_190_169 VPWR VGND sg13cmos5l_decap_8
X_4465_ _4465_/X _4424_/X _0100_/X _4423_/X _0140_/X _2209_/Q _2208_/Q VPWR VGND sg13cmos5l_mux4_1
XFILLER_117_28 VPWR VGND sg13cmos5l_decap_8
X_1677_ _1677_/Q Tile_X0Y3_FrameData[28] VGND VPWR Tile_X0Y9_FrameStrobe[0] latch
XFILLER_89_117 VPWR VGND sg13cmos5l_decap_4
XANTENNA__3506__X Tile_X0Y1_E2BEGb[4] VPWR VGND sg13cmos5l_antennanp
XFILLER_89_128 VPWR VGND sg13cmos5l_decap_8
XFILLER_264_56 VPWR VGND sg13cmos5l_decap_8
X_3416_ Tile_X0Y4_FrameData_O[7] Tile_X0Y4_FrameData[7] VPWR VGND sg13cmos5l_buf_1
X_0628_ _0628_/Q Tile_X0Y8_FrameData[11] VGND VPWR Tile_X0Y9_FrameStrobe[6] latch
X_4396_ _4396_/X Tile_X0Y5_WW4END[7] AXI_M_SOC_RRESP1 _4458_/X _4428_/X _2311_/Q _2310_/Q
+ VPWR VGND sg13cmos5l_mux4_1
XFILLER_561_21 VPWR VGND sg13cmos5l_decap_8
XFILLER_493_126 VPWR VGND sg13cmos5l_decap_8
XFILLER_682_226 VPWR VGND sg13cmos5l_fill_2
X_3347_ Tile_X0Y2_FrameData_O[18] Tile_X0Y2_FrameData[18] VPWR VGND sg13cmos5l_buf_1
XFILLER_97_161 VPWR VGND sg13cmos5l_decap_8
X_0559_ _0559_/Q Tile_X0Y8_FrameData[16] VGND VPWR Tile_X0Y9_FrameStrobe[4] latch
XFILLER_561_98 VPWR VGND sg13cmos5l_decap_8
X_3278_ Tile_X0Y0_EE4BEG[14] _3834_/X VPWR VGND sg13cmos5l_buf_1
XFILLER_133_49 VPWR VGND sg13cmos5l_decap_8
XFILLER_711_35 VPWR VGND sg13cmos5l_decap_8
XFILLER_434_215 VPWR VGND sg13cmos5l_fill_2
XFILLER_245_126 VPWR VGND sg13cmos5l_decap_8
XFILLER_650_112 VPWR VGND sg13cmos5l_decap_8
XFILLER_280_77 VPWR VGND sg13cmos5l_decap_8
X_2229_ _2229_/Q Tile_X0Y5_FrameData[16] VGND VPWR Tile_X0Y9_FrameStrobe[1] latch
XFILLER_430_14 VPWR VGND sg13cmos5l_decap_8
XFILLER_245_159 VPWR VGND sg13cmos5l_decap_8
XANTENNA__3241__X Tile_X0Y0_FrameData_O[9] VPWR VGND sg13cmos5l_antennanp
XFILLER_26_14 VPWR VGND sg13cmos5l_decap_8
XFILLER_399_130 VPWR VGND sg13cmos5l_decap_4
XFILLER_650_189 VPWR VGND sg13cmos5l_decap_8
XFILLER_289_42 VPWR VGND sg13cmos5l_decap_8
XFILLER_198_214 VPWR VGND sg13cmos5l_fill_2
XFILLER_402_123 VPWR VGND sg13cmos5l_decap_8
XFILLER_548_127 VPWR VGND sg13cmos5l_decap_8
XFILLER_158_7 VPWR VGND sg13cmos5l_decap_8
XFILLER_510_91 VPWR VGND sg13cmos5l_decap_8
XFILLER_201_207 VPWR VGND sg13cmos5l_fill_2
XFILLER_563_119 VPWR VGND sg13cmos5l_decap_4
XFILLER_439_56 VPWR VGND sg13cmos5l_decap_8
XFILLER_42_35 VPWR VGND sg13cmos5l_decap_8
XFILLER_355_211 VPWR VGND sg13cmos5l_fill_2
XFILLER_325_7 VPWR VGND sg13cmos5l_decap_8
XFILLER_586_84 VPWR VGND sg13cmos5l_decap_8
XFILLER_556_182 VPWR VGND sg13cmos5l_decap_8
XFILLER_158_35 VPWR VGND sg13cmos5l_decap_8
XFILLER_42_79 VPWR VGND sg13cmos5l_fill_1
XFILLER_166_144 VPWR VGND sg13cmos5l_decap_4
XFILLER_705_135 VPWR VGND sg13cmos5l_fill_1
XFILLER_504_208 VPWR VGND sg13cmos5l_decap_8
XFILLER_370_214 VPWR VGND sg13cmos5l_fill_2
XFILLER_571_196 VPWR VGND sg13cmos5l_decap_8
XFILLER_308_49 VPWR VGND sg13cmos5l_decap_8
XFILLER_694_7 VPWR VGND sg13cmos5l_decap_8
XFILLER_605_14 VPWR VGND sg13cmos5l_decap_8
XFILLER_469_134 VPWR VGND sg13cmos5l_fill_2
XFILLER_174_56 VPWR VGND sg13cmos5l_decap_8
XANTENNA__3416__X Tile_X0Y4_FrameData_O[7] VPWR VGND sg13cmos5l_antennanp
XFILLER_268_207 VPWR VGND sg13cmos5l_fill_2
XFILLER_471_21 VPWR VGND sg13cmos5l_decap_8
XFILLER_67_21 VPWR VGND sg13cmos5l_decap_8
XFILLER_484_159 VPWR VGND sg13cmos5l_decap_8
XFILLER_471_98 VPWR VGND sg13cmos5l_decap_8
XFILLER_621_35 VPWR VGND sg13cmos5l_decap_8
XFILLER_404_70 VPWR VGND sg13cmos5l_decap_8
XFILLER_641_112 VPWR VGND sg13cmos5l_decap_8
XFILLER_184_0 VPWR VGND sg13cmos5l_decap_8
XFILLER_190_88 VPWR VGND sg13cmos5l_fill_2
XANTENNA__3151__X Tile_X0Y7_FrameData_O[21] VPWR VGND sg13cmos5l_antennanp
XFILLER_340_47 VPWR VGND sg13cmos5l_decap_8
XFILLER_83_42 VPWR VGND sg13cmos5l_decap_8
XFILLER_697_28 VPWR VGND sg13cmos5l_decap_8
XFILLER_641_189 VPWR VGND sg13cmos5l_decap_8
XFILLER_351_0 VPWR VGND sg13cmos5l_decap_8
XFILLER_189_203 VPWR VGND sg13cmos5l_fill_1
XANTENNA__2990__X Tile_X0Y8_FrameData_O[30] VPWR VGND sg13cmos5l_antennanp
XFILLER_449_0 VPWR VGND sg13cmos5l_decap_8
XFILLER_199_42 VPWR VGND sg13cmos5l_decap_8
XFILLER_189_225 VPWR VGND sg13cmos5l_decap_4
XFILLER_420_91 VPWR VGND sg13cmos5l_decap_8
XFILLER_616_0 VPWR VGND sg13cmos5l_decap_8
XFILLER_554_119 VPWR VGND sg13cmos5l_decap_8
XFILLER_349_56 VPWR VGND sg13cmos5l_decap_8
XFILLER_496_84 VPWR VGND sg13cmos5l_decap_8
XFILLER_646_21 VPWR VGND sg13cmos5l_decap_8
XFILLER_157_144 VPWR VGND sg13cmos5l_decap_8
XFILLER_73_7 VPWR VGND sg13cmos5l_decap_8
XFILLER_562_130 VPWR VGND sg13cmos5l_fill_1
X_1600_ _1600_/Q Tile_X0Y2_FrameData[17] VGND VPWR Tile_X0Y9_FrameStrobe[5] latch
XFILLER_562_174 VPWR VGND sg13cmos5l_decap_8
XFILLER_361_214 VPWR VGND sg13cmos5l_fill_1
XFILLER_711_105 VPWR VGND sg13cmos5l_decap_8
X_2580_ _2580_/Q Tile_X0Y6_FrameData[19] VGND VPWR Tile_X0Y9_FrameStrobe[4] latch
XFILLER_646_98 VPWR VGND sg13cmos5l_decap_8
XFILLER_218_49 VPWR VGND sg13cmos5l_decap_8
X_1531_ _1531_/Q Tile_X0Y2_FrameData[22] VGND VPWR Tile_X0Y9_FrameStrobe[3] latch
XFILLER_365_77 VPWR VGND sg13cmos5l_decap_8
XFILLER_649_223 VPWR VGND sg13cmos5l_decap_4
XFILLER_515_14 VPWR VGND sg13cmos5l_decap_8
XANTENNA__3326__X Tile_X0Y4_EE4BEG[14] VPWR VGND sg13cmos5l_antennanp
XFILLER_662_42 VPWR VGND sg13cmos5l_decap_8
X_4250_ _4250_/X Tile_X0Y2_W1END[3] Tile_X0Y2_W2MID[0] Tile_X0Y2_W2END[0] _4096_/X
+ _1615_/Q _1614_/Q VPWR VGND sg13cmos5l_mux4_1
X_1462_ _1462_/Q Tile_X0Y2_FrameData[27] VGND VPWR Tile_X0Y9_FrameStrobe[1] latch
XFILLER_475_104 VPWR VGND sg13cmos5l_decap_4
XFILLER_381_21 VPWR VGND sg13cmos5l_decap_8
X_3201_ Tile_X0Y0_N2BEG[1] _3785_/X VPWR VGND sg13cmos5l_buf_1
X_0413_ _0413_/Q Tile_X0Y7_FrameData[2] VGND VPWR Tile_X0Y9_FrameStrobe[7] latch
X_4181_ _4181_/X _0088_/X Tile_X0Y0_S4END[13] _4232_/X _4215_/X _1779_/Q _1778_/Q
+ VPWR VGND sg13cmos5l_mux4_1
X_1393_ _1393_/Q Tile_X0Y1_FrameData[8] VGND VPWR Tile_X0Y9_FrameStrobe[6] latch
XFILLER_79_194 VPWR VGND sg13cmos5l_fill_2
X_3132_ Tile_X0Y7_FrameData_O[2] Tile_X0Y7_FrameData[2] VPWR VGND sg13cmos5l_buf_1
X_0344_ _0344_/Q Tile_X0Y7_FrameData[7] VGND VPWR Tile_X0Y9_FrameStrobe[5] latch
XFILLER_531_35 VPWR VGND sg13cmos5l_decap_8
XFILLER_314_70 VPWR VGND sg13cmos5l_fill_1
XFILLER_632_112 VPWR VGND sg13cmos5l_decap_8
X_3063_ Tile_X0Y5_FrameData_O[22] Tile_X0Y5_FrameData[22] VPWR VGND sg13cmos5l_buf_1
XFILLER_617_197 VPWR VGND sg13cmos5l_decap_8
XFILLER_250_14 VPWR VGND sg13cmos5l_decap_8
X_0275_ _0275_/Q Tile_X0Y7_FrameData[12] VGND VPWR Tile_X0Y9_FrameStrobe[3] latch
XFILLER_632_134 VPWR VGND sg13cmos5l_decap_4
XANTENNA__3061__X Tile_X0Y5_FrameData_O[20] VPWR VGND sg13cmos5l_antennanp
XFILLER_632_145 VPWR VGND sg13cmos5l_decap_8
X_2014_ _2014_/Q Tile_X0Y4_FrameData[7] VGND VPWR Tile_X0Y9_FrameStrobe[2] latch
XFILLER_235_181 VPWR VGND sg13cmos5l_fill_1
XFILLER_400_28 VPWR VGND sg13cmos5l_decap_8
X_3965_ _3965_/X _0096_/X Tile_X0Y0_S4END[5] _4018_/X _3999_/X _1279_/Q _1278_/Q VPWR
+ VGND sg13cmos5l_mux4_1
XFILLER_195_228 VPWR VGND sg13cmos5l_fill_1
XFILLER_396_188 VPWR VGND sg13cmos5l_decap_8
XFILLER_259_56 VPWR VGND sg13cmos5l_decap_8
XFILLER_259_67 VPWR VGND sg13cmos5l_fill_2
X_2916_ Tile_X0Y8_E2BEG[0] _4728_/X VPWR VGND sg13cmos5l_buf_1
X_3896_ _3896_/X Tile_X0Y2_W2MID[3] Tile_X0Y2_W2END[3] Tile_X0Y2_W6END[3] _4102_/X
+ _1657_/Q _1656_/Q VPWR VGND sg13cmos5l_mux4_1
XFILLER_556_21 VPWR VGND sg13cmos5l_decap_8
X_2847_ Tile_X0Y6_E2BEGb[4] _4508_/X VPWR VGND sg13cmos5l_buf_1
XFILLER_148_177 VPWR VGND sg13cmos5l_decap_8
XFILLER_12_49 VPWR VGND sg13cmos5l_decap_8
XFILLER_553_163 VPWR VGND sg13cmos5l_decap_8
X_2778_ Tile_X0Y3_EE4BEG[4] _4168_/X VPWR VGND sg13cmos5l_buf_1
XFILLER_556_98 VPWR VGND sg13cmos5l_decap_8
XFILLER_128_49 VPWR VGND sg13cmos5l_decap_8
XFILLER_706_35 VPWR VGND sg13cmos5l_decap_8
XFILLER_163_158 VPWR VGND sg13cmos5l_fill_2
XFILLER_275_77 VPWR VGND sg13cmos5l_decap_8
X_1729_ _1729_/Q Tile_X0Y3_FrameData[8] VGND VPWR Tile_X0Y9_FrameStrobe[1] latch
X_4517_ _4517_/X Tile_X0Y6_WW4END[10] AXI_M_SOC_RDATA29 _4578_/X _4557_/X _2573_/Q
+ _2572_/Q VPWR VGND sg13cmos5l_mux4_1
XFILLER_305_141 VPWR VGND sg13cmos5l_decap_4
XFILLER_425_14 VPWR VGND sg13cmos5l_decap_8
XANTENNA__3236__X Tile_X0Y0_FrameData_O[4] VPWR VGND sg13cmos5l_antennanp
XFILLER_572_42 VPWR VGND sg13cmos5l_decap_8
X_4448_ _4448_/X _4015_/X _4019_/X _3996_/X _3988_/X _1356_/Q _1355_/Q VPWR VGND sg13cmos5l_mux4_1
XFILLER_710_182 VPWR VGND sg13cmos5l_decap_8
XFILLER_320_133 VPWR VGND sg13cmos5l_decap_8
XFILLER_291_21 VPWR VGND sg13cmos5l_decap_8
X_4379_ _4379_/X Tile_X0Y5_W2MID[0] AXI_M_SOC_RRESP1 _4467_/X _4428_/X _2345_/Q _2344_/Q
+ VPWR VGND sg13cmos5l_mux4_1
XFILLER_608_131 VPWR VGND sg13cmos5l_fill_1
XFILLER_505_91 VPWR VGND sg13cmos5l_decap_8
XFILLER_291_98 VPWR VGND sg13cmos5l_decap_8
XFILLER_608_164 VPWR VGND sg13cmos5l_fill_2
XFILLER_441_35 VPWR VGND sg13cmos5l_decap_8
XFILLER_407_215 VPWR VGND sg13cmos5l_decap_8
XFILLER_224_70 VPWR VGND sg13cmos5l_decap_8
XFILLER_37_24 VPWR VGND sg13cmos5l_decap_8
XFILLER_85_153 VPWR VGND sg13cmos5l_decap_8
XFILLER_623_112 VPWR VGND sg13cmos5l_fill_2
XFILLER_474_192 VPWR VGND sg13cmos5l_decap_8
XFILLER_218_148 VPWR VGND sg13cmos5l_fill_2
XFILLER_160_14 VPWR VGND sg13cmos5l_decap_8
XFILLER_275_7 VPWR VGND sg13cmos5l_decap_8
XFILLER_26_220 VPWR VGND sg13cmos5l_fill_2
XFILLER_226_170 VPWR VGND sg13cmos5l_fill_1
XFILLER_442_7 VPWR VGND sg13cmos5l_decap_8
XFILLER_310_28 VPWR VGND sg13cmos5l_decap_8
XFILLER_53_56 VPWR VGND sg13cmos5l_decap_8
XFILLER_387_155 VPWR VGND sg13cmos5l_decap_4
XFILLER_186_206 VPWR VGND sg13cmos5l_decap_8
XFILLER_241_184 VPWR VGND sg13cmos5l_decap_8
XFILLER_53_89 VPWR VGND sg13cmos5l_decap_8
XFILLER_169_56 VPWR VGND sg13cmos5l_decap_8
XFILLER_707_7 VPWR VGND sg13cmos5l_decap_8
XFILLER_466_21 VPWR VGND sg13cmos5l_decap_8
XFILLER_139_133 VPWR VGND sg13cmos5l_decap_8
XFILLER_154_103 VPWR VGND sg13cmos5l_decap_4
XFILLER_544_163 VPWR VGND sg13cmos5l_fill_2
XFILLER_466_87 VPWR VGND sg13cmos5l_fill_1
XFILLER_343_225 VPWR VGND sg13cmos5l_decap_4
XFILLER_616_35 VPWR VGND sg13cmos5l_decap_8
XFILLER_5_135 VPWR VGND sg13cmos5l_fill_2
XFILLER_544_196 VPWR VGND sg13cmos5l_decap_8
XFILLER_335_14 VPWR VGND sg13cmos5l_decap_8
XANTENNA__3146__X Tile_X0Y7_FrameData_O[16] VPWR VGND sg13cmos5l_antennanp
XFILLER_482_42 VPWR VGND sg13cmos5l_decap_8
XFILLER_311_100 VPWR VGND sg13cmos5l_fill_1
XFILLER_78_42 VPWR VGND sg13cmos5l_decap_8
XFILLER_311_122 VPWR VGND sg13cmos5l_decap_4
XANTENNA__2985__X Tile_X0Y8_FrameData_O[25] VPWR VGND sg13cmos5l_antennanp
XFILLER_399_0 VPWR VGND sg13cmos5l_decap_8
XFILLER_632_56 VPWR VGND sg13cmos5l_decap_8
XFILLER_415_91 VPWR VGND sg13cmos5l_decap_8
XFILLER_351_35 VPWR VGND sg13cmos5l_decap_8
XFILLER_134_70 VPWR VGND sg13cmos5l_decap_8
XFILLER_76_142 VPWR VGND sg13cmos5l_decap_8
XFILLER_264_221 VPWR VGND sg13cmos5l_decap_8
XFILLER_209_126 VPWR VGND sg13cmos5l_decap_8
XFILLER_614_112 VPWR VGND sg13cmos5l_fill_1
XFILLER_566_0 VPWR VGND sg13cmos5l_decap_8
XFILLER_94_63 VPWR VGND sg13cmos5l_decap_8
XFILLER_224_118 VPWR VGND sg13cmos5l_decap_8
X_0060_ _3177_/A _3924_/X _3925_/X _1896_/Q VPWR VGND sg13cmos5l_mux2_1
XFILLER_413_218 VPWR VGND sg13cmos5l_decap_8
XFILLER_614_178 VPWR VGND sg13cmos5l_decap_8
XFILLER_501_49 VPWR VGND sg13cmos5l_decap_8
XFILLER_224_129 VPWR VGND sg13cmos5l_fill_1
XFILLER_91_167 VPWR VGND sg13cmos5l_decap_8
XFILLER_91_178 VPWR VGND sg13cmos5l_fill_2
XFILLER_567_200 VPWR VGND sg13cmos5l_decap_8
XFILLER_220_28 VPWR VGND sg13cmos5l_decap_8
XFILLER_150_91 VPWR VGND sg13cmos5l_decap_8
XFILLER_657_42 VPWR VGND sg13cmos5l_decap_8
XFILLER_319_200 VPWR VGND sg13cmos5l_decap_8
X_3750_ AXI_M_SOC_ARADDR22 Tile_X0Y8_WW4END[6] Tile_X0Y8_WW4END[14] Tile_X0Y8_W6END[6]
+ _4806_/X _0491_/Q _0490_/Q VPWR VGND sg13cmos5l_mux4_1
XFILLER_319_211 VPWR VGND sg13cmos5l_fill_1
X_0962_ _0962_/Q Tile_X0Y0_FrameData[9] VGND VPWR Tile_X0Y9_FrameStrobe[0] latch
XFILLER_376_21 VPWR VGND sg13cmos5l_decap_8
X_2701_ _4084_/A3 VPWR VGND sg13cmos5l_tielo
XFILLER_535_130 VPWR VGND sg13cmos5l_decap_4
XFILLER_393_169 VPWR VGND sg13cmos5l_decap_8
X_3681_ _3681_/X Tile_X0Y2_WW4END[3] Tile_X0Y2_WW4END[11] Tile_X0Y2_W6END[11] _4127_/X
+ _1483_/Q _1482_/Q VPWR VGND sg13cmos5l_mux4_1
XFILLER_535_141 VPWR VGND sg13cmos5l_decap_8
X_0893_ _0893_/Q Tile_X0Y9_FrameData[2] VGND VPWR Tile_X0Y9_FrameStrobe[6] latch
X_2632_ _2632_/Q Tile_X0Y6_FrameData[31] VGND VPWR Tile_X0Y9_FrameStrobe[6] latch
XFILLER_334_225 VPWR VGND sg13cmos5l_decap_4
XFILLER_526_35 VPWR VGND sg13cmos5l_decap_8
XFILLER_309_70 VPWR VGND sg13cmos5l_fill_1
XFILLER_696_126 VPWR VGND sg13cmos5l_fill_2
X_2563_ _2563_/Q Tile_X0Y6_FrameData[4] VGND VPWR Tile_X0Y9_FrameStrobe[3] latch
XFILLER_673_63 VPWR VGND sg13cmos5l_decap_8
XFILLER_550_155 VPWR VGND sg13cmos5l_fill_1
XFILLER_245_14 VPWR VGND sg13cmos5l_decap_8
XANTENNA__3056__X Tile_X0Y5_FrameData_O[15] VPWR VGND sg13cmos5l_antennanp
XFILLER_526_79 VPWR VGND sg13cmos5l_fill_1
XFILLER_99_223 VPWR VGND sg13cmos5l_decap_4
XFILLER_392_42 VPWR VGND sg13cmos5l_decap_8
X_1514_ _1514_/Q Tile_X0Y2_FrameData[7] VGND VPWR Tile_X0Y9_FrameStrobe[2] latch
X_4302_ _4302_/X Tile_X0Y5_W1END[0] Tile_X0Y5_W6END[4] _4463_/X _4416_/X _2439_/Q
+ _2438_/Q VPWR VGND sg13cmos5l_mux4_1
X_2494_ _2494_/Q Tile_X0Y6_FrameData[9] VGND VPWR Tile_X0Y9_FrameStrobe[1] latch
X_4233_ _4233_/X _4203_/X _0046_/X _4202_/X Tile_X0Y0_S4END[15] _1707_/Q _1706_/Q
+ VPWR VGND sg13cmos5l_mux4_1
XANTENNA__2895__X Tile_X0Y6_FrameData_O[16] VPWR VGND sg13cmos5l_antennanp
X_1445_ _1445_/Q Tile_X0Y2_FrameData[12] VGND VPWR Tile_X0Y9_FrameStrobe[0] latch
XFILLER_542_56 VPWR VGND sg13cmos5l_decap_8
X_4164_ _4164_/X Tile_X0Y3_WW4END[15] AXI_M_SOC_WREADY _4212_/X _4204_/X _1813_/Q
+ _1812_/Q VPWR VGND sg13cmos5l_mux4_1
XFILLER_463_118 VPWR VGND sg13cmos5l_decap_8
X_1376_ _1376_/Q Tile_X0Y1_FrameData[25] VGND VPWR Tile_X0Y9_FrameStrobe[6] latch
XFILLER_261_35 VPWR VGND sg13cmos5l_decap_8
XFILLER_67_142 VPWR VGND sg13cmos5l_decap_8
X_3115_ Tile_X0Y7_EE4BEG[1] _4629_/X VPWR VGND sg13cmos5l_buf_1
X_0327_ _0327_/Q Tile_X0Y7_FrameData[24] VGND VPWR Tile_X0Y9_FrameStrobe[5] latch
X_4095_ _4095_/X Tile_X0Y3_W1END[3] Tile_X0Y3_W6END[7] _4212_/X _4193_/X _1919_/Q
+ _1918_/Q VPWR VGND sg13cmos5l_mux4_1
XFILLER_82_112 VPWR VGND sg13cmos5l_decap_4
XFILLER_471_151 VPWR VGND sg13cmos5l_decap_4
XFILLER_404_207 VPWR VGND sg13cmos5l_decap_8
XFILLER_82_134 VPWR VGND sg13cmos5l_decap_8
X_3046_ Tile_X0Y5_FrameData_O[5] Tile_X0Y5_FrameData[5] VPWR VGND sg13cmos5l_buf_1
X_0258_ _0258_/Q Tile_X0Y7_FrameData[29] VGND VPWR Tile_X0Y9_FrameStrobe[3] latch
XFILLER_605_178 VPWR VGND sg13cmos5l_decap_4
XFILLER_411_49 VPWR VGND sg13cmos5l_decap_8
XFILLER_130_28 VPWR VGND sg13cmos5l_decap_8
X_0189_ _0189_/Q Tile_X0Y7_FrameData[2] VGND VPWR Tile_X0Y9_FrameStrobe[0] latch
XFILLER_23_212 VPWR VGND sg13cmos5l_decap_4
XFILLER_369_133 VPWR VGND sg13cmos5l_decap_8
XFILLER_573_203 VPWR VGND sg13cmos5l_decap_8
XFILLER_518_108 VPWR VGND sg13cmos5l_decap_8
XFILLER_567_42 VPWR VGND sg13cmos5l_decap_8
X_3948_ _3948_/X Tile_X0Y1_WW4END[15] AXI_M_SOC_ARREADY _3996_/X _3988_/X _1313_/Q
+ _1312_/Q VPWR VGND sg13cmos5l_mux4_1
XFILLER_286_21 VPWR VGND sg13cmos5l_decap_8
XFILLER_526_141 VPWR VGND sg13cmos5l_fill_1
X_3879_ _3879_/X _3851_/X _0078_/X Tile_X0Y0_S1END[3] Tile_X0Y0_S4END[3] _0981_/Q
+ _0980_/Q VPWR VGND sg13cmos5l_mux4_1
XFILLER_286_98 VPWR VGND sg13cmos5l_decap_8
XFILLER_136_147 VPWR VGND sg13cmos5l_decap_8
XFILLER_436_35 VPWR VGND sg13cmos5l_decap_8
XFILLER_219_70 VPWR VGND sg13cmos5l_decap_8
XFILLER_583_63 VPWR VGND sg13cmos5l_decap_8
XFILLER_155_14 VPWR VGND sg13cmos5l_decap_8
XFILLER_2_105 VPWR VGND sg13cmos5l_fill_2
XFILLER_340_228 VPWR VGND sg13cmos5l_fill_1
XFILLER_3_7 VPWR VGND sg13cmos5l_decap_8
XFILLER_494_210 VPWR VGND sg13cmos5l_decap_4
XFILLER_695_170 VPWR VGND sg13cmos5l_fill_1
XANTENNA__0102__Y AXI_M_SOC_ARLEN5 VPWR VGND sg13cmos5l_antennanp
XFILLER_305_28 VPWR VGND sg13cmos5l_decap_8
XFILLER_392_7 VPWR VGND sg13cmos5l_decap_8
XFILLER_452_56 VPWR VGND sg13cmos5l_decap_8
XFILLER_48_45 VPWR VGND sg13cmos5l_decap_8
XFILLER_58_131 VPWR VGND sg13cmos5l_decap_8
XFILLER_171_35 VPWR VGND sg13cmos5l_decap_8
XFILLER_73_112 VPWR VGND sg13cmos5l_fill_1
XFILLER_657_7 VPWR VGND sg13cmos5l_decap_8
XFILLER_321_49 VPWR VGND sg13cmos5l_decap_8
XFILLER_214_140 VPWR VGND sg13cmos5l_decap_8
XFILLER_64_99 VPWR VGND sg13cmos5l_decap_8
XFILLER_401_82 VPWR VGND sg13cmos5l_decap_8
XFILLER_159_217 VPWR VGND sg13cmos5l_fill_1
XFILLER_9_28 VPWR VGND sg13cmos5l_decap_8
XFILLER_509_119 VPWR VGND sg13cmos5l_decap_8
XFILLER_375_114 VPWR VGND sg13cmos5l_decap_8
XFILLER_80_21 VPWR VGND sg13cmos5l_decap_8
XFILLER_477_42 VPWR VGND sg13cmos5l_decap_8
XFILLER_147_0 VPWR VGND sg13cmos5l_decap_8
XFILLER_375_169 VPWR VGND sg13cmos5l_decap_8
XFILLER_477_97 VPWR VGND sg13cmos5l_decap_8
XFILLER_196_54 VPWR VGND sg13cmos5l_decap_8
XFILLER_390_128 VPWR VGND sg13cmos5l_decap_8
XFILLER_314_0 VPWR VGND sg13cmos5l_decap_8
XFILLER_627_56 VPWR VGND sg13cmos5l_decap_8
XFILLER_517_174 VPWR VGND sg13cmos5l_decap_4
XFILLER_13_70 VPWR VGND sg13cmos5l_decap_8
XFILLER_383_180 VPWR VGND sg13cmos5l_decap_8
XFILLER_346_35 VPWR VGND sg13cmos5l_decap_8
XFILLER_532_133 VPWR VGND sg13cmos5l_decap_4
XFILLER_129_70 VPWR VGND sg13cmos5l_decap_8
XFILLER_678_126 VPWR VGND sg13cmos5l_fill_1
XFILLER_532_144 VPWR VGND sg13cmos5l_decap_8
XFILLER_493_63 VPWR VGND sg13cmos5l_decap_8
XFILLER_678_148 VPWR VGND sg13cmos5l_fill_1
XFILLER_89_63 VPWR VGND sg13cmos5l_decap_8
XFILLER_619_215 VPWR VGND sg13cmos5l_fill_2
XFILLER_683_0 VPWR VGND sg13cmos5l_decap_8
XFILLER_643_77 VPWR VGND sg13cmos5l_decap_8
XFILLER_215_28 VPWR VGND sg13cmos5l_decap_8
XFILLER_296_165 VPWR VGND sg13cmos5l_decap_8
XANTENNA__3604__X Tile_X0Y9_S1BEG[2] VPWR VGND sg13cmos5l_antennanp
XFILLER_362_56 VPWR VGND sg13cmos5l_decap_8
XFILLER_145_91 VPWR VGND sg13cmos5l_decap_8
X_1230_ _1230_/Q Tile_X0Y1_FrameData[11] VGND VPWR Tile_X0Y9_FrameStrobe[1] latch
XFILLER_49_120 VPWR VGND sg13cmos5l_decap_8
XFILLER_49_131 VPWR VGND sg13cmos5l_fill_2
XFILLER_237_210 VPWR VGND sg13cmos5l_decap_8
XFILLER_237_221 VPWR VGND sg13cmos5l_fill_1
X_1161_ _1161_/Q Tile_X0Y0_FrameData[2] VGND VPWR Tile_X0Y9_FrameStrobe[6] latch
XFILLER_49_197 VPWR VGND sg13cmos5l_decap_4
X_0112_ _0112_/X _4320_/X _4321_/X _1115_/Q VPWR VGND sg13cmos5l_mux2_1
XFILLER_252_213 VPWR VGND sg13cmos5l_decap_8
X_1092_ _1092_/Q Tile_X0Y0_FrameData[7] VGND VPWR Tile_X0Y9_FrameStrobe[4] latch
XFILLER_231_49 VPWR VGND sg13cmos5l_decap_8
XFILLER_64_178 VPWR VGND sg13cmos5l_decap_8
X_0043_ _3632_/A _4720_/X _4721_/X _0603_/Q VPWR VGND sg13cmos5l_mux2_1
X_4920_ _4920_/X Tile_X0Y9_N1END[0] Tile_X0Y9_N4END[0] _4896_/X _0083_/X _0719_/Q
+ _0718_/Q VPWR VGND sg13cmos5l_mux4_1
XFILLER_205_140 VPWR VGND sg13cmos5l_decap_8
X_4851_ _4851_/X Tile_X0Y9_W2MID[4] AXI_M_SOC_RDATA3 _4907_/X _4906_/X _0841_/Q _0840_/Q
+ VPWR VGND sg13cmos5l_mux4_1
XFILLER_668_63 VPWR VGND sg13cmos5l_decap_8
XFILLER_387_42 VPWR VGND sg13cmos5l_decap_8
X_3802_ _3802_/X _3850_/X Tile_X0Y0_W2END[6] Tile_X0Y0_W2END[7] Tile_X0Y0_S1END[2]
+ _1101_/Q _1100_/Q VPWR VGND sg13cmos5l_mux4_1
XFILLER_366_136 VPWR VGND sg13cmos5l_fill_1
X_1994_ _1994_/Q Tile_X0Y4_FrameData[27] VGND VPWR Tile_X0Y9_FrameStrobe[2] latch
X_4782_ _4782_/X Tile_X0Y7_W1END[3] Tile_X0Y7_W6END[11] _4699_/X _4659_/X _0373_/Q
+ _0372_/Q VPWR VGND sg13cmos5l_mux4_1
XFILLER_165_209 VPWR VGND sg13cmos5l_fill_2
X_0945_ _0945_/Q Tile_X0Y0_FrameData[26] VGND VPWR Tile_X0Y9_FrameStrobe[0] latch
X_3733_ AXI_M_SOC_ARADDR5 Tile_X0Y9_WW4END[5] Tile_X0Y9_WW4END[13] Tile_X0Y9_W6END[5]
+ _4921_/X _0749_/Q _0748_/Q VPWR VGND sg13cmos5l_mux4_1
XFILLER_381_106 VPWR VGND sg13cmos5l_fill_2
XFILLER_570_228 VPWR VGND sg13cmos5l_fill_1
XFILLER_537_56 VPWR VGND sg13cmos5l_decap_8
XFILLER_307_225 VPWR VGND sg13cmos5l_decap_4
X_0876_ _0876_/Q Tile_X0Y9_FrameData[19] VGND VPWR Tile_X0Y9_FrameStrobe[6] latch
X_3664_ AXI_M_SOC_AWADDR25 Tile_X0Y4_WW4END[1] Tile_X0Y4_WW4END[9] Tile_X0Y4_W6END[9]
+ _4345_/X _1995_/Q _1994_/Q VPWR VGND sg13cmos5l_mux4_1
XFILLER_684_84 VPWR VGND sg13cmos5l_decap_8
XFILLER_508_196 VPWR VGND sg13cmos5l_decap_8
XFILLER_62_0 VPWR VGND sg13cmos5l_fill_1
XFILLER_256_35 VPWR VGND sg13cmos5l_decap_8
X_2615_ _2615_/Q Tile_X0Y6_FrameData[16] VGND VPWR Tile_X0Y9_FrameStrobe[5] latch
X_3595_ Tile_X0Y9_FrameData_O[25] Tile_X0Y9_FrameData[25] VPWR VGND sg13cmos5l_buf_1
XFILLER_669_159 VPWR VGND sg13cmos5l_decap_8
XFILLER_684_107 VPWR VGND sg13cmos5l_decap_4
X_2546_ _2546_/Q Tile_X0Y6_FrameData[21] VGND VPWR Tile_X0Y9_FrameStrobe[3] latch
XFILLER_684_129 VPWR VGND sg13cmos5l_fill_2
XFILLER_406_49 VPWR VGND sg13cmos5l_decap_8
XFILLER_553_77 VPWR VGND sg13cmos5l_decap_8
XFILLER_141_161 VPWR VGND sg13cmos5l_decap_8
XFILLER_125_28 VPWR VGND sg13cmos5l_decap_8
X_2477_ _2477_/Q Tile_X0Y6_FrameData[26] VGND VPWR Tile_X0Y9_FrameStrobe[1] latch
XFILLER_703_14 VPWR VGND sg13cmos5l_decap_8
XANTENNA__3514__X Tile_X0Y1_E2BEG[4] VPWR VGND sg13cmos5l_antennanp
XFILLER_272_56 VPWR VGND sg13cmos5l_decap_8
XFILLER_287_176 VPWR VGND sg13cmos5l_decap_8
X_1428_ _1428_/Q Tile_X0Y2_FrameData[29] VGND VPWR Tile_X0Y9_FrameStrobe[0] latch
X_4216_ _4216_/X Tile_X0Y7_W1END[1] Tile_X0Y7_WW4END[1] Tile_X0Y7_W6END[9] _4685_/X
+ _0388_/Q _0387_/Q VPWR VGND sg13cmos5l_mux4_1
XFILLER_228_221 VPWR VGND sg13cmos5l_fill_1
X_4147_ _4147_/X _4203_/X _4202_/X AXI_M_SOC_WREADY _4201_/X _1847_/Q _1846_/Q VPWR
+ VGND sg13cmos5l_mux4_1
X_1359_ _1359_/Q Tile_X0Y1_FrameData[10] VGND VPWR Tile_X0Y9_FrameStrobe[5] latch
X_4078_ _4078_/X AXI_M_SOC_AWREADY _4121_/X _4125_/X _4101_/X _1517_/Q _1516_/Q VPWR
+ VGND sg13cmos5l_mux4_1
XFILLER_141_49 VPWR VGND sg13cmos5l_decap_8
XFILLER_502_70 VPWR VGND sg13cmos5l_decap_8
XFILLER_55_167 VPWR VGND sg13cmos5l_decap_8
X_3029_ Tile_X0Y5_EE4BEG[4] _4392_/X VPWR VGND sg13cmos5l_buf_1
XFILLER_70_126 VPWR VGND sg13cmos5l_decap_8
XFILLER_578_63 VPWR VGND sg13cmos5l_decap_8
XFILLER_297_42 VPWR VGND sg13cmos5l_decap_8
XFILLER_140_7 VPWR VGND sg13cmos5l_decap_8
XFILLER_357_147 VPWR VGND sg13cmos5l_decap_8
XFILLER_238_7 VPWR VGND sg13cmos5l_decap_8
XFILLER_50_13 VPWR VGND sg13cmos5l_decap_4
XFILLER_561_228 VPWR VGND sg13cmos5l_fill_1
XFILLER_447_56 VPWR VGND sg13cmos5l_decap_8
XFILLER_405_7 VPWR VGND sg13cmos5l_decap_8
XFILLER_109_136 VPWR VGND sg13cmos5l_fill_1
XFILLER_594_84 VPWR VGND sg13cmos5l_decap_8
XFILLER_50_57 VPWR VGND sg13cmos5l_decap_8
XFILLER_166_35 VPWR VGND sg13cmos5l_decap_8
XFILLER_109_169 VPWR VGND sg13cmos5l_fill_2
XFILLER_313_206 VPWR VGND sg13cmos5l_decap_8
XFILLER_124_117 VPWR VGND sg13cmos5l_decap_8
XFILLER_467_210 VPWR VGND sg13cmos5l_decap_4
XFILLER_316_49 VPWR VGND sg13cmos5l_decap_8
XFILLER_59_55 VPWR VGND sg13cmos5l_decap_8
XFILLER_613_14 VPWR VGND sg13cmos5l_decap_8
XFILLER_278_154 VPWR VGND sg13cmos5l_decap_8
XFILLER_132_161 VPWR VGND sg13cmos5l_decap_4
XFILLER_182_56 VPWR VGND sg13cmos5l_decap_8
XANTENNA__3424__X Tile_X0Y4_FrameData_O[15] VPWR VGND sg13cmos5l_antennanp
XFILLER_75_21 VPWR VGND sg13cmos5l_decap_8
XFILLER_46_101 VPWR VGND sg13cmos5l_decap_8
XFILLER_435_140 VPWR VGND sg13cmos5l_decap_8
XFILLER_234_213 VPWR VGND sg13cmos5l_fill_1
XFILLER_450_110 VPWR VGND sg13cmos5l_fill_2
XFILLER_264_0 VPWR VGND sg13cmos5l_decap_8
XFILLER_61_104 VPWR VGND sg13cmos5l_fill_2
XFILLER_91_42 VPWR VGND sg13cmos5l_decap_8
XFILLER_488_63 VPWR VGND sg13cmos5l_decap_8
XFILLER_450_187 VPWR VGND sg13cmos5l_decap_8
XFILLER_431_0 VPWR VGND sg13cmos5l_decap_8
XFILLER_537_214 VPWR VGND sg13cmos5l_decap_8
XFILLER_529_0 VPWR VGND sg13cmos5l_decap_8
XFILLER_348_147 VPWR VGND sg13cmos5l_decap_8
XFILLER_147_209 VPWR VGND sg13cmos5l_fill_1
XFILLER_638_77 VPWR VGND sg13cmos5l_decap_8
XFILLER_357_56 VPWR VGND sg13cmos5l_decap_8
X_0730_ _0730_/Q Tile_X0Y9_FrameData[5] VGND VPWR Tile_X0Y9_FrameStrobe[1] latch
XFILLER_654_21 VPWR VGND sg13cmos5l_decap_8
XFILLER_505_133 VPWR VGND sg13cmos5l_decap_8
XFILLER_371_150 VPWR VGND sg13cmos5l_fill_2
X_0661_ _0661_/Q Tile_X0Y8_FrameData[10] VGND VPWR Tile_X0Y9_FrameStrobe[7] latch
X_2400_ _2400_/Q Tile_X0Y5_FrameData[5] VGND VPWR Tile_X0Y9_FrameStrobe[6] latch
XFILLER_40_90 VPWR VGND sg13cmos5l_fill_1
XFILLER_520_125 VPWR VGND sg13cmos5l_decap_4
XFILLER_108_180 VPWR VGND sg13cmos5l_fill_2
X_3380_ Tile_X0Y2_E6BEG[3] _4075_/X VPWR VGND sg13cmos5l_buf_1
X_0592_ _0592_/Q Tile_X0Y8_FrameData[15] VGND VPWR Tile_X0Y9_FrameStrobe[5] latch
XFILLER_654_98 VPWR VGND sg13cmos5l_decap_8
XFILLER_226_49 VPWR VGND sg13cmos5l_decap_8
X_2331_ _2331_/Q Tile_X0Y5_FrameData[10] VGND VPWR Tile_X0Y9_FrameStrobe[4] latch
XFILLER_373_77 VPWR VGND sg13cmos5l_decap_8
XFILLER_523_14 VPWR VGND sg13cmos5l_decap_8
XANTENNA__3334__X Tile_X0Y2_FrameData_O[5] VPWR VGND sg13cmos5l_antennanp
XFILLER_670_42 VPWR VGND sg13cmos5l_decap_8
X_2262_ _2262_/Q Tile_X0Y5_FrameData[15] VGND VPWR Tile_X0Y9_FrameStrobe[2] latch
XFILLER_674_162 VPWR VGND sg13cmos5l_decap_4
X_4001_ _4001_/X _4456_/X _4460_/X _4464_/X _4430_/X _2412_/Q _2411_/Q VPWR VGND sg13cmos5l_mux4_1
X_1213_ _1213_/Q Tile_X0Y1_FrameData[28] VGND VPWR Tile_X0Y9_FrameStrobe[1] latch
XFILLER_37_101 VPWR VGND sg13cmos5l_decap_8
X_2193_ _2193_/Q Tile_X0Y5_FrameData[20] VGND VPWR Tile_X0Y9_FrameStrobe[0] latch
XFILLER_284_168 VPWR VGND sg13cmos5l_decap_8
XFILLER_426_140 VPWR VGND sg13cmos5l_decap_8
XFILLER_603_91 VPWR VGND sg13cmos5l_decap_4
X_1144_ _1144_/Q Tile_X0Y0_FrameData[19] VGND VPWR Tile_X0Y9_FrameStrobe[6] latch
XFILLER_630_210 VPWR VGND sg13cmos5l_fill_1
XFILLER_1_84 VPWR VGND sg13cmos5l_decap_4
XFILLER_52_104 VPWR VGND sg13cmos5l_decap_8
X_1075_ _1075_/Q Tile_X0Y0_FrameData[24] VGND VPWR Tile_X0Y9_FrameStrobe[4] latch
XFILLER_679_84 VPWR VGND sg13cmos5l_decap_8
XFILLER_240_216 VPWR VGND sg13cmos5l_decap_4
XFILLER_197_109 VPWR VGND sg13cmos5l_fill_2
X_4903_ _4903_/X Tile_X0Y9_N2MID[1] Tile_X0Y9_N2END[1] _4933_/X _4817_/X _0693_/Q
+ _0692_/Q VPWR VGND sg13cmos5l_mux4_1
XFILLER_398_63 VPWR VGND sg13cmos5l_decap_8
X_4834_ _4834_/X Tile_X0Y9_W1END[2] Tile_X0Y9_W2MID[1] Tile_X0Y9_W2END[1] _4902_/X
+ _0871_/Q _0870_/Q VPWR VGND sg13cmos5l_mux4_1
XFILLER_60_181 VPWR VGND sg13cmos5l_decap_4
XFILLER_339_147 VPWR VGND sg13cmos5l_fill_1
XFILLER_548_77 VPWR VGND sg13cmos5l_decap_8
XFILLER_543_206 VPWR VGND sg13cmos5l_decap_8
X_4765_ _4765_/X AXI_M_SOC_RDATA9 _4806_/X _4810_/X _4787_/X _0517_/Q _0516_/Q VPWR
+ VGND sg13cmos5l_mux4_1
X_1977_ _1977_/Q Tile_X0Y4_FrameData[12] VGND VPWR Tile_X0Y9_FrameStrobe[1] latch
XFILLER_267_56 VPWR VGND sg13cmos5l_decap_8
XANTENNA__3509__X Tile_X0Y1_E2BEGb[7] VPWR VGND sg13cmos5l_antennanp
XFILLER_347_180 VPWR VGND sg13cmos5l_fill_1
X_3716_ AXI_M_SOC_WDATA26 Tile_X0Y6_WW4END[2] Tile_X0Y6_WW4END[10] Tile_X0Y6_W6END[10]
+ _4578_/X _2507_/Q _2506_/Q VPWR VGND sg13cmos5l_mux4_1
X_0928_ _0928_/Q Tile_X0Y9_FrameData[31] VGND VPWR Tile_X0Y9_FrameStrobe[0] latch
X_4696_ _4696_/X _4661_/X Tile_X0Y9_N4END[8] _4660_/X _0056_/X _0191_/Q _0190_/Q VPWR
+ VGND sg13cmos5l_mux4_1
XFILLER_564_21 VPWR VGND sg13cmos5l_decap_8
XFILLER_362_150 VPWR VGND sg13cmos5l_fill_2
X_0859_ _0859_/Q Tile_X0Y9_FrameData[4] VGND VPWR Tile_X0Y9_FrameStrobe[5] latch
X_3647_ AXI_M_SOC_AWADDR8 Tile_X0Y5_WW4END[0] Tile_X0Y5_WW4END[8] Tile_X0Y5_W6END[8]
+ _4459_/X _2255_/Q _2254_/Q VPWR VGND sg13cmos5l_mux4_1
XFILLER_20_49 VPWR VGND sg13cmos5l_decap_8
XFILLER_564_98 VPWR VGND sg13cmos5l_decap_8
XFILLER_136_49 VPWR VGND sg13cmos5l_decap_8
X_3578_ Tile_X0Y9_FrameData_O[8] Tile_X0Y9_FrameData[8] VPWR VGND sg13cmos5l_buf_1
XFILLER_121_109 VPWR VGND sg13cmos5l_decap_8
XFILLER_283_77 VPWR VGND sg13cmos5l_decap_8
XFILLER_714_57 VPWR VGND sg13cmos5l_decap_8
XFILLER_114_161 VPWR VGND sg13cmos5l_fill_1
X_2529_ _2529_/Q Tile_X0Y6_FrameData[6] VGND VPWR Tile_X0Y9_FrameStrobe[2] latch
XFILLER_433_14 VPWR VGND sg13cmos5l_decap_8
XANTENNA__3244__X Tile_X0Y0_FrameData_O[12] VPWR VGND sg13cmos5l_antennanp
XFILLER_29_14 VPWR VGND sg13cmos5l_decap_8
XFILLER_580_42 VPWR VGND sg13cmos5l_decap_8
XFILLER_665_195 VPWR VGND sg13cmos5l_fill_1
XFILLER_680_143 VPWR VGND sg13cmos5l_fill_2
XFILLER_290_105 VPWR VGND sg13cmos5l_decap_8
XFILLER_188_7 VPWR VGND sg13cmos5l_decap_8
XFILLER_513_91 VPWR VGND sg13cmos5l_decap_8
XFILLER_216_202 VPWR VGND sg13cmos5l_decap_8
XFILLER_680_187 VPWR VGND sg13cmos5l_decap_8
XFILLER_417_184 VPWR VGND sg13cmos5l_decap_8
XFILLER_232_70 VPWR VGND sg13cmos5l_decap_8
XFILLER_45_24 VPWR VGND sg13cmos5l_decap_8
XFILLER_355_7 VPWR VGND sg13cmos5l_decap_8
XFILLER_43_126 VPWR VGND sg13cmos5l_decap_8
XFILLER_432_154 VPWR VGND sg13cmos5l_decap_8
XFILLER_589_84 VPWR VGND sg13cmos5l_decap_8
XFILLER_578_147 VPWR VGND sg13cmos5l_decap_8
XANTENNA__0108__X AXI_M_SOC_ARBURST0 VPWR VGND sg13cmos5l_antennanp
XFILLER_522_7 VPWR VGND sg13cmos5l_decap_8
XFILLER_101_63 VPWR VGND sg13cmos5l_decap_4
XFILLER_196_142 VPWR VGND sg13cmos5l_decap_4
XFILLER_61_34 VPWR VGND sg13cmos5l_decap_8
XFILLER_458_77 VPWR VGND sg13cmos5l_fill_2
XFILLER_608_14 VPWR VGND sg13cmos5l_decap_8
XFILLER_177_56 VPWR VGND sg13cmos5l_decap_8
XANTENNA__3419__X Tile_X0Y4_FrameData_O[10] VPWR VGND sg13cmos5l_antennanp
XFILLER_474_21 VPWR VGND sg13cmos5l_decap_8
XFILLER_353_161 VPWR VGND sg13cmos5l_decap_8
XFILLER_499_154 VPWR VGND sg13cmos5l_decap_8
XFILLER_502_147 VPWR VGND sg13cmos5l_decap_8
XFILLER_624_35 VPWR VGND sg13cmos5l_decap_8
XFILLER_407_70 VPWR VGND sg13cmos5l_decap_8
XFILLER_112_109 VPWR VGND sg13cmos5l_fill_1
XFILLER_193_77 VPWR VGND sg13cmos5l_decap_8
XFILLER_343_14 VPWR VGND sg13cmos5l_decap_8
XANTENNA__3154__X Tile_X0Y7_FrameData_O[24] VPWR VGND sg13cmos5l_antennanp
XFILLER_656_140 VPWR VGND sg13cmos5l_decap_8
XFILLER_490_42 VPWR VGND sg13cmos5l_decap_8
XFILLER_86_42 VPWR VGND sg13cmos5l_decap_8
XFILLER_266_124 VPWR VGND sg13cmos5l_decap_8
XFILLER_120_142 VPWR VGND sg13cmos5l_decap_8
XFILLER_381_0 VPWR VGND sg13cmos5l_decap_8
XANTENNA__2993__X Tile_X0Y5_E1BEG[0] VPWR VGND sg13cmos5l_antennanp
XFILLER_479_0 VPWR VGND sg13cmos5l_decap_8
XFILLER_671_154 VPWR VGND sg13cmos5l_fill_2
XFILLER_281_105 VPWR VGND sg13cmos5l_decap_8
XFILLER_640_56 VPWR VGND sg13cmos5l_decap_8
XFILLER_423_91 VPWR VGND sg13cmos5l_decap_8
XFILLER_470_227 VPWR VGND sg13cmos5l_fill_2
XFILLER_19_156 VPWR VGND sg13cmos5l_fill_2
XFILLER_142_70 VPWR VGND sg13cmos5l_decap_8
XFILLER_646_0 VPWR VGND sg13cmos5l_decap_8
XFILLER_423_154 VPWR VGND sg13cmos5l_decap_8
XFILLER_569_147 VPWR VGND sg13cmos5l_decap_8
XFILLER_499_84 VPWR VGND sg13cmos5l_decap_8
XFILLER_423_165 VPWR VGND sg13cmos5l_fill_1
XFILLER_649_21 VPWR VGND sg13cmos5l_decap_8
X_1900_ _1900_/Q Tile_X0Y3_FrameData[29] VGND VPWR Tile_X0Y9_FrameStrobe[7] latch
X_2880_ Tile_X0Y6_FrameData_O[1] Tile_X0Y6_FrameData[1] VPWR VGND sg13cmos5l_buf_1
XFILLER_649_98 VPWR VGND sg13cmos5l_decap_8
XFILLER_187_153 VPWR VGND sg13cmos5l_decap_8
XFILLER_368_77 VPWR VGND sg13cmos5l_decap_8
X_1831_ _1831_/Q Tile_X0Y3_FrameData[2] VGND VPWR Tile_X0Y9_FrameStrobe[4] latch
XFILLER_525_206 VPWR VGND sg13cmos5l_decap_8
XFILLER_518_14 VPWR VGND sg13cmos5l_decap_8
XANTENNA__3329__X Tile_X0Y2_FrameData_O[0] VPWR VGND sg13cmos5l_antennanp
XFILLER_525_228 VPWR VGND sg13cmos5l_fill_1
XFILLER_665_42 VPWR VGND sg13cmos5l_decap_8
X_1762_ _1762_/Q Tile_X0Y3_FrameData[7] VGND VPWR Tile_X0Y9_FrameStrobe[2] latch
X_4550_ _4550_/X Tile_X0Y5_W1END[3] Tile_X0Y5_W6END[11] _4466_/X _4425_/X _2397_/Q
+ _2396_/Q VPWR VGND sg13cmos5l_mux4_1
XFILLER_384_21 VPWR VGND sg13cmos5l_decap_8
X_0713_ _0713_/Q Tile_X0Y9_FrameData[22] VGND VPWR Tile_X0Y9_FrameStrobe[1] latch
X_3501_ Tile_X0Y1_E6BEG[11] _3975_/X VPWR VGND sg13cmos5l_buf_1
X_1693_ _1693_/Q Tile_X0Y3_FrameData[12] VGND VPWR Tile_X0Y9_FrameStrobe[0] latch
X_4481_ _4481_/X Tile_X0Y7_W2MID[1] Tile_X0Y7_W2END[1] Tile_X0Y7_W6END[1] _4670_/X
+ _0395_/Q _0394_/Q VPWR VGND sg13cmos5l_mux4_1
XFILLER_344_172 VPWR VGND sg13cmos5l_decap_8
X_0644_ _0644_/Q Tile_X0Y8_FrameData[27] VGND VPWR Tile_X0Y9_FrameStrobe[7] latch
X_3432_ Tile_X0Y4_FrameData_O[23] Tile_X0Y4_FrameData[23] VPWR VGND sg13cmos5l_buf_1
XFILLER_534_35 VPWR VGND sg13cmos5l_decap_8
X_3363_ Tile_X0Y2_EE4BEG[2] _4058_/X VPWR VGND sg13cmos5l_buf_1
XFILLER_681_63 VPWR VGND sg13cmos5l_decap_8
XFILLER_253_14 VPWR VGND sg13cmos5l_decap_8
X_0575_ _0575_/Q Tile_X0Y8_FrameData[0] VGND VPWR Tile_X0Y9_FrameStrobe[4] latch
XANTENNA__3064__X Tile_X0Y5_FrameData_O[23] VPWR VGND sg13cmos5l_antennanp
XFILLER_647_140 VPWR VGND sg13cmos5l_decap_8
X_2314_ _2314_/Q Tile_X0Y5_FrameData[27] VGND VPWR Tile_X0Y9_FrameStrobe[4] latch
X_3294_ Tile_X0Y0_E2BEGb[2] _3814_/X VPWR VGND sg13cmos5l_buf_1
XFILLER_25_0 VPWR VGND sg13cmos5l_decap_8
X_2245_ _2245_/Q Tile_X0Y5_FrameData[0] VGND VPWR Tile_X0Y9_FrameStrobe[1] latch
XFILLER_403_28 VPWR VGND sg13cmos5l_decap_8
XFILLER_550_56 VPWR VGND sg13cmos5l_decap_8
X_2176_ _2176_/Q Tile_X0Y4_FrameData[5] VGND VPWR Tile_X0Y9_FrameStrobe[7] latch
XFILLER_603_221 VPWR VGND sg13cmos5l_decap_8
XFILLER_700_37 VPWR VGND sg13cmos5l_decap_8
X_1127_ _1127_/Q Tile_X0Y0_FrameData[4] VGND VPWR Tile_X0Y9_FrameStrobe[5] latch
XFILLER_559_21 VPWR VGND sg13cmos5l_decap_8
XFILLER_280_182 VPWR VGND sg13cmos5l_decap_8
X_1058_ _1058_/Q Tile_X0Y0_FrameData[9] VGND VPWR Tile_X0Y9_FrameStrobe[3] latch
XFILLER_202_84 VPWR VGND sg13cmos5l_decap_8
XFILLER_178_120 VPWR VGND sg13cmos5l_decap_8
XFILLER_15_49 VPWR VGND sg13cmos5l_decap_8
XFILLER_717_111 VPWR VGND sg13cmos5l_fill_2
XFILLER_559_98 VPWR VGND sg13cmos5l_decap_8
XFILLER_709_35 VPWR VGND sg13cmos5l_decap_8
XFILLER_590_109 VPWR VGND sg13cmos5l_fill_2
X_4817_ _4817_/X Tile_X0Y7_W2MID[6] Tile_X0Y7_W2END[6] Tile_X0Y7_W6END[9] _4671_/X
+ _0369_/Q _0368_/Q VPWR VGND sg13cmos5l_mux4_1
XFILLER_382_201 VPWR VGND sg13cmos5l_decap_4
XFILLER_278_77 VPWR VGND sg13cmos5l_decap_8
XFILLER_178_175 VPWR VGND sg13cmos5l_decap_8
XFILLER_428_14 VPWR VGND sg13cmos5l_decap_8
XFILLER_382_212 VPWR VGND sg13cmos5l_decap_8
XANTENNA__3239__X Tile_X0Y0_FrameData_O[7] VPWR VGND sg13cmos5l_antennanp
XFILLER_583_183 VPWR VGND sg13cmos5l_decap_8
XFILLER_516_228 VPWR VGND sg13cmos5l_fill_1
XFILLER_575_42 VPWR VGND sg13cmos5l_decap_8
X_4748_ _4748_/X Tile_X0Y8_WW4END[11] AXI_M_SOC_RDATA12 _4811_/X _4791_/X _0551_/Q
+ _0550_/Q VPWR VGND sg13cmos5l_mux4_1
XFILLER_294_21 VPWR VGND sg13cmos5l_decap_8
XFILLER_31_59 VPWR VGND sg13cmos5l_decap_8
X_4679_ _4679_/X _4227_/X _4231_/X _4235_/X _4208_/X _1862_/Q _1861_/Q VPWR VGND sg13cmos5l_mux4_1
XFILLER_335_183 VPWR VGND sg13cmos5l_decap_8
XFILLER_508_91 VPWR VGND sg13cmos5l_decap_8
XFILLER_103_7 VPWR VGND sg13cmos5l_decap_8
XFILLER_294_98 VPWR VGND sg13cmos5l_decap_8
XFILLER_444_35 VPWR VGND sg13cmos5l_decap_8
XFILLER_227_70 VPWR VGND sg13cmos5l_decap_8
XFILLER_591_63 VPWR VGND sg13cmos5l_decap_8
XFILLER_496_168 VPWR VGND sg13cmos5l_decap_8
XFILLER_163_14 VPWR VGND sg13cmos5l_decap_8
XFILLER_638_140 VPWR VGND sg13cmos5l_decap_8
XFILLER_102_153 VPWR VGND sg13cmos5l_decap_8
XFILLER_472_7 VPWR VGND sg13cmos5l_decap_8
XFILLER_313_28 VPWR VGND sg13cmos5l_decap_8
XFILLER_653_154 VPWR VGND sg13cmos5l_decap_8
XANTENNA__3702__X AXI_M_SOC_WDATA12 VPWR VGND sg13cmos5l_antennanp
XFILLER_56_45 VPWR VGND sg13cmos5l_decap_8
XFILLER_71_221 VPWR VGND sg13cmos5l_fill_1
XFILLER_469_21 VPWR VGND sg13cmos5l_decap_8
XFILLER_271_182 VPWR VGND sg13cmos5l_decap_8
XFILLER_112_84 VPWR VGND sg13cmos5l_decap_8
XFILLER_358_220 VPWR VGND sg13cmos5l_fill_1
XFILLER_31_129 VPWR VGND sg13cmos5l_fill_2
XFILLER_72_77 VPWR VGND sg13cmos5l_decap_8
XFILLER_708_133 VPWR VGND sg13cmos5l_decap_8
XFILLER_619_35 VPWR VGND sg13cmos5l_decap_8
XFILLER_188_77 VPWR VGND sg13cmos5l_decap_8
XFILLER_574_161 VPWR VGND sg13cmos5l_decap_8
XFILLER_338_14 VPWR VGND sg13cmos5l_decap_8
XANTENNA__3149__X Tile_X0Y7_FrameData_O[19] VPWR VGND sg13cmos5l_antennanp
XFILLER_507_228 VPWR VGND sg13cmos5l_fill_1
XFILLER_318_128 VPWR VGND sg13cmos5l_decap_4
XFILLER_485_42 VPWR VGND sg13cmos5l_decap_8
XFILLER_227_0 VPWR VGND sg13cmos5l_decap_8
XFILLER_333_109 VPWR VGND sg13cmos5l_decap_8
XANTENNA__2988__X Tile_X0Y8_FrameData_O[28] VPWR VGND sg13cmos5l_antennanp
XFILLER_635_56 VPWR VGND sg13cmos5l_decap_8
XFILLER_418_91 VPWR VGND sg13cmos5l_decap_8
XFILLER_21_70 VPWR VGND sg13cmos5l_decap_8
XFILLER_676_224 VPWR VGND sg13cmos5l_decap_4
XFILLER_354_35 VPWR VGND sg13cmos5l_decap_8
XFILLER_137_70 VPWR VGND sg13cmos5l_decap_8
XFILLER_596_0 VPWR VGND sg13cmos5l_decap_8
XFILLER_140_215 VPWR VGND sg13cmos5l_decap_4
XFILLER_97_63 VPWR VGND sg13cmos5l_decap_8
XFILLER_239_102 VPWR VGND sg13cmos5l_fill_2
X_0360_ _0360_/Q Tile_X0Y7_FrameData[23] VGND VPWR Tile_X0Y9_FrameStrobe[6] latch
XFILLER_504_49 VPWR VGND sg13cmos5l_decap_8
XFILLER_239_135 VPWR VGND sg13cmos5l_fill_1
XFILLER_651_77 VPWR VGND sg13cmos5l_decap_8
XFILLER_239_157 VPWR VGND sg13cmos5l_decap_8
XFILLER_223_28 VPWR VGND sg13cmos5l_decap_8
X_0291_ _0291_/Q Tile_X0Y7_FrameData[28] VGND VPWR Tile_X0Y9_FrameStrobe[4] latch
XFILLER_239_179 VPWR VGND sg13cmos5l_fill_1
XFILLER_644_154 VPWR VGND sg13cmos5l_decap_8
XFILLER_443_205 VPWR VGND sg13cmos5l_fill_1
XANTENNA__3612__X Tile_X0Y9_S2BEG[6] VPWR VGND sg13cmos5l_antennanp
XFILLER_370_56 VPWR VGND sg13cmos5l_decap_8
X_2030_ _2030_/Q Tile_X0Y4_FrameData[23] VGND VPWR Tile_X0Y9_FrameStrobe[3] latch
XFILLER_589_209 VPWR VGND sg13cmos5l_decap_8
XFILLER_379_21 VPWR VGND sg13cmos5l_decap_8
XFILLER_262_193 VPWR VGND sg13cmos5l_decap_4
X_3981_ _3981_/X Tile_X0Y2_W1END[0] Tile_X0Y2_W6END[4] _4113_/X _4084_/X _1673_/Q
+ _1672_/Q VPWR VGND sg13cmos5l_mux4_1
XFILLER_600_70 VPWR VGND sg13cmos5l_decap_8
XFILLER_411_135 VPWR VGND sg13cmos5l_fill_1
XFILLER_411_157 VPWR VGND sg13cmos5l_fill_2
X_2932_ Tile_X0Y8_E6BEG[0] _4760_/X VPWR VGND sg13cmos5l_buf_1
XFILLER_529_35 VPWR VGND sg13cmos5l_decap_8
XFILLER_676_63 VPWR VGND sg13cmos5l_decap_8
X_2863_ Tile_X0Y6_EE4BEG[0] _4512_/X VPWR VGND sg13cmos5l_buf_1
XFILLER_248_14 VPWR VGND sg13cmos5l_decap_8
XANTENNA__3059__X Tile_X0Y5_FrameData_O[18] VPWR VGND sg13cmos5l_antennanp
XFILLER_565_172 VPWR VGND sg13cmos5l_decap_8
XFILLER_30_162 VPWR VGND sg13cmos5l_fill_1
XFILLER_175_123 VPWR VGND sg13cmos5l_decap_8
XFILLER_565_183 VPWR VGND sg13cmos5l_fill_2
XFILLER_395_42 VPWR VGND sg13cmos5l_decap_8
XFILLER_175_134 VPWR VGND sg13cmos5l_fill_2
X_4602_ _4602_/X Tile_X0Y7_W1END[1] Tile_X0Y7_WW4END[13] Tile_X0Y7_W6END[5] _4685_/X
+ _0352_/Q _0351_/Q VPWR VGND sg13cmos5l_mux4_1
X_1814_ _1814_/Q Tile_X0Y3_FrameData[19] VGND VPWR Tile_X0Y9_FrameStrobe[4] latch
X_2794_ Tile_X0Y3_E6BEG[4] _4184_/X VPWR VGND sg13cmos5l_buf_1
XFILLER_190_104 VPWR VGND sg13cmos5l_decap_4
XFILLER_714_169 VPWR VGND sg13cmos5l_decap_8
XANTENNA__2898__X Tile_X0Y6_FrameData_O[19] VPWR VGND sg13cmos5l_antennanp
X_4533_ _4533_/X AXI_M_SOC_RDATA25 _4574_/X _4578_/X _4555_/X _2541_/Q _2540_/Q VPWR
+ VGND sg13cmos5l_mux4_1
XFILLER_580_175 VPWR VGND sg13cmos5l_decap_8
X_1745_ _1745_/Q Tile_X0Y3_FrameData[24] VGND VPWR Tile_X0Y9_FrameStrobe[2] latch
XFILLER_545_56 VPWR VGND sg13cmos5l_decap_8
XFILLER_317_194 VPWR VGND sg13cmos5l_fill_1
X_4464_ _4464_/X _4421_/X _0159_/X _4420_/X _0145_/X _2211_/Q _2210_/Q VPWR VGND sg13cmos5l_mux4_1
XFILLER_692_84 VPWR VGND sg13cmos5l_decap_8
X_1676_ _1676_/Q Tile_X0Y3_FrameData[29] VGND VPWR Tile_X0Y9_FrameStrobe[0] latch
XFILLER_264_35 VPWR VGND sg13cmos5l_decap_8
XFILLER_332_164 VPWR VGND sg13cmos5l_decap_8
X_3415_ Tile_X0Y4_FrameData_O[6] Tile_X0Y4_FrameData[6] VPWR VGND sg13cmos5l_buf_1
X_0627_ _0627_/Q Tile_X0Y8_FrameData[12] VGND VPWR Tile_X0Y9_FrameStrobe[6] latch
X_4395_ _4395_/X Tile_X0Y5_WW4END[8] AXI_M_SOC_RRESP1 _4459_/X _4467_/X _2313_/Q _2312_/Q
+ VPWR VGND sg13cmos5l_mux4_1
XFILLER_493_105 VPWR VGND sg13cmos5l_decap_8
XFILLER_478_179 VPWR VGND sg13cmos5l_decap_8
XFILLER_97_140 VPWR VGND sg13cmos5l_decap_8
X_0558_ _0558_/Q Tile_X0Y8_FrameData[17] VGND VPWR Tile_X0Y9_FrameStrobe[4] latch
X_3346_ Tile_X0Y2_FrameData_O[17] Tile_X0Y2_FrameData[17] VPWR VGND sg13cmos5l_buf_1
XFILLER_414_49 VPWR VGND sg13cmos5l_decap_8
XFILLER_561_77 VPWR VGND sg13cmos5l_decap_8
XFILLER_133_28 VPWR VGND sg13cmos5l_decap_8
XFILLER_711_14 VPWR VGND sg13cmos5l_decap_8
X_0489_ _0489_/Q Tile_X0Y8_FrameData[22] VGND VPWR Tile_X0Y9_FrameStrobe[2] latch
X_3277_ Tile_X0Y0_EE4BEG[13] _3833_/X VPWR VGND sg13cmos5l_buf_1
XFILLER_245_105 VPWR VGND sg13cmos5l_decap_8
XFILLER_280_56 VPWR VGND sg13cmos5l_decap_8
XANTENNA__3522__X Tile_X0Y9_E1BEG[0] VPWR VGND sg13cmos5l_antennanp
XFILLER_635_176 VPWR VGND sg13cmos5l_fill_1
X_2228_ _2228_/Q Tile_X0Y5_FrameData[17] VGND VPWR Tile_X0Y9_FrameStrobe[1] latch
XFILLER_238_190 VPWR VGND sg13cmos5l_decap_8
X_2159_ _2159_/Q Tile_X0Y4_FrameData[22] VGND VPWR Tile_X0Y9_FrameStrobe[7] latch
XFILLER_650_168 VPWR VGND sg13cmos5l_decap_8
XFILLER_253_160 VPWR VGND sg13cmos5l_decap_8
XFILLER_289_21 VPWR VGND sg13cmos5l_decap_8
XFILLER_399_164 VPWR VGND sg13cmos5l_fill_2
XFILLER_253_182 VPWR VGND sg13cmos5l_decap_8
XFILLER_510_70 VPWR VGND sg13cmos5l_decap_8
XFILLER_289_98 VPWR VGND sg13cmos5l_decap_8
XFILLER_439_35 VPWR VGND sg13cmos5l_decap_8
XFILLER_42_14 VPWR VGND sg13cmos5l_decap_8
XFILLER_586_63 VPWR VGND sg13cmos5l_decap_8
XFILLER_158_14 VPWR VGND sg13cmos5l_decap_8
XFILLER_220_7 VPWR VGND sg13cmos5l_decap_8
XFILLER_318_7 VPWR VGND sg13cmos5l_decap_8
XFILLER_308_161 VPWR VGND sg13cmos5l_decap_8
XANTENNA__0105__Y AXI_M_SOC_ARLEN4 VPWR VGND sg13cmos5l_antennanp
XFILLER_571_175 VPWR VGND sg13cmos5l_decap_8
XFILLER_308_28 VPWR VGND sg13cmos5l_decap_8
XFILLER_308_172 VPWR VGND sg13cmos5l_fill_1
XFILLER_455_56 VPWR VGND sg13cmos5l_decap_8
XFILLER_455_67 VPWR VGND sg13cmos5l_fill_1
XFILLER_455_89 VPWR VGND sg13cmos5l_decap_8
XFILLER_174_35 VPWR VGND sg13cmos5l_decap_8
XFILLER_323_164 VPWR VGND sg13cmos5l_decap_4
XFILLER_687_7 VPWR VGND sg13cmos5l_decap_8
XFILLER_324_49 VPWR VGND sg13cmos5l_decap_8
XFILLER_471_77 VPWR VGND sg13cmos5l_decap_8
XFILLER_621_14 VPWR VGND sg13cmos5l_decap_8
XFILLER_67_77 VPWR VGND sg13cmos5l_fill_1
XFILLER_291_200 VPWR VGND sg13cmos5l_decap_8
XFILLER_190_56 VPWR VGND sg13cmos5l_decap_4
XANTENNA__3432__X Tile_X0Y4_FrameData_O[23] VPWR VGND sg13cmos5l_antennanp
XFILLER_291_211 VPWR VGND sg13cmos5l_fill_2
XFILLER_492_182 VPWR VGND sg13cmos5l_fill_1
XFILLER_340_26 VPWR VGND sg13cmos5l_decap_8
XFILLER_83_21 VPWR VGND sg13cmos5l_decap_8
XFILLER_177_0 VPWR VGND sg13cmos5l_decap_8
XFILLER_641_168 VPWR VGND sg13cmos5l_decap_8
XFILLER_701_91 VPWR VGND sg13cmos5l_decap_8
XFILLER_199_21 VPWR VGND sg13cmos5l_decap_8
XFILLER_594_212 VPWR VGND sg13cmos5l_decap_4
XFILLER_420_70 VPWR VGND sg13cmos5l_decap_8
XFILLER_83_98 VPWR VGND sg13cmos5l_fill_1
XFILLER_344_0 VPWR VGND sg13cmos5l_decap_8
XFILLER_16_70 VPWR VGND sg13cmos5l_decap_8
XFILLER_199_98 VPWR VGND sg13cmos5l_decap_8
XFILLER_349_35 VPWR VGND sg13cmos5l_decap_8
XFILLER_496_63 VPWR VGND sg13cmos5l_decap_8
XFILLER_157_112 VPWR VGND sg13cmos5l_decap_8
XFILLER_511_0 VPWR VGND sg13cmos5l_decap_8
XFILLER_609_0 VPWR VGND sg13cmos5l_decap_8
XFILLER_32_80 VPWR VGND sg13cmos5l_decap_8
XFILLER_646_77 VPWR VGND sg13cmos5l_decap_8
XFILLER_218_28 VPWR VGND sg13cmos5l_decap_8
XFILLER_172_137 VPWR VGND sg13cmos5l_decap_8
XFILLER_365_56 VPWR VGND sg13cmos5l_decap_8
XFILLER_148_91 VPWR VGND sg13cmos5l_decap_8
XANTENNA__3607__X Tile_X0Y9_S2BEG[1] VPWR VGND sg13cmos5l_antennanp
XFILLER_649_202 VPWR VGND sg13cmos5l_decap_8
XFILLER_172_159 VPWR VGND sg13cmos5l_fill_2
X_1530_ _1530_/Q Tile_X0Y2_FrameData[23] VGND VPWR Tile_X0Y9_FrameStrobe[3] latch
XFILLER_662_21 VPWR VGND sg13cmos5l_decap_8
X_1461_ _1461_/Q Tile_X0Y2_FrameData[28] VGND VPWR Tile_X0Y9_FrameStrobe[1] latch
XFILLER_259_208 VPWR VGND sg13cmos5l_decap_8
XFILLER_180_181 VPWR VGND sg13cmos5l_decap_8
X_0412_ _0412_/Q Tile_X0Y7_FrameData[3] VGND VPWR Tile_X0Y9_FrameStrobe[7] latch
X_3200_ Tile_X0Y0_N2BEG[0] _3784_/X VPWR VGND sg13cmos5l_buf_1
XFILLER_664_216 VPWR VGND sg13cmos5l_fill_1
X_1392_ _1392_/Q Tile_X0Y1_FrameData[9] VGND VPWR Tile_X0Y9_FrameStrobe[6] latch
X_4180_ _4180_/X _0089_/X Tile_X0Y0_S4END[12] _4233_/X _4212_/X _1781_/Q _1780_/Q
+ VPWR VGND sg13cmos5l_mux4_1
XFILLER_662_98 VPWR VGND sg13cmos5l_decap_8
XFILLER_234_49 VPWR VGND sg13cmos5l_decap_8
XFILLER_381_77 VPWR VGND sg13cmos5l_decap_8
X_0343_ _0343_/Q Tile_X0Y7_FrameData[8] VGND VPWR Tile_X0Y9_FrameStrobe[5] latch
X_3131_ Tile_X0Y7_FrameData_O[1] Tile_X0Y7_FrameData[1] VPWR VGND sg13cmos5l_buf_1
XFILLER_531_14 VPWR VGND sg13cmos5l_decap_8
XANTENNA__3342__X Tile_X0Y2_FrameData_O[13] VPWR VGND sg13cmos5l_antennanp
XFILLER_490_119 VPWR VGND sg13cmos5l_decap_8
XFILLER_94_143 VPWR VGND sg13cmos5l_decap_8
XFILLER_617_176 VPWR VGND sg13cmos5l_decap_8
X_3062_ Tile_X0Y5_FrameData_O[21] Tile_X0Y5_FrameData[21] VPWR VGND sg13cmos5l_buf_1
XFILLER_483_182 VPWR VGND sg13cmos5l_decap_8
X_0274_ _0274_/Q Tile_X0Y7_FrameData[13] VGND VPWR Tile_X0Y9_FrameStrobe[3] latch
XFILLER_94_187 VPWR VGND sg13cmos5l_decap_8
X_2013_ _2013_/Q Tile_X0Y4_FrameData[8] VGND VPWR Tile_X0Y9_FrameStrobe[2] latch
XFILLER_242_119 VPWR VGND sg13cmos5l_decap_8
XFILLER_611_91 VPWR VGND sg13cmos5l_decap_8
XFILLER_330_70 VPWR VGND sg13cmos5l_decap_8
XFILLER_330_92 VPWR VGND sg13cmos5l_decap_8
X_3964_ _3964_/X _0073_/X Tile_X0Y0_S4END[4] _4019_/X _3996_/X _1281_/Q _1280_/Q VPWR
+ VGND sg13cmos5l_mux4_1
XFILLER_687_84 VPWR VGND sg13cmos5l_decap_8
XFILLER_92_0 VPWR VGND sg13cmos5l_decap_8
XFILLER_396_167 VPWR VGND sg13cmos5l_decap_8
XFILLER_259_35 VPWR VGND sg13cmos5l_decap_8
XFILLER_250_185 VPWR VGND sg13cmos5l_decap_8
X_2915_ Tile_X0Y8_E1BEG[3] _4727_/X VPWR VGND sg13cmos5l_buf_1
X_3895_ _3895_/X Tile_X0Y1_W2MID[4] Tile_X0Y1_W2END[4] Tile_X0Y1_W6END[4] _3995_/X
+ _1411_/Q _1410_/Q VPWR VGND sg13cmos5l_mux4_1
XFILLER_538_194 VPWR VGND sg13cmos5l_fill_2
X_2846_ Tile_X0Y6_E2BEGb[3] _4507_/X VPWR VGND sg13cmos5l_buf_1
XFILLER_409_49 VPWR VGND sg13cmos5l_decap_8
XFILLER_12_28 VPWR VGND sg13cmos5l_decap_8
XFILLER_556_77 VPWR VGND sg13cmos5l_decap_8
XFILLER_128_28 VPWR VGND sg13cmos5l_decap_8
XFILLER_706_14 VPWR VGND sg13cmos5l_decap_8
XFILLER_498_208 VPWR VGND sg13cmos5l_decap_4
X_2777_ Tile_X0Y3_EE4BEG[3] _4167_/X VPWR VGND sg13cmos5l_buf_1
XFILLER_699_179 VPWR VGND sg13cmos5l_fill_2
XFILLER_275_56 VPWR VGND sg13cmos5l_decap_8
XANTENNA__3517__X Tile_X0Y1_E2BEG[7] VPWR VGND sg13cmos5l_antennanp
X_4516_ _4516_/X Tile_X0Y6_WW4END[11] AXI_M_SOC_RDATA28 _4579_/X _4559_/X _2575_/Q
+ _2574_/Q VPWR VGND sg13cmos5l_mux4_1
X_1728_ _1728_/Q Tile_X0Y3_FrameData[9] VGND VPWR Tile_X0Y9_FrameStrobe[1] latch
XFILLER_572_21 VPWR VGND sg13cmos5l_decap_8
XFILLER_305_153 VPWR VGND sg13cmos5l_decap_4
XFILLER_104_226 VPWR VGND sg13cmos5l_fill_2
XFILLER_710_161 VPWR VGND sg13cmos5l_decap_8
X_4447_ _4447_/X Tile_X0Y1_W1END[3] Tile_X0Y1_WW4END[15] Tile_X0Y1_W6END[7] _4011_/X
+ _1356_/Q _1355_/Q VPWR VGND sg13cmos5l_mux4_1
XFILLER_305_186 VPWR VGND sg13cmos5l_fill_2
X_1659_ _1659_/Q Tile_X0Y2_FrameData[22] VGND VPWR Tile_X0Y9_FrameStrobe[7] latch
XFILLER_171_192 VPWR VGND sg13cmos5l_decap_4
XFILLER_572_98 VPWR VGND sg13cmos5l_decap_8
X_4378_ _4378_/X Tile_X0Y5_W2MID[1] AXI_M_SOC_RRESP0 _4430_/X _4429_/X _2347_/Q _2346_/Q
+ VPWR VGND sg13cmos5l_mux4_1
XFILLER_466_149 VPWR VGND sg13cmos5l_fill_2
XFILLER_144_49 VPWR VGND sg13cmos5l_decap_8
XFILLER_505_70 VPWR VGND sg13cmos5l_decap_8
XFILLER_291_77 VPWR VGND sg13cmos5l_decap_8
X_3329_ Tile_X0Y2_FrameData_O[0] Tile_X0Y2_FrameData[0] VPWR VGND sg13cmos5l_buf_1
XFILLER_441_14 VPWR VGND sg13cmos5l_decap_8
XFILLER_481_119 VPWR VGND sg13cmos5l_decap_4
XFILLER_218_105 VPWR VGND sg13cmos5l_fill_1
XANTENNA__3252__X Tile_X0Y0_FrameData_O[20] VPWR VGND sg13cmos5l_antennanp
XFILLER_623_157 VPWR VGND sg13cmos5l_fill_2
XFILLER_170_7 VPWR VGND sg13cmos5l_decap_8
XFILLER_268_7 VPWR VGND sg13cmos5l_fill_2
XFILLER_387_101 VPWR VGND sg13cmos5l_decap_4
XFILLER_241_130 VPWR VGND sg13cmos5l_decap_8
XFILLER_53_35 VPWR VGND sg13cmos5l_decap_8
XFILLER_435_7 VPWR VGND sg13cmos5l_decap_8
XFILLER_597_84 VPWR VGND sg13cmos5l_decap_8
XFILLER_169_35 VPWR VGND sg13cmos5l_decap_8
XFILLER_387_189 VPWR VGND sg13cmos5l_decap_8
XFILLER_139_112 VPWR VGND sg13cmos5l_decap_8
XFILLER_602_7 VPWR VGND sg13cmos5l_decap_8
XFILLER_544_120 VPWR VGND sg13cmos5l_fill_1
XFILLER_319_49 VPWR VGND sg13cmos5l_decap_8
XFILLER_139_189 VPWR VGND sg13cmos5l_fill_2
XFILLER_343_215 VPWR VGND sg13cmos5l_fill_1
XFILLER_616_14 VPWR VGND sg13cmos5l_decap_8
XFILLER_154_137 VPWR VGND sg13cmos5l_decap_8
XANTENNA__3427__X Tile_X0Y4_FrameData_O[18] VPWR VGND sg13cmos5l_antennanp
XFILLER_185_56 VPWR VGND sg13cmos5l_decap_4
XFILLER_154_159 VPWR VGND sg13cmos5l_fill_2
XFILLER_482_21 VPWR VGND sg13cmos5l_decap_8
XFILLER_78_21 VPWR VGND sg13cmos5l_decap_8
XFILLER_162_170 VPWR VGND sg13cmos5l_decap_8
XFILLER_482_98 VPWR VGND sg13cmos5l_decap_8
XFILLER_110_207 VPWR VGND sg13cmos5l_fill_1
XFILLER_632_35 VPWR VGND sg13cmos5l_decap_8
XFILLER_415_70 VPWR VGND sg13cmos5l_decap_8
XFILLER_78_98 VPWR VGND sg13cmos5l_decap_8
XFILLER_294_0 VPWR VGND sg13cmos5l_decap_8
XFILLER_351_14 VPWR VGND sg13cmos5l_decap_8
XFILLER_209_105 VPWR VGND sg13cmos5l_decap_8
XANTENNA__3162__X Tile_X0Y7_UserCLKo VPWR VGND sg13cmos5l_antennanp
XFILLER_94_42 VPWR VGND sg13cmos5l_decap_8
XFILLER_465_193 VPWR VGND sg13cmos5l_decap_8
XFILLER_461_0 VPWR VGND sg13cmos5l_decap_8
XFILLER_559_0 VPWR VGND sg13cmos5l_decap_8
XFILLER_501_28 VPWR VGND sg13cmos5l_decap_8
XFILLER_91_146 VPWR VGND sg13cmos5l_decap_8
XFILLER_431_91 VPWR VGND sg13cmos5l_decap_8
XFILLER_27_91 VPWR VGND sg13cmos5l_fill_2
XFILLER_378_112 VPWR VGND sg13cmos5l_decap_8
XFILLER_150_70 VPWR VGND sg13cmos5l_decap_8
XFILLER_622_190 VPWR VGND sg13cmos5l_decap_8
XFILLER_232_141 VPWR VGND sg13cmos5l_decap_8
XFILLER_232_185 VPWR VGND sg13cmos5l_fill_1
XFILLER_657_21 VPWR VGND sg13cmos5l_decap_8
X_0961_ _0961_/Q Tile_X0Y0_FrameData[10] VGND VPWR Tile_X0Y9_FrameStrobe[0] latch
XFILLER_300_84 VPWR VGND sg13cmos5l_decap_4
XFILLER_319_223 VPWR VGND sg13cmos5l_decap_4
X_2700_ _3976_/A3 VPWR VGND sg13cmos5l_tielo
X_3680_ _3680_/X Tile_X0Y2_WW4END[2] Tile_X0Y2_WW4END[10] Tile_X0Y2_W6END[10] _4126_/X
+ _1485_/Q _1484_/Q VPWR VGND sg13cmos5l_mux4_1
XFILLER_657_98 VPWR VGND sg13cmos5l_decap_8
X_0892_ _0892_/Q Tile_X0Y9_FrameData[3] VGND VPWR Tile_X0Y9_FrameStrobe[6] latch
XFILLER_229_49 VPWR VGND sg13cmos5l_decap_8
X_2631_ _2631_/Q Tile_X0Y6_FrameData[0] VGND VPWR Tile_X0Y9_FrameStrobe[5] latch
XFILLER_550_112 VPWR VGND sg13cmos5l_decap_4
XFILLER_526_14 VPWR VGND sg13cmos5l_decap_8
XFILLER_376_88 VPWR VGND sg13cmos5l_fill_2
XANTENNA__3337__X Tile_X0Y2_FrameData_O[8] VPWR VGND sg13cmos5l_antennanp
XFILLER_696_105 VPWR VGND sg13cmos5l_decap_8
XFILLER_673_42 VPWR VGND sg13cmos5l_decap_8
X_2562_ _2562_/Q Tile_X0Y6_FrameData[5] VGND VPWR Tile_X0Y9_FrameStrobe[3] latch
XFILLER_392_21 VPWR VGND sg13cmos5l_decap_8
XFILLER_160_118 VPWR VGND sg13cmos5l_decap_8
XFILLER_299_141 VPWR VGND sg13cmos5l_decap_4
X_4301_ _4301_/X Tile_X0Y3_W1END[0] Tile_X0Y3_W6END[8] _4234_/X _4198_/X _1889_/Q
+ _1888_/Q VPWR VGND sg13cmos5l_mux4_1
X_1513_ _1513_/Q Tile_X0Y2_FrameData[8] VGND VPWR Tile_X0Y9_FrameStrobe[2] latch
X_2493_ _2493_/Q Tile_X0Y6_FrameData[10] VGND VPWR Tile_X0Y9_FrameStrobe[1] latch
XFILLER_606_91 VPWR VGND sg13cmos5l_decap_8
X_4232_ _4232_/X _4200_/X _0087_/X _4199_/X Tile_X0Y0_S4END[14] _1709_/Q _1708_/Q
+ VPWR VGND sg13cmos5l_mux4_1
XFILLER_637_227 VPWR VGND sg13cmos5l_fill_2
X_1444_ _1444_/Q Tile_X0Y2_FrameData[13] VGND VPWR Tile_X0Y9_FrameStrobe[0] latch
XFILLER_302_156 VPWR VGND sg13cmos5l_decap_8
XFILLER_542_35 VPWR VGND sg13cmos5l_decap_8
XFILLER_4_84 VPWR VGND sg13cmos5l_decap_8
XFILLER_302_178 VPWR VGND sg13cmos5l_decap_4
X_1375_ _1375_/Q Tile_X0Y1_FrameData[26] VGND VPWR Tile_X0Y9_FrameStrobe[6] latch
X_4163_ _4163_/X Tile_X0Y3_W2END[0] AXI_M_SOC_WREADY _4205_/X _4204_/X _1815_/Q _1814_/Q
+ VPWR VGND sg13cmos5l_mux4_1
XFILLER_67_121 VPWR VGND sg13cmos5l_decap_8
XFILLER_261_14 VPWR VGND sg13cmos5l_decap_8
XANTENNA__3072__X Tile_X0Y5_FrameData_O[31] VPWR VGND sg13cmos5l_antennanp
X_0326_ _0326_/Q Tile_X0Y7_FrameData[25] VGND VPWR Tile_X0Y9_FrameStrobe[5] latch
X_3114_ Tile_X0Y7_EE4BEG[0] _4628_/X VPWR VGND sg13cmos5l_buf_1
X_4094_ _4094_/X Tile_X0Y1_W1END[3] Tile_X0Y1_W6END[11] _3996_/X _3979_/X _1383_/Q
+ _1382_/Q VPWR VGND sg13cmos5l_mux4_1
XFILLER_82_124 VPWR VGND sg13cmos5l_fill_2
XFILLER_67_198 VPWR VGND sg13cmos5l_decap_8
XFILLER_411_28 VPWR VGND sg13cmos5l_decap_8
X_0257_ _0257_/Q Tile_X0Y7_FrameData[30] VGND VPWR Tile_X0Y9_FrameStrobe[3] latch
X_3045_ Tile_X0Y5_FrameData_O[4] Tile_X0Y5_FrameData[4] VPWR VGND sg13cmos5l_buf_1
XFILLER_215_119 VPWR VGND sg13cmos5l_decap_8
XFILLER_620_105 VPWR VGND sg13cmos5l_decap_4
XFILLER_82_168 VPWR VGND sg13cmos5l_decap_4
XFILLER_208_182 VPWR VGND sg13cmos5l_decap_8
XFILLER_82_179 VPWR VGND sg13cmos5l_decap_8
X_0188_ _0188_/Q Tile_X0Y7_FrameData[3] VGND VPWR Tile_X0Y9_FrameStrobe[0] latch
XFILLER_369_112 VPWR VGND sg13cmos5l_decap_8
XFILLER_223_163 VPWR VGND sg13cmos5l_fill_2
XFILLER_567_21 VPWR VGND sg13cmos5l_decap_8
X_3947_ _3947_/X Tile_X0Y1_W2END[0] AXI_M_SOC_ARREADY _3989_/X _3988_/X _1315_/Q _1314_/Q
+ VPWR VGND sg13cmos5l_mux4_1
XFILLER_210_84 VPWR VGND sg13cmos5l_decap_8
XFILLER_23_49 VPWR VGND sg13cmos5l_decap_8
XFILLER_567_98 VPWR VGND sg13cmos5l_decap_8
X_3878_ _3878_/X _4343_/X _4347_/X _4351_/X _4319_/X _2148_/Q _2147_/Q VPWR VGND sg13cmos5l_mux4_1
XFILLER_139_49 VPWR VGND sg13cmos5l_decap_8
XFILLER_286_77 VPWR VGND sg13cmos5l_decap_8
XFILLER_136_126 VPWR VGND sg13cmos5l_decap_8
X_2829_ Tile_X0Y4_E2BEG[7] _4263_/X VPWR VGND sg13cmos5l_buf_1
XFILLER_436_14 VPWR VGND sg13cmos5l_decap_8
XANTENNA__3247__X Tile_X0Y0_FrameData_O[15] VPWR VGND sg13cmos5l_antennanp
XFILLER_392_192 VPWR VGND sg13cmos5l_decap_4
XFILLER_583_42 VPWR VGND sg13cmos5l_decap_8
XFILLER_541_134 VPWR VGND sg13cmos5l_decap_4
XFILLER_2_117 VPWR VGND sg13cmos5l_decap_4
XFILLER_541_189 VPWR VGND sg13cmos5l_decap_8
XFILLER_439_105 VPWR VGND sg13cmos5l_decap_8
XFILLER_516_91 VPWR VGND sg13cmos5l_decap_8
XFILLER_452_35 VPWR VGND sg13cmos5l_decap_8
XFILLER_235_70 VPWR VGND sg13cmos5l_decap_8
XFILLER_48_24 VPWR VGND sg13cmos5l_decap_8
XFILLER_171_14 VPWR VGND sg13cmos5l_decap_8
XFILLER_385_7 VPWR VGND sg13cmos5l_decap_8
XFILLER_447_182 VPWR VGND sg13cmos5l_decap_4
XFILLER_602_49 VPWR VGND sg13cmos5l_decap_8
XFILLER_58_187 VPWR VGND sg13cmos5l_decap_8
XFILLER_552_7 VPWR VGND sg13cmos5l_decap_8
XFILLER_321_28 VPWR VGND sg13cmos5l_decap_8
XFILLER_104_63 VPWR VGND sg13cmos5l_decap_8
XFILLER_206_119 VPWR VGND sg13cmos5l_decap_8
XANTENNA__3710__X AXI_M_SOC_WDATA20 VPWR VGND sg13cmos5l_antennanp
XFILLER_64_56 VPWR VGND sg13cmos5l_decap_8
XFILLER_477_21 VPWR VGND sg13cmos5l_decap_8
XFILLER_214_196 VPWR VGND sg13cmos5l_decap_8
XFILLER_120_84 VPWR VGND sg13cmos5l_decap_8
XFILLER_80_66 VPWR VGND sg13cmos5l_decap_8
XFILLER_196_33 VPWR VGND sg13cmos5l_decap_8
XFILLER_390_107 VPWR VGND sg13cmos5l_decap_8
XFILLER_80_88 VPWR VGND sg13cmos5l_decap_8
XFILLER_627_35 VPWR VGND sg13cmos5l_decap_8
XFILLER_346_14 VPWR VGND sg13cmos5l_decap_8
XANTENNA__3157__X Tile_X0Y7_FrameData_O[27] VPWR VGND sg13cmos5l_antennanp
XFILLER_678_105 VPWR VGND sg13cmos5l_decap_8
XFILLER_493_42 VPWR VGND sg13cmos5l_decap_8
XFILLER_307_0 VPWR VGND sg13cmos5l_decap_8
XFILLER_89_42 VPWR VGND sg13cmos5l_decap_8
XFILLER_331_218 VPWR VGND sg13cmos5l_decap_8
XANTENNA__2996__X Tile_X0Y5_E1BEG[3] VPWR VGND sg13cmos5l_antennanp
XFILLER_89_86 VPWR VGND sg13cmos5l_decap_8
XFILLER_693_119 VPWR VGND sg13cmos5l_decap_8
XFILLER_485_200 VPWR VGND sg13cmos5l_fill_1
XFILLER_643_56 VPWR VGND sg13cmos5l_decap_8
XFILLER_686_171 VPWR VGND sg13cmos5l_fill_1
XFILLER_485_222 VPWR VGND sg13cmos5l_decap_8
XFILLER_426_91 VPWR VGND sg13cmos5l_decap_8
XFILLER_686_193 VPWR VGND sg13cmos5l_decap_4
XFILLER_362_35 VPWR VGND sg13cmos5l_decap_8
XFILLER_145_70 VPWR VGND sg13cmos5l_decap_8
XFILLER_676_0 VPWR VGND sg13cmos5l_decap_8
XFILLER_634_208 VPWR VGND sg13cmos5l_decap_4
XFILLER_29_7 VPWR VGND sg13cmos5l_decap_8
X_1160_ _1160_/Q Tile_X0Y0_FrameData[3] VGND VPWR Tile_X0Y9_FrameStrobe[6] latch
XFILLER_438_182 VPWR VGND sg13cmos5l_decap_4
XFILLER_512_49 VPWR VGND sg13cmos5l_decap_8
XFILLER_64_113 VPWR VGND sg13cmos5l_decap_8
XFILLER_49_187 VPWR VGND sg13cmos5l_fill_2
X_0111_ _0111_/X _4324_/X _4325_/X _1112_/Q VPWR VGND sg13cmos5l_mux2_1
XFILLER_231_28 VPWR VGND sg13cmos5l_decap_8
X_1091_ _1091_/Q Tile_X0Y0_FrameData[8] VGND VPWR Tile_X0Y9_FrameStrobe[4] latch
XFILLER_64_157 VPWR VGND sg13cmos5l_decap_8
XFILLER_398_218 VPWR VGND sg13cmos5l_decap_8
XANTENNA__3620__X Tile_X0Y9_S2BEGb[6] VPWR VGND sg13cmos5l_antennanp
X_0042_ _3631_/A _4718_/X _4719_/X _0606_/Q VPWR VGND sg13cmos5l_mux2_1
XFILLER_668_42 VPWR VGND sg13cmos5l_decap_8
XFILLER_72_190 VPWR VGND sg13cmos5l_fill_2
X_4850_ _4850_/X Tile_X0Y9_W2MID[5] AXI_M_SOC_RDATA2 _4905_/X _4904_/X _0843_/Q _0842_/Q
+ VPWR VGND sg13cmos5l_mux4_1
XFILLER_387_21 VPWR VGND sg13cmos5l_decap_8
X_3801_ _3801_/X _3849_/X Tile_X0Y0_W2END[4] Tile_X0Y0_W2END[5] Tile_X0Y0_S1END[1]
+ _1103_/Q _1102_/Q VPWR VGND sg13cmos5l_mux4_1
XFILLER_366_126 VPWR VGND sg13cmos5l_fill_1
X_4781_ _4781_/X Tile_X0Y9_W1END[2] Tile_X0Y9_W6END[6] _4930_/X _4894_/X _0923_/Q
+ _0922_/Q VPWR VGND sg13cmos5l_mux4_1
X_1993_ _1993_/Q Tile_X0Y4_FrameData[28] VGND VPWR Tile_X0Y9_FrameStrobe[2] latch
XFILLER_366_159 VPWR VGND sg13cmos5l_fill_2
X_3732_ AXI_M_SOC_ARADDR4 Tile_X0Y9_WW4END[4] Tile_X0Y9_WW4END[12] Tile_X0Y9_W6END[4]
+ _4920_/X _0751_/Q _0750_/Q VPWR VGND sg13cmos5l_mux4_1
X_0944_ _0944_/Q Tile_X0Y0_FrameData[27] VGND VPWR Tile_X0Y9_FrameStrobe[0] latch
XFILLER_537_35 VPWR VGND sg13cmos5l_decap_8
XFILLER_118_104 VPWR VGND sg13cmos5l_decap_8
XFILLER_684_63 VPWR VGND sg13cmos5l_decap_8
XFILLER_508_175 VPWR VGND sg13cmos5l_decap_8
X_3663_ AXI_M_SOC_AWADDR24 Tile_X0Y4_WW4END[0] Tile_X0Y4_WW4END[8] Tile_X0Y4_W6END[8]
+ _4344_/X _1997_/Q _1996_/Q VPWR VGND sg13cmos5l_mux4_1
XFILLER_374_181 VPWR VGND sg13cmos5l_fill_2
XFILLER_256_14 VPWR VGND sg13cmos5l_decap_8
XANTENNA__3067__X Tile_X0Y5_FrameData_O[26] VPWR VGND sg13cmos5l_antennanp
X_0875_ _0875_/Q Tile_X0Y9_FrameData[20] VGND VPWR Tile_X0Y9_FrameStrobe[6] latch
XFILLER_523_123 VPWR VGND sg13cmos5l_fill_1
X_2614_ _2614_/Q Tile_X0Y6_FrameData[17] VGND VPWR Tile_X0Y9_FrameStrobe[5] latch
X_3594_ Tile_X0Y9_FrameData_O[24] Tile_X0Y9_FrameData[24] VPWR VGND sg13cmos5l_buf_1
XFILLER_55_0 VPWR VGND sg13cmos5l_decap_4
XFILLER_126_170 VPWR VGND sg13cmos5l_fill_2
X_2545_ _2545_/Q Tile_X0Y6_FrameData[22] VGND VPWR Tile_X0Y9_FrameStrobe[3] latch
XFILLER_406_28 VPWR VGND sg13cmos5l_decap_8
XFILLER_476_200 VPWR VGND sg13cmos5l_decap_8
XFILLER_476_211 VPWR VGND sg13cmos5l_fill_2
XFILLER_553_56 VPWR VGND sg13cmos5l_decap_8
XFILLER_336_91 VPWR VGND sg13cmos5l_decap_8
XFILLER_287_122 VPWR VGND sg13cmos5l_decap_4
XFILLER_141_140 VPWR VGND sg13cmos5l_decap_8
X_2476_ _2476_/Q Tile_X0Y6_FrameData[27] VGND VPWR Tile_X0Y9_FrameStrobe[1] latch
XFILLER_272_35 VPWR VGND sg13cmos5l_decap_8
XFILLER_287_155 VPWR VGND sg13cmos5l_decap_8
X_4215_ _4215_/X _4200_/X _0087_/X _4199_/X Tile_X0Y0_S4END[14] _1701_/Q _1700_/Q
+ VPWR VGND sg13cmos5l_mux4_1
X_1427_ _1427_/Q Tile_X0Y2_FrameData[30] VGND VPWR Tile_X0Y9_FrameStrobe[0] latch
XFILLER_436_119 VPWR VGND sg13cmos5l_decap_4
XFILLER_491_225 VPWR VGND sg13cmos5l_decap_4
XFILLER_429_182 VPWR VGND sg13cmos5l_decap_8
X_4146_ _4146_/X _4200_/X _4199_/X AXI_M_SOC_BVALID _4198_/X _1849_/Q _1848_/Q VPWR
+ VGND sg13cmos5l_mux4_1
X_1358_ _1358_/Q Tile_X0Y1_FrameData[11] VGND VPWR Tile_X0Y9_FrameStrobe[5] latch
XFILLER_422_49 VPWR VGND sg13cmos5l_decap_8
XFILLER_205_84 VPWR VGND sg13cmos5l_decap_8
XFILLER_18_49 VPWR VGND sg13cmos5l_decap_8
XFILLER_141_28 VPWR VGND sg13cmos5l_decap_8
X_0309_ _0309_/Q Tile_X0Y7_FrameData[10] VGND VPWR Tile_X0Y9_FrameStrobe[4] latch
X_4077_ _4077_/X AXI_M_SOC_AWREADY _4122_/X _4126_/X _4099_/X _1519_/Q _1518_/Q VPWR
+ VGND sg13cmos5l_mux4_1
XFILLER_55_146 VPWR VGND sg13cmos5l_decap_8
X_1289_ _1289_/Q Tile_X0Y1_FrameData[16] VGND VPWR Tile_X0Y9_FrameStrobe[3] latch
XANTENNA__3530__X Tile_X0Y9_E2BEG[4] VPWR VGND sg13cmos5l_antennanp
XFILLER_70_105 VPWR VGND sg13cmos5l_decap_8
X_3028_ Tile_X0Y5_EE4BEG[3] _4391_/X VPWR VGND sg13cmos5l_buf_1
XFILLER_578_42 VPWR VGND sg13cmos5l_decap_8
XFILLER_601_160 VPWR VGND sg13cmos5l_fill_1
XFILLER_297_21 VPWR VGND sg13cmos5l_decap_8
XFILLER_601_182 VPWR VGND sg13cmos5l_fill_1
XFILLER_211_133 VPWR VGND sg13cmos5l_decap_4
XFILLER_357_126 VPWR VGND sg13cmos5l_decap_8
XFILLER_211_177 VPWR VGND sg13cmos5l_decap_8
XFILLER_133_7 VPWR VGND sg13cmos5l_decap_8
XFILLER_447_35 VPWR VGND sg13cmos5l_decap_8
XFILLER_50_36 VPWR VGND sg13cmos5l_decap_8
XFILLER_594_63 VPWR VGND sg13cmos5l_decap_8
XFILLER_166_14 VPWR VGND sg13cmos5l_decap_8
XFILLER_300_7 VPWR VGND sg13cmos5l_decap_8
XFILLER_380_173 VPWR VGND sg13cmos5l_decap_8
XFILLER_316_28 VPWR VGND sg13cmos5l_decap_8
XANTENNA__3705__X AXI_M_SOC_WDATA15 VPWR VGND sg13cmos5l_antennanp
XFILLER_59_34 VPWR VGND sg13cmos5l_decap_8
XFILLER_463_56 VPWR VGND sg13cmos5l_fill_2
XFILLER_132_140 VPWR VGND sg13cmos5l_decap_8
XFILLER_278_133 VPWR VGND sg13cmos5l_decap_8
XFILLER_182_35 VPWR VGND sg13cmos5l_decap_8
XFILLER_78_227 VPWR VGND sg13cmos5l_fill_2
XFILLER_427_119 VPWR VGND sg13cmos5l_decap_8
XFILLER_332_49 VPWR VGND sg13cmos5l_decap_8
XFILLER_75_77 VPWR VGND sg13cmos5l_decap_8
XFILLER_234_225 VPWR VGND sg13cmos5l_decap_4
XANTENNA__3440__X Tile_X0Y4_FrameData_O[31] VPWR VGND sg13cmos5l_antennanp
XFILLER_412_82 VPWR VGND sg13cmos5l_decap_8
XFILLER_91_21 VPWR VGND sg13cmos5l_decap_8
XFILLER_257_0 VPWR VGND sg13cmos5l_decap_8
XFILLER_488_42 VPWR VGND sg13cmos5l_decap_8
XFILLER_348_126 VPWR VGND sg13cmos5l_decap_8
XFILLER_424_0 VPWR VGND sg13cmos5l_decap_8
XFILLER_638_56 VPWR VGND sg13cmos5l_decap_8
XFILLER_24_70 VPWR VGND sg13cmos5l_decap_8
XFILLER_357_35 VPWR VGND sg13cmos5l_decap_8
XFILLER_505_112 VPWR VGND sg13cmos5l_decap_8
X_0660_ _0660_/Q Tile_X0Y8_FrameData[11] VGND VPWR Tile_X0Y9_FrameStrobe[7] latch
XFILLER_507_49 VPWR VGND sg13cmos5l_decap_8
XFILLER_505_189 VPWR VGND sg13cmos5l_decap_8
XFILLER_170_224 VPWR VGND sg13cmos5l_decap_4
XFILLER_654_77 VPWR VGND sg13cmos5l_decap_8
XFILLER_226_28 VPWR VGND sg13cmos5l_decap_8
X_0591_ _0591_/Q Tile_X0Y8_FrameData[16] VGND VPWR Tile_X0Y9_FrameStrobe[5] latch
XFILLER_458_200 VPWR VGND sg13cmos5l_fill_1
XFILLER_373_56 VPWR VGND sg13cmos5l_decap_8
XANTENNA__3615__X Tile_X0Y9_S2BEGb[1] VPWR VGND sg13cmos5l_antennanp
XFILLER_269_122 VPWR VGND sg13cmos5l_decap_4
XFILLER_156_91 VPWR VGND sg13cmos5l_decap_4
X_2330_ _2330_/Q Tile_X0Y5_FrameData[11] VGND VPWR Tile_X0Y9_FrameStrobe[4] latch
XFILLER_670_21 VPWR VGND sg13cmos5l_decap_8
X_2261_ _2261_/Q Tile_X0Y5_FrameData[16] VGND VPWR Tile_X0Y9_FrameStrobe[2] latch
X_4000_ _4000_/X Tile_X0Y5_W1END[1] Tile_X0Y5_WW4END[1] Tile_X0Y5_W6END[9] _4452_/X
+ _2412_/Q _2411_/Q VPWR VGND sg13cmos5l_mux4_1
X_1212_ _1212_/Q Tile_X0Y1_FrameData[29] VGND VPWR Tile_X0Y9_FrameStrobe[1] latch
XFILLER_284_147 VPWR VGND sg13cmos5l_decap_8
X_2192_ _2192_/Q Tile_X0Y5_FrameData[21] VGND VPWR Tile_X0Y9_FrameStrobe[0] latch
XFILLER_242_49 VPWR VGND sg13cmos5l_decap_8
XFILLER_603_70 VPWR VGND sg13cmos5l_decap_8
XFILLER_37_124 VPWR VGND sg13cmos5l_fill_1
X_1143_ _1143_/Q Tile_X0Y0_FrameData[20] VGND VPWR Tile_X0Y9_FrameStrobe[6] latch
XANTENNA__3350__X Tile_X0Y2_FrameData_O[21] VPWR VGND sg13cmos5l_antennanp
XFILLER_37_146 VPWR VGND sg13cmos5l_decap_8
XFILLER_1_63 VPWR VGND sg13cmos5l_decap_8
XFILLER_37_157 VPWR VGND sg13cmos5l_fill_1
XFILLER_426_196 VPWR VGND sg13cmos5l_decap_8
X_1074_ _1074_/Q Tile_X0Y0_FrameData[25] VGND VPWR Tile_X0Y9_FrameStrobe[4] latch
XFILLER_679_63 VPWR VGND sg13cmos5l_decap_8
XFILLER_37_179 VPWR VGND sg13cmos5l_fill_1
XFILLER_587_126 VPWR VGND sg13cmos5l_decap_8
X_4902_ _4902_/X Tile_X0Y9_N2MID[6] Tile_X0Y9_N2END[6] _4938_/X _4822_/X _0683_/Q
+ _0682_/Q VPWR VGND sg13cmos5l_mux4_1
XFILLER_398_42 VPWR VGND sg13cmos5l_decap_8
XFILLER_240_228 VPWR VGND sg13cmos5l_fill_1
XFILLER_394_210 VPWR VGND sg13cmos5l_decap_4
X_4833_ _4833_/X Tile_X0Y9_W1END[1] Tile_X0Y9_W2MID[2] Tile_X0Y9_W2END[2] _4904_/X
+ _0873_/Q _0872_/Q VPWR VGND sg13cmos5l_mux4_1
XFILLER_394_221 VPWR VGND sg13cmos5l_decap_8
XFILLER_595_192 VPWR VGND sg13cmos5l_decap_8
XFILLER_548_56 VPWR VGND sg13cmos5l_decap_8
X_4764_ _4764_/X AXI_M_SOC_RDATA8 _4807_/X _4811_/X _4785_/X _0519_/Q _0518_/Q VPWR
+ VGND sg13cmos5l_mux4_1
X_1976_ _1976_/Q Tile_X0Y4_FrameData[13] VGND VPWR Tile_X0Y9_FrameStrobe[1] latch
XFILLER_695_84 VPWR VGND sg13cmos5l_decap_8
XFILLER_267_35 VPWR VGND sg13cmos5l_decap_8
X_3715_ AXI_M_SOC_WDATA25 Tile_X0Y6_WW4END[1] Tile_X0Y6_WW4END[9] Tile_X0Y6_W6END[9]
+ _4577_/X _2509_/Q _2508_/Q VPWR VGND sg13cmos5l_mux4_1
X_0927_ _0927_/Q Tile_X0Y9_FrameData[0] VGND VPWR Tile_X0Y9_FrameStrobe[7] latch
X_4695_ _4695_/X _4667_/X Tile_X0Y9_N4END[11] _4666_/X _0053_/X _0193_/Q _0192_/Q
+ VPWR VGND sg13cmos5l_mux4_1
X_3646_ AXI_M_SOC_AWADDR7 Tile_X0Y5_WW4END[7] Tile_X0Y5_WW4END[15] Tile_X0Y5_W6END[7]
+ _4458_/X _2257_/Q _2256_/Q VPWR VGND sg13cmos5l_mux4_1
X_0858_ _0858_/Q Tile_X0Y9_FrameData[5] VGND VPWR Tile_X0Y9_FrameStrobe[5] latch
XFILLER_417_49 VPWR VGND sg13cmos5l_decap_8
XFILLER_20_28 VPWR VGND sg13cmos5l_decap_8
XFILLER_564_77 VPWR VGND sg13cmos5l_decap_8
XFILLER_714_14 VPWR VGND sg13cmos5l_decap_4
XFILLER_511_126 VPWR VGND sg13cmos5l_fill_1
XFILLER_136_28 VPWR VGND sg13cmos5l_decap_8
X_3577_ Tile_X0Y9_FrameData_O[7] Tile_X0Y9_FrameData[7] VPWR VGND sg13cmos5l_buf_1
XFILLER_657_119 VPWR VGND sg13cmos5l_decap_4
X_0789_ _0789_/Q Tile_X0Y9_FrameData[10] VGND VPWR Tile_X0Y9_FrameStrobe[3] latch
XFILLER_283_56 VPWR VGND sg13cmos5l_decap_8
XANTENNA__3525__X Tile_X0Y9_E1BEG[3] VPWR VGND sg13cmos5l_antennanp
XFILLER_714_36 VPWR VGND sg13cmos5l_decap_8
X_2528_ _2528_/Q Tile_X0Y6_FrameData[7] VGND VPWR Tile_X0Y9_FrameStrobe[2] latch
XFILLER_580_21 VPWR VGND sg13cmos5l_decap_8
X_2459_ _2459_/Q Tile_X0Y6_FrameData[12] VGND VPWR Tile_X0Y9_FrameStrobe[0] latch
XFILLER_680_111 VPWR VGND sg13cmos5l_decap_8
XFILLER_275_147 VPWR VGND sg13cmos5l_decap_4
XFILLER_580_98 VPWR VGND sg13cmos5l_decap_8
XFILLER_152_49 VPWR VGND sg13cmos5l_decap_8
XFILLER_513_70 VPWR VGND sg13cmos5l_decap_8
XFILLER_680_166 VPWR VGND sg13cmos5l_decap_8
X_4129_ _4129_/X Tile_X0Y4_W2MID[7] Tile_X0Y4_W2END[7] Tile_X0Y4_W6END[7] _4313_/X
+ _2173_/Q _2172_/Q VPWR VGND sg13cmos5l_mux4_1
XFILLER_417_174 VPWR VGND sg13cmos5l_decap_4
XANTENNA__3260__X Tile_X0Y0_FrameData_O[28] VPWR VGND sg13cmos5l_antennanp
XFILLER_216_225 VPWR VGND sg13cmos5l_decap_4
XFILLER_621_222 VPWR VGND sg13cmos5l_decap_8
XFILLER_432_133 VPWR VGND sg13cmos5l_decap_8
XFILLER_589_63 VPWR VGND sg13cmos5l_decap_8
XFILLER_578_126 VPWR VGND sg13cmos5l_decap_8
XFILLER_250_7 VPWR VGND sg13cmos5l_decap_8
XFILLER_231_228 VPWR VGND sg13cmos5l_fill_1
XFILLER_348_7 VPWR VGND sg13cmos5l_decap_8
XFILLER_196_110 VPWR VGND sg13cmos5l_decap_8
XFILLER_101_42 VPWR VGND sg13cmos5l_decap_8
XFILLER_61_13 VPWR VGND sg13cmos5l_decap_8
XFILLER_385_221 VPWR VGND sg13cmos5l_fill_1
XFILLER_51_182 VPWR VGND sg13cmos5l_decap_4
XFILLER_458_56 VPWR VGND sg13cmos5l_decap_8
XFILLER_101_97 VPWR VGND sg13cmos5l_decap_8
XFILLER_515_7 VPWR VGND sg13cmos5l_decap_8
XFILLER_177_35 VPWR VGND sg13cmos5l_decap_8
XFILLER_338_181 VPWR VGND sg13cmos5l_decap_8
XFILLER_137_221 VPWR VGND sg13cmos5l_fill_1
XANTENNA__0124__X AXI_M_SOC_ARSIZE1 VPWR VGND sg13cmos5l_antennanp
XFILLER_353_140 VPWR VGND sg13cmos5l_decap_8
XFILLER_499_133 VPWR VGND sg13cmos5l_decap_8
XFILLER_327_49 VPWR VGND sg13cmos5l_decap_8
XFILLER_474_77 VPWR VGND sg13cmos5l_decap_8
XFILLER_298_217 VPWR VGND sg13cmos5l_fill_2
XFILLER_502_126 VPWR VGND sg13cmos5l_decap_8
XFILLER_298_228 VPWR VGND sg13cmos5l_fill_1
XFILLER_648_119 VPWR VGND sg13cmos5l_decap_8
XFILLER_624_14 VPWR VGND sg13cmos5l_decap_8
XANTENNA__3435__X Tile_X0Y4_FrameData_O[26] VPWR VGND sg13cmos5l_antennanp
XFILLER_193_56 VPWR VGND sg13cmos5l_decap_8
XFILLER_105_151 VPWR VGND sg13cmos5l_decap_8
XFILLER_490_21 VPWR VGND sg13cmos5l_decap_8
XFILLER_86_21 VPWR VGND sg13cmos5l_decap_8
XFILLER_120_121 VPWR VGND sg13cmos5l_decap_8
XFILLER_656_174 VPWR VGND sg13cmos5l_fill_1
XFILLER_455_225 VPWR VGND sg13cmos5l_decap_4
XFILLER_704_91 VPWR VGND sg13cmos5l_decap_8
XFILLER_490_98 VPWR VGND sg13cmos5l_decap_8
XFILLER_640_35 VPWR VGND sg13cmos5l_decap_8
XFILLER_423_70 VPWR VGND sg13cmos5l_decap_8
XFILLER_266_169 VPWR VGND sg13cmos5l_decap_8
XFILLER_374_0 VPWR VGND sg13cmos5l_decap_8
XFILLER_207_203 VPWR VGND sg13cmos5l_decap_8
XFILLER_19_70 VPWR VGND sg13cmos5l_decap_8
XANTENNA__3170__X Tile_X0Y4_E6BEG[7] VPWR VGND sg13cmos5l_antennanp
XFILLER_612_200 VPWR VGND sg13cmos5l_fill_1
XFILLER_671_199 VPWR VGND sg13cmos5l_decap_8
XFILLER_612_222 VPWR VGND sg13cmos5l_decap_8
XFILLER_423_133 VPWR VGND sg13cmos5l_decap_8
XFILLER_569_126 VPWR VGND sg13cmos5l_decap_8
XFILLER_499_63 VPWR VGND sg13cmos5l_decap_8
XFILLER_541_0 VPWR VGND sg13cmos5l_decap_8
XFILLER_639_0 VPWR VGND sg13cmos5l_decap_8
XFILLER_423_177 VPWR VGND sg13cmos5l_decap_8
XFILLER_649_77 VPWR VGND sg13cmos5l_decap_8
XFILLER_35_91 VPWR VGND sg13cmos5l_decap_8
XFILLER_96_7 VPWR VGND sg13cmos5l_decap_8
XFILLER_368_56 VPWR VGND sg13cmos5l_decap_8
X_1830_ _1830_/Q Tile_X0Y3_FrameData[3] VGND VPWR Tile_X0Y9_FrameStrobe[4] latch
XFILLER_665_21 VPWR VGND sg13cmos5l_decap_8
X_1761_ _1761_/Q Tile_X0Y3_FrameData[8] VGND VPWR Tile_X0Y9_FrameStrobe[2] latch
X_3500_ Tile_X0Y1_E6BEG[10] _3974_/X VPWR VGND sg13cmos5l_buf_1
X_0712_ _0712_/Q Tile_X0Y9_FrameData[23] VGND VPWR Tile_X0Y9_FrameStrobe[1] latch
X_4480_ _4480_/X Tile_X0Y4_W1END[2] Tile_X0Y4_W2MID[1] Tile_X0Y4_W2END[1] _4314_/X
+ _2125_/Q _2124_/Q VPWR VGND sg13cmos5l_mux4_1
XFILLER_665_98 VPWR VGND sg13cmos5l_decap_8
XFILLER_344_151 VPWR VGND sg13cmos5l_decap_8
X_1692_ _1692_/Q Tile_X0Y3_FrameData[13] VGND VPWR Tile_X0Y9_FrameStrobe[0] latch
XFILLER_237_49 VPWR VGND sg13cmos5l_decap_8
X_3431_ Tile_X0Y4_FrameData_O[22] Tile_X0Y4_FrameData[22] VPWR VGND sg13cmos5l_buf_1
X_0643_ _0643_/Q Tile_X0Y8_FrameData[28] VGND VPWR Tile_X0Y9_FrameStrobe[7] latch
XFILLER_534_14 VPWR VGND sg13cmos5l_decap_8
XFILLER_289_228 VPWR VGND sg13cmos5l_fill_1
XFILLER_639_119 VPWR VGND sg13cmos5l_decap_8
XFILLER_384_99 VPWR VGND sg13cmos5l_decap_8
XANTENNA__3345__X Tile_X0Y2_FrameData_O[16] VPWR VGND sg13cmos5l_antennanp
XFILLER_681_42 VPWR VGND sg13cmos5l_decap_8
X_3362_ Tile_X0Y2_EE4BEG[1] _4057_/X VPWR VGND sg13cmos5l_buf_1
XFILLER_317_93 VPWR VGND sg13cmos5l_fill_1
X_0574_ _0574_/Q Tile_X0Y8_FrameData[1] VGND VPWR Tile_X0Y9_FrameStrobe[4] latch
X_2313_ _2313_/Q Tile_X0Y5_FrameData[28] VGND VPWR Tile_X0Y9_FrameStrobe[4] latch
XFILLER_446_203 VPWR VGND sg13cmos5l_fill_2
X_3293_ Tile_X0Y0_E2BEGb[1] _3813_/X VPWR VGND sg13cmos5l_buf_1
XFILLER_614_91 VPWR VGND sg13cmos5l_decap_8
XFILLER_57_208 VPWR VGND sg13cmos5l_decap_4
XFILLER_647_196 VPWR VGND sg13cmos5l_decap_8
X_2244_ _2244_/Q Tile_X0Y5_FrameData[1] VGND VPWR Tile_X0Y9_FrameStrobe[1] latch
XFILLER_550_35 VPWR VGND sg13cmos5l_decap_8
XFILLER_333_70 VPWR VGND sg13cmos5l_decap_8
XFILLER_662_155 VPWR VGND sg13cmos5l_fill_2
XFILLER_18_0 VPWR VGND sg13cmos5l_decap_8
XANTENNA__3080__X Tile_X0Y4_E2BEGb[6] VPWR VGND sg13cmos5l_antennanp
X_2175_ _2175_/Q Tile_X0Y4_FrameData[6] VGND VPWR Tile_X0Y9_FrameStrobe[7] latch
XFILLER_461_228 VPWR VGND sg13cmos5l_fill_1
X_1126_ _1126_/Q Tile_X0Y0_FrameData[5] VGND VPWR Tile_X0Y9_FrameStrobe[5] latch
XFILLER_280_161 VPWR VGND sg13cmos5l_decap_8
XFILLER_202_63 VPWR VGND sg13cmos5l_decap_8
XFILLER_18_190 VPWR VGND sg13cmos5l_decap_8
X_1057_ _1057_/Q Tile_X0Y0_FrameData[10] VGND VPWR Tile_X0Y9_FrameStrobe[3] latch
XFILLER_15_28 VPWR VGND sg13cmos5l_decap_8
XFILLER_559_77 VPWR VGND sg13cmos5l_decap_8
XFILLER_709_14 VPWR VGND sg13cmos5l_decap_8
XFILLER_717_123 VPWR VGND sg13cmos5l_decap_8
XFILLER_717_134 VPWR VGND sg13cmos5l_fill_2
XFILLER_278_56 VPWR VGND sg13cmos5l_decap_8
X_4816_ _4816_/X Tile_X0Y7_W2MID[7] Tile_X0Y7_W2END[7] Tile_X0Y7_W6END[8] _4669_/X
+ _0371_/Q _0370_/Q VPWR VGND sg13cmos5l_mux4_1
XFILLER_575_21 VPWR VGND sg13cmos5l_decap_8
XFILLER_119_221 VPWR VGND sg13cmos5l_fill_1
X_4747_ _4747_/X Tile_X0Y8_WW4END[12] AXI_M_SOC_RDATA11 _4812_/X _4790_/X _0553_/Q
+ _0552_/Q VPWR VGND sg13cmos5l_mux4_1
X_1959_ _1959_/Q Tile_X0Y4_FrameData[30] VGND VPWR Tile_X0Y9_FrameStrobe[1] latch
XFILLER_31_38 VPWR VGND sg13cmos5l_decap_8
X_4678_ _4678_/X Tile_X0Y3_W1END[1] Tile_X0Y3_WW4END[13] Tile_X0Y3_W6END[5] _4223_/X
+ _1862_/Q _1861_/Q VPWR VGND sg13cmos5l_mux4_1
XFILLER_575_98 VPWR VGND sg13cmos5l_decap_8
XFILLER_147_49 VPWR VGND sg13cmos5l_decap_8
XFILLER_508_70 VPWR VGND sg13cmos5l_decap_8
XFILLER_294_77 VPWR VGND sg13cmos5l_decap_8
X_3629_ Tile_X0Y9_S4BEG[7] _3629_/A VPWR VGND sg13cmos5l_buf_1
XFILLER_444_14 VPWR VGND sg13cmos5l_decap_8
XANTENNA__3255__X Tile_X0Y0_FrameData_O[23] VPWR VGND sg13cmos5l_antennanp
XFILLER_591_42 VPWR VGND sg13cmos5l_decap_8
XFILLER_496_147 VPWR VGND sg13cmos5l_decap_8
XFILLER_638_163 VPWR VGND sg13cmos5l_fill_1
XFILLER_437_214 VPWR VGND sg13cmos5l_fill_2
XFILLER_298_7 VPWR VGND sg13cmos5l_decap_8
XFILLER_638_185 VPWR VGND sg13cmos5l_decap_8
XFILLER_653_133 VPWR VGND sg13cmos5l_decap_8
XFILLER_460_35 VPWR VGND sg13cmos5l_decap_8
XFILLER_243_70 VPWR VGND sg13cmos5l_decap_8
XFILLER_102_187 VPWR VGND sg13cmos5l_decap_8
XFILLER_56_24 VPWR VGND sg13cmos5l_decap_8
XFILLER_465_7 VPWR VGND sg13cmos5l_decap_8
XFILLER_405_122 VPWR VGND sg13cmos5l_fill_2
XFILLER_71_211 VPWR VGND sg13cmos5l_decap_4
XFILLER_610_49 VPWR VGND sg13cmos5l_decap_8
XANTENNA__0119__X AXI_M_SOC_ARCACHE1 VPWR VGND sg13cmos5l_antennanp
XFILLER_632_7 VPWR VGND sg13cmos5l_decap_8
XFILLER_204_228 VPWR VGND sg13cmos5l_fill_1
XFILLER_112_63 VPWR VGND sg13cmos5l_decap_8
XFILLER_72_56 VPWR VGND sg13cmos5l_decap_8
XFILLER_469_77 VPWR VGND sg13cmos5l_decap_8
XFILLER_708_112 VPWR VGND sg13cmos5l_decap_8
XFILLER_619_14 VPWR VGND sg13cmos5l_decap_8
XFILLER_188_56 VPWR VGND sg13cmos5l_decap_8
XFILLER_574_140 VPWR VGND sg13cmos5l_decap_8
XFILLER_318_107 VPWR VGND sg13cmos5l_decap_8
XFILLER_485_21 VPWR VGND sg13cmos5l_decap_8
XFILLER_184_113 VPWR VGND sg13cmos5l_decap_8
XFILLER_184_124 VPWR VGND sg13cmos5l_fill_1
XFILLER_169_198 VPWR VGND sg13cmos5l_decap_8
XFILLER_184_146 VPWR VGND sg13cmos5l_decap_4
XFILLER_184_157 VPWR VGND sg13cmos5l_decap_8
XFILLER_122_0 VPWR VGND sg13cmos5l_decap_8
XFILLER_184_179 VPWR VGND sg13cmos5l_decap_8
XFILLER_485_98 VPWR VGND sg13cmos5l_decap_8
XFILLER_635_35 VPWR VGND sg13cmos5l_decap_8
XFILLER_418_70 VPWR VGND sg13cmos5l_decap_8
XFILLER_354_14 VPWR VGND sg13cmos5l_decap_8
XANTENNA__3165__X Tile_X0Y4_E6BEG[2] VPWR VGND sg13cmos5l_antennanp
XFILLER_341_165 VPWR VGND sg13cmos5l_fill_2
XFILLER_97_42 VPWR VGND sg13cmos5l_decap_8
XFILLER_715_90 VPWR VGND sg13cmos5l_decap_8
XFILLER_491_0 VPWR VGND sg13cmos5l_decap_8
XFILLER_589_0 VPWR VGND sg13cmos5l_decap_8
XFILLER_428_203 VPWR VGND sg13cmos5l_decap_8
XFILLER_504_28 VPWR VGND sg13cmos5l_decap_8
XFILLER_97_97 VPWR VGND sg13cmos5l_decap_8
XFILLER_428_225 VPWR VGND sg13cmos5l_decap_4
XFILLER_651_56 VPWR VGND sg13cmos5l_decap_8
XFILLER_434_91 VPWR VGND sg13cmos5l_decap_8
X_0290_ _0290_/Q Tile_X0Y7_FrameData[29] VGND VPWR Tile_X0Y9_FrameStrobe[4] latch
XFILLER_644_133 VPWR VGND sg13cmos5l_decap_8
XFILLER_370_35 VPWR VGND sg13cmos5l_decap_8
XFILLER_153_70 VPWR VGND sg13cmos5l_decap_8
XFILLER_11_7 VPWR VGND sg13cmos5l_decap_8
XFILLER_153_92 VPWR VGND sg13cmos5l_decap_8
XFILLER_443_228 VPWR VGND sg13cmos5l_fill_1
XFILLER_597_221 VPWR VGND sg13cmos5l_fill_1
XFILLER_520_49 VPWR VGND sg13cmos5l_decap_8
XFILLER_46_90 VPWR VGND sg13cmos5l_decap_8
X_3980_ _3980_/X Tile_X0Y0_W1END[0] Tile_X0Y0_W6END[8] _3875_/X _3862_/X _1141_/Q
+ _1140_/Q VPWR VGND sg13cmos5l_mux4_1
XFILLER_600_214 VPWR VGND sg13cmos5l_fill_1
X_2931_ Tile_X0Y8_E2BEGb[7] _4743_/X VPWR VGND sg13cmos5l_buf_1
XFILLER_379_77 VPWR VGND sg13cmos5l_fill_1
XFILLER_529_14 VPWR VGND sg13cmos5l_decap_8
XFILLER_676_42 VPWR VGND sg13cmos5l_decap_8
XFILLER_565_140 VPWR VGND sg13cmos5l_decap_8
X_2862_ Tile_X0Y6_E6BEG[11] _4539_/X VPWR VGND sg13cmos5l_buf_1
XFILLER_309_107 VPWR VGND sg13cmos5l_decap_4
XFILLER_395_21 VPWR VGND sg13cmos5l_decap_8
X_4601_ _4601_/X _4688_/X _4692_/X _4696_/X _4674_/X _0355_/Q _0354_/Q VPWR VGND sg13cmos5l_mux4_1
X_1813_ _1813_/Q Tile_X0Y3_FrameData[20] VGND VPWR Tile_X0Y9_FrameStrobe[4] latch
X_2793_ Tile_X0Y3_E6BEG[3] _4183_/X VPWR VGND sg13cmos5l_buf_1
XFILLER_714_148 VPWR VGND sg13cmos5l_decap_8
XFILLER_609_91 VPWR VGND sg13cmos5l_decap_8
X_4532_ _4532_/X AXI_M_SOC_RDATA24 _4575_/X _4579_/X _4553_/X _2543_/Q _2542_/Q VPWR
+ VGND sg13cmos5l_mux4_1
XFILLER_580_154 VPWR VGND sg13cmos5l_decap_8
X_1744_ _1744_/Q Tile_X0Y3_FrameData[25] VGND VPWR Tile_X0Y9_FrameStrobe[2] latch
XFILLER_317_151 VPWR VGND sg13cmos5l_decap_8
XFILLER_7_84 VPWR VGND sg13cmos5l_decap_8
XFILLER_545_35 VPWR VGND sg13cmos5l_decap_8
XFILLER_328_70 VPWR VGND sg13cmos5l_decap_8
XFILLER_317_173 VPWR VGND sg13cmos5l_decap_8
XFILLER_692_63 VPWR VGND sg13cmos5l_decap_8
XFILLER_478_103 VPWR VGND sg13cmos5l_fill_2
XFILLER_328_92 VPWR VGND sg13cmos5l_fill_2
XFILLER_183_190 VPWR VGND sg13cmos5l_decap_8
X_4463_ _4463_/X _4418_/X _0157_/X _4417_/X _0143_/X _2213_/Q _2212_/Q VPWR VGND sg13cmos5l_mux4_1
XFILLER_264_14 VPWR VGND sg13cmos5l_decap_8
X_1675_ _1675_/Q Tile_X0Y3_FrameData[30] VGND VPWR Tile_X0Y9_FrameStrobe[0] latch
XANTENNA__3075__X Tile_X0Y4_E2BEGb[1] VPWR VGND sg13cmos5l_antennanp
X_3414_ Tile_X0Y4_FrameData_O[5] Tile_X0Y4_FrameData[5] VPWR VGND sg13cmos5l_buf_1
X_0626_ _0626_/Q Tile_X0Y8_FrameData[13] VGND VPWR Tile_X0Y9_FrameStrobe[6] latch
X_4394_ _4394_/X Tile_X0Y5_WW4END[9] AXI_M_SOC_RRESP0 _4460_/X _4430_/X _2315_/Q _2314_/Q
+ VPWR VGND sg13cmos5l_mux4_1
X_3345_ Tile_X0Y2_FrameData_O[16] Tile_X0Y2_FrameData[16] VPWR VGND sg13cmos5l_buf_1
XFILLER_414_28 VPWR VGND sg13cmos5l_decap_8
X_0557_ _0557_/Q Tile_X0Y8_FrameData[18] VGND VPWR Tile_X0Y9_FrameStrobe[4] latch
XFILLER_682_228 VPWR VGND sg13cmos5l_fill_1
XFILLER_486_180 VPWR VGND sg13cmos5l_fill_1
XFILLER_419_225 VPWR VGND sg13cmos5l_decap_4
XFILLER_561_56 VPWR VGND sg13cmos5l_decap_8
XFILLER_344_91 VPWR VGND sg13cmos5l_decap_8
XFILLER_635_133 VPWR VGND sg13cmos5l_decap_8
X_3276_ Tile_X0Y0_EE4BEG[12] _3832_/X VPWR VGND sg13cmos5l_buf_1
XFILLER_635_144 VPWR VGND sg13cmos5l_fill_2
XFILLER_280_35 VPWR VGND sg13cmos5l_decap_8
X_0488_ _0488_/Q Tile_X0Y8_FrameData[23] VGND VPWR Tile_X0Y9_FrameStrobe[2] latch
X_2227_ _2227_/Q Tile_X0Y5_FrameData[18] VGND VPWR Tile_X0Y9_FrameStrobe[1] latch
XFILLER_434_228 VPWR VGND sg13cmos5l_fill_1
XFILLER_650_147 VPWR VGND sg13cmos5l_decap_8
X_2158_ _2158_/Q Tile_X0Y4_FrameData[23] VGND VPWR Tile_X0Y9_FrameStrobe[7] latch
XFILLER_53_211 VPWR VGND sg13cmos5l_decap_8
XFILLER_430_49 VPWR VGND sg13cmos5l_decap_8
XFILLER_213_84 VPWR VGND sg13cmos5l_decap_8
XFILLER_26_49 VPWR VGND sg13cmos5l_decap_8
X_1109_ _1109_/Q Tile_X0Y0_FrameData[22] VGND VPWR Tile_X0Y9_FrameStrobe[5] latch
X_2089_ _2089_/Q Tile_X0Y4_FrameData[28] VGND VPWR Tile_X0Y9_FrameStrobe[5] latch
XFILLER_548_118 VPWR VGND sg13cmos5l_fill_2
XFILLER_289_77 VPWR VGND sg13cmos5l_decap_8
XFILLER_439_14 VPWR VGND sg13cmos5l_decap_8
XFILLER_586_42 VPWR VGND sg13cmos5l_decap_8
XFILLER_355_213 VPWR VGND sg13cmos5l_fill_1
XFILLER_556_173 VPWR VGND sg13cmos5l_fill_2
XFILLER_410_191 VPWR VGND sg13cmos5l_decap_8
XFILLER_705_126 VPWR VGND sg13cmos5l_decap_8
XFILLER_571_154 VPWR VGND sg13cmos5l_decap_8
XFILLER_308_140 VPWR VGND sg13cmos5l_decap_8
XFILLER_213_7 VPWR VGND sg13cmos5l_decap_8
XFILLER_181_116 VPWR VGND sg13cmos5l_decap_4
XFILLER_455_35 VPWR VGND sg13cmos5l_decap_8
XFILLER_370_227 VPWR VGND sg13cmos5l_fill_2
XFILLER_238_70 VPWR VGND sg13cmos5l_decap_8
XFILLER_107_213 VPWR VGND sg13cmos5l_decap_8
XFILLER_181_149 VPWR VGND sg13cmos5l_decap_8
XFILLER_174_14 VPWR VGND sg13cmos5l_decap_8
XFILLER_469_114 VPWR VGND sg13cmos5l_decap_8
XFILLER_323_143 VPWR VGND sg13cmos5l_decap_8
XFILLER_469_147 VPWR VGND sg13cmos5l_fill_1
XFILLER_122_227 VPWR VGND sg13cmos5l_fill_2
XFILLER_605_49 VPWR VGND sg13cmos5l_decap_8
XFILLER_582_7 VPWR VGND sg13cmos5l_decap_8
XFILLER_324_28 VPWR VGND sg13cmos5l_decap_8
XFILLER_107_63 VPWR VGND sg13cmos5l_decap_8
XFILLER_471_56 VPWR VGND sg13cmos5l_decap_8
XANTENNA__3713__X AXI_M_SOC_WDATA23 VPWR VGND sg13cmos5l_antennanp
XFILLER_88_174 VPWR VGND sg13cmos5l_decap_4
XFILLER_67_56 VPWR VGND sg13cmos5l_decap_8
XFILLER_190_35 VPWR VGND sg13cmos5l_decap_8
XFILLER_492_161 VPWR VGND sg13cmos5l_decap_8
XFILLER_425_217 VPWR VGND sg13cmos5l_fill_2
XFILLER_236_128 VPWR VGND sg13cmos5l_fill_1
XFILLER_425_228 VPWR VGND sg13cmos5l_fill_1
XFILLER_641_147 VPWR VGND sg13cmos5l_decap_8
XFILLER_579_210 VPWR VGND sg13cmos5l_fill_1
XFILLER_440_209 VPWR VGND sg13cmos5l_decap_8
XFILLER_701_70 VPWR VGND sg13cmos5l_decap_8
XFILLER_539_118 VPWR VGND sg13cmos5l_decap_4
XFILLER_199_77 VPWR VGND sg13cmos5l_decap_8
XFILLER_349_14 VPWR VGND sg13cmos5l_decap_8
XFILLER_337_0 VPWR VGND sg13cmos5l_decap_8
XFILLER_496_42 VPWR VGND sg13cmos5l_decap_8
XFILLER_8_112 VPWR VGND sg13cmos5l_decap_8
XFILLER_401_191 VPWR VGND sg13cmos5l_decap_8
XANTENNA__2999__X Tile_X0Y5_E2BEG[2] VPWR VGND sg13cmos5l_antennanp
XFILLER_8_134 VPWR VGND sg13cmos5l_decap_4
XFILLER_12_196 VPWR VGND sg13cmos5l_fill_1
XFILLER_504_0 VPWR VGND sg13cmos5l_fill_2
XFILLER_646_56 VPWR VGND sg13cmos5l_decap_8
XFILLER_429_91 VPWR VGND sg13cmos5l_decap_8
XFILLER_361_205 VPWR VGND sg13cmos5l_decap_8
XFILLER_365_35 VPWR VGND sg13cmos5l_decap_8
XFILLER_148_70 VPWR VGND sg13cmos5l_decap_8
XFILLER_503_210 VPWR VGND sg13cmos5l_decap_8
XFILLER_503_221 VPWR VGND sg13cmos5l_fill_1
X_1460_ _1460_/Q Tile_X0Y2_FrameData[29] VGND VPWR Tile_X0Y9_FrameStrobe[1] latch
XFILLER_314_176 VPWR VGND sg13cmos5l_fill_1
XFILLER_515_49 VPWR VGND sg13cmos5l_decap_8
X_0411_ _0411_/Q Tile_X0Y7_FrameData[4] VGND VPWR Tile_X0Y9_FrameStrobe[7] latch
XFILLER_662_77 VPWR VGND sg13cmos5l_decap_8
XFILLER_234_28 VPWR VGND sg13cmos5l_decap_8
X_1391_ _1391_/Q Tile_X0Y1_FrameData[10] VGND VPWR Tile_X0Y9_FrameStrobe[6] latch
XFILLER_381_56 VPWR VGND sg13cmos5l_decap_8
XANTENNA__3623__X Tile_X0Y9_S4BEG[1] VPWR VGND sg13cmos5l_antennanp
X_3130_ Tile_X0Y7_FrameData_O[0] Tile_X0Y7_FrameData[0] VPWR VGND sg13cmos5l_buf_1
X_0342_ _0342_/Q Tile_X0Y7_FrameData[9] VGND VPWR Tile_X0Y9_FrameStrobe[5] latch
XFILLER_617_133 VPWR VGND sg13cmos5l_decap_4
XFILLER_94_133 VPWR VGND sg13cmos5l_fill_2
XFILLER_483_161 VPWR VGND sg13cmos5l_decap_8
XFILLER_282_212 VPWR VGND sg13cmos5l_fill_2
X_3061_ Tile_X0Y5_FrameData_O[20] Tile_X0Y5_FrameData[20] VPWR VGND sg13cmos5l_buf_1
XFILLER_416_228 VPWR VGND sg13cmos5l_fill_1
X_0273_ _0273_/Q Tile_X0Y7_FrameData[14] VGND VPWR Tile_X0Y9_FrameStrobe[3] latch
X_2012_ _2012_/Q Tile_X0Y4_FrameData[9] VGND VPWR Tile_X0Y9_FrameStrobe[2] latch
XFILLER_35_211 VPWR VGND sg13cmos5l_fill_2
XFILLER_250_49 VPWR VGND sg13cmos5l_decap_8
XFILLER_242_109 VPWR VGND sg13cmos5l_fill_2
XFILLER_611_70 VPWR VGND sg13cmos5l_decap_8
XFILLER_585_213 VPWR VGND sg13cmos5l_fill_1
X_3963_ _3963_/X Tile_X0Y1_WW4END[0] AXI_M_SOC_ARREADY _4008_/X _3989_/X _1283_/Q
+ _1282_/Q VPWR VGND sg13cmos5l_mux4_1
XFILLER_687_63 VPWR VGND sg13cmos5l_decap_8
XFILLER_50_225 VPWR VGND sg13cmos5l_decap_4
XFILLER_396_146 VPWR VGND sg13cmos5l_decap_8
XFILLER_259_14 VPWR VGND sg13cmos5l_decap_8
XFILLER_250_164 VPWR VGND sg13cmos5l_decap_8
XFILLER_195_219 VPWR VGND sg13cmos5l_decap_8
X_2914_ Tile_X0Y8_E1BEG[2] _4726_/X VPWR VGND sg13cmos5l_buf_1
X_3894_ _3894_/X Tile_X0Y2_W2MID[4] Tile_X0Y2_W2END[4] Tile_X0Y2_W6END[4] _4103_/X
+ _1659_/Q _1658_/Q VPWR VGND sg13cmos5l_mux4_1
XFILLER_85_0 VPWR VGND sg13cmos5l_decap_8
XFILLER_337_224 VPWR VGND sg13cmos5l_decap_4
X_2845_ Tile_X0Y6_E2BEGb[2] _4506_/X VPWR VGND sg13cmos5l_buf_1
XFILLER_699_103 VPWR VGND sg13cmos5l_decap_8
XFILLER_409_28 VPWR VGND sg13cmos5l_decap_8
XFILLER_556_56 VPWR VGND sg13cmos5l_decap_4
XFILLER_163_105 VPWR VGND sg13cmos5l_decap_8
X_2776_ Tile_X0Y3_EE4BEG[2] _4166_/X VPWR VGND sg13cmos5l_buf_1
XFILLER_275_35 VPWR VGND sg13cmos5l_decap_8
X_4515_ _4515_/X Tile_X0Y6_WW4END[12] AXI_M_SOC_RDATA27 _4580_/X _4558_/X _2577_/Q
+ _2576_/Q VPWR VGND sg13cmos5l_mux4_1
X_1727_ _1727_/Q Tile_X0Y3_FrameData[10] VGND VPWR Tile_X0Y9_FrameStrobe[1] latch
XFILLER_710_140 VPWR VGND sg13cmos5l_decap_8
X_4446_ _4446_/X _4922_/X _4926_/X _4930_/X _4905_/X _0897_/Q _0896_/Q VPWR VGND sg13cmos5l_mux4_1
X_1658_ _1658_/Q Tile_X0Y2_FrameData[23] VGND VPWR Tile_X0Y9_FrameStrobe[7] latch
XFILLER_425_49 VPWR VGND sg13cmos5l_decap_8
XFILLER_208_84 VPWR VGND sg13cmos5l_decap_8
XFILLER_466_106 VPWR VGND sg13cmos5l_decap_4
XFILLER_572_77 VPWR VGND sg13cmos5l_decap_8
XFILLER_466_117 VPWR VGND sg13cmos5l_decap_4
X_0609_ _0609_/Q Tile_X0Y8_FrameData[30] VGND VPWR Tile_X0Y9_FrameStrobe[6] latch
XFILLER_466_128 VPWR VGND sg13cmos5l_decap_8
XFILLER_144_28 VPWR VGND sg13cmos5l_decap_8
X_4377_ _4377_/X Tile_X0Y5_W2MID[2] AXI_M_SOC_RLAST _4432_/X _4431_/X _2349_/Q _2348_/Q
+ VPWR VGND sg13cmos5l_mux4_1
X_1589_ _1589_/Q Tile_X0Y2_FrameData[28] VGND VPWR Tile_X0Y9_FrameStrobe[5] latch
XANTENNA__3533__X Tile_X0Y9_E2BEG[7] VPWR VGND sg13cmos5l_antennanp
XFILLER_291_56 VPWR VGND sg13cmos5l_decap_8
XFILLER_608_122 VPWR VGND sg13cmos5l_decap_8
X_3328_ Tile_X0Y2_UserCLKo Tile_X0Y2_UserCLK VPWR VGND sg13cmos5l_buf_1
XFILLER_608_166 VPWR VGND sg13cmos5l_fill_1
X_3259_ Tile_X0Y0_FrameData_O[27] Tile_X0Y0_FrameData[27] VPWR VGND sg13cmos5l_buf_1
XFILLER_623_114 VPWR VGND sg13cmos5l_fill_1
XFILLER_37_59 VPWR VGND sg13cmos5l_decap_8
XFILLER_233_109 VPWR VGND sg13cmos5l_decap_8
XFILLER_160_49 VPWR VGND sg13cmos5l_decap_8
XFILLER_521_70 VPWR VGND sg13cmos5l_decap_8
XFILLER_163_7 VPWR VGND sg13cmos5l_decap_8
XFILLER_576_213 VPWR VGND sg13cmos5l_decap_8
XFILLER_53_14 VPWR VGND sg13cmos5l_decap_8
XFILLER_597_63 VPWR VGND sg13cmos5l_decap_8
XFILLER_169_14 VPWR VGND sg13cmos5l_decap_8
XFILLER_387_168 VPWR VGND sg13cmos5l_decap_8
XFILLER_330_7 VPWR VGND sg13cmos5l_decap_8
XFILLER_428_7 VPWR VGND sg13cmos5l_decap_8
XANTENNA__0116__Y AXI_M_SOC_ARLEN7 VPWR VGND sg13cmos5l_antennanp
XFILLER_319_28 VPWR VGND sg13cmos5l_decap_8
XFILLER_139_168 VPWR VGND sg13cmos5l_decap_8
XFILLER_466_56 VPWR VGND sg13cmos5l_decap_8
XANTENNA__3708__X AXI_M_SOC_WDATA18 VPWR VGND sg13cmos5l_antennanp
XFILLER_249_91 VPWR VGND sg13cmos5l_decap_8
XFILLER_185_35 VPWR VGND sg13cmos5l_decap_8
XFILLER_5_137 VPWR VGND sg13cmos5l_fill_1
XFILLER_335_49 VPWR VGND sg13cmos5l_decap_8
XFILLER_646_217 VPWR VGND sg13cmos5l_decap_8
XFILLER_482_77 VPWR VGND sg13cmos5l_decap_8
XFILLER_311_135 VPWR VGND sg13cmos5l_decap_4
XFILLER_646_228 VPWR VGND sg13cmos5l_fill_1
XFILLER_632_14 VPWR VGND sg13cmos5l_decap_8
XFILLER_249_220 VPWR VGND sg13cmos5l_decap_8
XANTENNA__3443__X Tile_X0Y1_FrameData_O[1] VPWR VGND sg13cmos5l_antennanp
XFILLER_94_21 VPWR VGND sg13cmos5l_decap_8
XFILLER_465_172 VPWR VGND sg13cmos5l_decap_8
XFILLER_287_0 VPWR VGND sg13cmos5l_decap_8
XFILLER_712_91 VPWR VGND sg13cmos5l_decap_8
XFILLER_76_177 VPWR VGND sg13cmos5l_decap_8
XFILLER_91_125 VPWR VGND sg13cmos5l_decap_8
XFILLER_94_98 VPWR VGND sg13cmos5l_decap_8
XFILLER_431_70 VPWR VGND sg13cmos5l_decap_8
XFILLER_454_0 VPWR VGND sg13cmos5l_decap_8
XFILLER_27_70 VPWR VGND sg13cmos5l_decap_8
XFILLER_217_183 VPWR VGND sg13cmos5l_fill_2
XFILLER_232_120 VPWR VGND sg13cmos5l_decap_8
XFILLER_621_0 VPWR VGND sg13cmos5l_decap_8
XFILLER_177_208 VPWR VGND sg13cmos5l_decap_8
XFILLER_300_63 VPWR VGND sg13cmos5l_decap_8
X_0960_ _0960_/Q Tile_X0Y0_FrameData[11] VGND VPWR Tile_X0Y9_FrameStrobe[0] latch
XFILLER_582_227 VPWR VGND sg13cmos5l_fill_2
XFILLER_657_77 VPWR VGND sg13cmos5l_decap_8
XFILLER_43_91 VPWR VGND sg13cmos5l_fill_2
XFILLER_229_28 VPWR VGND sg13cmos5l_decap_8
X_0891_ _0891_/Q Tile_X0Y9_FrameData[4] VGND VPWR Tile_X0Y9_FrameStrobe[6] latch
XANTENNA__3618__X Tile_X0Y9_S2BEGb[4] VPWR VGND sg13cmos5l_antennanp
XFILLER_376_56 VPWR VGND sg13cmos5l_decap_8
XFILLER_145_105 VPWR VGND sg13cmos5l_decap_4
X_2630_ _2630_/Q Tile_X0Y6_FrameData[1] VGND VPWR Tile_X0Y9_FrameStrobe[5] latch
XFILLER_673_21 VPWR VGND sg13cmos5l_decap_8
X_2561_ _2561_/Q Tile_X0Y6_FrameData[6] VGND VPWR Tile_X0Y9_FrameStrobe[3] latch
XFILLER_299_131 VPWR VGND sg13cmos5l_fill_2
X_4300_ _4300_/X _4302_/X Tile_X0Y4_W6END[0] _4301_/X _4300_/A3 _1933_/Q _1932_/Q
+ VPWR VGND sg13cmos5l_mux4_1
X_1512_ _1512_/Q Tile_X0Y2_FrameData[9] VGND VPWR Tile_X0Y9_FrameStrobe[2] latch
XFILLER_153_160 VPWR VGND sg13cmos5l_decap_4
X_2492_ _2492_/Q Tile_X0Y6_FrameData[11] VGND VPWR Tile_X0Y9_FrameStrobe[1] latch
XFILLER_245_49 VPWR VGND sg13cmos5l_decap_8
XFILLER_606_70 VPWR VGND sg13cmos5l_decap_8
XFILLER_299_175 VPWR VGND sg13cmos5l_fill_2
XFILLER_4_181 VPWR VGND sg13cmos5l_fill_2
XFILLER_302_124 VPWR VGND sg13cmos5l_decap_4
X_4231_ _4231_/X _4197_/X _0088_/X _4196_/X Tile_X0Y0_S4END[13] _1711_/Q _1710_/Q
+ VPWR VGND sg13cmos5l_mux4_1
XFILLER_448_117 VPWR VGND sg13cmos5l_fill_2
X_1443_ _1443_/Q Tile_X0Y2_FrameData[14] VGND VPWR Tile_X0Y9_FrameStrobe[0] latch
XFILLER_542_14 VPWR VGND sg13cmos5l_decap_8
XFILLER_4_63 VPWR VGND sg13cmos5l_decap_8
XANTENNA__3353__X Tile_X0Y2_FrameData_O[24] VPWR VGND sg13cmos5l_antennanp
XFILLER_325_60 VPWR VGND sg13cmos5l_fill_1
XFILLER_67_100 VPWR VGND sg13cmos5l_decap_8
X_4162_ _4162_/X Tile_X0Y3_W2END[1] AXI_M_SOC_BVALID _4207_/X _4206_/X _1817_/Q _1816_/Q
+ VPWR VGND sg13cmos5l_mux4_1
X_1374_ _1374_/Q Tile_X0Y1_FrameData[27] VGND VPWR Tile_X0Y9_FrameStrobe[6] latch
X_3113_ Tile_X0Y7_E6BEG[11] _4655_/X VPWR VGND sg13cmos5l_buf_1
XFILLER_255_212 VPWR VGND sg13cmos5l_decap_8
X_0325_ _0325_/Q Tile_X0Y7_FrameData[26] VGND VPWR Tile_X0Y9_FrameStrobe[5] latch
X_4093_ _4093_/X Tile_X0Y3_W1END[2] Tile_X0Y3_W6END[6] _4215_/X _4192_/X _1921_/Q
+ _1920_/Q VPWR VGND sg13cmos5l_mux4_1
XFILLER_67_177 VPWR VGND sg13cmos5l_decap_8
XFILLER_622_91 VPWR VGND sg13cmos5l_decap_8
X_3044_ Tile_X0Y5_FrameData_O[3] Tile_X0Y5_FrameData[3] VPWR VGND sg13cmos5l_buf_1
X_0256_ _0256_/Q Tile_X0Y7_FrameData[31] VGND VPWR Tile_X0Y9_FrameStrobe[3] latch
XFILLER_605_169 VPWR VGND sg13cmos5l_fill_2
XFILLER_341_70 VPWR VGND sg13cmos5l_decap_8
XFILLER_208_161 VPWR VGND sg13cmos5l_decap_8
X_0187_ _0187_/Q Tile_X0Y7_FrameData[4] VGND VPWR Tile_X0Y9_FrameStrobe[0] latch
XFILLER_698_84 VPWR VGND sg13cmos5l_decap_8
XFILLER_412_220 VPWR VGND sg13cmos5l_decap_8
XFILLER_210_63 VPWR VGND sg13cmos5l_decap_8
X_3946_ _3946_/X Tile_X0Y1_W2END[1] AXI_M_SOC_ARREADY _3991_/X _3990_/X _1317_/Q _1316_/Q
+ VPWR VGND sg13cmos5l_mux4_1
XFILLER_23_28 VPWR VGND sg13cmos5l_decap_8
XFILLER_384_138 VPWR VGND sg13cmos5l_decap_4
XFILLER_567_77 VPWR VGND sg13cmos5l_decap_8
XFILLER_139_28 VPWR VGND sg13cmos5l_decap_8
X_3877_ _3877_/X Tile_X0Y4_W1END[3] Tile_X0Y4_WW4END[3] Tile_X0Y4_W6END[11] _4339_/X
+ _2148_/Q _2147_/Q VPWR VGND sg13cmos5l_mux4_1
XFILLER_286_56 VPWR VGND sg13cmos5l_decap_8
XFILLER_136_105 VPWR VGND sg13cmos5l_decap_8
XANTENNA__3528__X Tile_X0Y9_E2BEG[2] VPWR VGND sg13cmos5l_antennanp
X_2828_ Tile_X0Y4_E2BEG[6] _4262_/X VPWR VGND sg13cmos5l_buf_1
XFILLER_392_171 VPWR VGND sg13cmos5l_decap_8
XFILLER_325_227 VPWR VGND sg13cmos5l_fill_2
XFILLER_583_21 VPWR VGND sg13cmos5l_decap_8
XFILLER_541_113 VPWR VGND sg13cmos5l_decap_8
X_2759_ Tile_X0Y3_FrameData_O[17] Tile_X0Y3_FrameData[17] VPWR VGND sg13cmos5l_buf_1
XFILLER_340_219 VPWR VGND sg13cmos5l_decap_8
XFILLER_144_171 VPWR VGND sg13cmos5l_decap_8
XFILLER_583_98 VPWR VGND sg13cmos5l_decap_8
XFILLER_155_49 VPWR VGND sg13cmos5l_decap_8
XFILLER_516_70 VPWR VGND sg13cmos5l_decap_8
XFILLER_695_161 VPWR VGND sg13cmos5l_decap_8
X_4429_ _4429_/X _4365_/X _4481_/X _4480_/X _4364_/X _2193_/Q _2192_/Q VPWR VGND sg13cmos5l_mux4_1
XFILLER_452_14 VPWR VGND sg13cmos5l_decap_8
XANTENNA__3263__X Tile_X0Y0_FrameData_O[31] VPWR VGND sg13cmos5l_antennanp
XFILLER_447_150 VPWR VGND sg13cmos5l_decap_4
XFILLER_602_28 VPWR VGND sg13cmos5l_decap_8
XFILLER_280_7 VPWR VGND sg13cmos5l_decap_8
XFILLER_58_166 VPWR VGND sg13cmos5l_decap_8
XFILLER_378_7 VPWR VGND sg13cmos5l_decap_8
XFILLER_104_42 VPWR VGND sg13cmos5l_decap_8
XFILLER_251_70 VPWR VGND sg13cmos5l_fill_1
XFILLER_462_175 VPWR VGND sg13cmos5l_decap_8
XFILLER_64_35 VPWR VGND sg13cmos5l_decap_8
XFILLER_261_226 VPWR VGND sg13cmos5l_fill_2
XFILLER_545_7 VPWR VGND sg13cmos5l_decap_8
XFILLER_403_220 VPWR VGND sg13cmos5l_decap_8
XFILLER_604_191 VPWR VGND sg13cmos5l_decap_8
XFILLER_14_203 VPWR VGND sg13cmos5l_decap_8
XFILLER_214_175 VPWR VGND sg13cmos5l_decap_8
XANTENNA__0127__X AXI_M_SOC_WLAST VPWR VGND sg13cmos5l_antennanp
XFILLER_712_7 VPWR VGND sg13cmos5l_decap_8
XFILLER_120_63 VPWR VGND sg13cmos5l_decap_8
XFILLER_196_12 VPWR VGND sg13cmos5l_decap_8
XFILLER_80_56 VPWR VGND sg13cmos5l_fill_2
XFILLER_477_77 VPWR VGND sg13cmos5l_fill_1
XFILLER_627_14 VPWR VGND sg13cmos5l_decap_8
XANTENNA__3438__X Tile_X0Y4_FrameData_O[29] VPWR VGND sg13cmos5l_antennanp
XFILLER_127_127 VPWR VGND sg13cmos5l_decap_8
XFILLER_196_89 VPWR VGND sg13cmos5l_decap_8
XFILLER_127_138 VPWR VGND sg13cmos5l_fill_1
XFILLER_493_21 VPWR VGND sg13cmos5l_decap_8
XFILLER_89_21 VPWR VGND sg13cmos5l_decap_8
XFILLER_202_0 VPWR VGND sg13cmos5l_decap_8
XFILLER_707_91 VPWR VGND sg13cmos5l_decap_8
XFILLER_142_119 VPWR VGND sg13cmos5l_decap_8
XFILLER_493_98 VPWR VGND sg13cmos5l_decap_8
XFILLER_643_35 VPWR VGND sg13cmos5l_decap_8
XFILLER_426_70 VPWR VGND sg13cmos5l_decap_8
XFILLER_619_228 VPWR VGND sg13cmos5l_fill_1
XFILLER_362_14 VPWR VGND sg13cmos5l_decap_8
XANTENNA__3173__X Tile_X0Y4_E6BEG[10] VPWR VGND sg13cmos5l_antennanp
XFILLER_296_156 VPWR VGND sg13cmos5l_fill_2
XFILLER_571_0 VPWR VGND sg13cmos5l_decap_8
XFILLER_669_0 VPWR VGND sg13cmos5l_decap_8
XFILLER_512_28 VPWR VGND sg13cmos5l_decap_8
XFILLER_442_91 VPWR VGND sg13cmos5l_decap_8
X_0110_ _0110_/X _4328_/X _4329_/X _1109_/Q VPWR VGND sg13cmos5l_mux2_1
X_1090_ _1090_/Q Tile_X0Y0_FrameData[9] VGND VPWR Tile_X0Y9_FrameStrobe[4] latch
XFILLER_161_70 VPWR VGND sg13cmos5l_decap_8
XFILLER_599_157 VPWR VGND sg13cmos5l_fill_2
XFILLER_602_106 VPWR VGND sg13cmos5l_fill_1
XFILLER_453_186 VPWR VGND sg13cmos5l_decap_8
X_0041_ _3630_/A _4716_/X _4717_/X _0609_/Q VPWR VGND sg13cmos5l_mux2_1
XFILLER_668_21 VPWR VGND sg13cmos5l_decap_8
XFILLER_311_84 VPWR VGND sg13cmos5l_decap_8
XFILLER_220_112 VPWR VGND sg13cmos5l_decap_8
X_3800_ _3800_/X _3848_/X Tile_X0Y0_W2END[0] Tile_X0Y0_W2END[1] Tile_X0Y0_S1END[0]
+ _1105_/Q _1104_/Q VPWR VGND sg13cmos5l_mux4_1
XFILLER_366_105 VPWR VGND sg13cmos5l_decap_8
X_4780_ _4780_/X Tile_X0Y7_W1END[2] Tile_X0Y7_W6END[10] _4698_/X _4658_/X _0375_/Q
+ _0374_/Q VPWR VGND sg13cmos5l_mux4_1
X_1992_ _1992_/Q Tile_X0Y4_FrameData[29] VGND VPWR Tile_X0Y9_FrameStrobe[2] latch
XFILLER_20_228 VPWR VGND sg13cmos5l_fill_1
X_3731_ AXI_M_SOC_ARADDR3 Tile_X0Y9_WW4END[3] Tile_X0Y9_WW4END[11] Tile_X0Y9_W6END[3]
+ _4919_/X _0753_/Q _0752_/Q VPWR VGND sg13cmos5l_mux4_1
X_0943_ _0943_/Q Tile_X0Y0_FrameData[28] VGND VPWR Tile_X0Y9_FrameStrobe[0] latch
XFILLER_387_88 VPWR VGND sg13cmos5l_decap_4
XFILLER_220_178 VPWR VGND sg13cmos5l_fill_1
XFILLER_537_14 VPWR VGND sg13cmos5l_decap_8
XANTENNA__3348__X Tile_X0Y2_FrameData_O[19] VPWR VGND sg13cmos5l_antennanp
XFILLER_684_42 VPWR VGND sg13cmos5l_decap_8
XFILLER_508_165 VPWR VGND sg13cmos5l_fill_2
X_3662_ AXI_M_SOC_AWADDR23 Tile_X0Y4_WW4END[7] Tile_X0Y4_WW4END[15] Tile_X0Y4_W6END[7]
+ _4343_/X _1999_/Q _1998_/Q VPWR VGND sg13cmos5l_mux4_1
XFILLER_307_216 VPWR VGND sg13cmos5l_fill_1
X_0874_ _0874_/Q Tile_X0Y9_FrameData[21] VGND VPWR Tile_X0Y9_FrameStrobe[6] latch
X_2613_ _2613_/Q Tile_X0Y6_FrameData[18] VGND VPWR Tile_X0Y9_FrameStrobe[5] latch
X_3593_ Tile_X0Y9_FrameData_O[23] Tile_X0Y9_FrameData[23] VPWR VGND sg13cmos5l_buf_1
XFILLER_133_119 VPWR VGND sg13cmos5l_decap_8
XFILLER_617_91 VPWR VGND sg13cmos5l_decap_8
X_2544_ _2544_/Q Tile_X0Y6_FrameData[23] VGND VPWR Tile_X0Y9_FrameStrobe[3] latch
XFILLER_553_35 VPWR VGND sg13cmos5l_decap_8
XFILLER_336_70 VPWR VGND sg13cmos5l_decap_8
XFILLER_48_0 VPWR VGND sg13cmos5l_fill_1
XFILLER_287_112 VPWR VGND sg13cmos5l_decap_8
XFILLER_272_14 VPWR VGND sg13cmos5l_decap_8
X_2475_ _2475_/Q Tile_X0Y6_FrameData[28] VGND VPWR Tile_X0Y9_FrameStrobe[1] latch
XANTENNA__3083__X Tile_X0Y7_E1BEG[1] VPWR VGND sg13cmos5l_antennanp
X_4214_ _4214_/X _4688_/X _4692_/X _4696_/X _4669_/X _0391_/Q _0390_/Q VPWR VGND sg13cmos5l_mux4_1
X_1426_ _1426_/Q Tile_X0Y1_FrameData[31] VGND VPWR Tile_X0Y9_FrameStrobe[0] latch
XFILLER_692_142 VPWR VGND sg13cmos5l_fill_2
XFILLER_141_196 VPWR VGND sg13cmos5l_decap_8
XFILLER_703_49 VPWR VGND sg13cmos5l_decap_8
XFILLER_429_161 VPWR VGND sg13cmos5l_decap_8
X_4145_ _4145_/X _4197_/X Tile_X0Y3_WW4END[7] _4196_/X AXI_M_SOC_WREADY _1851_/Q _1850_/Q
+ VPWR VGND sg13cmos5l_mux4_1
XFILLER_422_28 VPWR VGND sg13cmos5l_decap_8
XFILLER_205_63 VPWR VGND sg13cmos5l_decap_8
X_1357_ _1357_/Q Tile_X0Y1_FrameData[12] VGND VPWR Tile_X0Y9_FrameStrobe[5] latch
XFILLER_352_91 VPWR VGND sg13cmos5l_decap_8
XFILLER_18_28 VPWR VGND sg13cmos5l_decap_8
X_0308_ _0308_/Q Tile_X0Y7_FrameData[11] VGND VPWR Tile_X0Y9_FrameStrobe[4] latch
XFILLER_55_125 VPWR VGND sg13cmos5l_decap_8
X_4076_ _4076_/X AXI_M_SOC_AWREADY _4123_/X _4127_/X _4097_/X _1521_/Q _1520_/Q VPWR
+ VGND sg13cmos5l_mux4_1
X_1288_ _1288_/Q Tile_X0Y1_FrameData[17] VGND VPWR Tile_X0Y9_FrameStrobe[3] latch
X_3027_ Tile_X0Y5_EE4BEG[2] _4390_/X VPWR VGND sg13cmos5l_buf_1
X_0239_ _0239_/Q Tile_X0Y7_FrameData[16] VGND VPWR Tile_X0Y9_FrameStrobe[2] latch
XFILLER_578_21 VPWR VGND sg13cmos5l_decap_8
XFILLER_598_190 VPWR VGND sg13cmos5l_decap_8
XFILLER_221_84 VPWR VGND sg13cmos5l_decap_8
XFILLER_34_38 VPWR VGND sg13cmos5l_fill_2
XFILLER_211_112 VPWR VGND sg13cmos5l_decap_8
XFILLER_357_105 VPWR VGND sg13cmos5l_decap_8
XFILLER_578_98 VPWR VGND sg13cmos5l_decap_8
XFILLER_211_156 VPWR VGND sg13cmos5l_decap_8
XFILLER_297_77 VPWR VGND sg13cmos5l_decap_8
X_3929_ _3929_/X _3983_/X Tile_X0Y1_WW4END[5] _3982_/X AXI_M_SOC_ARREADY _1351_/Q
+ _1350_/Q VPWR VGND sg13cmos5l_mux4_1
XFILLER_447_14 VPWR VGND sg13cmos5l_decap_8
XANTENNA__3258__X Tile_X0Y0_FrameData_O[26] VPWR VGND sg13cmos5l_antennanp
XFILLER_594_42 VPWR VGND sg13cmos5l_decap_8
XFILLER_126_7 VPWR VGND sg13cmos5l_decap_8
XFILLER_514_124 VPWR VGND sg13cmos5l_fill_1
XFILLER_365_193 VPWR VGND sg13cmos5l_decap_4
XFILLER_59_13 VPWR VGND sg13cmos5l_decap_8
XFILLER_463_35 VPWR VGND sg13cmos5l_decap_8
XFILLER_246_70 VPWR VGND sg13cmos5l_decap_4
XFILLER_117_193 VPWR VGND sg13cmos5l_fill_2
XFILLER_278_112 VPWR VGND sg13cmos5l_decap_8
XFILLER_668_172 VPWR VGND sg13cmos5l_decap_8
XFILLER_182_14 VPWR VGND sg13cmos5l_decap_8
XFILLER_495_7 VPWR VGND sg13cmos5l_decap_8
XFILLER_132_185 VPWR VGND sg13cmos5l_decap_8
XFILLER_132_196 VPWR VGND sg13cmos5l_decap_8
XFILLER_613_49 VPWR VGND sg13cmos5l_decap_8
XFILLER_219_201 VPWR VGND sg13cmos5l_fill_1
XFILLER_482_226 VPWR VGND sg13cmos5l_fill_2
XFILLER_332_28 VPWR VGND sg13cmos5l_decap_8
XFILLER_293_137 VPWR VGND sg13cmos5l_fill_1
XFILLER_662_7 VPWR VGND sg13cmos5l_decap_8
XFILLER_115_63 VPWR VGND sg13cmos5l_decap_8
XANTENNA__3721__X AXI_M_SOC_WDATA31 VPWR VGND sg13cmos5l_antennanp
XFILLER_75_56 VPWR VGND sg13cmos5l_decap_8
XFILLER_435_175 VPWR VGND sg13cmos5l_fill_2
XFILLER_46_158 VPWR VGND sg13cmos5l_fill_1
XFILLER_412_61 VPWR VGND sg13cmos5l_decap_8
XFILLER_450_123 VPWR VGND sg13cmos5l_fill_2
XFILLER_61_106 VPWR VGND sg13cmos5l_fill_1
XFILLER_488_21 VPWR VGND sg13cmos5l_decap_8
XFILLER_61_139 VPWR VGND sg13cmos5l_decap_8
XFILLER_54_180 VPWR VGND sg13cmos5l_decap_8
XFILLER_450_178 VPWR VGND sg13cmos5l_decap_4
XFILLER_131_84 VPWR VGND sg13cmos5l_decap_8
XFILLER_152_0 VPWR VGND sg13cmos5l_decap_8
XFILLER_348_105 VPWR VGND sg13cmos5l_decap_8
XFILLER_199_174 VPWR VGND sg13cmos5l_decap_8
XFILLER_91_77 VPWR VGND sg13cmos5l_decap_8
XFILLER_488_98 VPWR VGND sg13cmos5l_decap_8
XFILLER_91_88 VPWR VGND sg13cmos5l_fill_2
XFILLER_638_35 VPWR VGND sg13cmos5l_decap_8
XFILLER_202_156 VPWR VGND sg13cmos5l_fill_2
XFILLER_357_14 VPWR VGND sg13cmos5l_decap_8
XFILLER_202_189 VPWR VGND sg13cmos5l_fill_2
XANTENNA__3168__X Tile_X0Y4_E6BEG[5] VPWR VGND sg13cmos5l_antennanp
XFILLER_417_0 VPWR VGND sg13cmos5l_decap_8
XFILLER_363_119 VPWR VGND sg13cmos5l_decap_8
XFILLER_155_211 VPWR VGND sg13cmos5l_fill_1
XFILLER_356_182 VPWR VGND sg13cmos5l_decap_8
XFILLER_371_130 VPWR VGND sg13cmos5l_fill_2
XFILLER_507_28 VPWR VGND sg13cmos5l_decap_8
XFILLER_654_56 VPWR VGND sg13cmos5l_decap_8
XFILLER_505_168 VPWR VGND sg13cmos5l_decap_8
XFILLER_437_91 VPWR VGND sg13cmos5l_decap_8
XFILLER_40_70 VPWR VGND sg13cmos5l_fill_2
XANTENNA__2800__X Tile_X0Y3_E6BEG[10] VPWR VGND sg13cmos5l_antennanp
X_0590_ _0590_/Q Tile_X0Y8_FrameData[17] VGND VPWR Tile_X0Y9_FrameStrobe[5] latch
XFILLER_373_35 VPWR VGND sg13cmos5l_decap_8
XFILLER_156_70 VPWR VGND sg13cmos5l_decap_8
XFILLER_269_112 VPWR VGND sg13cmos5l_fill_2
XFILLER_69_217 VPWR VGND sg13cmos5l_decap_8
XFILLER_69_228 VPWR VGND sg13cmos5l_fill_1
X_2260_ _2260_/Q Tile_X0Y5_FrameData[17] VGND VPWR Tile_X0Y9_FrameStrobe[2] latch
XFILLER_523_49 VPWR VGND sg13cmos5l_decap_8
XFILLER_284_126 VPWR VGND sg13cmos5l_decap_8
X_1211_ _1211_/Q Tile_X0Y1_FrameData[30] VGND VPWR Tile_X0Y9_FrameStrobe[1] latch
XFILLER_670_77 VPWR VGND sg13cmos5l_decap_8
XFILLER_242_28 VPWR VGND sg13cmos5l_decap_8
X_2191_ _2191_/Q Tile_X0Y5_FrameData[22] VGND VPWR Tile_X0Y9_FrameStrobe[0] latch
XANTENNA__3631__X Tile_X0Y9_S4BEG[9] VPWR VGND sg13cmos5l_antennanp
X_1142_ _1142_/Q Tile_X0Y0_FrameData[21] VGND VPWR Tile_X0Y9_FrameStrobe[6] latch
XFILLER_1_42 VPWR VGND sg13cmos5l_decap_8
XFILLER_630_201 VPWR VGND sg13cmos5l_decap_8
XFILLER_426_175 VPWR VGND sg13cmos5l_decap_8
XFILLER_679_42 VPWR VGND sg13cmos5l_decap_8
XFILLER_587_105 VPWR VGND sg13cmos5l_decap_8
X_1073_ _1073_/Q Tile_X0Y0_FrameData[26] VGND VPWR Tile_X0Y9_FrameStrobe[4] latch
XFILLER_398_21 VPWR VGND sg13cmos5l_decap_8
X_4901_ _4901_/X Tile_X0Y9_N2MID[0] Tile_X0Y9_N2END[0] _4932_/X _4816_/X _0695_/Q
+ _0694_/Q VPWR VGND sg13cmos5l_mux4_1
XFILLER_587_149 VPWR VGND sg13cmos5l_fill_1
XFILLER_52_139 VPWR VGND sg13cmos5l_decap_8
X_4832_ _4832_/X Tile_X0Y9_W1END[0] Tile_X0Y9_W2MID[3] Tile_X0Y9_W2END[3] _4906_/X
+ _0875_/Q _0874_/Q VPWR VGND sg13cmos5l_mux4_1
XFILLER_528_216 VPWR VGND sg13cmos5l_fill_2
XFILLER_339_116 VPWR VGND sg13cmos5l_fill_1
XFILLER_548_35 VPWR VGND sg13cmos5l_decap_8
XFILLER_695_63 VPWR VGND sg13cmos5l_decap_8
XFILLER_267_14 VPWR VGND sg13cmos5l_decap_8
X_1975_ _1975_/Q Tile_X0Y4_FrameData[14] VGND VPWR Tile_X0Y9_FrameStrobe[1] latch
X_4763_ _4763_/X Tile_X0Y9_N4END[7] _0074_/X _4808_/X _4812_/X _0521_/Q _0520_/Q VPWR
+ VGND sg13cmos5l_mux4_1
XANTENNA__3078__X Tile_X0Y4_E2BEGb[4] VPWR VGND sg13cmos5l_antennanp
XFILLER_354_119 VPWR VGND sg13cmos5l_decap_8
X_0926_ _0926_/Q Tile_X0Y9_FrameData[1] VGND VPWR Tile_X0Y9_FrameStrobe[7] latch
X_3714_ AXI_M_SOC_WDATA24 Tile_X0Y6_WW4END[0] Tile_X0Y6_WW4END[8] Tile_X0Y6_W6END[8]
+ _4576_/X _2511_/Q _2510_/Q VPWR VGND sg13cmos5l_mux4_1
X_4694_ _4694_/X _4665_/X Tile_X0Y9_N4END[10] _4664_/X _0054_/X _0195_/Q _0194_/Q
+ VPWR VGND sg13cmos5l_mux4_1
XFILLER_417_28 VPWR VGND sg13cmos5l_decap_8
XFILLER_362_141 VPWR VGND sg13cmos5l_fill_2
X_0857_ _0857_/Q Tile_X0Y9_FrameData[6] VGND VPWR Tile_X0Y9_FrameStrobe[5] latch
X_3645_ AXI_M_SOC_AWADDR6 Tile_X0Y5_WW4END[6] Tile_X0Y5_WW4END[14] Tile_X0Y5_W6END[6]
+ _4457_/X _2259_/Q _2258_/Q VPWR VGND sg13cmos5l_mux4_1
XFILLER_106_108 VPWR VGND sg13cmos5l_fill_2
XFILLER_564_56 VPWR VGND sg13cmos5l_decap_8
XFILLER_362_163 VPWR VGND sg13cmos5l_fill_1
XFILLER_511_105 VPWR VGND sg13cmos5l_decap_8
XFILLER_347_91 VPWR VGND sg13cmos5l_decap_8
XFILLER_362_185 VPWR VGND sg13cmos5l_decap_4
X_3576_ Tile_X0Y9_FrameData_O[6] Tile_X0Y9_FrameData[6] VPWR VGND sg13cmos5l_buf_1
X_0788_ _0788_/Q Tile_X0Y9_FrameData[11] VGND VPWR Tile_X0Y9_FrameStrobe[3] latch
XFILLER_283_35 VPWR VGND sg13cmos5l_decap_8
X_2527_ _2527_/Q Tile_X0Y6_FrameData[8] VGND VPWR Tile_X0Y9_FrameStrobe[2] latch
XFILLER_114_141 VPWR VGND sg13cmos5l_decap_4
X_2458_ _2458_/Q Tile_X0Y6_FrameData[13] VGND VPWR Tile_X0Y9_FrameStrobe[0] latch
XFILLER_433_49 VPWR VGND sg13cmos5l_decap_8
XFILLER_216_84 VPWR VGND sg13cmos5l_decap_8
XFILLER_275_126 VPWR VGND sg13cmos5l_decap_8
XFILLER_580_77 VPWR VGND sg13cmos5l_decap_8
XFILLER_29_49 VPWR VGND sg13cmos5l_decap_8
XFILLER_75_209 VPWR VGND sg13cmos5l_fill_2
X_1409_ _1409_/Q Tile_X0Y1_FrameData[24] VGND VPWR Tile_X0Y9_FrameStrobe[7] latch
XFILLER_152_28 VPWR VGND sg13cmos5l_decap_8
X_2389_ _2389_/Q Tile_X0Y5_FrameData[16] VGND VPWR Tile_X0Y9_FrameStrobe[6] latch
XFILLER_606_220 VPWR VGND sg13cmos5l_decap_8
XANTENNA__3541__X Tile_X0Y9_E2BEGb[7] VPWR VGND sg13cmos5l_antennanp
X_4128_ _4128_/X Tile_X0Y1_W2MID[7] Tile_X0Y1_W2END[7] Tile_X0Y1_W6END[8] _3989_/X
+ _1381_/Q _1380_/Q VPWR VGND sg13cmos5l_mux4_1
XFILLER_28_136 VPWR VGND sg13cmos5l_decap_8
XFILLER_432_112 VPWR VGND sg13cmos5l_decap_8
XFILLER_589_42 VPWR VGND sg13cmos5l_decap_8
XFILLER_578_105 VPWR VGND sg13cmos5l_decap_8
X_4059_ _4059_/X Tile_X0Y2_WW4END[12] AXI_M_SOC_AWREADY _4113_/X _4102_/X _1555_/Q
+ _1554_/Q VPWR VGND sg13cmos5l_mux4_1
XFILLER_45_59 VPWR VGND sg13cmos5l_decap_8
XFILLER_231_207 VPWR VGND sg13cmos5l_decap_4
XFILLER_36_191 VPWR VGND sg13cmos5l_decap_8
XFILLER_432_189 VPWR VGND sg13cmos5l_decap_8
XFILLER_101_21 VPWR VGND sg13cmos5l_decap_8
XFILLER_586_160 VPWR VGND sg13cmos5l_decap_4
XFILLER_243_7 VPWR VGND sg13cmos5l_decap_8
XFILLER_458_35 VPWR VGND sg13cmos5l_decap_8
XFILLER_177_14 VPWR VGND sg13cmos5l_decap_8
XFILLER_61_69 VPWR VGND sg13cmos5l_decap_8
XFILLER_534_219 VPWR VGND sg13cmos5l_fill_2
XFILLER_410_7 VPWR VGND sg13cmos5l_decap_8
XFILLER_345_119 VPWR VGND sg13cmos5l_decap_8
XFILLER_508_7 VPWR VGND sg13cmos5l_decap_8
XFILLER_608_49 VPWR VGND sg13cmos5l_decap_8
XFILLER_499_112 VPWR VGND sg13cmos5l_decap_8
XFILLER_327_28 VPWR VGND sg13cmos5l_decap_8
XANTENNA__3716__X AXI_M_SOC_WDATA26 VPWR VGND sg13cmos5l_antennanp
XFILLER_474_56 VPWR VGND sg13cmos5l_decap_8
XFILLER_152_214 VPWR VGND sg13cmos5l_fill_2
XFILLER_502_105 VPWR VGND sg13cmos5l_decap_8
XFILLER_193_35 VPWR VGND sg13cmos5l_decap_8
XFILLER_499_189 VPWR VGND sg13cmos5l_fill_2
XFILLER_105_130 VPWR VGND sg13cmos5l_decap_8
XFILLER_120_100 VPWR VGND sg13cmos5l_decap_8
XFILLER_10_84 VPWR VGND sg13cmos5l_decap_8
XFILLER_343_49 VPWR VGND sg13cmos5l_decap_8
XFILLER_126_84 VPWR VGND sg13cmos5l_decap_8
XFILLER_704_70 VPWR VGND sg13cmos5l_decap_8
XFILLER_671_101 VPWR VGND sg13cmos5l_fill_1
XFILLER_490_77 VPWR VGND sg13cmos5l_decap_8
XFILLER_671_123 VPWR VGND sg13cmos5l_fill_2
XFILLER_640_14 VPWR VGND sg13cmos5l_decap_8
XFILLER_266_148 VPWR VGND sg13cmos5l_decap_8
XFILLER_120_166 VPWR VGND sg13cmos5l_fill_1
XFILLER_408_120 VPWR VGND sg13cmos5l_fill_2
XANTENNA__3451__X Tile_X0Y1_FrameData_O[9] VPWR VGND sg13cmos5l_antennanp
XFILLER_671_156 VPWR VGND sg13cmos5l_fill_1
XFILLER_19_158 VPWR VGND sg13cmos5l_fill_1
XFILLER_569_105 VPWR VGND sg13cmos5l_decap_8
XFILLER_499_42 VPWR VGND sg13cmos5l_decap_8
XFILLER_423_112 VPWR VGND sg13cmos5l_decap_8
XFILLER_367_0 VPWR VGND sg13cmos5l_decap_8
XFILLER_222_218 VPWR VGND sg13cmos5l_fill_1
XFILLER_534_0 VPWR VGND sg13cmos5l_decap_8
XFILLER_649_56 VPWR VGND sg13cmos5l_decap_8
XFILLER_35_70 VPWR VGND sg13cmos5l_decap_4
XFILLER_187_111 VPWR VGND sg13cmos5l_decap_8
XFILLER_376_211 VPWR VGND sg13cmos5l_decap_4
XFILLER_577_182 VPWR VGND sg13cmos5l_decap_4
XFILLER_368_35 VPWR VGND sg13cmos5l_decap_8
XFILLER_89_7 VPWR VGND sg13cmos5l_decap_8
XFILLER_701_0 VPWR VGND sg13cmos5l_decap_8
XFILLER_187_188 VPWR VGND sg13cmos5l_decap_4
X_1760_ _1760_/Q Tile_X0Y3_FrameData[9] VGND VPWR Tile_X0Y9_FrameStrobe[2] latch
XFILLER_391_225 VPWR VGND sg13cmos5l_decap_4
XFILLER_518_49 VPWR VGND sg13cmos5l_decap_8
X_0711_ _0711_/Q Tile_X0Y9_FrameData[24] VGND VPWR Tile_X0Y9_FrameStrobe[1] latch
XFILLER_665_77 VPWR VGND sg13cmos5l_decap_8
XFILLER_237_28 VPWR VGND sg13cmos5l_decap_8
X_1691_ _1691_/Q Tile_X0Y3_FrameData[14] VGND VPWR Tile_X0Y9_FrameStrobe[0] latch
XFILLER_143_203 VPWR VGND sg13cmos5l_decap_8
XANTENNA__3626__X Tile_X0Y9_S4BEG[4] VPWR VGND sg13cmos5l_antennanp
XFILLER_384_56 VPWR VGND sg13cmos5l_decap_8
X_3430_ Tile_X0Y4_FrameData_O[21] Tile_X0Y4_FrameData[21] VPWR VGND sg13cmos5l_buf_1
XFILLER_143_225 VPWR VGND sg13cmos5l_decap_4
X_0642_ _0642_/Q Tile_X0Y8_FrameData[29] VGND VPWR Tile_X0Y9_FrameStrobe[7] latch
XFILLER_344_196 VPWR VGND sg13cmos5l_decap_8
XFILLER_681_21 VPWR VGND sg13cmos5l_decap_8
X_3361_ Tile_X0Y2_EE4BEG[0] _4056_/X VPWR VGND sg13cmos5l_buf_1
X_0573_ _0573_/Q Tile_X0Y8_FrameData[2] VGND VPWR Tile_X0Y9_FrameStrobe[4] latch
X_2312_ _2312_/Q Tile_X0Y5_FrameData[29] VGND VPWR Tile_X0Y9_FrameStrobe[4] latch
X_3292_ Tile_X0Y0_E2BEGb[0] _3812_/X VPWR VGND sg13cmos5l_buf_1
XFILLER_681_98 VPWR VGND sg13cmos5l_decap_8
XFILLER_253_49 VPWR VGND sg13cmos5l_decap_8
XFILLER_111_122 VPWR VGND sg13cmos5l_decap_4
XFILLER_614_70 VPWR VGND sg13cmos5l_decap_8
XFILLER_501_182 VPWR VGND sg13cmos5l_decap_8
XFILLER_647_175 VPWR VGND sg13cmos5l_decap_8
XFILLER_662_112 VPWR VGND sg13cmos5l_fill_1
XFILLER_257_137 VPWR VGND sg13cmos5l_decap_8
X_2243_ _2243_/Q Tile_X0Y5_FrameData[2] VGND VPWR Tile_X0Y9_FrameStrobe[1] latch
XFILLER_550_14 VPWR VGND sg13cmos5l_decap_8
XANTENNA__3361__X Tile_X0Y2_EE4BEG[0] VPWR VGND sg13cmos5l_antennanp
X_2174_ _2174_/Q Tile_X0Y4_FrameData[7] VGND VPWR Tile_X0Y9_FrameStrobe[7] latch
XFILLER_272_129 VPWR VGND sg13cmos5l_decap_4
XFILLER_662_189 VPWR VGND sg13cmos5l_fill_2
X_1125_ _1125_/Q Tile_X0Y0_FrameData[6] VGND VPWR Tile_X0Y9_FrameStrobe[5] latch
XFILLER_265_192 VPWR VGND sg13cmos5l_fill_2
XFILLER_280_140 VPWR VGND sg13cmos5l_decap_8
XFILLER_630_91 VPWR VGND sg13cmos5l_decap_8
XFILLER_202_42 VPWR VGND sg13cmos5l_decap_8
X_1056_ _1056_/Q Tile_X0Y0_FrameData[11] VGND VPWR Tile_X0Y9_FrameStrobe[3] latch
XFILLER_559_56 VPWR VGND sg13cmos5l_decap_8
XFILLER_575_119 VPWR VGND sg13cmos5l_decap_8
XFILLER_717_102 VPWR VGND sg13cmos5l_decap_4
XFILLER_278_35 VPWR VGND sg13cmos5l_decap_8
X_4815_ _4815_/X _4783_/X Tile_X0Y9_N4END[7] _4782_/X _0074_/X _0441_/Q _0440_/Q VPWR
+ VGND sg13cmos5l_mux4_1
XFILLER_33_194 VPWR VGND sg13cmos5l_decap_4
XFILLER_717_146 VPWR VGND sg13cmos5l_decap_8
XFILLER_717_157 VPWR VGND sg13cmos5l_fill_1
XFILLER_717_168 VPWR VGND sg13cmos5l_decap_8
XFILLER_516_208 VPWR VGND sg13cmos5l_decap_4
XFILLER_583_174 VPWR VGND sg13cmos5l_fill_2
XFILLER_193_125 VPWR VGND sg13cmos5l_decap_8
XFILLER_717_179 VPWR VGND sg13cmos5l_fill_1
XFILLER_31_17 VPWR VGND sg13cmos5l_decap_8
X_4746_ _4746_/X Tile_X0Y8_WW4END[13] AXI_M_SOC_RDATA10 _4813_/X _4788_/X _0555_/Q
+ _0554_/Q VPWR VGND sg13cmos5l_mux4_1
X_1958_ _1958_/Q Tile_X0Y4_FrameData[31] VGND VPWR Tile_X0Y9_FrameStrobe[1] latch
XFILLER_428_49 VPWR VGND sg13cmos5l_decap_8
XFILLER_575_77 VPWR VGND sg13cmos5l_decap_8
XFILLER_147_28 VPWR VGND sg13cmos5l_decap_8
X_0909_ _0909_/Q Tile_X0Y9_FrameData[18] VGND VPWR Tile_X0Y9_FrameStrobe[7] latch
X_1889_ _1889_/Q Tile_X0Y3_FrameData[8] VGND VPWR Tile_X0Y9_FrameStrobe[6] latch
X_4677_ _4677_/X _4226_/X _4230_/X _4234_/X _4210_/X _1865_/Q _1864_/Q VPWR VGND sg13cmos5l_mux4_1
XFILLER_335_152 VPWR VGND sg13cmos5l_decap_4
XFILLER_294_56 VPWR VGND sg13cmos5l_decap_8
XANTENNA__3536__X Tile_X0Y9_E2BEGb[2] VPWR VGND sg13cmos5l_antennanp
XFILLER_335_174 VPWR VGND sg13cmos5l_fill_2
X_3628_ Tile_X0Y9_S4BEG[6] _3628_/A VPWR VGND sg13cmos5l_buf_1
XFILLER_591_21 VPWR VGND sg13cmos5l_decap_8
XFILLER_350_133 VPWR VGND sg13cmos5l_decap_8
XFILLER_685_226 VPWR VGND sg13cmos5l_fill_2
XFILLER_496_126 VPWR VGND sg13cmos5l_decap_8
X_3559_ Tile_X0Y9_EE4BEG[5] _4869_/X VPWR VGND sg13cmos5l_buf_1
XFILLER_248_104 VPWR VGND sg13cmos5l_decap_4
XFILLER_163_49 VPWR VGND sg13cmos5l_decap_8
XFILLER_102_133 VPWR VGND sg13cmos5l_decap_4
XFILLER_524_70 VPWR VGND sg13cmos5l_decap_8
XFILLER_653_112 VPWR VGND sg13cmos5l_decap_8
XFILLER_460_14 VPWR VGND sg13cmos5l_decap_8
XFILLER_193_7 VPWR VGND sg13cmos5l_decap_8
XANTENNA__3271__X Tile_X0Y0_EE4BEG[7] VPWR VGND sg13cmos5l_antennanp
XFILLER_263_118 VPWR VGND sg13cmos5l_fill_1
XFILLER_653_189 VPWR VGND sg13cmos5l_decap_8
XFILLER_610_28 VPWR VGND sg13cmos5l_decap_8
XFILLER_360_7 VPWR VGND sg13cmos5l_decap_8
XFILLER_458_7 VPWR VGND sg13cmos5l_decap_8
XFILLER_405_145 VPWR VGND sg13cmos5l_fill_1
XFILLER_540_91 VPWR VGND sg13cmos5l_decap_8
XFILLER_271_151 VPWR VGND sg13cmos5l_fill_2
XFILLER_405_167 VPWR VGND sg13cmos5l_fill_1
XFILLER_112_42 VPWR VGND sg13cmos5l_decap_8
XFILLER_72_35 VPWR VGND sg13cmos5l_decap_8
XFILLER_566_119 VPWR VGND sg13cmos5l_decap_8
XFILLER_469_56 VPWR VGND sg13cmos5l_decap_8
XFILLER_420_137 VPWR VGND sg13cmos5l_decap_8
XFILLER_169_100 VPWR VGND sg13cmos5l_fill_2
XFILLER_24_150 VPWR VGND sg13cmos5l_fill_2
XFILLER_625_7 VPWR VGND sg13cmos5l_decap_8
XFILLER_188_35 VPWR VGND sg13cmos5l_decap_8
XFILLER_169_177 VPWR VGND sg13cmos5l_decap_8
XFILLER_708_168 VPWR VGND sg13cmos5l_decap_8
XFILLER_373_225 VPWR VGND sg13cmos5l_decap_4
XFILLER_574_196 VPWR VGND sg13cmos5l_decap_8
XFILLER_338_49 VPWR VGND sg13cmos5l_decap_8
XFILLER_485_77 VPWR VGND sg13cmos5l_decap_8
XFILLER_635_14 VPWR VGND sg13cmos5l_decap_8
XANTENNA__3446__X Tile_X0Y1_FrameData_O[4] VPWR VGND sg13cmos5l_antennanp
XFILLER_115_0 VPWR VGND sg13cmos5l_decap_8
XFILLER_192_180 VPWR VGND sg13cmos5l_decap_8
XFILLER_530_211 VPWR VGND sg13cmos5l_decap_8
XFILLER_487_126 VPWR VGND sg13cmos5l_fill_1
XFILLER_97_21 VPWR VGND sg13cmos5l_decap_8
XFILLER_341_188 VPWR VGND sg13cmos5l_decap_8
XFILLER_651_35 VPWR VGND sg13cmos5l_decap_8
XFILLER_434_70 VPWR VGND sg13cmos5l_decap_8
XFILLER_484_0 VPWR VGND sg13cmos5l_decap_8
XFILLER_644_112 VPWR VGND sg13cmos5l_decap_8
XFILLER_370_14 VPWR VGND sg13cmos5l_decap_8
XANTENNA__3181__X Tile_X0Y0_N4BEG[5] VPWR VGND sg13cmos5l_antennanp
XFILLER_651_0 VPWR VGND sg13cmos5l_decap_8
XFILLER_644_189 VPWR VGND sg13cmos5l_decap_8
XFILLER_247_192 VPWR VGND sg13cmos5l_decap_8
XFILLER_520_28 VPWR VGND sg13cmos5l_decap_8
XFILLER_303_63 VPWR VGND sg13cmos5l_fill_1
XFILLER_62_201 VPWR VGND sg13cmos5l_fill_2
XFILLER_262_151 VPWR VGND sg13cmos5l_decap_8
XFILLER_557_119 VPWR VGND sg13cmos5l_decap_8
XFILLER_379_56 VPWR VGND sg13cmos5l_decap_8
X_2930_ Tile_X0Y8_E2BEGb[6] _4742_/X VPWR VGND sg13cmos5l_buf_1
XFILLER_349_211 VPWR VGND sg13cmos5l_fill_1
XFILLER_411_159 VPWR VGND sg13cmos5l_fill_1
XFILLER_676_21 VPWR VGND sg13cmos5l_decap_8
X_2861_ Tile_X0Y6_E6BEG[10] _4538_/X VPWR VGND sg13cmos5l_buf_1
XFILLER_364_214 VPWR VGND sg13cmos5l_fill_2
X_4600_ _4600_/X Tile_X0Y7_W1END[0] Tile_X0Y7_WW4END[12] Tile_X0Y7_W6END[4] _4684_/X
+ _0355_/Q _0354_/Q VPWR VGND sg13cmos5l_mux4_1
X_1812_ _1812_/Q Tile_X0Y3_FrameData[21] VGND VPWR Tile_X0Y9_FrameStrobe[4] latch
X_2792_ Tile_X0Y3_E6BEG[2] _4182_/X VPWR VGND sg13cmos5l_buf_1
XFILLER_676_98 VPWR VGND sg13cmos5l_decap_8
XFILLER_248_49 VPWR VGND sg13cmos5l_decap_8
XFILLER_714_127 VPWR VGND sg13cmos5l_decap_8
XFILLER_609_70 VPWR VGND sg13cmos5l_decap_8
XFILLER_580_133 VPWR VGND sg13cmos5l_decap_8
X_1743_ _1743_/Q Tile_X0Y3_FrameData[26] VGND VPWR Tile_X0Y9_FrameStrobe[2] latch
X_4531_ _4531_/X Tile_X0Y9_N4END[15] _0150_/X _4576_/X _4580_/X _2545_/Q _2544_/Q
+ VPWR VGND sg13cmos5l_mux4_1
XFILLER_545_14 VPWR VGND sg13cmos5l_decap_8
XANTENNA__3356__X Tile_X0Y2_FrameData_O[27] VPWR VGND sg13cmos5l_antennanp
XFILLER_7_63 VPWR VGND sg13cmos5l_decap_8
XFILLER_116_203 VPWR VGND sg13cmos5l_decap_4
XFILLER_692_42 VPWR VGND sg13cmos5l_decap_8
X_1674_ _1674_/Q Tile_X0Y2_FrameData[31] VGND VPWR Tile_X0Y9_FrameStrobe[0] latch
X_4462_ _4462_/X _4427_/X _0097_/X _4426_/X _0156_/X _2215_/Q _2214_/Q VPWR VGND sg13cmos5l_mux4_1
X_0625_ _0625_/Q Tile_X0Y8_FrameData[14] VGND VPWR Tile_X0Y9_FrameStrobe[6] latch
X_3413_ Tile_X0Y4_FrameData_O[4] Tile_X0Y4_FrameData[4] VPWR VGND sg13cmos5l_buf_1
X_4393_ _4393_/X Tile_X0Y5_WW4END[10] AXI_M_SOC_RLAST _4461_/X _4432_/X _2317_/Q _2316_/Q
+ VPWR VGND sg13cmos5l_mux4_1
XFILLER_625_91 VPWR VGND sg13cmos5l_decap_8
X_3344_ Tile_X0Y2_FrameData_O[15] Tile_X0Y2_FrameData[15] VPWR VGND sg13cmos5l_buf_1
X_0556_ _0556_/Q Tile_X0Y8_FrameData[19] VGND VPWR Tile_X0Y9_FrameStrobe[4] latch
XFILLER_561_35 VPWR VGND sg13cmos5l_decap_8
XFILLER_344_70 VPWR VGND sg13cmos5l_decap_8
XFILLER_30_0 VPWR VGND sg13cmos5l_fill_1
XFILLER_635_112 VPWR VGND sg13cmos5l_decap_8
XFILLER_280_14 VPWR VGND sg13cmos5l_decap_8
X_3275_ Tile_X0Y0_EE4BEG[11] _3831_/X VPWR VGND sg13cmos5l_buf_1
XANTENNA__3091__X Tile_X0Y7_E2BEG[5] VPWR VGND sg13cmos5l_antennanp
X_0487_ _0487_/Q Tile_X0Y8_FrameData[24] VGND VPWR Tile_X0Y9_FrameStrobe[2] latch
X_2226_ _2226_/Q Tile_X0Y5_FrameData[19] VGND VPWR Tile_X0Y9_FrameStrobe[1] latch
XFILLER_711_49 VPWR VGND sg13cmos5l_decap_8
XFILLER_650_126 VPWR VGND sg13cmos5l_decap_8
XFILLER_430_28 VPWR VGND sg13cmos5l_decap_8
X_2157_ _2157_/Q Tile_X0Y4_FrameData[24] VGND VPWR Tile_X0Y9_FrameStrobe[7] latch
XFILLER_213_63 VPWR VGND sg13cmos5l_decap_8
XFILLER_26_28 VPWR VGND sg13cmos5l_decap_8
XFILLER_360_91 VPWR VGND sg13cmos5l_decap_8
X_1108_ _1108_/Q Tile_X0Y0_FrameData[23] VGND VPWR Tile_X0Y9_FrameStrobe[5] latch
XFILLER_198_206 VPWR VGND sg13cmos5l_fill_1
X_2088_ _2088_/Q Tile_X0Y4_FrameData[29] VGND VPWR Tile_X0Y9_FrameStrobe[5] latch
XFILLER_399_188 VPWR VGND sg13cmos5l_decap_8
XFILLER_289_56 VPWR VGND sg13cmos5l_decap_8
X_1039_ _1039_/Q Tile_X0Y0_FrameData[28] VGND VPWR Tile_X0Y9_FrameStrobe[3] latch
XFILLER_402_159 VPWR VGND sg13cmos5l_decap_8
XFILLER_586_21 VPWR VGND sg13cmos5l_decap_8
XFILLER_42_49 VPWR VGND sg13cmos5l_fill_1
XFILLER_705_105 VPWR VGND sg13cmos5l_decap_8
XFILLER_586_98 VPWR VGND sg13cmos5l_decap_8
XFILLER_556_196 VPWR VGND sg13cmos5l_decap_8
XFILLER_158_49 VPWR VGND sg13cmos5l_decap_8
XFILLER_571_133 VPWR VGND sg13cmos5l_decap_8
XFILLER_519_70 VPWR VGND sg13cmos5l_decap_8
X_4729_ _4729_/X Tile_X0Y8_W2MID[6] AXI_M_SOC_RDATA9 _4787_/X _4786_/X _0589_/Q _0588_/Q
+ VPWR VGND sg13cmos5l_mux4_1
XFILLER_455_14 VPWR VGND sg13cmos5l_decap_8
XANTENNA__3266__X Tile_X0Y0_EE4BEG[2] VPWR VGND sg13cmos5l_antennanp
XFILLER_323_111 VPWR VGND sg13cmos5l_decap_4
XFILLER_206_7 VPWR VGND sg13cmos5l_decap_8
XFILLER_713_182 VPWR VGND sg13cmos5l_decap_8
XFILLER_605_28 VPWR VGND sg13cmos5l_decap_8
XFILLER_107_42 VPWR VGND sg13cmos5l_decap_8
XFILLER_471_35 VPWR VGND sg13cmos5l_decap_8
XFILLER_88_153 VPWR VGND sg13cmos5l_decap_8
XFILLER_67_35 VPWR VGND sg13cmos5l_decap_8
XFILLER_626_112 VPWR VGND sg13cmos5l_fill_2
XFILLER_190_14 VPWR VGND sg13cmos5l_decap_8
XFILLER_575_7 VPWR VGND sg13cmos5l_decap_8
XFILLER_492_140 VPWR VGND sg13cmos5l_decap_8
XFILLER_626_156 VPWR VGND sg13cmos5l_decap_4
XFILLER_236_107 VPWR VGND sg13cmos5l_decap_8
XFILLER_29_220 VPWR VGND sg13cmos5l_fill_2
XFILLER_621_49 VPWR VGND sg13cmos5l_decap_8
XFILLER_404_84 VPWR VGND sg13cmos5l_fill_2
XFILLER_641_126 VPWR VGND sg13cmos5l_decap_8
XFILLER_123_63 VPWR VGND sg13cmos5l_decap_8
XFILLER_123_74 VPWR VGND sg13cmos5l_fill_1
XFILLER_270_91 VPWR VGND sg13cmos5l_decap_8
XFILLER_244_162 VPWR VGND sg13cmos5l_fill_1
XFILLER_83_56 VPWR VGND sg13cmos5l_decap_4
XFILLER_199_56 VPWR VGND sg13cmos5l_decap_8
XFILLER_496_21 VPWR VGND sg13cmos5l_decap_8
XFILLER_232_0 VPWR VGND sg13cmos5l_decap_8
XFILLER_346_214 VPWR VGND sg13cmos5l_fill_2
XFILLER_496_98 VPWR VGND sg13cmos5l_decap_8
XFILLER_646_35 VPWR VGND sg13cmos5l_decap_8
XFILLER_429_70 VPWR VGND sg13cmos5l_decap_8
XFILLER_157_158 VPWR VGND sg13cmos5l_decap_8
XFILLER_365_14 VPWR VGND sg13cmos5l_decap_8
XANTENNA__3176__X Tile_X0Y0_N4BEG[0] VPWR VGND sg13cmos5l_antennanp
XFILLER_32_93 VPWR VGND sg13cmos5l_decap_8
XFILLER_711_119 VPWR VGND sg13cmos5l_decap_8
XFILLER_562_188 VPWR VGND sg13cmos5l_decap_8
XFILLER_314_144 VPWR VGND sg13cmos5l_decap_8
XFILLER_699_0 VPWR VGND sg13cmos5l_decap_8
XFILLER_515_28 VPWR VGND sg13cmos5l_decap_8
XFILLER_662_56 VPWR VGND sg13cmos5l_decap_8
X_0410_ _0410_/Q Tile_X0Y7_FrameData[5] VGND VPWR Tile_X0Y9_FrameStrobe[7] latch
X_1390_ _1390_/Q Tile_X0Y1_FrameData[11] VGND VPWR Tile_X0Y9_FrameStrobe[6] latch
XFILLER_381_35 VPWR VGND sg13cmos5l_decap_8
XFILLER_267_210 VPWR VGND sg13cmos5l_decap_8
XFILLER_164_70 VPWR VGND sg13cmos5l_decap_4
XFILLER_617_112 VPWR VGND sg13cmos5l_decap_8
X_0341_ _0341_/Q Tile_X0Y7_FrameData[10] VGND VPWR Tile_X0Y9_FrameStrobe[5] latch
XFILLER_94_112 VPWR VGND sg13cmos5l_decap_8
XFILLER_617_145 VPWR VGND sg13cmos5l_fill_2
X_3060_ Tile_X0Y5_FrameData_O[19] Tile_X0Y5_FrameData[19] VPWR VGND sg13cmos5l_buf_1
X_0272_ _0272_/Q Tile_X0Y7_FrameData[15] VGND VPWR Tile_X0Y9_FrameStrobe[3] latch
XFILLER_531_49 VPWR VGND sg13cmos5l_decap_8
X_2011_ _2011_/Q Tile_X0Y4_FrameData[10] VGND VPWR Tile_X0Y9_FrameStrobe[2] latch
XFILLER_632_126 VPWR VGND sg13cmos5l_fill_1
XFILLER_250_28 VPWR VGND sg13cmos5l_decap_8
XFILLER_180_91 VPWR VGND sg13cmos5l_decap_8
XFILLER_235_173 VPWR VGND sg13cmos5l_fill_1
XFILLER_687_42 VPWR VGND sg13cmos5l_decap_8
X_3962_ _3962_/X Tile_X0Y1_WW4END[1] AXI_M_SOC_ARREADY _4009_/X _3991_/X _1285_/Q
+ _1284_/Q VPWR VGND sg13cmos5l_mux4_1
X_2913_ Tile_X0Y8_E1BEG[1] _4725_/X VPWR VGND sg13cmos5l_buf_1
X_3893_ _3893_/X Tile_X0Y1_W2MID[5] Tile_X0Y1_W2END[5] Tile_X0Y1_W6END[5] _3993_/X
+ _1413_/Q _1412_/Q VPWR VGND sg13cmos5l_mux4_1
XFILLER_538_163 VPWR VGND sg13cmos5l_decap_8
XFILLER_148_125 VPWR VGND sg13cmos5l_fill_1
X_2844_ Tile_X0Y6_E2BEGb[1] _4505_/X VPWR VGND sg13cmos5l_buf_1
XFILLER_148_147 VPWR VGND sg13cmos5l_decap_8
XFILLER_556_35 VPWR VGND sg13cmos5l_decap_8
XFILLER_339_70 VPWR VGND sg13cmos5l_decap_8
XFILLER_148_158 VPWR VGND sg13cmos5l_fill_2
XFILLER_78_0 VPWR VGND sg13cmos5l_decap_8
XFILLER_275_14 VPWR VGND sg13cmos5l_decap_8
XANTENNA__3086__X Tile_X0Y7_E2BEG[0] VPWR VGND sg13cmos5l_antennanp
X_2775_ Tile_X0Y3_EE4BEG[1] _4165_/X VPWR VGND sg13cmos5l_buf_1
XFILLER_702_108 VPWR VGND sg13cmos5l_decap_8
XFILLER_352_228 VPWR VGND sg13cmos5l_fill_1
XFILLER_702_119 VPWR VGND sg13cmos5l_fill_2
X_4514_ _4514_/X Tile_X0Y6_WW4END[13] AXI_M_SOC_RDATA26 _4581_/X _4556_/X _2579_/Q
+ _2578_/Q VPWR VGND sg13cmos5l_mux4_1
X_1726_ _1726_/Q Tile_X0Y3_FrameData[11] VGND VPWR Tile_X0Y9_FrameStrobe[1] latch
XFILLER_706_49 VPWR VGND sg13cmos5l_decap_8
X_1657_ _1657_/Q Tile_X0Y2_FrameData[24] VGND VPWR Tile_X0Y9_FrameStrobe[7] latch
X_4445_ _4445_/X Tile_X0Y9_W1END[2] Tile_X0Y9_WW4END[2] Tile_X0Y9_W6END[10] _4918_/X
+ _0897_/Q _0896_/Q VPWR VGND sg13cmos5l_mux4_1
XFILLER_425_28 VPWR VGND sg13cmos5l_decap_8
XFILLER_208_63 VPWR VGND sg13cmos5l_decap_8
XFILLER_171_161 VPWR VGND sg13cmos5l_decap_8
XFILLER_572_56 VPWR VGND sg13cmos5l_decap_8
XFILLER_305_188 VPWR VGND sg13cmos5l_fill_1
XFILLER_104_228 VPWR VGND sg13cmos5l_fill_1
XFILLER_355_91 VPWR VGND sg13cmos5l_decap_8
X_0608_ _0608_/Q Tile_X0Y8_FrameData[31] VGND VPWR Tile_X0Y9_FrameStrobe[6] latch
XFILLER_710_196 VPWR VGND sg13cmos5l_decap_8
X_1588_ _1588_/Q Tile_X0Y2_FrameData[29] VGND VPWR Tile_X0Y9_FrameStrobe[5] latch
X_4376_ _4376_/X Tile_X0Y5_W2MID[3] AXI_M_SOC_RVALID _4434_/X _4433_/X _2351_/Q _2350_/Q
+ VPWR VGND sg13cmos5l_mux4_1
XFILLER_291_35 VPWR VGND sg13cmos5l_decap_8
XFILLER_320_158 VPWR VGND sg13cmos5l_decap_4
XFILLER_258_221 VPWR VGND sg13cmos5l_decap_8
XFILLER_459_181 VPWR VGND sg13cmos5l_decap_8
X_0539_ _0539_/Q Tile_X0Y8_FrameData[4] VGND VPWR Tile_X0Y9_FrameStrobe[3] latch
X_3327_ Tile_X0Y4_EE4BEG[15] _4287_/X VPWR VGND sg13cmos5l_buf_1
XFILLER_85_112 VPWR VGND sg13cmos5l_decap_4
XFILLER_273_213 VPWR VGND sg13cmos5l_fill_2
X_3258_ Tile_X0Y0_FrameData_O[26] Tile_X0Y0_FrameData[26] VPWR VGND sg13cmos5l_buf_1
XFILLER_441_49 VPWR VGND sg13cmos5l_decap_8
XFILLER_224_84 VPWR VGND sg13cmos5l_decap_4
XFILLER_37_38 VPWR VGND sg13cmos5l_decap_8
XFILLER_160_28 VPWR VGND sg13cmos5l_decap_8
X_2209_ _2209_/Q Tile_X0Y5_FrameData[4] VGND VPWR Tile_X0Y9_FrameStrobe[0] latch
X_3189_ Tile_X0Y0_N4BEG[13] _3189_/A VPWR VGND sg13cmos5l_buf_1
XFILLER_387_114 VPWR VGND sg13cmos5l_decap_4
XFILLER_597_42 VPWR VGND sg13cmos5l_decap_8
XFILLER_576_225 VPWR VGND sg13cmos5l_decap_4
XFILLER_156_7 VPWR VGND sg13cmos5l_decap_8
XFILLER_529_130 VPWR VGND sg13cmos5l_decap_8
XFILLER_529_141 VPWR VGND sg13cmos5l_fill_1
XFILLER_591_217 VPWR VGND sg13cmos5l_fill_2
XFILLER_591_228 VPWR VGND sg13cmos5l_fill_1
XFILLER_323_7 VPWR VGND sg13cmos5l_decap_8
XFILLER_139_147 VPWR VGND sg13cmos5l_decap_8
XFILLER_466_35 VPWR VGND sg13cmos5l_decap_8
XFILLER_249_70 VPWR VGND sg13cmos5l_decap_8
XFILLER_343_206 VPWR VGND sg13cmos5l_decap_8
XFILLER_185_14 VPWR VGND sg13cmos5l_decap_8
XFILLER_5_105 VPWR VGND sg13cmos5l_decap_8
XFILLER_544_188 VPWR VGND sg13cmos5l_fill_1
XFILLER_616_49 VPWR VGND sg13cmos5l_decap_8
XFILLER_497_210 VPWR VGND sg13cmos5l_decap_4
XFILLER_162_150 VPWR VGND sg13cmos5l_fill_1
XANTENNA__0132__Y AXI_M_SOC_AWLEN7 VPWR VGND sg13cmos5l_antennanp
XFILLER_692_7 VPWR VGND sg13cmos5l_decap_8
XFILLER_335_28 VPWR VGND sg13cmos5l_decap_8
XFILLER_118_63 VPWR VGND sg13cmos5l_decap_4
XFILLER_500_203 VPWR VGND sg13cmos5l_decap_8
XFILLER_482_56 VPWR VGND sg13cmos5l_decap_8
XFILLER_457_107 VPWR VGND sg13cmos5l_decap_8
XFILLER_78_56 VPWR VGND sg13cmos5l_decap_8
XFILLER_500_225 VPWR VGND sg13cmos5l_decap_4
XFILLER_76_134 VPWR VGND sg13cmos5l_fill_1
XFILLER_351_49 VPWR VGND sg13cmos5l_decap_8
XFILLER_134_84 VPWR VGND sg13cmos5l_decap_8
XFILLER_712_70 VPWR VGND sg13cmos5l_decap_8
XFILLER_76_156 VPWR VGND sg13cmos5l_decap_8
XFILLER_182_0 VPWR VGND sg13cmos5l_decap_8
XFILLER_94_77 VPWR VGND sg13cmos5l_decap_8
XFILLER_614_148 VPWR VGND sg13cmos5l_fill_2
XFILLER_480_165 VPWR VGND sg13cmos5l_decap_8
XFILLER_27_93 VPWR VGND sg13cmos5l_fill_1
XFILLER_447_0 VPWR VGND sg13cmos5l_decap_8
XFILLER_300_42 VPWR VGND sg13cmos5l_decap_8
XFILLER_614_0 VPWR VGND sg13cmos5l_decap_8
XFILLER_657_56 VPWR VGND sg13cmos5l_decap_8
XFILLER_43_70 VPWR VGND sg13cmos5l_decap_8
XFILLER_535_100 VPWR VGND sg13cmos5l_fill_1
XFILLER_393_139 VPWR VGND sg13cmos5l_fill_2
XANTENNA__2803__X Tile_X0Y3_E2BEGb[1] VPWR VGND sg13cmos5l_antennanp
X_0890_ _0890_/Q Tile_X0Y9_FrameData[5] VGND VPWR Tile_X0Y9_FrameStrobe[6] latch
XFILLER_376_35 VPWR VGND sg13cmos5l_decap_8
XFILLER_159_70 VPWR VGND sg13cmos5l_fill_2
XFILLER_71_7 VPWR VGND sg13cmos5l_decap_8
XFILLER_535_155 VPWR VGND sg13cmos5l_fill_2
X_2560_ _2560_/Q Tile_X0Y6_FrameData[7] VGND VPWR Tile_X0Y9_FrameStrobe[3] latch
XFILLER_526_49 VPWR VGND sg13cmos5l_decap_8
XFILLER_488_210 VPWR VGND sg13cmos5l_fill_2
X_1511_ _1511_/Q Tile_X0Y2_FrameData[10] VGND VPWR Tile_X0Y9_FrameStrobe[2] latch
XFILLER_673_77 VPWR VGND sg13cmos5l_decap_8
XFILLER_245_28 VPWR VGND sg13cmos5l_decap_8
X_2491_ _2491_/Q Tile_X0Y6_FrameData[12] VGND VPWR Tile_X0Y9_FrameStrobe[1] latch
XFILLER_673_88 VPWR VGND sg13cmos5l_fill_2
XFILLER_392_56 VPWR VGND sg13cmos5l_decap_4
XANTENNA__3634__X Tile_X0Y9_S4BEG[12] VPWR VGND sg13cmos5l_antennanp
XFILLER_153_194 VPWR VGND sg13cmos5l_fill_2
X_1442_ _1442_/Q Tile_X0Y2_FrameData[15] VGND VPWR Tile_X0Y9_FrameStrobe[0] latch
X_4230_ _4230_/X _4195_/X _0089_/X _4194_/X Tile_X0Y0_S4END[12] _1713_/Q _1712_/Q
+ VPWR VGND sg13cmos5l_mux4_1
XFILLER_4_42 VPWR VGND sg13cmos5l_decap_8
X_4161_ _4161_/X Tile_X0Y3_W2END[2] AXI_M_SOC_WREADY _4209_/X _4208_/X _1819_/Q _1818_/Q
+ VPWR VGND sg13cmos5l_mux4_1
X_1373_ _1373_/Q Tile_X0Y1_FrameData[28] VGND VPWR Tile_X0Y9_FrameStrobe[6] latch
XFILLER_456_140 VPWR VGND sg13cmos5l_decap_8
X_0324_ _0324_/Q Tile_X0Y7_FrameData[27] VGND VPWR Tile_X0Y9_FrameStrobe[5] latch
X_3112_ Tile_X0Y7_E6BEG[10] _4654_/X VPWR VGND sg13cmos5l_buf_1
X_4092_ _4092_/X Tile_X0Y1_W1END[2] Tile_X0Y1_W6END[10] _3999_/X _3978_/X _1385_/Q
+ _1384_/Q VPWR VGND sg13cmos5l_mux4_1
XFILLER_261_49 VPWR VGND sg13cmos5l_decap_8
XFILLER_67_156 VPWR VGND sg13cmos5l_decap_8
XFILLER_622_70 VPWR VGND sg13cmos5l_decap_8
X_3043_ Tile_X0Y5_FrameData_O[2] Tile_X0Y5_FrameData[2] VPWR VGND sg13cmos5l_buf_1
X_0255_ _0255_/Q Tile_X0Y7_FrameData[0] VGND VPWR Tile_X0Y9_FrameStrobe[2] latch
XFILLER_82_126 VPWR VGND sg13cmos5l_fill_1
XFILLER_208_140 VPWR VGND sg13cmos5l_decap_8
XFILLER_270_205 VPWR VGND sg13cmos5l_decap_8
XFILLER_698_63 VPWR VGND sg13cmos5l_decap_8
XFILLER_620_118 VPWR VGND sg13cmos5l_fill_1
X_0186_ _0186_/Q Tile_X0Y7_FrameData[5] VGND VPWR Tile_X0Y9_FrameStrobe[0] latch
XFILLER_23_204 VPWR VGND sg13cmos5l_fill_1
XFILLER_90_170 VPWR VGND sg13cmos5l_decap_8
XFILLER_223_165 VPWR VGND sg13cmos5l_fill_1
XFILLER_210_42 VPWR VGND sg13cmos5l_decap_8
XFILLER_223_187 VPWR VGND sg13cmos5l_decap_8
X_3945_ _3945_/X Tile_X0Y1_W2END[2] AXI_M_SOC_ARREADY _3993_/X _3992_/X _1319_/Q _1318_/Q
+ VPWR VGND sg13cmos5l_mux4_1
XFILLER_384_106 VPWR VGND sg13cmos5l_decap_8
XFILLER_573_217 VPWR VGND sg13cmos5l_decap_8
XFILLER_573_228 VPWR VGND sg13cmos5l_fill_1
XFILLER_567_56 VPWR VGND sg13cmos5l_decap_8
X_3876_ _3876_/X _3848_/X _0067_/X Tile_X0Y0_S1END[0] Tile_X0Y0_S4END[0] _0979_/Q
+ _0978_/Q VPWR VGND sg13cmos5l_mux4_1
XFILLER_286_35 VPWR VGND sg13cmos5l_decap_8
X_2827_ Tile_X0Y4_E2BEG[5] _4261_/X VPWR VGND sg13cmos5l_buf_1
X_2758_ Tile_X0Y3_FrameData_O[16] Tile_X0Y3_FrameData[16] VPWR VGND sg13cmos5l_buf_1
XFILLER_436_49 VPWR VGND sg13cmos5l_decap_8
XFILLER_219_84 VPWR VGND sg13cmos5l_decap_8
XFILLER_541_147 VPWR VGND sg13cmos5l_decap_8
XFILLER_583_77 VPWR VGND sg13cmos5l_decap_8
XFILLER_155_28 VPWR VGND sg13cmos5l_decap_8
X_1709_ _1709_/Q Tile_X0Y3_FrameData[28] VGND VPWR Tile_X0Y9_FrameStrobe[1] latch
XFILLER_144_161 VPWR VGND sg13cmos5l_fill_2
X_2689_ _2689_/Q Tile_X0Y6_FrameData[6] VGND VPWR Tile_X0Y9_FrameStrobe[7] latch
XANTENNA__3544__X Tile_X0Y9_E6BEG[2] VPWR VGND sg13cmos5l_antennanp
XFILLER_144_194 VPWR VGND sg13cmos5l_decap_8
X_4428_ _4428_/X _4367_/X _4483_/X _4482_/X _4366_/X _2191_/Q _2190_/Q VPWR VGND sg13cmos5l_mux4_1
X_4359_ _4359_/X Tile_X0Y6_W2MID[4] Tile_X0Y6_W2END[4] Tile_X0Y6_W6END[4] _4559_/X
+ _2681_/Q _2680_/Q VPWR VGND sg13cmos5l_mux4_1
XFILLER_235_94 VPWR VGND sg13cmos5l_fill_1
XFILLER_48_59 VPWR VGND sg13cmos5l_decap_8
XFILLER_58_145 VPWR VGND sg13cmos5l_decap_8
XFILLER_171_49 VPWR VGND sg13cmos5l_decap_8
XFILLER_532_70 VPWR VGND sg13cmos5l_fill_1
XFILLER_462_110 VPWR VGND sg13cmos5l_fill_1
XFILLER_104_21 VPWR VGND sg13cmos5l_decap_8
XFILLER_462_132 VPWR VGND sg13cmos5l_decap_8
XFILLER_273_7 VPWR VGND sg13cmos5l_decap_8
XFILLER_64_14 VPWR VGND sg13cmos5l_decap_8
XFILLER_73_148 VPWR VGND sg13cmos5l_decap_8
XFILLER_549_225 VPWR VGND sg13cmos5l_decap_4
XFILLER_440_7 VPWR VGND sg13cmos5l_decap_8
XFILLER_401_63 VPWR VGND sg13cmos5l_decap_8
XFILLER_81_170 VPWR VGND sg13cmos5l_fill_2
XFILLER_401_74 VPWR VGND sg13cmos5l_fill_1
XFILLER_214_154 VPWR VGND sg13cmos5l_decap_8
XFILLER_538_7 VPWR VGND sg13cmos5l_decap_8
XFILLER_401_96 VPWR VGND sg13cmos5l_fill_2
XFILLER_159_209 VPWR VGND sg13cmos5l_decap_4
XFILLER_120_42 VPWR VGND sg13cmos5l_decap_8
XFILLER_564_206 VPWR VGND sg13cmos5l_fill_1
XFILLER_80_35 VPWR VGND sg13cmos5l_decap_8
XFILLER_564_228 VPWR VGND sg13cmos5l_fill_1
XFILLER_477_56 VPWR VGND sg13cmos5l_decap_8
XANTENNA__3719__X AXI_M_SOC_WDATA29 VPWR VGND sg13cmos5l_antennanp
XFILLER_705_7 VPWR VGND sg13cmos5l_decap_8
XFILLER_477_89 VPWR VGND sg13cmos5l_fill_1
XFILLER_383_150 VPWR VGND sg13cmos5l_fill_2
XFILLER_127_106 VPWR VGND sg13cmos5l_decap_8
XFILLER_196_68 VPWR VGND sg13cmos5l_decap_8
XFILLER_316_228 VPWR VGND sg13cmos5l_fill_1
XFILLER_13_84 VPWR VGND sg13cmos5l_decap_8
XFILLER_346_49 VPWR VGND sg13cmos5l_decap_8
XFILLER_129_84 VPWR VGND sg13cmos5l_decap_4
XFILLER_707_70 VPWR VGND sg13cmos5l_decap_8
XFILLER_532_158 VPWR VGND sg13cmos5l_decap_4
XFILLER_493_77 VPWR VGND sg13cmos5l_decap_8
XFILLER_135_161 VPWR VGND sg13cmos5l_decap_8
XFILLER_643_14 VPWR VGND sg13cmos5l_decap_8
XANTENNA__3454__X Tile_X0Y1_FrameData_O[12] VPWR VGND sg13cmos5l_antennanp
XFILLER_8_0 VPWR VGND sg13cmos5l_decap_8
XFILLER_150_142 VPWR VGND sg13cmos5l_decap_4
XFILLER_397_0 VPWR VGND sg13cmos5l_decap_8
XFILLER_442_70 VPWR VGND sg13cmos5l_decap_8
XFILLER_642_210 VPWR VGND sg13cmos5l_fill_1
XFILLER_564_0 VPWR VGND sg13cmos5l_decap_8
XFILLER_49_189 VPWR VGND sg13cmos5l_fill_1
XFILLER_38_70 VPWR VGND sg13cmos5l_decap_4
XFILLER_599_147 VPWR VGND sg13cmos5l_fill_2
X_0040_ _0040_/X _4334_/X _4335_/X _0636_/Q VPWR VGND sg13cmos5l_mux2_1
XFILLER_252_227 VPWR VGND sg13cmos5l_fill_2
XFILLER_72_170 VPWR VGND sg13cmos5l_fill_2
XFILLER_311_63 VPWR VGND sg13cmos5l_decap_8
XFILLER_205_154 VPWR VGND sg13cmos5l_decap_8
XFILLER_54_80 VPWR VGND sg13cmos5l_decap_8
XFILLER_668_77 VPWR VGND sg13cmos5l_decap_8
X_1991_ _1991_/Q Tile_X0Y4_FrameData[30] VGND VPWR Tile_X0Y9_FrameStrobe[2] latch
XFILLER_555_228 VPWR VGND sg13cmos5l_fill_1
XFILLER_387_56 VPWR VGND sg13cmos5l_decap_8
XANTENNA__3629__X Tile_X0Y9_S4BEG[7] VPWR VGND sg13cmos5l_antennanp
X_3730_ AXI_M_SOC_ARADDR2 Tile_X0Y9_WW4END[2] Tile_X0Y9_WW4END[10] Tile_X0Y9_W6END[2]
+ _4918_/X _0755_/Q _0754_/Q VPWR VGND sg13cmos5l_mux4_1
X_0942_ _0942_/Q Tile_X0Y0_FrameData[29] VGND VPWR Tile_X0Y9_FrameStrobe[0] latch
XFILLER_508_133 VPWR VGND sg13cmos5l_decap_8
XFILLER_684_21 VPWR VGND sg13cmos5l_decap_8
X_3661_ AXI_M_SOC_AWADDR22 Tile_X0Y4_WW4END[6] Tile_X0Y4_WW4END[14] Tile_X0Y4_W6END[6]
+ _4342_/X _2001_/Q _2000_/Q VPWR VGND sg13cmos5l_mux4_1
X_0873_ _0873_/Q Tile_X0Y9_FrameData[22] VGND VPWR Tile_X0Y9_FrameStrobe[6] latch
XFILLER_712_203 VPWR VGND sg13cmos5l_decap_8
XFILLER_523_114 VPWR VGND sg13cmos5l_decap_8
XFILLER_374_194 VPWR VGND sg13cmos5l_decap_8
XFILLER_712_225 VPWR VGND sg13cmos5l_decap_4
X_2612_ _2612_/Q Tile_X0Y6_FrameData[19] VGND VPWR Tile_X0Y9_FrameStrobe[5] latch
XFILLER_684_98 VPWR VGND sg13cmos5l_fill_2
X_3592_ Tile_X0Y9_FrameData_O[22] Tile_X0Y9_FrameData[22] VPWR VGND sg13cmos5l_buf_1
XFILLER_256_49 VPWR VGND sg13cmos5l_decap_8
XFILLER_617_70 VPWR VGND sg13cmos5l_decap_8
XFILLER_126_161 VPWR VGND sg13cmos5l_fill_2
X_2543_ _2543_/Q Tile_X0Y6_FrameData[24] VGND VPWR Tile_X0Y9_FrameStrobe[3] latch
XFILLER_553_14 VPWR VGND sg13cmos5l_decap_8
XANTENNA__3364__X Tile_X0Y2_EE4BEG[3] VPWR VGND sg13cmos5l_antennanp
X_2474_ _2474_/Q Tile_X0Y6_FrameData[29] VGND VPWR Tile_X0Y9_FrameStrobe[1] latch
X_4213_ _4213_/X Tile_X0Y7_W1END[0] Tile_X0Y7_WW4END[0] Tile_X0Y7_W6END[8] _4684_/X
+ _0391_/Q _0390_/Q VPWR VGND sg13cmos5l_mux4_1
XFILLER_141_175 VPWR VGND sg13cmos5l_decap_8
X_1425_ _1425_/Q Tile_X0Y1_FrameData[8] VGND VPWR Tile_X0Y9_FrameStrobe[7] latch
XFILLER_703_28 VPWR VGND sg13cmos5l_decap_8
XFILLER_429_140 VPWR VGND sg13cmos5l_decap_8
XFILLER_491_205 VPWR VGND sg13cmos5l_decap_8
XFILLER_633_91 VPWR VGND sg13cmos5l_decap_8
XFILLER_205_42 VPWR VGND sg13cmos5l_decap_8
X_1356_ _1356_/Q Tile_X0Y1_FrameData[13] VGND VPWR Tile_X0Y9_FrameStrobe[5] latch
X_4144_ _4144_/X _4195_/X Tile_X0Y3_WW4END[6] _4194_/X AXI_M_SOC_BVALID _1853_/Q _1852_/Q
+ VPWR VGND sg13cmos5l_mux4_1
XFILLER_352_70 VPWR VGND sg13cmos5l_decap_8
X_0307_ _0307_/Q Tile_X0Y7_FrameData[12] VGND VPWR Tile_X0Y9_FrameStrobe[4] latch
XFILLER_55_104 VPWR VGND sg13cmos5l_decap_8
X_1287_ _1287_/Q Tile_X0Y1_FrameData[18] VGND VPWR Tile_X0Y9_FrameStrobe[3] latch
X_4075_ _4075_/X _0094_/X Tile_X0Y0_S4END[11] _4124_/X _4113_/X _1523_/Q _1522_/Q
+ VPWR VGND sg13cmos5l_mux4_1
X_0238_ _0238_/Q Tile_X0Y7_FrameData[17] VGND VPWR Tile_X0Y9_FrameStrobe[2] latch
X_3026_ Tile_X0Y5_EE4BEG[1] _4389_/X VPWR VGND sg13cmos5l_buf_1
XFILLER_502_84 VPWR VGND sg13cmos5l_decap_8
XFILLER_221_63 VPWR VGND sg13cmos5l_decap_8
X_0169_ _0169_/Q Tile_X0Y7_FrameData[22] VGND VPWR Tile_X0Y9_FrameStrobe[0] latch
XFILLER_34_17 VPWR VGND sg13cmos5l_decap_8
XFILLER_63_181 VPWR VGND sg13cmos5l_decap_8
XFILLER_578_77 VPWR VGND sg13cmos5l_decap_8
XFILLER_400_213 VPWR VGND sg13cmos5l_decap_8
XFILLER_546_217 VPWR VGND sg13cmos5l_decap_8
XFILLER_546_228 VPWR VGND sg13cmos5l_fill_1
XANTENNA__3539__X Tile_X0Y9_E2BEGb[5] VPWR VGND sg13cmos5l_antennanp
XFILLER_297_56 VPWR VGND sg13cmos5l_decap_8
XFILLER_11_218 VPWR VGND sg13cmos5l_fill_1
X_3928_ _3928_/X _3981_/X Tile_X0Y1_WW4END[4] _3980_/X AXI_M_SOC_ARREADY _1353_/Q
+ _1352_/Q VPWR VGND sg13cmos5l_mux4_1
XFILLER_594_21 VPWR VGND sg13cmos5l_decap_8
X_3859_ _3859_/X _3895_/X _3894_/X Tile_X0Y0_S2MID[3] Tile_X0Y0_S2END[3] _0957_/Q
+ _0956_/Q VPWR VGND sg13cmos5l_mux4_1
XFILLER_594_98 VPWR VGND sg13cmos5l_decap_8
XFILLER_166_49 VPWR VGND sg13cmos5l_decap_8
XFILLER_119_7 VPWR VGND sg13cmos5l_decap_8
XFILLER_527_70 VPWR VGND sg13cmos5l_decap_8
XFILLER_463_14 VPWR VGND sg13cmos5l_decap_8
XANTENNA__3274__X Tile_X0Y0_EE4BEG[10] VPWR VGND sg13cmos5l_antennanp
XFILLER_668_140 VPWR VGND sg13cmos5l_decap_8
XFILLER_1_7 VPWR VGND sg13cmos5l_decap_8
XFILLER_59_69 VPWR VGND sg13cmos5l_decap_8
XFILLER_613_28 VPWR VGND sg13cmos5l_decap_8
XFILLER_390_7 VPWR VGND sg13cmos5l_decap_8
XFILLER_488_7 VPWR VGND sg13cmos5l_decap_8
XFILLER_482_205 VPWR VGND sg13cmos5l_decap_8
XFILLER_293_105 VPWR VGND sg13cmos5l_decap_8
XFILLER_543_91 VPWR VGND sg13cmos5l_decap_8
XFILLER_115_42 VPWR VGND sg13cmos5l_decap_8
XFILLER_293_149 VPWR VGND sg13cmos5l_decap_8
XFILLER_262_70 VPWR VGND sg13cmos5l_decap_4
XFILLER_624_221 VPWR VGND sg13cmos5l_fill_1
XFILLER_75_35 VPWR VGND sg13cmos5l_decap_8
XFILLER_115_86 VPWR VGND sg13cmos5l_decap_8
XFILLER_46_115 VPWR VGND sg13cmos5l_fill_1
XFILLER_115_97 VPWR VGND sg13cmos5l_fill_1
XFILLER_655_7 VPWR VGND sg13cmos5l_decap_8
XFILLER_435_154 VPWR VGND sg13cmos5l_decap_8
XFILLER_412_40 VPWR VGND sg13cmos5l_decap_8
XFILLER_131_63 VPWR VGND sg13cmos5l_decap_8
XFILLER_91_56 VPWR VGND sg13cmos5l_decap_8
XFILLER_488_77 VPWR VGND sg13cmos5l_decap_8
XFILLER_638_14 VPWR VGND sg13cmos5l_decap_8
XFILLER_537_228 VPWR VGND sg13cmos5l_fill_1
XFILLER_145_0 VPWR VGND sg13cmos5l_decap_8
XANTENNA__3449__X Tile_X0Y1_FrameData_O[7] VPWR VGND sg13cmos5l_antennanp
XFILLER_356_161 VPWR VGND sg13cmos5l_decap_8
XFILLER_312_0 VPWR VGND sg13cmos5l_decap_8
XFILLER_654_35 VPWR VGND sg13cmos5l_decap_8
XFILLER_505_147 VPWR VGND sg13cmos5l_decap_8
XFILLER_437_70 VPWR VGND sg13cmos5l_decap_8
XFILLER_170_204 VPWR VGND sg13cmos5l_decap_4
XFILLER_371_175 VPWR VGND sg13cmos5l_decap_8
XFILLER_170_215 VPWR VGND sg13cmos5l_decap_4
XFILLER_108_161 VPWR VGND sg13cmos5l_decap_4
XFILLER_373_14 VPWR VGND sg13cmos5l_decap_8
XANTENNA__3184__X Tile_X0Y0_N4BEG[8] VPWR VGND sg13cmos5l_antennanp
XFILLER_659_140 VPWR VGND sg13cmos5l_decap_8
XFILLER_269_135 VPWR VGND sg13cmos5l_decap_8
XFILLER_681_0 VPWR VGND sg13cmos5l_decap_8
XFILLER_659_195 VPWR VGND sg13cmos5l_decap_8
XFILLER_123_153 VPWR VGND sg13cmos5l_fill_1
XFILLER_523_28 VPWR VGND sg13cmos5l_decap_8
XFILLER_306_63 VPWR VGND sg13cmos5l_decap_8
XFILLER_674_154 VPWR VGND sg13cmos5l_fill_1
XFILLER_284_105 VPWR VGND sg13cmos5l_decap_8
XFILLER_670_56 VPWR VGND sg13cmos5l_decap_8
X_1210_ _1210_/Q Tile_X0Y1_FrameData[31] VGND VPWR Tile_X0Y9_FrameStrobe[1] latch
XFILLER_453_91 VPWR VGND sg13cmos5l_fill_1
XFILLER_49_80 VPWR VGND sg13cmos5l_decap_8
X_2190_ _2190_/Q Tile_X0Y5_FrameData[23] VGND VPWR Tile_X0Y9_FrameStrobe[0] latch
XFILLER_674_187 VPWR VGND sg13cmos5l_decap_4
XFILLER_172_70 VPWR VGND sg13cmos5l_fill_2
XFILLER_1_21 VPWR VGND sg13cmos5l_decap_8
X_1141_ _1141_/Q Tile_X0Y0_FrameData[22] VGND VPWR Tile_X0Y9_FrameStrobe[6] latch
XFILLER_37_115 VPWR VGND sg13cmos5l_decap_8
XFILLER_92_210 VPWR VGND sg13cmos5l_decap_8
XFILLER_426_154 VPWR VGND sg13cmos5l_decap_8
XFILLER_679_21 VPWR VGND sg13cmos5l_decap_8
XFILLER_225_216 VPWR VGND sg13cmos5l_fill_1
X_1072_ _1072_/Q Tile_X0Y0_FrameData[27] VGND VPWR Tile_X0Y9_FrameStrobe[4] latch
XFILLER_52_118 VPWR VGND sg13cmos5l_decap_8
XANTENNA__0048__X AXI_M_SOC_AWCACHE1 VPWR VGND sg13cmos5l_antennanp
X_4900_ _4900_/X Tile_X0Y9_N2MID[7] Tile_X0Y9_N2END[7] _4939_/X _4823_/X _0681_/Q
+ _0680_/Q VPWR VGND sg13cmos5l_mux4_1
XFILLER_679_98 VPWR VGND sg13cmos5l_decap_8
XFILLER_441_179 VPWR VGND sg13cmos5l_decap_8
X_4831_ _4831_/X Tile_X0Y9_W2MID[4] Tile_X0Y9_W2END[4] Tile_X0Y9_W6END[11] _4907_/X
+ _0877_/Q _0876_/Q VPWR VGND sg13cmos5l_mux4_1
XFILLER_548_14 VPWR VGND sg13cmos5l_decap_8
XANTENNA__3359__X Tile_X0Y2_FrameData_O[30] VPWR VGND sg13cmos5l_antennanp
XFILLER_528_228 VPWR VGND sg13cmos5l_fill_1
XFILLER_695_42 VPWR VGND sg13cmos5l_decap_8
X_4762_ _4762_/X Tile_X0Y9_N4END[6] _0075_/X _4809_/X _4813_/X _0523_/Q _0522_/Q VPWR
+ VGND sg13cmos5l_mux4_1
X_1974_ _1974_/Q Tile_X0Y4_FrameData[15] VGND VPWR Tile_X0Y9_FrameStrobe[1] latch
X_3713_ AXI_M_SOC_WDATA23 Tile_X0Y6_WW4END[7] Tile_X0Y6_WW4END[15] Tile_X0Y6_W6END[7]
+ _4575_/X _2513_/Q _2512_/Q VPWR VGND sg13cmos5l_mux4_1
X_0925_ _0925_/Q Tile_X0Y9_FrameData[2] VGND VPWR Tile_X0Y9_FrameStrobe[7] latch
XFILLER_146_212 VPWR VGND sg13cmos5l_fill_1
X_4693_ _4693_/X _4663_/X Tile_X0Y9_N4END[9] _4662_/X _0055_/X _0197_/Q _0196_/Q VPWR
+ VGND sg13cmos5l_mux4_1
X_3644_ AXI_M_SOC_AWADDR5 Tile_X0Y5_WW4END[5] Tile_X0Y5_WW4END[13] Tile_X0Y5_W6END[5]
+ _4456_/X _2261_/Q _2260_/Q VPWR VGND sg13cmos5l_mux4_1
X_0856_ _0856_/Q Tile_X0Y9_FrameData[7] VGND VPWR Tile_X0Y9_FrameStrobe[5] latch
XFILLER_60_0 VPWR VGND sg13cmos5l_fill_1
XFILLER_564_35 VPWR VGND sg13cmos5l_decap_8
XFILLER_347_70 VPWR VGND sg13cmos5l_decap_8
XFILLER_283_14 VPWR VGND sg13cmos5l_decap_8
X_3575_ Tile_X0Y9_FrameData_O[5] Tile_X0Y9_FrameData[5] VPWR VGND sg13cmos5l_buf_1
XANTENNA__3094__X Tile_X0Y7_E2BEGb[0] VPWR VGND sg13cmos5l_antennanp
X_0787_ _0787_/Q Tile_X0Y9_FrameData[12] VGND VPWR Tile_X0Y9_FrameStrobe[3] latch
XFILLER_362_197 VPWR VGND sg13cmos5l_decap_8
XFILLER_504_180 VPWR VGND sg13cmos5l_decap_8
X_2526_ _2526_/Q Tile_X0Y6_FrameData[9] VGND VPWR Tile_X0Y9_FrameStrobe[2] latch
XFILLER_433_28 VPWR VGND sg13cmos5l_decap_8
XFILLER_216_63 VPWR VGND sg13cmos5l_decap_8
X_2457_ _2457_/Q Tile_X0Y6_FrameData[14] VGND VPWR Tile_X0Y9_FrameStrobe[0] latch
XFILLER_29_28 VPWR VGND sg13cmos5l_decap_8
XFILLER_275_105 VPWR VGND sg13cmos5l_decap_8
XFILLER_580_56 VPWR VGND sg13cmos5l_decap_8
XFILLER_363_91 VPWR VGND sg13cmos5l_decap_8
X_1408_ _1408_/Q Tile_X0Y1_FrameData[25] VGND VPWR Tile_X0Y9_FrameStrobe[7] latch
X_2388_ _2388_/Q Tile_X0Y5_FrameData[17] VGND VPWR Tile_X0Y9_FrameStrobe[6] latch
XFILLER_606_210 VPWR VGND sg13cmos5l_fill_2
XFILLER_417_132 VPWR VGND sg13cmos5l_decap_8
X_4127_ _4127_/X _4095_/X _0094_/X _4094_/X Tile_X0Y0_S4END[11] _1459_/Q _1458_/Q
+ VPWR VGND sg13cmos5l_mux4_1
X_1339_ _1339_/Q Tile_X0Y1_FrameData[30] VGND VPWR Tile_X0Y9_FrameStrobe[5] latch
XFILLER_290_119 VPWR VGND sg13cmos5l_decap_8
XFILLER_589_21 VPWR VGND sg13cmos5l_decap_8
XFILLER_216_216 VPWR VGND sg13cmos5l_fill_2
XFILLER_283_182 VPWR VGND sg13cmos5l_decap_8
X_4058_ _4058_/X Tile_X0Y2_WW4END[13] AXI_M_SOC_AWREADY _4110_/X _4100_/X _1557_/Q
+ _1556_/Q VPWR VGND sg13cmos5l_mux4_1
XFILLER_417_198 VPWR VGND sg13cmos5l_decap_8
XFILLER_45_38 VPWR VGND sg13cmos5l_decap_8
XFILLER_43_107 VPWR VGND sg13cmos5l_fill_2
X_3009_ Tile_X0Y5_E2BEGb[4] _4384_/X VPWR VGND sg13cmos5l_buf_1
XFILLER_432_168 VPWR VGND sg13cmos5l_decap_8
XFILLER_589_98 VPWR VGND sg13cmos5l_decap_8
XFILLER_586_150 VPWR VGND sg13cmos5l_fill_2
XFILLER_458_14 VPWR VGND sg13cmos5l_decap_8
XFILLER_519_217 VPWR VGND sg13cmos5l_fill_2
XANTENNA__3269__X Tile_X0Y0_EE4BEG[5] VPWR VGND sg13cmos5l_antennanp
XFILLER_519_228 VPWR VGND sg13cmos5l_fill_1
XFILLER_236_7 VPWR VGND sg13cmos5l_decap_8
XFILLER_61_48 VPWR VGND sg13cmos5l_decap_8
XFILLER_608_28 VPWR VGND sg13cmos5l_decap_8
XFILLER_538_91 VPWR VGND sg13cmos5l_decap_4
XANTENNA__2901__X Tile_X0Y6_FrameData_O[22] VPWR VGND sg13cmos5l_antennanp
XFILLER_403_7 VPWR VGND sg13cmos5l_decap_8
XFILLER_474_35 VPWR VGND sg13cmos5l_decap_8
XFILLER_257_70 VPWR VGND sg13cmos5l_fill_2
XFILLER_353_175 VPWR VGND sg13cmos5l_decap_8
XFILLER_298_208 VPWR VGND sg13cmos5l_decap_4
XFILLER_193_14 VPWR VGND sg13cmos5l_decap_8
XFILLER_499_168 VPWR VGND sg13cmos5l_decap_8
XFILLER_624_49 VPWR VGND sg13cmos5l_decap_8
XFILLER_10_63 VPWR VGND sg13cmos5l_decap_8
XFILLER_343_28 VPWR VGND sg13cmos5l_decap_8
XFILLER_126_63 VPWR VGND sg13cmos5l_decap_8
XFILLER_510_161 VPWR VGND sg13cmos5l_fill_1
XFILLER_105_186 VPWR VGND sg13cmos5l_decap_8
XFILLER_656_154 VPWR VGND sg13cmos5l_fill_2
XFILLER_490_56 VPWR VGND sg13cmos5l_decap_8
XFILLER_273_91 VPWR VGND sg13cmos5l_decap_8
XFILLER_266_116 VPWR VGND sg13cmos5l_fill_1
XANTENNA__3732__X AXI_M_SOC_ARADDR4 VPWR VGND sg13cmos5l_antennanp
XFILLER_266_138 VPWR VGND sg13cmos5l_fill_2
XFILLER_120_156 VPWR VGND sg13cmos5l_fill_2
XFILLER_408_143 VPWR VGND sg13cmos5l_fill_2
XFILLER_281_119 VPWR VGND sg13cmos5l_decap_8
XFILLER_499_21 VPWR VGND sg13cmos5l_decap_8
XFILLER_142_84 VPWR VGND sg13cmos5l_decap_8
XFILLER_262_0 VPWR VGND sg13cmos5l_decap_8
XFILLER_34_129 VPWR VGND sg13cmos5l_fill_2
XFILLER_499_98 VPWR VGND sg13cmos5l_decap_8
XFILLER_649_35 VPWR VGND sg13cmos5l_decap_8
XFILLER_577_161 VPWR VGND sg13cmos5l_decap_8
XFILLER_42_151 VPWR VGND sg13cmos5l_decap_8
XFILLER_368_14 VPWR VGND sg13cmos5l_decap_8
XANTENNA__3179__X Tile_X0Y0_N4BEG[3] VPWR VGND sg13cmos5l_antennanp
XFILLER_527_0 VPWR VGND sg13cmos5l_decap_8
XFILLER_592_120 VPWR VGND sg13cmos5l_fill_1
XFILLER_518_28 VPWR VGND sg13cmos5l_decap_8
XFILLER_679_202 VPWR VGND sg13cmos5l_fill_1
XFILLER_665_56 VPWR VGND sg13cmos5l_decap_8
XANTENNA__2811__X Tile_X0Y3_E2BEG[1] VPWR VGND sg13cmos5l_antennanp
X_0710_ _0710_/Q Tile_X0Y9_FrameData[25] VGND VPWR Tile_X0Y9_FrameStrobe[1] latch
X_1690_ _1690_/Q Tile_X0Y3_FrameData[15] VGND VPWR Tile_X0Y9_FrameStrobe[0] latch
XFILLER_679_224 VPWR VGND sg13cmos5l_decap_4
XFILLER_384_35 VPWR VGND sg13cmos5l_decap_8
XFILLER_167_70 VPWR VGND sg13cmos5l_decap_8
XFILLER_289_208 VPWR VGND sg13cmos5l_decap_8
X_0641_ _0641_/Q Tile_X0Y8_FrameData[30] VGND VPWR Tile_X0Y9_FrameStrobe[7] latch
X_0572_ _0572_/Q Tile_X0Y8_FrameData[3] VGND VPWR Tile_X0Y9_FrameStrobe[4] latch
X_3360_ Tile_X0Y2_FrameData_O[31] Tile_X0Y2_FrameData[31] VPWR VGND sg13cmos5l_buf_1
XFILLER_534_49 VPWR VGND sg13cmos5l_decap_8
XANTENNA__0050__Y AXI_M_SOC_AWLOCK VPWR VGND sg13cmos5l_antennanp
X_2311_ _2311_/Q Tile_X0Y5_FrameData[30] VGND VPWR Tile_X0Y9_FrameStrobe[4] latch
XFILLER_681_77 VPWR VGND sg13cmos5l_decap_8
XFILLER_253_28 VPWR VGND sg13cmos5l_decap_8
XFILLER_501_161 VPWR VGND sg13cmos5l_decap_8
X_3291_ Tile_X0Y0_E6BEG[11] _3847_/X VPWR VGND sg13cmos5l_buf_1
XFILLER_647_154 VPWR VGND sg13cmos5l_decap_8
XFILLER_446_205 VPWR VGND sg13cmos5l_fill_1
XANTENNA__3642__X AXI_M_SOC_AWADDR3 VPWR VGND sg13cmos5l_antennanp
XFILLER_446_227 VPWR VGND sg13cmos5l_fill_2
X_2242_ _2242_/Q Tile_X0Y5_FrameData[3] VGND VPWR Tile_X0Y9_FrameStrobe[1] latch
X_2173_ _2173_/Q Tile_X0Y4_FrameData[8] VGND VPWR Tile_X0Y9_FrameStrobe[7] latch
XFILLER_461_208 VPWR VGND sg13cmos5l_decap_4
XFILLER_65_221 VPWR VGND sg13cmos5l_fill_1
XFILLER_265_171 VPWR VGND sg13cmos5l_fill_1
X_1124_ _1124_/Q Tile_X0Y0_FrameData[7] VGND VPWR Tile_X0Y9_FrameStrobe[5] latch
XFILLER_700_18 VPWR VGND sg13cmos5l_fill_1
XFILLER_630_70 VPWR VGND sg13cmos5l_decap_8
XFILLER_414_135 VPWR VGND sg13cmos5l_decap_8
XFILLER_202_21 VPWR VGND sg13cmos5l_decap_8
XFILLER_414_157 VPWR VGND sg13cmos5l_decap_4
X_1055_ _1055_/Q Tile_X0Y0_FrameData[12] VGND VPWR Tile_X0Y9_FrameStrobe[3] latch
XFILLER_213_208 VPWR VGND sg13cmos5l_decap_8
XFILLER_18_170 VPWR VGND sg13cmos5l_decap_4
XFILLER_559_35 VPWR VGND sg13cmos5l_decap_8
XFILLER_280_196 VPWR VGND sg13cmos5l_fill_2
XFILLER_33_140 VPWR VGND sg13cmos5l_fill_2
XFILLER_568_161 VPWR VGND sg13cmos5l_decap_8
XFILLER_278_14 VPWR VGND sg13cmos5l_decap_8
XFILLER_202_98 VPWR VGND sg13cmos5l_decap_8
XANTENNA__3089__X Tile_X0Y7_E2BEG[3] VPWR VGND sg13cmos5l_antennanp
XFILLER_178_134 VPWR VGND sg13cmos5l_decap_8
X_4814_ _4814_/X _4781_/X Tile_X0Y9_N4END[6] _4780_/X _0075_/X _0443_/Q _0442_/Q VPWR
+ VGND sg13cmos5l_mux4_1
XFILLER_568_194 VPWR VGND sg13cmos5l_decap_4
XFILLER_709_49 VPWR VGND sg13cmos5l_decap_8
XFILLER_327_109 VPWR VGND sg13cmos5l_decap_8
XFILLER_178_189 VPWR VGND sg13cmos5l_decap_8
X_4745_ _4745_/X Tile_X0Y8_WW4END[14] AXI_M_SOC_RDATA9 _4814_/X _4786_/X _0557_/Q
+ _0556_/Q VPWR VGND sg13cmos5l_mux4_1
XFILLER_428_28 VPWR VGND sg13cmos5l_decap_8
X_1957_ _1957_/Q Tile_X0Y4_FrameData[0] VGND VPWR Tile_X0Y9_FrameStrobe[0] latch
XFILLER_382_226 VPWR VGND sg13cmos5l_fill_2
XFILLER_575_56 VPWR VGND sg13cmos5l_decap_8
XFILLER_358_91 VPWR VGND sg13cmos5l_decap_8
XFILLER_335_120 VPWR VGND sg13cmos5l_decap_4
X_0908_ _0908_/Q Tile_X0Y9_FrameData[19] VGND VPWR Tile_X0Y9_FrameStrobe[7] latch
X_4676_ _4676_/X Tile_X0Y3_W1END[0] Tile_X0Y3_WW4END[12] Tile_X0Y3_W6END[4] _4222_/X
+ _1865_/Q _1864_/Q VPWR VGND sg13cmos5l_mux4_1
XFILLER_294_35 VPWR VGND sg13cmos5l_decap_8
X_1888_ _1888_/Q Tile_X0Y3_FrameData[9] VGND VPWR Tile_X0Y9_FrameStrobe[6] latch
X_3627_ Tile_X0Y9_S4BEG[5] _3627_/A VPWR VGND sg13cmos5l_buf_1
X_0839_ _0839_/Q Tile_X0Y9_FrameData[24] VGND VPWR Tile_X0Y9_FrameStrobe[5] latch
XFILLER_350_112 VPWR VGND sg13cmos5l_decap_8
XFILLER_496_105 VPWR VGND sg13cmos5l_decap_8
X_3558_ Tile_X0Y9_EE4BEG[4] _4868_/X VPWR VGND sg13cmos5l_buf_1
XFILLER_444_49 VPWR VGND sg13cmos5l_decap_8
XFILLER_227_84 VPWR VGND sg13cmos5l_decap_8
XFILLER_591_77 VPWR VGND sg13cmos5l_decap_8
X_2509_ _2509_/Q Tile_X0Y6_FrameData[26] VGND VPWR Tile_X0Y9_FrameStrobe[2] latch
XFILLER_163_28 VPWR VGND sg13cmos5l_decap_8
XFILLER_0_228 VPWR VGND sg13cmos5l_fill_1
XFILLER_638_154 VPWR VGND sg13cmos5l_decap_8
XFILLER_102_112 VPWR VGND sg13cmos5l_decap_8
X_3489_ Tile_X0Y1_EE4BEG[15] _3963_/X VPWR VGND sg13cmos5l_buf_1
XANTENNA__3552__X Tile_X0Y9_E6BEG[10] VPWR VGND sg13cmos5l_antennanp
XFILLER_437_216 VPWR VGND sg13cmos5l_fill_1
XFILLER_102_167 VPWR VGND sg13cmos5l_decap_4
XFILLER_653_168 VPWR VGND sg13cmos5l_decap_8
XFILLER_243_94 VPWR VGND sg13cmos5l_fill_1
XFILLER_186_7 VPWR VGND sg13cmos5l_decap_8
XFILLER_256_171 VPWR VGND sg13cmos5l_fill_1
XFILLER_56_59 VPWR VGND sg13cmos5l_decap_8
XFILLER_256_193 VPWR VGND sg13cmos5l_fill_1
XFILLER_540_70 VPWR VGND sg13cmos5l_decap_8
XFILLER_112_21 VPWR VGND sg13cmos5l_decap_8
XFILLER_353_7 VPWR VGND sg13cmos5l_decap_8
XFILLER_420_105 VPWR VGND sg13cmos5l_decap_8
XFILLER_72_14 VPWR VGND sg13cmos5l_decap_8
XFILLER_469_35 VPWR VGND sg13cmos5l_decap_8
XFILLER_271_196 VPWR VGND sg13cmos5l_decap_8
XFILLER_188_14 VPWR VGND sg13cmos5l_decap_8
XFILLER_520_7 VPWR VGND sg13cmos5l_decap_8
XFILLER_618_7 VPWR VGND sg13cmos5l_decap_8
XFILLER_24_195 VPWR VGND sg13cmos5l_decap_4
XFILLER_708_147 VPWR VGND sg13cmos5l_decap_8
XFILLER_619_49 VPWR VGND sg13cmos5l_decap_8
XFILLER_507_209 VPWR VGND sg13cmos5l_decap_8
XANTENNA__0135__Y AXI_M_SOC_AWLEN5 VPWR VGND sg13cmos5l_antennanp
XFILLER_574_175 VPWR VGND sg13cmos5l_decap_8
XFILLER_338_28 VPWR VGND sg13cmos5l_decap_8
XFILLER_485_56 VPWR VGND sg13cmos5l_decap_8
XANTENNA__3727__X AXI_M_SOC_BREADY VPWR VGND sg13cmos5l_antennanp
XFILLER_326_153 VPWR VGND sg13cmos5l_decap_8
XFILLER_326_186 VPWR VGND sg13cmos5l_decap_8
XFILLER_487_105 VPWR VGND sg13cmos5l_decap_8
XFILLER_21_84 VPWR VGND sg13cmos5l_decap_4
XFILLER_108_0 VPWR VGND sg13cmos5l_decap_8
XFILLER_354_49 VPWR VGND sg13cmos5l_decap_8
XFILLER_137_84 VPWR VGND sg13cmos5l_decap_8
XFILLER_651_14 VPWR VGND sg13cmos5l_decap_8
XFILLER_97_77 VPWR VGND sg13cmos5l_decap_8
XFILLER_294_200 VPWR VGND sg13cmos5l_fill_1
XANTENNA__3462__X Tile_X0Y1_FrameData_O[20] VPWR VGND sg13cmos5l_antennanp
XFILLER_97_88 VPWR VGND sg13cmos5l_fill_2
XFILLER_428_216 VPWR VGND sg13cmos5l_fill_2
XFILLER_495_182 VPWR VGND sg13cmos5l_decap_8
XFILLER_477_0 VPWR VGND sg13cmos5l_decap_8
XFILLER_644_168 VPWR VGND sg13cmos5l_decap_8
XFILLER_303_42 VPWR VGND sg13cmos5l_decap_8
XFILLER_262_130 VPWR VGND sg13cmos5l_decap_8
XFILLER_644_0 VPWR VGND sg13cmos5l_decap_8
XFILLER_450_92 VPWR VGND sg13cmos5l_decap_8
XANTENNA__2806__X Tile_X0Y3_E2BEGb[4] VPWR VGND sg13cmos5l_antennanp
XFILLER_379_35 VPWR VGND sg13cmos5l_decap_8
XFILLER_600_84 VPWR VGND sg13cmos5l_decap_4
X_2860_ Tile_X0Y6_E6BEG[9] _4537_/X VPWR VGND sg13cmos5l_buf_1
XFILLER_529_49 VPWR VGND sg13cmos5l_decap_8
XFILLER_565_164 VPWR VGND sg13cmos5l_fill_1
X_1811_ _1811_/Q Tile_X0Y3_FrameData[22] VGND VPWR Tile_X0Y9_FrameStrobe[4] latch
XFILLER_676_77 VPWR VGND sg13cmos5l_decap_8
XFILLER_62_91 VPWR VGND sg13cmos5l_decap_4
XFILLER_714_106 VPWR VGND sg13cmos5l_decap_8
XFILLER_248_28 VPWR VGND sg13cmos5l_decap_8
X_2791_ Tile_X0Y3_E6BEG[1] _4181_/X VPWR VGND sg13cmos5l_buf_1
XFILLER_580_112 VPWR VGND sg13cmos5l_decap_8
XANTENNA__3637__X Tile_X0Y9_S4BEG[15] VPWR VGND sg13cmos5l_antennanp
XFILLER_395_56 VPWR VGND sg13cmos5l_decap_8
XFILLER_178_91 VPWR VGND sg13cmos5l_decap_8
X_4530_ _4530_/X Tile_X0Y9_N4END[14] _0155_/X _4577_/X _4581_/X _2547_/Q _2546_/Q
+ VPWR VGND sg13cmos5l_mux4_1
XFILLER_30_198 VPWR VGND sg13cmos5l_fill_2
XFILLER_7_42 VPWR VGND sg13cmos5l_decap_8
X_1742_ _1742_/Q Tile_X0Y3_FrameData[27] VGND VPWR Tile_X0Y9_FrameStrobe[2] latch
XFILLER_692_21 VPWR VGND sg13cmos5l_decap_8
X_4461_ _4461_/X _4424_/X _0100_/X _4423_/X _0140_/X _2217_/Q _2216_/Q VPWR VGND sg13cmos5l_mux4_1
XFILLER_580_189 VPWR VGND sg13cmos5l_decap_8
X_1673_ _1673_/Q Tile_X0Y2_FrameData[8] VGND VPWR Tile_X0Y9_FrameStrobe[7] latch
X_3412_ Tile_X0Y4_FrameData_O[3] Tile_X0Y4_FrameData[3] VPWR VGND sg13cmos5l_buf_1
X_0624_ _0624_/Q Tile_X0Y8_FrameData[15] VGND VPWR Tile_X0Y9_FrameStrobe[6] latch
XFILLER_692_98 VPWR VGND sg13cmos5l_decap_8
X_4392_ _4392_/X Tile_X0Y5_WW4END[11] AXI_M_SOC_RVALID _4462_/X _4434_/X _2319_/Q
+ _2318_/Q VPWR VGND sg13cmos5l_mux4_1
XFILLER_264_49 VPWR VGND sg13cmos5l_decap_8
XFILLER_625_70 VPWR VGND sg13cmos5l_decap_8
XFILLER_332_178 VPWR VGND sg13cmos5l_fill_1
X_3343_ Tile_X0Y2_FrameData_O[14] Tile_X0Y2_FrameData[14] VPWR VGND sg13cmos5l_buf_1
XFILLER_561_14 VPWR VGND sg13cmos5l_decap_8
X_0555_ _0555_/Q Tile_X0Y8_FrameData[20] VGND VPWR Tile_X0Y9_FrameStrobe[4] latch
XFILLER_493_119 VPWR VGND sg13cmos5l_decap_8
XANTENNA__3372__X Tile_X0Y2_EE4BEG[11] VPWR VGND sg13cmos5l_antennanp
XFILLER_97_154 VPWR VGND sg13cmos5l_decap_8
X_3274_ Tile_X0Y0_EE4BEG[10] _3830_/X VPWR VGND sg13cmos5l_buf_1
X_0486_ _0486_/Q Tile_X0Y8_FrameData[25] VGND VPWR Tile_X0Y9_FrameStrobe[2] latch
XFILLER_23_0 VPWR VGND sg13cmos5l_decap_8
XFILLER_97_198 VPWR VGND sg13cmos5l_decap_8
XFILLER_711_28 VPWR VGND sg13cmos5l_decap_8
X_2225_ _2225_/Q Tile_X0Y5_FrameData[20] VGND VPWR Tile_X0Y9_FrameStrobe[1] latch
XFILLER_434_208 VPWR VGND sg13cmos5l_decap_8
XFILLER_245_119 VPWR VGND sg13cmos5l_decap_8
XFILLER_650_105 VPWR VGND sg13cmos5l_decap_8
XFILLER_641_91 VPWR VGND sg13cmos5l_decap_8
XFILLER_213_42 VPWR VGND sg13cmos5l_decap_8
X_2156_ _2156_/Q Tile_X0Y4_FrameData[25] VGND VPWR Tile_X0Y9_FrameStrobe[7] latch
XFILLER_588_212 VPWR VGND sg13cmos5l_decap_4
XFILLER_360_70 VPWR VGND sg13cmos5l_decap_8
XFILLER_399_123 VPWR VGND sg13cmos5l_decap_8
XFILLER_399_134 VPWR VGND sg13cmos5l_fill_2
X_1107_ _1107_/Q Tile_X0Y0_FrameData[24] VGND VPWR Tile_X0Y9_FrameStrobe[5] latch
X_2087_ _2087_/Q Tile_X0Y4_FrameData[30] VGND VPWR Tile_X0Y9_FrameStrobe[5] latch
XFILLER_253_174 VPWR VGND sg13cmos5l_fill_1
XFILLER_402_116 VPWR VGND sg13cmos5l_decap_8
XFILLER_289_35 VPWR VGND sg13cmos5l_decap_8
XFILLER_253_196 VPWR VGND sg13cmos5l_decap_8
X_1038_ _1038_/Q Tile_X0Y0_FrameData[29] VGND VPWR Tile_X0Y9_FrameStrobe[3] latch
XFILLER_510_84 VPWR VGND sg13cmos5l_decap_8
XFILLER_439_49 VPWR VGND sg13cmos5l_decap_8
XFILLER_42_28 VPWR VGND sg13cmos5l_decap_8
XFILLER_355_204 VPWR VGND sg13cmos5l_decap_8
XFILLER_586_77 VPWR VGND sg13cmos5l_decap_8
XFILLER_158_28 VPWR VGND sg13cmos5l_decap_8
XFILLER_571_112 VPWR VGND sg13cmos5l_decap_8
X_2989_ Tile_X0Y8_FrameData_O[29] Tile_X0Y8_FrameData[29] VPWR VGND sg13cmos5l_buf_1
XFILLER_166_148 VPWR VGND sg13cmos5l_fill_2
XANTENNA__3547__X Tile_X0Y9_E6BEG[5] VPWR VGND sg13cmos5l_antennanp
X_4728_ _4728_/X Tile_X0Y8_W2MID[7] AXI_M_SOC_RDATA8 _4785_/X _4784_/X _0591_/Q _0590_/Q
+ VPWR VGND sg13cmos5l_mux4_1
XFILLER_370_207 VPWR VGND sg13cmos5l_decap_8
XFILLER_571_189 VPWR VGND sg13cmos5l_decap_8
XFILLER_713_161 VPWR VGND sg13cmos5l_decap_8
X_4659_ _4659_/X _4667_/X Tile_X0Y7_W6END[3] _4666_/X _4659_/A3 _0161_/Q _0416_/Q
+ VPWR VGND sg13cmos5l_mux4_1
XFILLER_512_212 VPWR VGND sg13cmos5l_fill_2
XFILLER_101_7 VPWR VGND sg13cmos5l_decap_8
XFILLER_174_49 VPWR VGND sg13cmos5l_decap_8
XFILLER_535_70 VPWR VGND sg13cmos5l_decap_8
XFILLER_107_21 VPWR VGND sg13cmos5l_decap_8
XFILLER_471_14 VPWR VGND sg13cmos5l_decap_8
XANTENNA__3282__X Tile_X0Y0_E6BEG[2] VPWR VGND sg13cmos5l_antennanp
XFILLER_88_132 VPWR VGND sg13cmos5l_decap_8
XFILLER_67_14 VPWR VGND sg13cmos5l_decap_8
XFILLER_107_98 VPWR VGND sg13cmos5l_decap_8
XFILLER_621_28 VPWR VGND sg13cmos5l_decap_8
XFILLER_470_7 VPWR VGND sg13cmos5l_decap_8
XFILLER_29_210 VPWR VGND sg13cmos5l_fill_2
XFILLER_425_208 VPWR VGND sg13cmos5l_fill_2
XFILLER_404_63 VPWR VGND sg13cmos5l_decap_8
XFILLER_568_7 VPWR VGND sg13cmos5l_decap_8
XFILLER_641_105 VPWR VGND sg13cmos5l_decap_8
XFILLER_229_171 VPWR VGND sg13cmos5l_decap_4
XFILLER_551_91 VPWR VGND sg13cmos5l_decap_8
XFILLER_123_42 VPWR VGND sg13cmos5l_decap_8
XFILLER_270_70 VPWR VGND sg13cmos5l_decap_8
XFILLER_83_35 VPWR VGND sg13cmos5l_decap_8
XFILLER_44_213 VPWR VGND sg13cmos5l_decap_8
XFILLER_44_224 VPWR VGND sg13cmos5l_decap_4
XFILLER_199_35 VPWR VGND sg13cmos5l_decap_8
XFILLER_189_218 VPWR VGND sg13cmos5l_decap_8
XFILLER_420_84 VPWR VGND sg13cmos5l_decap_8
XFILLER_349_49 VPWR VGND sg13cmos5l_decap_8
XFILLER_547_153 VPWR VGND sg13cmos5l_decap_4
XFILLER_547_164 VPWR VGND sg13cmos5l_fill_2
XFILLER_496_77 VPWR VGND sg13cmos5l_decap_8
XFILLER_646_14 VPWR VGND sg13cmos5l_decap_8
XFILLER_157_137 VPWR VGND sg13cmos5l_decap_8
XFILLER_562_112 VPWR VGND sg13cmos5l_decap_8
XFILLER_225_0 VPWR VGND sg13cmos5l_decap_8
XANTENNA__3457__X Tile_X0Y1_FrameData_O[15] VPWR VGND sg13cmos5l_antennanp
XFILLER_504_2 VPWR VGND sg13cmos5l_fill_1
XFILLER_172_107 VPWR VGND sg13cmos5l_fill_2
XFILLER_562_167 VPWR VGND sg13cmos5l_decap_8
XFILLER_165_181 VPWR VGND sg13cmos5l_fill_1
XFILLER_649_216 VPWR VGND sg13cmos5l_decap_8
XFILLER_649_227 VPWR VGND sg13cmos5l_fill_2
XFILLER_662_35 VPWR VGND sg13cmos5l_decap_8
XFILLER_445_70 VPWR VGND sg13cmos5l_decap_4
XFILLER_594_0 VPWR VGND sg13cmos5l_decap_8
XFILLER_381_14 VPWR VGND sg13cmos5l_decap_8
XFILLER_180_195 VPWR VGND sg13cmos5l_decap_8
XANTENNA__3192__X Tile_X0Y0_N2BEGb[0] VPWR VGND sg13cmos5l_antennanp
X_0340_ _0340_/Q Tile_X0Y7_FrameData[11] VGND VPWR Tile_X0Y9_FrameStrobe[5] latch
XFILLER_468_193 VPWR VGND sg13cmos5l_decap_8
XFILLER_79_176 VPWR VGND sg13cmos5l_decap_4
XFILLER_94_135 VPWR VGND sg13cmos5l_fill_1
X_0271_ _0271_/Q Tile_X0Y7_FrameData[16] VGND VPWR Tile_X0Y9_FrameStrobe[3] latch
XFILLER_531_28 VPWR VGND sg13cmos5l_decap_8
XFILLER_314_63 VPWR VGND sg13cmos5l_decap_8
XFILLER_632_105 VPWR VGND sg13cmos5l_decap_8
X_2010_ _2010_/Q Tile_X0Y4_FrameData[11] VGND VPWR Tile_X0Y9_FrameStrobe[2] latch
XFILLER_57_91 VPWR VGND sg13cmos5l_fill_2
XFILLER_180_70 VPWR VGND sg13cmos5l_decap_8
XFILLER_35_213 VPWR VGND sg13cmos5l_fill_1
XFILLER_250_100 VPWR VGND sg13cmos5l_decap_4
XFILLER_687_21 VPWR VGND sg13cmos5l_decap_8
XFILLER_640_182 VPWR VGND sg13cmos5l_decap_8
X_3961_ _3961_/X Tile_X0Y1_WW4END[2] AXI_M_SOC_ARREADY _4010_/X _3993_/X _1287_/Q
+ _1286_/Q VPWR VGND sg13cmos5l_mux4_1
X_2912_ Tile_X0Y8_E1BEG[0] _4724_/X VPWR VGND sg13cmos5l_buf_1
X_3892_ _3892_/X Tile_X0Y2_W2MID[5] Tile_X0Y2_W2END[5] Tile_X0Y2_W6END[5] _4101_/X
+ _1661_/Q _1660_/Q VPWR VGND sg13cmos5l_mux4_1
XFILLER_687_98 VPWR VGND sg13cmos5l_decap_4
XFILLER_259_49 VPWR VGND sg13cmos5l_decap_8
XFILLER_250_199 VPWR VGND sg13cmos5l_decap_8
X_2843_ Tile_X0Y6_E2BEGb[0] _4504_/X VPWR VGND sg13cmos5l_buf_1
XFILLER_556_14 VPWR VGND sg13cmos5l_decap_8
XFILLER_553_112 VPWR VGND sg13cmos5l_decap_8
XANTENNA__3367__X Tile_X0Y2_EE4BEG[6] VPWR VGND sg13cmos5l_antennanp
XFILLER_553_134 VPWR VGND sg13cmos5l_fill_1
X_2774_ Tile_X0Y3_EE4BEG[0] _4164_/X VPWR VGND sg13cmos5l_buf_1
XFILLER_553_156 VPWR VGND sg13cmos5l_decap_8
X_4513_ _4513_/X Tile_X0Y6_WW4END[14] AXI_M_SOC_RDATA25 _4582_/X _4554_/X _2581_/Q
+ _2580_/Q VPWR VGND sg13cmos5l_mux4_1
XFILLER_706_28 VPWR VGND sg13cmos5l_decap_8
X_1725_ _1725_/Q Tile_X0Y3_FrameData[12] VGND VPWR Tile_X0Y9_FrameStrobe[1] latch
XFILLER_305_134 VPWR VGND sg13cmos5l_decap_8
XFILLER_636_91 VPWR VGND sg13cmos5l_decap_8
XFILLER_305_145 VPWR VGND sg13cmos5l_fill_1
XFILLER_208_42 VPWR VGND sg13cmos5l_decap_8
XFILLER_171_140 VPWR VGND sg13cmos5l_decap_8
X_4444_ _4444_/X _4014_/X _4018_/X _3999_/X _3990_/X _1359_/Q _1358_/Q VPWR VGND sg13cmos5l_mux4_1
X_1656_ _1656_/Q Tile_X0Y2_FrameData[25] VGND VPWR Tile_X0Y9_FrameStrobe[7] latch
XFILLER_572_35 VPWR VGND sg13cmos5l_decap_8
XFILLER_355_70 VPWR VGND sg13cmos5l_decap_8
XFILLER_710_175 VPWR VGND sg13cmos5l_decap_8
X_0607_ _0607_/Q Tile_X0Y8_FrameData[0] VGND VPWR Tile_X0Y9_FrameStrobe[5] latch
XFILLER_291_14 VPWR VGND sg13cmos5l_decap_8
X_4375_ _4375_/X Tile_X0Y5_W2MID[4] AXI_M_SOC_RRESP1 _4434_/X _4433_/X _2353_/Q _2352_/Q
+ VPWR VGND sg13cmos5l_mux4_1
XFILLER_258_200 VPWR VGND sg13cmos5l_decap_8
X_1587_ _1587_/Q Tile_X0Y2_FrameData[30] VGND VPWR Tile_X0Y9_FrameStrobe[5] latch
X_3326_ Tile_X0Y4_EE4BEG[14] _4286_/X VPWR VGND sg13cmos5l_buf_1
XFILLER_608_113 VPWR VGND sg13cmos5l_fill_2
X_0538_ _0538_/Q Tile_X0Y8_FrameData[5] VGND VPWR Tile_X0Y9_FrameStrobe[3] latch
XFILLER_505_84 VPWR VGND sg13cmos5l_decap_8
XFILLER_474_141 VPWR VGND sg13cmos5l_fill_2
XFILLER_441_28 VPWR VGND sg13cmos5l_decap_8
XFILLER_407_208 VPWR VGND sg13cmos5l_decap_8
XFILLER_224_63 VPWR VGND sg13cmos5l_decap_8
X_3257_ Tile_X0Y0_FrameData_O[25] Tile_X0Y0_FrameData[25] VPWR VGND sg13cmos5l_buf_1
XFILLER_37_17 VPWR VGND sg13cmos5l_decap_8
XFILLER_85_146 VPWR VGND sg13cmos5l_decap_8
X_0469_ _0469_/Q Tile_X0Y8_FrameData[10] VGND VPWR Tile_X0Y9_FrameStrobe[1] latch
XFILLER_623_105 VPWR VGND sg13cmos5l_decap_8
XFILLER_371_91 VPWR VGND sg13cmos5l_decap_8
X_2208_ _2208_/Q Tile_X0Y5_FrameData[5] VGND VPWR Tile_X0Y9_FrameStrobe[0] latch
X_3188_ Tile_X0Y0_N4BEG[12] _3188_/A VPWR VGND sg13cmos5l_buf_1
XFILLER_26_202 VPWR VGND sg13cmos5l_decap_8
XFILLER_616_190 VPWR VGND sg13cmos5l_decap_4
XFILLER_226_141 VPWR VGND sg13cmos5l_decap_4
X_2139_ _2139_/Q Tile_X0Y4_FrameData[10] VGND VPWR Tile_X0Y9_FrameStrobe[6] latch
XFILLER_597_21 VPWR VGND sg13cmos5l_decap_8
XFILLER_241_155 VPWR VGND sg13cmos5l_fill_1
XFILLER_53_49 VPWR VGND sg13cmos5l_decap_8
XFILLER_387_148 VPWR VGND sg13cmos5l_decap_8
XFILLER_387_159 VPWR VGND sg13cmos5l_fill_2
XFILLER_169_49 VPWR VGND sg13cmos5l_decap_8
XFILLER_149_7 VPWR VGND sg13cmos5l_decap_8
XFILLER_139_126 VPWR VGND sg13cmos5l_decap_8
XFILLER_466_14 VPWR VGND sg13cmos5l_decap_8
XANTENNA__3277__X Tile_X0Y0_EE4BEG[13] VPWR VGND sg13cmos5l_antennanp
XFILLER_395_192 VPWR VGND sg13cmos5l_fill_2
XFILLER_544_156 VPWR VGND sg13cmos5l_decap_8
XFILLER_316_7 VPWR VGND sg13cmos5l_decap_8
XFILLER_154_107 VPWR VGND sg13cmos5l_fill_2
XFILLER_616_28 VPWR VGND sg13cmos5l_decap_8
XFILLER_147_181 VPWR VGND sg13cmos5l_decap_4
XFILLER_147_192 VPWR VGND sg13cmos5l_decap_8
XFILLER_546_91 VPWR VGND sg13cmos5l_fill_2
XFILLER_118_42 VPWR VGND sg13cmos5l_decap_8
XFILLER_482_35 VPWR VGND sg13cmos5l_decap_8
XFILLER_265_70 VPWR VGND sg13cmos5l_decap_8
XFILLER_162_162 VPWR VGND sg13cmos5l_fill_1
XFILLER_78_35 VPWR VGND sg13cmos5l_decap_8
XFILLER_311_115 VPWR VGND sg13cmos5l_decap_8
XFILLER_118_97 VPWR VGND sg13cmos5l_decap_8
XFILLER_685_7 VPWR VGND sg13cmos5l_decap_8
XFILLER_311_126 VPWR VGND sg13cmos5l_fill_2
XFILLER_632_49 VPWR VGND sg13cmos5l_decap_8
XFILLER_415_84 VPWR VGND sg13cmos5l_decap_8
XFILLER_351_28 VPWR VGND sg13cmos5l_decap_8
XFILLER_209_119 VPWR VGND sg13cmos5l_decap_8
XFILLER_134_63 VPWR VGND sg13cmos5l_decap_8
XFILLER_264_214 VPWR VGND sg13cmos5l_decap_8
XFILLER_614_105 VPWR VGND sg13cmos5l_decap_8
XANTENNA__3740__X AXI_M_SOC_ARADDR12 VPWR VGND sg13cmos5l_antennanp
XFILLER_281_91 VPWR VGND sg13cmos5l_decap_8
XFILLER_94_56 VPWR VGND sg13cmos5l_decap_8
XFILLER_175_0 VPWR VGND sg13cmos5l_decap_8
XFILLER_150_84 VPWR VGND sg13cmos5l_decap_8
XFILLER_300_21 VPWR VGND sg13cmos5l_decap_8
XFILLER_342_0 VPWR VGND sg13cmos5l_decap_8
XFILLER_657_35 VPWR VGND sg13cmos5l_decap_8
XFILLER_376_14 VPWR VGND sg13cmos5l_decap_8
XFILLER_43_93 VPWR VGND sg13cmos5l_fill_1
XANTENNA__3187__X Tile_X0Y0_N4BEG[11] VPWR VGND sg13cmos5l_antennanp
XFILLER_535_123 VPWR VGND sg13cmos5l_decap_8
XFILLER_607_0 VPWR VGND sg13cmos5l_decap_8
XFILLER_334_218 VPWR VGND sg13cmos5l_decap_8
XFILLER_64_7 VPWR VGND sg13cmos5l_decap_8
XFILLER_526_28 VPWR VGND sg13cmos5l_decap_8
XFILLER_309_63 VPWR VGND sg13cmos5l_decap_8
XFILLER_696_119 VPWR VGND sg13cmos5l_decap_8
XFILLER_673_56 VPWR VGND sg13cmos5l_decap_8
XFILLER_309_85 VPWR VGND sg13cmos5l_fill_1
X_1510_ _1510_/Q Tile_X0Y2_FrameData[11] VGND VPWR Tile_X0Y9_FrameStrobe[2] latch
XFILLER_299_133 VPWR VGND sg13cmos5l_fill_1
X_2490_ _2490_/Q Tile_X0Y6_FrameData[13] VGND VPWR Tile_X0Y9_FrameStrobe[1] latch
XFILLER_392_35 VPWR VGND sg13cmos5l_decap_8
XFILLER_99_227 VPWR VGND sg13cmos5l_fill_2
XFILLER_175_70 VPWR VGND sg13cmos5l_decap_8
XFILLER_4_21 VPWR VGND sg13cmos5l_decap_8
XFILLER_299_177 VPWR VGND sg13cmos5l_fill_1
XFILLER_175_92 VPWR VGND sg13cmos5l_decap_8
X_1441_ _1441_/Q Tile_X0Y2_FrameData[16] VGND VPWR Tile_X0Y9_FrameStrobe[0] latch
X_4160_ _4160_/X Tile_X0Y3_W2END[3] AXI_M_SOC_BVALID _4211_/X _4210_/X _1821_/Q _1820_/Q
+ VPWR VGND sg13cmos5l_mux4_1
X_1372_ _1372_/Q Tile_X0Y1_FrameData[29] VGND VPWR Tile_X0Y9_FrameStrobe[6] latch
XFILLER_542_49 VPWR VGND sg13cmos5l_decap_8
XFILLER_4_98 VPWR VGND sg13cmos5l_decap_8
X_3111_ Tile_X0Y7_E6BEG[9] _4653_/X VPWR VGND sg13cmos5l_buf_1
X_0323_ _0323_/Q Tile_X0Y7_FrameData[28] VGND VPWR Tile_X0Y9_FrameStrobe[5] latch
XFILLER_67_135 VPWR VGND sg13cmos5l_decap_8
XFILLER_456_163 VPWR VGND sg13cmos5l_decap_4
XFILLER_261_28 VPWR VGND sg13cmos5l_decap_8
X_4091_ _4091_/X Tile_X0Y3_W1END[1] Tile_X0Y3_W6END[5] _4235_/X _4201_/X _1923_/Q
+ _1922_/Q VPWR VGND sg13cmos5l_mux4_1
XFILLER_456_174 VPWR VGND sg13cmos5l_fill_2
XANTENNA__3650__X AXI_M_SOC_AWADDR11 VPWR VGND sg13cmos5l_antennanp
XFILLER_191_91 VPWR VGND sg13cmos5l_decap_8
X_3042_ Tile_X0Y5_FrameData_O[1] Tile_X0Y5_FrameData[1] VPWR VGND sg13cmos5l_buf_1
X_0254_ _0254_/Q Tile_X0Y7_FrameData[1] VGND VPWR Tile_X0Y9_FrameStrobe[2] latch
XFILLER_82_116 VPWR VGND sg13cmos5l_fill_1
XFILLER_82_149 VPWR VGND sg13cmos5l_decap_4
XFILLER_698_42 VPWR VGND sg13cmos5l_decap_8
X_0185_ _0185_/Q Tile_X0Y7_FrameData[6] VGND VPWR Tile_X0Y9_FrameStrobe[0] latch
XFILLER_208_196 VPWR VGND sg13cmos5l_decap_8
XFILLER_613_182 VPWR VGND sg13cmos5l_decap_8
XFILLER_613_193 VPWR VGND sg13cmos5l_fill_2
XFILLER_558_226 VPWR VGND sg13cmos5l_fill_2
XFILLER_369_126 VPWR VGND sg13cmos5l_decap_8
XFILLER_23_216 VPWR VGND sg13cmos5l_fill_2
XFILLER_210_21 VPWR VGND sg13cmos5l_decap_8
X_3944_ _3944_/X Tile_X0Y1_W2END[3] AXI_M_SOC_ARREADY _3995_/X _3994_/X _1321_/Q _1320_/Q
+ VPWR VGND sg13cmos5l_mux4_1
XFILLER_90_0 VPWR VGND sg13cmos5l_decap_8
XFILLER_567_35 VPWR VGND sg13cmos5l_decap_8
XFILLER_286_14 VPWR VGND sg13cmos5l_decap_8
XFILLER_210_98 VPWR VGND sg13cmos5l_decap_8
X_3875_ _3875_/X _3848_/X _0067_/X Tile_X0Y0_S1END[0] Tile_X0Y0_S4END[0] _0971_/Q
+ _0970_/Q VPWR VGND sg13cmos5l_mux4_1
XANTENNA__3097__X Tile_X0Y7_E2BEGb[3] VPWR VGND sg13cmos5l_antennanp
X_2826_ Tile_X0Y4_E2BEG[4] _4260_/X VPWR VGND sg13cmos5l_buf_1
XFILLER_436_28 VPWR VGND sg13cmos5l_decap_8
XFILLER_129_181 VPWR VGND sg13cmos5l_decap_4
X_2757_ Tile_X0Y3_FrameData_O[15] Tile_X0Y3_FrameData[15] VPWR VGND sg13cmos5l_buf_1
XFILLER_219_63 VPWR VGND sg13cmos5l_decap_8
XFILLER_583_56 VPWR VGND sg13cmos5l_decap_8
XFILLER_366_91 VPWR VGND sg13cmos5l_decap_8
XFILLER_144_140 VPWR VGND sg13cmos5l_decap_8
X_1708_ _1708_/Q Tile_X0Y3_FrameData[29] VGND VPWR Tile_X0Y9_FrameStrobe[1] latch
X_2688_ _2688_/Q Tile_X0Y6_FrameData[7] VGND VPWR Tile_X0Y9_FrameStrobe[7] latch
X_4427_ _4427_/X Tile_X0Y6_W1END[3] Tile_X0Y6_W6END[7] _4583_/X _4543_/X _2689_/Q
+ _2688_/Q VPWR VGND sg13cmos5l_mux4_1
XFILLER_494_203 VPWR VGND sg13cmos5l_decap_8
X_1639_ _1639_/Q Tile_X0Y2_FrameData[10] VGND VPWR Tile_X0Y9_FrameStrobe[6] latch
X_4358_ _4358_/X Tile_X0Y3_W2MID[4] Tile_X0Y3_W2END[4] Tile_X0Y3_W6END[11] _4211_/X
+ _1875_/Q _1874_/Q VPWR VGND sg13cmos5l_mux4_1
XFILLER_452_49 VPWR VGND sg13cmos5l_decap_8
XFILLER_48_38 VPWR VGND sg13cmos5l_decap_8
XFILLER_58_124 VPWR VGND sg13cmos5l_decap_8
XFILLER_100_210 VPWR VGND sg13cmos5l_fill_2
X_3309_ Tile_X0Y0_E1BEG[1] _3801_/X VPWR VGND sg13cmos5l_buf_1
XFILLER_171_28 VPWR VGND sg13cmos5l_decap_8
X_4289_ _4289_/X _0158_/X _0111_/X _4346_/X _4350_/X _2035_/Q _2034_/Q VPWR VGND sg13cmos5l_mux4_1
XFILLER_301_192 VPWR VGND sg13cmos5l_decap_8
XANTENNA__3560__X Tile_X0Y9_EE4BEG[6] VPWR VGND sg13cmos5l_antennanp
XFILLER_73_105 VPWR VGND sg13cmos5l_decap_8
XFILLER_73_127 VPWR VGND sg13cmos5l_decap_8
XFILLER_261_228 VPWR VGND sg13cmos5l_fill_1
XFILLER_266_7 VPWR VGND sg13cmos5l_decap_8
XFILLER_401_42 VPWR VGND sg13cmos5l_decap_8
XFILLER_214_133 VPWR VGND sg13cmos5l_decap_8
XFILLER_120_21 VPWR VGND sg13cmos5l_decap_8
XFILLER_81_193 VPWR VGND sg13cmos5l_fill_1
XANTENNA__2904__X Tile_X0Y6_FrameData_O[25] VPWR VGND sg13cmos5l_antennanp
XFILLER_433_7 VPWR VGND sg13cmos5l_decap_8
XFILLER_375_107 VPWR VGND sg13cmos5l_decap_8
XFILLER_80_14 VPWR VGND sg13cmos5l_decap_8
XFILLER_477_35 VPWR VGND sg13cmos5l_decap_8
XFILLER_80_58 VPWR VGND sg13cmos5l_fill_1
XFILLER_600_7 VPWR VGND sg13cmos5l_decap_8
XFILLER_196_47 VPWR VGND sg13cmos5l_decap_8
XFILLER_627_49 VPWR VGND sg13cmos5l_decap_8
XFILLER_13_63 VPWR VGND sg13cmos5l_decap_8
XFILLER_517_178 VPWR VGND sg13cmos5l_fill_2
XFILLER_532_126 VPWR VGND sg13cmos5l_decap_8
XFILLER_346_28 VPWR VGND sg13cmos5l_decap_8
XFILLER_129_63 VPWR VGND sg13cmos5l_decap_8
XFILLER_678_119 VPWR VGND sg13cmos5l_decap_8
XFILLER_493_56 VPWR VGND sg13cmos5l_decap_8
XANTENNA__3735__X AXI_M_SOC_ARADDR7 VPWR VGND sg13cmos5l_antennanp
XFILLER_276_91 VPWR VGND sg13cmos5l_decap_8
XFILLER_135_140 VPWR VGND sg13cmos5l_decap_8
XFILLER_89_56 VPWR VGND sg13cmos5l_decap_8
XFILLER_135_195 VPWR VGND sg13cmos5l_decap_8
XFILLER_619_208 VPWR VGND sg13cmos5l_decap_8
XFILLER_296_114 VPWR VGND sg13cmos5l_decap_8
XFILLER_362_49 VPWR VGND sg13cmos5l_decap_8
XFILLER_145_84 VPWR VGND sg13cmos5l_decap_8
XFILLER_49_113 VPWR VGND sg13cmos5l_decap_8
XFILLER_292_0 VPWR VGND sg13cmos5l_decap_8
XFILLER_438_174 VPWR VGND sg13cmos5l_fill_1
XFILLER_237_225 VPWR VGND sg13cmos5l_decap_4
XANTENNA__3470__X Tile_X0Y1_FrameData_O[28] VPWR VGND sg13cmos5l_antennanp
XFILLER_599_115 VPWR VGND sg13cmos5l_decap_4
XFILLER_64_127 VPWR VGND sg13cmos5l_decap_4
XFILLER_453_155 VPWR VGND sg13cmos5l_fill_2
XFILLER_38_93 VPWR VGND sg13cmos5l_decap_8
XFILLER_252_206 VPWR VGND sg13cmos5l_decap_8
XFILLER_557_0 VPWR VGND sg13cmos5l_decap_8
XFILLER_311_42 VPWR VGND sg13cmos5l_decap_8
XFILLER_205_133 VPWR VGND sg13cmos5l_decap_8
XFILLER_668_56 VPWR VGND sg13cmos5l_decap_8
XANTENNA__2814__X Tile_X0Y3_E2BEG[4] VPWR VGND sg13cmos5l_antennanp
X_1990_ _1990_/Q Tile_X0Y4_FrameData[31] VGND VPWR Tile_X0Y9_FrameStrobe[2] latch
XFILLER_387_35 VPWR VGND sg13cmos5l_decap_8
X_0941_ _0941_/Q Tile_X0Y0_FrameData[30] VGND VPWR Tile_X0Y9_FrameStrobe[0] latch
XFILLER_508_112 VPWR VGND sg13cmos5l_decap_8
XFILLER_220_169 VPWR VGND sg13cmos5l_fill_2
X_3660_ AXI_M_SOC_AWADDR21 Tile_X0Y4_WW4END[5] Tile_X0Y4_WW4END[13] Tile_X0Y4_W6END[5]
+ _4341_/X _2003_/Q _2002_/Q VPWR VGND sg13cmos5l_mux4_1
X_0872_ _0872_/Q Tile_X0Y9_FrameData[23] VGND VPWR Tile_X0Y9_FrameStrobe[6] latch
XFILLER_537_49 VPWR VGND sg13cmos5l_decap_8
XFILLER_508_167 VPWR VGND sg13cmos5l_fill_1
XFILLER_70_91 VPWR VGND sg13cmos5l_decap_8
X_2611_ _2611_/Q Tile_X0Y6_FrameData[20] VGND VPWR Tile_X0Y9_FrameStrobe[5] latch
XFILLER_684_77 VPWR VGND sg13cmos5l_decap_8
XFILLER_508_189 VPWR VGND sg13cmos5l_decap_8
XFILLER_256_28 VPWR VGND sg13cmos5l_decap_8
X_3591_ Tile_X0Y9_FrameData_O[21] Tile_X0Y9_FrameData[21] VPWR VGND sg13cmos5l_buf_1
XFILLER_669_119 VPWR VGND sg13cmos5l_decap_4
XANTENNA__3645__X AXI_M_SOC_AWADDR6 VPWR VGND sg13cmos5l_antennanp
XFILLER_126_140 VPWR VGND sg13cmos5l_decap_8
X_2542_ _2542_/Q Tile_X0Y6_FrameData[25] VGND VPWR Tile_X0Y9_FrameStrobe[3] latch
XFILLER_677_130 VPWR VGND sg13cmos5l_decap_8
XFILLER_677_152 VPWR VGND sg13cmos5l_decap_8
X_2473_ _2473_/Q Tile_X0Y6_FrameData[30] VGND VPWR Tile_X0Y9_FrameStrobe[1] latch
XFILLER_677_174 VPWR VGND sg13cmos5l_decap_4
XFILLER_531_192 VPWR VGND sg13cmos5l_decap_4
X_4212_ _4212_/X _4203_/X _0046_/X _4202_/X Tile_X0Y0_S4END[15] _1699_/Q _1698_/Q
+ VPWR VGND sg13cmos5l_mux4_1
XFILLER_141_154 VPWR VGND sg13cmos5l_decap_8
X_1424_ _1424_/Q Tile_X0Y1_FrameData[9] VGND VPWR Tile_X0Y9_FrameStrobe[7] latch
XFILLER_272_49 VPWR VGND sg13cmos5l_decap_8
XFILLER_633_70 VPWR VGND sg13cmos5l_decap_8
XFILLER_287_169 VPWR VGND sg13cmos5l_decap_8
XFILLER_205_21 VPWR VGND sg13cmos5l_decap_8
X_4143_ _4143_/X Tile_X0Y4_W2MID[0] Tile_X0Y4_W2END[0] Tile_X0Y4_W6END[0] _4312_/X
+ _2159_/Q _2158_/Q VPWR VGND sg13cmos5l_mux4_1
X_1355_ _1355_/Q Tile_X0Y1_FrameData[14] VGND VPWR Tile_X0Y9_FrameStrobe[5] latch
XFILLER_228_214 VPWR VGND sg13cmos5l_fill_2
XANTENNA__3380__X Tile_X0Y2_E6BEG[3] VPWR VGND sg13cmos5l_antennanp
XFILLER_429_196 VPWR VGND sg13cmos5l_decap_8
X_0306_ _0306_/Q Tile_X0Y7_FrameData[13] VGND VPWR Tile_X0Y9_FrameStrobe[4] latch
X_4074_ _4074_/X _0057_/X Tile_X0Y0_S4END[10] _4125_/X _4110_/X _1525_/Q _1524_/Q
+ VPWR VGND sg13cmos5l_mux4_1
XFILLER_205_98 VPWR VGND sg13cmos5l_decap_8
X_1286_ _1286_/Q Tile_X0Y1_FrameData[19] VGND VPWR Tile_X0Y9_FrameStrobe[3] latch
XFILLER_444_155 VPWR VGND sg13cmos5l_decap_4
X_3025_ Tile_X0Y5_EE4BEG[0] _4388_/X VPWR VGND sg13cmos5l_buf_1
X_0237_ _0237_/Q Tile_X0Y7_FrameData[18] VGND VPWR Tile_X0Y9_FrameStrobe[2] latch
XFILLER_502_63 VPWR VGND sg13cmos5l_decap_8
XFILLER_243_228 VPWR VGND sg13cmos5l_fill_1
XFILLER_221_42 VPWR VGND sg13cmos5l_decap_8
XFILLER_70_119 VPWR VGND sg13cmos5l_decap_8
XFILLER_63_160 VPWR VGND sg13cmos5l_decap_8
X_0168_ _0168_/Q Tile_X0Y7_FrameData[23] VGND VPWR Tile_X0Y9_FrameStrobe[0] latch
XFILLER_598_181 VPWR VGND sg13cmos5l_fill_2
XFILLER_601_130 VPWR VGND sg13cmos5l_fill_1
XFILLER_578_56 VPWR VGND sg13cmos5l_decap_8
X_0099_ _0099_/X _4322_/X _4323_/X _0645_/Q VPWR VGND sg13cmos5l_mux2_1
XFILLER_297_35 VPWR VGND sg13cmos5l_decap_8
X_3927_ _3927_/X _4226_/X _4230_/X _4234_/X _4205_/X _1901_/Q _1900_/Q VPWR VGND sg13cmos5l_mux4_1
XFILLER_50_17 VPWR VGND sg13cmos5l_fill_2
X_3858_ _3858_/X _3897_/X _3896_/X Tile_X0Y0_S2MID[4] Tile_X0Y0_S2END[4] _0955_/Q
+ _0954_/Q VPWR VGND sg13cmos5l_mux4_1
XFILLER_109_107 VPWR VGND sg13cmos5l_fill_1
XFILLER_447_49 VPWR VGND sg13cmos5l_decap_8
X_2809_ Tile_X0Y3_E2BEGb[7] _4163_/X VPWR VGND sg13cmos5l_buf_1
XFILLER_594_77 VPWR VGND sg13cmos5l_decap_8
XFILLER_166_28 VPWR VGND sg13cmos5l_decap_8
X_3789_ _3789_/X Tile_X0Y0_W2MID[2] Tile_X0Y0_W2END[2] Tile_X0Y0_W6END[2] _3856_/X
+ _1159_/Q _1158_/Q VPWR VGND sg13cmos5l_mux4_1
XANTENNA__3555__X Tile_X0Y9_EE4BEG[1] VPWR VGND sg13cmos5l_antennanp
XFILLER_59_48 VPWR VGND sg13cmos5l_decap_8
XFILLER_522_192 VPWR VGND sg13cmos5l_decap_8
XFILLER_467_225 VPWR VGND sg13cmos5l_decap_4
XFILLER_132_154 VPWR VGND sg13cmos5l_decap_8
XFILLER_278_147 VPWR VGND sg13cmos5l_decap_8
XFILLER_132_165 VPWR VGND sg13cmos5l_fill_1
XFILLER_182_49 VPWR VGND sg13cmos5l_decap_8
XFILLER_132_176 VPWR VGND sg13cmos5l_fill_2
XFILLER_543_70 VPWR VGND sg13cmos5l_decap_8
XFILLER_115_21 VPWR VGND sg13cmos5l_decap_8
XFILLER_482_228 VPWR VGND sg13cmos5l_fill_1
XFILLER_383_7 VPWR VGND sg13cmos5l_decap_8
XANTENNA__3290__X Tile_X0Y0_E6BEG[10] VPWR VGND sg13cmos5l_antennanp
XFILLER_75_14 VPWR VGND sg13cmos5l_decap_8
XFILLER_262_82 VPWR VGND sg13cmos5l_decap_8
XFILLER_435_133 VPWR VGND sg13cmos5l_decap_8
XFILLER_262_93 VPWR VGND sg13cmos5l_fill_2
XFILLER_550_7 VPWR VGND sg13cmos5l_decap_8
XFILLER_435_177 VPWR VGND sg13cmos5l_fill_1
XFILLER_648_7 VPWR VGND sg13cmos5l_decap_8
XFILLER_435_199 VPWR VGND sg13cmos5l_decap_8
XFILLER_131_42 VPWR VGND sg13cmos5l_decap_8
XFILLER_412_96 VPWR VGND sg13cmos5l_fill_2
XANTENNA__0138__Y AXI_M_SOC_AWLEN0 VPWR VGND sg13cmos5l_antennanp
XFILLER_91_35 VPWR VGND sg13cmos5l_decap_8
XFILLER_488_56 VPWR VGND sg13cmos5l_decap_8
XFILLER_537_207 VPWR VGND sg13cmos5l_decap_8
XFILLER_24_84 VPWR VGND sg13cmos5l_fill_2
XFILLER_138_0 VPWR VGND sg13cmos5l_decap_8
XFILLER_356_140 VPWR VGND sg13cmos5l_decap_8
XFILLER_357_49 VPWR VGND sg13cmos5l_decap_8
XFILLER_560_210 VPWR VGND sg13cmos5l_decap_4
XFILLER_654_14 VPWR VGND sg13cmos5l_decap_8
XFILLER_505_126 VPWR VGND sg13cmos5l_decap_8
XFILLER_305_0 VPWR VGND sg13cmos5l_decap_8
XANTENNA__3465__X Tile_X0Y1_FrameData_O[23] VPWR VGND sg13cmos5l_antennanp
XFILLER_40_72 VPWR VGND sg13cmos5l_fill_1
XFILLER_108_173 VPWR VGND sg13cmos5l_decap_8
XFILLER_520_118 VPWR VGND sg13cmos5l_decap_8
XFILLER_123_110 VPWR VGND sg13cmos5l_decap_4
XFILLER_269_114 VPWR VGND sg13cmos5l_fill_1
XFILLER_674_100 VPWR VGND sg13cmos5l_fill_1
XFILLER_458_225 VPWR VGND sg13cmos5l_decap_4
XFILLER_123_143 VPWR VGND sg13cmos5l_fill_2
XFILLER_306_42 VPWR VGND sg13cmos5l_decap_8
XFILLER_670_35 VPWR VGND sg13cmos5l_decap_8
XFILLER_453_70 VPWR VGND sg13cmos5l_decap_4
XFILLER_674_0 VPWR VGND sg13cmos5l_decap_8
XFILLER_27_7 VPWR VGND sg13cmos5l_decap_8
XANTENNA__2809__X Tile_X0Y3_E2BEGb[7] VPWR VGND sg13cmos5l_antennanp
XFILLER_473_228 VPWR VGND sg13cmos5l_fill_1
XFILLER_277_191 VPWR VGND sg13cmos5l_fill_2
X_1140_ _1140_/Q Tile_X0Y0_FrameData[23] VGND VPWR Tile_X0Y9_FrameStrobe[6] latch
XFILLER_426_133 VPWR VGND sg13cmos5l_decap_8
XFILLER_603_84 VPWR VGND sg13cmos5l_decap_8
XFILLER_603_95 VPWR VGND sg13cmos5l_fill_1
XFILLER_322_63 VPWR VGND sg13cmos5l_decap_4
XFILLER_225_228 VPWR VGND sg13cmos5l_fill_1
X_1071_ _1071_/Q Tile_X0Y0_FrameData[28] VGND VPWR Tile_X0Y9_FrameStrobe[4] latch
XFILLER_1_77 VPWR VGND sg13cmos5l_decap_8
XFILLER_1_88 VPWR VGND sg13cmos5l_fill_2
XFILLER_630_225 VPWR VGND sg13cmos5l_decap_4
XFILLER_322_96 VPWR VGND sg13cmos5l_decap_8
XFILLER_679_77 VPWR VGND sg13cmos5l_decap_8
XFILLER_240_209 VPWR VGND sg13cmos5l_decap_8
XFILLER_45_193 VPWR VGND sg13cmos5l_decap_4
XFILLER_398_56 VPWR VGND sg13cmos5l_decap_8
X_4830_ _4830_/X Tile_X0Y9_W2MID[5] Tile_X0Y9_W2END[5] Tile_X0Y9_W6END[10] _4905_/X
+ _0879_/Q _0878_/Q VPWR VGND sg13cmos5l_mux4_1
XFILLER_60_141 VPWR VGND sg13cmos5l_decap_8
XFILLER_695_21 VPWR VGND sg13cmos5l_decap_8
XFILLER_528_218 VPWR VGND sg13cmos5l_fill_1
XFILLER_60_174 VPWR VGND sg13cmos5l_decap_8
X_4761_ _4761_/X Tile_X0Y9_N4END[5] _0076_/X _4810_/X _4814_/X _0525_/Q _0524_/Q VPWR
+ VGND sg13cmos5l_mux4_1
X_1973_ _1973_/Q Tile_X0Y4_FrameData[16] VGND VPWR Tile_X0Y9_FrameStrobe[1] latch
XFILLER_60_185 VPWR VGND sg13cmos5l_fill_2
X_3712_ AXI_M_SOC_WDATA22 Tile_X0Y6_WW4END[6] Tile_X0Y6_WW4END[14] Tile_X0Y6_W6END[6]
+ _4574_/X _2515_/Q _2514_/Q VPWR VGND sg13cmos5l_mux4_1
X_0924_ _0924_/Q Tile_X0Y9_FrameData[3] VGND VPWR Tile_X0Y9_FrameStrobe[7] latch
X_4692_ _4692_/X _4661_/X Tile_X0Y9_N4END[8] _4660_/X _0056_/X _0199_/Q _0198_/Q VPWR
+ VGND sg13cmos5l_mux4_1
XFILLER_695_98 VPWR VGND sg13cmos5l_decap_8
XFILLER_267_49 VPWR VGND sg13cmos5l_decap_8
XFILLER_347_173 VPWR VGND sg13cmos5l_decap_8
X_3643_ AXI_M_SOC_AWADDR4 Tile_X0Y5_WW4END[4] Tile_X0Y5_WW4END[12] Tile_X0Y5_W6END[4]
+ _4455_/X _2263_/Q _2262_/Q VPWR VGND sg13cmos5l_mux4_1
X_0855_ _0855_/Q Tile_X0Y9_FrameData[8] VGND VPWR Tile_X0Y9_FrameStrobe[5] latch
XFILLER_564_14 VPWR VGND sg13cmos5l_decap_8
XANTENNA__3375__X Tile_X0Y2_EE4BEG[14] VPWR VGND sg13cmos5l_antennanp
X_3574_ Tile_X0Y9_FrameData_O[4] Tile_X0Y9_FrameData[4] VPWR VGND sg13cmos5l_buf_1
XFILLER_161_216 VPWR VGND sg13cmos5l_fill_1
X_0786_ _0786_/Q Tile_X0Y9_FrameData[13] VGND VPWR Tile_X0Y9_FrameStrobe[3] latch
XFILLER_53_0 VPWR VGND sg13cmos5l_fill_1
X_2525_ _2525_/Q Tile_X0Y6_FrameData[10] VGND VPWR Tile_X0Y9_FrameStrobe[2] latch
XFILLER_114_154 VPWR VGND sg13cmos5l_decap_8
XFILLER_644_91 VPWR VGND sg13cmos5l_decap_8
XFILLER_216_42 VPWR VGND sg13cmos5l_decap_8
X_2456_ _2456_/Q Tile_X0Y6_FrameData[15] VGND VPWR Tile_X0Y9_FrameStrobe[0] latch
XFILLER_580_35 VPWR VGND sg13cmos5l_decap_8
XFILLER_363_70 VPWR VGND sg13cmos5l_decap_8
X_1407_ _1407_/Q Tile_X0Y1_FrameData[26] VGND VPWR Tile_X0Y9_FrameStrobe[7] latch
X_2387_ _2387_/Q Tile_X0Y5_FrameData[18] VGND VPWR Tile_X0Y9_FrameStrobe[6] latch
X_4126_ _4126_/X _4093_/X _0057_/X _4092_/X Tile_X0Y0_S4END[10] _1461_/Q _1460_/Q
+ VPWR VGND sg13cmos5l_mux4_1
X_1338_ _1338_/Q Tile_X0Y1_FrameData[31] VGND VPWR Tile_X0Y9_FrameStrobe[5] latch
XFILLER_83_211 VPWR VGND sg13cmos5l_fill_2
XFILLER_513_84 VPWR VGND sg13cmos5l_decap_8
XFILLER_283_161 VPWR VGND sg13cmos5l_decap_8
X_4057_ _4057_/X Tile_X0Y2_WW4END[14] AXI_M_SOC_AWREADY _4107_/X _4098_/X _1559_/Q
+ _1558_/Q VPWR VGND sg13cmos5l_mux4_1
XFILLER_45_17 VPWR VGND sg13cmos5l_decap_8
XFILLER_232_63 VPWR VGND sg13cmos5l_decap_8
X_1269_ _1269_/Q Tile_X0Y1_FrameData[4] VGND VPWR Tile_X0Y9_FrameStrobe[2] latch
X_3008_ Tile_X0Y5_E2BEGb[3] _4383_/X VPWR VGND sg13cmos5l_buf_1
XFILLER_43_119 VPWR VGND sg13cmos5l_decap_8
XFILLER_432_147 VPWR VGND sg13cmos5l_decap_8
XFILLER_589_77 VPWR VGND sg13cmos5l_decap_8
XFILLER_196_124 VPWR VGND sg13cmos5l_decap_4
XFILLER_101_56 VPWR VGND sg13cmos5l_decap_8
XFILLER_101_67 VPWR VGND sg13cmos5l_fill_2
XFILLER_61_27 VPWR VGND sg13cmos5l_decap_8
XFILLER_196_135 VPWR VGND sg13cmos5l_decap_8
XFILLER_196_157 VPWR VGND sg13cmos5l_decap_8
XFILLER_131_7 VPWR VGND sg13cmos5l_decap_8
XFILLER_229_7 VPWR VGND sg13cmos5l_decap_8
XFILLER_177_49 VPWR VGND sg13cmos5l_decap_8
XFILLER_538_70 VPWR VGND sg13cmos5l_decap_8
XFILLER_474_14 VPWR VGND sg13cmos5l_decap_8
XFILLER_688_214 VPWR VGND sg13cmos5l_decap_4
XANTENNA__3285__X Tile_X0Y0_E6BEG[5] VPWR VGND sg13cmos5l_antennanp
XFILLER_353_154 VPWR VGND sg13cmos5l_decap_8
XFILLER_499_147 VPWR VGND sg13cmos5l_decap_8
XFILLER_624_28 VPWR VGND sg13cmos5l_decap_8
XFILLER_407_63 VPWR VGND sg13cmos5l_decap_8
XFILLER_10_42 VPWR VGND sg13cmos5l_decap_8
XFILLER_598_7 VPWR VGND sg13cmos5l_decap_8
XFILLER_554_91 VPWR VGND sg13cmos5l_decap_8
XFILLER_126_42 VPWR VGND sg13cmos5l_decap_8
XFILLER_656_133 VPWR VGND sg13cmos5l_decap_8
XFILLER_490_35 VPWR VGND sg13cmos5l_decap_8
XFILLER_273_70 VPWR VGND sg13cmos5l_decap_8
XFILLER_86_35 VPWR VGND sg13cmos5l_decap_8
XFILLER_455_217 VPWR VGND sg13cmos5l_decap_4
XFILLER_120_135 VPWR VGND sg13cmos5l_decap_8
XFILLER_671_125 VPWR VGND sg13cmos5l_fill_1
XFILLER_640_49 VPWR VGND sg13cmos5l_decap_8
XFILLER_423_84 VPWR VGND sg13cmos5l_decap_8
XFILLER_19_127 VPWR VGND sg13cmos5l_fill_1
XFILLER_408_166 VPWR VGND sg13cmos5l_decap_4
XFILLER_19_84 VPWR VGND sg13cmos5l_fill_1
XFILLER_19_149 VPWR VGND sg13cmos5l_decap_8
XFILLER_207_228 VPWR VGND sg13cmos5l_fill_1
XFILLER_142_63 VPWR VGND sg13cmos5l_decap_8
XFILLER_408_199 VPWR VGND sg13cmos5l_decap_8
XFILLER_499_77 VPWR VGND sg13cmos5l_decap_8
XFILLER_423_147 VPWR VGND sg13cmos5l_decap_8
XFILLER_649_14 VPWR VGND sg13cmos5l_decap_8
XFILLER_255_0 VPWR VGND sg13cmos5l_decap_8
XFILLER_577_140 VPWR VGND sg13cmos5l_decap_8
XFILLER_577_195 VPWR VGND sg13cmos5l_decap_8
XFILLER_422_0 VPWR VGND sg13cmos5l_decap_8
XFILLER_665_35 VPWR VGND sg13cmos5l_decap_8
XFILLER_448_70 VPWR VGND sg13cmos5l_decap_4
XFILLER_384_14 VPWR VGND sg13cmos5l_decap_8
XANTENNA__3195__X Tile_X0Y0_N2BEGb[3] VPWR VGND sg13cmos5l_antennanp
X_0640_ _0640_/Q Tile_X0Y8_FrameData[31] VGND VPWR Tile_X0Y9_FrameStrobe[7] latch
XFILLER_534_28 VPWR VGND sg13cmos5l_decap_8
X_0571_ _0571_/Q Tile_X0Y8_FrameData[4] VGND VPWR Tile_X0Y9_FrameStrobe[4] latch
XFILLER_297_220 VPWR VGND sg13cmos5l_fill_1
XFILLER_681_56 VPWR VGND sg13cmos5l_decap_8
X_2310_ _2310_/Q Tile_X0Y5_FrameData[31] VGND VPWR Tile_X0Y9_FrameStrobe[4] latch
XFILLER_647_133 VPWR VGND sg13cmos5l_decap_8
XFILLER_501_140 VPWR VGND sg13cmos5l_decap_8
X_3290_ Tile_X0Y0_E6BEG[10] _3846_/X VPWR VGND sg13cmos5l_buf_1
XFILLER_183_70 VPWR VGND sg13cmos5l_decap_8
XFILLER_446_217 VPWR VGND sg13cmos5l_decap_4
XFILLER_111_135 VPWR VGND sg13cmos5l_fill_2
X_2241_ _2241_/Q Tile_X0Y5_FrameData[4] VGND VPWR Tile_X0Y9_FrameStrobe[1] latch
X_2172_ _2172_/Q Tile_X0Y4_FrameData[9] VGND VPWR Tile_X0Y9_FrameStrobe[7] latch
XFILLER_65_211 VPWR VGND sg13cmos5l_decap_4
XFILLER_550_49 VPWR VGND sg13cmos5l_decap_8
X_1123_ _1123_/Q Tile_X0Y0_FrameData[8] VGND VPWR Tile_X0Y9_FrameStrobe[5] latch
X_1054_ _1054_/Q Tile_X0Y0_FrameData[13] VGND VPWR Tile_X0Y9_FrameStrobe[3] latch
XFILLER_559_14 VPWR VGND sg13cmos5l_decap_8
XFILLER_280_175 VPWR VGND sg13cmos5l_decap_8
XFILLER_568_140 VPWR VGND sg13cmos5l_decap_8
XFILLER_202_77 VPWR VGND sg13cmos5l_decap_8
XFILLER_33_163 VPWR VGND sg13cmos5l_fill_2
X_4813_ _4813_/X _4779_/X Tile_X0Y9_N4END[5] _4778_/X _0076_/X _0445_/Q _0444_/Q VPWR
+ VGND sg13cmos5l_mux4_1
XFILLER_709_28 VPWR VGND sg13cmos5l_decap_8
XFILLER_639_91 VPWR VGND sg13cmos5l_decap_8
XFILLER_193_105 VPWR VGND sg13cmos5l_decap_4
X_1956_ _1956_/Q Tile_X0Y4_FrameData[1] VGND VPWR Tile_X0Y9_FrameStrobe[0] latch
X_4744_ _4744_/X Tile_X0Y8_WW4END[15] AXI_M_SOC_RDATA8 _4815_/X _4784_/X _0559_/Q
+ _0558_/Q VPWR VGND sg13cmos5l_mux4_1
XFILLER_119_202 VPWR VGND sg13cmos5l_decap_8
XFILLER_575_35 VPWR VGND sg13cmos5l_decap_8
XFILLER_358_70 VPWR VGND sg13cmos5l_decap_8
XFILLER_119_213 VPWR VGND sg13cmos5l_fill_1
XFILLER_524_210 VPWR VGND sg13cmos5l_decap_8
X_0907_ _0907_/Q Tile_X0Y9_FrameData[20] VGND VPWR Tile_X0Y9_FrameStrobe[7] latch
X_4675_ _4675_/X _4591_/X _4707_/X _4706_/X _4590_/X _0177_/Q _0176_/Q VPWR VGND sg13cmos5l_mux4_1
XFILLER_294_14 VPWR VGND sg13cmos5l_decap_8
X_1887_ _1887_/Q Tile_X0Y3_FrameData[10] VGND VPWR Tile_X0Y9_FrameStrobe[6] latch
X_3626_ Tile_X0Y9_S4BEG[4] _3626_/A VPWR VGND sg13cmos5l_buf_1
X_0838_ _0838_/Q Tile_X0Y9_FrameData[25] VGND VPWR Tile_X0Y9_FrameStrobe[5] latch
XFILLER_508_84 VPWR VGND sg13cmos5l_decap_8
XFILLER_444_28 VPWR VGND sg13cmos5l_decap_8
X_3557_ Tile_X0Y9_EE4BEG[3] _4867_/X VPWR VGND sg13cmos5l_buf_1
XFILLER_685_228 VPWR VGND sg13cmos5l_fill_1
XFILLER_227_63 VPWR VGND sg13cmos5l_decap_8
X_0769_ _0769_/Q Tile_X0Y9_FrameData[30] VGND VPWR Tile_X0Y9_FrameStrobe[3] latch
XFILLER_591_56 VPWR VGND sg13cmos5l_decap_8
X_2508_ _2508_/Q Tile_X0Y6_FrameData[27] VGND VPWR Tile_X0Y9_FrameStrobe[2] latch
XFILLER_350_179 VPWR VGND sg13cmos5l_decap_8
XFILLER_638_133 VPWR VGND sg13cmos5l_decap_8
X_3488_ Tile_X0Y1_EE4BEG[14] _3962_/X VPWR VGND sg13cmos5l_buf_1
X_2439_ _2439_/Q Tile_X0Y5_FrameData[30] VGND VPWR Tile_X0Y9_FrameStrobe[8] latch
XFILLER_102_146 VPWR VGND sg13cmos5l_decap_8
XFILLER_638_199 VPWR VGND sg13cmos5l_decap_4
XFILLER_653_147 VPWR VGND sg13cmos5l_decap_8
XFILLER_56_211 VPWR VGND sg13cmos5l_decap_4
XFILLER_460_49 VPWR VGND sg13cmos5l_decap_8
XFILLER_243_84 VPWR VGND sg13cmos5l_fill_2
XFILLER_56_38 VPWR VGND sg13cmos5l_decap_8
XFILLER_256_150 VPWR VGND sg13cmos5l_decap_8
X_4109_ _4109_/X _4573_/X _4577_/X _4581_/X _4555_/X _2668_/Q _2667_/Q VPWR VGND sg13cmos5l_mux4_1
XFILLER_110_190 VPWR VGND sg13cmos5l_fill_1
XFILLER_460_220 VPWR VGND sg13cmos5l_fill_2
XFILLER_179_7 VPWR VGND sg13cmos5l_decap_8
XFILLER_271_153 VPWR VGND sg13cmos5l_fill_1
XFILLER_71_225 VPWR VGND sg13cmos5l_decap_4
XFILLER_469_14 VPWR VGND sg13cmos5l_decap_8
XFILLER_204_209 VPWR VGND sg13cmos5l_decap_8
XFILLER_271_175 VPWR VGND sg13cmos5l_decap_8
XFILLER_112_77 VPWR VGND sg13cmos5l_decap_8
XFILLER_559_151 VPWR VGND sg13cmos5l_fill_1
XFILLER_346_7 VPWR VGND sg13cmos5l_decap_8
XFILLER_708_126 VPWR VGND sg13cmos5l_decap_8
XFILLER_619_28 VPWR VGND sg13cmos5l_decap_8
XANTENNA__2912__X Tile_X0Y8_E1BEG[0] VPWR VGND sg13cmos5l_antennanp
XFILLER_574_154 VPWR VGND sg13cmos5l_decap_8
XFILLER_513_7 VPWR VGND sg13cmos5l_decap_8
XFILLER_485_35 VPWR VGND sg13cmos5l_decap_8
XFILLER_326_132 VPWR VGND sg13cmos5l_decap_8
XFILLER_635_49 VPWR VGND sg13cmos5l_decap_8
XFILLER_21_63 VPWR VGND sg13cmos5l_decap_8
XFILLER_418_84 VPWR VGND sg13cmos5l_decap_8
XANTENNA__0151__Y AXI_M_SOC_AWLEN2 VPWR VGND sg13cmos5l_antennanp
XFILLER_354_28 VPWR VGND sg13cmos5l_decap_8
XFILLER_137_63 VPWR VGND sg13cmos5l_decap_8
XFILLER_676_228 VPWR VGND sg13cmos5l_fill_1
XFILLER_140_208 VPWR VGND sg13cmos5l_decap_8
XANTENNA__3743__X AXI_M_SOC_ARADDR15 VPWR VGND sg13cmos5l_antennanp
XFILLER_284_91 VPWR VGND sg13cmos5l_decap_8
XFILLER_629_122 VPWR VGND sg13cmos5l_decap_8
XFILLER_97_56 VPWR VGND sg13cmos5l_decap_8
XFILLER_495_161 VPWR VGND sg13cmos5l_decap_8
XFILLER_629_199 VPWR VGND sg13cmos5l_decap_8
XFILLER_644_147 VPWR VGND sg13cmos5l_decap_8
XFILLER_370_49 VPWR VGND sg13cmos5l_decap_8
XFILLER_153_84 VPWR VGND sg13cmos5l_fill_1
XFILLER_247_150 VPWR VGND sg13cmos5l_decap_8
XFILLER_372_0 VPWR VGND sg13cmos5l_decap_8
XFILLER_303_21 VPWR VGND sg13cmos5l_decap_8
XFILLER_597_213 VPWR VGND sg13cmos5l_fill_2
XFILLER_62_214 VPWR VGND sg13cmos5l_decap_4
XFILLER_379_14 VPWR VGND sg13cmos5l_decap_8
XFILLER_637_0 VPWR VGND sg13cmos5l_decap_8
XFILLER_262_186 VPWR VGND sg13cmos5l_decap_8
XFILLER_600_63 VPWR VGND sg13cmos5l_decap_8
XFILLER_600_228 VPWR VGND sg13cmos5l_fill_1
XFILLER_94_7 VPWR VGND sg13cmos5l_decap_8
XFILLER_529_28 VPWR VGND sg13cmos5l_decap_8
XFILLER_676_56 VPWR VGND sg13cmos5l_decap_8
X_1810_ _1810_/Q Tile_X0Y3_FrameData[23] VGND VPWR Tile_X0Y9_FrameStrobe[4] latch
XANTENNA__2822__X Tile_X0Y4_E2BEG[0] VPWR VGND sg13cmos5l_antennanp
XFILLER_175_116 VPWR VGND sg13cmos5l_decap_8
X_2790_ Tile_X0Y3_E6BEG[0] _4180_/X VPWR VGND sg13cmos5l_buf_1
XFILLER_395_35 VPWR VGND sg13cmos5l_decap_8
XFILLER_7_21 VPWR VGND sg13cmos5l_decap_8
X_1741_ _1741_/Q Tile_X0Y3_FrameData[28] VGND VPWR Tile_X0Y9_FrameStrobe[2] latch
XFILLER_580_168 VPWR VGND sg13cmos5l_decap_8
X_4460_ _4460_/X _4421_/X _0159_/X _4420_/X _0145_/X _2219_/Q _2218_/Q VPWR VGND sg13cmos5l_mux4_1
XFILLER_317_165 VPWR VGND sg13cmos5l_fill_1
X_1672_ _1672_/Q Tile_X0Y2_FrameData[9] VGND VPWR Tile_X0Y9_FrameStrobe[7] latch
XFILLER_545_49 VPWR VGND sg13cmos5l_decap_8
XFILLER_7_98 VPWR VGND sg13cmos5l_decap_8
X_3411_ Tile_X0Y4_FrameData_O[2] Tile_X0Y4_FrameData[2] VPWR VGND sg13cmos5l_buf_1
XFILLER_692_77 VPWR VGND sg13cmos5l_decap_8
X_0623_ _0623_/Q Tile_X0Y8_FrameData[16] VGND VPWR Tile_X0Y9_FrameStrobe[6] latch
XFILLER_332_135 VPWR VGND sg13cmos5l_fill_1
XFILLER_264_28 VPWR VGND sg13cmos5l_decap_8
X_4391_ _4391_/X Tile_X0Y5_WW4END[12] AXI_M_SOC_RRESP1 _4463_/X _4433_/X _2321_/Q
+ _2320_/Q VPWR VGND sg13cmos5l_mux4_1
XFILLER_667_228 VPWR VGND sg13cmos5l_fill_1
XANTENNA__3653__X AXI_M_SOC_AWADDR14 VPWR VGND sg13cmos5l_antennanp
X_3342_ Tile_X0Y2_FrameData_O[13] Tile_X0Y2_FrameData[13] VPWR VGND sg13cmos5l_buf_1
X_0554_ _0554_/Q Tile_X0Y8_FrameData[21] VGND VPWR Tile_X0Y9_FrameStrobe[4] latch
X_3273_ Tile_X0Y0_EE4BEG[9] _3829_/X VPWR VGND sg13cmos5l_buf_1
X_0485_ _0485_/Q Tile_X0Y8_FrameData[26] VGND VPWR Tile_X0Y9_FrameStrobe[2] latch
XFILLER_97_177 VPWR VGND sg13cmos5l_decap_8
X_2224_ _2224_/Q Tile_X0Y5_FrameData[21] VGND VPWR Tile_X0Y9_FrameStrobe[1] latch
XFILLER_280_49 VPWR VGND sg13cmos5l_decap_8
XFILLER_641_70 VPWR VGND sg13cmos5l_decap_8
XFILLER_213_21 VPWR VGND sg13cmos5l_decap_8
XFILLER_16_0 VPWR VGND sg13cmos5l_decap_8
X_2155_ _2155_/Q Tile_X0Y4_FrameData[26] VGND VPWR Tile_X0Y9_FrameStrobe[7] latch
XFILLER_399_102 VPWR VGND sg13cmos5l_decap_8
X_1106_ _1106_/Q Tile_X0Y0_FrameData[25] VGND VPWR Tile_X0Y9_FrameStrobe[5] latch
XFILLER_53_225 VPWR VGND sg13cmos5l_decap_4
XFILLER_253_153 VPWR VGND sg13cmos5l_decap_8
X_2086_ _2086_/Q Tile_X0Y4_FrameData[31] VGND VPWR Tile_X0Y9_FrameStrobe[5] latch
XFILLER_289_14 VPWR VGND sg13cmos5l_decap_8
XFILLER_213_98 VPWR VGND sg13cmos5l_decap_8
XFILLER_399_157 VPWR VGND sg13cmos5l_decap_8
X_1037_ _1037_/Q Tile_X0Y0_FrameData[30] VGND VPWR Tile_X0Y9_FrameStrobe[3] latch
XFILLER_510_63 VPWR VGND sg13cmos5l_decap_8
XFILLER_439_28 VPWR VGND sg13cmos5l_decap_8
XFILLER_410_150 VPWR VGND sg13cmos5l_decap_4
XFILLER_586_56 VPWR VGND sg13cmos5l_decap_8
XFILLER_369_91 VPWR VGND sg13cmos5l_decap_8
X_2988_ Tile_X0Y8_FrameData_O[28] Tile_X0Y8_FrameData[28] VPWR VGND sg13cmos5l_buf_1
X_4727_ _4727_/X _4783_/X _4782_/X AXI_M_SOC_RDATA8 AXI_M_SOC_RDATA12 _0593_/Q _0592_/Q
+ VPWR VGND sg13cmos5l_mux4_1
X_1939_ _1939_/Q Tile_X0Y4_FrameData[18] VGND VPWR Tile_X0Y9_FrameStrobe[0] latch
XFILLER_571_168 VPWR VGND sg13cmos5l_decap_8
XFILLER_713_140 VPWR VGND sg13cmos5l_decap_8
X_4658_ _4658_/X _4665_/X Tile_X0Y7_W6END[2] _4664_/X _4658_/A3 _0163_/Q _0162_/Q
+ VPWR VGND sg13cmos5l_mux4_1
XFILLER_455_49 VPWR VGND sg13cmos5l_decap_8
XFILLER_238_84 VPWR VGND sg13cmos5l_fill_1
XFILLER_107_227 VPWR VGND sg13cmos5l_fill_2
XFILLER_174_193 VPWR VGND sg13cmos5l_decap_8
XFILLER_174_28 VPWR VGND sg13cmos5l_decap_8
X_3609_ Tile_X0Y9_S2BEG[3] _4831_/X VPWR VGND sg13cmos5l_buf_1
XFILLER_658_228 VPWR VGND sg13cmos5l_fill_1
X_4589_ _4589_/X Tile_X0Y8_W2MID[5] Tile_X0Y8_W2END[5] Tile_X0Y8_W6END[5] _4789_/X
+ _0659_/Q _0658_/Q VPWR VGND sg13cmos5l_mux4_1
XANTENNA__3563__X Tile_X0Y9_EE4BEG[9] VPWR VGND sg13cmos5l_antennanp
XFILLER_323_168 VPWR VGND sg13cmos5l_fill_2
XFILLER_88_111 VPWR VGND sg13cmos5l_decap_8
XFILLER_296_7 VPWR VGND sg13cmos5l_decap_8
XFILLER_404_42 VPWR VGND sg13cmos5l_decap_8
XFILLER_190_49 VPWR VGND sg13cmos5l_decap_8
XFILLER_551_70 VPWR VGND sg13cmos5l_decap_8
XFILLER_123_21 VPWR VGND sg13cmos5l_decap_8
XFILLER_492_175 VPWR VGND sg13cmos5l_decap_8
XFILLER_404_86 VPWR VGND sg13cmos5l_fill_1
XANTENNA__2907__X Tile_X0Y6_FrameData_O[28] VPWR VGND sg13cmos5l_antennanp
XFILLER_463_7 VPWR VGND sg13cmos5l_decap_8
XFILLER_340_19 VPWR VGND sg13cmos5l_decap_8
XFILLER_83_14 VPWR VGND sg13cmos5l_decap_8
XFILLER_199_14 VPWR VGND sg13cmos5l_decap_8
XFILLER_701_84 VPWR VGND sg13cmos5l_decap_8
XFILLER_630_7 VPWR VGND sg13cmos5l_decap_8
XFILLER_420_63 VPWR VGND sg13cmos5l_decap_8
XFILLER_594_216 VPWR VGND sg13cmos5l_fill_2
XFILLER_16_63 VPWR VGND sg13cmos5l_decap_8
XANTENNA__0146__Y AXI_M_SOC_ARCACHE3 VPWR VGND sg13cmos5l_antennanp
XFILLER_349_28 VPWR VGND sg13cmos5l_decap_8
XFILLER_401_150 VPWR VGND sg13cmos5l_decap_8
XANTENNA__3738__X AXI_M_SOC_ARADDR10 VPWR VGND sg13cmos5l_antennanp
XFILLER_496_56 VPWR VGND sg13cmos5l_decap_8
XFILLER_279_91 VPWR VGND sg13cmos5l_decap_8
XFILLER_200_212 VPWR VGND sg13cmos5l_fill_2
XFILLER_157_105 VPWR VGND sg13cmos5l_decap_8
XFILLER_401_172 VPWR VGND sg13cmos5l_decap_4
XFILLER_346_216 VPWR VGND sg13cmos5l_fill_1
XFILLER_8_126 VPWR VGND sg13cmos5l_fill_1
XFILLER_547_187 VPWR VGND sg13cmos5l_decap_4
XFILLER_8_159 VPWR VGND sg13cmos5l_decap_4
XFILLER_32_73 VPWR VGND sg13cmos5l_decap_8
XFILLER_120_0 VPWR VGND sg13cmos5l_decap_8
XFILLER_218_0 VPWR VGND sg13cmos5l_decap_8
XFILLER_704_140 VPWR VGND sg13cmos5l_fill_2
XFILLER_165_160 VPWR VGND sg13cmos5l_fill_2
XFILLER_365_49 VPWR VGND sg13cmos5l_decap_8
XFILLER_148_84 VPWR VGND sg13cmos5l_decap_8
XFILLER_662_14 VPWR VGND sg13cmos5l_decap_8
XANTENNA__3473__X Tile_X0Y1_FrameData_O[31] VPWR VGND sg13cmos5l_antennanp
XFILLER_468_161 VPWR VGND sg13cmos5l_decap_8
XFILLER_587_0 VPWR VGND sg13cmos5l_decap_8
XFILLER_314_42 VPWR VGND sg13cmos5l_decap_8
XFILLER_617_147 VPWR VGND sg13cmos5l_fill_1
X_0270_ _0270_/Q Tile_X0Y7_FrameData[17] VGND VPWR Tile_X0Y9_FrameStrobe[3] latch
XFILLER_461_70 VPWR VGND sg13cmos5l_fill_2
XFILLER_483_175 VPWR VGND sg13cmos5l_decap_8
XFILLER_461_81 VPWR VGND sg13cmos5l_fill_1
XFILLER_57_70 VPWR VGND sg13cmos5l_decap_8
XANTENNA__2817__X Tile_X0Y3_E2BEG[7] VPWR VGND sg13cmos5l_antennanp
XFILLER_611_84 VPWR VGND sg13cmos5l_decap_8
XFILLER_640_161 VPWR VGND sg13cmos5l_decap_8
XFILLER_250_112 VPWR VGND sg13cmos5l_decap_8
XFILLER_396_105 VPWR VGND sg13cmos5l_decap_4
XFILLER_330_63 VPWR VGND sg13cmos5l_decap_8
X_3960_ _3960_/X Tile_X0Y1_WW4END[3] AXI_M_SOC_ARREADY _4011_/X _3995_/X _1289_/Q
+ _1288_/Q VPWR VGND sg13cmos5l_mux4_1
XFILLER_330_85 VPWR VGND sg13cmos5l_decap_8
XFILLER_73_91 VPWR VGND sg13cmos5l_decap_8
X_2911_ Tile_X0Y6_UserCLKo Tile_X0Y6_UserCLK VPWR VGND sg13cmos5l_buf_1
XFILLER_687_77 VPWR VGND sg13cmos5l_decap_8
XFILLER_389_190 VPWR VGND sg13cmos5l_fill_2
XFILLER_259_28 VPWR VGND sg13cmos5l_decap_8
X_3891_ _3891_/X Tile_X0Y1_W2MID[6] Tile_X0Y1_W2END[6] Tile_X0Y1_W6END[6] _3991_/X
+ _1415_/Q _1414_/Q VPWR VGND sg13cmos5l_mux4_1
XFILLER_250_178 VPWR VGND sg13cmos5l_decap_8
XANTENNA__3648__X AXI_M_SOC_AWADDR9 VPWR VGND sg13cmos5l_antennanp
XFILLER_189_91 VPWR VGND sg13cmos5l_fill_2
X_2842_ Tile_X0Y6_E2BEG[7] _4503_/X VPWR VGND sg13cmos5l_buf_1
XFILLER_148_116 VPWR VGND sg13cmos5l_fill_2
X_2773_ Tile_X0Y3_FrameData_O[31] Tile_X0Y3_FrameData[31] VPWR VGND sg13cmos5l_buf_1
XFILLER_699_128 VPWR VGND sg13cmos5l_decap_4
XFILLER_352_208 VPWR VGND sg13cmos5l_fill_2
X_1724_ _1724_/Q Tile_X0Y3_FrameData[13] VGND VPWR Tile_X0Y9_FrameStrobe[1] latch
X_4512_ _4512_/X Tile_X0Y6_WW4END[15] AXI_M_SOC_RDATA24 _4583_/X _4552_/X _2583_/Q
+ _2582_/Q VPWR VGND sg13cmos5l_mux4_1
XFILLER_275_49 VPWR VGND sg13cmos5l_decap_8
XFILLER_636_70 VPWR VGND sg13cmos5l_decap_8
XFILLER_208_21 VPWR VGND sg13cmos5l_decap_8
X_1655_ _1655_/Q Tile_X0Y2_FrameData[26] VGND VPWR Tile_X0Y9_FrameStrobe[7] latch
X_4443_ _4443_/X Tile_X0Y1_W1END[2] Tile_X0Y1_WW4END[14] Tile_X0Y1_W6END[6] _4010_/X
+ _1359_/Q _1358_/Q VPWR VGND sg13cmos5l_mux4_1
XFILLER_572_14 VPWR VGND sg13cmos5l_decap_8
XANTENNA__3383__X Tile_X0Y2_E6BEG[6] VPWR VGND sg13cmos5l_antennanp
XFILLER_305_157 VPWR VGND sg13cmos5l_fill_1
XFILLER_104_219 VPWR VGND sg13cmos5l_decap_8
XFILLER_710_154 VPWR VGND sg13cmos5l_decap_8
X_0606_ _0606_/Q Tile_X0Y8_FrameData[1] VGND VPWR Tile_X0Y9_FrameStrobe[5] latch
XFILLER_320_105 VPWR VGND sg13cmos5l_decap_8
X_4374_ _4374_/X Tile_X0Y5_W2MID[5] AXI_M_SOC_RRESP0 _4432_/X _4431_/X _2355_/Q _2354_/Q
+ VPWR VGND sg13cmos5l_mux4_1
XFILLER_171_185 VPWR VGND sg13cmos5l_decap_8
X_1586_ _1586_/Q Tile_X0Y2_FrameData[31] VGND VPWR Tile_X0Y9_FrameStrobe[5] latch
XFILLER_208_98 VPWR VGND sg13cmos5l_decap_8
X_3325_ Tile_X0Y4_EE4BEG[13] _4285_/X VPWR VGND sg13cmos5l_buf_1
X_0537_ _0537_/Q Tile_X0Y8_FrameData[6] VGND VPWR Tile_X0Y9_FrameStrobe[3] latch
XFILLER_505_63 VPWR VGND sg13cmos5l_decap_8
XFILLER_652_91 VPWR VGND sg13cmos5l_decap_8
XFILLER_224_42 VPWR VGND sg13cmos5l_decap_8
X_3256_ Tile_X0Y0_FrameData_O[24] Tile_X0Y0_FrameData[24] VPWR VGND sg13cmos5l_buf_1
X_0468_ _0468_/Q Tile_X0Y8_FrameData[11] VGND VPWR Tile_X0Y9_FrameStrobe[1] latch
XFILLER_371_70 VPWR VGND sg13cmos5l_decap_8
X_2207_ _2207_/Q Tile_X0Y5_FrameData[6] VGND VPWR Tile_X0Y9_FrameStrobe[0] latch
X_3187_ Tile_X0Y0_N4BEG[11] _3187_/A VPWR VGND sg13cmos5l_buf_1
X_0399_ _0399_/Q Tile_X0Y7_FrameData[16] VGND VPWR Tile_X0Y9_FrameStrobe[7] latch
X_2138_ _2138_/Q Tile_X0Y4_FrameData[11] VGND VPWR Tile_X0Y9_FrameStrobe[6] latch
XFILLER_430_212 VPWR VGND sg13cmos5l_decap_8
XFILLER_387_105 VPWR VGND sg13cmos5l_fill_2
XFILLER_240_63 VPWR VGND sg13cmos5l_decap_4
X_2069_ _2069_/Q Tile_X0Y4_FrameData[16] VGND VPWR Tile_X0Y9_FrameStrobe[4] latch
XFILLER_631_194 VPWR VGND sg13cmos5l_fill_2
XFILLER_53_28 VPWR VGND sg13cmos5l_decap_8
XFILLER_240_96 VPWR VGND sg13cmos5l_decap_8
XFILLER_597_77 VPWR VGND sg13cmos5l_decap_8
XFILLER_169_28 VPWR VGND sg13cmos5l_decap_8
XANTENNA__3558__X Tile_X0Y9_EE4BEG[4] VPWR VGND sg13cmos5l_antennanp
XFILLER_591_208 VPWR VGND sg13cmos5l_decap_4
XFILLER_139_105 VPWR VGND sg13cmos5l_decap_8
XFILLER_211_7 VPWR VGND sg13cmos5l_decap_8
XFILLER_147_160 VPWR VGND sg13cmos5l_decap_8
XFILLER_309_7 VPWR VGND sg13cmos5l_decap_8
XFILLER_185_49 VPWR VGND sg13cmos5l_decap_8
XFILLER_546_70 VPWR VGND sg13cmos5l_decap_8
XFILLER_118_21 VPWR VGND sg13cmos5l_decap_8
XFILLER_698_172 VPWR VGND sg13cmos5l_fill_2
XFILLER_482_14 VPWR VGND sg13cmos5l_decap_8
XANTENNA__3293__X Tile_X0Y0_E2BEGb[1] VPWR VGND sg13cmos5l_antennanp
XFILLER_78_14 VPWR VGND sg13cmos5l_decap_8
XFILLER_701_165 VPWR VGND sg13cmos5l_fill_2
XFILLER_265_93 VPWR VGND sg13cmos5l_decap_8
XFILLER_632_28 VPWR VGND sg13cmos5l_decap_8
XFILLER_580_7 VPWR VGND sg13cmos5l_decap_8
XFILLER_415_63 VPWR VGND sg13cmos5l_decap_8
XFILLER_678_7 VPWR VGND sg13cmos5l_decap_8
XFILLER_562_91 VPWR VGND sg13cmos5l_decap_8
XFILLER_134_42 VPWR VGND sg13cmos5l_decap_8
XFILLER_281_70 VPWR VGND sg13cmos5l_decap_8
XFILLER_94_35 VPWR VGND sg13cmos5l_decap_8
XFILLER_465_186 VPWR VGND sg13cmos5l_decap_8
XFILLER_217_131 VPWR VGND sg13cmos5l_decap_8
XFILLER_607_191 VPWR VGND sg13cmos5l_decap_4
XFILLER_91_139 VPWR VGND sg13cmos5l_decap_8
XFILLER_431_84 VPWR VGND sg13cmos5l_decap_8
XFILLER_27_84 VPWR VGND sg13cmos5l_decap_8
XFILLER_168_0 VPWR VGND sg13cmos5l_decap_8
XFILLER_150_63 VPWR VGND sg13cmos5l_decap_8
XFILLER_232_134 VPWR VGND sg13cmos5l_decap_8
XFILLER_709_210 VPWR VGND sg13cmos5l_fill_1
XFILLER_378_149 VPWR VGND sg13cmos5l_fill_1
XFILLER_709_221 VPWR VGND sg13cmos5l_fill_1
XFILLER_657_14 VPWR VGND sg13cmos5l_decap_8
XANTENNA__3468__X Tile_X0Y1_FrameData_O[26] VPWR VGND sg13cmos5l_antennanp
XFILLER_335_0 VPWR VGND sg13cmos5l_decap_8
XFILLER_300_77 VPWR VGND sg13cmos5l_decap_8
XFILLER_319_227 VPWR VGND sg13cmos5l_fill_2
XFILLER_159_72 VPWR VGND sg13cmos5l_fill_1
XFILLER_502_0 VPWR VGND sg13cmos5l_decap_8
XFILLER_159_94 VPWR VGND sg13cmos5l_decap_8
XFILLER_309_42 VPWR VGND sg13cmos5l_decap_8
XFILLER_550_116 VPWR VGND sg13cmos5l_fill_2
XFILLER_138_182 VPWR VGND sg13cmos5l_decap_8
XFILLER_673_35 VPWR VGND sg13cmos5l_decap_8
XFILLER_689_150 VPWR VGND sg13cmos5l_decap_4
XFILLER_488_212 VPWR VGND sg13cmos5l_fill_1
XFILLER_392_14 VPWR VGND sg13cmos5l_decap_8
XFILLER_57_7 VPWR VGND sg13cmos5l_decap_8
XFILLER_299_145 VPWR VGND sg13cmos5l_fill_2
X_1440_ _1440_/Q Tile_X0Y2_FrameData[17] VGND VPWR Tile_X0Y9_FrameStrobe[0] latch
XFILLER_153_196 VPWR VGND sg13cmos5l_fill_1
XFILLER_637_209 VPWR VGND sg13cmos5l_fill_2
XFILLER_606_84 VPWR VGND sg13cmos5l_decap_8
XFILLER_542_28 VPWR VGND sg13cmos5l_decap_8
X_1371_ _1371_/Q Tile_X0Y1_FrameData[30] VGND VPWR Tile_X0Y9_FrameStrobe[6] latch
XFILLER_4_77 VPWR VGND sg13cmos5l_decap_8
X_3110_ Tile_X0Y7_E6BEG[8] _4652_/X VPWR VGND sg13cmos5l_buf_1
XFILLER_67_114 VPWR VGND sg13cmos5l_decap_8
X_0322_ _0322_/Q Tile_X0Y7_FrameData[29] VGND VPWR Tile_X0Y9_FrameStrobe[5] latch
X_4090_ _4090_/X Tile_X0Y1_W1END[1] Tile_X0Y1_W6END[9] _4002_/X _3977_/X _1387_/Q
+ _1386_/Q VPWR VGND sg13cmos5l_mux4_1
XFILLER_191_70 VPWR VGND sg13cmos5l_decap_8
XFILLER_255_226 VPWR VGND sg13cmos5l_fill_2
X_3041_ Tile_X0Y5_FrameData_O[0] Tile_X0Y5_FrameData[0] VPWR VGND sg13cmos5l_buf_1
XFILLER_471_112 VPWR VGND sg13cmos5l_decap_8
X_0253_ _0253_/Q Tile_X0Y7_FrameData[2] VGND VPWR Tile_X0Y9_FrameStrobe[2] latch
XFILLER_605_128 VPWR VGND sg13cmos5l_decap_4
XFILLER_698_21 VPWR VGND sg13cmos5l_decap_8
XFILLER_75_180 VPWR VGND sg13cmos5l_decap_4
X_0184_ _0184_/Q Tile_X0Y7_FrameData[7] VGND VPWR Tile_X0Y9_FrameStrobe[0] latch
XFILLER_620_109 VPWR VGND sg13cmos5l_fill_2
XFILLER_341_84 VPWR VGND sg13cmos5l_fill_2
XFILLER_75_191 VPWR VGND sg13cmos5l_decap_4
XFILLER_208_175 VPWR VGND sg13cmos5l_decap_8
XFILLER_369_105 VPWR VGND sg13cmos5l_decap_8
XFILLER_698_98 VPWR VGND sg13cmos5l_decap_8
XFILLER_23_228 VPWR VGND sg13cmos5l_fill_1
X_3943_ _3943_/X Tile_X0Y1_W2END[4] AXI_M_SOC_ARREADY _3995_/X _3994_/X _1323_/Q _1322_/Q
+ VPWR VGND sg13cmos5l_mux4_1
XFILLER_567_14 VPWR VGND sg13cmos5l_decap_8
XANTENNA__3378__X Tile_X0Y2_E6BEG[1] VPWR VGND sg13cmos5l_antennanp
XFILLER_210_77 VPWR VGND sg13cmos5l_decap_8
X_3874_ _3874_/X _4342_/X _4346_/X _4350_/X _4317_/X _2151_/Q _2150_/Q VPWR VGND sg13cmos5l_mux4_1
XFILLER_83_0 VPWR VGND sg13cmos5l_decap_8
XFILLER_392_130 VPWR VGND sg13cmos5l_decap_4
X_2825_ Tile_X0Y4_E2BEG[3] _4259_/X VPWR VGND sg13cmos5l_buf_1
XFILLER_647_91 VPWR VGND sg13cmos5l_decap_8
XFILLER_136_119 VPWR VGND sg13cmos5l_decap_8
XFILLER_526_179 VPWR VGND sg13cmos5l_fill_1
XFILLER_219_42 VPWR VGND sg13cmos5l_decap_8
XFILLER_191_225 VPWR VGND sg13cmos5l_decap_4
XFILLER_392_185 VPWR VGND sg13cmos5l_decap_8
X_2756_ Tile_X0Y3_FrameData_O[14] Tile_X0Y3_FrameData[14] VPWR VGND sg13cmos5l_buf_1
XFILLER_583_35 VPWR VGND sg13cmos5l_decap_8
XFILLER_541_127 VPWR VGND sg13cmos5l_decap_8
XFILLER_392_196 VPWR VGND sg13cmos5l_fill_2
XFILLER_366_70 VPWR VGND sg13cmos5l_decap_8
XFILLER_129_193 VPWR VGND sg13cmos5l_decap_8
XFILLER_541_138 VPWR VGND sg13cmos5l_fill_2
XFILLER_479_212 VPWR VGND sg13cmos5l_decap_8
X_1707_ _1707_/Q Tile_X0Y3_FrameData[30] VGND VPWR Tile_X0Y9_FrameStrobe[1] latch
X_2687_ _2687_/Q Tile_X0Y6_FrameData[8] VGND VPWR Tile_X0Y9_FrameStrobe[7] latch
XFILLER_144_163 VPWR VGND sg13cmos5l_fill_1
XFILLER_144_185 VPWR VGND sg13cmos5l_decap_4
X_1638_ _1638_/Q Tile_X0Y2_FrameData[11] VGND VPWR Tile_X0Y9_FrameStrobe[6] latch
X_4426_ _4426_/X Tile_X0Y4_W1END[3] Tile_X0Y4_W6END[11] _4351_/X _4309_/X _2139_/Q
+ _2138_/Q VPWR VGND sg13cmos5l_mux4_1
XFILLER_516_84 VPWR VGND sg13cmos5l_decap_8
XFILLER_452_28 VPWR VGND sg13cmos5l_decap_8
XFILLER_235_63 VPWR VGND sg13cmos5l_decap_8
X_1569_ _1569_/Q Tile_X0Y2_FrameData[16] VGND VPWR Tile_X0Y9_FrameStrobe[4] latch
X_4357_ _4357_/X Tile_X0Y6_W2MID[5] Tile_X0Y6_W2END[5] Tile_X0Y6_W6END[5] _4557_/X
+ _2683_/Q _2682_/Q VPWR VGND sg13cmos5l_mux4_1
XFILLER_48_17 VPWR VGND sg13cmos5l_decap_8
X_3308_ Tile_X0Y0_E1BEG[0] _3800_/X VPWR VGND sg13cmos5l_buf_1
X_4288_ _4288_/X _0099_/X _0112_/X _4347_/X _4351_/X _2037_/Q _2036_/Q VPWR VGND sg13cmos5l_mux4_1
XFILLER_651_201 VPWR VGND sg13cmos5l_decap_8
XFILLER_447_186 VPWR VGND sg13cmos5l_fill_1
X_3239_ Tile_X0Y0_FrameData_O[7] Tile_X0Y0_FrameData[7] VPWR VGND sg13cmos5l_buf_1
XFILLER_104_56 VPWR VGND sg13cmos5l_decap_8
XFILLER_462_189 VPWR VGND sg13cmos5l_decap_4
XFILLER_64_49 VPWR VGND sg13cmos5l_decap_8
XFILLER_401_21 VPWR VGND sg13cmos5l_decap_8
XFILLER_214_112 VPWR VGND sg13cmos5l_decap_8
XFILLER_161_7 VPWR VGND sg13cmos5l_decap_8
XFILLER_259_7 VPWR VGND sg13cmos5l_decap_8
XFILLER_14_217 VPWR VGND sg13cmos5l_fill_1
XFILLER_477_14 VPWR VGND sg13cmos5l_decap_8
XFILLER_214_189 VPWR VGND sg13cmos5l_decap_8
XANTENNA__3288__X Tile_X0Y0_E6BEG[8] VPWR VGND sg13cmos5l_antennanp
XFILLER_120_77 VPWR VGND sg13cmos5l_decap_8
XFILLER_426_7 VPWR VGND sg13cmos5l_decap_8
XFILLER_167_211 VPWR VGND sg13cmos5l_decap_8
XFILLER_517_113 VPWR VGND sg13cmos5l_fill_2
XFILLER_196_26 VPWR VGND sg13cmos5l_decap_8
XFILLER_627_28 VPWR VGND sg13cmos5l_decap_8
XFILLER_13_42 VPWR VGND sg13cmos5l_decap_8
XANTENNA__2920__X Tile_X0Y8_E2BEG[4] VPWR VGND sg13cmos5l_antennanp
XFILLER_557_91 VPWR VGND sg13cmos5l_decap_8
XFILLER_129_42 VPWR VGND sg13cmos5l_decap_8
XFILLER_493_35 VPWR VGND sg13cmos5l_decap_8
XFILLER_276_70 VPWR VGND sg13cmos5l_decap_8
XFILLER_89_35 VPWR VGND sg13cmos5l_decap_8
XFILLER_129_97 VPWR VGND sg13cmos5l_decap_8
XFILLER_89_79 VPWR VGND sg13cmos5l_decap_8
XFILLER_150_100 VPWR VGND sg13cmos5l_fill_1
XFILLER_643_49 VPWR VGND sg13cmos5l_decap_8
XFILLER_540_182 VPWR VGND sg13cmos5l_decap_8
XFILLER_426_84 VPWR VGND sg13cmos5l_decap_8
XFILLER_150_133 VPWR VGND sg13cmos5l_fill_2
XFILLER_485_215 VPWR VGND sg13cmos5l_decap_8
XFILLER_362_28 VPWR VGND sg13cmos5l_decap_8
XFILLER_145_63 VPWR VGND sg13cmos5l_decap_8
XFILLER_1_154 VPWR VGND sg13cmos5l_fill_1
XANTENNA__3751__X AXI_M_SOC_ARADDR23 VPWR VGND sg13cmos5l_antennanp
XFILLER_292_91 VPWR VGND sg13cmos5l_decap_8
XFILLER_1_165 VPWR VGND sg13cmos5l_fill_2
XFILLER_49_147 VPWR VGND sg13cmos5l_decap_4
XFILLER_453_101 VPWR VGND sg13cmos5l_fill_1
XFILLER_438_186 VPWR VGND sg13cmos5l_fill_1
XFILLER_285_0 VPWR VGND sg13cmos5l_decap_8
XFILLER_599_105 VPWR VGND sg13cmos5l_fill_2
XFILLER_453_123 VPWR VGND sg13cmos5l_decap_4
XFILLER_64_106 VPWR VGND sg13cmos5l_decap_8
XFILLER_599_138 VPWR VGND sg13cmos5l_fill_2
XFILLER_599_149 VPWR VGND sg13cmos5l_fill_1
XFILLER_57_180 VPWR VGND sg13cmos5l_decap_8
XFILLER_161_84 VPWR VGND sg13cmos5l_fill_2
XFILLER_452_0 VPWR VGND sg13cmos5l_decap_8
XFILLER_311_21 VPWR VGND sg13cmos5l_decap_8
XFILLER_205_112 VPWR VGND sg13cmos5l_decap_8
XFILLER_72_172 VPWR VGND sg13cmos5l_fill_1
XFILLER_668_35 VPWR VGND sg13cmos5l_decap_8
XFILLER_72_183 VPWR VGND sg13cmos5l_decap_8
XFILLER_311_98 VPWR VGND sg13cmos5l_fill_2
XFILLER_387_14 VPWR VGND sg13cmos5l_decap_8
XANTENNA__3198__X Tile_X0Y0_N2BEGb[6] VPWR VGND sg13cmos5l_antennanp
XFILLER_717_0 VPWR VGND sg13cmos5l_fill_2
XFILLER_220_126 VPWR VGND sg13cmos5l_fill_1
XFILLER_366_119 VPWR VGND sg13cmos5l_decap_8
XFILLER_20_209 VPWR VGND sg13cmos5l_decap_4
X_0940_ _0940_/Q Tile_X0Y9_FrameData[31] VGND VPWR Tile_X0Y9_FrameStrobe[8] latch
X_0871_ _0871_/Q Tile_X0Y9_FrameData[24] VGND VPWR Tile_X0Y9_FrameStrobe[6] latch
XFILLER_537_28 VPWR VGND sg13cmos5l_decap_8
XFILLER_684_56 VPWR VGND sg13cmos5l_decap_8
XFILLER_467_80 VPWR VGND sg13cmos5l_decap_8
XFILLER_70_70 VPWR VGND sg13cmos5l_decap_8
XANTENNA__2830__X Tile_X0Y4_UserCLKo VPWR VGND sg13cmos5l_antennanp
X_2610_ _2610_/Q Tile_X0Y6_FrameData[21] VGND VPWR Tile_X0Y9_FrameStrobe[5] latch
X_3590_ Tile_X0Y9_FrameData_O[20] Tile_X0Y9_FrameData[20] VPWR VGND sg13cmos5l_buf_1
XFILLER_186_70 VPWR VGND sg13cmos5l_decap_8
X_2541_ _2541_/Q Tile_X0Y6_FrameData[26] VGND VPWR Tile_X0Y9_FrameStrobe[3] latch
X_2472_ _2472_/Q Tile_X0Y6_FrameData[31] VGND VPWR Tile_X0Y9_FrameStrobe[1] latch
XFILLER_553_49 VPWR VGND sg13cmos5l_decap_8
XFILLER_336_84 VPWR VGND sg13cmos5l_decap_8
XFILLER_141_133 VPWR VGND sg13cmos5l_decap_8
XFILLER_287_126 VPWR VGND sg13cmos5l_fill_1
X_1423_ _1423_/Q Tile_X0Y1_FrameData[10] VGND VPWR Tile_X0Y9_FrameStrobe[7] latch
X_4211_ _4211_/X _4135_/X _4243_/X _4242_/X _4134_/X _1691_/Q _1690_/Q VPWR VGND sg13cmos5l_mux4_1
XFILLER_692_112 VPWR VGND sg13cmos5l_decap_8
XFILLER_677_186 VPWR VGND sg13cmos5l_fill_2
XFILLER_272_28 VPWR VGND sg13cmos5l_decap_8
XANTENNA__3661__X AXI_M_SOC_AWADDR22 VPWR VGND sg13cmos5l_antennanp
X_4142_ _4142_/X Tile_X0Y1_W1END[3] Tile_X0Y1_W2MID[0] Tile_X0Y1_W2END[0] _3988_/X
+ _1367_/Q _1366_/Q VPWR VGND sg13cmos5l_mux4_1
X_1354_ _1354_/Q Tile_X0Y1_FrameData[15] VGND VPWR Tile_X0Y9_FrameStrobe[5] latch
XFILLER_429_175 VPWR VGND sg13cmos5l_decap_8
X_0305_ _0305_/Q Tile_X0Y7_FrameData[14] VGND VPWR Tile_X0Y9_FrameStrobe[4] latch
XFILLER_633_212 VPWR VGND sg13cmos5l_decap_4
XFILLER_295_192 VPWR VGND sg13cmos5l_decap_8
X_4073_ _4073_/X _0064_/X Tile_X0Y0_S4END[9] _4126_/X _4107_/X _1527_/Q _1526_/Q VPWR
+ VGND sg13cmos5l_mux4_1
XFILLER_205_77 VPWR VGND sg13cmos5l_decap_8
X_1285_ _1285_/Q Tile_X0Y1_FrameData[20] VGND VPWR Tile_X0Y9_FrameStrobe[3] latch
X_3024_ Tile_X0Y5_E6BEG[11] _4415_/X VPWR VGND sg13cmos5l_buf_1
XFILLER_502_42 VPWR VGND sg13cmos5l_decap_8
X_0236_ _0236_/Q Tile_X0Y7_FrameData[19] VGND VPWR Tile_X0Y9_FrameStrobe[2] latch
XFILLER_55_139 VPWR VGND sg13cmos5l_decap_8
XFILLER_221_21 VPWR VGND sg13cmos5l_decap_8
X_0167_ _0167_/Q Tile_X0Y7_FrameData[24] VGND VPWR Tile_X0Y9_FrameStrobe[0] latch
XFILLER_578_35 VPWR VGND sg13cmos5l_decap_8
XFILLER_297_14 VPWR VGND sg13cmos5l_decap_8
XFILLER_221_98 VPWR VGND sg13cmos5l_decap_8
X_0098_ _3634_/A _4836_/X _4837_/X _0865_/Q VPWR VGND sg13cmos5l_mux2_1
XFILLER_211_126 VPWR VGND sg13cmos5l_decap_8
XFILLER_357_119 VPWR VGND sg13cmos5l_decap_8
XFILLER_211_137 VPWR VGND sg13cmos5l_fill_1
XFILLER_149_211 VPWR VGND sg13cmos5l_decap_4
X_3926_ _3926_/X Tile_X0Y3_W1END[0] Tile_X0Y3_WW4END[0] Tile_X0Y3_W6END[8] _4222_/X
+ _1901_/Q _1900_/Q VPWR VGND sg13cmos5l_mux4_1
XFILLER_447_28 VPWR VGND sg13cmos5l_decap_8
X_3857_ _3857_/X _3893_/X _3892_/X Tile_X0Y0_S2MID[2] Tile_X0Y0_S2END[2] _0959_/Q
+ _0958_/Q VPWR VGND sg13cmos5l_mux4_1
XFILLER_50_29 VPWR VGND sg13cmos5l_decap_8
XFILLER_594_56 VPWR VGND sg13cmos5l_decap_8
XANTENNA__2740__X Tile_X0Y4_E1BEG[3] VPWR VGND sg13cmos5l_antennanp
XFILLER_514_105 VPWR VGND sg13cmos5l_decap_4
XFILLER_164_225 VPWR VGND sg13cmos5l_decap_4
X_2808_ Tile_X0Y3_E2BEGb[6] _4162_/X VPWR VGND sg13cmos5l_buf_1
X_3788_ _3788_/X Tile_X0Y0_W2MID[3] Tile_X0Y0_W2END[3] Tile_X0Y0_W6END[3] _3858_/X
+ _1161_/Q _1160_/Q VPWR VGND sg13cmos5l_mux4_1
XFILLER_703_227 VPWR VGND sg13cmos5l_fill_2
XFILLER_380_133 VPWR VGND sg13cmos5l_decap_4
X_2739_ Tile_X0Y4_E1BEG[2] _4254_/X VPWR VGND sg13cmos5l_buf_1
XFILLER_380_166 VPWR VGND sg13cmos5l_decap_8
XFILLER_117_152 VPWR VGND sg13cmos5l_decap_8
XFILLER_59_27 VPWR VGND sg13cmos5l_decap_8
XFILLER_463_49 VPWR VGND sg13cmos5l_decap_8
XFILLER_132_133 VPWR VGND sg13cmos5l_decap_8
XFILLER_278_126 VPWR VGND sg13cmos5l_decap_8
X_4409_ _4409_/X AXI_M_SOC_RLAST _4457_/X _4461_/X _4430_/X _2285_/Q _2284_/Q VPWR
+ VGND sg13cmos5l_mux4_1
XFILLER_182_28 VPWR VGND sg13cmos5l_decap_8
XFILLER_609_220 VPWR VGND sg13cmos5l_fill_2
XANTENNA__3571__X Tile_X0Y9_FrameData_O[1] VPWR VGND sg13cmos5l_antennanp
XFILLER_683_156 VPWR VGND sg13cmos5l_decap_8
XFILLER_624_212 VPWR VGND sg13cmos5l_fill_2
XFILLER_435_112 VPWR VGND sg13cmos5l_decap_8
XFILLER_115_77 VPWR VGND sg13cmos5l_fill_2
XFILLER_376_7 VPWR VGND sg13cmos5l_decap_8
XFILLER_234_218 VPWR VGND sg13cmos5l_decap_4
XFILLER_412_75 VPWR VGND sg13cmos5l_decap_8
XFILLER_131_21 VPWR VGND sg13cmos5l_decap_8
XANTENNA__2915__X Tile_X0Y8_E1BEG[3] VPWR VGND sg13cmos5l_antennanp
XFILLER_543_7 VPWR VGND sg13cmos5l_decap_8
XFILLER_91_14 VPWR VGND sg13cmos5l_decap_8
XFILLER_488_35 VPWR VGND sg13cmos5l_decap_8
XFILLER_54_194 VPWR VGND sg13cmos5l_decap_8
XFILLER_131_98 VPWR VGND sg13cmos5l_decap_8
XFILLER_348_119 VPWR VGND sg13cmos5l_decap_8
XFILLER_199_188 VPWR VGND sg13cmos5l_fill_2
XFILLER_710_7 VPWR VGND sg13cmos5l_decap_8
XFILLER_638_49 VPWR VGND sg13cmos5l_decap_8
XFILLER_24_63 VPWR VGND sg13cmos5l_decap_8
XFILLER_357_28 VPWR VGND sg13cmos5l_decap_8
XFILLER_287_91 VPWR VGND sg13cmos5l_decap_8
XANTENNA__3746__X AXI_M_SOC_ARADDR18 VPWR VGND sg13cmos5l_antennanp
XFILLER_505_105 VPWR VGND sg13cmos5l_decap_8
XFILLER_356_196 VPWR VGND sg13cmos5l_decap_8
XFILLER_200_0 VPWR VGND sg13cmos5l_decap_8
XFILLER_170_228 VPWR VGND sg13cmos5l_fill_1
XFILLER_312_211 VPWR VGND sg13cmos5l_decap_8
XFILLER_373_49 VPWR VGND sg13cmos5l_decap_8
XFILLER_108_196 VPWR VGND sg13cmos5l_decap_8
XFILLER_513_182 VPWR VGND sg13cmos5l_decap_4
XFILLER_458_215 VPWR VGND sg13cmos5l_decap_8
XFILLER_156_84 VPWR VGND sg13cmos5l_decap_8
XFILLER_306_21 VPWR VGND sg13cmos5l_decap_8
XFILLER_269_126 VPWR VGND sg13cmos5l_fill_2
XFILLER_156_95 VPWR VGND sg13cmos5l_fill_2
XFILLER_670_14 VPWR VGND sg13cmos5l_decap_8
XANTENNA__3481__X Tile_X0Y1_EE4BEG[7] VPWR VGND sg13cmos5l_antennanp
XFILLER_615_201 VPWR VGND sg13cmos5l_decap_8
XFILLER_667_0 VPWR VGND sg13cmos5l_decap_8
XFILLER_426_112 VPWR VGND sg13cmos5l_decap_8
XFILLER_615_223 VPWR VGND sg13cmos5l_decap_4
XFILLER_603_63 VPWR VGND sg13cmos5l_decap_8
XFILLER_322_42 VPWR VGND sg13cmos5l_decap_8
XFILLER_292_151 VPWR VGND sg13cmos5l_decap_8
XFILLER_37_139 VPWR VGND sg13cmos5l_decap_8
XFILLER_1_56 VPWR VGND sg13cmos5l_decap_8
X_1070_ _1070_/Q Tile_X0Y0_FrameData[29] VGND VPWR Tile_X0Y9_FrameStrobe[4] latch
XFILLER_426_189 VPWR VGND sg13cmos5l_decap_8
XFILLER_679_56 VPWR VGND sg13cmos5l_decap_8
XFILLER_65_70 VPWR VGND sg13cmos5l_fill_2
XFILLER_587_119 VPWR VGND sg13cmos5l_decap_8
XANTENNA__2825__X Tile_X0Y4_E2BEG[3] VPWR VGND sg13cmos5l_antennanp
XFILLER_65_92 VPWR VGND sg13cmos5l_decap_8
XFILLER_379_222 VPWR VGND sg13cmos5l_decap_8
XFILLER_398_35 VPWR VGND sg13cmos5l_decap_8
XFILLER_394_203 VPWR VGND sg13cmos5l_decap_8
X_4760_ _4760_/X Tile_X0Y9_N4END[4] _0077_/X _4811_/X _4815_/X _0527_/Q _0526_/Q VPWR
+ VGND sg13cmos5l_mux4_1
XFILLER_595_185 VPWR VGND sg13cmos5l_fill_2
X_1972_ _1972_/Q Tile_X0Y4_FrameData[17] VGND VPWR Tile_X0Y9_FrameStrobe[1] latch
XFILLER_548_49 VPWR VGND sg13cmos5l_decap_8
XFILLER_347_130 VPWR VGND sg13cmos5l_fill_1
X_3711_ AXI_M_SOC_WDATA21 Tile_X0Y6_WW4END[5] Tile_X0Y6_WW4END[13] Tile_X0Y6_W6END[5]
+ _4573_/X _2517_/Q _2516_/Q VPWR VGND sg13cmos5l_mux4_1
XFILLER_695_77 VPWR VGND sg13cmos5l_decap_8
X_0923_ _0923_/Q Tile_X0Y9_FrameData[4] VGND VPWR Tile_X0Y9_FrameStrobe[7] latch
XFILLER_267_28 VPWR VGND sg13cmos5l_decap_8
X_4691_ _4691_/X _4667_/X Tile_X0Y9_N4END[11] _4666_/X _0053_/X _0201_/Q _0200_/Q
+ VPWR VGND sg13cmos5l_mux4_1
XANTENNA__3656__X AXI_M_SOC_AWADDR17 VPWR VGND sg13cmos5l_antennanp
XFILLER_197_91 VPWR VGND sg13cmos5l_decap_8
XFILLER_628_82 VPWR VGND sg13cmos5l_decap_8
X_0854_ _0854_/Q Tile_X0Y9_FrameData[9] VGND VPWR Tile_X0Y9_FrameStrobe[5] latch
X_3642_ AXI_M_SOC_AWADDR3 Tile_X0Y5_WW4END[3] Tile_X0Y5_WW4END[11] Tile_X0Y5_W6END[3]
+ _4454_/X _2265_/Q _2264_/Q VPWR VGND sg13cmos5l_mux4_1
XFILLER_551_211 VPWR VGND sg13cmos5l_decap_4
X_0785_ _0785_/Q Tile_X0Y9_FrameData[14] VGND VPWR Tile_X0Y9_FrameStrobe[3] latch
X_3573_ Tile_X0Y9_FrameData_O[3] Tile_X0Y9_FrameData[3] VPWR VGND sg13cmos5l_buf_1
XFILLER_161_228 VPWR VGND sg13cmos5l_fill_1
XFILLER_511_119 VPWR VGND sg13cmos5l_decap_8
XFILLER_714_18 VPWR VGND sg13cmos5l_fill_1
X_2524_ _2524_/Q Tile_X0Y6_FrameData[11] VGND VPWR Tile_X0Y9_FrameStrobe[2] latch
XFILLER_714_29 VPWR VGND sg13cmos5l_decap_8
XFILLER_283_49 VPWR VGND sg13cmos5l_decap_8
XFILLER_644_70 VPWR VGND sg13cmos5l_decap_8
XFILLER_449_215 VPWR VGND sg13cmos5l_decap_4
XFILLER_114_133 VPWR VGND sg13cmos5l_fill_1
XFILLER_46_0 VPWR VGND sg13cmos5l_fill_1
XFILLER_216_21 VPWR VGND sg13cmos5l_decap_8
XFILLER_665_112 VPWR VGND sg13cmos5l_fill_2
X_2455_ _2455_/Q Tile_X0Y6_FrameData[16] VGND VPWR Tile_X0Y9_FrameStrobe[0] latch
XFILLER_580_14 VPWR VGND sg13cmos5l_decap_8
XANTENNA__3391__X Tile_X0Y2_E2BEGb[2] VPWR VGND sg13cmos5l_antennanp
XFILLER_114_199 VPWR VGND sg13cmos5l_decap_8
X_1406_ _1406_/Q Tile_X0Y1_FrameData[27] VGND VPWR Tile_X0Y9_FrameStrobe[7] latch
XFILLER_665_167 VPWR VGND sg13cmos5l_decap_4
X_2386_ _2386_/Q Tile_X0Y5_FrameData[19] VGND VPWR Tile_X0Y9_FrameStrobe[6] latch
XFILLER_680_104 VPWR VGND sg13cmos5l_decap_8
XFILLER_216_98 VPWR VGND sg13cmos5l_decap_8
XFILLER_606_212 VPWR VGND sg13cmos5l_fill_1
X_1337_ _1337_/Q Tile_X0Y1_FrameData[0] VGND VPWR Tile_X0Y9_FrameStrobe[4] latch
X_4125_ _4125_/X _4091_/X _0064_/X _4090_/X Tile_X0Y0_S4END[9] _1463_/Q _1462_/Q VPWR
+ VGND sg13cmos5l_mux4_1
XFILLER_513_63 VPWR VGND sg13cmos5l_decap_8
XFILLER_83_201 VPWR VGND sg13cmos5l_fill_2
XFILLER_283_140 VPWR VGND sg13cmos5l_decap_8
XFILLER_660_91 VPWR VGND sg13cmos5l_decap_8
XFILLER_232_42 VPWR VGND sg13cmos5l_decap_8
XFILLER_417_167 VPWR VGND sg13cmos5l_decap_8
X_1268_ _1268_/Q Tile_X0Y1_FrameData[5] VGND VPWR Tile_X0Y9_FrameStrobe[2] latch
X_4056_ _4056_/X Tile_X0Y2_WW4END[15] AXI_M_SOC_AWREADY _4104_/X _4096_/X _1561_/Q
+ _1560_/Q VPWR VGND sg13cmos5l_mux4_1
XFILLER_417_178 VPWR VGND sg13cmos5l_fill_2
XFILLER_621_215 VPWR VGND sg13cmos5l_decap_8
XFILLER_432_126 VPWR VGND sg13cmos5l_decap_8
XFILLER_589_56 VPWR VGND sg13cmos5l_decap_8
XFILLER_578_119 VPWR VGND sg13cmos5l_decap_8
X_0219_ _0219_/Q Tile_X0Y7_FrameData[4] VGND VPWR Tile_X0Y9_FrameStrobe[1] latch
X_3007_ Tile_X0Y5_E2BEGb[2] _4382_/X VPWR VGND sg13cmos5l_buf_1
X_1199_ _1199_/Q Tile_X0Y1_FrameData[10] VGND VPWR Tile_X0Y9_FrameStrobe[0] latch
XFILLER_51_131 VPWR VGND sg13cmos5l_fill_1
XFILLER_196_103 VPWR VGND sg13cmos5l_decap_8
XFILLER_101_35 VPWR VGND sg13cmos5l_decap_8
XFILLER_586_152 VPWR VGND sg13cmos5l_fill_1
XFILLER_440_170 VPWR VGND sg13cmos5l_decap_8
XFILLER_51_153 VPWR VGND sg13cmos5l_fill_1
XFILLER_385_214 VPWR VGND sg13cmos5l_decap_8
XFILLER_440_192 VPWR VGND sg13cmos5l_decap_8
XFILLER_385_225 VPWR VGND sg13cmos5l_decap_4
XFILLER_458_49 VPWR VGND sg13cmos5l_decap_8
XFILLER_388_90 VPWR VGND sg13cmos5l_decap_4
X_3909_ _3909_/X _4013_/X _4017_/X _4002_/X _3991_/X _1398_/Q _1397_/Q VPWR VGND sg13cmos5l_mux4_1
XFILLER_177_28 VPWR VGND sg13cmos5l_decap_8
X_4889_ _4889_/X AXI_M_SOC_RDATA5 _4918_/X _4922_/X _4904_/X _0765_/Q _0764_/Q VPWR
+ VGND sg13cmos5l_mux4_1
XANTENNA__3566__X Tile_X0Y9_EE4BEG[12] VPWR VGND sg13cmos5l_antennanp
XFILLER_338_174 VPWR VGND sg13cmos5l_decap_8
XFILLER_137_225 VPWR VGND sg13cmos5l_decap_4
XFILLER_124_7 VPWR VGND sg13cmos5l_fill_2
XFILLER_353_133 VPWR VGND sg13cmos5l_decap_8
XFILLER_499_126 VPWR VGND sg13cmos5l_decap_8
XFILLER_688_226 VPWR VGND sg13cmos5l_fill_2
XFILLER_152_228 VPWR VGND sg13cmos5l_fill_1
XFILLER_502_119 VPWR VGND sg13cmos5l_decap_8
XFILLER_407_42 VPWR VGND sg13cmos5l_decap_8
XFILLER_10_21 VPWR VGND sg13cmos5l_decap_8
XFILLER_193_49 VPWR VGND sg13cmos5l_decap_8
XFILLER_554_70 VPWR VGND sg13cmos5l_decap_8
XFILLER_126_21 VPWR VGND sg13cmos5l_decap_8
XFILLER_105_144 VPWR VGND sg13cmos5l_decap_8
XFILLER_656_112 VPWR VGND sg13cmos5l_decap_8
XFILLER_490_14 VPWR VGND sg13cmos5l_decap_8
XFILLER_493_7 VPWR VGND sg13cmos5l_decap_8
XFILLER_86_14 VPWR VGND sg13cmos5l_decap_8
XFILLER_120_114 VPWR VGND sg13cmos5l_decap_8
XFILLER_10_98 VPWR VGND sg13cmos5l_decap_8
XFILLER_126_98 VPWR VGND sg13cmos5l_decap_8
XFILLER_704_84 VPWR VGND sg13cmos5l_decap_8
XFILLER_120_158 VPWR VGND sg13cmos5l_fill_1
XFILLER_660_7 VPWR VGND sg13cmos5l_decap_8
XFILLER_640_28 VPWR VGND sg13cmos5l_decap_8
XFILLER_259_192 VPWR VGND sg13cmos5l_decap_8
XFILLER_423_63 VPWR VGND sg13cmos5l_decap_8
XFILLER_570_91 VPWR VGND sg13cmos5l_decap_8
XFILLER_19_63 VPWR VGND sg13cmos5l_decap_8
XFILLER_142_42 VPWR VGND sg13cmos5l_decap_8
XANTENNA__0149__Y AXI_M_SOC_AWLEN1 VPWR VGND sg13cmos5l_antennanp
XFILLER_274_184 VPWR VGND sg13cmos5l_fill_2
XFILLER_499_56 VPWR VGND sg13cmos5l_decap_8
XFILLER_423_126 VPWR VGND sg13cmos5l_decap_8
XFILLER_569_119 VPWR VGND sg13cmos5l_decap_8
XFILLER_376_203 VPWR VGND sg13cmos5l_fill_1
XFILLER_150_0 VPWR VGND sg13cmos5l_decap_8
XFILLER_35_84 VPWR VGND sg13cmos5l_decap_8
XFILLER_248_0 VPWR VGND sg13cmos5l_decap_8
XFILLER_187_125 VPWR VGND sg13cmos5l_decap_8
XFILLER_368_49 VPWR VGND sg13cmos5l_decap_8
XFILLER_592_144 VPWR VGND sg13cmos5l_fill_2
XFILLER_665_14 VPWR VGND sg13cmos5l_decap_8
XFILLER_391_206 VPWR VGND sg13cmos5l_decap_4
XFILLER_329_152 VPWR VGND sg13cmos5l_decap_8
XFILLER_391_217 VPWR VGND sg13cmos5l_fill_1
XFILLER_415_0 VPWR VGND sg13cmos5l_decap_8
XANTENNA__3476__X Tile_X0Y1_EE4BEG[2] VPWR VGND sg13cmos5l_antennanp
XFILLER_195_191 VPWR VGND sg13cmos5l_decap_8
XFILLER_533_222 VPWR VGND sg13cmos5l_decap_8
XFILLER_51_83 VPWR VGND sg13cmos5l_fill_1
XFILLER_344_144 VPWR VGND sg13cmos5l_decap_8
XFILLER_143_217 VPWR VGND sg13cmos5l_fill_2
XFILLER_317_42 VPWR VGND sg13cmos5l_decap_8
X_0570_ _0570_/Q Tile_X0Y8_FrameData[5] VGND VPWR Tile_X0Y9_FrameStrobe[4] latch
XFILLER_681_35 VPWR VGND sg13cmos5l_decap_8
XFILLER_464_70 VPWR VGND sg13cmos5l_decap_8
XFILLER_647_112 VPWR VGND sg13cmos5l_decap_8
XFILLER_257_107 VPWR VGND sg13cmos5l_fill_2
X_2240_ _2240_/Q Tile_X0Y5_FrameData[5] VGND VPWR Tile_X0Y9_FrameStrobe[1] latch
XFILLER_300_225 VPWR VGND sg13cmos5l_decap_4
XFILLER_614_84 VPWR VGND sg13cmos5l_decap_8
XFILLER_501_196 VPWR VGND sg13cmos5l_decap_8
XFILLER_647_189 VPWR VGND sg13cmos5l_decap_8
X_2171_ _2171_/Q Tile_X0Y4_FrameData[10] VGND VPWR Tile_X0Y9_FrameStrobe[7] latch
XFILLER_550_28 VPWR VGND sg13cmos5l_decap_8
XFILLER_333_63 VPWR VGND sg13cmos5l_decap_8
X_1122_ _1122_/Q Tile_X0Y0_FrameData[9] VGND VPWR Tile_X0Y9_FrameStrobe[5] latch
XFILLER_76_91 VPWR VGND sg13cmos5l_decap_8
X_1053_ _1053_/Q Tile_X0Y0_FrameData[14] VGND VPWR Tile_X0Y9_FrameStrobe[3] latch
XFILLER_670_192 VPWR VGND sg13cmos5l_fill_2
XFILLER_280_154 VPWR VGND sg13cmos5l_decap_8
XFILLER_202_56 VPWR VGND sg13cmos5l_decap_8
XFILLER_18_183 VPWR VGND sg13cmos5l_decap_8
X_4812_ _4812_/X _4777_/X Tile_X0Y9_N4END[4] _4776_/X _0077_/X _0447_/Q _0446_/Q VPWR
+ VGND sg13cmos5l_mux4_1
XFILLER_717_116 VPWR VGND sg13cmos5l_decap_8
XFILLER_278_49 VPWR VGND sg13cmos5l_decap_8
XFILLER_639_70 VPWR VGND sg13cmos5l_decap_8
X_4743_ _4743_/X Tile_X0Y8_W2END[0] AXI_M_SOC_RDATA8 _4785_/X _4784_/X _0561_/Q _0560_/Q
+ VPWR VGND sg13cmos5l_mux4_1
XFILLER_575_14 VPWR VGND sg13cmos5l_decap_8
X_1955_ _1955_/Q Tile_X0Y4_FrameData[2] VGND VPWR Tile_X0Y9_FrameStrobe[0] latch
XANTENNA__3386__X Tile_X0Y2_E6BEG[9] VPWR VGND sg13cmos5l_antennanp
XFILLER_382_228 VPWR VGND sg13cmos5l_fill_1
X_0906_ _0906_/Q Tile_X0Y9_FrameData[21] VGND VPWR Tile_X0Y9_FrameStrobe[7] latch
XFILLER_583_199 VPWR VGND sg13cmos5l_decap_8
X_4674_ _4674_/X _4593_/X _4709_/X _4708_/X _4592_/X _0175_/Q _0174_/Q VPWR VGND sg13cmos5l_mux4_1
X_1886_ _1886_/Q Tile_X0Y3_FrameData[11] VGND VPWR Tile_X0Y9_FrameStrobe[6] latch
X_3625_ Tile_X0Y9_S4BEG[3] _3625_/A VPWR VGND sg13cmos5l_buf_1
X_0837_ _0837_/Q Tile_X0Y9_FrameData[26] VGND VPWR Tile_X0Y9_FrameStrobe[5] latch
XFILLER_508_63 VPWR VGND sg13cmos5l_decap_8
XFILLER_134_228 VPWR VGND sg13cmos5l_fill_1
XFILLER_655_91 VPWR VGND sg13cmos5l_decap_8
XFILLER_227_42 VPWR VGND sg13cmos5l_decap_8
X_3556_ Tile_X0Y9_EE4BEG[2] _4866_/X VPWR VGND sg13cmos5l_buf_1
X_0768_ _0768_/Q Tile_X0Y9_FrameData[31] VGND VPWR Tile_X0Y9_FrameStrobe[3] latch
XFILLER_591_35 VPWR VGND sg13cmos5l_decap_8
XFILLER_374_70 VPWR VGND sg13cmos5l_decap_8
XFILLER_350_147 VPWR VGND sg13cmos5l_decap_4
XFILLER_638_112 VPWR VGND sg13cmos5l_decap_8
X_2507_ _2507_/Q Tile_X0Y6_FrameData[28] VGND VPWR Tile_X0Y9_FrameStrobe[2] latch
X_0699_ _0699_/Q Tile_X0Y9_FrameData[4] VGND VPWR Tile_X0Y9_FrameStrobe[0] latch
X_3487_ Tile_X0Y1_EE4BEG[13] _3961_/X VPWR VGND sg13cmos5l_buf_1
X_2438_ _2438_/Q Tile_X0Y5_FrameData[31] VGND VPWR Tile_X0Y9_FrameStrobe[8] latch
XFILLER_638_178 VPWR VGND sg13cmos5l_decap_8
XFILLER_248_129 VPWR VGND sg13cmos5l_decap_4
XFILLER_653_126 VPWR VGND sg13cmos5l_decap_8
XFILLER_460_28 VPWR VGND sg13cmos5l_decap_8
XFILLER_243_63 VPWR VGND sg13cmos5l_decap_8
XFILLER_56_201 VPWR VGND sg13cmos5l_decap_8
XFILLER_56_17 VPWR VGND sg13cmos5l_decap_8
X_2369_ _2369_/Q Tile_X0Y5_FrameData[4] VGND VPWR Tile_X0Y9_FrameStrobe[5] latch
X_4108_ _4108_/X Tile_X0Y6_W1END[1] Tile_X0Y6_WW4END[1] Tile_X0Y6_W6END[9] _4569_/X
+ _2668_/Q _2667_/Q VPWR VGND sg13cmos5l_mux4_1
XFILLER_405_115 VPWR VGND sg13cmos5l_decap_8
XFILLER_71_204 VPWR VGND sg13cmos5l_decap_8
XFILLER_71_215 VPWR VGND sg13cmos5l_fill_2
X_4039_ _4039_/X _4095_/X Tile_X0Y2_WW4END[7] _4094_/X AXI_M_SOC_AWREADY _1595_/Q
+ _1594_/Q VPWR VGND sg13cmos5l_mux4_1
XFILLER_112_56 VPWR VGND sg13cmos5l_decap_8
XFILLER_24_142 VPWR VGND sg13cmos5l_fill_1
XFILLER_212_221 VPWR VGND sg13cmos5l_fill_1
XFILLER_72_49 VPWR VGND sg13cmos5l_decap_8
XFILLER_708_105 VPWR VGND sg13cmos5l_decap_8
XFILLER_413_192 VPWR VGND sg13cmos5l_decap_4
XFILLER_358_225 VPWR VGND sg13cmos5l_decap_4
XFILLER_241_7 VPWR VGND sg13cmos5l_decap_8
XFILLER_339_7 VPWR VGND sg13cmos5l_decap_8
XFILLER_188_49 VPWR VGND sg13cmos5l_decap_8
XFILLER_169_147 VPWR VGND sg13cmos5l_fill_1
XFILLER_549_70 VPWR VGND sg13cmos5l_decap_8
XFILLER_574_133 VPWR VGND sg13cmos5l_decap_8
XFILLER_169_169 VPWR VGND sg13cmos5l_fill_1
XFILLER_184_106 VPWR VGND sg13cmos5l_decap_8
XFILLER_485_14 VPWR VGND sg13cmos5l_decap_8
XANTENNA__3296__X Tile_X0Y0_E2BEGb[4] VPWR VGND sg13cmos5l_antennanp
XFILLER_373_217 VPWR VGND sg13cmos5l_fill_2
XFILLER_268_82 VPWR VGND sg13cmos5l_decap_8
XFILLER_177_180 VPWR VGND sg13cmos5l_decap_8
XFILLER_506_7 VPWR VGND sg13cmos5l_decap_8
XFILLER_635_28 VPWR VGND sg13cmos5l_decap_8
XFILLER_418_63 VPWR VGND sg13cmos5l_decap_8
XFILLER_21_42 VPWR VGND sg13cmos5l_decap_8
XFILLER_125_228 VPWR VGND sg13cmos5l_fill_1
XFILLER_565_91 VPWR VGND sg13cmos5l_decap_8
XFILLER_341_114 VPWR VGND sg13cmos5l_fill_2
XFILLER_192_194 VPWR VGND sg13cmos5l_decap_8
XFILLER_137_42 VPWR VGND sg13cmos5l_decap_8
XFILLER_530_225 VPWR VGND sg13cmos5l_decap_4
XFILLER_676_218 VPWR VGND sg13cmos5l_fill_2
XFILLER_284_70 VPWR VGND sg13cmos5l_decap_8
XFILLER_341_158 VPWR VGND sg13cmos5l_decap_8
XFILLER_97_35 VPWR VGND sg13cmos5l_decap_8
XFILLER_715_83 VPWR VGND sg13cmos5l_decap_8
XFILLER_495_140 VPWR VGND sg13cmos5l_decap_8
XFILLER_239_118 VPWR VGND sg13cmos5l_decap_4
XFILLER_428_218 VPWR VGND sg13cmos5l_fill_1
XFILLER_651_49 VPWR VGND sg13cmos5l_decap_8
XFILLER_434_84 VPWR VGND sg13cmos5l_decap_8
XFILLER_644_126 VPWR VGND sg13cmos5l_decap_8
XFILLER_370_28 VPWR VGND sg13cmos5l_decap_8
XFILLER_198_0 VPWR VGND sg13cmos5l_decap_8
XFILLER_153_63 VPWR VGND sg13cmos5l_decap_8
XFILLER_365_0 VPWR VGND sg13cmos5l_decap_8
XFILLER_597_225 VPWR VGND sg13cmos5l_decap_4
XFILLER_46_83 VPWR VGND sg13cmos5l_decap_8
XFILLER_303_99 VPWR VGND sg13cmos5l_decap_8
XFILLER_262_165 VPWR VGND sg13cmos5l_decap_8
XFILLER_600_42 VPWR VGND sg13cmos5l_decap_8
XFILLER_15_120 VPWR VGND sg13cmos5l_decap_8
XFILLER_532_0 VPWR VGND sg13cmos5l_decap_8
XFILLER_404_181 VPWR VGND sg13cmos5l_decap_4
XFILLER_676_35 VPWR VGND sg13cmos5l_decap_8
XFILLER_565_133 VPWR VGND sg13cmos5l_decap_8
XFILLER_459_70 VPWR VGND sg13cmos5l_fill_2
XFILLER_175_106 VPWR VGND sg13cmos5l_fill_2
XFILLER_87_7 VPWR VGND sg13cmos5l_decap_8
XFILLER_395_14 VPWR VGND sg13cmos5l_decap_8
XFILLER_364_228 VPWR VGND sg13cmos5l_fill_1
XFILLER_317_111 VPWR VGND sg13cmos5l_decap_8
X_1740_ _1740_/Q Tile_X0Y3_FrameData[29] VGND VPWR Tile_X0Y9_FrameStrobe[2] latch
XFILLER_317_122 VPWR VGND sg13cmos5l_fill_1
XFILLER_609_84 VPWR VGND sg13cmos5l_decap_8
XFILLER_580_147 VPWR VGND sg13cmos5l_decap_8
XFILLER_317_144 VPWR VGND sg13cmos5l_decap_8
XFILLER_545_28 VPWR VGND sg13cmos5l_decap_8
XFILLER_7_77 VPWR VGND sg13cmos5l_decap_8
X_1671_ _1671_/Q Tile_X0Y2_FrameData[10] VGND VPWR Tile_X0Y9_FrameStrobe[7] latch
XFILLER_692_56 VPWR VGND sg13cmos5l_decap_8
XFILLER_328_85 VPWR VGND sg13cmos5l_decap_8
X_3410_ Tile_X0Y4_FrameData_O[1] Tile_X0Y4_FrameData[1] VPWR VGND sg13cmos5l_buf_1
X_0622_ _0622_/Q Tile_X0Y8_FrameData[17] VGND VPWR Tile_X0Y9_FrameStrobe[6] latch
X_4390_ _4390_/X Tile_X0Y5_WW4END[13] AXI_M_SOC_RRESP0 _4464_/X _4431_/X _2323_/Q
+ _2322_/Q VPWR VGND sg13cmos5l_mux4_1
XFILLER_194_70 VPWR VGND sg13cmos5l_decap_8
X_0553_ _0553_/Q Tile_X0Y8_FrameData[22] VGND VPWR Tile_X0Y9_FrameStrobe[4] latch
X_3341_ Tile_X0Y2_FrameData_O[12] Tile_X0Y2_FrameData[12] VPWR VGND sg13cmos5l_buf_1
XFILLER_486_140 VPWR VGND sg13cmos5l_decap_4
X_0484_ _0484_/Q Tile_X0Y8_FrameData[27] VGND VPWR Tile_X0Y9_FrameStrobe[2] latch
X_3272_ Tile_X0Y0_EE4BEG[8] _3828_/X VPWR VGND sg13cmos5l_buf_1
XFILLER_561_49 VPWR VGND sg13cmos5l_decap_8
XFILLER_486_173 VPWR VGND sg13cmos5l_decap_8
XFILLER_344_84 VPWR VGND sg13cmos5l_decap_8
XFILLER_635_126 VPWR VGND sg13cmos5l_decap_8
XFILLER_280_28 VPWR VGND sg13cmos5l_decap_8
X_2223_ _2223_/Q Tile_X0Y5_FrameData[22] VGND VPWR Tile_X0Y9_FrameStrobe[1] latch
X_2154_ _2154_/Q Tile_X0Y4_FrameData[27] VGND VPWR Tile_X0Y9_FrameStrobe[7] latch
XFILLER_442_221 VPWR VGND sg13cmos5l_fill_1
X_1105_ _1105_/Q Tile_X0Y0_FrameData[26] VGND VPWR Tile_X0Y9_FrameStrobe[5] latch
XFILLER_53_204 VPWR VGND sg13cmos5l_decap_8
XFILLER_213_77 VPWR VGND sg13cmos5l_decap_8
X_2085_ _2085_/Q Tile_X0Y4_FrameData[0] VGND VPWR Tile_X0Y9_FrameStrobe[4] latch
XFILLER_510_42 VPWR VGND sg13cmos5l_decap_8
X_1036_ _1036_/Q Tile_X0Y0_FrameData[31] VGND VPWR Tile_X0Y9_FrameStrobe[3] latch
XFILLER_586_35 VPWR VGND sg13cmos5l_decap_8
XFILLER_369_70 VPWR VGND sg13cmos5l_decap_8
XFILLER_410_162 VPWR VGND sg13cmos5l_decap_8
XFILLER_410_184 VPWR VGND sg13cmos5l_decap_8
XFILLER_166_117 VPWR VGND sg13cmos5l_decap_4
X_2987_ Tile_X0Y8_FrameData_O[27] Tile_X0Y8_FrameData[27] VPWR VGND sg13cmos5l_buf_1
XFILLER_355_228 VPWR VGND sg13cmos5l_fill_1
XFILLER_705_119 VPWR VGND sg13cmos5l_decap_8
X_4726_ _4726_/X _4781_/X _4780_/X AXI_M_SOC_RDATA9 AXI_M_SOC_RDATA13 _0595_/Q _0594_/Q
+ VPWR VGND sg13cmos5l_mux4_1
X_1938_ _1938_/Q Tile_X0Y4_FrameData[19] VGND VPWR Tile_X0Y9_FrameStrobe[0] latch
XFILLER_571_147 VPWR VGND sg13cmos5l_decap_8
XFILLER_181_109 VPWR VGND sg13cmos5l_decap_8
XFILLER_455_28 VPWR VGND sg13cmos5l_decap_8
XFILLER_238_63 VPWR VGND sg13cmos5l_decap_8
XFILLER_174_161 VPWR VGND sg13cmos5l_decap_4
XFILLER_107_206 VPWR VGND sg13cmos5l_decap_8
X_4657_ _4657_/X _4663_/X Tile_X0Y7_W6END[1] _4662_/X _4657_/A3 _0165_/Q _0164_/Q
+ VPWR VGND sg13cmos5l_mux4_1
X_1869_ _1869_/Q Tile_X0Y3_FrameData[28] VGND VPWR Tile_X0Y9_FrameStrobe[6] latch
XFILLER_512_203 VPWR VGND sg13cmos5l_fill_2
XFILLER_174_172 VPWR VGND sg13cmos5l_decap_8
XFILLER_469_107 VPWR VGND sg13cmos5l_decap_8
X_3608_ Tile_X0Y9_S2BEG[2] _4830_/X VPWR VGND sg13cmos5l_buf_1
XFILLER_323_136 VPWR VGND sg13cmos5l_decap_8
X_4588_ _4588_/X Tile_X0Y5_W2MID[5] Tile_X0Y5_W2END[5] Tile_X0Y5_W6END[10] _4432_/X
+ _2391_/Q _2390_/Q VPWR VGND sg13cmos5l_mux4_1
X_3539_ Tile_X0Y9_E2BEGb[5] _4861_/X VPWR VGND sg13cmos5l_buf_1
XFILLER_107_56 VPWR VGND sg13cmos5l_decap_8
XFILLER_477_162 VPWR VGND sg13cmos5l_decap_8
XFILLER_477_173 VPWR VGND sg13cmos5l_fill_2
XFILLER_471_49 VPWR VGND sg13cmos5l_decap_8
XFILLER_88_167 VPWR VGND sg13cmos5l_decap_8
XFILLER_404_21 VPWR VGND sg13cmos5l_decap_8
XFILLER_67_49 VPWR VGND sg13cmos5l_decap_8
XFILLER_190_28 VPWR VGND sg13cmos5l_decap_8
XFILLER_191_7 VPWR VGND sg13cmos5l_decap_8
XFILLER_492_154 VPWR VGND sg13cmos5l_decap_8
XFILLER_29_212 VPWR VGND sg13cmos5l_fill_1
XFILLER_289_7 VPWR VGND sg13cmos5l_decap_8
XFILLER_579_203 VPWR VGND sg13cmos5l_decap_8
XFILLER_579_214 VPWR VGND sg13cmos5l_decap_4
XFILLER_433_221 VPWR VGND sg13cmos5l_fill_1
XFILLER_701_63 VPWR VGND sg13cmos5l_decap_8
XFILLER_456_7 VPWR VGND sg13cmos5l_decap_8
XFILLER_420_42 VPWR VGND sg13cmos5l_decap_8
XFILLER_244_198 VPWR VGND sg13cmos5l_decap_8
XFILLER_16_42 VPWR VGND sg13cmos5l_decap_8
XFILLER_594_228 VPWR VGND sg13cmos5l_fill_1
XANTENNA__2923__X Tile_X0Y8_E2BEG[7] VPWR VGND sg13cmos5l_antennanp
XFILLER_623_7 VPWR VGND sg13cmos5l_decap_8
XFILLER_496_35 VPWR VGND sg13cmos5l_decap_8
XFILLER_401_140 VPWR VGND sg13cmos5l_fill_2
XFILLER_279_70 VPWR VGND sg13cmos5l_decap_8
XFILLER_12_145 VPWR VGND sg13cmos5l_fill_2
XFILLER_8_105 VPWR VGND sg13cmos5l_decap_8
XFILLER_401_184 VPWR VGND sg13cmos5l_decap_8
XFILLER_346_228 VPWR VGND sg13cmos5l_fill_1
XFILLER_32_52 VPWR VGND sg13cmos5l_decap_8
XFILLER_646_49 VPWR VGND sg13cmos5l_decap_8
XFILLER_429_84 VPWR VGND sg13cmos5l_decap_8
XFILLER_365_28 VPWR VGND sg13cmos5l_decap_8
XFILLER_148_63 VPWR VGND sg13cmos5l_decap_8
XFILLER_503_203 VPWR VGND sg13cmos5l_decap_8
XFILLER_113_0 VPWR VGND sg13cmos5l_decap_8
XANTENNA__3754__X AXI_M_SOC_ARADDR26 VPWR VGND sg13cmos5l_antennanp
XFILLER_295_91 VPWR VGND sg13cmos5l_decap_8
XFILLER_503_225 VPWR VGND sg13cmos5l_decap_4
XFILLER_314_136 VPWR VGND sg13cmos5l_decap_4
XFILLER_314_158 VPWR VGND sg13cmos5l_decap_8
XFILLER_468_140 VPWR VGND sg13cmos5l_decap_8
XFILLER_381_49 VPWR VGND sg13cmos5l_decap_8
XFILLER_267_224 VPWR VGND sg13cmos5l_decap_4
XFILLER_314_21 VPWR VGND sg13cmos5l_decap_8
XFILLER_672_221 VPWR VGND sg13cmos5l_fill_1
XFILLER_482_0 VPWR VGND sg13cmos5l_decap_8
XFILLER_617_137 VPWR VGND sg13cmos5l_fill_1
XFILLER_94_126 VPWR VGND sg13cmos5l_decap_8
XFILLER_483_154 VPWR VGND sg13cmos5l_decap_8
XFILLER_282_205 VPWR VGND sg13cmos5l_decap_8
XFILLER_57_93 VPWR VGND sg13cmos5l_fill_1
XFILLER_35_204 VPWR VGND sg13cmos5l_decap_8
XFILLER_611_63 VPWR VGND sg13cmos5l_decap_8
XFILLER_640_140 VPWR VGND sg13cmos5l_decap_8
XFILLER_330_42 VPWR VGND sg13cmos5l_decap_8
XFILLER_73_70 VPWR VGND sg13cmos5l_decap_8
XFILLER_687_56 VPWR VGND sg13cmos5l_decap_8
XFILLER_50_218 VPWR VGND sg13cmos5l_decap_8
XFILLER_396_139 VPWR VGND sg13cmos5l_decap_8
XANTENNA__2833__X Tile_X0Y6_E1BEG[2] VPWR VGND sg13cmos5l_antennanp
X_2910_ Tile_X0Y6_FrameData_O[31] Tile_X0Y6_FrameData[31] VPWR VGND sg13cmos5l_buf_1
XFILLER_250_157 VPWR VGND sg13cmos5l_decap_8
X_3890_ _3890_/X Tile_X0Y2_W2MID[6] Tile_X0Y2_W2END[6] Tile_X0Y2_W6END[6] _4099_/X
+ _1663_/Q _1662_/Q VPWR VGND sg13cmos5l_mux4_1
XFILLER_189_70 VPWR VGND sg13cmos5l_decap_8
X_2841_ Tile_X0Y6_E2BEG[6] _4502_/X VPWR VGND sg13cmos5l_buf_1
XFILLER_337_217 VPWR VGND sg13cmos5l_decap_8
XFILLER_538_177 VPWR VGND sg13cmos5l_decap_4
XFILLER_337_228 VPWR VGND sg13cmos5l_fill_1
X_2772_ Tile_X0Y3_FrameData_O[30] Tile_X0Y3_FrameData[30] VPWR VGND sg13cmos5l_buf_1
XFILLER_556_49 VPWR VGND sg13cmos5l_decap_8
X_4511_ _4511_/X Tile_X0Y6_W2END[0] AXI_M_SOC_RDATA24 _4553_/X _4552_/X _2585_/Q _2584_/Q
+ VPWR VGND sg13cmos5l_mux4_1
XANTENNA__0072__Y AXI_M_SOC_AWCACHE3 VPWR VGND sg13cmos5l_antennanp
X_1723_ _1723_/Q Tile_X0Y3_FrameData[14] VGND VPWR Tile_X0Y9_FrameStrobe[1] latch
XFILLER_275_28 VPWR VGND sg13cmos5l_decap_8
XANTENNA__3664__X AXI_M_SOC_AWADDR25 VPWR VGND sg13cmos5l_antennanp
XFILLER_156_194 VPWR VGND sg13cmos5l_decap_4
X_4442_ _4442_/X _4921_/X _4925_/X _4929_/X _4903_/X _0900_/Q _0899_/Q VPWR VGND sg13cmos5l_mux4_1
X_1654_ _1654_/Q Tile_X0Y2_FrameData[27] VGND VPWR Tile_X0Y9_FrameStrobe[7] latch
XFILLER_710_133 VPWR VGND sg13cmos5l_decap_8
X_0605_ _0605_/Q Tile_X0Y8_FrameData[2] VGND VPWR Tile_X0Y9_FrameStrobe[5] latch
XFILLER_208_77 VPWR VGND sg13cmos5l_decap_8
XFILLER_171_175 VPWR VGND sg13cmos5l_fill_2
X_4373_ _4373_/X Tile_X0Y5_W2MID[6] AXI_M_SOC_RLAST _4430_/X _4429_/X _2357_/Q _2356_/Q
+ VPWR VGND sg13cmos5l_mux4_1
X_1585_ _1585_/Q Tile_X0Y2_FrameData[0] VGND VPWR Tile_X0Y9_FrameStrobe[4] latch
XFILLER_459_151 VPWR VGND sg13cmos5l_decap_8
XFILLER_505_42 VPWR VGND sg13cmos5l_decap_8
X_3324_ Tile_X0Y4_EE4BEG[12] _4284_/X VPWR VGND sg13cmos5l_buf_1
X_0536_ _0536_/Q Tile_X0Y8_FrameData[7] VGND VPWR Tile_X0Y9_FrameStrobe[3] latch
XFILLER_291_49 VPWR VGND sg13cmos5l_decap_8
XFILLER_652_70 VPWR VGND sg13cmos5l_decap_8
XFILLER_459_195 VPWR VGND sg13cmos5l_decap_4
XFILLER_224_21 VPWR VGND sg13cmos5l_decap_8
XFILLER_474_132 VPWR VGND sg13cmos5l_fill_2
X_0467_ _0467_/Q Tile_X0Y8_FrameData[12] VGND VPWR Tile_X0Y9_FrameStrobe[1] latch
X_3255_ Tile_X0Y0_FrameData_O[23] Tile_X0Y0_FrameData[23] VPWR VGND sg13cmos5l_buf_1
X_2206_ _2206_/Q Tile_X0Y5_FrameData[7] VGND VPWR Tile_X0Y9_FrameStrobe[0] latch
X_0398_ _0398_/Q Tile_X0Y7_FrameData[17] VGND VPWR Tile_X0Y9_FrameStrobe[7] latch
X_3186_ Tile_X0Y0_N4BEG[10] _3186_/A VPWR VGND sg13cmos5l_buf_1
XFILLER_521_63 VPWR VGND sg13cmos5l_decap_8
X_2137_ _2137_/Q Tile_X0Y4_FrameData[12] VGND VPWR Tile_X0Y9_FrameStrobe[6] latch
XFILLER_240_42 VPWR VGND sg13cmos5l_decap_8
X_2068_ _2068_/Q Tile_X0Y4_FrameData[17] VGND VPWR Tile_X0Y9_FrameStrobe[4] latch
XFILLER_576_206 VPWR VGND sg13cmos5l_decap_8
XFILLER_597_56 VPWR VGND sg13cmos5l_decap_8
XANTENNA__2743__X Tile_X0Y3_FrameData_O[1] VPWR VGND sg13cmos5l_antennanp
X_1019_ _1019_/Q Tile_X0Y0_FrameData[16] VGND VPWR Tile_X0Y9_FrameStrobe[2] latch
XFILLER_529_177 VPWR VGND sg13cmos5l_fill_2
XFILLER_328_228 VPWR VGND sg13cmos5l_fill_1
XFILLER_466_49 VPWR VGND sg13cmos5l_decap_8
XFILLER_249_84 VPWR VGND sg13cmos5l_decap_8
XFILLER_147_150 VPWR VGND sg13cmos5l_fill_2
X_4709_ _4709_/X Tile_X0Y9_W2MID[3] Tile_X0Y9_W2END[3] Tile_X0Y9_W6END[3] _4906_/X
+ _0911_/Q _0910_/Q VPWR VGND sg13cmos5l_mux4_1
XFILLER_185_28 VPWR VGND sg13cmos5l_decap_8
XFILLER_5_119 VPWR VGND sg13cmos5l_fill_2
XANTENNA__3574__X Tile_X0Y9_FrameData_O[4] VPWR VGND sg13cmos5l_antennanp
XFILLER_204_7 VPWR VGND sg13cmos5l_decap_8
XFILLER_552_191 VPWR VGND sg13cmos5l_fill_1
XFILLER_698_195 VPWR VGND sg13cmos5l_fill_1
XFILLER_162_186 VPWR VGND sg13cmos5l_fill_2
XFILLER_500_217 VPWR VGND sg13cmos5l_fill_2
XFILLER_415_42 VPWR VGND sg13cmos5l_decap_8
XFILLER_249_213 VPWR VGND sg13cmos5l_decap_8
XFILLER_562_70 VPWR VGND sg13cmos5l_decap_8
XFILLER_134_21 VPWR VGND sg13cmos5l_decap_8
XANTENNA__2918__X Tile_X0Y8_E2BEG[2] VPWR VGND sg13cmos5l_antennanp
XFILLER_573_7 VPWR VGND sg13cmos5l_decap_8
XFILLER_94_14 VPWR VGND sg13cmos5l_decap_8
XFILLER_465_165 VPWR VGND sg13cmos5l_decap_8
XFILLER_712_84 VPWR VGND sg13cmos5l_decap_8
XFILLER_217_110 VPWR VGND sg13cmos5l_decap_8
XFILLER_134_98 VPWR VGND sg13cmos5l_decap_8
XFILLER_217_121 VPWR VGND sg13cmos5l_fill_2
XFILLER_91_118 VPWR VGND sg13cmos5l_decap_8
XFILLER_431_63 VPWR VGND sg13cmos5l_decap_8
XFILLER_17_215 VPWR VGND sg13cmos5l_fill_2
XFILLER_480_179 VPWR VGND sg13cmos5l_decap_8
XFILLER_27_63 VPWR VGND sg13cmos5l_decap_8
XFILLER_150_42 VPWR VGND sg13cmos5l_decap_8
XFILLER_232_113 VPWR VGND sg13cmos5l_decap_8
XFILLER_567_228 VPWR VGND sg13cmos5l_fill_1
XANTENNA__3749__X AXI_M_SOC_ARADDR21 VPWR VGND sg13cmos5l_antennanp
XFILLER_300_56 VPWR VGND sg13cmos5l_decap_8
XFILLER_230_0 VPWR VGND sg13cmos5l_decap_8
XFILLER_185_223 VPWR VGND sg13cmos5l_decap_4
XFILLER_43_84 VPWR VGND sg13cmos5l_decap_8
XFILLER_328_0 VPWR VGND sg13cmos5l_decap_8
XFILLER_376_49 VPWR VGND sg13cmos5l_decap_8
XFILLER_334_209 VPWR VGND sg13cmos5l_fill_2
XFILLER_309_21 VPWR VGND sg13cmos5l_decap_8
XFILLER_673_14 VPWR VGND sg13cmos5l_decap_8
XFILLER_138_161 VPWR VGND sg13cmos5l_decap_8
XANTENNA__3484__X Tile_X0Y1_EE4BEG[10] VPWR VGND sg13cmos5l_antennanp
XFILLER_456_71 VPWR VGND sg13cmos5l_decap_8
XFILLER_689_162 VPWR VGND sg13cmos5l_fill_1
XFILLER_488_202 VPWR VGND sg13cmos5l_decap_4
XFILLER_299_124 VPWR VGND sg13cmos5l_decap_8
XFILLER_689_184 VPWR VGND sg13cmos5l_decap_4
XFILLER_153_153 VPWR VGND sg13cmos5l_decap_8
XFILLER_153_164 VPWR VGND sg13cmos5l_fill_2
XFILLER_697_0 VPWR VGND sg13cmos5l_decap_8
XFILLER_606_63 VPWR VGND sg13cmos5l_decap_8
XFILLER_302_117 VPWR VGND sg13cmos5l_decap_8
XFILLER_4_56 VPWR VGND sg13cmos5l_decap_8
XFILLER_325_42 VPWR VGND sg13cmos5l_decap_8
X_1370_ _1370_/Q Tile_X0Y1_FrameData[31] VGND VPWR Tile_X0Y9_FrameStrobe[6] latch
XFILLER_645_210 VPWR VGND sg13cmos5l_decap_8
XFILLER_472_70 VPWR VGND sg13cmos5l_decap_8
X_0321_ _0321_/Q Tile_X0Y7_FrameData[30] VGND VPWR Tile_X0Y9_FrameStrobe[5] latch
XFILLER_68_70 VPWR VGND sg13cmos5l_decap_8
XANTENNA__2828__X Tile_X0Y4_E2BEG[6] VPWR VGND sg13cmos5l_antennanp
XFILLER_255_205 VPWR VGND sg13cmos5l_decap_8
XFILLER_310_194 VPWR VGND sg13cmos5l_fill_1
X_0252_ _0252_/Q Tile_X0Y7_FrameData[3] VGND VPWR Tile_X0Y9_FrameStrobe[2] latch
X_3040_ Tile_X0Y5_EE4BEG[15] _4403_/X VPWR VGND sg13cmos5l_buf_1
XFILLER_660_213 VPWR VGND sg13cmos5l_fill_1
XFILLER_622_84 VPWR VGND sg13cmos5l_decap_8
XFILLER_341_63 VPWR VGND sg13cmos5l_decap_8
X_0183_ _0183_/Q Tile_X0Y7_FrameData[8] VGND VPWR Tile_X0Y9_FrameStrobe[0] latch
XFILLER_208_154 VPWR VGND sg13cmos5l_decap_8
XFILLER_613_151 VPWR VGND sg13cmos5l_decap_8
XFILLER_84_91 VPWR VGND sg13cmos5l_decap_8
XFILLER_698_77 VPWR VGND sg13cmos5l_decap_8
XFILLER_412_213 VPWR VGND sg13cmos5l_decap_8
XANTENNA__3659__X AXI_M_SOC_AWADDR20 VPWR VGND sg13cmos5l_antennanp
XFILLER_558_228 VPWR VGND sg13cmos5l_fill_1
X_3942_ _3942_/X Tile_X0Y1_W2END[5] AXI_M_SOC_ARREADY _3993_/X _3992_/X _1325_/Q _1324_/Q
+ VPWR VGND sg13cmos5l_mux4_1
XFILLER_210_56 VPWR VGND sg13cmos5l_decap_8
X_3873_ _3873_/X Tile_X0Y4_W1END[2] Tile_X0Y4_WW4END[2] Tile_X0Y4_W6END[10] _4338_/X
+ _2151_/Q _2150_/Q VPWR VGND sg13cmos5l_mux4_1
X_2824_ Tile_X0Y4_E2BEG[2] _4258_/X VPWR VGND sg13cmos5l_buf_1
XFILLER_286_49 VPWR VGND sg13cmos5l_decap_8
XFILLER_717_29 VPWR VGND sg13cmos5l_fill_2
XFILLER_647_70 VPWR VGND sg13cmos5l_decap_8
XFILLER_76_0 VPWR VGND sg13cmos5l_decap_8
XFILLER_219_21 VPWR VGND sg13cmos5l_decap_8
XFILLER_392_164 VPWR VGND sg13cmos5l_decap_8
XFILLER_583_14 VPWR VGND sg13cmos5l_decap_8
X_2755_ Tile_X0Y3_FrameData_O[13] Tile_X0Y3_FrameData[13] VPWR VGND sg13cmos5l_buf_1
XANTENNA__3394__X Tile_X0Y2_E2BEGb[5] VPWR VGND sg13cmos5l_antennanp
XFILLER_333_220 VPWR VGND sg13cmos5l_decap_8
X_1706_ _1706_/Q Tile_X0Y3_FrameData[31] VGND VPWR Tile_X0Y9_FrameStrobe[1] latch
XFILLER_534_191 VPWR VGND sg13cmos5l_decap_8
XFILLER_219_98 VPWR VGND sg13cmos5l_decap_8
X_2686_ _2686_/Q Tile_X0Y6_FrameData[9] VGND VPWR Tile_X0Y9_FrameStrobe[7] latch
X_4425_ _4425_/X _4427_/X Tile_X0Y5_W6END[3] _4426_/X _4425_/A3 _2183_/Q _2440_/Q
+ VPWR VGND sg13cmos5l_mux4_1
X_1637_ _1637_/Q Tile_X0Y2_FrameData[12] VGND VPWR Tile_X0Y9_FrameStrobe[6] latch
XFILLER_516_63 VPWR VGND sg13cmos5l_decap_8
XFILLER_695_154 VPWR VGND sg13cmos5l_decap_8
XFILLER_663_91 VPWR VGND sg13cmos5l_decap_8
XFILLER_235_42 VPWR VGND sg13cmos5l_decap_8
X_4356_ _4356_/X Tile_X0Y3_W2MID[5] Tile_X0Y3_W2END[5] Tile_X0Y3_W6END[10] _4209_/X
+ _1877_/Q _1876_/Q VPWR VGND sg13cmos5l_mux4_1
X_1568_ _1568_/Q Tile_X0Y2_FrameData[17] VGND VPWR Tile_X0Y9_FrameStrobe[4] latch
XFILLER_382_70 VPWR VGND sg13cmos5l_decap_4
X_3307_ Tile_X0Y0_E2BEG[7] _3811_/X VPWR VGND sg13cmos5l_buf_1
XANTENNA__2738__X Tile_X0Y4_E1BEG[1] VPWR VGND sg13cmos5l_antennanp
X_0519_ _0519_/Q Tile_X0Y8_FrameData[24] VGND VPWR Tile_X0Y9_FrameStrobe[3] latch
XFILLER_447_143 VPWR VGND sg13cmos5l_decap_8
X_4287_ _4287_/X Tile_X0Y4_WW4END[0] AXI_M_SOC_BRESP0 _4336_/X _4313_/X _2039_/Q _2038_/Q
+ VPWR VGND sg13cmos5l_mux4_1
X_1499_ _1499_/Q Tile_X0Y2_FrameData[22] VGND VPWR Tile_X0Y9_FrameStrobe[2] latch
XFILLER_58_159 VPWR VGND sg13cmos5l_decap_8
XFILLER_246_227 VPWR VGND sg13cmos5l_fill_2
X_3238_ Tile_X0Y0_FrameData_O[6] Tile_X0Y0_FrameData[6] VPWR VGND sg13cmos5l_buf_1
XFILLER_447_198 VPWR VGND sg13cmos5l_decap_4
XFILLER_532_95 VPWR VGND sg13cmos5l_fill_2
XFILLER_104_35 VPWR VGND sg13cmos5l_decap_8
XFILLER_251_63 VPWR VGND sg13cmos5l_decap_8
X_3169_ Tile_X0Y4_E6BEG[6] _4294_/X VPWR VGND sg13cmos5l_buf_1
XFILLER_462_168 VPWR VGND sg13cmos5l_decap_8
XFILLER_64_28 VPWR VGND sg13cmos5l_decap_8
XFILLER_66_192 VPWR VGND sg13cmos5l_decap_8
XFILLER_604_162 VPWR VGND sg13cmos5l_fill_1
XFILLER_403_213 VPWR VGND sg13cmos5l_decap_8
XFILLER_549_217 VPWR VGND sg13cmos5l_decap_4
XANTENNA__3569__X Tile_X0Y9_EE4BEG[15] VPWR VGND sg13cmos5l_antennanp
XFILLER_214_168 VPWR VGND sg13cmos5l_decap_8
XFILLER_154_7 VPWR VGND sg13cmos5l_decap_8
XFILLER_120_56 VPWR VGND sg13cmos5l_decap_8
XFILLER_80_49 VPWR VGND sg13cmos5l_decap_8
XFILLER_321_7 VPWR VGND sg13cmos5l_decap_8
XFILLER_13_21 VPWR VGND sg13cmos5l_decap_8
XFILLER_517_136 VPWR VGND sg13cmos5l_fill_1
XFILLER_419_7 VPWR VGND sg13cmos5l_decap_8
XFILLER_557_70 VPWR VGND sg13cmos5l_decap_8
XFILLER_129_21 VPWR VGND sg13cmos5l_decap_8
XFILLER_493_14 VPWR VGND sg13cmos5l_decap_8
XFILLER_89_14 VPWR VGND sg13cmos5l_decap_8
XFILLER_13_98 VPWR VGND sg13cmos5l_decap_4
XFILLER_707_84 VPWR VGND sg13cmos5l_decap_8
XFILLER_135_175 VPWR VGND sg13cmos5l_decap_4
XFILLER_690_7 VPWR VGND sg13cmos5l_decap_8
XFILLER_643_28 VPWR VGND sg13cmos5l_decap_8
XFILLER_426_63 VPWR VGND sg13cmos5l_decap_8
XFILLER_540_161 VPWR VGND sg13cmos5l_decap_8
XFILLER_296_105 VPWR VGND sg13cmos5l_fill_2
XFILLER_573_91 VPWR VGND sg13cmos5l_decap_8
XFILLER_145_42 VPWR VGND sg13cmos5l_decap_8
XFILLER_292_70 VPWR VGND sg13cmos5l_decap_8
XFILLER_438_165 VPWR VGND sg13cmos5l_fill_2
XFILLER_442_84 VPWR VGND sg13cmos5l_decap_8
XFILLER_599_128 VPWR VGND sg13cmos5l_fill_2
XFILLER_180_0 VPWR VGND sg13cmos5l_decap_8
XFILLER_278_0 VPWR VGND sg13cmos5l_decap_8
XFILLER_453_157 VPWR VGND sg13cmos5l_fill_1
XFILLER_161_63 VPWR VGND sg13cmos5l_decap_8
XFILLER_668_14 VPWR VGND sg13cmos5l_decap_8
XFILLER_610_121 VPWR VGND sg13cmos5l_fill_1
XANTENNA__3479__X Tile_X0Y1_EE4BEG[5] VPWR VGND sg13cmos5l_antennanp
XFILLER_445_0 VPWR VGND sg13cmos5l_decap_8
XFILLER_311_77 VPWR VGND sg13cmos5l_decap_8
XFILLER_610_143 VPWR VGND sg13cmos5l_fill_1
XFILLER_205_168 VPWR VGND sg13cmos5l_decap_4
XFILLER_220_105 VPWR VGND sg13cmos5l_decap_8
XFILLER_610_165 VPWR VGND sg13cmos5l_decap_4
XFILLER_54_94 VPWR VGND sg13cmos5l_decap_4
XFILLER_158_212 VPWR VGND sg13cmos5l_decap_8
XFILLER_612_0 VPWR VGND sg13cmos5l_decap_8
XFILLER_359_194 VPWR VGND sg13cmos5l_decap_8
X_0870_ _0870_/Q Tile_X0Y9_FrameData[25] VGND VPWR Tile_X0Y9_FrameStrobe[6] latch
XFILLER_508_147 VPWR VGND sg13cmos5l_decap_4
XFILLER_684_35 VPWR VGND sg13cmos5l_decap_8
XFILLER_508_158 VPWR VGND sg13cmos5l_decap_8
XFILLER_307_209 VPWR VGND sg13cmos5l_decap_8
XFILLER_712_217 VPWR VGND sg13cmos5l_fill_2
X_2540_ _2540_/Q Tile_X0Y6_FrameData[27] VGND VPWR Tile_X0Y9_FrameStrobe[3] latch
XFILLER_617_84 VPWR VGND sg13cmos5l_decap_8
XFILLER_553_28 VPWR VGND sg13cmos5l_decap_8
XFILLER_531_150 VPWR VGND sg13cmos5l_decap_8
XFILLER_336_63 VPWR VGND sg13cmos5l_decap_8
X_2471_ _2471_/Q Tile_X0Y6_FrameData[0] VGND VPWR Tile_X0Y9_FrameStrobe[0] latch
XFILLER_141_112 VPWR VGND sg13cmos5l_decap_8
XFILLER_287_105 VPWR VGND sg13cmos5l_decap_8
XFILLER_483_91 VPWR VGND sg13cmos5l_decap_8
X_4210_ _4210_/X _4137_/X _4245_/X _4244_/X _4136_/X _1689_/Q _1688_/Q VPWR VGND sg13cmos5l_mux4_1
X_1422_ _1422_/Q Tile_X0Y1_FrameData[11] VGND VPWR Tile_X0Y9_FrameStrobe[7] latch
XFILLER_476_227 VPWR VGND sg13cmos5l_fill_2
XFILLER_79_91 VPWR VGND sg13cmos5l_decap_4
XFILLER_692_135 VPWR VGND sg13cmos5l_decap_8
XFILLER_141_189 VPWR VGND sg13cmos5l_decap_8
X_4141_ _4141_/X Tile_X0Y4_W2MID[1] Tile_X0Y4_W2END[1] Tile_X0Y4_W6END[1] _4314_/X
+ _2161_/Q _2160_/Q VPWR VGND sg13cmos5l_mux4_1
X_1353_ _1353_/Q Tile_X0Y1_FrameData[16] VGND VPWR Tile_X0Y9_FrameStrobe[5] latch
XFILLER_429_154 VPWR VGND sg13cmos5l_decap_8
XFILLER_228_216 VPWR VGND sg13cmos5l_fill_1
XFILLER_205_56 VPWR VGND sg13cmos5l_decap_8
X_0304_ _0304_/Q Tile_X0Y7_FrameData[15] VGND VPWR Tile_X0Y9_FrameStrobe[4] latch
X_4072_ _4072_/X _0079_/X Tile_X0Y0_S4END[8] _4127_/X _4104_/X _1529_/Q _1528_/Q VPWR
+ VGND sg13cmos5l_mux4_1
X_1284_ _1284_/Q Tile_X0Y1_FrameData[21] VGND VPWR Tile_X0Y9_FrameStrobe[3] latch
XFILLER_352_84 VPWR VGND sg13cmos5l_decap_8
XFILLER_502_21 VPWR VGND sg13cmos5l_decap_8
XFILLER_444_135 VPWR VGND sg13cmos5l_decap_4
XFILLER_55_118 VPWR VGND sg13cmos5l_decap_8
X_3023_ Tile_X0Y5_E6BEG[10] _4414_/X VPWR VGND sg13cmos5l_buf_1
X_0235_ _0235_/Q Tile_X0Y7_FrameData[20] VGND VPWR Tile_X0Y9_FrameStrobe[2] latch
X_0166_ _0166_/Q Tile_X0Y7_FrameData[25] VGND VPWR Tile_X0Y9_FrameStrobe[0] latch
XFILLER_502_98 VPWR VGND sg13cmos5l_decap_8
XFILLER_578_14 VPWR VGND sg13cmos5l_decap_8
XANTENNA__3389__X Tile_X0Y2_E2BEGb[0] VPWR VGND sg13cmos5l_antennanp
XFILLER_397_223 VPWR VGND sg13cmos5l_decap_4
XFILLER_601_121 VPWR VGND sg13cmos5l_decap_8
XFILLER_221_77 VPWR VGND sg13cmos5l_decap_8
X_0097_ _0097_/X _4449_/X _4450_/X _0892_/Q VPWR VGND sg13cmos5l_mux2_1
XFILLER_63_195 VPWR VGND sg13cmos5l_decap_8
XFILLER_211_105 VPWR VGND sg13cmos5l_decap_8
XFILLER_546_209 VPWR VGND sg13cmos5l_fill_1
XFILLER_400_227 VPWR VGND sg13cmos5l_fill_2
X_3925_ _3925_/X _4227_/X _4231_/X _4235_/X _4207_/X _1898_/Q _1897_/Q VPWR VGND sg13cmos5l_mux4_1
XFILLER_211_149 VPWR VGND sg13cmos5l_decap_8
XFILLER_658_91 VPWR VGND sg13cmos5l_decap_8
XFILLER_365_131 VPWR VGND sg13cmos5l_fill_2
X_3856_ _3856_/X _3899_/X _3898_/X Tile_X0Y0_S2MID[5] Tile_X0Y0_S2END[5] _0953_/Q
+ _0952_/Q VPWR VGND sg13cmos5l_mux4_1
XFILLER_594_35 VPWR VGND sg13cmos5l_decap_8
XFILLER_377_70 VPWR VGND sg13cmos5l_decap_8
X_2807_ Tile_X0Y3_E2BEGb[5] _4161_/X VPWR VGND sg13cmos5l_buf_1
X_3787_ _3787_/X Tile_X0Y0_W2MID[4] Tile_X0Y0_W2END[4] Tile_X0Y0_W6END[4] _3859_/X
+ _1163_/Q _1162_/Q VPWR VGND sg13cmos5l_mux4_1
XFILLER_514_117 VPWR VGND sg13cmos5l_decap_8
XFILLER_380_112 VPWR VGND sg13cmos5l_decap_8
X_0999_ _0999_/Q Tile_X0Y0_FrameData[4] VGND VPWR Tile_X0Y9_FrameStrobe[1] latch
XFILLER_365_197 VPWR VGND sg13cmos5l_fill_1
XFILLER_117_131 VPWR VGND sg13cmos5l_decap_8
X_2738_ Tile_X0Y4_E1BEG[1] _4253_/X VPWR VGND sg13cmos5l_buf_1
XFILLER_380_156 VPWR VGND sg13cmos5l_fill_2
XFILLER_463_28 VPWR VGND sg13cmos5l_decap_8
XFILLER_321_201 VPWR VGND sg13cmos5l_decap_8
XFILLER_246_63 VPWR VGND sg13cmos5l_decap_8
XFILLER_132_112 VPWR VGND sg13cmos5l_decap_8
X_2669_ _2669_/Q Tile_X0Y6_FrameData[26] VGND VPWR Tile_X0Y9_FrameStrobe[7] latch
XFILLER_278_105 VPWR VGND sg13cmos5l_decap_8
XFILLER_246_74 VPWR VGND sg13cmos5l_fill_2
X_4408_ _4408_/X AXI_M_SOC_RVALID _4458_/X _4462_/X _4467_/X _2287_/Q _2286_/Q VPWR
+ VGND sg13cmos5l_mux4_1
X_4339_ _4339_/X _4311_/X _0040_/X _4310_/X _0109_/X _1975_/Q _1974_/Q VPWR VGND sg13cmos5l_mux4_1
XFILLER_482_219 VPWR VGND sg13cmos5l_decap_8
XFILLER_293_119 VPWR VGND sg13cmos5l_decap_4
XFILLER_115_56 VPWR VGND sg13cmos5l_decap_8
XFILLER_286_182 VPWR VGND sg13cmos5l_decap_8
XFILLER_75_49 VPWR VGND sg13cmos5l_decap_8
XFILLER_271_7 VPWR VGND sg13cmos5l_decap_8
XFILLER_234_208 VPWR VGND sg13cmos5l_fill_1
XFILLER_435_168 VPWR VGND sg13cmos5l_decap_8
XFILLER_412_54 VPWR VGND sg13cmos5l_decap_8
XFILLER_39_192 VPWR VGND sg13cmos5l_decap_8
XFILLER_369_7 VPWR VGND sg13cmos5l_decap_8
XFILLER_488_14 VPWR VGND sg13cmos5l_decap_8
XFILLER_412_98 VPWR VGND sg13cmos5l_fill_1
XFILLER_199_112 VPWR VGND sg13cmos5l_decap_8
XFILLER_450_149 VPWR VGND sg13cmos5l_fill_1
XFILLER_199_123 VPWR VGND sg13cmos5l_fill_2
XANTENNA__3299__X Tile_X0Y0_E2BEGb[7] VPWR VGND sg13cmos5l_antennanp
XFILLER_54_173 VPWR VGND sg13cmos5l_decap_8
XFILLER_131_77 VPWR VGND sg13cmos5l_decap_8
XFILLER_536_7 VPWR VGND sg13cmos5l_decap_8
XFILLER_202_105 VPWR VGND sg13cmos5l_decap_8
XFILLER_199_167 VPWR VGND sg13cmos5l_decap_8
XFILLER_638_28 VPWR VGND sg13cmos5l_decap_8
XFILLER_24_42 VPWR VGND sg13cmos5l_decap_8
XFILLER_568_91 VPWR VGND sg13cmos5l_decap_8
XANTENNA__2931__X Tile_X0Y8_E2BEGb[7] VPWR VGND sg13cmos5l_antennanp
XFILLER_703_7 VPWR VGND sg13cmos5l_decap_8
XFILLER_287_70 VPWR VGND sg13cmos5l_decap_8
XFILLER_210_182 VPWR VGND sg13cmos5l_decap_8
XFILLER_560_201 VPWR VGND sg13cmos5l_fill_2
XFILLER_356_175 VPWR VGND sg13cmos5l_decap_8
XFILLER_210_193 VPWR VGND sg13cmos5l_fill_2
XFILLER_371_112 VPWR VGND sg13cmos5l_decap_8
XFILLER_108_131 VPWR VGND sg13cmos5l_decap_8
XFILLER_108_142 VPWR VGND sg13cmos5l_decap_8
XFILLER_654_49 VPWR VGND sg13cmos5l_decap_8
XFILLER_40_63 VPWR VGND sg13cmos5l_decap_8
XFILLER_437_84 VPWR VGND sg13cmos5l_decap_8
XFILLER_108_153 VPWR VGND sg13cmos5l_fill_1
XFILLER_371_189 VPWR VGND sg13cmos5l_decap_8
XFILLER_373_28 VPWR VGND sg13cmos5l_decap_8
XFILLER_156_63 VPWR VGND sg13cmos5l_decap_8
XFILLER_659_154 VPWR VGND sg13cmos5l_decap_4
XFILLER_269_105 VPWR VGND sg13cmos5l_decap_8
XFILLER_6_0 VPWR VGND sg13cmos5l_decap_8
XFILLER_123_145 VPWR VGND sg13cmos5l_fill_1
XFILLER_395_0 VPWR VGND sg13cmos5l_decap_8
XFILLER_306_77 VPWR VGND sg13cmos5l_decap_8
XFILLER_284_119 VPWR VGND sg13cmos5l_decap_8
XFILLER_603_42 VPWR VGND sg13cmos5l_decap_8
XFILLER_49_94 VPWR VGND sg13cmos5l_fill_2
XFILLER_277_193 VPWR VGND sg13cmos5l_fill_1
XFILLER_92_202 VPWR VGND sg13cmos5l_fill_1
XFILLER_562_0 VPWR VGND sg13cmos5l_decap_8
XFILLER_322_21 VPWR VGND sg13cmos5l_decap_8
XFILLER_1_35 VPWR VGND sg13cmos5l_decap_8
XFILLER_426_168 VPWR VGND sg13cmos5l_decap_8
XFILLER_679_35 VPWR VGND sg13cmos5l_decap_8
XFILLER_398_14 VPWR VGND sg13cmos5l_decap_8
XFILLER_595_120 VPWR VGND sg13cmos5l_decap_4
XFILLER_60_121 VPWR VGND sg13cmos5l_fill_1
XANTENNA__3002__X Tile_X0Y5_E2BEG[5] VPWR VGND sg13cmos5l_antennanp
XFILLER_548_28 VPWR VGND sg13cmos5l_decap_8
X_1971_ _1971_/Q Tile_X0Y4_FrameData[18] VGND VPWR Tile_X0Y9_FrameStrobe[1] latch
XFILLER_695_56 VPWR VGND sg13cmos5l_decap_8
XANTENNA__2841__X Tile_X0Y6_E2BEG[6] VPWR VGND sg13cmos5l_antennanp
X_3710_ AXI_M_SOC_WDATA20 Tile_X0Y6_WW4END[4] Tile_X0Y6_WW4END[12] Tile_X0Y6_W6END[4]
+ _4572_/X _2519_/Q _2518_/Q VPWR VGND sg13cmos5l_mux4_1
X_0922_ _0922_/Q Tile_X0Y9_FrameData[5] VGND VPWR Tile_X0Y9_FrameStrobe[7] latch
X_4690_ _4690_/X _4665_/X Tile_X0Y9_N4END[10] _4664_/X _0054_/X _0203_/Q _0202_/Q
+ VPWR VGND sg13cmos5l_mux4_1
XFILLER_197_70 VPWR VGND sg13cmos5l_decap_8
XFILLER_628_61 VPWR VGND sg13cmos5l_decap_8
X_3641_ AXI_M_SOC_AWADDR2 Tile_X0Y5_WW4END[2] Tile_X0Y5_WW4END[10] Tile_X0Y5_W6END[2]
+ _4453_/X _2267_/Q _2266_/Q VPWR VGND sg13cmos5l_mux4_1
X_0853_ _0853_/Q Tile_X0Y9_FrameData[10] VGND VPWR Tile_X0Y9_FrameStrobe[5] latch
XFILLER_362_112 VPWR VGND sg13cmos5l_decap_8
XFILLER_551_223 VPWR VGND sg13cmos5l_decap_4
X_3572_ Tile_X0Y9_FrameData_O[2] Tile_X0Y9_FrameData[2] VPWR VGND sg13cmos5l_buf_1
XFILLER_564_49 VPWR VGND sg13cmos5l_decap_8
X_0784_ _0784_/Q Tile_X0Y9_FrameData[15] VGND VPWR Tile_X0Y9_FrameStrobe[3] latch
XFILLER_347_84 VPWR VGND sg13cmos5l_decap_8
X_2523_ _2523_/Q Tile_X0Y6_FrameData[12] VGND VPWR Tile_X0Y9_FrameStrobe[2] latch
XFILLER_362_189 VPWR VGND sg13cmos5l_fill_1
XFILLER_283_28 VPWR VGND sg13cmos5l_decap_8
XFILLER_114_112 VPWR VGND sg13cmos5l_decap_8
XFILLER_504_194 VPWR VGND sg13cmos5l_decap_8
XFILLER_114_145 VPWR VGND sg13cmos5l_fill_2
XFILLER_449_227 VPWR VGND sg13cmos5l_fill_2
X_2454_ _2454_/Q Tile_X0Y6_FrameData[17] VGND VPWR Tile_X0Y9_FrameStrobe[0] latch
XFILLER_39_0 VPWR VGND sg13cmos5l_fill_1
X_1405_ _1405_/Q Tile_X0Y1_FrameData[28] VGND VPWR Tile_X0Y9_FrameStrobe[7] latch
XFILLER_216_77 VPWR VGND sg13cmos5l_decap_8
X_2385_ _2385_/Q Tile_X0Y5_FrameData[20] VGND VPWR Tile_X0Y9_FrameStrobe[6] latch
XFILLER_275_119 VPWR VGND sg13cmos5l_decap_8
XFILLER_513_42 VPWR VGND sg13cmos5l_decap_8
X_4124_ _4124_/X _4089_/X _0079_/X _4088_/X Tile_X0Y0_S4END[8] _1465_/Q _1464_/Q VPWR
+ VGND sg13cmos5l_mux4_1
X_1336_ _1336_/Q Tile_X0Y1_FrameData[1] VGND VPWR Tile_X0Y9_FrameStrobe[4] latch
XFILLER_660_70 VPWR VGND sg13cmos5l_decap_8
XFILLER_232_21 VPWR VGND sg13cmos5l_decap_8
XFILLER_417_157 VPWR VGND sg13cmos5l_fill_2
X_4055_ _4055_/X Tile_X0Y2_W2END[0] AXI_M_SOC_AWREADY _4097_/X _4096_/X _1563_/Q _1562_/Q
+ VPWR VGND sg13cmos5l_mux4_1
X_1267_ _1267_/Q Tile_X0Y1_FrameData[6] VGND VPWR Tile_X0Y9_FrameStrobe[2] latch
XFILLER_621_205 VPWR VGND sg13cmos5l_fill_2
XFILLER_589_35 VPWR VGND sg13cmos5l_decap_8
XFILLER_432_105 VPWR VGND sg13cmos5l_decap_8
X_3006_ Tile_X0Y5_E2BEGb[1] _4381_/X VPWR VGND sg13cmos5l_buf_1
XFILLER_283_196 VPWR VGND sg13cmos5l_decap_8
X_0218_ _0218_/Q Tile_X0Y7_FrameData[5] VGND VPWR Tile_X0Y9_FrameStrobe[1] latch
X_1198_ _1198_/Q Tile_X0Y1_FrameData[11] VGND VPWR Tile_X0Y9_FrameStrobe[0] latch
XFILLER_51_110 VPWR VGND sg13cmos5l_decap_8
XFILLER_101_14 VPWR VGND sg13cmos5l_decap_8
X_0149_ AXI_M_SOC_AWLEN1 _0940_/Q _3672_/X VPWR VGND sg13cmos5l_nor2b_1
XFILLER_586_164 VPWR VGND sg13cmos5l_fill_1
XFILLER_458_28 VPWR VGND sg13cmos5l_decap_8
XFILLER_586_186 VPWR VGND sg13cmos5l_fill_2
XANTENNA__2751__X Tile_X0Y3_FrameData_O[9] VPWR VGND sg13cmos5l_antennanp
X_3908_ _3908_/X Tile_X0Y1_W1END[1] Tile_X0Y1_WW4END[1] Tile_X0Y1_W6END[9] _4009_/X
+ _1398_/Q _1397_/Q VPWR VGND sg13cmos5l_mux4_1
X_4888_ _4888_/X AXI_M_SOC_RDATA4 _4919_/X _4923_/X _4906_/X _0767_/Q _0766_/Q VPWR
+ VGND sg13cmos5l_mux4_1
XFILLER_338_164 VPWR VGND sg13cmos5l_fill_2
X_3839_ _3839_/X _0078_/X Tile_X0Y0_S4END[3] _3876_/X _3875_/X _1027_/Q _1026_/Q VPWR
+ VGND sg13cmos5l_mux4_1
XFILLER_499_105 VPWR VGND sg13cmos5l_decap_8
XFILLER_353_112 VPWR VGND sg13cmos5l_decap_8
XFILLER_117_7 VPWR VGND sg13cmos5l_decap_8
XFILLER_474_49 VPWR VGND sg13cmos5l_decap_8
XFILLER_407_21 VPWR VGND sg13cmos5l_decap_8
XFILLER_353_189 VPWR VGND sg13cmos5l_decap_8
XFILLER_193_28 VPWR VGND sg13cmos5l_decap_8
XFILLER_3_228 VPWR VGND sg13cmos5l_fill_1
XANTENNA__3582__X Tile_X0Y9_FrameData_O[12] VPWR VGND sg13cmos5l_antennanp
XFILLER_10_77 VPWR VGND sg13cmos5l_decap_8
XFILLER_126_77 VPWR VGND sg13cmos5l_decap_8
XFILLER_704_63 VPWR VGND sg13cmos5l_decap_8
XFILLER_486_7 VPWR VGND sg13cmos5l_decap_8
XFILLER_423_42 VPWR VGND sg13cmos5l_decap_8
XFILLER_408_113 VPWR VGND sg13cmos5l_decap_8
XFILLER_19_42 VPWR VGND sg13cmos5l_decap_8
XFILLER_570_70 VPWR VGND sg13cmos5l_decap_8
XFILLER_142_21 VPWR VGND sg13cmos5l_decap_8
XANTENNA__2926__X Tile_X0Y8_E2BEGb[2] VPWR VGND sg13cmos5l_antennanp
XFILLER_653_7 VPWR VGND sg13cmos5l_decap_8
XFILLER_423_105 VPWR VGND sg13cmos5l_decap_8
XFILLER_499_35 VPWR VGND sg13cmos5l_decap_8
XFILLER_142_98 VPWR VGND sg13cmos5l_decap_8
XFILLER_649_49 VPWR VGND sg13cmos5l_decap_8
XFILLER_35_63 VPWR VGND sg13cmos5l_decap_8
XFILLER_187_104 VPWR VGND sg13cmos5l_decap_8
XFILLER_431_182 VPWR VGND sg13cmos5l_decap_4
XFILLER_577_175 VPWR VGND sg13cmos5l_decap_8
XFILLER_42_165 VPWR VGND sg13cmos5l_fill_2
XFILLER_376_226 VPWR VGND sg13cmos5l_fill_2
XFILLER_368_28 VPWR VGND sg13cmos5l_decap_8
XFILLER_143_0 VPWR VGND sg13cmos5l_decap_8
XANTENNA__3757__X AXI_M_SOC_ARADDR29 VPWR VGND sg13cmos5l_antennanp
XFILLER_329_131 VPWR VGND sg13cmos5l_decap_8
XFILLER_329_175 VPWR VGND sg13cmos5l_decap_4
XFILLER_195_170 VPWR VGND sg13cmos5l_decap_8
XFILLER_51_62 VPWR VGND sg13cmos5l_decap_8
XFILLER_344_112 VPWR VGND sg13cmos5l_decap_8
XFILLER_310_0 VPWR VGND sg13cmos5l_decap_8
XFILLER_408_0 VPWR VGND sg13cmos5l_decap_8
XFILLER_384_49 VPWR VGND sg13cmos5l_decap_8
XFILLER_317_21 VPWR VGND sg13cmos5l_decap_8
XFILLER_344_189 VPWR VGND sg13cmos5l_decap_8
XFILLER_681_14 VPWR VGND sg13cmos5l_decap_8
XANTENNA__3492__X Tile_X0Y1_E6BEG[2] VPWR VGND sg13cmos5l_antennanp
XFILLER_498_182 VPWR VGND sg13cmos5l_decap_8
XFILLER_111_115 VPWR VGND sg13cmos5l_decap_8
XFILLER_501_175 VPWR VGND sg13cmos5l_decap_8
XFILLER_300_215 VPWR VGND sg13cmos5l_fill_2
XFILLER_111_126 VPWR VGND sg13cmos5l_fill_2
XFILLER_647_168 VPWR VGND sg13cmos5l_decap_8
XFILLER_614_63 VPWR VGND sg13cmos5l_decap_8
XFILLER_662_105 VPWR VGND sg13cmos5l_decap_8
XFILLER_333_42 VPWR VGND sg13cmos5l_decap_8
X_2170_ _2170_/Q Tile_X0Y4_FrameData[11] VGND VPWR Tile_X0Y9_FrameStrobe[7] latch
XFILLER_480_70 VPWR VGND sg13cmos5l_decap_4
XFILLER_76_70 VPWR VGND sg13cmos5l_decap_8
X_1121_ _1121_/Q Tile_X0Y0_FrameData[10] VGND VPWR Tile_X0Y9_FrameStrobe[5] latch
XANTENNA__2836__X Tile_X0Y6_E2BEG[1] VPWR VGND sg13cmos5l_antennanp
X_1052_ _1052_/Q Tile_X0Y0_FrameData[15] VGND VPWR Tile_X0Y9_FrameStrobe[3] latch
XFILLER_670_182 VPWR VGND sg13cmos5l_fill_2
XFILLER_280_133 VPWR VGND sg13cmos5l_decap_8
XFILLER_630_84 VPWR VGND sg13cmos5l_decap_8
XFILLER_202_35 VPWR VGND sg13cmos5l_decap_8
XFILLER_559_49 VPWR VGND sg13cmos5l_decap_8
X_4811_ _4811_/X _4783_/X Tile_X0Y9_N4END[7] _4782_/X _0074_/X _0449_/Q _0448_/Q VPWR
+ VGND sg13cmos5l_mux4_1
XFILLER_422_182 VPWR VGND sg13cmos5l_decap_8
XFILLER_717_106 VPWR VGND sg13cmos5l_fill_2
XFILLER_568_175 VPWR VGND sg13cmos5l_decap_4
XFILLER_33_165 VPWR VGND sg13cmos5l_fill_1
XFILLER_278_28 VPWR VGND sg13cmos5l_decap_8
XFILLER_367_226 VPWR VGND sg13cmos5l_fill_2
XFILLER_583_112 VPWR VGND sg13cmos5l_decap_8
XFILLER_583_123 VPWR VGND sg13cmos5l_fill_2
XFILLER_178_148 VPWR VGND sg13cmos5l_decap_4
XANTENNA__3667__X AXI_M_SOC_AWADDR28 VPWR VGND sg13cmos5l_antennanp
XFILLER_717_139 VPWR VGND sg13cmos5l_decap_8
X_4742_ _4742_/X Tile_X0Y8_W2END[1] AXI_M_SOC_RDATA9 _4787_/X _4786_/X _0563_/Q _0562_/Q
+ VPWR VGND sg13cmos5l_mux4_1
X_1954_ _1954_/Q Tile_X0Y4_FrameData[3] VGND VPWR Tile_X0Y9_FrameStrobe[0] latch
XFILLER_583_167 VPWR VGND sg13cmos5l_decap_8
XFILLER_193_118 VPWR VGND sg13cmos5l_decap_8
X_0905_ _0905_/Q Tile_X0Y9_FrameData[22] VGND VPWR Tile_X0Y9_FrameStrobe[7] latch
X_4673_ _4673_/X _4589_/X _4705_/X _4704_/X _4588_/X _0179_/Q _0178_/Q VPWR VGND sg13cmos5l_mux4_1
X_1885_ _1885_/Q Tile_X0Y3_FrameData[12] VGND VPWR Tile_X0Y9_FrameStrobe[6] latch
XFILLER_186_192 VPWR VGND sg13cmos5l_decap_8
X_3624_ Tile_X0Y9_S4BEG[2] _3624_/A VPWR VGND sg13cmos5l_buf_1
XFILLER_508_42 VPWR VGND sg13cmos5l_decap_8
XFILLER_335_145 VPWR VGND sg13cmos5l_decap_8
X_0836_ _0836_/Q Tile_X0Y9_FrameData[27] VGND VPWR Tile_X0Y9_FrameStrobe[5] latch
XFILLER_294_49 VPWR VGND sg13cmos5l_decap_8
XFILLER_134_207 VPWR VGND sg13cmos5l_decap_4
XFILLER_655_70 VPWR VGND sg13cmos5l_decap_8
XFILLER_227_21 VPWR VGND sg13cmos5l_decap_8
X_3555_ Tile_X0Y9_EE4BEG[1] _4865_/X VPWR VGND sg13cmos5l_buf_1
XFILLER_685_208 VPWR VGND sg13cmos5l_decap_8
XFILLER_591_14 VPWR VGND sg13cmos5l_decap_8
XFILLER_350_126 VPWR VGND sg13cmos5l_decap_8
X_0767_ _0767_/Q Tile_X0Y9_FrameData[0] VGND VPWR Tile_X0Y9_FrameStrobe[2] latch
XFILLER_496_119 VPWR VGND sg13cmos5l_decap_8
X_2506_ _2506_/Q Tile_X0Y6_FrameData[29] VGND VPWR Tile_X0Y9_FrameStrobe[2] latch
XFILLER_489_182 VPWR VGND sg13cmos5l_decap_8
X_3486_ Tile_X0Y1_EE4BEG[12] _3960_/X VPWR VGND sg13cmos5l_buf_1
XFILLER_227_98 VPWR VGND sg13cmos5l_decap_8
X_0698_ _0698_/Q Tile_X0Y9_FrameData[5] VGND VPWR Tile_X0Y9_FrameStrobe[0] latch
X_2437_ _2437_/Q Tile_X0Y5_FrameData[0] VGND VPWR Tile_X0Y9_FrameStrobe[7] latch
XFILLER_524_63 VPWR VGND sg13cmos5l_decap_8
XFILLER_102_126 VPWR VGND sg13cmos5l_decap_8
XFILLER_102_137 VPWR VGND sg13cmos5l_fill_2
XFILLER_653_105 VPWR VGND sg13cmos5l_decap_8
XFILLER_671_91 VPWR VGND sg13cmos5l_fill_1
XFILLER_243_42 VPWR VGND sg13cmos5l_decap_8
X_2368_ _2368_/Q Tile_X0Y5_FrameData[5] VGND VPWR Tile_X0Y9_FrameStrobe[5] latch
XFILLER_390_70 VPWR VGND sg13cmos5l_decap_8
XFILLER_243_86 VPWR VGND sg13cmos5l_fill_1
X_4107_ _4107_/X _4093_/X _0057_/X _4092_/X Tile_X0Y0_S4END[10] _1453_/Q _1452_/Q
+ VPWR VGND sg13cmos5l_mux4_1
XFILLER_110_170 VPWR VGND sg13cmos5l_decap_8
XANTENNA__2746__X Tile_X0Y3_FrameData_O[4] VPWR VGND sg13cmos5l_antennanp
X_1319_ _1319_/Q Tile_X0Y1_FrameData[18] VGND VPWR Tile_X0Y9_FrameStrobe[4] latch
XFILLER_271_100 VPWR VGND sg13cmos5l_fill_1
X_2299_ _2299_/Q Tile_X0Y5_FrameData[10] VGND VPWR Tile_X0Y9_FrameStrobe[3] latch
X_4038_ _4038_/X _4093_/X Tile_X0Y2_WW4END[6] _4092_/X AXI_M_SOC_AWREADY _1597_/Q
+ _1596_/Q VPWR VGND sg13cmos5l_mux4_1
XFILLER_540_84 VPWR VGND sg13cmos5l_decap_8
XFILLER_112_35 VPWR VGND sg13cmos5l_decap_8
XFILLER_24_121 VPWR VGND sg13cmos5l_decap_8
XFILLER_72_28 VPWR VGND sg13cmos5l_decap_8
XFILLER_469_49 VPWR VGND sg13cmos5l_decap_8
XFILLER_188_28 VPWR VGND sg13cmos5l_decap_8
XFILLER_574_112 VPWR VGND sg13cmos5l_decap_8
XFILLER_559_197 VPWR VGND sg13cmos5l_fill_2
XANTENNA__3577__X Tile_X0Y9_FrameData_O[7] VPWR VGND sg13cmos5l_antennanp
XFILLER_234_7 VPWR VGND sg13cmos5l_decap_8
XFILLER_268_61 VPWR VGND sg13cmos5l_decap_8
XFILLER_574_189 VPWR VGND sg13cmos5l_decap_8
XANTENNA_50 Tile_X0Y9_N2MID[2] VPWR VGND sg13cmos5l_antennanp
XFILLER_716_172 VPWR VGND sg13cmos5l_decap_8
XFILLER_716_183 VPWR VGND sg13cmos5l_fill_2
XFILLER_418_42 VPWR VGND sg13cmos5l_decap_8
XFILLER_401_7 VPWR VGND sg13cmos5l_decap_8
XFILLER_21_21 VPWR VGND sg13cmos5l_decap_8
XFILLER_565_70 VPWR VGND sg13cmos5l_decap_8
XFILLER_326_167 VPWR VGND sg13cmos5l_decap_4
XFILLER_137_21 VPWR VGND sg13cmos5l_decap_8
XFILLER_192_173 VPWR VGND sg13cmos5l_decap_8
XFILLER_487_119 VPWR VGND sg13cmos5l_decap_8
XFILLER_97_14 VPWR VGND sg13cmos5l_decap_8
XFILLER_137_98 VPWR VGND sg13cmos5l_decap_8
XFILLER_651_28 VPWR VGND sg13cmos5l_decap_8
XFILLER_434_63 VPWR VGND sg13cmos5l_decap_8
XFILLER_644_105 VPWR VGND sg13cmos5l_decap_8
XFILLER_581_91 VPWR VGND sg13cmos5l_decap_8
XFILLER_495_196 VPWR VGND sg13cmos5l_decap_4
XFILLER_153_42 VPWR VGND sg13cmos5l_decap_8
XFILLER_247_185 VPWR VGND sg13cmos5l_decap_8
XFILLER_303_56 VPWR VGND sg13cmos5l_decap_8
XFILLER_652_182 VPWR VGND sg13cmos5l_decap_8
XFILLER_46_62 VPWR VGND sg13cmos5l_decap_8
XFILLER_262_144 VPWR VGND sg13cmos5l_decap_8
XFILLER_600_21 VPWR VGND sg13cmos5l_decap_8
XFILLER_260_0 VPWR VGND sg13cmos5l_decap_8
XFILLER_358_0 VPWR VGND sg13cmos5l_decap_8
XFILLER_379_49 VPWR VGND sg13cmos5l_decap_8
XFILLER_404_193 VPWR VGND sg13cmos5l_decap_8
XFILLER_676_14 VPWR VGND sg13cmos5l_decap_8
XFILLER_565_112 VPWR VGND sg13cmos5l_decap_8
XANTENNA__3487__X Tile_X0Y1_EE4BEG[13] VPWR VGND sg13cmos5l_antennanp
XFILLER_525_0 VPWR VGND sg13cmos5l_decap_8
XFILLER_565_189 VPWR VGND sg13cmos5l_fill_1
XFILLER_707_161 VPWR VGND sg13cmos5l_decap_4
XFILLER_609_63 VPWR VGND sg13cmos5l_decap_8
XFILLER_580_126 VPWR VGND sg13cmos5l_decap_8
XFILLER_707_172 VPWR VGND sg13cmos5l_decap_8
XFILLER_328_42 VPWR VGND sg13cmos5l_decap_8
XFILLER_7_56 VPWR VGND sg13cmos5l_decap_8
X_1670_ _1670_/Q Tile_X0Y2_FrameData[11] VGND VPWR Tile_X0Y9_FrameStrobe[7] latch
XFILLER_116_207 VPWR VGND sg13cmos5l_fill_1
XFILLER_692_35 VPWR VGND sg13cmos5l_decap_8
XFILLER_475_70 VPWR VGND sg13cmos5l_decap_8
X_0621_ _0621_/Q Tile_X0Y8_FrameData[18] VGND VPWR Tile_X0Y9_FrameStrobe[6] latch
X_3340_ Tile_X0Y2_FrameData_O[11] Tile_X0Y2_FrameData[11] VPWR VGND sg13cmos5l_buf_1
X_0552_ _0552_/Q Tile_X0Y8_FrameData[23] VGND VPWR Tile_X0Y9_FrameStrobe[4] latch
XFILLER_625_84 VPWR VGND sg13cmos5l_decap_8
XFILLER_561_28 VPWR VGND sg13cmos5l_decap_8
XFILLER_486_152 VPWR VGND sg13cmos5l_decap_8
X_3271_ Tile_X0Y0_EE4BEG[7] _3827_/X VPWR VGND sg13cmos5l_buf_1
XFILLER_344_63 VPWR VGND sg13cmos5l_decap_8
X_0483_ _0483_/Q Tile_X0Y8_FrameData[28] VGND VPWR Tile_X0Y9_FrameStrobe[2] latch
XFILLER_690_200 VPWR VGND sg13cmos5l_fill_2
XFILLER_635_105 VPWR VGND sg13cmos5l_decap_8
XFILLER_491_91 VPWR VGND sg13cmos5l_decap_8
XFILLER_285_225 VPWR VGND sg13cmos5l_decap_4
XFILLER_97_168 VPWR VGND sg13cmos5l_fill_2
X_2222_ _2222_/Q Tile_X0Y5_FrameData[23] VGND VPWR Tile_X0Y9_FrameStrobe[1] latch
XFILLER_38_224 VPWR VGND sg13cmos5l_decap_4
X_2153_ _2153_/Q Tile_X0Y4_FrameData[28] VGND VPWR Tile_X0Y9_FrameStrobe[7] latch
XFILLER_650_119 VPWR VGND sg13cmos5l_decap_8
XFILLER_213_56 VPWR VGND sg13cmos5l_decap_8
X_1104_ _1104_/Q Tile_X0Y0_FrameData[27] VGND VPWR Tile_X0Y9_FrameStrobe[5] latch
XFILLER_643_182 VPWR VGND sg13cmos5l_decap_8
X_2084_ _2084_/Q Tile_X0Y4_FrameData[1] VGND VPWR Tile_X0Y9_FrameStrobe[4] latch
XFILLER_360_84 VPWR VGND sg13cmos5l_decap_8
XFILLER_510_21 VPWR VGND sg13cmos5l_decap_8
X_1035_ _1035_/Q Tile_X0Y0_FrameData[0] VGND VPWR Tile_X0Y9_FrameStrobe[2] latch
XFILLER_289_49 VPWR VGND sg13cmos5l_decap_8
XFILLER_586_14 VPWR VGND sg13cmos5l_decap_8
XFILLER_510_98 VPWR VGND sg13cmos5l_decap_8
XFILLER_556_112 VPWR VGND sg13cmos5l_decap_4
XANTENNA__3397__X Tile_X0Y2_E2BEG[0] VPWR VGND sg13cmos5l_antennanp
X_2986_ Tile_X0Y8_FrameData_O[26] Tile_X0Y8_FrameData[26] VPWR VGND sg13cmos5l_buf_1
XFILLER_21_157 VPWR VGND sg13cmos5l_fill_1
XFILLER_556_189 VPWR VGND sg13cmos5l_decap_8
X_1937_ _1937_/Q Tile_X0Y4_FrameData[20] VGND VPWR Tile_X0Y9_FrameStrobe[0] latch
X_4725_ _4725_/X _4779_/X _4778_/X AXI_M_SOC_RDATA10 AXI_M_SOC_RDATA14 _0597_/Q _0596_/Q
+ VPWR VGND sg13cmos5l_mux4_1
XFILLER_571_126 VPWR VGND sg13cmos5l_decap_8
XFILLER_519_63 VPWR VGND sg13cmos5l_decap_8
XFILLER_666_91 VPWR VGND sg13cmos5l_decap_8
XFILLER_238_42 VPWR VGND sg13cmos5l_decap_8
XFILLER_174_140 VPWR VGND sg13cmos5l_decap_8
X_4656_ _4656_/X _4661_/X Tile_X0Y7_W6END[0] _4660_/X _4656_/A3 _0167_/Q _0166_/Q
+ VPWR VGND sg13cmos5l_mux4_1
X_1868_ _1868_/Q Tile_X0Y3_FrameData[29] VGND VPWR Tile_X0Y9_FrameStrobe[6] latch
XFILLER_323_104 VPWR VGND sg13cmos5l_decap_8
X_3607_ Tile_X0Y9_S2BEG[1] _4829_/X VPWR VGND sg13cmos5l_buf_1
XFILLER_713_175 VPWR VGND sg13cmos5l_decap_8
X_0819_ _0819_/Q Tile_X0Y9_FrameData[12] VGND VPWR Tile_X0Y9_FrameStrobe[4] latch
X_4587_ _4587_/X Tile_X0Y8_W2MID[6] Tile_X0Y8_W2END[6] Tile_X0Y8_W6END[6] _4787_/X
+ _0661_/Q _0660_/Q VPWR VGND sg13cmos5l_mux4_1
X_1799_ _1799_/Q Tile_X0Y3_FrameData[2] VGND VPWR Tile_X0Y9_FrameStrobe[3] latch
X_3538_ Tile_X0Y9_E2BEGb[4] _4860_/X VPWR VGND sg13cmos5l_buf_1
XFILLER_535_84 VPWR VGND sg13cmos5l_decap_8
XFILLER_107_35 VPWR VGND sg13cmos5l_decap_8
XFILLER_477_141 VPWR VGND sg13cmos5l_decap_8
XFILLER_331_170 VPWR VGND sg13cmos5l_decap_8
XFILLER_471_28 VPWR VGND sg13cmos5l_decap_8
XFILLER_254_63 VPWR VGND sg13cmos5l_fill_1
XFILLER_88_146 VPWR VGND sg13cmos5l_decap_8
X_3469_ Tile_X0Y1_FrameData_O[27] Tile_X0Y1_FrameData[27] VPWR VGND sg13cmos5l_buf_1
XFILLER_67_28 VPWR VGND sg13cmos5l_decap_8
XFILLER_626_105 VPWR VGND sg13cmos5l_decap_8
XFILLER_492_133 VPWR VGND sg13cmos5l_decap_8
XFILLER_404_77 VPWR VGND sg13cmos5l_decap_8
XFILLER_291_228 VPWR VGND sg13cmos5l_fill_1
XFILLER_184_7 VPWR VGND sg13cmos5l_decap_8
XFILLER_641_119 VPWR VGND sg13cmos5l_decap_8
XFILLER_123_56 VPWR VGND sg13cmos5l_decap_8
XFILLER_701_42 VPWR VGND sg13cmos5l_decap_8
XFILLER_244_122 VPWR VGND sg13cmos5l_decap_8
XFILLER_244_133 VPWR VGND sg13cmos5l_fill_1
XFILLER_270_84 VPWR VGND sg13cmos5l_decap_8
XFILLER_83_49 VPWR VGND sg13cmos5l_decap_8
XFILLER_420_21 VPWR VGND sg13cmos5l_decap_8
XFILLER_351_7 VPWR VGND sg13cmos5l_decap_8
XFILLER_16_21 VPWR VGND sg13cmos5l_decap_8
XFILLER_449_7 VPWR VGND sg13cmos5l_decap_8
XFILLER_199_49 VPWR VGND sg13cmos5l_decap_8
XFILLER_496_14 VPWR VGND sg13cmos5l_decap_8
XFILLER_420_98 VPWR VGND sg13cmos5l_decap_8
XFILLER_616_7 VPWR VGND sg13cmos5l_decap_8
XFILLER_200_214 VPWR VGND sg13cmos5l_fill_1
XFILLER_346_207 VPWR VGND sg13cmos5l_decap_8
XANTENNA__3100__X Tile_X0Y7_E2BEGb[6] VPWR VGND sg13cmos5l_antennanp
XFILLER_32_31 VPWR VGND sg13cmos5l_decap_8
XFILLER_646_28 VPWR VGND sg13cmos5l_decap_8
XFILLER_562_126 VPWR VGND sg13cmos5l_decap_4
XFILLER_429_63 VPWR VGND sg13cmos5l_decap_8
XFILLER_576_91 VPWR VGND sg13cmos5l_decap_8
XFILLER_148_42 VPWR VGND sg13cmos5l_decap_8
XFILLER_704_142 VPWR VGND sg13cmos5l_fill_1
XFILLER_295_70 VPWR VGND sg13cmos5l_decap_8
XFILLER_165_195 VPWR VGND sg13cmos5l_decap_8
XFILLER_106_0 VPWR VGND sg13cmos5l_decap_8
XFILLER_662_49 VPWR VGND sg13cmos5l_decap_8
XFILLER_79_124 VPWR VGND sg13cmos5l_fill_2
XFILLER_381_28 VPWR VGND sg13cmos5l_decap_8
XFILLER_267_203 VPWR VGND sg13cmos5l_decap_8
XFILLER_164_63 VPWR VGND sg13cmos5l_decap_8
XFILLER_121_221 VPWR VGND sg13cmos5l_fill_1
XFILLER_164_74 VPWR VGND sg13cmos5l_fill_2
XFILLER_617_105 VPWR VGND sg13cmos5l_decap_8
XFILLER_94_105 VPWR VGND sg13cmos5l_decap_8
XFILLER_475_0 VPWR VGND sg13cmos5l_decap_8
XFILLER_632_119 VPWR VGND sg13cmos5l_decap_8
XFILLER_314_99 VPWR VGND sg13cmos5l_fill_2
XFILLER_611_42 VPWR VGND sg13cmos5l_decap_8
XFILLER_180_84 VPWR VGND sg13cmos5l_decap_8
XFILLER_642_0 VPWR VGND sg13cmos5l_decap_8
XFILLER_330_21 VPWR VGND sg13cmos5l_decap_8
XFILLER_687_35 VPWR VGND sg13cmos5l_decap_8
XFILLER_640_196 VPWR VGND sg13cmos5l_decap_8
XFILLER_250_147 VPWR VGND sg13cmos5l_fill_2
XFILLER_389_192 VPWR VGND sg13cmos5l_fill_1
X_2840_ Tile_X0Y6_E2BEG[5] _4501_/X VPWR VGND sg13cmos5l_buf_1
XFILLER_538_156 VPWR VGND sg13cmos5l_decap_8
XANTENNA__3010__X Tile_X0Y5_E2BEGb[5] VPWR VGND sg13cmos5l_antennanp
XFILLER_556_28 VPWR VGND sg13cmos5l_decap_8
X_2771_ Tile_X0Y3_FrameData_O[29] Tile_X0Y3_FrameData[29] VPWR VGND sg13cmos5l_buf_1
XFILLER_553_126 VPWR VGND sg13cmos5l_fill_1
XFILLER_339_63 VPWR VGND sg13cmos5l_decap_8
X_4510_ _4510_/X Tile_X0Y6_W2END[1] AXI_M_SOC_RDATA25 _4555_/X _4554_/X _2587_/Q _2586_/Q
+ VPWR VGND sg13cmos5l_mux4_1
XFILLER_486_91 VPWR VGND sg13cmos5l_decap_8
X_1722_ _1722_/Q Tile_X0Y3_FrameData[15] VGND VPWR Tile_X0Y9_FrameStrobe[1] latch
XFILLER_156_184 VPWR VGND sg13cmos5l_fill_2
X_4441_ _4441_/X Tile_X0Y9_W1END[1] Tile_X0Y9_WW4END[1] Tile_X0Y9_W6END[9] _4917_/X
+ _0900_/Q _0899_/Q VPWR VGND sg13cmos5l_mux4_1
X_1653_ _1653_/Q Tile_X0Y2_FrameData[28] VGND VPWR Tile_X0Y9_FrameStrobe[7] latch
XFILLER_710_112 VPWR VGND sg13cmos5l_decap_8
XFILLER_208_56 VPWR VGND sg13cmos5l_decap_8
XFILLER_171_154 VPWR VGND sg13cmos5l_decap_8
X_0604_ _0604_/Q Tile_X0Y8_FrameData[3] VGND VPWR Tile_X0Y9_FrameStrobe[5] latch
X_4372_ _4372_/X Tile_X0Y5_W2MID[7] AXI_M_SOC_RVALID _4467_/X _4428_/X _2359_/Q _2358_/Q
+ VPWR VGND sg13cmos5l_mux4_1
X_1584_ _1584_/Q Tile_X0Y2_FrameData[1] VGND VPWR Tile_X0Y9_FrameStrobe[4] latch
XFILLER_572_49 VPWR VGND sg13cmos5l_decap_8
XFILLER_355_84 VPWR VGND sg13cmos5l_decap_8
XFILLER_505_21 VPWR VGND sg13cmos5l_decap_8
X_3323_ Tile_X0Y4_EE4BEG[11] _4283_/X VPWR VGND sg13cmos5l_buf_1
XFILLER_291_28 VPWR VGND sg13cmos5l_decap_8
XFILLER_710_189 VPWR VGND sg13cmos5l_decap_8
X_0535_ _0535_/Q Tile_X0Y8_FrameData[8] VGND VPWR Tile_X0Y9_FrameStrobe[3] latch
XFILLER_313_181 VPWR VGND sg13cmos5l_decap_8
XFILLER_258_214 VPWR VGND sg13cmos5l_decap_8
XFILLER_459_174 VPWR VGND sg13cmos5l_decap_8
XFILLER_85_105 VPWR VGND sg13cmos5l_decap_8
X_3254_ Tile_X0Y0_FrameData_O[22] Tile_X0Y0_FrameData[22] VPWR VGND sg13cmos5l_buf_1
XFILLER_85_116 VPWR VGND sg13cmos5l_fill_1
X_0466_ _0466_/Q Tile_X0Y8_FrameData[13] VGND VPWR Tile_X0Y9_FrameStrobe[1] latch
XFILLER_505_98 VPWR VGND sg13cmos5l_decap_8
XFILLER_21_0 VPWR VGND sg13cmos5l_decap_8
XFILLER_85_138 VPWR VGND sg13cmos5l_fill_1
XFILLER_273_206 VPWR VGND sg13cmos5l_decap_8
X_2205_ _2205_/Q Tile_X0Y5_FrameData[8] VGND VPWR Tile_X0Y9_FrameStrobe[0] latch
XFILLER_224_77 VPWR VGND sg13cmos5l_decap_8
XFILLER_273_228 VPWR VGND sg13cmos5l_fill_1
X_3185_ Tile_X0Y0_N4BEG[9] _3185_/A VPWR VGND sg13cmos5l_buf_1
XFILLER_224_88 VPWR VGND sg13cmos5l_fill_2
X_0397_ _0397_/Q Tile_X0Y7_FrameData[18] VGND VPWR Tile_X0Y9_FrameStrobe[7] latch
XFILLER_474_199 VPWR VGND sg13cmos5l_decap_8
XFILLER_521_42 VPWR VGND sg13cmos5l_decap_8
X_2136_ _2136_/Q Tile_X0Y4_FrameData[13] VGND VPWR Tile_X0Y9_FrameStrobe[6] latch
XFILLER_93_160 VPWR VGND sg13cmos5l_fill_2
XFILLER_240_21 VPWR VGND sg13cmos5l_decap_8
XFILLER_430_203 VPWR VGND sg13cmos5l_fill_2
X_2067_ _2067_/Q Tile_X0Y4_FrameData[18] VGND VPWR Tile_X0Y9_FrameStrobe[4] latch
XFILLER_241_114 VPWR VGND sg13cmos5l_decap_4
XFILLER_597_35 VPWR VGND sg13cmos5l_decap_8
XFILLER_387_118 VPWR VGND sg13cmos5l_fill_2
X_1018_ _1018_/Q Tile_X0Y0_FrameData[17] VGND VPWR Tile_X0Y9_FrameStrobe[2] latch
XFILLER_529_123 VPWR VGND sg13cmos5l_decap_8
XFILLER_466_28 VPWR VGND sg13cmos5l_decap_8
XFILLER_249_63 VPWR VGND sg13cmos5l_decap_8
X_2969_ Tile_X0Y8_FrameData_O[9] Tile_X0Y8_FrameData[9] VPWR VGND sg13cmos5l_buf_1
XFILLER_396_91 VPWR VGND sg13cmos5l_decap_8
X_4708_ _4708_/X Tile_X0Y6_W1END[0] Tile_X0Y6_W2MID[3] Tile_X0Y6_W2END[3] _4558_/X
+ _2643_/Q _2642_/Q VPWR VGND sg13cmos5l_mux4_1
XFILLER_497_203 VPWR VGND sg13cmos5l_decap_8
X_4639_ _4639_/X Tile_X0Y7_WW4END[4] AXI_M_SOC_RDATA20 _4688_/X _4674_/X _0281_/Q
+ _0280_/Q VPWR VGND sg13cmos5l_mux4_1
XFILLER_701_112 VPWR VGND sg13cmos5l_decap_8
XFILLER_497_214 VPWR VGND sg13cmos5l_fill_1
XFILLER_162_143 VPWR VGND sg13cmos5l_decap_8
XFILLER_118_56 VPWR VGND sg13cmos5l_decap_8
XFILLER_118_67 VPWR VGND sg13cmos5l_fill_2
XFILLER_482_49 VPWR VGND sg13cmos5l_decap_8
XFILLER_265_84 VPWR VGND sg13cmos5l_fill_2
XFILLER_701_167 VPWR VGND sg13cmos5l_fill_1
XFILLER_78_49 VPWR VGND sg13cmos5l_decap_8
XFILLER_415_21 VPWR VGND sg13cmos5l_decap_8
XFILLER_103_210 VPWR VGND sg13cmos5l_decap_8
XFILLER_399_7 VPWR VGND sg13cmos5l_decap_8
XANTENNA__3590__X Tile_X0Y9_FrameData_O[20] VPWR VGND sg13cmos5l_antennanp
XFILLER_465_122 VPWR VGND sg13cmos5l_fill_1
XFILLER_76_105 VPWR VGND sg13cmos5l_decap_8
XFILLER_415_98 VPWR VGND sg13cmos5l_decap_8
XFILLER_76_127 VPWR VGND sg13cmos5l_decap_8
XFILLER_76_149 VPWR VGND sg13cmos5l_decap_8
XFILLER_134_77 VPWR VGND sg13cmos5l_decap_8
XFILLER_712_63 VPWR VGND sg13cmos5l_decap_8
XFILLER_566_7 VPWR VGND sg13cmos5l_decap_8
XFILLER_264_228 VPWR VGND sg13cmos5l_fill_1
XFILLER_431_42 VPWR VGND sg13cmos5l_decap_8
XFILLER_27_42 VPWR VGND sg13cmos5l_decap_8
XFILLER_150_21 VPWR VGND sg13cmos5l_decap_8
XANTENNA__2934__X Tile_X0Y8_E6BEG[2] VPWR VGND sg13cmos5l_antennanp
XFILLER_567_207 VPWR VGND sg13cmos5l_decap_4
XFILLER_421_225 VPWR VGND sg13cmos5l_decap_4
XFILLER_150_98 VPWR VGND sg13cmos5l_fill_2
XFILLER_300_35 VPWR VGND sg13cmos5l_decap_8
XFILLER_319_207 VPWR VGND sg13cmos5l_decap_4
XFILLER_185_202 VPWR VGND sg13cmos5l_decap_8
XFILLER_657_49 VPWR VGND sg13cmos5l_decap_8
XFILLER_43_63 VPWR VGND sg13cmos5l_decap_8
XFILLER_240_180 VPWR VGND sg13cmos5l_decap_4
XFILLER_386_173 VPWR VGND sg13cmos5l_decap_4
XFILLER_376_28 VPWR VGND sg13cmos5l_decap_8
XFILLER_159_63 VPWR VGND sg13cmos5l_decap_8
XFILLER_535_148 VPWR VGND sg13cmos5l_decap_8
XFILLER_223_0 VPWR VGND sg13cmos5l_decap_8
XFILLER_138_140 VPWR VGND sg13cmos5l_decap_8
XFILLER_606_42 VPWR VGND sg13cmos5l_decap_8
XFILLER_392_49 VPWR VGND sg13cmos5l_decap_8
XFILLER_592_0 VPWR VGND sg13cmos5l_decap_8
XFILLER_325_21 VPWR VGND sg13cmos5l_decap_8
XFILLER_4_35 VPWR VGND sg13cmos5l_decap_8
X_0320_ _0320_/Q Tile_X0Y7_FrameData[31] VGND VPWR Tile_X0Y9_FrameStrobe[5] latch
XFILLER_456_133 VPWR VGND sg13cmos5l_decap_8
XFILLER_310_151 VPWR VGND sg13cmos5l_decap_8
XFILLER_68_93 VPWR VGND sg13cmos5l_decap_8
XFILLER_67_149 VPWR VGND sg13cmos5l_decap_8
X_0251_ _0251_/Q Tile_X0Y7_FrameData[4] VGND VPWR Tile_X0Y9_FrameStrobe[2] latch
XFILLER_622_63 VPWR VGND sg13cmos5l_decap_8
XFILLER_255_228 VPWR VGND sg13cmos5l_fill_1
XANTENNA__3005__X Tile_X0Y5_E2BEGb[0] VPWR VGND sg13cmos5l_antennanp
XFILLER_341_42 VPWR VGND sg13cmos5l_decap_8
XFILLER_208_133 VPWR VGND sg13cmos5l_decap_8
X_0182_ _0182_/Q Tile_X0Y7_FrameData[9] VGND VPWR Tile_X0Y9_FrameStrobe[0] latch
XFILLER_84_70 VPWR VGND sg13cmos5l_decap_8
XFILLER_698_56 VPWR VGND sg13cmos5l_decap_8
XANTENNA__2844__X Tile_X0Y6_E2BEGb[1] VPWR VGND sg13cmos5l_antennanp
XFILLER_223_114 VPWR VGND sg13cmos5l_decap_8
X_3941_ _3941_/X Tile_X0Y1_W2END[6] AXI_M_SOC_ARREADY _3991_/X _3990_/X _1327_/Q _1326_/Q
+ VPWR VGND sg13cmos5l_mux4_1
XFILLER_210_35 VPWR VGND sg13cmos5l_decap_8
X_3872_ _3872_/X _3849_/X _0086_/X Tile_X0Y0_S1END[1] Tile_X0Y0_S4END[1] _0977_/Q
+ _0976_/Q VPWR VGND sg13cmos5l_mux4_1
XFILLER_567_49 VPWR VGND sg13cmos5l_decap_8
XFILLER_231_191 VPWR VGND sg13cmos5l_fill_2
XFILLER_176_224 VPWR VGND sg13cmos5l_decap_4
X_2823_ Tile_X0Y4_E2BEG[1] _4257_/X VPWR VGND sg13cmos5l_buf_1
XFILLER_526_115 VPWR VGND sg13cmos5l_decap_4
XFILLER_286_28 VPWR VGND sg13cmos5l_decap_8
X_2754_ Tile_X0Y3_FrameData_O[12] Tile_X0Y3_FrameData[12] VPWR VGND sg13cmos5l_buf_1
XFILLER_69_0 VPWR VGND sg13cmos5l_decap_8
X_1705_ _1705_/Q Tile_X0Y3_FrameData[0] VGND VPWR Tile_X0Y9_FrameStrobe[0] latch
XFILLER_534_170 VPWR VGND sg13cmos5l_decap_8
XFILLER_219_77 VPWR VGND sg13cmos5l_decap_8
X_2685_ _2685_/Q Tile_X0Y6_FrameData[10] VGND VPWR Tile_X0Y9_FrameStrobe[7] latch
X_4424_ _4424_/X Tile_X0Y6_W1END[2] Tile_X0Y6_W6END[6] _4582_/X _4542_/X _2691_/Q
+ _2690_/Q VPWR VGND sg13cmos5l_mux4_1
XFILLER_516_42 VPWR VGND sg13cmos5l_decap_8
X_1636_ _1636_/Q Tile_X0Y2_FrameData[13] VGND VPWR Tile_X0Y9_FrameStrobe[6] latch
XFILLER_663_70 VPWR VGND sg13cmos5l_decap_8
XFILLER_235_21 VPWR VGND sg13cmos5l_decap_8
X_4355_ _4355_/X Tile_X0Y6_W2MID[6] Tile_X0Y6_W2END[6] Tile_X0Y6_W6END[6] _4555_/X
+ _2685_/Q _2684_/Q VPWR VGND sg13cmos5l_mux4_1
X_1567_ _1567_/Q Tile_X0Y2_FrameData[18] VGND VPWR Tile_X0Y9_FrameStrobe[4] latch
XFILLER_494_228 VPWR VGND sg13cmos5l_fill_1
XFILLER_695_199 VPWR VGND sg13cmos5l_fill_1
X_3306_ Tile_X0Y0_E2BEG[6] _3810_/X VPWR VGND sg13cmos5l_buf_1
X_0518_ _0518_/Q Tile_X0Y8_FrameData[25] VGND VPWR Tile_X0Y9_FrameStrobe[3] latch
XFILLER_58_105 VPWR VGND sg13cmos5l_fill_2
XFILLER_235_87 VPWR VGND sg13cmos5l_decap_8
X_4286_ _4286_/X Tile_X0Y4_WW4END[1] AXI_M_SOC_BRESP1 _4337_/X _4315_/X _2041_/Q _2040_/Q
+ VPWR VGND sg13cmos5l_mux4_1
X_1498_ _1498_/Q Tile_X0Y2_FrameData[23] VGND VPWR Tile_X0Y9_FrameStrobe[2] latch
XFILLER_58_138 VPWR VGND sg13cmos5l_decap_8
X_3237_ Tile_X0Y0_FrameData_O[5] Tile_X0Y0_FrameData[5] VPWR VGND sg13cmos5l_buf_1
XFILLER_532_63 VPWR VGND sg13cmos5l_decap_8
XFILLER_462_103 VPWR VGND sg13cmos5l_decap_8
X_0449_ _0449_/Q Tile_X0Y8_FrameData[30] VGND VPWR Tile_X0Y9_FrameStrobe[1] latch
XFILLER_104_14 VPWR VGND sg13cmos5l_decap_8
XFILLER_251_42 VPWR VGND sg13cmos5l_decap_8
X_3168_ Tile_X0Y4_E6BEG[5] _4293_/X VPWR VGND sg13cmos5l_buf_1
XFILLER_66_171 VPWR VGND sg13cmos5l_decap_8
XANTENNA__2754__X Tile_X0Y3_FrameData_O[12] VPWR VGND sg13cmos5l_antennanp
X_2119_ _2119_/Q Tile_X0Y4_FrameData[30] VGND VPWR Tile_X0Y9_FrameStrobe[6] latch
X_3099_ Tile_X0Y7_E2BEGb[5] _4625_/X VPWR VGND sg13cmos5l_buf_1
XFILLER_470_180 VPWR VGND sg13cmos5l_decap_8
XFILLER_401_56 VPWR VGND sg13cmos5l_decap_8
XFILLER_214_147 VPWR VGND sg13cmos5l_decap_8
XFILLER_401_89 VPWR VGND sg13cmos5l_decap_8
XFILLER_120_35 VPWR VGND sg13cmos5l_decap_8
XFILLER_80_28 VPWR VGND sg13cmos5l_decap_8
XFILLER_477_49 VPWR VGND sg13cmos5l_decap_8
XFILLER_147_7 VPWR VGND sg13cmos5l_decap_8
XFILLER_572_210 VPWR VGND sg13cmos5l_decap_4
XFILLER_368_184 VPWR VGND sg13cmos5l_decap_4
XANTENNA__3585__X Tile_X0Y9_FrameData_O[15] VPWR VGND sg13cmos5l_antennanp
XFILLER_383_143 VPWR VGND sg13cmos5l_decap_8
XFILLER_314_7 VPWR VGND sg13cmos5l_decap_8
XFILLER_13_77 VPWR VGND sg13cmos5l_decap_8
XFILLER_182_227 VPWR VGND sg13cmos5l_fill_2
XFILLER_324_210 VPWR VGND sg13cmos5l_fill_2
XFILLER_129_77 VPWR VGND sg13cmos5l_decap_8
XFILLER_707_63 VPWR VGND sg13cmos5l_decap_8
XFILLER_129_88 VPWR VGND sg13cmos5l_fill_2
XFILLER_135_154 VPWR VGND sg13cmos5l_decap_8
XFILLER_426_42 VPWR VGND sg13cmos5l_decap_8
XFILLER_573_70 VPWR VGND sg13cmos5l_decap_8
XFILLER_145_21 VPWR VGND sg13cmos5l_decap_8
XANTENNA__2929__X Tile_X0Y8_E2BEGb[5] VPWR VGND sg13cmos5l_antennanp
XFILLER_683_7 VPWR VGND sg13cmos5l_decap_8
XFILLER_145_98 VPWR VGND sg13cmos5l_decap_8
XFILLER_49_127 VPWR VGND sg13cmos5l_decap_4
XFILLER_438_155 VPWR VGND sg13cmos5l_fill_2
XFILLER_237_217 VPWR VGND sg13cmos5l_decap_4
XFILLER_442_63 VPWR VGND sg13cmos5l_decap_8
XFILLER_642_203 VPWR VGND sg13cmos5l_decap_8
XFILLER_599_107 VPWR VGND sg13cmos5l_fill_1
XFILLER_38_63 VPWR VGND sg13cmos5l_decap_8
XFILLER_161_42 VPWR VGND sg13cmos5l_decap_8
XFILLER_173_0 VPWR VGND sg13cmos5l_decap_8
XFILLER_161_86 VPWR VGND sg13cmos5l_fill_1
XFILLER_311_56 VPWR VGND sg13cmos5l_decap_8
XFILLER_205_147 VPWR VGND sg13cmos5l_decap_8
XFILLER_72_196 VPWR VGND sg13cmos5l_decap_8
XFILLER_54_73 VPWR VGND sg13cmos5l_decap_8
XFILLER_340_0 VPWR VGND sg13cmos5l_decap_8
XFILLER_438_0 VPWR VGND sg13cmos5l_decap_8
XFILLER_387_49 VPWR VGND sg13cmos5l_decap_8
XFILLER_684_14 VPWR VGND sg13cmos5l_decap_8
XFILLER_508_126 VPWR VGND sg13cmos5l_decap_8
XFILLER_374_132 VPWR VGND sg13cmos5l_fill_2
XANTENNA__3495__X Tile_X0Y1_E6BEG[5] VPWR VGND sg13cmos5l_antennanp
XFILLER_605_0 VPWR VGND sg13cmos5l_decap_8
XFILLER_173_227 VPWR VGND sg13cmos5l_fill_2
XFILLER_374_187 VPWR VGND sg13cmos5l_decap_8
XFILLER_617_63 VPWR VGND sg13cmos5l_decap_8
XFILLER_126_154 VPWR VGND sg13cmos5l_decap_8
XFILLER_336_42 VPWR VGND sg13cmos5l_decap_8
X_2470_ _2470_/Q Tile_X0Y6_FrameData[1] VGND VPWR Tile_X0Y9_FrameStrobe[0] latch
XFILLER_483_70 VPWR VGND sg13cmos5l_decap_8
XFILLER_79_70 VPWR VGND sg13cmos5l_decap_8
X_1421_ _1421_/Q Tile_X0Y1_FrameData[12] VGND VPWR Tile_X0Y9_FrameStrobe[7] latch
XFILLER_677_166 VPWR VGND sg13cmos5l_fill_1
XANTENNA__2839__X Tile_X0Y6_E2BEG[4] VPWR VGND sg13cmos5l_antennanp
XFILLER_141_168 VPWR VGND sg13cmos5l_decap_8
X_4140_ _4140_/X Tile_X0Y1_W1END[2] Tile_X0Y1_W2MID[1] Tile_X0Y1_W2END[1] _3990_/X
+ _1369_/Q _1368_/Q VPWR VGND sg13cmos5l_mux4_1
X_1352_ _1352_/Q Tile_X0Y1_FrameData[17] VGND VPWR Tile_X0Y9_FrameStrobe[5] latch
XFILLER_429_133 VPWR VGND sg13cmos5l_decap_8
XFILLER_633_84 VPWR VGND sg13cmos5l_decap_8
XFILLER_205_35 VPWR VGND sg13cmos5l_decap_8
X_0303_ _0303_/Q Tile_X0Y7_FrameData[16] VGND VPWR Tile_X0Y9_FrameStrobe[4] latch
X_4071_ _4071_/X Tile_X0Y2_WW4END[0] AXI_M_SOC_AWREADY _4116_/X _4097_/X _1531_/Q
+ _1530_/Q VPWR VGND sg13cmos5l_mux4_1
XFILLER_352_63 VPWR VGND sg13cmos5l_decap_8
XFILLER_228_228 VPWR VGND sg13cmos5l_fill_1
X_1283_ _1283_/Q Tile_X0Y1_FrameData[22] VGND VPWR Tile_X0Y9_FrameStrobe[3] latch
X_3022_ Tile_X0Y5_E6BEG[9] _4413_/X VPWR VGND sg13cmos5l_buf_1
X_0234_ _0234_/Q Tile_X0Y7_FrameData[21] VGND VPWR Tile_X0Y9_FrameStrobe[2] latch
XFILLER_48_182 VPWR VGND sg13cmos5l_decap_4
XFILLER_502_77 VPWR VGND sg13cmos5l_decap_8
X_0165_ _0165_/Q Tile_X0Y7_FrameData[26] VGND VPWR Tile_X0Y9_FrameStrobe[0] latch
XFILLER_221_56 VPWR VGND sg13cmos5l_decap_8
XFILLER_63_174 VPWR VGND sg13cmos5l_decap_8
X_0096_ _0096_/X _4000_/X _4001_/X _2410_/Q VPWR VGND sg13cmos5l_mux2_1
XFILLER_400_206 VPWR VGND sg13cmos5l_decap_8
X_3924_ _3924_/X Tile_X0Y3_W1END[1] Tile_X0Y3_WW4END[1] Tile_X0Y3_W6END[9] _4223_/X
+ _1898_/Q _1897_/Q VPWR VGND sg13cmos5l_mux4_1
XFILLER_149_202 VPWR VGND sg13cmos5l_fill_2
XFILLER_297_49 VPWR VGND sg13cmos5l_decap_8
XFILLER_658_70 VPWR VGND sg13cmos5l_decap_8
XFILLER_594_14 VPWR VGND sg13cmos5l_decap_8
X_3855_ _3855_/X _3891_/X _3890_/X Tile_X0Y0_S2MID[1] Tile_X0Y0_S2END[1] _0961_/Q
+ _0960_/Q VPWR VGND sg13cmos5l_mux4_1
X_2806_ Tile_X0Y3_E2BEGb[4] _4160_/X VPWR VGND sg13cmos5l_buf_1
XFILLER_164_216 VPWR VGND sg13cmos5l_fill_2
X_3786_ _3786_/X Tile_X0Y0_W2MID[5] Tile_X0Y0_W2END[5] Tile_X0Y0_W6END[5] _3857_/X
+ _1165_/Q _1164_/Q VPWR VGND sg13cmos5l_mux4_1
X_0998_ _0998_/Q Tile_X0Y0_FrameData[5] VGND VPWR Tile_X0Y9_FrameStrobe[1] latch
XFILLER_527_63 VPWR VGND sg13cmos5l_decap_8
X_2737_ Tile_X0Y4_E1BEG[0] _4252_/X VPWR VGND sg13cmos5l_buf_1
XFILLER_674_91 VPWR VGND sg13cmos5l_decap_8
XFILLER_522_140 VPWR VGND sg13cmos5l_decap_4
XFILLER_246_42 VPWR VGND sg13cmos5l_decap_8
XFILLER_668_133 VPWR VGND sg13cmos5l_decap_8
X_2668_ _2668_/Q Tile_X0Y6_FrameData[27] VGND VPWR Tile_X0Y9_FrameStrobe[7] latch
XFILLER_393_70 VPWR VGND sg13cmos5l_fill_2
XANTENNA__2749__X Tile_X0Y3_FrameData_O[7] VPWR VGND sg13cmos5l_antennanp
X_1619_ _1619_/Q Tile_X0Y2_FrameData[30] VGND VPWR Tile_X0Y9_FrameStrobe[6] latch
X_4407_ _4407_/X _0097_/X _0156_/X _4459_/X _4463_/X _2289_/Q _2288_/Q VPWR VGND sg13cmos5l_mux4_1
XFILLER_246_97 VPWR VGND sg13cmos5l_decap_8
X_2599_ _2599_/Q Tile_X0Y6_FrameData[0] VGND VPWR Tile_X0Y9_FrameStrobe[4] latch
X_4338_ _4338_/X _4308_/X _0160_/X _4307_/X _0110_/X _1977_/Q _1976_/Q VPWR VGND sg13cmos5l_mux4_1
XFILLER_543_84 VPWR VGND sg13cmos5l_decap_8
XFILLER_115_35 VPWR VGND sg13cmos5l_decap_8
XFILLER_262_63 VPWR VGND sg13cmos5l_decap_8
X_4269_ _4269_/X Tile_X0Y4_W2END[2] AXI_M_SOC_BRESP0 _4317_/X _4316_/X _2075_/Q _2074_/Q
+ VPWR VGND sg13cmos5l_mux4_1
XFILLER_262_74 VPWR VGND sg13cmos5l_fill_1
XFILLER_75_28 VPWR VGND sg13cmos5l_decap_8
XFILLER_624_225 VPWR VGND sg13cmos5l_decap_4
XFILLER_46_108 VPWR VGND sg13cmos5l_decap_8
XFILLER_435_147 VPWR VGND sg13cmos5l_decap_8
XFILLER_412_33 VPWR VGND sg13cmos5l_decap_8
XFILLER_39_160 VPWR VGND sg13cmos5l_decap_8
XFILLER_450_106 VPWR VGND sg13cmos5l_decap_4
XFILLER_264_7 VPWR VGND sg13cmos5l_decap_8
XFILLER_242_220 VPWR VGND sg13cmos5l_decap_8
XFILLER_54_152 VPWR VGND sg13cmos5l_decap_8
XFILLER_131_56 VPWR VGND sg13cmos5l_decap_8
XFILLER_589_195 VPWR VGND sg13cmos5l_fill_2
XFILLER_91_49 VPWR VGND sg13cmos5l_decap_8
XFILLER_431_7 VPWR VGND sg13cmos5l_decap_8
XFILLER_24_21 VPWR VGND sg13cmos5l_decap_8
XFILLER_529_7 VPWR VGND sg13cmos5l_decap_8
XFILLER_568_70 VPWR VGND sg13cmos5l_decap_8
XFILLER_210_161 VPWR VGND sg13cmos5l_decap_8
XFILLER_356_154 VPWR VGND sg13cmos5l_decap_8
XFILLER_155_216 VPWR VGND sg13cmos5l_fill_2
XFILLER_108_110 VPWR VGND sg13cmos5l_decap_8
XFILLER_654_28 VPWR VGND sg13cmos5l_decap_8
XFILLER_40_42 VPWR VGND sg13cmos5l_decap_8
XFILLER_437_63 VPWR VGND sg13cmos5l_decap_8
XFILLER_371_146 VPWR VGND sg13cmos5l_decap_4
XFILLER_584_91 VPWR VGND sg13cmos5l_decap_8
XFILLER_371_168 VPWR VGND sg13cmos5l_decap_8
XFILLER_170_219 VPWR VGND sg13cmos5l_fill_1
XFILLER_156_42 VPWR VGND sg13cmos5l_decap_8
XFILLER_108_165 VPWR VGND sg13cmos5l_fill_1
XFILLER_513_151 VPWR VGND sg13cmos5l_fill_1
XFILLER_306_56 VPWR VGND sg13cmos5l_decap_8
XFILLER_670_49 VPWR VGND sg13cmos5l_decap_8
XFILLER_453_84 VPWR VGND sg13cmos5l_decap_8
XFILLER_603_21 VPWR VGND sg13cmos5l_decap_8
XFILLER_49_73 VPWR VGND sg13cmos5l_decap_8
XFILLER_290_0 VPWR VGND sg13cmos5l_decap_8
XFILLER_388_0 VPWR VGND sg13cmos5l_decap_8
XFILLER_172_63 VPWR VGND sg13cmos5l_decap_8
XFILLER_1_14 VPWR VGND sg13cmos5l_decap_8
XFILLER_682_180 VPWR VGND sg13cmos5l_fill_1
XFILLER_37_108 VPWR VGND sg13cmos5l_decap_8
XFILLER_426_147 VPWR VGND sg13cmos5l_decap_8
XFILLER_679_14 VPWR VGND sg13cmos5l_decap_8
XFILLER_225_209 VPWR VGND sg13cmos5l_fill_2
XFILLER_555_0 VPWR VGND sg13cmos5l_decap_8
XFILLER_292_186 VPWR VGND sg13cmos5l_decap_8
XFILLER_65_72 VPWR VGND sg13cmos5l_fill_1
XFILLER_45_163 VPWR VGND sg13cmos5l_fill_2
XFILLER_595_154 VPWR VGND sg13cmos5l_fill_1
X_1970_ _1970_/Q Tile_X0Y4_FrameData[19] VGND VPWR Tile_X0Y9_FrameStrobe[1] latch
XFILLER_695_35 VPWR VGND sg13cmos5l_decap_8
XFILLER_595_176 VPWR VGND sg13cmos5l_fill_2
XFILLER_595_187 VPWR VGND sg13cmos5l_fill_1
XFILLER_478_70 VPWR VGND sg13cmos5l_decap_8
X_0921_ _0921_/Q Tile_X0Y9_FrameData[6] VGND VPWR Tile_X0Y9_FrameStrobe[7] latch
XFILLER_60_199 VPWR VGND sg13cmos5l_decap_8
XFILLER_536_221 VPWR VGND sg13cmos5l_decap_8
XFILLER_628_40 VPWR VGND sg13cmos5l_decap_8
X_3640_ AXI_M_SOC_AWADDR1 Tile_X0Y5_WW4END[1] Tile_X0Y5_WW4END[9] Tile_X0Y5_W6END[1]
+ _4452_/X _2269_/Q _2268_/Q VPWR VGND sg13cmos5l_mux4_1
X_0852_ _0852_/Q Tile_X0Y9_FrameData[11] VGND VPWR Tile_X0Y9_FrameStrobe[5] latch
XFILLER_146_227 VPWR VGND sg13cmos5l_fill_2
X_3571_ Tile_X0Y9_FrameData_O[1] Tile_X0Y9_FrameData[1] VPWR VGND sg13cmos5l_buf_1
XFILLER_564_28 VPWR VGND sg13cmos5l_decap_8
XFILLER_347_63 VPWR VGND sg13cmos5l_decap_8
X_0783_ _0783_/Q Tile_X0Y9_FrameData[16] VGND VPWR Tile_X0Y9_FrameStrobe[3] latch
XFILLER_697_228 VPWR VGND sg13cmos5l_fill_1
XFILLER_494_91 VPWR VGND sg13cmos5l_decap_8
X_2522_ _2522_/Q Tile_X0Y6_FrameData[13] VGND VPWR Tile_X0Y9_FrameStrobe[2] latch
XFILLER_504_140 VPWR VGND sg13cmos5l_decap_8
XFILLER_504_173 VPWR VGND sg13cmos5l_decap_8
X_2453_ _2453_/Q Tile_X0Y6_FrameData[18] VGND VPWR Tile_X0Y9_FrameStrobe[0] latch
XFILLER_665_125 VPWR VGND sg13cmos5l_decap_4
XFILLER_216_56 VPWR VGND sg13cmos5l_decap_8
X_1404_ _1404_/Q Tile_X0Y1_FrameData[29] VGND VPWR Tile_X0Y9_FrameStrobe[7] latch
X_2384_ _2384_/Q Tile_X0Y5_FrameData[21] VGND VPWR Tile_X0Y9_FrameStrobe[6] latch
XFILLER_580_49 VPWR VGND sg13cmos5l_decap_8
XFILLER_363_84 VPWR VGND sg13cmos5l_decap_8
XFILLER_513_21 VPWR VGND sg13cmos5l_decap_8
X_4123_ _4123_/X _4095_/X _0094_/X _4094_/X Tile_X0Y0_S4END[11] _1467_/Q _1466_/Q
+ VPWR VGND sg13cmos5l_mux4_1
X_1335_ _1335_/Q Tile_X0Y1_FrameData[2] VGND VPWR Tile_X0Y9_FrameStrobe[4] latch
XFILLER_606_203 VPWR VGND sg13cmos5l_decap_8
XFILLER_680_139 VPWR VGND sg13cmos5l_decap_4
XFILLER_83_203 VPWR VGND sg13cmos5l_fill_1
XFILLER_673_191 VPWR VGND sg13cmos5l_fill_1
X_4054_ _4054_/X Tile_X0Y2_W2END[1] AXI_M_SOC_AWREADY _4099_/X _4098_/X _1565_/Q _1564_/Q
+ VPWR VGND sg13cmos5l_mux4_1
X_1266_ _1266_/Q Tile_X0Y1_FrameData[7] VGND VPWR Tile_X0Y9_FrameStrobe[2] latch
XFILLER_589_14 VPWR VGND sg13cmos5l_decap_8
XFILLER_513_98 VPWR VGND sg13cmos5l_decap_8
XFILLER_283_175 VPWR VGND sg13cmos5l_decap_8
X_3005_ Tile_X0Y5_E2BEGb[0] _4380_/X VPWR VGND sg13cmos5l_buf_1
X_0217_ _0217_/Q Tile_X0Y7_FrameData[6] VGND VPWR Tile_X0Y9_FrameStrobe[1] latch
XFILLER_36_130 VPWR VGND sg13cmos5l_decap_4
XFILLER_232_77 VPWR VGND sg13cmos5l_fill_1
XFILLER_36_141 VPWR VGND sg13cmos5l_decap_8
X_1197_ _1197_/Q Tile_X0Y1_FrameData[12] VGND VPWR Tile_X0Y9_FrameStrobe[0] latch
X_0148_ AXI_M_SOC_ARCACHE2 _0929_/Q _3776_/X VPWR VGND sg13cmos5l_nor2b_1
XFILLER_586_143 VPWR VGND sg13cmos5l_decap_8
XFILLER_385_205 VPWR VGND sg13cmos5l_fill_2
X_0079_ _0079_/X _4105_/X _4106_/X _2669_/Q VPWR VGND sg13cmos5l_mux2_1
X_3907_ _3907_/X _4014_/X _4018_/X _3999_/X _3993_/X _1395_/Q _1394_/Q VPWR VGND sg13cmos5l_mux4_1
X_4887_ _4887_/X AXI_M_SOC_RDATA3 _4920_/X _4924_/X _4907_/X _0769_/Q _0768_/Q VPWR
+ VGND sg13cmos5l_mux4_1
X_3838_ _3838_/X _0085_/X Tile_X0Y0_S4END[2] _3872_/X _3871_/X _1029_/Q _1028_/Q VPWR
+ VGND sg13cmos5l_mux4_1
XFILLER_538_84 VPWR VGND sg13cmos5l_decap_8
XFILLER_538_95 VPWR VGND sg13cmos5l_fill_2
XFILLER_688_206 VPWR VGND sg13cmos5l_fill_1
XFILLER_474_28 VPWR VGND sg13cmos5l_decap_8
XFILLER_257_63 VPWR VGND sg13cmos5l_decap_8
XFILLER_688_228 VPWR VGND sg13cmos5l_fill_1
X_3769_ _3769_/X Tile_X0Y1_WW4END[2] Tile_X0Y1_WW4END[10] Tile_X0Y1_W6END[10] _4018_/X
+ _1237_/Q _1236_/Q VPWR VGND sg13cmos5l_mux4_1
XFILLER_353_168 VPWR VGND sg13cmos5l_decap_8
XFILLER_407_77 VPWR VGND sg13cmos5l_decap_4
XFILLER_10_56 VPWR VGND sg13cmos5l_decap_8
XFILLER_510_143 VPWR VGND sg13cmos5l_decap_4
XFILLER_126_56 VPWR VGND sg13cmos5l_decap_8
XFILLER_704_42 VPWR VGND sg13cmos5l_decap_8
XFILLER_656_147 VPWR VGND sg13cmos5l_decap_8
XFILLER_490_49 VPWR VGND sg13cmos5l_decap_8
XFILLER_266_109 VPWR VGND sg13cmos5l_decap_8
XFILLER_273_84 VPWR VGND sg13cmos5l_decap_8
XFILLER_423_21 VPWR VGND sg13cmos5l_decap_8
XFILLER_86_49 VPWR VGND sg13cmos5l_fill_2
XFILLER_120_149 VPWR VGND sg13cmos5l_decap_8
XFILLER_19_21 VPWR VGND sg13cmos5l_decap_8
XFILLER_381_7 VPWR VGND sg13cmos5l_decap_8
XFILLER_479_7 VPWR VGND sg13cmos5l_decap_8
XFILLER_463_220 VPWR VGND sg13cmos5l_decap_8
XFILLER_423_98 VPWR VGND sg13cmos5l_decap_8
XFILLER_499_14 VPWR VGND sg13cmos5l_decap_8
XFILLER_142_77 VPWR VGND sg13cmos5l_decap_8
XFILLER_646_7 VPWR VGND sg13cmos5l_decap_8
XANTENNA__3103__X Tile_X0Y7_E6BEG[1] VPWR VGND sg13cmos5l_antennanp
XFILLER_649_28 VPWR VGND sg13cmos5l_decap_8
XFILLER_42_111 VPWR VGND sg13cmos5l_decap_4
XFILLER_35_42 VPWR VGND sg13cmos5l_decap_8
XFILLER_431_161 VPWR VGND sg13cmos5l_decap_8
XFILLER_579_91 VPWR VGND sg13cmos5l_decap_8
XFILLER_577_154 VPWR VGND sg13cmos5l_decap_8
XFILLER_230_212 VPWR VGND sg13cmos5l_decap_8
XANTENNA__2942__X Tile_X0Y8_E6BEG[10] VPWR VGND sg13cmos5l_antennanp
XFILLER_298_70 VPWR VGND sg13cmos5l_decap_8
XFILLER_329_110 VPWR VGND sg13cmos5l_decap_8
XFILLER_51_41 VPWR VGND sg13cmos5l_decap_8
XFILLER_136_0 VPWR VGND sg13cmos5l_decap_8
XFILLER_665_49 VPWR VGND sg13cmos5l_decap_8
XFILLER_384_28 VPWR VGND sg13cmos5l_decap_8
XFILLER_679_228 VPWR VGND sg13cmos5l_fill_1
XFILLER_51_96 VPWR VGND sg13cmos5l_decap_8
XFILLER_167_63 VPWR VGND sg13cmos5l_decap_8
XFILLER_303_0 VPWR VGND sg13cmos5l_decap_8
XFILLER_167_96 VPWR VGND sg13cmos5l_decap_8
XFILLER_344_179 VPWR VGND sg13cmos5l_fill_2
XFILLER_498_161 VPWR VGND sg13cmos5l_decap_8
XFILLER_647_147 VPWR VGND sg13cmos5l_decap_8
XFILLER_614_42 VPWR VGND sg13cmos5l_decap_8
XFILLER_501_154 VPWR VGND sg13cmos5l_decap_8
XFILLER_183_84 VPWR VGND sg13cmos5l_decap_4
XFILLER_333_21 VPWR VGND sg13cmos5l_decap_8
XFILLER_672_0 VPWR VGND sg13cmos5l_decap_8
XFILLER_25_7 VPWR VGND sg13cmos5l_decap_8
X_1120_ _1120_/Q Tile_X0Y0_FrameData[11] VGND VPWR Tile_X0Y9_FrameStrobe[5] latch
XFILLER_265_142 VPWR VGND sg13cmos5l_decap_8
XFILLER_333_87 VPWR VGND sg13cmos5l_fill_1
XFILLER_265_164 VPWR VGND sg13cmos5l_decap_8
XFILLER_280_112 VPWR VGND sg13cmos5l_decap_8
X_1051_ _1051_/Q Tile_X0Y0_FrameData[16] VGND VPWR Tile_X0Y9_FrameStrobe[3] latch
XFILLER_630_63 VPWR VGND sg13cmos5l_decap_8
XFILLER_603_228 VPWR VGND sg13cmos5l_fill_1
XFILLER_202_14 VPWR VGND sg13cmos5l_decap_8
XANTENNA__3013__X Tile_X0Y5_E6BEG[0] VPWR VGND sg13cmos5l_antennanp
XFILLER_18_163 VPWR VGND sg13cmos5l_decap_8
XFILLER_18_174 VPWR VGND sg13cmos5l_fill_2
XFILLER_559_28 VPWR VGND sg13cmos5l_decap_8
XFILLER_280_189 VPWR VGND sg13cmos5l_fill_2
XFILLER_568_154 VPWR VGND sg13cmos5l_decap_8
XFILLER_489_91 VPWR VGND sg13cmos5l_decap_8
XFILLER_422_161 VPWR VGND sg13cmos5l_decap_8
XANTENNA__2852__X Tile_X0Y6_E6BEG[1] VPWR VGND sg13cmos5l_antennanp
X_4810_ _4810_/X _4781_/X Tile_X0Y9_N4END[6] _4780_/X _0075_/X _0451_/Q _0450_/Q VPWR
+ VGND sg13cmos5l_mux4_1
XFILLER_568_187 VPWR VGND sg13cmos5l_decap_8
X_4741_ _4741_/X Tile_X0Y8_W2END[2] AXI_M_SOC_RDATA10 _4789_/X _4788_/X _0565_/Q _0564_/Q
+ VPWR VGND sg13cmos5l_mux4_1
X_1953_ _1953_/Q Tile_X0Y4_FrameData[4] VGND VPWR Tile_X0Y9_FrameStrobe[0] latch
X_0904_ _0904_/Q Tile_X0Y9_FrameData[23] VGND VPWR Tile_X0Y9_FrameStrobe[7] latch
X_1884_ _1884_/Q Tile_X0Y3_FrameData[13] VGND VPWR Tile_X0Y9_FrameStrobe[6] latch
X_4672_ _4672_/X _4595_/X _4711_/X _4710_/X _4594_/X _0173_/Q _0172_/Q VPWR VGND sg13cmos5l_mux4_1
XFILLER_575_49 VPWR VGND sg13cmos5l_decap_8
XFILLER_358_84 VPWR VGND sg13cmos5l_decap_8
XFILLER_335_102 VPWR VGND sg13cmos5l_decap_8
XFILLER_508_21 VPWR VGND sg13cmos5l_decap_8
XFILLER_524_224 VPWR VGND sg13cmos5l_decap_4
X_0835_ _0835_/Q Tile_X0Y9_FrameData[28] VGND VPWR Tile_X0Y9_FrameStrobe[5] latch
X_3623_ Tile_X0Y9_S4BEG[1] _3623_/A VPWR VGND sg13cmos5l_buf_1
XFILLER_294_28 VPWR VGND sg13cmos5l_decap_8
XFILLER_350_105 VPWR VGND sg13cmos5l_decap_8
X_0766_ _0766_/Q Tile_X0Y9_FrameData[1] VGND VPWR Tile_X0Y9_FrameStrobe[2] latch
X_3554_ Tile_X0Y9_EE4BEG[0] _4864_/X VPWR VGND sg13cmos5l_buf_1
XFILLER_508_98 VPWR VGND sg13cmos5l_decap_8
XFILLER_51_0 VPWR VGND sg13cmos5l_fill_1
XFILLER_489_161 VPWR VGND sg13cmos5l_decap_8
X_2505_ _2505_/Q Tile_X0Y6_FrameData[30] VGND VPWR Tile_X0Y9_FrameStrobe[2] latch
XFILLER_343_190 VPWR VGND sg13cmos5l_decap_4
XFILLER_227_77 VPWR VGND sg13cmos5l_decap_8
X_3485_ Tile_X0Y1_EE4BEG[11] _3959_/X VPWR VGND sg13cmos5l_buf_1
X_0697_ _0697_/Q Tile_X0Y9_FrameData[6] VGND VPWR Tile_X0Y9_FrameStrobe[0] latch
XFILLER_524_42 VPWR VGND sg13cmos5l_decap_8
XFILLER_102_105 VPWR VGND sg13cmos5l_decap_8
X_2436_ _2436_/Q Tile_X0Y5_FrameData[1] VGND VPWR Tile_X0Y9_FrameStrobe[7] latch
XFILLER_638_147 VPWR VGND sg13cmos5l_decap_8
XFILLER_671_70 VPWR VGND sg13cmos5l_decap_8
XFILLER_243_21 VPWR VGND sg13cmos5l_decap_8
X_2367_ _2367_/Q Tile_X0Y5_FrameData[6] VGND VPWR Tile_X0Y9_FrameStrobe[5] latch
X_1318_ _1318_/Q Tile_X0Y1_FrameData[19] VGND VPWR Tile_X0Y9_FrameStrobe[4] latch
X_4106_ _4106_/X _4572_/X _4576_/X _4580_/X _4553_/X _2671_/Q _2670_/Q VPWR VGND sg13cmos5l_mux4_1
XFILLER_390_93 VPWR VGND sg13cmos5l_decap_8
X_2298_ _2298_/Q Tile_X0Y5_FrameData[11] VGND VPWR Tile_X0Y9_FrameStrobe[3] latch
XFILLER_256_164 VPWR VGND sg13cmos5l_decap_8
XFILLER_256_186 VPWR VGND sg13cmos5l_decap_8
X_4037_ _4037_/X _4091_/X Tile_X0Y2_WW4END[5] _4090_/X AXI_M_SOC_AWREADY _1599_/Q
+ _1598_/Q VPWR VGND sg13cmos5l_mux4_1
XFILLER_540_63 VPWR VGND sg13cmos5l_decap_8
X_1249_ _1249_/Q Tile_X0Y1_FrameData[24] VGND VPWR Tile_X0Y9_FrameStrobe[2] latch
XFILLER_112_14 VPWR VGND sg13cmos5l_decap_8
XFILLER_469_28 VPWR VGND sg13cmos5l_decap_8
XFILLER_271_189 VPWR VGND sg13cmos5l_decap_4
XANTENNA__2762__X Tile_X0Y3_FrameData_O[20] VPWR VGND sg13cmos5l_antennanp
XFILLER_413_172 VPWR VGND sg13cmos5l_decap_4
XFILLER_24_199 VPWR VGND sg13cmos5l_fill_2
X_4939_ _4939_/X Tile_X0Y8_W1END[3] Tile_X0Y8_W2MID[0] Tile_X0Y8_W2END[0] _4784_/X
+ _0613_/Q _0612_/Q VPWR VGND sg13cmos5l_mux4_1
XFILLER_268_40 VPWR VGND sg13cmos5l_decap_8
XFILLER_574_168 VPWR VGND sg13cmos5l_decap_8
XANTENNA_40 Tile_X0Y9_N2MID[1] VPWR VGND sg13cmos5l_antennanp
XFILLER_485_49 VPWR VGND sg13cmos5l_decap_8
XFILLER_227_7 VPWR VGND sg13cmos5l_decap_8
XANTENNA_51 Tile_X0Y9_N2MID[5] VPWR VGND sg13cmos5l_antennanp
XFILLER_716_162 VPWR VGND sg13cmos5l_fill_1
XFILLER_418_21 VPWR VGND sg13cmos5l_decap_8
XFILLER_326_146 VPWR VGND sg13cmos5l_decap_8
XFILLER_192_152 VPWR VGND sg13cmos5l_decap_4
XANTENNA__3593__X Tile_X0Y9_FrameData_O[23] VPWR VGND sg13cmos5l_antennanp
XFILLER_326_179 VPWR VGND sg13cmos5l_decap_8
XFILLER_21_77 VPWR VGND sg13cmos5l_decap_8
XFILLER_418_98 VPWR VGND sg13cmos5l_decap_4
XFILLER_279_201 VPWR VGND sg13cmos5l_decap_4
XFILLER_21_88 VPWR VGND sg13cmos5l_fill_2
XFILLER_137_77 VPWR VGND sg13cmos5l_decap_8
XFILLER_596_7 VPWR VGND sg13cmos5l_decap_8
XFILLER_434_42 VPWR VGND sg13cmos5l_decap_8
XFILLER_629_147 VPWR VGND sg13cmos5l_fill_2
XFILLER_581_70 VPWR VGND sg13cmos5l_decap_8
XFILLER_294_215 VPWR VGND sg13cmos5l_decap_4
XFILLER_153_21 VPWR VGND sg13cmos5l_decap_8
XFILLER_495_175 VPWR VGND sg13cmos5l_decap_8
XANTENNA__2937__X Tile_X0Y8_E6BEG[5] VPWR VGND sg13cmos5l_antennanp
XFILLER_303_35 VPWR VGND sg13cmos5l_decap_8
XFILLER_451_201 VPWR VGND sg13cmos5l_decap_4
XFILLER_652_161 VPWR VGND sg13cmos5l_decap_8
XFILLER_451_212 VPWR VGND sg13cmos5l_decap_8
XFILLER_46_41 VPWR VGND sg13cmos5l_decap_8
XFILLER_450_63 VPWR VGND sg13cmos5l_fill_1
XFILLER_262_123 VPWR VGND sg13cmos5l_decap_8
XFILLER_62_228 VPWR VGND sg13cmos5l_fill_1
XFILLER_379_28 VPWR VGND sg13cmos5l_decap_8
XFILLER_15_111 VPWR VGND sg13cmos5l_fill_2
XFILLER_253_0 VPWR VGND sg13cmos5l_decap_8
XFILLER_404_172 VPWR VGND sg13cmos5l_fill_2
XFILLER_15_144 VPWR VGND sg13cmos5l_fill_1
XFILLER_600_77 VPWR VGND sg13cmos5l_decap_8
XFILLER_600_88 VPWR VGND sg13cmos5l_fill_2
XFILLER_15_166 VPWR VGND sg13cmos5l_fill_2
XFILLER_102_91 VPWR VGND sg13cmos5l_decap_8
XFILLER_62_51 VPWR VGND sg13cmos5l_decap_8
XFILLER_30_125 VPWR VGND sg13cmos5l_decap_4
XFILLER_420_0 VPWR VGND sg13cmos5l_decap_8
XFILLER_565_157 VPWR VGND sg13cmos5l_decap_8
XFILLER_175_108 VPWR VGND sg13cmos5l_fill_1
XFILLER_518_0 VPWR VGND sg13cmos5l_decap_8
XFILLER_707_140 VPWR VGND sg13cmos5l_decap_8
XFILLER_62_95 VPWR VGND sg13cmos5l_fill_2
XFILLER_609_42 VPWR VGND sg13cmos5l_decap_8
XFILLER_580_105 VPWR VGND sg13cmos5l_decap_8
XFILLER_565_179 VPWR VGND sg13cmos5l_decap_4
XFILLER_168_171 VPWR VGND sg13cmos5l_decap_8
XFILLER_395_49 VPWR VGND sg13cmos5l_decap_8
XFILLER_506_213 VPWR VGND sg13cmos5l_fill_1
XFILLER_7_35 VPWR VGND sg13cmos5l_decap_8
XFILLER_328_21 VPWR VGND sg13cmos5l_decap_8
XFILLER_692_14 VPWR VGND sg13cmos5l_fill_2
X_0620_ _0620_/Q Tile_X0Y8_FrameData[19] VGND VPWR Tile_X0Y9_FrameStrobe[6] latch
XFILLER_332_105 VPWR VGND sg13cmos5l_fill_2
XFILLER_475_93 VPWR VGND sg13cmos5l_fill_1
XFILLER_521_216 VPWR VGND sg13cmos5l_fill_2
X_0551_ _0551_/Q Tile_X0Y8_FrameData[24] VGND VPWR Tile_X0Y9_FrameStrobe[4] latch
XFILLER_625_63 VPWR VGND sg13cmos5l_decap_8
XANTENNA__3008__X Tile_X0Y5_E2BEGb[3] VPWR VGND sg13cmos5l_antennanp
XFILLER_344_42 VPWR VGND sg13cmos5l_decap_8
X_3270_ Tile_X0Y0_EE4BEG[6] _3826_/X VPWR VGND sg13cmos5l_buf_1
X_0482_ _0482_/Q Tile_X0Y8_FrameData[29] VGND VPWR Tile_X0Y9_FrameStrobe[2] latch
XFILLER_491_70 VPWR VGND sg13cmos5l_decap_8
XFILLER_285_215 VPWR VGND sg13cmos5l_fill_2
XFILLER_97_147 VPWR VGND sg13cmos5l_decap_8
XFILLER_87_70 VPWR VGND sg13cmos5l_decap_8
X_2221_ _2221_/Q Tile_X0Y5_FrameData[24] VGND VPWR Tile_X0Y9_FrameStrobe[1] latch
XANTENNA__2847__X Tile_X0Y6_E2BEGb[4] VPWR VGND sg13cmos5l_antennanp
XFILLER_238_142 VPWR VGND sg13cmos5l_decap_4
X_2152_ _2152_/Q Tile_X0Y4_FrameData[29] VGND VPWR Tile_X0Y9_FrameStrobe[7] latch
XFILLER_641_84 VPWR VGND sg13cmos5l_decap_8
XFILLER_213_35 VPWR VGND sg13cmos5l_decap_8
XFILLER_253_101 VPWR VGND sg13cmos5l_fill_2
X_1103_ _1103_/Q Tile_X0Y0_FrameData[28] VGND VPWR Tile_X0Y9_FrameStrobe[5] latch
XFILLER_643_161 VPWR VGND sg13cmos5l_decap_8
XFILLER_360_63 VPWR VGND sg13cmos5l_decap_8
XFILLER_238_197 VPWR VGND sg13cmos5l_fill_2
X_2083_ _2083_/Q Tile_X0Y4_FrameData[2] VGND VPWR Tile_X0Y9_FrameStrobe[4] latch
XFILLER_399_116 VPWR VGND sg13cmos5l_decap_8
X_1034_ _1034_/Q Tile_X0Y0_FrameData[1] VGND VPWR Tile_X0Y9_FrameStrobe[2] latch
XFILLER_253_167 VPWR VGND sg13cmos5l_decap_8
XFILLER_402_109 VPWR VGND sg13cmos5l_decap_8
XFILLER_289_28 VPWR VGND sg13cmos5l_decap_8
XFILLER_253_189 VPWR VGND sg13cmos5l_decap_8
XFILLER_510_77 VPWR VGND sg13cmos5l_decap_8
XFILLER_99_0 VPWR VGND sg13cmos5l_decap_8
X_2985_ Tile_X0Y8_FrameData_O[25] Tile_X0Y8_FrameData[25] VPWR VGND sg13cmos5l_buf_1
XFILLER_519_42 VPWR VGND sg13cmos5l_decap_8
X_4724_ _4724_/X _4777_/X _4776_/X AXI_M_SOC_RDATA11 AXI_M_SOC_RDATA15 _0599_/Q _0598_/Q
+ VPWR VGND sg13cmos5l_mux4_1
XFILLER_571_105 VPWR VGND sg13cmos5l_decap_8
XFILLER_308_102 VPWR VGND sg13cmos5l_decap_8
X_1936_ _1936_/Q Tile_X0Y4_FrameData[21] VGND VPWR Tile_X0Y9_FrameStrobe[0] latch
XFILLER_666_70 VPWR VGND sg13cmos5l_decap_8
XFILLER_238_21 VPWR VGND sg13cmos5l_decap_8
X_4655_ _4655_/X AXI_M_SOC_RDATA23 _4684_/X _4688_/X _4668_/X _0249_/Q _0248_/Q VPWR
+ VGND sg13cmos5l_mux4_1
X_1867_ _1867_/Q Tile_X0Y3_FrameData[30] VGND VPWR Tile_X0Y9_FrameStrobe[6] latch
XFILLER_308_168 VPWR VGND sg13cmos5l_decap_4
XFILLER_713_154 VPWR VGND sg13cmos5l_decap_8
X_3606_ Tile_X0Y9_S2BEG[0] _4828_/X VPWR VGND sg13cmos5l_buf_1
X_0818_ _0818_/Q Tile_X0Y9_FrameData[13] VGND VPWR Tile_X0Y9_FrameStrobe[4] latch
X_1798_ _1798_/Q Tile_X0Y3_FrameData[3] VGND VPWR Tile_X0Y9_FrameStrobe[3] latch
X_4586_ _4586_/X Tile_X0Y5_W2MID[6] Tile_X0Y5_W2END[6] Tile_X0Y5_W6END[9] _4430_/X
+ _2393_/Q _2392_/Q VPWR VGND sg13cmos5l_mux4_1
X_3537_ Tile_X0Y9_E2BEGb[3] _4859_/X VPWR VGND sg13cmos5l_buf_1
XFILLER_535_63 VPWR VGND sg13cmos5l_decap_8
XFILLER_107_14 VPWR VGND sg13cmos5l_decap_8
X_0749_ _0749_/Q Tile_X0Y9_FrameData[18] VGND VPWR Tile_X0Y9_FrameStrobe[2] latch
XFILLER_682_91 VPWR VGND sg13cmos5l_decap_8
XFILLER_254_42 VPWR VGND sg13cmos5l_decap_8
XFILLER_88_125 VPWR VGND sg13cmos5l_decap_8
X_3468_ Tile_X0Y1_FrameData_O[26] Tile_X0Y1_FrameData[26] VPWR VGND sg13cmos5l_buf_1
XFILLER_492_112 VPWR VGND sg13cmos5l_decap_8
XANTENNA__2757__X Tile_X0Y3_FrameData_O[15] VPWR VGND sg13cmos5l_antennanp
X_2419_ _2419_/Q Tile_X0Y5_FrameData[18] VGND VPWR Tile_X0Y9_FrameStrobe[7] latch
X_3399_ Tile_X0Y2_E2BEG[2] _4042_/X VPWR VGND sg13cmos5l_buf_1
XFILLER_29_203 VPWR VGND sg13cmos5l_decap_8
XFILLER_404_56 VPWR VGND sg13cmos5l_decap_8
XFILLER_291_207 VPWR VGND sg13cmos5l_decap_4
XFILLER_551_84 VPWR VGND sg13cmos5l_decap_8
XFILLER_123_35 VPWR VGND sg13cmos5l_decap_8
XFILLER_701_21 VPWR VGND sg13cmos5l_decap_8
XFILLER_433_201 VPWR VGND sg13cmos5l_decap_8
XFILLER_433_212 VPWR VGND sg13cmos5l_fill_1
XFILLER_270_63 VPWR VGND sg13cmos5l_decap_8
XFILLER_83_28 VPWR VGND sg13cmos5l_decap_8
XFILLER_44_206 VPWR VGND sg13cmos5l_decap_8
XFILLER_177_7 VPWR VGND sg13cmos5l_decap_8
XFILLER_44_228 VPWR VGND sg13cmos5l_fill_1
XFILLER_199_28 VPWR VGND sg13cmos5l_decap_8
XFILLER_701_98 VPWR VGND sg13cmos5l_decap_8
XANTENNA__3588__X Tile_X0Y9_FrameData_O[18] VPWR VGND sg13cmos5l_antennanp
XFILLER_420_77 VPWR VGND sg13cmos5l_decap_8
XFILLER_344_7 VPWR VGND sg13cmos5l_decap_8
XFILLER_16_77 VPWR VGND sg13cmos5l_decap_8
XFILLER_401_142 VPWR VGND sg13cmos5l_fill_1
XFILLER_12_114 VPWR VGND sg13cmos5l_fill_2
XFILLER_32_10 VPWR VGND sg13cmos5l_decap_8
XFILLER_200_226 VPWR VGND sg13cmos5l_fill_2
XFILLER_157_119 VPWR VGND sg13cmos5l_decap_4
XFILLER_562_105 VPWR VGND sg13cmos5l_decap_8
XFILLER_511_7 VPWR VGND sg13cmos5l_decap_8
XFILLER_429_42 VPWR VGND sg13cmos5l_decap_8
XFILLER_609_7 VPWR VGND sg13cmos5l_decap_8
XFILLER_576_70 VPWR VGND sg13cmos5l_decap_8
XFILLER_148_21 VPWR VGND sg13cmos5l_decap_8
XFILLER_562_138 VPWR VGND sg13cmos5l_fill_1
XFILLER_165_130 VPWR VGND sg13cmos5l_fill_2
XFILLER_32_87 VPWR VGND sg13cmos5l_fill_2
XFILLER_704_154 VPWR VGND sg13cmos5l_decap_4
XFILLER_165_185 VPWR VGND sg13cmos5l_fill_2
XFILLER_649_209 VPWR VGND sg13cmos5l_decap_8
XFILLER_180_122 VPWR VGND sg13cmos5l_decap_8
XFILLER_148_98 VPWR VGND sg13cmos5l_decap_4
XFILLER_570_182 VPWR VGND sg13cmos5l_decap_8
XFILLER_662_28 VPWR VGND sg13cmos5l_decap_8
XFILLER_445_63 VPWR VGND sg13cmos5l_decap_8
XFILLER_445_74 VPWR VGND sg13cmos5l_fill_2
XFILLER_592_91 VPWR VGND sg13cmos5l_decap_8
XFILLER_180_188 VPWR VGND sg13cmos5l_decap_8
XFILLER_164_42 VPWR VGND sg13cmos5l_decap_8
XFILLER_322_182 VPWR VGND sg13cmos5l_decap_8
XFILLER_164_97 VPWR VGND sg13cmos5l_decap_8
XFILLER_314_56 VPWR VGND sg13cmos5l_decap_8
XFILLER_483_189 VPWR VGND sg13cmos5l_decap_4
XFILLER_370_0 VPWR VGND sg13cmos5l_decap_8
XFILLER_611_21 VPWR VGND sg13cmos5l_decap_8
XFILLER_57_84 VPWR VGND sg13cmos5l_decap_8
XFILLER_468_0 VPWR VGND sg13cmos5l_decap_8
XFILLER_235_123 VPWR VGND sg13cmos5l_decap_8
XFILLER_180_63 VPWR VGND sg13cmos5l_decap_8
XFILLER_235_145 VPWR VGND sg13cmos5l_decap_8
XFILLER_687_14 VPWR VGND sg13cmos5l_decap_8
XFILLER_611_98 VPWR VGND sg13cmos5l_decap_4
XFILLER_250_104 VPWR VGND sg13cmos5l_fill_1
XFILLER_640_175 VPWR VGND sg13cmos5l_decap_8
XFILLER_635_0 VPWR VGND sg13cmos5l_decap_8
XANTENNA__3498__X Tile_X0Y1_E6BEG[8] VPWR VGND sg13cmos5l_antennanp
XFILLER_330_77 VPWR VGND sg13cmos5l_fill_1
XFILLER_330_99 VPWR VGND sg13cmos5l_decap_8
XFILLER_188_222 VPWR VGND sg13cmos5l_decap_8
XFILLER_92_7 VPWR VGND sg13cmos5l_decap_8
XFILLER_553_105 VPWR VGND sg13cmos5l_decap_8
XFILLER_339_42 VPWR VGND sg13cmos5l_decap_8
X_2770_ Tile_X0Y3_FrameData_O[28] Tile_X0Y3_FrameData[28] VPWR VGND sg13cmos5l_buf_1
XFILLER_486_70 VPWR VGND sg13cmos5l_decap_8
X_1721_ _1721_/Q Tile_X0Y3_FrameData[16] VGND VPWR Tile_X0Y9_FrameStrobe[1] latch
X_1652_ _1652_/Q Tile_X0Y2_FrameData[29] VGND VPWR Tile_X0Y9_FrameStrobe[7] latch
X_4440_ _4440_/X _4013_/X _4017_/X _4002_/X _3992_/X _1362_/Q _1361_/Q VPWR VGND sg13cmos5l_mux4_1
XFILLER_305_116 VPWR VGND sg13cmos5l_decap_4
XFILLER_305_127 VPWR VGND sg13cmos5l_decap_8
XFILLER_636_84 VPWR VGND sg13cmos5l_decap_8
XFILLER_208_35 VPWR VGND sg13cmos5l_decap_8
X_0603_ _0603_/Q Tile_X0Y8_FrameData[4] VGND VPWR Tile_X0Y9_FrameStrobe[5] latch
XFILLER_572_28 VPWR VGND sg13cmos5l_decap_8
XFILLER_355_63 VPWR VGND sg13cmos5l_decap_8
X_1583_ _1583_/Q Tile_X0Y2_FrameData[2] VGND VPWR Tile_X0Y9_FrameStrobe[4] latch
X_4371_ _4371_/X _4427_/X _4426_/X AXI_M_SOC_RVALID _4425_/X _2361_/Q _2360_/Q VPWR
+ VGND sg13cmos5l_mux4_1
XFILLER_171_177 VPWR VGND sg13cmos5l_fill_1
XFILLER_710_168 VPWR VGND sg13cmos5l_decap_8
X_0534_ _0534_/Q Tile_X0Y8_FrameData[9] VGND VPWR Tile_X0Y9_FrameStrobe[3] latch
X_3322_ Tile_X0Y4_EE4BEG[10] _4282_/X VPWR VGND sg13cmos5l_buf_1
XFILLER_608_106 VPWR VGND sg13cmos5l_decap_8
XFILLER_505_77 VPWR VGND sg13cmos5l_decap_8
X_0465_ _0465_/Q Tile_X0Y8_FrameData[14] VGND VPWR Tile_X0Y9_FrameStrobe[1] latch
X_3253_ Tile_X0Y0_FrameData_O[21] Tile_X0Y0_FrameData[21] VPWR VGND sg13cmos5l_buf_1
XFILLER_608_139 VPWR VGND sg13cmos5l_decap_4
XFILLER_224_56 VPWR VGND sg13cmos5l_decap_8
X_2204_ _2204_/Q Tile_X0Y5_FrameData[9] VGND VPWR Tile_X0Y9_FrameStrobe[0] latch
X_3184_ Tile_X0Y0_N4BEG[8] _3184_/A VPWR VGND sg13cmos5l_buf_1
XFILLER_371_84 VPWR VGND sg13cmos5l_decap_8
X_0396_ _0396_/Q Tile_X0Y7_FrameData[19] VGND VPWR Tile_X0Y9_FrameStrobe[7] latch
XFILLER_521_21 VPWR VGND sg13cmos5l_decap_8
XFILLER_415_201 VPWR VGND sg13cmos5l_decap_8
XFILLER_14_0 VPWR VGND sg13cmos5l_decap_8
XFILLER_616_161 VPWR VGND sg13cmos5l_fill_1
X_2135_ _2135_/Q Tile_X0Y4_FrameData[14] VGND VPWR Tile_X0Y9_FrameStrobe[6] latch
XFILLER_616_194 VPWR VGND sg13cmos5l_fill_2
XFILLER_226_145 VPWR VGND sg13cmos5l_fill_2
XFILLER_631_131 VPWR VGND sg13cmos5l_decap_8
X_2066_ _2066_/Q Tile_X0Y4_FrameData[19] VGND VPWR Tile_X0Y9_FrameStrobe[4] latch
XFILLER_597_14 VPWR VGND sg13cmos5l_decap_8
XFILLER_430_226 VPWR VGND sg13cmos5l_fill_2
X_1017_ _1017_/Q Tile_X0Y0_FrameData[18] VGND VPWR Tile_X0Y9_FrameStrobe[2] latch
XFILLER_241_137 VPWR VGND sg13cmos5l_decap_4
XFILLER_241_148 VPWR VGND sg13cmos5l_decap_8
XANTENNA__3201__X Tile_X0Y0_N2BEG[1] VPWR VGND sg13cmos5l_antennanp
XFILLER_139_119 VPWR VGND sg13cmos5l_decap_8
XFILLER_677_91 VPWR VGND sg13cmos5l_decap_8
XFILLER_529_179 VPWR VGND sg13cmos5l_fill_1
XFILLER_328_219 VPWR VGND sg13cmos5l_fill_2
XFILLER_249_42 VPWR VGND sg13cmos5l_decap_8
XFILLER_194_225 VPWR VGND sg13cmos5l_decap_4
X_2968_ Tile_X0Y8_FrameData_O[8] Tile_X0Y8_FrameData[8] VPWR VGND sg13cmos5l_buf_1
XFILLER_396_70 VPWR VGND sg13cmos5l_decap_8
X_4707_ _4707_/X Tile_X0Y9_W2MID[4] Tile_X0Y9_W2END[4] Tile_X0Y9_W6END[4] _4907_/X
+ _0913_/Q _0912_/Q VPWR VGND sg13cmos5l_mux4_1
X_1919_ _1919_/Q Tile_X0Y3_FrameData[10] VGND VPWR Tile_X0Y9_FrameStrobe[7] latch
XFILLER_147_152 VPWR VGND sg13cmos5l_fill_1
X_2899_ Tile_X0Y6_FrameData_O[20] Tile_X0Y6_FrameData[20] VPWR VGND sg13cmos5l_buf_1
XFILLER_147_174 VPWR VGND sg13cmos5l_decap_8
X_4638_ _4638_/X Tile_X0Y7_WW4END[5] AXI_M_SOC_RDATA21 _4689_/X _4672_/X _0283_/Q
+ _0282_/Q VPWR VGND sg13cmos5l_mux4_1
XFILLER_546_84 VPWR VGND sg13cmos5l_decap_8
XFILLER_118_35 VPWR VGND sg13cmos5l_decap_8
XFILLER_482_28 VPWR VGND sg13cmos5l_decap_8
XFILLER_265_63 VPWR VGND sg13cmos5l_decap_8
X_4569_ _4569_/X _4547_/X Tile_X0Y9_N4END[13] _4546_/X _0153_/X _2493_/Q _2492_/Q
+ VPWR VGND sg13cmos5l_mux4_1
XFILLER_162_177 VPWR VGND sg13cmos5l_fill_2
XFILLER_78_28 VPWR VGND sg13cmos5l_decap_8
XFILLER_311_108 VPWR VGND sg13cmos5l_decap_8
XFILLER_162_188 VPWR VGND sg13cmos5l_fill_1
XFILLER_415_77 VPWR VGND sg13cmos5l_decap_8
XFILLER_294_7 VPWR VGND sg13cmos5l_decap_8
XFILLER_134_56 VPWR VGND sg13cmos5l_decap_8
XFILLER_712_42 VPWR VGND sg13cmos5l_decap_8
XFILLER_264_207 VPWR VGND sg13cmos5l_decap_8
XFILLER_480_104 VPWR VGND sg13cmos5l_fill_2
XFILLER_281_84 VPWR VGND sg13cmos5l_decap_8
XFILLER_431_21 VPWR VGND sg13cmos5l_decap_8
XFILLER_94_49 VPWR VGND sg13cmos5l_decap_8
XFILLER_607_161 VPWR VGND sg13cmos5l_decap_8
XFILLER_217_123 VPWR VGND sg13cmos5l_fill_1
XFILLER_461_7 VPWR VGND sg13cmos5l_decap_8
XFILLER_27_21 VPWR VGND sg13cmos5l_decap_8
XFILLER_559_7 VPWR VGND sg13cmos5l_decap_8
XFILLER_17_217 VPWR VGND sg13cmos5l_fill_1
XFILLER_84_172 VPWR VGND sg13cmos5l_decap_8
XFILLER_217_156 VPWR VGND sg13cmos5l_fill_2
XFILLER_17_228 VPWR VGND sg13cmos5l_fill_1
XFILLER_84_183 VPWR VGND sg13cmos5l_fill_1
XFILLER_622_142 VPWR VGND sg13cmos5l_decap_4
XFILLER_431_98 VPWR VGND sg13cmos5l_decap_8
XFILLER_378_119 VPWR VGND sg13cmos5l_fill_2
XFILLER_150_77 VPWR VGND sg13cmos5l_decap_8
XFILLER_232_148 VPWR VGND sg13cmos5l_decap_8
XFILLER_300_14 VPWR VGND sg13cmos5l_decap_8
XANTENNA__3111__X Tile_X0Y7_E6BEG[9] VPWR VGND sg13cmos5l_antennanp
XFILLER_40_220 VPWR VGND sg13cmos5l_decap_8
XFILLER_657_28 VPWR VGND sg13cmos5l_decap_8
XFILLER_43_42 VPWR VGND sg13cmos5l_decap_8
XFILLER_587_91 VPWR VGND sg13cmos5l_decap_8
XANTENNA__2950__X Tile_X0Y8_EE4BEG[6] VPWR VGND sg13cmos5l_antennanp
XFILLER_159_42 VPWR VGND sg13cmos5l_decap_8
XFILLER_535_116 VPWR VGND sg13cmos5l_decap_8
XFILLER_689_120 VPWR VGND sg13cmos5l_fill_2
XFILLER_216_0 VPWR VGND sg13cmos5l_fill_2
XFILLER_309_56 VPWR VGND sg13cmos5l_decap_8
XFILLER_543_160 VPWR VGND sg13cmos5l_decap_8
XFILLER_153_111 VPWR VGND sg13cmos5l_decap_8
XFILLER_673_49 VPWR VGND sg13cmos5l_decap_8
XFILLER_309_78 VPWR VGND sg13cmos5l_decap_8
XFILLER_138_196 VPWR VGND sg13cmos5l_decap_4
XFILLER_606_21 VPWR VGND sg13cmos5l_decap_8
XFILLER_392_28 VPWR VGND sg13cmos5l_decap_8
XFILLER_175_63 VPWR VGND sg13cmos5l_decap_8
XFILLER_4_14 VPWR VGND sg13cmos5l_decap_8
XFILLER_175_85 VPWR VGND sg13cmos5l_decap_8
XFILLER_606_98 VPWR VGND sg13cmos5l_decap_8
XFILLER_585_0 VPWR VGND sg13cmos5l_decap_8
XFILLER_67_128 VPWR VGND sg13cmos5l_decap_8
XFILLER_622_42 VPWR VGND sg13cmos5l_decap_8
XFILLER_456_156 VPWR VGND sg13cmos5l_decap_8
X_0250_ _0250_/Q Tile_X0Y7_FrameData[5] VGND VPWR Tile_X0Y9_FrameStrobe[2] latch
XFILLER_191_84 VPWR VGND sg13cmos5l_decap_8
XFILLER_341_21 VPWR VGND sg13cmos5l_decap_8
XFILLER_208_112 VPWR VGND sg13cmos5l_decap_8
XFILLER_75_150 VPWR VGND sg13cmos5l_decap_4
X_0181_ _0181_/Q Tile_X0Y7_FrameData[10] VGND VPWR Tile_X0Y9_FrameStrobe[0] latch
XFILLER_698_35 VPWR VGND sg13cmos5l_decap_8
XFILLER_90_131 VPWR VGND sg13cmos5l_decap_8
XFILLER_208_189 VPWR VGND sg13cmos5l_fill_2
XFILLER_613_175 VPWR VGND sg13cmos5l_decap_8
XFILLER_369_119 VPWR VGND sg13cmos5l_decap_8
X_3940_ _3940_/X Tile_X0Y1_W2END[7] AXI_M_SOC_ARREADY _3989_/X _3988_/X _1329_/Q _1328_/Q
+ VPWR VGND sg13cmos5l_mux4_1
XFILLER_210_14 VPWR VGND sg13cmos5l_decap_8
XANTENNA__3021__X Tile_X0Y5_E6BEG[8] VPWR VGND sg13cmos5l_antennanp
XFILLER_377_130 VPWR VGND sg13cmos5l_fill_1
XFILLER_567_28 VPWR VGND sg13cmos5l_decap_8
X_3871_ _3871_/X _3849_/X _0086_/X Tile_X0Y0_S1END[1] Tile_X0Y0_S4END[1] _0969_/Q
+ _0968_/Q VPWR VGND sg13cmos5l_mux4_1
XFILLER_497_91 VPWR VGND sg13cmos5l_decap_8
XANTENNA__2860__X Tile_X0Y6_E6BEG[9] VPWR VGND sg13cmos5l_antennanp
X_2822_ Tile_X0Y4_E2BEG[0] _4256_/X VPWR VGND sg13cmos5l_buf_1
X_2753_ Tile_X0Y3_FrameData_O[11] Tile_X0Y3_FrameData[11] VPWR VGND sg13cmos5l_buf_1
XFILLER_219_56 VPWR VGND sg13cmos5l_decap_8
X_1704_ _1704_/Q Tile_X0Y3_FrameData[1] VGND VPWR Tile_X0Y9_FrameStrobe[0] latch
XFILLER_129_185 VPWR VGND sg13cmos5l_fill_1
XFILLER_583_49 VPWR VGND sg13cmos5l_decap_8
X_2684_ _2684_/Q Tile_X0Y6_FrameData[11] VGND VPWR Tile_X0Y9_FrameStrobe[7] latch
XFILLER_366_84 VPWR VGND sg13cmos5l_decap_8
XFILLER_144_133 VPWR VGND sg13cmos5l_decap_8
XFILLER_516_21 VPWR VGND sg13cmos5l_decap_8
XFILLER_479_226 VPWR VGND sg13cmos5l_fill_2
X_4423_ _4423_/X Tile_X0Y4_W1END[2] Tile_X0Y4_W6END[10] _4350_/X _4306_/X _2141_/Q
+ _2140_/Q VPWR VGND sg13cmos5l_mux4_1
XFILLER_695_112 VPWR VGND sg13cmos5l_decap_8
X_1635_ _1635_/Q Tile_X0Y2_FrameData[14] VGND VPWR Tile_X0Y9_FrameStrobe[6] latch
XANTENNA__3691__X AXI_M_SOC_WDATA1 VPWR VGND sg13cmos5l_antennanp
X_4354_ _4354_/X Tile_X0Y3_W2MID[6] Tile_X0Y3_W2END[6] Tile_X0Y3_W6END[9] _4207_/X
+ _1879_/Q _1878_/Q VPWR VGND sg13cmos5l_mux4_1
X_1566_ _1566_/Q Tile_X0Y2_FrameData[19] VGND VPWR Tile_X0Y9_FrameStrobe[4] latch
XFILLER_516_98 VPWR VGND sg13cmos5l_decap_4
XFILLER_301_130 VPWR VGND sg13cmos5l_decap_8
X_3305_ Tile_X0Y0_E2BEG[5] _3809_/X VPWR VGND sg13cmos5l_buf_1
XFILLER_235_77 VPWR VGND sg13cmos5l_fill_2
X_0517_ _0517_/Q Tile_X0Y8_FrameData[26] VGND VPWR Tile_X0Y9_FrameStrobe[3] latch
X_1497_ _1497_/Q Tile_X0Y2_FrameData[24] VGND VPWR Tile_X0Y9_FrameStrobe[2] latch
X_4285_ _4285_/X Tile_X0Y4_WW4END[2] AXI_M_SOC_BRESP0 _4338_/X _4317_/X _2043_/Q _2042_/Q
+ VPWR VGND sg13cmos5l_mux4_1
XFILLER_301_152 VPWR VGND sg13cmos5l_decap_4
XFILLER_100_203 VPWR VGND sg13cmos5l_decap_8
XFILLER_532_42 VPWR VGND sg13cmos5l_decap_8
X_0448_ _0448_/Q Tile_X0Y8_FrameData[31] VGND VPWR Tile_X0Y9_FrameStrobe[1] latch
X_3236_ Tile_X0Y0_FrameData_O[4] Tile_X0Y0_FrameData[4] VPWR VGND sg13cmos5l_buf_1
XFILLER_301_185 VPWR VGND sg13cmos5l_decap_8
XFILLER_651_215 VPWR VGND sg13cmos5l_fill_2
XFILLER_251_21 VPWR VGND sg13cmos5l_decap_8
XFILLER_532_97 VPWR VGND sg13cmos5l_fill_1
XFILLER_66_150 VPWR VGND sg13cmos5l_decap_8
X_0379_ _0379_/Q Tile_X0Y7_FrameData[4] VGND VPWR Tile_X0Y9_FrameStrobe[6] latch
X_3167_ Tile_X0Y4_E6BEG[4] _4292_/X VPWR VGND sg13cmos5l_buf_1
X_2118_ _2118_/Q Tile_X0Y4_FrameData[31] VGND VPWR Tile_X0Y9_FrameStrobe[6] latch
X_3098_ Tile_X0Y7_E2BEGb[4] _4624_/X VPWR VGND sg13cmos5l_buf_1
XFILLER_401_35 VPWR VGND sg13cmos5l_decap_8
XFILLER_214_126 VPWR VGND sg13cmos5l_decap_8
X_2049_ _2049_/Q Tile_X0Y4_FrameData[4] VGND VPWR Tile_X0Y9_FrameStrobe[3] latch
XFILLER_120_14 VPWR VGND sg13cmos5l_decap_8
XFILLER_477_28 VPWR VGND sg13cmos5l_decap_8
XFILLER_368_152 VPWR VGND sg13cmos5l_decap_4
XFILLER_383_100 VPWR VGND sg13cmos5l_decap_8
XANTENNA__2770__X Tile_X0Y3_FrameData_O[28] VPWR VGND sg13cmos5l_antennanp
XFILLER_167_225 VPWR VGND sg13cmos5l_decap_4
XFILLER_200_91 VPWR VGND sg13cmos5l_decap_8
XFILLER_13_56 VPWR VGND sg13cmos5l_decap_8
XFILLER_532_119 VPWR VGND sg13cmos5l_decap_8
XFILLER_129_56 VPWR VGND sg13cmos5l_decap_8
XFILLER_707_42 VPWR VGND sg13cmos5l_decap_8
XFILLER_307_7 VPWR VGND sg13cmos5l_decap_8
XFILLER_493_49 VPWR VGND sg13cmos5l_decap_8
XFILLER_276_84 VPWR VGND sg13cmos5l_decap_8
XFILLER_426_21 VPWR VGND sg13cmos5l_decap_8
XFILLER_135_133 VPWR VGND sg13cmos5l_decap_8
XFILLER_89_49 VPWR VGND sg13cmos5l_decap_8
XFILLER_686_112 VPWR VGND sg13cmos5l_decap_8
XFILLER_135_188 VPWR VGND sg13cmos5l_decap_8
XFILLER_686_167 VPWR VGND sg13cmos5l_decap_4
XFILLER_540_196 VPWR VGND sg13cmos5l_decap_8
XFILLER_426_98 VPWR VGND sg13cmos5l_decap_8
XFILLER_145_77 VPWR VGND sg13cmos5l_decap_8
XFILLER_676_7 VPWR VGND sg13cmos5l_decap_8
XFILLER_49_106 VPWR VGND sg13cmos5l_decap_8
XANTENNA__3106__X Tile_X0Y7_E6BEG[4] VPWR VGND sg13cmos5l_antennanp
XFILLER_442_42 VPWR VGND sg13cmos5l_decap_8
XFILLER_38_42 VPWR VGND sg13cmos5l_decap_8
XFILLER_161_21 VPWR VGND sg13cmos5l_decap_8
XFILLER_599_119 VPWR VGND sg13cmos5l_fill_2
XANTENNA__2945__X Tile_X0Y8_EE4BEG[1] VPWR VGND sg13cmos5l_antennanp
XFILLER_453_148 VPWR VGND sg13cmos5l_decap_8
XFILLER_38_86 VPWR VGND sg13cmos5l_decap_8
XFILLER_57_194 VPWR VGND sg13cmos5l_decap_8
XFILLER_311_35 VPWR VGND sg13cmos5l_decap_8
XFILLER_205_126 VPWR VGND sg13cmos5l_decap_8
XFILLER_610_112 VPWR VGND sg13cmos5l_fill_2
XFILLER_166_0 VPWR VGND sg13cmos5l_decap_8
XFILLER_668_49 VPWR VGND sg13cmos5l_decap_8
XFILLER_387_28 VPWR VGND sg13cmos5l_decap_8
XFILLER_333_0 VPWR VGND sg13cmos5l_decap_8
XFILLER_508_105 VPWR VGND sg13cmos5l_decap_8
XFILLER_158_225 VPWR VGND sg13cmos5l_decap_4
XFILLER_563_211 VPWR VGND sg13cmos5l_decap_4
XFILLER_110_91 VPWR VGND sg13cmos5l_decap_8
XFILLER_500_0 VPWR VGND sg13cmos5l_decap_8
XFILLER_467_94 VPWR VGND sg13cmos5l_decap_8
XFILLER_70_84 VPWR VGND sg13cmos5l_decap_8
XFILLER_617_42 VPWR VGND sg13cmos5l_decap_8
XFILLER_315_222 VPWR VGND sg13cmos5l_decap_8
XFILLER_516_182 VPWR VGND sg13cmos5l_decap_4
XFILLER_336_21 VPWR VGND sg13cmos5l_decap_8
XFILLER_55_7 VPWR VGND sg13cmos5l_decap_8
XFILLER_677_145 VPWR VGND sg13cmos5l_decap_8
XFILLER_476_207 VPWR VGND sg13cmos5l_decap_4
X_1420_ _1420_/Q Tile_X0Y1_FrameData[13] VGND VPWR Tile_X0Y9_FrameStrobe[7] latch
XFILLER_330_225 VPWR VGND sg13cmos5l_decap_4
XFILLER_677_178 VPWR VGND sg13cmos5l_fill_1
XFILLER_336_98 VPWR VGND sg13cmos5l_decap_4
XFILLER_531_196 VPWR VGND sg13cmos5l_fill_2
XFILLER_141_147 VPWR VGND sg13cmos5l_decap_8
XFILLER_429_112 VPWR VGND sg13cmos5l_decap_8
X_1351_ _1351_/Q Tile_X0Y1_FrameData[18] VGND VPWR Tile_X0Y9_FrameStrobe[5] latch
XFILLER_633_63 VPWR VGND sg13cmos5l_decap_8
XFILLER_205_14 VPWR VGND sg13cmos5l_decap_8
XANTENNA__3016__X Tile_X0Y5_E6BEG[3] VPWR VGND sg13cmos5l_antennanp
X_0302_ _0302_/Q Tile_X0Y7_FrameData[17] VGND VPWR Tile_X0Y9_FrameStrobe[4] latch
XFILLER_352_42 VPWR VGND sg13cmos5l_decap_8
XFILLER_228_207 VPWR VGND sg13cmos5l_decap_8
X_1282_ _1282_/Q Tile_X0Y1_FrameData[23] VGND VPWR Tile_X0Y9_FrameStrobe[3] latch
X_4070_ _4070_/X Tile_X0Y2_WW4END[1] AXI_M_SOC_AWREADY _4117_/X _4099_/X _1533_/Q
+ _1532_/Q VPWR VGND sg13cmos5l_mux4_1
XFILLER_429_189 VPWR VGND sg13cmos5l_decap_8
XFILLER_95_70 VPWR VGND sg13cmos5l_decap_4
X_0233_ _0233_/Q Tile_X0Y7_FrameData[22] VGND VPWR Tile_X0Y9_FrameStrobe[2] latch
X_3021_ Tile_X0Y5_E6BEG[8] _4412_/X VPWR VGND sg13cmos5l_buf_1
XANTENNA__2855__X Tile_X0Y6_E6BEG[4] VPWR VGND sg13cmos5l_antennanp
XFILLER_444_148 VPWR VGND sg13cmos5l_decap_8
XFILLER_444_159 VPWR VGND sg13cmos5l_fill_1
XFILLER_502_56 VPWR VGND sg13cmos5l_decap_8
X_0164_ _0164_/Q Tile_X0Y7_FrameData[27] VGND VPWR Tile_X0Y9_FrameStrobe[0] latch
XFILLER_221_35 VPWR VGND sg13cmos5l_decap_8
XFILLER_452_170 VPWR VGND sg13cmos5l_decap_8
XFILLER_63_153 VPWR VGND sg13cmos5l_decap_8
XFILLER_452_181 VPWR VGND sg13cmos5l_fill_2
XFILLER_598_174 VPWR VGND sg13cmos5l_decap_8
X_0095_ _0095_/X _4003_/X _4004_/X _2407_/Q VPWR VGND sg13cmos5l_mux2_1
XFILLER_578_49 VPWR VGND sg13cmos5l_decap_8
XFILLER_601_156 VPWR VGND sg13cmos5l_decap_4
X_3923_ _3923_/X _4228_/X _4232_/X _4215_/X _4209_/X _1895_/Q _1894_/Q VPWR VGND sg13cmos5l_mux4_1
XFILLER_297_28 VPWR VGND sg13cmos5l_decap_8
XFILLER_554_200 VPWR VGND sg13cmos5l_decap_8
X_3854_ _3854_/X _3901_/X _3900_/X Tile_X0Y0_S2MID[6] Tile_X0Y0_S2END[6] _0951_/Q
+ _0950_/Q VPWR VGND sg13cmos5l_mux4_1
XFILLER_554_211 VPWR VGND sg13cmos5l_fill_1
XFILLER_81_0 VPWR VGND sg13cmos5l_decap_8
XFILLER_365_133 VPWR VGND sg13cmos5l_fill_1
X_2805_ Tile_X0Y3_E2BEGb[3] _4159_/X VPWR VGND sg13cmos5l_buf_1
XFILLER_365_155 VPWR VGND sg13cmos5l_fill_2
X_3785_ _3785_/X Tile_X0Y0_W2MID[6] Tile_X0Y0_W2END[6] Tile_X0Y0_W6END[6] _3855_/X
+ _1167_/Q _1166_/Q VPWR VGND sg13cmos5l_mux4_1
X_0997_ _0997_/Q Tile_X0Y0_FrameData[6] VGND VPWR Tile_X0Y9_FrameStrobe[1] latch
XFILLER_527_42 VPWR VGND sg13cmos5l_decap_8
X_2736_ _3979_/A3 VPWR VGND sg13cmos5l_tielo
XFILLER_117_122 VPWR VGND sg13cmos5l_fill_2
XFILLER_674_70 VPWR VGND sg13cmos5l_decap_8
XFILLER_507_182 VPWR VGND sg13cmos5l_decap_4
XFILLER_246_21 VPWR VGND sg13cmos5l_decap_8
XFILLER_380_158 VPWR VGND sg13cmos5l_fill_1
X_2667_ _2667_/Q Tile_X0Y6_FrameData[28] VGND VPWR Tile_X0Y9_FrameStrobe[7] latch
X_4406_ _4406_/X _0100_/X _0140_/X _4460_/X _4464_/X _2291_/Q _2290_/Q VPWR VGND sg13cmos5l_mux4_1
XFILLER_321_225 VPWR VGND sg13cmos5l_decap_4
X_1618_ _1618_/Q Tile_X0Y2_FrameData[31] VGND VPWR Tile_X0Y9_FrameStrobe[6] latch
XFILLER_132_147 VPWR VGND sg13cmos5l_decap_8
X_2598_ _2598_/Q Tile_X0Y6_FrameData[1] VGND VPWR Tile_X0Y9_FrameStrobe[4] latch
XFILLER_132_169 VPWR VGND sg13cmos5l_decap_8
X_4337_ _4337_/X _4305_/X _0158_/X _4304_/X _0111_/X _1979_/Q _1978_/Q VPWR VGND sg13cmos5l_mux4_1
XFILLER_543_63 VPWR VGND sg13cmos5l_decap_8
XFILLER_115_14 VPWR VGND sg13cmos5l_decap_8
X_1549_ _1549_/Q Tile_X0Y2_FrameData[4] VGND VPWR Tile_X0Y9_FrameStrobe[3] latch
XFILLER_286_140 VPWR VGND sg13cmos5l_decap_4
XFILLER_690_91 VPWR VGND sg13cmos5l_decap_8
XFILLER_286_151 VPWR VGND sg13cmos5l_decap_8
XFILLER_262_42 VPWR VGND sg13cmos5l_decap_8
XFILLER_140_180 VPWR VGND sg13cmos5l_decap_8
X_4268_ _4268_/X Tile_X0Y4_W2END[3] AXI_M_SOC_BRESP1 _4319_/X _4318_/X _2077_/Q _2076_/Q
+ VPWR VGND sg13cmos5l_mux4_1
XFILLER_490_221 VPWR VGND sg13cmos5l_fill_1
XFILLER_435_126 VPWR VGND sg13cmos5l_decap_8
XFILLER_412_12 VPWR VGND sg13cmos5l_decap_8
XANTENNA__2765__X Tile_X0Y3_FrameData_O[23] VPWR VGND sg13cmos5l_antennanp
X_3219_ Tile_X0Y0_FrameStrobe_O[7] Tile_X0Y9_FrameStrobe[7] VPWR VGND sg13cmos5l_buf_1
X_4199_ _4199_/X Tile_X0Y2_W1END[2] Tile_X0Y2_W6END[10] _4107_/X _4086_/X _1633_/Q
+ _1632_/Q VPWR VGND sg13cmos5l_mux4_1
XFILLER_54_131 VPWR VGND sg13cmos5l_decap_8
XFILLER_412_89 VPWR VGND sg13cmos5l_decap_8
XFILLER_131_35 VPWR VGND sg13cmos5l_decap_8
XFILLER_388_225 VPWR VGND sg13cmos5l_decap_4
XFILLER_91_28 VPWR VGND sg13cmos5l_decap_8
XFILLER_488_49 VPWR VGND sg13cmos5l_decap_8
XFILLER_257_7 VPWR VGND sg13cmos5l_decap_8
XANTENNA__3596__X Tile_X0Y9_FrameData_O[26] VPWR VGND sg13cmos5l_antennanp
XFILLER_424_7 VPWR VGND sg13cmos5l_decap_8
XFILLER_24_77 VPWR VGND sg13cmos5l_decap_8
XFILLER_210_140 VPWR VGND sg13cmos5l_decap_8
XFILLER_356_133 VPWR VGND sg13cmos5l_decap_8
XFILLER_155_228 VPWR VGND sg13cmos5l_fill_1
XFILLER_505_119 VPWR VGND sg13cmos5l_decap_8
XFILLER_437_42 VPWR VGND sg13cmos5l_decap_8
XFILLER_40_21 VPWR VGND sg13cmos5l_decap_8
XFILLER_584_70 VPWR VGND sg13cmos5l_decap_8
XFILLER_156_21 VPWR VGND sg13cmos5l_decap_8
XFILLER_123_103 VPWR VGND sg13cmos5l_decap_8
XFILLER_123_114 VPWR VGND sg13cmos5l_fill_1
XFILLER_312_225 VPWR VGND sg13cmos5l_decap_4
XFILLER_123_136 VPWR VGND sg13cmos5l_decap_8
XFILLER_306_35 VPWR VGND sg13cmos5l_decap_8
XFILLER_670_28 VPWR VGND sg13cmos5l_decap_8
XFILLER_453_63 VPWR VGND sg13cmos5l_decap_8
XFILLER_49_52 VPWR VGND sg13cmos5l_decap_8
XFILLER_277_140 VPWR VGND sg13cmos5l_decap_8
XFILLER_172_42 VPWR VGND sg13cmos5l_decap_8
XFILLER_131_180 VPWR VGND sg13cmos5l_fill_2
XFILLER_481_210 VPWR VGND sg13cmos5l_decap_4
XFILLER_615_215 VPWR VGND sg13cmos5l_fill_1
XFILLER_426_126 VPWR VGND sg13cmos5l_decap_8
XFILLER_283_0 VPWR VGND sg13cmos5l_decap_8
XFILLER_481_221 VPWR VGND sg13cmos5l_decap_8
XFILLER_603_77 VPWR VGND sg13cmos5l_decap_8
XFILLER_322_56 VPWR VGND sg13cmos5l_decap_8
XFILLER_292_165 VPWR VGND sg13cmos5l_decap_8
XFILLER_105_91 VPWR VGND sg13cmos5l_decap_8
XFILLER_322_67 VPWR VGND sg13cmos5l_fill_1
XFILLER_450_0 VPWR VGND sg13cmos5l_decap_8
XFILLER_548_0 VPWR VGND sg13cmos5l_decap_8
XFILLER_398_49 VPWR VGND sg13cmos5l_decap_8
XFILLER_60_112 VPWR VGND sg13cmos5l_decap_8
XFILLER_45_197 VPWR VGND sg13cmos5l_fill_2
XFILLER_60_134 VPWR VGND sg13cmos5l_decap_8
XFILLER_695_14 VPWR VGND sg13cmos5l_decap_8
XFILLER_715_0 VPWR VGND sg13cmos5l_decap_8
XFILLER_60_167 VPWR VGND sg13cmos5l_decap_8
XFILLER_394_228 VPWR VGND sg13cmos5l_fill_1
X_0920_ _0920_/Q Tile_X0Y9_FrameData[7] VGND VPWR Tile_X0Y9_FrameStrobe[7] latch
XFILLER_595_199 VPWR VGND sg13cmos5l_fill_2
X_0851_ _0851_/Q Tile_X0Y9_FrameData[12] VGND VPWR Tile_X0Y9_FrameStrobe[5] latch
XFILLER_347_166 VPWR VGND sg13cmos5l_decap_8
XFILLER_628_96 VPWR VGND sg13cmos5l_decap_8
XFILLER_347_42 VPWR VGND sg13cmos5l_decap_8
X_3570_ Tile_X0Y9_FrameData_O[0] Tile_X0Y9_FrameData[0] VPWR VGND sg13cmos5l_buf_1
X_0782_ _0782_/Q Tile_X0Y9_FrameData[17] VGND VPWR Tile_X0Y9_FrameStrobe[3] latch
XFILLER_494_70 VPWR VGND sg13cmos5l_decap_8
XFILLER_161_209 VPWR VGND sg13cmos5l_decap_8
X_2521_ _2521_/Q Tile_X0Y6_FrameData[14] VGND VPWR Tile_X0Y9_FrameStrobe[2] latch
XFILLER_504_152 VPWR VGND sg13cmos5l_decap_8
XFILLER_303_225 VPWR VGND sg13cmos5l_decap_4
X_2452_ _2452_/Q Tile_X0Y6_FrameData[19] VGND VPWR Tile_X0Y9_FrameStrobe[0] latch
XFILLER_644_84 VPWR VGND sg13cmos5l_decap_8
XFILLER_216_35 VPWR VGND sg13cmos5l_decap_8
XFILLER_114_169 VPWR VGND sg13cmos5l_fill_2
X_1403_ _1403_/Q Tile_X0Y1_FrameData[30] VGND VPWR Tile_X0Y9_FrameStrobe[7] latch
XFILLER_580_28 VPWR VGND sg13cmos5l_decap_8
XFILLER_363_63 VPWR VGND sg13cmos5l_decap_8
X_2383_ _2383_/Q Tile_X0Y5_FrameData[22] VGND VPWR Tile_X0Y9_FrameStrobe[6] latch
XFILLER_68_212 VPWR VGND sg13cmos5l_decap_8
X_4122_ _4122_/X _4093_/X _0057_/X _4092_/X Tile_X0Y0_S4END[10] _1469_/Q _1468_/Q
+ VPWR VGND sg13cmos5l_mux4_1
X_1334_ _1334_/Q Tile_X0Y1_FrameData[3] VGND VPWR Tile_X0Y9_FrameStrobe[4] latch
XFILLER_513_77 VPWR VGND sg13cmos5l_decap_8
X_1265_ _1265_/Q Tile_X0Y1_FrameData[8] VGND VPWR Tile_X0Y9_FrameStrobe[2] latch
X_4053_ _4053_/X Tile_X0Y2_W2END[2] AXI_M_SOC_AWREADY _4101_/X _4100_/X _1567_/Q _1566_/Q
+ VPWR VGND sg13cmos5l_mux4_1
XFILLER_417_159 VPWR VGND sg13cmos5l_fill_1
XFILLER_283_154 VPWR VGND sg13cmos5l_decap_8
XFILLER_232_56 VPWR VGND sg13cmos5l_decap_8
X_3004_ Tile_X0Y5_E2BEG[7] _4379_/X VPWR VGND sg13cmos5l_buf_1
XFILLER_621_207 VPWR VGND sg13cmos5l_fill_1
X_0216_ _0216_/Q Tile_X0Y7_FrameData[7] VGND VPWR Tile_X0Y9_FrameStrobe[1] latch
X_1196_ _1196_/Q Tile_X0Y1_FrameData[13] VGND VPWR Tile_X0Y9_FrameStrobe[0] latch
XFILLER_224_210 VPWR VGND sg13cmos5l_fill_2
X_0147_ _3184_/A _3910_/X _3911_/X _1399_/Q VPWR VGND sg13cmos5l_mux2_1
XFILLER_669_70 VPWR VGND sg13cmos5l_decap_8
XFILLER_586_133 VPWR VGND sg13cmos5l_fill_2
X_0078_ _0078_/X _3877_/X _3878_/X _2146_/Q VPWR VGND sg13cmos5l_mux2_1
XFILLER_101_49 VPWR VGND sg13cmos5l_decap_8
XFILLER_440_184 VPWR VGND sg13cmos5l_fill_1
XFILLER_196_117 VPWR VGND sg13cmos5l_decap_8
XFILLER_586_188 VPWR VGND sg13cmos5l_fill_1
X_3906_ _3906_/X Tile_X0Y1_W1END[2] Tile_X0Y1_WW4END[2] Tile_X0Y1_W6END[10] _4010_/X
+ _1395_/Q _1394_/Q VPWR VGND sg13cmos5l_mux4_1
X_4886_ _4886_/X AXI_M_SOC_RDATA2 _4921_/X _4925_/X _4905_/X _0771_/Q _0770_/Q VPWR
+ VGND sg13cmos5l_mux4_1
XFILLER_338_144 VPWR VGND sg13cmos5l_decap_4
XFILLER_137_206 VPWR VGND sg13cmos5l_decap_8
X_3837_ _3837_/X _0086_/X Tile_X0Y0_S4END[1] _3868_/X _3867_/X _1031_/Q _1030_/Q VPWR
+ VGND sg13cmos5l_mux4_1
XFILLER_538_63 VPWR VGND sg13cmos5l_decap_8
XFILLER_338_166 VPWR VGND sg13cmos5l_fill_1
XFILLER_685_91 VPWR VGND sg13cmos5l_decap_8
XFILLER_338_188 VPWR VGND sg13cmos5l_decap_8
XFILLER_257_42 VPWR VGND sg13cmos5l_decap_8
XFILLER_688_218 VPWR VGND sg13cmos5l_fill_1
X_3768_ _3768_/X Tile_X0Y1_WW4END[1] Tile_X0Y1_WW4END[9] Tile_X0Y1_W6END[9] _4017_/X
+ _1239_/Q _1238_/Q VPWR VGND sg13cmos5l_mux4_1
XFILLER_353_147 VPWR VGND sg13cmos5l_decap_8
X_2719_ _4656_/A3 VPWR VGND sg13cmos5l_tielo
X_3699_ AXI_M_SOC_WDATA9 Tile_X0Y7_WW4END[1] Tile_X0Y7_WW4END[9] Tile_X0Y7_W6END[9]
+ _4693_/X _0229_/Q _0228_/Q VPWR VGND sg13cmos5l_mux4_1
XFILLER_407_56 VPWR VGND sg13cmos5l_decap_8
XFILLER_10_35 VPWR VGND sg13cmos5l_decap_8
XFILLER_554_84 VPWR VGND sg13cmos5l_decap_8
XFILLER_361_191 VPWR VGND sg13cmos5l_decap_8
XFILLER_510_133 VPWR VGND sg13cmos5l_fill_2
XFILLER_126_35 VPWR VGND sg13cmos5l_decap_8
XFILLER_704_21 VPWR VGND sg13cmos5l_decap_8
XFILLER_656_126 VPWR VGND sg13cmos5l_decap_8
XFILLER_490_28 VPWR VGND sg13cmos5l_decap_8
XFILLER_273_63 VPWR VGND sg13cmos5l_decap_8
XFILLER_86_28 VPWR VGND sg13cmos5l_decap_8
XFILLER_120_128 VPWR VGND sg13cmos5l_decap_8
XFILLER_259_162 VPWR VGND sg13cmos5l_fill_2
XFILLER_704_98 VPWR VGND sg13cmos5l_decap_8
XFILLER_463_210 VPWR VGND sg13cmos5l_fill_2
XFILLER_423_77 VPWR VGND sg13cmos5l_decap_8
XFILLER_374_7 VPWR VGND sg13cmos5l_decap_8
XFILLER_19_77 VPWR VGND sg13cmos5l_decap_8
XFILLER_142_56 VPWR VGND sg13cmos5l_decap_8
XFILLER_541_7 VPWR VGND sg13cmos5l_decap_8
XFILLER_35_21 VPWR VGND sg13cmos5l_decap_8
XFILLER_639_7 VPWR VGND sg13cmos5l_decap_8
XFILLER_431_140 VPWR VGND sg13cmos5l_decap_8
XFILLER_579_70 VPWR VGND sg13cmos5l_decap_8
XFILLER_577_133 VPWR VGND sg13cmos5l_decap_8
XFILLER_27_197 VPWR VGND sg13cmos5l_fill_2
XFILLER_35_98 VPWR VGND sg13cmos5l_decap_4
XFILLER_376_228 VPWR VGND sg13cmos5l_fill_1
XFILLER_518_211 VPWR VGND sg13cmos5l_fill_2
XFILLER_51_20 VPWR VGND sg13cmos5l_decap_8
XFILLER_665_28 VPWR VGND sg13cmos5l_decap_8
XFILLER_448_63 VPWR VGND sg13cmos5l_decap_8
XFILLER_448_74 VPWR VGND sg13cmos5l_fill_1
XFILLER_128_228 VPWR VGND sg13cmos5l_fill_1
XFILLER_595_91 VPWR VGND sg13cmos5l_fill_1
XFILLER_167_42 VPWR VGND sg13cmos5l_decap_8
XFILLER_129_0 VPWR VGND sg13cmos5l_decap_8
XFILLER_344_158 VPWR VGND sg13cmos5l_decap_8
XFILLER_498_140 VPWR VGND sg13cmos5l_decap_8
XFILLER_317_56 VPWR VGND sg13cmos5l_decap_8
XFILLER_297_213 VPWR VGND sg13cmos5l_decap_8
XFILLER_681_49 VPWR VGND sg13cmos5l_decap_8
XFILLER_352_191 VPWR VGND sg13cmos5l_fill_1
XFILLER_464_84 VPWR VGND sg13cmos5l_decap_4
XFILLER_614_21 VPWR VGND sg13cmos5l_decap_8
XFILLER_501_133 VPWR VGND sg13cmos5l_decap_8
XFILLER_647_126 VPWR VGND sg13cmos5l_decap_8
XFILLER_498_0 VPWR VGND sg13cmos5l_decap_8
XFILLER_183_63 VPWR VGND sg13cmos5l_decap_8
XFILLER_300_217 VPWR VGND sg13cmos5l_fill_1
XFILLER_614_98 VPWR VGND sg13cmos5l_decap_8
XFILLER_265_121 VPWR VGND sg13cmos5l_decap_8
XFILLER_665_0 VPWR VGND sg13cmos5l_decap_8
XFILLER_65_204 VPWR VGND sg13cmos5l_decap_8
XFILLER_333_77 VPWR VGND sg13cmos5l_fill_2
XFILLER_65_215 VPWR VGND sg13cmos5l_fill_2
XFILLER_18_7 VPWR VGND sg13cmos5l_decap_8
XFILLER_670_140 VPWR VGND sg13cmos5l_decap_4
XFILLER_630_42 VPWR VGND sg13cmos5l_decap_8
X_1050_ _1050_/Q Tile_X0Y0_FrameData[17] VGND VPWR Tile_X0Y9_FrameStrobe[3] latch
XFILLER_603_207 VPWR VGND sg13cmos5l_decap_8
XFILLER_206_210 VPWR VGND sg13cmos5l_decap_4
XFILLER_670_184 VPWR VGND sg13cmos5l_fill_1
XFILLER_280_168 VPWR VGND sg13cmos5l_decap_8
XFILLER_489_70 VPWR VGND sg13cmos5l_decap_8
XFILLER_422_140 VPWR VGND sg13cmos5l_decap_8
XFILLER_568_133 VPWR VGND sg13cmos5l_decap_8
XFILLER_18_197 VPWR VGND sg13cmos5l_decap_8
XFILLER_92_82 VPWR VGND sg13cmos5l_decap_8
XFILLER_367_217 VPWR VGND sg13cmos5l_fill_2
XFILLER_367_228 VPWR VGND sg13cmos5l_fill_1
X_4740_ _4740_/X Tile_X0Y8_W2END[3] AXI_M_SOC_RDATA11 _4791_/X _4790_/X _0567_/Q _0566_/Q
+ VPWR VGND sg13cmos5l_mux4_1
X_1952_ _1952_/Q Tile_X0Y4_FrameData[5] VGND VPWR Tile_X0Y9_FrameStrobe[0] latch
XFILLER_639_84 VPWR VGND sg13cmos5l_decap_8
XFILLER_193_109 VPWR VGND sg13cmos5l_fill_2
X_0903_ _0903_/Q Tile_X0Y9_FrameData[24] VGND VPWR Tile_X0Y9_FrameStrobe[7] latch
XFILLER_575_28 VPWR VGND sg13cmos5l_decap_8
X_4671_ _4671_/X _4587_/X _4703_/X _4702_/X _4586_/X _0181_/Q _0180_/Q VPWR VGND sg13cmos5l_mux4_1
XFILLER_358_63 VPWR VGND sg13cmos5l_decap_8
X_1883_ _1883_/Q Tile_X0Y3_FrameData[14] VGND VPWR Tile_X0Y9_FrameStrobe[6] latch
XFILLER_524_203 VPWR VGND sg13cmos5l_decap_8
X_3622_ Tile_X0Y9_S4BEG[0] _3622_/A VPWR VGND sg13cmos5l_buf_1
X_0834_ _0834_/Q Tile_X0Y9_FrameData[29] VGND VPWR Tile_X0Y9_FrameStrobe[5] latch
X_3553_ Tile_X0Y9_E6BEG[11] _4891_/X VPWR VGND sg13cmos5l_buf_1
XFILLER_508_77 VPWR VGND sg13cmos5l_decap_8
X_0765_ _0765_/Q Tile_X0Y9_FrameData[2] VGND VPWR Tile_X0Y9_FrameStrobe[2] latch
XFILLER_489_140 VPWR VGND sg13cmos5l_decap_8
XFILLER_227_56 VPWR VGND sg13cmos5l_decap_8
X_2504_ _2504_/Q Tile_X0Y6_FrameData[31] VGND VPWR Tile_X0Y9_FrameStrobe[2] latch
XFILLER_288_213 VPWR VGND sg13cmos5l_fill_2
X_3484_ Tile_X0Y1_EE4BEG[10] _3958_/X VPWR VGND sg13cmos5l_buf_1
XFILLER_591_49 VPWR VGND sg13cmos5l_decap_8
X_0696_ _0696_/Q Tile_X0Y9_FrameData[7] VGND VPWR Tile_X0Y9_FrameStrobe[0] latch
XFILLER_524_21 VPWR VGND sg13cmos5l_decap_8
XFILLER_44_0 VPWR VGND sg13cmos5l_fill_1
XFILLER_638_126 VPWR VGND sg13cmos5l_decap_8
X_2435_ _2435_/Q Tile_X0Y5_FrameData[2] VGND VPWR Tile_X0Y9_FrameStrobe[7] latch
X_2366_ _2366_/Q Tile_X0Y5_FrameData[7] VGND VPWR Tile_X0Y9_FrameStrobe[5] latch
X_4105_ _4105_/X Tile_X0Y6_W1END[0] Tile_X0Y6_WW4END[0] Tile_X0Y6_W6END[8] _4568_/X
+ _2671_/Q _2670_/Q VPWR VGND sg13cmos5l_mux4_1
XFILLER_243_77 VPWR VGND sg13cmos5l_decap_8
X_1317_ _1317_/Q Tile_X0Y1_FrameData[20] VGND VPWR Tile_X0Y9_FrameStrobe[4] latch
XFILLER_56_215 VPWR VGND sg13cmos5l_fill_2
XFILLER_256_143 VPWR VGND sg13cmos5l_decap_8
XANTENNA__3204__X Tile_X0Y0_N2BEG[4] VPWR VGND sg13cmos5l_antennanp
X_2297_ _2297_/Q Tile_X0Y5_FrameData[12] VGND VPWR Tile_X0Y9_FrameStrobe[3] latch
XFILLER_540_42 VPWR VGND sg13cmos5l_decap_8
XFILLER_2_91 VPWR VGND sg13cmos5l_decap_8
X_4036_ _4036_/X _4089_/X Tile_X0Y2_WW4END[4] _4088_/X AXI_M_SOC_AWREADY _1601_/Q
+ _1600_/Q VPWR VGND sg13cmos5l_mux4_1
XFILLER_460_213 VPWR VGND sg13cmos5l_decap_8
X_1248_ _1248_/Q Tile_X0Y1_FrameData[25] VGND VPWR Tile_X0Y9_FrameStrobe[2] latch
X_1179_ _1179_/Q Tile_X0Y1_FrameData[30] VGND VPWR Tile_X0Y9_FrameStrobe[0] latch
XFILLER_399_70 VPWR VGND sg13cmos5l_decap_8
XFILLER_212_202 VPWR VGND sg13cmos5l_fill_2
XFILLER_559_166 VPWR VGND sg13cmos5l_fill_2
XFILLER_708_119 VPWR VGND sg13cmos5l_decap_8
X_4938_ _4938_/X Tile_X0Y8_W1END[2] Tile_X0Y8_W2MID[1] Tile_X0Y8_W2END[1] _4786_/X
+ _0615_/Q _0614_/Q VPWR VGND sg13cmos5l_mux4_1
XFILLER_574_147 VPWR VGND sg13cmos5l_decap_8
XFILLER_549_84 VPWR VGND sg13cmos5l_decap_4
XANTENNA_30 Tile_X0Y9_FrameStrobe[12] VPWR VGND sg13cmos5l_antennanp
XFILLER_485_28 VPWR VGND sg13cmos5l_decap_8
XANTENNA_41 Tile_X0Y9_N2MID[1] VPWR VGND sg13cmos5l_antennanp
X_4869_ _4869_/X Tile_X0Y9_WW4END[10] AXI_M_SOC_RDATA5 _4926_/X _4905_/X _0805_/Q
+ _0804_/Q VPWR VGND sg13cmos5l_mux4_1
XANTENNA_52 Tile_X0Y9_N2MID[5] VPWR VGND sg13cmos5l_antennanp
XFILLER_515_225 VPWR VGND sg13cmos5l_decap_4
XFILLER_268_96 VPWR VGND sg13cmos5l_fill_2
XFILLER_177_194 VPWR VGND sg13cmos5l_decap_8
XFILLER_582_180 VPWR VGND sg13cmos5l_fill_2
XFILLER_192_131 VPWR VGND sg13cmos5l_decap_8
XFILLER_122_7 VPWR VGND sg13cmos5l_decap_8
XFILLER_192_164 VPWR VGND sg13cmos5l_fill_2
XFILLER_418_77 VPWR VGND sg13cmos5l_decap_8
XFILLER_21_56 VPWR VGND sg13cmos5l_decap_8
XFILLER_137_56 VPWR VGND sg13cmos5l_decap_8
XFILLER_715_42 VPWR VGND sg13cmos5l_decap_8
XFILLER_284_84 VPWR VGND sg13cmos5l_decap_8
XFILLER_629_115 VPWR VGND sg13cmos5l_decap_8
XFILLER_97_49 VPWR VGND sg13cmos5l_decap_8
XFILLER_434_21 VPWR VGND sg13cmos5l_decap_8
XFILLER_684_221 VPWR VGND sg13cmos5l_decap_8
XFILLER_715_97 VPWR VGND sg13cmos5l_decap_8
XFILLER_491_7 VPWR VGND sg13cmos5l_decap_8
XFILLER_589_7 VPWR VGND sg13cmos5l_decap_8
XFILLER_495_154 VPWR VGND sg13cmos5l_decap_8
XFILLER_434_98 VPWR VGND sg13cmos5l_decap_8
XFILLER_153_77 VPWR VGND sg13cmos5l_decap_8
XFILLER_303_14 VPWR VGND sg13cmos5l_decap_8
XFILLER_153_99 VPWR VGND sg13cmos5l_decap_4
XANTENNA__3114__X Tile_X0Y7_EE4BEG[0] VPWR VGND sg13cmos5l_antennanp
XFILLER_652_140 VPWR VGND sg13cmos5l_decap_8
XFILLER_46_20 VPWR VGND sg13cmos5l_decap_8
XFILLER_450_42 VPWR VGND sg13cmos5l_decap_8
XFILLER_262_102 VPWR VGND sg13cmos5l_decap_8
XFILLER_62_207 VPWR VGND sg13cmos5l_decap_4
XANTENNA__2953__X Tile_X0Y8_EE4BEG[9] VPWR VGND sg13cmos5l_antennanp
XFILLER_46_97 VPWR VGND sg13cmos5l_fill_1
XFILLER_262_179 VPWR VGND sg13cmos5l_decap_8
XFILLER_600_56 VPWR VGND sg13cmos5l_decap_8
XFILLER_102_70 VPWR VGND sg13cmos5l_decap_8
XFILLER_62_30 VPWR VGND sg13cmos5l_decap_8
XFILLER_246_0 VPWR VGND sg13cmos5l_decap_8
XFILLER_676_49 VPWR VGND sg13cmos5l_decap_8
XFILLER_565_147 VPWR VGND sg13cmos5l_fill_2
XFILLER_609_21 VPWR VGND sg13cmos5l_decap_8
XFILLER_62_85 VPWR VGND sg13cmos5l_fill_1
XFILLER_168_150 VPWR VGND sg13cmos5l_decap_8
XFILLER_395_28 VPWR VGND sg13cmos5l_decap_8
XFILLER_178_63 VPWR VGND sg13cmos5l_decap_8
XFILLER_7_14 VPWR VGND sg13cmos5l_decap_8
XFILLER_413_0 VPWR VGND sg13cmos5l_decap_8
XFILLER_609_98 VPWR VGND sg13cmos5l_decap_4
XFILLER_183_142 VPWR VGND sg13cmos5l_decap_8
XFILLER_317_158 VPWR VGND sg13cmos5l_decap_8
XFILLER_183_153 VPWR VGND sg13cmos5l_fill_2
XFILLER_328_77 VPWR VGND sg13cmos5l_fill_1
XFILLER_521_228 VPWR VGND sg13cmos5l_fill_1
XFILLER_183_197 VPWR VGND sg13cmos5l_decap_8
XFILLER_625_42 VPWR VGND sg13cmos5l_decap_8
X_0550_ _0550_/Q Tile_X0Y8_FrameData[25] VGND VPWR Tile_X0Y9_FrameStrobe[4] latch
XFILLER_344_21 VPWR VGND sg13cmos5l_decap_8
XFILLER_194_95 VPWR VGND sg13cmos5l_fill_2
XFILLER_97_104 VPWR VGND sg13cmos5l_fill_1
X_0481_ _0481_/Q Tile_X0Y8_FrameData[30] VGND VPWR Tile_X0Y9_FrameStrobe[2] latch
X_2220_ _2220_/Q Tile_X0Y5_FrameData[25] VGND VPWR Tile_X0Y9_FrameStrobe[1] latch
XFILLER_690_202 VPWR VGND sg13cmos5l_fill_1
XFILLER_344_98 VPWR VGND sg13cmos5l_decap_8
XFILLER_427_210 VPWR VGND sg13cmos5l_decap_8
XFILLER_690_224 VPWR VGND sg13cmos5l_decap_4
XFILLER_628_170 VPWR VGND sg13cmos5l_fill_2
X_2151_ _2151_/Q Tile_X0Y4_FrameData[30] VGND VPWR Tile_X0Y9_FrameStrobe[7] latch
XFILLER_641_63 VPWR VGND sg13cmos5l_decap_8
XFILLER_213_14 VPWR VGND sg13cmos5l_decap_8
XFILLER_238_154 VPWR VGND sg13cmos5l_decap_8
XANTENNA__3024__X Tile_X0Y5_E6BEG[11] VPWR VGND sg13cmos5l_antennanp
XFILLER_643_140 VPWR VGND sg13cmos5l_decap_8
XFILLER_360_42 VPWR VGND sg13cmos5l_decap_8
X_1102_ _1102_/Q Tile_X0Y0_FrameData[29] VGND VPWR Tile_X0Y9_FrameStrobe[5] latch
X_2082_ _2082_/Q Tile_X0Y4_FrameData[3] VGND VPWR Tile_X0Y9_FrameStrobe[4] latch
XFILLER_588_228 VPWR VGND sg13cmos5l_fill_1
XFILLER_53_218 VPWR VGND sg13cmos5l_decap_8
XANTENNA__2863__X Tile_X0Y6_EE4BEG[0] VPWR VGND sg13cmos5l_antennanp
X_1033_ _1033_/Q Tile_X0Y0_FrameData[2] VGND VPWR Tile_X0Y9_FrameStrobe[2] latch
XFILLER_510_56 VPWR VGND sg13cmos5l_decap_8
XFILLER_410_143 VPWR VGND sg13cmos5l_decap_8
X_2984_ Tile_X0Y8_FrameData_O[24] Tile_X0Y8_FrameData[24] VPWR VGND sg13cmos5l_buf_1
XFILLER_586_49 VPWR VGND sg13cmos5l_decap_8
XFILLER_410_154 VPWR VGND sg13cmos5l_fill_1
XFILLER_369_84 VPWR VGND sg13cmos5l_decap_8
XFILLER_519_21 VPWR VGND sg13cmos5l_decap_8
X_4723_ _4723_/X _4807_/X _4811_/X _4815_/X _4784_/X _0602_/Q _0601_/Q VPWR VGND sg13cmos5l_mux4_1
X_1935_ _1935_/Q Tile_X0Y4_FrameData[22] VGND VPWR Tile_X0Y9_FrameStrobe[0] latch
XFILLER_410_198 VPWR VGND sg13cmos5l_fill_1
XANTENNA__3694__X AXI_M_SOC_WDATA4 VPWR VGND sg13cmos5l_antennanp
XFILLER_159_194 VPWR VGND sg13cmos5l_decap_8
X_4654_ _4654_/X AXI_M_SOC_RDATA22 _4685_/X _4689_/X _4670_/X _0251_/Q _0250_/Q VPWR
+ VGND sg13cmos5l_mux4_1
X_1866_ _1866_/Q Tile_X0Y3_FrameData[31] VGND VPWR Tile_X0Y9_FrameStrobe[6] latch
XFILLER_564_191 VPWR VGND sg13cmos5l_decap_4
XFILLER_713_133 VPWR VGND sg13cmos5l_decap_8
X_3605_ Tile_X0Y9_S1BEG[3] _4827_/X VPWR VGND sg13cmos5l_buf_1
X_0817_ _0817_/Q Tile_X0Y9_FrameData[14] VGND VPWR Tile_X0Y9_FrameStrobe[4] latch
XFILLER_238_77 VPWR VGND sg13cmos5l_decap_8
X_4585_ _4585_/X Tile_X0Y8_W2MID[7] Tile_X0Y8_W2END[7] Tile_X0Y8_W6END[7] _4785_/X
+ _0663_/Q _0662_/Q VPWR VGND sg13cmos5l_mux4_1
XFILLER_174_186 VPWR VGND sg13cmos5l_decap_8
X_1797_ _1797_/Q Tile_X0Y3_FrameData[4] VGND VPWR Tile_X0Y9_FrameStrobe[3] latch
XFILLER_512_228 VPWR VGND sg13cmos5l_fill_1
XFILLER_535_42 VPWR VGND sg13cmos5l_decap_8
XFILLER_115_220 VPWR VGND sg13cmos5l_fill_1
X_3536_ Tile_X0Y9_E2BEGb[2] _4858_/X VPWR VGND sg13cmos5l_buf_1
X_0748_ _0748_/Q Tile_X0Y9_FrameData[19] VGND VPWR Tile_X0Y9_FrameStrobe[2] latch
XFILLER_682_70 VPWR VGND sg13cmos5l_decap_8
XFILLER_254_21 VPWR VGND sg13cmos5l_decap_8
XFILLER_88_104 VPWR VGND sg13cmos5l_decap_8
X_3467_ Tile_X0Y1_FrameData_O[25] Tile_X0Y1_FrameData[25] VPWR VGND sg13cmos5l_buf_1
X_0679_ _0679_/Q Tile_X0Y9_FrameData[24] VGND VPWR Tile_X0Y9_FrameStrobe[0] latch
XFILLER_276_216 VPWR VGND sg13cmos5l_fill_1
X_2418_ _2418_/Q Tile_X0Y5_FrameData[19] VGND VPWR Tile_X0Y9_FrameStrobe[7] latch
XFILLER_681_213 VPWR VGND sg13cmos5l_fill_2
X_3398_ Tile_X0Y2_E2BEG[1] _4041_/X VPWR VGND sg13cmos5l_buf_1
XFILLER_619_170 VPWR VGND sg13cmos5l_fill_2
XFILLER_404_35 VPWR VGND sg13cmos5l_decap_8
XFILLER_551_63 VPWR VGND sg13cmos5l_decap_8
X_2349_ _2349_/Q Tile_X0Y5_FrameData[24] VGND VPWR Tile_X0Y9_FrameStrobe[5] latch
XFILLER_492_168 VPWR VGND sg13cmos5l_decap_8
XFILLER_123_14 VPWR VGND sg13cmos5l_decap_8
XFILLER_270_42 VPWR VGND sg13cmos5l_decap_8
XFILLER_634_173 VPWR VGND sg13cmos5l_decap_4
XANTENNA__2773__X Tile_X0Y3_FrameData_O[31] VPWR VGND sg13cmos5l_antennanp
X_4019_ _4019_/X _3987_/X _0084_/X _3986_/X Tile_X0Y0_S4END[7] _1211_/Q _1210_/Q VPWR
+ VGND sg13cmos5l_mux4_1
XFILLER_701_77 VPWR VGND sg13cmos5l_decap_8
XFILLER_420_56 VPWR VGND sg13cmos5l_decap_8
XFILLER_203_91 VPWR VGND sg13cmos5l_decap_8
XFILLER_16_56 VPWR VGND sg13cmos5l_decap_8
XFILLER_197_223 VPWR VGND sg13cmos5l_decap_4
XFILLER_496_49 VPWR VGND sg13cmos5l_decap_8
XFILLER_337_7 VPWR VGND sg13cmos5l_decap_8
XFILLER_279_84 VPWR VGND sg13cmos5l_decap_8
XFILLER_200_205 VPWR VGND sg13cmos5l_decap_8
XFILLER_401_165 VPWR VGND sg13cmos5l_decap_8
XFILLER_429_21 VPWR VGND sg13cmos5l_decap_8
XFILLER_401_176 VPWR VGND sg13cmos5l_fill_1
XFILLER_8_119 VPWR VGND sg13cmos5l_decap_8
XFILLER_401_198 VPWR VGND sg13cmos5l_decap_8
XFILLER_504_7 VPWR VGND sg13cmos5l_decap_8
XFILLER_32_66 VPWR VGND sg13cmos5l_decap_8
XFILLER_429_98 VPWR VGND sg13cmos5l_decap_8
XFILLER_165_153 VPWR VGND sg13cmos5l_decap_8
XFILLER_704_133 VPWR VGND sg13cmos5l_decap_8
XFILLER_148_77 VPWR VGND sg13cmos5l_decap_8
XFILLER_704_166 VPWR VGND sg13cmos5l_fill_2
XFILLER_570_161 VPWR VGND sg13cmos5l_decap_8
XFILLER_503_217 VPWR VGND sg13cmos5l_decap_4
XANTENNA__3109__X Tile_X0Y7_E6BEG[7] VPWR VGND sg13cmos5l_antennanp
XFILLER_445_42 VPWR VGND sg13cmos5l_decap_8
XFILLER_592_70 VPWR VGND sg13cmos5l_decap_8
XFILLER_468_110 VPWR VGND sg13cmos5l_fill_2
XFILLER_164_21 VPWR VGND sg13cmos5l_decap_8
XANTENNA__2948__X Tile_X0Y8_EE4BEG[4] VPWR VGND sg13cmos5l_antennanp
XFILLER_79_126 VPWR VGND sg13cmos5l_fill_1
XFILLER_468_154 VPWR VGND sg13cmos5l_decap_8
XFILLER_79_148 VPWR VGND sg13cmos5l_decap_8
XFILLER_314_35 VPWR VGND sg13cmos5l_decap_8
XFILLER_461_63 VPWR VGND sg13cmos5l_decap_8
XFILLER_196_0 VPWR VGND sg13cmos5l_decap_8
XFILLER_483_168 VPWR VGND sg13cmos5l_decap_8
XFILLER_57_63 VPWR VGND sg13cmos5l_decap_8
XFILLER_235_102 VPWR VGND sg13cmos5l_decap_8
XFILLER_180_42 VPWR VGND sg13cmos5l_decap_8
XFILLER_363_0 VPWR VGND sg13cmos5l_decap_8
XANTENNA__3779__X AXI_M_SOC_RREADY VPWR VGND sg13cmos5l_antennanp
XFILLER_611_77 VPWR VGND sg13cmos5l_decap_8
XFILLER_640_154 VPWR VGND sg13cmos5l_decap_8
XFILLER_330_56 VPWR VGND sg13cmos5l_decap_8
XFILLER_396_109 VPWR VGND sg13cmos5l_fill_2
XFILLER_389_161 VPWR VGND sg13cmos5l_decap_8
XFILLER_250_149 VPWR VGND sg13cmos5l_fill_1
XFILLER_530_0 VPWR VGND sg13cmos5l_decap_8
XFILLER_73_84 VPWR VGND sg13cmos5l_decap_8
XFILLER_389_183 VPWR VGND sg13cmos5l_decap_8
XFILLER_628_0 VPWR VGND sg13cmos5l_decap_8
XFILLER_593_220 VPWR VGND sg13cmos5l_fill_2
XFILLER_538_147 VPWR VGND sg13cmos5l_fill_2
XFILLER_189_84 VPWR VGND sg13cmos5l_decap_8
XFILLER_339_21 VPWR VGND sg13cmos5l_decap_8
XFILLER_148_109 VPWR VGND sg13cmos5l_decap_8
XFILLER_85_7 VPWR VGND sg13cmos5l_decap_8
X_1720_ _1720_/Q Tile_X0Y3_FrameData[17] VGND VPWR Tile_X0Y9_FrameStrobe[1] latch
X_1651_ _1651_/Q Tile_X0Y2_FrameData[30] VGND VPWR Tile_X0Y9_FrameStrobe[7] latch
XFILLER_636_63 VPWR VGND sg13cmos5l_decap_8
XFILLER_156_186 VPWR VGND sg13cmos5l_fill_1
XFILLER_208_14 VPWR VGND sg13cmos5l_decap_8
XFILLER_171_112 VPWR VGND sg13cmos5l_decap_8
XANTENNA__3019__X Tile_X0Y5_E6BEG[6] VPWR VGND sg13cmos5l_antennanp
XFILLER_355_42 VPWR VGND sg13cmos5l_decap_8
X_0602_ _0602_/Q Tile_X0Y8_FrameData[5] VGND VPWR Tile_X0Y9_FrameStrobe[5] latch
X_4370_ _4370_/X _4424_/X _4423_/X AXI_M_SOC_RLAST _4422_/X _2363_/Q _2362_/Q VPWR
+ VGND sg13cmos5l_mux4_1
X_1582_ _1582_/Q Tile_X0Y2_FrameData[3] VGND VPWR Tile_X0Y9_FrameStrobe[4] latch
XFILLER_710_147 VPWR VGND sg13cmos5l_decap_8
XFILLER_648_221 VPWR VGND sg13cmos5l_fill_1
XFILLER_98_70 VPWR VGND sg13cmos5l_fill_1
X_3321_ Tile_X0Y4_EE4BEG[9] _4281_/X VPWR VGND sg13cmos5l_buf_1
XFILLER_112_201 VPWR VGND sg13cmos5l_decap_8
XANTENNA__2858__X Tile_X0Y6_E6BEG[7] VPWR VGND sg13cmos5l_antennanp
X_0533_ _0533_/Q Tile_X0Y8_FrameData[10] VGND VPWR Tile_X0Y9_FrameStrobe[3] latch
XFILLER_459_165 VPWR VGND sg13cmos5l_decap_4
XFILLER_505_56 VPWR VGND sg13cmos5l_decap_8
X_3252_ Tile_X0Y0_FrameData_O[20] Tile_X0Y0_FrameData[20] VPWR VGND sg13cmos5l_buf_1
XFILLER_663_213 VPWR VGND sg13cmos5l_fill_2
X_0464_ _0464_/Q Tile_X0Y8_FrameData[15] VGND VPWR Tile_X0Y9_FrameStrobe[1] latch
XFILLER_652_84 VPWR VGND sg13cmos5l_decap_8
XFILLER_608_129 VPWR VGND sg13cmos5l_fill_2
XFILLER_224_35 VPWR VGND sg13cmos5l_decap_8
X_2203_ _2203_/Q Tile_X0Y5_FrameData[10] VGND VPWR Tile_X0Y9_FrameStrobe[0] latch
XFILLER_371_63 VPWR VGND sg13cmos5l_decap_8
X_3183_ Tile_X0Y0_N4BEG[7] _3183_/A VPWR VGND sg13cmos5l_buf_1
XFILLER_78_181 VPWR VGND sg13cmos5l_decap_8
X_0395_ _0395_/Q Tile_X0Y7_FrameData[20] VGND VPWR Tile_X0Y9_FrameStrobe[7] latch
XFILLER_616_151 VPWR VGND sg13cmos5l_fill_1
X_2134_ _2134_/Q Tile_X0Y4_FrameData[15] VGND VPWR Tile_X0Y9_FrameStrobe[6] latch
XFILLER_93_162 VPWR VGND sg13cmos5l_fill_1
XANTENNA__3689__X AXI_M_SOC_AWVALID VPWR VGND sg13cmos5l_antennanp
XFILLER_93_184 VPWR VGND sg13cmos5l_fill_1
XFILLER_521_77 VPWR VGND sg13cmos5l_decap_4
XFILLER_226_168 VPWR VGND sg13cmos5l_fill_2
X_2065_ _2065_/Q Tile_X0Y4_FrameData[20] VGND VPWR Tile_X0Y9_FrameStrobe[4] latch
XFILLER_240_56 VPWR VGND sg13cmos5l_decap_8
XFILLER_240_67 VPWR VGND sg13cmos5l_fill_1
X_1016_ _1016_/Q Tile_X0Y0_FrameData[19] VGND VPWR Tile_X0Y9_FrameStrobe[2] latch
XFILLER_677_70 VPWR VGND sg13cmos5l_decap_8
XFILLER_249_21 VPWR VGND sg13cmos5l_decap_8
XFILLER_194_215 VPWR VGND sg13cmos5l_decap_4
X_2967_ Tile_X0Y8_FrameData_O[7] Tile_X0Y8_FrameData[7] VPWR VGND sg13cmos5l_buf_1
X_1918_ _1918_/Q Tile_X0Y3_FrameData[11] VGND VPWR Tile_X0Y9_FrameStrobe[7] latch
X_4706_ _4706_/X Tile_X0Y6_W2MID[4] Tile_X0Y6_W2END[4] Tile_X0Y6_W6END[11] _4559_/X
+ _2645_/Q _2644_/Q VPWR VGND sg13cmos5l_mux4_1
XFILLER_147_131 VPWR VGND sg13cmos5l_fill_1
XFILLER_249_98 VPWR VGND sg13cmos5l_decap_8
X_2898_ Tile_X0Y6_FrameData_O[19] Tile_X0Y6_FrameData[19] VPWR VGND sg13cmos5l_buf_1
X_4637_ _4637_/X Tile_X0Y7_WW4END[6] AXI_M_SOC_RDATA22 _4690_/X _4670_/X _0285_/Q
+ _0284_/Q VPWR VGND sg13cmos5l_mux4_1
XFILLER_546_63 VPWR VGND sg13cmos5l_decap_8
X_1849_ _1849_/Q Tile_X0Y3_FrameData[16] VGND VPWR Tile_X0Y9_FrameStrobe[5] latch
XFILLER_118_14 VPWR VGND sg13cmos5l_decap_8
XFILLER_693_91 VPWR VGND sg13cmos5l_decap_8
XFILLER_265_42 VPWR VGND sg13cmos5l_decap_8
X_4568_ _4568_/X _4545_/X Tile_X0Y9_N4END[12] _4544_/X _0152_/X _2495_/Q _2494_/Q
+ VPWR VGND sg13cmos5l_mux4_1
XANTENNA__2768__X Tile_X0Y3_FrameData_O[26] VPWR VGND sg13cmos5l_antennanp
X_3519_ Tile_X0Y1_E1BEG[1] _3929_/X VPWR VGND sg13cmos5l_buf_1
X_4499_ _4499_/X Tile_X0Y6_W2MID[4] AXI_M_SOC_RDATA27 _4559_/X _4558_/X _2609_/Q _2608_/Q
+ VPWR VGND sg13cmos5l_mux4_1
XFILLER_415_56 VPWR VGND sg13cmos5l_decap_8
XFILLER_249_227 VPWR VGND sg13cmos5l_fill_2
XFILLER_562_84 VPWR VGND sg13cmos5l_decap_8
XFILLER_134_35 VPWR VGND sg13cmos5l_decap_8
XFILLER_712_21 VPWR VGND sg13cmos5l_decap_8
XFILLER_281_63 VPWR VGND sg13cmos5l_decap_8
XFILLER_94_28 VPWR VGND sg13cmos5l_decap_8
XFILLER_465_179 VPWR VGND sg13cmos5l_decap_8
XFILLER_287_7 VPWR VGND sg13cmos5l_decap_8
XFILLER_712_98 VPWR VGND sg13cmos5l_decap_8
XFILLER_84_140 VPWR VGND sg13cmos5l_decap_4
XFILLER_607_195 VPWR VGND sg13cmos5l_fill_2
XANTENNA__3599__X Tile_X0Y9_FrameData_O[29] VPWR VGND sg13cmos5l_antennanp
XFILLER_431_77 VPWR VGND sg13cmos5l_decap_8
XFILLER_454_7 VPWR VGND sg13cmos5l_decap_8
XFILLER_27_77 VPWR VGND sg13cmos5l_decap_8
XFILLER_217_179 VPWR VGND sg13cmos5l_decap_4
XFILLER_150_56 VPWR VGND sg13cmos5l_decap_8
XFILLER_232_127 VPWR VGND sg13cmos5l_decap_8
XFILLER_709_203 VPWR VGND sg13cmos5l_decap_8
XFILLER_621_7 VPWR VGND sg13cmos5l_decap_8
XFILLER_43_21 VPWR VGND sg13cmos5l_decap_8
XFILLER_40_210 VPWR VGND sg13cmos5l_fill_2
XFILLER_587_70 VPWR VGND sg13cmos5l_decap_8
XFILLER_159_21 VPWR VGND sg13cmos5l_decap_8
XFILLER_240_193 VPWR VGND sg13cmos5l_decap_8
XFILLER_309_35 VPWR VGND sg13cmos5l_decap_8
XFILLER_673_28 VPWR VGND sg13cmos5l_decap_8
XFILLER_138_175 VPWR VGND sg13cmos5l_decap_8
XFILLER_456_63 VPWR VGND sg13cmos5l_fill_1
XFILLER_689_154 VPWR VGND sg13cmos5l_fill_1
XFILLER_111_0 VPWR VGND sg13cmos5l_decap_8
XFILLER_209_0 VPWR VGND sg13cmos5l_decap_8
XFILLER_175_42 VPWR VGND sg13cmos5l_decap_8
XFILLER_488_227 VPWR VGND sg13cmos5l_fill_2
XFILLER_606_77 VPWR VGND sg13cmos5l_decap_8
XFILLER_325_56 VPWR VGND sg13cmos5l_decap_4
XFILLER_645_224 VPWR VGND sg13cmos5l_decap_4
XFILLER_67_107 VPWR VGND sg13cmos5l_decap_8
XFILLER_622_21 VPWR VGND sg13cmos5l_decap_8
XFILLER_480_0 VPWR VGND sg13cmos5l_decap_8
XFILLER_325_89 VPWR VGND sg13cmos5l_fill_2
XFILLER_578_0 VPWR VGND sg13cmos5l_decap_8
XFILLER_191_63 VPWR VGND sg13cmos5l_decap_8
XFILLER_255_219 VPWR VGND sg13cmos5l_decap_8
XFILLER_471_105 VPWR VGND sg13cmos5l_decap_8
X_0180_ _0180_/Q Tile_X0Y7_FrameData[11] VGND VPWR Tile_X0Y9_FrameStrobe[0] latch
XFILLER_698_14 VPWR VGND sg13cmos5l_decap_8
XFILLER_622_98 VPWR VGND sg13cmos5l_decap_8
XFILLER_613_121 VPWR VGND sg13cmos5l_fill_1
XFILLER_75_173 VPWR VGND sg13cmos5l_decap_8
XFILLER_341_77 VPWR VGND sg13cmos5l_decap_8
XFILLER_613_143 VPWR VGND sg13cmos5l_fill_1
XFILLER_208_168 VPWR VGND sg13cmos5l_decap_8
XFILLER_75_195 VPWR VGND sg13cmos5l_fill_1
XFILLER_223_105 VPWR VGND sg13cmos5l_fill_2
XANTENNA__3302__X Tile_X0Y0_E2BEG[2] VPWR VGND sg13cmos5l_antennanp
XFILLER_613_165 VPWR VGND sg13cmos5l_fill_2
XFILLER_412_227 VPWR VGND sg13cmos5l_fill_2
XFILLER_31_210 VPWR VGND sg13cmos5l_fill_2
X_3870_ _3870_/X _4341_/X _4345_/X _4349_/X _4315_/X _2154_/Q _2153_/Q VPWR VGND sg13cmos5l_mux4_1
XFILLER_231_160 VPWR VGND sg13cmos5l_decap_8
XFILLER_497_70 VPWR VGND sg13cmos5l_decap_8
XFILLER_377_153 VPWR VGND sg13cmos5l_decap_4
XFILLER_231_171 VPWR VGND sg13cmos5l_fill_1
X_2821_ Tile_X0Y3_E1BEG[3] _4147_/X VPWR VGND sg13cmos5l_buf_1
XFILLER_715_206 VPWR VGND sg13cmos5l_decap_8
XFILLER_715_228 VPWR VGND sg13cmos5l_fill_1
XFILLER_392_134 VPWR VGND sg13cmos5l_fill_2
X_2752_ Tile_X0Y3_FrameData_O[10] Tile_X0Y3_FrameData[10] VPWR VGND sg13cmos5l_buf_1
XFILLER_647_84 VPWR VGND sg13cmos5l_decap_8
XFILLER_219_35 VPWR VGND sg13cmos5l_decap_8
XFILLER_392_178 VPWR VGND sg13cmos5l_decap_8
X_1703_ _1703_/Q Tile_X0Y3_FrameData[2] VGND VPWR Tile_X0Y9_FrameStrobe[0] latch
XFILLER_583_28 VPWR VGND sg13cmos5l_decap_8
XFILLER_366_63 VPWR VGND sg13cmos5l_decap_8
XFILLER_144_112 VPWR VGND sg13cmos5l_fill_2
X_2683_ _2683_/Q Tile_X0Y6_FrameData[12] VGND VPWR Tile_X0Y9_FrameStrobe[7] latch
XFILLER_479_205 VPWR VGND sg13cmos5l_decap_8
X_4422_ _4422_/X _4424_/X Tile_X0Y5_W6END[2] _4423_/X _4422_/A3 _2185_/Q _2184_/Q
+ VPWR VGND sg13cmos5l_mux4_1
X_1634_ _1634_/Q Tile_X0Y2_FrameData[15] VGND VPWR Tile_X0Y9_FrameStrobe[6] latch
XFILLER_144_189 VPWR VGND sg13cmos5l_fill_1
XFILLER_98_210 VPWR VGND sg13cmos5l_decap_4
X_4353_ _4353_/X Tile_X0Y6_W2MID[7] Tile_X0Y6_W2END[7] Tile_X0Y6_W6END[7] _4553_/X
+ _2687_/Q _2686_/Q VPWR VGND sg13cmos5l_mux4_1
XFILLER_516_77 VPWR VGND sg13cmos5l_decap_8
XFILLER_98_221 VPWR VGND sg13cmos5l_fill_1
X_1565_ _1565_/Q Tile_X0Y2_FrameData[20] VGND VPWR Tile_X0Y9_FrameStrobe[4] latch
XFILLER_695_168 VPWR VGND sg13cmos5l_fill_2
XFILLER_235_56 VPWR VGND sg13cmos5l_decap_8
X_3304_ Tile_X0Y0_E2BEG[4] _3808_/X VPWR VGND sg13cmos5l_buf_1
X_0516_ _0516_/Q Tile_X0Y8_FrameData[27] VGND VPWR Tile_X0Y9_FrameStrobe[3] latch
X_4284_ _4284_/X Tile_X0Y4_WW4END[3] AXI_M_SOC_BRESP1 _4339_/X _4319_/X _2045_/Q _2044_/Q
+ VPWR VGND sg13cmos5l_mux4_1
X_1496_ _1496_/Q Tile_X0Y2_FrameData[25] VGND VPWR Tile_X0Y9_FrameStrobe[2] latch
XFILLER_532_21 VPWR VGND sg13cmos5l_decap_8
X_3235_ Tile_X0Y0_FrameData_O[3] Tile_X0Y0_FrameData[3] VPWR VGND sg13cmos5l_buf_1
XFILLER_100_226 VPWR VGND sg13cmos5l_fill_2
X_0447_ _0447_/Q Tile_X0Y8_FrameData[0] VGND VPWR Tile_X0Y9_FrameStrobe[0] latch
X_3166_ Tile_X0Y4_E6BEG[3] _4291_/X VPWR VGND sg13cmos5l_buf_1
X_0378_ _0378_/Q Tile_X0Y7_FrameData[5] VGND VPWR Tile_X0Y9_FrameStrobe[6] latch
XFILLER_104_49 VPWR VGND sg13cmos5l_decap_8
X_2117_ _2117_/Q Tile_X0Y4_FrameData[0] VGND VPWR Tile_X0Y9_FrameStrobe[5] latch
XFILLER_401_14 VPWR VGND sg13cmos5l_decap_8
X_3097_ Tile_X0Y7_E2BEGb[3] _4623_/X VPWR VGND sg13cmos5l_buf_1
XFILLER_214_105 VPWR VGND sg13cmos5l_decap_8
XANTENNA__3212__X Tile_X0Y0_FrameStrobe_O[0] VPWR VGND sg13cmos5l_antennanp
XFILLER_81_143 VPWR VGND sg13cmos5l_fill_2
XFILLER_403_227 VPWR VGND sg13cmos5l_fill_2
X_2048_ _2048_/Q Tile_X0Y4_FrameData[5] VGND VPWR Tile_X0Y9_FrameStrobe[3] latch
XFILLER_604_198 VPWR VGND sg13cmos5l_decap_4
XFILLER_688_91 VPWR VGND sg13cmos5l_decap_8
XFILLER_557_220 VPWR VGND sg13cmos5l_decap_8
XFILLER_200_70 VPWR VGND sg13cmos5l_decap_8
XFILLER_196_19 VPWR VGND sg13cmos5l_decap_8
X_3999_ _3999_/X _3985_/X _0095_/X _3984_/X Tile_X0Y0_S4END[6] _1205_/Q _1204_/Q VPWR
+ VGND sg13cmos5l_mux4_1
XFILLER_383_123 VPWR VGND sg13cmos5l_decap_4
XFILLER_368_197 VPWR VGND sg13cmos5l_decap_8
XFILLER_706_228 VPWR VGND sg13cmos5l_fill_1
XFILLER_13_35 VPWR VGND sg13cmos5l_decap_8
XFILLER_557_84 VPWR VGND sg13cmos5l_decap_8
XFILLER_129_35 VPWR VGND sg13cmos5l_decap_8
XFILLER_707_21 VPWR VGND sg13cmos5l_decap_8
XFILLER_525_150 VPWR VGND sg13cmos5l_decap_8
XFILLER_493_28 VPWR VGND sg13cmos5l_decap_8
XFILLER_276_63 VPWR VGND sg13cmos5l_decap_8
XFILLER_135_112 VPWR VGND sg13cmos5l_decap_8
XFILLER_89_28 VPWR VGND sg13cmos5l_decap_8
XFILLER_202_7 VPWR VGND sg13cmos5l_decap_8
XFILLER_707_98 VPWR VGND sg13cmos5l_decap_8
XFILLER_540_142 VPWR VGND sg13cmos5l_decap_8
XFILLER_540_153 VPWR VGND sg13cmos5l_fill_1
XFILLER_426_77 VPWR VGND sg13cmos5l_decap_8
XFILLER_540_175 VPWR VGND sg13cmos5l_decap_8
XFILLER_485_208 VPWR VGND sg13cmos5l_decap_8
XFILLER_145_56 VPWR VGND sg13cmos5l_decap_8
XFILLER_292_84 VPWR VGND sg13cmos5l_decap_8
XFILLER_442_21 VPWR VGND sg13cmos5l_decap_8
XFILLER_438_157 VPWR VGND sg13cmos5l_fill_1
XFILLER_38_21 VPWR VGND sg13cmos5l_decap_8
XFILLER_571_7 VPWR VGND sg13cmos5l_decap_8
XFILLER_669_7 VPWR VGND sg13cmos5l_decap_8
XFILLER_442_98 VPWR VGND sg13cmos5l_decap_8
XFILLER_57_173 VPWR VGND sg13cmos5l_decap_8
XFILLER_161_77 VPWR VGND sg13cmos5l_decap_8
XFILLER_311_14 VPWR VGND sg13cmos5l_decap_8
XFILLER_205_105 VPWR VGND sg13cmos5l_decap_8
XANTENNA__3122__X Tile_X0Y7_EE4BEG[8] VPWR VGND sg13cmos5l_antennanp
XFILLER_260_211 VPWR VGND sg13cmos5l_decap_8
XFILLER_668_28 VPWR VGND sg13cmos5l_decap_8
XFILLER_54_42 VPWR VGND sg13cmos5l_decap_8
XFILLER_72_176 VPWR VGND sg13cmos5l_decap_8
XFILLER_598_91 VPWR VGND sg13cmos5l_decap_8
XFILLER_159_0 VPWR VGND sg13cmos5l_decap_8
XANTENNA__2961__X Tile_X0Y8_FrameData_O[1] VPWR VGND sg13cmos5l_antennanp
XFILLER_220_119 VPWR VGND sg13cmos5l_decap_8
XFILLER_213_182 VPWR VGND sg13cmos5l_decap_8
XFILLER_374_101 VPWR VGND sg13cmos5l_fill_2
XFILLER_110_70 VPWR VGND sg13cmos5l_decap_8
XFILLER_374_134 VPWR VGND sg13cmos5l_fill_1
XFILLER_326_0 VPWR VGND sg13cmos5l_decap_8
XFILLER_70_63 VPWR VGND sg13cmos5l_decap_8
XFILLER_684_49 VPWR VGND sg13cmos5l_decap_8
XFILLER_617_21 VPWR VGND sg13cmos5l_decap_8
XFILLER_186_63 VPWR VGND sg13cmos5l_decap_8
XFILLER_126_112 VPWR VGND sg13cmos5l_decap_8
XFILLER_516_172 VPWR VGND sg13cmos5l_fill_2
XFILLER_617_98 VPWR VGND sg13cmos5l_decap_8
XFILLER_695_0 VPWR VGND sg13cmos5l_decap_8
XFILLER_531_164 VPWR VGND sg13cmos5l_decap_8
XFILLER_336_77 VPWR VGND sg13cmos5l_decap_8
XFILLER_141_126 VPWR VGND sg13cmos5l_decap_8
XFILLER_692_105 VPWR VGND sg13cmos5l_decap_8
XFILLER_633_42 VPWR VGND sg13cmos5l_decap_8
X_1350_ _1350_/Q Tile_X0Y1_FrameData[19] VGND VPWR Tile_X0Y9_FrameStrobe[5] latch
XFILLER_618_224 VPWR VGND sg13cmos5l_decap_4
XFILLER_352_21 VPWR VGND sg13cmos5l_decap_8
X_0301_ _0301_/Q Tile_X0Y7_FrameData[18] VGND VPWR Tile_X0Y9_FrameStrobe[4] latch
XFILLER_295_152 VPWR VGND sg13cmos5l_decap_8
XFILLER_429_168 VPWR VGND sg13cmos5l_decap_8
XFILLER_295_163 VPWR VGND sg13cmos5l_fill_1
X_1281_ _1281_/Q Tile_X0Y1_FrameData[24] VGND VPWR Tile_X0Y9_FrameStrobe[3] latch
XFILLER_295_185 VPWR VGND sg13cmos5l_decap_8
X_3020_ Tile_X0Y5_E6BEG[7] _4411_/X VPWR VGND sg13cmos5l_buf_1
XFILLER_633_216 VPWR VGND sg13cmos5l_fill_2
X_0232_ _0232_/Q Tile_X0Y7_FrameData[23] VGND VPWR Tile_X0Y9_FrameStrobe[2] latch
XFILLER_352_98 VPWR VGND sg13cmos5l_decap_8
XFILLER_95_93 VPWR VGND sg13cmos5l_decap_4
XFILLER_502_35 VPWR VGND sg13cmos5l_decap_8
X_0163_ _0163_/Q Tile_X0Y7_FrameData[28] VGND VPWR Tile_X0Y9_FrameStrobe[0] latch
XFILLER_221_14 VPWR VGND sg13cmos5l_decap_8
XANTENNA__3032__X Tile_X0Y5_EE4BEG[7] VPWR VGND sg13cmos5l_antennanp
XFILLER_63_132 VPWR VGND sg13cmos5l_decap_8
XFILLER_397_204 VPWR VGND sg13cmos5l_decap_4
XFILLER_578_28 VPWR VGND sg13cmos5l_decap_8
X_0094_ _0094_/X _4114_/X _4115_/X _2660_/Q VPWR VGND sg13cmos5l_mux2_1
XFILLER_598_197 VPWR VGND sg13cmos5l_fill_2
XANTENNA__2871__X Tile_X0Y6_EE4BEG[8] VPWR VGND sg13cmos5l_antennanp
X_3922_ _3922_/X Tile_X0Y3_W1END[2] Tile_X0Y3_WW4END[2] Tile_X0Y3_W6END[10] _4224_/X
+ _1895_/Q _1894_/Q VPWR VGND sg13cmos5l_mux4_1
XFILLER_211_119 VPWR VGND sg13cmos5l_decap_8
XFILLER_204_182 VPWR VGND sg13cmos5l_fill_1
XFILLER_149_215 VPWR VGND sg13cmos5l_fill_2
X_3853_ _3853_/X _3889_/X _3888_/X Tile_X0Y0_S2MID[0] Tile_X0Y0_S2END[0] _0963_/Q
+ _0962_/Q VPWR VGND sg13cmos5l_mux4_1
XFILLER_365_112 VPWR VGND sg13cmos5l_decap_8
XFILLER_365_123 VPWR VGND sg13cmos5l_fill_1
X_2804_ Tile_X0Y3_E2BEGb[2] _4158_/X VPWR VGND sg13cmos5l_buf_1
X_3784_ _3784_/X Tile_X0Y0_W2MID[7] Tile_X0Y0_W2END[7] Tile_X0Y0_W6END[7] _3853_/X
+ _1169_/Q _1168_/Q VPWR VGND sg13cmos5l_mux4_1
XFILLER_594_49 VPWR VGND sg13cmos5l_decap_8
X_0996_ _0996_/Q Tile_X0Y0_FrameData[7] VGND VPWR Tile_X0Y9_FrameStrobe[1] latch
XFILLER_164_218 VPWR VGND sg13cmos5l_fill_1
XFILLER_74_0 VPWR VGND sg13cmos5l_decap_8
XFILLER_527_21 VPWR VGND sg13cmos5l_decap_8
XFILLER_514_109 VPWR VGND sg13cmos5l_fill_1
XFILLER_117_101 VPWR VGND sg13cmos5l_decap_8
X_2735_ _3978_/A3 VPWR VGND sg13cmos5l_tielo
XFILLER_507_161 VPWR VGND sg13cmos5l_decap_8
XFILLER_380_126 VPWR VGND sg13cmos5l_decap_8
XFILLER_380_137 VPWR VGND sg13cmos5l_fill_2
XFILLER_117_145 VPWR VGND sg13cmos5l_decap_8
X_2666_ _2666_/Q Tile_X0Y6_FrameData[29] VGND VPWR Tile_X0Y9_FrameStrobe[7] latch
XFILLER_117_167 VPWR VGND sg13cmos5l_fill_1
X_4405_ _4405_/X _0159_/X _0145_/X _4461_/X _4465_/X _2293_/Q _2292_/Q VPWR VGND sg13cmos5l_mux4_1
XFILLER_393_72 VPWR VGND sg13cmos5l_fill_1
XFILLER_117_189 VPWR VGND sg13cmos5l_decap_4
X_1617_ _1617_/Q Tile_X0Y2_FrameData[0] VGND VPWR Tile_X0Y9_FrameStrobe[5] latch
XFILLER_321_215 VPWR VGND sg13cmos5l_decap_8
XFILLER_132_126 VPWR VGND sg13cmos5l_decap_8
XFILLER_278_119 VPWR VGND sg13cmos5l_decap_8
X_2597_ _2597_/Q Tile_X0Y6_FrameData[2] VGND VPWR Tile_X0Y9_FrameStrobe[4] latch
XFILLER_668_179 VPWR VGND sg13cmos5l_fill_1
XANTENNA__3207__X Tile_X0Y0_N2BEG[7] VPWR VGND sg13cmos5l_antennanp
XFILLER_683_105 VPWR VGND sg13cmos5l_fill_1
XFILLER_609_202 VPWR VGND sg13cmos5l_decap_8
XFILLER_543_42 VPWR VGND sg13cmos5l_decap_8
X_4336_ _4336_/X _4302_/X _0099_/X _4301_/X _0112_/X _1981_/Q _1980_/Q VPWR VGND sg13cmos5l_mux4_1
XFILLER_683_127 VPWR VGND sg13cmos5l_fill_1
XFILLER_5_91 VPWR VGND sg13cmos5l_decap_8
X_1548_ _1548_/Q Tile_X0Y2_FrameData[5] VGND VPWR Tile_X0Y9_FrameStrobe[3] latch
XFILLER_690_70 VPWR VGND sg13cmos5l_decap_8
XFILLER_262_21 VPWR VGND sg13cmos5l_decap_8
XFILLER_676_190 VPWR VGND sg13cmos5l_decap_8
X_4267_ _4267_/X Tile_X0Y4_W2END[4] AXI_M_SOC_BRESP0 _4319_/X _4318_/X _2079_/Q _2078_/Q
+ VPWR VGND sg13cmos5l_mux4_1
X_1479_ _1479_/Q Tile_X0Y2_FrameData[10] VGND VPWR Tile_X0Y9_FrameStrobe[1] latch
XFILLER_435_105 VPWR VGND sg13cmos5l_decap_8
XFILLER_624_205 VPWR VGND sg13cmos5l_decap_8
XFILLER_286_196 VPWR VGND sg13cmos5l_decap_8
X_3218_ Tile_X0Y0_FrameStrobe_O[6] Tile_X0Y9_FrameStrobe[6] VPWR VGND sg13cmos5l_buf_1
X_4198_ _4198_/X _4195_/X Tile_X0Y3_W6END[0] _4194_/X _4198_/A3 _1681_/Q _1680_/Q
+ VPWR VGND sg13cmos5l_mux4_1
XFILLER_54_110 VPWR VGND sg13cmos5l_decap_8
X_3149_ Tile_X0Y7_FrameData_O[19] Tile_X0Y7_FrameData[19] VPWR VGND sg13cmos5l_buf_1
XFILLER_412_68 VPWR VGND sg13cmos5l_decap_8
XFILLER_131_14 VPWR VGND sg13cmos5l_decap_8
XFILLER_450_119 VPWR VGND sg13cmos5l_decap_4
XFILLER_488_28 VPWR VGND sg13cmos5l_decap_8
XFILLER_589_197 VPWR VGND sg13cmos5l_fill_1
XFILLER_54_187 VPWR VGND sg13cmos5l_decap_8
XANTENNA__2781__X Tile_X0Y3_EE4BEG[7] VPWR VGND sg13cmos5l_antennanp
XFILLER_152_7 VPWR VGND sg13cmos5l_decap_8
XFILLER_211_91 VPWR VGND sg13cmos5l_decap_8
XFILLER_24_56 VPWR VGND sg13cmos5l_decap_8
XFILLER_356_112 VPWR VGND sg13cmos5l_decap_8
XFILLER_417_7 VPWR VGND sg13cmos5l_decap_8
XFILLER_287_84 VPWR VGND sg13cmos5l_decap_8
XFILLER_437_21 VPWR VGND sg13cmos5l_decap_8
XFILLER_6_228 VPWR VGND sg13cmos5l_fill_1
XFILLER_356_189 VPWR VGND sg13cmos5l_decap_8
XFILLER_371_126 VPWR VGND sg13cmos5l_decap_4
XFILLER_371_159 VPWR VGND sg13cmos5l_fill_2
XFILLER_513_142 VPWR VGND sg13cmos5l_decap_8
XFILLER_437_98 VPWR VGND sg13cmos5l_decap_8
XFILLER_108_189 VPWR VGND sg13cmos5l_decap_8
XFILLER_156_77 VPWR VGND sg13cmos5l_decap_8
XFILLER_458_208 VPWR VGND sg13cmos5l_decap_8
XFILLER_306_14 VPWR VGND sg13cmos5l_decap_8
XFILLER_513_186 VPWR VGND sg13cmos5l_fill_1
XANTENNA__3117__X Tile_X0Y7_EE4BEG[3] VPWR VGND sg13cmos5l_antennanp
XFILLER_453_42 VPWR VGND sg13cmos5l_decap_8
XFILLER_49_31 VPWR VGND sg13cmos5l_decap_8
XFILLER_172_21 VPWR VGND sg13cmos5l_decap_8
XANTENNA__2956__X Tile_X0Y8_EE4BEG[12] VPWR VGND sg13cmos5l_antennanp
XFILLER_426_105 VPWR VGND sg13cmos5l_decap_8
XFILLER_603_56 VPWR VGND sg13cmos5l_decap_8
XFILLER_615_227 VPWR VGND sg13cmos5l_fill_2
XFILLER_322_35 VPWR VGND sg13cmos5l_decap_8
XFILLER_1_49 VPWR VGND sg13cmos5l_decap_8
XFILLER_105_70 VPWR VGND sg13cmos5l_decap_8
XFILLER_276_0 VPWR VGND sg13cmos5l_decap_8
XFILLER_630_208 VPWR VGND sg13cmos5l_fill_2
XFILLER_679_49 VPWR VGND sg13cmos5l_decap_8
XFILLER_65_63 VPWR VGND sg13cmos5l_decap_8
XFILLER_65_85 VPWR VGND sg13cmos5l_decap_8
XFILLER_398_28 VPWR VGND sg13cmos5l_decap_8
XFILLER_379_215 VPWR VGND sg13cmos5l_fill_2
XFILLER_443_0 VPWR VGND sg13cmos5l_decap_8
XFILLER_198_170 VPWR VGND sg13cmos5l_fill_1
XFILLER_347_112 VPWR VGND sg13cmos5l_decap_8
XFILLER_610_0 VPWR VGND sg13cmos5l_decap_8
XFILLER_198_192 VPWR VGND sg13cmos5l_fill_2
XFILLER_708_0 VPWR VGND sg13cmos5l_decap_8
X_0850_ _0850_/Q Tile_X0Y9_FrameData[13] VGND VPWR Tile_X0Y9_FrameStrobe[5] latch
XFILLER_197_84 VPWR VGND sg13cmos5l_decap_8
XFILLER_347_21 VPWR VGND sg13cmos5l_decap_8
XFILLER_628_75 VPWR VGND sg13cmos5l_decap_8
XFILLER_551_204 VPWR VGND sg13cmos5l_decap_8
XFILLER_551_215 VPWR VGND sg13cmos5l_fill_1
XFILLER_362_126 VPWR VGND sg13cmos5l_fill_1
X_0781_ _0781_/Q Tile_X0Y9_FrameData[18] VGND VPWR Tile_X0Y9_FrameStrobe[3] latch
X_2520_ _2520_/Q Tile_X0Y6_FrameData[15] VGND VPWR Tile_X0Y9_FrameStrobe[2] latch
XFILLER_362_159 VPWR VGND sg13cmos5l_decap_4
XFILLER_347_98 VPWR VGND sg13cmos5l_decap_8
XFILLER_303_215 VPWR VGND sg13cmos5l_decap_4
X_2451_ _2451_/Q Tile_X0Y6_FrameData[20] VGND VPWR Tile_X0Y9_FrameStrobe[0] latch
XFILLER_644_63 VPWR VGND sg13cmos5l_decap_8
XFILLER_114_126 VPWR VGND sg13cmos5l_decap_8
XFILLER_449_219 VPWR VGND sg13cmos5l_fill_1
XFILLER_216_14 VPWR VGND sg13cmos5l_decap_8
XANTENNA__3027__X Tile_X0Y5_EE4BEG[2] VPWR VGND sg13cmos5l_antennanp
XFILLER_665_105 VPWR VGND sg13cmos5l_decap_8
X_1402_ _1402_/Q Tile_X0Y1_FrameData[31] VGND VPWR Tile_X0Y9_FrameStrobe[7] latch
XFILLER_363_42 VPWR VGND sg13cmos5l_decap_8
X_2382_ _2382_/Q Tile_X0Y5_FrameData[23] VGND VPWR Tile_X0Y9_FrameStrobe[6] latch
XFILLER_665_138 VPWR VGND sg13cmos5l_fill_1
X_4121_ _4121_/X _4091_/X _0064_/X _4090_/X Tile_X0Y0_S4END[9] _1471_/Q _1470_/Q VPWR
+ VGND sg13cmos5l_mux4_1
XANTENNA__2866__X Tile_X0Y6_EE4BEG[3] VPWR VGND sg13cmos5l_antennanp
X_1333_ _1333_/Q Tile_X0Y1_FrameData[4] VGND VPWR Tile_X0Y9_FrameStrobe[4] latch
XFILLER_417_105 VPWR VGND sg13cmos5l_decap_4
XFILLER_513_56 VPWR VGND sg13cmos5l_decap_8
XFILLER_268_196 VPWR VGND sg13cmos5l_decap_8
X_4052_ _4052_/X Tile_X0Y2_W2END[3] AXI_M_SOC_AWREADY _4103_/X _4102_/X _1569_/Q _1568_/Q
+ VPWR VGND sg13cmos5l_mux4_1
XFILLER_606_227 VPWR VGND sg13cmos5l_fill_2
XFILLER_283_133 VPWR VGND sg13cmos5l_decap_8
X_1264_ _1264_/Q Tile_X0Y1_FrameData[9] VGND VPWR Tile_X0Y9_FrameStrobe[2] latch
XFILLER_660_84 VPWR VGND sg13cmos5l_decap_8
XFILLER_232_35 VPWR VGND sg13cmos5l_decap_8
X_3003_ Tile_X0Y5_E2BEG[6] _4378_/X VPWR VGND sg13cmos5l_buf_1
X_0215_ _0215_/Q Tile_X0Y7_FrameData[8] VGND VPWR Tile_X0Y9_FrameStrobe[1] latch
XFILLER_36_121 VPWR VGND sg13cmos5l_fill_2
X_1195_ _1195_/Q Tile_X0Y1_FrameData[14] VGND VPWR Tile_X0Y9_FrameStrobe[0] latch
XFILLER_589_49 VPWR VGND sg13cmos5l_decap_8
XFILLER_432_119 VPWR VGND sg13cmos5l_decap_8
XFILLER_425_182 VPWR VGND sg13cmos5l_decap_8
X_0146_ AXI_M_SOC_ARCACHE3 _0929_/Q _3777_/X VPWR VGND sg13cmos5l_nor2b_1
XFILLER_425_193 VPWR VGND sg13cmos5l_fill_2
XFILLER_586_112 VPWR VGND sg13cmos5l_decap_8
XANTENNA__3697__X AXI_M_SOC_WDATA7 VPWR VGND sg13cmos5l_antennanp
XFILLER_51_124 VPWR VGND sg13cmos5l_decap_8
XFILLER_101_28 VPWR VGND sg13cmos5l_decap_8
XFILLER_440_163 VPWR VGND sg13cmos5l_decap_8
X_0077_ _0077_/X _4792_/X _4793_/X _2119_/Q VPWR VGND sg13cmos5l_mux2_1
XFILLER_51_146 VPWR VGND sg13cmos5l_decap_8
X_3905_ _3905_/X _4015_/X _4019_/X _3996_/X _3995_/X _1392_/Q _1391_/Q VPWR VGND sg13cmos5l_mux4_1
X_4885_ _4885_/X AXI_M_SOC_RDATA1 _4922_/X _4926_/X _4903_/X _0773_/Q _0772_/Q VPWR
+ VGND sg13cmos5l_mux4_1
XFILLER_388_94 VPWR VGND sg13cmos5l_fill_1
XFILLER_538_42 VPWR VGND sg13cmos5l_decap_8
X_3836_ _3836_/X _0067_/X Tile_X0Y0_S4END[0] _3864_/X _3863_/X _1033_/Q _1032_/Q VPWR
+ VGND sg13cmos5l_mux4_1
XFILLER_685_70 VPWR VGND sg13cmos5l_decap_8
XFILLER_257_21 VPWR VGND sg13cmos5l_decap_8
X_3767_ _3767_/X Tile_X0Y1_WW4END[0] Tile_X0Y1_WW4END[8] Tile_X0Y1_W6END[8] _4016_/X
+ _1241_/Q _1240_/Q VPWR VGND sg13cmos5l_mux4_1
XFILLER_499_119 VPWR VGND sg13cmos5l_decap_8
XFILLER_353_126 VPWR VGND sg13cmos5l_decap_8
X_0979_ _0979_/Q Tile_X0Y0_FrameData[24] VGND VPWR Tile_X0Y9_FrameStrobe[1] latch
X_2718_ _4774_/A3 VPWR VGND sg13cmos5l_tielo
X_3698_ AXI_M_SOC_WDATA8 Tile_X0Y7_WW4END[0] Tile_X0Y7_WW4END[8] Tile_X0Y7_W6END[8]
+ _4692_/X _0231_/Q _0230_/Q VPWR VGND sg13cmos5l_mux4_1
XFILLER_10_14 VPWR VGND sg13cmos5l_decap_8
XFILLER_407_35 VPWR VGND sg13cmos5l_decap_8
XFILLER_554_63 VPWR VGND sg13cmos5l_decap_8
X_2649_ _2649_/Q Tile_X0Y6_FrameData[14] VGND VPWR Tile_X0Y9_FrameStrobe[6] latch
XFILLER_126_14 VPWR VGND sg13cmos5l_decap_8
XFILLER_105_137 VPWR VGND sg13cmos5l_decap_8
XFILLER_656_105 VPWR VGND sg13cmos5l_decap_8
XFILLER_510_112 VPWR VGND sg13cmos5l_decap_8
XFILLER_273_42 VPWR VGND sg13cmos5l_decap_8
XFILLER_120_107 VPWR VGND sg13cmos5l_decap_8
XANTENNA__2776__X Tile_X0Y3_EE4BEG[2] VPWR VGND sg13cmos5l_antennanp
XFILLER_704_77 VPWR VGND sg13cmos5l_decap_8
X_4319_ _4319_/X _4243_/X _4359_/X _4358_/X _4242_/X _1943_/Q _1942_/Q VPWR VGND sg13cmos5l_mux4_1
XFILLER_113_181 VPWR VGND sg13cmos5l_fill_1
XFILLER_259_185 VPWR VGND sg13cmos5l_decap_8
XFILLER_423_56 VPWR VGND sg13cmos5l_decap_8
XFILLER_206_91 VPWR VGND sg13cmos5l_decap_8
XFILLER_274_133 VPWR VGND sg13cmos5l_fill_2
XFILLER_19_56 VPWR VGND sg13cmos5l_decap_8
XFILLER_570_84 VPWR VGND sg13cmos5l_decap_8
XFILLER_142_35 VPWR VGND sg13cmos5l_decap_8
XFILLER_423_119 VPWR VGND sg13cmos5l_decap_8
XFILLER_367_7 VPWR VGND sg13cmos5l_decap_8
XFILLER_499_49 VPWR VGND sg13cmos5l_decap_8
XFILLER_215_211 VPWR VGND sg13cmos5l_decap_8
XFILLER_577_112 VPWR VGND sg13cmos5l_decap_8
XFILLER_534_7 VPWR VGND sg13cmos5l_decap_8
XFILLER_35_77 VPWR VGND sg13cmos5l_decap_8
XFILLER_187_118 VPWR VGND sg13cmos5l_decap_8
XANTENNA__3400__X Tile_X0Y2_E2BEG[3] VPWR VGND sg13cmos5l_antennanp
XFILLER_592_137 VPWR VGND sg13cmos5l_decap_8
XFILLER_701_7 VPWR VGND sg13cmos5l_decap_8
XFILLER_448_42 VPWR VGND sg13cmos5l_decap_8
XFILLER_329_145 VPWR VGND sg13cmos5l_decap_8
XFILLER_595_70 VPWR VGND sg13cmos5l_decap_8
XFILLER_167_21 VPWR VGND sg13cmos5l_decap_8
XFILLER_195_184 VPWR VGND sg13cmos5l_decap_8
XFILLER_51_76 VPWR VGND sg13cmos5l_decap_8
XFILLER_344_126 VPWR VGND sg13cmos5l_decap_4
XFILLER_317_35 VPWR VGND sg13cmos5l_decap_8
XFILLER_681_28 VPWR VGND sg13cmos5l_decap_8
XFILLER_464_63 VPWR VGND sg13cmos5l_decap_8
XFILLER_501_112 VPWR VGND sg13cmos5l_decap_8
XFILLER_647_105 VPWR VGND sg13cmos5l_decap_8
XFILLER_4_0 VPWR VGND sg13cmos5l_decap_8
XFILLER_183_42 VPWR VGND sg13cmos5l_decap_8
XFILLER_498_196 VPWR VGND sg13cmos5l_decap_8
XFILLER_393_0 VPWR VGND sg13cmos5l_decap_8
XFILLER_501_189 VPWR VGND sg13cmos5l_decap_8
XFILLER_614_77 VPWR VGND sg13cmos5l_decap_8
XFILLER_265_100 VPWR VGND sg13cmos5l_decap_8
XFILLER_454_200 VPWR VGND sg13cmos5l_fill_2
XFILLER_333_56 VPWR VGND sg13cmos5l_decap_8
XFILLER_655_182 VPWR VGND sg13cmos5l_decap_8
XFILLER_630_21 VPWR VGND sg13cmos5l_decap_8
XFILLER_560_0 VPWR VGND sg13cmos5l_decap_8
XFILLER_76_84 VPWR VGND sg13cmos5l_decap_8
XFILLER_658_0 VPWR VGND sg13cmos5l_decap_8
XFILLER_265_188 VPWR VGND sg13cmos5l_decap_4
XFILLER_280_147 VPWR VGND sg13cmos5l_decap_8
XFILLER_630_98 VPWR VGND sg13cmos5l_decap_8
XFILLER_202_49 VPWR VGND sg13cmos5l_decap_8
XFILLER_568_112 VPWR VGND sg13cmos5l_decap_8
XFILLER_33_113 VPWR VGND sg13cmos5l_fill_2
XANTENNA__3310__X Tile_X0Y0_E1BEG[2] VPWR VGND sg13cmos5l_antennanp
XFILLER_422_196 VPWR VGND sg13cmos5l_decap_8
X_1951_ _1951_/Q Tile_X0Y4_FrameData[6] VGND VPWR Tile_X0Y9_FrameStrobe[0] latch
XFILLER_639_63 VPWR VGND sg13cmos5l_decap_8
X_0902_ _0902_/Q Tile_X0Y9_FrameData[25] VGND VPWR Tile_X0Y9_FrameStrobe[7] latch
XFILLER_358_42 VPWR VGND sg13cmos5l_decap_8
X_4670_ _4670_/X _4597_/X _4713_/X _4712_/X _4596_/X _0171_/Q _0170_/Q VPWR VGND sg13cmos5l_mux4_1
X_1882_ _1882_/Q Tile_X0Y3_FrameData[15] VGND VPWR Tile_X0Y9_FrameStrobe[6] latch
XFILLER_186_173 VPWR VGND sg13cmos5l_decap_4
X_3621_ Tile_X0Y9_S2BEGb[7] _4939_/X VPWR VGND sg13cmos5l_buf_1
X_0833_ _0833_/Q Tile_X0Y9_FrameData[30] VGND VPWR Tile_X0Y9_FrameStrobe[5] latch
XFILLER_508_56 VPWR VGND sg13cmos5l_decap_8
X_3552_ Tile_X0Y9_E6BEG[10] _4890_/X VPWR VGND sg13cmos5l_buf_1
X_0764_ _0764_/Q Tile_X0Y9_FrameData[3] VGND VPWR Tile_X0Y9_FrameStrobe[2] latch
XFILLER_655_84 VPWR VGND sg13cmos5l_decap_8
XFILLER_227_35 VPWR VGND sg13cmos5l_decap_8
X_2503_ _2503_/Q Tile_X0Y6_FrameData[0] VGND VPWR Tile_X0Y9_FrameStrobe[1] latch
XFILLER_142_210 VPWR VGND sg13cmos5l_decap_8
XFILLER_591_28 VPWR VGND sg13cmos5l_decap_8
XFILLER_374_63 VPWR VGND sg13cmos5l_decap_8
XFILLER_288_203 VPWR VGND sg13cmos5l_fill_2
X_3483_ Tile_X0Y1_EE4BEG[9] _3957_/X VPWR VGND sg13cmos5l_buf_1
X_0695_ _0695_/Q Tile_X0Y9_FrameData[8] VGND VPWR Tile_X0Y9_FrameStrobe[0] latch
XFILLER_638_105 VPWR VGND sg13cmos5l_decap_8
XFILLER_489_196 VPWR VGND sg13cmos5l_decap_4
X_2434_ _2434_/Q Tile_X0Y5_FrameData[3] VGND VPWR Tile_X0Y9_FrameStrobe[7] latch
XFILLER_37_0 VPWR VGND sg13cmos5l_fill_1
XFILLER_524_77 VPWR VGND sg13cmos5l_fill_2
X_2365_ _2365_/Q Tile_X0Y5_FrameData[8] VGND VPWR Tile_X0Y9_FrameStrobe[5] latch
XFILLER_653_119 VPWR VGND sg13cmos5l_decap_8
XFILLER_243_56 VPWR VGND sg13cmos5l_decap_8
X_4104_ _4104_/X _4095_/X _0094_/X _4094_/X Tile_X0Y0_S4END[11] _1451_/Q _1450_/Q
+ VPWR VGND sg13cmos5l_mux4_1
X_1316_ _1316_/Q Tile_X0Y1_FrameData[21] VGND VPWR Tile_X0Y9_FrameStrobe[4] latch
XFILLER_646_182 VPWR VGND sg13cmos5l_decap_8
X_2296_ _2296_/Q Tile_X0Y5_FrameData[13] VGND VPWR Tile_X0Y9_FrameStrobe[3] latch
XFILLER_540_21 VPWR VGND sg13cmos5l_decap_8
XFILLER_661_141 VPWR VGND sg13cmos5l_decap_4
XFILLER_2_70 VPWR VGND sg13cmos5l_decap_8
X_4035_ _4035_/X Tile_X0Y3_W2MID[0] Tile_X0Y3_W2END[0] Tile_X0Y3_W6END[0] _4204_/X
+ _1903_/Q _1902_/Q VPWR VGND sg13cmos5l_mux4_1
X_1247_ _1247_/Q Tile_X0Y1_FrameData[26] VGND VPWR Tile_X0Y9_FrameStrobe[2] latch
XFILLER_661_174 VPWR VGND sg13cmos5l_fill_2
XFILLER_460_225 VPWR VGND sg13cmos5l_decap_4
XFILLER_540_98 VPWR VGND sg13cmos5l_decap_8
X_1178_ _1178_/Q Tile_X0Y0_FrameData[31] VGND VPWR Tile_X0Y9_FrameStrobe[0] latch
XFILLER_559_112 VPWR VGND sg13cmos5l_decap_8
XFILLER_112_49 VPWR VGND sg13cmos5l_decap_8
X_0129_ _3636_/A _4840_/X _4841_/X _0859_/Q VPWR VGND sg13cmos5l_mux2_1
XFILLER_24_135 VPWR VGND sg13cmos5l_decap_8
XFILLER_212_214 VPWR VGND sg13cmos5l_decap_8
XANTENNA__3220__X Tile_X0Y0_FrameStrobe_O[8] VPWR VGND sg13cmos5l_antennanp
XFILLER_212_225 VPWR VGND sg13cmos5l_decap_4
XFILLER_413_196 VPWR VGND sg13cmos5l_fill_1
X_4937_ _4937_/X Tile_X0Y8_W1END[1] Tile_X0Y8_W2MID[2] Tile_X0Y8_W2END[2] _4788_/X
+ _0617_/Q _0616_/Q VPWR VGND sg13cmos5l_mux4_1
XFILLER_574_126 VPWR VGND sg13cmos5l_decap_8
XFILLER_549_63 VPWR VGND sg13cmos5l_decap_8
XFILLER_696_91 VPWR VGND sg13cmos5l_decap_8
XANTENNA_20 Tile_X0Y0_S4END[12] VPWR VGND sg13cmos5l_antennanp
XANTENNA_31 Tile_X0Y9_FrameStrobe[13] VPWR VGND sg13cmos5l_antennanp
X_4868_ _4868_/X Tile_X0Y9_WW4END[11] AXI_M_SOC_RDATA4 _4927_/X _4907_/X _0807_/Q
+ _0806_/Q VPWR VGND sg13cmos5l_mux4_1
XANTENNA_42 Tile_X0Y9_N2MID[1] VPWR VGND sg13cmos5l_antennanp
XFILLER_268_75 VPWR VGND sg13cmos5l_decap_8
XFILLER_177_173 VPWR VGND sg13cmos5l_decap_8
XANTENNA_53 Tile_X0Y9_N2MID[5] VPWR VGND sg13cmos5l_antennanp
XFILLER_515_215 VPWR VGND sg13cmos5l_decap_4
X_3819_ _3819_/X Tile_X0Y0_W2END[0] _3853_/X _3852_/X _3861_/X _1067_/Q _1066_/Q VPWR
+ VGND sg13cmos5l_mux4_1
X_4799_ _4799_/X _4343_/X _4347_/X _4351_/X _4312_/X _2112_/Q _2111_/Q VPWR VGND sg13cmos5l_mux4_1
XFILLER_418_56 VPWR VGND sg13cmos5l_decap_8
XFILLER_21_35 VPWR VGND sg13cmos5l_decap_8
XFILLER_115_7 VPWR VGND sg13cmos5l_decap_8
XFILLER_565_84 VPWR VGND sg13cmos5l_decap_8
XFILLER_715_21 VPWR VGND sg13cmos5l_decap_8
XFILLER_192_187 VPWR VGND sg13cmos5l_decap_8
XFILLER_137_35 VPWR VGND sg13cmos5l_decap_8
XFILLER_334_170 VPWR VGND sg13cmos5l_decap_4
XFILLER_284_63 VPWR VGND sg13cmos5l_decap_8
XFILLER_133_221 VPWR VGND sg13cmos5l_fill_1
XFILLER_629_105 VPWR VGND sg13cmos5l_fill_2
XFILLER_97_28 VPWR VGND sg13cmos5l_decap_8
XFILLER_279_225 VPWR VGND sg13cmos5l_fill_1
XFILLER_715_76 VPWR VGND sg13cmos5l_decap_8
XFILLER_629_138 VPWR VGND sg13cmos5l_fill_2
XFILLER_495_133 VPWR VGND sg13cmos5l_decap_8
XFILLER_629_149 VPWR VGND sg13cmos5l_fill_1
XFILLER_434_77 VPWR VGND sg13cmos5l_decap_8
XFILLER_294_228 VPWR VGND sg13cmos5l_fill_1
XFILLER_644_119 VPWR VGND sg13cmos5l_decap_8
XFILLER_484_7 VPWR VGND sg13cmos5l_fill_2
XFILLER_153_56 VPWR VGND sg13cmos5l_decap_8
XFILLER_47_227 VPWR VGND sg13cmos5l_fill_2
XFILLER_450_21 VPWR VGND sg13cmos5l_decap_8
XFILLER_101_184 VPWR VGND sg13cmos5l_decap_4
XFILLER_651_7 VPWR VGND sg13cmos5l_decap_8
XFILLER_451_225 VPWR VGND sg13cmos5l_decap_4
XFILLER_247_199 VPWR VGND sg13cmos5l_decap_8
XFILLER_46_76 VPWR VGND sg13cmos5l_decap_8
XFILLER_262_158 VPWR VGND sg13cmos5l_decap_8
XFILLER_600_35 VPWR VGND sg13cmos5l_decap_8
XFILLER_15_102 VPWR VGND sg13cmos5l_fill_2
XFILLER_404_163 VPWR VGND sg13cmos5l_decap_4
XANTENNA__3130__X Tile_X0Y7_FrameData_O[0] VPWR VGND sg13cmos5l_antennanp
XFILLER_404_185 VPWR VGND sg13cmos5l_fill_1
XFILLER_349_218 VPWR VGND sg13cmos5l_fill_1
XFILLER_15_168 VPWR VGND sg13cmos5l_fill_1
XFILLER_676_28 VPWR VGND sg13cmos5l_decap_8
XFILLER_565_126 VPWR VGND sg13cmos5l_decap_8
XFILLER_459_63 VPWR VGND sg13cmos5l_decap_8
XFILLER_30_116 VPWR VGND sg13cmos5l_fill_2
XFILLER_141_0 VPWR VGND sg13cmos5l_decap_8
XFILLER_178_42 VPWR VGND sg13cmos5l_decap_8
XFILLER_239_0 VPWR VGND sg13cmos5l_decap_8
XFILLER_609_77 VPWR VGND sg13cmos5l_decap_8
XFILLER_692_16 VPWR VGND sg13cmos5l_fill_1
XFILLER_406_0 VPWR VGND sg13cmos5l_decap_8
XFILLER_328_56 VPWR VGND sg13cmos5l_decap_8
XFILLER_692_49 VPWR VGND sg13cmos5l_decap_8
XFILLER_625_21 VPWR VGND sg13cmos5l_decap_8
XFILLER_521_218 VPWR VGND sg13cmos5l_fill_1
XFILLER_194_63 VPWR VGND sg13cmos5l_decap_8
XFILLER_486_133 VPWR VGND sg13cmos5l_decap_8
X_0480_ _0480_/Q Tile_X0Y8_FrameData[31] VGND VPWR Tile_X0Y9_FrameStrobe[2] latch
XFILLER_625_98 VPWR VGND sg13cmos5l_decap_8
XFILLER_486_144 VPWR VGND sg13cmos5l_fill_1
XFILLER_486_166 VPWR VGND sg13cmos5l_decap_8
XFILLER_285_217 VPWR VGND sg13cmos5l_fill_1
XFILLER_344_77 VPWR VGND sg13cmos5l_decap_8
XFILLER_635_119 VPWR VGND sg13cmos5l_decap_8
XANTENNA__3305__X Tile_X0Y0_E2BEG[5] VPWR VGND sg13cmos5l_antennanp
XFILLER_641_42 VPWR VGND sg13cmos5l_decap_8
X_2150_ _2150_/Q Tile_X0Y4_FrameData[31] VGND VPWR Tile_X0Y9_FrameStrobe[7] latch
XFILLER_360_21 VPWR VGND sg13cmos5l_decap_8
X_1101_ _1101_/Q Tile_X0Y0_FrameData[30] VGND VPWR Tile_X0Y9_FrameStrobe[5] latch
X_2081_ _2081_/Q Tile_X0Y4_FrameData[4] VGND VPWR Tile_X0Y9_FrameStrobe[4] latch
XFILLER_442_214 VPWR VGND sg13cmos5l_decap_8
XFILLER_238_199 VPWR VGND sg13cmos5l_fill_1
X_1032_ _1032_/Q Tile_X0Y0_FrameData[3] VGND VPWR Tile_X0Y9_FrameStrobe[2] latch
XFILLER_643_196 VPWR VGND sg13cmos5l_decap_8
XFILLER_360_98 VPWR VGND sg13cmos5l_decap_4
XFILLER_510_35 VPWR VGND sg13cmos5l_decap_8
XANTENNA__3040__X Tile_X0Y5_EE4BEG[15] VPWR VGND sg13cmos5l_antennanp
XFILLER_586_28 VPWR VGND sg13cmos5l_decap_8
XFILLER_369_63 VPWR VGND sg13cmos5l_decap_8
X_2983_ Tile_X0Y8_FrameData_O[23] Tile_X0Y8_FrameData[23] VPWR VGND sg13cmos5l_buf_1
X_4722_ _4722_/X Tile_X0Y8_W1END[3] Tile_X0Y8_WW4END[15] Tile_X0Y8_W6END[7] _4803_/X
+ _0602_/Q _0601_/Q VPWR VGND sg13cmos5l_mux4_1
XFILLER_410_177 VPWR VGND sg13cmos5l_decap_8
X_1934_ _1934_/Q Tile_X0Y4_FrameData[23] VGND VPWR Tile_X0Y9_FrameStrobe[0] latch
XFILLER_159_162 VPWR VGND sg13cmos5l_decap_8
XFILLER_519_77 VPWR VGND sg13cmos5l_fill_1
X_1865_ _1865_/Q Tile_X0Y3_FrameData[0] VGND VPWR Tile_X0Y9_FrameStrobe[5] latch
X_4653_ _4653_/X AXI_M_SOC_RDATA21 _4686_/X _4690_/X _4672_/X _0253_/Q _0252_/Q VPWR
+ VGND sg13cmos5l_mux4_1
XFILLER_713_112 VPWR VGND sg13cmos5l_decap_8
XFILLER_238_56 VPWR VGND sg13cmos5l_decap_8
XFILLER_174_154 VPWR VGND sg13cmos5l_decap_8
X_0816_ _0816_/Q Tile_X0Y9_FrameData[15] VGND VPWR Tile_X0Y9_FrameStrobe[4] latch
X_3604_ Tile_X0Y9_S1BEG[2] _4826_/X VPWR VGND sg13cmos5l_buf_1
X_1796_ _1796_/Q Tile_X0Y3_FrameData[5] VGND VPWR Tile_X0Y9_FrameStrobe[3] latch
X_4584_ _4584_/X Tile_X0Y5_W2MID[7] Tile_X0Y5_W2END[7] Tile_X0Y5_W6END[8] _4467_/X
+ _2395_/Q _2394_/Q VPWR VGND sg13cmos5l_mux4_1
XFILLER_535_21 VPWR VGND sg13cmos5l_decap_8
XFILLER_512_218 VPWR VGND sg13cmos5l_fill_1
XFILLER_713_189 VPWR VGND sg13cmos5l_decap_8
X_0747_ _0747_/Q Tile_X0Y9_FrameData[20] VGND VPWR Tile_X0Y9_FrameStrobe[2] latch
X_3535_ Tile_X0Y9_E2BEGb[1] _4857_/X VPWR VGND sg13cmos5l_buf_1
XFILLER_477_111 VPWR VGND sg13cmos5l_decap_8
X_3466_ Tile_X0Y1_FrameData_O[24] Tile_X0Y1_FrameData[24] VPWR VGND sg13cmos5l_buf_1
XFILLER_535_98 VPWR VGND sg13cmos5l_fill_2
XFILLER_477_133 VPWR VGND sg13cmos5l_fill_1
XFILLER_130_202 VPWR VGND sg13cmos5l_fill_1
X_0678_ _0678_/Q Tile_X0Y9_FrameData[25] VGND VPWR Tile_X0Y9_FrameStrobe[0] latch
XFILLER_107_49 VPWR VGND sg13cmos5l_decap_8
XFILLER_477_155 VPWR VGND sg13cmos5l_decap_8
X_2417_ _2417_/Q Tile_X0Y5_FrameData[20] VGND VPWR Tile_X0Y9_FrameStrobe[7] latch
XFILLER_331_184 VPWR VGND sg13cmos5l_decap_4
XFILLER_404_14 VPWR VGND sg13cmos5l_decap_8
XFILLER_276_228 VPWR VGND sg13cmos5l_fill_1
X_3397_ Tile_X0Y2_E2BEG[0] _4040_/X VPWR VGND sg13cmos5l_buf_1
XANTENNA__3215__X Tile_X0Y0_FrameStrobe_O[3] VPWR VGND sg13cmos5l_antennanp
XFILLER_418_211 VPWR VGND sg13cmos5l_decap_8
XFILLER_551_42 VPWR VGND sg13cmos5l_decap_8
XFILLER_492_147 VPWR VGND sg13cmos5l_decap_8
X_2348_ _2348_/Q Tile_X0Y5_FrameData[25] VGND VPWR Tile_X0Y9_FrameStrobe[5] latch
XFILLER_270_21 VPWR VGND sg13cmos5l_decap_8
X_2279_ _2279_/Q Tile_X0Y5_FrameData[30] VGND VPWR Tile_X0Y9_FrameStrobe[3] latch
XFILLER_701_56 VPWR VGND sg13cmos5l_decap_8
X_4018_ _4018_/X _3985_/X _0095_/X _3984_/X Tile_X0Y0_S4END[6] _1213_/Q _1212_/Q VPWR
+ VGND sg13cmos5l_mux4_1
XFILLER_270_98 VPWR VGND sg13cmos5l_decap_8
XFILLER_420_35 VPWR VGND sg13cmos5l_decap_8
XFILLER_203_70 VPWR VGND sg13cmos5l_decap_8
XFILLER_16_35 VPWR VGND sg13cmos5l_decap_8
XFILLER_197_202 VPWR VGND sg13cmos5l_decap_8
XFILLER_547_115 VPWR VGND sg13cmos5l_fill_2
XFILLER_496_28 VPWR VGND sg13cmos5l_decap_8
XFILLER_279_63 VPWR VGND sg13cmos5l_decap_8
XFILLER_12_116 VPWR VGND sg13cmos5l_fill_1
XFILLER_232_7 VPWR VGND sg13cmos5l_decap_8
XFILLER_200_228 VPWR VGND sg13cmos5l_fill_1
XFILLER_32_45 VPWR VGND sg13cmos5l_decap_8
XFILLER_429_77 VPWR VGND sg13cmos5l_decap_8
XFILLER_704_112 VPWR VGND sg13cmos5l_decap_8
XFILLER_32_89 VPWR VGND sg13cmos5l_fill_1
XFILLER_148_56 VPWR VGND sg13cmos5l_decap_8
XFILLER_570_140 VPWR VGND sg13cmos5l_decap_8
XFILLER_295_84 VPWR VGND sg13cmos5l_decap_8
XFILLER_445_21 VPWR VGND sg13cmos5l_decap_8
XFILLER_165_187 VPWR VGND sg13cmos5l_fill_1
XFILLER_704_189 VPWR VGND sg13cmos5l_decap_4
XFILLER_180_146 VPWR VGND sg13cmos5l_decap_8
XFILLER_699_7 VPWR VGND sg13cmos5l_fill_1
XFILLER_121_213 VPWR VGND sg13cmos5l_fill_1
XFILLER_267_228 VPWR VGND sg13cmos5l_fill_1
XFILLER_617_119 VPWR VGND sg13cmos5l_decap_8
XFILLER_314_14 VPWR VGND sg13cmos5l_decap_8
XANTENNA__3125__X Tile_X0Y7_EE4BEG[11] VPWR VGND sg13cmos5l_antennanp
XFILLER_672_225 VPWR VGND sg13cmos5l_decap_4
XFILLER_461_42 VPWR VGND sg13cmos5l_decap_8
XFILLER_94_119 VPWR VGND sg13cmos5l_decap_8
XFILLER_483_147 VPWR VGND sg13cmos5l_decap_8
XFILLER_57_42 VPWR VGND sg13cmos5l_decap_8
XFILLER_180_21 VPWR VGND sg13cmos5l_decap_8
XANTENNA__2964__X Tile_X0Y8_FrameData_O[4] VPWR VGND sg13cmos5l_antennanp
XFILLER_189_0 VPWR VGND sg13cmos5l_decap_8
XFILLER_611_56 VPWR VGND sg13cmos5l_decap_8
XFILLER_491_191 VPWR VGND sg13cmos5l_fill_2
XFILLER_180_98 VPWR VGND sg13cmos5l_decap_8
XFILLER_640_133 VPWR VGND sg13cmos5l_decap_8
XFILLER_330_35 VPWR VGND sg13cmos5l_decap_8
XFILLER_235_169 VPWR VGND sg13cmos5l_decap_4
XFILLER_113_70 VPWR VGND sg13cmos5l_decap_8
XFILLER_356_0 VPWR VGND sg13cmos5l_decap_8
XFILLER_389_140 VPWR VGND sg13cmos5l_decap_8
XFILLER_73_63 VPWR VGND sg13cmos5l_decap_8
XFILLER_687_49 VPWR VGND sg13cmos5l_decap_8
XFILLER_189_63 VPWR VGND sg13cmos5l_decap_8
XFILLER_523_0 VPWR VGND sg13cmos5l_decap_8
XFILLER_339_77 VPWR VGND sg13cmos5l_decap_8
XFILLER_78_7 VPWR VGND sg13cmos5l_decap_8
XFILLER_11_171 VPWR VGND sg13cmos5l_fill_1
XFILLER_636_42 VPWR VGND sg13cmos5l_decap_8
XFILLER_11_193 VPWR VGND sg13cmos5l_fill_1
X_1650_ _1650_/Q Tile_X0Y2_FrameData[31] VGND VPWR Tile_X0Y9_FrameStrobe[7] latch
XFILLER_561_140 VPWR VGND sg13cmos5l_fill_2
XFILLER_355_21 VPWR VGND sg13cmos5l_decap_8
XFILLER_156_198 VPWR VGND sg13cmos5l_fill_2
X_0601_ _0601_/Q Tile_X0Y8_FrameData[6] VGND VPWR Tile_X0Y9_FrameStrobe[5] latch
XFILLER_561_184 VPWR VGND sg13cmos5l_fill_1
XFILLER_710_126 VPWR VGND sg13cmos5l_decap_8
X_1581_ _1581_/Q Tile_X0Y2_FrameData[4] VGND VPWR Tile_X0Y9_FrameStrobe[4] latch
XFILLER_459_100 VPWR VGND sg13cmos5l_fill_2
XFILLER_648_200 VPWR VGND sg13cmos5l_decap_8
XFILLER_171_168 VPWR VGND sg13cmos5l_decap_8
X_3320_ Tile_X0Y4_EE4BEG[8] _4280_/X VPWR VGND sg13cmos5l_buf_1
X_0532_ _0532_/Q Tile_X0Y8_FrameData[11] VGND VPWR Tile_X0Y9_FrameStrobe[3] latch
XFILLER_459_144 VPWR VGND sg13cmos5l_decap_8
XFILLER_355_98 VPWR VGND sg13cmos5l_decap_8
XFILLER_505_35 VPWR VGND sg13cmos5l_decap_8
X_3251_ Tile_X0Y0_FrameData_O[19] Tile_X0Y0_FrameData[19] VPWR VGND sg13cmos5l_buf_1
XFILLER_652_63 VPWR VGND sg13cmos5l_decap_8
XFILLER_313_195 VPWR VGND sg13cmos5l_decap_4
XFILLER_258_228 VPWR VGND sg13cmos5l_fill_1
X_0463_ _0463_/Q Tile_X0Y8_FrameData[16] VGND VPWR Tile_X0Y9_FrameStrobe[1] latch
XFILLER_459_188 VPWR VGND sg13cmos5l_decap_8
XFILLER_224_14 VPWR VGND sg13cmos5l_decap_8
XFILLER_459_199 VPWR VGND sg13cmos5l_fill_2
XANTENNA__3035__X Tile_X0Y5_EE4BEG[10] VPWR VGND sg13cmos5l_antennanp
X_2202_ _2202_/Q Tile_X0Y5_FrameData[11] VGND VPWR Tile_X0Y9_FrameStrobe[0] latch
XFILLER_371_42 VPWR VGND sg13cmos5l_decap_8
X_3182_ Tile_X0Y0_N4BEG[6] _3182_/A VPWR VGND sg13cmos5l_buf_1
X_0394_ _0394_/Q Tile_X0Y7_FrameData[21] VGND VPWR Tile_X0Y9_FrameStrobe[7] latch
XFILLER_616_130 VPWR VGND sg13cmos5l_decap_8
XANTENNA__2874__X Tile_X0Y6_EE4BEG[11] VPWR VGND sg13cmos5l_antennanp
X_2133_ _2133_/Q Tile_X0Y4_FrameData[16] VGND VPWR Tile_X0Y9_FrameStrobe[6] latch
XFILLER_226_114 VPWR VGND sg13cmos5l_decap_4
XFILLER_521_56 VPWR VGND sg13cmos5l_decap_8
XFILLER_482_191 VPWR VGND sg13cmos5l_decap_8
X_2064_ _2064_/Q Tile_X0Y4_FrameData[21] VGND VPWR Tile_X0Y9_FrameStrobe[4] latch
XFILLER_240_35 VPWR VGND sg13cmos5l_decap_8
X_1015_ _1015_/Q Tile_X0Y0_FrameData[20] VGND VPWR Tile_X0Y9_FrameStrobe[2] latch
XFILLER_430_228 VPWR VGND sg13cmos5l_fill_1
XFILLER_597_49 VPWR VGND sg13cmos5l_decap_8
XFILLER_179_224 VPWR VGND sg13cmos5l_decap_4
XFILLER_584_221 VPWR VGND sg13cmos5l_fill_1
XFILLER_529_137 VPWR VGND sg13cmos5l_decap_4
X_2966_ Tile_X0Y8_FrameData_O[6] Tile_X0Y8_FrameData[6] VPWR VGND sg13cmos5l_buf_1
XFILLER_544_118 VPWR VGND sg13cmos5l_fill_2
X_4705_ _4705_/X Tile_X0Y9_W2MID[5] Tile_X0Y9_W2END[5] Tile_X0Y9_W6END[5] _4905_/X
+ _0915_/Q _0914_/Q VPWR VGND sg13cmos5l_mux4_1
XFILLER_336_221 VPWR VGND sg13cmos5l_fill_1
XFILLER_249_77 VPWR VGND sg13cmos5l_decap_8
X_1917_ _1917_/Q Tile_X0Y3_FrameData[12] VGND VPWR Tile_X0Y9_FrameStrobe[7] latch
XFILLER_147_143 VPWR VGND sg13cmos5l_decap_8
X_2897_ Tile_X0Y6_FrameData_O[18] Tile_X0Y6_FrameData[18] VPWR VGND sg13cmos5l_buf_1
XFILLER_546_42 VPWR VGND sg13cmos5l_decap_8
XFILLER_8_91 VPWR VGND sg13cmos5l_decap_8
X_4636_ _4636_/X Tile_X0Y7_WW4END[7] AXI_M_SOC_RDATA23 _4691_/X _4668_/X _0287_/Q
+ _0286_/Q VPWR VGND sg13cmos5l_mux4_1
XFILLER_162_102 VPWR VGND sg13cmos5l_fill_2
X_1848_ _1848_/Q Tile_X0Y3_FrameData[17] VGND VPWR Tile_X0Y9_FrameStrobe[5] latch
XFILLER_693_70 VPWR VGND sg13cmos5l_decap_8
XFILLER_351_202 VPWR VGND sg13cmos5l_decap_8
XFILLER_351_213 VPWR VGND sg13cmos5l_fill_1
XFILLER_265_21 VPWR VGND sg13cmos5l_decap_8
XFILLER_701_126 VPWR VGND sg13cmos5l_decap_4
X_1779_ _1779_/Q Tile_X0Y3_FrameData[22] VGND VPWR Tile_X0Y9_FrameStrobe[3] latch
X_4567_ _4567_/X _4123_/X _4127_/X _4104_/X _4096_/X _1604_/Q _1603_/Q VPWR VGND sg13cmos5l_mux4_1
X_3518_ Tile_X0Y1_E1BEG[0] _3928_/X VPWR VGND sg13cmos5l_buf_1
X_4498_ _4498_/X Tile_X0Y6_W2MID[5] AXI_M_SOC_RDATA26 _4557_/X _4556_/X _2611_/Q _2610_/Q
+ VPWR VGND sg13cmos5l_mux4_1
XFILLER_415_35 VPWR VGND sg13cmos5l_decap_8
XFILLER_249_206 VPWR VGND sg13cmos5l_decap_8
XFILLER_304_184 VPWR VGND sg13cmos5l_fill_1
XFILLER_103_224 VPWR VGND sg13cmos5l_decap_4
XFILLER_654_203 VPWR VGND sg13cmos5l_fill_2
XFILLER_562_63 VPWR VGND sg13cmos5l_decap_8
XFILLER_134_14 VPWR VGND sg13cmos5l_decap_8
X_3449_ Tile_X0Y1_FrameData_O[7] Tile_X0Y1_FrameData[7] VPWR VGND sg13cmos5l_buf_1
XFILLER_654_225 VPWR VGND sg13cmos5l_decap_4
XFILLER_281_42 VPWR VGND sg13cmos5l_decap_8
XFILLER_76_119 VPWR VGND sg13cmos5l_fill_1
XFILLER_69_182 VPWR VGND sg13cmos5l_decap_8
XFILLER_217_103 VPWR VGND sg13cmos5l_decap_8
XANTENNA__2784__X Tile_X0Y3_EE4BEG[10] VPWR VGND sg13cmos5l_antennanp
XFILLER_712_77 VPWR VGND sg13cmos5l_decap_8
XFILLER_182_7 VPWR VGND sg13cmos5l_decap_8
XFILLER_406_225 VPWR VGND sg13cmos5l_decap_4
XFILLER_473_180 VPWR VGND sg13cmos5l_fill_1
XFILLER_431_56 VPWR VGND sg13cmos5l_decap_8
XFILLER_214_91 VPWR VGND sg13cmos5l_decap_8
XFILLER_27_56 VPWR VGND sg13cmos5l_decap_8
XFILLER_150_35 VPWR VGND sg13cmos5l_decap_8
XFILLER_232_106 VPWR VGND sg13cmos5l_decap_8
XFILLER_421_217 VPWR VGND sg13cmos5l_fill_2
XFILLER_447_7 VPWR VGND sg13cmos5l_decap_8
XFILLER_575_210 VPWR VGND sg13cmos5l_decap_8
XFILLER_575_221 VPWR VGND sg13cmos5l_fill_1
XFILLER_300_49 VPWR VGND sg13cmos5l_decap_8
XFILLER_240_172 VPWR VGND sg13cmos5l_fill_1
XFILLER_614_7 VPWR VGND sg13cmos5l_decap_8
XFILLER_185_216 VPWR VGND sg13cmos5l_decap_8
XFILLER_43_77 VPWR VGND sg13cmos5l_decap_8
XFILLER_185_227 VPWR VGND sg13cmos5l_fill_2
XFILLER_327_221 VPWR VGND sg13cmos5l_fill_1
XFILLER_309_14 VPWR VGND sg13cmos5l_decap_8
XFILLER_138_154 VPWR VGND sg13cmos5l_decap_8
XFILLER_456_42 VPWR VGND sg13cmos5l_decap_8
XFILLER_216_2 VPWR VGND sg13cmos5l_fill_1
XFILLER_175_21 VPWR VGND sg13cmos5l_decap_8
XFILLER_4_112 VPWR VGND sg13cmos5l_decap_8
XFILLER_299_117 VPWR VGND sg13cmos5l_decap_8
XANTENNA__2959__X Tile_X0Y8_EE4BEG[15] VPWR VGND sg13cmos5l_antennanp
XFILLER_4_123 VPWR VGND sg13cmos5l_fill_2
XFILLER_104_0 VPWR VGND sg13cmos5l_decap_8
XFILLER_606_56 VPWR VGND sg13cmos5l_decap_8
XFILLER_325_35 VPWR VGND sg13cmos5l_decap_8
XFILLER_108_70 VPWR VGND sg13cmos5l_decap_8
XFILLER_4_49 VPWR VGND sg13cmos5l_decap_8
XFILLER_645_203 VPWR VGND sg13cmos5l_decap_8
XFILLER_472_63 VPWR VGND sg13cmos5l_decap_8
XFILLER_310_132 VPWR VGND sg13cmos5l_decap_4
XFILLER_68_63 VPWR VGND sg13cmos5l_decap_8
XFILLER_191_42 VPWR VGND sg13cmos5l_decap_8
XFILLER_456_147 VPWR VGND sg13cmos5l_fill_2
XFILLER_473_0 VPWR VGND sg13cmos5l_decap_8
XFILLER_622_77 VPWR VGND sg13cmos5l_decap_8
XFILLER_660_228 VPWR VGND sg13cmos5l_fill_1
XFILLER_341_56 VPWR VGND sg13cmos5l_decap_8
XFILLER_208_147 VPWR VGND sg13cmos5l_decap_8
XFILLER_640_0 VPWR VGND sg13cmos5l_decap_8
XFILLER_84_84 VPWR VGND sg13cmos5l_decap_8
XFILLER_412_206 VPWR VGND sg13cmos5l_decap_8
XFILLER_90_177 VPWR VGND sg13cmos5l_decap_8
XFILLER_377_121 VPWR VGND sg13cmos5l_decap_8
XFILLER_210_49 VPWR VGND sg13cmos5l_decap_8
X_2820_ Tile_X0Y3_E1BEG[2] _4146_/X VPWR VGND sg13cmos5l_buf_1
XFILLER_519_170 VPWR VGND sg13cmos5l_fill_2
XFILLER_318_221 VPWR VGND sg13cmos5l_fill_1
X_2751_ Tile_X0Y3_FrameData_O[9] Tile_X0Y3_FrameData[9] VPWR VGND sg13cmos5l_buf_1
XFILLER_647_63 VPWR VGND sg13cmos5l_decap_8
XFILLER_219_14 VPWR VGND sg13cmos5l_decap_8
XFILLER_129_132 VPWR VGND sg13cmos5l_decap_8
XFILLER_392_157 VPWR VGND sg13cmos5l_decap_8
XFILLER_366_42 VPWR VGND sg13cmos5l_decap_8
X_1702_ _1702_/Q Tile_X0Y3_FrameData[3] VGND VPWR Tile_X0Y9_FrameStrobe[0] latch
X_2682_ _2682_/Q Tile_X0Y6_FrameData[13] VGND VPWR Tile_X0Y9_FrameStrobe[7] latch
X_1633_ _1633_/Q Tile_X0Y2_FrameData[16] VGND VPWR Tile_X0Y9_FrameStrobe[6] latch
X_4421_ _4421_/X Tile_X0Y6_W1END[1] Tile_X0Y6_W6END[5] _4581_/X _4541_/X _2693_/Q
+ _2692_/Q VPWR VGND sg13cmos5l_mux4_1
XFILLER_534_184 VPWR VGND sg13cmos5l_decap_8
XANTENNA__2869__X Tile_X0Y6_EE4BEG[6] VPWR VGND sg13cmos5l_antennanp
XFILLER_479_228 VPWR VGND sg13cmos5l_fill_1
XFILLER_516_56 VPWR VGND sg13cmos5l_decap_8
X_1564_ _1564_/Q Tile_X0Y2_FrameData[21] VGND VPWR Tile_X0Y9_FrameStrobe[4] latch
X_4352_ _4352_/X Tile_X0Y3_W2MID[7] Tile_X0Y3_W2END[7] Tile_X0Y3_W6END[8] _4205_/X
+ _1881_/Q _1880_/Q VPWR VGND sg13cmos5l_mux4_1
XFILLER_663_84 VPWR VGND sg13cmos5l_decap_8
XFILLER_298_150 VPWR VGND sg13cmos5l_fill_1
XFILLER_235_35 VPWR VGND sg13cmos5l_decap_8
X_0515_ _0515_/Q Tile_X0Y8_FrameData[28] VGND VPWR Tile_X0Y9_FrameStrobe[3] latch
X_3303_ Tile_X0Y0_E2BEG[3] _3807_/X VPWR VGND sg13cmos5l_buf_1
XFILLER_382_63 VPWR VGND sg13cmos5l_decap_8
X_4283_ _4283_/X Tile_X0Y4_WW4END[4] AXI_M_SOC_BRESP0 _4340_/X _4318_/X _2047_/Q _2046_/Q
+ VPWR VGND sg13cmos5l_mux4_1
XFILLER_301_121 VPWR VGND sg13cmos5l_fill_2
X_1495_ _1495_/Q Tile_X0Y2_FrameData[26] VGND VPWR Tile_X0Y9_FrameStrobe[2] latch
XFILLER_382_74 VPWR VGND sg13cmos5l_fill_1
XFILLER_235_79 VPWR VGND sg13cmos5l_fill_1
XFILLER_447_136 VPWR VGND sg13cmos5l_decap_8
X_3234_ Tile_X0Y0_FrameData_O[2] Tile_X0Y0_FrameData[2] VPWR VGND sg13cmos5l_buf_1
X_0446_ _0446_/Q Tile_X0Y8_FrameData[1] VGND VPWR Tile_X0Y9_FrameStrobe[0] latch
X_3165_ Tile_X0Y4_E6BEG[2] _4290_/X VPWR VGND sg13cmos5l_buf_1
XFILLER_651_217 VPWR VGND sg13cmos5l_fill_1
XFILLER_532_88 VPWR VGND sg13cmos5l_decap_8
XFILLER_104_28 VPWR VGND sg13cmos5l_decap_8
X_0377_ _0377_/Q Tile_X0Y7_FrameData[6] VGND VPWR Tile_X0Y9_FrameStrobe[6] latch
XFILLER_462_139 VPWR VGND sg13cmos5l_fill_1
XFILLER_251_56 VPWR VGND sg13cmos5l_decap_8
X_2116_ _2116_/Q Tile_X0Y4_FrameData[1] VGND VPWR Tile_X0Y9_FrameStrobe[5] latch
X_3096_ Tile_X0Y7_E2BEGb[2] _4622_/X VPWR VGND sg13cmos5l_buf_1
XFILLER_66_185 VPWR VGND sg13cmos5l_decap_8
XFILLER_81_122 VPWR VGND sg13cmos5l_decap_8
XFILLER_403_206 VPWR VGND sg13cmos5l_decap_8
X_2047_ _2047_/Q Tile_X0Y4_FrameData[6] VGND VPWR Tile_X0Y9_FrameStrobe[3] latch
XFILLER_81_166 VPWR VGND sg13cmos5l_decap_4
XFILLER_470_194 VPWR VGND sg13cmos5l_fill_1
XFILLER_688_70 VPWR VGND sg13cmos5l_decap_8
XFILLER_368_121 VPWR VGND sg13cmos5l_fill_2
XFILLER_120_49 VPWR VGND sg13cmos5l_decap_8
X_3998_ _3998_/X _4455_/X _4459_/X _4463_/X _4467_/X _2415_/Q _2414_/Q VPWR VGND sg13cmos5l_mux4_1
XFILLER_13_14 VPWR VGND sg13cmos5l_decap_8
XFILLER_557_63 VPWR VGND sg13cmos5l_decap_8
X_2949_ Tile_X0Y8_EE4BEG[5] _4749_/X VPWR VGND sg13cmos5l_buf_1
XFILLER_129_14 VPWR VGND sg13cmos5l_decap_8
XFILLER_276_42 VPWR VGND sg13cmos5l_decap_8
XFILLER_525_173 VPWR VGND sg13cmos5l_decap_4
XANTENNA__2779__X Tile_X0Y3_EE4BEG[5] VPWR VGND sg13cmos5l_antennanp
XFILLER_707_77 VPWR VGND sg13cmos5l_decap_8
X_4619_ _4619_/X Tile_X0Y7_W2MID[0] AXI_M_SOC_RDATA23 _4669_/X _4668_/X _0321_/Q _0320_/Q
+ VPWR VGND sg13cmos5l_mux4_1
XFILLER_540_121 VPWR VGND sg13cmos5l_decap_8
XFILLER_135_168 VPWR VGND sg13cmos5l_decap_8
XFILLER_426_56 VPWR VGND sg13cmos5l_decap_8
XFILLER_209_91 VPWR VGND sg13cmos5l_decap_8
XFILLER_135_179 VPWR VGND sg13cmos5l_fill_2
XFILLER_89_211 VPWR VGND sg13cmos5l_fill_2
XFILLER_573_84 VPWR VGND sg13cmos5l_decap_8
XFILLER_8_7 VPWR VGND sg13cmos5l_decap_8
XFILLER_145_35 VPWR VGND sg13cmos5l_decap_8
XFILLER_292_63 VPWR VGND sg13cmos5l_decap_8
XFILLER_493_220 VPWR VGND sg13cmos5l_fill_2
XFILLER_397_7 VPWR VGND sg13cmos5l_decap_8
XFILLER_289_194 VPWR VGND sg13cmos5l_decap_8
XFILLER_1_159 VPWR VGND sg13cmos5l_fill_2
XFILLER_442_77 VPWR VGND sg13cmos5l_decap_8
XFILLER_57_141 VPWR VGND sg13cmos5l_decap_8
XFILLER_564_7 VPWR VGND sg13cmos5l_decap_8
XFILLER_57_152 VPWR VGND sg13cmos5l_decap_8
XFILLER_161_56 VPWR VGND sg13cmos5l_decap_8
XANTENNA__3403__X Tile_X0Y2_E2BEG[6] VPWR VGND sg13cmos5l_antennanp
XFILLER_54_21 VPWR VGND sg13cmos5l_decap_8
XFILLER_461_194 VPWR VGND sg13cmos5l_decap_8
XFILLER_598_70 VPWR VGND sg13cmos5l_decap_8
XFILLER_610_136 VPWR VGND sg13cmos5l_decap_8
XFILLER_13_200 VPWR VGND sg13cmos5l_decap_8
XFILLER_610_158 VPWR VGND sg13cmos5l_decap_8
XFILLER_54_87 VPWR VGND sg13cmos5l_decap_8
XFILLER_610_169 VPWR VGND sg13cmos5l_fill_1
XFILLER_54_98 VPWR VGND sg13cmos5l_fill_2
XFILLER_213_161 VPWR VGND sg13cmos5l_decap_8
XFILLER_359_187 VPWR VGND sg13cmos5l_decap_8
XFILLER_70_42 VPWR VGND sg13cmos5l_decap_8
XFILLER_684_28 VPWR VGND sg13cmos5l_decap_8
XFILLER_374_146 VPWR VGND sg13cmos5l_decap_8
XFILLER_221_0 VPWR VGND sg13cmos5l_decap_8
XFILLER_319_0 VPWR VGND sg13cmos5l_decap_8
XFILLER_186_42 VPWR VGND sg13cmos5l_decap_8
XFILLER_186_86 VPWR VGND sg13cmos5l_decap_4
XFILLER_617_77 VPWR VGND sg13cmos5l_decap_8
XFILLER_336_56 VPWR VGND sg13cmos5l_decap_8
XFILLER_141_105 VPWR VGND sg13cmos5l_decap_8
XFILLER_330_205 VPWR VGND sg13cmos5l_decap_4
XFILLER_483_84 VPWR VGND sg13cmos5l_decap_8
XFILLER_633_21 VPWR VGND sg13cmos5l_decap_8
XFILLER_590_0 VPWR VGND sg13cmos5l_decap_8
XFILLER_79_84 VPWR VGND sg13cmos5l_decap_8
XFILLER_79_95 VPWR VGND sg13cmos5l_fill_1
XFILLER_688_0 VPWR VGND sg13cmos5l_decap_8
X_0300_ _0300_/Q Tile_X0Y7_FrameData[19] VGND VPWR Tile_X0Y9_FrameStrobe[4] latch
XFILLER_429_147 VPWR VGND sg13cmos5l_decap_8
X_1280_ _1280_/Q Tile_X0Y1_FrameData[25] VGND VPWR Tile_X0Y9_FrameStrobe[3] latch
XFILLER_633_98 VPWR VGND sg13cmos5l_decap_8
XFILLER_205_49 VPWR VGND sg13cmos5l_decap_8
X_0231_ _0231_/Q Tile_X0Y7_FrameData[24] VGND VPWR Tile_X0Y9_FrameStrobe[2] latch
XFILLER_352_77 VPWR VGND sg13cmos5l_decap_8
XFILLER_502_14 VPWR VGND sg13cmos5l_decap_8
XFILLER_444_139 VPWR VGND sg13cmos5l_fill_2
XANTENNA__3313__X Tile_X0Y4_EE4BEG[1] VPWR VGND sg13cmos5l_antennanp
X_0162_ _0162_/Q Tile_X0Y7_FrameData[29] VGND VPWR Tile_X0Y9_FrameStrobe[0] latch
XFILLER_63_111 VPWR VGND sg13cmos5l_decap_8
X_0093_ _3622_/A _4484_/X _4485_/X _2633_/Q VPWR VGND sg13cmos5l_mux2_1
XFILLER_397_216 VPWR VGND sg13cmos5l_decap_8
XFILLER_397_227 VPWR VGND sg13cmos5l_fill_2
XFILLER_63_188 VPWR VGND sg13cmos5l_decap_8
X_3921_ _3921_/X _4229_/X _4233_/X _4212_/X _4211_/X _1892_/Q _1891_/Q VPWR VGND sg13cmos5l_mux4_1
XFILLER_539_221 VPWR VGND sg13cmos5l_decap_8
XFILLER_301_70 VPWR VGND sg13cmos5l_decap_8
XFILLER_204_161 VPWR VGND sg13cmos5l_decap_8
X_3852_ _3852_/X _3903_/X _3902_/X Tile_X0Y0_S2MID[7] Tile_X0Y0_S2END[7] _0949_/Q
+ _0948_/Q VPWR VGND sg13cmos5l_mux4_1
XFILLER_658_84 VPWR VGND sg13cmos5l_decap_8
X_2803_ Tile_X0Y3_E2BEGb[1] _4157_/X VPWR VGND sg13cmos5l_buf_1
XFILLER_594_28 VPWR VGND sg13cmos5l_decap_8
XFILLER_377_63 VPWR VGND sg13cmos5l_decap_8
X_0995_ _0995_/Q Tile_X0Y0_FrameData[8] VGND VPWR Tile_X0Y9_FrameStrobe[1] latch
X_3783_ _3783_/X Tile_X0Y0_W1END[3] Tile_X0Y0_W6END[7] _3863_/X _3880_/X _1171_/Q
+ _1170_/Q VPWR VGND sg13cmos5l_mux4_1
XFILLER_365_157 VPWR VGND sg13cmos5l_fill_1
XFILLER_507_140 VPWR VGND sg13cmos5l_decap_8
XFILLER_380_105 VPWR VGND sg13cmos5l_decap_8
X_2734_ _3977_/A3 VPWR VGND sg13cmos5l_tielo
XFILLER_306_213 VPWR VGND sg13cmos5l_decap_4
XFILLER_67_0 VPWR VGND sg13cmos5l_decap_8
XFILLER_527_77 VPWR VGND sg13cmos5l_decap_8
XFILLER_522_110 VPWR VGND sg13cmos5l_fill_2
X_2665_ _2665_/Q Tile_X0Y6_FrameData[30] VGND VPWR Tile_X0Y9_FrameStrobe[7] latch
XFILLER_246_56 VPWR VGND sg13cmos5l_decap_8
XFILLER_132_105 VPWR VGND sg13cmos5l_decap_8
X_4404_ _4404_/X _0157_/X _0143_/X _4462_/X _4466_/X _2295_/Q _2294_/Q VPWR VGND sg13cmos5l_mux4_1
XFILLER_668_147 VPWR VGND sg13cmos5l_decap_4
X_1616_ _1616_/Q Tile_X0Y2_FrameData[1] VGND VPWR Tile_X0Y9_FrameStrobe[5] latch
X_2596_ _2596_/Q Tile_X0Y6_FrameData[3] VGND VPWR Tile_X0Y9_FrameStrobe[4] latch
XFILLER_543_21 VPWR VGND sg13cmos5l_decap_8
XFILLER_5_70 VPWR VGND sg13cmos5l_decap_8
X_4335_ _4335_/X _4807_/X _4811_/X _4815_/X _4791_/X _0638_/Q _0637_/Q VPWR VGND sg13cmos5l_mux4_1
X_1547_ _1547_/Q Tile_X0Y2_FrameData[6] VGND VPWR Tile_X0Y9_FrameStrobe[3] latch
XFILLER_609_225 VPWR VGND sg13cmos5l_decap_4
X_1478_ _1478_/Q Tile_X0Y2_FrameData[11] VGND VPWR Tile_X0Y9_FrameStrobe[1] latch
X_4266_ _4266_/X Tile_X0Y4_W2END[5] AXI_M_SOC_BRESP1 _4317_/X _4316_/X _2081_/Q _2080_/Q
+ VPWR VGND sg13cmos5l_mux4_1
XFILLER_543_98 VPWR VGND sg13cmos5l_decap_4
XFILLER_219_209 VPWR VGND sg13cmos5l_fill_2
XFILLER_115_49 VPWR VGND sg13cmos5l_decap_8
XFILLER_286_175 VPWR VGND sg13cmos5l_decap_8
X_0429_ _0429_/Q Tile_X0Y8_FrameData[18] VGND VPWR Tile_X0Y9_FrameStrobe[0] latch
X_3217_ Tile_X0Y0_FrameStrobe_O[5] Tile_X0Y9_FrameStrobe[5] VPWR VGND sg13cmos5l_buf_1
XFILLER_39_130 VPWR VGND sg13cmos5l_fill_2
XANTENNA__3223__X Tile_X0Y0_FrameStrobe_O[11] VPWR VGND sg13cmos5l_antennanp
X_4197_ _4197_/X Tile_X0Y4_W1END[1] Tile_X0Y4_W6END[5] _4349_/X _4303_/X _2179_/Q
+ _2178_/Q VPWR VGND sg13cmos5l_mux4_1
XFILLER_412_47 VPWR VGND sg13cmos5l_decap_8
X_3148_ Tile_X0Y7_FrameData_O[18] Tile_X0Y7_FrameData[18] VPWR VGND sg13cmos5l_buf_1
XFILLER_443_150 VPWR VGND sg13cmos5l_fill_2
XFILLER_242_201 VPWR VGND sg13cmos5l_decap_8
XFILLER_242_212 VPWR VGND sg13cmos5l_fill_1
XFILLER_199_105 VPWR VGND sg13cmos5l_decap_8
XFILLER_388_205 VPWR VGND sg13cmos5l_decap_8
X_3079_ Tile_X0Y4_E2BEGb[5] _4269_/X VPWR VGND sg13cmos5l_buf_1
XFILLER_54_166 VPWR VGND sg13cmos5l_decap_8
XFILLER_211_70 VPWR VGND sg13cmos5l_decap_8
XFILLER_24_35 VPWR VGND sg13cmos5l_decap_8
XFILLER_145_7 VPWR VGND sg13cmos5l_decap_8
XFILLER_568_84 VPWR VGND sg13cmos5l_decap_8
XFILLER_545_224 VPWR VGND sg13cmos5l_decap_4
XFILLER_10_214 VPWR VGND sg13cmos5l_fill_1
XFILLER_287_63 VPWR VGND sg13cmos5l_decap_8
XFILLER_210_175 VPWR VGND sg13cmos5l_decap_8
XFILLER_356_168 VPWR VGND sg13cmos5l_decap_8
XFILLER_371_105 VPWR VGND sg13cmos5l_decap_8
XFILLER_312_7 VPWR VGND sg13cmos5l_decap_8
XFILLER_40_56 VPWR VGND sg13cmos5l_decap_8
XFILLER_437_77 VPWR VGND sg13cmos5l_decap_8
XFILLER_156_56 VPWR VGND sg13cmos5l_decap_8
XFILLER_659_147 VPWR VGND sg13cmos5l_decap_8
XFILLER_659_158 VPWR VGND sg13cmos5l_fill_2
XFILLER_453_21 VPWR VGND sg13cmos5l_decap_8
XFILLER_49_10 VPWR VGND sg13cmos5l_decap_8
XFILLER_681_7 VPWR VGND sg13cmos5l_decap_8
XFILLER_603_35 VPWR VGND sg13cmos5l_decap_8
XFILLER_49_87 VPWR VGND sg13cmos5l_decap_8
XFILLER_292_112 VPWR VGND sg13cmos5l_decap_8
XFILLER_322_14 VPWR VGND sg13cmos5l_decap_8
XFILLER_1_28 VPWR VGND sg13cmos5l_decap_8
XANTENNA__3133__X Tile_X0Y7_FrameData_O[3] VPWR VGND sg13cmos5l_antennanp
XFILLER_92_217 VPWR VGND sg13cmos5l_fill_2
XFILLER_679_28 VPWR VGND sg13cmos5l_decap_8
XFILLER_65_42 VPWR VGND sg13cmos5l_decap_8
XFILLER_171_0 VPWR VGND sg13cmos5l_decap_8
XANTENNA__2972__X Tile_X0Y8_FrameData_O[12] VPWR VGND sg13cmos5l_antennanp
XFILLER_269_0 VPWR VGND sg13cmos5l_decap_8
XFILLER_434_183 VPWR VGND sg13cmos5l_decap_4
XFILLER_434_194 VPWR VGND sg13cmos5l_decap_8
XFILLER_595_124 VPWR VGND sg13cmos5l_fill_2
XFILLER_121_70 VPWR VGND sg13cmos5l_decap_4
XFILLER_436_0 VPWR VGND sg13cmos5l_decap_8
XFILLER_81_63 VPWR VGND sg13cmos5l_fill_1
XFILLER_695_49 VPWR VGND sg13cmos5l_decap_8
XFILLER_81_85 VPWR VGND sg13cmos5l_fill_2
XFILLER_197_63 VPWR VGND sg13cmos5l_decap_8
XFILLER_628_54 VPWR VGND sg13cmos5l_decap_8
XFILLER_603_0 VPWR VGND sg13cmos5l_decap_8
XFILLER_362_105 VPWR VGND sg13cmos5l_decap_8
X_0780_ _0780_/Q Tile_X0Y9_FrameData[19] VGND VPWR Tile_X0Y9_FrameStrobe[3] latch
XFILLER_551_227 VPWR VGND sg13cmos5l_fill_2
XFILLER_60_7 VPWR VGND sg13cmos5l_decap_8
XFILLER_347_77 VPWR VGND sg13cmos5l_decap_8
XANTENNA__3308__X Tile_X0Y0_E1BEG[0] VPWR VGND sg13cmos5l_antennanp
XFILLER_644_42 VPWR VGND sg13cmos5l_decap_8
XFILLER_114_105 VPWR VGND sg13cmos5l_decap_8
X_2450_ _2450_/Q Tile_X0Y6_FrameData[21] VGND VPWR Tile_X0Y9_FrameStrobe[0] latch
XFILLER_504_187 VPWR VGND sg13cmos5l_decap_8
XFILLER_363_21 VPWR VGND sg13cmos5l_decap_8
X_1401_ _1401_/Q Tile_X0Y1_FrameData[0] VGND VPWR Tile_X0Y9_FrameStrobe[6] latch
X_2381_ _2381_/Q Tile_X0Y5_FrameData[24] VGND VPWR Tile_X0Y9_FrameStrobe[6] latch
XFILLER_457_220 VPWR VGND sg13cmos5l_fill_1
XFILLER_268_131 VPWR VGND sg13cmos5l_fill_2
X_1332_ _1332_/Q Tile_X0Y1_FrameData[5] VGND VPWR Tile_X0Y9_FrameStrobe[4] latch
X_4120_ _4120_/X _4089_/X _0079_/X _4088_/X Tile_X0Y0_S4END[8] _1473_/Q _1472_/Q VPWR
+ VGND sg13cmos5l_mux4_1
XFILLER_68_225 VPWR VGND sg13cmos5l_decap_4
XFILLER_363_98 VPWR VGND sg13cmos5l_decap_8
XFILLER_513_35 VPWR VGND sg13cmos5l_decap_8
XFILLER_283_112 VPWR VGND sg13cmos5l_decap_8
X_1263_ _1263_/Q Tile_X0Y1_FrameData[10] VGND VPWR Tile_X0Y9_FrameStrobe[2] latch
X_4051_ _4051_/X Tile_X0Y2_W2END[4] AXI_M_SOC_AWREADY _4103_/X _4102_/X _1571_/Q _1570_/Q
+ VPWR VGND sg13cmos5l_mux4_1
XFILLER_660_63 VPWR VGND sg13cmos5l_decap_8
XFILLER_232_14 VPWR VGND sg13cmos5l_decap_8
XFILLER_417_139 VPWR VGND sg13cmos5l_decap_4
XANTENNA__3043__X Tile_X0Y5_FrameData_O[2] VPWR VGND sg13cmos5l_antennanp
X_0214_ _0214_/Q Tile_X0Y7_FrameData[9] VGND VPWR Tile_X0Y9_FrameStrobe[1] latch
X_3002_ Tile_X0Y5_E2BEG[5] _4377_/X VPWR VGND sg13cmos5l_buf_1
XFILLER_589_28 VPWR VGND sg13cmos5l_decap_8
X_1194_ _1194_/Q Tile_X0Y1_FrameData[15] VGND VPWR Tile_X0Y9_FrameStrobe[0] latch
XFILLER_283_189 VPWR VGND sg13cmos5l_decap_8
XFILLER_425_161 VPWR VGND sg13cmos5l_decap_8
XANTENNA__2882__X Tile_X0Y6_FrameData_O[3] VPWR VGND sg13cmos5l_antennanp
X_0145_ _0145_/X _4439_/X _4440_/X _1360_/Q VPWR VGND sg13cmos5l_mux2_1
XFILLER_36_155 VPWR VGND sg13cmos5l_fill_1
XFILLER_51_103 VPWR VGND sg13cmos5l_decap_4
XFILLER_586_135 VPWR VGND sg13cmos5l_fill_1
X_0076_ _0076_/X _4794_/X _4795_/X _2116_/Q VPWR VGND sg13cmos5l_mux2_1
X_3904_ _3904_/X Tile_X0Y1_W1END[3] Tile_X0Y1_WW4END[3] Tile_X0Y1_W6END[11] _4011_/X
+ _1392_/Q _1391_/Q VPWR VGND sg13cmos5l_mux4_1
X_4884_ _4884_/X AXI_M_SOC_RDATA0 _4923_/X _4927_/X _4901_/X _0775_/Q _0774_/Q VPWR
+ VGND sg13cmos5l_mux4_1
XFILLER_189_182 VPWR VGND sg13cmos5l_decap_8
XFILLER_538_21 VPWR VGND sg13cmos5l_decap_8
XFILLER_527_213 VPWR VGND sg13cmos5l_decap_4
X_3835_ _3835_/X Tile_X0Y0_WW4END[0] Tile_X0Y0_WW4END[9] _3881_/X _3853_/X _1035_/Q
+ _1034_/Q VPWR VGND sg13cmos5l_mux4_1
XFILLER_594_190 VPWR VGND sg13cmos5l_fill_1
XFILLER_353_105 VPWR VGND sg13cmos5l_decap_8
X_3766_ _3766_/X Tile_X0Y1_WW4END[7] Tile_X0Y1_WW4END[15] Tile_X0Y1_W6END[7] _4015_/X
+ _1243_/Q _1242_/Q VPWR VGND sg13cmos5l_mux4_1
X_0978_ _0978_/Q Tile_X0Y0_FrameData[25] VGND VPWR Tile_X0Y9_FrameStrobe[1] latch
X_2717_ _4773_/A3 VPWR VGND sg13cmos5l_tielo
XFILLER_407_14 VPWR VGND sg13cmos5l_decap_8
XANTENNA__3218__X Tile_X0Y0_FrameStrobe_O[6] VPWR VGND sg13cmos5l_antennanp
X_3697_ AXI_M_SOC_WDATA7 Tile_X0Y7_WW4END[7] Tile_X0Y7_WW4END[15] Tile_X0Y7_W6END[7]
+ _4691_/X _0233_/Q _0232_/Q VPWR VGND sg13cmos5l_mux4_1
XFILLER_554_42 VPWR VGND sg13cmos5l_decap_8
X_2648_ _2648_/Q Tile_X0Y6_FrameData[15] VGND VPWR Tile_X0Y9_FrameStrobe[6] latch
XFILLER_273_21 VPWR VGND sg13cmos5l_decap_8
XFILLER_510_135 VPWR VGND sg13cmos5l_fill_1
XFILLER_259_120 VPWR VGND sg13cmos5l_decap_8
X_2579_ _2579_/Q Tile_X0Y6_FrameData[20] VGND VPWR Tile_X0Y9_FrameStrobe[4] latch
XFILLER_448_220 VPWR VGND sg13cmos5l_fill_2
XFILLER_704_56 VPWR VGND sg13cmos5l_decap_8
XFILLER_59_214 VPWR VGND sg13cmos5l_fill_1
X_4318_ _4318_/X _4245_/X _4361_/X _4360_/X _4244_/X _1941_/Q _1940_/Q VPWR VGND sg13cmos5l_mux4_1
XFILLER_273_98 VPWR VGND sg13cmos5l_decap_8
XFILLER_423_35 VPWR VGND sg13cmos5l_decap_8
XFILLER_206_70 VPWR VGND sg13cmos5l_decap_8
XFILLER_408_106 VPWR VGND sg13cmos5l_decap_8
XFILLER_463_212 VPWR VGND sg13cmos5l_fill_1
XFILLER_274_112 VPWR VGND sg13cmos5l_decap_8
XFILLER_19_35 VPWR VGND sg13cmos5l_decap_8
XFILLER_570_63 VPWR VGND sg13cmos5l_decap_8
XFILLER_142_14 VPWR VGND sg13cmos5l_decap_8
X_4249_ _4249_/X Tile_X0Y5_W2MID[1] Tile_X0Y5_W2END[1] Tile_X0Y5_W6END[1] _4429_/X
+ _2419_/Q _2418_/Q VPWR VGND sg13cmos5l_mux4_1
XFILLER_74_228 VPWR VGND sg13cmos5l_fill_1
XFILLER_499_28 VPWR VGND sg13cmos5l_decap_8
XANTENNA__2792__X Tile_X0Y3_E6BEG[2] VPWR VGND sg13cmos5l_antennanp
XFILLER_262_7 VPWR VGND sg13cmos5l_decap_8
XFILLER_222_91 VPWR VGND sg13cmos5l_decap_8
XFILLER_35_56 VPWR VGND sg13cmos5l_decap_8
XFILLER_27_199 VPWR VGND sg13cmos5l_fill_1
XFILLER_431_175 VPWR VGND sg13cmos5l_decap_8
XFILLER_577_168 VPWR VGND sg13cmos5l_decap_8
XFILLER_431_186 VPWR VGND sg13cmos5l_fill_2
XFILLER_42_158 VPWR VGND sg13cmos5l_decap_8
XFILLER_527_7 VPWR VGND sg13cmos5l_decap_8
XFILLER_298_84 VPWR VGND sg13cmos5l_decap_4
XFILLER_448_21 VPWR VGND sg13cmos5l_decap_8
XFILLER_329_124 VPWR VGND sg13cmos5l_decap_8
XFILLER_329_168 VPWR VGND sg13cmos5l_decap_8
XFILLER_195_163 VPWR VGND sg13cmos5l_decap_8
XFILLER_51_55 VPWR VGND sg13cmos5l_decap_8
XFILLER_344_105 VPWR VGND sg13cmos5l_decap_8
XFILLER_329_179 VPWR VGND sg13cmos5l_fill_1
XFILLER_167_77 VPWR VGND sg13cmos5l_fill_1
XFILLER_317_14 VPWR VGND sg13cmos5l_decap_8
XANTENNA__3128__X Tile_X0Y7_EE4BEG[14] VPWR VGND sg13cmos5l_antennanp
XFILLER_464_42 VPWR VGND sg13cmos5l_decap_8
XFILLER_297_204 VPWR VGND sg13cmos5l_fill_2
XFILLER_352_182 VPWR VGND sg13cmos5l_decap_8
XFILLER_183_21 VPWR VGND sg13cmos5l_decap_8
XFILLER_498_175 VPWR VGND sg13cmos5l_decap_8
XANTENNA__2967__X Tile_X0Y8_FrameData_O[7] VPWR VGND sg13cmos5l_antennanp
XFILLER_111_108 VPWR VGND sg13cmos5l_decap_8
XFILLER_614_56 VPWR VGND sg13cmos5l_decap_8
XFILLER_501_168 VPWR VGND sg13cmos5l_decap_8
XFILLER_333_35 VPWR VGND sg13cmos5l_decap_8
XFILLER_116_70 VPWR VGND sg13cmos5l_decap_8
XFILLER_655_161 VPWR VGND sg13cmos5l_decap_8
XFILLER_386_0 VPWR VGND sg13cmos5l_decap_8
XFILLER_480_63 VPWR VGND sg13cmos5l_decap_8
XFILLER_480_74 VPWR VGND sg13cmos5l_fill_2
XFILLER_333_79 VPWR VGND sg13cmos5l_fill_1
XFILLER_76_63 VPWR VGND sg13cmos5l_decap_8
XFILLER_65_228 VPWR VGND sg13cmos5l_fill_1
XFILLER_265_156 VPWR VGND sg13cmos5l_fill_1
XFILLER_670_175 VPWR VGND sg13cmos5l_decap_8
XFILLER_553_0 VPWR VGND sg13cmos5l_decap_8
XFILLER_280_126 VPWR VGND sg13cmos5l_decap_8
XFILLER_630_77 VPWR VGND sg13cmos5l_decap_8
XFILLER_202_28 VPWR VGND sg13cmos5l_decap_8
XFILLER_407_194 VPWR VGND sg13cmos5l_decap_8
XFILLER_33_103 VPWR VGND sg13cmos5l_fill_2
XFILLER_132_91 VPWR VGND sg13cmos5l_decap_8
XFILLER_33_136 VPWR VGND sg13cmos5l_decap_4
XFILLER_568_168 VPWR VGND sg13cmos5l_decap_8
XFILLER_422_175 VPWR VGND sg13cmos5l_decap_8
XFILLER_639_42 VPWR VGND sg13cmos5l_decap_8
XFILLER_583_105 VPWR VGND sg13cmos5l_decap_8
XFILLER_568_179 VPWR VGND sg13cmos5l_fill_1
X_1950_ _1950_/Q Tile_X0Y4_FrameData[7] VGND VPWR Tile_X0Y9_FrameStrobe[0] latch
XFILLER_509_213 VPWR VGND sg13cmos5l_fill_2
XFILLER_358_21 VPWR VGND sg13cmos5l_decap_8
X_0901_ _0901_/Q Tile_X0Y9_FrameData[26] VGND VPWR Tile_X0Y9_FrameStrobe[7] latch
XFILLER_583_149 VPWR VGND sg13cmos5l_decap_4
X_1881_ _1881_/Q Tile_X0Y3_FrameData[16] VGND VPWR Tile_X0Y9_FrameStrobe[6] latch
XFILLER_186_152 VPWR VGND sg13cmos5l_decap_8
X_3620_ Tile_X0Y9_S2BEGb[6] _4938_/X VPWR VGND sg13cmos5l_buf_1
XFILLER_186_185 VPWR VGND sg13cmos5l_decap_8
X_0832_ _0832_/Q Tile_X0Y9_FrameData[31] VGND VPWR Tile_X0Y9_FrameStrobe[5] latch
XFILLER_591_160 VPWR VGND sg13cmos5l_fill_1
XFILLER_358_98 VPWR VGND sg13cmos5l_decap_8
XFILLER_591_182 VPWR VGND sg13cmos5l_fill_2
XFILLER_508_35 VPWR VGND sg13cmos5l_decap_8
X_3551_ Tile_X0Y9_E6BEG[9] _4889_/X VPWR VGND sg13cmos5l_buf_1
XFILLER_655_63 VPWR VGND sg13cmos5l_decap_8
XFILLER_227_14 VPWR VGND sg13cmos5l_decap_8
X_0763_ _0763_/Q Tile_X0Y9_FrameData[4] VGND VPWR Tile_X0Y9_FrameStrobe[2] latch
XANTENNA__3038__X Tile_X0Y5_EE4BEG[13] VPWR VGND sg13cmos5l_antennanp
XFILLER_374_42 VPWR VGND sg13cmos5l_decap_8
XFILLER_350_119 VPWR VGND sg13cmos5l_decap_8
X_2502_ _2502_/Q Tile_X0Y6_FrameData[1] VGND VPWR Tile_X0Y9_FrameStrobe[1] latch
X_0694_ _0694_/Q Tile_X0Y9_FrameData[9] VGND VPWR Tile_X0Y9_FrameStrobe[0] latch
X_3482_ Tile_X0Y1_EE4BEG[8] _3956_/X VPWR VGND sg13cmos5l_buf_1
XFILLER_489_175 VPWR VGND sg13cmos5l_decap_8
XANTENNA__2877__X Tile_X0Y6_EE4BEG[14] VPWR VGND sg13cmos5l_antennanp
X_2433_ _2433_/Q Tile_X0Y5_FrameData[4] VGND VPWR Tile_X0Y9_FrameStrobe[7] latch
XFILLER_524_56 VPWR VGND sg13cmos5l_decap_8
XFILLER_102_119 VPWR VGND sg13cmos5l_decap_8
XFILLER_307_91 VPWR VGND sg13cmos5l_fill_1
X_2364_ _2364_/Q Tile_X0Y5_FrameData[9] VGND VPWR Tile_X0Y9_FrameStrobe[5] latch
XFILLER_671_84 VPWR VGND sg13cmos5l_decap_8
XFILLER_243_35 VPWR VGND sg13cmos5l_decap_8
XFILLER_646_161 VPWR VGND sg13cmos5l_decap_8
X_4103_ _4103_/X _4027_/X _4135_/X _4134_/X _4026_/X _1443_/Q _1442_/Q VPWR VGND sg13cmos5l_mux4_1
X_1315_ _1315_/Q Tile_X0Y1_FrameData[22] VGND VPWR Tile_X0Y9_FrameStrobe[4] latch
XFILLER_390_63 VPWR VGND sg13cmos5l_decap_8
X_2295_ _2295_/Q Tile_X0Y5_FrameData[14] VGND VPWR Tile_X0Y9_FrameStrobe[3] latch
XFILLER_110_163 VPWR VGND sg13cmos5l_decap_8
XFILLER_56_228 VPWR VGND sg13cmos5l_fill_1
X_1246_ _1246_/Q Tile_X0Y1_FrameData[27] VGND VPWR Tile_X0Y9_FrameStrobe[2] latch
X_4034_ _4034_/X Tile_X0Y0_W1END[3] Tile_X0Y0_W2MID[0] Tile_X0Y0_W2END[0] _3852_/X
+ _1119_/Q _1118_/Q VPWR VGND sg13cmos5l_mux4_1
XFILLER_323_90 VPWR VGND sg13cmos5l_decap_8
XFILLER_540_77 VPWR VGND sg13cmos5l_decap_8
XFILLER_271_137 VPWR VGND sg13cmos5l_decap_8
XFILLER_112_28 VPWR VGND sg13cmos5l_decap_8
X_1177_ _1177_/Q Tile_X0Y0_FrameData[18] VGND VPWR Tile_X0Y9_FrameStrobe[7] latch
XFILLER_602_220 VPWR VGND sg13cmos5l_decap_8
XANTENNA__3501__X Tile_X0Y1_E6BEG[11] VPWR VGND sg13cmos5l_antennanp
X_0128_ _3637_/A _4842_/X _4843_/X _0856_/Q VPWR VGND sg13cmos5l_mux2_1
XFILLER_559_168 VPWR VGND sg13cmos5l_fill_1
XFILLER_574_105 VPWR VGND sg13cmos5l_decap_8
XFILLER_549_42 VPWR VGND sg13cmos5l_decap_8
X_0059_ _3178_/A _3922_/X _3923_/X _1893_/Q VPWR VGND sg13cmos5l_mux2_1
X_4936_ _4936_/X Tile_X0Y8_W1END[0] Tile_X0Y8_W2MID[3] Tile_X0Y8_W2END[3] _4790_/X
+ _0619_/Q _0618_/Q VPWR VGND sg13cmos5l_mux4_1
XFILLER_696_70 VPWR VGND sg13cmos5l_decap_8
XANTENNA_10 Tile_X0Y0_S2MID[1] VPWR VGND sg13cmos5l_antennanp
XFILLER_567_190 VPWR VGND sg13cmos5l_fill_2
XFILLER_177_141 VPWR VGND sg13cmos5l_decap_8
XANTENNA_21 _4701_/X VPWR VGND sg13cmos5l_antennanp
XFILLER_716_132 VPWR VGND sg13cmos5l_decap_8
X_4867_ _4867_/X Tile_X0Y9_WW4END[12] AXI_M_SOC_RDATA3 _4928_/X _4906_/X _0809_/Q
+ _0808_/Q VPWR VGND sg13cmos5l_mux4_1
XFILLER_268_54 VPWR VGND sg13cmos5l_decap_8
XANTENNA_32 Tile_X0Y9_FrameStrobe[14] VPWR VGND sg13cmos5l_antennanp
XFILLER_177_163 VPWR VGND sg13cmos5l_fill_2
XANTENNA_43 Tile_X0Y9_N2MID[1] VPWR VGND sg13cmos5l_antennanp
XANTENNA_54 Tile_X0Y9_N2MID[5] VPWR VGND sg13cmos5l_antennanp
X_3818_ _3818_/X Tile_X0Y0_W2END[1] Tile_X0Y0_W6END[8] _3855_/X _3854_/X _1069_/Q
+ _1068_/Q VPWR VGND sg13cmos5l_mux4_1
XFILLER_381_211 VPWR VGND sg13cmos5l_decap_8
XFILLER_268_98 VPWR VGND sg13cmos5l_fill_1
X_4798_ _4798_/X Tile_X0Y4_W1END[3] Tile_X0Y4_WW4END[15] Tile_X0Y4_W6END[7] _4339_/X
+ _2112_/Q _2111_/Q VPWR VGND sg13cmos5l_mux4_1
XFILLER_418_35 VPWR VGND sg13cmos5l_decap_8
XFILLER_21_14 VPWR VGND sg13cmos5l_decap_8
XFILLER_565_63 VPWR VGND sg13cmos5l_decap_8
X_3749_ AXI_M_SOC_ARADDR21 Tile_X0Y8_WW4END[5] Tile_X0Y8_WW4END[13] Tile_X0Y8_W6END[5]
+ _4805_/X _0493_/Q _0492_/Q VPWR VGND sg13cmos5l_mux4_1
XFILLER_137_14 VPWR VGND sg13cmos5l_decap_8
XFILLER_284_42 VPWR VGND sg13cmos5l_decap_8
XFILLER_108_7 VPWR VGND sg13cmos5l_decap_8
XFILLER_495_112 VPWR VGND sg13cmos5l_decap_8
XANTENNA__2787__X Tile_X0Y3_EE4BEG[13] VPWR VGND sg13cmos5l_antennanp
XFILLER_434_56 VPWR VGND sg13cmos5l_decap_8
XFILLER_217_91 VPWR VGND sg13cmos5l_decap_8
XFILLER_581_84 VPWR VGND sg13cmos5l_decap_8
XFILLER_153_35 VPWR VGND sg13cmos5l_decap_8
XFILLER_495_189 VPWR VGND sg13cmos5l_decap_8
XFILLER_477_7 VPWR VGND sg13cmos5l_decap_8
XFILLER_303_49 VPWR VGND sg13cmos5l_decap_8
XFILLER_652_175 VPWR VGND sg13cmos5l_decap_8
XFILLER_597_219 VPWR VGND sg13cmos5l_fill_2
XFILLER_46_55 VPWR VGND sg13cmos5l_decap_8
XFILLER_262_137 VPWR VGND sg13cmos5l_decap_8
XFILLER_652_197 VPWR VGND sg13cmos5l_decap_8
XFILLER_644_7 VPWR VGND sg13cmos5l_decap_8
XFILLER_600_14 VPWR VGND sg13cmos5l_decap_8
XFILLER_450_99 VPWR VGND sg13cmos5l_decap_8
XANTENNA__3411__X Tile_X0Y4_FrameData_O[2] VPWR VGND sg13cmos5l_antennanp
XFILLER_565_105 VPWR VGND sg13cmos5l_decap_8
XFILLER_459_42 VPWR VGND sg13cmos5l_decap_8
XFILLER_178_21 VPWR VGND sg13cmos5l_decap_8
XFILLER_62_65 VPWR VGND sg13cmos5l_decap_8
XFILLER_565_149 VPWR VGND sg13cmos5l_fill_1
XFILLER_134_0 VPWR VGND sg13cmos5l_decap_8
XFILLER_707_154 VPWR VGND sg13cmos5l_decap_8
XFILLER_609_56 VPWR VGND sg13cmos5l_decap_8
XFILLER_580_119 VPWR VGND sg13cmos5l_decap_8
XFILLER_168_185 VPWR VGND sg13cmos5l_fill_2
XFILLER_178_98 VPWR VGND sg13cmos5l_fill_1
XFILLER_506_227 VPWR VGND sg13cmos5l_fill_2
XFILLER_7_49 VPWR VGND sg13cmos5l_decap_8
XFILLER_573_182 VPWR VGND sg13cmos5l_decap_8
XFILLER_328_35 VPWR VGND sg13cmos5l_decap_8
XFILLER_183_133 VPWR VGND sg13cmos5l_fill_2
XFILLER_692_28 VPWR VGND sg13cmos5l_decap_8
XFILLER_475_63 VPWR VGND sg13cmos5l_decap_8
XFILLER_301_0 VPWR VGND sg13cmos5l_decap_8
XFILLER_194_42 VPWR VGND sg13cmos5l_decap_8
XFILLER_124_211 VPWR VGND sg13cmos5l_fill_1
XFILLER_325_171 VPWR VGND sg13cmos5l_decap_8
XFILLER_486_112 VPWR VGND sg13cmos5l_decap_8
XFILLER_625_77 VPWR VGND sg13cmos5l_decap_8
XFILLER_340_152 VPWR VGND sg13cmos5l_fill_2
XFILLER_344_56 VPWR VGND sg13cmos5l_decap_8
XFILLER_491_84 VPWR VGND sg13cmos5l_decap_8
XFILLER_670_0 VPWR VGND sg13cmos5l_decap_8
XFILLER_641_21 VPWR VGND sg13cmos5l_decap_8
XFILLER_87_84 VPWR VGND sg13cmos5l_decap_4
XFILLER_87_95 VPWR VGND sg13cmos5l_decap_8
XFILLER_23_7 VPWR VGND sg13cmos5l_decap_8
X_1100_ _1100_/Q Tile_X0Y0_FrameData[31] VGND VPWR Tile_X0Y9_FrameStrobe[5] latch
XFILLER_38_228 VPWR VGND sg13cmos5l_fill_1
X_2080_ _2080_/Q Tile_X0Y4_FrameData[5] VGND VPWR Tile_X0Y9_FrameStrobe[4] latch
XFILLER_641_98 VPWR VGND sg13cmos5l_decap_8
XFILLER_213_49 VPWR VGND sg13cmos5l_decap_8
XFILLER_643_175 VPWR VGND sg13cmos5l_decap_8
XFILLER_442_226 VPWR VGND sg13cmos5l_fill_2
X_1031_ _1031_/Q Tile_X0Y0_FrameData[4] VGND VPWR Tile_X0Y9_FrameStrobe[2] latch
XFILLER_360_77 VPWR VGND sg13cmos5l_decap_8
XFILLER_510_14 VPWR VGND sg13cmos5l_decap_8
XANTENNA__3321__X Tile_X0Y4_EE4BEG[9] VPWR VGND sg13cmos5l_antennanp
XFILLER_556_105 VPWR VGND sg13cmos5l_decap_8
XFILLER_369_42 VPWR VGND sg13cmos5l_decap_8
XFILLER_556_116 VPWR VGND sg13cmos5l_fill_1
X_2982_ Tile_X0Y8_FrameData_O[22] Tile_X0Y8_FrameData[22] VPWR VGND sg13cmos5l_buf_1
X_4721_ _4721_/X _4806_/X _4810_/X _4814_/X _4786_/X _0605_/Q _0604_/Q VPWR VGND sg13cmos5l_mux4_1
XFILLER_159_141 VPWR VGND sg13cmos5l_decap_8
X_1933_ _1933_/Q Tile_X0Y4_FrameData[24] VGND VPWR Tile_X0Y9_FrameStrobe[0] latch
XFILLER_519_56 VPWR VGND sg13cmos5l_decap_8
XFILLER_571_119 VPWR VGND sg13cmos5l_decap_8
X_4652_ _4652_/X AXI_M_SOC_RDATA20 _4687_/X _4691_/X _4674_/X _0255_/Q _0254_/Q VPWR
+ VGND sg13cmos5l_mux4_1
X_1864_ _1864_/Q Tile_X0Y3_FrameData[1] VGND VPWR Tile_X0Y9_FrameStrobe[5] latch
XFILLER_666_84 VPWR VGND sg13cmos5l_decap_8
XFILLER_238_35 VPWR VGND sg13cmos5l_decap_8
XFILLER_174_133 VPWR VGND sg13cmos5l_decap_8
X_3603_ Tile_X0Y9_S1BEG[1] _4825_/X VPWR VGND sg13cmos5l_buf_1
X_0815_ _0815_/Q Tile_X0Y9_FrameData[16] VGND VPWR Tile_X0Y9_FrameStrobe[4] latch
XFILLER_385_63 VPWR VGND sg13cmos5l_decap_4
X_4583_ _4583_/X _4551_/X Tile_X0Y9_N4END[15] _4550_/X _0150_/X _2465_/Q _2464_/Q
+ VPWR VGND sg13cmos5l_mux4_1
X_1795_ _1795_/Q Tile_X0Y3_FrameData[6] VGND VPWR Tile_X0Y9_FrameStrobe[3] latch
XFILLER_713_168 VPWR VGND sg13cmos5l_decap_8
X_3534_ Tile_X0Y9_E2BEGb[0] _4856_/X VPWR VGND sg13cmos5l_buf_1
X_0746_ _0746_/Q Tile_X0Y9_FrameData[21] VGND VPWR Tile_X0Y9_FrameStrobe[2] latch
XFILLER_535_77 VPWR VGND sg13cmos5l_decap_8
XFILLER_107_28 VPWR VGND sg13cmos5l_decap_8
X_3465_ Tile_X0Y1_FrameData_O[23] Tile_X0Y1_FrameData[23] VPWR VGND sg13cmos5l_buf_1
X_0677_ _0677_/Q Tile_X0Y9_FrameData[26] VGND VPWR Tile_X0Y9_FrameStrobe[0] latch
XFILLER_331_163 VPWR VGND sg13cmos5l_decap_8
XFILLER_254_56 VPWR VGND sg13cmos5l_decap_8
XFILLER_88_139 VPWR VGND sg13cmos5l_decap_8
X_2416_ _2416_/Q Tile_X0Y5_FrameData[21] VGND VPWR Tile_X0Y9_FrameStrobe[7] latch
X_3396_ Tile_X0Y2_E2BEGb[7] _4055_/X VPWR VGND sg13cmos5l_buf_1
XFILLER_551_21 VPWR VGND sg13cmos5l_decap_8
XFILLER_492_126 VPWR VGND sg13cmos5l_decap_8
XFILLER_619_172 VPWR VGND sg13cmos5l_fill_1
X_2347_ _2347_/Q Tile_X0Y5_FrameData[26] VGND VPWR Tile_X0Y9_FrameStrobe[5] latch
XFILLER_619_194 VPWR VGND sg13cmos5l_decap_8
XFILLER_229_145 VPWR VGND sg13cmos5l_decap_4
XFILLER_551_98 VPWR VGND sg13cmos5l_decap_8
XFILLER_123_49 VPWR VGND sg13cmos5l_decap_8
X_2278_ _2278_/Q Tile_X0Y5_FrameData[31] VGND VPWR Tile_X0Y9_FrameStrobe[3] latch
XFILLER_701_35 VPWR VGND sg13cmos5l_decap_8
XFILLER_270_77 VPWR VGND sg13cmos5l_decap_8
X_4017_ _4017_/X _3983_/X _0096_/X _3982_/X Tile_X0Y0_S4END[5] _1215_/Q _1214_/Q VPWR
+ VGND sg13cmos5l_mux4_1
X_1229_ _1229_/Q Tile_X0Y1_FrameData[12] VGND VPWR Tile_X0Y9_FrameStrobe[1] latch
XFILLER_420_14 VPWR VGND sg13cmos5l_decap_8
XANTENNA__3231__X Tile_X0Y0_FrameStrobe_O[19] VPWR VGND sg13cmos5l_antennanp
XFILLER_16_14 VPWR VGND sg13cmos5l_decap_8
XFILLER_52_220 VPWR VGND sg13cmos5l_fill_2
XFILLER_547_105 VPWR VGND sg13cmos5l_fill_2
XFILLER_279_42 VPWR VGND sg13cmos5l_decap_8
XFILLER_252_192 VPWR VGND sg13cmos5l_decap_8
XFILLER_398_185 VPWR VGND sg13cmos5l_decap_4
XFILLER_500_91 VPWR VGND sg13cmos5l_decap_8
X_4919_ _4919_/X Tile_X0Y9_N1END[3] Tile_X0Y9_N4END[3] _4899_/X _0080_/X _0721_/Q
+ _0720_/Q VPWR VGND sg13cmos5l_mux4_1
XFILLER_32_24 VPWR VGND sg13cmos5l_decap_8
XFILLER_562_119 VPWR VGND sg13cmos5l_decap_8
XFILLER_429_56 VPWR VGND sg13cmos5l_decap_8
XFILLER_354_200 VPWR VGND sg13cmos5l_fill_2
XFILLER_225_7 VPWR VGND sg13cmos5l_decap_8
XFILLER_576_84 VPWR VGND sg13cmos5l_decap_8
XFILLER_555_182 VPWR VGND sg13cmos5l_decap_8
XFILLER_148_35 VPWR VGND sg13cmos5l_decap_8
XFILLER_20_183 VPWR VGND sg13cmos5l_decap_4
XFILLER_295_63 VPWR VGND sg13cmos5l_decap_8
XFILLER_704_146 VPWR VGND sg13cmos5l_fill_1
XFILLER_314_108 VPWR VGND sg13cmos5l_decap_8
XFILLER_180_136 VPWR VGND sg13cmos5l_fill_2
XFILLER_570_196 VPWR VGND sg13cmos5l_decap_8
XFILLER_594_7 VPWR VGND sg13cmos5l_decap_8
XFILLER_164_56 VPWR VGND sg13cmos5l_decap_8
XANTENNA__3406__X Tile_X0Y2_E1BEG[1] VPWR VGND sg13cmos5l_antennanp
XFILLER_121_225 VPWR VGND sg13cmos5l_decap_4
XFILLER_461_21 VPWR VGND sg13cmos5l_decap_8
XFILLER_57_21 VPWR VGND sg13cmos5l_decap_8
XFILLER_611_35 VPWR VGND sg13cmos5l_decap_8
XFILLER_640_112 VPWR VGND sg13cmos5l_decap_8
XFILLER_235_137 VPWR VGND sg13cmos5l_decap_4
XFILLER_180_77 VPWR VGND sg13cmos5l_decap_8
XFILLER_330_14 VPWR VGND sg13cmos5l_decap_8
XANTENNA__3141__X Tile_X0Y7_FrameData_O[11] VPWR VGND sg13cmos5l_antennanp
XFILLER_73_42 VPWR VGND sg13cmos5l_decap_8
XFILLER_687_28 VPWR VGND sg13cmos5l_decap_8
XFILLER_640_189 VPWR VGND sg13cmos5l_decap_8
XFILLER_251_0 VPWR VGND sg13cmos5l_decap_8
XFILLER_243_181 VPWR VGND sg13cmos5l_decap_8
XFILLER_188_214 VPWR VGND sg13cmos5l_decap_4
XANTENNA__2980__X Tile_X0Y8_FrameData_O[20] VPWR VGND sg13cmos5l_antennanp
XFILLER_349_0 VPWR VGND sg13cmos5l_decap_8
XFILLER_243_192 VPWR VGND sg13cmos5l_fill_1
XFILLER_189_42 VPWR VGND sg13cmos5l_decap_8
XFILLER_516_0 VPWR VGND sg13cmos5l_decap_8
XFILLER_553_119 VPWR VGND sg13cmos5l_decap_8
XFILLER_339_56 VPWR VGND sg13cmos5l_decap_8
XFILLER_486_84 VPWR VGND sg13cmos5l_decap_8
XFILLER_636_21 VPWR VGND sg13cmos5l_decap_8
XFILLER_710_105 VPWR VGND sg13cmos5l_decap_8
X_0600_ _0600_/Q Tile_X0Y8_FrameData[7] VGND VPWR Tile_X0Y9_FrameStrobe[5] latch
XFILLER_7_198 VPWR VGND sg13cmos5l_fill_1
X_1580_ _1580_/Q Tile_X0Y2_FrameData[5] VGND VPWR Tile_X0Y9_FrameStrobe[4] latch
XFILLER_636_98 VPWR VGND sg13cmos5l_decap_8
XFILLER_208_49 VPWR VGND sg13cmos5l_decap_8
XFILLER_171_147 VPWR VGND sg13cmos5l_decap_8
XFILLER_355_77 VPWR VGND sg13cmos5l_decap_8
X_0531_ _0531_/Q Tile_X0Y8_FrameData[12] VGND VPWR Tile_X0Y9_FrameStrobe[3] latch
XFILLER_505_14 VPWR VGND sg13cmos5l_decap_8
XANTENNA__3316__X Tile_X0Y4_EE4BEG[4] VPWR VGND sg13cmos5l_antennanp
XFILLER_652_42 VPWR VGND sg13cmos5l_decap_8
XFILLER_313_174 VPWR VGND sg13cmos5l_decap_8
XFILLER_258_207 VPWR VGND sg13cmos5l_decap_8
XFILLER_112_225 VPWR VGND sg13cmos5l_decap_4
X_0462_ _0462_/Q Tile_X0Y8_FrameData[17] VGND VPWR Tile_X0Y9_FrameStrobe[1] latch
X_3250_ Tile_X0Y0_FrameData_O[18] Tile_X0Y0_FrameData[18] VPWR VGND sg13cmos5l_buf_1
XFILLER_474_104 VPWR VGND sg13cmos5l_decap_8
XFILLER_371_21 VPWR VGND sg13cmos5l_decap_8
X_2201_ _2201_/Q Tile_X0Y5_FrameData[12] VGND VPWR Tile_X0Y9_FrameStrobe[0] latch
X_0393_ _0393_/Q Tile_X0Y7_FrameData[22] VGND VPWR Tile_X0Y9_FrameStrobe[7] latch
X_3181_ Tile_X0Y0_N4BEG[5] _3181_/A VPWR VGND sg13cmos5l_buf_1
X_2132_ _2132_/Q Tile_X0Y4_FrameData[17] VGND VPWR Tile_X0Y9_FrameStrobe[6] latch
XFILLER_371_98 VPWR VGND sg13cmos5l_decap_8
XFILLER_521_35 VPWR VGND sg13cmos5l_decap_8
XFILLER_304_70 VPWR VGND sg13cmos5l_decap_8
XFILLER_304_81 VPWR VGND sg13cmos5l_fill_1
XFILLER_93_153 VPWR VGND sg13cmos5l_decap_8
XFILLER_631_112 VPWR VGND sg13cmos5l_decap_8
XFILLER_26_209 VPWR VGND sg13cmos5l_decap_4
XFILLER_631_123 VPWR VGND sg13cmos5l_fill_1
XFILLER_240_14 VPWR VGND sg13cmos5l_decap_8
X_2063_ _2063_/Q Tile_X0Y4_FrameData[22] VGND VPWR Tile_X0Y9_FrameStrobe[4] latch
XANTENNA__3051__X Tile_X0Y5_FrameData_O[10] VPWR VGND sg13cmos5l_antennanp
XFILLER_631_145 VPWR VGND sg13cmos5l_decap_8
XFILLER_241_107 VPWR VGND sg13cmos5l_decap_8
X_1014_ _1014_/Q Tile_X0Y0_FrameData[21] VGND VPWR Tile_X0Y9_FrameStrobe[2] latch
XFILLER_241_118 VPWR VGND sg13cmos5l_fill_2
XFILLER_597_28 VPWR VGND sg13cmos5l_decap_8
XANTENNA__2890__X Tile_X0Y6_FrameData_O[11] VPWR VGND sg13cmos5l_antennanp
XFILLER_584_200 VPWR VGND sg13cmos5l_fill_2
XFILLER_529_105 VPWR VGND sg13cmos5l_decap_4
XFILLER_234_192 VPWR VGND sg13cmos5l_decap_8
XFILLER_529_116 VPWR VGND sg13cmos5l_decap_8
XFILLER_97_0 VPWR VGND sg13cmos5l_decap_8
X_2965_ Tile_X0Y8_FrameData_O[5] Tile_X0Y8_FrameData[5] VPWR VGND sg13cmos5l_buf_1
XFILLER_249_56 VPWR VGND sg13cmos5l_decap_8
X_4704_ _4704_/X Tile_X0Y6_W2MID[5] Tile_X0Y6_W2END[5] Tile_X0Y6_W6END[10] _4557_/X
+ _2647_/Q _2646_/Q VPWR VGND sg13cmos5l_mux4_1
XFILLER_147_111 VPWR VGND sg13cmos5l_decap_8
X_1916_ _1916_/Q Tile_X0Y3_FrameData[13] VGND VPWR Tile_X0Y9_FrameStrobe[7] latch
XFILLER_396_84 VPWR VGND sg13cmos5l_decap_8
X_2896_ Tile_X0Y6_FrameData_O[17] Tile_X0Y6_FrameData[17] VPWR VGND sg13cmos5l_buf_1
XFILLER_537_182 VPWR VGND sg13cmos5l_decap_4
XFILLER_546_21 VPWR VGND sg13cmos5l_decap_8
XFILLER_8_70 VPWR VGND sg13cmos5l_decap_8
XFILLER_698_112 VPWR VGND sg13cmos5l_decap_8
X_4635_ _4635_/X Tile_X0Y7_WW4END[8] AXI_M_SOC_RDATA23 _4692_/X _4669_/X _0289_/Q
+ _0288_/Q VPWR VGND sg13cmos5l_mux4_1
X_1847_ _1847_/Q Tile_X0Y3_FrameData[18] VGND VPWR Tile_X0Y9_FrameStrobe[5] latch
XFILLER_552_163 VPWR VGND sg13cmos5l_decap_8
XFILLER_147_199 VPWR VGND sg13cmos5l_fill_2
XFILLER_701_105 VPWR VGND sg13cmos5l_decap_8
X_4566_ _4566_/X Tile_X0Y2_W1END[3] Tile_X0Y2_WW4END[15] Tile_X0Y2_W6END[7] _4119_/X
+ _1604_/Q _1603_/Q VPWR VGND sg13cmos5l_mux4_1
X_1778_ _1778_/Q Tile_X0Y3_FrameData[23] VGND VPWR Tile_X0Y9_FrameStrobe[3] latch
XFILLER_118_49 VPWR VGND sg13cmos5l_decap_8
XFILLER_162_158 VPWR VGND sg13cmos5l_decap_4
XFILLER_639_212 VPWR VGND sg13cmos5l_fill_2
X_3517_ Tile_X0Y1_E2BEG[7] _3939_/X VPWR VGND sg13cmos5l_buf_1
XFILLER_265_77 VPWR VGND sg13cmos5l_decap_8
X_0729_ _0729_/Q Tile_X0Y9_FrameData[6] VGND VPWR Tile_X0Y9_FrameStrobe[1] latch
XFILLER_415_14 VPWR VGND sg13cmos5l_decap_8
X_4497_ _4497_/X Tile_X0Y6_W2MID[6] AXI_M_SOC_RDATA25 _4555_/X _4554_/X _2613_/Q _2612_/Q
+ VPWR VGND sg13cmos5l_mux4_1
XFILLER_103_203 VPWR VGND sg13cmos5l_decap_8
XANTENNA__3226__X Tile_X0Y0_FrameStrobe_O[14] VPWR VGND sg13cmos5l_antennanp
XFILLER_562_42 VPWR VGND sg13cmos5l_decap_8
XFILLER_170_180 VPWR VGND sg13cmos5l_decap_8
X_3448_ Tile_X0Y1_FrameData_O[6] Tile_X0Y1_FrameData[6] VPWR VGND sg13cmos5l_buf_1
XFILLER_281_21 VPWR VGND sg13cmos5l_decap_8
X_3379_ Tile_X0Y2_E6BEG[2] _4074_/X VPWR VGND sg13cmos5l_buf_1
XFILLER_69_161 VPWR VGND sg13cmos5l_decap_8
XFILLER_712_56 VPWR VGND sg13cmos5l_decap_8
XFILLER_281_98 VPWR VGND sg13cmos5l_decap_8
XFILLER_431_35 VPWR VGND sg13cmos5l_decap_8
XFILLER_607_175 VPWR VGND sg13cmos5l_fill_2
XFILLER_214_70 VPWR VGND sg13cmos5l_decap_8
XFILLER_473_192 VPWR VGND sg13cmos5l_fill_1
XFILLER_27_35 VPWR VGND sg13cmos5l_decap_8
XFILLER_150_14 VPWR VGND sg13cmos5l_decap_8
XFILLER_175_7 VPWR VGND sg13cmos5l_decap_8
XFILLER_342_7 VPWR VGND sg13cmos5l_decap_8
XFILLER_300_28 VPWR VGND sg13cmos5l_decap_8
XFILLER_40_212 VPWR VGND sg13cmos5l_fill_1
XFILLER_43_56 VPWR VGND sg13cmos5l_decap_8
XFILLER_386_166 VPWR VGND sg13cmos5l_decap_8
XFILLER_386_177 VPWR VGND sg13cmos5l_fill_2
XFILLER_240_184 VPWR VGND sg13cmos5l_fill_2
XFILLER_535_108 VPWR VGND sg13cmos5l_fill_1
XFILLER_159_56 VPWR VGND sg13cmos5l_decap_8
XFILLER_607_7 VPWR VGND sg13cmos5l_decap_8
XFILLER_138_133 VPWR VGND sg13cmos5l_decap_8
XFILLER_528_193 VPWR VGND sg13cmos5l_decap_8
XFILLER_456_21 VPWR VGND sg13cmos5l_decap_8
XFILLER_153_103 VPWR VGND sg13cmos5l_fill_1
XFILLER_342_214 VPWR VGND sg13cmos5l_decap_4
XFILLER_543_174 VPWR VGND sg13cmos5l_decap_4
XFILLER_606_35 VPWR VGND sg13cmos5l_decap_8
XFILLER_175_77 VPWR VGND sg13cmos5l_fill_1
XFILLER_325_14 VPWR VGND sg13cmos5l_decap_8
XFILLER_4_28 VPWR VGND sg13cmos5l_decap_8
XFILLER_175_99 VPWR VGND sg13cmos5l_decap_8
XANTENNA__3136__X Tile_X0Y7_FrameData_O[6] VPWR VGND sg13cmos5l_antennanp
XFILLER_472_42 VPWR VGND sg13cmos5l_decap_8
XFILLER_310_111 VPWR VGND sg13cmos5l_decap_8
XFILLER_68_42 VPWR VGND sg13cmos5l_decap_8
XFILLER_191_21 VPWR VGND sg13cmos5l_decap_8
XFILLER_456_126 VPWR VGND sg13cmos5l_decap_8
XFILLER_310_144 VPWR VGND sg13cmos5l_decap_8
XFILLER_299_0 VPWR VGND sg13cmos5l_decap_8
XANTENNA__2975__X Tile_X0Y8_FrameData_O[15] VPWR VGND sg13cmos5l_antennanp
XFILLER_68_86 VPWR VGND sg13cmos5l_decap_8
XFILLER_622_56 VPWR VGND sg13cmos5l_decap_8
XFILLER_191_98 VPWR VGND sg13cmos5l_decap_8
XFILLER_464_170 VPWR VGND sg13cmos5l_decap_8
XFILLER_341_35 VPWR VGND sg13cmos5l_decap_8
XFILLER_208_126 VPWR VGND sg13cmos5l_decap_8
XFILLER_613_112 VPWR VGND sg13cmos5l_decap_8
XFILLER_466_0 VPWR VGND sg13cmos5l_decap_8
XFILLER_464_192 VPWR VGND sg13cmos5l_fill_2
XFILLER_84_63 VPWR VGND sg13cmos5l_decap_8
XFILLER_698_49 VPWR VGND sg13cmos5l_decap_8
XFILLER_613_167 VPWR VGND sg13cmos5l_fill_1
XFILLER_90_145 VPWR VGND sg13cmos5l_decap_4
XFILLER_613_189 VPWR VGND sg13cmos5l_decap_4
XFILLER_633_0 VPWR VGND sg13cmos5l_decap_8
XFILLER_210_28 VPWR VGND sg13cmos5l_decap_8
XFILLER_140_91 VPWR VGND sg13cmos5l_decap_8
XFILLER_90_7 VPWR VGND sg13cmos5l_decap_8
XFILLER_176_217 VPWR VGND sg13cmos5l_decap_8
XFILLER_176_228 VPWR VGND sg13cmos5l_fill_1
XFILLER_526_119 VPWR VGND sg13cmos5l_fill_1
XFILLER_318_200 VPWR VGND sg13cmos5l_decap_8
XFILLER_647_42 VPWR VGND sg13cmos5l_decap_8
XFILLER_581_214 VPWR VGND sg13cmos5l_fill_1
XFILLER_129_111 VPWR VGND sg13cmos5l_decap_8
X_2750_ Tile_X0Y3_FrameData_O[8] Tile_X0Y3_FrameData[8] VPWR VGND sg13cmos5l_buf_1
XFILLER_366_21 VPWR VGND sg13cmos5l_decap_8
X_1701_ _1701_/Q Tile_X0Y3_FrameData[4] VGND VPWR Tile_X0Y9_FrameStrobe[0] latch
X_2681_ _2681_/Q Tile_X0Y6_FrameData[14] VGND VPWR Tile_X0Y9_FrameStrobe[7] latch
XFILLER_534_163 VPWR VGND sg13cmos5l_decap_8
XFILLER_144_114 VPWR VGND sg13cmos5l_fill_1
X_4420_ _4420_/X Tile_X0Y4_W1END[1] Tile_X0Y4_W6END[9] _4349_/X _4303_/X _2143_/Q
+ _2142_/Q VPWR VGND sg13cmos5l_mux4_1
X_1632_ _1632_/Q Tile_X0Y2_FrameData[17] VGND VPWR Tile_X0Y9_FrameStrobe[6] latch
XFILLER_366_98 VPWR VGND sg13cmos5l_decap_8
XFILLER_144_147 VPWR VGND sg13cmos5l_decap_8
XFILLER_516_35 VPWR VGND sg13cmos5l_decap_8
X_4351_ _4351_/X _4311_/X _0040_/X _4310_/X _0109_/X _1951_/Q _1950_/Q VPWR VGND sg13cmos5l_mux4_1
XFILLER_663_63 VPWR VGND sg13cmos5l_decap_8
X_1563_ _1563_/Q Tile_X0Y2_FrameData[22] VGND VPWR Tile_X0Y9_FrameStrobe[4] latch
XFILLER_235_14 VPWR VGND sg13cmos5l_decap_8
XANTENNA__3046__X Tile_X0Y5_FrameData_O[5] VPWR VGND sg13cmos5l_antennanp
XFILLER_382_42 VPWR VGND sg13cmos5l_decap_8
X_3302_ Tile_X0Y0_E2BEG[2] _3806_/X VPWR VGND sg13cmos5l_buf_1
X_0514_ _0514_/Q Tile_X0Y8_FrameData[29] VGND VPWR Tile_X0Y9_FrameStrobe[3] latch
X_4282_ _4282_/X Tile_X0Y4_WW4END[5] AXI_M_SOC_BRESP1 _4341_/X _4316_/X _2049_/Q _2048_/Q
+ VPWR VGND sg13cmos5l_mux4_1
XFILLER_152_191 VPWR VGND sg13cmos5l_fill_2
X_1494_ _1494_/Q Tile_X0Y2_FrameData[27] VGND VPWR Tile_X0Y9_FrameStrobe[2] latch
XFILLER_301_144 VPWR VGND sg13cmos5l_fill_1
XANTENNA__2885__X Tile_X0Y6_FrameData_O[6] VPWR VGND sg13cmos5l_antennanp
X_3233_ Tile_X0Y0_FrameData_O[1] Tile_X0Y0_FrameData[1] VPWR VGND sg13cmos5l_buf_1
X_0445_ _0445_/Q Tile_X0Y8_FrameData[2] VGND VPWR Tile_X0Y9_FrameStrobe[0] latch
XFILLER_532_56 VPWR VGND sg13cmos5l_decap_8
XFILLER_100_228 VPWR VGND sg13cmos5l_fill_1
XFILLER_301_199 VPWR VGND sg13cmos5l_fill_2
X_3164_ Tile_X0Y4_E6BEG[1] _4289_/X VPWR VGND sg13cmos5l_buf_1
X_0376_ _0376_/Q Tile_X0Y7_FrameData[7] VGND VPWR Tile_X0Y9_FrameStrobe[6] latch
XFILLER_251_35 VPWR VGND sg13cmos5l_decap_8
XFILLER_12_0 VPWR VGND sg13cmos5l_decap_8
XFILLER_254_221 VPWR VGND sg13cmos5l_decap_8
X_2115_ _2115_/Q Tile_X0Y4_FrameData[2] VGND VPWR Tile_X0Y9_FrameStrobe[5] latch
XFILLER_66_164 VPWR VGND sg13cmos5l_decap_8
X_3095_ Tile_X0Y7_E2BEGb[1] _4621_/X VPWR VGND sg13cmos5l_buf_1
X_2046_ _2046_/Q Tile_X0Y4_FrameData[7] VGND VPWR Tile_X0Y9_FrameStrobe[3] latch
XFILLER_470_173 VPWR VGND sg13cmos5l_decap_8
XFILLER_401_49 VPWR VGND sg13cmos5l_decap_8
XFILLER_120_28 VPWR VGND sg13cmos5l_decap_8
XFILLER_557_211 VPWR VGND sg13cmos5l_fill_2
XFILLER_222_184 VPWR VGND sg13cmos5l_decap_4
X_3997_ _3997_/X Tile_X0Y5_W1END[0] Tile_X0Y5_WW4END[0] Tile_X0Y5_W6END[8] _4451_/X
+ _2415_/Q _2414_/Q VPWR VGND sg13cmos5l_mux4_1
XFILLER_368_177 VPWR VGND sg13cmos5l_decap_8
XFILLER_706_208 VPWR VGND sg13cmos5l_fill_1
XFILLER_572_203 VPWR VGND sg13cmos5l_decap_8
XFILLER_368_188 VPWR VGND sg13cmos5l_fill_2
XFILLER_572_214 VPWR VGND sg13cmos5l_fill_2
XFILLER_557_42 VPWR VGND sg13cmos5l_decap_8
X_2948_ Tile_X0Y8_EE4BEG[4] _4748_/X VPWR VGND sg13cmos5l_buf_1
XFILLER_383_136 VPWR VGND sg13cmos5l_decap_8
XFILLER_276_21 VPWR VGND sg13cmos5l_decap_8
X_2879_ Tile_X0Y6_FrameData_O[0] Tile_X0Y6_FrameData[0] VPWR VGND sg13cmos5l_buf_1
XFILLER_324_203 VPWR VGND sg13cmos5l_decap_8
XFILLER_707_56 VPWR VGND sg13cmos5l_decap_8
X_4618_ _4618_/X Tile_X0Y7_W2MID[1] AXI_M_SOC_RDATA22 _4671_/X _4670_/X _0323_/Q _0322_/Q
+ VPWR VGND sg13cmos5l_mux4_1
XFILLER_190_220 VPWR VGND sg13cmos5l_fill_1
XFILLER_276_98 VPWR VGND sg13cmos5l_decap_8
XFILLER_426_35 VPWR VGND sg13cmos5l_decap_8
XFILLER_135_147 VPWR VGND sg13cmos5l_decap_8
XFILLER_209_70 VPWR VGND sg13cmos5l_decap_8
XFILLER_573_63 VPWR VGND sg13cmos5l_decap_8
X_4549_ _4549_/X Tile_X0Y7_W1END[2] Tile_X0Y7_W6END[6] _4698_/X _4658_/X _0411_/Q
+ _0410_/Q VPWR VGND sg13cmos5l_mux4_1
XFILLER_145_14 VPWR VGND sg13cmos5l_decap_8
XFILLER_292_42 VPWR VGND sg13cmos5l_decap_8
XFILLER_289_173 VPWR VGND sg13cmos5l_decap_8
XANTENNA__2795__X Tile_X0Y3_E6BEG[5] VPWR VGND sg13cmos5l_antennanp
XFILLER_438_137 VPWR VGND sg13cmos5l_decap_8
XFILLER_292_7 VPWR VGND sg13cmos5l_decap_8
XFILLER_442_56 VPWR VGND sg13cmos5l_decap_8
XFILLER_225_91 VPWR VGND sg13cmos5l_decap_8
XFILLER_57_120 VPWR VGND sg13cmos5l_decap_8
XFILLER_38_56 VPWR VGND sg13cmos5l_decap_8
XFILLER_161_35 VPWR VGND sg13cmos5l_decap_8
XFILLER_557_7 VPWR VGND sg13cmos5l_decap_8
XFILLER_72_145 VPWR VGND sg13cmos5l_decap_4
XFILLER_311_49 VPWR VGND sg13cmos5l_decap_8
XFILLER_54_66 VPWR VGND sg13cmos5l_decap_8
XFILLER_548_222 VPWR VGND sg13cmos5l_decap_8
XFILLER_213_140 VPWR VGND sg13cmos5l_decap_8
XFILLER_374_103 VPWR VGND sg13cmos5l_fill_1
XFILLER_70_21 VPWR VGND sg13cmos5l_decap_8
XFILLER_9_227 VPWR VGND sg13cmos5l_fill_2
XFILLER_508_119 VPWR VGND sg13cmos5l_decap_8
XFILLER_467_42 VPWR VGND sg13cmos5l_decap_8
XFILLER_186_21 VPWR VGND sg13cmos5l_decap_8
XFILLER_70_98 VPWR VGND sg13cmos5l_decap_8
XFILLER_214_0 VPWR VGND sg13cmos5l_decap_8
XFILLER_617_56 VPWR VGND sg13cmos5l_decap_8
XFILLER_516_174 VPWR VGND sg13cmos5l_fill_1
XFILLER_126_147 VPWR VGND sg13cmos5l_decap_8
XFILLER_677_115 VPWR VGND sg13cmos5l_fill_2
XFILLER_336_35 VPWR VGND sg13cmos5l_decap_8
XFILLER_119_70 VPWR VGND sg13cmos5l_decap_8
XFILLER_677_137 VPWR VGND sg13cmos5l_fill_1
XFILLER_483_63 VPWR VGND sg13cmos5l_decap_8
XFILLER_79_63 VPWR VGND sg13cmos5l_decap_8
XFILLER_677_159 VPWR VGND sg13cmos5l_decap_8
XFILLER_583_0 VPWR VGND sg13cmos5l_decap_8
XFILLER_484_221 VPWR VGND sg13cmos5l_decap_8
XFILLER_429_126 VPWR VGND sg13cmos5l_decap_8
XFILLER_633_77 VPWR VGND sg13cmos5l_decap_8
XFILLER_205_28 VPWR VGND sg13cmos5l_decap_8
XFILLER_352_56 VPWR VGND sg13cmos5l_decap_8
XFILLER_135_91 VPWR VGND sg13cmos5l_decap_8
X_0230_ _0230_/Q Tile_X0Y7_FrameData[25] VGND VPWR Tile_X0Y9_FrameStrobe[2] latch
XFILLER_48_142 VPWR VGND sg13cmos5l_decap_8
XFILLER_437_170 VPWR VGND sg13cmos5l_decap_8
X_0161_ _0161_/Q Tile_X0Y7_FrameData[30] VGND VPWR Tile_X0Y9_FrameStrobe[0] latch
XFILLER_48_175 VPWR VGND sg13cmos5l_decap_8
XFILLER_48_186 VPWR VGND sg13cmos5l_fill_2
X_0092_ _3623_/A _4486_/X _4487_/X _2630_/Q VPWR VGND sg13cmos5l_mux2_1
XFILLER_221_49 VPWR VGND sg13cmos5l_decap_8
XFILLER_63_167 VPWR VGND sg13cmos5l_decap_8
X_3920_ _3920_/X Tile_X0Y3_W1END[3] Tile_X0Y3_WW4END[3] Tile_X0Y3_W6END[11] _4225_/X
+ _1892_/Q _1891_/Q VPWR VGND sg13cmos5l_mux4_1
XFILLER_598_199 VPWR VGND sg13cmos5l_fill_1
XFILLER_204_140 VPWR VGND sg13cmos5l_decap_8
X_3851_ _3851_/X Tile_X0Y1_W1END[3] Tile_X0Y1_W6END[7] _3996_/X _3979_/X _1419_/Q
+ _1418_/Q VPWR VGND sg13cmos5l_mux4_1
XFILLER_658_63 VPWR VGND sg13cmos5l_decap_8
XFILLER_149_228 VPWR VGND sg13cmos5l_fill_1
X_2802_ Tile_X0Y3_E2BEGb[0] _4156_/X VPWR VGND sg13cmos5l_buf_1
XFILLER_377_42 VPWR VGND sg13cmos5l_decap_8
X_3782_ _3782_/X Tile_X0Y0_W1END[2] Tile_X0Y0_W6END[6] _3867_/X _3861_/X _1173_/Q
+ _1172_/Q VPWR VGND sg13cmos5l_mux4_1
X_0994_ _0994_/Q Tile_X0Y0_FrameData[9] VGND VPWR Tile_X0Y9_FrameStrobe[1] latch
X_2733_ _4892_/A3 VPWR VGND sg13cmos5l_tielo
XFILLER_527_56 VPWR VGND sg13cmos5l_decap_8
XFILLER_306_225 VPWR VGND sg13cmos5l_decap_4
XFILLER_711_211 VPWR VGND sg13cmos5l_fill_1
X_2664_ _2664_/Q Tile_X0Y6_FrameData[31] VGND VPWR Tile_X0Y9_FrameStrobe[7] latch
XFILLER_674_84 VPWR VGND sg13cmos5l_decap_8
XFILLER_246_35 VPWR VGND sg13cmos5l_decap_8
XFILLER_668_126 VPWR VGND sg13cmos5l_decap_8
X_4403_ _4403_/X Tile_X0Y5_WW4END[0] AXI_M_SOC_RVALID _4451_/X _4467_/X _2297_/Q _2296_/Q
+ VPWR VGND sg13cmos5l_mux4_1
XFILLER_522_144 VPWR VGND sg13cmos5l_fill_2
X_1615_ _1615_/Q Tile_X0Y2_FrameData[2] VGND VPWR Tile_X0Y9_FrameStrobe[5] latch
XFILLER_393_63 VPWR VGND sg13cmos5l_decap_8
X_2595_ _2595_/Q Tile_X0Y6_FrameData[4] VGND VPWR Tile_X0Y9_FrameStrobe[4] latch
X_4334_ _4334_/X Tile_X0Y8_W1END[3] Tile_X0Y8_WW4END[3] Tile_X0Y8_W6END[11] _4803_/X
+ _0638_/Q _0637_/Q VPWR VGND sg13cmos5l_mux4_1
XFILLER_522_199 VPWR VGND sg13cmos5l_fill_2
X_1546_ _1546_/Q Tile_X0Y2_FrameData[7] VGND VPWR Tile_X0Y9_FrameStrobe[3] latch
XFILLER_475_221 VPWR VGND sg13cmos5l_decap_8
XFILLER_543_77 VPWR VGND sg13cmos5l_decap_8
XFILLER_115_28 VPWR VGND sg13cmos5l_decap_8
X_4265_ _4265_/X Tile_X0Y4_W2END[6] AXI_M_SOC_BRESP0 _4315_/X _4314_/X _2083_/Q _2082_/Q
+ VPWR VGND sg13cmos5l_mux4_1
X_1477_ _1477_/Q Tile_X0Y2_FrameData[12] VGND VPWR Tile_X0Y9_FrameStrobe[1] latch
XFILLER_286_165 VPWR VGND sg13cmos5l_fill_2
XFILLER_262_56 VPWR VGND sg13cmos5l_decap_8
XANTENNA__3504__X Tile_X0Y1_E2BEGb[2] VPWR VGND sg13cmos5l_antennanp
XFILLER_140_194 VPWR VGND sg13cmos5l_decap_8
X_3216_ Tile_X0Y0_FrameStrobe_O[4] Tile_X0Y9_FrameStrobe[4] VPWR VGND sg13cmos5l_buf_1
X_0428_ _0428_/Q Tile_X0Y8_FrameData[19] VGND VPWR Tile_X0Y9_FrameStrobe[0] latch
X_4196_ _4196_/X Tile_X0Y2_W1END[1] Tile_X0Y2_W6END[9] _4110_/X _4085_/X _1635_/Q
+ _1634_/Q VPWR VGND sg13cmos5l_mux4_1
XFILLER_262_89 VPWR VGND sg13cmos5l_decap_4
XFILLER_412_26 VPWR VGND sg13cmos5l_decap_8
X_3147_ Tile_X0Y7_FrameData_O[17] Tile_X0Y7_FrameData[17] VPWR VGND sg13cmos5l_buf_1
X_0359_ _0359_/Q Tile_X0Y7_FrameData[24] VGND VPWR Tile_X0Y9_FrameStrobe[6] latch
XFILLER_443_140 VPWR VGND sg13cmos5l_fill_2
XFILLER_54_145 VPWR VGND sg13cmos5l_decap_8
X_3078_ Tile_X0Y4_E2BEGb[4] _4268_/X VPWR VGND sg13cmos5l_buf_1
XFILLER_131_49 VPWR VGND sg13cmos5l_decap_8
XFILLER_589_177 VPWR VGND sg13cmos5l_decap_8
XFILLER_589_188 VPWR VGND sg13cmos5l_decap_8
X_2029_ _2029_/Q Tile_X0Y4_FrameData[24] VGND VPWR Tile_X0Y9_FrameStrobe[3] latch
XFILLER_24_14 VPWR VGND sg13cmos5l_decap_8
XFILLER_568_63 VPWR VGND sg13cmos5l_decap_8
XFILLER_287_42 VPWR VGND sg13cmos5l_decap_8
XFILLER_210_154 VPWR VGND sg13cmos5l_decap_8
XFILLER_356_147 VPWR VGND sg13cmos5l_decap_8
XFILLER_138_7 VPWR VGND sg13cmos5l_decap_8
XFILLER_155_209 VPWR VGND sg13cmos5l_fill_2
XFILLER_6_219 VPWR VGND sg13cmos5l_fill_2
XFILLER_108_103 VPWR VGND sg13cmos5l_decap_8
XFILLER_437_56 VPWR VGND sg13cmos5l_decap_8
XFILLER_40_35 VPWR VGND sg13cmos5l_decap_8
XFILLER_371_139 VPWR VGND sg13cmos5l_decap_8
XFILLER_364_180 VPWR VGND sg13cmos5l_decap_8
XFILLER_305_7 VPWR VGND sg13cmos5l_decap_8
XFILLER_584_84 VPWR VGND sg13cmos5l_decap_8
XFILLER_156_35 VPWR VGND sg13cmos5l_decap_8
XFILLER_513_133 VPWR VGND sg13cmos5l_fill_2
XFILLER_306_49 VPWR VGND sg13cmos5l_decap_8
XFILLER_466_221 VPWR VGND sg13cmos5l_fill_1
XFILLER_674_7 VPWR VGND sg13cmos5l_decap_8
XFILLER_49_66 VPWR VGND sg13cmos5l_decap_8
XFILLER_131_161 VPWR VGND sg13cmos5l_decap_4
XFILLER_603_14 VPWR VGND sg13cmos5l_decap_8
XFILLER_277_154 VPWR VGND sg13cmos5l_decap_4
XFILLER_453_99 VPWR VGND sg13cmos5l_fill_2
XANTENNA__3414__X Tile_X0Y4_FrameData_O[5] VPWR VGND sg13cmos5l_antennanp
XFILLER_172_56 VPWR VGND sg13cmos5l_decap_8
XFILLER_49_99 VPWR VGND sg13cmos5l_decap_8
XFILLER_277_198 VPWR VGND sg13cmos5l_decap_4
XFILLER_682_195 VPWR VGND sg13cmos5l_fill_2
XFILLER_65_21 VPWR VGND sg13cmos5l_decap_8
XFILLER_45_112 VPWR VGND sg13cmos5l_fill_2
XFILLER_434_140 VPWR VGND sg13cmos5l_fill_1
XFILLER_292_179 VPWR VGND sg13cmos5l_decap_8
XFILLER_402_70 VPWR VGND sg13cmos5l_decap_4
XFILLER_379_217 VPWR VGND sg13cmos5l_fill_1
XFILLER_164_0 VPWR VGND sg13cmos5l_decap_8
XFILLER_60_148 VPWR VGND sg13cmos5l_fill_2
XFILLER_81_42 VPWR VGND sg13cmos5l_decap_8
XFILLER_695_28 VPWR VGND sg13cmos5l_decap_8
XFILLER_478_63 VPWR VGND sg13cmos5l_decap_8
XFILLER_331_0 VPWR VGND sg13cmos5l_decap_8
XFILLER_429_0 VPWR VGND sg13cmos5l_decap_8
XFILLER_197_42 VPWR VGND sg13cmos5l_decap_8
XFILLER_198_194 VPWR VGND sg13cmos5l_fill_1
XFILLER_628_33 VPWR VGND sg13cmos5l_decap_8
XFILLER_14_91 VPWR VGND sg13cmos5l_decap_4
XFILLER_347_56 VPWR VGND sg13cmos5l_decap_8
XFILLER_154_220 VPWR VGND sg13cmos5l_fill_2
XFILLER_494_84 VPWR VGND sg13cmos5l_decap_8
XFILLER_504_133 VPWR VGND sg13cmos5l_decap_8
XFILLER_644_21 VPWR VGND sg13cmos5l_decap_8
XFILLER_53_7 VPWR VGND sg13cmos5l_decap_8
XFILLER_504_166 VPWR VGND sg13cmos5l_decap_8
XFILLER_370_161 VPWR VGND sg13cmos5l_decap_8
X_1400_ _1400_/Q Tile_X0Y1_FrameData[1] VGND VPWR Tile_X0Y9_FrameStrobe[6] latch
X_2380_ _2380_/Q Tile_X0Y5_FrameData[25] VGND VPWR Tile_X0Y9_FrameStrobe[6] latch
XFILLER_644_98 VPWR VGND sg13cmos5l_decap_8
XFILLER_665_129 VPWR VGND sg13cmos5l_fill_2
XFILLER_216_49 VPWR VGND sg13cmos5l_decap_8
XFILLER_658_170 VPWR VGND sg13cmos5l_decap_8
XFILLER_363_77 VPWR VGND sg13cmos5l_decap_8
X_1331_ _1331_/Q Tile_X0Y1_FrameData[6] VGND VPWR Tile_X0Y9_FrameStrobe[4] latch
XFILLER_513_14 VPWR VGND sg13cmos5l_decap_8
XFILLER_268_154 VPWR VGND sg13cmos5l_decap_8
XANTENNA__3324__X Tile_X0Y4_EE4BEG[12] VPWR VGND sg13cmos5l_antennanp
XFILLER_660_42 VPWR VGND sg13cmos5l_decap_8
XFILLER_472_202 VPWR VGND sg13cmos5l_decap_8
X_4050_ _4050_/X Tile_X0Y2_W2END[5] AXI_M_SOC_AWREADY _4101_/X _4100_/X _1573_/Q _1572_/Q
+ VPWR VGND sg13cmos5l_mux4_1
X_1262_ _1262_/Q Tile_X0Y1_FrameData[11] VGND VPWR Tile_X0Y9_FrameStrobe[2] latch
X_3001_ Tile_X0Y5_E2BEG[4] _4376_/X VPWR VGND sg13cmos5l_buf_1
X_0213_ _0213_/Q Tile_X0Y7_FrameData[10] VGND VPWR Tile_X0Y9_FrameStrobe[1] latch
XFILLER_283_168 VPWR VGND sg13cmos5l_decap_8
X_1193_ _1193_/Q Tile_X0Y1_FrameData[16] VGND VPWR Tile_X0Y9_FrameStrobe[0] latch
XFILLER_425_140 VPWR VGND sg13cmos5l_decap_8
X_0144_ _3186_/A _3906_/X _3907_/X _1393_/Q VPWR VGND sg13cmos5l_mux2_1
XFILLER_312_70 VPWR VGND sg13cmos5l_decap_8
XFILLER_312_81 VPWR VGND sg13cmos5l_fill_2
X_0075_ _0075_/X _4796_/X _4797_/X _2113_/Q VPWR VGND sg13cmos5l_mux2_1
XFILLER_669_84 VPWR VGND sg13cmos5l_decap_8
X_3903_ _3903_/X Tile_X0Y1_W2MID[0] Tile_X0Y1_W2END[0] Tile_X0Y1_W6END[0] _3988_/X
+ _1403_/Q _1402_/Q VPWR VGND sg13cmos5l_mux4_1
XFILLER_388_63 VPWR VGND sg13cmos5l_decap_4
X_4883_ _4883_/X Tile_X0Y9_N4END[3] _0080_/X _4924_/X _4928_/X _0777_/Q _0776_/Q VPWR
+ VGND sg13cmos5l_mux4_1
XFILLER_338_114 VPWR VGND sg13cmos5l_fill_2
X_3834_ _3834_/X Tile_X0Y0_WW4END[1] Tile_X0Y0_WW4END[2] _3882_/X _3855_/X _1037_/Q
+ _1036_/Q VPWR VGND sg13cmos5l_mux4_1
XFILLER_538_77 VPWR VGND sg13cmos5l_decap_8
X_3765_ _3765_/X Tile_X0Y1_WW4END[6] Tile_X0Y1_WW4END[14] Tile_X0Y1_W6END[6] _4014_/X
+ _1245_/Q _1244_/Q VPWR VGND sg13cmos5l_mux4_1
X_0977_ _0977_/Q Tile_X0Y0_FrameData[26] VGND VPWR Tile_X0Y9_FrameStrobe[1] latch
XFILLER_542_228 VPWR VGND sg13cmos5l_fill_1
XFILLER_257_56 VPWR VGND sg13cmos5l_decap_8
X_2716_ _4543_/A3 VPWR VGND sg13cmos5l_tielo
X_3696_ AXI_M_SOC_WDATA6 Tile_X0Y7_WW4END[6] Tile_X0Y7_WW4END[14] Tile_X0Y7_W6END[6]
+ _4690_/X _0235_/Q _0234_/Q VPWR VGND sg13cmos5l_mux4_1
XFILLER_554_21 VPWR VGND sg13cmos5l_decap_8
X_2647_ _2647_/Q Tile_X0Y6_FrameData[16] VGND VPWR Tile_X0Y9_FrameStrobe[6] latch
XFILLER_361_161 VPWR VGND sg13cmos5l_decap_8
XFILLER_160_212 VPWR VGND sg13cmos5l_decap_8
XFILLER_10_49 VPWR VGND sg13cmos5l_decap_8
XFILLER_554_98 VPWR VGND sg13cmos5l_decap_8
X_2578_ _2578_/Q Tile_X0Y6_FrameData[21] VGND VPWR Tile_X0Y9_FrameStrobe[4] latch
XFILLER_126_49 VPWR VGND sg13cmos5l_decap_8
XFILLER_704_35 VPWR VGND sg13cmos5l_decap_8
XFILLER_649_170 VPWR VGND sg13cmos5l_decap_8
X_4317_ _4317_/X _4241_/X _4357_/X _4356_/X _4240_/X _1945_/Q _1944_/Q VPWR VGND sg13cmos5l_mux4_1
XFILLER_510_169 VPWR VGND sg13cmos5l_decap_4
XFILLER_273_77 VPWR VGND sg13cmos5l_decap_8
X_1529_ _1529_/Q Tile_X0Y2_FrameData[24] VGND VPWR Tile_X0Y9_FrameStrobe[3] latch
XFILLER_423_14 VPWR VGND sg13cmos5l_decap_8
XFILLER_59_226 VPWR VGND sg13cmos5l_fill_2
XANTENNA__3234__X Tile_X0Y0_FrameData_O[2] VPWR VGND sg13cmos5l_antennanp
XFILLER_570_42 VPWR VGND sg13cmos5l_decap_8
XFILLER_19_14 VPWR VGND sg13cmos5l_decap_8
X_4248_ _4248_/X Tile_X0Y2_W1END[2] Tile_X0Y2_W2MID[1] Tile_X0Y2_W2END[1] _4098_/X
+ _1617_/Q _1616_/Q VPWR VGND sg13cmos5l_mux4_1
XFILLER_27_101 VPWR VGND sg13cmos5l_fill_2
X_4179_ _4179_/X Tile_X0Y3_WW4END[0] AXI_M_SOC_WREADY _4222_/X _4205_/X _1783_/Q _1782_/Q
+ VPWR VGND sg13cmos5l_mux4_1
XFILLER_503_91 VPWR VGND sg13cmos5l_decap_8
XFILLER_27_145 VPWR VGND sg13cmos5l_fill_2
XFILLER_222_70 VPWR VGND sg13cmos5l_decap_8
XFILLER_35_35 VPWR VGND sg13cmos5l_decap_8
XFILLER_42_115 VPWR VGND sg13cmos5l_fill_1
XFILLER_431_154 VPWR VGND sg13cmos5l_decap_8
XFILLER_255_7 VPWR VGND sg13cmos5l_decap_8
XFILLER_579_84 VPWR VGND sg13cmos5l_decap_8
XFILLER_577_147 VPWR VGND sg13cmos5l_decap_8
XFILLER_298_63 VPWR VGND sg13cmos5l_decap_8
XFILLER_329_103 VPWR VGND sg13cmos5l_decap_8
XFILLER_592_128 VPWR VGND sg13cmos5l_fill_2
XFILLER_422_7 VPWR VGND sg13cmos5l_decap_8
XFILLER_195_142 VPWR VGND sg13cmos5l_decap_8
XFILLER_51_34 VPWR VGND sg13cmos5l_decap_8
XANTENNA__3409__X Tile_X0Y4_FrameData_O[0] VPWR VGND sg13cmos5l_antennanp
XFILLER_51_89 VPWR VGND sg13cmos5l_decap_8
XFILLER_167_56 VPWR VGND sg13cmos5l_decap_8
XFILLER_464_21 VPWR VGND sg13cmos5l_decap_8
XFILLER_167_89 VPWR VGND sg13cmos5l_decap_8
XFILLER_352_161 VPWR VGND sg13cmos5l_decap_8
XFILLER_498_154 VPWR VGND sg13cmos5l_decap_8
XFILLER_614_35 VPWR VGND sg13cmos5l_decap_8
XFILLER_501_147 VPWR VGND sg13cmos5l_decap_8
XFILLER_183_77 VPWR VGND sg13cmos5l_decap_8
XFILLER_183_88 VPWR VGND sg13cmos5l_fill_1
XFILLER_104_161 VPWR VGND sg13cmos5l_decap_8
XFILLER_333_14 VPWR VGND sg13cmos5l_decap_8
XANTENNA__3144__X Tile_X0Y7_FrameData_O[14] VPWR VGND sg13cmos5l_antennanp
XFILLER_655_140 VPWR VGND sg13cmos5l_decap_8
XFILLER_480_42 VPWR VGND sg13cmos5l_decap_8
XFILLER_76_42 VPWR VGND sg13cmos5l_decap_8
XFILLER_265_135 VPWR VGND sg13cmos5l_decap_8
XFILLER_281_0 VPWR VGND sg13cmos5l_decap_8
XANTENNA__2983__X Tile_X0Y8_FrameData_O[23] VPWR VGND sg13cmos5l_antennanp
XFILLER_670_132 VPWR VGND sg13cmos5l_fill_1
XFILLER_379_0 VPWR VGND sg13cmos5l_decap_8
XFILLER_280_105 VPWR VGND sg13cmos5l_decap_8
XFILLER_265_179 VPWR VGND sg13cmos5l_fill_2
XFILLER_630_56 VPWR VGND sg13cmos5l_decap_8
XFILLER_413_91 VPWR VGND sg13cmos5l_decap_8
XFILLER_132_70 VPWR VGND sg13cmos5l_decap_8
XFILLER_546_0 VPWR VGND sg13cmos5l_decap_8
XFILLER_92_63 VPWR VGND sg13cmos5l_decap_4
XFILLER_489_84 VPWR VGND sg13cmos5l_decap_8
XFILLER_422_154 VPWR VGND sg13cmos5l_decap_8
XFILLER_568_147 VPWR VGND sg13cmos5l_decap_8
XFILLER_639_21 VPWR VGND sg13cmos5l_decap_8
XFILLER_713_0 VPWR VGND sg13cmos5l_decap_8
X_0900_ _0900_/Q Tile_X0Y9_FrameData[27] VGND VPWR Tile_X0Y9_FrameStrobe[7] latch
X_1880_ _1880_/Q Tile_X0Y3_FrameData[17] VGND VPWR Tile_X0Y9_FrameStrobe[6] latch
XFILLER_639_98 VPWR VGND sg13cmos5l_decap_8
XFILLER_41_192 VPWR VGND sg13cmos5l_decap_8
XFILLER_119_209 VPWR VGND sg13cmos5l_decap_4
X_0831_ _0831_/Q Tile_X0Y9_FrameData[0] VGND VPWR Tile_X0Y9_FrameStrobe[4] latch
XFILLER_390_201 VPWR VGND sg13cmos5l_decap_8
XFILLER_358_77 VPWR VGND sg13cmos5l_decap_8
XFILLER_508_14 VPWR VGND sg13cmos5l_decap_8
XFILLER_524_217 VPWR VGND sg13cmos5l_fill_2
XANTENNA__3319__X Tile_X0Y4_EE4BEG[7] VPWR VGND sg13cmos5l_antennanp
XFILLER_524_228 VPWR VGND sg13cmos5l_fill_1
XFILLER_655_42 VPWR VGND sg13cmos5l_decap_8
X_3550_ Tile_X0Y9_E6BEG[8] _4888_/X VPWR VGND sg13cmos5l_buf_1
X_0762_ _0762_/Q Tile_X0Y9_FrameData[5] VGND VPWR Tile_X0Y9_FrameStrobe[2] latch
XFILLER_374_21 VPWR VGND sg13cmos5l_decap_8
XFILLER_678_221 VPWR VGND sg13cmos5l_decap_8
X_2501_ _2501_/Q Tile_X0Y6_FrameData[2] VGND VPWR Tile_X0Y9_FrameStrobe[1] latch
X_3481_ Tile_X0Y1_EE4BEG[7] _3955_/X VPWR VGND sg13cmos5l_buf_1
XFILLER_343_161 VPWR VGND sg13cmos5l_fill_1
X_0693_ _0693_/Q Tile_X0Y9_FrameData[10] VGND VPWR Tile_X0Y9_FrameStrobe[0] latch
XFILLER_489_154 VPWR VGND sg13cmos5l_decap_8
XFILLER_288_205 VPWR VGND sg13cmos5l_fill_1
XFILLER_343_183 VPWR VGND sg13cmos5l_decap_8
XFILLER_343_194 VPWR VGND sg13cmos5l_fill_1
X_2432_ _2432_/Q Tile_X0Y5_FrameData[5] VGND VPWR Tile_X0Y9_FrameStrobe[7] latch
XFILLER_524_35 VPWR VGND sg13cmos5l_decap_8
XFILLER_307_70 VPWR VGND sg13cmos5l_decap_8
XFILLER_671_63 VPWR VGND sg13cmos5l_decap_8
X_2363_ _2363_/Q Tile_X0Y5_FrameData[10] VGND VPWR Tile_X0Y9_FrameStrobe[5] latch
XFILLER_243_14 VPWR VGND sg13cmos5l_decap_8
XANTENNA__3054__X Tile_X0Y5_FrameData_O[13] VPWR VGND sg13cmos5l_antennanp
XFILLER_646_140 VPWR VGND sg13cmos5l_decap_8
X_4102_ _4102_/X _4029_/X _4137_/X _4136_/X _4028_/X _1441_/Q _1440_/Q VPWR VGND sg13cmos5l_mux4_1
XFILLER_390_42 VPWR VGND sg13cmos5l_decap_8
X_1314_ _1314_/Q Tile_X0Y1_FrameData[23] VGND VPWR Tile_X0Y9_FrameStrobe[4] latch
X_2294_ _2294_/Q Tile_X0Y5_FrameData[15] VGND VPWR Tile_X0Y9_FrameStrobe[3] latch
XFILLER_110_142 VPWR VGND sg13cmos5l_decap_8
XFILLER_390_86 VPWR VGND sg13cmos5l_decap_8
XANTENNA__2893__X Tile_X0Y6_FrameData_O[14] VPWR VGND sg13cmos5l_antennanp
X_4033_ _4033_/X Tile_X0Y3_W2MID[1] Tile_X0Y3_W2END[1] Tile_X0Y3_W6END[1] _4206_/X
+ _1905_/Q _1904_/Q VPWR VGND sg13cmos5l_mux4_1
XFILLER_256_157 VPWR VGND sg13cmos5l_decap_8
X_1245_ _1245_/Q Tile_X0Y1_FrameData[28] VGND VPWR Tile_X0Y9_FrameStrobe[2] latch
XFILLER_256_179 VPWR VGND sg13cmos5l_decap_8
XFILLER_540_56 VPWR VGND sg13cmos5l_decap_8
XFILLER_661_176 VPWR VGND sg13cmos5l_fill_1
X_1176_ _1176_/Q Tile_X0Y0_FrameData[19] VGND VPWR Tile_X0Y9_FrameStrobe[7] latch
X_0127_ AXI_M_SOC_WLAST _4940_/X _0934_/Q VPWR VGND sg13cmos5l_or2_1
XFILLER_559_147 VPWR VGND sg13cmos5l_decap_4
XFILLER_413_165 VPWR VGND sg13cmos5l_decap_8
XFILLER_399_84 VPWR VGND sg13cmos5l_decap_4
XFILLER_549_21 VPWR VGND sg13cmos5l_decap_8
XFILLER_413_176 VPWR VGND sg13cmos5l_fill_2
XFILLER_24_159 VPWR VGND sg13cmos5l_fill_1
X_0058_ _3179_/A _3920_/X _3921_/X _1890_/Q VPWR VGND sg13cmos5l_mux2_1
X_4935_ _4935_/X Tile_X0Y8_W2MID[4] Tile_X0Y8_W2END[4] Tile_X0Y8_W6END[11] _4791_/X
+ _0621_/Q _0620_/Q VPWR VGND sg13cmos5l_mux4_1
XFILLER_177_120 VPWR VGND sg13cmos5l_decap_8
XFILLER_268_33 VPWR VGND sg13cmos5l_decap_8
XANTENNA_11 Tile_X0Y0_S2MID[1] VPWR VGND sg13cmos5l_antennanp
XANTENNA_22 _4701_/X VPWR VGND sg13cmos5l_antennanp
X_4866_ _4866_/X Tile_X0Y9_WW4END[13] AXI_M_SOC_RDATA2 _4929_/X _4904_/X _0811_/Q
+ _0810_/Q VPWR VGND sg13cmos5l_mux4_1
XANTENNA_33 Tile_X0Y9_FrameStrobe[15] VPWR VGND sg13cmos5l_antennanp
XANTENNA_44 Tile_X0Y9_N2MID[1] VPWR VGND sg13cmos5l_antennanp
XFILLER_716_155 VPWR VGND sg13cmos5l_decap_8
XANTENNA_55 Tile_X0Y9_N2MID[6] VPWR VGND sg13cmos5l_antennanp
X_3817_ _3817_/X Tile_X0Y0_W2END[2] Tile_X0Y0_W6END[0] _3857_/X _3856_/X _1071_/Q
+ _1070_/Q VPWR VGND sg13cmos5l_mux4_1
XFILLER_418_14 VPWR VGND sg13cmos5l_decap_8
X_4797_ _4797_/X _4342_/X _4346_/X _4350_/X _4314_/X _2115_/Q _2114_/Q VPWR VGND sg13cmos5l_mux4_1
XANTENNA__3229__X Tile_X0Y0_FrameStrobe_O[17] VPWR VGND sg13cmos5l_antennanp
XFILLER_565_42 VPWR VGND sg13cmos5l_decap_8
XFILLER_192_145 VPWR VGND sg13cmos5l_decap_8
X_3748_ AXI_M_SOC_ARADDR20 Tile_X0Y8_WW4END[4] Tile_X0Y8_WW4END[12] Tile_X0Y8_W6END[4]
+ _4804_/X _0495_/Q _0494_/Q VPWR VGND sg13cmos5l_mux4_1
XFILLER_192_156 VPWR VGND sg13cmos5l_fill_1
XFILLER_284_21 VPWR VGND sg13cmos5l_decap_8
XFILLER_133_201 VPWR VGND sg13cmos5l_decap_8
X_3679_ _3679_/X Tile_X0Y2_WW4END[1] Tile_X0Y2_WW4END[9] Tile_X0Y2_W6END[9] _4125_/X
+ _1487_/Q _1486_/Q VPWR VGND sg13cmos5l_mux4_1
XFILLER_133_212 VPWR VGND sg13cmos5l_fill_1
XFILLER_715_56 VPWR VGND sg13cmos5l_fill_1
XFILLER_629_107 VPWR VGND sg13cmos5l_fill_1
XFILLER_284_98 VPWR VGND sg13cmos5l_decap_8
XFILLER_629_129 VPWR VGND sg13cmos5l_fill_2
XFILLER_434_35 VPWR VGND sg13cmos5l_decap_8
XFILLER_217_70 VPWR VGND sg13cmos5l_decap_8
XFILLER_581_63 VPWR VGND sg13cmos5l_decap_8
XFILLER_294_208 VPWR VGND sg13cmos5l_decap_8
XFILLER_153_14 VPWR VGND sg13cmos5l_decap_8
XFILLER_495_168 VPWR VGND sg13cmos5l_decap_8
XFILLER_637_140 VPWR VGND sg13cmos5l_decap_8
XFILLER_637_162 VPWR VGND sg13cmos5l_decap_4
XFILLER_436_202 VPWR VGND sg13cmos5l_decap_8
XFILLER_101_153 VPWR VGND sg13cmos5l_fill_2
XFILLER_372_7 VPWR VGND sg13cmos5l_decap_8
XFILLER_303_28 VPWR VGND sg13cmos5l_decap_8
XFILLER_652_154 VPWR VGND sg13cmos5l_decap_8
XFILLER_46_34 VPWR VGND sg13cmos5l_decap_8
XFILLER_450_56 VPWR VGND sg13cmos5l_decap_8
XFILLER_262_116 VPWR VGND sg13cmos5l_decap_8
XFILLER_233_91 VPWR VGND sg13cmos5l_decap_4
XFILLER_597_209 VPWR VGND sg13cmos5l_decap_4
XFILLER_70_210 VPWR VGND sg13cmos5l_decap_8
XFILLER_637_7 VPWR VGND sg13cmos5l_decap_8
XFILLER_404_154 VPWR VGND sg13cmos5l_fill_2
XFILLER_459_21 VPWR VGND sg13cmos5l_decap_8
XFILLER_203_216 VPWR VGND sg13cmos5l_fill_2
XFILLER_270_171 VPWR VGND sg13cmos5l_fill_1
XFILLER_270_182 VPWR VGND sg13cmos5l_decap_4
XFILLER_102_84 VPWR VGND sg13cmos5l_decap_8
XFILLER_62_44 VPWR VGND sg13cmos5l_decap_8
XFILLER_30_129 VPWR VGND sg13cmos5l_fill_2
XFILLER_707_133 VPWR VGND sg13cmos5l_decap_8
XFILLER_609_35 VPWR VGND sg13cmos5l_decap_8
XFILLER_168_164 VPWR VGND sg13cmos5l_decap_8
XFILLER_506_206 VPWR VGND sg13cmos5l_decap_8
XFILLER_7_28 VPWR VGND sg13cmos5l_decap_8
XFILLER_573_161 VPWR VGND sg13cmos5l_decap_8
XFILLER_328_14 VPWR VGND sg13cmos5l_decap_8
XANTENNA__3139__X Tile_X0Y7_FrameData_O[9] VPWR VGND sg13cmos5l_antennanp
XFILLER_127_0 VPWR VGND sg13cmos5l_decap_8
XFILLER_475_42 VPWR VGND sg13cmos5l_decap_8
XFILLER_194_21 VPWR VGND sg13cmos5l_decap_8
XFILLER_475_86 VPWR VGND sg13cmos5l_decap_8
XANTENNA__2978__X Tile_X0Y8_FrameData_O[18] VPWR VGND sg13cmos5l_antennanp
XFILLER_625_56 VPWR VGND sg13cmos5l_decap_8
XFILLER_408_91 VPWR VGND sg13cmos5l_decap_8
XFILLER_11_70 VPWR VGND sg13cmos5l_decap_8
XFILLER_344_35 VPWR VGND sg13cmos5l_decap_8
XFILLER_127_70 VPWR VGND sg13cmos5l_fill_1
XFILLER_496_0 VPWR VGND sg13cmos5l_decap_8
XFILLER_491_63 VPWR VGND sg13cmos5l_decap_8
XFILLER_87_63 VPWR VGND sg13cmos5l_decap_8
XFILLER_628_140 VPWR VGND sg13cmos5l_fill_1
XFILLER_238_135 VPWR VGND sg13cmos5l_decap_8
XFILLER_663_0 VPWR VGND sg13cmos5l_decap_8
XFILLER_238_146 VPWR VGND sg13cmos5l_fill_1
XFILLER_641_77 VPWR VGND sg13cmos5l_decap_8
XFILLER_213_28 VPWR VGND sg13cmos5l_decap_8
XFILLER_238_168 VPWR VGND sg13cmos5l_fill_1
XFILLER_16_7 VPWR VGND sg13cmos5l_decap_8
XFILLER_643_154 VPWR VGND sg13cmos5l_decap_8
XFILLER_360_56 VPWR VGND sg13cmos5l_decap_8
XANTENNA__3602__X Tile_X0Y9_S1BEG[0] VPWR VGND sg13cmos5l_antennanp
XFILLER_399_109 VPWR VGND sg13cmos5l_decap_8
XFILLER_143_91 VPWR VGND sg13cmos5l_decap_8
X_1030_ _1030_/Q Tile_X0Y0_FrameData[5] VGND VPWR Tile_X0Y9_FrameStrobe[2] latch
XFILLER_61_221 VPWR VGND sg13cmos5l_fill_1
XFILLER_369_21 VPWR VGND sg13cmos5l_decap_8
XFILLER_261_182 VPWR VGND sg13cmos5l_decap_4
X_2981_ Tile_X0Y8_FrameData_O[21] Tile_X0Y8_FrameData[21] VPWR VGND sg13cmos5l_buf_1
XFILLER_21_118 VPWR VGND sg13cmos5l_decap_4
X_1932_ _1932_/Q Tile_X0Y4_FrameData[25] VGND VPWR Tile_X0Y9_FrameStrobe[0] latch
X_4720_ _4720_/X Tile_X0Y8_W1END[2] Tile_X0Y8_WW4END[14] Tile_X0Y8_W6END[6] _4802_/X
+ _0605_/Q _0604_/Q VPWR VGND sg13cmos5l_mux4_1
XFILLER_369_98 VPWR VGND sg13cmos5l_decap_8
XFILLER_14_181 VPWR VGND sg13cmos5l_fill_1
XFILLER_519_35 VPWR VGND sg13cmos5l_decap_8
X_4651_ _4651_/X AXI_M_SOC_RDATA19 _4688_/X _4692_/X _4675_/X _0257_/Q _0256_/Q VPWR
+ VGND sg13cmos5l_mux4_1
XFILLER_666_63 VPWR VGND sg13cmos5l_decap_8
X_1863_ _1863_/Q Tile_X0Y3_FrameData[2] VGND VPWR Tile_X0Y9_FrameStrobe[5] latch
XFILLER_238_14 VPWR VGND sg13cmos5l_decap_8
XFILLER_174_112 VPWR VGND sg13cmos5l_decap_8
XANTENNA__3049__X Tile_X0Y5_FrameData_O[8] VPWR VGND sg13cmos5l_antennanp
X_3602_ Tile_X0Y9_S1BEG[0] _4824_/X VPWR VGND sg13cmos5l_buf_1
XFILLER_385_42 VPWR VGND sg13cmos5l_decap_8
X_0814_ _0814_/Q Tile_X0Y9_FrameData[17] VGND VPWR Tile_X0Y9_FrameStrobe[4] latch
X_4582_ _4582_/X _4549_/X Tile_X0Y9_N4END[14] _4548_/X _0155_/X _2467_/Q _2466_/Q
+ VPWR VGND sg13cmos5l_mux4_1
XFILLER_713_147 VPWR VGND sg13cmos5l_decap_8
X_1794_ _1794_/Q Tile_X0Y3_FrameData[7] VGND VPWR Tile_X0Y9_FrameStrobe[3] latch
X_3533_ Tile_X0Y9_E2BEG[7] _4855_/X VPWR VGND sg13cmos5l_buf_1
XANTENNA__2888__X Tile_X0Y6_FrameData_O[9] VPWR VGND sg13cmos5l_antennanp
X_0745_ _0745_/Q Tile_X0Y9_FrameData[22] VGND VPWR Tile_X0Y9_FrameStrobe[2] latch
XFILLER_316_172 VPWR VGND sg13cmos5l_decap_8
XFILLER_535_56 VPWR VGND sg13cmos5l_decap_8
XFILLER_666_202 VPWR VGND sg13cmos5l_decap_4
X_3464_ Tile_X0Y1_FrameData_O[22] Tile_X0Y1_FrameData[22] VPWR VGND sg13cmos5l_buf_1
X_0676_ _0676_/Q Tile_X0Y9_FrameData[27] VGND VPWR Tile_X0Y9_FrameStrobe[0] latch
XFILLER_682_84 VPWR VGND sg13cmos5l_decap_8
XFILLER_42_0 VPWR VGND sg13cmos5l_decap_8
XFILLER_331_142 VPWR VGND sg13cmos5l_decap_8
XFILLER_254_35 VPWR VGND sg13cmos5l_decap_8
XFILLER_88_118 VPWR VGND sg13cmos5l_decap_8
X_2415_ _2415_/Q Tile_X0Y5_FrameData[22] VGND VPWR Tile_X0Y9_FrameStrobe[7] latch
X_3395_ Tile_X0Y2_E2BEGb[6] _4054_/X VPWR VGND sg13cmos5l_buf_1
XFILLER_619_140 VPWR VGND sg13cmos5l_fill_2
XFILLER_492_105 VPWR VGND sg13cmos5l_decap_8
XFILLER_331_197 VPWR VGND sg13cmos5l_decap_8
XFILLER_229_113 VPWR VGND sg13cmos5l_decap_4
X_2346_ _2346_/Q Tile_X0Y5_FrameData[27] VGND VPWR Tile_X0Y9_FrameStrobe[5] latch
XFILLER_404_49 VPWR VGND sg13cmos5l_decap_8
XFILLER_551_77 VPWR VGND sg13cmos5l_decap_8
XFILLER_701_14 VPWR VGND sg13cmos5l_decap_8
XFILLER_123_28 VPWR VGND sg13cmos5l_decap_8
X_2277_ _2277_/Q Tile_X0Y5_FrameData[0] VGND VPWR Tile_X0Y9_FrameStrobe[2] latch
XANTENNA__3512__X Tile_X0Y1_E2BEG[2] VPWR VGND sg13cmos5l_antennanp
XFILLER_270_56 VPWR VGND sg13cmos5l_decap_8
X_4016_ _4016_/X _3981_/X _0073_/X _3980_/X Tile_X0Y0_S4END[4] _1217_/Q _1216_/Q VPWR
+ VGND sg13cmos5l_mux4_1
X_1228_ _1228_/Q Tile_X0Y1_FrameData[13] VGND VPWR Tile_X0Y9_FrameStrobe[1] latch
X_1159_ _1159_/Q Tile_X0Y0_FrameData[4] VGND VPWR Tile_X0Y9_FrameStrobe[6] latch
XFILLER_398_153 VPWR VGND sg13cmos5l_fill_1
XFILLER_279_21 VPWR VGND sg13cmos5l_decap_8
XFILLER_547_117 VPWR VGND sg13cmos5l_fill_1
XFILLER_500_70 VPWR VGND sg13cmos5l_decap_8
XFILLER_401_157 VPWR VGND sg13cmos5l_fill_1
X_4918_ _4918_/X Tile_X0Y9_N1END[2] Tile_X0Y9_N4END[2] _4898_/X _0081_/X _0723_/Q
+ _0722_/Q VPWR VGND sg13cmos5l_mux4_1
XFILLER_279_98 VPWR VGND sg13cmos5l_decap_8
XFILLER_429_35 VPWR VGND sg13cmos5l_decap_8
XFILLER_576_63 VPWR VGND sg13cmos5l_decap_8
XFILLER_555_161 VPWR VGND sg13cmos5l_decap_8
XFILLER_148_14 VPWR VGND sg13cmos5l_decap_8
X_4849_ _4849_/X Tile_X0Y9_W2MID[6] AXI_M_SOC_RDATA1 _4903_/X _4902_/X _0845_/Q _0844_/Q
+ VPWR VGND sg13cmos5l_mux4_1
XFILLER_295_42 VPWR VGND sg13cmos5l_decap_8
XFILLER_120_7 VPWR VGND sg13cmos5l_decap_8
XFILLER_218_7 VPWR VGND sg13cmos5l_decap_8
XFILLER_704_158 VPWR VGND sg13cmos5l_fill_1
XFILLER_180_115 VPWR VGND sg13cmos5l_decap_8
XANTENNA__2798__X Tile_X0Y3_E6BEG[8] VPWR VGND sg13cmos5l_antennanp
XFILLER_570_175 VPWR VGND sg13cmos5l_decap_8
XFILLER_445_56 VPWR VGND sg13cmos5l_decap_8
XFILLER_592_84 VPWR VGND sg13cmos5l_decap_8
XFILLER_164_35 VPWR VGND sg13cmos5l_decap_8
XFILLER_468_168 VPWR VGND sg13cmos5l_decap_4
XFILLER_587_7 VPWR VGND sg13cmos5l_decap_8
XFILLER_483_105 VPWR VGND sg13cmos5l_decap_8
XFILLER_314_49 VPWR VGND sg13cmos5l_decap_8
XFILLER_87_173 VPWR VGND sg13cmos5l_fill_2
XFILLER_611_14 VPWR VGND sg13cmos5l_decap_8
XFILLER_57_77 VPWR VGND sg13cmos5l_decap_8
XANTENNA__3422__X Tile_X0Y4_FrameData_O[13] VPWR VGND sg13cmos5l_antennanp
XFILLER_235_116 VPWR VGND sg13cmos5l_decap_8
XFILLER_180_56 VPWR VGND sg13cmos5l_decap_8
XFILLER_424_227 VPWR VGND sg13cmos5l_fill_2
XFILLER_491_193 VPWR VGND sg13cmos5l_fill_1
XFILLER_73_21 VPWR VGND sg13cmos5l_decap_8
XFILLER_640_168 VPWR VGND sg13cmos5l_decap_8
XFILLER_250_119 VPWR VGND sg13cmos5l_decap_8
XFILLER_243_160 VPWR VGND sg13cmos5l_decap_8
XFILLER_189_21 VPWR VGND sg13cmos5l_decap_8
XFILLER_410_70 VPWR VGND sg13cmos5l_fill_2
XFILLER_73_98 VPWR VGND sg13cmos5l_decap_8
XFILLER_244_0 VPWR VGND sg13cmos5l_decap_8
XFILLER_339_35 VPWR VGND sg13cmos5l_decap_8
XFILLER_486_63 VPWR VGND sg13cmos5l_decap_8
XFILLER_411_0 VPWR VGND sg13cmos5l_decap_8
XFILLER_509_0 VPWR VGND sg13cmos5l_decap_8
XFILLER_7_166 VPWR VGND sg13cmos5l_fill_1
XFILLER_305_109 VPWR VGND sg13cmos5l_decap_8
XFILLER_636_77 VPWR VGND sg13cmos5l_decap_8
XFILLER_22_91 VPWR VGND sg13cmos5l_fill_1
XFILLER_208_28 VPWR VGND sg13cmos5l_decap_8
XFILLER_355_56 VPWR VGND sg13cmos5l_decap_8
XFILLER_138_91 VPWR VGND sg13cmos5l_decap_8
X_0530_ _0530_/Q Tile_X0Y8_FrameData[13] VGND VPWR Tile_X0Y9_FrameStrobe[3] latch
XFILLER_459_113 VPWR VGND sg13cmos5l_fill_2
XFILLER_703_191 VPWR VGND sg13cmos5l_fill_1
XFILLER_652_21 VPWR VGND sg13cmos5l_decap_8
XFILLER_112_215 VPWR VGND sg13cmos5l_decap_4
X_0461_ _0461_/Q Tile_X0Y8_FrameData[18] VGND VPWR Tile_X0Y9_FrameStrobe[1] latch
XFILLER_663_205 VPWR VGND sg13cmos5l_fill_1
X_2200_ _2200_/Q Tile_X0Y5_FrameData[13] VGND VPWR Tile_X0Y9_FrameStrobe[0] latch
X_3180_ Tile_X0Y0_N4BEG[4] _3180_/A VPWR VGND sg13cmos5l_buf_1
XFILLER_652_98 VPWR VGND sg13cmos5l_decap_8
X_0392_ _0392_/Q Tile_X0Y7_FrameData[23] VGND VPWR Tile_X0Y9_FrameStrobe[7] latch
XFILLER_224_49 VPWR VGND sg13cmos5l_decap_8
X_2131_ _2131_/Q Tile_X0Y4_FrameData[18] VGND VPWR Tile_X0Y9_FrameStrobe[6] latch
XFILLER_371_77 VPWR VGND sg13cmos5l_decap_8
XFILLER_521_14 VPWR VGND sg13cmos5l_decap_8
XANTENNA__3332__X Tile_X0Y2_FrameData_O[3] VPWR VGND sg13cmos5l_antennanp
X_2062_ _2062_/Q Tile_X0Y4_FrameData[23] VGND VPWR Tile_X0Y9_FrameStrobe[4] latch
X_1013_ _1013_/Q Tile_X0Y0_FrameData[22] VGND VPWR Tile_X0Y9_FrameStrobe[2] latch
XFILLER_430_219 VPWR VGND sg13cmos5l_decap_8
XFILLER_320_92 VPWR VGND sg13cmos5l_decap_4
X_2964_ Tile_X0Y8_FrameData_O[4] Tile_X0Y8_FrameData[4] VPWR VGND sg13cmos5l_buf_1
XFILLER_677_84 VPWR VGND sg13cmos5l_decap_8
XFILLER_249_35 VPWR VGND sg13cmos5l_decap_8
X_1915_ _1915_/Q Tile_X0Y3_FrameData[14] VGND VPWR Tile_X0Y9_FrameStrobe[7] latch
X_4703_ _4703_/X Tile_X0Y9_W2MID[6] Tile_X0Y9_W2END[6] Tile_X0Y9_W6END[6] _4903_/X
+ _0917_/Q _0916_/Q VPWR VGND sg13cmos5l_mux4_1
XFILLER_396_63 VPWR VGND sg13cmos5l_decap_8
XFILLER_336_212 VPWR VGND sg13cmos5l_decap_4
X_2895_ Tile_X0Y6_FrameData_O[16] Tile_X0Y6_FrameData[16] VPWR VGND sg13cmos5l_buf_1
X_1846_ _1846_/Q Tile_X0Y3_FrameData[19] VGND VPWR Tile_X0Y9_FrameStrobe[5] latch
X_4634_ _4634_/X Tile_X0Y7_WW4END[9] AXI_M_SOC_RDATA22 _4693_/X _4671_/X _0291_/Q
+ _0290_/Q VPWR VGND sg13cmos5l_mux4_1
XFILLER_147_167 VPWR VGND sg13cmos5l_decap_8
XFILLER_162_104 VPWR VGND sg13cmos5l_fill_1
XFILLER_546_77 VPWR VGND sg13cmos5l_decap_8
X_4565_ _4565_/X _4122_/X _4126_/X _4107_/X _4098_/X _1607_/Q _1606_/Q VPWR VGND sg13cmos5l_mux4_1
XFILLER_118_28 VPWR VGND sg13cmos5l_decap_8
X_1777_ _1777_/Q Tile_X0Y3_FrameData[24] VGND VPWR Tile_X0Y9_FrameStrobe[3] latch
XFILLER_698_168 VPWR VGND sg13cmos5l_decap_4
XANTENNA__3507__X Tile_X0Y1_E2BEGb[5] VPWR VGND sg13cmos5l_antennanp
XFILLER_265_56 VPWR VGND sg13cmos5l_decap_8
X_0728_ _0728_/Q Tile_X0Y9_FrameData[7] VGND VPWR Tile_X0Y9_FrameStrobe[1] latch
X_3516_ Tile_X0Y1_E2BEG[6] _3938_/X VPWR VGND sg13cmos5l_buf_1
X_4496_ _4496_/X Tile_X0Y6_W2MID[7] AXI_M_SOC_RDATA24 _4553_/X _4552_/X _2615_/Q _2614_/Q
+ VPWR VGND sg13cmos5l_mux4_1
XFILLER_562_21 VPWR VGND sg13cmos5l_decap_8
X_3447_ Tile_X0Y1_FrameData_O[5] Tile_X0Y1_FrameData[5] VPWR VGND sg13cmos5l_buf_1
X_0659_ _0659_/Q Tile_X0Y8_FrameData[12] VGND VPWR Tile_X0Y9_FrameStrobe[7] latch
XFILLER_654_216 VPWR VGND sg13cmos5l_fill_2
XFILLER_69_140 VPWR VGND sg13cmos5l_decap_8
X_3378_ Tile_X0Y2_E6BEG[1] _4073_/X VPWR VGND sg13cmos5l_buf_1
XFILLER_562_98 VPWR VGND sg13cmos5l_decap_8
XFILLER_134_49 VPWR VGND sg13cmos5l_decap_8
XFILLER_712_35 VPWR VGND sg13cmos5l_decap_8
XFILLER_281_77 VPWR VGND sg13cmos5l_decap_8
X_2329_ _2329_/Q Tile_X0Y5_FrameData[12] VGND VPWR Tile_X0Y9_FrameStrobe[4] latch
XFILLER_431_14 VPWR VGND sg13cmos5l_decap_8
XANTENNA__3242__X Tile_X0Y0_FrameData_O[10] VPWR VGND sg13cmos5l_antennanp
XFILLER_27_14 VPWR VGND sg13cmos5l_decap_8
XFILLER_473_171 VPWR VGND sg13cmos5l_decap_8
XFILLER_217_138 VPWR VGND sg13cmos5l_decap_4
XFILLER_622_146 VPWR VGND sg13cmos5l_fill_2
XFILLER_84_198 VPWR VGND sg13cmos5l_decap_8
XFILLER_168_7 VPWR VGND sg13cmos5l_decap_8
XFILLER_511_91 VPWR VGND sg13cmos5l_decap_8
XFILLER_230_70 VPWR VGND sg13cmos5l_decap_8
XFILLER_709_228 VPWR VGND sg13cmos5l_fill_1
XFILLER_43_35 VPWR VGND sg13cmos5l_decap_8
XFILLER_335_7 VPWR VGND sg13cmos5l_decap_8
XFILLER_587_84 VPWR VGND sg13cmos5l_decap_8
XFILLER_159_35 VPWR VGND sg13cmos5l_decap_8
XFILLER_138_112 VPWR VGND sg13cmos5l_decap_8
XFILLER_689_102 VPWR VGND sg13cmos5l_decap_8
XFILLER_502_7 VPWR VGND sg13cmos5l_decap_8
XFILLER_309_49 VPWR VGND sg13cmos5l_decap_8
XFILLER_543_153 VPWR VGND sg13cmos5l_decap_8
XFILLER_138_189 VPWR VGND sg13cmos5l_decap_8
XFILLER_606_14 VPWR VGND sg13cmos5l_decap_8
XFILLER_175_56 VPWR VGND sg13cmos5l_decap_8
XANTENNA__3417__X Tile_X0Y4_FrameData_O[8] VPWR VGND sg13cmos5l_antennanp
XFILLER_472_21 VPWR VGND sg13cmos5l_decap_8
XFILLER_68_21 VPWR VGND sg13cmos5l_decap_8
XFILLER_700_172 VPWR VGND sg13cmos5l_fill_2
XFILLER_622_35 VPWR VGND sg13cmos5l_decap_8
XFILLER_405_70 VPWR VGND sg13cmos5l_decap_8
XFILLER_194_0 VPWR VGND sg13cmos5l_decap_8
XFILLER_341_14 VPWR VGND sg13cmos5l_decap_8
XANTENNA__3152__X Tile_X0Y7_FrameData_O[22] VPWR VGND sg13cmos5l_antennanp
XFILLER_471_119 VPWR VGND sg13cmos5l_decap_4
XFILLER_208_105 VPWR VGND sg13cmos5l_decap_8
XFILLER_75_154 VPWR VGND sg13cmos5l_fill_1
XFILLER_124_82 VPWR VGND sg13cmos5l_decap_8
XFILLER_84_42 VPWR VGND sg13cmos5l_decap_8
XFILLER_698_28 VPWR VGND sg13cmos5l_decap_8
XFILLER_361_0 VPWR VGND sg13cmos5l_decap_8
XANTENNA__2991__X Tile_X0Y8_FrameData_O[31] VPWR VGND sg13cmos5l_antennanp
XFILLER_459_0 VPWR VGND sg13cmos5l_decap_8
XFILLER_421_91 VPWR VGND sg13cmos5l_decap_8
XFILLER_17_91 VPWR VGND sg13cmos5l_fill_1
XFILLER_140_70 VPWR VGND sg13cmos5l_decap_8
XFILLER_626_0 VPWR VGND sg13cmos5l_decap_8
XFILLER_621_190 VPWR VGND sg13cmos5l_fill_1
XFILLER_31_224 VPWR VGND sg13cmos5l_decap_4
XFILLER_497_84 VPWR VGND sg13cmos5l_decap_8
XFILLER_647_21 VPWR VGND sg13cmos5l_decap_8
XFILLER_581_204 VPWR VGND sg13cmos5l_fill_2
XFILLER_83_7 VPWR VGND sg13cmos5l_decap_8
X_1700_ _1700_/Q Tile_X0Y3_FrameData[5] VGND VPWR Tile_X0Y9_FrameStrobe[0] latch
X_2680_ _2680_/Q Tile_X0Y6_FrameData[15] VGND VPWR Tile_X0Y9_FrameStrobe[7] latch
XFILLER_647_98 VPWR VGND sg13cmos5l_decap_8
XFILLER_534_142 VPWR VGND sg13cmos5l_decap_8
XFILLER_219_49 VPWR VGND sg13cmos5l_decap_8
X_1631_ _1631_/Q Tile_X0Y2_FrameData[18] VGND VPWR Tile_X0Y9_FrameStrobe[6] latch
XFILLER_366_77 VPWR VGND sg13cmos5l_decap_8
XFILLER_144_126 VPWR VGND sg13cmos5l_decap_8
XFILLER_516_14 VPWR VGND sg13cmos5l_decap_8
XFILLER_479_219 VPWR VGND sg13cmos5l_decap_8
XANTENNA__3327__X Tile_X0Y4_EE4BEG[15] VPWR VGND sg13cmos5l_antennanp
XFILLER_695_105 VPWR VGND sg13cmos5l_decap_8
XFILLER_663_42 VPWR VGND sg13cmos5l_decap_8
X_4350_ _4350_/X _4308_/X _0160_/X _4307_/X _0110_/X _1953_/Q _1952_/Q VPWR VGND sg13cmos5l_mux4_1
X_1562_ _1562_/Q Tile_X0Y2_FrameData[23] VGND VPWR Tile_X0Y9_FrameStrobe[4] latch
XFILLER_382_21 VPWR VGND sg13cmos5l_decap_8
X_3301_ Tile_X0Y0_E2BEG[1] _3805_/X VPWR VGND sg13cmos5l_buf_1
X_0513_ _0513_/Q Tile_X0Y8_FrameData[30] VGND VPWR Tile_X0Y9_FrameStrobe[3] latch
X_4281_ _4281_/X Tile_X0Y4_WW4END[6] AXI_M_SOC_BRESP0 _4342_/X _4314_/X _2051_/Q _2050_/Q
+ VPWR VGND sg13cmos5l_mux4_1
X_1493_ _1493_/Q Tile_X0Y2_FrameData[28] VGND VPWR Tile_X0Y9_FrameStrobe[2] latch
X_3232_ Tile_X0Y0_FrameData_O[0] Tile_X0Y0_FrameData[0] VPWR VGND sg13cmos5l_buf_1
XFILLER_636_227 VPWR VGND sg13cmos5l_fill_2
X_0444_ _0444_/Q Tile_X0Y8_FrameData[3] VGND VPWR Tile_X0Y9_FrameStrobe[0] latch
XFILLER_301_156 VPWR VGND sg13cmos5l_fill_1
XFILLER_532_35 VPWR VGND sg13cmos5l_decap_8
X_3163_ Tile_X0Y4_E6BEG[0] _4288_/X VPWR VGND sg13cmos5l_buf_1
XFILLER_251_14 VPWR VGND sg13cmos5l_decap_8
X_0375_ _0375_/Q Tile_X0Y7_FrameData[8] VGND VPWR Tile_X0Y9_FrameStrobe[6] latch
XFILLER_651_208 VPWR VGND sg13cmos5l_decap_8
XANTENNA__3062__X Tile_X0Y5_FrameData_O[21] VPWR VGND sg13cmos5l_antennanp
XFILLER_66_143 VPWR VGND sg13cmos5l_decap_8
X_2114_ _2114_/Q Tile_X0Y4_FrameData[3] VGND VPWR Tile_X0Y9_FrameStrobe[5] latch
X_3094_ Tile_X0Y7_E2BEGb[0] _4620_/X VPWR VGND sg13cmos5l_buf_1
X_2045_ _2045_/Q Tile_X0Y4_FrameData[8] VGND VPWR Tile_X0Y9_FrameStrobe[3] latch
XFILLER_470_152 VPWR VGND sg13cmos5l_decap_8
XFILLER_401_28 VPWR VGND sg13cmos5l_decap_8
XFILLER_214_119 VPWR VGND sg13cmos5l_decap_8
XFILLER_331_91 VPWR VGND sg13cmos5l_fill_2
XFILLER_207_182 VPWR VGND sg13cmos5l_decap_8
XFILLER_368_112 VPWR VGND sg13cmos5l_fill_2
XFILLER_368_123 VPWR VGND sg13cmos5l_fill_1
X_3996_ _3996_/X _3987_/X _0084_/X _3986_/X Tile_X0Y0_S4END[7] _1203_/Q _1202_/Q VPWR
+ VGND sg13cmos5l_mux4_1
XFILLER_557_21 VPWR VGND sg13cmos5l_decap_8
XFILLER_167_218 VPWR VGND sg13cmos5l_decap_8
XFILLER_309_201 VPWR VGND sg13cmos5l_fill_1
X_2947_ Tile_X0Y8_EE4BEG[3] _4747_/X VPWR VGND sg13cmos5l_buf_1
XFILLER_200_84 VPWR VGND sg13cmos5l_decap_8
XFILLER_13_49 VPWR VGND sg13cmos5l_decap_8
XFILLER_557_98 VPWR VGND sg13cmos5l_decap_8
XFILLER_129_49 VPWR VGND sg13cmos5l_decap_8
XFILLER_707_35 VPWR VGND sg13cmos5l_decap_8
X_2878_ Tile_X0Y6_EE4BEG[15] _4527_/X VPWR VGND sg13cmos5l_buf_1
XFILLER_276_77 VPWR VGND sg13cmos5l_decap_8
X_4617_ _4617_/X Tile_X0Y7_W2MID[2] AXI_M_SOC_RDATA21 _4673_/X _4672_/X _0325_/Q _0324_/Q
+ VPWR VGND sg13cmos5l_mux4_1
XFILLER_324_226 VPWR VGND sg13cmos5l_fill_2
XFILLER_135_126 VPWR VGND sg13cmos5l_decap_8
X_1829_ _1829_/Q Tile_X0Y3_FrameData[4] VGND VPWR Tile_X0Y9_FrameStrobe[4] latch
XFILLER_426_14 VPWR VGND sg13cmos5l_decap_8
XANTENNA__3237__X Tile_X0Y0_FrameData_O[5] VPWR VGND sg13cmos5l_antennanp
XFILLER_686_105 VPWR VGND sg13cmos5l_decap_8
XFILLER_573_42 VPWR VGND sg13cmos5l_decap_8
X_4548_ _4548_/X Tile_X0Y5_W1END[2] Tile_X0Y5_W6END[10] _4465_/X _4422_/X _2399_/Q
+ _2398_/Q VPWR VGND sg13cmos5l_mux4_1
XFILLER_292_21 VPWR VGND sg13cmos5l_decap_8
XFILLER_289_141 VPWR VGND sg13cmos5l_decap_4
XFILLER_1_106 VPWR VGND sg13cmos5l_fill_1
XFILLER_150_129 VPWR VGND sg13cmos5l_decap_4
XFILLER_289_152 VPWR VGND sg13cmos5l_decap_8
XFILLER_540_189 VPWR VGND sg13cmos5l_decap_8
X_4479_ _4479_/X Tile_X0Y7_W2MID[2] Tile_X0Y7_W2END[2] Tile_X0Y7_W6END[2] _4672_/X
+ _0397_/Q _0396_/Q VPWR VGND sg13cmos5l_mux4_1
XFILLER_694_160 VPWR VGND sg13cmos5l_fill_1
XFILLER_506_91 VPWR VGND sg13cmos5l_decap_8
XFILLER_292_98 VPWR VGND sg13cmos5l_decap_8
XFILLER_442_35 VPWR VGND sg13cmos5l_decap_8
XFILLER_225_70 VPWR VGND sg13cmos5l_decap_8
XFILLER_38_35 VPWR VGND sg13cmos5l_decap_8
XFILLER_161_14 VPWR VGND sg13cmos5l_decap_8
XFILLER_285_7 VPWR VGND sg13cmos5l_decap_8
XFILLER_446_171 VPWR VGND sg13cmos5l_decap_8
XFILLER_38_79 VPWR VGND sg13cmos5l_decap_8
XFILLER_461_130 VPWR VGND sg13cmos5l_decap_4
XFILLER_57_187 VPWR VGND sg13cmos5l_decap_8
XFILLER_461_141 VPWR VGND sg13cmos5l_decap_8
XFILLER_311_28 VPWR VGND sg13cmos5l_decap_8
XFILLER_452_7 VPWR VGND sg13cmos5l_decap_8
XFILLER_205_119 VPWR VGND sg13cmos5l_decap_8
XFILLER_610_105 VPWR VGND sg13cmos5l_decap_8
XFILLER_241_91 VPWR VGND sg13cmos5l_decap_4
XANTENNA__3700__X AXI_M_SOC_WDATA10 VPWR VGND sg13cmos5l_antennanp
XFILLER_54_56 VPWR VGND sg13cmos5l_decap_8
XFILLER_359_112 VPWR VGND sg13cmos5l_decap_8
XFILLER_80_190 VPWR VGND sg13cmos5l_fill_2
XFILLER_467_21 VPWR VGND sg13cmos5l_decap_8
XFILLER_213_196 VPWR VGND sg13cmos5l_decap_8
XFILLER_563_204 VPWR VGND sg13cmos5l_decap_8
XFILLER_563_215 VPWR VGND sg13cmos5l_fill_2
XFILLER_110_84 VPWR VGND sg13cmos5l_decap_8
XFILLER_467_87 VPWR VGND sg13cmos5l_decap_8
XFILLER_70_77 VPWR VGND sg13cmos5l_decap_8
XFILLER_617_35 VPWR VGND sg13cmos5l_decap_8
XFILLER_186_77 VPWR VGND sg13cmos5l_fill_2
XFILLER_516_186 VPWR VGND sg13cmos5l_fill_1
XFILLER_336_14 VPWR VGND sg13cmos5l_decap_8
XFILLER_677_105 VPWR VGND sg13cmos5l_fill_2
XANTENNA__3147__X Tile_X0Y7_FrameData_O[17] VPWR VGND sg13cmos5l_antennanp
XFILLER_483_42 VPWR VGND sg13cmos5l_decap_8
XFILLER_207_0 VPWR VGND sg13cmos5l_decap_8
XFILLER_79_42 VPWR VGND sg13cmos5l_decap_8
XFILLER_330_218 VPWR VGND sg13cmos5l_decap_8
XANTENNA__2986__X Tile_X0Y8_FrameData_O[26] VPWR VGND sg13cmos5l_antennanp
XFILLER_692_119 VPWR VGND sg13cmos5l_fill_2
XFILLER_429_105 VPWR VGND sg13cmos5l_decap_8
XFILLER_633_56 VPWR VGND sg13cmos5l_decap_8
XFILLER_416_91 VPWR VGND sg13cmos5l_decap_8
XFILLER_352_35 VPWR VGND sg13cmos5l_decap_8
XFILLER_135_70 VPWR VGND sg13cmos5l_decap_8
XFILLER_576_0 VPWR VGND sg13cmos5l_fill_2
XFILLER_95_63 VPWR VGND sg13cmos5l_decap_8
XFILLER_295_199 VPWR VGND sg13cmos5l_decap_8
XFILLER_95_74 VPWR VGND sg13cmos5l_fill_1
X_0160_ _0160_/X _4330_/X _4331_/X _0639_/Q VPWR VGND sg13cmos5l_mux2_1
XFILLER_502_49 VPWR VGND sg13cmos5l_decap_8
XFILLER_452_163 VPWR VGND sg13cmos5l_decap_8
XFILLER_221_28 VPWR VGND sg13cmos5l_decap_8
X_0091_ _3624_/A _4488_/X _4489_/X _2627_/Q VPWR VGND sg13cmos5l_mux2_1
XFILLER_63_146 VPWR VGND sg13cmos5l_decap_8
XFILLER_598_167 VPWR VGND sg13cmos5l_decap_8
XFILLER_151_80 VPWR VGND sg13cmos5l_decap_8
XANTENNA__3610__X Tile_X0Y9_S2BEG[4] VPWR VGND sg13cmos5l_antennanp
XFILLER_658_42 VPWR VGND sg13cmos5l_decap_8
XFILLER_71_190 VPWR VGND sg13cmos5l_decap_8
X_3850_ _3850_/X Tile_X0Y1_W1END[2] Tile_X0Y1_W6END[6] _3999_/X _3978_/X _1421_/Q
+ _1420_/Q VPWR VGND sg13cmos5l_mux4_1
XFILLER_377_21 VPWR VGND sg13cmos5l_decap_8
X_2801_ Tile_X0Y3_E6BEG[11] _4191_/X VPWR VGND sg13cmos5l_buf_1
X_3781_ _3781_/X Tile_X0Y0_W1END[1] Tile_X0Y0_W6END[5] _3871_/X _3860_/X _1175_/Q
+ _1174_/Q VPWR VGND sg13cmos5l_mux4_1
XFILLER_554_226 VPWR VGND sg13cmos5l_fill_2
X_0993_ _0993_/Q Tile_X0Y0_FrameData[10] VGND VPWR Tile_X0Y9_FrameStrobe[1] latch
X_2732_ _3880_/A3 VPWR VGND sg13cmos5l_tielo
XFILLER_527_35 VPWR VGND sg13cmos5l_decap_8
XFILLER_117_115 VPWR VGND sg13cmos5l_decap_8
XFILLER_507_175 VPWR VGND sg13cmos5l_decap_8
XFILLER_172_210 VPWR VGND sg13cmos5l_decap_8
X_2663_ _2663_/Q Tile_X0Y6_FrameData[0] VGND VPWR Tile_X0Y9_FrameStrobe[6] latch
XFILLER_674_63 VPWR VGND sg13cmos5l_decap_8
XFILLER_246_14 VPWR VGND sg13cmos5l_decap_8
XFILLER_507_186 VPWR VGND sg13cmos5l_fill_2
XANTENNA__3057__X Tile_X0Y5_FrameData_O[16] VPWR VGND sg13cmos5l_antennanp
XFILLER_393_42 VPWR VGND sg13cmos5l_decap_8
XFILLER_117_159 VPWR VGND sg13cmos5l_fill_1
X_1614_ _1614_/Q Tile_X0Y2_FrameData[3] VGND VPWR Tile_X0Y9_FrameStrobe[5] latch
X_4402_ _4402_/X Tile_X0Y5_WW4END[1] AXI_M_SOC_RLAST _4452_/X _4430_/X _2299_/Q _2298_/Q
+ VPWR VGND sg13cmos5l_mux4_1
X_2594_ _2594_/Q Tile_X0Y6_FrameData[5] VGND VPWR Tile_X0Y9_FrameStrobe[4] latch
XANTENNA__2896__X Tile_X0Y6_FrameData_O[17] VPWR VGND sg13cmos5l_antennanp
X_1545_ _1545_/Q Tile_X0Y2_FrameData[8] VGND VPWR Tile_X0Y9_FrameStrobe[3] latch
X_4333_ _4333_/X _3879_/X _3864_/X _3863_/X _3852_/X _1108_/Q _1107_/Q VPWR VGND sg13cmos5l_mux4_1
XFILLER_125_181 VPWR VGND sg13cmos5l_decap_4
XFILLER_676_160 VPWR VGND sg13cmos5l_fill_2
XFILLER_609_216 VPWR VGND sg13cmos5l_decap_4
XFILLER_543_56 VPWR VGND sg13cmos5l_decap_8
XFILLER_326_91 VPWR VGND sg13cmos5l_decap_4
XFILLER_140_140 VPWR VGND sg13cmos5l_decap_8
X_4264_ _4264_/X Tile_X0Y4_W2END[7] AXI_M_SOC_BRESP1 _4313_/X _4312_/X _2085_/Q _2084_/Q
+ VPWR VGND sg13cmos5l_mux4_1
XFILLER_286_133 VPWR VGND sg13cmos5l_decap_8
X_1476_ _1476_/Q Tile_X0Y2_FrameData[13] VGND VPWR Tile_X0Y9_FrameStrobe[1] latch
XFILLER_690_84 VPWR VGND sg13cmos5l_decap_8
XFILLER_262_35 VPWR VGND sg13cmos5l_decap_8
XFILLER_86_227 VPWR VGND sg13cmos5l_fill_2
XFILLER_140_173 VPWR VGND sg13cmos5l_decap_8
X_3215_ Tile_X0Y0_FrameStrobe_O[3] Tile_X0Y9_FrameStrobe[3] VPWR VGND sg13cmos5l_buf_1
X_0427_ _0427_/Q Tile_X0Y8_FrameData[20] VGND VPWR Tile_X0Y9_FrameStrobe[0] latch
X_4195_ _4195_/X Tile_X0Y4_W1END[0] Tile_X0Y4_W6END[4] _4348_/X _4300_/X _2181_/Q
+ _2180_/Q VPWR VGND sg13cmos5l_mux4_1
XFILLER_435_119 VPWR VGND sg13cmos5l_decap_8
XFILLER_227_200 VPWR VGND sg13cmos5l_fill_2
XFILLER_691_174 VPWR VGND sg13cmos5l_fill_2
XFILLER_227_211 VPWR VGND sg13cmos5l_fill_1
XFILLER_428_182 VPWR VGND sg13cmos5l_decap_8
X_3146_ Tile_X0Y7_FrameData_O[16] Tile_X0Y7_FrameData[16] VPWR VGND sg13cmos5l_buf_1
X_0358_ _0358_/Q Tile_X0Y7_FrameData[25] VGND VPWR Tile_X0Y9_FrameStrobe[6] latch
XFILLER_589_112 VPWR VGND sg13cmos5l_decap_4
XFILLER_54_124 VPWR VGND sg13cmos5l_decap_8
XFILLER_443_152 VPWR VGND sg13cmos5l_fill_1
XFILLER_699_82 VPWR VGND sg13cmos5l_decap_8
XFILLER_131_28 VPWR VGND sg13cmos5l_decap_8
X_3077_ Tile_X0Y4_E2BEGb[3] _4267_/X VPWR VGND sg13cmos5l_buf_1
X_0289_ _0289_/Q Tile_X0Y7_FrameData[30] VGND VPWR Tile_X0Y9_FrameStrobe[4] latch
XANTENNA__3520__X Tile_X0Y1_E1BEG[2] VPWR VGND sg13cmos5l_antennanp
XFILLER_443_196 VPWR VGND sg13cmos5l_decap_8
X_2028_ _2028_/Q Tile_X0Y4_FrameData[25] VGND VPWR Tile_X0Y9_FrameStrobe[3] latch
XFILLER_568_42 VPWR VGND sg13cmos5l_decap_8
XFILLER_287_21 VPWR VGND sg13cmos5l_decap_8
XFILLER_210_133 VPWR VGND sg13cmos5l_decap_8
XFILLER_356_126 VPWR VGND sg13cmos5l_decap_8
X_3979_ _3979_/X _3987_/X Tile_X0Y1_W6END[3] _3986_/X _3979_/A3 _1179_/Q _1426_/Q
+ VPWR VGND sg13cmos5l_mux4_1
XFILLER_287_98 VPWR VGND sg13cmos5l_decap_8
XFILLER_437_35 VPWR VGND sg13cmos5l_decap_8
XFILLER_40_14 VPWR VGND sg13cmos5l_decap_8
XFILLER_210_199 VPWR VGND sg13cmos5l_decap_8
XFILLER_584_63 VPWR VGND sg13cmos5l_decap_8
XFILLER_513_112 VPWR VGND sg13cmos5l_decap_8
XFILLER_156_14 VPWR VGND sg13cmos5l_decap_8
XFILLER_659_105 VPWR VGND sg13cmos5l_decap_8
XFILLER_200_7 VPWR VGND sg13cmos5l_decap_8
XFILLER_306_28 VPWR VGND sg13cmos5l_decap_8
XFILLER_667_160 VPWR VGND sg13cmos5l_fill_2
XFILLER_453_56 VPWR VGND sg13cmos5l_decap_8
XFILLER_131_140 VPWR VGND sg13cmos5l_decap_8
XFILLER_49_45 VPWR VGND sg13cmos5l_decap_8
XFILLER_277_133 VPWR VGND sg13cmos5l_decap_8
XFILLER_172_35 VPWR VGND sg13cmos5l_decap_8
XFILLER_682_141 VPWR VGND sg13cmos5l_decap_4
XFILLER_615_208 VPWR VGND sg13cmos5l_decap_8
XFILLER_481_203 VPWR VGND sg13cmos5l_decap_8
XFILLER_426_119 VPWR VGND sg13cmos5l_decap_8
XFILLER_667_7 VPWR VGND sg13cmos5l_decap_8
XFILLER_292_158 VPWR VGND sg13cmos5l_decap_8
XFILLER_322_49 VPWR VGND sg13cmos5l_decap_8
XFILLER_105_84 VPWR VGND sg13cmos5l_decap_8
XFILLER_45_135 VPWR VGND sg13cmos5l_fill_2
XANTENNA__3430__X Tile_X0Y4_FrameData_O[21] VPWR VGND sg13cmos5l_antennanp
XFILLER_65_99 VPWR VGND sg13cmos5l_decap_8
XFILLER_60_105 VPWR VGND sg13cmos5l_decap_8
XFILLER_60_127 VPWR VGND sg13cmos5l_decap_8
XFILLER_81_21 VPWR VGND sg13cmos5l_decap_8
XFILLER_478_42 VPWR VGND sg13cmos5l_decap_8
XFILLER_157_0 VPWR VGND sg13cmos5l_decap_8
XFILLER_197_21 VPWR VGND sg13cmos5l_decap_8
XFILLER_628_12 VPWR VGND sg13cmos5l_decap_8
XFILLER_347_126 VPWR VGND sg13cmos5l_decap_4
XFILLER_324_0 VPWR VGND sg13cmos5l_decap_8
XFILLER_347_159 VPWR VGND sg13cmos5l_decap_8
XFILLER_14_70 VPWR VGND sg13cmos5l_decap_8
XFILLER_197_98 VPWR VGND sg13cmos5l_decap_8
XFILLER_347_35 VPWR VGND sg13cmos5l_decap_8
XFILLER_628_89 VPWR VGND sg13cmos5l_decap_8
XFILLER_494_63 VPWR VGND sg13cmos5l_decap_8
XFILLER_504_112 VPWR VGND sg13cmos5l_decap_8
XFILLER_370_140 VPWR VGND sg13cmos5l_decap_8
XFILLER_693_0 VPWR VGND sg13cmos5l_decap_8
XFILLER_644_77 VPWR VGND sg13cmos5l_decap_8
XFILLER_216_28 VPWR VGND sg13cmos5l_decap_8
XFILLER_107_192 VPWR VGND sg13cmos5l_decap_8
XFILLER_658_160 VPWR VGND sg13cmos5l_decap_8
XANTENNA__3605__X Tile_X0Y9_S1BEG[3] VPWR VGND sg13cmos5l_antennanp
XFILLER_457_211 VPWR VGND sg13cmos5l_fill_2
XFILLER_363_56 VPWR VGND sg13cmos5l_decap_8
XFILLER_146_91 VPWR VGND sg13cmos5l_decap_8
X_1330_ _1330_/Q Tile_X0Y1_FrameData[7] VGND VPWR Tile_X0Y9_FrameStrobe[4] latch
XFILLER_68_205 VPWR VGND sg13cmos5l_decap_8
XFILLER_122_151 VPWR VGND sg13cmos5l_fill_1
XFILLER_660_21 VPWR VGND sg13cmos5l_decap_8
X_1261_ _1261_/Q Tile_X0Y1_FrameData[12] VGND VPWR Tile_X0Y9_FrameStrobe[2] latch
XFILLER_122_195 VPWR VGND sg13cmos5l_decap_8
X_3000_ Tile_X0Y5_E2BEG[3] _4375_/X VPWR VGND sg13cmos5l_buf_1
X_0212_ _0212_/Q Tile_X0Y7_FrameData[11] VGND VPWR Tile_X0Y9_FrameStrobe[1] latch
XFILLER_283_147 VPWR VGND sg13cmos5l_decap_8
XFILLER_660_98 VPWR VGND sg13cmos5l_decap_8
X_1192_ _1192_/Q Tile_X0Y1_FrameData[17] VGND VPWR Tile_X0Y9_FrameStrobe[0] latch
XFILLER_232_49 VPWR VGND sg13cmos5l_decap_8
X_0143_ _0143_/X _4435_/X _4436_/X _1363_/Q VPWR VGND sg13cmos5l_mux2_1
XANTENNA__3340__X Tile_X0Y2_FrameData_O[11] VPWR VGND sg13cmos5l_antennanp
X_0074_ _0074_/X _4798_/X _4799_/X _2110_/Q VPWR VGND sg13cmos5l_mux2_1
XFILLER_669_63 VPWR VGND sg13cmos5l_decap_8
XFILLER_586_126 VPWR VGND sg13cmos5l_decap_8
XFILLER_440_155 VPWR VGND sg13cmos5l_fill_1
XFILLER_388_42 VPWR VGND sg13cmos5l_decap_8
X_3902_ _3902_/X Tile_X0Y2_W2MID[0] Tile_X0Y2_W2END[0] Tile_X0Y2_W6END[0] _4096_/X
+ _1651_/Q _1650_/Q VPWR VGND sg13cmos5l_mux4_1
XFILLER_440_177 VPWR VGND sg13cmos5l_decap_8
X_4882_ _4882_/X Tile_X0Y9_N4END[2] _0081_/X _4925_/X _4929_/X _0779_/Q _0778_/Q VPWR
+ VGND sg13cmos5l_mux4_1
XFILLER_440_199 VPWR VGND sg13cmos5l_fill_2
X_3833_ _3833_/X Tile_X0Y0_WW4END[2] _3883_/X _3857_/X _3880_/X _1039_/Q _1038_/Q
+ VPWR VGND sg13cmos5l_mux4_1
XFILLER_527_226 VPWR VGND sg13cmos5l_fill_2
XFILLER_393_221 VPWR VGND sg13cmos5l_decap_8
XFILLER_338_148 VPWR VGND sg13cmos5l_fill_2
XFILLER_538_56 VPWR VGND sg13cmos5l_decap_8
X_0976_ _0976_/Q Tile_X0Y0_FrameData[27] VGND VPWR Tile_X0Y9_FrameStrobe[1] latch
X_3764_ _3764_/X Tile_X0Y1_WW4END[5] Tile_X0Y1_WW4END[13] Tile_X0Y1_W6END[5] _4013_/X
+ _1247_/Q _1246_/Q VPWR VGND sg13cmos5l_mux4_1
XFILLER_685_84 VPWR VGND sg13cmos5l_decap_8
XFILLER_72_0 VPWR VGND sg13cmos5l_fill_2
XFILLER_257_35 VPWR VGND sg13cmos5l_decap_8
XFILLER_346_170 VPWR VGND sg13cmos5l_decap_8
X_2715_ _4416_/A3 VPWR VGND sg13cmos5l_tielo
X_3695_ AXI_M_SOC_WDATA5 Tile_X0Y7_WW4END[5] Tile_X0Y7_WW4END[13] Tile_X0Y7_W6END[5]
+ _4689_/X _0237_/Q _0236_/Q VPWR VGND sg13cmos5l_mux4_1
X_2646_ _2646_/Q Tile_X0Y6_FrameData[17] VGND VPWR Tile_X0Y9_FrameStrobe[6] latch
XFILLER_10_28 VPWR VGND sg13cmos5l_decap_8
XFILLER_407_49 VPWR VGND sg13cmos5l_decap_8
XFILLER_361_184 VPWR VGND sg13cmos5l_decap_8
XFILLER_554_77 VPWR VGND sg13cmos5l_decap_8
XFILLER_126_28 VPWR VGND sg13cmos5l_decap_8
XFILLER_704_14 VPWR VGND sg13cmos5l_decap_8
X_2577_ _2577_/Q Tile_X0Y6_FrameData[22] VGND VPWR Tile_X0Y9_FrameStrobe[4] latch
XFILLER_510_126 VPWR VGND sg13cmos5l_decap_8
XFILLER_656_119 VPWR VGND sg13cmos5l_decap_8
XFILLER_273_56 VPWR VGND sg13cmos5l_decap_8
XANTENNA__3515__X Tile_X0Y1_E2BEG[5] VPWR VGND sg13cmos5l_antennanp
XFILLER_113_140 VPWR VGND sg13cmos5l_decap_8
X_4316_ _4316_/X _4247_/X _4363_/X _4362_/X _4246_/X _1939_/Q _1938_/Q VPWR VGND sg13cmos5l_mux4_1
XFILLER_113_151 VPWR VGND sg13cmos5l_fill_2
X_1528_ _1528_/Q Tile_X0Y2_FrameData[25] VGND VPWR Tile_X0Y9_FrameStrobe[3] latch
XFILLER_570_21 VPWR VGND sg13cmos5l_decap_8
XFILLER_259_155 VPWR VGND sg13cmos5l_decap_8
XFILLER_463_203 VPWR VGND sg13cmos5l_decap_8
X_1459_ _1459_/Q Tile_X0Y2_FrameData[30] VGND VPWR Tile_X0Y9_FrameStrobe[1] latch
X_4247_ _4247_/X Tile_X0Y5_W2MID[2] Tile_X0Y5_W2END[2] Tile_X0Y5_W6END[2] _4431_/X
+ _2421_/Q _2420_/Q VPWR VGND sg13cmos5l_mux4_1
XFILLER_664_163 VPWR VGND sg13cmos5l_fill_1
XFILLER_259_199 VPWR VGND sg13cmos5l_fill_2
X_4178_ _4178_/X Tile_X0Y3_WW4END[1] AXI_M_SOC_BVALID _4223_/X _4207_/X _1785_/Q _1784_/Q
+ VPWR VGND sg13cmos5l_mux4_1
XFILLER_570_98 VPWR VGND sg13cmos5l_decap_8
XFILLER_142_49 VPWR VGND sg13cmos5l_decap_8
XFILLER_503_70 VPWR VGND sg13cmos5l_decap_8
X_3129_ Tile_X0Y7_EE4BEG[15] _4643_/X VPWR VGND sg13cmos5l_buf_1
XANTENNA__3250__X Tile_X0Y0_FrameData_O[18] VPWR VGND sg13cmos5l_antennanp
XFILLER_416_174 VPWR VGND sg13cmos5l_fill_1
XFILLER_215_225 VPWR VGND sg13cmos5l_decap_4
XFILLER_35_14 VPWR VGND sg13cmos5l_decap_8
XFILLER_579_63 VPWR VGND sg13cmos5l_decap_8
XFILLER_577_126 VPWR VGND sg13cmos5l_decap_8
XFILLER_431_133 VPWR VGND sg13cmos5l_decap_8
XFILLER_298_42 VPWR VGND sg13cmos5l_decap_8
XFILLER_150_7 VPWR VGND sg13cmos5l_decap_8
XFILLER_230_228 VPWR VGND sg13cmos5l_fill_1
XFILLER_248_7 VPWR VGND sg13cmos5l_decap_8
XFILLER_298_97 VPWR VGND sg13cmos5l_decap_8
XFILLER_195_121 VPWR VGND sg13cmos5l_decap_8
XFILLER_51_13 VPWR VGND sg13cmos5l_decap_8
XFILLER_50_182 VPWR VGND sg13cmos5l_fill_1
XFILLER_448_56 VPWR VGND sg13cmos5l_decap_8
XFILLER_329_159 VPWR VGND sg13cmos5l_fill_2
XFILLER_415_7 VPWR VGND sg13cmos5l_decap_8
XFILLER_595_84 VPWR VGND sg13cmos5l_decap_8
XFILLER_167_35 VPWR VGND sg13cmos5l_decap_8
XFILLER_195_198 VPWR VGND sg13cmos5l_decap_8
XFILLER_337_192 VPWR VGND sg13cmos5l_decap_8
XFILLER_498_133 VPWR VGND sg13cmos5l_decap_8
XFILLER_352_140 VPWR VGND sg13cmos5l_decap_8
XFILLER_317_49 VPWR VGND sg13cmos5l_decap_8
XFILLER_464_77 VPWR VGND sg13cmos5l_decap_8
XFILLER_614_14 VPWR VGND sg13cmos5l_decap_8
XFILLER_501_126 VPWR VGND sg13cmos5l_decap_8
XFILLER_297_228 VPWR VGND sg13cmos5l_fill_1
XFILLER_647_119 VPWR VGND sg13cmos5l_decap_8
XFILLER_183_56 VPWR VGND sg13cmos5l_decap_8
XANTENNA__3425__X Tile_X0Y4_FrameData_O[16] VPWR VGND sg13cmos5l_antennanp
XFILLER_104_140 VPWR VGND sg13cmos5l_decap_8
XFILLER_480_21 VPWR VGND sg13cmos5l_decap_8
XFILLER_76_21 VPWR VGND sg13cmos5l_decap_8
XFILLER_265_114 VPWR VGND sg13cmos5l_decap_8
XFILLER_670_100 VPWR VGND sg13cmos5l_decap_8
XFILLER_454_225 VPWR VGND sg13cmos5l_decap_4
XFILLER_655_196 VPWR VGND sg13cmos5l_decap_8
XFILLER_630_35 VPWR VGND sg13cmos5l_decap_8
XFILLER_670_144 VPWR VGND sg13cmos5l_fill_1
XFILLER_413_70 VPWR VGND sg13cmos5l_decap_8
XFILLER_76_98 VPWR VGND sg13cmos5l_decap_8
XFILLER_274_0 VPWR VGND sg13cmos5l_decap_8
XFILLER_670_166 VPWR VGND sg13cmos5l_fill_2
XFILLER_206_203 VPWR VGND sg13cmos5l_decap_4
XFILLER_206_214 VPWR VGND sg13cmos5l_fill_1
XANTENNA__3160__X Tile_X0Y7_FrameData_O[30] VPWR VGND sg13cmos5l_antennanp
XFILLER_92_42 VPWR VGND sg13cmos5l_decap_8
XFILLER_422_133 VPWR VGND sg13cmos5l_decap_8
XFILLER_33_105 VPWR VGND sg13cmos5l_fill_1
XFILLER_568_126 VPWR VGND sg13cmos5l_decap_8
XFILLER_489_63 VPWR VGND sg13cmos5l_decap_8
XFILLER_441_0 VPWR VGND sg13cmos5l_decap_8
XFILLER_92_75 VPWR VGND sg13cmos5l_decap_8
XFILLER_539_0 VPWR VGND sg13cmos5l_decap_8
XFILLER_221_228 VPWR VGND sg13cmos5l_fill_1
XFILLER_639_77 VPWR VGND sg13cmos5l_decap_8
XFILLER_25_91 VPWR VGND sg13cmos5l_decap_8
XFILLER_186_132 VPWR VGND sg13cmos5l_decap_4
XFILLER_706_0 VPWR VGND sg13cmos5l_decap_8
XFILLER_576_192 VPWR VGND sg13cmos5l_decap_8
XFILLER_358_56 VPWR VGND sg13cmos5l_decap_8
X_0830_ _0830_/Q Tile_X0Y9_FrameData[1] VGND VPWR Tile_X0Y9_FrameStrobe[4] latch
XFILLER_655_21 VPWR VGND sg13cmos5l_decap_8
XFILLER_591_184 VPWR VGND sg13cmos5l_fill_1
XFILLER_127_221 VPWR VGND sg13cmos5l_fill_1
X_0761_ _0761_/Q Tile_X0Y9_FrameData[6] VGND VPWR Tile_X0Y9_FrameStrobe[2] latch
X_2500_ _2500_/Q Tile_X0Y6_FrameData[3] VGND VPWR Tile_X0Y9_FrameStrobe[1] latch
X_3480_ Tile_X0Y1_EE4BEG[6] _3954_/X VPWR VGND sg13cmos5l_buf_1
XFILLER_489_133 VPWR VGND sg13cmos5l_decap_8
X_0692_ _0692_/Q Tile_X0Y9_FrameData[11] VGND VPWR Tile_X0Y9_FrameStrobe[0] latch
XFILLER_655_98 VPWR VGND sg13cmos5l_decap_8
XFILLER_227_49 VPWR VGND sg13cmos5l_decap_8
XFILLER_142_224 VPWR VGND sg13cmos5l_decap_4
X_2431_ _2431_/Q Tile_X0Y5_FrameData[6] VGND VPWR Tile_X0Y9_FrameStrobe[7] latch
XFILLER_374_77 VPWR VGND sg13cmos5l_fill_2
XFILLER_693_203 VPWR VGND sg13cmos5l_fill_1
XFILLER_288_228 VPWR VGND sg13cmos5l_fill_1
XFILLER_638_119 VPWR VGND sg13cmos5l_decap_8
XFILLER_524_14 VPWR VGND sg13cmos5l_decap_8
XANTENNA__3335__X Tile_X0Y2_FrameData_O[6] VPWR VGND sg13cmos5l_antennanp
XFILLER_693_225 VPWR VGND sg13cmos5l_decap_4
XFILLER_671_42 VPWR VGND sg13cmos5l_decap_8
X_2362_ _2362_/Q Tile_X0Y5_FrameData[11] VGND VPWR Tile_X0Y9_FrameStrobe[5] latch
XFILLER_390_21 VPWR VGND sg13cmos5l_decap_8
X_1313_ _1313_/Q Tile_X0Y1_FrameData[24] VGND VPWR Tile_X0Y9_FrameStrobe[4] latch
X_4101_ _4101_/X _4025_/X _4133_/X _4132_/X _4024_/X _1445_/Q _1444_/Q VPWR VGND sg13cmos5l_mux4_1
XFILLER_110_121 VPWR VGND sg13cmos5l_decap_8
X_2293_ _2293_/Q Tile_X0Y5_FrameData[16] VGND VPWR Tile_X0Y9_FrameStrobe[3] latch
XFILLER_256_136 VPWR VGND sg13cmos5l_decap_8
X_4032_ _4032_/X Tile_X0Y0_W1END[2] Tile_X0Y0_W2MID[1] Tile_X0Y0_W2END[1] _3854_/X
+ _1121_/Q _1120_/Q VPWR VGND sg13cmos5l_mux4_1
XFILLER_646_196 VPWR VGND sg13cmos5l_decap_8
X_1244_ _1244_/Q Tile_X0Y1_FrameData[29] VGND VPWR Tile_X0Y9_FrameStrobe[2] latch
XFILLER_540_35 VPWR VGND sg13cmos5l_decap_8
XFILLER_323_70 VPWR VGND sg13cmos5l_decap_4
XFILLER_2_84 VPWR VGND sg13cmos5l_decap_8
XFILLER_110_198 VPWR VGND sg13cmos5l_decap_8
X_1175_ _1175_/Q Tile_X0Y0_FrameData[20] VGND VPWR Tile_X0Y9_FrameStrobe[7] latch
XANTENNA__3070__X Tile_X0Y5_FrameData_O[29] VPWR VGND sg13cmos5l_antennanp
X_0126_ _3188_/A _3792_/X _3793_/X _1151_/Q VPWR VGND sg13cmos5l_mux2_1
XFILLER_399_63 VPWR VGND sg13cmos5l_decap_8
XFILLER_559_159 VPWR VGND sg13cmos5l_decap_8
X_0057_ _0057_/X _4111_/X _4112_/X _2663_/Q VPWR VGND sg13cmos5l_mux2_1
X_4934_ _4934_/X Tile_X0Y8_W2MID[5] Tile_X0Y8_W2END[5] Tile_X0Y8_W6END[10] _4789_/X
+ _0623_/Q _0622_/Q VPWR VGND sg13cmos5l_mux4_1
XFILLER_268_12 VPWR VGND sg13cmos5l_decap_8
XFILLER_549_77 VPWR VGND sg13cmos5l_decap_8
XFILLER_32_160 VPWR VGND sg13cmos5l_fill_1
X_4865_ _4865_/X Tile_X0Y9_WW4END[14] AXI_M_SOC_RDATA1 _4930_/X _4902_/X _0813_/Q
+ _0812_/Q VPWR VGND sg13cmos5l_mux4_1
XFILLER_549_88 VPWR VGND sg13cmos5l_fill_1
XANTENNA_12 Tile_X0Y0_S2MID[7] VPWR VGND sg13cmos5l_antennanp
XFILLER_716_123 VPWR VGND sg13cmos5l_decap_4
XFILLER_567_192 VPWR VGND sg13cmos5l_fill_1
XANTENNA_23 _4701_/X VPWR VGND sg13cmos5l_antennanp
XANTENNA_34 Tile_X0Y9_FrameStrobe[16] VPWR VGND sg13cmos5l_antennanp
XFILLER_177_165 VPWR VGND sg13cmos5l_fill_1
X_3816_ _3816_/X Tile_X0Y0_W2END[3] Tile_X0Y0_WW4END[10] _3859_/X _3858_/X _1073_/Q
+ _1072_/Q VPWR VGND sg13cmos5l_mux4_1
XANTENNA_45 Tile_X0Y9_N2MID[1] VPWR VGND sg13cmos5l_antennanp
XANTENNA_56 Tile_X0Y9_N2MID[6] VPWR VGND sg13cmos5l_antennanp
XFILLER_716_167 VPWR VGND sg13cmos5l_fill_1
X_4796_ _4796_/X Tile_X0Y4_W1END[2] Tile_X0Y4_WW4END[14] Tile_X0Y4_W6END[6] _4338_/X
+ _2115_/Q _2114_/Q VPWR VGND sg13cmos5l_mux4_1
XFILLER_326_118 VPWR VGND sg13cmos5l_decap_8
XFILLER_268_89 VPWR VGND sg13cmos5l_decap_8
XFILLER_177_187 VPWR VGND sg13cmos5l_decap_8
XFILLER_582_173 VPWR VGND sg13cmos5l_decap_8
XFILLER_565_21 VPWR VGND sg13cmos5l_decap_8
XFILLER_192_124 VPWR VGND sg13cmos5l_decap_8
X_3747_ AXI_M_SOC_ARADDR19 Tile_X0Y8_WW4END[3] Tile_X0Y8_WW4END[11] Tile_X0Y8_W6END[3]
+ _4803_/X _0497_/Q _0496_/Q VPWR VGND sg13cmos5l_mux4_1
X_0959_ _0959_/Q Tile_X0Y0_FrameData[12] VGND VPWR Tile_X0Y9_FrameStrobe[0] latch
XFILLER_21_49 VPWR VGND sg13cmos5l_decap_8
XFILLER_565_98 VPWR VGND sg13cmos5l_decap_8
XFILLER_715_35 VPWR VGND sg13cmos5l_decap_8
X_3678_ _3678_/X Tile_X0Y2_WW4END[0] Tile_X0Y2_WW4END[8] Tile_X0Y2_W6END[8] _4124_/X
+ _1489_/Q _1488_/Q VPWR VGND sg13cmos5l_mux4_1
XFILLER_137_49 VPWR VGND sg13cmos5l_decap_8
XFILLER_284_77 VPWR VGND sg13cmos5l_decap_8
XFILLER_334_195 VPWR VGND sg13cmos5l_decap_8
X_2629_ _2629_/Q Tile_X0Y6_FrameData[2] VGND VPWR Tile_X0Y9_FrameStrobe[5] latch
XFILLER_434_14 VPWR VGND sg13cmos5l_decap_8
XANTENNA__3245__X Tile_X0Y0_FrameData_O[13] VPWR VGND sg13cmos5l_antennanp
XFILLER_581_42 VPWR VGND sg13cmos5l_decap_8
XFILLER_495_147 VPWR VGND sg13cmos5l_decap_8
XFILLER_99_193 VPWR VGND sg13cmos5l_decap_8
XFILLER_101_132 VPWR VGND sg13cmos5l_decap_8
XFILLER_198_7 VPWR VGND sg13cmos5l_decap_8
XFILLER_247_136 VPWR VGND sg13cmos5l_decap_8
XFILLER_514_91 VPWR VGND sg13cmos5l_decap_8
XFILLER_652_133 VPWR VGND sg13cmos5l_decap_8
XFILLER_46_13 VPWR VGND sg13cmos5l_decap_8
XFILLER_450_35 VPWR VGND sg13cmos5l_decap_8
XFILLER_233_70 VPWR VGND sg13cmos5l_decap_8
XFILLER_365_7 VPWR VGND sg13cmos5l_decap_8
XFILLER_600_49 VPWR VGND sg13cmos5l_decap_8
XFILLER_15_127 VPWR VGND sg13cmos5l_fill_2
XFILLER_532_7 VPWR VGND sg13cmos5l_decap_8
XFILLER_102_63 VPWR VGND sg13cmos5l_decap_8
XFILLER_62_23 VPWR VGND sg13cmos5l_decap_8
XFILLER_23_160 VPWR VGND sg13cmos5l_decap_8
XFILLER_707_112 VPWR VGND sg13cmos5l_decap_8
XFILLER_609_14 VPWR VGND sg13cmos5l_decap_8
XFILLER_558_181 VPWR VGND sg13cmos5l_fill_1
XFILLER_168_143 VPWR VGND sg13cmos5l_decap_8
XFILLER_23_193 VPWR VGND sg13cmos5l_decap_8
XFILLER_178_56 VPWR VGND sg13cmos5l_decap_8
XFILLER_573_140 VPWR VGND sg13cmos5l_decap_8
XFILLER_372_202 VPWR VGND sg13cmos5l_decap_8
XFILLER_317_118 VPWR VGND sg13cmos5l_decap_4
XFILLER_475_21 VPWR VGND sg13cmos5l_decap_8
XFILLER_124_202 VPWR VGND sg13cmos5l_decap_8
XFILLER_625_35 VPWR VGND sg13cmos5l_decap_8
XFILLER_408_70 VPWR VGND sg13cmos5l_decap_8
XFILLER_194_77 VPWR VGND sg13cmos5l_decap_4
XFILLER_344_14 VPWR VGND sg13cmos5l_decap_8
XFILLER_194_88 VPWR VGND sg13cmos5l_decap_8
XANTENNA__3155__X Tile_X0Y7_FrameData_O[25] VPWR VGND sg13cmos5l_antennanp
XFILLER_2_0 VPWR VGND sg13cmos5l_decap_8
XFILLER_491_42 VPWR VGND sg13cmos5l_decap_8
XFILLER_340_154 VPWR VGND sg13cmos5l_fill_1
XFILLER_87_42 VPWR VGND sg13cmos5l_decap_8
XFILLER_340_176 VPWR VGND sg13cmos5l_fill_1
XFILLER_391_0 VPWR VGND sg13cmos5l_decap_8
XFILLER_489_0 VPWR VGND sg13cmos5l_decap_8
XANTENNA__2994__X Tile_X0Y5_E1BEG[1] VPWR VGND sg13cmos5l_antennanp
XFILLER_427_203 VPWR VGND sg13cmos5l_decap_8
XFILLER_690_228 VPWR VGND sg13cmos5l_fill_1
XFILLER_641_56 VPWR VGND sg13cmos5l_decap_8
XFILLER_424_91 VPWR VGND sg13cmos5l_decap_8
XFILLER_643_133 VPWR VGND sg13cmos5l_decap_8
XFILLER_360_35 VPWR VGND sg13cmos5l_decap_8
XFILLER_143_70 VPWR VGND sg13cmos5l_decap_8
XFILLER_656_0 VPWR VGND sg13cmos5l_decap_8
XFILLER_253_117 VPWR VGND sg13cmos5l_decap_4
XFILLER_253_128 VPWR VGND sg13cmos5l_decap_4
XFILLER_442_228 VPWR VGND sg13cmos5l_fill_1
XFILLER_246_191 VPWR VGND sg13cmos5l_fill_1
XFILLER_510_49 VPWR VGND sg13cmos5l_decap_8
XFILLER_36_90 VPWR VGND sg13cmos5l_fill_2
X_2980_ Tile_X0Y8_FrameData_O[20] Tile_X0Y8_FrameData[20] VPWR VGND sg13cmos5l_buf_1
XFILLER_410_136 VPWR VGND sg13cmos5l_decap_8
XFILLER_369_77 VPWR VGND sg13cmos5l_decap_8
X_1931_ _1931_/Q Tile_X0Y4_FrameData[26] VGND VPWR Tile_X0Y9_FrameStrobe[0] latch
XFILLER_519_14 VPWR VGND sg13cmos5l_decap_8
XFILLER_410_169 VPWR VGND sg13cmos5l_fill_1
XFILLER_666_42 VPWR VGND sg13cmos5l_decap_8
X_4650_ _4650_/X AXI_M_SOC_RDATA18 _4689_/X _4693_/X _4673_/X _0259_/Q _0258_/Q VPWR
+ VGND sg13cmos5l_mux4_1
XFILLER_159_176 VPWR VGND sg13cmos5l_decap_4
X_1862_ _1862_/Q Tile_X0Y3_FrameData[3] VGND VPWR Tile_X0Y9_FrameStrobe[5] latch
XFILLER_159_187 VPWR VGND sg13cmos5l_decap_8
XFILLER_385_21 VPWR VGND sg13cmos5l_decap_8
XFILLER_308_118 VPWR VGND sg13cmos5l_fill_1
X_3601_ Tile_X0Y9_FrameData_O[31] Tile_X0Y9_FrameData[31] VPWR VGND sg13cmos5l_buf_1
XFILLER_564_184 VPWR VGND sg13cmos5l_decap_8
X_0813_ _0813_/Q Tile_X0Y9_FrameData[18] VGND VPWR Tile_X0Y9_FrameStrobe[4] latch
XFILLER_713_126 VPWR VGND sg13cmos5l_decap_8
X_1793_ _1793_/Q Tile_X0Y3_FrameData[8] VGND VPWR Tile_X0Y9_FrameStrobe[3] latch
X_4581_ _4581_/X _4547_/X Tile_X0Y9_N4END[13] _4546_/X _0153_/X _2469_/Q _2468_/Q
+ VPWR VGND sg13cmos5l_mux4_1
X_3532_ Tile_X0Y9_E2BEG[6] _4854_/X VPWR VGND sg13cmos5l_buf_1
X_0744_ _0744_/Q Tile_X0Y9_FrameData[23] VGND VPWR Tile_X0Y9_FrameStrobe[2] latch
XFILLER_535_35 VPWR VGND sg13cmos5l_decap_8
XFILLER_318_70 VPWR VGND sg13cmos5l_decap_8
XFILLER_318_81 VPWR VGND sg13cmos5l_decap_4
XFILLER_682_63 VPWR VGND sg13cmos5l_decap_8
XFILLER_254_14 VPWR VGND sg13cmos5l_decap_8
X_0675_ _0675_/Q Tile_X0Y9_FrameData[28] VGND VPWR Tile_X0Y9_FrameStrobe[0] latch
X_3463_ Tile_X0Y1_FrameData_O[21] Tile_X0Y1_FrameData[21] VPWR VGND sg13cmos5l_buf_1
XFILLER_666_214 VPWR VGND sg13cmos5l_fill_2
XANTENNA__3065__X Tile_X0Y5_FrameData_O[24] VPWR VGND sg13cmos5l_antennanp
X_2414_ _2414_/Q Tile_X0Y5_FrameData[23] VGND VPWR Tile_X0Y9_FrameStrobe[7] latch
X_3394_ Tile_X0Y2_E2BEGb[5] _4053_/X VPWR VGND sg13cmos5l_buf_1
XFILLER_477_169 VPWR VGND sg13cmos5l_decap_4
XFILLER_35_0 VPWR VGND sg13cmos5l_fill_1
XFILLER_681_206 VPWR VGND sg13cmos5l_decap_8
XFILLER_404_28 VPWR VGND sg13cmos5l_decap_8
X_2345_ _2345_/Q Tile_X0Y5_FrameData[28] VGND VPWR Tile_X0Y9_FrameStrobe[5] latch
XFILLER_551_56 VPWR VGND sg13cmos5l_decap_8
XFILLER_334_91 VPWR VGND sg13cmos5l_decap_8
XFILLER_96_185 VPWR VGND sg13cmos5l_decap_8
X_2276_ _2276_/Q Tile_X0Y5_FrameData[1] VGND VPWR Tile_X0Y9_FrameStrobe[2] latch
XFILLER_634_133 VPWR VGND sg13cmos5l_decap_4
XFILLER_634_144 VPWR VGND sg13cmos5l_fill_1
XFILLER_270_35 VPWR VGND sg13cmos5l_decap_8
X_1227_ _1227_/Q Tile_X0Y1_FrameData[14] VGND VPWR Tile_X0Y9_FrameStrobe[1] latch
X_4015_ _4015_/X _3987_/X _0084_/X _3986_/X Tile_X0Y0_S4END[7] _1219_/Q _1218_/Q VPWR
+ VGND sg13cmos5l_mux4_1
XFILLER_433_228 VPWR VGND sg13cmos5l_fill_1
X_1158_ _1158_/Q Tile_X0Y0_FrameData[5] VGND VPWR Tile_X0Y9_FrameStrobe[6] latch
XFILLER_587_221 VPWR VGND sg13cmos5l_fill_1
XFILLER_420_49 VPWR VGND sg13cmos5l_decap_8
XFILLER_203_84 VPWR VGND sg13cmos5l_decap_8
XFILLER_16_49 VPWR VGND sg13cmos5l_decap_8
X_0109_ _0109_/X _4332_/X _4333_/X _1106_/Q VPWR VGND sg13cmos5l_mux2_1
XFILLER_197_216 VPWR VGND sg13cmos5l_decap_8
X_1089_ _1089_/Q Tile_X0Y0_FrameData[10] VGND VPWR Tile_X0Y9_FrameStrobe[4] latch
XFILLER_547_107 VPWR VGND sg13cmos5l_fill_1
XFILLER_197_227 VPWR VGND sg13cmos5l_fill_2
X_4917_ _4917_/X Tile_X0Y9_N1END[1] Tile_X0Y9_N4END[1] _4897_/X _0082_/X _0725_/Q
+ _0724_/Q VPWR VGND sg13cmos5l_mux4_1
XFILLER_279_77 VPWR VGND sg13cmos5l_decap_8
XFILLER_429_14 VPWR VGND sg13cmos5l_decap_8
XFILLER_576_42 VPWR VGND sg13cmos5l_decap_8
XFILLER_20_130 VPWR VGND sg13cmos5l_fill_2
X_4848_ _4848_/X Tile_X0Y9_W2MID[7] AXI_M_SOC_RDATA0 _4901_/X _4900_/X _0847_/Q _0846_/Q
+ VPWR VGND sg13cmos5l_mux4_1
XFILLER_295_21 VPWR VGND sg13cmos5l_decap_8
XFILLER_32_59 VPWR VGND sg13cmos5l_decap_8
XFILLER_704_126 VPWR VGND sg13cmos5l_decap_8
X_4779_ _4779_/X Tile_X0Y9_W1END[1] Tile_X0Y9_W6END[5] _4929_/X _4893_/X _0925_/Q
+ _0924_/Q VPWR VGND sg13cmos5l_mux4_1
XFILLER_570_154 VPWR VGND sg13cmos5l_decap_8
XFILLER_509_91 VPWR VGND sg13cmos5l_decap_8
XFILLER_180_105 VPWR VGND sg13cmos5l_fill_2
XFILLER_165_179 VPWR VGND sg13cmos5l_fill_2
XFILLER_113_7 VPWR VGND sg13cmos5l_decap_8
XFILLER_295_98 VPWR VGND sg13cmos5l_decap_8
XFILLER_445_35 VPWR VGND sg13cmos5l_decap_8
XFILLER_228_70 VPWR VGND sg13cmos5l_decap_8
XFILLER_180_138 VPWR VGND sg13cmos5l_fill_1
XFILLER_592_63 VPWR VGND sg13cmos5l_decap_8
XFILLER_307_195 VPWR VGND sg13cmos5l_decap_8
XFILLER_164_14 VPWR VGND sg13cmos5l_decap_8
XFILLER_468_147 VPWR VGND sg13cmos5l_decap_8
XFILLER_322_198 VPWR VGND sg13cmos5l_decap_8
XFILLER_482_7 VPWR VGND sg13cmos5l_decap_8
XFILLER_314_28 VPWR VGND sg13cmos5l_decap_8
XFILLER_87_141 VPWR VGND sg13cmos5l_decap_8
XANTENNA__3703__X AXI_M_SOC_WDATA13 VPWR VGND sg13cmos5l_antennanp
XFILLER_476_191 VPWR VGND sg13cmos5l_fill_2
XFILLER_461_56 VPWR VGND sg13cmos5l_decap_8
XFILLER_244_91 VPWR VGND sg13cmos5l_fill_2
XFILLER_57_56 VPWR VGND sg13cmos5l_decap_8
XFILLER_180_35 VPWR VGND sg13cmos5l_decap_8
XFILLER_491_161 VPWR VGND sg13cmos5l_decap_4
XFILLER_424_206 VPWR VGND sg13cmos5l_decap_8
XFILLER_491_172 VPWR VGND sg13cmos5l_decap_4
XFILLER_640_147 VPWR VGND sg13cmos5l_decap_8
XFILLER_578_210 VPWR VGND sg13cmos5l_fill_2
XFILLER_330_49 VPWR VGND sg13cmos5l_decap_8
XFILLER_389_154 VPWR VGND sg13cmos5l_decap_8
XFILLER_73_77 VPWR VGND sg13cmos5l_decap_8
XFILLER_389_176 VPWR VGND sg13cmos5l_decap_8
XFILLER_538_118 VPWR VGND sg13cmos5l_fill_1
XFILLER_339_14 VPWR VGND sg13cmos5l_decap_8
XFILLER_486_42 VPWR VGND sg13cmos5l_decap_8
XFILLER_237_0 VPWR VGND sg13cmos5l_decap_8
XFILLER_345_202 VPWR VGND sg13cmos5l_fill_2
XFILLER_345_213 VPWR VGND sg13cmos5l_fill_2
XANTENNA__2989__X Tile_X0Y8_FrameData_O[29] VPWR VGND sg13cmos5l_antennanp
XFILLER_546_195 VPWR VGND sg13cmos5l_decap_8
XFILLER_404_0 VPWR VGND sg13cmos5l_decap_8
XFILLER_636_56 VPWR VGND sg13cmos5l_decap_8
XFILLER_22_70 VPWR VGND sg13cmos5l_decap_8
XFILLER_419_91 VPWR VGND sg13cmos5l_decap_8
XFILLER_171_105 VPWR VGND sg13cmos5l_decap_8
XFILLER_355_35 VPWR VGND sg13cmos5l_decap_8
XFILLER_138_70 VPWR VGND sg13cmos5l_decap_8
XFILLER_502_210 VPWR VGND sg13cmos5l_decap_8
XFILLER_648_214 VPWR VGND sg13cmos5l_fill_2
XFILLER_313_132 VPWR VGND sg13cmos5l_decap_8
XFILLER_98_63 VPWR VGND sg13cmos5l_decap_8
XFILLER_648_225 VPWR VGND sg13cmos5l_decap_4
X_0460_ _0460_/Q Tile_X0Y8_FrameData[19] VGND VPWR Tile_X0Y9_FrameStrobe[1] latch
XFILLER_459_158 VPWR VGND sg13cmos5l_decap_8
XFILLER_505_49 VPWR VGND sg13cmos5l_decap_8
XFILLER_459_169 VPWR VGND sg13cmos5l_fill_1
XFILLER_652_77 VPWR VGND sg13cmos5l_decap_8
XFILLER_224_28 VPWR VGND sg13cmos5l_decap_8
X_0391_ _0391_/Q Tile_X0Y7_FrameData[24] VGND VPWR Tile_X0Y9_FrameStrobe[7] latch
XFILLER_266_220 VPWR VGND sg13cmos5l_decap_8
XANTENNA__3613__X Tile_X0Y9_S2BEG[7] VPWR VGND sg13cmos5l_antennanp
XFILLER_371_56 VPWR VGND sg13cmos5l_decap_8
X_2130_ _2130_/Q Tile_X0Y4_FrameData[19] VGND VPWR Tile_X0Y9_FrameStrobe[6] latch
XFILLER_78_174 VPWR VGND sg13cmos5l_decap_8
XFILLER_616_144 VPWR VGND sg13cmos5l_decap_8
X_2061_ _2061_/Q Tile_X0Y4_FrameData[24] VGND VPWR Tile_X0Y9_FrameStrobe[4] latch
X_1012_ _1012_/Q Tile_X0Y0_FrameData[23] VGND VPWR Tile_X0Y9_FrameStrobe[2] latch
XFILLER_569_221 VPWR VGND sg13cmos5l_fill_1
XFILLER_240_49 VPWR VGND sg13cmos5l_decap_8
XFILLER_601_70 VPWR VGND sg13cmos5l_decap_8
XFILLER_234_161 VPWR VGND sg13cmos5l_fill_2
XFILLER_584_202 VPWR VGND sg13cmos5l_fill_1
XFILLER_395_135 VPWR VGND sg13cmos5l_fill_1
XFILLER_677_63 VPWR VGND sg13cmos5l_decap_8
X_2963_ Tile_X0Y8_FrameData_O[3] Tile_X0Y8_FrameData[3] VPWR VGND sg13cmos5l_buf_1
XFILLER_249_14 VPWR VGND sg13cmos5l_decap_8
X_4702_ _4702_/X Tile_X0Y6_W2MID[6] Tile_X0Y6_W2END[6] Tile_X0Y6_W6END[9] _4555_/X
+ _2649_/Q _2648_/Q VPWR VGND sg13cmos5l_mux4_1
XFILLER_396_42 VPWR VGND sg13cmos5l_decap_8
XFILLER_194_219 VPWR VGND sg13cmos5l_fill_2
X_1914_ _1914_/Q Tile_X0Y3_FrameData[15] VGND VPWR Tile_X0Y9_FrameStrobe[7] latch
XFILLER_537_151 VPWR VGND sg13cmos5l_fill_2
XFILLER_147_102 VPWR VGND sg13cmos5l_fill_2
X_2894_ Tile_X0Y6_FrameData_O[15] Tile_X0Y6_FrameData[15] VPWR VGND sg13cmos5l_buf_1
XANTENNA__2899__X Tile_X0Y6_FrameData_O[20] VPWR VGND sg13cmos5l_antennanp
X_4633_ _4633_/X Tile_X0Y7_WW4END[10] AXI_M_SOC_RDATA21 _4694_/X _4673_/X _0293_/Q
+ _0292_/Q VPWR VGND sg13cmos5l_mux4_1
X_1845_ _1845_/Q Tile_X0Y3_FrameData[20] VGND VPWR Tile_X0Y9_FrameStrobe[5] latch
XFILLER_546_56 VPWR VGND sg13cmos5l_decap_8
X_4564_ _4564_/X Tile_X0Y2_W1END[2] Tile_X0Y2_WW4END[14] Tile_X0Y2_W6END[6] _4118_/X
+ _1607_/Q _1606_/Q VPWR VGND sg13cmos5l_mux4_1
XFILLER_693_84 VPWR VGND sg13cmos5l_decap_8
X_1776_ _1776_/Q Tile_X0Y3_FrameData[25] VGND VPWR Tile_X0Y9_FrameStrobe[3] latch
XFILLER_265_35 VPWR VGND sg13cmos5l_decap_8
XFILLER_552_187 VPWR VGND sg13cmos5l_decap_4
X_3515_ Tile_X0Y1_E2BEG[5] _3937_/X VPWR VGND sg13cmos5l_buf_1
X_0727_ _0727_/Q Tile_X0Y9_FrameData[8] VGND VPWR Tile_X0Y9_FrameStrobe[1] latch
XFILLER_639_214 VPWR VGND sg13cmos5l_fill_1
X_4495_ _4495_/X _4551_/X _4550_/X AXI_M_SOC_RDATA24 AXI_M_SOC_RDATA28 _2617_/Q _2616_/Q
+ VPWR VGND sg13cmos5l_mux4_1
X_3446_ Tile_X0Y1_FrameData_O[4] Tile_X0Y1_FrameData[4] VPWR VGND sg13cmos5l_buf_1
X_0658_ _0658_/Q Tile_X0Y8_FrameData[13] VGND VPWR Tile_X0Y9_FrameStrobe[7] latch
XFILLER_415_49 VPWR VGND sg13cmos5l_decap_8
XFILLER_562_77 VPWR VGND sg13cmos5l_decap_8
XFILLER_134_28 VPWR VGND sg13cmos5l_decap_8
XFILLER_712_14 VPWR VGND sg13cmos5l_decap_8
X_0589_ _0589_/Q Tile_X0Y8_FrameData[18] VGND VPWR Tile_X0Y9_FrameStrobe[5] latch
X_3377_ Tile_X0Y2_E6BEG[0] _4072_/X VPWR VGND sg13cmos5l_buf_1
XFILLER_281_56 VPWR VGND sg13cmos5l_decap_8
XANTENNA__3523__X Tile_X0Y9_E1BEG[1] VPWR VGND sg13cmos5l_antennanp
XFILLER_458_191 VPWR VGND sg13cmos5l_decap_8
X_2328_ _2328_/Q Tile_X0Y5_FrameData[13] VGND VPWR Tile_X0Y9_FrameStrobe[4] latch
XFILLER_69_196 VPWR VGND sg13cmos5l_decap_8
XFILLER_84_133 VPWR VGND sg13cmos5l_decap_8
XFILLER_473_161 VPWR VGND sg13cmos5l_fill_2
X_2259_ _2259_/Q Tile_X0Y5_FrameData[18] VGND VPWR Tile_X0Y9_FrameStrobe[2] latch
XFILLER_25_211 VPWR VGND sg13cmos5l_decap_8
XFILLER_150_49 VPWR VGND sg13cmos5l_decap_8
XFILLER_511_70 VPWR VGND sg13cmos5l_decap_8
XFILLER_43_14 VPWR VGND sg13cmos5l_decap_8
XFILLER_40_203 VPWR VGND sg13cmos5l_decap_8
XFILLER_587_63 VPWR VGND sg13cmos5l_decap_8
XFILLER_159_14 VPWR VGND sg13cmos5l_decap_8
XFILLER_230_7 VPWR VGND sg13cmos5l_decap_8
XFILLER_328_7 VPWR VGND sg13cmos5l_decap_8
XFILLER_590_216 VPWR VGND sg13cmos5l_fill_1
XANTENNA__0106__Y AXI_M_SOC_ARLEN3 VPWR VGND sg13cmos5l_antennanp
XFILLER_309_28 VPWR VGND sg13cmos5l_decap_8
XFILLER_138_168 VPWR VGND sg13cmos5l_decap_8
XFILLER_456_56 VPWR VGND sg13cmos5l_decap_8
XFILLER_239_91 VPWR VGND sg13cmos5l_decap_8
XFILLER_456_78 VPWR VGND sg13cmos5l_fill_1
XFILLER_456_89 VPWR VGND sg13cmos5l_fill_2
XFILLER_175_35 VPWR VGND sg13cmos5l_decap_8
XFILLER_697_7 VPWR VGND sg13cmos5l_decap_8
XFILLER_325_49 VPWR VGND sg13cmos5l_decap_8
XFILLER_108_84 VPWR VGND sg13cmos5l_decap_4
XFILLER_645_217 VPWR VGND sg13cmos5l_decap_8
XFILLER_472_77 VPWR VGND sg13cmos5l_fill_2
XFILLER_622_14 VPWR VGND sg13cmos5l_decap_8
XFILLER_645_228 VPWR VGND sg13cmos5l_fill_1
XFILLER_68_77 VPWR VGND sg13cmos5l_decap_4
XANTENNA__3433__X Tile_X0Y4_FrameData_O[24] VPWR VGND sg13cmos5l_antennanp
XFILLER_191_56 VPWR VGND sg13cmos5l_decap_8
XFILLER_75_122 VPWR VGND sg13cmos5l_decap_8
XFILLER_124_61 VPWR VGND sg13cmos5l_decap_8
XFILLER_84_21 VPWR VGND sg13cmos5l_decap_8
XFILLER_187_0 VPWR VGND sg13cmos5l_decap_8
XFILLER_75_166 VPWR VGND sg13cmos5l_decap_8
XFILLER_702_80 VPWR VGND sg13cmos5l_decap_8
XFILLER_613_136 VPWR VGND sg13cmos5l_decap_8
XFILLER_613_158 VPWR VGND sg13cmos5l_decap_8
XFILLER_421_70 VPWR VGND sg13cmos5l_decap_8
XFILLER_84_98 VPWR VGND sg13cmos5l_decap_8
XFILLER_354_0 VPWR VGND sg13cmos5l_decap_8
XFILLER_17_70 VPWR VGND sg13cmos5l_decap_8
XFILLER_31_203 VPWR VGND sg13cmos5l_decap_8
XFILLER_231_153 VPWR VGND sg13cmos5l_decap_8
XFILLER_497_63 VPWR VGND sg13cmos5l_decap_8
XFILLER_377_146 VPWR VGND sg13cmos5l_decap_8
XFILLER_521_0 VPWR VGND sg13cmos5l_decap_8
XFILLER_377_157 VPWR VGND sg13cmos5l_fill_1
XFILLER_619_0 VPWR VGND sg13cmos5l_decap_8
XFILLER_231_197 VPWR VGND sg13cmos5l_fill_2
XFILLER_519_151 VPWR VGND sg13cmos5l_fill_1
XFILLER_33_80 VPWR VGND sg13cmos5l_decap_8
XFILLER_76_7 VPWR VGND sg13cmos5l_decap_8
XFILLER_647_77 VPWR VGND sg13cmos5l_decap_8
XFILLER_219_28 VPWR VGND sg13cmos5l_decap_8
XFILLER_129_146 VPWR VGND sg13cmos5l_decap_8
XFILLER_366_56 VPWR VGND sg13cmos5l_decap_8
XANTENNA__3608__X Tile_X0Y9_S2BEG[2] VPWR VGND sg13cmos5l_antennanp
XFILLER_144_105 VPWR VGND sg13cmos5l_decap_8
X_1630_ _1630_/Q Tile_X0Y2_FrameData[19] VGND VPWR Tile_X0Y9_FrameStrobe[6] latch
XFILLER_663_21 VPWR VGND sg13cmos5l_decap_8
XFILLER_333_227 VPWR VGND sg13cmos5l_fill_2
XFILLER_534_198 VPWR VGND sg13cmos5l_decap_8
X_1561_ _1561_/Q Tile_X0Y2_FrameData[24] VGND VPWR Tile_X0Y9_FrameStrobe[4] latch
XFILLER_98_203 VPWR VGND sg13cmos5l_decap_8
X_3300_ Tile_X0Y0_E2BEG[0] _3804_/X VPWR VGND sg13cmos5l_buf_1
X_0512_ _0512_/Q Tile_X0Y8_FrameData[31] VGND VPWR Tile_X0Y9_FrameStrobe[3] latch
X_1492_ _1492_/Q Tile_X0Y2_FrameData[29] VGND VPWR Tile_X0Y9_FrameStrobe[2] latch
X_4280_ _4280_/X Tile_X0Y4_WW4END[7] AXI_M_SOC_BRESP1 _4343_/X _4312_/X _2053_/Q _2052_/Q
+ VPWR VGND sg13cmos5l_mux4_1
XFILLER_663_98 VPWR VGND sg13cmos5l_decap_8
XFILLER_235_49 VPWR VGND sg13cmos5l_decap_8
XFILLER_152_182 VPWR VGND sg13cmos5l_fill_2
X_0443_ _0443_/Q Tile_X0Y8_FrameData[4] VGND VPWR Tile_X0Y9_FrameStrobe[0] latch
X_3231_ Tile_X0Y0_FrameStrobe_O[19] Tile_X0Y9_FrameStrobe[19] VPWR VGND sg13cmos5l_buf_1
XFILLER_532_14 VPWR VGND sg13cmos5l_decap_8
XANTENNA__3343__X Tile_X0Y2_FrameData_O[14] VPWR VGND sg13cmos5l_antennanp
XFILLER_100_219 VPWR VGND sg13cmos5l_decap_8
X_0374_ _0374_/Q Tile_X0Y7_FrameData[9] VGND VPWR Tile_X0Y9_FrameStrobe[6] latch
X_3162_ Tile_X0Y7_UserCLKo Tile_X0Y7_UserCLK VPWR VGND sg13cmos5l_buf_1
XFILLER_66_122 VPWR VGND sg13cmos5l_decap_8
X_2113_ _2113_/Q Tile_X0Y4_FrameData[4] VGND VPWR Tile_X0Y9_FrameStrobe[5] latch
X_3093_ Tile_X0Y7_E2BEG[7] _4619_/X VPWR VGND sg13cmos5l_buf_1
XFILLER_612_91 VPWR VGND sg13cmos5l_decap_8
X_2044_ _2044_/Q Tile_X0Y4_FrameData[9] VGND VPWR Tile_X0Y9_FrameStrobe[3] latch
XFILLER_66_199 VPWR VGND sg13cmos5l_fill_2
XFILLER_604_158 VPWR VGND sg13cmos5l_decap_4
XFILLER_81_136 VPWR VGND sg13cmos5l_decap_8
XFILLER_331_70 VPWR VGND sg13cmos5l_decap_8
XFILLER_207_161 VPWR VGND sg13cmos5l_decap_8
XFILLER_688_84 VPWR VGND sg13cmos5l_decap_8
XFILLER_411_220 VPWR VGND sg13cmos5l_decap_8
XFILLER_22_225 VPWR VGND sg13cmos5l_decap_4
X_3995_ _3995_/X _3894_/X _4027_/X _4026_/X Tile_X0Y0_S2MID[3] _1195_/Q _1194_/Q VPWR
+ VGND sg13cmos5l_mux4_1
XFILLER_200_63 VPWR VGND sg13cmos5l_decap_8
X_2946_ Tile_X0Y8_EE4BEG[2] _4746_/X VPWR VGND sg13cmos5l_buf_1
XFILLER_383_116 VPWR VGND sg13cmos5l_decap_8
XFILLER_383_127 VPWR VGND sg13cmos5l_fill_2
XFILLER_309_213 VPWR VGND sg13cmos5l_fill_1
XFILLER_13_28 VPWR VGND sg13cmos5l_decap_8
XFILLER_557_77 VPWR VGND sg13cmos5l_decap_8
XFILLER_707_14 VPWR VGND sg13cmos5l_decap_8
XFILLER_129_28 VPWR VGND sg13cmos5l_decap_8
X_2877_ Tile_X0Y6_EE4BEG[14] _4526_/X VPWR VGND sg13cmos5l_buf_1
XFILLER_276_56 VPWR VGND sg13cmos5l_decap_8
XANTENNA__3518__X Tile_X0Y1_E1BEG[0] VPWR VGND sg13cmos5l_antennanp
XFILLER_135_105 VPWR VGND sg13cmos5l_decap_8
X_4616_ _4616_/X Tile_X0Y7_W2MID[3] AXI_M_SOC_RDATA20 _4675_/X _4674_/X _0327_/Q _0326_/Q
+ VPWR VGND sg13cmos5l_mux4_1
X_1828_ _1828_/Q Tile_X0Y3_FrameData[5] VGND VPWR Tile_X0Y9_FrameStrobe[4] latch
XFILLER_190_211 VPWR VGND sg13cmos5l_fill_2
XFILLER_573_21 VPWR VGND sg13cmos5l_decap_8
X_4547_ _4547_/X Tile_X0Y7_W1END[1] Tile_X0Y7_W6END[5] _4697_/X _4657_/X _0413_/Q
+ _0412_/Q VPWR VGND sg13cmos5l_mux4_1
XFILLER_686_128 VPWR VGND sg13cmos5l_decap_4
X_1759_ _1759_/Q Tile_X0Y3_FrameData[10] VGND VPWR Tile_X0Y9_FrameStrobe[2] latch
XFILLER_679_191 VPWR VGND sg13cmos5l_decap_8
XFILLER_540_168 VPWR VGND sg13cmos5l_decap_8
XFILLER_573_98 VPWR VGND sg13cmos5l_decap_8
X_4478_ _4478_/X Tile_X0Y4_W1END[1] Tile_X0Y4_W2MID[2] Tile_X0Y4_W2END[2] _4316_/X
+ _2127_/Q _2126_/Q VPWR VGND sg13cmos5l_mux4_1
XFILLER_145_49 VPWR VGND sg13cmos5l_decap_8
XFILLER_143_182 VPWR VGND sg13cmos5l_decap_8
XFILLER_506_70 VPWR VGND sg13cmos5l_decap_8
XFILLER_292_77 VPWR VGND sg13cmos5l_decap_8
X_3429_ Tile_X0Y4_FrameData_O[20] Tile_X0Y4_FrameData[20] VPWR VGND sg13cmos5l_buf_1
XFILLER_442_14 VPWR VGND sg13cmos5l_decap_8
XANTENNA__3253__X Tile_X0Y0_FrameData_O[21] VPWR VGND sg13cmos5l_antennanp
XFILLER_38_14 VPWR VGND sg13cmos5l_decap_8
XFILLER_180_7 VPWR VGND sg13cmos5l_decap_8
XFILLER_57_166 VPWR VGND sg13cmos5l_decap_8
XFILLER_278_7 VPWR VGND sg13cmos5l_decap_8
XFILLER_522_91 VPWR VGND sg13cmos5l_decap_8
XFILLER_241_70 VPWR VGND sg13cmos5l_decap_8
XFILLER_54_35 VPWR VGND sg13cmos5l_decap_8
XFILLER_445_7 VPWR VGND sg13cmos5l_decap_8
XFILLER_598_84 VPWR VGND sg13cmos5l_decap_8
XFILLER_359_157 VPWR VGND sg13cmos5l_fill_2
XFILLER_213_175 VPWR VGND sg13cmos5l_decap_8
XANTENNA__0117__X AXI_M_SOC_ARCACHE0 VPWR VGND sg13cmos5l_antennanp
XFILLER_612_7 VPWR VGND sg13cmos5l_decap_8
XFILLER_110_63 VPWR VGND sg13cmos5l_decap_8
XFILLER_563_227 VPWR VGND sg13cmos5l_fill_2
XFILLER_467_66 VPWR VGND sg13cmos5l_decap_8
XFILLER_70_56 VPWR VGND sg13cmos5l_decap_8
XFILLER_617_14 VPWR VGND sg13cmos5l_decap_8
XFILLER_516_143 VPWR VGND sg13cmos5l_fill_1
XANTENNA__3428__X Tile_X0Y4_FrameData_O[19] VPWR VGND sg13cmos5l_antennanp
XFILLER_186_56 VPWR VGND sg13cmos5l_decap_8
XFILLER_126_105 VPWR VGND sg13cmos5l_decap_8
XFILLER_516_165 VPWR VGND sg13cmos5l_decap_8
XFILLER_181_222 VPWR VGND sg13cmos5l_decap_8
XFILLER_483_21 VPWR VGND sg13cmos5l_decap_8
XFILLER_79_21 VPWR VGND sg13cmos5l_decap_8
XFILLER_531_157 VPWR VGND sg13cmos5l_decap_8
XFILLER_102_0 VPWR VGND sg13cmos5l_decap_8
XFILLER_141_119 VPWR VGND sg13cmos5l_decap_8
XFILLER_483_98 VPWR VGND sg13cmos5l_decap_8
XFILLER_633_35 VPWR VGND sg13cmos5l_decap_8
XFILLER_416_70 VPWR VGND sg13cmos5l_decap_8
XFILLER_134_193 VPWR VGND sg13cmos5l_decap_8
XFILLER_295_112 VPWR VGND sg13cmos5l_decap_8
XFILLER_352_14 VPWR VGND sg13cmos5l_decap_8
XFILLER_295_123 VPWR VGND sg13cmos5l_fill_1
XFILLER_618_228 VPWR VGND sg13cmos5l_fill_1
XANTENNA__3163__X Tile_X0Y4_E6BEG[0] VPWR VGND sg13cmos5l_antennanp
XFILLER_295_145 VPWR VGND sg13cmos5l_decap_8
XFILLER_48_100 VPWR VGND sg13cmos5l_decap_8
XFILLER_95_42 VPWR VGND sg13cmos5l_decap_8
XFILLER_471_0 VPWR VGND sg13cmos5l_decap_8
XFILLER_569_0 VPWR VGND sg13cmos5l_decap_8
XFILLER_502_28 VPWR VGND sg13cmos5l_decap_8
XFILLER_95_86 VPWR VGND sg13cmos5l_decap_8
XFILLER_452_131 VPWR VGND sg13cmos5l_decap_4
XFILLER_432_91 VPWR VGND sg13cmos5l_decap_8
X_0090_ _3625_/A _4490_/X _4491_/X _2624_/Q VPWR VGND sg13cmos5l_mux2_1
XFILLER_63_125 VPWR VGND sg13cmos5l_decap_8
XFILLER_28_91 VPWR VGND sg13cmos5l_decap_8
XFILLER_151_70 VPWR VGND sg13cmos5l_fill_2
XFILLER_397_208 VPWR VGND sg13cmos5l_fill_1
XFILLER_251_226 VPWR VGND sg13cmos5l_fill_2
XFILLER_601_128 VPWR VGND sg13cmos5l_fill_2
XFILLER_658_21 VPWR VGND sg13cmos5l_decap_8
XFILLER_301_84 VPWR VGND sg13cmos5l_decap_4
XFILLER_204_175 VPWR VGND sg13cmos5l_decap_8
X_2800_ Tile_X0Y3_E6BEG[10] _4190_/X VPWR VGND sg13cmos5l_buf_1
XFILLER_365_105 VPWR VGND sg13cmos5l_decap_8
XFILLER_204_197 VPWR VGND sg13cmos5l_fill_1
X_3780_ _3780_/X Tile_X0Y0_W1END[0] Tile_X0Y0_W6END[4] _3875_/X _3862_/X _1177_/Q
+ _1176_/Q VPWR VGND sg13cmos5l_mux4_1
XFILLER_658_98 VPWR VGND sg13cmos5l_decap_8
X_0992_ _0992_/Q Tile_X0Y0_FrameData[11] VGND VPWR Tile_X0Y9_FrameStrobe[1] latch
X_2731_ _3862_/A3 VPWR VGND sg13cmos5l_tielo
XFILLER_377_77 VPWR VGND sg13cmos5l_fill_2
XFILLER_358_190 VPWR VGND sg13cmos5l_fill_2
XFILLER_527_14 VPWR VGND sg13cmos5l_decap_8
XANTENNA__3338__X Tile_X0Y2_FrameData_O[9] VPWR VGND sg13cmos5l_antennanp
XFILLER_674_42 VPWR VGND sg13cmos5l_decap_8
XFILLER_507_154 VPWR VGND sg13cmos5l_decap_8
XFILLER_380_119 VPWR VGND sg13cmos5l_decap_8
X_2662_ _2662_/Q Tile_X0Y6_FrameData[1] VGND VPWR Tile_X0Y9_FrameStrobe[6] latch
XFILLER_393_21 VPWR VGND sg13cmos5l_decap_8
XFILLER_117_138 VPWR VGND sg13cmos5l_decap_8
X_4401_ _4401_/X Tile_X0Y5_WW4END[2] AXI_M_SOC_RRESP0 _4453_/X _4432_/X _2301_/Q _2300_/Q
+ VPWR VGND sg13cmos5l_mux4_1
X_1613_ _1613_/Q Tile_X0Y2_FrameData[4] VGND VPWR Tile_X0Y9_FrameStrobe[5] latch
X_2593_ _2593_/Q Tile_X0Y6_FrameData[6] VGND VPWR Tile_X0Y9_FrameStrobe[4] latch
XFILLER_321_208 VPWR VGND sg13cmos5l_decap_8
XFILLER_607_91 VPWR VGND sg13cmos5l_decap_8
XFILLER_132_119 VPWR VGND sg13cmos5l_decap_8
X_4332_ _4332_/X Tile_X0Y0_W1END[3] Tile_X0Y0_WW4END[15] Tile_X0Y0_W6END[7] _3884_/X
+ _1108_/Q _1107_/Q VPWR VGND sg13cmos5l_mux4_1
X_1544_ _1544_/Q Tile_X0Y2_FrameData[9] VGND VPWR Tile_X0Y9_FrameStrobe[3] latch
XFILLER_543_35 VPWR VGND sg13cmos5l_decap_8
XFILLER_5_84 VPWR VGND sg13cmos5l_decap_8
XFILLER_326_70 VPWR VGND sg13cmos5l_decap_8
XFILLER_286_112 VPWR VGND sg13cmos5l_decap_8
XFILLER_690_63 VPWR VGND sg13cmos5l_decap_8
X_4263_ _4263_/X Tile_X0Y4_W2MID[0] AXI_M_SOC_BRESP1 _4313_/X _4312_/X _2087_/Q _2086_/Q
+ VPWR VGND sg13cmos5l_mux4_1
XFILLER_262_14 VPWR VGND sg13cmos5l_decap_8
XANTENNA__3073__X Tile_X0Y5_UserCLKo VPWR VGND sg13cmos5l_antennanp
X_1475_ _1475_/Q Tile_X0Y2_FrameData[14] VGND VPWR Tile_X0Y9_FrameStrobe[1] latch
XFILLER_140_152 VPWR VGND sg13cmos5l_decap_8
X_3214_ Tile_X0Y0_FrameStrobe_O[2] Tile_X0Y9_FrameStrobe[2] VPWR VGND sg13cmos5l_buf_1
XFILLER_286_167 VPWR VGND sg13cmos5l_fill_1
X_0426_ _0426_/Q Tile_X0Y8_FrameData[21] VGND VPWR Tile_X0Y9_FrameStrobe[0] latch
X_4194_ _4194_/X Tile_X0Y2_W1END[0] Tile_X0Y2_W6END[8] _4113_/X _4084_/X _1637_/Q
+ _1636_/Q VPWR VGND sg13cmos5l_mux4_1
XFILLER_286_189 VPWR VGND sg13cmos5l_decap_8
XFILLER_428_161 VPWR VGND sg13cmos5l_decap_8
X_3145_ Tile_X0Y7_FrameData_O[15] Tile_X0Y7_FrameData[15] VPWR VGND sg13cmos5l_buf_1
X_0357_ _0357_/Q Tile_X0Y7_FrameData[26] VGND VPWR Tile_X0Y9_FrameStrobe[6] latch
XFILLER_699_61 VPWR VGND sg13cmos5l_decap_8
XFILLER_54_103 VPWR VGND sg13cmos5l_decap_8
XFILLER_342_91 VPWR VGND sg13cmos5l_decap_8
XFILLER_443_142 VPWR VGND sg13cmos5l_fill_1
X_0288_ _0288_/Q Tile_X0Y7_FrameData[31] VGND VPWR Tile_X0Y9_FrameStrobe[4] latch
X_3076_ Tile_X0Y4_E2BEGb[2] _4266_/X VPWR VGND sg13cmos5l_buf_1
XFILLER_199_119 VPWR VGND sg13cmos5l_decap_4
X_2027_ _2027_/Q Tile_X0Y4_FrameData[26] VGND VPWR Tile_X0Y9_FrameStrobe[3] latch
XFILLER_568_21 VPWR VGND sg13cmos5l_decap_8
XFILLER_211_84 VPWR VGND sg13cmos5l_decap_8
XFILLER_24_49 VPWR VGND sg13cmos5l_decap_8
XFILLER_210_112 VPWR VGND sg13cmos5l_decap_8
XFILLER_356_105 VPWR VGND sg13cmos5l_decap_8
XFILLER_568_98 VPWR VGND sg13cmos5l_decap_8
X_3978_ _3978_/X _3985_/X Tile_X0Y1_W6END[2] _3984_/X _3978_/A3 _1181_/Q _1180_/Q
+ VPWR VGND sg13cmos5l_mux4_1
XFILLER_349_190 VPWR VGND sg13cmos5l_fill_2
XFILLER_287_77 VPWR VGND sg13cmos5l_decap_8
X_2929_ Tile_X0Y8_E2BEGb[5] _4741_/X VPWR VGND sg13cmos5l_buf_1
XFILLER_437_14 VPWR VGND sg13cmos5l_decap_8
XFILLER_210_189 VPWR VGND sg13cmos5l_decap_4
XANTENNA__3248__X Tile_X0Y0_FrameData_O[16] VPWR VGND sg13cmos5l_antennanp
XFILLER_584_42 VPWR VGND sg13cmos5l_decap_8
XFILLER_371_119 VPWR VGND sg13cmos5l_decap_8
XFILLER_702_213 VPWR VGND sg13cmos5l_fill_2
XFILLER_108_149 VPWR VGND sg13cmos5l_decap_4
XFILLER_517_91 VPWR VGND sg13cmos5l_decap_4
XFILLER_6_7 VPWR VGND sg13cmos5l_decap_8
XFILLER_453_35 VPWR VGND sg13cmos5l_decap_8
XFILLER_236_70 VPWR VGND sg13cmos5l_decap_8
XFILLER_49_24 VPWR VGND sg13cmos5l_decap_8
XFILLER_277_112 VPWR VGND sg13cmos5l_decap_8
XFILLER_172_14 VPWR VGND sg13cmos5l_decap_8
XFILLER_395_7 VPWR VGND sg13cmos5l_decap_8
XFILLER_77_228 VPWR VGND sg13cmos5l_fill_1
XFILLER_603_49 VPWR VGND sg13cmos5l_decap_8
XFILLER_292_126 VPWR VGND sg13cmos5l_decap_4
XFILLER_562_7 VPWR VGND sg13cmos5l_decap_8
XFILLER_322_28 VPWR VGND sg13cmos5l_decap_8
XFILLER_105_63 VPWR VGND sg13cmos5l_decap_8
XFILLER_682_197 VPWR VGND sg13cmos5l_fill_1
XANTENNA__3711__X AXI_M_SOC_WDATA21 VPWR VGND sg13cmos5l_antennanp
XFILLER_252_91 VPWR VGND sg13cmos5l_decap_8
XFILLER_65_56 VPWR VGND sg13cmos5l_decap_8
XFILLER_233_215 VPWR VGND sg13cmos5l_decap_4
XFILLER_65_78 VPWR VGND sg13cmos5l_decap_8
XFILLER_478_21 VPWR VGND sg13cmos5l_decap_8
XFILLER_201_112 VPWR VGND sg13cmos5l_decap_8
XFILLER_347_105 VPWR VGND sg13cmos5l_decap_8
XFILLER_201_123 VPWR VGND sg13cmos5l_fill_1
XFILLER_201_145 VPWR VGND sg13cmos5l_decap_4
XFILLER_197_77 VPWR VGND sg13cmos5l_decap_8
XFILLER_628_68 VPWR VGND sg13cmos5l_decap_8
XFILLER_347_14 VPWR VGND sg13cmos5l_decap_8
XANTENNA__3158__X Tile_X0Y7_FrameData_O[28] VPWR VGND sg13cmos5l_antennanp
XFILLER_317_0 VPWR VGND sg13cmos5l_decap_8
XFILLER_494_42 VPWR VGND sg13cmos5l_decap_8
XFILLER_362_119 VPWR VGND sg13cmos5l_decap_8
XFILLER_355_182 VPWR VGND sg13cmos5l_decap_8
XANTENNA__2997__X Tile_X0Y5_E2BEG[0] VPWR VGND sg13cmos5l_antennanp
XFILLER_644_56 VPWR VGND sg13cmos5l_decap_8
XFILLER_114_119 VPWR VGND sg13cmos5l_decap_8
XFILLER_427_91 VPWR VGND sg13cmos5l_decap_8
XFILLER_363_35 VPWR VGND sg13cmos5l_decap_8
XFILLER_146_70 VPWR VGND sg13cmos5l_decap_8
XFILLER_686_0 VPWR VGND sg13cmos5l_decap_8
X_1260_ _1260_/Q Tile_X0Y1_FrameData[13] VGND VPWR Tile_X0Y9_FrameStrobe[2] latch
XFILLER_417_109 VPWR VGND sg13cmos5l_fill_2
XFILLER_513_49 VPWR VGND sg13cmos5l_decap_8
XFILLER_268_189 VPWR VGND sg13cmos5l_decap_8
XFILLER_209_201 VPWR VGND sg13cmos5l_decap_8
XFILLER_283_126 VPWR VGND sg13cmos5l_decap_8
XFILLER_472_226 VPWR VGND sg13cmos5l_fill_2
XFILLER_209_212 VPWR VGND sg13cmos5l_fill_2
X_0211_ _0211_/Q Tile_X0Y7_FrameData[12] VGND VPWR Tile_X0Y9_FrameStrobe[1] latch
XFILLER_660_77 VPWR VGND sg13cmos5l_decap_8
XFILLER_232_28 VPWR VGND sg13cmos5l_decap_8
X_1191_ _1191_/Q Tile_X0Y1_FrameData[18] VGND VPWR Tile_X0Y9_FrameStrobe[0] latch
XFILLER_162_80 VPWR VGND sg13cmos5l_fill_1
XFILLER_36_103 VPWR VGND sg13cmos5l_decap_8
XANTENNA__3621__X Tile_X0Y9_S2BEGb[7] VPWR VGND sg13cmos5l_antennanp
X_0142_ _3187_/A _3904_/X _3905_/X _1390_/Q VPWR VGND sg13cmos5l_mux2_1
XFILLER_425_175 VPWR VGND sg13cmos5l_decap_8
XFILLER_669_42 VPWR VGND sg13cmos5l_decap_8
XFILLER_586_105 VPWR VGND sg13cmos5l_decap_8
XFILLER_440_112 VPWR VGND sg13cmos5l_fill_1
X_0073_ _0073_/X _3997_/X _3998_/X _2413_/Q VPWR VGND sg13cmos5l_mux2_1
XFILLER_51_117 VPWR VGND sg13cmos5l_decap_8
XFILLER_388_21 VPWR VGND sg13cmos5l_decap_8
X_3901_ _3901_/X Tile_X0Y1_W2MID[1] Tile_X0Y1_W2END[1] Tile_X0Y1_W6END[1] _3990_/X
+ _1405_/Q _1404_/Q VPWR VGND sg13cmos5l_mux4_1
XFILLER_51_139 VPWR VGND sg13cmos5l_decap_8
X_4881_ _4881_/X Tile_X0Y9_N4END[1] _0082_/X _4926_/X _4930_/X _0781_/Q _0780_/Q VPWR
+ VGND sg13cmos5l_mux4_1
XFILLER_393_200 VPWR VGND sg13cmos5l_decap_8
X_3832_ _3832_/X Tile_X0Y0_WW4END[3] _3884_/X _3859_/X _3861_/X _1041_/Q _1040_/Q
+ VPWR VGND sg13cmos5l_mux4_1
XFILLER_189_196 VPWR VGND sg13cmos5l_decap_8
XFILLER_538_35 VPWR VGND sg13cmos5l_decap_8
XFILLER_685_63 VPWR VGND sg13cmos5l_decap_8
X_3763_ _3763_/X Tile_X0Y1_WW4END[4] Tile_X0Y1_WW4END[12] Tile_X0Y1_W6END[4] _4012_/X
+ _1249_/Q _1248_/Q VPWR VGND sg13cmos5l_mux4_1
XFILLER_257_14 VPWR VGND sg13cmos5l_decap_8
X_0975_ _0975_/Q Tile_X0Y0_FrameData[28] VGND VPWR Tile_X0Y9_FrameStrobe[1] latch
XANTENNA__3068__X Tile_X0Y5_FrameData_O[27] VPWR VGND sg13cmos5l_antennanp
XFILLER_353_119 VPWR VGND sg13cmos5l_decap_8
X_2714_ _4541_/A3 VPWR VGND sg13cmos5l_tielo
XFILLER_145_211 VPWR VGND sg13cmos5l_decap_8
X_3694_ AXI_M_SOC_WDATA4 Tile_X0Y7_WW4END[4] Tile_X0Y7_WW4END[12] Tile_X0Y7_W6END[4]
+ _4688_/X _0239_/Q _0238_/Q VPWR VGND sg13cmos5l_mux4_1
XFILLER_65_0 VPWR VGND sg13cmos5l_decap_4
X_2645_ _2645_/Q Tile_X0Y6_FrameData[18] VGND VPWR Tile_X0Y9_FrameStrobe[6] latch
XFILLER_407_28 VPWR VGND sg13cmos5l_decap_8
XFILLER_554_56 VPWR VGND sg13cmos5l_decap_8
XFILLER_510_105 VPWR VGND sg13cmos5l_decap_8
XFILLER_160_225 VPWR VGND sg13cmos5l_decap_4
X_2576_ _2576_/Q Tile_X0Y6_FrameData[23] VGND VPWR Tile_X0Y9_FrameStrobe[4] latch
XFILLER_273_35 VPWR VGND sg13cmos5l_decap_8
XFILLER_448_212 VPWR VGND sg13cmos5l_decap_4
X_4315_ _4315_/X _4239_/X _4355_/X _4354_/X _4238_/X _1947_/Q _1946_/Q VPWR VGND sg13cmos5l_mux4_1
X_1527_ _1527_/Q Tile_X0Y2_FrameData[26] VGND VPWR Tile_X0Y9_FrameStrobe[3] latch
XFILLER_59_228 VPWR VGND sg13cmos5l_fill_1
XFILLER_113_174 VPWR VGND sg13cmos5l_decap_8
X_4246_ _4246_/X Tile_X0Y2_W1END[1] Tile_X0Y2_W2MID[2] Tile_X0Y2_W2END[2] _4100_/X
+ _1619_/Q _1618_/Q VPWR VGND sg13cmos5l_mux4_1
X_1458_ _1458_/Q Tile_X0Y2_FrameData[31] VGND VPWR Tile_X0Y9_FrameStrobe[1] latch
XFILLER_423_49 VPWR VGND sg13cmos5l_decap_8
XFILLER_206_84 VPWR VGND sg13cmos5l_decap_8
XFILLER_274_126 VPWR VGND sg13cmos5l_decap_8
XFILLER_664_186 VPWR VGND sg13cmos5l_fill_2
XFILLER_570_77 VPWR VGND sg13cmos5l_decap_8
XFILLER_19_49 VPWR VGND sg13cmos5l_decap_8
X_0409_ _0409_/Q Tile_X0Y7_FrameData[6] VGND VPWR Tile_X0Y9_FrameStrobe[7] latch
XFILLER_142_28 VPWR VGND sg13cmos5l_decap_8
X_4177_ _4177_/X Tile_X0Y3_WW4END[2] AXI_M_SOC_WREADY _4224_/X _4209_/X _1787_/Q _1786_/Q
+ VPWR VGND sg13cmos5l_mux4_1
X_1389_ _1389_/Q Tile_X0Y1_FrameData[12] VGND VPWR Tile_X0Y9_FrameStrobe[6] latch
XFILLER_27_103 VPWR VGND sg13cmos5l_fill_1
XANTENNA__3531__X Tile_X0Y9_E2BEG[5] VPWR VGND sg13cmos5l_antennanp
XFILLER_416_142 VPWR VGND sg13cmos5l_decap_8
X_3128_ Tile_X0Y7_EE4BEG[14] _4642_/X VPWR VGND sg13cmos5l_buf_1
XFILLER_27_125 VPWR VGND sg13cmos5l_decap_4
XFILLER_215_204 VPWR VGND sg13cmos5l_decap_8
XFILLER_27_147 VPWR VGND sg13cmos5l_fill_1
XFILLER_579_42 VPWR VGND sg13cmos5l_decap_8
XFILLER_431_112 VPWR VGND sg13cmos5l_decap_8
XFILLER_577_105 VPWR VGND sg13cmos5l_decap_8
X_3059_ Tile_X0Y5_FrameData_O[18] Tile_X0Y5_FrameData[18] VPWR VGND sg13cmos5l_buf_1
XFILLER_298_21 VPWR VGND sg13cmos5l_decap_8
XFILLER_195_100 VPWR VGND sg13cmos5l_decap_8
XFILLER_143_7 VPWR VGND sg13cmos5l_decap_8
XFILLER_448_35 VPWR VGND sg13cmos5l_decap_8
XFILLER_329_138 VPWR VGND sg13cmos5l_decap_8
XFILLER_595_63 VPWR VGND sg13cmos5l_decap_8
XFILLER_167_14 VPWR VGND sg13cmos5l_decap_8
XFILLER_195_177 VPWR VGND sg13cmos5l_decap_8
XFILLER_51_69 VPWR VGND sg13cmos5l_decap_8
XFILLER_344_119 VPWR VGND sg13cmos5l_decap_8
XFILLER_310_7 VPWR VGND sg13cmos5l_decap_8
XFILLER_408_7 VPWR VGND sg13cmos5l_decap_8
XFILLER_498_112 VPWR VGND sg13cmos5l_decap_8
XANTENNA__0114__Y AXI_M_SOC_ARLOCK VPWR VGND sg13cmos5l_antennanp
XFILLER_317_28 VPWR VGND sg13cmos5l_decap_8
XFILLER_464_56 VPWR VGND sg13cmos5l_decap_8
XANTENNA__3706__X AXI_M_SOC_WDATA16 VPWR VGND sg13cmos5l_antennanp
XFILLER_501_105 VPWR VGND sg13cmos5l_decap_8
XFILLER_352_196 VPWR VGND sg13cmos5l_fill_2
XFILLER_2_224 VPWR VGND sg13cmos5l_fill_1
XFILLER_183_35 VPWR VGND sg13cmos5l_decap_8
XFILLER_498_189 VPWR VGND sg13cmos5l_decap_8
XFILLER_104_185 VPWR VGND sg13cmos5l_decap_4
XFILLER_333_49 VPWR VGND sg13cmos5l_decap_8
XFILLER_116_84 VPWR VGND sg13cmos5l_fill_2
XFILLER_655_175 VPWR VGND sg13cmos5l_decap_8
XFILLER_630_14 VPWR VGND sg13cmos5l_decap_8
XFILLER_76_77 VPWR VGND sg13cmos5l_decap_8
XANTENNA__3441__X Tile_X0Y1_UserCLKo VPWR VGND sg13cmos5l_antennanp
XFILLER_73_220 VPWR VGND sg13cmos5l_fill_2
XFILLER_92_21 VPWR VGND sg13cmos5l_decap_8
XFILLER_422_112 VPWR VGND sg13cmos5l_decap_8
XFILLER_267_0 VPWR VGND sg13cmos5l_decap_8
XFILLER_568_105 VPWR VGND sg13cmos5l_decap_8
XFILLER_489_42 VPWR VGND sg13cmos5l_decap_8
XFILLER_710_91 VPWR VGND sg13cmos5l_decap_8
XFILLER_26_180 VPWR VGND sg13cmos5l_decap_8
XFILLER_422_189 VPWR VGND sg13cmos5l_decap_8
XFILLER_434_0 VPWR VGND sg13cmos5l_decap_8
XFILLER_639_56 VPWR VGND sg13cmos5l_decap_8
XFILLER_583_119 VPWR VGND sg13cmos5l_decap_4
XFILLER_25_70 VPWR VGND sg13cmos5l_decap_8
XFILLER_576_171 VPWR VGND sg13cmos5l_decap_8
XFILLER_358_35 VPWR VGND sg13cmos5l_decap_8
XFILLER_186_166 VPWR VGND sg13cmos5l_decap_8
XFILLER_601_0 VPWR VGND sg13cmos5l_decap_8
XFILLER_186_177 VPWR VGND sg13cmos5l_fill_1
XFILLER_524_219 VPWR VGND sg13cmos5l_fill_1
XFILLER_186_199 VPWR VGND sg13cmos5l_decap_8
XFILLER_390_225 VPWR VGND sg13cmos5l_decap_4
XFILLER_328_171 VPWR VGND sg13cmos5l_decap_8
X_0760_ _0760_/Q Tile_X0Y9_FrameData[7] VGND VPWR Tile_X0Y9_FrameStrobe[2] latch
XFILLER_508_49 VPWR VGND sg13cmos5l_decap_8
XFILLER_489_112 VPWR VGND sg13cmos5l_decap_8
XFILLER_41_80 VPWR VGND sg13cmos5l_decap_8
XFILLER_655_77 VPWR VGND sg13cmos5l_decap_8
XFILLER_227_28 VPWR VGND sg13cmos5l_decap_8
X_0691_ _0691_/Q Tile_X0Y9_FrameData[12] VGND VPWR Tile_X0Y9_FrameStrobe[0] latch
XFILLER_142_203 VPWR VGND sg13cmos5l_decap_8
XFILLER_374_56 VPWR VGND sg13cmos5l_decap_8
XANTENNA__3616__X Tile_X0Y9_S2BEGb[2] VPWR VGND sg13cmos5l_antennanp
X_2430_ _2430_/Q Tile_X0Y5_FrameData[7] VGND VPWR Tile_X0Y9_FrameStrobe[7] latch
XFILLER_489_189 VPWR VGND sg13cmos5l_decap_8
XFILLER_671_21 VPWR VGND sg13cmos5l_decap_8
X_2361_ _2361_/Q Tile_X0Y5_FrameData[12] VGND VPWR Tile_X0Y9_FrameStrobe[5] latch
X_4100_ _4100_/X _4031_/X _4139_/X _4138_/X _4030_/X _1439_/Q _1438_/Q VPWR VGND sg13cmos5l_mux4_1
X_1312_ _1312_/Q Tile_X0Y1_FrameData[25] VGND VPWR Tile_X0Y9_FrameStrobe[4] latch
XFILLER_256_104 VPWR VGND sg13cmos5l_decap_4
X_2292_ _2292_/Q Tile_X0Y5_FrameData[17] VGND VPWR Tile_X0Y9_FrameStrobe[3] latch
XFILLER_243_49 VPWR VGND sg13cmos5l_decap_8
XFILLER_646_175 VPWR VGND sg13cmos5l_decap_8
XFILLER_604_70 VPWR VGND sg13cmos5l_decap_8
XFILLER_500_182 VPWR VGND sg13cmos5l_decap_8
X_4031_ _4031_/X Tile_X0Y3_W2MID[2] Tile_X0Y3_W2END[2] Tile_X0Y3_W6END[2] _4208_/X
+ _1907_/Q _1906_/Q VPWR VGND sg13cmos5l_mux4_1
XFILLER_661_112 VPWR VGND sg13cmos5l_fill_1
XFILLER_390_77 VPWR VGND sg13cmos5l_fill_2
X_1243_ _1243_/Q Tile_X0Y1_FrameData[30] VGND VPWR Tile_X0Y9_FrameStrobe[2] latch
XFILLER_540_14 VPWR VGND sg13cmos5l_decap_8
XFILLER_2_63 VPWR VGND sg13cmos5l_decap_8
XFILLER_110_177 VPWR VGND sg13cmos5l_decap_4
XANTENNA__3351__X Tile_X0Y2_FrameData_O[22] VPWR VGND sg13cmos5l_antennanp
XFILLER_661_145 VPWR VGND sg13cmos5l_fill_1
XFILLER_110_188 VPWR VGND sg13cmos5l_fill_2
XFILLER_661_167 VPWR VGND sg13cmos5l_decap_8
X_1174_ _1174_/Q Tile_X0Y0_FrameData[21] VGND VPWR Tile_X0Y9_FrameStrobe[7] latch
XFILLER_271_129 VPWR VGND sg13cmos5l_fill_1
XFILLER_559_105 VPWR VGND sg13cmos5l_decap_8
XFILLER_399_42 VPWR VGND sg13cmos5l_decap_8
X_0125_ _3189_/A _3794_/X _3795_/X _1148_/Q VPWR VGND sg13cmos5l_mux2_1
XFILLER_620_91 VPWR VGND sg13cmos5l_decap_8
XFILLER_24_128 VPWR VGND sg13cmos5l_decap_8
XFILLER_212_207 VPWR VGND sg13cmos5l_decap_8
X_0056_ _0056_/X _4676_/X _4677_/X _1863_/Q VPWR VGND sg13cmos5l_mux2_1
X_4933_ _4933_/X Tile_X0Y8_W2MID[6] Tile_X0Y8_W2END[6] Tile_X0Y8_W6END[9] _4787_/X
+ _0625_/Q _0624_/Q VPWR VGND sg13cmos5l_mux4_1
XFILLER_17_191 VPWR VGND sg13cmos5l_fill_2
XFILLER_574_119 VPWR VGND sg13cmos5l_decap_8
XFILLER_549_56 VPWR VGND sg13cmos5l_decap_8
X_4864_ _4864_/X Tile_X0Y9_WW4END[15] AXI_M_SOC_RDATA0 _4931_/X _4900_/X _0815_/Q
+ _0814_/Q VPWR VGND sg13cmos5l_mux4_1
XFILLER_716_102 VPWR VGND sg13cmos5l_decap_8
XFILLER_696_84 VPWR VGND sg13cmos5l_decap_8
XANTENNA_13 Tile_X0Y0_S2MID[7] VPWR VGND sg13cmos5l_antennanp
XANTENNA_24 _4701_/X VPWR VGND sg13cmos5l_antennanp
X_3815_ _3815_/X Tile_X0Y0_W2END[4] Tile_X0Y0_WW4END[3] _3859_/X _3858_/X _1075_/Q
+ _1074_/Q VPWR VGND sg13cmos5l_mux4_1
XANTENNA_35 Tile_X0Y9_FrameStrobe[17] VPWR VGND sg13cmos5l_antennanp
XFILLER_268_68 VPWR VGND sg13cmos5l_decap_8
XANTENNA_46 Tile_X0Y9_N2MID[2] VPWR VGND sg13cmos5l_antennanp
X_4795_ _4795_/X _4341_/X _4345_/X _4349_/X _4316_/X _2118_/Q _2117_/Q VPWR VGND sg13cmos5l_mux4_1
XFILLER_582_152 VPWR VGND sg13cmos5l_decap_8
XANTENNA_57 Tile_X0Y9_N2MID[6] VPWR VGND sg13cmos5l_antennanp
XFILLER_381_203 VPWR VGND sg13cmos5l_fill_1
XFILLER_716_179 VPWR VGND sg13cmos5l_decap_4
X_3746_ AXI_M_SOC_ARADDR18 Tile_X0Y8_WW4END[2] Tile_X0Y8_WW4END[10] Tile_X0Y8_W6END[2]
+ _4802_/X _0499_/Q _0498_/Q VPWR VGND sg13cmos5l_mux4_1
X_0958_ _0958_/Q Tile_X0Y0_FrameData[13] VGND VPWR Tile_X0Y9_FrameStrobe[0] latch
XFILLER_418_49 VPWR VGND sg13cmos5l_decap_8
XFILLER_21_28 VPWR VGND sg13cmos5l_decap_8
XFILLER_319_193 VPWR VGND sg13cmos5l_decap_8
XFILLER_565_77 VPWR VGND sg13cmos5l_decap_8
XFILLER_137_28 VPWR VGND sg13cmos5l_decap_8
XFILLER_715_14 VPWR VGND sg13cmos5l_decap_8
X_3677_ _3677_/X Tile_X0Y2_WW4END[7] Tile_X0Y2_WW4END[15] Tile_X0Y2_W6END[7] _4123_/X
+ _1491_/Q _1490_/Q VPWR VGND sg13cmos5l_mux4_1
X_0889_ _0889_/Q Tile_X0Y9_FrameData[6] VGND VPWR Tile_X0Y9_FrameStrobe[6] latch
XFILLER_334_163 VPWR VGND sg13cmos5l_decap_8
XANTENNA__3526__X Tile_X0Y9_E2BEG[0] VPWR VGND sg13cmos5l_antennanp
XFILLER_284_56 VPWR VGND sg13cmos5l_decap_8
X_2628_ _2628_/Q Tile_X0Y6_FrameData[3] VGND VPWR Tile_X0Y9_FrameStrobe[5] latch
XFILLER_715_69 VPWR VGND sg13cmos5l_decap_8
XFILLER_581_21 VPWR VGND sg13cmos5l_decap_8
XFILLER_495_126 VPWR VGND sg13cmos5l_decap_8
XFILLER_99_150 VPWR VGND sg13cmos5l_fill_1
X_2559_ _2559_/Q Tile_X0Y6_FrameData[8] VGND VPWR Tile_X0Y9_FrameStrobe[3] latch
XFILLER_99_172 VPWR VGND sg13cmos5l_decap_8
XFILLER_101_111 VPWR VGND sg13cmos5l_decap_8
XFILLER_581_98 VPWR VGND sg13cmos5l_decap_8
XFILLER_153_49 VPWR VGND sg13cmos5l_decap_8
XFILLER_514_70 VPWR VGND sg13cmos5l_decap_8
XFILLER_652_112 VPWR VGND sg13cmos5l_decap_8
XFILLER_101_155 VPWR VGND sg13cmos5l_fill_1
X_4229_ _4229_/X _4203_/X _0046_/X _4202_/X Tile_X0Y0_S4END[15] _1715_/Q _1714_/Q
+ VPWR VGND sg13cmos5l_mux4_1
XFILLER_637_197 VPWR VGND sg13cmos5l_fill_1
XFILLER_450_14 VPWR VGND sg13cmos5l_decap_8
XANTENNA__3261__X Tile_X0Y0_FrameData_O[29] VPWR VGND sg13cmos5l_antennanp
XFILLER_652_189 VPWR VGND sg13cmos5l_decap_4
XFILLER_46_69 VPWR VGND sg13cmos5l_decap_8
XFILLER_600_28 VPWR VGND sg13cmos5l_decap_8
XFILLER_260_7 VPWR VGND sg13cmos5l_decap_8
XFILLER_358_7 VPWR VGND sg13cmos5l_decap_8
XFILLER_270_140 VPWR VGND sg13cmos5l_decap_8
XFILLER_102_42 VPWR VGND sg13cmos5l_decap_8
XFILLER_404_167 VPWR VGND sg13cmos5l_fill_1
XFILLER_270_162 VPWR VGND sg13cmos5l_decap_8
XFILLER_565_119 VPWR VGND sg13cmos5l_decap_8
XFILLER_459_56 VPWR VGND sg13cmos5l_decap_8
XFILLER_525_7 VPWR VGND sg13cmos5l_decap_8
XFILLER_168_122 VPWR VGND sg13cmos5l_decap_8
XFILLER_178_35 VPWR VGND sg13cmos5l_decap_8
XFILLER_558_193 VPWR VGND sg13cmos5l_fill_2
XFILLER_372_225 VPWR VGND sg13cmos5l_decap_4
XFILLER_573_196 VPWR VGND sg13cmos5l_decap_8
XFILLER_328_49 VPWR VGND sg13cmos5l_decap_8
XFILLER_475_77 VPWR VGND sg13cmos5l_fill_2
XFILLER_625_14 VPWR VGND sg13cmos5l_decap_8
XFILLER_194_56 VPWR VGND sg13cmos5l_decap_8
XANTENNA__3436__X Tile_X0Y4_FrameData_O[27] VPWR VGND sg13cmos5l_antennanp
XFILLER_340_111 VPWR VGND sg13cmos5l_decap_8
XFILLER_325_185 VPWR VGND sg13cmos5l_decap_8
XFILLER_340_122 VPWR VGND sg13cmos5l_fill_2
XFILLER_491_21 VPWR VGND sg13cmos5l_decap_8
XFILLER_486_126 VPWR VGND sg13cmos5l_fill_2
XFILLER_87_21 VPWR VGND sg13cmos5l_decap_8
XFILLER_486_159 VPWR VGND sg13cmos5l_decap_8
XFILLER_705_91 VPWR VGND sg13cmos5l_decap_8
XFILLER_491_98 VPWR VGND sg13cmos5l_decap_8
XFILLER_641_35 VPWR VGND sg13cmos5l_decap_8
XFILLER_424_70 VPWR VGND sg13cmos5l_decap_8
XFILLER_643_112 VPWR VGND sg13cmos5l_decap_8
XFILLER_384_0 VPWR VGND sg13cmos5l_decap_8
XFILLER_360_14 VPWR VGND sg13cmos5l_decap_8
XANTENNA__3171__X Tile_X0Y4_E6BEG[8] VPWR VGND sg13cmos5l_antennanp
XFILLER_643_189 VPWR VGND sg13cmos5l_decap_8
XFILLER_551_0 VPWR VGND sg13cmos5l_decap_8
XFILLER_649_0 VPWR VGND sg13cmos5l_decap_8
XFILLER_510_28 VPWR VGND sg13cmos5l_decap_8
XFILLER_440_91 VPWR VGND sg13cmos5l_decap_8
XFILLER_369_56 VPWR VGND sg13cmos5l_decap_8
X_1930_ _1930_/Q Tile_X0Y4_FrameData[27] VGND VPWR Tile_X0Y9_FrameStrobe[0] latch
XFILLER_14_150 VPWR VGND sg13cmos5l_fill_2
XFILLER_549_182 VPWR VGND sg13cmos5l_decap_8
XFILLER_666_21 VPWR VGND sg13cmos5l_decap_8
XFILLER_159_155 VPWR VGND sg13cmos5l_decap_8
X_1861_ _1861_/Q Tile_X0Y3_FrameData[4] VGND VPWR Tile_X0Y9_FrameStrobe[5] latch
X_3600_ Tile_X0Y9_FrameData_O[30] Tile_X0Y9_FrameData[30] VPWR VGND sg13cmos5l_buf_1
XFILLER_713_105 VPWR VGND sg13cmos5l_decap_8
X_0812_ _0812_/Q Tile_X0Y9_FrameData[19] VGND VPWR Tile_X0Y9_FrameStrobe[4] latch
X_4580_ _4580_/X _4545_/X Tile_X0Y9_N4END[12] _4544_/X _0152_/X _2471_/Q _2470_/Q
+ VPWR VGND sg13cmos5l_mux4_1
XFILLER_666_98 VPWR VGND sg13cmos5l_decap_8
X_1792_ _1792_/Q Tile_X0Y3_FrameData[9] VGND VPWR Tile_X0Y9_FrameStrobe[3] latch
XFILLER_238_49 VPWR VGND sg13cmos5l_decap_8
XFILLER_174_147 VPWR VGND sg13cmos5l_decap_8
X_3531_ Tile_X0Y9_E2BEG[5] _4853_/X VPWR VGND sg13cmos5l_buf_1
X_0743_ _0743_/Q Tile_X0Y9_FrameData[24] VGND VPWR Tile_X0Y9_FrameStrobe[2] latch
XFILLER_535_14 VPWR VGND sg13cmos5l_decap_8
XANTENNA__3346__X Tile_X0Y2_FrameData_O[17] VPWR VGND sg13cmos5l_antennanp
XFILLER_682_42 VPWR VGND sg13cmos5l_decap_8
XFILLER_115_225 VPWR VGND sg13cmos5l_decap_4
X_3462_ Tile_X0Y1_FrameData_O[20] Tile_X0Y1_FrameData[20] VPWR VGND sg13cmos5l_buf_1
XFILLER_477_104 VPWR VGND sg13cmos5l_decap_8
X_0674_ _0674_/Q Tile_X0Y9_FrameData[29] VGND VPWR Tile_X0Y9_FrameStrobe[0] latch
X_2413_ _2413_/Q Tile_X0Y5_FrameData[24] VGND VPWR Tile_X0Y9_FrameStrobe[7] latch
XFILLER_477_148 VPWR VGND sg13cmos5l_decap_8
X_3393_ Tile_X0Y2_E2BEGb[4] _4052_/X VPWR VGND sg13cmos5l_buf_1
XFILLER_331_177 VPWR VGND sg13cmos5l_decap_8
XFILLER_130_228 VPWR VGND sg13cmos5l_fill_1
XFILLER_615_91 VPWR VGND sg13cmos5l_decap_8
XFILLER_331_188 VPWR VGND sg13cmos5l_fill_2
X_2344_ _2344_/Q Tile_X0Y5_FrameData[29] VGND VPWR Tile_X0Y9_FrameStrobe[5] latch
XFILLER_418_204 VPWR VGND sg13cmos5l_decap_8
XFILLER_551_35 VPWR VGND sg13cmos5l_decap_8
XFILLER_334_70 VPWR VGND sg13cmos5l_decap_8
XFILLER_28_0 VPWR VGND sg13cmos5l_decap_8
XFILLER_634_112 VPWR VGND sg13cmos5l_decap_8
XFILLER_270_14 VPWR VGND sg13cmos5l_decap_8
X_2275_ _2275_/Q Tile_X0Y5_FrameData[2] VGND VPWR Tile_X0Y9_FrameStrobe[2] latch
XANTENNA__3081__X Tile_X0Y4_E2BEGb[7] VPWR VGND sg13cmos5l_antennanp
X_4014_ _4014_/X _3985_/X _0095_/X _3984_/X Tile_X0Y0_S4END[6] _1221_/Q _1220_/Q VPWR
+ VGND sg13cmos5l_mux4_1
X_1226_ _1226_/Q Tile_X0Y1_FrameData[15] VGND VPWR Tile_X0Y9_FrameStrobe[1] latch
XFILLER_701_49 VPWR VGND sg13cmos5l_decap_8
XFILLER_244_129 VPWR VGND sg13cmos5l_decap_4
XFILLER_237_170 VPWR VGND sg13cmos5l_decap_8
XFILLER_237_181 VPWR VGND sg13cmos5l_fill_1
XFILLER_420_28 VPWR VGND sg13cmos5l_decap_8
XFILLER_203_63 VPWR VGND sg13cmos5l_decap_8
X_1157_ _1157_/Q Tile_X0Y0_FrameData[6] VGND VPWR Tile_X0Y9_FrameStrobe[6] latch
XFILLER_16_28 VPWR VGND sg13cmos5l_decap_8
XFILLER_350_91 VPWR VGND sg13cmos5l_decap_8
X_0108_ AXI_M_SOC_ARBURST0 _3771_/X _0931_/Q VPWR VGND sg13cmos5l_or2_1
X_1088_ _1088_/Q Tile_X0Y0_FrameData[11] VGND VPWR Tile_X0Y9_FrameStrobe[4] latch
XFILLER_279_56 VPWR VGND sg13cmos5l_decap_8
X_4916_ _4916_/X Tile_X0Y9_N1END[0] Tile_X0Y9_N4END[0] _4896_/X _0083_/X _0727_/Q
+ _0726_/Q VPWR VGND sg13cmos5l_mux4_1
XFILLER_339_222 VPWR VGND sg13cmos5l_decap_8
XFILLER_576_21 VPWR VGND sg13cmos5l_decap_8
X_4847_ _4847_/X Tile_X0Y9_N1END[3] _4899_/X AXI_M_SOC_RDATA0 AXI_M_SOC_RDATA4 _0849_/Q
+ _0848_/Q VPWR VGND sg13cmos5l_mux4_1
XFILLER_32_38 VPWR VGND sg13cmos5l_decap_8
XFILLER_704_105 VPWR VGND sg13cmos5l_decap_8
X_4778_ _4778_/X Tile_X0Y7_W1END[1] Tile_X0Y7_W6END[9] _4697_/X _4657_/X _0377_/Q
+ _0376_/Q VPWR VGND sg13cmos5l_mux4_1
XFILLER_576_98 VPWR VGND sg13cmos5l_decap_8
XFILLER_148_49 VPWR VGND sg13cmos5l_decap_8
XFILLER_509_70 VPWR VGND sg13cmos5l_decap_8
XFILLER_570_133 VPWR VGND sg13cmos5l_decap_8
XFILLER_295_77 VPWR VGND sg13cmos5l_decap_8
X_3729_ AXI_M_SOC_ARADDR1 Tile_X0Y9_WW4END[1] Tile_X0Y9_WW4END[9] Tile_X0Y9_W6END[1]
+ _4917_/X _0757_/Q _0756_/Q VPWR VGND sg13cmos5l_mux4_1
XFILLER_445_14 VPWR VGND sg13cmos5l_decap_8
XANTENNA__3256__X Tile_X0Y0_FrameData_O[24] VPWR VGND sg13cmos5l_antennanp
XFILLER_592_42 VPWR VGND sg13cmos5l_decap_8
XFILLER_511_211 VPWR VGND sg13cmos5l_fill_2
XFILLER_106_7 VPWR VGND sg13cmos5l_decap_8
XFILLER_173_191 VPWR VGND sg13cmos5l_fill_1
XFILLER_712_182 VPWR VGND sg13cmos5l_decap_8
XFILLER_322_133 VPWR VGND sg13cmos5l_decap_8
XFILLER_121_206 VPWR VGND sg13cmos5l_decap_8
XFILLER_461_35 VPWR VGND sg13cmos5l_decap_8
XFILLER_244_70 VPWR VGND sg13cmos5l_decap_8
XFILLER_409_226 VPWR VGND sg13cmos5l_fill_2
XFILLER_625_112 VPWR VGND sg13cmos5l_fill_2
XFILLER_57_35 VPWR VGND sg13cmos5l_decap_8
XFILLER_180_14 VPWR VGND sg13cmos5l_decap_8
XFILLER_475_7 VPWR VGND sg13cmos5l_decap_8
XFILLER_461_79 VPWR VGND sg13cmos5l_fill_2
XFILLER_491_140 VPWR VGND sg13cmos5l_decap_8
XFILLER_290_213 VPWR VGND sg13cmos5l_fill_1
XFILLER_611_49 VPWR VGND sg13cmos5l_decap_8
XFILLER_491_184 VPWR VGND sg13cmos5l_decap_8
XFILLER_640_126 VPWR VGND sg13cmos5l_decap_8
XFILLER_642_7 VPWR VGND sg13cmos5l_decap_8
XFILLER_330_28 VPWR VGND sg13cmos5l_decap_8
XFILLER_113_63 VPWR VGND sg13cmos5l_decap_8
XFILLER_73_56 VPWR VGND sg13cmos5l_decap_8
XFILLER_593_203 VPWR VGND sg13cmos5l_decap_4
XFILLER_189_56 VPWR VGND sg13cmos5l_decap_8
XFILLER_593_214 VPWR VGND sg13cmos5l_fill_2
XFILLER_410_72 VPWR VGND sg13cmos5l_fill_1
XFILLER_486_21 VPWR VGND sg13cmos5l_decap_8
XFILLER_132_0 VPWR VGND sg13cmos5l_decap_8
XFILLER_400_192 VPWR VGND sg13cmos5l_decap_8
XFILLER_486_98 VPWR VGND sg13cmos5l_decap_8
XFILLER_636_35 VPWR VGND sg13cmos5l_decap_8
XFILLER_561_133 VPWR VGND sg13cmos5l_decap_8
XFILLER_419_70 VPWR VGND sg13cmos5l_decap_8
XFILLER_355_14 VPWR VGND sg13cmos5l_decap_8
XANTENNA__3166__X Tile_X0Y4_E6BEG[3] VPWR VGND sg13cmos5l_antennanp
XFILLER_360_217 VPWR VGND sg13cmos5l_fill_1
XFILLER_360_228 VPWR VGND sg13cmos5l_fill_1
XFILLER_710_119 VPWR VGND sg13cmos5l_decap_8
XFILLER_98_42 VPWR VGND sg13cmos5l_decap_8
XFILLER_459_115 VPWR VGND sg13cmos5l_fill_1
XFILLER_599_0 VPWR VGND sg13cmos5l_decap_8
XFILLER_505_28 VPWR VGND sg13cmos5l_decap_8
XFILLER_652_56 VPWR VGND sg13cmos5l_decap_8
XFILLER_435_91 VPWR VGND sg13cmos5l_decap_8
XFILLER_313_188 VPWR VGND sg13cmos5l_decap_8
X_0390_ _0390_/Q Tile_X0Y7_FrameData[25] VGND VPWR Tile_X0Y9_FrameStrobe[7] latch
XFILLER_371_35 VPWR VGND sg13cmos5l_decap_8
XFILLER_78_164 VPWR VGND sg13cmos5l_fill_2
XFILLER_21_7 VPWR VGND sg13cmos5l_decap_8
XFILLER_482_140 VPWR VGND sg13cmos5l_fill_2
XFILLER_281_202 VPWR VGND sg13cmos5l_decap_4
XFILLER_226_118 VPWR VGND sg13cmos5l_fill_2
X_2060_ _2060_/Q Tile_X0Y4_FrameData[25] VGND VPWR Tile_X0Y9_FrameStrobe[4] latch
XFILLER_521_49 VPWR VGND sg13cmos5l_decap_8
XFILLER_482_184 VPWR VGND sg13cmos5l_decap_8
XFILLER_219_181 VPWR VGND sg13cmos5l_decap_4
X_1011_ _1011_/Q Tile_X0Y0_FrameData[24] VGND VPWR Tile_X0Y9_FrameStrobe[2] latch
XFILLER_240_28 VPWR VGND sg13cmos5l_decap_8
XFILLER_234_184 VPWR VGND sg13cmos5l_fill_1
XFILLER_179_228 VPWR VGND sg13cmos5l_fill_1
XFILLER_677_42 VPWR VGND sg13cmos5l_decap_8
X_2962_ Tile_X0Y8_FrameData_O[2] Tile_X0Y8_FrameData[2] VPWR VGND sg13cmos5l_buf_1
XFILLER_396_21 VPWR VGND sg13cmos5l_decap_8
X_1913_ _1913_/Q Tile_X0Y3_FrameData[16] VGND VPWR Tile_X0Y9_FrameStrobe[7] latch
X_4701_ _4701_/X Tile_X0Y9_W2MID[7] Tile_X0Y9_W2END[7] Tile_X0Y9_W6END[7] _4901_/X
+ _0919_/Q _0918_/Q VPWR VGND sg13cmos5l_mux4_1
X_2893_ Tile_X0Y6_FrameData_O[14] Tile_X0Y6_FrameData[14] VPWR VGND sg13cmos5l_buf_1
X_4632_ _4632_/X Tile_X0Y7_WW4END[11] AXI_M_SOC_RDATA20 _4695_/X _4675_/X _0295_/Q
+ _0294_/Q VPWR VGND sg13cmos5l_mux4_1
X_1844_ _1844_/Q Tile_X0Y3_FrameData[21] VGND VPWR Tile_X0Y9_FrameStrobe[5] latch
XFILLER_396_98 VPWR VGND sg13cmos5l_decap_8
XFILLER_546_35 VPWR VGND sg13cmos5l_decap_8
XFILLER_8_84 VPWR VGND sg13cmos5l_decap_8
XFILLER_698_126 VPWR VGND sg13cmos5l_decap_8
X_4563_ _4563_/X _4121_/X _4125_/X _4110_/X _4100_/X _1610_/Q _1609_/Q VPWR VGND sg13cmos5l_mux4_1
XFILLER_693_63 VPWR VGND sg13cmos5l_decap_8
XFILLER_265_14 VPWR VGND sg13cmos5l_decap_8
X_1775_ _1775_/Q Tile_X0Y3_FrameData[26] VGND VPWR Tile_X0Y9_FrameStrobe[3] latch
XANTENNA__3076__X Tile_X0Y4_E2BEGb[2] VPWR VGND sg13cmos5l_antennanp
XFILLER_351_228 VPWR VGND sg13cmos5l_fill_1
X_3514_ Tile_X0Y1_E2BEG[4] _3936_/X VPWR VGND sg13cmos5l_buf_1
XFILLER_701_119 VPWR VGND sg13cmos5l_decap_8
X_0726_ _0726_/Q Tile_X0Y9_FrameData[9] VGND VPWR Tile_X0Y9_FrameStrobe[1] latch
XFILLER_552_199 VPWR VGND sg13cmos5l_fill_2
X_4494_ _4494_/X _4549_/X _4548_/X AXI_M_SOC_RDATA25 AXI_M_SOC_RDATA29 _2619_/Q _2618_/Q
+ VPWR VGND sg13cmos5l_mux4_1
X_3445_ Tile_X0Y1_FrameData_O[3] Tile_X0Y1_FrameData[3] VPWR VGND sg13cmos5l_buf_1
XFILLER_415_28 VPWR VGND sg13cmos5l_decap_8
X_0657_ _0657_/Q Tile_X0Y8_FrameData[14] VGND VPWR Tile_X0Y9_FrameStrobe[7] latch
XFILLER_103_217 VPWR VGND sg13cmos5l_decap_8
XFILLER_103_228 VPWR VGND sg13cmos5l_fill_1
XFILLER_562_56 VPWR VGND sg13cmos5l_decap_8
XFILLER_345_91 VPWR VGND sg13cmos5l_decap_8
XFILLER_465_118 VPWR VGND sg13cmos5l_decap_4
X_3376_ Tile_X0Y2_EE4BEG[15] _4071_/X VPWR VGND sg13cmos5l_buf_1
XFILLER_654_218 VPWR VGND sg13cmos5l_fill_1
XFILLER_281_35 VPWR VGND sg13cmos5l_decap_8
X_0588_ _0588_/Q Tile_X0Y8_FrameData[19] VGND VPWR Tile_X0Y9_FrameStrobe[5] latch
XFILLER_458_170 VPWR VGND sg13cmos5l_decap_8
X_2327_ _2327_/Q Tile_X0Y5_FrameData[14] VGND VPWR Tile_X0Y9_FrameStrobe[4] latch
XFILLER_69_175 VPWR VGND sg13cmos5l_decap_8
XFILLER_84_112 VPWR VGND sg13cmos5l_decap_8
XFILLER_406_218 VPWR VGND sg13cmos5l_decap_8
X_2258_ _2258_/Q Tile_X0Y5_FrameData[19] VGND VPWR Tile_X0Y9_FrameStrobe[2] latch
XFILLER_431_49 VPWR VGND sg13cmos5l_decap_8
XFILLER_214_84 VPWR VGND sg13cmos5l_decap_8
XFILLER_27_49 VPWR VGND sg13cmos5l_decap_8
X_1209_ _1209_/Q Tile_X0Y1_FrameData[0] VGND VPWR Tile_X0Y9_FrameStrobe[0] latch
XFILLER_150_28 VPWR VGND sg13cmos5l_decap_8
X_2189_ _2189_/Q Tile_X0Y5_FrameData[24] VGND VPWR Tile_X0Y9_FrameStrobe[0] latch
XFILLER_240_110 VPWR VGND sg13cmos5l_decap_4
XFILLER_575_203 VPWR VGND sg13cmos5l_decap_8
XFILLER_240_121 VPWR VGND sg13cmos5l_fill_2
XFILLER_587_42 VPWR VGND sg13cmos5l_decap_8
XFILLER_575_225 VPWR VGND sg13cmos5l_decap_4
XFILLER_240_165 VPWR VGND sg13cmos5l_decap_8
XFILLER_185_209 VPWR VGND sg13cmos5l_decap_8
XFILLER_327_225 VPWR VGND sg13cmos5l_decap_4
XFILLER_543_111 VPWR VGND sg13cmos5l_decap_8
XFILLER_528_185 VPWR VGND sg13cmos5l_decap_4
XFILLER_223_7 VPWR VGND sg13cmos5l_decap_8
XFILLER_138_147 VPWR VGND sg13cmos5l_decap_8
XFILLER_456_35 VPWR VGND sg13cmos5l_decap_8
XFILLER_239_70 VPWR VGND sg13cmos5l_decap_8
XFILLER_175_14 VPWR VGND sg13cmos5l_decap_8
XFILLER_4_105 VPWR VGND sg13cmos5l_decap_8
XFILLER_342_228 VPWR VGND sg13cmos5l_fill_1
XFILLER_543_199 VPWR VGND sg13cmos5l_decap_8
XFILLER_606_49 VPWR VGND sg13cmos5l_decap_8
XFILLER_496_210 VPWR VGND sg13cmos5l_fill_1
XFILLER_697_192 VPWR VGND sg13cmos5l_decap_4
XFILLER_325_28 VPWR VGND sg13cmos5l_decap_8
XFILLER_592_7 VPWR VGND sg13cmos5l_decap_8
XFILLER_108_63 VPWR VGND sg13cmos5l_decap_8
XFILLER_472_56 VPWR VGND sg13cmos5l_decap_8
XANTENNA__3714__X AXI_M_SOC_WDATA24 VPWR VGND sg13cmos5l_antennanp
XFILLER_108_96 VPWR VGND sg13cmos5l_decap_8
XFILLER_700_174 VPWR VGND sg13cmos5l_fill_1
XFILLER_68_56 VPWR VGND sg13cmos5l_decap_8
XFILLER_310_136 VPWR VGND sg13cmos5l_fill_1
XFILLER_700_196 VPWR VGND sg13cmos5l_fill_1
XFILLER_248_210 VPWR VGND sg13cmos5l_decap_8
XFILLER_191_35 VPWR VGND sg13cmos5l_decap_8
XFILLER_310_158 VPWR VGND sg13cmos5l_decap_4
XFILLER_124_40 VPWR VGND sg13cmos5l_decap_8
XFILLER_341_49 VPWR VGND sg13cmos5l_decap_8
XFILLER_90_104 VPWR VGND sg13cmos5l_decap_4
XFILLER_84_77 VPWR VGND sg13cmos5l_decap_8
XFILLER_16_212 VPWR VGND sg13cmos5l_fill_2
XFILLER_231_110 VPWR VGND sg13cmos5l_fill_1
XFILLER_377_114 VPWR VGND sg13cmos5l_decap_8
XFILLER_497_42 VPWR VGND sg13cmos5l_decap_8
XFILLER_347_0 VPWR VGND sg13cmos5l_decap_8
XFILLER_231_187 VPWR VGND sg13cmos5l_decap_4
XFILLER_581_206 VPWR VGND sg13cmos5l_fill_1
XFILLER_514_0 VPWR VGND sg13cmos5l_decap_8
XFILLER_318_214 VPWR VGND sg13cmos5l_decap_8
XFILLER_647_56 VPWR VGND sg13cmos5l_decap_8
XFILLER_581_228 VPWR VGND sg13cmos5l_fill_1
XFILLER_129_125 VPWR VGND sg13cmos5l_decap_8
XFILLER_318_225 VPWR VGND sg13cmos5l_decap_4
XFILLER_534_122 VPWR VGND sg13cmos5l_decap_4
XFILLER_366_35 VPWR VGND sg13cmos5l_decap_8
XFILLER_149_70 VPWR VGND sg13cmos5l_decap_8
XFILLER_69_7 VPWR VGND sg13cmos5l_decap_8
XFILLER_534_177 VPWR VGND sg13cmos5l_decap_8
X_1560_ _1560_/Q Tile_X0Y2_FrameData[25] VGND VPWR Tile_X0Y9_FrameStrobe[4] latch
XFILLER_516_49 VPWR VGND sg13cmos5l_decap_8
XFILLER_688_181 VPWR VGND sg13cmos5l_decap_8
X_0511_ _0511_/Q Tile_X0Y8_FrameData[0] VGND VPWR Tile_X0Y9_FrameStrobe[2] latch
XFILLER_663_77 VPWR VGND sg13cmos5l_decap_8
XFILLER_235_28 VPWR VGND sg13cmos5l_decap_8
XFILLER_98_226 VPWR VGND sg13cmos5l_fill_2
X_1491_ _1491_/Q Tile_X0Y2_FrameData[30] VGND VPWR Tile_X0Y9_FrameStrobe[2] latch
XANTENNA__3624__X Tile_X0Y9_S4BEG[2] VPWR VGND sg13cmos5l_antennanp
XFILLER_382_56 VPWR VGND sg13cmos5l_decap_8
XFILLER_301_114 VPWR VGND sg13cmos5l_decap_8
XFILLER_165_91 VPWR VGND sg13cmos5l_decap_4
X_3230_ Tile_X0Y0_FrameStrobe_O[18] Tile_X0Y9_FrameStrobe[18] VPWR VGND sg13cmos5l_buf_1
X_0442_ _0442_/Q Tile_X0Y8_FrameData[5] VGND VPWR Tile_X0Y9_FrameStrobe[0] latch
XFILLER_636_218 VPWR VGND sg13cmos5l_fill_2
X_3161_ Tile_X0Y7_FrameData_O[31] Tile_X0Y7_FrameData[31] VPWR VGND sg13cmos5l_buf_1
X_0373_ _0373_/Q Tile_X0Y7_FrameData[10] VGND VPWR Tile_X0Y9_FrameStrobe[6] latch
XFILLER_66_101 VPWR VGND sg13cmos5l_decap_8
X_2112_ _2112_/Q Tile_X0Y4_FrameData[5] VGND VPWR Tile_X0Y9_FrameStrobe[5] latch
X_3092_ Tile_X0Y7_E2BEG[6] _4618_/X VPWR VGND sg13cmos5l_buf_1
XFILLER_251_49 VPWR VGND sg13cmos5l_decap_8
XFILLER_612_70 VPWR VGND sg13cmos5l_decap_8
XFILLER_455_184 VPWR VGND sg13cmos5l_fill_1
XFILLER_66_178 VPWR VGND sg13cmos5l_decap_8
XFILLER_81_115 VPWR VGND sg13cmos5l_decap_8
X_2043_ _2043_/Q Tile_X0Y4_FrameData[10] VGND VPWR Tile_X0Y9_FrameStrobe[3] latch
XFILLER_207_140 VPWR VGND sg13cmos5l_decap_8
XFILLER_470_187 VPWR VGND sg13cmos5l_decap_8
XFILLER_331_93 VPWR VGND sg13cmos5l_fill_1
XFILLER_688_63 VPWR VGND sg13cmos5l_decap_8
XFILLER_22_215 VPWR VGND sg13cmos5l_fill_2
X_3994_ _3994_/X _3896_/X _4029_/X _4028_/X Tile_X0Y0_S2MID[4] _1193_/Q _1192_/Q VPWR
+ VGND sg13cmos5l_mux4_1
XFILLER_95_0 VPWR VGND sg13cmos5l_decap_8
XFILLER_222_176 VPWR VGND sg13cmos5l_fill_1
XFILLER_200_42 VPWR VGND sg13cmos5l_decap_8
X_2945_ Tile_X0Y8_EE4BEG[1] _4745_/X VPWR VGND sg13cmos5l_buf_1
XFILLER_572_228 VPWR VGND sg13cmos5l_fill_1
XFILLER_557_56 VPWR VGND sg13cmos5l_decap_8
XFILLER_309_225 VPWR VGND sg13cmos5l_decap_4
XFILLER_525_111 VPWR VGND sg13cmos5l_decap_8
X_2876_ Tile_X0Y6_EE4BEG[13] _4525_/X VPWR VGND sg13cmos5l_buf_1
XFILLER_376_191 VPWR VGND sg13cmos5l_decap_8
XFILLER_276_35 VPWR VGND sg13cmos5l_decap_8
X_1827_ _1827_/Q Tile_X0Y3_FrameData[6] VGND VPWR Tile_X0Y9_FrameStrobe[4] latch
X_4615_ _4615_/X Tile_X0Y7_W2MID[4] AXI_M_SOC_RDATA19 _4675_/X _4674_/X _0329_/Q _0328_/Q
+ VPWR VGND sg13cmos5l_mux4_1
XFILLER_525_166 VPWR VGND sg13cmos5l_decap_8
XFILLER_525_177 VPWR VGND sg13cmos5l_fill_1
XFILLER_540_114 VPWR VGND sg13cmos5l_decap_8
XFILLER_324_228 VPWR VGND sg13cmos5l_fill_1
X_4546_ _4546_/X Tile_X0Y5_W1END[1] Tile_X0Y5_W6END[9] _4464_/X _4419_/X _2401_/Q
+ _2400_/Q VPWR VGND sg13cmos5l_mux4_1
X_1758_ _1758_/Q Tile_X0Y3_FrameData[11] VGND VPWR Tile_X0Y9_FrameStrobe[2] latch
XFILLER_426_49 VPWR VGND sg13cmos5l_decap_8
XFILLER_209_84 VPWR VGND sg13cmos5l_decap_8
XFILLER_89_204 VPWR VGND sg13cmos5l_decap_8
XFILLER_573_77 VPWR VGND sg13cmos5l_decap_8
X_0709_ _0709_/Q Tile_X0Y9_FrameData[26] VGND VPWR Tile_X0Y9_FrameStrobe[1] latch
XFILLER_145_28 VPWR VGND sg13cmos5l_decap_8
XFILLER_143_161 VPWR VGND sg13cmos5l_decap_8
X_4477_ _4477_/X Tile_X0Y7_W2MID[3] Tile_X0Y7_W2END[3] Tile_X0Y7_W6END[3] _4674_/X
+ _0399_/Q _0398_/Q VPWR VGND sg13cmos5l_mux4_1
X_1689_ _1689_/Q Tile_X0Y3_FrameData[16] VGND VPWR Tile_X0Y9_FrameStrobe[0] latch
XANTENNA__3534__X Tile_X0Y9_E2BEGb[0] VPWR VGND sg13cmos5l_antennanp
XFILLER_292_56 VPWR VGND sg13cmos5l_decap_8
X_3428_ Tile_X0Y4_FrameData_O[19] Tile_X0Y4_FrameData[19] VPWR VGND sg13cmos5l_buf_1
XFILLER_289_187 VPWR VGND sg13cmos5l_decap_8
X_3359_ Tile_X0Y2_FrameData_O[30] Tile_X0Y2_FrameData[30] VPWR VGND sg13cmos5l_buf_1
XFILLER_57_134 VPWR VGND sg13cmos5l_decap_8
XFILLER_245_202 VPWR VGND sg13cmos5l_decap_8
XFILLER_161_49 VPWR VGND sg13cmos5l_decap_8
XFILLER_522_70 VPWR VGND sg13cmos5l_decap_8
XFILLER_650_210 VPWR VGND sg13cmos5l_decap_8
XFILLER_461_121 VPWR VGND sg13cmos5l_fill_2
XFILLER_173_7 VPWR VGND sg13cmos5l_decap_8
XFILLER_54_14 VPWR VGND sg13cmos5l_decap_8
XFILLER_598_63 VPWR VGND sg13cmos5l_decap_8
XFILLER_461_187 VPWR VGND sg13cmos5l_decap_8
XFILLER_610_129 VPWR VGND sg13cmos5l_decap_8
XFILLER_340_7 VPWR VGND sg13cmos5l_fill_2
XFILLER_438_7 VPWR VGND sg13cmos5l_decap_8
XFILLER_213_154 VPWR VGND sg13cmos5l_decap_8
XFILLER_80_192 VPWR VGND sg13cmos5l_fill_1
XFILLER_110_42 VPWR VGND sg13cmos5l_decap_8
XFILLER_70_35 VPWR VGND sg13cmos5l_decap_8
XFILLER_467_56 VPWR VGND sg13cmos5l_fill_2
XANTENNA__3709__X AXI_M_SOC_WDATA19 VPWR VGND sg13cmos5l_antennanp
XFILLER_374_139 VPWR VGND sg13cmos5l_decap_8
XFILLER_605_7 VPWR VGND sg13cmos5l_decap_8
XFILLER_186_35 VPWR VGND sg13cmos5l_decap_8
XFILLER_181_201 VPWR VGND sg13cmos5l_decap_8
XFILLER_677_107 VPWR VGND sg13cmos5l_fill_1
XFILLER_382_194 VPWR VGND sg13cmos5l_decap_8
XFILLER_336_49 VPWR VGND sg13cmos5l_decap_8
XFILLER_119_95 VPWR VGND sg13cmos5l_decap_8
XFILLER_330_209 VPWR VGND sg13cmos5l_fill_2
XFILLER_483_77 VPWR VGND sg13cmos5l_decap_8
XFILLER_633_14 VPWR VGND sg13cmos5l_decap_8
XFILLER_79_77 VPWR VGND sg13cmos5l_decap_8
XANTENNA__3444__X Tile_X0Y1_FrameData_O[2] VPWR VGND sg13cmos5l_antennanp
XFILLER_484_213 VPWR VGND sg13cmos5l_fill_1
XFILLER_0_141 VPWR VGND sg13cmos5l_fill_2
XFILLER_95_21 VPWR VGND sg13cmos5l_decap_8
XFILLER_297_0 VPWR VGND sg13cmos5l_decap_8
XFILLER_576_2 VPWR VGND sg13cmos5l_fill_1
XFILLER_713_91 VPWR VGND sg13cmos5l_decap_8
XFILLER_48_156 VPWR VGND sg13cmos5l_fill_1
XFILLER_437_184 VPWR VGND sg13cmos5l_fill_2
XFILLER_641_210 VPWR VGND sg13cmos5l_fill_2
XFILLER_452_110 VPWR VGND sg13cmos5l_decap_8
XFILLER_432_70 VPWR VGND sg13cmos5l_decap_8
XFILLER_641_221 VPWR VGND sg13cmos5l_fill_1
XFILLER_464_0 VPWR VGND sg13cmos5l_decap_8
XFILLER_63_104 VPWR VGND sg13cmos5l_decap_8
XFILLER_28_70 VPWR VGND sg13cmos5l_decap_8
XFILLER_598_158 VPWR VGND sg13cmos5l_fill_2
XFILLER_631_0 VPWR VGND sg13cmos5l_decap_8
XFILLER_301_63 VPWR VGND sg13cmos5l_decap_8
XFILLER_204_154 VPWR VGND sg13cmos5l_decap_8
XFILLER_658_77 VPWR VGND sg13cmos5l_decap_8
X_0991_ _0991_/Q Tile_X0Y0_FrameData[12] VGND VPWR Tile_X0Y9_FrameStrobe[1] latch
XANTENNA__3619__X Tile_X0Y9_S2BEGb[5] VPWR VGND sg13cmos5l_antennanp
XFILLER_554_228 VPWR VGND sg13cmos5l_fill_1
XFILLER_377_56 VPWR VGND sg13cmos5l_decap_8
X_2730_ _3860_/A3 VPWR VGND sg13cmos5l_tielo
XFILLER_674_21 VPWR VGND sg13cmos5l_decap_8
XFILLER_507_133 VPWR VGND sg13cmos5l_decap_8
X_2661_ _2661_/Q Tile_X0Y6_FrameData[2] VGND VPWR Tile_X0Y9_FrameStrobe[6] latch
XFILLER_306_217 VPWR VGND sg13cmos5l_fill_1
X_4400_ _4400_/X Tile_X0Y5_WW4END[3] AXI_M_SOC_RRESP1 _4454_/X _4434_/X _2303_/Q _2302_/Q
+ VPWR VGND sg13cmos5l_mux4_1
X_1612_ _1612_/Q Tile_X0Y2_FrameData[5] VGND VPWR Tile_X0Y9_FrameStrobe[5] latch
X_2592_ _2592_/Q Tile_X0Y6_FrameData[7] VGND VPWR Tile_X0Y9_FrameStrobe[4] latch
XFILLER_674_98 VPWR VGND sg13cmos5l_fill_2
XFILLER_246_49 VPWR VGND sg13cmos5l_decap_8
XFILLER_607_70 VPWR VGND sg13cmos5l_decap_8
X_4331_ _4331_/X _4806_/X _4810_/X _4814_/X _4789_/X _0641_/Q _0640_/Q VPWR VGND sg13cmos5l_mux4_1
X_1543_ _1543_/Q Tile_X0Y2_FrameData[10] VGND VPWR Tile_X0Y9_FrameStrobe[3] latch
XFILLER_543_14 VPWR VGND sg13cmos5l_decap_8
XFILLER_5_63 VPWR VGND sg13cmos5l_decap_8
XANTENNA__3354__X Tile_X0Y2_FrameData_O[25] VPWR VGND sg13cmos5l_antennanp
XFILLER_690_42 VPWR VGND sg13cmos5l_decap_8
X_4262_ _4262_/X Tile_X0Y4_W2MID[1] AXI_M_SOC_BRESP0 _4315_/X _4314_/X _2089_/Q _2088_/Q
+ VPWR VGND sg13cmos5l_mux4_1
X_1474_ _1474_/Q Tile_X0Y2_FrameData[15] VGND VPWR Tile_X0Y9_FrameStrobe[1] latch
X_3213_ Tile_X0Y0_FrameStrobe_O[1] Tile_X0Y9_FrameStrobe[1] VPWR VGND sg13cmos5l_buf_1
X_0425_ _0425_/Q Tile_X0Y8_FrameData[22] VGND VPWR Tile_X0Y9_FrameStrobe[0] latch
X_4193_ _4193_/X _4203_/X Tile_X0Y3_W6END[3] _4202_/X _4193_/A3 _1675_/Q _1926_/Q
+ VPWR VGND sg13cmos5l_mux4_1
XFILLER_428_140 VPWR VGND sg13cmos5l_decap_8
XFILLER_623_91 VPWR VGND sg13cmos5l_decap_8
XFILLER_490_216 VPWR VGND sg13cmos5l_fill_1
X_3144_ Tile_X0Y7_FrameData_O[14] Tile_X0Y7_FrameData[14] VPWR VGND sg13cmos5l_buf_1
XFILLER_691_176 VPWR VGND sg13cmos5l_fill_1
X_0356_ _0356_/Q Tile_X0Y7_FrameData[27] VGND VPWR Tile_X0Y9_FrameStrobe[6] latch
XFILLER_10_0 VPWR VGND sg13cmos5l_decap_8
XFILLER_699_40 VPWR VGND sg13cmos5l_decap_8
XFILLER_691_198 VPWR VGND sg13cmos5l_decap_4
XFILLER_342_70 VPWR VGND sg13cmos5l_decap_8
XFILLER_39_167 VPWR VGND sg13cmos5l_decap_4
X_3075_ Tile_X0Y4_E2BEGb[1] _4265_/X VPWR VGND sg13cmos5l_buf_1
X_0287_ _0287_/Q Tile_X0Y7_FrameData[0] VGND VPWR Tile_X0Y9_FrameStrobe[3] latch
X_2026_ _2026_/Q Tile_X0Y4_FrameData[27] VGND VPWR Tile_X0Y9_FrameStrobe[3] latch
XFILLER_54_159 VPWR VGND sg13cmos5l_decap_8
XFILLER_242_227 VPWR VGND sg13cmos5l_fill_2
XFILLER_211_63 VPWR VGND sg13cmos5l_decap_8
XFILLER_597_180 VPWR VGND sg13cmos5l_fill_1
XFILLER_24_28 VPWR VGND sg13cmos5l_decap_8
XFILLER_568_77 VPWR VGND sg13cmos5l_decap_8
X_3977_ _3977_/X _3983_/X Tile_X0Y1_W6END[1] _3982_/X _3977_/A3 _1183_/Q _1182_/Q
+ VPWR VGND sg13cmos5l_mux4_1
XFILLER_545_228 VPWR VGND sg13cmos5l_fill_1
XFILLER_287_56 VPWR VGND sg13cmos5l_decap_8
XANTENNA__3529__X Tile_X0Y9_E2BEG[3] VPWR VGND sg13cmos5l_antennanp
XFILLER_210_168 VPWR VGND sg13cmos5l_decap_8
X_2928_ Tile_X0Y8_E2BEGb[4] _4740_/X VPWR VGND sg13cmos5l_buf_1
XFILLER_584_21 VPWR VGND sg13cmos5l_decap_8
XFILLER_108_117 VPWR VGND sg13cmos5l_decap_8
X_2859_ Tile_X0Y6_E6BEG[8] _4536_/X VPWR VGND sg13cmos5l_buf_1
XFILLER_163_223 VPWR VGND sg13cmos5l_decap_4
XFILLER_40_49 VPWR VGND sg13cmos5l_decap_8
XFILLER_584_98 VPWR VGND sg13cmos5l_decap_8
XFILLER_156_49 VPWR VGND sg13cmos5l_decap_8
XFILLER_517_70 VPWR VGND sg13cmos5l_decap_8
X_4529_ _4529_/X Tile_X0Y9_N4END[13] _0153_/X _4578_/X _4582_/X _2549_/Q _2548_/Q
+ VPWR VGND sg13cmos5l_mux4_1
XFILLER_453_14 VPWR VGND sg13cmos5l_decap_8
XANTENNA__3264__X Tile_X0Y0_EE4BEG[0] VPWR VGND sg13cmos5l_antennanp
XFILLER_290_7 VPWR VGND sg13cmos5l_decap_8
XFILLER_603_28 VPWR VGND sg13cmos5l_decap_8
XFILLER_388_7 VPWR VGND sg13cmos5l_decap_8
XFILLER_292_105 VPWR VGND sg13cmos5l_decap_8
XFILLER_533_91 VPWR VGND sg13cmos5l_decap_4
XFILLER_105_42 VPWR VGND sg13cmos5l_decap_8
XFILLER_419_162 VPWR VGND sg13cmos5l_decap_8
XFILLER_252_70 VPWR VGND sg13cmos5l_decap_8
XFILLER_65_35 VPWR VGND sg13cmos5l_decap_8
XFILLER_555_7 VPWR VGND sg13cmos5l_decap_8
XFILLER_45_137 VPWR VGND sg13cmos5l_fill_1
XFILLER_434_176 VPWR VGND sg13cmos5l_decap_8
XFILLER_45_159 VPWR VGND sg13cmos5l_decap_4
XFILLER_121_63 VPWR VGND sg13cmos5l_decap_8
XFILLER_81_56 VPWR VGND sg13cmos5l_decap_8
XFILLER_478_77 VPWR VGND sg13cmos5l_fill_1
XFILLER_478_99 VPWR VGND sg13cmos5l_decap_4
XFILLER_536_228 VPWR VGND sg13cmos5l_fill_1
XFILLER_197_56 VPWR VGND sg13cmos5l_decap_8
XANTENNA__3439__X Tile_X0Y4_FrameData_O[30] VPWR VGND sg13cmos5l_antennanp
XFILLER_628_47 VPWR VGND sg13cmos5l_decap_8
XFILLER_494_21 VPWR VGND sg13cmos5l_decap_8
XFILLER_355_161 VPWR VGND sg13cmos5l_decap_8
XFILLER_212_0 VPWR VGND sg13cmos5l_decap_8
XFILLER_708_91 VPWR VGND sg13cmos5l_decap_8
XFILLER_494_98 VPWR VGND sg13cmos5l_decap_8
XFILLER_504_147 VPWR VGND sg13cmos5l_fill_1
XFILLER_644_35 VPWR VGND sg13cmos5l_decap_8
XFILLER_427_70 VPWR VGND sg13cmos5l_decap_8
XFILLER_363_14 VPWR VGND sg13cmos5l_decap_8
XANTENNA__3174__X Tile_X0Y4_E6BEG[11] VPWR VGND sg13cmos5l_antennanp
XFILLER_457_213 VPWR VGND sg13cmos5l_fill_1
XFILLER_581_0 VPWR VGND sg13cmos5l_decap_8
XFILLER_679_0 VPWR VGND sg13cmos5l_decap_8
XFILLER_513_28 VPWR VGND sg13cmos5l_decap_8
XFILLER_673_154 VPWR VGND sg13cmos5l_decap_8
XFILLER_283_105 VPWR VGND sg13cmos5l_decap_8
XFILLER_660_56 VPWR VGND sg13cmos5l_decap_8
XFILLER_472_216 VPWR VGND sg13cmos5l_fill_2
XFILLER_443_91 VPWR VGND sg13cmos5l_decap_8
X_0210_ _0210_/Q Tile_X0Y7_FrameData[13] VGND VPWR Tile_X0Y9_FrameStrobe[1] latch
X_1190_ _1190_/Q Tile_X0Y1_FrameData[19] VGND VPWR Tile_X0Y9_FrameStrobe[0] latch
XFILLER_162_70 VPWR VGND sg13cmos5l_fill_2
XFILLER_614_221 VPWR VGND sg13cmos5l_decap_8
X_0141_ AXI_M_SOC_ARLEN1 _0933_/Q _3761_/X VPWR VGND sg13cmos5l_nor2b_1
XFILLER_425_154 VPWR VGND sg13cmos5l_decap_8
XFILLER_669_21 VPWR VGND sg13cmos5l_decap_8
XFILLER_36_148 VPWR VGND sg13cmos5l_decap_8
X_0072_ AXI_M_SOC_AWCACHE3 _0936_/Q _3688_/X VPWR VGND sg13cmos5l_nor2b_1
XFILLER_291_193 VPWR VGND sg13cmos5l_decap_8
X_3900_ _3900_/X Tile_X0Y2_W2MID[1] Tile_X0Y2_W2END[1] Tile_X0Y2_W6END[1] _4098_/X
+ _1653_/Q _1652_/Q VPWR VGND sg13cmos5l_mux4_1
X_4880_ _4880_/X Tile_X0Y9_N4END[0] _0083_/X _4927_/X _4931_/X _0783_/Q _0782_/Q VPWR
+ VGND sg13cmos5l_mux4_1
XFILLER_189_153 VPWR VGND sg13cmos5l_fill_1
X_3831_ _3831_/X Tile_X0Y0_WW4END[4] Tile_X0Y0_WW4END[11] _3885_/X _3858_/X _1043_/Q
+ _1042_/Q VPWR VGND sg13cmos5l_mux4_1
XFILLER_527_206 VPWR VGND sg13cmos5l_decap_8
XFILLER_538_14 VPWR VGND sg13cmos5l_decap_8
XFILLER_527_217 VPWR VGND sg13cmos5l_fill_2
XANTENNA__3349__X Tile_X0Y2_FrameData_O[20] VPWR VGND sg13cmos5l_antennanp
XFILLER_527_228 VPWR VGND sg13cmos5l_fill_1
XFILLER_685_42 VPWR VGND sg13cmos5l_decap_8
X_3762_ _3762_/X Tile_X0Y1_WW4END[3] Tile_X0Y1_WW4END[11] Tile_X0Y1_W6END[3] _4011_/X
+ _1251_/Q _1250_/Q VPWR VGND sg13cmos5l_mux4_1
X_0974_ _0974_/Q Tile_X0Y0_FrameData[29] VGND VPWR Tile_X0Y9_FrameStrobe[1] latch
XFILLER_72_2 VPWR VGND sg13cmos5l_fill_1
X_2713_ _4542_/A3 VPWR VGND sg13cmos5l_tielo
X_3693_ AXI_M_SOC_WDATA3 Tile_X0Y7_WW4END[3] Tile_X0Y7_WW4END[11] Tile_X0Y7_W6END[3]
+ _4687_/X _0241_/Q _0240_/Q VPWR VGND sg13cmos5l_mux4_1
XFILLER_618_91 VPWR VGND sg13cmos5l_decap_8
X_2644_ _2644_/Q Tile_X0Y6_FrameData[19] VGND VPWR Tile_X0Y9_FrameStrobe[6] latch
XFILLER_554_35 VPWR VGND sg13cmos5l_decap_8
XFILLER_337_70 VPWR VGND sg13cmos5l_decap_8
XFILLER_58_0 VPWR VGND sg13cmos5l_fill_1
XFILLER_361_175 VPWR VGND sg13cmos5l_fill_2
XFILLER_273_14 VPWR VGND sg13cmos5l_decap_8
X_2575_ _2575_/Q Tile_X0Y6_FrameData[24] VGND VPWR Tile_X0Y9_FrameStrobe[4] latch
XANTENNA__3084__X Tile_X0Y7_E1BEG[2] VPWR VGND sg13cmos5l_antennanp
XFILLER_649_140 VPWR VGND sg13cmos5l_decap_8
XFILLER_649_151 VPWR VGND sg13cmos5l_fill_2
X_1526_ _1526_/Q Tile_X0Y2_FrameData[27] VGND VPWR Tile_X0Y9_FrameStrobe[3] latch
X_4314_ _4314_/X _4249_/X _4365_/X _4364_/X _4248_/X _1937_/Q _1936_/Q VPWR VGND sg13cmos5l_mux4_1
XFILLER_259_113 VPWR VGND sg13cmos5l_decap_8
XFILLER_704_49 VPWR VGND sg13cmos5l_decap_8
XFILLER_649_184 VPWR VGND sg13cmos5l_decap_8
XFILLER_59_207 VPWR VGND sg13cmos5l_decap_8
XFILLER_649_195 VPWR VGND sg13cmos5l_decap_8
X_4245_ _4245_/X Tile_X0Y5_W2MID[3] Tile_X0Y5_W2END[3] Tile_X0Y5_W6END[3] _4433_/X
+ _2423_/Q _2422_/Q VPWR VGND sg13cmos5l_mux4_1
XFILLER_423_28 VPWR VGND sg13cmos5l_decap_8
X_1457_ _1457_/Q Tile_X0Y2_FrameData[0] VGND VPWR Tile_X0Y9_FrameStrobe[0] latch
XFILLER_206_63 VPWR VGND sg13cmos5l_decap_8
XFILLER_274_105 VPWR VGND sg13cmos5l_decap_8
XFILLER_570_56 VPWR VGND sg13cmos5l_decap_8
XFILLER_19_28 VPWR VGND sg13cmos5l_decap_8
XFILLER_353_91 VPWR VGND sg13cmos5l_decap_8
X_0408_ _0408_/Q Tile_X0Y7_FrameData[7] VGND VPWR Tile_X0Y9_FrameStrobe[7] latch
XFILLER_463_227 VPWR VGND sg13cmos5l_fill_2
X_4176_ _4176_/X Tile_X0Y3_WW4END[3] AXI_M_SOC_BVALID _4225_/X _4211_/X _1789_/Q _1788_/Q
+ VPWR VGND sg13cmos5l_mux4_1
X_1388_ _1388_/Q Tile_X0Y1_FrameData[13] VGND VPWR Tile_X0Y9_FrameStrobe[6] latch
X_3127_ Tile_X0Y7_EE4BEG[13] _4641_/X VPWR VGND sg13cmos5l_buf_1
X_0339_ _0339_/Q Tile_X0Y7_FrameData[12] VGND VPWR Tile_X0Y9_FrameStrobe[5] latch
XFILLER_579_21 VPWR VGND sg13cmos5l_decap_8
XFILLER_282_182 VPWR VGND sg13cmos5l_fill_2
X_3058_ Tile_X0Y5_FrameData_O[17] Tile_X0Y5_FrameData[17] VPWR VGND sg13cmos5l_buf_1
XFILLER_620_224 VPWR VGND sg13cmos5l_decap_4
XFILLER_222_84 VPWR VGND sg13cmos5l_decap_8
XFILLER_35_49 VPWR VGND sg13cmos5l_decap_8
X_2009_ _2009_/Q Tile_X0Y4_FrameData[12] VGND VPWR Tile_X0Y9_FrameStrobe[2] latch
XFILLER_579_98 VPWR VGND sg13cmos5l_decap_8
XFILLER_431_168 VPWR VGND sg13cmos5l_decap_8
XFILLER_50_140 VPWR VGND sg13cmos5l_fill_2
XFILLER_298_77 VPWR VGND sg13cmos5l_decap_8
XFILLER_448_14 VPWR VGND sg13cmos5l_decap_8
XFILLER_329_117 VPWR VGND sg13cmos5l_decap_8
XFILLER_298_88 VPWR VGND sg13cmos5l_fill_2
XFILLER_518_217 VPWR VGND sg13cmos5l_fill_2
XANTENNA__3259__X Tile_X0Y0_FrameData_O[27] VPWR VGND sg13cmos5l_antennanp
XFILLER_518_228 VPWR VGND sg13cmos5l_fill_1
XFILLER_595_42 VPWR VGND sg13cmos5l_decap_8
XFILLER_195_156 VPWR VGND sg13cmos5l_decap_8
XFILLER_136_7 VPWR VGND sg13cmos5l_decap_8
XFILLER_51_48 VPWR VGND sg13cmos5l_decap_8
XFILLER_136_201 VPWR VGND sg13cmos5l_decap_8
XFILLER_337_172 VPWR VGND sg13cmos5l_decap_8
XFILLER_337_183 VPWR VGND sg13cmos5l_fill_2
XFILLER_303_7 VPWR VGND sg13cmos5l_decap_8
XFILLER_464_35 VPWR VGND sg13cmos5l_decap_8
XFILLER_352_175 VPWR VGND sg13cmos5l_decap_8
XFILLER_498_168 VPWR VGND sg13cmos5l_decap_8
XFILLER_183_14 VPWR VGND sg13cmos5l_decap_8
XFILLER_614_49 VPWR VGND sg13cmos5l_decap_8
XFILLER_104_175 VPWR VGND sg13cmos5l_fill_2
XANTENNA__0130__Y AXI_M_SOC_AWSIZE0 VPWR VGND sg13cmos5l_antennanp
XFILLER_672_7 VPWR VGND sg13cmos5l_decap_8
XFILLER_333_28 VPWR VGND sg13cmos5l_decap_8
XFILLER_116_63 VPWR VGND sg13cmos5l_decap_8
XFILLER_655_154 VPWR VGND sg13cmos5l_decap_8
XFILLER_480_56 VPWR VGND sg13cmos5l_decap_8
XFILLER_454_216 VPWR VGND sg13cmos5l_fill_2
XFILLER_76_56 VPWR VGND sg13cmos5l_decap_8
XFILLER_265_149 VPWR VGND sg13cmos5l_decap_8
XFILLER_280_119 VPWR VGND sg13cmos5l_decap_8
XFILLER_273_160 VPWR VGND sg13cmos5l_decap_8
XFILLER_489_21 VPWR VGND sg13cmos5l_decap_8
XFILLER_273_171 VPWR VGND sg13cmos5l_fill_1
XFILLER_407_187 VPWR VGND sg13cmos5l_decap_8
XFILLER_611_224 VPWR VGND sg13cmos5l_decap_4
XFILLER_132_84 VPWR VGND sg13cmos5l_decap_8
XFILLER_710_70 VPWR VGND sg13cmos5l_decap_8
XFILLER_162_0 VPWR VGND sg13cmos5l_decap_8
XFILLER_489_98 VPWR VGND sg13cmos5l_decap_8
XFILLER_422_168 VPWR VGND sg13cmos5l_decap_8
XFILLER_639_35 VPWR VGND sg13cmos5l_decap_8
XFILLER_358_14 VPWR VGND sg13cmos5l_decap_8
XFILLER_375_212 VPWR VGND sg13cmos5l_decap_8
XANTENNA__3169__X Tile_X0Y4_E6BEG[6] VPWR VGND sg13cmos5l_antennanp
XFILLER_427_0 VPWR VGND sg13cmos5l_decap_8
XFILLER_186_145 VPWR VGND sg13cmos5l_decap_8
XFILLER_335_109 VPWR VGND sg13cmos5l_decap_4
XFILLER_390_215 VPWR VGND sg13cmos5l_decap_8
XFILLER_328_150 VPWR VGND sg13cmos5l_decap_8
XFILLER_127_201 VPWR VGND sg13cmos5l_fill_1
XFILLER_508_28 VPWR VGND sg13cmos5l_decap_8
XFILLER_655_56 VPWR VGND sg13cmos5l_decap_8
XFILLER_438_91 VPWR VGND sg13cmos5l_decap_8
XANTENNA__2801__X Tile_X0Y3_E6BEG[11] VPWR VGND sg13cmos5l_antennanp
X_0690_ _0690_/Q Tile_X0Y9_FrameData[13] VGND VPWR Tile_X0Y9_FrameStrobe[0] latch
XFILLER_343_142 VPWR VGND sg13cmos5l_decap_4
XFILLER_374_35 VPWR VGND sg13cmos5l_decap_8
XFILLER_157_70 VPWR VGND sg13cmos5l_decap_8
XFILLER_489_168 VPWR VGND sg13cmos5l_decap_8
XFILLER_374_79 VPWR VGND sg13cmos5l_fill_1
X_2360_ _2360_/Q Tile_X0Y5_FrameData[13] VGND VPWR Tile_X0Y9_FrameStrobe[5] latch
XFILLER_524_49 VPWR VGND sg13cmos5l_decap_8
XFILLER_307_84 VPWR VGND sg13cmos5l_decap_8
X_1311_ _1311_/Q Tile_X0Y1_FrameData[26] VGND VPWR Tile_X0Y9_FrameStrobe[4] latch
XFILLER_671_77 VPWR VGND sg13cmos5l_decap_8
XFILLER_243_28 VPWR VGND sg13cmos5l_decap_8
X_2291_ _2291_/Q Tile_X0Y5_FrameData[18] VGND VPWR Tile_X0Y9_FrameStrobe[3] latch
XFILLER_500_161 VPWR VGND sg13cmos5l_decap_8
XFILLER_671_99 VPWR VGND sg13cmos5l_fill_2
XFILLER_646_154 VPWR VGND sg13cmos5l_decap_8
XANTENNA__3632__X Tile_X0Y9_S4BEG[10] VPWR VGND sg13cmos5l_antennanp
XFILLER_390_56 VPWR VGND sg13cmos5l_decap_8
XFILLER_173_91 VPWR VGND sg13cmos5l_decap_8
X_4030_ _4030_/X Tile_X0Y0_W1END[1] Tile_X0Y0_W2MID[2] Tile_X0Y0_W2END[2] _3856_/X
+ _1123_/Q _1122_/Q VPWR VGND sg13cmos5l_mux4_1
X_1242_ _1242_/Q Tile_X0Y1_FrameData[31] VGND VPWR Tile_X0Y9_FrameStrobe[2] latch
XFILLER_2_42 VPWR VGND sg13cmos5l_decap_8
XFILLER_110_156 VPWR VGND sg13cmos5l_decap_8
X_1173_ _1173_/Q Tile_X0Y0_FrameData[22] VGND VPWR Tile_X0Y9_FrameStrobe[7] latch
XFILLER_323_83 VPWR VGND sg13cmos5l_decap_8
XFILLER_64_221 VPWR VGND sg13cmos5l_fill_1
XFILLER_399_21 VPWR VGND sg13cmos5l_decap_8
X_0124_ AXI_M_SOC_ARSIZE1 _0932_/Q _3769_/X VPWR VGND sg13cmos5l_or2_1
XFILLER_264_182 VPWR VGND sg13cmos5l_decap_4
XFILLER_602_213 VPWR VGND sg13cmos5l_decap_8
XFILLER_620_70 VPWR VGND sg13cmos5l_decap_8
XFILLER_413_135 VPWR VGND sg13cmos5l_decap_4
X_0055_ _0055_/X _4678_/X _4679_/X _1860_/Q VPWR VGND sg13cmos5l_mux2_1
X_4932_ _4932_/X Tile_X0Y8_W2MID[7] Tile_X0Y8_W2END[7] Tile_X0Y8_W6END[8] _4785_/X
+ _0627_/Q _0626_/Q VPWR VGND sg13cmos5l_mux4_1
XFILLER_549_35 VPWR VGND sg13cmos5l_decap_8
XFILLER_696_63 VPWR VGND sg13cmos5l_decap_8
X_4863_ _4863_/X Tile_X0Y9_W2END[0] AXI_M_SOC_RDATA0 _4901_/X _4900_/X _0817_/Q _0816_/Q
+ VPWR VGND sg13cmos5l_mux4_1
XFILLER_567_161 VPWR VGND sg13cmos5l_fill_1
XFILLER_32_151 VPWR VGND sg13cmos5l_fill_2
XANTENNA__3079__X Tile_X0Y4_E2BEGb[5] VPWR VGND sg13cmos5l_antennanp
XFILLER_177_134 VPWR VGND sg13cmos5l_decap_8
XANTENNA_14 Tile_X0Y0_S2MID[7] VPWR VGND sg13cmos5l_antennanp
XFILLER_268_47 VPWR VGND sg13cmos5l_decap_8
XANTENNA_25 _4816_/X VPWR VGND sg13cmos5l_antennanp
X_3814_ _3814_/X Tile_X0Y0_W2END[3] Tile_X0Y0_W2END[5] _3857_/X _3856_/X _1077_/Q
+ _1076_/Q VPWR VGND sg13cmos5l_mux4_1
XFILLER_177_156 VPWR VGND sg13cmos5l_decap_8
XANTENNA_36 Tile_X0Y9_FrameStrobe[18] VPWR VGND sg13cmos5l_antennanp
XFILLER_716_147 VPWR VGND sg13cmos5l_decap_4
X_4794_ _4794_/X Tile_X0Y4_W1END[1] Tile_X0Y4_WW4END[13] Tile_X0Y4_W6END[5] _4337_/X
+ _2118_/Q _2117_/Q VPWR VGND sg13cmos5l_mux4_1
XANTENNA_47 Tile_X0Y9_N2MID[2] VPWR VGND sg13cmos5l_antennanp
XANTENNA_58 Tile_X0Y9_N2MID[6] VPWR VGND sg13cmos5l_antennanp
X_0957_ _0957_/Q Tile_X0Y0_FrameData[14] VGND VPWR Tile_X0Y9_FrameStrobe[0] latch
X_3745_ AXI_M_SOC_ARADDR17 Tile_X0Y8_WW4END[1] Tile_X0Y8_WW4END[9] Tile_X0Y8_W6END[1]
+ _4801_/X _0501_/Q _0500_/Q VPWR VGND sg13cmos5l_mux4_1
XFILLER_418_28 VPWR VGND sg13cmos5l_decap_8
XFILLER_319_172 VPWR VGND sg13cmos5l_decap_8
XFILLER_118_223 VPWR VGND sg13cmos5l_decap_4
XFILLER_565_56 VPWR VGND sg13cmos5l_decap_8
XFILLER_348_91 VPWR VGND sg13cmos5l_decap_8
XFILLER_334_142 VPWR VGND sg13cmos5l_decap_8
X_0888_ _0888_/Q Tile_X0Y9_FrameData[7] VGND VPWR Tile_X0Y9_FrameStrobe[6] latch
X_3676_ _3676_/X Tile_X0Y2_WW4END[6] Tile_X0Y2_WW4END[14] Tile_X0Y2_W6END[6] _4122_/X
+ _1493_/Q _1492_/Q VPWR VGND sg13cmos5l_mux4_1
XFILLER_284_35 VPWR VGND sg13cmos5l_decap_8
X_2627_ _2627_/Q Tile_X0Y6_FrameData[4] VGND VPWR Tile_X0Y9_FrameStrobe[5] latch
XFILLER_495_105 VPWR VGND sg13cmos5l_decap_8
X_2558_ _2558_/Q Tile_X0Y6_FrameData[9] VGND VPWR Tile_X0Y9_FrameStrobe[3] latch
XFILLER_434_49 VPWR VGND sg13cmos5l_decap_8
XFILLER_217_84 VPWR VGND sg13cmos5l_decap_8
X_1509_ _1509_/Q Tile_X0Y2_FrameData[12] VGND VPWR Tile_X0Y9_FrameStrobe[2] latch
XFILLER_581_77 VPWR VGND sg13cmos5l_decap_8
XFILLER_153_28 VPWR VGND sg13cmos5l_decap_8
X_2489_ _2489_/Q Tile_X0Y6_FrameData[14] VGND VPWR Tile_X0Y9_FrameStrobe[1] latch
XFILLER_637_154 VPWR VGND sg13cmos5l_fill_1
XANTENNA__3542__X Tile_X0Y9_E6BEG[0] VPWR VGND sg13cmos5l_antennanp
X_4228_ _4228_/X _4200_/X _0087_/X _4199_/X Tile_X0Y0_S4END[14] _1717_/Q _1716_/Q
+ VPWR VGND sg13cmos5l_mux4_1
X_4159_ _4159_/X Tile_X0Y3_W2END[4] AXI_M_SOC_WREADY _4211_/X _4210_/X _1823_/Q _1822_/Q
+ VPWR VGND sg13cmos5l_mux4_1
XFILLER_652_168 VPWR VGND sg13cmos5l_decap_8
XFILLER_46_48 VPWR VGND sg13cmos5l_decap_8
XFILLER_530_70 VPWR VGND sg13cmos5l_decap_8
XFILLER_102_21 VPWR VGND sg13cmos5l_decap_8
XFILLER_70_224 VPWR VGND sg13cmos5l_decap_4
XFILLER_15_129 VPWR VGND sg13cmos5l_fill_1
XFILLER_253_7 VPWR VGND sg13cmos5l_decap_8
XFILLER_459_35 VPWR VGND sg13cmos5l_decap_8
XFILLER_168_101 VPWR VGND sg13cmos5l_decap_8
XFILLER_178_14 VPWR VGND sg13cmos5l_decap_8
XFILLER_102_98 VPWR VGND sg13cmos5l_decap_8
XFILLER_62_58 VPWR VGND sg13cmos5l_decap_8
XFILLER_558_172 VPWR VGND sg13cmos5l_decap_8
XFILLER_420_7 VPWR VGND sg13cmos5l_decap_8
XFILLER_518_7 VPWR VGND sg13cmos5l_decap_8
XFILLER_707_147 VPWR VGND sg13cmos5l_decap_8
XFILLER_609_49 VPWR VGND sg13cmos5l_decap_8
XFILLER_168_178 VPWR VGND sg13cmos5l_decap_8
XFILLER_573_175 VPWR VGND sg13cmos5l_decap_8
XFILLER_328_28 VPWR VGND sg13cmos5l_decap_8
XFILLER_183_126 VPWR VGND sg13cmos5l_decap_8
XANTENNA__3717__X AXI_M_SOC_WDATA27 VPWR VGND sg13cmos5l_antennanp
XFILLER_475_56 VPWR VGND sg13cmos5l_decap_8
XFILLER_258_91 VPWR VGND sg13cmos5l_decap_8
XFILLER_194_35 VPWR VGND sg13cmos5l_decap_8
XFILLER_124_226 VPWR VGND sg13cmos5l_fill_2
XFILLER_486_105 VPWR VGND sg13cmos5l_decap_8
XFILLER_11_84 VPWR VGND sg13cmos5l_decap_4
XFILLER_340_145 VPWR VGND sg13cmos5l_decap_8
XFILLER_11_95 VPWR VGND sg13cmos5l_decap_8
XFILLER_628_110 VPWR VGND sg13cmos5l_decap_4
XFILLER_344_49 VPWR VGND sg13cmos5l_decap_8
XFILLER_705_70 VPWR VGND sg13cmos5l_decap_8
XFILLER_491_77 VPWR VGND sg13cmos5l_decap_8
XFILLER_641_14 VPWR VGND sg13cmos5l_decap_8
XFILLER_87_77 VPWR VGND sg13cmos5l_decap_8
XANTENNA__3452__X Tile_X0Y1_FrameData_O[10] VPWR VGND sg13cmos5l_antennanp
XFILLER_494_182 VPWR VGND sg13cmos5l_decap_8
XFILLER_377_0 VPWR VGND sg13cmos5l_decap_8
XFILLER_643_168 VPWR VGND sg13cmos5l_decap_8
XFILLER_246_182 VPWR VGND sg13cmos5l_decap_8
XFILLER_61_202 VPWR VGND sg13cmos5l_decap_8
XFILLER_440_70 VPWR VGND sg13cmos5l_decap_8
XFILLER_544_0 VPWR VGND sg13cmos5l_decap_8
XFILLER_369_35 VPWR VGND sg13cmos5l_decap_8
XFILLER_159_101 VPWR VGND sg13cmos5l_decap_4
XFILLER_711_0 VPWR VGND sg13cmos5l_decap_8
XFILLER_99_7 VPWR VGND sg13cmos5l_decap_8
XFILLER_348_212 VPWR VGND sg13cmos5l_fill_2
XFILLER_159_134 VPWR VGND sg13cmos5l_decap_8
X_1860_ _1860_/Q Tile_X0Y3_FrameData[5] VGND VPWR Tile_X0Y9_FrameStrobe[5] latch
XFILLER_519_49 VPWR VGND sg13cmos5l_decap_8
XFILLER_308_109 VPWR VGND sg13cmos5l_fill_2
X_0811_ _0811_/Q Tile_X0Y9_FrameData[20] VGND VPWR Tile_X0Y9_FrameStrobe[4] latch
XFILLER_666_77 VPWR VGND sg13cmos5l_decap_8
XFILLER_238_28 VPWR VGND sg13cmos5l_decap_8
XFILLER_174_126 VPWR VGND sg13cmos5l_decap_8
X_1791_ _1791_/Q Tile_X0Y3_FrameData[10] VGND VPWR Tile_X0Y9_FrameStrobe[3] latch
XFILLER_385_56 VPWR VGND sg13cmos5l_decap_8
XANTENNA__3627__X Tile_X0Y9_S4BEG[5] VPWR VGND sg13cmos5l_antennanp
XFILLER_385_67 VPWR VGND sg13cmos5l_fill_1
X_0742_ _0742_/Q Tile_X0Y9_FrameData[25] VGND VPWR Tile_X0Y9_FrameStrobe[2] latch
X_3530_ Tile_X0Y9_E2BEG[4] _4852_/X VPWR VGND sg13cmos5l_buf_1
XFILLER_682_21 VPWR VGND sg13cmos5l_decap_8
XFILLER_385_89 VPWR VGND sg13cmos5l_fill_2
X_3461_ Tile_X0Y1_FrameData_O[19] Tile_X0Y1_FrameData[19] VPWR VGND sg13cmos5l_buf_1
XFILLER_331_101 VPWR VGND sg13cmos5l_decap_8
X_0673_ _0673_/Q Tile_X0Y9_FrameData[30] VGND VPWR Tile_X0Y9_FrameStrobe[0] latch
XFILLER_331_112 VPWR VGND sg13cmos5l_fill_2
XFILLER_316_186 VPWR VGND sg13cmos5l_decap_8
X_2412_ _2412_/Q Tile_X0Y5_FrameData[25] VGND VPWR Tile_X0Y9_FrameStrobe[7] latch
XFILLER_666_227 VPWR VGND sg13cmos5l_fill_2
X_3392_ Tile_X0Y2_E2BEGb[3] _4051_/X VPWR VGND sg13cmos5l_buf_1
XFILLER_682_98 VPWR VGND sg13cmos5l_decap_8
XFILLER_331_156 VPWR VGND sg13cmos5l_decap_8
XFILLER_254_49 VPWR VGND sg13cmos5l_decap_8
XFILLER_615_70 VPWR VGND sg13cmos5l_decap_8
XFILLER_96_110 VPWR VGND sg13cmos5l_decap_8
X_2343_ _2343_/Q Tile_X0Y5_FrameData[30] VGND VPWR Tile_X0Y9_FrameStrobe[5] latch
XFILLER_551_14 VPWR VGND sg13cmos5l_decap_8
XANTENNA__3362__X Tile_X0Y2_EE4BEG[1] VPWR VGND sg13cmos5l_antennanp
XFILLER_492_119 VPWR VGND sg13cmos5l_decap_8
XFILLER_284_211 VPWR VGND sg13cmos5l_decap_8
XFILLER_485_182 VPWR VGND sg13cmos5l_decap_8
XFILLER_96_165 VPWR VGND sg13cmos5l_decap_4
X_2274_ _2274_/Q Tile_X0Y5_FrameData[3] VGND VPWR Tile_X0Y9_FrameStrobe[2] latch
XFILLER_229_149 VPWR VGND sg13cmos5l_fill_1
X_4013_ _4013_/X _3983_/X _0096_/X _3982_/X Tile_X0Y0_S4END[5] _1223_/Q _1222_/Q VPWR
+ VGND sg13cmos5l_mux4_1
X_1225_ _1225_/Q Tile_X0Y1_FrameData[16] VGND VPWR Tile_X0Y9_FrameStrobe[1] latch
XFILLER_701_28 VPWR VGND sg13cmos5l_decap_8
XFILLER_433_208 VPWR VGND sg13cmos5l_decap_4
XFILLER_631_91 VPWR VGND sg13cmos5l_decap_8
XFILLER_203_42 VPWR VGND sg13cmos5l_decap_8
X_1156_ _1156_/Q Tile_X0Y0_FrameData[7] VGND VPWR Tile_X0Y9_FrameStrobe[6] latch
XFILLER_350_70 VPWR VGND sg13cmos5l_decap_8
XFILLER_52_213 VPWR VGND sg13cmos5l_decap_8
X_0107_ AXI_M_SOC_ARLEN2 _0933_/Q _3762_/X VPWR VGND sg13cmos5l_nor2b_1
XFILLER_398_145 VPWR VGND sg13cmos5l_fill_1
X_1087_ _1087_/Q Tile_X0Y0_FrameData[12] VGND VPWR Tile_X0Y9_FrameStrobe[4] latch
XFILLER_279_35 VPWR VGND sg13cmos5l_decap_8
XFILLER_398_189 VPWR VGND sg13cmos5l_fill_1
X_4915_ _4915_/X _4458_/X _4462_/X _4466_/X _4428_/X _2370_/Q _2369_/Q VPWR VGND sg13cmos5l_mux4_1
XFILLER_500_84 VPWR VGND sg13cmos5l_decap_8
XFILLER_32_17 VPWR VGND sg13cmos5l_decap_8
X_4846_ _4846_/X Tile_X0Y9_N1END[2] _4898_/X AXI_M_SOC_RDATA1 AXI_M_SOC_RDATA5 _0851_/Q
+ _0850_/Q VPWR VGND sg13cmos5l_mux4_1
XFILLER_429_49 VPWR VGND sg13cmos5l_decap_8
XFILLER_555_153 VPWR VGND sg13cmos5l_fill_1
XFILLER_576_77 VPWR VGND sg13cmos5l_decap_8
XFILLER_555_175 VPWR VGND sg13cmos5l_decap_8
XFILLER_165_126 VPWR VGND sg13cmos5l_decap_4
XFILLER_148_28 VPWR VGND sg13cmos5l_decap_8
X_4777_ _4777_/X Tile_X0Y9_W1END[0] Tile_X0Y9_W6END[4] _4928_/X _4892_/X _0927_/Q
+ _0926_/Q VPWR VGND sg13cmos5l_mux4_1
XFILLER_570_112 VPWR VGND sg13cmos5l_decap_8
XFILLER_20_176 VPWR VGND sg13cmos5l_decap_8
X_1989_ _1989_/Q Tile_X0Y4_FrameData[0] VGND VPWR Tile_X0Y9_FrameStrobe[1] latch
XFILLER_295_56 VPWR VGND sg13cmos5l_decap_8
XFILLER_20_187 VPWR VGND sg13cmos5l_fill_1
XANTENNA__3537__X Tile_X0Y9_E2BEGb[3] VPWR VGND sg13cmos5l_antennanp
XFILLER_307_120 VPWR VGND sg13cmos5l_decap_8
X_3728_ AXI_M_SOC_ARADDR0 Tile_X0Y9_WW4END[0] Tile_X0Y9_WW4END[8] Tile_X0Y9_W6END[0]
+ _4916_/X _0759_/Q _0758_/Q VPWR VGND sg13cmos5l_mux4_1
XFILLER_180_107 VPWR VGND sg13cmos5l_fill_1
XFILLER_592_21 VPWR VGND sg13cmos5l_decap_8
XFILLER_180_129 VPWR VGND sg13cmos5l_decap_8
XFILLER_570_189 VPWR VGND sg13cmos5l_decap_8
XFILLER_173_170 VPWR VGND sg13cmos5l_decap_8
XFILLER_712_161 VPWR VGND sg13cmos5l_decap_8
X_3659_ AXI_M_SOC_AWADDR20 Tile_X0Y4_WW4END[4] Tile_X0Y4_WW4END[12] Tile_X0Y4_W6END[4]
+ _4340_/X _2005_/Q _2004_/Q VPWR VGND sg13cmos5l_mux4_1
XFILLER_322_123 VPWR VGND sg13cmos5l_fill_2
XFILLER_592_98 VPWR VGND sg13cmos5l_fill_1
XFILLER_164_49 VPWR VGND sg13cmos5l_decap_8
XFILLER_525_70 VPWR VGND sg13cmos5l_decap_4
XFILLER_322_189 VPWR VGND sg13cmos5l_fill_2
XFILLER_461_14 VPWR VGND sg13cmos5l_decap_8
XANTENNA__3272__X Tile_X0Y0_EE4BEG[8] VPWR VGND sg13cmos5l_antennanp
XFILLER_57_14 VPWR VGND sg13cmos5l_decap_8
XFILLER_244_93 VPWR VGND sg13cmos5l_fill_1
XFILLER_611_28 VPWR VGND sg13cmos5l_decap_8
XFILLER_370_7 VPWR VGND sg13cmos5l_decap_8
XFILLER_640_105 VPWR VGND sg13cmos5l_decap_8
XFILLER_468_7 VPWR VGND sg13cmos5l_decap_8
XFILLER_113_42 VPWR VGND sg13cmos5l_decap_8
XFILLER_228_193 VPWR VGND sg13cmos5l_decap_8
XFILLER_578_212 VPWR VGND sg13cmos5l_fill_1
XFILLER_260_70 VPWR VGND sg13cmos5l_decap_4
XFILLER_73_35 VPWR VGND sg13cmos5l_decap_8
XFILLER_635_7 VPWR VGND sg13cmos5l_decap_8
XFILLER_243_174 VPWR VGND sg13cmos5l_decap_8
XFILLER_189_35 VPWR VGND sg13cmos5l_decap_8
XFILLER_339_49 VPWR VGND sg13cmos5l_decap_8
XFILLER_156_104 VPWR VGND sg13cmos5l_fill_2
XFILLER_345_204 VPWR VGND sg13cmos5l_fill_1
XFILLER_486_77 VPWR VGND sg13cmos5l_decap_8
XFILLER_636_14 VPWR VGND sg13cmos5l_decap_8
XFILLER_561_112 VPWR VGND sg13cmos5l_decap_8
XANTENNA__3447__X Tile_X0Y1_FrameData_O[5] VPWR VGND sg13cmos5l_antennanp
XFILLER_125_0 VPWR VGND sg13cmos5l_decap_8
XFILLER_7_158 VPWR VGND sg13cmos5l_fill_1
XFILLER_98_21 VPWR VGND sg13cmos5l_decap_8
XFILLER_648_216 VPWR VGND sg13cmos5l_fill_1
XFILLER_652_35 VPWR VGND sg13cmos5l_decap_8
XFILLER_435_70 VPWR VGND sg13cmos5l_decap_8
XFILLER_313_167 VPWR VGND sg13cmos5l_decap_8
XFILLER_494_0 VPWR VGND sg13cmos5l_decap_8
XFILLER_371_14 VPWR VGND sg13cmos5l_decap_8
XFILLER_78_121 VPWR VGND sg13cmos5l_fill_1
XANTENNA__3182__X Tile_X0Y0_N4BEG[6] VPWR VGND sg13cmos5l_antennanp
XFILLER_661_0 VPWR VGND sg13cmos5l_decap_8
XFILLER_521_28 VPWR VGND sg13cmos5l_decap_8
XFILLER_415_208 VPWR VGND sg13cmos5l_decap_8
XFILLER_19_210 VPWR VGND sg13cmos5l_fill_2
XFILLER_14_7 VPWR VGND sg13cmos5l_decap_8
XFILLER_304_63 VPWR VGND sg13cmos5l_decap_8
XFILLER_19_221 VPWR VGND sg13cmos5l_fill_1
XFILLER_93_146 VPWR VGND sg13cmos5l_decap_8
XFILLER_631_105 VPWR VGND sg13cmos5l_decap_8
X_1010_ _1010_/Q Tile_X0Y0_FrameData[25] VGND VPWR Tile_X0Y9_FrameStrobe[2] latch
XFILLER_304_96 VPWR VGND sg13cmos5l_decap_8
XFILLER_47_80 VPWR VGND sg13cmos5l_decap_8
XFILLER_631_138 VPWR VGND sg13cmos5l_decap_8
XFILLER_569_212 VPWR VGND sg13cmos5l_fill_1
XFILLER_34_202 VPWR VGND sg13cmos5l_fill_1
XFILLER_170_70 VPWR VGND sg13cmos5l_decap_4
XFILLER_34_224 VPWR VGND sg13cmos5l_decap_4
XFILLER_677_21 VPWR VGND sg13cmos5l_decap_8
X_2961_ Tile_X0Y8_FrameData_O[1] Tile_X0Y8_FrameData[1] VPWR VGND sg13cmos5l_buf_1
X_4700_ _4700_/X Tile_X0Y6_W2MID[7] Tile_X0Y6_W2END[7] Tile_X0Y6_W6END[8] _4553_/X
+ _2651_/Q _2650_/Q VPWR VGND sg13cmos5l_mux4_1
X_1912_ _1912_/Q Tile_X0Y3_FrameData[17] VGND VPWR Tile_X0Y9_FrameStrobe[7] latch
X_2892_ Tile_X0Y6_FrameData_O[13] Tile_X0Y6_FrameData[13] VPWR VGND sg13cmos5l_buf_1
XFILLER_249_49 VPWR VGND sg13cmos5l_decap_8
XFILLER_537_153 VPWR VGND sg13cmos5l_fill_1
XFILLER_396_77 VPWR VGND sg13cmos5l_decap_8
X_4631_ _4631_/X Tile_X0Y7_WW4END[12] AXI_M_SOC_RDATA19 _4696_/X _4674_/X _0297_/Q
+ _0296_/Q VPWR VGND sg13cmos5l_mux4_1
X_1843_ _1843_/Q Tile_X0Y3_FrameData[22] VGND VPWR Tile_X0Y9_FrameStrobe[5] latch
XFILLER_546_14 VPWR VGND sg13cmos5l_decap_8
XFILLER_336_226 VPWR VGND sg13cmos5l_fill_2
XFILLER_8_63 VPWR VGND sg13cmos5l_decap_8
XFILLER_698_105 VPWR VGND sg13cmos5l_decap_8
XFILLER_329_60 VPWR VGND sg13cmos5l_fill_1
XANTENNA__3357__X Tile_X0Y2_FrameData_O[28] VPWR VGND sg13cmos5l_antennanp
XFILLER_693_42 VPWR VGND sg13cmos5l_decap_8
XFILLER_552_134 VPWR VGND sg13cmos5l_fill_1
X_1774_ _1774_/Q Tile_X0Y3_FrameData[27] VGND VPWR Tile_X0Y9_FrameStrobe[3] latch
X_4562_ _4562_/X Tile_X0Y2_W1END[1] Tile_X0Y2_WW4END[13] Tile_X0Y2_W6END[5] _4117_/X
+ _1610_/Q _1609_/Q VPWR VGND sg13cmos5l_mux4_1
XFILLER_552_156 VPWR VGND sg13cmos5l_decap_8
X_0725_ _0725_/Q Tile_X0Y9_FrameData[10] VGND VPWR Tile_X0Y9_FrameStrobe[1] latch
X_3513_ Tile_X0Y1_E2BEG[3] _3935_/X VPWR VGND sg13cmos5l_buf_1
X_4493_ _4493_/X _4547_/X _4546_/X AXI_M_SOC_RDATA26 AXI_M_SOC_RDATA30 _2621_/Q _2620_/Q
+ VPWR VGND sg13cmos5l_mux4_1
XFILLER_626_91 VPWR VGND sg13cmos5l_decap_8
XFILLER_304_145 VPWR VGND sg13cmos5l_fill_1
X_0656_ _0656_/Q Tile_X0Y8_FrameData[15] VGND VPWR Tile_X0Y9_FrameStrobe[7] latch
X_3444_ Tile_X0Y1_FrameData_O[2] Tile_X0Y1_FrameData[2] VPWR VGND sg13cmos5l_buf_1
XFILLER_562_35 VPWR VGND sg13cmos5l_decap_8
XFILLER_40_0 VPWR VGND sg13cmos5l_decap_8
XFILLER_345_70 VPWR VGND sg13cmos5l_decap_8
X_3375_ Tile_X0Y2_EE4BEG[14] _4070_/X VPWR VGND sg13cmos5l_buf_1
XFILLER_281_14 VPWR VGND sg13cmos5l_decap_8
XANTENNA__3092__X Tile_X0Y7_E2BEG[6] VPWR VGND sg13cmos5l_antennanp
X_0587_ _0587_/Q Tile_X0Y8_FrameData[20] VGND VPWR Tile_X0Y9_FrameStrobe[5] latch
XFILLER_69_154 VPWR VGND sg13cmos5l_decap_8
X_2326_ _2326_/Q Tile_X0Y5_FrameData[15] VGND VPWR Tile_X0Y9_FrameStrobe[4] latch
XFILLER_712_49 VPWR VGND sg13cmos5l_decap_8
XFILLER_473_130 VPWR VGND sg13cmos5l_decap_8
XFILLER_431_28 VPWR VGND sg13cmos5l_decap_8
X_2257_ _2257_/Q Tile_X0Y5_FrameData[20] VGND VPWR Tile_X0Y9_FrameStrobe[2] latch
XFILLER_607_168 VPWR VGND sg13cmos5l_decap_8
XFILLER_473_163 VPWR VGND sg13cmos5l_fill_1
XFILLER_214_63 VPWR VGND sg13cmos5l_decap_8
XFILLER_622_105 VPWR VGND sg13cmos5l_fill_2
XFILLER_27_28 VPWR VGND sg13cmos5l_decap_8
XFILLER_361_91 VPWR VGND sg13cmos5l_decap_8
X_1208_ _1208_/Q Tile_X0Y1_FrameData[1] VGND VPWR Tile_X0Y9_FrameStrobe[0] latch
XFILLER_84_179 VPWR VGND sg13cmos5l_decap_4
X_2188_ _2188_/Q Tile_X0Y5_FrameData[25] VGND VPWR Tile_X0Y9_FrameStrobe[0] latch
XFILLER_225_141 VPWR VGND sg13cmos5l_fill_1
X_1139_ _1139_/Q Tile_X0Y0_FrameData[24] VGND VPWR Tile_X0Y9_FrameStrobe[6] latch
XFILLER_587_21 VPWR VGND sg13cmos5l_decap_8
XFILLER_43_49 VPWR VGND sg13cmos5l_decap_8
XFILLER_40_227 VPWR VGND sg13cmos5l_fill_2
XFILLER_587_98 VPWR VGND sg13cmos5l_decap_8
XFILLER_159_49 VPWR VGND sg13cmos5l_decap_8
XFILLER_528_153 VPWR VGND sg13cmos5l_decap_4
XFILLER_138_126 VPWR VGND sg13cmos5l_decap_8
X_4829_ _4829_/X Tile_X0Y9_W2MID[6] Tile_X0Y9_W2END[6] Tile_X0Y9_W6END[9] _4903_/X
+ _0881_/Q _0880_/Q VPWR VGND sg13cmos5l_mux4_1
XFILLER_456_14 VPWR VGND sg13cmos5l_decap_8
XFILLER_394_181 VPWR VGND sg13cmos5l_fill_1
XANTENNA__3267__X Tile_X0Y0_EE4BEG[3] VPWR VGND sg13cmos5l_antennanp
XFILLER_216_7 VPWR VGND sg13cmos5l_decap_8
XFILLER_543_167 VPWR VGND sg13cmos5l_decap_8
XFILLER_606_28 VPWR VGND sg13cmos5l_decap_8
XFILLER_536_91 VPWR VGND sg13cmos5l_decap_8
XFILLER_108_42 VPWR VGND sg13cmos5l_decap_8
XFILLER_472_35 VPWR VGND sg13cmos5l_decap_8
XFILLER_255_70 VPWR VGND sg13cmos5l_decap_4
XFILLER_310_104 VPWR VGND sg13cmos5l_decap_8
XFILLER_68_35 VPWR VGND sg13cmos5l_decap_8
XFILLER_191_14 VPWR VGND sg13cmos5l_decap_8
XFILLER_585_7 VPWR VGND sg13cmos5l_decap_8
XFILLER_456_119 VPWR VGND sg13cmos5l_decap_8
XFILLER_449_171 VPWR VGND sg13cmos5l_decap_4
XFILLER_622_49 VPWR VGND sg13cmos5l_decap_8
XFILLER_464_141 VPWR VGND sg13cmos5l_decap_8
XFILLER_341_28 VPWR VGND sg13cmos5l_decap_8
XFILLER_208_119 VPWR VGND sg13cmos5l_decap_8
XFILLER_613_105 VPWR VGND sg13cmos5l_decap_8
XANTENNA__3730__X AXI_M_SOC_ARADDR2 VPWR VGND sg13cmos5l_antennanp
XFILLER_464_185 VPWR VGND sg13cmos5l_decap_8
XFILLER_271_91 VPWR VGND sg13cmos5l_decap_8
XFILLER_124_96 VPWR VGND sg13cmos5l_decap_8
XFILLER_84_56 VPWR VGND sg13cmos5l_decap_8
XFILLER_90_138 VPWR VGND sg13cmos5l_decap_8
XFILLER_497_21 VPWR VGND sg13cmos5l_decap_8
XFILLER_420_211 VPWR VGND sg13cmos5l_fill_2
XFILLER_140_84 VPWR VGND sg13cmos5l_decap_8
XFILLER_242_0 VPWR VGND sg13cmos5l_decap_8
XFILLER_519_142 VPWR VGND sg13cmos5l_decap_8
XFILLER_497_98 VPWR VGND sg13cmos5l_decap_8
XFILLER_647_35 VPWR VGND sg13cmos5l_decap_8
XFILLER_231_199 VPWR VGND sg13cmos5l_fill_1
XFILLER_129_104 VPWR VGND sg13cmos5l_decap_8
XFILLER_366_14 VPWR VGND sg13cmos5l_decap_8
XANTENNA__3177__X Tile_X0Y0_N4BEG[1] VPWR VGND sg13cmos5l_antennanp
XFILLER_385_192 VPWR VGND sg13cmos5l_decap_4
XFILLER_507_0 VPWR VGND sg13cmos5l_decap_8
XFILLER_534_156 VPWR VGND sg13cmos5l_decap_8
XFILLER_516_28 VPWR VGND sg13cmos5l_decap_8
XFILLER_487_200 VPWR VGND sg13cmos5l_decap_8
XFILLER_663_56 VPWR VGND sg13cmos5l_decap_8
X_0510_ _0510_/Q Tile_X0Y8_FrameData[1] VGND VPWR Tile_X0Y9_FrameStrobe[2] latch
XFILLER_446_91 VPWR VGND sg13cmos5l_decap_8
X_1490_ _1490_/Q Tile_X0Y2_FrameData[31] VGND VPWR Tile_X0Y9_FrameStrobe[2] latch
XFILLER_382_35 VPWR VGND sg13cmos5l_decap_8
XFILLER_165_70 VPWR VGND sg13cmos5l_decap_8
XFILLER_301_104 VPWR VGND sg13cmos5l_fill_2
X_0441_ _0441_/Q Tile_X0Y8_FrameData[6] VGND VPWR Tile_X0Y9_FrameStrobe[0] latch
XFILLER_301_137 VPWR VGND sg13cmos5l_decap_8
X_3160_ Tile_X0Y7_FrameData_O[30] Tile_X0Y7_FrameData[30] VPWR VGND sg13cmos5l_buf_1
X_0372_ _0372_/Q Tile_X0Y7_FrameData[11] VGND VPWR Tile_X0Y9_FrameStrobe[6] latch
XFILLER_532_49 VPWR VGND sg13cmos5l_decap_8
X_2111_ _2111_/Q Tile_X0Y4_FrameData[6] VGND VPWR Tile_X0Y9_FrameStrobe[5] latch
XFILLER_251_28 VPWR VGND sg13cmos5l_decap_8
X_3091_ Tile_X0Y7_E2BEG[5] _4617_/X VPWR VGND sg13cmos5l_buf_1
XFILLER_181_80 VPWR VGND sg13cmos5l_fill_1
XFILLER_66_157 VPWR VGND sg13cmos5l_decap_8
XANTENNA__3640__X AXI_M_SOC_AWADDR1 VPWR VGND sg13cmos5l_antennanp
X_2042_ _2042_/Q Tile_X0Y4_FrameData[11] VGND VPWR Tile_X0Y9_FrameStrobe[3] latch
XFILLER_604_127 VPWR VGND sg13cmos5l_fill_2
XFILLER_470_122 VPWR VGND sg13cmos5l_fill_2
XFILLER_688_42 VPWR VGND sg13cmos5l_decap_8
XFILLER_411_200 VPWR VGND sg13cmos5l_decap_8
XFILLER_612_171 VPWR VGND sg13cmos5l_decap_8
XFILLER_557_204 VPWR VGND sg13cmos5l_decap_8
XFILLER_411_211 VPWR VGND sg13cmos5l_fill_2
XFILLER_207_196 VPWR VGND sg13cmos5l_decap_8
XFILLER_222_133 VPWR VGND sg13cmos5l_decap_4
X_3993_ _3993_/X _3892_/X _4025_/X _4024_/X Tile_X0Y0_S2MID[2] _1197_/Q _1196_/Q VPWR
+ VGND sg13cmos5l_mux4_1
XFILLER_200_21 VPWR VGND sg13cmos5l_decap_8
X_2944_ Tile_X0Y8_EE4BEG[0] _4744_/X VPWR VGND sg13cmos5l_buf_1
XFILLER_222_188 VPWR VGND sg13cmos5l_fill_2
XFILLER_557_35 VPWR VGND sg13cmos5l_decap_8
XFILLER_383_107 VPWR VGND sg13cmos5l_fill_2
XFILLER_88_0 VPWR VGND sg13cmos5l_decap_8
XFILLER_175_221 VPWR VGND sg13cmos5l_decap_8
XFILLER_714_201 VPWR VGND sg13cmos5l_fill_1
XFILLER_276_14 VPWR VGND sg13cmos5l_decap_8
XFILLER_200_98 VPWR VGND sg13cmos5l_decap_8
XANTENNA__3087__X Tile_X0Y7_E2BEG[1] VPWR VGND sg13cmos5l_antennanp
XFILLER_714_212 VPWR VGND sg13cmos5l_fill_2
X_2875_ Tile_X0Y6_EE4BEG[12] _4524_/X VPWR VGND sg13cmos5l_buf_1
X_4614_ _4614_/X Tile_X0Y7_W2MID[5] AXI_M_SOC_RDATA18 _4673_/X _4672_/X _0331_/Q _0330_/Q
+ VPWR VGND sg13cmos5l_mux4_1
XFILLER_391_140 VPWR VGND sg13cmos5l_fill_1
X_1826_ _1826_/Q Tile_X0Y3_FrameData[7] VGND VPWR Tile_X0Y9_FrameStrobe[4] latch
XFILLER_707_49 VPWR VGND sg13cmos5l_decap_8
X_4545_ _4545_/X Tile_X0Y7_W1END[0] Tile_X0Y7_W6END[4] _4696_/X _4656_/X _0415_/Q
+ _0414_/Q VPWR VGND sg13cmos5l_mux4_1
XFILLER_426_28 VPWR VGND sg13cmos5l_decap_8
XFILLER_209_63 VPWR VGND sg13cmos5l_decap_8
X_1757_ _1757_/Q Tile_X0Y3_FrameData[12] VGND VPWR Tile_X0Y9_FrameStrobe[2] latch
XFILLER_686_119 VPWR VGND sg13cmos5l_fill_2
XFILLER_573_56 VPWR VGND sg13cmos5l_decap_8
XFILLER_356_91 VPWR VGND sg13cmos5l_decap_8
XFILLER_143_140 VPWR VGND sg13cmos5l_decap_8
XFILLER_478_222 VPWR VGND sg13cmos5l_decap_8
X_0708_ _0708_/Q Tile_X0Y9_FrameData[27] VGND VPWR Tile_X0Y9_FrameStrobe[1] latch
X_4476_ _4476_/X Tile_X0Y4_W1END[0] Tile_X0Y4_W2MID[3] Tile_X0Y4_W2END[3] _4318_/X
+ _2129_/Q _2128_/Q VPWR VGND sg13cmos5l_mux4_1
XFILLER_292_35 VPWR VGND sg13cmos5l_decap_8
X_1688_ _1688_/Q Tile_X0Y3_FrameData[17] VGND VPWR Tile_X0Y9_FrameStrobe[0] latch
XFILLER_289_166 VPWR VGND sg13cmos5l_decap_8
X_3427_ Tile_X0Y4_FrameData_O[18] Tile_X0Y4_FrameData[18] VPWR VGND sg13cmos5l_buf_1
XFILLER_493_203 VPWR VGND sg13cmos5l_decap_4
X_0639_ _0639_/Q Tile_X0Y8_FrameData[0] VGND VPWR Tile_X0Y9_FrameStrobe[6] latch
X_3358_ Tile_X0Y2_FrameData_O[29] Tile_X0Y2_FrameData[29] VPWR VGND sg13cmos5l_buf_1
XFILLER_442_49 VPWR VGND sg13cmos5l_decap_8
XFILLER_225_84 VPWR VGND sg13cmos5l_decap_8
XFILLER_446_141 VPWR VGND sg13cmos5l_decap_8
XFILLER_38_49 VPWR VGND sg13cmos5l_decap_8
XFILLER_161_28 VPWR VGND sg13cmos5l_decap_8
X_2309_ _2309_/Q Tile_X0Y5_FrameData[0] VGND VPWR Tile_X0Y9_FrameStrobe[3] latch
X_3289_ Tile_X0Y0_E6BEG[9] _3845_/X VPWR VGND sg13cmos5l_buf_1
XFILLER_245_225 VPWR VGND sg13cmos5l_decap_4
XANTENNA__3550__X Tile_X0Y9_E6BEG[8] VPWR VGND sg13cmos5l_antennanp
XFILLER_446_196 VPWR VGND sg13cmos5l_decap_8
XFILLER_598_42 VPWR VGND sg13cmos5l_decap_8
XFILLER_65_190 VPWR VGND sg13cmos5l_decap_8
XFILLER_260_228 VPWR VGND sg13cmos5l_fill_1
XFILLER_166_7 VPWR VGND sg13cmos5l_decap_8
XFILLER_603_171 VPWR VGND sg13cmos5l_fill_1
XFILLER_548_215 VPWR VGND sg13cmos5l_decap_8
XFILLER_213_133 VPWR VGND sg13cmos5l_decap_8
XFILLER_359_126 VPWR VGND sg13cmos5l_fill_2
XFILLER_110_21 VPWR VGND sg13cmos5l_decap_8
XFILLER_333_7 VPWR VGND sg13cmos5l_decap_8
XFILLER_70_14 VPWR VGND sg13cmos5l_decap_8
XFILLER_467_35 VPWR VGND sg13cmos5l_decap_8
XFILLER_367_181 VPWR VGND sg13cmos5l_decap_8
XFILLER_186_14 VPWR VGND sg13cmos5l_decap_8
XFILLER_110_98 VPWR VGND sg13cmos5l_fill_2
XFILLER_500_7 VPWR VGND sg13cmos5l_decap_8
XFILLER_617_49 VPWR VGND sg13cmos5l_decap_8
XANTENNA__0133__Y AXI_M_SOC_AWSIZE2 VPWR VGND sg13cmos5l_antennanp
XFILLER_336_28 VPWR VGND sg13cmos5l_decap_8
XFILLER_119_63 VPWR VGND sg13cmos5l_decap_8
XFILLER_483_56 VPWR VGND sg13cmos5l_decap_8
XFILLER_469_211 VPWR VGND sg13cmos5l_decap_4
XFILLER_469_222 VPWR VGND sg13cmos5l_decap_8
XFILLER_134_140 VPWR VGND sg13cmos5l_decap_8
XFILLER_79_56 VPWR VGND sg13cmos5l_decap_8
XFILLER_134_151 VPWR VGND sg13cmos5l_fill_1
XFILLER_429_119 VPWR VGND sg13cmos5l_decap_8
XFILLER_352_49 VPWR VGND sg13cmos5l_decap_8
XFILLER_713_70 VPWR VGND sg13cmos5l_decap_8
XFILLER_135_84 VPWR VGND sg13cmos5l_decap_8
XFILLER_192_0 VPWR VGND sg13cmos5l_decap_8
XFILLER_236_225 VPWR VGND sg13cmos5l_decap_4
XANTENNA__3460__X Tile_X0Y1_FrameData_O[18] VPWR VGND sg13cmos5l_antennanp
XFILLER_48_168 VPWR VGND sg13cmos5l_decap_8
XFILLER_457_0 VPWR VGND sg13cmos5l_decap_8
XFILLER_151_72 VPWR VGND sg13cmos5l_fill_1
XFILLER_452_177 VPWR VGND sg13cmos5l_decap_4
XFILLER_251_228 VPWR VGND sg13cmos5l_fill_1
XFILLER_301_42 VPWR VGND sg13cmos5l_decap_8
XFILLER_204_133 VPWR VGND sg13cmos5l_decap_8
XFILLER_71_160 VPWR VGND sg13cmos5l_fill_1
XFILLER_624_0 VPWR VGND sg13cmos5l_decap_8
XFILLER_658_56 VPWR VGND sg13cmos5l_decap_8
XFILLER_301_97 VPWR VGND sg13cmos5l_decap_8
XANTENNA__2804__X Tile_X0Y3_E2BEGb[2] VPWR VGND sg13cmos5l_antennanp
X_0990_ _0990_/Q Tile_X0Y0_FrameData[13] VGND VPWR Tile_X0Y9_FrameStrobe[1] latch
XFILLER_554_207 VPWR VGND sg13cmos5l_decap_4
XFILLER_377_35 VPWR VGND sg13cmos5l_decap_8
XFILLER_81_7 VPWR VGND sg13cmos5l_decap_8
XFILLER_507_112 VPWR VGND sg13cmos5l_decap_8
X_2660_ _2660_/Q Tile_X0Y6_FrameData[3] VGND VPWR Tile_X0Y9_FrameStrobe[6] latch
XFILLER_527_49 VPWR VGND sg13cmos5l_decap_8
XFILLER_373_162 VPWR VGND sg13cmos5l_decap_8
XFILLER_373_184 VPWR VGND sg13cmos5l_decap_4
XFILLER_172_224 VPWR VGND sg13cmos5l_decap_4
X_1611_ _1611_/Q Tile_X0Y2_FrameData[6] VGND VPWR Tile_X0Y9_FrameStrobe[5] latch
XFILLER_674_77 VPWR VGND sg13cmos5l_decap_8
XFILLER_60_91 VPWR VGND sg13cmos5l_decap_8
XFILLER_246_28 VPWR VGND sg13cmos5l_decap_8
X_2591_ _2591_/Q Tile_X0Y6_FrameData[8] VGND VPWR Tile_X0Y9_FrameStrobe[4] latch
XFILLER_393_56 VPWR VGND sg13cmos5l_decap_8
XANTENNA__3635__X Tile_X0Y9_S4BEG[13] VPWR VGND sg13cmos5l_antennanp
X_4330_ _4330_/X Tile_X0Y8_W1END[2] Tile_X0Y8_WW4END[2] Tile_X0Y8_W6END[10] _4802_/X
+ _0641_/Q _0640_/Q VPWR VGND sg13cmos5l_mux4_1
X_1542_ _1542_/Q Tile_X0Y2_FrameData[11] VGND VPWR Tile_X0Y9_FrameStrobe[3] latch
XFILLER_5_42 VPWR VGND sg13cmos5l_decap_8
XFILLER_690_21 VPWR VGND sg13cmos5l_decap_8
XFILLER_676_141 VPWR VGND sg13cmos5l_fill_1
X_1473_ _1473_/Q Tile_X0Y2_FrameData[16] VGND VPWR Tile_X0Y9_FrameStrobe[1] latch
X_4261_ _4261_/X Tile_X0Y4_W2MID[2] AXI_M_SOC_BRESP1 _4317_/X _4316_/X _2091_/Q _2090_/Q
+ VPWR VGND sg13cmos5l_mux4_1
X_0424_ _0424_/Q Tile_X0Y8_FrameData[23] VGND VPWR Tile_X0Y9_FrameStrobe[0] latch
X_3212_ Tile_X0Y0_FrameStrobe_O[0] Tile_X0Y9_FrameStrobe[0] VPWR VGND sg13cmos5l_buf_1
XFILLER_690_98 VPWR VGND sg13cmos5l_decap_8
XFILLER_286_158 VPWR VGND sg13cmos5l_decap_8
X_4192_ _4192_/X _4200_/X Tile_X0Y3_W6END[2] _4199_/X _4192_/A3 _1677_/Q _1676_/Q
+ VPWR VGND sg13cmos5l_mux4_1
XFILLER_262_49 VPWR VGND sg13cmos5l_decap_8
XFILLER_623_70 VPWR VGND sg13cmos5l_decap_8
XFILLER_140_187 VPWR VGND sg13cmos5l_decap_8
XFILLER_691_166 VPWR VGND sg13cmos5l_fill_1
X_0355_ _0355_/Q Tile_X0Y7_FrameData[28] VGND VPWR Tile_X0Y9_FrameStrobe[6] latch
X_3143_ Tile_X0Y7_FrameData_O[13] Tile_X0Y7_FrameData[13] VPWR VGND sg13cmos5l_buf_1
XANTENNA__3370__X Tile_X0Y2_EE4BEG[9] VPWR VGND sg13cmos5l_antennanp
XFILLER_490_228 VPWR VGND sg13cmos5l_fill_1
XFILLER_412_19 VPWR VGND sg13cmos5l_decap_8
XFILLER_227_225 VPWR VGND sg13cmos5l_decap_4
XFILLER_428_196 VPWR VGND sg13cmos5l_decap_8
X_3074_ Tile_X0Y4_E2BEGb[0] _4264_/X VPWR VGND sg13cmos5l_buf_1
XFILLER_443_133 VPWR VGND sg13cmos5l_decap_8
X_0286_ _0286_/Q Tile_X0Y7_FrameData[1] VGND VPWR Tile_X0Y9_FrameStrobe[3] latch
XFILLER_54_138 VPWR VGND sg13cmos5l_decap_8
X_2025_ _2025_/Q Tile_X0Y4_FrameData[28] VGND VPWR Tile_X0Y9_FrameStrobe[3] latch
XFILLER_699_96 VPWR VGND sg13cmos5l_decap_8
XFILLER_443_188 VPWR VGND sg13cmos5l_fill_1
XFILLER_211_42 VPWR VGND sg13cmos5l_decap_8
XFILLER_62_182 VPWR VGND sg13cmos5l_decap_8
XFILLER_568_56 VPWR VGND sg13cmos5l_decap_8
X_3976_ _3976_/X _3981_/X Tile_X0Y1_W6END[0] _3980_/X _3976_/A3 _1185_/Q _1184_/Q
+ VPWR VGND sg13cmos5l_mux4_1
XFILLER_287_35 VPWR VGND sg13cmos5l_decap_8
XFILLER_210_147 VPWR VGND sg13cmos5l_decap_8
X_2927_ Tile_X0Y8_E2BEGb[3] _4739_/X VPWR VGND sg13cmos5l_buf_1
XFILLER_349_192 VPWR VGND sg13cmos5l_fill_1
X_2858_ Tile_X0Y6_E6BEG[7] _4535_/X VPWR VGND sg13cmos5l_buf_1
XFILLER_437_49 VPWR VGND sg13cmos5l_decap_8
XFILLER_40_28 VPWR VGND sg13cmos5l_decap_8
XFILLER_584_77 VPWR VGND sg13cmos5l_decap_8
X_1809_ _1809_/Q Tile_X0Y3_FrameData[24] VGND VPWR Tile_X0Y9_FrameStrobe[4] latch
XFILLER_513_126 VPWR VGND sg13cmos5l_decap_8
XFILLER_156_28 VPWR VGND sg13cmos5l_decap_8
X_2789_ Tile_X0Y3_EE4BEG[15] _4179_/X VPWR VGND sg13cmos5l_buf_1
XANTENNA__3545__X Tile_X0Y9_E6BEG[3] VPWR VGND sg13cmos5l_antennanp
XFILLER_513_159 VPWR VGND sg13cmos5l_fill_2
X_4528_ _4528_/X Tile_X0Y9_N4END[12] _0152_/X _4579_/X _4583_/X _2551_/Q _2550_/Q
+ VPWR VGND sg13cmos5l_mux4_1
XFILLER_320_221 VPWR VGND sg13cmos5l_decap_8
X_4459_ _4459_/X _4418_/X _0157_/X _4417_/X _0143_/X _2221_/Q _2220_/Q VPWR VGND sg13cmos5l_mux4_1
XFILLER_466_214 VPWR VGND sg13cmos5l_decap_8
XFILLER_466_225 VPWR VGND sg13cmos5l_decap_4
XFILLER_131_154 VPWR VGND sg13cmos5l_decap_8
XFILLER_49_59 VPWR VGND sg13cmos5l_decap_8
XFILLER_277_147 VPWR VGND sg13cmos5l_decap_8
XFILLER_277_158 VPWR VGND sg13cmos5l_fill_1
XFILLER_131_165 VPWR VGND sg13cmos5l_fill_1
XFILLER_172_49 VPWR VGND sg13cmos5l_decap_8
XFILLER_533_70 VPWR VGND sg13cmos5l_decap_8
XFILLER_105_21 VPWR VGND sg13cmos5l_decap_8
XFILLER_419_152 VPWR VGND sg13cmos5l_fill_2
XFILLER_481_228 VPWR VGND sg13cmos5l_fill_1
XFILLER_283_7 VPWR VGND sg13cmos5l_decap_8
XANTENNA__3280__X Tile_X0Y0_E6BEG[0] VPWR VGND sg13cmos5l_antennanp
XFILLER_65_14 VPWR VGND sg13cmos5l_decap_8
XFILLER_623_222 VPWR VGND sg13cmos5l_decap_8
XFILLER_434_133 VPWR VGND sg13cmos5l_decap_8
XFILLER_105_98 VPWR VGND sg13cmos5l_decap_4
XFILLER_450_7 VPWR VGND sg13cmos5l_decap_8
XFILLER_402_63 VPWR VGND sg13cmos5l_decap_8
XFILLER_233_228 VPWR VGND sg13cmos5l_fill_1
XFILLER_548_7 VPWR VGND sg13cmos5l_decap_8
XFILLER_121_42 VPWR VGND sg13cmos5l_decap_8
XFILLER_60_119 VPWR VGND sg13cmos5l_fill_2
XFILLER_387_210 VPWR VGND sg13cmos5l_decap_8
XFILLER_588_181 VPWR VGND sg13cmos5l_fill_2
XFILLER_81_35 VPWR VGND sg13cmos5l_decap_8
XFILLER_478_56 VPWR VGND sg13cmos5l_decap_8
XFILLER_715_7 VPWR VGND sg13cmos5l_decap_8
XFILLER_197_35 VPWR VGND sg13cmos5l_decap_8
XFILLER_628_26 VPWR VGND sg13cmos5l_decap_8
XFILLER_14_84 VPWR VGND sg13cmos5l_decap_8
XFILLER_355_140 VPWR VGND sg13cmos5l_decap_8
XFILLER_14_95 VPWR VGND sg13cmos5l_fill_2
XFILLER_347_49 VPWR VGND sg13cmos5l_decap_8
XFILLER_708_70 VPWR VGND sg13cmos5l_decap_8
XFILLER_494_77 VPWR VGND sg13cmos5l_decap_8
XFILLER_644_14 VPWR VGND sg13cmos5l_decap_8
XFILLER_504_126 VPWR VGND sg13cmos5l_decap_8
XANTENNA__3455__X Tile_X0Y1_FrameData_O[13] VPWR VGND sg13cmos5l_antennanp
XFILLER_205_0 VPWR VGND sg13cmos5l_decap_8
XFILLER_504_159 VPWR VGND sg13cmos5l_decap_8
XFILLER_370_154 VPWR VGND sg13cmos5l_decap_8
XFILLER_512_192 VPWR VGND sg13cmos5l_decap_8
XFILLER_660_35 VPWR VGND sg13cmos5l_decap_8
XFILLER_443_70 VPWR VGND sg13cmos5l_decap_8
XFILLER_574_0 VPWR VGND sg13cmos5l_decap_8
XFILLER_472_228 VPWR VGND sg13cmos5l_fill_1
XANTENNA__3190__X Tile_X0Y0_N4BEG[14] VPWR VGND sg13cmos5l_antennanp
XFILLER_209_225 VPWR VGND sg13cmos5l_decap_4
XFILLER_673_199 VPWR VGND sg13cmos5l_decap_4
X_0140_ _0140_/X _4443_/X _4444_/X _1357_/Q VPWR VGND sg13cmos5l_mux2_1
XFILLER_425_133 VPWR VGND sg13cmos5l_decap_8
XFILLER_224_206 VPWR VGND sg13cmos5l_decap_4
XFILLER_291_172 VPWR VGND sg13cmos5l_decap_8
X_0071_ AXI_M_SOC_WSTRB0 _0935_/Q _3722_/X VPWR VGND sg13cmos5l_or2_1
XFILLER_312_63 VPWR VGND sg13cmos5l_decap_8
XFILLER_224_228 VPWR VGND sg13cmos5l_fill_1
XFILLER_425_199 VPWR VGND sg13cmos5l_decap_4
XFILLER_669_77 VPWR VGND sg13cmos5l_decap_8
XFILLER_378_221 VPWR VGND sg13cmos5l_fill_1
XFILLER_189_121 VPWR VGND sg13cmos5l_decap_4
XFILLER_189_132 VPWR VGND sg13cmos5l_decap_4
XFILLER_388_56 VPWR VGND sg13cmos5l_decap_8
X_3830_ _3830_/X Tile_X0Y0_WW4END[5] Tile_X0Y0_WW4END[10] _3886_/X _3856_/X _1045_/Q
+ _1044_/Q VPWR VGND sg13cmos5l_mux4_1
XFILLER_388_67 VPWR VGND sg13cmos5l_fill_2
XFILLER_594_151 VPWR VGND sg13cmos5l_decap_8
XFILLER_338_107 VPWR VGND sg13cmos5l_decap_8
XFILLER_685_21 VPWR VGND sg13cmos5l_decap_8
X_3761_ _3761_/X Tile_X0Y1_WW4END[2] Tile_X0Y1_WW4END[10] Tile_X0Y1_W6END[2] _4010_/X
+ _1253_/Q _1252_/Q VPWR VGND sg13cmos5l_mux4_1
X_0973_ _0973_/Q Tile_X0Y0_FrameData[30] VGND VPWR Tile_X0Y9_FrameStrobe[1] latch
XFILLER_346_140 VPWR VGND sg13cmos5l_decap_8
X_2712_ _4425_/A3 VPWR VGND sg13cmos5l_tielo
XFILLER_685_98 VPWR VGND sg13cmos5l_decap_8
X_3692_ AXI_M_SOC_WDATA2 Tile_X0Y7_WW4END[2] Tile_X0Y7_WW4END[10] Tile_X0Y7_W6END[2]
+ _4686_/X _0243_/Q _0242_/Q VPWR VGND sg13cmos5l_mux4_1
XFILLER_257_49 VPWR VGND sg13cmos5l_decap_8
XFILLER_618_70 VPWR VGND sg13cmos5l_decap_8
XFILLER_187_90 VPWR VGND sg13cmos5l_decap_8
XFILLER_346_184 VPWR VGND sg13cmos5l_decap_8
X_2643_ _2643_/Q Tile_X0Y6_FrameData[20] VGND VPWR Tile_X0Y9_FrameStrobe[6] latch
XFILLER_554_14 VPWR VGND sg13cmos5l_decap_8
XFILLER_346_195 VPWR VGND sg13cmos5l_decap_4
XANTENNA__3365__X Tile_X0Y2_EE4BEG[4] VPWR VGND sg13cmos5l_antennanp
X_2574_ _2574_/Q Tile_X0Y6_FrameData[25] VGND VPWR Tile_X0Y9_FrameStrobe[4] latch
XFILLER_361_198 VPWR VGND sg13cmos5l_decap_8
X_4313_ _4313_/X _4237_/X _4353_/X _4352_/X _4236_/X _1949_/Q _1948_/Q VPWR VGND sg13cmos5l_mux4_1
XFILLER_113_121 VPWR VGND sg13cmos5l_decap_8
XFILLER_704_28 VPWR VGND sg13cmos5l_decap_8
X_1525_ _1525_/Q Tile_X0Y2_FrameData[28] VGND VPWR Tile_X0Y9_FrameStrobe[3] latch
XFILLER_649_163 VPWR VGND sg13cmos5l_decap_8
XFILLER_113_132 VPWR VGND sg13cmos5l_fill_1
XFILLER_634_91 VPWR VGND sg13cmos5l_decap_8
XFILLER_206_42 VPWR VGND sg13cmos5l_decap_8
X_4244_ _4244_/X Tile_X0Y2_W1END[0] Tile_X0Y2_W2MID[3] Tile_X0Y2_W2END[3] _4102_/X
+ _1621_/Q _1620_/Q VPWR VGND sg13cmos5l_mux4_1
X_1456_ _1456_/Q Tile_X0Y2_FrameData[1] VGND VPWR Tile_X0Y9_FrameStrobe[0] latch
XFILLER_570_35 VPWR VGND sg13cmos5l_decap_8
XFILLER_353_70 VPWR VGND sg13cmos5l_decap_8
X_0407_ _0407_/Q Tile_X0Y7_FrameData[8] VGND VPWR Tile_X0Y9_FrameStrobe[7] latch
X_1387_ _1387_/Q Tile_X0Y1_FrameData[14] VGND VPWR Tile_X0Y9_FrameStrobe[6] latch
X_4175_ _4175_/X Tile_X0Y3_WW4END[4] AXI_M_SOC_WREADY _4226_/X _4210_/X _1791_/Q _1790_/Q
+ VPWR VGND sg13cmos5l_mux4_1
XFILLER_605_200 VPWR VGND sg13cmos5l_fill_1
XFILLER_605_222 VPWR VGND sg13cmos5l_decap_8
X_3126_ Tile_X0Y7_EE4BEG[12] _4640_/X VPWR VGND sg13cmos5l_buf_1
X_0338_ _0338_/Q Tile_X0Y7_FrameData[13] VGND VPWR Tile_X0Y9_FrameStrobe[5] latch
XFILLER_503_84 VPWR VGND sg13cmos5l_decap_8
XFILLER_282_161 VPWR VGND sg13cmos5l_decap_8
XFILLER_27_138 VPWR VGND sg13cmos5l_decap_8
XFILLER_222_63 VPWR VGND sg13cmos5l_decap_8
X_0269_ _0269_/Q Tile_X0Y7_FrameData[18] VGND VPWR Tile_X0Y9_FrameStrobe[3] latch
X_3057_ Tile_X0Y5_FrameData_O[16] Tile_X0Y5_FrameData[16] VPWR VGND sg13cmos5l_buf_1
XFILLER_35_28 VPWR VGND sg13cmos5l_decap_8
X_2008_ _2008_/Q Tile_X0Y4_FrameData[13] VGND VPWR Tile_X0Y9_FrameStrobe[2] latch
XFILLER_579_77 VPWR VGND sg13cmos5l_decap_8
XFILLER_431_147 VPWR VGND sg13cmos5l_decap_8
XFILLER_298_56 VPWR VGND sg13cmos5l_decap_8
XFILLER_518_207 VPWR VGND sg13cmos5l_decap_4
XFILLER_595_21 VPWR VGND sg13cmos5l_decap_8
XFILLER_384_224 VPWR VGND sg13cmos5l_decap_4
XFILLER_195_135 VPWR VGND sg13cmos5l_decap_8
XFILLER_51_27 VPWR VGND sg13cmos5l_decap_8
X_3959_ _3959_/X Tile_X0Y1_WW4END[4] AXI_M_SOC_ARREADY _4012_/X _3994_/X _1291_/Q
+ _1290_/Q VPWR VGND sg13cmos5l_mux4_1
XFILLER_167_49 VPWR VGND sg13cmos5l_decap_8
XFILLER_129_7 VPWR VGND sg13cmos5l_decap_8
XFILLER_528_70 VPWR VGND sg13cmos5l_decap_8
XFILLER_541_210 VPWR VGND sg13cmos5l_decap_8
XFILLER_464_14 VPWR VGND sg13cmos5l_decap_8
XANTENNA__3275__X Tile_X0Y0_EE4BEG[11] VPWR VGND sg13cmos5l_antennanp
XFILLER_498_147 VPWR VGND sg13cmos5l_decap_8
XFILLER_352_154 VPWR VGND sg13cmos5l_decap_8
XFILLER_151_227 VPWR VGND sg13cmos5l_fill_2
XFILLER_614_28 VPWR VGND sg13cmos5l_decap_8
XFILLER_498_7 VPWR VGND sg13cmos5l_decap_8
XFILLER_104_154 VPWR VGND sg13cmos5l_decap_8
XFILLER_116_42 VPWR VGND sg13cmos5l_decap_8
XFILLER_655_133 VPWR VGND sg13cmos5l_decap_8
XFILLER_480_35 VPWR VGND sg13cmos5l_decap_8
XFILLER_263_70 VPWR VGND sg13cmos5l_decap_4
XFILLER_76_35 VPWR VGND sg13cmos5l_decap_8
XFILLER_265_128 VPWR VGND sg13cmos5l_decap_8
XFILLER_665_7 VPWR VGND sg13cmos5l_decap_8
XFILLER_670_125 VPWR VGND sg13cmos5l_decap_8
XFILLER_407_111 VPWR VGND sg13cmos5l_fill_1
XFILLER_630_49 VPWR VGND sg13cmos5l_decap_8
XFILLER_413_84 VPWR VGND sg13cmos5l_decap_8
XFILLER_407_177 VPWR VGND sg13cmos5l_fill_2
XFILLER_132_63 VPWR VGND sg13cmos5l_decap_8
XFILLER_92_56 VPWR VGND sg13cmos5l_decap_8
XFILLER_422_147 VPWR VGND sg13cmos5l_decap_8
XFILLER_489_77 VPWR VGND sg13cmos5l_decap_8
XFILLER_92_67 VPWR VGND sg13cmos5l_fill_1
XFILLER_639_14 VPWR VGND sg13cmos5l_decap_8
XFILLER_92_89 VPWR VGND sg13cmos5l_fill_2
XFILLER_155_0 VPWR VGND sg13cmos5l_decap_8
XFILLER_576_140 VPWR VGND sg13cmos5l_fill_2
XFILLER_41_163 VPWR VGND sg13cmos5l_fill_1
XFILLER_322_0 VPWR VGND sg13cmos5l_decap_8
XFILLER_655_35 VPWR VGND sg13cmos5l_decap_8
XFILLER_438_70 VPWR VGND sg13cmos5l_decap_8
XFILLER_374_14 VPWR VGND sg13cmos5l_decap_8
XANTENNA__3185__X Tile_X0Y0_N4BEG[9] VPWR VGND sg13cmos5l_antennanp
XFILLER_678_214 VPWR VGND sg13cmos5l_decap_8
XFILLER_343_154 VPWR VGND sg13cmos5l_decap_8
XFILLER_489_147 VPWR VGND sg13cmos5l_decap_8
XFILLER_343_176 VPWR VGND sg13cmos5l_decap_8
XFILLER_691_0 VPWR VGND sg13cmos5l_decap_8
XFILLER_524_28 VPWR VGND sg13cmos5l_decap_8
XFILLER_307_63 VPWR VGND sg13cmos5l_decap_8
XFILLER_671_56 VPWR VGND sg13cmos5l_decap_8
X_1310_ _1310_/Q Tile_X0Y1_FrameData[27] VGND VPWR Tile_X0Y9_FrameStrobe[4] latch
XFILLER_500_140 VPWR VGND sg13cmos5l_decap_8
X_2290_ _2290_/Q Tile_X0Y5_FrameData[19] VGND VPWR Tile_X0Y9_FrameStrobe[3] latch
XFILLER_646_133 VPWR VGND sg13cmos5l_decap_8
XFILLER_390_35 VPWR VGND sg13cmos5l_decap_8
XFILLER_173_70 VPWR VGND sg13cmos5l_decap_8
XFILLER_2_21 VPWR VGND sg13cmos5l_decap_8
X_1241_ _1241_/Q Tile_X0Y1_FrameData[0] VGND VPWR Tile_X0Y9_FrameStrobe[1] latch
XFILLER_110_135 VPWR VGND sg13cmos5l_decap_8
X_1172_ _1172_/Q Tile_X0Y0_FrameData[23] VGND VPWR Tile_X0Y9_FrameStrobe[7] latch
XFILLER_540_49 VPWR VGND sg13cmos5l_decap_8
XFILLER_2_98 VPWR VGND sg13cmos5l_decap_8
X_0123_ AXI_M_SOC_ARSIZE2 _0932_/Q _3770_/X VPWR VGND sg13cmos5l_nor2b_1
XANTENNA__0049__X AXI_M_SOC_AWCACHE0 VPWR VGND sg13cmos5l_antennanp
X_0054_ _0054_/X _4680_/X _4681_/X _1857_/Q VPWR VGND sg13cmos5l_mux2_1
X_4931_ _4931_/X Tile_X0Y9_N1END[3] Tile_X0Y9_N4END[3] _4899_/X _0080_/X _0697_/Q
+ _0696_/Q VPWR VGND sg13cmos5l_mux4_1
XFILLER_399_77 VPWR VGND sg13cmos5l_decap_8
XFILLER_549_14 VPWR VGND sg13cmos5l_decap_8
XFILLER_413_158 VPWR VGND sg13cmos5l_decap_8
XFILLER_696_42 VPWR VGND sg13cmos5l_decap_8
XFILLER_17_193 VPWR VGND sg13cmos5l_fill_1
XFILLER_567_140 VPWR VGND sg13cmos5l_decap_8
X_4862_ _4862_/X Tile_X0Y9_W2END[1] AXI_M_SOC_RDATA1 _4903_/X _4902_/X _0819_/Q _0818_/Q
+ VPWR VGND sg13cmos5l_mux4_1
XFILLER_220_220 VPWR VGND sg13cmos5l_fill_2
XFILLER_177_113 VPWR VGND sg13cmos5l_decap_8
XFILLER_366_213 VPWR VGND sg13cmos5l_decap_4
XFILLER_268_26 VPWR VGND sg13cmos5l_decap_8
X_3813_ _3813_/X Tile_X0Y0_W2MID[4] Tile_X0Y0_W2END[6] _3855_/X _3854_/X _1079_/Q
+ _1078_/Q VPWR VGND sg13cmos5l_mux4_1
XANTENNA_15 Tile_X0Y0_S2MID[7] VPWR VGND sg13cmos5l_antennanp
XANTENNA_26 _4816_/X VPWR VGND sg13cmos5l_antennanp
X_4793_ _4793_/X _4340_/X _4344_/X _4348_/X _4318_/X _2121_/Q _2120_/Q VPWR VGND sg13cmos5l_mux4_1
XFILLER_32_196 VPWR VGND sg13cmos5l_decap_4
XANTENNA_37 Tile_X0Y9_FrameStrobe[18] VPWR VGND sg13cmos5l_antennanp
XFILLER_582_143 VPWR VGND sg13cmos5l_fill_2
XANTENNA_48 Tile_X0Y9_N2MID[2] VPWR VGND sg13cmos5l_antennanp
XFILLER_629_91 VPWR VGND sg13cmos5l_decap_8
X_3744_ AXI_M_SOC_ARADDR16 Tile_X0Y8_WW4END[0] Tile_X0Y8_WW4END[8] Tile_X0Y8_W6END[0]
+ _4800_/X _0503_/Q _0502_/Q VPWR VGND sg13cmos5l_mux4_1
XFILLER_118_202 VPWR VGND sg13cmos5l_decap_8
XFILLER_70_0 VPWR VGND sg13cmos5l_decap_8
X_0956_ _0956_/Q Tile_X0Y0_FrameData[15] VGND VPWR Tile_X0Y9_FrameStrobe[0] latch
XFILLER_565_35 VPWR VGND sg13cmos5l_decap_8
XFILLER_348_70 VPWR VGND sg13cmos5l_decap_8
XFILLER_284_14 VPWR VGND sg13cmos5l_decap_8
X_3675_ _3675_/X Tile_X0Y2_WW4END[5] Tile_X0Y2_WW4END[13] Tile_X0Y2_W6END[5] _4121_/X
+ _1495_/Q _1494_/Q VPWR VGND sg13cmos5l_mux4_1
XANTENNA__3095__X Tile_X0Y7_E2BEGb[1] VPWR VGND sg13cmos5l_antennanp
X_0887_ _0887_/Q Tile_X0Y9_FrameData[8] VGND VPWR Tile_X0Y9_FrameStrobe[6] latch
X_2626_ _2626_/Q Tile_X0Y6_FrameData[5] VGND VPWR Tile_X0Y9_FrameStrobe[5] latch
XFILLER_715_49 VPWR VGND sg13cmos5l_decap_8
XFILLER_279_209 VPWR VGND sg13cmos5l_fill_2
XFILLER_434_28 VPWR VGND sg13cmos5l_decap_8
XFILLER_217_63 VPWR VGND sg13cmos5l_decap_8
X_2557_ _2557_/Q Tile_X0Y6_FrameData[10] VGND VPWR Tile_X0Y9_FrameStrobe[3] latch
XFILLER_684_228 VPWR VGND sg13cmos5l_fill_1
XFILLER_287_220 VPWR VGND sg13cmos5l_fill_2
XFILLER_581_56 VPWR VGND sg13cmos5l_decap_8
XFILLER_364_91 VPWR VGND sg13cmos5l_decap_8
X_1508_ _1508_/Q Tile_X0Y2_FrameData[13] VGND VPWR Tile_X0Y9_FrameStrobe[2] latch
XFILLER_637_133 VPWR VGND sg13cmos5l_decap_8
X_2488_ _2488_/Q Tile_X0Y6_FrameData[15] VGND VPWR Tile_X0Y9_FrameStrobe[1] latch
XFILLER_637_166 VPWR VGND sg13cmos5l_fill_2
X_4227_ _4227_/X _4197_/X _0088_/X _4196_/X Tile_X0Y0_S4END[13] _1719_/Q _1718_/Q
+ VPWR VGND sg13cmos5l_mux4_1
XFILLER_436_228 VPWR VGND sg13cmos5l_fill_1
XFILLER_247_128 VPWR VGND sg13cmos5l_fill_1
XFILLER_101_146 VPWR VGND sg13cmos5l_decap_8
X_1439_ _1439_/Q Tile_X0Y2_FrameData[18] VGND VPWR Tile_X0Y9_FrameStrobe[0] latch
XFILLER_652_147 VPWR VGND sg13cmos5l_decap_8
X_4158_ _4158_/X Tile_X0Y3_W2END[5] AXI_M_SOC_BVALID _4209_/X _4208_/X _1825_/Q _1824_/Q
+ VPWR VGND sg13cmos5l_mux4_1
XFILLER_46_27 VPWR VGND sg13cmos5l_decap_8
XFILLER_450_49 VPWR VGND sg13cmos5l_decap_8
XFILLER_262_109 VPWR VGND sg13cmos5l_decap_8
XFILLER_233_84 VPWR VGND sg13cmos5l_decap_8
X_3109_ Tile_X0Y7_E6BEG[7] _4651_/X VPWR VGND sg13cmos5l_buf_1
X_4089_ _4089_/X Tile_X0Y3_W1END[0] Tile_X0Y3_W6END[4] _4234_/X _4198_/X _1925_/Q
+ _1924_/Q VPWR VGND sg13cmos5l_mux4_1
XFILLER_660_180 VPWR VGND sg13cmos5l_decap_8
XFILLER_70_203 VPWR VGND sg13cmos5l_decap_8
XFILLER_660_191 VPWR VGND sg13cmos5l_fill_1
XFILLER_404_147 VPWR VGND sg13cmos5l_decap_8
XFILLER_459_14 VPWR VGND sg13cmos5l_decap_8
XFILLER_270_186 VPWR VGND sg13cmos5l_fill_1
XFILLER_102_77 VPWR VGND sg13cmos5l_decap_8
XFILLER_62_37 VPWR VGND sg13cmos5l_decap_8
XFILLER_246_7 VPWR VGND sg13cmos5l_decap_8
XFILLER_211_220 VPWR VGND sg13cmos5l_fill_2
XFILLER_357_224 VPWR VGND sg13cmos5l_decap_4
XFILLER_23_174 VPWR VGND sg13cmos5l_decap_4
XFILLER_707_126 VPWR VGND sg13cmos5l_decap_8
XFILLER_609_28 VPWR VGND sg13cmos5l_decap_8
XFILLER_168_157 VPWR VGND sg13cmos5l_decap_8
XFILLER_573_154 VPWR VGND sg13cmos5l_decap_8
XANTENNA__2902__X Tile_X0Y6_FrameData_O[23] VPWR VGND sg13cmos5l_antennanp
XFILLER_413_7 VPWR VGND sg13cmos5l_decap_8
XFILLER_372_216 VPWR VGND sg13cmos5l_fill_2
XFILLER_475_35 VPWR VGND sg13cmos5l_decap_8
XFILLER_258_70 VPWR VGND sg13cmos5l_decap_8
XFILLER_183_149 VPWR VGND sg13cmos5l_decap_4
XFILLER_194_14 VPWR VGND sg13cmos5l_decap_8
XFILLER_715_181 VPWR VGND sg13cmos5l_decap_8
XFILLER_625_49 VPWR VGND sg13cmos5l_decap_8
XFILLER_408_84 VPWR VGND sg13cmos5l_decap_8
XFILLER_11_63 VPWR VGND sg13cmos5l_decap_8
XANTENNA__0141__Y AXI_M_SOC_ARLEN1 VPWR VGND sg13cmos5l_antennanp
XFILLER_344_28 VPWR VGND sg13cmos5l_decap_8
XFILLER_675_228 VPWR VGND sg13cmos5l_fill_1
XFILLER_486_128 VPWR VGND sg13cmos5l_fill_1
XFILLER_127_63 VPWR VGND sg13cmos5l_decap_8
XFILLER_491_56 VPWR VGND sg13cmos5l_decap_8
XFILLER_274_91 VPWR VGND sg13cmos5l_decap_8
XANTENNA__3733__X AXI_M_SOC_ARADDR5 VPWR VGND sg13cmos5l_antennanp
XFILLER_479_191 VPWR VGND sg13cmos5l_decap_8
XFILLER_87_56 VPWR VGND sg13cmos5l_decap_8
XFILLER_238_106 VPWR VGND sg13cmos5l_fill_1
XFILLER_628_166 VPWR VGND sg13cmos5l_decap_4
XFILLER_494_161 VPWR VGND sg13cmos5l_decap_8
XFILLER_427_228 VPWR VGND sg13cmos5l_fill_1
XFILLER_643_147 VPWR VGND sg13cmos5l_decap_8
XFILLER_360_49 VPWR VGND sg13cmos5l_decap_8
XFILLER_143_84 VPWR VGND sg13cmos5l_decap_8
XFILLER_272_0 VPWR VGND sg13cmos5l_decap_8
XFILLER_246_161 VPWR VGND sg13cmos5l_decap_8
XFILLER_369_14 VPWR VGND sg13cmos5l_decap_8
XFILLER_261_175 VPWR VGND sg13cmos5l_decap_8
XFILLER_537_0 VPWR VGND sg13cmos5l_decap_8
XFILLER_261_186 VPWR VGND sg13cmos5l_fill_1
XFILLER_14_152 VPWR VGND sg13cmos5l_fill_1
XFILLER_519_28 VPWR VGND sg13cmos5l_decap_8
XFILLER_704_0 VPWR VGND sg13cmos5l_decap_8
XFILLER_666_56 VPWR VGND sg13cmos5l_decap_8
XANTENNA__2812__X Tile_X0Y3_E2BEG[2] VPWR VGND sg13cmos5l_antennanp
X_0810_ _0810_/Q Tile_X0Y9_FrameData[21] VGND VPWR Tile_X0Y9_FrameStrobe[4] latch
X_1790_ _1790_/Q Tile_X0Y3_FrameData[11] VGND VPWR Tile_X0Y9_FrameStrobe[3] latch
XFILLER_564_176 VPWR VGND sg13cmos5l_fill_1
XFILLER_385_35 VPWR VGND sg13cmos5l_decap_8
XFILLER_363_227 VPWR VGND sg13cmos5l_fill_2
XFILLER_505_210 VPWR VGND sg13cmos5l_decap_4
XFILLER_167_190 VPWR VGND sg13cmos5l_decap_8
X_0741_ _0741_/Q Tile_X0Y9_FrameData[26] VGND VPWR Tile_X0Y9_FrameStrobe[2] latch
XFILLER_316_165 VPWR VGND sg13cmos5l_decap_8
X_3460_ Tile_X0Y1_FrameData_O[18] Tile_X0Y1_FrameData[18] VPWR VGND sg13cmos5l_buf_1
X_0672_ _0672_/Q Tile_X0Y8_FrameData[31] VGND VPWR Tile_X0Y9_FrameStrobe[0] latch
XFILLER_535_49 VPWR VGND sg13cmos5l_decap_8
XFILLER_666_206 VPWR VGND sg13cmos5l_fill_1
XFILLER_182_193 VPWR VGND sg13cmos5l_decap_4
XANTENNA__0051__Y AXI_M_SOC_AWBURST1 VPWR VGND sg13cmos5l_antennanp
X_2411_ _2411_/Q Tile_X0Y5_FrameData[26] VGND VPWR Tile_X0Y9_FrameStrobe[7] latch
XFILLER_682_77 VPWR VGND sg13cmos5l_decap_8
XFILLER_331_135 VPWR VGND sg13cmos5l_decap_8
XFILLER_254_28 VPWR VGND sg13cmos5l_decap_8
X_3391_ Tile_X0Y2_E2BEGb[2] _4050_/X VPWR VGND sg13cmos5l_buf_1
XANTENNA__3643__X AXI_M_SOC_AWADDR4 VPWR VGND sg13cmos5l_antennanp
X_2342_ _2342_/Q Tile_X0Y5_FrameData[31] VGND VPWR Tile_X0Y9_FrameStrobe[5] latch
XFILLER_418_228 VPWR VGND sg13cmos5l_fill_1
XFILLER_96_155 VPWR VGND sg13cmos5l_fill_2
X_2273_ _2273_/Q Tile_X0Y5_FrameData[4] VGND VPWR Tile_X0Y9_FrameStrobe[2] latch
X_4012_ _4012_/X _3981_/X _0073_/X _3980_/X Tile_X0Y0_S4END[4] _1225_/Q _1224_/Q VPWR
+ VGND sg13cmos5l_mux4_1
XFILLER_96_199 VPWR VGND sg13cmos5l_fill_1
X_1224_ _1224_/Q Tile_X0Y1_FrameData[17] VGND VPWR Tile_X0Y9_FrameStrobe[1] latch
XFILLER_270_49 VPWR VGND sg13cmos5l_decap_8
XFILLER_631_70 VPWR VGND sg13cmos5l_decap_8
XFILLER_203_21 VPWR VGND sg13cmos5l_decap_8
X_1155_ _1155_/Q Tile_X0Y0_FrameData[8] VGND VPWR Tile_X0Y9_FrameStrobe[6] latch
X_0106_ AXI_M_SOC_ARLEN3 _0933_/Q _3763_/X VPWR VGND sg13cmos5l_nor2b_1
X_1086_ _1086_/Q Tile_X0Y0_FrameData[13] VGND VPWR Tile_X0Y9_FrameStrobe[4] latch
XFILLER_52_225 VPWR VGND sg13cmos5l_decap_4
XFILLER_279_14 VPWR VGND sg13cmos5l_decap_8
XFILLER_203_98 VPWR VGND sg13cmos5l_decap_8
X_4914_ _4914_/X Tile_X0Y5_W1END[3] Tile_X0Y5_WW4END[15] Tile_X0Y5_W6END[7] _4454_/X
+ _2370_/Q _2369_/Q VPWR VGND sg13cmos5l_mux4_1
XFILLER_500_63 VPWR VGND sg13cmos5l_decap_8
X_4845_ _4845_/X Tile_X0Y9_N1END[1] _4897_/X AXI_M_SOC_RDATA2 AXI_M_SOC_RDATA6 _0853_/Q
+ _0852_/Q VPWR VGND sg13cmos5l_mux4_1
XFILLER_429_28 VPWR VGND sg13cmos5l_decap_8
XFILLER_576_56 VPWR VGND sg13cmos5l_decap_8
XFILLER_359_91 VPWR VGND sg13cmos5l_decap_8
XFILLER_354_205 VPWR VGND sg13cmos5l_fill_2
X_4776_ _4776_/X Tile_X0Y7_W1END[0] Tile_X0Y7_W6END[8] _4696_/X _4656_/X _0379_/Q
+ _0378_/Q VPWR VGND sg13cmos5l_mux4_1
XFILLER_295_35 VPWR VGND sg13cmos5l_decap_8
X_1988_ _1988_/Q Tile_X0Y4_FrameData[1] VGND VPWR Tile_X0Y9_FrameStrobe[1] latch
X_3727_ AXI_M_SOC_BREADY Tile_X0Y3_W1END[1] Tile_X0Y3_WW4END[5] Tile_X0Y3_WW4END[13]
+ _4235_/X _1731_/Q _1730_/Q VPWR VGND sg13cmos5l_mux4_1
X_0939_ _0939_/Q Tile_X0Y9_FrameData[30] VGND VPWR Tile_X0Y9_FrameStrobe[8] latch
XFILLER_570_168 VPWR VGND sg13cmos5l_decap_8
XFILLER_712_140 VPWR VGND sg13cmos5l_decap_8
X_3658_ AXI_M_SOC_AWADDR19 Tile_X0Y4_WW4END[3] Tile_X0Y4_WW4END[11] Tile_X0Y4_W6END[3]
+ _4339_/X _2007_/Q _2006_/Q VPWR VGND sg13cmos5l_mux4_1
XFILLER_445_49 VPWR VGND sg13cmos5l_decap_8
XFILLER_228_84 VPWR VGND sg13cmos5l_fill_2
XFILLER_468_106 VPWR VGND sg13cmos5l_decap_4
XFILLER_592_77 VPWR VGND sg13cmos5l_decap_8
X_2609_ _2609_/Q Tile_X0Y6_FrameData[22] VGND VPWR Tile_X0Y9_FrameStrobe[5] latch
XFILLER_164_28 VPWR VGND sg13cmos5l_decap_8
X_3589_ Tile_X0Y9_FrameData_O[19] Tile_X0Y9_FrameData[19] VPWR VGND sg13cmos5l_buf_1
XANTENNA__3553__X Tile_X0Y9_E6BEG[11] VPWR VGND sg13cmos5l_antennanp
XFILLER_322_168 VPWR VGND sg13cmos5l_decap_8
XFILLER_409_228 VPWR VGND sg13cmos5l_fill_1
XFILLER_87_155 VPWR VGND sg13cmos5l_decap_4
XFILLER_196_7 VPWR VGND sg13cmos5l_fill_2
XFILLER_235_109 VPWR VGND sg13cmos5l_decap_8
XFILLER_180_49 VPWR VGND sg13cmos5l_decap_8
XFILLER_541_70 VPWR VGND sg13cmos5l_decap_8
XFILLER_113_21 VPWR VGND sg13cmos5l_decap_8
XFILLER_363_7 VPWR VGND sg13cmos5l_decap_8
XFILLER_73_14 VPWR VGND sg13cmos5l_decap_8
XFILLER_243_153 VPWR VGND sg13cmos5l_decap_8
XFILLER_189_14 VPWR VGND sg13cmos5l_decap_8
XFILLER_389_168 VPWR VGND sg13cmos5l_decap_4
XFILLER_530_7 VPWR VGND sg13cmos5l_decap_8
XFILLER_410_63 VPWR VGND sg13cmos5l_decap_8
XFILLER_628_7 VPWR VGND sg13cmos5l_fill_2
XANTENNA__0136__Y AXI_M_SOC_AWLEN3 VPWR VGND sg13cmos5l_antennanp
XFILLER_397_190 VPWR VGND sg13cmos5l_decap_8
XFILLER_339_28 VPWR VGND sg13cmos5l_decap_8
XFILLER_11_122 VPWR VGND sg13cmos5l_fill_2
XFILLER_486_56 VPWR VGND sg13cmos5l_decap_8
XANTENNA__3728__X AXI_M_SOC_ARADDR0 VPWR VGND sg13cmos5l_antennanp
XFILLER_269_91 VPWR VGND sg13cmos5l_decap_8
XFILLER_22_84 VPWR VGND sg13cmos5l_decap_8
XFILLER_118_0 VPWR VGND sg13cmos5l_decap_8
XFILLER_355_49 VPWR VGND sg13cmos5l_decap_8
XFILLER_138_84 VPWR VGND sg13cmos5l_decap_8
XFILLER_502_224 VPWR VGND sg13cmos5l_decap_4
XFILLER_313_124 VPWR VGND sg13cmos5l_fill_1
XFILLER_652_14 VPWR VGND sg13cmos5l_decap_8
XFILLER_112_208 VPWR VGND sg13cmos5l_decap_8
XFILLER_0_0 VPWR VGND sg13cmos5l_fill_2
XANTENNA__3463__X Tile_X0Y1_FrameData_O[21] VPWR VGND sg13cmos5l_antennanp
XFILLER_98_99 VPWR VGND sg13cmos5l_decap_8
XFILLER_112_219 VPWR VGND sg13cmos5l_fill_2
XFILLER_78_144 VPWR VGND sg13cmos5l_decap_4
XFILLER_487_0 VPWR VGND sg13cmos5l_decap_8
XFILLER_78_166 VPWR VGND sg13cmos5l_fill_1
XFILLER_467_194 VPWR VGND sg13cmos5l_fill_2
XFILLER_78_188 VPWR VGND sg13cmos5l_decap_4
XFILLER_93_114 VPWR VGND sg13cmos5l_decap_4
XFILLER_304_42 VPWR VGND sg13cmos5l_decap_8
XFILLER_451_70 VPWR VGND sg13cmos5l_decap_8
XFILLER_654_0 VPWR VGND sg13cmos5l_decap_8
XANTENNA__2807__X Tile_X0Y3_E2BEGb[5] VPWR VGND sg13cmos5l_antennanp
XFILLER_219_194 VPWR VGND sg13cmos5l_decap_8
XFILLER_601_84 VPWR VGND sg13cmos5l_decap_4
XFILLER_320_63 VPWR VGND sg13cmos5l_fill_1
X_2960_ Tile_X0Y8_FrameData_O[0] Tile_X0Y8_FrameData[0] VPWR VGND sg13cmos5l_buf_1
XFILLER_320_96 VPWR VGND sg13cmos5l_fill_2
X_1911_ _1911_/Q Tile_X0Y3_FrameData[18] VGND VPWR Tile_X0Y9_FrameStrobe[7] latch
XFILLER_677_77 VPWR VGND sg13cmos5l_decap_8
XFILLER_537_121 VPWR VGND sg13cmos5l_decap_8
XFILLER_249_28 VPWR VGND sg13cmos5l_decap_8
X_2891_ Tile_X0Y6_FrameData_O[12] Tile_X0Y6_FrameData[12] VPWR VGND sg13cmos5l_buf_1
XFILLER_179_80 VPWR VGND sg13cmos5l_decap_8
XANTENNA__3638__X Tile_X0Y9_UserCLKo VPWR VGND sg13cmos5l_antennanp
XFILLER_396_56 VPWR VGND sg13cmos5l_decap_8
X_4630_ _4630_/X Tile_X0Y7_WW4END[13] AXI_M_SOC_RDATA18 _4697_/X _4672_/X _0299_/Q
+ _0298_/Q VPWR VGND sg13cmos5l_mux4_1
XFILLER_8_42 VPWR VGND sg13cmos5l_decap_8
X_1842_ _1842_/Q Tile_X0Y3_FrameData[23] VGND VPWR Tile_X0Y9_FrameStrobe[5] latch
XFILLER_336_216 VPWR VGND sg13cmos5l_fill_1
XFILLER_147_127 VPWR VGND sg13cmos5l_decap_4
XFILLER_693_21 VPWR VGND sg13cmos5l_decap_8
X_4561_ _4561_/X _4120_/X _4124_/X _4113_/X _4102_/X _1613_/Q _1612_/Q VPWR VGND sg13cmos5l_mux4_1
X_1773_ _1773_/Q Tile_X0Y3_FrameData[28] VGND VPWR Tile_X0Y9_FrameStrobe[3] latch
X_3512_ Tile_X0Y1_E2BEG[2] _3934_/X VPWR VGND sg13cmos5l_buf_1
X_0724_ _0724_/Q Tile_X0Y9_FrameData[11] VGND VPWR Tile_X0Y9_FrameStrobe[1] latch
XFILLER_693_98 VPWR VGND sg13cmos5l_decap_8
X_4492_ _4492_/X _4545_/X _4544_/X AXI_M_SOC_RDATA27 AXI_M_SOC_RDATA31 _2623_/Q _2622_/Q
+ VPWR VGND sg13cmos5l_mux4_1
XFILLER_265_49 VPWR VGND sg13cmos5l_decap_8
XFILLER_626_70 VPWR VGND sg13cmos5l_decap_8
X_3443_ Tile_X0Y1_FrameData_O[1] Tile_X0Y1_FrameData[1] VPWR VGND sg13cmos5l_buf_1
XFILLER_639_228 VPWR VGND sg13cmos5l_fill_1
XFILLER_562_14 VPWR VGND sg13cmos5l_decap_8
X_0655_ _0655_/Q Tile_X0Y8_FrameData[16] VGND VPWR Tile_X0Y9_FrameStrobe[7] latch
XANTENNA__3373__X Tile_X0Y2_EE4BEG[12] VPWR VGND sg13cmos5l_antennanp
X_3374_ Tile_X0Y2_EE4BEG[13] _4069_/X VPWR VGND sg13cmos5l_buf_1
X_0586_ _0586_/Q Tile_X0Y8_FrameData[21] VGND VPWR Tile_X0Y9_FrameStrobe[5] latch
XFILLER_654_209 VPWR VGND sg13cmos5l_decap_8
XFILLER_33_0 VPWR VGND sg13cmos5l_fill_1
XFILLER_69_133 VPWR VGND sg13cmos5l_decap_8
XFILLER_712_28 VPWR VGND sg13cmos5l_decap_8
X_2325_ _2325_/Q Tile_X0Y5_FrameData[16] VGND VPWR Tile_X0Y9_FrameStrobe[4] latch
XFILLER_312_190 VPWR VGND sg13cmos5l_decap_8
XFILLER_642_91 VPWR VGND sg13cmos5l_decap_8
XFILLER_214_42 VPWR VGND sg13cmos5l_decap_8
X_2256_ _2256_/Q Tile_X0Y5_FrameData[21] VGND VPWR Tile_X0Y9_FrameStrobe[2] latch
XFILLER_361_70 VPWR VGND sg13cmos5l_decap_8
X_1207_ _1207_/Q Tile_X0Y1_FrameData[2] VGND VPWR Tile_X0Y9_FrameStrobe[0] latch
X_2187_ _2187_/Q Tile_X0Y5_FrameData[26] VGND VPWR Tile_X0Y9_FrameStrobe[0] latch
X_1138_ _1138_/Q Tile_X0Y0_FrameData[25] VGND VPWR Tile_X0Y9_FrameStrobe[6] latch
XFILLER_25_225 VPWR VGND sg13cmos5l_decap_4
XFILLER_92_191 VPWR VGND sg13cmos5l_decap_8
XFILLER_511_84 VPWR VGND sg13cmos5l_decap_8
XFILLER_630_150 VPWR VGND sg13cmos5l_fill_2
XFILLER_230_63 VPWR VGND sg13cmos5l_decap_8
X_1069_ _1069_/Q Tile_X0Y0_FrameData[30] VGND VPWR Tile_X0Y9_FrameStrobe[4] latch
XFILLER_43_28 VPWR VGND sg13cmos5l_decap_8
XFILLER_386_127 VPWR VGND sg13cmos5l_decap_4
XFILLER_587_77 VPWR VGND sg13cmos5l_decap_8
XFILLER_159_28 VPWR VGND sg13cmos5l_decap_8
XANTENNA__3548__X Tile_X0Y9_E6BEG[6] VPWR VGND sg13cmos5l_antennanp
XFILLER_138_105 VPWR VGND sg13cmos5l_decap_8
X_4828_ _4828_/X Tile_X0Y9_W2MID[7] Tile_X0Y9_W2END[7] Tile_X0Y9_W6END[8] _4901_/X
+ _0883_/Q _0882_/Q VPWR VGND sg13cmos5l_mux4_1
XFILLER_543_102 VPWR VGND sg13cmos5l_fill_2
X_4759_ _4759_/X Tile_X0Y8_WW4END[0] AXI_M_SOC_RDATA8 _4800_/X _4785_/X _0529_/Q _0528_/Q
+ VPWR VGND sg13cmos5l_mux4_1
XFILLER_111_7 VPWR VGND sg13cmos5l_decap_8
XFILLER_209_7 VPWR VGND sg13cmos5l_decap_8
XFILLER_175_49 VPWR VGND sg13cmos5l_decap_8
XFILLER_536_70 VPWR VGND sg13cmos5l_decap_8
XFILLER_108_21 VPWR VGND sg13cmos5l_decap_8
XFILLER_161_130 VPWR VGND sg13cmos5l_decap_8
XFILLER_697_172 VPWR VGND sg13cmos5l_fill_1
XFILLER_700_121 VPWR VGND sg13cmos5l_decap_8
XFILLER_472_14 VPWR VGND sg13cmos5l_decap_8
XANTENNA__3283__X Tile_X0Y0_E6BEG[3] VPWR VGND sg13cmos5l_antennanp
XFILLER_68_14 VPWR VGND sg13cmos5l_decap_8
XFILLER_161_196 VPWR VGND sg13cmos5l_decap_4
XFILLER_480_7 VPWR VGND sg13cmos5l_decap_8
XFILLER_303_190 VPWR VGND sg13cmos5l_decap_4
XFILLER_622_28 VPWR VGND sg13cmos5l_decap_8
XFILLER_405_63 VPWR VGND sg13cmos5l_decap_8
XFILLER_578_7 VPWR VGND sg13cmos5l_decap_8
XFILLER_552_91 VPWR VGND sg13cmos5l_decap_8
XFILLER_464_131 VPWR VGND sg13cmos5l_fill_2
XFILLER_75_136 VPWR VGND sg13cmos5l_decap_8
XFILLER_271_70 VPWR VGND sg13cmos5l_decap_8
XFILLER_124_75 VPWR VGND sg13cmos5l_decap_8
XFILLER_84_35 VPWR VGND sg13cmos5l_decap_8
XFILLER_702_94 VPWR VGND sg13cmos5l_decap_8
XFILLER_16_203 VPWR VGND sg13cmos5l_fill_2
XFILLER_421_84 VPWR VGND sg13cmos5l_decap_8
XFILLER_216_164 VPWR VGND sg13cmos5l_decap_4
XFILLER_140_63 VPWR VGND sg13cmos5l_decap_8
XFILLER_377_138 VPWR VGND sg13cmos5l_decap_4
XFILLER_31_228 VPWR VGND sg13cmos5l_fill_1
XFILLER_231_167 VPWR VGND sg13cmos5l_decap_4
XFILLER_497_77 VPWR VGND sg13cmos5l_decap_8
XFILLER_647_14 VPWR VGND sg13cmos5l_decap_8
XFILLER_235_0 VPWR VGND sg13cmos5l_decap_8
XANTENNA__3458__X Tile_X0Y1_FrameData_O[16] VPWR VGND sg13cmos5l_antennanp
XFILLER_581_219 VPWR VGND sg13cmos5l_fill_2
XFILLER_385_171 VPWR VGND sg13cmos5l_decap_8
XFILLER_519_187 VPWR VGND sg13cmos5l_fill_2
XFILLER_33_94 VPWR VGND sg13cmos5l_fill_2
XFILLER_534_135 VPWR VGND sg13cmos5l_decap_8
XFILLER_402_0 VPWR VGND sg13cmos5l_decap_8
XFILLER_144_119 VPWR VGND sg13cmos5l_decap_8
XFILLER_663_35 VPWR VGND sg13cmos5l_decap_8
XFILLER_137_182 VPWR VGND sg13cmos5l_decap_8
XFILLER_446_70 VPWR VGND sg13cmos5l_decap_8
XFILLER_382_14 VPWR VGND sg13cmos5l_decap_8
XFILLER_3_140 VPWR VGND sg13cmos5l_fill_1
XANTENNA__3193__X Tile_X0Y0_N2BEGb[1] VPWR VGND sg13cmos5l_antennanp
XFILLER_98_228 VPWR VGND sg13cmos5l_fill_1
X_0440_ _0440_/Q Tile_X0Y8_FrameData[7] VGND VPWR Tile_X0Y9_FrameStrobe[0] latch
XFILLER_239_201 VPWR VGND sg13cmos5l_decap_8
XFILLER_532_28 VPWR VGND sg13cmos5l_decap_8
XFILLER_315_63 VPWR VGND sg13cmos5l_decap_4
X_0371_ _0371_/Q Tile_X0Y7_FrameData[12] VGND VPWR Tile_X0Y9_FrameStrobe[6] latch
X_2110_ _2110_/Q Tile_X0Y4_FrameData[7] VGND VPWR Tile_X0Y9_FrameStrobe[5] latch
XFILLER_58_80 VPWR VGND sg13cmos5l_decap_8
X_3090_ Tile_X0Y7_E2BEG[4] _4616_/X VPWR VGND sg13cmos5l_buf_1
XFILLER_66_136 VPWR VGND sg13cmos5l_decap_8
XFILLER_58_91 VPWR VGND sg13cmos5l_fill_1
X_2041_ _2041_/Q Tile_X0Y4_FrameData[12] VGND VPWR Tile_X0Y9_FrameStrobe[3] latch
XFILLER_688_21 VPWR VGND sg13cmos5l_decap_8
XFILLER_470_145 VPWR VGND sg13cmos5l_decap_8
XFILLER_331_84 VPWR VGND sg13cmos5l_decap_8
XFILLER_207_175 VPWR VGND sg13cmos5l_decap_8
XFILLER_368_105 VPWR VGND sg13cmos5l_decap_8
X_3992_ _3992_/X _3898_/X _4031_/X _4030_/X Tile_X0Y0_S2MID[5] _1191_/Q _1190_/Q VPWR
+ VGND sg13cmos5l_mux4_1
XFILLER_557_227 VPWR VGND sg13cmos5l_fill_2
XFILLER_22_217 VPWR VGND sg13cmos5l_fill_1
X_2943_ Tile_X0Y8_E6BEG[11] _4771_/X VPWR VGND sg13cmos5l_buf_1
XFILLER_557_14 VPWR VGND sg13cmos5l_decap_8
XANTENNA__3368__X Tile_X0Y2_EE4BEG[7] VPWR VGND sg13cmos5l_antennanp
XFILLER_200_77 VPWR VGND sg13cmos5l_decap_8
X_2874_ Tile_X0Y6_EE4BEG[11] _4523_/X VPWR VGND sg13cmos5l_buf_1
X_4613_ _4613_/X Tile_X0Y7_W2MID[6] AXI_M_SOC_RDATA17 _4671_/X _4670_/X _0333_/Q _0332_/Q
+ VPWR VGND sg13cmos5l_mux4_1
XFILLER_707_28 VPWR VGND sg13cmos5l_decap_8
X_1825_ _1825_/Q Tile_X0Y3_FrameData[8] VGND VPWR Tile_X0Y9_FrameStrobe[4] latch
XFILLER_525_157 VPWR VGND sg13cmos5l_fill_2
XFILLER_135_119 VPWR VGND sg13cmos5l_decap_8
XFILLER_637_91 VPWR VGND sg13cmos5l_decap_8
XFILLER_540_105 VPWR VGND sg13cmos5l_fill_2
XFILLER_324_219 VPWR VGND sg13cmos5l_decap_8
XFILLER_209_42 VPWR VGND sg13cmos5l_decap_8
X_4544_ _4544_/X Tile_X0Y5_W1END[0] Tile_X0Y5_W6END[8] _4463_/X _4416_/X _2403_/Q
+ _2402_/Q VPWR VGND sg13cmos5l_mux4_1
XFILLER_190_225 VPWR VGND sg13cmos5l_decap_4
X_1756_ _1756_/Q Tile_X0Y3_FrameData[13] VGND VPWR Tile_X0Y9_FrameStrobe[2] latch
XFILLER_573_35 VPWR VGND sg13cmos5l_decap_8
XFILLER_356_70 VPWR VGND sg13cmos5l_decap_8
XFILLER_679_161 VPWR VGND sg13cmos5l_fill_2
XFILLER_540_149 VPWR VGND sg13cmos5l_decap_4
XFILLER_289_112 VPWR VGND sg13cmos5l_decap_8
X_0707_ _0707_/Q Tile_X0Y9_FrameData[28] VGND VPWR Tile_X0Y9_FrameStrobe[1] latch
XFILLER_292_14 VPWR VGND sg13cmos5l_decap_8
X_4475_ _4475_/X Tile_X0Y7_W2MID[4] Tile_X0Y7_W2END[4] Tile_X0Y7_W6END[4] _4675_/X
+ _0401_/Q _0400_/Q VPWR VGND sg13cmos5l_mux4_1
XFILLER_289_134 VPWR VGND sg13cmos5l_decap_8
X_1687_ _1687_/Q Tile_X0Y3_FrameData[18] VGND VPWR Tile_X0Y9_FrameStrobe[0] latch
X_3426_ Tile_X0Y4_FrameData_O[17] Tile_X0Y4_FrameData[17] VPWR VGND sg13cmos5l_buf_1
X_0638_ _0638_/Q Tile_X0Y8_FrameData[1] VGND VPWR Tile_X0Y9_FrameStrobe[6] latch
XFILLER_694_153 VPWR VGND sg13cmos5l_decap_8
XFILLER_143_196 VPWR VGND sg13cmos5l_decap_8
XFILLER_506_84 VPWR VGND sg13cmos5l_decap_8
XFILLER_694_175 VPWR VGND sg13cmos5l_decap_4
XFILLER_442_28 VPWR VGND sg13cmos5l_decap_8
XFILLER_225_63 VPWR VGND sg13cmos5l_decap_8
X_3357_ Tile_X0Y2_FrameData_O[28] Tile_X0Y2_FrameData[28] VPWR VGND sg13cmos5l_buf_1
X_0569_ _0569_/Q Tile_X0Y8_FrameData[6] VGND VPWR Tile_X0Y9_FrameStrobe[4] latch
XFILLER_38_28 VPWR VGND sg13cmos5l_decap_8
XFILLER_372_91 VPWR VGND sg13cmos5l_decap_8
XFILLER_57_114 VPWR VGND sg13cmos5l_fill_1
X_2308_ _2308_/Q Tile_X0Y5_FrameData[1] VGND VPWR Tile_X0Y9_FrameStrobe[3] latch
X_3288_ Tile_X0Y0_E6BEG[8] _3844_/X VPWR VGND sg13cmos5l_buf_1
XFILLER_446_164 VPWR VGND sg13cmos5l_decap_8
XFILLER_446_186 VPWR VGND sg13cmos5l_fill_2
X_2239_ _2239_/Q Tile_X0Y5_FrameData[6] VGND VPWR Tile_X0Y9_FrameStrobe[1] latch
XFILLER_598_21 VPWR VGND sg13cmos5l_decap_8
XFILLER_241_84 VPWR VGND sg13cmos5l_decap_8
XFILLER_241_95 VPWR VGND sg13cmos5l_fill_1
XFILLER_54_49 VPWR VGND sg13cmos5l_decap_8
XFILLER_213_112 VPWR VGND sg13cmos5l_decap_8
XFILLER_359_105 VPWR VGND sg13cmos5l_decap_8
XFILLER_402_223 VPWR VGND sg13cmos5l_decap_4
XFILLER_598_98 VPWR VGND sg13cmos5l_fill_1
XFILLER_159_7 VPWR VGND sg13cmos5l_decap_8
XFILLER_13_228 VPWR VGND sg13cmos5l_fill_1
XFILLER_467_14 VPWR VGND sg13cmos5l_decap_8
XANTENNA__3278__X Tile_X0Y0_EE4BEG[14] VPWR VGND sg13cmos5l_antennanp
XFILLER_213_189 VPWR VGND sg13cmos5l_decap_8
XFILLER_110_77 VPWR VGND sg13cmos5l_decap_8
XFILLER_166_211 VPWR VGND sg13cmos5l_decap_8
XFILLER_516_102 VPWR VGND sg13cmos5l_fill_2
XFILLER_467_58 VPWR VGND sg13cmos5l_fill_1
XFILLER_326_7 VPWR VGND sg13cmos5l_decap_8
XFILLER_617_28 VPWR VGND sg13cmos5l_decap_8
XFILLER_126_119 VPWR VGND sg13cmos5l_decap_4
XFILLER_547_91 VPWR VGND sg13cmos5l_decap_8
XANTENNA__2910__X Tile_X0Y6_FrameData_O[31] VPWR VGND sg13cmos5l_antennanp
XFILLER_119_42 VPWR VGND sg13cmos5l_decap_8
XFILLER_119_171 VPWR VGND sg13cmos5l_fill_2
XFILLER_483_35 VPWR VGND sg13cmos5l_decap_8
XFILLER_266_70 VPWR VGND sg13cmos5l_decap_8
XFILLER_79_35 VPWR VGND sg13cmos5l_decap_8
XFILLER_695_7 VPWR VGND sg13cmos5l_decap_8
XFILLER_633_49 VPWR VGND sg13cmos5l_decap_8
XFILLER_416_84 VPWR VGND sg13cmos5l_decap_8
XFILLER_685_164 VPWR VGND sg13cmos5l_fill_2
XFILLER_352_28 VPWR VGND sg13cmos5l_decap_8
XFILLER_135_63 VPWR VGND sg13cmos5l_decap_8
XFILLER_295_159 VPWR VGND sg13cmos5l_decap_4
XANTENNA__3741__X AXI_M_SOC_ARADDR13 VPWR VGND sg13cmos5l_antennanp
XFILLER_282_91 VPWR VGND sg13cmos5l_decap_8
XFILLER_0_176 VPWR VGND sg13cmos5l_fill_2
XFILLER_95_56 VPWR VGND sg13cmos5l_decap_8
XFILLER_452_101 VPWR VGND sg13cmos5l_fill_2
XFILLER_185_0 VPWR VGND sg13cmos5l_decap_8
XFILLER_63_139 VPWR VGND sg13cmos5l_decap_8
XFILLER_56_180 VPWR VGND sg13cmos5l_decap_8
XFILLER_301_21 VPWR VGND sg13cmos5l_decap_8
XFILLER_352_0 VPWR VGND sg13cmos5l_decap_8
XFILLER_204_112 VPWR VGND sg13cmos5l_decap_8
XFILLER_71_172 VPWR VGND sg13cmos5l_fill_1
XFILLER_658_35 VPWR VGND sg13cmos5l_decap_8
XFILLER_71_183 VPWR VGND sg13cmos5l_decap_8
XFILLER_44_82 VPWR VGND sg13cmos5l_decap_8
XFILLER_377_14 VPWR VGND sg13cmos5l_decap_8
XANTENNA__3188__X Tile_X0Y0_N4BEG[12] VPWR VGND sg13cmos5l_antennanp
XFILLER_617_0 VPWR VGND sg13cmos5l_decap_8
XFILLER_365_119 VPWR VGND sg13cmos5l_decap_4
XFILLER_554_219 VPWR VGND sg13cmos5l_decap_8
XFILLER_157_211 VPWR VGND sg13cmos5l_decap_8
XFILLER_74_7 VPWR VGND sg13cmos5l_decap_8
XFILLER_527_28 VPWR VGND sg13cmos5l_decap_8
XFILLER_117_108 VPWR VGND sg13cmos5l_decap_8
XFILLER_172_203 VPWR VGND sg13cmos5l_decap_8
XFILLER_674_56 VPWR VGND sg13cmos5l_decap_8
XFILLER_60_70 VPWR VGND sg13cmos5l_decap_8
XFILLER_507_168 VPWR VGND sg13cmos5l_decap_8
XANTENNA__2820__X Tile_X0Y3_E1BEG[2] VPWR VGND sg13cmos5l_antennanp
X_1610_ _1610_/Q Tile_X0Y2_FrameData[7] VGND VPWR Tile_X0Y9_FrameStrobe[5] latch
X_2590_ _2590_/Q Tile_X0Y6_FrameData[9] VGND VPWR Tile_X0Y9_FrameStrobe[4] latch
XFILLER_393_35 VPWR VGND sg13cmos5l_decap_8
XFILLER_5_21 VPWR VGND sg13cmos5l_decap_8
X_1541_ _1541_/Q Tile_X0Y2_FrameData[12] VGND VPWR Tile_X0Y9_FrameStrobe[3] latch
XFILLER_125_174 VPWR VGND sg13cmos5l_decap_8
X_4260_ _4260_/X Tile_X0Y4_W2MID[3] AXI_M_SOC_BRESP0 _4319_/X _4318_/X _2093_/Q _2092_/Q
+ VPWR VGND sg13cmos5l_mux4_1
X_1472_ _1472_/Q Tile_X0Y2_FrameData[17] VGND VPWR Tile_X0Y9_FrameStrobe[1] latch
XFILLER_543_49 VPWR VGND sg13cmos5l_decap_8
XFILLER_5_98 VPWR VGND sg13cmos5l_decap_8
XFILLER_326_84 VPWR VGND sg13cmos5l_decap_8
XFILLER_140_133 VPWR VGND sg13cmos5l_decap_8
XFILLER_326_95 VPWR VGND sg13cmos5l_fill_2
XFILLER_286_126 VPWR VGND sg13cmos5l_decap_8
X_3211_ Tile_X0Y0_N1BEG[3] _3783_/X VPWR VGND sg13cmos5l_buf_1
XFILLER_690_77 VPWR VGND sg13cmos5l_decap_8
X_0423_ _0423_/Q Tile_X0Y8_FrameData[24] VGND VPWR Tile_X0Y9_FrameStrobe[0] latch
XFILLER_262_28 VPWR VGND sg13cmos5l_decap_8
X_4191_ _4191_/X AXI_M_SOC_BVALID _4222_/X _4226_/X _4204_/X _1759_/Q _1758_/Q VPWR
+ VGND sg13cmos5l_mux4_1
XFILLER_140_166 VPWR VGND sg13cmos5l_decap_8
XANTENNA__3651__X AXI_M_SOC_AWADDR12 VPWR VGND sg13cmos5l_antennanp
X_3142_ Tile_X0Y7_FrameData_O[12] Tile_X0Y7_FrameData[12] VPWR VGND sg13cmos5l_buf_1
X_0354_ _0354_/Q Tile_X0Y7_FrameData[29] VGND VPWR Tile_X0Y9_FrameStrobe[6] latch
XFILLER_632_201 VPWR VGND sg13cmos5l_fill_1
XFILLER_428_175 VPWR VGND sg13cmos5l_decap_8
XFILLER_443_112 VPWR VGND sg13cmos5l_decap_8
XFILLER_589_105 VPWR VGND sg13cmos5l_decap_8
X_3073_ Tile_X0Y5_UserCLKo Tile_X0Y5_UserCLK VPWR VGND sg13cmos5l_buf_1
XFILLER_589_116 VPWR VGND sg13cmos5l_fill_2
X_0285_ _0285_/Q Tile_X0Y7_FrameData[2] VGND VPWR Tile_X0Y9_FrameStrobe[3] latch
XFILLER_699_75 VPWR VGND sg13cmos5l_decap_8
XFILLER_54_117 VPWR VGND sg13cmos5l_decap_8
X_2024_ _2024_/Q Tile_X0Y4_FrameData[29] VGND VPWR Tile_X0Y9_FrameStrobe[3] latch
XFILLER_211_21 VPWR VGND sg13cmos5l_decap_8
XFILLER_62_161 VPWR VGND sg13cmos5l_decap_8
XFILLER_568_35 VPWR VGND sg13cmos5l_decap_8
XFILLER_287_14 VPWR VGND sg13cmos5l_decap_8
XFILLER_211_98 VPWR VGND sg13cmos5l_decap_8
X_3975_ _3975_/X AXI_M_SOC_ARREADY _4008_/X _4012_/X _3988_/X _1259_/Q _1258_/Q VPWR
+ VGND sg13cmos5l_mux4_1
XANTENNA__3098__X Tile_X0Y7_E2BEGb[4] VPWR VGND sg13cmos5l_antennanp
XFILLER_356_119 VPWR VGND sg13cmos5l_decap_8
XFILLER_210_126 VPWR VGND sg13cmos5l_decap_8
X_2926_ Tile_X0Y8_E2BEGb[2] _4738_/X VPWR VGND sg13cmos5l_buf_1
XFILLER_437_28 VPWR VGND sg13cmos5l_decap_8
X_2857_ Tile_X0Y6_E6BEG[6] _4534_/X VPWR VGND sg13cmos5l_buf_1
XFILLER_584_56 VPWR VGND sg13cmos5l_decap_8
XFILLER_163_214 VPWR VGND sg13cmos5l_decap_4
XFILLER_513_105 VPWR VGND sg13cmos5l_decap_8
XFILLER_367_91 VPWR VGND sg13cmos5l_decap_8
X_1808_ _1808_/Q Tile_X0Y3_FrameData[25] VGND VPWR Tile_X0Y9_FrameStrobe[4] latch
X_2788_ Tile_X0Y3_EE4BEG[14] _4178_/X VPWR VGND sg13cmos5l_buf_1
XFILLER_702_227 VPWR VGND sg13cmos5l_fill_2
XFILLER_513_149 VPWR VGND sg13cmos5l_fill_2
XFILLER_116_130 VPWR VGND sg13cmos5l_decap_8
X_4527_ _4527_/X Tile_X0Y6_WW4END[0] AXI_M_SOC_RDATA24 _4568_/X _4553_/X _2553_/Q
+ _2552_/Q VPWR VGND sg13cmos5l_mux4_1
X_1739_ _1739_/Q Tile_X0Y3_FrameData[30] VGND VPWR Tile_X0Y9_FrameStrobe[2] latch
X_4458_ _4458_/X _4427_/X _0097_/X _4426_/X _0156_/X _2223_/Q _2222_/Q VPWR VGND sg13cmos5l_mux4_1
XFILLER_667_153 VPWR VGND sg13cmos5l_decap_8
XFILLER_521_171 VPWR VGND sg13cmos5l_decap_4
XFILLER_116_196 VPWR VGND sg13cmos5l_decap_8
XFILLER_453_49 VPWR VGND sg13cmos5l_decap_8
XFILLER_236_84 VPWR VGND sg13cmos5l_fill_2
XFILLER_521_182 VPWR VGND sg13cmos5l_decap_4
XFILLER_49_38 VPWR VGND sg13cmos5l_decap_8
XFILLER_277_126 VPWR VGND sg13cmos5l_decap_8
XFILLER_131_133 VPWR VGND sg13cmos5l_decap_8
X_3409_ Tile_X0Y4_FrameData_O[0] Tile_X0Y4_FrameData[0] VPWR VGND sg13cmos5l_buf_1
XFILLER_172_28 VPWR VGND sg13cmos5l_decap_8
X_4389_ _4389_/X Tile_X0Y5_WW4END[14] AXI_M_SOC_RLAST _4465_/X _4429_/X _2325_/Q _2324_/Q
+ VPWR VGND sg13cmos5l_mux4_1
XFILLER_682_134 VPWR VGND sg13cmos5l_decap_8
XFILLER_419_120 VPWR VGND sg13cmos5l_fill_1
XANTENNA__3561__X Tile_X0Y9_EE4BEG[7] VPWR VGND sg13cmos5l_antennanp
XFILLER_434_112 VPWR VGND sg13cmos5l_decap_8
XFILLER_105_77 VPWR VGND sg13cmos5l_decap_8
XFILLER_276_7 VPWR VGND sg13cmos5l_decap_8
XFILLER_402_42 VPWR VGND sg13cmos5l_decap_8
XFILLER_121_21 VPWR VGND sg13cmos5l_decap_8
XFILLER_198_100 VPWR VGND sg13cmos5l_fill_1
XANTENNA__2905__X Tile_X0Y6_FrameData_O[26] VPWR VGND sg13cmos5l_antennanp
XFILLER_443_7 VPWR VGND sg13cmos5l_decap_8
XFILLER_81_14 VPWR VGND sg13cmos5l_decap_8
XFILLER_478_35 VPWR VGND sg13cmos5l_decap_8
XFILLER_198_166 VPWR VGND sg13cmos5l_decap_4
XFILLER_197_14 VPWR VGND sg13cmos5l_decap_8
XFILLER_610_7 VPWR VGND sg13cmos5l_decap_8
XFILLER_347_119 VPWR VGND sg13cmos5l_decap_8
XFILLER_198_199 VPWR VGND sg13cmos5l_decap_8
XFILLER_708_7 VPWR VGND sg13cmos5l_decap_8
XFILLER_14_63 VPWR VGND sg13cmos5l_decap_8
XFILLER_347_28 VPWR VGND sg13cmos5l_decap_8
XANTENNA__3736__X AXI_M_SOC_ARADDR8 VPWR VGND sg13cmos5l_antennanp
XFILLER_494_56 VPWR VGND sg13cmos5l_decap_8
XFILLER_277_91 VPWR VGND sg13cmos5l_decap_8
XFILLER_504_105 VPWR VGND sg13cmos5l_decap_8
XFILLER_355_196 VPWR VGND sg13cmos5l_decap_4
XFILLER_370_133 VPWR VGND sg13cmos5l_decap_8
XFILLER_30_62 VPWR VGND sg13cmos5l_decap_8
XFILLER_100_0 VPWR VGND sg13cmos5l_decap_8
XFILLER_658_153 VPWR VGND sg13cmos5l_decap_8
XFILLER_512_171 VPWR VGND sg13cmos5l_fill_1
XFILLER_363_49 VPWR VGND sg13cmos5l_decap_8
XFILLER_146_84 VPWR VGND sg13cmos5l_decap_8
XFILLER_122_144 VPWR VGND sg13cmos5l_decap_8
XFILLER_660_14 VPWR VGND sg13cmos5l_decap_8
XANTENNA__3471__X Tile_X0Y1_FrameData_O[29] VPWR VGND sg13cmos5l_antennanp
XFILLER_472_218 VPWR VGND sg13cmos5l_fill_1
XFILLER_39_82 VPWR VGND sg13cmos5l_decap_8
XFILLER_673_189 VPWR VGND sg13cmos5l_fill_2
XFILLER_39_93 VPWR VGND sg13cmos5l_fill_2
XFILLER_567_0 VPWR VGND sg13cmos5l_decap_8
XFILLER_425_112 VPWR VGND sg13cmos5l_decap_8
XFILLER_162_72 VPWR VGND sg13cmos5l_fill_1
XFILLER_36_117 VPWR VGND sg13cmos5l_decap_4
XFILLER_312_42 VPWR VGND sg13cmos5l_decap_8
X_0070_ AXI_M_SOC_WSTRB1 _0935_/Q _3723_/X VPWR VGND sg13cmos5l_or2_1
XFILLER_425_189 VPWR VGND sg13cmos5l_decap_4
XFILLER_669_56 VPWR VGND sg13cmos5l_decap_8
XFILLER_55_70 VPWR VGND sg13cmos5l_decap_8
XANTENNA__2815__X Tile_X0Y3_E2BEG[5] VPWR VGND sg13cmos5l_antennanp
XFILLER_440_148 VPWR VGND sg13cmos5l_decap_8
XFILLER_378_211 VPWR VGND sg13cmos5l_decap_4
XFILLER_579_182 VPWR VGND sg13cmos5l_decap_8
XFILLER_388_35 VPWR VGND sg13cmos5l_decap_8
XFILLER_393_214 VPWR VGND sg13cmos5l_decap_8
X_3760_ _3760_/X Tile_X0Y1_WW4END[1] Tile_X0Y1_WW4END[9] Tile_X0Y1_W6END[1] _4009_/X
+ _1255_/Q _1254_/Q VPWR VGND sg13cmos5l_mux4_1
X_0972_ _0972_/Q Tile_X0Y0_FrameData[31] VGND VPWR Tile_X0Y9_FrameStrobe[1] latch
XFILLER_538_49 VPWR VGND sg13cmos5l_decap_8
X_2711_ _4300_/A3 VPWR VGND sg13cmos5l_tielo
XFILLER_685_77 VPWR VGND sg13cmos5l_decap_8
XFILLER_71_91 VPWR VGND sg13cmos5l_decap_8
XFILLER_257_28 VPWR VGND sg13cmos5l_decap_8
X_3691_ AXI_M_SOC_WDATA1 Tile_X0Y7_WW4END[1] Tile_X0Y7_WW4END[9] Tile_X0Y7_W6END[1]
+ _4685_/X _0245_/Q _0244_/Q VPWR VGND sg13cmos5l_mux4_1
XFILLER_346_163 VPWR VGND sg13cmos5l_decap_8
XANTENNA__3646__X AXI_M_SOC_AWADDR7 VPWR VGND sg13cmos5l_antennanp
XFILLER_145_225 VPWR VGND sg13cmos5l_decap_4
X_2642_ _2642_/Q Tile_X0Y6_FrameData[21] VGND VPWR Tile_X0Y9_FrameStrobe[6] latch
XFILLER_361_133 VPWR VGND sg13cmos5l_fill_2
X_2573_ _2573_/Q Tile_X0Y6_FrameData[26] VGND VPWR Tile_X0Y9_FrameStrobe[4] latch
XANTENNA__0070__X AXI_M_SOC_WSTRB1 VPWR VGND sg13cmos5l_antennanp
X_4312_ _4312_/X _4251_/X _4367_/X _4366_/X _4250_/X _1935_/Q _1934_/Q VPWR VGND sg13cmos5l_mux4_1
XFILLER_510_119 VPWR VGND sg13cmos5l_decap_8
X_1524_ _1524_/Q Tile_X0Y2_FrameData[29] VGND VPWR Tile_X0Y9_FrameStrobe[3] latch
XFILLER_302_211 VPWR VGND sg13cmos5l_decap_4
XFILLER_273_49 VPWR VGND sg13cmos5l_decap_8
XFILLER_634_70 VPWR VGND sg13cmos5l_decap_8
XFILLER_503_182 VPWR VGND sg13cmos5l_decap_8
XFILLER_206_21 VPWR VGND sg13cmos5l_decap_8
X_4243_ _4243_/X Tile_X0Y5_W2MID[4] Tile_X0Y5_W2END[4] Tile_X0Y5_W6END[4] _4434_/X
+ _2425_/Q _2424_/Q VPWR VGND sg13cmos5l_mux4_1
X_1455_ _1455_/Q Tile_X0Y2_FrameData[2] VGND VPWR Tile_X0Y9_FrameStrobe[0] latch
XFILLER_570_14 VPWR VGND sg13cmos5l_decap_8
XANTENNA__3381__X Tile_X0Y2_E6BEG[4] VPWR VGND sg13cmos5l_antennanp
X_0406_ _0406_/Q Tile_X0Y7_FrameData[9] VGND VPWR Tile_X0Y9_FrameStrobe[7] latch
X_4174_ _4174_/X Tile_X0Y3_WW4END[5] AXI_M_SOC_BVALID _4227_/X _4208_/X _1793_/Q _1792_/Q
+ VPWR VGND sg13cmos5l_mux4_1
XFILLER_206_98 VPWR VGND sg13cmos5l_decap_8
X_1386_ _1386_/Q Tile_X0Y1_FrameData[15] VGND VPWR Tile_X0Y9_FrameStrobe[6] latch
XFILLER_664_178 VPWR VGND sg13cmos5l_fill_1
XFILLER_267_181 VPWR VGND sg13cmos5l_fill_1
X_3125_ Tile_X0Y7_EE4BEG[11] _4639_/X VPWR VGND sg13cmos5l_buf_1
X_0337_ _0337_/Q Tile_X0Y7_FrameData[14] VGND VPWR Tile_X0Y9_FrameStrobe[5] latch
XFILLER_503_63 VPWR VGND sg13cmos5l_decap_8
XFILLER_282_140 VPWR VGND sg13cmos5l_decap_8
XFILLER_650_91 VPWR VGND sg13cmos5l_decap_8
XFILLER_416_156 VPWR VGND sg13cmos5l_decap_4
XFILLER_222_42 VPWR VGND sg13cmos5l_decap_8
XFILLER_416_167 VPWR VGND sg13cmos5l_decap_8
X_3056_ Tile_X0Y5_FrameData_O[15] Tile_X0Y5_FrameData[15] VPWR VGND sg13cmos5l_buf_1
XFILLER_215_218 VPWR VGND sg13cmos5l_decap_4
X_0268_ _0268_/Q Tile_X0Y7_FrameData[19] VGND VPWR Tile_X0Y9_FrameStrobe[3] latch
XFILLER_579_56 VPWR VGND sg13cmos5l_decap_8
XFILLER_431_126 VPWR VGND sg13cmos5l_decap_8
XFILLER_282_195 VPWR VGND sg13cmos5l_decap_8
X_2007_ _2007_/Q Tile_X0Y4_FrameData[14] VGND VPWR Tile_X0Y9_FrameStrobe[2] latch
XFILLER_577_119 VPWR VGND sg13cmos5l_decap_8
XFILLER_369_211 VPWR VGND sg13cmos5l_decap_8
X_0199_ _0199_/Q Tile_X0Y7_FrameData[24] VGND VPWR Tile_X0Y9_FrameStrobe[1] latch
XFILLER_298_35 VPWR VGND sg13cmos5l_decap_8
XFILLER_50_120 VPWR VGND sg13cmos5l_decap_8
XFILLER_50_142 VPWR VGND sg13cmos5l_fill_1
XFILLER_195_114 VPWR VGND sg13cmos5l_decap_8
XFILLER_518_219 VPWR VGND sg13cmos5l_fill_1
X_3958_ _3958_/X Tile_X0Y1_WW4END[5] AXI_M_SOC_ARREADY _4013_/X _3992_/X _1293_/Q
+ _1292_/Q VPWR VGND sg13cmos5l_mux4_1
XFILLER_448_49 VPWR VGND sg13cmos5l_decap_8
XFILLER_337_130 VPWR VGND sg13cmos5l_decap_4
XFILLER_595_77 VPWR VGND sg13cmos5l_decap_8
XFILLER_167_28 VPWR VGND sg13cmos5l_decap_8
X_2909_ Tile_X0Y6_FrameData_O[30] Tile_X0Y6_FrameData[30] VPWR VGND sg13cmos5l_buf_1
X_3889_ _3889_/X Tile_X0Y1_W2MID[7] Tile_X0Y1_W2END[7] Tile_X0Y1_W6END[7] _3989_/X
+ _1417_/Q _1416_/Q VPWR VGND sg13cmos5l_mux4_1
XANTENNA__3556__X Tile_X0Y9_EE4BEG[2] VPWR VGND sg13cmos5l_antennanp
XFILLER_352_133 VPWR VGND sg13cmos5l_decap_8
XFILLER_687_226 VPWR VGND sg13cmos5l_fill_2
XFILLER_498_126 VPWR VGND sg13cmos5l_decap_8
XFILLER_501_119 VPWR VGND sg13cmos5l_decap_8
XFILLER_4_7 VPWR VGND sg13cmos5l_decap_8
XFILLER_183_49 VPWR VGND sg13cmos5l_decap_8
XFILLER_104_133 VPWR VGND sg13cmos5l_decap_8
XFILLER_544_70 VPWR VGND sg13cmos5l_decap_8
XFILLER_116_21 VPWR VGND sg13cmos5l_decap_8
XFILLER_655_112 VPWR VGND sg13cmos5l_decap_8
XFILLER_480_14 VPWR VGND sg13cmos5l_decap_8
XFILLER_393_7 VPWR VGND sg13cmos5l_decap_8
XANTENNA__3291__X Tile_X0Y0_E6BEG[11] VPWR VGND sg13cmos5l_antennanp
XFILLER_104_177 VPWR VGND sg13cmos5l_fill_1
XFILLER_76_14 VPWR VGND sg13cmos5l_decap_8
XFILLER_265_107 VPWR VGND sg13cmos5l_decap_8
XFILLER_655_189 VPWR VGND sg13cmos5l_decap_8
XFILLER_630_28 VPWR VGND sg13cmos5l_decap_8
XFILLER_560_7 VPWR VGND sg13cmos5l_decap_8
XFILLER_413_63 VPWR VGND sg13cmos5l_decap_8
XFILLER_658_7 VPWR VGND sg13cmos5l_decap_8
XFILLER_670_159 VPWR VGND sg13cmos5l_decap_8
XFILLER_273_140 VPWR VGND sg13cmos5l_decap_8
XFILLER_18_117 VPWR VGND sg13cmos5l_decap_4
XFILLER_560_91 VPWR VGND sg13cmos5l_decap_8
XFILLER_273_151 VPWR VGND sg13cmos5l_fill_2
XFILLER_132_42 VPWR VGND sg13cmos5l_decap_8
XANTENNA__0139__Y AXI_M_SOC_ARLEN0 VPWR VGND sg13cmos5l_antennanp
XFILLER_422_126 VPWR VGND sg13cmos5l_decap_8
XFILLER_273_195 VPWR VGND sg13cmos5l_fill_1
XFILLER_92_35 VPWR VGND sg13cmos5l_decap_8
XFILLER_568_119 VPWR VGND sg13cmos5l_decap_8
XFILLER_489_56 VPWR VGND sg13cmos5l_decap_8
XFILLER_26_194 VPWR VGND sg13cmos5l_fill_1
XFILLER_41_142 VPWR VGND sg13cmos5l_decap_4
XFILLER_25_84 VPWR VGND sg13cmos5l_decap_8
XFILLER_148_0 VPWR VGND sg13cmos5l_decap_8
XFILLER_375_225 VPWR VGND sg13cmos5l_decap_4
XFILLER_186_125 VPWR VGND sg13cmos5l_decap_8
XFILLER_576_185 VPWR VGND sg13cmos5l_decap_8
XFILLER_186_136 VPWR VGND sg13cmos5l_fill_2
XFILLER_358_49 VPWR VGND sg13cmos5l_decap_8
XFILLER_655_14 VPWR VGND sg13cmos5l_decap_8
XANTENNA__3466__X Tile_X0Y1_FrameData_O[24] VPWR VGND sg13cmos5l_antennanp
XFILLER_315_0 VPWR VGND sg13cmos5l_decap_8
XFILLER_591_199 VPWR VGND sg13cmos5l_fill_2
XFILLER_328_185 VPWR VGND sg13cmos5l_decap_4
XFILLER_489_126 VPWR VGND sg13cmos5l_decap_8
XFILLER_41_94 VPWR VGND sg13cmos5l_fill_1
XFILLER_142_217 VPWR VGND sg13cmos5l_decap_8
XFILLER_142_228 VPWR VGND sg13cmos5l_fill_1
XFILLER_343_199 VPWR VGND sg13cmos5l_decap_8
XFILLER_307_42 VPWR VGND sg13cmos5l_decap_8
XFILLER_671_35 VPWR VGND sg13cmos5l_decap_8
XFILLER_454_70 VPWR VGND sg13cmos5l_decap_8
XFILLER_684_0 VPWR VGND sg13cmos5l_decap_8
XFILLER_646_112 VPWR VGND sg13cmos5l_decap_8
XFILLER_390_14 VPWR VGND sg13cmos5l_decap_8
XFILLER_110_114 VPWR VGND sg13cmos5l_decap_8
X_1240_ _1240_/Q Tile_X0Y1_FrameData[1] VGND VPWR Tile_X0Y9_FrameStrobe[1] latch
XFILLER_604_84 VPWR VGND sg13cmos5l_decap_8
XFILLER_500_196 VPWR VGND sg13cmos5l_decap_8
XFILLER_646_189 VPWR VGND sg13cmos5l_decap_8
XFILLER_540_28 VPWR VGND sg13cmos5l_decap_8
XFILLER_323_63 VPWR VGND sg13cmos5l_decap_8
X_1171_ _1171_/Q Tile_X0Y0_FrameData[24] VGND VPWR Tile_X0Y9_FrameStrobe[7] latch
XFILLER_2_77 VPWR VGND sg13cmos5l_decap_8
XFILLER_323_74 VPWR VGND sg13cmos5l_fill_2
X_0122_ _3180_/A _3918_/X _3919_/X _1647_/Q VPWR VGND sg13cmos5l_mux2_1
XFILLER_559_119 VPWR VGND sg13cmos5l_decap_8
XFILLER_399_56 VPWR VGND sg13cmos5l_decap_8
X_0053_ _0053_/X _4682_/X _4683_/X _1854_/Q VPWR VGND sg13cmos5l_mux2_1
X_4930_ _4930_/X Tile_X0Y9_N1END[2] Tile_X0Y9_N4END[2] _4898_/X _0081_/X _0699_/Q
+ _0698_/Q VPWR VGND sg13cmos5l_mux4_1
XFILLER_696_21 VPWR VGND sg13cmos5l_decap_8
X_4861_ _4861_/X Tile_X0Y9_W2END[2] AXI_M_SOC_RDATA2 _4905_/X _4904_/X _0821_/Q _0820_/Q
+ VPWR VGND sg13cmos5l_mux4_1
X_3812_ _3812_/X Tile_X0Y0_W2MID[1] Tile_X0Y0_W2END[7] _3853_/X _3852_/X _1081_/Q
+ _1080_/Q VPWR VGND sg13cmos5l_mux4_1
XFILLER_366_225 VPWR VGND sg13cmos5l_decap_4
XANTENNA_16 Tile_X0Y0_S4END[12] VPWR VGND sg13cmos5l_antennanp
X_4792_ _4792_/X Tile_X0Y4_W1END[0] Tile_X0Y4_WW4END[12] Tile_X0Y4_W6END[4] _4336_/X
+ _2121_/Q _2120_/Q VPWR VGND sg13cmos5l_mux4_1
XFILLER_696_98 VPWR VGND sg13cmos5l_decap_8
XFILLER_716_127 VPWR VGND sg13cmos5l_fill_1
XANTENNA_27 _3626_/A VPWR VGND sg13cmos5l_antennanp
XFILLER_629_70 VPWR VGND sg13cmos5l_decap_8
XFILLER_582_133 VPWR VGND sg13cmos5l_fill_2
XANTENNA_38 Tile_X0Y9_FrameStrobe[19] VPWR VGND sg13cmos5l_antennanp
XANTENNA_49 Tile_X0Y9_N2MID[2] VPWR VGND sg13cmos5l_antennanp
X_3743_ AXI_M_SOC_ARADDR15 Tile_X0Y9_W1END[3] Tile_X0Y9_WW4END[7] Tile_X0Y9_WW4END[15]
+ _4931_/X _0729_/Q _0728_/Q VPWR VGND sg13cmos5l_mux4_1
X_0955_ _0955_/Q Tile_X0Y0_FrameData[16] VGND VPWR Tile_X0Y9_FrameStrobe[0] latch
XFILLER_565_14 VPWR VGND sg13cmos5l_decap_8
XFILLER_192_117 VPWR VGND sg13cmos5l_decap_8
XANTENNA__3376__X Tile_X0Y2_EE4BEG[15] VPWR VGND sg13cmos5l_antennanp
XFILLER_582_166 VPWR VGND sg13cmos5l_decap_8
XFILLER_381_228 VPWR VGND sg13cmos5l_fill_1
X_3674_ _3674_/X Tile_X0Y2_WW4END[4] Tile_X0Y2_WW4END[12] Tile_X0Y2_W6END[4] _4120_/X
+ _1497_/Q _1496_/Q VPWR VGND sg13cmos5l_mux4_1
X_0886_ _0886_/Q Tile_X0Y9_FrameData[9] VGND VPWR Tile_X0Y9_FrameStrobe[6] latch
XFILLER_334_133 VPWR VGND sg13cmos5l_fill_2
XFILLER_63_0 VPWR VGND sg13cmos5l_decap_4
X_2625_ _2625_/Q Tile_X0Y6_FrameData[6] VGND VPWR Tile_X0Y9_FrameStrobe[5] latch
XFILLER_715_28 VPWR VGND sg13cmos5l_decap_8
XFILLER_133_228 VPWR VGND sg13cmos5l_fill_1
XFILLER_645_91 VPWR VGND sg13cmos5l_decap_8
XFILLER_334_188 VPWR VGND sg13cmos5l_decap_8
XFILLER_217_42 VPWR VGND sg13cmos5l_decap_8
X_2556_ _2556_/Q Tile_X0Y6_FrameData[11] VGND VPWR Tile_X0Y9_FrameStrobe[3] latch
XFILLER_581_35 VPWR VGND sg13cmos5l_decap_8
XFILLER_364_70 VPWR VGND sg13cmos5l_decap_8
XFILLER_637_112 VPWR VGND sg13cmos5l_decap_8
X_1507_ _1507_/Q Tile_X0Y2_FrameData[14] VGND VPWR Tile_X0Y9_FrameStrobe[2] latch
X_2487_ _2487_/Q Tile_X0Y6_FrameData[16] VGND VPWR Tile_X0Y9_FrameStrobe[1] latch
XFILLER_99_186 VPWR VGND sg13cmos5l_decap_8
X_4226_ _4226_/X _4195_/X _0089_/X _4194_/X Tile_X0Y0_S4END[12] _1721_/Q _1720_/Q
+ VPWR VGND sg13cmos5l_mux4_1
X_1438_ _1438_/Q Tile_X0Y2_FrameData[19] VGND VPWR Tile_X0Y9_FrameStrobe[0] latch
XFILLER_514_84 VPWR VGND sg13cmos5l_decap_8
XFILLER_637_189 VPWR VGND sg13cmos5l_fill_1
XFILLER_652_126 VPWR VGND sg13cmos5l_decap_8
XFILLER_450_28 VPWR VGND sg13cmos5l_decap_8
X_4157_ _4157_/X Tile_X0Y3_W2END[6] AXI_M_SOC_WREADY _4207_/X _4206_/X _1827_/Q _1826_/Q
+ VPWR VGND sg13cmos5l_mux4_1
XFILLER_233_63 VPWR VGND sg13cmos5l_decap_8
X_1369_ _1369_/Q Tile_X0Y1_FrameData[0] VGND VPWR Tile_X0Y9_FrameStrobe[5] latch
X_3108_ Tile_X0Y7_E6BEG[6] _4650_/X VPWR VGND sg13cmos5l_buf_1
X_4088_ _4088_/X Tile_X0Y1_W1END[0] Tile_X0Y1_W6END[8] _4005_/X _3976_/X _1389_/Q
+ _1388_/Q VPWR VGND sg13cmos5l_mux4_1
X_3039_ Tile_X0Y5_EE4BEG[14] _4402_/X VPWR VGND sg13cmos5l_buf_1
XFILLER_102_56 VPWR VGND sg13cmos5l_decap_8
XFILLER_62_16 VPWR VGND sg13cmos5l_decap_8
XFILLER_270_198 VPWR VGND sg13cmos5l_decap_8
XFILLER_357_203 VPWR VGND sg13cmos5l_decap_8
XFILLER_23_142 VPWR VGND sg13cmos5l_decap_8
XFILLER_211_210 VPWR VGND sg13cmos5l_fill_2
XFILLER_707_105 VPWR VGND sg13cmos5l_decap_8
XFILLER_412_192 VPWR VGND sg13cmos5l_decap_8
XFILLER_141_7 VPWR VGND sg13cmos5l_decap_8
XFILLER_23_186 VPWR VGND sg13cmos5l_decap_8
XFILLER_239_7 VPWR VGND sg13cmos5l_decap_8
XFILLER_178_49 VPWR VGND sg13cmos5l_decap_8
XFILLER_573_133 VPWR VGND sg13cmos5l_decap_8
XFILLER_539_70 VPWR VGND sg13cmos5l_decap_8
XFILLER_475_14 VPWR VGND sg13cmos5l_decap_8
XFILLER_183_117 VPWR VGND sg13cmos5l_fill_2
XANTENNA__3286__X Tile_X0Y0_E6BEG[6] VPWR VGND sg13cmos5l_antennanp
XFILLER_715_160 VPWR VGND sg13cmos5l_decap_8
XFILLER_406_7 VPWR VGND sg13cmos5l_decap_8
XFILLER_625_28 VPWR VGND sg13cmos5l_decap_8
XFILLER_408_63 VPWR VGND sg13cmos5l_decap_8
XFILLER_11_42 VPWR VGND sg13cmos5l_decap_8
XFILLER_124_228 VPWR VGND sg13cmos5l_fill_1
XFILLER_555_91 VPWR VGND sg13cmos5l_decap_8
XFILLER_127_42 VPWR VGND sg13cmos5l_decap_8
XFILLER_491_35 VPWR VGND sg13cmos5l_decap_8
XFILLER_274_70 VPWR VGND sg13cmos5l_decap_8
XFILLER_87_35 VPWR VGND sg13cmos5l_decap_8
XFILLER_494_140 VPWR VGND sg13cmos5l_decap_8
XFILLER_641_49 VPWR VGND sg13cmos5l_decap_8
XFILLER_424_84 VPWR VGND sg13cmos5l_decap_8
XFILLER_643_126 VPWR VGND sg13cmos5l_decap_8
XFILLER_360_28 VPWR VGND sg13cmos5l_decap_8
XFILLER_143_63 VPWR VGND sg13cmos5l_decap_8
XFILLER_246_140 VPWR VGND sg13cmos5l_decap_8
XFILLER_290_91 VPWR VGND sg13cmos5l_decap_8
XFILLER_265_0 VPWR VGND sg13cmos5l_decap_8
XFILLER_36_72 VPWR VGND sg13cmos5l_decap_8
XFILLER_410_129 VPWR VGND sg13cmos5l_decap_8
XFILLER_432_0 VPWR VGND sg13cmos5l_fill_2
XFILLER_348_203 VPWR VGND sg13cmos5l_decap_4
XFILLER_348_214 VPWR VGND sg13cmos5l_fill_1
XFILLER_403_192 VPWR VGND sg13cmos5l_decap_8
XFILLER_666_35 VPWR VGND sg13cmos5l_decap_8
XFILLER_564_133 VPWR VGND sg13cmos5l_decap_4
XFILLER_449_70 VPWR VGND sg13cmos5l_decap_8
XFILLER_159_169 VPWR VGND sg13cmos5l_decap_8
XFILLER_385_14 VPWR VGND sg13cmos5l_decap_8
XANTENNA__3196__X Tile_X0Y0_N2BEGb[4] VPWR VGND sg13cmos5l_antennanp
XFILLER_363_217 VPWR VGND sg13cmos5l_fill_2
XFILLER_713_119 VPWR VGND sg13cmos5l_decap_8
X_0740_ _0740_/Q Tile_X0Y9_FrameData[27] VGND VPWR Tile_X0Y9_FrameStrobe[2] latch
XFILLER_535_28 VPWR VGND sg13cmos5l_decap_8
X_0671_ _0671_/Q Tile_X0Y8_FrameData[0] VGND VPWR Tile_X0Y9_FrameStrobe[7] latch
XFILLER_318_63 VPWR VGND sg13cmos5l_decap_8
XFILLER_682_56 VPWR VGND sg13cmos5l_decap_8
XFILLER_318_85 VPWR VGND sg13cmos5l_fill_1
X_2410_ _2410_/Q Tile_X0Y5_FrameData[27] VGND VPWR Tile_X0Y9_FrameStrobe[7] latch
XFILLER_520_214 VPWR VGND sg13cmos5l_decap_4
XFILLER_477_118 VPWR VGND sg13cmos5l_decap_4
X_3390_ Tile_X0Y2_E2BEGb[1] _4049_/X VPWR VGND sg13cmos5l_buf_1
XFILLER_477_129 VPWR VGND sg13cmos5l_decap_4
XFILLER_184_70 VPWR VGND sg13cmos5l_decap_4
XFILLER_184_92 VPWR VGND sg13cmos5l_decap_8
X_2341_ _2341_/Q Tile_X0Y5_FrameData[0] VGND VPWR Tile_X0Y9_FrameStrobe[4] latch
X_2272_ _2272_/Q Tile_X0Y5_FrameData[5] VGND VPWR Tile_X0Y9_FrameStrobe[2] latch
XFILLER_551_49 VPWR VGND sg13cmos5l_decap_8
XFILLER_334_84 VPWR VGND sg13cmos5l_decap_8
X_4011_ _4011_/X _3987_/X _0084_/X _3986_/X Tile_X0Y0_S4END[7] _1227_/Q _1226_/Q VPWR
+ VGND sg13cmos5l_mux4_1
XFILLER_634_126 VPWR VGND sg13cmos5l_decap_8
XFILLER_96_178 VPWR VGND sg13cmos5l_decap_8
X_1223_ _1223_/Q Tile_X0Y1_FrameData[18] VGND VPWR Tile_X0Y9_FrameStrobe[1] latch
XFILLER_270_28 VPWR VGND sg13cmos5l_decap_8
XFILLER_37_223 VPWR VGND sg13cmos5l_decap_4
X_1154_ _1154_/Q Tile_X0Y0_FrameData[9] VGND VPWR Tile_X0Y9_FrameStrobe[6] latch
X_0105_ AXI_M_SOC_ARLEN4 _0933_/Q _3764_/X VPWR VGND sg13cmos5l_nor2b_1
XFILLER_587_214 VPWR VGND sg13cmos5l_fill_2
XFILLER_203_77 VPWR VGND sg13cmos5l_decap_8
X_1085_ _1085_/Q Tile_X0Y0_FrameData[14] VGND VPWR Tile_X0Y9_FrameStrobe[4] latch
XFILLER_197_209 VPWR VGND sg13cmos5l_decap_8
XFILLER_500_42 VPWR VGND sg13cmos5l_decap_8
X_4913_ _4913_/X _4457_/X _4461_/X _4465_/X _4429_/X _2373_/Q _2372_/Q VPWR VGND sg13cmos5l_mux4_1
X_4844_ _4844_/X Tile_X0Y9_N1END[0] _4896_/X AXI_M_SOC_RDATA3 AXI_M_SOC_RDATA7 _0855_/Q
+ _0854_/Q VPWR VGND sg13cmos5l_mux4_1
XFILLER_576_35 VPWR VGND sg13cmos5l_decap_8
XFILLER_359_70 VPWR VGND sg13cmos5l_decap_8
XFILLER_295_14 VPWR VGND sg13cmos5l_decap_8
X_1987_ _1987_/Q Tile_X0Y4_FrameData[2] VGND VPWR Tile_X0Y9_FrameStrobe[1] latch
X_4775_ _4775_/X _4783_/X Tile_X0Y8_W6END[3] _4782_/X _4775_/A3 _0417_/Q _0672_/Q
+ VPWR VGND sg13cmos5l_mux4_1
XFILLER_354_228 VPWR VGND sg13cmos5l_fill_1
XFILLER_20_167 VPWR VGND sg13cmos5l_fill_2
XFILLER_704_119 VPWR VGND sg13cmos5l_decap_8
X_0938_ _0938_/Q Tile_X0Y9_FrameData[29] VGND VPWR Tile_X0Y9_FrameStrobe[8] latch
X_3726_ AXI_M_SOC_WVALID Tile_X0Y3_W1END[0] Tile_X0Y3_WW4END[4] Tile_X0Y3_WW4END[12]
+ _4234_/X _1733_/Q _1732_/Q VPWR VGND sg13cmos5l_mux4_1
XFILLER_509_84 VPWR VGND sg13cmos5l_decap_8
XFILLER_570_147 VPWR VGND sg13cmos5l_decap_8
XFILLER_445_28 VPWR VGND sg13cmos5l_decap_8
XFILLER_228_63 VPWR VGND sg13cmos5l_decap_8
X_0869_ _0869_/Q Tile_X0Y9_FrameData[26] VGND VPWR Tile_X0Y9_FrameStrobe[6] latch
X_3657_ AXI_M_SOC_AWADDR18 Tile_X0Y4_WW4END[2] Tile_X0Y4_WW4END[10] Tile_X0Y4_W6END[2]
+ _4338_/X _2009_/Q _2008_/Q VPWR VGND sg13cmos5l_mux4_1
XFILLER_322_103 VPWR VGND sg13cmos5l_decap_4
XFILLER_592_56 VPWR VGND sg13cmos5l_decap_8
XFILLER_307_188 VPWR VGND sg13cmos5l_decap_8
XFILLER_106_228 VPWR VGND sg13cmos5l_fill_1
XFILLER_322_125 VPWR VGND sg13cmos5l_fill_1
X_2608_ _2608_/Q Tile_X0Y6_FrameData[23] VGND VPWR Tile_X0Y9_FrameStrobe[5] latch
XFILLER_712_196 VPWR VGND sg13cmos5l_decap_8
X_3588_ Tile_X0Y9_FrameData_O[18] Tile_X0Y9_FrameData[18] VPWR VGND sg13cmos5l_buf_1
X_2539_ _2539_/Q Tile_X0Y6_FrameData[28] VGND VPWR Tile_X0Y9_FrameStrobe[3] latch
XFILLER_87_123 VPWR VGND sg13cmos5l_decap_4
XFILLER_87_134 VPWR VGND sg13cmos5l_decap_8
XFILLER_275_213 VPWR VGND sg13cmos5l_fill_2
XFILLER_461_49 VPWR VGND sg13cmos5l_decap_8
XFILLER_244_84 VPWR VGND sg13cmos5l_decap_8
XFILLER_57_49 VPWR VGND sg13cmos5l_decap_8
XFILLER_180_28 VPWR VGND sg13cmos5l_decap_8
X_4209_ _4209_/X _4133_/X _4241_/X _4240_/X _4132_/X _1693_/Q _1692_/Q VPWR VGND sg13cmos5l_mux4_1
XFILLER_491_154 VPWR VGND sg13cmos5l_decap_8
XFILLER_189_7 VPWR VGND sg13cmos5l_decap_8
XFILLER_491_176 VPWR VGND sg13cmos5l_fill_1
XFILLER_290_227 VPWR VGND sg13cmos5l_fill_2
XFILLER_432_210 VPWR VGND sg13cmos5l_decap_4
XFILLER_389_103 VPWR VGND sg13cmos5l_fill_2
XFILLER_578_203 VPWR VGND sg13cmos5l_decap_8
XFILLER_43_204 VPWR VGND sg13cmos5l_decap_4
XFILLER_578_225 VPWR VGND sg13cmos5l_decap_4
XFILLER_113_77 VPWR VGND sg13cmos5l_fill_2
XFILLER_356_7 VPWR VGND sg13cmos5l_decap_8
XFILLER_389_147 VPWR VGND sg13cmos5l_decap_8
XFILLER_410_42 VPWR VGND sg13cmos5l_decap_8
XFILLER_593_228 VPWR VGND sg13cmos5l_fill_1
XANTENNA__2913__X Tile_X0Y8_E1BEG[1] VPWR VGND sg13cmos5l_antennanp
XFILLER_523_7 VPWR VGND sg13cmos5l_decap_8
XFILLER_486_35 VPWR VGND sg13cmos5l_decap_8
XFILLER_269_70 VPWR VGND sg13cmos5l_decap_8
XFILLER_400_162 VPWR VGND sg13cmos5l_fill_2
XFILLER_156_106 VPWR VGND sg13cmos5l_fill_1
XFILLER_7_105 VPWR VGND sg13cmos5l_decap_4
XFILLER_345_228 VPWR VGND sg13cmos5l_fill_1
XFILLER_636_49 VPWR VGND sg13cmos5l_decap_8
XFILLER_499_210 VPWR VGND sg13cmos5l_decap_4
XFILLER_419_84 VPWR VGND sg13cmos5l_decap_8
XFILLER_22_63 VPWR VGND sg13cmos5l_decap_8
XFILLER_355_28 VPWR VGND sg13cmos5l_decap_8
XFILLER_138_63 VPWR VGND sg13cmos5l_decap_8
XFILLER_502_203 VPWR VGND sg13cmos5l_decap_8
XANTENNA__3744__X AXI_M_SOC_ARADDR16 VPWR VGND sg13cmos5l_antennanp
XFILLER_703_163 VPWR VGND sg13cmos5l_decap_4
XFILLER_285_91 VPWR VGND sg13cmos5l_decap_8
XFILLER_648_207 VPWR VGND sg13cmos5l_decap_8
XFILLER_98_56 VPWR VGND sg13cmos5l_decap_8
XFILLER_78_112 VPWR VGND sg13cmos5l_decap_8
XFILLER_321_180 VPWR VGND sg13cmos5l_decap_8
XFILLER_371_49 VPWR VGND sg13cmos5l_decap_8
XFILLER_671_210 VPWR VGND sg13cmos5l_fill_2
XFILLER_382_0 VPWR VGND sg13cmos5l_decap_8
XFILLER_304_21 VPWR VGND sg13cmos5l_decap_8
XFILLER_616_137 VPWR VGND sg13cmos5l_decap_8
XFILLER_616_159 VPWR VGND sg13cmos5l_fill_2
XFILLER_281_216 VPWR VGND sg13cmos5l_fill_2
XFILLER_482_198 VPWR VGND sg13cmos5l_decap_8
XFILLER_569_203 VPWR VGND sg13cmos5l_fill_2
XFILLER_647_0 VPWR VGND sg13cmos5l_decap_8
XFILLER_601_63 VPWR VGND sg13cmos5l_decap_8
XFILLER_320_42 VPWR VGND sg13cmos5l_decap_8
XFILLER_395_117 VPWR VGND sg13cmos5l_decap_4
XFILLER_677_56 VPWR VGND sg13cmos5l_decap_8
XFILLER_63_70 VPWR VGND sg13cmos5l_fill_1
XFILLER_395_128 VPWR VGND sg13cmos5l_decap_8
X_1910_ _1910_/Q Tile_X0Y3_FrameData[19] VGND VPWR Tile_X0Y9_FrameStrobe[7] latch
XANTENNA__2823__X Tile_X0Y4_E2BEG[1] VPWR VGND sg13cmos5l_antennanp
X_2890_ Tile_X0Y6_FrameData_O[11] Tile_X0Y6_FrameData[11] VPWR VGND sg13cmos5l_buf_1
XFILLER_396_35 VPWR VGND sg13cmos5l_decap_8
XFILLER_8_21 VPWR VGND sg13cmos5l_decap_8
X_1841_ _1841_/Q Tile_X0Y3_FrameData[24] VGND VPWR Tile_X0Y9_FrameStrobe[5] latch
XFILLER_336_228 VPWR VGND sg13cmos5l_fill_1
X_4560_ _4560_/X Tile_X0Y2_W1END[0] Tile_X0Y2_WW4END[12] Tile_X0Y2_W6END[4] _4116_/X
+ _1613_/Q _1612_/Q VPWR VGND sg13cmos5l_mux4_1
XFILLER_552_125 VPWR VGND sg13cmos5l_fill_2
X_1772_ _1772_/Q Tile_X0Y3_FrameData[29] VGND VPWR Tile_X0Y9_FrameStrobe[3] latch
XFILLER_546_49 VPWR VGND sg13cmos5l_decap_8
XFILLER_8_98 VPWR VGND sg13cmos5l_decap_8
XFILLER_351_209 VPWR VGND sg13cmos5l_decap_4
X_0723_ _0723_/Q Tile_X0Y9_FrameData[12] VGND VPWR Tile_X0Y9_FrameStrobe[1] latch
X_3511_ Tile_X0Y1_E2BEG[1] _3933_/X VPWR VGND sg13cmos5l_buf_1
XFILLER_693_77 VPWR VGND sg13cmos5l_decap_8
XFILLER_265_28 VPWR VGND sg13cmos5l_decap_8
X_4491_ _4491_/X _4575_/X _4579_/X _4583_/X _4552_/X _2626_/Q _2625_/Q VPWR VGND sg13cmos5l_mux4_1
XANTENNA__3654__X AXI_M_SOC_AWADDR15 VPWR VGND sg13cmos5l_antennanp
XFILLER_170_120 VPWR VGND sg13cmos5l_fill_2
X_3442_ Tile_X0Y1_FrameData_O[0] Tile_X0Y1_FrameData[0] VPWR VGND sg13cmos5l_buf_1
XFILLER_639_207 VPWR VGND sg13cmos5l_fill_2
X_0654_ _0654_/Q Tile_X0Y8_FrameData[17] VGND VPWR Tile_X0Y9_FrameStrobe[7] latch
X_3373_ Tile_X0Y2_EE4BEG[12] _4068_/X VPWR VGND sg13cmos5l_buf_1
X_0585_ _0585_/Q Tile_X0Y8_FrameData[22] VGND VPWR Tile_X0Y9_FrameStrobe[5] latch
XFILLER_69_112 VPWR VGND sg13cmos5l_decap_8
XFILLER_170_197 VPWR VGND sg13cmos5l_decap_8
X_2324_ _2324_/Q Tile_X0Y5_FrameData[17] VGND VPWR Tile_X0Y9_FrameStrobe[4] latch
XFILLER_281_49 VPWR VGND sg13cmos5l_decap_8
XFILLER_642_70 VPWR VGND sg13cmos5l_decap_8
XFILLER_26_0 VPWR VGND sg13cmos5l_decap_8
XFILLER_214_21 VPWR VGND sg13cmos5l_decap_8
XFILLER_607_126 VPWR VGND sg13cmos5l_decap_8
X_2255_ _2255_/Q Tile_X0Y5_FrameData[22] VGND VPWR Tile_X0Y9_FrameStrobe[2] latch
XFILLER_69_189 VPWR VGND sg13cmos5l_decap_8
XFILLER_84_126 VPWR VGND sg13cmos5l_decap_8
XFILLER_473_154 VPWR VGND sg13cmos5l_decap_8
X_1206_ _1206_/Q Tile_X0Y1_FrameData[3] VGND VPWR Tile_X0Y9_FrameStrobe[0] latch
XFILLER_272_227 VPWR VGND sg13cmos5l_fill_2
X_2186_ _2186_/Q Tile_X0Y5_FrameData[27] VGND VPWR Tile_X0Y9_FrameStrobe[0] latch
XFILLER_225_110 VPWR VGND sg13cmos5l_decap_8
XFILLER_214_98 VPWR VGND sg13cmos5l_decap_8
X_1137_ _1137_/Q Tile_X0Y0_FrameData[26] VGND VPWR Tile_X0Y9_FrameStrobe[6] latch
XFILLER_511_63 VPWR VGND sg13cmos5l_decap_8
XFILLER_630_140 VPWR VGND sg13cmos5l_fill_2
XFILLER_230_42 VPWR VGND sg13cmos5l_decap_8
XFILLER_225_187 VPWR VGND sg13cmos5l_fill_1
X_1068_ _1068_/Q Tile_X0Y0_FrameData[31] VGND VPWR Tile_X0Y9_FrameStrobe[4] latch
XFILLER_575_217 VPWR VGND sg13cmos5l_decap_4
XFILLER_230_86 VPWR VGND sg13cmos5l_fill_2
XFILLER_587_56 VPWR VGND sg13cmos5l_decap_8
XFILLER_717_200 VPWR VGND sg13cmos5l_fill_1
XFILLER_717_211 VPWR VGND sg13cmos5l_decap_8
XFILLER_394_150 VPWR VGND sg13cmos5l_fill_2
X_4827_ _4827_/X Tile_X0Y9_W1END[3] Tile_X0Y9_W6END[11] _4931_/X _4895_/X _0885_/Q
+ _0884_/Q VPWR VGND sg13cmos5l_mux4_1
XFILLER_193_212 VPWR VGND sg13cmos5l_decap_8
X_4758_ _4758_/X Tile_X0Y8_WW4END[1] AXI_M_SOC_RDATA9 _4801_/X _4787_/X _0531_/Q _0530_/Q
+ VPWR VGND sg13cmos5l_mux4_1
XFILLER_456_49 VPWR VGND sg13cmos5l_decap_8
X_3709_ AXI_M_SOC_WDATA19 Tile_X0Y6_WW4END[3] Tile_X0Y6_WW4END[11] Tile_X0Y6_W6END[3]
+ _4571_/X _2521_/Q _2520_/Q VPWR VGND sg13cmos5l_mux4_1
XFILLER_175_28 VPWR VGND sg13cmos5l_decap_8
XFILLER_4_119 VPWR VGND sg13cmos5l_decap_4
X_4689_ _4689_/X _4663_/X Tile_X0Y9_N4END[9] _4662_/X _0055_/X _0205_/Q _0204_/Q VPWR
+ VGND sg13cmos5l_mux4_1
XFILLER_146_183 VPWR VGND sg13cmos5l_fill_1
XANTENNA__3564__X Tile_X0Y9_EE4BEG[10] VPWR VGND sg13cmos5l_antennanp
XFILLER_700_100 VPWR VGND sg13cmos5l_decap_8
XFILLER_104_7 VPWR VGND sg13cmos5l_decap_8
XFILLER_108_77 VPWR VGND sg13cmos5l_decap_8
XFILLER_255_94 VPWR VGND sg13cmos5l_decap_8
XFILLER_108_88 VPWR VGND sg13cmos5l_fill_1
XFILLER_449_162 VPWR VGND sg13cmos5l_fill_2
XFILLER_405_42 VPWR VGND sg13cmos5l_decap_8
XFILLER_191_49 VPWR VGND sg13cmos5l_decap_8
XFILLER_653_210 VPWR VGND sg13cmos5l_fill_2
XFILLER_552_70 VPWR VGND sg13cmos5l_decap_8
XANTENNA__2908__X Tile_X0Y6_FrameData_O[29] VPWR VGND sg13cmos5l_antennanp
XFILLER_473_7 VPWR VGND sg13cmos5l_decap_8
XFILLER_124_54 VPWR VGND sg13cmos5l_decap_8
XFILLER_84_14 VPWR VGND sg13cmos5l_decap_8
XFILLER_702_73 VPWR VGND sg13cmos5l_decap_8
XFILLER_640_7 VPWR VGND sg13cmos5l_decap_8
XFILLER_421_63 VPWR VGND sg13cmos5l_decap_8
XFILLER_83_181 VPWR VGND sg13cmos5l_decap_4
XFILLER_83_192 VPWR VGND sg13cmos5l_fill_2
XFILLER_17_63 VPWR VGND sg13cmos5l_decap_8
XFILLER_140_42 VPWR VGND sg13cmos5l_decap_8
XFILLER_377_128 VPWR VGND sg13cmos5l_fill_2
XFILLER_566_228 VPWR VGND sg13cmos5l_fill_1
XFILLER_497_56 VPWR VGND sg13cmos5l_decap_8
XFILLER_231_146 VPWR VGND sg13cmos5l_decap_8
XANTENNA__3739__X AXI_M_SOC_ARADDR11 VPWR VGND sg13cmos5l_antennanp
XFILLER_708_200 VPWR VGND sg13cmos5l_fill_2
XFILLER_231_179 VPWR VGND sg13cmos5l_decap_4
XFILLER_385_150 VPWR VGND sg13cmos5l_decap_8
XFILLER_519_166 VPWR VGND sg13cmos5l_decap_4
XFILLER_33_73 VPWR VGND sg13cmos5l_decap_8
XFILLER_130_0 VPWR VGND sg13cmos5l_decap_8
XFILLER_534_114 VPWR VGND sg13cmos5l_fill_1
XFILLER_129_139 VPWR VGND sg13cmos5l_decap_8
XFILLER_228_0 VPWR VGND sg13cmos5l_decap_8
XFILLER_366_49 VPWR VGND sg13cmos5l_decap_8
XFILLER_149_84 VPWR VGND sg13cmos5l_fill_1
XFILLER_137_161 VPWR VGND sg13cmos5l_decap_8
XFILLER_663_14 VPWR VGND sg13cmos5l_decap_8
XFILLER_688_140 VPWR VGND sg13cmos5l_decap_8
XANTENNA__3474__X Tile_X0Y1_EE4BEG[0] VPWR VGND sg13cmos5l_antennanp
XFILLER_688_173 VPWR VGND sg13cmos5l_fill_1
XFILLER_298_146 VPWR VGND sg13cmos5l_decap_4
XFILLER_597_0 VPWR VGND sg13cmos5l_decap_8
XFILLER_301_106 VPWR VGND sg13cmos5l_fill_1
XFILLER_298_179 VPWR VGND sg13cmos5l_fill_1
XFILLER_315_42 VPWR VGND sg13cmos5l_decap_8
X_0370_ _0370_/Q Tile_X0Y7_FrameData[13] VGND VPWR Tile_X0Y9_FrameStrobe[6] latch
XFILLER_462_70 VPWR VGND sg13cmos5l_decap_4
XFILLER_644_210 VPWR VGND sg13cmos5l_decap_8
XFILLER_462_81 VPWR VGND sg13cmos5l_decap_8
XANTENNA__2818__X Tile_X0Y3_E1BEG[0] VPWR VGND sg13cmos5l_antennanp
XFILLER_66_115 VPWR VGND sg13cmos5l_decap_8
X_2040_ _2040_/Q Tile_X0Y4_FrameData[13] VGND VPWR Tile_X0Y9_FrameStrobe[3] latch
XFILLER_612_84 VPWR VGND sg13cmos5l_decap_8
XFILLER_604_129 VPWR VGND sg13cmos5l_fill_1
XFILLER_81_129 VPWR VGND sg13cmos5l_decap_8
XFILLER_331_63 VPWR VGND sg13cmos5l_decap_8
XFILLER_207_154 VPWR VGND sg13cmos5l_decap_8
XFILLER_74_91 VPWR VGND sg13cmos5l_decap_8
XFILLER_688_77 VPWR VGND sg13cmos5l_decap_8
X_3991_ _3991_/X _3890_/X _4023_/X _4022_/X Tile_X0Y0_S2MID[1] _1199_/Q _1198_/Q VPWR
+ VGND sg13cmos5l_mux4_1
XANTENNA__3649__X AXI_M_SOC_AWADDR10 VPWR VGND sg13cmos5l_antennanp
X_2942_ Tile_X0Y8_E6BEG[10] _4770_/X VPWR VGND sg13cmos5l_buf_1
XFILLER_200_56 VPWR VGND sg13cmos5l_decap_8
X_2873_ Tile_X0Y6_EE4BEG[10] _4522_/X VPWR VGND sg13cmos5l_buf_1
XFILLER_525_103 VPWR VGND sg13cmos5l_fill_1
XFILLER_714_214 VPWR VGND sg13cmos5l_fill_1
XFILLER_90_90 VPWR VGND sg13cmos5l_decap_8
X_4612_ _4612_/X Tile_X0Y7_W2MID[7] AXI_M_SOC_RDATA16 _4669_/X _4668_/X _0335_/Q _0334_/Q
+ VPWR VGND sg13cmos5l_mux4_1
X_1824_ _1824_/Q Tile_X0Y3_FrameData[9] VGND VPWR Tile_X0Y9_FrameStrobe[4] latch
XFILLER_276_49 VPWR VGND sg13cmos5l_decap_8
XFILLER_637_70 VPWR VGND sg13cmos5l_decap_8
XFILLER_209_21 VPWR VGND sg13cmos5l_decap_8
XFILLER_190_204 VPWR VGND sg13cmos5l_decap_8
X_1755_ _1755_/Q Tile_X0Y3_FrameData[14] VGND VPWR Tile_X0Y9_FrameStrobe[2] latch
X_4543_ _4543_/X _4551_/X Tile_X0Y6_W6END[3] _4550_/X _4543_/A3 _2441_/Q _2696_/Q
+ VPWR VGND sg13cmos5l_mux4_1
XFILLER_573_14 VPWR VGND sg13cmos5l_decap_8
XANTENNA__3384__X Tile_X0Y2_E6BEG[7] VPWR VGND sg13cmos5l_antennanp
XFILLER_540_128 VPWR VGND sg13cmos5l_decap_8
X_0706_ _0706_/Q Tile_X0Y9_FrameData[29] VGND VPWR Tile_X0Y9_FrameStrobe[1] latch
X_1686_ _1686_/Q Tile_X0Y3_FrameData[19] VGND VPWR Tile_X0Y9_FrameStrobe[0] latch
X_4474_ _4474_/X Tile_X0Y4_W2MID[4] Tile_X0Y4_W2END[4] Tile_X0Y4_W6END[11] _4319_/X
+ _2131_/Q _2130_/Q VPWR VGND sg13cmos5l_mux4_1
XFILLER_209_98 VPWR VGND sg13cmos5l_decap_8
XFILLER_143_175 VPWR VGND sg13cmos5l_decap_8
X_0637_ _0637_/Q Tile_X0Y8_FrameData[2] VGND VPWR Tile_X0Y9_FrameStrobe[6] latch
X_3425_ Tile_X0Y4_FrameData_O[16] Tile_X0Y4_FrameData[16] VPWR VGND sg13cmos5l_buf_1
XFILLER_506_63 VPWR VGND sg13cmos5l_decap_8
XFILLER_653_91 VPWR VGND sg13cmos5l_decap_8
XFILLER_225_42 VPWR VGND sg13cmos5l_decap_8
X_3356_ Tile_X0Y2_FrameData_O[27] Tile_X0Y2_FrameData[27] VPWR VGND sg13cmos5l_buf_1
X_0568_ _0568_/Q Tile_X0Y8_FrameData[7] VGND VPWR Tile_X0Y9_FrameStrobe[4] latch
XFILLER_372_70 VPWR VGND sg13cmos5l_decap_8
XFILLER_297_190 VPWR VGND sg13cmos5l_decap_8
X_2307_ _2307_/Q Tile_X0Y5_FrameData[2] VGND VPWR Tile_X0Y9_FrameStrobe[3] latch
X_3287_ Tile_X0Y0_E6BEG[7] _3843_/X VPWR VGND sg13cmos5l_buf_1
X_0499_ _0499_/Q Tile_X0Y8_FrameData[12] VGND VPWR Tile_X0Y9_FrameStrobe[2] latch
X_2238_ _2238_/Q Tile_X0Y5_FrameData[7] VGND VPWR Tile_X0Y9_FrameStrobe[1] latch
XFILLER_57_159 VPWR VGND sg13cmos5l_decap_8
XFILLER_522_84 VPWR VGND sg13cmos5l_decap_8
XFILLER_461_157 VPWR VGND sg13cmos5l_fill_2
XFILLER_241_63 VPWR VGND sg13cmos5l_decap_8
X_2169_ _2169_/Q Tile_X0Y4_FrameData[12] VGND VPWR Tile_X0Y9_FrameStrobe[7] latch
XFILLER_54_28 VPWR VGND sg13cmos5l_decap_8
XFILLER_603_162 VPWR VGND sg13cmos5l_decap_8
XFILLER_598_77 VPWR VGND sg13cmos5l_decap_8
XFILLER_548_206 VPWR VGND sg13cmos5l_fill_2
XFILLER_13_207 VPWR VGND sg13cmos5l_fill_1
XFILLER_359_128 VPWR VGND sg13cmos5l_fill_1
XANTENNA__3559__X Tile_X0Y9_EE4BEG[5] VPWR VGND sg13cmos5l_antennanp
XFILLER_213_168 VPWR VGND sg13cmos5l_decap_8
XFILLER_110_56 VPWR VGND sg13cmos5l_decap_8
XFILLER_367_161 VPWR VGND sg13cmos5l_decap_4
XFILLER_70_49 VPWR VGND sg13cmos5l_decap_8
XFILLER_221_7 VPWR VGND sg13cmos5l_decap_8
XFILLER_319_7 VPWR VGND sg13cmos5l_decap_8
XFILLER_186_49 VPWR VGND sg13cmos5l_decap_8
XFILLER_547_70 VPWR VGND sg13cmos5l_decap_8
XFILLER_119_21 VPWR VGND sg13cmos5l_decap_8
XFILLER_181_215 VPWR VGND sg13cmos5l_decap_8
XFILLER_483_14 VPWR VGND sg13cmos5l_decap_8
XANTENNA__3294__X Tile_X0Y0_E2BEGb[2] VPWR VGND sg13cmos5l_antennanp
XFILLER_79_14 VPWR VGND sg13cmos5l_decap_8
XFILLER_685_132 VPWR VGND sg13cmos5l_fill_2
XFILLER_633_28 VPWR VGND sg13cmos5l_decap_8
XFILLER_590_7 VPWR VGND sg13cmos5l_decap_8
XFILLER_416_63 VPWR VGND sg13cmos5l_decap_8
XFILLER_688_7 VPWR VGND sg13cmos5l_decap_8
XFILLER_295_105 VPWR VGND sg13cmos5l_decap_8
XFILLER_563_91 VPWR VGND sg13cmos5l_decap_8
XFILLER_135_42 VPWR VGND sg13cmos5l_decap_8
XFILLER_0_133 VPWR VGND sg13cmos5l_fill_1
XFILLER_282_70 VPWR VGND sg13cmos5l_decap_8
XFILLER_95_35 VPWR VGND sg13cmos5l_decap_8
XFILLER_452_124 VPWR VGND sg13cmos5l_decap_8
XFILLER_432_84 VPWR VGND sg13cmos5l_decap_8
XFILLER_63_118 VPWR VGND sg13cmos5l_decap_8
XFILLER_28_84 VPWR VGND sg13cmos5l_decap_8
XFILLER_178_0 VPWR VGND sg13cmos5l_decap_8
XFILLER_151_63 VPWR VGND sg13cmos5l_decap_8
XFILLER_251_219 VPWR VGND sg13cmos5l_decap_8
XFILLER_658_14 VPWR VGND sg13cmos5l_decap_8
XFILLER_539_228 VPWR VGND sg13cmos5l_fill_1
XFILLER_345_0 VPWR VGND sg13cmos5l_decap_8
XANTENNA__3469__X Tile_X0Y1_FrameData_O[27] VPWR VGND sg13cmos5l_antennanp
XFILLER_301_77 VPWR VGND sg13cmos5l_decap_8
XFILLER_44_61 VPWR VGND sg13cmos5l_decap_8
XFILLER_301_88 VPWR VGND sg13cmos5l_fill_2
XFILLER_512_0 VPWR VGND sg13cmos5l_decap_8
XFILLER_674_35 VPWR VGND sg13cmos5l_decap_8
XFILLER_507_147 VPWR VGND sg13cmos5l_decap_8
XFILLER_457_70 VPWR VGND sg13cmos5l_fill_2
XFILLER_67_7 VPWR VGND sg13cmos5l_decap_8
XFILLER_522_106 VPWR VGND sg13cmos5l_decap_4
XFILLER_393_14 VPWR VGND sg13cmos5l_decap_8
XFILLER_176_60 VPWR VGND sg13cmos5l_fill_1
X_1540_ _1540_/Q Tile_X0Y2_FrameData[13] VGND VPWR Tile_X0Y9_FrameStrobe[3] latch
XFILLER_607_84 VPWR VGND sg13cmos5l_decap_8
XFILLER_543_28 VPWR VGND sg13cmos5l_decap_8
X_1471_ _1471_/Q Tile_X0Y2_FrameData[18] VGND VPWR Tile_X0Y9_FrameStrobe[1] latch
XFILLER_5_77 VPWR VGND sg13cmos5l_decap_8
XFILLER_326_63 VPWR VGND sg13cmos5l_decap_8
XFILLER_140_112 VPWR VGND sg13cmos5l_decap_8
XFILLER_286_105 VPWR VGND sg13cmos5l_decap_8
XFILLER_690_56 VPWR VGND sg13cmos5l_decap_8
XFILLER_473_80 VPWR VGND sg13cmos5l_fill_1
X_3210_ Tile_X0Y0_N1BEG[2] _3782_/X VPWR VGND sg13cmos5l_buf_1
X_0422_ _0422_/Q Tile_X0Y8_FrameData[25] VGND VPWR Tile_X0Y9_FrameStrobe[0] latch
X_4190_ _4190_/X AXI_M_SOC_WREADY _4223_/X _4227_/X _4206_/X _1761_/Q _1760_/Q VPWR
+ VGND sg13cmos5l_mux4_1
XFILLER_69_91 VPWR VGND sg13cmos5l_decap_8
X_3141_ Tile_X0Y7_FrameData_O[11] Tile_X0Y7_FrameData[11] VPWR VGND sg13cmos5l_buf_1
X_0353_ _0353_/Q Tile_X0Y7_FrameData[30] VGND VPWR Tile_X0Y9_FrameStrobe[6] latch
XFILLER_428_154 VPWR VGND sg13cmos5l_decap_8
XFILLER_227_216 VPWR VGND sg13cmos5l_fill_2
X_3072_ Tile_X0Y5_FrameData_O[31] Tile_X0Y5_FrameData[31] VPWR VGND sg13cmos5l_buf_1
X_0284_ _0284_/Q Tile_X0Y7_FrameData[3] VGND VPWR Tile_X0Y9_FrameStrobe[3] latch
XFILLER_699_54 VPWR VGND sg13cmos5l_decap_8
XFILLER_342_84 VPWR VGND sg13cmos5l_decap_8
XFILLER_294_193 VPWR VGND sg13cmos5l_decap_8
XANTENNA__0068__X AXI_M_SOC_WSTRB3 VPWR VGND sg13cmos5l_antennanp
X_2023_ _2023_/Q Tile_X0Y4_FrameData[30] VGND VPWR Tile_X0Y9_FrameStrobe[3] latch
XFILLER_242_208 VPWR VGND sg13cmos5l_decap_4
XFILLER_62_140 VPWR VGND sg13cmos5l_decap_8
XFILLER_568_14 VPWR VGND sg13cmos5l_decap_8
XANTENNA__3379__X Tile_X0Y2_E6BEG[2] VPWR VGND sg13cmos5l_antennanp
XFILLER_396_223 VPWR VGND sg13cmos5l_decap_4
XFILLER_211_77 VPWR VGND sg13cmos5l_decap_8
X_3974_ _3974_/X AXI_M_SOC_ARREADY _4009_/X _4013_/X _3990_/X _1261_/Q _1260_/Q VPWR
+ VGND sg13cmos5l_mux4_1
XFILLER_210_105 VPWR VGND sg13cmos5l_decap_8
XFILLER_93_0 VPWR VGND sg13cmos5l_decap_8
XFILLER_600_165 VPWR VGND sg13cmos5l_decap_8
X_2925_ Tile_X0Y8_E2BEGb[1] _4737_/X VPWR VGND sg13cmos5l_buf_1
XFILLER_349_161 VPWR VGND sg13cmos5l_decap_8
XFILLER_148_212 VPWR VGND sg13cmos5l_fill_2
XFILLER_349_183 VPWR VGND sg13cmos5l_decap_8
XFILLER_648_91 VPWR VGND sg13cmos5l_decap_8
XFILLER_364_131 VPWR VGND sg13cmos5l_fill_2
X_2856_ Tile_X0Y6_E6BEG[5] _4533_/X VPWR VGND sg13cmos5l_buf_1
XFILLER_584_35 VPWR VGND sg13cmos5l_decap_8
XFILLER_367_70 VPWR VGND sg13cmos5l_decap_8
X_1807_ _1807_/Q Tile_X0Y3_FrameData[26] VGND VPWR Tile_X0Y9_FrameStrobe[4] latch
X_2787_ Tile_X0Y3_EE4BEG[13] _4177_/X VPWR VGND sg13cmos5l_buf_1
X_4526_ _4526_/X Tile_X0Y6_WW4END[1] AXI_M_SOC_RDATA25 _4569_/X _4555_/X _2555_/Q
+ _2554_/Q VPWR VGND sg13cmos5l_mux4_1
X_1738_ _1738_/Q Tile_X0Y3_FrameData[31] VGND VPWR Tile_X0Y9_FrameStrobe[2] latch
XFILLER_517_84 VPWR VGND sg13cmos5l_decap_8
XFILLER_517_95 VPWR VGND sg13cmos5l_fill_1
XFILLER_453_28 VPWR VGND sg13cmos5l_decap_8
XFILLER_236_63 VPWR VGND sg13cmos5l_decap_8
X_4457_ _4457_/X _4424_/X _0100_/X _4423_/X _0140_/X _2225_/Q _2224_/Q VPWR VGND sg13cmos5l_mux4_1
XFILLER_49_17 VPWR VGND sg13cmos5l_decap_8
XFILLER_131_112 VPWR VGND sg13cmos5l_decap_8
X_1669_ _1669_/Q Tile_X0Y2_FrameData[12] VGND VPWR Tile_X0Y9_FrameStrobe[7] latch
XFILLER_277_105 VPWR VGND sg13cmos5l_decap_8
X_3408_ Tile_X0Y2_E1BEG[3] _4039_/X VPWR VGND sg13cmos5l_buf_1
X_4388_ _4388_/X Tile_X0Y5_WW4END[15] AXI_M_SOC_RVALID _4466_/X _4428_/X _2327_/Q
+ _2326_/Q VPWR VGND sg13cmos5l_mux4_1
X_3339_ Tile_X0Y2_FrameData_O[10] Tile_X0Y2_FrameData[10] VPWR VGND sg13cmos5l_buf_1
XFILLER_419_154 VPWR VGND sg13cmos5l_fill_1
XFILLER_292_119 VPWR VGND sg13cmos5l_decap_8
XFILLER_419_176 VPWR VGND sg13cmos5l_fill_1
XFILLER_218_227 VPWR VGND sg13cmos5l_fill_2
XFILLER_105_56 VPWR VGND sg13cmos5l_decap_8
XFILLER_252_84 VPWR VGND sg13cmos5l_decap_8
XFILLER_65_49 VPWR VGND sg13cmos5l_decap_8
XFILLER_402_21 VPWR VGND sg13cmos5l_decap_8
XFILLER_171_7 VPWR VGND sg13cmos5l_decap_8
XFILLER_269_7 VPWR VGND sg13cmos5l_decap_8
XFILLER_478_14 VPWR VGND sg13cmos5l_decap_8
XANTENNA__3289__X Tile_X0Y0_E6BEG[9] VPWR VGND sg13cmos5l_antennanp
XFILLER_588_183 VPWR VGND sg13cmos5l_fill_1
XFILLER_53_173 VPWR VGND sg13cmos5l_decap_8
XFILLER_436_7 VPWR VGND sg13cmos5l_decap_8
XFILLER_201_105 VPWR VGND sg13cmos5l_decap_8
XFILLER_14_42 VPWR VGND sg13cmos5l_decap_8
XFILLER_201_149 VPWR VGND sg13cmos5l_fill_2
XFILLER_558_91 VPWR VGND sg13cmos5l_decap_8
XANTENNA__2921__X Tile_X0Y8_E2BEG[5] VPWR VGND sg13cmos5l_antennanp
XFILLER_603_7 VPWR VGND sg13cmos5l_decap_8
XFILLER_494_35 VPWR VGND sg13cmos5l_decap_8
XFILLER_277_70 VPWR VGND sg13cmos5l_decap_8
XFILLER_355_175 VPWR VGND sg13cmos5l_decap_8
XFILLER_30_41 VPWR VGND sg13cmos5l_decap_8
XFILLER_644_49 VPWR VGND sg13cmos5l_decap_8
XFILLER_427_84 VPWR VGND sg13cmos5l_decap_8
XFILLER_370_178 VPWR VGND sg13cmos5l_fill_1
XFILLER_363_28 VPWR VGND sg13cmos5l_decap_8
XFILLER_146_63 VPWR VGND sg13cmos5l_decap_8
XFILLER_122_123 VPWR VGND sg13cmos5l_decap_8
XFILLER_293_91 VPWR VGND sg13cmos5l_decap_8
XANTENNA__3752__X AXI_M_SOC_ARADDR24 VPWR VGND sg13cmos5l_antennanp
XFILLER_268_127 VPWR VGND sg13cmos5l_decap_4
XFILLER_295_0 VPWR VGND sg13cmos5l_decap_8
XFILLER_283_119 VPWR VGND sg13cmos5l_decap_8
XFILLER_276_182 VPWR VGND sg13cmos5l_decap_4
XFILLER_462_0 VPWR VGND sg13cmos5l_decap_8
XFILLER_312_21 VPWR VGND sg13cmos5l_decap_8
XFILLER_681_190 VPWR VGND sg13cmos5l_decap_8
XFILLER_425_168 VPWR VGND sg13cmos5l_decap_8
XFILLER_669_35 VPWR VGND sg13cmos5l_decap_8
XFILLER_440_105 VPWR VGND sg13cmos5l_decap_8
XFILLER_579_161 VPWR VGND sg13cmos5l_decap_8
XFILLER_388_14 VPWR VGND sg13cmos5l_decap_8
XANTENNA__3199__X Tile_X0Y0_N2BEGb[7] VPWR VGND sg13cmos5l_antennanp
XFILLER_189_189 VPWR VGND sg13cmos5l_decap_8
X_0971_ _0971_/Q Tile_X0Y0_FrameData[0] VGND VPWR Tile_X0Y9_FrameStrobe[0] latch
XFILLER_538_28 VPWR VGND sg13cmos5l_decap_8
XFILLER_71_70 VPWR VGND sg13cmos5l_decap_8
XFILLER_685_56 VPWR VGND sg13cmos5l_decap_8
XANTENNA__2831__X Tile_X0Y6_E1BEG[0] VPWR VGND sg13cmos5l_antennanp
X_2710_ _4419_/A3 VPWR VGND sg13cmos5l_tielo
XFILLER_535_220 VPWR VGND sg13cmos5l_fill_1
X_3690_ AXI_M_SOC_WDATA0 Tile_X0Y7_WW4END[0] Tile_X0Y7_WW4END[8] Tile_X0Y7_W6END[0]
+ _4684_/X _0247_/Q _0246_/Q VPWR VGND sg13cmos5l_mux4_1
X_2641_ _2641_/Q Tile_X0Y6_FrameData[22] VGND VPWR Tile_X0Y9_FrameStrobe[6] latch
XFILLER_200_193 VPWR VGND sg13cmos5l_decap_4
XFILLER_361_112 VPWR VGND sg13cmos5l_decap_8
X_2572_ _2572_/Q Tile_X0Y6_FrameData[27] VGND VPWR Tile_X0Y9_FrameStrobe[4] latch
XFILLER_554_49 VPWR VGND sg13cmos5l_decap_8
X_4311_ _4311_/X Tile_X0Y5_W1END[3] Tile_X0Y5_W6END[7] _4466_/X _4425_/X _2433_/Q
+ _2432_/Q VPWR VGND sg13cmos5l_mux4_1
XFILLER_273_28 VPWR VGND sg13cmos5l_decap_8
X_1523_ _1523_/Q Tile_X0Y2_FrameData[30] VGND VPWR Tile_X0Y9_FrameStrobe[3] latch
XFILLER_503_161 VPWR VGND sg13cmos5l_decap_8
XFILLER_302_223 VPWR VGND sg13cmos5l_decap_4
XANTENNA__3662__X AXI_M_SOC_AWADDR23 VPWR VGND sg13cmos5l_antennanp
X_1454_ _1454_/Q Tile_X0Y2_FrameData[3] VGND VPWR Tile_X0Y9_FrameStrobe[0] latch
X_4242_ _4242_/X Tile_X0Y2_W2MID[4] Tile_X0Y2_W2END[4] Tile_X0Y2_W6END[11] _4103_/X
+ _1623_/Q _1622_/Q VPWR VGND sg13cmos5l_mux4_1
X_0405_ _0405_/Q Tile_X0Y7_FrameData[10] VGND VPWR Tile_X0Y9_FrameStrobe[7] latch
XFILLER_113_189 VPWR VGND sg13cmos5l_fill_2
X_4173_ _4173_/X Tile_X0Y3_WW4END[6] AXI_M_SOC_WREADY _4228_/X _4206_/X _1795_/Q _1794_/Q
+ VPWR VGND sg13cmos5l_mux4_1
XFILLER_206_77 VPWR VGND sg13cmos5l_decap_8
X_1385_ _1385_/Q Tile_X0Y1_FrameData[16] VGND VPWR Tile_X0Y9_FrameStrobe[6] latch
XFILLER_274_119 VPWR VGND sg13cmos5l_decap_8
XFILLER_503_42 VPWR VGND sg13cmos5l_decap_8
X_0336_ _0336_/Q Tile_X0Y7_FrameData[15] VGND VPWR Tile_X0Y9_FrameStrobe[5] latch
X_3124_ Tile_X0Y7_EE4BEG[10] _4638_/X VPWR VGND sg13cmos5l_buf_1
XFILLER_416_113 VPWR VGND sg13cmos5l_fill_1
XFILLER_650_70 VPWR VGND sg13cmos5l_decap_8
XFILLER_222_21 VPWR VGND sg13cmos5l_decap_8
XFILLER_27_129 VPWR VGND sg13cmos5l_fill_2
X_3055_ Tile_X0Y5_FrameData_O[14] Tile_X0Y5_FrameData[14] VPWR VGND sg13cmos5l_buf_1
X_0267_ _0267_/Q Tile_X0Y7_FrameData[20] VGND VPWR Tile_X0Y9_FrameStrobe[3] latch
XFILLER_431_105 VPWR VGND sg13cmos5l_decap_8
XFILLER_579_35 VPWR VGND sg13cmos5l_decap_8
X_2006_ _2006_/Q Tile_X0Y4_FrameData[15] VGND VPWR Tile_X0Y9_FrameStrobe[2] latch
XFILLER_298_14 VPWR VGND sg13cmos5l_decap_8
XFILLER_222_98 VPWR VGND sg13cmos5l_decap_8
X_0198_ _0198_/Q Tile_X0Y7_FrameData[25] VGND VPWR Tile_X0Y9_FrameStrobe[1] latch
XFILLER_448_28 VPWR VGND sg13cmos5l_decap_8
X_3957_ _3957_/X Tile_X0Y1_WW4END[6] AXI_M_SOC_ARREADY _4014_/X _3990_/X _1295_/Q
+ _1294_/Q VPWR VGND sg13cmos5l_mux4_1
XFILLER_595_56 VPWR VGND sg13cmos5l_decap_8
XANTENNA__2741__X Tile_X0Y3_UserCLKo VPWR VGND sg13cmos5l_antennanp
X_2908_ Tile_X0Y6_FrameData_O[29] Tile_X0Y6_FrameData[29] VPWR VGND sg13cmos5l_buf_1
X_3888_ _3888_/X Tile_X0Y2_W2MID[7] Tile_X0Y2_W2END[7] Tile_X0Y2_W6END[7] _4097_/X
+ _1665_/Q _1664_/Q VPWR VGND sg13cmos5l_mux4_1
XFILLER_136_215 VPWR VGND sg13cmos5l_fill_2
X_2839_ Tile_X0Y6_E2BEG[4] _4500_/X VPWR VGND sg13cmos5l_buf_1
XFILLER_352_112 VPWR VGND sg13cmos5l_decap_8
XFILLER_498_105 VPWR VGND sg13cmos5l_decap_8
XFILLER_464_49 VPWR VGND sg13cmos5l_decap_8
X_4509_ _4509_/X Tile_X0Y6_W2END[2] AXI_M_SOC_RDATA26 _4557_/X _4556_/X _2589_/Q _2588_/Q
+ VPWR VGND sg13cmos5l_mux4_1
XFILLER_352_189 VPWR VGND sg13cmos5l_fill_2
XFILLER_2_228 VPWR VGND sg13cmos5l_fill_1
XFILLER_183_28 VPWR VGND sg13cmos5l_decap_8
XANTENNA__3572__X Tile_X0Y9_FrameData_O[2] VPWR VGND sg13cmos5l_antennanp
XFILLER_104_189 VPWR VGND sg13cmos5l_fill_2
XFILLER_116_77 VPWR VGND sg13cmos5l_decap_8
XFILLER_655_168 VPWR VGND sg13cmos5l_decap_8
XFILLER_58_221 VPWR VGND sg13cmos5l_fill_1
XFILLER_386_7 VPWR VGND sg13cmos5l_decap_8
XFILLER_670_116 VPWR VGND sg13cmos5l_fill_2
XFILLER_413_42 VPWR VGND sg13cmos5l_decap_8
XFILLER_258_193 VPWR VGND sg13cmos5l_decap_8
XFILLER_560_70 VPWR VGND sg13cmos5l_decap_8
XFILLER_132_21 VPWR VGND sg13cmos5l_decap_8
XANTENNA__2916__X Tile_X0Y8_E2BEG[0] VPWR VGND sg13cmos5l_antennanp
XFILLER_553_7 VPWR VGND sg13cmos5l_decap_8
XFILLER_422_105 VPWR VGND sg13cmos5l_decap_8
XFILLER_407_179 VPWR VGND sg13cmos5l_fill_1
XFILLER_92_14 VPWR VGND sg13cmos5l_decap_8
XFILLER_489_35 VPWR VGND sg13cmos5l_decap_8
XFILLER_132_98 VPWR VGND sg13cmos5l_decap_8
XFILLER_710_84 VPWR VGND sg13cmos5l_decap_8
XFILLER_26_151 VPWR VGND sg13cmos5l_decap_8
XFILLER_26_173 VPWR VGND sg13cmos5l_decap_8
XFILLER_41_121 VPWR VGND sg13cmos5l_decap_4
XFILLER_639_49 VPWR VGND sg13cmos5l_decap_8
XFILLER_576_142 VPWR VGND sg13cmos5l_fill_1
XFILLER_25_63 VPWR VGND sg13cmos5l_decap_8
XFILLER_576_164 VPWR VGND sg13cmos5l_decap_8
XFILLER_509_209 VPWR VGND sg13cmos5l_decap_4
XFILLER_430_182 VPWR VGND sg13cmos5l_decap_8
XFILLER_358_28 VPWR VGND sg13cmos5l_decap_8
XANTENNA__3747__X AXI_M_SOC_ARADDR19 VPWR VGND sg13cmos5l_antennanp
XFILLER_328_120 VPWR VGND sg13cmos5l_fill_2
XFILLER_288_91 VPWR VGND sg13cmos5l_decap_8
XFILLER_186_159 VPWR VGND sg13cmos5l_decap_8
XFILLER_591_156 VPWR VGND sg13cmos5l_decap_4
XFILLER_328_164 VPWR VGND sg13cmos5l_decap_8
XFILLER_489_105 VPWR VGND sg13cmos5l_decap_8
XFILLER_41_73 VPWR VGND sg13cmos5l_decap_8
XFILLER_210_0 VPWR VGND sg13cmos5l_decap_8
XFILLER_678_205 VPWR VGND sg13cmos5l_fill_2
XFILLER_308_0 VPWR VGND sg13cmos5l_decap_8
XFILLER_374_49 VPWR VGND sg13cmos5l_decap_8
XFILLER_307_21 VPWR VGND sg13cmos5l_decap_8
XFILLER_671_14 VPWR VGND sg13cmos5l_decap_8
XANTENNA__3482__X Tile_X0Y1_EE4BEG[8] VPWR VGND sg13cmos5l_antennanp
XFILLER_497_182 VPWR VGND sg13cmos5l_decap_8
XFILLER_677_0 VPWR VGND sg13cmos5l_decap_8
XFILLER_604_63 VPWR VGND sg13cmos5l_decap_8
XFILLER_500_175 VPWR VGND sg13cmos5l_decap_8
XFILLER_646_168 VPWR VGND sg13cmos5l_decap_8
XFILLER_661_105 VPWR VGND sg13cmos5l_decap_8
XFILLER_323_42 VPWR VGND sg13cmos5l_decap_8
XFILLER_2_56 VPWR VGND sg13cmos5l_decap_8
X_1170_ _1170_/Q Tile_X0Y0_FrameData[25] VGND VPWR Tile_X0Y9_FrameStrobe[7] latch
XFILLER_470_70 VPWR VGND sg13cmos5l_decap_8
XFILLER_264_130 VPWR VGND sg13cmos5l_decap_4
X_0121_ _3181_/A _3916_/X _3917_/X _1644_/Q VPWR VGND sg13cmos5l_mux2_1
XANTENNA__2826__X Tile_X0Y4_E2BEG[4] VPWR VGND sg13cmos5l_antennanp
XFILLER_323_97 VPWR VGND sg13cmos5l_decap_8
XFILLER_413_105 VPWR VGND sg13cmos5l_fill_2
XFILLER_399_35 VPWR VGND sg13cmos5l_decap_8
X_0052_ AXI_M_SOC_AWBURST0 _0938_/Q _3682_/X VPWR VGND sg13cmos5l_or2_1
XFILLER_602_227 VPWR VGND sg13cmos5l_fill_2
XFILLER_620_84 VPWR VGND sg13cmos5l_decap_8
X_4860_ _4860_/X Tile_X0Y9_W2END[3] AXI_M_SOC_RDATA3 _4907_/X _4906_/X _0823_/Q _0822_/Q
+ VPWR VGND sg13cmos5l_mux4_1
XFILLER_549_49 VPWR VGND sg13cmos5l_decap_8
XFILLER_32_132 VPWR VGND sg13cmos5l_decap_4
XFILLER_82_91 VPWR VGND sg13cmos5l_decap_8
X_3811_ _3811_/X Tile_X0Y0_W2MID[0] _3853_/X _3852_/X _3860_/X _1083_/Q _1082_/Q VPWR
+ VGND sg13cmos5l_mux4_1
XFILLER_696_77 VPWR VGND sg13cmos5l_decap_8
XFILLER_716_117 VPWR VGND sg13cmos5l_fill_2
X_4791_ _4791_/X _4707_/X Tile_X0Y9_N2MID[3] _4819_/X _4706_/X _0433_/Q _0432_/Q VPWR
+ VGND sg13cmos5l_mux4_1
XFILLER_582_112 VPWR VGND sg13cmos5l_decap_8
XANTENNA_17 Tile_X0Y0_S4END[12] VPWR VGND sg13cmos5l_antennanp
XFILLER_177_148 VPWR VGND sg13cmos5l_fill_1
XANTENNA__3657__X AXI_M_SOC_AWADDR18 VPWR VGND sg13cmos5l_antennanp
XANTENNA_28 Tile_X0Y9_FrameStrobe[10] VPWR VGND sg13cmos5l_antennanp
XFILLER_198_91 VPWR VGND sg13cmos5l_decap_8
XANTENNA_39 Tile_X0Y9_FrameStrobe[9] VPWR VGND sg13cmos5l_antennanp
X_3742_ AXI_M_SOC_ARADDR14 Tile_X0Y9_W1END[2] Tile_X0Y9_WW4END[6] Tile_X0Y9_WW4END[14]
+ _4930_/X _0731_/Q _0730_/Q VPWR VGND sg13cmos5l_mux4_1
X_0954_ _0954_/Q Tile_X0Y0_FrameData[17] VGND VPWR Tile_X0Y9_FrameStrobe[0] latch
XFILLER_381_218 VPWR VGND sg13cmos5l_fill_1
XFILLER_319_186 VPWR VGND sg13cmos5l_decap_8
X_3673_ _3673_/X Tile_X0Y2_WW4END[3] Tile_X0Y2_WW4END[11] Tile_X0Y2_W6END[3] _4119_/X
+ _1499_/Q _1498_/Q VPWR VGND sg13cmos5l_mux4_1
XFILLER_334_112 VPWR VGND sg13cmos5l_decap_8
X_0885_ _0885_/Q Tile_X0Y9_FrameData[10] VGND VPWR Tile_X0Y9_FrameStrobe[6] latch
XFILLER_523_223 VPWR VGND sg13cmos5l_decap_4
X_2624_ _2624_/Q Tile_X0Y6_FrameData[7] VGND VPWR Tile_X0Y9_FrameStrobe[5] latch
XFILLER_334_156 VPWR VGND sg13cmos5l_decap_8
XFILLER_284_49 VPWR VGND sg13cmos5l_decap_8
XFILLER_645_70 VPWR VGND sg13cmos5l_decap_8
XFILLER_56_0 VPWR VGND sg13cmos5l_fill_1
XFILLER_217_21 VPWR VGND sg13cmos5l_decap_8
XFILLER_581_14 VPWR VGND sg13cmos5l_decap_8
XFILLER_99_121 VPWR VGND sg13cmos5l_fill_1
X_2555_ _2555_/Q Tile_X0Y6_FrameData[12] VGND VPWR Tile_X0Y9_FrameStrobe[3] latch
XFILLER_495_119 VPWR VGND sg13cmos5l_decap_8
XANTENNA__3392__X Tile_X0Y2_E2BEGb[3] VPWR VGND sg13cmos5l_antennanp
X_1506_ _1506_/Q Tile_X0Y2_FrameData[15] VGND VPWR Tile_X0Y9_FrameStrobe[2] latch
XFILLER_217_98 VPWR VGND sg13cmos5l_fill_1
X_2486_ _2486_/Q Tile_X0Y6_FrameData[17] VGND VPWR Tile_X0Y9_FrameStrobe[1] latch
XFILLER_101_104 VPWR VGND sg13cmos5l_decap_8
X_4225_ _4225_/X _4203_/X _0046_/X _4202_/X Tile_X0Y0_S4END[15] _1723_/Q _1722_/Q
+ VPWR VGND sg13cmos5l_mux4_1
XFILLER_514_63 VPWR VGND sg13cmos5l_decap_8
X_1437_ _1437_/Q Tile_X0Y2_FrameData[20] VGND VPWR Tile_X0Y9_FrameStrobe[0] latch
XFILLER_652_105 VPWR VGND sg13cmos5l_decap_8
XFILLER_661_91 VPWR VGND sg13cmos5l_decap_8
XFILLER_233_42 VPWR VGND sg13cmos5l_decap_8
X_1368_ _1368_/Q Tile_X0Y1_FrameData[1] VGND VPWR Tile_X0Y9_FrameStrobe[5] latch
X_4156_ _4156_/X Tile_X0Y3_W2END[7] AXI_M_SOC_BVALID _4205_/X _4204_/X _1829_/Q _1828_/Q
+ VPWR VGND sg13cmos5l_mux4_1
XFILLER_380_70 VPWR VGND sg13cmos5l_decap_8
X_0319_ _0319_/Q Tile_X0Y7_FrameData[0] VGND VPWR Tile_X0Y9_FrameStrobe[4] latch
X_3107_ Tile_X0Y7_E6BEG[5] _4649_/X VPWR VGND sg13cmos5l_buf_1
X_1299_ _1299_/Q Tile_X0Y1_FrameData[6] VGND VPWR Tile_X0Y9_FrameStrobe[3] latch
X_4087_ _4087_/X _4095_/X Tile_X0Y2_W6END[3] _4094_/X _4087_/A3 _1427_/Q _1674_/Q
+ VPWR VGND sg13cmos5l_mux4_1
X_3038_ Tile_X0Y5_EE4BEG[13] _4401_/X VPWR VGND sg13cmos5l_buf_1
XFILLER_270_133 VPWR VGND sg13cmos5l_decap_8
XFILLER_530_84 VPWR VGND sg13cmos5l_decap_4
XFILLER_102_35 VPWR VGND sg13cmos5l_decap_8
XFILLER_270_155 VPWR VGND sg13cmos5l_decap_8
XFILLER_459_49 VPWR VGND sg13cmos5l_decap_8
XFILLER_412_171 VPWR VGND sg13cmos5l_decap_8
XFILLER_168_115 VPWR VGND sg13cmos5l_decap_8
XFILLER_178_28 VPWR VGND sg13cmos5l_decap_8
XFILLER_573_112 VPWR VGND sg13cmos5l_decap_8
XANTENNA__3567__X Tile_X0Y9_EE4BEG[13] VPWR VGND sg13cmos5l_antennanp
XFILLER_134_7 VPWR VGND sg13cmos5l_decap_8
XFILLER_372_218 VPWR VGND sg13cmos5l_fill_1
XFILLER_573_189 VPWR VGND sg13cmos5l_decap_8
XFILLER_176_181 VPWR VGND sg13cmos5l_decap_8
XFILLER_301_7 VPWR VGND sg13cmos5l_decap_8
XFILLER_11_21 VPWR VGND sg13cmos5l_decap_8
XFILLER_408_42 VPWR VGND sg13cmos5l_decap_8
XFILLER_194_49 VPWR VGND sg13cmos5l_decap_8
XFILLER_555_70 VPWR VGND sg13cmos5l_decap_8
XFILLER_325_178 VPWR VGND sg13cmos5l_decap_8
XFILLER_127_21 VPWR VGND sg13cmos5l_decap_8
XFILLER_491_14 VPWR VGND sg13cmos5l_decap_8
XFILLER_486_119 VPWR VGND sg13cmos5l_decap_8
XFILLER_87_14 VPWR VGND sg13cmos5l_decap_8
XFILLER_705_84 VPWR VGND sg13cmos5l_decap_8
XFILLER_670_7 VPWR VGND sg13cmos5l_decap_8
XFILLER_641_28 VPWR VGND sg13cmos5l_decap_8
XFILLER_424_63 VPWR VGND sg13cmos5l_decap_8
XFILLER_643_105 VPWR VGND sg13cmos5l_decap_8
XFILLER_571_91 VPWR VGND sg13cmos5l_decap_8
XFILLER_143_42 VPWR VGND sg13cmos5l_decap_8
XFILLER_494_196 VPWR VGND sg13cmos5l_decap_8
XFILLER_290_70 VPWR VGND sg13cmos5l_decap_8
XFILLER_651_182 VPWR VGND sg13cmos5l_decap_8
XFILLER_36_51 VPWR VGND sg13cmos5l_decap_8
XFILLER_61_216 VPWR VGND sg13cmos5l_fill_1
XFILLER_440_84 VPWR VGND sg13cmos5l_decap_8
XFILLER_160_0 VPWR VGND sg13cmos5l_decap_8
XFILLER_258_0 VPWR VGND sg13cmos5l_decap_8
XFILLER_36_95 VPWR VGND sg13cmos5l_fill_1
XFILLER_369_49 VPWR VGND sg13cmos5l_decap_8
XFILLER_549_153 VPWR VGND sg13cmos5l_decap_4
XFILLER_549_175 VPWR VGND sg13cmos5l_decap_8
XFILLER_666_14 VPWR VGND sg13cmos5l_decap_8
XFILLER_564_112 VPWR VGND sg13cmos5l_decap_8
XFILLER_425_0 VPWR VGND sg13cmos5l_decap_8
XFILLER_159_148 VPWR VGND sg13cmos5l_decap_8
XANTENNA__3477__X Tile_X0Y1_EE4BEG[3] VPWR VGND sg13cmos5l_antennanp
XFILLER_316_101 VPWR VGND sg13cmos5l_decap_8
XFILLER_316_123 VPWR VGND sg13cmos5l_fill_2
XFILLER_168_94 VPWR VGND sg13cmos5l_decap_8
XFILLER_318_42 VPWR VGND sg13cmos5l_decap_8
X_0670_ _0670_/Q Tile_X0Y8_FrameData[1] VGND VPWR Tile_X0Y9_FrameStrobe[7] latch
XFILLER_682_35 VPWR VGND sg13cmos5l_decap_8
XFILLER_520_226 VPWR VGND sg13cmos5l_fill_2
X_2340_ _2340_/Q Tile_X0Y5_FrameData[1] VGND VPWR Tile_X0Y9_FrameStrobe[4] latch
XFILLER_615_84 VPWR VGND sg13cmos5l_decap_8
XFILLER_96_135 VPWR VGND sg13cmos5l_fill_2
X_2271_ _2271_/Q Tile_X0Y5_FrameData[6] VGND VPWR Tile_X0Y9_FrameStrobe[2] latch
XFILLER_551_28 VPWR VGND sg13cmos5l_decap_8
XFILLER_334_63 VPWR VGND sg13cmos5l_decap_8
XFILLER_284_203 VPWR VGND sg13cmos5l_fill_1
XFILLER_634_105 VPWR VGND sg13cmos5l_decap_8
XFILLER_96_157 VPWR VGND sg13cmos5l_fill_1
XFILLER_481_91 VPWR VGND sg13cmos5l_decap_8
X_1222_ _1222_/Q Tile_X0Y1_FrameData[19] VGND VPWR Tile_X0Y9_FrameStrobe[1] latch
X_4010_ _4010_/X _3985_/X _0095_/X _3984_/X Tile_X0Y0_S4END[6] _1229_/Q _1228_/Q VPWR
+ VGND sg13cmos5l_mux4_1
XFILLER_485_196 VPWR VGND sg13cmos5l_decap_4
XFILLER_237_130 VPWR VGND sg13cmos5l_decap_4
X_1153_ _1153_/Q Tile_X0Y0_FrameData[10] VGND VPWR Tile_X0Y9_FrameStrobe[6] latch
XFILLER_441_211 VPWR VGND sg13cmos5l_decap_8
XFILLER_203_56 VPWR VGND sg13cmos5l_decap_8
X_0104_ _3190_/A _3796_/X _3797_/X _1145_/Q VPWR VGND sg13cmos5l_mux2_1
XFILLER_642_182 VPWR VGND sg13cmos5l_decap_8
X_1084_ _1084_/Q Tile_X0Y0_FrameData[15] VGND VPWR Tile_X0Y9_FrameStrobe[4] latch
XFILLER_350_84 VPWR VGND sg13cmos5l_decap_8
XFILLER_500_21 VPWR VGND sg13cmos5l_decap_8
X_4912_ _4912_/X Tile_X0Y5_W1END[2] Tile_X0Y5_WW4END[14] Tile_X0Y5_W6END[6] _4453_/X
+ _2373_/Q _2372_/Q VPWR VGND sg13cmos5l_mux4_1
XFILLER_279_49 VPWR VGND sg13cmos5l_decap_8
XFILLER_252_199 VPWR VGND sg13cmos5l_decap_8
X_4843_ _4843_/X _4923_/X _4927_/X _4931_/X _4900_/X _0858_/Q _0857_/Q VPWR VGND sg13cmos5l_mux4_1
XFILLER_576_14 VPWR VGND sg13cmos5l_decap_8
XFILLER_500_98 VPWR VGND sg13cmos5l_decap_8
XFILLER_555_112 VPWR VGND sg13cmos5l_decap_4
XANTENNA__3387__X Tile_X0Y2_E6BEG[10] VPWR VGND sg13cmos5l_antennanp
X_4774_ _4774_/X _4781_/X Tile_X0Y8_W6END[2] _4780_/X _4774_/A3 _0419_/Q _0418_/Q
+ VPWR VGND sg13cmos5l_mux4_1
X_1986_ _1986_/Q Tile_X0Y4_FrameData[3] VGND VPWR Tile_X0Y9_FrameStrobe[1] latch
XFILLER_165_118 VPWR VGND sg13cmos5l_fill_1
XFILLER_555_189 VPWR VGND sg13cmos5l_decap_4
X_3725_ _3725_/X Tile_X0Y3_WW4END[2] Tile_X0Y3_WW4END[10] Tile_X0Y3_W6END[10] _4232_/X
+ _1737_/Q _1736_/Q VPWR VGND sg13cmos5l_mux4_1
X_0937_ _0937_/Q Tile_X0Y9_FrameData[28] VGND VPWR Tile_X0Y9_FrameStrobe[8] latch
XFILLER_570_126 VPWR VGND sg13cmos5l_decap_8
XFILLER_509_63 VPWR VGND sg13cmos5l_decap_8
XFILLER_9_191 VPWR VGND sg13cmos5l_fill_1
XFILLER_656_91 VPWR VGND sg13cmos5l_decap_8
XFILLER_228_42 VPWR VGND sg13cmos5l_decap_8
X_3656_ AXI_M_SOC_AWADDR17 Tile_X0Y4_WW4END[1] Tile_X0Y4_WW4END[9] Tile_X0Y4_W6END[1]
+ _4337_/X _2011_/Q _2010_/Q VPWR VGND sg13cmos5l_mux4_1
X_0868_ _0868_/Q Tile_X0Y9_FrameData[27] VGND VPWR Tile_X0Y9_FrameStrobe[6] latch
XFILLER_592_35 VPWR VGND sg13cmos5l_decap_8
XFILLER_375_70 VPWR VGND sg13cmos5l_fill_2
XFILLER_228_86 VPWR VGND sg13cmos5l_fill_1
XFILLER_173_184 VPWR VGND sg13cmos5l_decap_8
X_2607_ _2607_/Q Tile_X0Y6_FrameData[24] VGND VPWR Tile_X0Y9_FrameStrobe[5] latch
XFILLER_712_175 VPWR VGND sg13cmos5l_decap_8
X_3587_ Tile_X0Y9_FrameData_O[17] Tile_X0Y9_FrameData[17] VPWR VGND sg13cmos5l_buf_1
X_0799_ _0799_/Q Tile_X0Y9_FrameData[0] VGND VPWR Tile_X0Y9_FrameStrobe[3] latch
X_2538_ _2538_/Q Tile_X0Y6_FrameData[29] VGND VPWR Tile_X0Y9_FrameStrobe[3] latch
XFILLER_87_102 VPWR VGND sg13cmos5l_decap_8
XFILLER_461_28 VPWR VGND sg13cmos5l_decap_8
XFILLER_244_63 VPWR VGND sg13cmos5l_decap_8
XFILLER_409_219 VPWR VGND sg13cmos5l_decap_8
X_2469_ _2469_/Q Tile_X0Y6_FrameData[2] VGND VPWR Tile_X0Y9_FrameStrobe[0] latch
XFILLER_625_105 VPWR VGND sg13cmos5l_decap_8
XFILLER_57_28 VPWR VGND sg13cmos5l_decap_8
X_4208_ _4208_/X _4139_/X _4247_/X _4246_/X _4138_/X _1687_/Q _1686_/Q VPWR VGND sg13cmos5l_mux4_1
XFILLER_491_133 VPWR VGND sg13cmos5l_decap_8
XFILLER_625_149 VPWR VGND sg13cmos5l_fill_2
XFILLER_290_206 VPWR VGND sg13cmos5l_decap_8
X_4139_ _4139_/X Tile_X0Y4_W2MID[2] Tile_X0Y4_W2END[2] Tile_X0Y4_W6END[2] _4316_/X
+ _2163_/Q _2162_/Q VPWR VGND sg13cmos5l_mux4_1
XFILLER_640_119 VPWR VGND sg13cmos5l_decap_8
XFILLER_113_56 VPWR VGND sg13cmos5l_decap_8
XFILLER_43_227 VPWR VGND sg13cmos5l_fill_2
XFILLER_410_21 VPWR VGND sg13cmos5l_decap_8
XFILLER_73_49 VPWR VGND sg13cmos5l_decap_8
XFILLER_251_7 VPWR VGND sg13cmos5l_decap_8
XFILLER_243_188 VPWR VGND sg13cmos5l_decap_4
XFILLER_189_49 VPWR VGND sg13cmos5l_decap_8
XFILLER_349_7 VPWR VGND sg13cmos5l_decap_8
XFILLER_196_221 VPWR VGND sg13cmos5l_decap_8
XFILLER_486_14 VPWR VGND sg13cmos5l_decap_8
XANTENNA__3297__X Tile_X0Y0_E2BEGb[5] VPWR VGND sg13cmos5l_antennanp
XFILLER_11_102 VPWR VGND sg13cmos5l_decap_4
XFILLER_400_141 VPWR VGND sg13cmos5l_decap_8
XFILLER_516_7 VPWR VGND sg13cmos5l_decap_8
XFILLER_400_185 VPWR VGND sg13cmos5l_decap_8
XFILLER_636_28 VPWR VGND sg13cmos5l_decap_8
XFILLER_561_126 VPWR VGND sg13cmos5l_decap_8
XFILLER_419_63 VPWR VGND sg13cmos5l_decap_8
XFILLER_22_42 VPWR VGND sg13cmos5l_decap_8
XFILLER_566_91 VPWR VGND sg13cmos5l_decap_8
XFILLER_138_42 VPWR VGND sg13cmos5l_decap_8
XFILLER_285_70 VPWR VGND sg13cmos5l_decap_8
XFILLER_164_162 VPWR VGND sg13cmos5l_decap_4
XFILLER_98_35 VPWR VGND sg13cmos5l_decap_8
XFILLER_0_2 VPWR VGND sg13cmos5l_fill_1
XFILLER_652_49 VPWR VGND sg13cmos5l_decap_8
XFILLER_435_84 VPWR VGND sg13cmos5l_decap_8
XFILLER_371_28 VPWR VGND sg13cmos5l_decap_8
XFILLER_154_63 VPWR VGND sg13cmos5l_decap_4
XFILLER_78_157 VPWR VGND sg13cmos5l_decap_8
XFILLER_482_133 VPWR VGND sg13cmos5l_decap_8
XFILLER_375_0 VPWR VGND sg13cmos5l_decap_8
XFILLER_281_206 VPWR VGND sg13cmos5l_fill_2
XFILLER_482_177 VPWR VGND sg13cmos5l_decap_8
XFILLER_451_83 VPWR VGND sg13cmos5l_decap_4
XFILLER_304_77 VPWR VGND sg13cmos5l_decap_4
XFILLER_219_174 VPWR VGND sg13cmos5l_decap_8
XFILLER_631_119 VPWR VGND sg13cmos5l_decap_4
XFILLER_219_185 VPWR VGND sg13cmos5l_fill_2
XFILLER_601_42 VPWR VGND sg13cmos5l_decap_8
XFILLER_320_21 VPWR VGND sg13cmos5l_decap_8
XFILLER_542_0 VPWR VGND sg13cmos5l_decap_8
XFILLER_601_97 VPWR VGND sg13cmos5l_fill_2
XFILLER_234_199 VPWR VGND sg13cmos5l_fill_2
XFILLER_677_35 VPWR VGND sg13cmos5l_decap_8
XFILLER_388_170 VPWR VGND sg13cmos5l_decap_8
XFILLER_396_14 VPWR VGND sg13cmos5l_decap_8
XFILLER_187_221 VPWR VGND sg13cmos5l_decap_8
XFILLER_97_7 VPWR VGND sg13cmos5l_decap_8
XFILLER_63_93 VPWR VGND sg13cmos5l_decap_4
X_1840_ _1840_/Q Tile_X0Y3_FrameData[25] VGND VPWR Tile_X0Y9_FrameStrobe[5] latch
XANTENNA__3000__X Tile_X0Y5_E2BEG[3] VPWR VGND sg13cmos5l_antennanp
XFILLER_147_118 VPWR VGND sg13cmos5l_fill_2
XFILLER_546_28 VPWR VGND sg13cmos5l_decap_8
XFILLER_8_77 VPWR VGND sg13cmos5l_decap_8
X_1771_ _1771_/Q Tile_X0Y3_FrameData[30] VGND VPWR Tile_X0Y9_FrameStrobe[3] latch
XFILLER_698_119 VPWR VGND sg13cmos5l_decap_8
XFILLER_693_56 VPWR VGND sg13cmos5l_decap_8
X_3510_ Tile_X0Y1_E2BEG[0] _3932_/X VPWR VGND sg13cmos5l_buf_1
X_0722_ _0722_/Q Tile_X0Y9_FrameData[13] VGND VPWR Tile_X0Y9_FrameStrobe[1] latch
X_4490_ _4490_/X Tile_X0Y6_W1END[3] Tile_X0Y6_WW4END[15] Tile_X0Y6_W6END[7] _4571_/X
+ _2626_/Q _2625_/Q VPWR VGND sg13cmos5l_mux4_1
XFILLER_155_162 VPWR VGND sg13cmos5l_decap_4
XFILLER_195_92 VPWR VGND sg13cmos5l_fill_1
X_3441_ Tile_X0Y1_UserCLKo Tile_X0Y1_UserCLK VPWR VGND sg13cmos5l_buf_1
X_0653_ _0653_/Q Tile_X0Y8_FrameData[18] VGND VPWR Tile_X0Y9_FrameStrobe[7] latch
XFILLER_560_181 VPWR VGND sg13cmos5l_decap_8
XFILLER_560_192 VPWR VGND sg13cmos5l_fill_1
X_0584_ _0584_/Q Tile_X0Y8_FrameData[23] VGND VPWR Tile_X0Y9_FrameStrobe[5] latch
X_3372_ Tile_X0Y2_EE4BEG[11] _4067_/X VPWR VGND sg13cmos5l_buf_1
XFILLER_562_49 VPWR VGND sg13cmos5l_decap_8
XFILLER_345_84 VPWR VGND sg13cmos5l_decap_8
XFILLER_170_187 VPWR VGND sg13cmos5l_fill_2
X_2323_ _2323_/Q Tile_X0Y5_FrameData[18] VGND VPWR Tile_X0Y9_FrameStrobe[4] latch
XFILLER_458_163 VPWR VGND sg13cmos5l_decap_8
XFILLER_281_28 VPWR VGND sg13cmos5l_decap_8
XANTENNA__3670__X AXI_M_SOC_AWADDR31 VPWR VGND sg13cmos5l_antennanp
XFILLER_69_168 VPWR VGND sg13cmos5l_decap_8
XFILLER_84_105 VPWR VGND sg13cmos5l_decap_8
X_2254_ _2254_/Q Tile_X0Y5_FrameData[23] VGND VPWR Tile_X0Y9_FrameStrobe[2] latch
XFILLER_473_144 VPWR VGND sg13cmos5l_fill_2
XFILLER_19_0 VPWR VGND sg13cmos5l_decap_8
X_1205_ _1205_/Q Tile_X0Y1_FrameData[4] VGND VPWR Tile_X0Y9_FrameStrobe[0] latch
XFILLER_272_217 VPWR VGND sg13cmos5l_fill_2
XFILLER_214_77 VPWR VGND sg13cmos5l_decap_8
X_2185_ _2185_/Q Tile_X0Y5_FrameData[28] VGND VPWR Tile_X0Y9_FrameStrobe[0] latch
XFILLER_473_188 VPWR VGND sg13cmos5l_decap_4
XFILLER_414_211 VPWR VGND sg13cmos5l_decap_4
XFILLER_511_42 VPWR VGND sg13cmos5l_decap_8
XFILLER_92_160 VPWR VGND sg13cmos5l_fill_2
X_1136_ _1136_/Q Tile_X0Y0_FrameData[27] VGND VPWR Tile_X0Y9_FrameStrobe[6] latch
XFILLER_230_21 VPWR VGND sg13cmos5l_decap_8
XFILLER_240_103 VPWR VGND sg13cmos5l_decap_8
X_1067_ _1067_/Q Tile_X0Y0_FrameData[0] VGND VPWR Tile_X0Y9_FrameStrobe[3] latch
XFILLER_587_35 VPWR VGND sg13cmos5l_decap_8
XFILLER_178_210 VPWR VGND sg13cmos5l_decap_8
XFILLER_240_158 VPWR VGND sg13cmos5l_decap_8
XFILLER_178_221 VPWR VGND sg13cmos5l_fill_1
XFILLER_379_181 VPWR VGND sg13cmos5l_decap_4
X_4826_ _4826_/X Tile_X0Y9_W1END[2] Tile_X0Y9_W6END[10] _4930_/X _4894_/X _0887_/Q
+ _0886_/Q VPWR VGND sg13cmos5l_mux4_1
XFILLER_456_28 VPWR VGND sg13cmos5l_decap_8
X_4757_ _4757_/X Tile_X0Y8_WW4END[2] AXI_M_SOC_RDATA10 _4802_/X _4789_/X _0533_/Q
+ _0532_/Q VPWR VGND sg13cmos5l_mux4_1
XFILLER_239_63 VPWR VGND sg13cmos5l_decap_8
X_1969_ _1969_/Q Tile_X0Y4_FrameData[20] VGND VPWR Tile_X0Y9_FrameStrobe[1] latch
X_3708_ AXI_M_SOC_WDATA18 Tile_X0Y6_WW4END[2] Tile_X0Y6_WW4END[10] Tile_X0Y6_W6END[2]
+ _4570_/X _2523_/Q _2522_/Q VPWR VGND sg13cmos5l_mux4_1
XFILLER_146_162 VPWR VGND sg13cmos5l_decap_8
X_4688_ _4688_/X _4661_/X Tile_X0Y9_N4END[8] _4660_/X _0056_/X _0207_/Q _0206_/Q VPWR
+ VGND sg13cmos5l_mux4_1
XFILLER_496_203 VPWR VGND sg13cmos5l_decap_8
X_3639_ AXI_M_SOC_AWADDR0 Tile_X0Y5_WW4END[0] Tile_X0Y5_WW4END[8] Tile_X0Y5_W6END[0]
+ _4451_/X _2271_/Q _2270_/Q VPWR VGND sg13cmos5l_mux4_1
XFILLER_697_185 VPWR VGND sg13cmos5l_decap_8
XFILLER_108_56 VPWR VGND sg13cmos5l_decap_8
XFILLER_472_49 VPWR VGND sg13cmos5l_decap_8
XFILLER_700_156 VPWR VGND sg13cmos5l_fill_2
XFILLER_449_141 VPWR VGND sg13cmos5l_decap_8
XFILLER_405_21 VPWR VGND sg13cmos5l_decap_8
XFILLER_310_118 VPWR VGND sg13cmos5l_decap_8
XFILLER_68_49 VPWR VGND sg13cmos5l_decap_8
XFILLER_248_203 VPWR VGND sg13cmos5l_decap_8
XFILLER_191_28 VPWR VGND sg13cmos5l_decap_8
XFILLER_248_225 VPWR VGND sg13cmos5l_decap_4
XANTENNA__3580__X Tile_X0Y9_FrameData_O[10] VPWR VGND sg13cmos5l_antennanp
XFILLER_299_7 VPWR VGND sg13cmos5l_decap_8
XFILLER_124_33 VPWR VGND sg13cmos5l_decap_8
XFILLER_464_133 VPWR VGND sg13cmos5l_fill_1
XFILLER_702_52 VPWR VGND sg13cmos5l_decap_8
XFILLER_464_177 VPWR VGND sg13cmos5l_fill_1
XFILLER_263_228 VPWR VGND sg13cmos5l_fill_1
XFILLER_613_119 VPWR VGND sg13cmos5l_fill_2
XFILLER_466_7 VPWR VGND sg13cmos5l_decap_8
XFILLER_90_108 VPWR VGND sg13cmos5l_fill_2
XFILLER_421_42 VPWR VGND sg13cmos5l_decap_8
XFILLER_216_133 VPWR VGND sg13cmos5l_fill_2
XFILLER_17_42 VPWR VGND sg13cmos5l_decap_8
XFILLER_140_21 VPWR VGND sg13cmos5l_decap_8
XFILLER_621_152 VPWR VGND sg13cmos5l_decap_4
XFILLER_231_103 VPWR VGND sg13cmos5l_decap_8
XANTENNA__2924__X Tile_X0Y8_E2BEGb[0] VPWR VGND sg13cmos5l_antennanp
XFILLER_633_7 VPWR VGND sg13cmos5l_decap_8
XFILLER_420_203 VPWR VGND sg13cmos5l_fill_1
XFILLER_621_163 VPWR VGND sg13cmos5l_decap_4
XFILLER_377_107 VPWR VGND sg13cmos5l_decap_8
XFILLER_497_35 VPWR VGND sg13cmos5l_decap_8
XFILLER_31_219 VPWR VGND sg13cmos5l_fill_1
XFILLER_140_98 VPWR VGND sg13cmos5l_decap_8
XFILLER_708_212 VPWR VGND sg13cmos5l_fill_1
XFILLER_33_52 VPWR VGND sg13cmos5l_decap_8
XFILLER_647_49 VPWR VGND sg13cmos5l_decap_8
XFILLER_318_207 VPWR VGND sg13cmos5l_decap_8
XFILLER_129_118 VPWR VGND sg13cmos5l_decap_8
XFILLER_534_126 VPWR VGND sg13cmos5l_fill_2
XFILLER_366_28 VPWR VGND sg13cmos5l_decap_8
XFILLER_33_96 VPWR VGND sg13cmos5l_fill_1
XFILLER_149_63 VPWR VGND sg13cmos5l_decap_8
XFILLER_123_0 VPWR VGND sg13cmos5l_decap_8
XANTENNA__3755__X AXI_M_SOC_ARADDR27 VPWR VGND sg13cmos5l_antennanp
XFILLER_137_140 VPWR VGND sg13cmos5l_decap_8
XFILLER_298_114 VPWR VGND sg13cmos5l_decap_4
XFILLER_382_49 VPWR VGND sg13cmos5l_decap_8
XFILLER_165_84 VPWR VGND sg13cmos5l_decap_8
XFILLER_165_95 VPWR VGND sg13cmos5l_fill_2
XFILLER_492_0 VPWR VGND sg13cmos5l_decap_8
XFILLER_315_21 VPWR VGND sg13cmos5l_decap_8
XFILLER_239_225 VPWR VGND sg13cmos5l_decap_4
XANTENNA__3490__X Tile_X0Y1_E6BEG[0] VPWR VGND sg13cmos5l_antennanp
XFILLER_455_144 VPWR VGND sg13cmos5l_decap_4
XFILLER_12_7 VPWR VGND sg13cmos5l_decap_8
XFILLER_612_63 VPWR VGND sg13cmos5l_decap_8
XFILLER_254_228 VPWR VGND sg13cmos5l_fill_1
XFILLER_331_42 VPWR VGND sg13cmos5l_decap_8
XFILLER_207_133 VPWR VGND sg13cmos5l_decap_8
XFILLER_74_70 VPWR VGND sg13cmos5l_decap_8
XFILLER_688_56 VPWR VGND sg13cmos5l_decap_8
XANTENNA__2834__X Tile_X0Y6_E1BEG[3] VPWR VGND sg13cmos5l_antennanp
XFILLER_612_163 VPWR VGND sg13cmos5l_fill_1
X_3990_ _3990_/X _3900_/X _4033_/X _4032_/X Tile_X0Y0_S2MID[6] _1189_/Q _1188_/Q VPWR
+ VGND sg13cmos5l_mux4_1
X_2941_ Tile_X0Y8_E6BEG[9] _4769_/X VPWR VGND sg13cmos5l_buf_1
XFILLER_222_158 VPWR VGND sg13cmos5l_decap_4
XFILLER_222_169 VPWR VGND sg13cmos5l_decap_8
XFILLER_200_35 VPWR VGND sg13cmos5l_decap_8
X_2872_ Tile_X0Y6_EE4BEG[9] _4521_/X VPWR VGND sg13cmos5l_buf_1
XFILLER_557_49 VPWR VGND sg13cmos5l_decap_8
XFILLER_309_218 VPWR VGND sg13cmos5l_decap_4
X_4611_ _4611_/X _4667_/X _4666_/X AXI_M_SOC_RDATA16 AXI_M_SOC_RDATA20 _0337_/Q _0336_/Q
+ VPWR VGND sg13cmos5l_mux4_1
X_1823_ _1823_/Q Tile_X0Y3_FrameData[10] VGND VPWR Tile_X0Y9_FrameStrobe[4] latch
XFILLER_276_28 VPWR VGND sg13cmos5l_decap_8
XFILLER_714_226 VPWR VGND sg13cmos5l_fill_2
XANTENNA__3665__X AXI_M_SOC_AWADDR26 VPWR VGND sg13cmos5l_antennanp
X_4542_ _4542_/X _4549_/X Tile_X0Y6_W6END[2] _4548_/X _4542_/A3 _2443_/Q _2442_/Q
+ VPWR VGND sg13cmos5l_mux4_1
X_1754_ _1754_/Q Tile_X0Y3_FrameData[15] VGND VPWR Tile_X0Y9_FrameStrobe[2] latch
X_0705_ _0705_/Q Tile_X0Y9_FrameData[30] VGND VPWR Tile_X0Y9_FrameStrobe[1] latch
XFILLER_679_152 VPWR VGND sg13cmos5l_fill_2
XFILLER_209_77 VPWR VGND sg13cmos5l_decap_8
X_4473_ _4473_/X Tile_X0Y7_W2MID[5] Tile_X0Y7_W2END[5] Tile_X0Y7_W6END[5] _4673_/X
+ _0403_/Q _0402_/Q VPWR VGND sg13cmos5l_mux4_1
X_1685_ _1685_/Q Tile_X0Y3_FrameData[20] VGND VPWR Tile_X0Y9_FrameStrobe[0] latch
XFILLER_506_42 VPWR VGND sg13cmos5l_decap_8
XFILLER_143_154 VPWR VGND sg13cmos5l_decap_8
X_3424_ Tile_X0Y4_FrameData_O[15] Tile_X0Y4_FrameData[15] VPWR VGND sg13cmos5l_buf_1
X_0636_ _0636_/Q Tile_X0Y8_FrameData[3] VGND VPWR Tile_X0Y9_FrameStrobe[6] latch
XFILLER_694_133 VPWR VGND sg13cmos5l_fill_2
XFILLER_292_49 VPWR VGND sg13cmos5l_decap_8
XFILLER_653_70 VPWR VGND sg13cmos5l_decap_8
XFILLER_225_21 VPWR VGND sg13cmos5l_decap_8
X_3355_ Tile_X0Y2_FrameData_O[26] Tile_X0Y2_FrameData[26] VPWR VGND sg13cmos5l_buf_1
XFILLER_493_228 VPWR VGND sg13cmos5l_fill_1
X_0567_ _0567_/Q Tile_X0Y8_FrameData[8] VGND VPWR Tile_X0Y9_FrameStrobe[4] latch
X_2306_ _2306_/Q Tile_X0Y5_FrameData[3] VGND VPWR Tile_X0Y9_FrameStrobe[3] latch
XFILLER_225_98 VPWR VGND sg13cmos5l_decap_4
X_3286_ Tile_X0Y0_E6BEG[6] _3842_/X VPWR VGND sg13cmos5l_buf_1
X_0498_ _0498_/Q Tile_X0Y8_FrameData[13] VGND VPWR Tile_X0Y9_FrameStrobe[2] latch
XFILLER_57_127 VPWR VGND sg13cmos5l_decap_8
X_2237_ _2237_/Q Tile_X0Y5_FrameData[8] VGND VPWR Tile_X0Y9_FrameStrobe[1] latch
XFILLER_650_203 VPWR VGND sg13cmos5l_decap_8
XFILLER_522_63 VPWR VGND sg13cmos5l_decap_8
XFILLER_446_188 VPWR VGND sg13cmos5l_fill_1
XFILLER_241_42 VPWR VGND sg13cmos5l_decap_8
X_2168_ _2168_/Q Tile_X0Y4_FrameData[13] VGND VPWR Tile_X0Y9_FrameStrobe[7] latch
XFILLER_598_56 VPWR VGND sg13cmos5l_decap_8
XANTENNA__2744__X Tile_X0Y3_FrameData_O[2] VPWR VGND sg13cmos5l_antennanp
X_1119_ _1119_/Q Tile_X0Y0_FrameData[12] VGND VPWR Tile_X0Y9_FrameStrobe[5] latch
X_2099_ _2099_/Q Tile_X0Y4_FrameData[18] VGND VPWR Tile_X0Y9_FrameStrobe[5] latch
XFILLER_213_147 VPWR VGND sg13cmos5l_decap_8
XFILLER_110_35 VPWR VGND sg13cmos5l_decap_8
XFILLER_70_28 VPWR VGND sg13cmos5l_decap_8
XFILLER_467_49 VPWR VGND sg13cmos5l_decap_8
XFILLER_382_110 VPWR VGND sg13cmos5l_fill_2
X_4809_ _4809_/X _4779_/X Tile_X0Y9_N4END[5] _4778_/X _0076_/X _0453_/Q _0452_/Q VPWR
+ VGND sg13cmos5l_mux4_1
XFILLER_571_210 VPWR VGND sg13cmos5l_fill_2
XFILLER_367_195 VPWR VGND sg13cmos5l_fill_1
XFILLER_186_28 VPWR VGND sg13cmos5l_decap_8
XANTENNA__3575__X Tile_X0Y9_FrameData_O[5] VPWR VGND sg13cmos5l_antennanp
XFILLER_214_7 VPWR VGND sg13cmos5l_decap_8
XFILLER_531_118 VPWR VGND sg13cmos5l_decap_4
XFILLER_119_173 VPWR VGND sg13cmos5l_fill_1
XFILLER_524_170 VPWR VGND sg13cmos5l_fill_2
XFILLER_119_77 VPWR VGND sg13cmos5l_decap_8
XFILLER_119_88 VPWR VGND sg13cmos5l_decap_8
XFILLER_416_42 VPWR VGND sg13cmos5l_decap_8
XFILLER_563_70 VPWR VGND sg13cmos5l_decap_8
XFILLER_135_21 VPWR VGND sg13cmos5l_decap_8
XFILLER_484_206 VPWR VGND sg13cmos5l_decap_8
XANTENNA__2919__X Tile_X0Y8_E2BEG[3] VPWR VGND sg13cmos5l_antennanp
XFILLER_583_7 VPWR VGND sg13cmos5l_decap_8
XFILLER_484_228 VPWR VGND sg13cmos5l_fill_1
XFILLER_95_14 VPWR VGND sg13cmos5l_decap_8
XFILLER_135_98 VPWR VGND sg13cmos5l_decap_8
XFILLER_713_84 VPWR VGND sg13cmos5l_decap_8
XFILLER_48_149 VPWR VGND sg13cmos5l_decap_8
XFILLER_641_203 VPWR VGND sg13cmos5l_decap_8
XFILLER_437_177 VPWR VGND sg13cmos5l_decap_8
XFILLER_432_63 VPWR VGND sg13cmos5l_decap_8
XFILLER_28_63 VPWR VGND sg13cmos5l_decap_8
XFILLER_151_42 VPWR VGND sg13cmos5l_decap_8
XFILLER_151_97 VPWR VGND sg13cmos5l_decap_4
XFILLER_301_56 VPWR VGND sg13cmos5l_decap_8
XFILLER_44_40 VPWR VGND sg13cmos5l_decap_8
XFILLER_204_147 VPWR VGND sg13cmos5l_decap_8
XFILLER_240_0 VPWR VGND sg13cmos5l_decap_8
XFILLER_338_0 VPWR VGND sg13cmos5l_decap_8
XFILLER_377_49 VPWR VGND sg13cmos5l_decap_8
XFILLER_358_162 VPWR VGND sg13cmos5l_fill_2
XFILLER_674_14 VPWR VGND sg13cmos5l_decap_8
XFILLER_507_126 VPWR VGND sg13cmos5l_decap_8
XFILLER_505_0 VPWR VGND sg13cmos5l_decap_8
XANTENNA__3485__X Tile_X0Y1_EE4BEG[11] VPWR VGND sg13cmos5l_antennanp
XFILLER_711_207 VPWR VGND sg13cmos5l_decap_4
XFILLER_607_63 VPWR VGND sg13cmos5l_decap_8
XFILLER_326_42 VPWR VGND sg13cmos5l_decap_8
XFILLER_5_56 VPWR VGND sg13cmos5l_decap_8
X_1470_ _1470_/Q Tile_X0Y2_FrameData[19] VGND VPWR Tile_X0Y9_FrameStrobe[1] latch
XFILLER_690_35 VPWR VGND sg13cmos5l_decap_8
XFILLER_473_70 VPWR VGND sg13cmos5l_fill_2
XFILLER_69_70 VPWR VGND sg13cmos5l_decap_8
X_0421_ _0421_/Q Tile_X0Y8_FrameData[26] VGND VPWR Tile_X0Y9_FrameStrobe[0] latch
XANTENNA__2829__X Tile_X0Y4_E2BEG[7] VPWR VGND sg13cmos5l_antennanp
XFILLER_475_228 VPWR VGND sg13cmos5l_fill_1
XFILLER_617_211 VPWR VGND sg13cmos5l_decap_8
X_3140_ Tile_X0Y7_FrameData_O[10] Tile_X0Y7_FrameData[10] VPWR VGND sg13cmos5l_buf_1
XFILLER_428_133 VPWR VGND sg13cmos5l_decap_8
X_0352_ _0352_/Q Tile_X0Y7_FrameData[31] VGND VPWR Tile_X0Y9_FrameStrobe[6] latch
XFILLER_623_84 VPWR VGND sg13cmos5l_decap_8
XFILLER_342_63 VPWR VGND sg13cmos5l_decap_8
X_0283_ _0283_/Q Tile_X0Y7_FrameData[4] VGND VPWR Tile_X0Y9_FrameStrobe[3] latch
X_3071_ Tile_X0Y5_FrameData_O[30] Tile_X0Y5_FrameData[30] VPWR VGND sg13cmos5l_buf_1
XFILLER_699_33 VPWR VGND sg13cmos5l_decap_8
XFILLER_294_183 VPWR VGND sg13cmos5l_fill_2
XFILLER_85_80 VPWR VGND sg13cmos5l_decap_8
X_2022_ _2022_/Q Tile_X0Y4_FrameData[31] VGND VPWR Tile_X0Y9_FrameStrobe[3] latch
XFILLER_396_202 VPWR VGND sg13cmos5l_decap_8
XFILLER_451_180 VPWR VGND sg13cmos5l_decap_8
XFILLER_211_56 VPWR VGND sg13cmos5l_decap_8
XFILLER_600_122 VPWR VGND sg13cmos5l_fill_1
X_3973_ _3973_/X AXI_M_SOC_ARREADY _4010_/X _4014_/X _3992_/X _1263_/Q _1262_/Q VPWR
+ VGND sg13cmos5l_mux4_1
XFILLER_62_196 VPWR VGND sg13cmos5l_fill_1
XFILLER_349_140 VPWR VGND sg13cmos5l_decap_8
X_2924_ Tile_X0Y8_E2BEGb[0] _4736_/X VPWR VGND sg13cmos5l_buf_1
XFILLER_600_188 VPWR VGND sg13cmos5l_fill_1
XFILLER_287_49 VPWR VGND sg13cmos5l_decap_8
XFILLER_86_0 VPWR VGND sg13cmos5l_decap_8
XFILLER_648_70 VPWR VGND sg13cmos5l_decap_8
X_2855_ Tile_X0Y6_E6BEG[4] _4532_/X VPWR VGND sg13cmos5l_buf_1
XFILLER_584_14 VPWR VGND sg13cmos5l_decap_8
XANTENNA__3395__X Tile_X0Y2_E2BEGb[6] VPWR VGND sg13cmos5l_antennanp
XFILLER_364_154 VPWR VGND sg13cmos5l_decap_4
X_1806_ _1806_/Q Tile_X0Y3_FrameData[27] VGND VPWR Tile_X0Y9_FrameStrobe[4] latch
X_2786_ Tile_X0Y3_EE4BEG[12] _4176_/X VPWR VGND sg13cmos5l_buf_1
XFILLER_163_227 VPWR VGND sg13cmos5l_fill_2
XFILLER_364_187 VPWR VGND sg13cmos5l_fill_2
X_4525_ _4525_/X Tile_X0Y6_WW4END[2] AXI_M_SOC_RDATA26 _4570_/X _4557_/X _2557_/Q
+ _2556_/Q VPWR VGND sg13cmos5l_mux4_1
XFILLER_116_121 VPWR VGND sg13cmos5l_decap_4
X_1737_ _1737_/Q Tile_X0Y3_FrameData[0] VGND VPWR Tile_X0Y9_FrameStrobe[1] latch
XFILLER_517_63 VPWR VGND sg13cmos5l_decap_8
XFILLER_664_91 VPWR VGND sg13cmos5l_fill_2
XFILLER_236_42 VPWR VGND sg13cmos5l_decap_8
X_4456_ _4456_/X _4421_/X _0159_/X _4420_/X _0145_/X _2227_/Q _2226_/Q VPWR VGND sg13cmos5l_mux4_1
X_1668_ _1668_/Q Tile_X0Y2_FrameData[13] VGND VPWR Tile_X0Y9_FrameStrobe[7] latch
XFILLER_383_70 VPWR VGND sg13cmos5l_decap_8
X_3407_ Tile_X0Y2_E1BEG[2] _4038_/X VPWR VGND sg13cmos5l_buf_1
XANTENNA__2739__X Tile_X0Y4_E1BEG[2] VPWR VGND sg13cmos5l_antennanp
X_0619_ _0619_/Q Tile_X0Y8_FrameData[20] VGND VPWR Tile_X0Y9_FrameStrobe[6] latch
X_4387_ _4387_/X Tile_X0Y5_W2END[0] AXI_M_SOC_RVALID _4467_/X _4428_/X _2329_/Q _2328_/Q
+ VPWR VGND sg13cmos5l_mux4_1
X_1599_ _1599_/Q Tile_X0Y2_FrameData[18] VGND VPWR Tile_X0Y9_FrameStrobe[5] latch
X_3338_ Tile_X0Y2_FrameData_O[9] Tile_X0Y2_FrameData[9] VPWR VGND sg13cmos5l_buf_1
XFILLER_533_84 VPWR VGND sg13cmos5l_decap_8
XFILLER_680_90 VPWR VGND sg13cmos5l_decap_8
XFILLER_533_95 VPWR VGND sg13cmos5l_fill_1
XFILLER_105_35 VPWR VGND sg13cmos5l_decap_8
XFILLER_252_63 VPWR VGND sg13cmos5l_decap_8
X_3269_ Tile_X0Y0_EE4BEG[5] _3825_/X VPWR VGND sg13cmos5l_buf_1
XFILLER_65_28 VPWR VGND sg13cmos5l_decap_8
XFILLER_434_169 VPWR VGND sg13cmos5l_decap_8
XFILLER_164_7 VPWR VGND sg13cmos5l_decap_8
XFILLER_53_152 VPWR VGND sg13cmos5l_decap_8
XFILLER_241_220 VPWR VGND sg13cmos5l_decap_8
XFILLER_121_56 VPWR VGND sg13cmos5l_decap_8
XFILLER_387_224 VPWR VGND sg13cmos5l_decap_4
XFILLER_81_49 VPWR VGND sg13cmos5l_decap_8
XFILLER_331_7 VPWR VGND sg13cmos5l_decap_8
XFILLER_14_21 VPWR VGND sg13cmos5l_decap_8
XFILLER_429_7 VPWR VGND sg13cmos5l_decap_8
XFILLER_197_49 VPWR VGND sg13cmos5l_decap_8
XFILLER_558_70 VPWR VGND sg13cmos5l_decap_8
XFILLER_544_210 VPWR VGND sg13cmos5l_decap_4
XFILLER_494_14 VPWR VGND sg13cmos5l_decap_8
XFILLER_355_154 VPWR VGND sg13cmos5l_decap_8
XFILLER_708_84 VPWR VGND sg13cmos5l_decap_8
XFILLER_30_20 VPWR VGND sg13cmos5l_decap_8
XFILLER_644_28 VPWR VGND sg13cmos5l_decap_8
XFILLER_427_63 VPWR VGND sg13cmos5l_decap_8
XFILLER_574_91 VPWR VGND sg13cmos5l_decap_8
XFILLER_512_140 VPWR VGND sg13cmos5l_fill_1
XFILLER_146_42 VPWR VGND sg13cmos5l_decap_8
XFILLER_122_102 VPWR VGND sg13cmos5l_decap_8
XFILLER_512_162 VPWR VGND sg13cmos5l_decap_8
XFILLER_293_70 VPWR VGND sg13cmos5l_decap_8
XFILLER_658_177 VPWR VGND sg13cmos5l_fill_1
XFILLER_457_228 VPWR VGND sg13cmos5l_fill_1
XFILLER_658_199 VPWR VGND sg13cmos5l_decap_4
XFILLER_673_125 VPWR VGND sg13cmos5l_fill_1
XFILLER_673_147 VPWR VGND sg13cmos5l_decap_8
XFILLER_660_49 VPWR VGND sg13cmos5l_decap_8
XFILLER_443_84 VPWR VGND sg13cmos5l_decap_8
XFILLER_39_62 VPWR VGND sg13cmos5l_fill_2
XFILLER_276_161 VPWR VGND sg13cmos5l_decap_8
XFILLER_190_0 VPWR VGND sg13cmos5l_decap_8
XFILLER_288_0 VPWR VGND sg13cmos5l_fill_2
XFILLER_162_63 VPWR VGND sg13cmos5l_decap_8
XFILLER_614_214 VPWR VGND sg13cmos5l_decap_8
XFILLER_425_147 VPWR VGND sg13cmos5l_decap_8
XFILLER_669_14 VPWR VGND sg13cmos5l_decap_8
XFILLER_29_182 VPWR VGND sg13cmos5l_decap_8
XFILLER_455_0 VPWR VGND sg13cmos5l_decap_8
XFILLER_291_186 VPWR VGND sg13cmos5l_decap_8
XFILLER_579_140 VPWR VGND sg13cmos5l_decap_8
XFILLER_312_77 VPWR VGND sg13cmos5l_decap_4
XFILLER_378_202 VPWR VGND sg13cmos5l_fill_2
XFILLER_232_220 VPWR VGND sg13cmos5l_fill_2
XFILLER_433_180 VPWR VGND sg13cmos5l_decap_8
XFILLER_622_0 VPWR VGND sg13cmos5l_decap_8
XFILLER_594_165 VPWR VGND sg13cmos5l_fill_2
X_0970_ _0970_/Q Tile_X0Y0_FrameData[1] VGND VPWR Tile_X0Y9_FrameStrobe[0] latch
XFILLER_685_35 VPWR VGND sg13cmos5l_decap_8
XFILLER_468_92 VPWR VGND sg13cmos5l_decap_8
XFILLER_187_60 VPWR VGND sg13cmos5l_fill_2
X_2640_ _2640_/Q Tile_X0Y6_FrameData[23] VGND VPWR Tile_X0Y9_FrameStrobe[6] latch
XFILLER_618_84 VPWR VGND sg13cmos5l_decap_8
XFILLER_554_28 VPWR VGND sg13cmos5l_decap_8
XFILLER_361_135 VPWR VGND sg13cmos5l_fill_1
X_2571_ _2571_/Q Tile_X0Y6_FrameData[28] VGND VPWR Tile_X0Y9_FrameStrobe[4] latch
XFILLER_337_63 VPWR VGND sg13cmos5l_decap_8
XFILLER_361_168 VPWR VGND sg13cmos5l_decap_8
X_4310_ _4310_/X Tile_X0Y3_W1END[3] Tile_X0Y3_W6END[11] _4212_/X _4193_/X _1883_/Q
+ _1882_/Q VPWR VGND sg13cmos5l_mux4_1
X_1522_ _1522_/Q Tile_X0Y2_FrameData[31] VGND VPWR Tile_X0Y9_FrameStrobe[3] latch
XFILLER_649_133 VPWR VGND sg13cmos5l_decap_8
XFILLER_503_140 VPWR VGND sg13cmos5l_decap_8
XFILLER_259_106 VPWR VGND sg13cmos5l_decap_8
X_4241_ _4241_/X Tile_X0Y5_W2MID[5] Tile_X0Y5_W2END[5] Tile_X0Y5_W6END[5] _4432_/X
+ _2427_/Q _2426_/Q VPWR VGND sg13cmos5l_mux4_1
XFILLER_649_177 VPWR VGND sg13cmos5l_decap_8
X_1453_ _1453_/Q Tile_X0Y2_FrameData[4] VGND VPWR Tile_X0Y9_FrameStrobe[0] latch
XFILLER_206_56 VPWR VGND sg13cmos5l_decap_8
X_0404_ _0404_/Q Tile_X0Y7_FrameData[11] VGND VPWR Tile_X0Y9_FrameStrobe[7] latch
X_4172_ _4172_/X Tile_X0Y3_WW4END[7] AXI_M_SOC_BVALID _4229_/X _4204_/X _1797_/Q _1796_/Q
+ VPWR VGND sg13cmos5l_mux4_1
XFILLER_570_49 VPWR VGND sg13cmos5l_decap_8
X_1384_ _1384_/Q Tile_X0Y1_FrameData[17] VGND VPWR Tile_X0Y9_FrameStrobe[6] latch
XFILLER_353_84 VPWR VGND sg13cmos5l_decap_8
XFILLER_503_21 VPWR VGND sg13cmos5l_decap_8
X_3123_ Tile_X0Y7_EE4BEG[9] _4637_/X VPWR VGND sg13cmos5l_buf_1
XFILLER_267_172 VPWR VGND sg13cmos5l_decap_8
X_0335_ _0335_/Q Tile_X0Y7_FrameData[16] VGND VPWR Tile_X0Y9_FrameStrobe[5] latch
X_3054_ Tile_X0Y5_FrameData_O[13] Tile_X0Y5_FrameData[13] VPWR VGND sg13cmos5l_buf_1
X_0266_ _0266_/Q Tile_X0Y7_FrameData[21] VGND VPWR Tile_X0Y9_FrameStrobe[3] latch
XFILLER_579_14 VPWR VGND sg13cmos5l_decap_8
XFILLER_503_98 VPWR VGND sg13cmos5l_decap_8
XFILLER_282_175 VPWR VGND sg13cmos5l_decap_8
X_2005_ _2005_/Q Tile_X0Y4_FrameData[16] VGND VPWR Tile_X0Y9_FrameStrobe[2] latch
XFILLER_222_77 VPWR VGND sg13cmos5l_decap_8
X_0197_ _0197_/Q Tile_X0Y7_FrameData[26] VGND VPWR Tile_X0Y9_FrameStrobe[1] latch
XFILLER_620_228 VPWR VGND sg13cmos5l_fill_1
XFILLER_223_220 VPWR VGND sg13cmos5l_fill_1
XFILLER_35_174 VPWR VGND sg13cmos5l_fill_2
XFILLER_659_91 VPWR VGND sg13cmos5l_decap_8
X_3956_ _3956_/X Tile_X0Y1_WW4END[7] AXI_M_SOC_ARREADY _4015_/X _3988_/X _1297_/Q
+ _1296_/Q VPWR VGND sg13cmos5l_mux4_1
XFILLER_384_216 VPWR VGND sg13cmos5l_decap_4
XFILLER_595_35 VPWR VGND sg13cmos5l_decap_8
XFILLER_378_70 VPWR VGND sg13cmos5l_decap_8
XFILLER_526_210 VPWR VGND sg13cmos5l_fill_1
XFILLER_195_149 VPWR VGND sg13cmos5l_decap_8
X_2907_ Tile_X0Y6_FrameData_O[28] Tile_X0Y6_FrameData[28] VPWR VGND sg13cmos5l_buf_1
XFILLER_526_221 VPWR VGND sg13cmos5l_fill_1
X_3887_ _3887_/X _3850_/X _0085_/X Tile_X0Y0_S1END[2] Tile_X0Y0_S4END[2] _0983_/Q
+ _0982_/Q VPWR VGND sg13cmos5l_mux4_1
X_2838_ Tile_X0Y6_E2BEG[3] _4499_/X VPWR VGND sg13cmos5l_buf_1
XFILLER_528_84 VPWR VGND sg13cmos5l_decap_4
XFILLER_541_224 VPWR VGND sg13cmos5l_decap_4
XFILLER_464_28 VPWR VGND sg13cmos5l_decap_8
XFILLER_687_228 VPWR VGND sg13cmos5l_fill_1
XFILLER_247_63 VPWR VGND sg13cmos5l_decap_8
X_2769_ Tile_X0Y3_FrameData_O[27] Tile_X0Y3_FrameData[27] VPWR VGND sg13cmos5l_buf_1
XFILLER_394_91 VPWR VGND sg13cmos5l_decap_8
XFILLER_352_168 VPWR VGND sg13cmos5l_decap_8
X_4508_ _4508_/X Tile_X0Y6_W2END[3] AXI_M_SOC_RDATA27 _4559_/X _4558_/X _2591_/Q _2590_/Q
+ VPWR VGND sg13cmos5l_mux4_1
XFILLER_104_102 VPWR VGND sg13cmos5l_decap_8
X_4439_ _4439_/X Tile_X0Y1_W1END[1] Tile_X0Y1_WW4END[13] Tile_X0Y1_W6END[5] _4009_/X
+ _1362_/Q _1361_/Q VPWR VGND sg13cmos5l_mux4_1
XFILLER_104_168 VPWR VGND sg13cmos5l_decap_8
XFILLER_116_56 VPWR VGND sg13cmos5l_decap_8
XFILLER_655_147 VPWR VGND sg13cmos5l_decap_8
XFILLER_480_49 VPWR VGND sg13cmos5l_decap_8
XFILLER_454_209 VPWR VGND sg13cmos5l_decap_8
XFILLER_413_21 VPWR VGND sg13cmos5l_decap_8
XFILLER_76_49 VPWR VGND sg13cmos5l_decap_8
XFILLER_258_172 VPWR VGND sg13cmos5l_decap_8
XFILLER_281_7 VPWR VGND sg13cmos5l_decap_8
XFILLER_379_7 VPWR VGND sg13cmos5l_decap_8
XFILLER_407_147 VPWR VGND sg13cmos5l_fill_2
XFILLER_489_14 VPWR VGND sg13cmos5l_decap_8
XFILLER_413_98 VPWR VGND sg13cmos5l_decap_8
XFILLER_132_77 VPWR VGND sg13cmos5l_decap_8
XFILLER_710_63 VPWR VGND sg13cmos5l_decap_8
XFILLER_611_228 VPWR VGND sg13cmos5l_fill_1
XFILLER_546_7 VPWR VGND sg13cmos5l_decap_8
XFILLER_415_191 VPWR VGND sg13cmos5l_fill_2
XFILLER_639_28 VPWR VGND sg13cmos5l_decap_8
XFILLER_25_42 VPWR VGND sg13cmos5l_decap_8
XFILLER_569_91 VPWR VGND sg13cmos5l_decap_8
XFILLER_430_161 VPWR VGND sg13cmos5l_decap_8
XANTENNA__2932__X Tile_X0Y8_E6BEG[0] VPWR VGND sg13cmos5l_antennanp
XFILLER_713_7 VPWR VGND sg13cmos5l_decap_8
XFILLER_576_154 VPWR VGND sg13cmos5l_decap_4
XFILLER_375_205 VPWR VGND sg13cmos5l_decap_8
XFILLER_288_70 VPWR VGND sg13cmos5l_decap_8
XFILLER_41_199 VPWR VGND sg13cmos5l_fill_2
XFILLER_390_208 VPWR VGND sg13cmos5l_decap_8
XFILLER_41_52 VPWR VGND sg13cmos5l_decap_8
XFILLER_194_171 VPWR VGND sg13cmos5l_fill_1
XFILLER_655_49 VPWR VGND sg13cmos5l_decap_8
XFILLER_438_84 VPWR VGND sg13cmos5l_decap_8
XFILLER_374_28 VPWR VGND sg13cmos5l_decap_8
XFILLER_157_63 VPWR VGND sg13cmos5l_decap_8
XFILLER_678_228 VPWR VGND sg13cmos5l_fill_1
XFILLER_343_146 VPWR VGND sg13cmos5l_fill_1
XFILLER_203_0 VPWR VGND sg13cmos5l_decap_8
XFILLER_497_161 VPWR VGND sg13cmos5l_decap_8
XFILLER_307_77 VPWR VGND sg13cmos5l_decap_8
XFILLER_604_42 VPWR VGND sg13cmos5l_decap_8
XFILLER_500_154 VPWR VGND sg13cmos5l_decap_8
XFILLER_646_147 VPWR VGND sg13cmos5l_decap_8
XFILLER_390_49 VPWR VGND sg13cmos5l_decap_8
XFILLER_173_84 VPWR VGND sg13cmos5l_decap_8
XFILLER_572_0 VPWR VGND sg13cmos5l_decap_8
XFILLER_323_21 VPWR VGND sg13cmos5l_decap_8
XFILLER_2_35 VPWR VGND sg13cmos5l_decap_8
XFILLER_110_149 VPWR VGND sg13cmos5l_decap_8
X_0120_ _3182_/A _3914_/X _3915_/X _1641_/Q VPWR VGND sg13cmos5l_mux2_1
XFILLER_399_14 VPWR VGND sg13cmos5l_decap_8
XFILLER_602_206 VPWR VGND sg13cmos5l_decap_8
X_0051_ AXI_M_SOC_AWBURST1 _0938_/Q _3683_/X VPWR VGND sg13cmos5l_nor2b_1
XFILLER_620_63 VPWR VGND sg13cmos5l_decap_8
XFILLER_413_139 VPWR VGND sg13cmos5l_fill_2
XANTENNA__3003__X Tile_X0Y5_E2BEG[6] VPWR VGND sg13cmos5l_antennanp
XFILLER_17_152 VPWR VGND sg13cmos5l_decap_8
XFILLER_32_100 VPWR VGND sg13cmos5l_decap_8
XFILLER_549_28 VPWR VGND sg13cmos5l_decap_8
XFILLER_82_70 VPWR VGND sg13cmos5l_decap_8
XFILLER_696_56 VPWR VGND sg13cmos5l_decap_8
X_3810_ _3810_/X Tile_X0Y0_W2MID[1] Tile_X0Y0_W6END[7] _3855_/X _3854_/X _1085_/Q
+ _1084_/Q VPWR VGND sg13cmos5l_mux4_1
XFILLER_567_154 VPWR VGND sg13cmos5l_decap_8
XANTENNA__2842__X Tile_X0Y6_E2BEG[7] VPWR VGND sg13cmos5l_antennanp
X_4790_ _4790_/X _4709_/X Tile_X0Y9_N2MID[4] _4820_/X _4708_/X _0431_/Q _0430_/Q VPWR
+ VGND sg13cmos5l_mux4_1
XFILLER_177_127 VPWR VGND sg13cmos5l_decap_8
XFILLER_198_70 VPWR VGND sg13cmos5l_decap_8
XANTENNA_18 Tile_X0Y0_S4END[12] VPWR VGND sg13cmos5l_antennanp
XANTENNA_29 Tile_X0Y9_FrameStrobe[11] VPWR VGND sg13cmos5l_antennanp
X_3741_ AXI_M_SOC_ARADDR13 Tile_X0Y9_W1END[1] Tile_X0Y9_WW4END[5] Tile_X0Y9_WW4END[13]
+ _4929_/X _0733_/Q _0732_/Q VPWR VGND sg13cmos5l_mux4_1
XFILLER_582_135 VPWR VGND sg13cmos5l_fill_1
X_0953_ _0953_/Q Tile_X0Y0_FrameData[18] VGND VPWR Tile_X0Y9_FrameStrobe[0] latch
XFILLER_319_165 VPWR VGND sg13cmos5l_decap_8
XFILLER_118_216 VPWR VGND sg13cmos5l_decap_8
X_3672_ _3672_/X Tile_X0Y2_WW4END[2] Tile_X0Y2_WW4END[10] Tile_X0Y2_W6END[2] _4118_/X
+ _1501_/Q _1500_/Q VPWR VGND sg13cmos5l_mux4_1
XFILLER_118_227 VPWR VGND sg13cmos5l_fill_2
X_0884_ _0884_/Q Tile_X0Y9_FrameData[11] VGND VPWR Tile_X0Y9_FrameStrobe[6] latch
XFILLER_565_49 VPWR VGND sg13cmos5l_decap_8
XFILLER_348_84 VPWR VGND sg13cmos5l_decap_8
XFILLER_185_182 VPWR VGND sg13cmos5l_decap_4
X_2623_ _2623_/Q Tile_X0Y6_FrameData[8] VGND VPWR Tile_X0Y9_FrameStrobe[5] latch
XFILLER_284_28 VPWR VGND sg13cmos5l_decap_8
XFILLER_669_228 VPWR VGND sg13cmos5l_fill_1
XFILLER_133_208 VPWR VGND sg13cmos5l_decap_4
X_2554_ _2554_/Q Tile_X0Y6_FrameData[13] VGND VPWR Tile_X0Y9_FrameStrobe[3] latch
XFILLER_49_0 VPWR VGND sg13cmos5l_fill_1
X_1505_ _1505_/Q Tile_X0Y2_FrameData[16] VGND VPWR Tile_X0Y9_FrameStrobe[2] latch
XFILLER_217_77 VPWR VGND sg13cmos5l_decap_8
X_2485_ _2485_/Q Tile_X0Y6_FrameData[18] VGND VPWR Tile_X0Y9_FrameStrobe[1] latch
X_4224_ _4224_/X _4200_/X _0087_/X _4199_/X Tile_X0Y0_S4END[14] _1725_/Q _1724_/Q
+ VPWR VGND sg13cmos5l_mux4_1
XFILLER_637_147 VPWR VGND sg13cmos5l_decap_8
XFILLER_514_42 VPWR VGND sg13cmos5l_decap_8
X_1436_ _1436_/Q Tile_X0Y2_FrameData[21] VGND VPWR Tile_X0Y9_FrameStrobe[0] latch
XFILLER_436_209 VPWR VGND sg13cmos5l_decap_8
XFILLER_661_70 VPWR VGND sg13cmos5l_decap_8
XFILLER_233_21 VPWR VGND sg13cmos5l_decap_8
X_4155_ _4155_/X Tile_X0Y3_W2MID[0] AXI_M_SOC_BVALID _4205_/X _4204_/X _1831_/Q _1830_/Q
+ VPWR VGND sg13cmos5l_mux4_1
X_1367_ _1367_/Q Tile_X0Y1_FrameData[2] VGND VPWR Tile_X0Y9_FrameStrobe[5] latch
X_3106_ Tile_X0Y7_E6BEG[4] _4648_/X VPWR VGND sg13cmos5l_buf_1
X_0318_ _0318_/Q Tile_X0Y7_FrameData[1] VGND VPWR Tile_X0Y9_FrameStrobe[4] latch
X_4086_ _4086_/X _4093_/X Tile_X0Y2_W6END[2] _4092_/X _4086_/A3 _1429_/Q _1428_/Q
+ VPWR VGND sg13cmos5l_mux4_1
X_1298_ _1298_/Q Tile_X0Y1_FrameData[7] VGND VPWR Tile_X0Y9_FrameStrobe[3] latch
XFILLER_270_112 VPWR VGND sg13cmos5l_decap_8
X_3037_ Tile_X0Y5_EE4BEG[12] _4400_/X VPWR VGND sg13cmos5l_buf_1
XFILLER_530_63 VPWR VGND sg13cmos5l_decap_8
XFILLER_102_14 VPWR VGND sg13cmos5l_decap_8
X_0249_ _0249_/Q Tile_X0Y7_FrameData[6] VGND VPWR Tile_X0Y9_FrameStrobe[2] latch
XFILLER_70_217 VPWR VGND sg13cmos5l_decap_8
XFILLER_70_228 VPWR VGND sg13cmos5l_fill_1
XFILLER_459_28 VPWR VGND sg13cmos5l_decap_8
XFILLER_23_122 VPWR VGND sg13cmos5l_decap_4
XFILLER_558_154 VPWR VGND sg13cmos5l_fill_1
XANTENNA__2752__X Tile_X0Y3_FrameData_O[10] VPWR VGND sg13cmos5l_antennanp
X_3939_ _3939_/X Tile_X0Y1_W2MID[0] AXI_M_SOC_ARREADY _3989_/X _3988_/X _1331_/Q _1330_/Q
+ VPWR VGND sg13cmos5l_mux4_1
XFILLER_573_168 VPWR VGND sg13cmos5l_decap_8
XFILLER_475_49 VPWR VGND sg13cmos5l_decap_8
XFILLER_258_84 VPWR VGND sg13cmos5l_decap_8
XFILLER_127_7 VPWR VGND sg13cmos5l_decap_8
XFILLER_514_213 VPWR VGND sg13cmos5l_fill_2
XFILLER_408_21 VPWR VGND sg13cmos5l_decap_8
XFILLER_194_28 VPWR VGND sg13cmos5l_decap_8
XANTENNA__3583__X Tile_X0Y9_FrameData_O[13] VPWR VGND sg13cmos5l_antennanp
XFILLER_124_219 VPWR VGND sg13cmos5l_decap_8
XFILLER_408_98 VPWR VGND sg13cmos5l_fill_1
XFILLER_11_77 VPWR VGND sg13cmos5l_decap_8
XFILLER_705_63 VPWR VGND sg13cmos5l_decap_8
XFILLER_628_103 VPWR VGND sg13cmos5l_decap_8
XFILLER_333_190 VPWR VGND sg13cmos5l_fill_2
XFILLER_628_114 VPWR VGND sg13cmos5l_fill_1
XFILLER_496_7 VPWR VGND sg13cmos5l_decap_8
XFILLER_127_99 VPWR VGND sg13cmos5l_decap_8
XFILLER_628_136 VPWR VGND sg13cmos5l_decap_4
XFILLER_424_42 VPWR VGND sg13cmos5l_decap_8
XFILLER_571_70 VPWR VGND sg13cmos5l_decap_8
XFILLER_143_21 VPWR VGND sg13cmos5l_decap_8
XFILLER_494_175 VPWR VGND sg13cmos5l_decap_8
XANTENNA__2927__X Tile_X0Y8_E2BEGb[3] VPWR VGND sg13cmos5l_antennanp
XFILLER_663_7 VPWR VGND sg13cmos5l_decap_8
XFILLER_143_98 VPWR VGND sg13cmos5l_decap_8
XFILLER_100_182 VPWR VGND sg13cmos5l_decap_8
XFILLER_450_201 VPWR VGND sg13cmos5l_decap_8
XFILLER_651_161 VPWR VGND sg13cmos5l_decap_8
XFILLER_36_30 VPWR VGND sg13cmos5l_decap_8
XFILLER_440_63 VPWR VGND sg13cmos5l_decap_8
XFILLER_61_228 VPWR VGND sg13cmos5l_fill_1
XFILLER_369_28 VPWR VGND sg13cmos5l_decap_8
XANTENNA__3758__X AXI_M_SOC_ARADDR30 VPWR VGND sg13cmos5l_antennanp
XFILLER_299_91 VPWR VGND sg13cmos5l_decap_4
XFILLER_159_105 VPWR VGND sg13cmos5l_fill_1
XFILLER_153_0 VPWR VGND sg13cmos5l_decap_8
XFILLER_432_2 VPWR VGND sg13cmos5l_fill_1
XFILLER_52_73 VPWR VGND sg13cmos5l_decap_8
XFILLER_320_0 VPWR VGND sg13cmos5l_decap_8
XFILLER_418_0 VPWR VGND sg13cmos5l_decap_8
XFILLER_174_119 VPWR VGND sg13cmos5l_decap_8
XFILLER_706_140 VPWR VGND sg13cmos5l_decap_8
XFILLER_167_160 VPWR VGND sg13cmos5l_decap_8
XFILLER_385_49 VPWR VGND sg13cmos5l_decap_8
XFILLER_318_21 VPWR VGND sg13cmos5l_decap_8
XFILLER_182_141 VPWR VGND sg13cmos5l_decap_8
XFILLER_682_14 VPWR VGND sg13cmos5l_decap_8
XANTENNA__3493__X Tile_X0Y1_E6BEG[3] VPWR VGND sg13cmos5l_antennanp
XFILLER_182_163 VPWR VGND sg13cmos5l_fill_2
XFILLER_316_179 VPWR VGND sg13cmos5l_decap_8
XFILLER_331_149 VPWR VGND sg13cmos5l_decap_8
XFILLER_42_7 VPWR VGND sg13cmos5l_decap_8
XFILLER_615_63 VPWR VGND sg13cmos5l_decap_8
XFILLER_96_103 VPWR VGND sg13cmos5l_decap_8
XFILLER_619_136 VPWR VGND sg13cmos5l_decap_4
XFILLER_334_42 VPWR VGND sg13cmos5l_decap_8
X_2270_ _2270_/Q Tile_X0Y5_FrameData[7] VGND VPWR Tile_X0Y9_FrameStrobe[2] latch
XFILLER_485_153 VPWR VGND sg13cmos5l_fill_1
XFILLER_481_70 VPWR VGND sg13cmos5l_decap_8
XFILLER_77_70 VPWR VGND sg13cmos5l_decap_8
X_1221_ _1221_/Q Tile_X0Y1_FrameData[20] VGND VPWR Tile_X0Y9_FrameStrobe[1] latch
XANTENNA__2837__X Tile_X0Y6_E2BEG[2] VPWR VGND sg13cmos5l_antennanp
XFILLER_96_169 VPWR VGND sg13cmos5l_fill_2
X_1152_ _1152_/Q Tile_X0Y0_FrameData[11] VGND VPWR Tile_X0Y9_FrameStrobe[6] latch
XFILLER_631_84 VPWR VGND sg13cmos5l_decap_8
XFILLER_203_35 VPWR VGND sg13cmos5l_decap_8
XFILLER_642_161 VPWR VGND sg13cmos5l_decap_8
XFILLER_441_201 VPWR VGND sg13cmos5l_fill_2
XFILLER_252_112 VPWR VGND sg13cmos5l_decap_8
X_0103_ _3191_/A _3798_/X _3799_/X _1142_/Q VPWR VGND sg13cmos5l_mux2_1
XFILLER_398_105 VPWR VGND sg13cmos5l_decap_4
XFILLER_350_63 VPWR VGND sg13cmos5l_decap_8
X_1083_ _1083_/Q Tile_X0Y0_FrameData[16] VGND VPWR Tile_X0Y9_FrameStrobe[4] latch
XFILLER_587_216 VPWR VGND sg13cmos5l_fill_1
XFILLER_52_206 VPWR VGND sg13cmos5l_decap_8
X_4911_ _4911_/X _4456_/X _4460_/X _4464_/X _4431_/X _2376_/Q _2375_/Q VPWR VGND sg13cmos5l_mux4_1
XFILLER_279_28 VPWR VGND sg13cmos5l_decap_8
XANTENNA__3668__X AXI_M_SOC_AWADDR29 VPWR VGND sg13cmos5l_antennanp
XFILLER_500_77 VPWR VGND sg13cmos5l_decap_8
X_4842_ _4842_/X Tile_X0Y9_W1END[3] Tile_X0Y9_WW4END[15] Tile_X0Y9_W6END[7] _4919_/X
+ _0858_/Q _0857_/Q VPWR VGND sg13cmos5l_mux4_1
X_4773_ _4773_/X _4779_/X Tile_X0Y8_W6END[1] _4778_/X _4773_/A3 _0421_/Q _0420_/Q
+ VPWR VGND sg13cmos5l_mux4_1
X_1985_ _1985_/Q Tile_X0Y4_FrameData[4] VGND VPWR Tile_X0Y9_FrameStrobe[1] latch
XFILLER_555_168 VPWR VGND sg13cmos5l_decap_8
X_3724_ _3724_/X Tile_X0Y3_WW4END[1] Tile_X0Y3_WW4END[9] Tile_X0Y3_W6END[9] _4231_/X
+ _1739_/Q _1738_/Q VPWR VGND sg13cmos5l_mux4_1
XFILLER_570_105 VPWR VGND sg13cmos5l_decap_8
XFILLER_509_42 VPWR VGND sg13cmos5l_decap_8
X_0936_ _0936_/Q Tile_X0Y9_FrameData[27] VGND VPWR Tile_X0Y9_FrameStrobe[8] latch
XFILLER_295_49 VPWR VGND sg13cmos5l_decap_8
XFILLER_656_70 VPWR VGND sg13cmos5l_decap_8
XFILLER_228_21 VPWR VGND sg13cmos5l_decap_8
X_3655_ AXI_M_SOC_AWADDR16 Tile_X0Y4_WW4END[0] Tile_X0Y4_WW4END[8] Tile_X0Y4_W6END[0]
+ _4336_/X _2013_/Q _2012_/Q VPWR VGND sg13cmos5l_mux4_1
XFILLER_592_14 VPWR VGND sg13cmos5l_decap_8
X_0867_ _0867_/Q Tile_X0Y9_FrameData[28] VGND VPWR Tile_X0Y9_FrameStrobe[6] latch
XFILLER_307_157 VPWR VGND sg13cmos5l_fill_2
XFILLER_173_163 VPWR VGND sg13cmos5l_decap_8
XFILLER_712_154 VPWR VGND sg13cmos5l_decap_8
X_2606_ _2606_/Q Tile_X0Y6_FrameData[25] VGND VPWR Tile_X0Y9_FrameStrobe[5] latch
XFILLER_322_116 VPWR VGND sg13cmos5l_decap_8
X_3586_ Tile_X0Y9_FrameData_O[16] Tile_X0Y9_FrameData[16] VPWR VGND sg13cmos5l_buf_1
X_0798_ _0798_/Q Tile_X0Y9_FrameData[1] VGND VPWR Tile_X0Y9_FrameStrobe[3] latch
XFILLER_315_190 VPWR VGND sg13cmos5l_decap_8
X_2537_ _2537_/Q Tile_X0Y6_FrameData[30] VGND VPWR Tile_X0Y9_FrameStrobe[3] latch
XFILLER_525_63 VPWR VGND sg13cmos5l_decap_8
XFILLER_525_74 VPWR VGND sg13cmos5l_fill_1
XFILLER_476_120 VPWR VGND sg13cmos5l_decap_8
XFILLER_244_42 VPWR VGND sg13cmos5l_decap_8
X_2468_ _2468_/Q Tile_X0Y6_FrameData[3] VGND VPWR Tile_X0Y9_FrameStrobe[0] latch
XFILLER_330_171 VPWR VGND sg13cmos5l_decap_8
XFILLER_680_201 VPWR VGND sg13cmos5l_decap_4
XFILLER_476_175 VPWR VGND sg13cmos5l_decap_4
X_4207_ _4207_/X _4131_/X _4239_/X _4238_/X _4130_/X _1695_/Q _1694_/Q VPWR VGND sg13cmos5l_mux4_1
XFILLER_491_112 VPWR VGND sg13cmos5l_decap_8
XANTENNA__2747__X Tile_X0Y3_FrameData_O[5] VPWR VGND sg13cmos5l_antennanp
XFILLER_87_169 VPWR VGND sg13cmos5l_decap_4
X_1419_ _1419_/Q Tile_X0Y1_FrameData[14] VGND VPWR Tile_X0Y9_FrameStrobe[7] latch
X_2399_ _2399_/Q Tile_X0Y5_FrameData[6] VGND VPWR Tile_X0Y9_FrameStrobe[6] latch
XFILLER_228_142 VPWR VGND sg13cmos5l_decap_8
X_4138_ _4138_/X Tile_X0Y1_W1END[1] Tile_X0Y1_W2MID[2] Tile_X0Y1_W2END[2] _3992_/X
+ _1371_/Q _1370_/Q VPWR VGND sg13cmos5l_mux4_1
XFILLER_28_225 VPWR VGND sg13cmos5l_decap_4
XFILLER_541_84 VPWR VGND sg13cmos5l_fill_1
XFILLER_113_35 VPWR VGND sg13cmos5l_decap_8
XFILLER_260_63 VPWR VGND sg13cmos5l_decap_8
X_4069_ _4069_/X Tile_X0Y2_WW4END[2] AXI_M_SOC_AWREADY _4118_/X _4101_/X _1535_/Q
+ _1534_/Q VPWR VGND sg13cmos5l_mux4_1
XFILLER_260_74 VPWR VGND sg13cmos5l_fill_1
XFILLER_73_28 VPWR VGND sg13cmos5l_decap_8
XFILLER_260_96 VPWR VGND sg13cmos5l_decap_8
XFILLER_243_167 VPWR VGND sg13cmos5l_decap_8
XFILLER_189_28 VPWR VGND sg13cmos5l_decap_8
XANTENNA__3578__X Tile_X0Y9_FrameData_O[8] VPWR VGND sg13cmos5l_antennanp
XFILLER_244_7 VPWR VGND sg13cmos5l_decap_8
XFILLER_561_105 VPWR VGND sg13cmos5l_decap_8
XFILLER_419_42 VPWR VGND sg13cmos5l_decap_8
XFILLER_411_7 VPWR VGND sg13cmos5l_decap_8
XFILLER_22_21 VPWR VGND sg13cmos5l_decap_8
XFILLER_11_169 VPWR VGND sg13cmos5l_fill_2
XFILLER_509_7 VPWR VGND sg13cmos5l_decap_8
XFILLER_566_70 VPWR VGND sg13cmos5l_decap_8
XFILLER_138_21 VPWR VGND sg13cmos5l_decap_8
XFILLER_164_130 VPWR VGND sg13cmos5l_decap_8
XFILLER_98_14 VPWR VGND sg13cmos5l_decap_8
XFILLER_313_105 VPWR VGND sg13cmos5l_decap_4
XFILLER_138_98 VPWR VGND sg13cmos5l_decap_8
XFILLER_716_95 VPWR VGND sg13cmos5l_decap_8
XFILLER_313_149 VPWR VGND sg13cmos5l_fill_1
XFILLER_652_28 VPWR VGND sg13cmos5l_decap_8
XFILLER_435_63 VPWR VGND sg13cmos5l_decap_8
XFILLER_582_91 VPWR VGND sg13cmos5l_decap_8
XFILLER_154_42 VPWR VGND sg13cmos5l_decap_8
XFILLER_78_136 VPWR VGND sg13cmos5l_fill_1
XFILLER_408_220 VPWR VGND sg13cmos5l_decap_8
XFILLER_304_56 VPWR VGND sg13cmos5l_decap_8
XFILLER_281_218 VPWR VGND sg13cmos5l_fill_1
XFILLER_601_21 VPWR VGND sg13cmos5l_decap_8
XFILLER_47_73 VPWR VGND sg13cmos5l_decap_8
XFILLER_270_0 VPWR VGND sg13cmos5l_decap_8
XFILLER_423_212 VPWR VGND sg13cmos5l_fill_2
XFILLER_368_0 VPWR VGND sg13cmos5l_decap_8
XFILLER_170_63 VPWR VGND sg13cmos5l_decap_8
XFILLER_234_134 VPWR VGND sg13cmos5l_fill_2
XFILLER_34_228 VPWR VGND sg13cmos5l_fill_1
XFILLER_677_14 VPWR VGND sg13cmos5l_decap_8
XANTENNA__3488__X Tile_X0Y1_EE4BEG[14] VPWR VGND sg13cmos5l_antennanp
XFILLER_535_0 VPWR VGND sg13cmos5l_decap_8
XFILLER_702_0 VPWR VGND sg13cmos5l_decap_8
XFILLER_329_42 VPWR VGND sg13cmos5l_decap_8
XFILLER_8_56 VPWR VGND sg13cmos5l_decap_8
XFILLER_552_105 VPWR VGND sg13cmos5l_fill_2
X_1770_ _1770_/Q Tile_X0Y3_FrameData[31] VGND VPWR Tile_X0Y9_FrameStrobe[3] latch
XFILLER_693_35 VPWR VGND sg13cmos5l_decap_8
X_0721_ _0721_/Q Tile_X0Y9_FrameData[14] VGND VPWR Tile_X0Y9_FrameStrobe[1] latch
XFILLER_155_152 VPWR VGND sg13cmos5l_fill_2
X_3440_ Tile_X0Y4_FrameData_O[31] Tile_X0Y4_FrameData[31] VPWR VGND sg13cmos5l_buf_1
X_0652_ _0652_/Q Tile_X0Y8_FrameData[19] VGND VPWR Tile_X0Y9_FrameStrobe[7] latch
XFILLER_626_84 VPWR VGND sg13cmos5l_decap_8
XFILLER_304_138 VPWR VGND sg13cmos5l_decap_8
XFILLER_562_28 VPWR VGND sg13cmos5l_decap_8
X_3371_ Tile_X0Y2_EE4BEG[10] _4066_/X VPWR VGND sg13cmos5l_buf_1
XFILLER_345_63 VPWR VGND sg13cmos5l_decap_8
X_0583_ _0583_/Q Tile_X0Y8_FrameData[24] VGND VPWR Tile_X0Y9_FrameStrobe[5] latch
XFILLER_492_91 VPWR VGND sg13cmos5l_decap_8
X_2322_ _2322_/Q Tile_X0Y5_FrameData[19] VGND VPWR Tile_X0Y9_FrameStrobe[4] latch
XFILLER_458_153 VPWR VGND sg13cmos5l_fill_2
XFILLER_69_147 VPWR VGND sg13cmos5l_decap_8
X_2253_ _2253_/Q Tile_X0Y5_FrameData[24] VGND VPWR Tile_X0Y9_FrameStrobe[2] latch
XFILLER_473_123 VPWR VGND sg13cmos5l_decap_8
XFILLER_214_56 VPWR VGND sg13cmos5l_decap_8
X_1204_ _1204_/Q Tile_X0Y1_FrameData[5] VGND VPWR Tile_X0Y9_FrameStrobe[0] latch
X_2184_ _2184_/Q Tile_X0Y5_FrameData[29] VGND VPWR Tile_X0Y9_FrameStrobe[0] latch
XFILLER_473_178 VPWR VGND sg13cmos5l_fill_2
XFILLER_361_84 VPWR VGND sg13cmos5l_decap_8
XFILLER_511_21 VPWR VGND sg13cmos5l_decap_8
XFILLER_615_172 VPWR VGND sg13cmos5l_decap_8
X_1135_ _1135_/Q Tile_X0Y0_FrameData[28] VGND VPWR Tile_X0Y9_FrameStrobe[6] latch
XFILLER_615_194 VPWR VGND sg13cmos5l_decap_8
XFILLER_630_142 VPWR VGND sg13cmos5l_fill_1
X_1066_ _1066_/Q Tile_X0Y0_FrameData[1] VGND VPWR Tile_X0Y9_FrameStrobe[3] latch
XFILLER_587_14 VPWR VGND sg13cmos5l_decap_8
XFILLER_511_98 VPWR VGND sg13cmos5l_decap_8
XANTENNA__3398__X Tile_X0Y2_E2BEG[1] VPWR VGND sg13cmos5l_antennanp
XFILLER_230_77 VPWR VGND sg13cmos5l_fill_2
XFILLER_230_88 VPWR VGND sg13cmos5l_fill_1
X_4825_ _4825_/X Tile_X0Y9_W1END[1] Tile_X0Y9_W6END[9] _4929_/X _4893_/X _0889_/Q
+ _0888_/Q VPWR VGND sg13cmos5l_mux4_1
XFILLER_528_146 VPWR VGND sg13cmos5l_decap_8
XFILLER_394_141 VPWR VGND sg13cmos5l_fill_2
XFILLER_394_152 VPWR VGND sg13cmos5l_fill_1
XFILLER_667_91 VPWR VGND sg13cmos5l_decap_8
XFILLER_138_119 VPWR VGND sg13cmos5l_decap_8
XFILLER_394_174 VPWR VGND sg13cmos5l_decap_8
XFILLER_239_42 VPWR VGND sg13cmos5l_decap_8
X_1968_ _1968_/Q Tile_X0Y4_FrameData[21] VGND VPWR Tile_X0Y9_FrameStrobe[1] latch
X_4756_ _4756_/X Tile_X0Y8_WW4END[3] AXI_M_SOC_RDATA11 _4803_/X _4791_/X _0535_/Q
+ _0534_/Q VPWR VGND sg13cmos5l_mux4_1
XFILLER_689_109 VPWR VGND sg13cmos5l_decap_4
XFILLER_394_196 VPWR VGND sg13cmos5l_decap_8
XFILLER_386_70 VPWR VGND sg13cmos5l_fill_1
X_0919_ _0919_/Q Tile_X0Y9_FrameData[8] VGND VPWR Tile_X0Y9_FrameStrobe[7] latch
X_3707_ AXI_M_SOC_WDATA17 Tile_X0Y6_WW4END[1] Tile_X0Y6_WW4END[9] Tile_X0Y6_W6END[1]
+ _4569_/X _2525_/Q _2524_/Q VPWR VGND sg13cmos5l_mux4_1
X_4687_ _4687_/X _4667_/X Tile_X0Y9_N4END[11] _4666_/X _0053_/X _0209_/Q _0208_/Q
+ VPWR VGND sg13cmos5l_mux4_1
X_1899_ _1899_/Q Tile_X0Y3_FrameData[30] VGND VPWR Tile_X0Y9_FrameStrobe[7] latch
X_3638_ Tile_X0Y9_UserCLKo Tile_X0Y9_UserCLK VPWR VGND sg13cmos5l_buf_1
XFILLER_161_122 VPWR VGND sg13cmos5l_fill_1
XFILLER_536_84 VPWR VGND sg13cmos5l_decap_8
XFILLER_108_35 VPWR VGND sg13cmos5l_decap_8
XFILLER_472_28 VPWR VGND sg13cmos5l_decap_8
XFILLER_255_63 VPWR VGND sg13cmos5l_decap_8
X_3569_ Tile_X0Y9_EE4BEG[15] _4879_/X VPWR VGND sg13cmos5l_buf_1
XFILLER_255_74 VPWR VGND sg13cmos5l_fill_2
XFILLER_68_28 VPWR VGND sg13cmos5l_decap_8
XFILLER_449_175 VPWR VGND sg13cmos5l_fill_1
XFILLER_124_12 VPWR VGND sg13cmos5l_decap_8
XFILLER_405_77 VPWR VGND sg13cmos5l_fill_2
XFILLER_194_7 VPWR VGND sg13cmos5l_decap_8
XFILLER_702_31 VPWR VGND sg13cmos5l_decap_8
XFILLER_464_156 VPWR VGND sg13cmos5l_decap_8
XFILLER_271_84 VPWR VGND sg13cmos5l_decap_8
XFILLER_263_218 VPWR VGND sg13cmos5l_fill_2
XFILLER_68_191 VPWR VGND sg13cmos5l_decap_8
XFILLER_84_49 VPWR VGND sg13cmos5l_decap_8
XFILLER_421_21 VPWR VGND sg13cmos5l_decap_8
XFILLER_606_161 VPWR VGND sg13cmos5l_decap_4
XFILLER_216_112 VPWR VGND sg13cmos5l_decap_8
XFILLER_361_7 VPWR VGND sg13cmos5l_decap_8
XFILLER_17_21 VPWR VGND sg13cmos5l_decap_8
XFILLER_459_7 VPWR VGND sg13cmos5l_decap_8
XFILLER_497_14 VPWR VGND sg13cmos5l_decap_8
XFILLER_421_98 VPWR VGND sg13cmos5l_decap_8
XFILLER_140_77 VPWR VGND sg13cmos5l_decap_8
XFILLER_626_7 VPWR VGND sg13cmos5l_decap_8
XANTENNA__3101__X Tile_X0Y7_E2BEGb[7] VPWR VGND sg13cmos5l_antennanp
XFILLER_33_31 VPWR VGND sg13cmos5l_decap_8
XFILLER_647_28 VPWR VGND sg13cmos5l_decap_8
XANTENNA__2940__X Tile_X0Y8_E6BEG[8] VPWR VGND sg13cmos5l_antennanp
XFILLER_577_91 VPWR VGND sg13cmos5l_decap_8
XFILLER_184_225 VPWR VGND sg13cmos5l_decap_4
XFILLER_149_42 VPWR VGND sg13cmos5l_decap_8
XFILLER_385_185 VPWR VGND sg13cmos5l_decap_8
XFILLER_385_196 VPWR VGND sg13cmos5l_fill_2
XFILLER_296_70 VPWR VGND sg13cmos5l_decap_8
XFILLER_534_149 VPWR VGND sg13cmos5l_decap_8
XFILLER_116_0 VPWR VGND sg13cmos5l_decap_8
XFILLER_152_100 VPWR VGND sg13cmos5l_decap_8
XFILLER_298_104 VPWR VGND sg13cmos5l_fill_2
XFILLER_137_196 VPWR VGND sg13cmos5l_decap_8
XFILLER_663_49 VPWR VGND sg13cmos5l_decap_8
XFILLER_446_84 VPWR VGND sg13cmos5l_decap_8
XFILLER_382_28 VPWR VGND sg13cmos5l_decap_8
XFILLER_165_63 VPWR VGND sg13cmos5l_decap_8
XFILLER_629_220 VPWR VGND sg13cmos5l_fill_1
XFILLER_3_198 VPWR VGND sg13cmos5l_fill_2
XFILLER_239_215 VPWR VGND sg13cmos5l_decap_8
XFILLER_485_0 VPWR VGND sg13cmos5l_decap_8
XFILLER_612_42 VPWR VGND sg13cmos5l_decap_8
XFILLER_652_0 VPWR VGND sg13cmos5l_decap_8
XFILLER_331_21 VPWR VGND sg13cmos5l_decap_8
XFILLER_181_95 VPWR VGND sg13cmos5l_decap_8
XFILLER_207_112 VPWR VGND sg13cmos5l_decap_8
XFILLER_688_35 VPWR VGND sg13cmos5l_decap_8
XFILLER_470_159 VPWR VGND sg13cmos5l_decap_8
XFILLER_74_172 VPWR VGND sg13cmos5l_fill_1
XFILLER_207_189 VPWR VGND sg13cmos5l_decap_8
X_2940_ Tile_X0Y8_E6BEG[8] _4768_/X VPWR VGND sg13cmos5l_buf_1
XFILLER_200_14 VPWR VGND sg13cmos5l_decap_8
XANTENNA__3011__X Tile_X0Y5_E2BEGb[6] VPWR VGND sg13cmos5l_antennanp
X_2871_ Tile_X0Y6_EE4BEG[8] _4520_/X VPWR VGND sg13cmos5l_buf_1
XFILLER_557_28 VPWR VGND sg13cmos5l_decap_8
XFILLER_487_91 VPWR VGND sg13cmos5l_decap_8
XFILLER_175_214 VPWR VGND sg13cmos5l_decap_8
XANTENNA__2850__X Tile_X0Y6_E2BEGb[7] VPWR VGND sg13cmos5l_antennanp
XFILLER_714_205 VPWR VGND sg13cmos5l_decap_8
X_1822_ _1822_/Q Tile_X0Y3_FrameData[11] VGND VPWR Tile_X0Y9_FrameStrobe[4] latch
X_4610_ _4610_/X _4665_/X _4664_/X AXI_M_SOC_RDATA17 AXI_M_SOC_RDATA21 _0339_/Q _0338_/Q
+ VPWR VGND sg13cmos5l_mux4_1
XFILLER_391_100 VPWR VGND sg13cmos5l_decap_8
XFILLER_580_211 VPWR VGND sg13cmos5l_fill_1
X_4541_ _4541_/X _4547_/X Tile_X0Y6_W6END[1] _4546_/X _4541_/A3 _2445_/Q _2444_/Q
+ VPWR VGND sg13cmos5l_mux4_1
X_1753_ _1753_/Q Tile_X0Y3_FrameData[16] VGND VPWR Tile_X0Y9_FrameStrobe[2] latch
XFILLER_209_56 VPWR VGND sg13cmos5l_decap_8
X_0704_ _0704_/Q Tile_X0Y9_FrameData[31] VGND VPWR Tile_X0Y9_FrameStrobe[1] latch
XFILLER_391_199 VPWR VGND sg13cmos5l_decap_8
XFILLER_332_200 VPWR VGND sg13cmos5l_decap_8
X_4472_ _4472_/X Tile_X0Y4_W2MID[5] Tile_X0Y4_W2END[5] Tile_X0Y4_W6END[10] _4317_/X
+ _2133_/Q _2132_/Q VPWR VGND sg13cmos5l_mux4_1
XFILLER_332_211 VPWR VGND sg13cmos5l_fill_1
X_1684_ _1684_/Q Tile_X0Y3_FrameData[21] VGND VPWR Tile_X0Y9_FrameStrobe[0] latch
XFILLER_573_49 VPWR VGND sg13cmos5l_decap_8
XFILLER_356_84 VPWR VGND sg13cmos5l_decap_8
XFILLER_143_133 VPWR VGND sg13cmos5l_decap_8
XFILLER_506_21 VPWR VGND sg13cmos5l_decap_8
XFILLER_289_126 VPWR VGND sg13cmos5l_fill_1
X_3423_ Tile_X0Y4_FrameData_O[14] Tile_X0Y4_FrameData[14] VPWR VGND sg13cmos5l_buf_1
XFILLER_694_112 VPWR VGND sg13cmos5l_decap_8
XFILLER_292_28 VPWR VGND sg13cmos5l_decap_8
X_0635_ _0635_/Q Tile_X0Y8_FrameData[4] VGND VPWR Tile_X0Y9_FrameStrobe[6] latch
XFILLER_289_159 VPWR VGND sg13cmos5l_decap_8
XFILLER_493_207 VPWR VGND sg13cmos5l_fill_1
X_3354_ Tile_X0Y2_FrameData_O[25] Tile_X0Y2_FrameData[25] VPWR VGND sg13cmos5l_buf_1
X_0566_ _0566_/Q Tile_X0Y8_FrameData[9] VGND VPWR Tile_X0Y9_FrameStrobe[4] latch
XFILLER_506_98 VPWR VGND sg13cmos5l_decap_8
XFILLER_31_0 VPWR VGND sg13cmos5l_fill_1
X_2305_ _2305_/Q Tile_X0Y5_FrameData[4] VGND VPWR Tile_X0Y9_FrameStrobe[3] latch
XFILLER_225_77 VPWR VGND sg13cmos5l_decap_8
X_3285_ Tile_X0Y0_E6BEG[5] _3841_/X VPWR VGND sg13cmos5l_buf_1
X_0497_ _0497_/Q Tile_X0Y8_FrameData[14] VGND VPWR Tile_X0Y9_FrameStrobe[2] latch
XFILLER_522_42 VPWR VGND sg13cmos5l_decap_8
X_2236_ _2236_/Q Tile_X0Y5_FrameData[9] VGND VPWR Tile_X0Y9_FrameStrobe[1] latch
XFILLER_245_218 VPWR VGND sg13cmos5l_decap_8
XFILLER_446_178 VPWR VGND sg13cmos5l_decap_4
XFILLER_241_21 VPWR VGND sg13cmos5l_decap_8
X_2167_ _2167_/Q Tile_X0Y4_FrameData[14] VGND VPWR Tile_X0Y9_FrameStrobe[7] latch
XFILLER_461_148 VPWR VGND sg13cmos5l_fill_2
XFILLER_603_131 VPWR VGND sg13cmos5l_fill_2
XFILLER_598_35 VPWR VGND sg13cmos5l_decap_8
XFILLER_65_183 VPWR VGND sg13cmos5l_decap_8
X_1118_ _1118_/Q Tile_X0Y0_FrameData[13] VGND VPWR Tile_X0Y9_FrameStrobe[5] latch
X_2098_ _2098_/Q Tile_X0Y4_FrameData[19] VGND VPWR Tile_X0Y9_FrameStrobe[5] latch
XFILLER_213_126 VPWR VGND sg13cmos5l_decap_8
XFILLER_359_119 VPWR VGND sg13cmos5l_decap_8
X_1049_ _1049_/Q Tile_X0Y0_FrameData[18] VGND VPWR Tile_X0Y9_FrameStrobe[3] latch
XFILLER_110_14 VPWR VGND sg13cmos5l_decap_8
XFILLER_80_175 VPWR VGND sg13cmos5l_fill_1
XFILLER_467_28 VPWR VGND sg13cmos5l_decap_8
XFILLER_221_181 VPWR VGND sg13cmos5l_fill_1
XANTENNA__2760__X Tile_X0Y3_FrameData_O[18] VPWR VGND sg13cmos5l_antennanp
XFILLER_367_174 VPWR VGND sg13cmos5l_decap_8
XFILLER_166_225 VPWR VGND sg13cmos5l_decap_4
X_4808_ _4808_/X _4777_/X Tile_X0Y9_N4END[4] _4776_/X _0077_/X _0455_/Q _0454_/Q VPWR
+ VGND sg13cmos5l_mux4_1
XFILLER_382_133 VPWR VGND sg13cmos5l_fill_1
X_4739_ _4739_/X Tile_X0Y8_W2END[4] AXI_M_SOC_RDATA12 _4791_/X _4790_/X _0569_/Q _0568_/Q
+ VPWR VGND sg13cmos5l_mux4_1
XFILLER_119_56 VPWR VGND sg13cmos5l_decap_8
XFILLER_483_49 VPWR VGND sg13cmos5l_decap_8
XFILLER_469_204 VPWR VGND sg13cmos5l_decap_8
XFILLER_207_7 VPWR VGND sg13cmos5l_decap_8
XFILLER_266_84 VPWR VGND sg13cmos5l_decap_8
XFILLER_134_133 VPWR VGND sg13cmos5l_decap_8
XFILLER_524_193 VPWR VGND sg13cmos5l_fill_2
XFILLER_416_21 VPWR VGND sg13cmos5l_decap_8
XFILLER_79_49 VPWR VGND sg13cmos5l_decap_8
XFILLER_685_112 VPWR VGND sg13cmos5l_decap_4
XFILLER_685_134 VPWR VGND sg13cmos5l_fill_1
XANTENNA__3591__X Tile_X0Y9_FrameData_O[21] VPWR VGND sg13cmos5l_antennanp
XFILLER_685_156 VPWR VGND sg13cmos5l_fill_1
XFILLER_88_220 VPWR VGND sg13cmos5l_fill_2
XFILLER_416_98 VPWR VGND sg13cmos5l_decap_8
XFILLER_626_212 VPWR VGND sg13cmos5l_fill_2
XFILLER_437_112 VPWR VGND sg13cmos5l_decap_8
XFILLER_135_77 VPWR VGND sg13cmos5l_decap_8
XFILLER_713_63 VPWR VGND sg13cmos5l_decap_8
XFILLER_576_7 VPWR VGND sg13cmos5l_decap_8
XFILLER_432_42 VPWR VGND sg13cmos5l_decap_8
XFILLER_28_42 VPWR VGND sg13cmos5l_decap_8
XFILLER_151_21 VPWR VGND sg13cmos5l_decap_8
XANTENNA__2935__X Tile_X0Y8_E6BEG[3] VPWR VGND sg13cmos5l_antennanp
XFILLER_56_150 VPWR VGND sg13cmos5l_decap_8
XFILLER_56_161 VPWR VGND sg13cmos5l_fill_2
XFILLER_151_87 VPWR VGND sg13cmos5l_fill_2
XFILLER_56_194 VPWR VGND sg13cmos5l_decap_8
XFILLER_301_35 VPWR VGND sg13cmos5l_decap_8
XFILLER_71_142 VPWR VGND sg13cmos5l_decap_8
XFILLER_204_126 VPWR VGND sg13cmos5l_decap_8
XFILLER_658_49 VPWR VGND sg13cmos5l_decap_8
XFILLER_71_197 VPWR VGND sg13cmos5l_decap_8
XFILLER_44_96 VPWR VGND sg13cmos5l_fill_1
XFILLER_377_28 VPWR VGND sg13cmos5l_decap_8
XFILLER_233_0 VPWR VGND sg13cmos5l_decap_8
XFILLER_507_105 VPWR VGND sg13cmos5l_decap_8
XFILLER_157_225 VPWR VGND sg13cmos5l_decap_4
XFILLER_373_144 VPWR VGND sg13cmos5l_fill_1
XFILLER_373_155 VPWR VGND sg13cmos5l_decap_8
XFILLER_400_0 VPWR VGND sg13cmos5l_decap_8
XFILLER_172_217 VPWR VGND sg13cmos5l_decap_8
XFILLER_60_84 VPWR VGND sg13cmos5l_decap_8
XFILLER_373_177 VPWR VGND sg13cmos5l_fill_2
XFILLER_172_228 VPWR VGND sg13cmos5l_fill_1
XFILLER_373_188 VPWR VGND sg13cmos5l_fill_1
XFILLER_607_42 VPWR VGND sg13cmos5l_decap_8
XFILLER_393_49 VPWR VGND sg13cmos5l_decap_8
XFILLER_326_21 VPWR VGND sg13cmos5l_decap_8
XFILLER_5_35 VPWR VGND sg13cmos5l_decap_8
XFILLER_690_14 VPWR VGND sg13cmos5l_decap_8
XFILLER_676_134 VPWR VGND sg13cmos5l_decap_8
XFILLER_530_152 VPWR VGND sg13cmos5l_decap_8
XFILLER_125_188 VPWR VGND sg13cmos5l_decap_8
XFILLER_676_156 VPWR VGND sg13cmos5l_decap_4
X_0420_ _0420_/Q Tile_X0Y8_FrameData[27] VGND VPWR Tile_X0Y9_FrameStrobe[0] latch
XFILLER_125_199 VPWR VGND sg13cmos5l_fill_1
XFILLER_140_147 VPWR VGND sg13cmos5l_fill_1
XFILLER_428_112 VPWR VGND sg13cmos5l_decap_8
X_0351_ _0351_/Q Tile_X0Y7_FrameData[0] VGND VPWR Tile_X0Y9_FrameStrobe[5] latch
XFILLER_623_63 VPWR VGND sg13cmos5l_decap_8
XFILLER_94_201 VPWR VGND sg13cmos5l_decap_8
XANTENNA__3006__X Tile_X0Y5_E2BEGb[1] VPWR VGND sg13cmos5l_antennanp
XFILLER_342_42 VPWR VGND sg13cmos5l_decap_8
XFILLER_699_12 VPWR VGND sg13cmos5l_decap_8
XFILLER_294_162 VPWR VGND sg13cmos5l_decap_8
X_3070_ Tile_X0Y5_FrameData_O[29] Tile_X0Y5_FrameData[29] VPWR VGND sg13cmos5l_buf_1
XFILLER_227_218 VPWR VGND sg13cmos5l_fill_1
X_0282_ _0282_/Q Tile_X0Y7_FrameData[5] VGND VPWR Tile_X0Y9_FrameStrobe[3] latch
XFILLER_428_189 VPWR VGND sg13cmos5l_decap_8
XFILLER_443_126 VPWR VGND sg13cmos5l_decap_8
X_2021_ _2021_/Q Tile_X0Y4_FrameData[0] VGND VPWR Tile_X0Y9_FrameStrobe[2] latch
XANTENNA__2845__X Tile_X0Y6_E2BEGb[2] VPWR VGND sg13cmos5l_antennanp
XFILLER_699_89 VPWR VGND sg13cmos5l_decap_8
XFILLER_211_35 VPWR VGND sg13cmos5l_decap_8
XFILLER_62_175 VPWR VGND sg13cmos5l_decap_8
X_3972_ _3972_/X AXI_M_SOC_ARREADY _4011_/X _4015_/X _3994_/X _1265_/Q _1264_/Q VPWR
+ VGND sg13cmos5l_mux4_1
XFILLER_568_49 VPWR VGND sg13cmos5l_decap_8
X_2923_ Tile_X0Y8_E2BEG[7] _4735_/X VPWR VGND sg13cmos5l_buf_1
XFILLER_287_28 VPWR VGND sg13cmos5l_decap_8
XFILLER_148_214 VPWR VGND sg13cmos5l_fill_1
XFILLER_203_192 VPWR VGND sg13cmos5l_fill_2
XFILLER_553_211 VPWR VGND sg13cmos5l_decap_4
X_2854_ Tile_X0Y6_E6BEG[3] _4531_/X VPWR VGND sg13cmos5l_buf_1
XFILLER_553_222 VPWR VGND sg13cmos5l_decap_8
XFILLER_79_0 VPWR VGND sg13cmos5l_decap_8
X_1805_ _1805_/Q Tile_X0Y3_FrameData[28] VGND VPWR Tile_X0Y9_FrameStrobe[4] latch
X_2785_ Tile_X0Y3_EE4BEG[11] _4175_/X VPWR VGND sg13cmos5l_buf_1
XFILLER_513_119 VPWR VGND sg13cmos5l_decap_8
XFILLER_517_42 VPWR VGND sg13cmos5l_decap_8
XFILLER_305_200 VPWR VGND sg13cmos5l_fill_2
X_1736_ _1736_/Q Tile_X0Y3_FrameData[1] VGND VPWR Tile_X0Y9_FrameStrobe[1] latch
X_4524_ _4524_/X Tile_X0Y6_WW4END[3] AXI_M_SOC_RDATA27 _4571_/X _4559_/X _2559_/Q
+ _2558_/Q VPWR VGND sg13cmos5l_mux4_1
XFILLER_664_70 VPWR VGND sg13cmos5l_decap_8
XFILLER_506_182 VPWR VGND sg13cmos5l_decap_8
XFILLER_236_21 VPWR VGND sg13cmos5l_decap_8
XFILLER_116_144 VPWR VGND sg13cmos5l_fill_2
X_1667_ _1667_/Q Tile_X0Y2_FrameData[14] VGND VPWR Tile_X0Y9_FrameStrobe[7] latch
X_4455_ _4455_/X _4418_/X _0157_/X _4417_/X _0143_/X _2229_/Q _2228_/Q VPWR VGND sg13cmos5l_mux4_1
XFILLER_521_152 VPWR VGND sg13cmos5l_decap_4
XFILLER_667_145 VPWR VGND sg13cmos5l_fill_1
XFILLER_466_207 VPWR VGND sg13cmos5l_decap_8
X_0618_ _0618_/Q Tile_X0Y8_FrameData[21] VGND VPWR Tile_X0Y9_FrameStrobe[6] latch
X_3406_ Tile_X0Y2_E1BEG[1] _4037_/X VPWR VGND sg13cmos5l_buf_1
X_4386_ _4386_/X Tile_X0Y5_W2END[1] AXI_M_SOC_RLAST _4430_/X _4429_/X _2331_/Q _2330_/Q
+ VPWR VGND sg13cmos5l_mux4_1
X_1598_ _1598_/Q Tile_X0Y2_FrameData[19] VGND VPWR Tile_X0Y9_FrameStrobe[5] latch
XFILLER_131_147 VPWR VGND sg13cmos5l_decap_8
XFILLER_682_126 VPWR VGND sg13cmos5l_fill_1
X_3337_ Tile_X0Y2_FrameData_O[8] Tile_X0Y2_FrameData[8] VPWR VGND sg13cmos5l_buf_1
XFILLER_608_223 VPWR VGND sg13cmos5l_decap_4
XFILLER_533_63 VPWR VGND sg13cmos5l_decap_8
X_0549_ _0549_/Q Tile_X0Y8_FrameData[26] VGND VPWR Tile_X0Y9_FrameStrobe[4] latch
XFILLER_105_14 VPWR VGND sg13cmos5l_decap_8
XFILLER_419_145 VPWR VGND sg13cmos5l_decap_8
XFILLER_285_140 VPWR VGND sg13cmos5l_decap_8
XFILLER_252_42 VPWR VGND sg13cmos5l_decap_8
X_3268_ Tile_X0Y0_EE4BEG[4] _3824_/X VPWR VGND sg13cmos5l_buf_1
XFILLER_434_126 VPWR VGND sg13cmos5l_decap_8
XANTENNA__2755__X Tile_X0Y3_FrameData_O[13] VPWR VGND sg13cmos5l_antennanp
X_2219_ _2219_/Q Tile_X0Y5_FrameData[26] VGND VPWR Tile_X0Y9_FrameStrobe[1] latch
X_3199_ Tile_X0Y0_N2BEGb[7] _3903_/X VPWR VGND sg13cmos5l_buf_1
XFILLER_402_56 VPWR VGND sg13cmos5l_decap_8
XFILLER_53_131 VPWR VGND sg13cmos5l_decap_8
XFILLER_121_35 VPWR VGND sg13cmos5l_decap_8
XFILLER_442_170 VPWR VGND sg13cmos5l_decap_4
XFILLER_387_203 VPWR VGND sg13cmos5l_decap_8
XFILLER_442_192 VPWR VGND sg13cmos5l_fill_1
XFILLER_198_125 VPWR VGND sg13cmos5l_decap_4
XFILLER_81_28 VPWR VGND sg13cmos5l_decap_8
XFILLER_478_49 VPWR VGND sg13cmos5l_decap_8
XFILLER_157_7 VPWR VGND sg13cmos5l_decap_8
XFILLER_53_197 VPWR VGND sg13cmos5l_decap_8
XFILLER_197_28 VPWR VGND sg13cmos5l_decap_8
XFILLER_628_19 VPWR VGND sg13cmos5l_decap_8
XFILLER_139_203 VPWR VGND sg13cmos5l_decap_4
XANTENNA__3586__X Tile_X0Y9_FrameData_O[16] VPWR VGND sg13cmos5l_antennanp
XFILLER_324_7 VPWR VGND sg13cmos5l_decap_8
XFILLER_14_77 VPWR VGND sg13cmos5l_decap_8
XFILLER_355_133 VPWR VGND sg13cmos5l_decap_8
XFILLER_708_63 VPWR VGND sg13cmos5l_decap_8
XFILLER_154_228 VPWR VGND sg13cmos5l_fill_1
XFILLER_504_119 VPWR VGND sg13cmos5l_decap_8
XFILLER_427_42 VPWR VGND sg13cmos5l_decap_8
XFILLER_574_70 VPWR VGND sg13cmos5l_decap_8
XFILLER_370_147 VPWR VGND sg13cmos5l_decap_8
XFILLER_146_21 VPWR VGND sg13cmos5l_decap_8
XFILLER_658_112 VPWR VGND sg13cmos5l_decap_4
XFILLER_30_76 VPWR VGND sg13cmos5l_decap_4
XFILLER_693_7 VPWR VGND sg13cmos5l_decap_8
XFILLER_30_87 VPWR VGND sg13cmos5l_fill_1
XFILLER_107_199 VPWR VGND sg13cmos5l_decap_8
XFILLER_512_185 VPWR VGND sg13cmos5l_decap_8
XFILLER_457_218 VPWR VGND sg13cmos5l_fill_2
XFILLER_146_98 VPWR VGND sg13cmos5l_decap_8
XFILLER_660_28 VPWR VGND sg13cmos5l_decap_8
XFILLER_443_63 VPWR VGND sg13cmos5l_decap_8
XFILLER_39_41 VPWR VGND sg13cmos5l_decap_8
XFILLER_276_140 VPWR VGND sg13cmos5l_decap_8
XFILLER_590_91 VPWR VGND sg13cmos5l_decap_8
XFILLER_162_42 VPWR VGND sg13cmos5l_decap_8
XFILLER_130_191 VPWR VGND sg13cmos5l_fill_1
XFILLER_425_126 VPWR VGND sg13cmos5l_decap_8
XFILLER_183_0 VPWR VGND sg13cmos5l_decap_8
XFILLER_29_161 VPWR VGND sg13cmos5l_decap_8
XFILLER_291_165 VPWR VGND sg13cmos5l_decap_8
XFILLER_312_56 VPWR VGND sg13cmos5l_decap_8
XFILLER_350_0 VPWR VGND sg13cmos5l_decap_8
XFILLER_55_84 VPWR VGND sg13cmos5l_decap_4
XFILLER_189_114 VPWR VGND sg13cmos5l_decap_8
XFILLER_448_0 VPWR VGND sg13cmos5l_decap_8
XFILLER_579_196 VPWR VGND sg13cmos5l_decap_8
XFILLER_388_49 VPWR VGND sg13cmos5l_decap_8
XFILLER_685_14 VPWR VGND sg13cmos5l_decap_8
XFILLER_615_0 VPWR VGND sg13cmos5l_decap_8
XFILLER_393_228 VPWR VGND sg13cmos5l_fill_1
XANTENNA__3496__X Tile_X0Y1_E6BEG[6] VPWR VGND sg13cmos5l_antennanp
XFILLER_594_188 VPWR VGND sg13cmos5l_fill_2
XFILLER_346_133 VPWR VGND sg13cmos5l_decap_8
XFILLER_200_151 VPWR VGND sg13cmos5l_fill_1
XFILLER_72_7 VPWR VGND sg13cmos5l_decap_8
XFILLER_618_63 VPWR VGND sg13cmos5l_decap_8
XFILLER_200_173 VPWR VGND sg13cmos5l_decap_4
XFILLER_346_177 VPWR VGND sg13cmos5l_decap_8
XFILLER_346_199 VPWR VGND sg13cmos5l_fill_1
XFILLER_337_42 VPWR VGND sg13cmos5l_decap_8
X_2570_ _2570_/Q Tile_X0Y6_FrameData[29] VGND VPWR Tile_X0Y9_FrameStrobe[4] latch
X_1521_ _1521_/Q Tile_X0Y2_FrameData[0] VGND VPWR Tile_X0Y9_FrameStrobe[2] latch
XFILLER_649_112 VPWR VGND sg13cmos5l_decap_8
XFILLER_649_156 VPWR VGND sg13cmos5l_decap_8
XFILLER_113_114 VPWR VGND sg13cmos5l_decap_8
X_4240_ _4240_/X Tile_X0Y2_W2MID[5] Tile_X0Y2_W2END[5] Tile_X0Y2_W6END[10] _4101_/X
+ _1625_/Q _1624_/Q VPWR VGND sg13cmos5l_mux4_1
X_1452_ _1452_/Q Tile_X0Y2_FrameData[5] VGND VPWR Tile_X0Y9_FrameStrobe[0] latch
XFILLER_634_84 VPWR VGND sg13cmos5l_decap_8
XFILLER_503_196 VPWR VGND sg13cmos5l_decap_8
XFILLER_113_147 VPWR VGND sg13cmos5l_decap_4
XFILLER_206_35 VPWR VGND sg13cmos5l_decap_8
X_0403_ _0403_/Q Tile_X0Y7_FrameData[12] VGND VPWR Tile_X0Y9_FrameStrobe[7] latch
X_4171_ _4171_/X Tile_X0Y3_WW4END[8] AXI_M_SOC_BVALID _4230_/X _4205_/X _1799_/Q _1798_/Q
+ VPWR VGND sg13cmos5l_mux4_1
XFILLER_570_28 VPWR VGND sg13cmos5l_decap_8
XFILLER_353_63 VPWR VGND sg13cmos5l_decap_8
X_1383_ _1383_/Q Tile_X0Y1_FrameData[18] VGND VPWR Tile_X0Y9_FrameStrobe[6] latch
XFILLER_67_212 VPWR VGND sg13cmos5l_fill_1
X_3122_ Tile_X0Y7_EE4BEG[8] _4636_/X VPWR VGND sg13cmos5l_buf_1
XFILLER_121_180 VPWR VGND sg13cmos5l_decap_8
X_0334_ _0334_/Q Tile_X0Y7_FrameData[17] VGND VPWR Tile_X0Y9_FrameStrobe[5] latch
X_3053_ Tile_X0Y5_FrameData_O[12] Tile_X0Y5_FrameData[12] VPWR VGND sg13cmos5l_buf_1
XFILLER_503_77 VPWR VGND sg13cmos5l_decap_8
X_0265_ _0265_/Q Tile_X0Y7_FrameData[22] VGND VPWR Tile_X0Y9_FrameStrobe[3] latch
XFILLER_282_154 VPWR VGND sg13cmos5l_decap_8
XFILLER_222_56 VPWR VGND sg13cmos5l_decap_8
X_2004_ _2004_/Q Tile_X0Y4_FrameData[17] VGND VPWR Tile_X0Y9_FrameStrobe[2] latch
X_0196_ _0196_/Q Tile_X0Y7_FrameData[27] VGND VPWR Tile_X0Y9_FrameStrobe[1] latch
XFILLER_424_192 VPWR VGND sg13cmos5l_decap_8
XFILLER_369_225 VPWR VGND sg13cmos5l_decap_4
XFILLER_298_49 VPWR VGND sg13cmos5l_decap_8
XFILLER_659_70 VPWR VGND sg13cmos5l_decap_8
XFILLER_595_14 VPWR VGND sg13cmos5l_decap_8
X_3955_ _3955_/X Tile_X0Y1_WW4END[8] AXI_M_SOC_ARREADY _4016_/X _3989_/X _1299_/Q
+ _1298_/Q VPWR VGND sg13cmos5l_mux4_1
XFILLER_195_128 VPWR VGND sg13cmos5l_decap_8
XFILLER_384_228 VPWR VGND sg13cmos5l_fill_1
XFILLER_50_178 VPWR VGND sg13cmos5l_decap_4
X_2906_ Tile_X0Y6_FrameData_O[27] Tile_X0Y6_FrameData[27] VPWR VGND sg13cmos5l_buf_1
X_3886_ _3886_/X _3849_/X _0086_/X Tile_X0Y0_S1END[1] Tile_X0Y0_S4END[1] _0985_/Q
+ _0984_/Q VPWR VGND sg13cmos5l_mux4_1
X_2837_ Tile_X0Y6_E2BEG[2] _4498_/X VPWR VGND sg13cmos5l_buf_1
XFILLER_528_63 VPWR VGND sg13cmos5l_decap_8
XFILLER_136_217 VPWR VGND sg13cmos5l_fill_1
XFILLER_136_228 VPWR VGND sg13cmos5l_fill_1
XFILLER_675_91 VPWR VGND sg13cmos5l_decap_8
XFILLER_541_203 VPWR VGND sg13cmos5l_decap_8
XFILLER_337_199 VPWR VGND sg13cmos5l_decap_4
XFILLER_247_42 VPWR VGND sg13cmos5l_decap_8
X_2768_ Tile_X0Y3_FrameData_O[26] Tile_X0Y3_FrameData[26] VPWR VGND sg13cmos5l_buf_1
XFILLER_352_147 VPWR VGND sg13cmos5l_decap_8
X_4507_ _4507_/X Tile_X0Y6_W2END[4] AXI_M_SOC_RDATA28 _4559_/X _4558_/X _2593_/Q _2592_/Q
+ VPWR VGND sg13cmos5l_mux4_1
X_1719_ _1719_/Q Tile_X0Y3_FrameData[18] VGND VPWR Tile_X0Y9_FrameStrobe[1] latch
X_2699_ _4085_/A3 VPWR VGND sg13cmos5l_tielo
X_4438_ _4438_/X _4920_/X _4924_/X _4928_/X _4901_/X _0903_/Q _0902_/Q VPWR VGND sg13cmos5l_mux4_1
XFILLER_104_147 VPWR VGND sg13cmos5l_decap_8
XFILLER_544_84 VPWR VGND sg13cmos5l_decap_4
XFILLER_116_35 VPWR VGND sg13cmos5l_decap_8
XFILLER_655_126 VPWR VGND sg13cmos5l_decap_8
XFILLER_480_28 VPWR VGND sg13cmos5l_decap_8
XFILLER_263_63 VPWR VGND sg13cmos5l_decap_8
XFILLER_58_201 VPWR VGND sg13cmos5l_decap_8
XFILLER_263_74 VPWR VGND sg13cmos5l_fill_1
XFILLER_76_28 VPWR VGND sg13cmos5l_decap_8
X_4369_ _4369_/X _4421_/X _4420_/X AXI_M_SOC_RRESP0 _4419_/X _2365_/Q _2364_/Q VPWR
+ VGND sg13cmos5l_mux4_1
XFILLER_258_140 VPWR VGND sg13cmos5l_decap_4
XFILLER_258_151 VPWR VGND sg13cmos5l_decap_8
XFILLER_263_96 VPWR VGND sg13cmos5l_decap_8
XFILLER_670_107 VPWR VGND sg13cmos5l_fill_2
XFILLER_112_180 VPWR VGND sg13cmos5l_decap_8
XFILLER_462_221 VPWR VGND sg13cmos5l_decap_8
XFILLER_413_77 VPWR VGND sg13cmos5l_decap_8
XFILLER_274_7 VPWR VGND sg13cmos5l_decap_8
XFILLER_710_42 VPWR VGND sg13cmos5l_decap_8
XFILLER_132_56 VPWR VGND sg13cmos5l_decap_8
XFILLER_611_218 VPWR VGND sg13cmos5l_fill_2
XFILLER_273_187 VPWR VGND sg13cmos5l_decap_4
XFILLER_214_210 VPWR VGND sg13cmos5l_decap_8
XFILLER_415_170 VPWR VGND sg13cmos5l_decap_8
XFILLER_214_221 VPWR VGND sg13cmos5l_fill_1
XFILLER_92_49 VPWR VGND sg13cmos5l_decap_8
XFILLER_25_21 VPWR VGND sg13cmos5l_decap_8
XFILLER_441_7 VPWR VGND sg13cmos5l_decap_8
XFILLER_539_7 VPWR VGND sg13cmos5l_decap_8
XFILLER_430_140 VPWR VGND sg13cmos5l_decap_8
XFILLER_576_133 VPWR VGND sg13cmos5l_decap_8
XFILLER_569_70 VPWR VGND sg13cmos5l_decap_8
XFILLER_41_134 VPWR VGND sg13cmos5l_fill_1
XFILLER_576_199 VPWR VGND sg13cmos5l_decap_8
XFILLER_179_180 VPWR VGND sg13cmos5l_decap_8
XFILLER_706_7 VPWR VGND sg13cmos5l_decap_8
XFILLER_41_31 VPWR VGND sg13cmos5l_decap_8
XFILLER_655_28 VPWR VGND sg13cmos5l_decap_8
XFILLER_438_63 VPWR VGND sg13cmos5l_decap_8
XFILLER_585_91 VPWR VGND sg13cmos5l_decap_8
XFILLER_157_42 VPWR VGND sg13cmos5l_decap_8
XFILLER_532_225 VPWR VGND sg13cmos5l_decap_4
XFILLER_343_169 VPWR VGND sg13cmos5l_decap_8
XFILLER_497_140 VPWR VGND sg13cmos5l_decap_8
XFILLER_307_56 VPWR VGND sg13cmos5l_decap_8
XFILLER_9_0 VPWR VGND sg13cmos5l_decap_8
XFILLER_671_49 VPWR VGND sg13cmos5l_decap_8
XFILLER_500_133 VPWR VGND sg13cmos5l_decap_8
XFILLER_646_126 VPWR VGND sg13cmos5l_decap_8
XFILLER_604_21 VPWR VGND sg13cmos5l_decap_8
XFILLER_398_0 VPWR VGND sg13cmos5l_decap_8
XFILLER_390_28 VPWR VGND sg13cmos5l_decap_8
XFILLER_49_201 VPWR VGND sg13cmos5l_fill_2
XFILLER_173_63 VPWR VGND sg13cmos5l_decap_8
XFILLER_2_14 VPWR VGND sg13cmos5l_decap_8
XFILLER_249_151 VPWR VGND sg13cmos5l_decap_4
XFILLER_110_128 VPWR VGND sg13cmos5l_decap_8
XFILLER_604_98 VPWR VGND sg13cmos5l_fill_1
XFILLER_249_184 VPWR VGND sg13cmos5l_fill_1
XFILLER_565_0 VPWR VGND sg13cmos5l_decap_8
XFILLER_453_221 VPWR VGND sg13cmos5l_fill_1
XFILLER_66_94 VPWR VGND sg13cmos5l_decap_8
XFILLER_620_42 VPWR VGND sg13cmos5l_decap_8
X_0050_ AXI_M_SOC_AWLOCK _0937_/Q _3684_/X VPWR VGND sg13cmos5l_nor2b_1
XFILLER_17_120 VPWR VGND sg13cmos5l_fill_1
XFILLER_406_170 VPWR VGND sg13cmos5l_fill_2
XFILLER_17_142 VPWR VGND sg13cmos5l_fill_2
XFILLER_696_35 VPWR VGND sg13cmos5l_decap_8
XFILLER_421_140 VPWR VGND sg13cmos5l_decap_8
XFILLER_567_133 VPWR VGND sg13cmos5l_decap_8
XFILLER_479_70 VPWR VGND sg13cmos5l_fill_2
XFILLER_177_106 VPWR VGND sg13cmos5l_decap_8
XFILLER_366_206 VPWR VGND sg13cmos5l_decap_8
XFILLER_366_217 VPWR VGND sg13cmos5l_fill_2
XFILLER_268_19 VPWR VGND sg13cmos5l_decap_8
XANTENNA_19 Tile_X0Y0_S4END[12] VPWR VGND sg13cmos5l_antennanp
X_0952_ _0952_/Q Tile_X0Y0_FrameData[19] VGND VPWR Tile_X0Y9_FrameStrobe[0] latch
X_3740_ AXI_M_SOC_ARADDR12 Tile_X0Y9_W1END[0] Tile_X0Y9_WW4END[4] Tile_X0Y9_WW4END[12]
+ _4928_/X _0735_/Q _0734_/Q VPWR VGND sg13cmos5l_mux4_1
XFILLER_709_182 VPWR VGND sg13cmos5l_decap_8
XFILLER_629_84 VPWR VGND sg13cmos5l_decap_8
XFILLER_565_28 VPWR VGND sg13cmos5l_decap_8
XFILLER_348_63 VPWR VGND sg13cmos5l_decap_8
X_0883_ _0883_/Q Tile_X0Y9_FrameData[12] VGND VPWR Tile_X0Y9_FrameStrobe[6] latch
X_3671_ _3671_/X Tile_X0Y2_WW4END[1] Tile_X0Y2_WW4END[9] Tile_X0Y2_W6END[1] _4117_/X
+ _1503_/Q _1502_/Q VPWR VGND sg13cmos5l_mux4_1
XFILLER_495_91 VPWR VGND sg13cmos5l_decap_8
X_2622_ _2622_/Q Tile_X0Y6_FrameData[9] VGND VPWR Tile_X0Y9_FrameStrobe[5] latch
X_2553_ _2553_/Q Tile_X0Y6_FrameData[14] VGND VPWR Tile_X0Y9_FrameStrobe[3] latch
XFILLER_99_112 VPWR VGND sg13cmos5l_decap_8
X_1504_ _1504_/Q Tile_X0Y2_FrameData[17] VGND VPWR Tile_X0Y9_FrameStrobe[2] latch
XFILLER_217_56 VPWR VGND sg13cmos5l_decap_8
XFILLER_342_180 VPWR VGND sg13cmos5l_decap_4
X_2484_ _2484_/Q Tile_X0Y6_FrameData[19] VGND VPWR Tile_X0Y9_FrameStrobe[1] latch
XFILLER_581_49 VPWR VGND sg13cmos5l_decap_8
XFILLER_364_84 VPWR VGND sg13cmos5l_decap_8
XFILLER_637_126 VPWR VGND sg13cmos5l_decap_8
XFILLER_514_21 VPWR VGND sg13cmos5l_decap_8
X_1435_ _1435_/Q Tile_X0Y2_FrameData[22] VGND VPWR Tile_X0Y9_FrameStrobe[0] latch
X_4223_ _4223_/X _4197_/X _0088_/X _4196_/X Tile_X0Y0_S4END[13] _1727_/Q _1726_/Q
+ VPWR VGND sg13cmos5l_mux4_1
XFILLER_101_139 VPWR VGND sg13cmos5l_decap_8
X_4154_ _4154_/X Tile_X0Y3_W2MID[1] AXI_M_SOC_WREADY _4207_/X _4206_/X _1833_/Q _1832_/Q
+ VPWR VGND sg13cmos5l_mux4_1
X_1366_ _1366_/Q Tile_X0Y1_FrameData[3] VGND VPWR Tile_X0Y9_FrameStrobe[5] latch
XFILLER_514_98 VPWR VGND sg13cmos5l_decap_8
X_3105_ Tile_X0Y7_E6BEG[3] _4647_/X VPWR VGND sg13cmos5l_buf_1
X_0317_ _0317_/Q Tile_X0Y7_FrameData[2] VGND VPWR Tile_X0Y9_FrameStrobe[4] latch
XFILLER_233_77 VPWR VGND sg13cmos5l_decap_8
X_4085_ _4085_/X _4091_/X Tile_X0Y2_W6END[1] _4090_/X _4085_/A3 _1431_/Q _1430_/Q
+ VPWR VGND sg13cmos5l_mux4_1
X_1297_ _1297_/Q Tile_X0Y1_FrameData[8] VGND VPWR Tile_X0Y9_FrameStrobe[3] latch
XFILLER_530_42 VPWR VGND sg13cmos5l_decap_8
XFILLER_255_176 VPWR VGND sg13cmos5l_fill_1
X_3036_ Tile_X0Y5_EE4BEG[11] _4399_/X VPWR VGND sg13cmos5l_buf_1
X_0248_ _0248_/Q Tile_X0Y7_FrameData[7] VGND VPWR Tile_X0Y9_FrameStrobe[2] latch
X_0179_ _0179_/Q Tile_X0Y7_FrameData[12] VGND VPWR Tile_X0Y9_FrameStrobe[0] latch
XFILLER_357_217 VPWR VGND sg13cmos5l_decap_8
XFILLER_23_167 VPWR VGND sg13cmos5l_decap_8
XFILLER_357_228 VPWR VGND sg13cmos5l_fill_1
XFILLER_707_119 VPWR VGND sg13cmos5l_decap_8
XFILLER_23_178 VPWR VGND sg13cmos5l_fill_1
X_3938_ _3938_/X Tile_X0Y1_W2MID[1] AXI_M_SOC_ARREADY _3991_/X _3990_/X _1333_/Q _1332_/Q
+ VPWR VGND sg13cmos5l_mux4_1
XFILLER_573_147 VPWR VGND sg13cmos5l_decap_8
XFILLER_539_84 VPWR VGND sg13cmos5l_decap_4
XFILLER_372_209 VPWR VGND sg13cmos5l_decap_8
XFILLER_475_28 VPWR VGND sg13cmos5l_decap_8
XFILLER_258_63 VPWR VGND sg13cmos5l_decap_8
X_3869_ _3869_/X Tile_X0Y4_W1END[1] Tile_X0Y4_WW4END[1] Tile_X0Y4_W6END[9] _4337_/X
+ _2154_/Q _2153_/Q VPWR VGND sg13cmos5l_mux4_1
XFILLER_715_174 VPWR VGND sg13cmos5l_decap_8
XFILLER_124_209 VPWR VGND sg13cmos5l_fill_2
XFILLER_408_77 VPWR VGND sg13cmos5l_decap_8
XFILLER_11_56 VPWR VGND sg13cmos5l_decap_8
XFILLER_127_56 VPWR VGND sg13cmos5l_decap_8
XFILLER_705_42 VPWR VGND sg13cmos5l_decap_8
XFILLER_278_213 VPWR VGND sg13cmos5l_fill_1
XFILLER_491_49 VPWR VGND sg13cmos5l_decap_8
XFILLER_2_7 VPWR VGND sg13cmos5l_decap_8
XFILLER_479_184 VPWR VGND sg13cmos5l_decap_8
XFILLER_274_84 VPWR VGND sg13cmos5l_decap_8
XFILLER_424_21 VPWR VGND sg13cmos5l_decap_8
XFILLER_87_49 VPWR VGND sg13cmos5l_decap_8
XFILLER_391_7 VPWR VGND sg13cmos5l_decap_8
XFILLER_494_154 VPWR VGND sg13cmos5l_decap_8
XFILLER_489_7 VPWR VGND sg13cmos5l_decap_8
XFILLER_293_227 VPWR VGND sg13cmos5l_fill_2
XFILLER_424_98 VPWR VGND sg13cmos5l_decap_8
XFILLER_143_77 VPWR VGND sg13cmos5l_decap_8
XFILLER_100_161 VPWR VGND sg13cmos5l_decap_8
XFILLER_656_7 VPWR VGND sg13cmos5l_decap_8
XFILLER_246_154 VPWR VGND sg13cmos5l_decap_8
XANTENNA__3104__X Tile_X0Y7_E6BEG[2] VPWR VGND sg13cmos5l_antennanp
XFILLER_651_140 VPWR VGND sg13cmos5l_decap_8
XFILLER_440_42 VPWR VGND sg13cmos5l_decap_8
XFILLER_36_20 VPWR VGND sg13cmos5l_decap_8
XANTENNA__2943__X Tile_X0Y8_E6BEG[11] VPWR VGND sg13cmos5l_antennanp
XFILLER_36_86 VPWR VGND sg13cmos5l_decap_4
XFILLER_261_168 VPWR VGND sg13cmos5l_decap_8
XFILLER_299_70 VPWR VGND sg13cmos5l_decap_8
XFILLER_549_166 VPWR VGND sg13cmos5l_fill_2
XFILLER_146_0 VPWR VGND sg13cmos5l_decap_8
XFILLER_52_52 VPWR VGND sg13cmos5l_decap_8
XFILLER_666_49 VPWR VGND sg13cmos5l_decap_8
XFILLER_449_95 VPWR VGND sg13cmos5l_decap_8
XFILLER_385_28 VPWR VGND sg13cmos5l_decap_8
XFILLER_168_63 VPWR VGND sg13cmos5l_fill_2
XFILLER_505_203 VPWR VGND sg13cmos5l_decap_8
XFILLER_313_0 VPWR VGND sg13cmos5l_decap_8
XFILLER_167_183 VPWR VGND sg13cmos5l_decap_8
XFILLER_505_214 VPWR VGND sg13cmos5l_fill_2
XFILLER_316_125 VPWR VGND sg13cmos5l_fill_1
XFILLER_182_120 VPWR VGND sg13cmos5l_decap_8
XFILLER_316_147 VPWR VGND sg13cmos5l_decap_4
XFILLER_316_158 VPWR VGND sg13cmos5l_decap_8
XFILLER_520_206 VPWR VGND sg13cmos5l_fill_1
XFILLER_182_197 VPWR VGND sg13cmos5l_fill_2
XFILLER_520_228 VPWR VGND sg13cmos5l_fill_1
XFILLER_615_42 VPWR VGND sg13cmos5l_decap_8
XFILLER_324_180 VPWR VGND sg13cmos5l_fill_2
XFILLER_334_21 VPWR VGND sg13cmos5l_decap_8
XFILLER_682_0 VPWR VGND sg13cmos5l_decap_8
XFILLER_35_7 VPWR VGND sg13cmos5l_decap_8
XFILLER_96_137 VPWR VGND sg13cmos5l_fill_1
XFILLER_96_148 VPWR VGND sg13cmos5l_decap_8
X_1220_ _1220_/Q Tile_X0Y1_FrameData[21] VGND VPWR Tile_X0Y9_FrameStrobe[1] latch
XFILLER_426_210 VPWR VGND sg13cmos5l_decap_4
X_1151_ _1151_/Q Tile_X0Y0_FrameData[12] VGND VPWR Tile_X0Y9_FrameStrobe[6] latch
XFILLER_631_63 VPWR VGND sg13cmos5l_decap_8
XFILLER_203_14 VPWR VGND sg13cmos5l_decap_8
XANTENNA__3014__X Tile_X0Y5_E6BEG[1] VPWR VGND sg13cmos5l_antennanp
XFILLER_642_140 VPWR VGND sg13cmos5l_decap_8
X_0102_ AXI_M_SOC_ARLEN5 _0933_/Q _3765_/X VPWR VGND sg13cmos5l_nor2b_1
XFILLER_350_42 VPWR VGND sg13cmos5l_decap_8
X_1082_ _1082_/Q Tile_X0Y0_FrameData[17] VGND VPWR Tile_X0Y9_FrameStrobe[4] latch
XFILLER_587_228 VPWR VGND sg13cmos5l_fill_1
XANTENNA__2853__X Tile_X0Y6_E6BEG[2] VPWR VGND sg13cmos5l_antennanp
X_4910_ _4910_/X Tile_X0Y5_W1END[1] Tile_X0Y5_WW4END[13] Tile_X0Y5_W6END[5] _4452_/X
+ _2376_/Q _2375_/Q VPWR VGND sg13cmos5l_mux4_1
XFILLER_93_92 VPWR VGND sg13cmos5l_decap_8
XFILLER_500_56 VPWR VGND sg13cmos5l_decap_8
X_4841_ _4841_/X _4922_/X _4926_/X _4930_/X _4902_/X _0861_/Q _0860_/Q VPWR VGND sg13cmos5l_mux4_1
X_4772_ _4772_/X _4777_/X Tile_X0Y8_W6END[0] _4776_/X _4772_/A3 _0423_/Q _0422_/Q
+ VPWR VGND sg13cmos5l_mux4_1
XFILLER_576_49 VPWR VGND sg13cmos5l_decap_8
XFILLER_20_126 VPWR VGND sg13cmos5l_decap_4
X_1984_ _1984_/Q Tile_X0Y4_FrameData[5] VGND VPWR Tile_X0Y9_FrameStrobe[1] latch
XFILLER_359_84 VPWR VGND sg13cmos5l_decap_8
XFILLER_509_21 VPWR VGND sg13cmos5l_decap_8
X_3723_ _3723_/X Tile_X0Y3_WW4END[0] Tile_X0Y3_WW4END[8] Tile_X0Y3_W6END[8] _4230_/X
+ _1741_/Q _1740_/Q VPWR VGND sg13cmos5l_mux4_1
XFILLER_295_28 VPWR VGND sg13cmos5l_decap_8
X_0935_ _0935_/Q Tile_X0Y9_FrameData[26] VGND VPWR Tile_X0Y9_FrameStrobe[8] latch
XFILLER_9_160 VPWR VGND sg13cmos5l_fill_1
XFILLER_9_182 VPWR VGND sg13cmos5l_fill_2
XFILLER_173_120 VPWR VGND sg13cmos5l_decap_4
X_0866_ _0866_/Q Tile_X0Y9_FrameData[29] VGND VPWR Tile_X0Y9_FrameStrobe[6] latch
X_3654_ AXI_M_SOC_AWADDR15 Tile_X0Y5_W1END[3] Tile_X0Y5_WW4END[7] Tile_X0Y5_WW4END[15]
+ _4466_/X _2241_/Q _2240_/Q VPWR VGND sg13cmos5l_mux4_1
XFILLER_61_0 VPWR VGND sg13cmos5l_fill_1
XFILLER_509_98 VPWR VGND sg13cmos5l_decap_8
XFILLER_712_133 VPWR VGND sg13cmos5l_decap_8
X_2605_ _2605_/Q Tile_X0Y6_FrameData[26] VGND VPWR Tile_X0Y9_FrameStrobe[5] latch
XFILLER_228_77 VPWR VGND sg13cmos5l_decap_8
X_0797_ _0797_/Q Tile_X0Y9_FrameData[2] VGND VPWR Tile_X0Y9_FrameStrobe[3] latch
X_3585_ Tile_X0Y9_FrameData_O[15] Tile_X0Y9_FrameData[15] VPWR VGND sg13cmos5l_buf_1
XFILLER_511_217 VPWR VGND sg13cmos5l_fill_1
XFILLER_525_42 VPWR VGND sg13cmos5l_decap_8
XFILLER_114_220 VPWR VGND sg13cmos5l_fill_1
XFILLER_315_180 VPWR VGND sg13cmos5l_fill_2
X_2536_ _2536_/Q Tile_X0Y6_FrameData[31] VGND VPWR Tile_X0Y9_FrameStrobe[3] latch
XFILLER_672_70 VPWR VGND sg13cmos5l_decap_8
XFILLER_244_21 VPWR VGND sg13cmos5l_decap_8
X_2467_ _2467_/Q Tile_X0Y6_FrameData[4] VGND VPWR Tile_X0Y9_FrameStrobe[0] latch
XFILLER_476_154 VPWR VGND sg13cmos5l_decap_8
XFILLER_391_60 VPWR VGND sg13cmos5l_fill_2
XFILLER_275_205 VPWR VGND sg13cmos5l_fill_1
XFILLER_391_71 VPWR VGND sg13cmos5l_fill_1
XFILLER_87_148 VPWR VGND sg13cmos5l_decap_8
X_4206_ _4206_/X _4141_/X _4249_/X _4248_/X _4140_/X _1685_/Q _1684_/Q VPWR VGND sg13cmos5l_mux4_1
XFILLER_476_187 VPWR VGND sg13cmos5l_decap_4
X_1418_ _1418_/Q Tile_X0Y1_FrameData[15] VGND VPWR Tile_X0Y9_FrameStrobe[7] latch
X_2398_ _2398_/Q Tile_X0Y5_FrameData[7] VGND VPWR Tile_X0Y9_FrameStrobe[6] latch
XFILLER_417_221 VPWR VGND sg13cmos5l_fill_1
XFILLER_618_181 VPWR VGND sg13cmos5l_decap_8
X_1349_ _1349_/Q Tile_X0Y1_FrameData[20] VGND VPWR Tile_X0Y9_FrameStrobe[5] latch
X_4137_ _4137_/X Tile_X0Y4_W2MID[3] Tile_X0Y4_W2END[3] Tile_X0Y4_W6END[3] _4318_/X
+ _2165_/Q _2164_/Q VPWR VGND sg13cmos5l_mux4_1
XFILLER_541_63 VPWR VGND sg13cmos5l_decap_8
XFILLER_113_14 VPWR VGND sg13cmos5l_decap_8
XFILLER_260_42 VPWR VGND sg13cmos5l_decap_8
X_4068_ _4068_/X Tile_X0Y2_WW4END[3] AXI_M_SOC_AWREADY _4119_/X _4103_/X _1537_/Q
+ _1536_/Q VPWR VGND sg13cmos5l_mux4_1
XFILLER_578_217 VPWR VGND sg13cmos5l_fill_2
XFILLER_243_146 VPWR VGND sg13cmos5l_decap_8
XANTENNA__2763__X Tile_X0Y3_FrameData_O[21] VPWR VGND sg13cmos5l_antennanp
X_3019_ Tile_X0Y5_E6BEG[6] _4410_/X VPWR VGND sg13cmos5l_buf_1
XFILLER_410_56 VPWR VGND sg13cmos5l_decap_8
XFILLER_397_183 VPWR VGND sg13cmos5l_decap_8
XFILLER_237_7 VPWR VGND sg13cmos5l_decap_8
XFILLER_486_49 VPWR VGND sg13cmos5l_decap_8
XFILLER_269_84 VPWR VGND sg13cmos5l_decap_8
XFILLER_419_21 VPWR VGND sg13cmos5l_decap_8
XFILLER_345_209 VPWR VGND sg13cmos5l_decap_4
XFILLER_149_161 VPWR VGND sg13cmos5l_decap_8
XANTENNA__3594__X Tile_X0Y9_FrameData_O[24] VPWR VGND sg13cmos5l_antennanp
XFILLER_404_7 VPWR VGND sg13cmos5l_decap_8
XFILLER_419_98 VPWR VGND sg13cmos5l_decap_8
XFILLER_22_77 VPWR VGND sg13cmos5l_decap_8
XFILLER_22_99 VPWR VGND sg13cmos5l_fill_1
XFILLER_138_77 VPWR VGND sg13cmos5l_decap_8
XFILLER_502_217 VPWR VGND sg13cmos5l_decap_8
XFILLER_313_117 VPWR VGND sg13cmos5l_decap_8
XFILLER_502_228 VPWR VGND sg13cmos5l_fill_1
XFILLER_313_139 VPWR VGND sg13cmos5l_decap_8
XFILLER_105_220 VPWR VGND sg13cmos5l_fill_1
XFILLER_435_42 VPWR VGND sg13cmos5l_decap_8
XFILLER_582_70 VPWR VGND sg13cmos5l_decap_8
XFILLER_154_21 VPWR VGND sg13cmos5l_decap_8
XFILLER_656_221 VPWR VGND sg13cmos5l_fill_1
XFILLER_467_132 VPWR VGND sg13cmos5l_decap_8
XANTENNA__2938__X Tile_X0Y8_E6BEG[6] VPWR VGND sg13cmos5l_antennanp
XFILLER_467_143 VPWR VGND sg13cmos5l_fill_1
XFILLER_120_223 VPWR VGND sg13cmos5l_decap_4
XFILLER_78_148 VPWR VGND sg13cmos5l_fill_2
XFILLER_321_194 VPWR VGND sg13cmos5l_decap_8
XFILLER_266_227 VPWR VGND sg13cmos5l_fill_2
XFILLER_467_187 VPWR VGND sg13cmos5l_decap_8
XFILLER_93_107 VPWR VGND sg13cmos5l_decap_8
XFILLER_304_35 VPWR VGND sg13cmos5l_decap_8
XFILLER_609_181 VPWR VGND sg13cmos5l_decap_8
XFILLER_451_63 VPWR VGND sg13cmos5l_decap_8
XFILLER_47_52 VPWR VGND sg13cmos5l_decap_8
XFILLER_170_42 VPWR VGND sg13cmos5l_decap_8
XFILLER_624_173 VPWR VGND sg13cmos5l_decap_4
XFILLER_569_228 VPWR VGND sg13cmos5l_fill_1
XFILLER_263_0 VPWR VGND sg13cmos5l_decap_8
XFILLER_234_157 VPWR VGND sg13cmos5l_decap_4
XFILLER_601_77 VPWR VGND sg13cmos5l_decap_8
XFILLER_601_88 VPWR VGND sg13cmos5l_fill_2
XFILLER_601_99 VPWR VGND sg13cmos5l_fill_1
XFILLER_320_56 VPWR VGND sg13cmos5l_decap_8
XFILLER_103_91 VPWR VGND sg13cmos5l_fill_2
XFILLER_430_0 VPWR VGND sg13cmos5l_decap_8
XFILLER_528_0 VPWR VGND sg13cmos5l_decap_8
XFILLER_179_73 VPWR VGND sg13cmos5l_decap_8
XFILLER_396_49 VPWR VGND sg13cmos5l_decap_8
XFILLER_8_35 VPWR VGND sg13cmos5l_decap_8
XFILLER_329_21 VPWR VGND sg13cmos5l_decap_8
XFILLER_693_14 VPWR VGND sg13cmos5l_decap_8
XFILLER_476_60 VPWR VGND sg13cmos5l_fill_2
X_0720_ _0720_/Q Tile_X0Y9_FrameData[15] VGND VPWR Tile_X0Y9_FrameStrobe[1] latch
XFILLER_155_142 VPWR VGND sg13cmos5l_fill_2
X_0651_ _0651_/Q Tile_X0Y8_FrameData[20] VGND VPWR Tile_X0Y9_FrameStrobe[7] latch
XFILLER_626_63 VPWR VGND sg13cmos5l_decap_8
XFILLER_560_150 VPWR VGND sg13cmos5l_decap_8
XANTENNA__3009__X Tile_X0Y5_E2BEGb[4] VPWR VGND sg13cmos5l_antennanp
XFILLER_345_42 VPWR VGND sg13cmos5l_decap_8
X_3370_ Tile_X0Y2_EE4BEG[9] _4065_/X VPWR VGND sg13cmos5l_buf_1
X_0582_ _0582_/Q Tile_X0Y8_FrameData[25] VGND VPWR Tile_X0Y9_FrameStrobe[5] latch
XFILLER_647_210 VPWR VGND sg13cmos5l_decap_8
XFILLER_492_70 VPWR VGND sg13cmos5l_decap_8
XFILLER_170_189 VPWR VGND sg13cmos5l_fill_1
XANTENNA__2848__X Tile_X0Y6_E2BEGb[5] VPWR VGND sg13cmos5l_antennanp
X_2321_ _2321_/Q Tile_X0Y5_FrameData[20] VGND VPWR Tile_X0Y9_FrameStrobe[4] latch
XFILLER_69_126 VPWR VGND sg13cmos5l_decap_8
XFILLER_312_172 VPWR VGND sg13cmos5l_fill_1
XFILLER_312_183 VPWR VGND sg13cmos5l_decap_8
X_2252_ _2252_/Q Tile_X0Y5_FrameData[25] VGND VPWR Tile_X0Y9_FrameStrobe[2] latch
XFILLER_458_198 VPWR VGND sg13cmos5l_fill_2
XFILLER_642_84 VPWR VGND sg13cmos5l_decap_8
XFILLER_214_35 VPWR VGND sg13cmos5l_decap_8
X_1203_ _1203_/Q Tile_X0Y1_FrameData[6] VGND VPWR Tile_X0Y9_FrameStrobe[0] latch
XFILLER_473_146 VPWR VGND sg13cmos5l_fill_1
XFILLER_361_63 VPWR VGND sg13cmos5l_decap_8
X_2183_ _2183_/Q Tile_X0Y5_FrameData[30] VGND VPWR Tile_X0Y9_FrameStrobe[0] latch
XFILLER_225_102 VPWR VGND sg13cmos5l_fill_1
X_1134_ _1134_/Q Tile_X0Y0_FrameData[29] VGND VPWR Tile_X0Y9_FrameStrobe[6] latch
XFILLER_92_162 VPWR VGND sg13cmos5l_fill_1
XFILLER_25_218 VPWR VGND sg13cmos5l_decap_4
XFILLER_511_77 VPWR VGND sg13cmos5l_decap_8
X_1065_ _1065_/Q Tile_X0Y0_FrameData[2] VGND VPWR Tile_X0Y9_FrameStrobe[3] latch
XFILLER_225_179 VPWR VGND sg13cmos5l_fill_1
XFILLER_230_56 VPWR VGND sg13cmos5l_decap_8
XFILLER_394_120 VPWR VGND sg13cmos5l_decap_8
XFILLER_717_225 VPWR VGND sg13cmos5l_decap_4
X_4824_ _4824_/X Tile_X0Y9_W1END[0] Tile_X0Y9_W6END[8] _4928_/X _4892_/X _0891_/Q
+ _0890_/Q VPWR VGND sg13cmos5l_mux4_1
XFILLER_667_70 VPWR VGND sg13cmos5l_decap_8
XFILLER_239_21 VPWR VGND sg13cmos5l_decap_8
XFILLER_193_204 VPWR VGND sg13cmos5l_fill_1
X_4755_ _4755_/X Tile_X0Y8_WW4END[4] AXI_M_SOC_RDATA12 _4804_/X _4790_/X _0537_/Q
+ _0536_/Q VPWR VGND sg13cmos5l_mux4_1
XFILLER_193_226 VPWR VGND sg13cmos5l_fill_2
X_1967_ _1967_/Q Tile_X0Y4_FrameData[22] VGND VPWR Tile_X0Y9_FrameStrobe[1] latch
XFILLER_335_220 VPWR VGND sg13cmos5l_fill_2
X_3706_ AXI_M_SOC_WDATA16 Tile_X0Y6_WW4END[0] Tile_X0Y6_WW4END[8] Tile_X0Y6_W6END[0]
+ _4568_/X _2527_/Q _2526_/Q VPWR VGND sg13cmos5l_mux4_1
X_0918_ _0918_/Q Tile_X0Y9_FrameData[9] VGND VPWR Tile_X0Y9_FrameStrobe[7] latch
XFILLER_239_98 VPWR VGND sg13cmos5l_decap_4
X_4686_ _4686_/X _4665_/X Tile_X0Y9_N4END[10] _4664_/X _0054_/X _0211_/Q _0210_/Q
+ VPWR VGND sg13cmos5l_mux4_1
X_1898_ _1898_/Q Tile_X0Y3_FrameData[31] VGND VPWR Tile_X0Y9_FrameStrobe[7] latch
XFILLER_161_101 VPWR VGND sg13cmos5l_decap_8
X_3637_ Tile_X0Y9_S4BEG[15] _3637_/A VPWR VGND sg13cmos5l_buf_1
XFILLER_536_63 VPWR VGND sg13cmos5l_decap_8
XFILLER_108_14 VPWR VGND sg13cmos5l_decap_8
X_0849_ _0849_/Q Tile_X0Y9_FrameData[14] VGND VPWR Tile_X0Y9_FrameStrobe[5] latch
XFILLER_700_114 VPWR VGND sg13cmos5l_decap_8
XFILLER_683_91 VPWR VGND sg13cmos5l_decap_8
XFILLER_255_42 VPWR VGND sg13cmos5l_decap_8
X_3568_ Tile_X0Y9_EE4BEG[14] _4878_/X VPWR VGND sg13cmos5l_buf_1
XANTENNA__2758__X Tile_X0Y3_FrameData_O[16] VPWR VGND sg13cmos5l_antennanp
X_2519_ _2519_/Q Tile_X0Y6_FrameData[16] VGND VPWR Tile_X0Y9_FrameStrobe[2] latch
X_3499_ Tile_X0Y1_E6BEG[9] _3973_/X VPWR VGND sg13cmos5l_buf_1
XFILLER_303_183 VPWR VGND sg13cmos5l_decap_8
XFILLER_102_223 VPWR VGND sg13cmos5l_decap_4
XFILLER_405_56 VPWR VGND sg13cmos5l_decap_8
XFILLER_552_84 VPWR VGND sg13cmos5l_decap_8
XFILLER_464_124 VPWR VGND sg13cmos5l_decap_8
XFILLER_702_21 VPWR VGND sg13cmos5l_decap_4
XFILLER_75_129 VPWR VGND sg13cmos5l_decap_8
XFILLER_271_63 VPWR VGND sg13cmos5l_decap_8
XFILLER_68_170 VPWR VGND sg13cmos5l_decap_8
XFILLER_124_68 VPWR VGND sg13cmos5l_decap_8
XFILLER_187_7 VPWR VGND sg13cmos5l_decap_8
XFILLER_84_28 VPWR VGND sg13cmos5l_decap_8
XFILLER_702_87 VPWR VGND sg13cmos5l_decap_8
XFILLER_405_224 VPWR VGND sg13cmos5l_decap_4
XFILLER_216_135 VPWR VGND sg13cmos5l_fill_1
XFILLER_606_195 VPWR VGND sg13cmos5l_fill_1
XANTENNA__3589__X Tile_X0Y9_FrameData_O[19] VPWR VGND sg13cmos5l_antennanp
XFILLER_621_132 VPWR VGND sg13cmos5l_decap_8
XFILLER_421_77 VPWR VGND sg13cmos5l_decap_8
XFILLER_621_143 VPWR VGND sg13cmos5l_fill_2
XFILLER_216_168 VPWR VGND sg13cmos5l_fill_2
XFILLER_354_7 VPWR VGND sg13cmos5l_decap_8
XFILLER_140_56 VPWR VGND sg13cmos5l_decap_8
XFILLER_169_212 VPWR VGND sg13cmos5l_decap_8
XFILLER_621_198 VPWR VGND sg13cmos5l_decap_8
XFILLER_33_10 VPWR VGND sg13cmos5l_decap_8
XFILLER_521_7 VPWR VGND sg13cmos5l_decap_8
XFILLER_619_7 VPWR VGND sg13cmos5l_decap_8
XFILLER_577_70 VPWR VGND sg13cmos5l_decap_8
XFILLER_149_21 VPWR VGND sg13cmos5l_decap_8
XFILLER_385_164 VPWR VGND sg13cmos5l_decap_8
XFILLER_184_215 VPWR VGND sg13cmos5l_decap_8
XFILLER_33_87 VPWR VGND sg13cmos5l_decap_8
XFILLER_137_175 VPWR VGND sg13cmos5l_decap_8
XFILLER_663_28 VPWR VGND sg13cmos5l_decap_8
XFILLER_446_63 VPWR VGND sg13cmos5l_decap_8
XFILLER_341_223 VPWR VGND sg13cmos5l_decap_4
XFILLER_3_122 VPWR VGND sg13cmos5l_decap_8
XFILLER_165_42 VPWR VGND sg13cmos5l_decap_8
XFILLER_109_0 VPWR VGND sg13cmos5l_decap_8
XFILLER_152_178 VPWR VGND sg13cmos5l_decap_4
XFILLER_315_56 VPWR VGND sg13cmos5l_decap_8
XFILLER_315_67 VPWR VGND sg13cmos5l_fill_2
XFILLER_612_21 VPWR VGND sg13cmos5l_decap_8
XFILLER_58_73 VPWR VGND sg13cmos5l_decap_8
XFILLER_380_0 VPWR VGND sg13cmos5l_decap_8
XFILLER_478_0 VPWR VGND sg13cmos5l_decap_8
XFILLER_66_129 VPWR VGND sg13cmos5l_decap_8
XFILLER_181_63 VPWR VGND sg13cmos5l_decap_4
XFILLER_59_181 VPWR VGND sg13cmos5l_decap_8
XFILLER_688_14 VPWR VGND sg13cmos5l_decap_8
XFILLER_612_98 VPWR VGND sg13cmos5l_decap_8
XANTENNA__3499__X Tile_X0Y1_E6BEG[9] VPWR VGND sg13cmos5l_antennanp
XFILLER_645_0 VPWR VGND sg13cmos5l_decap_8
XFILLER_331_77 VPWR VGND sg13cmos5l_decap_8
XFILLER_207_168 VPWR VGND sg13cmos5l_decap_8
XFILLER_411_227 VPWR VGND sg13cmos5l_fill_2
XFILLER_612_187 VPWR VGND sg13cmos5l_decap_4
XFILLER_612_198 VPWR VGND sg13cmos5l_fill_2
XFILLER_565_220 VPWR VGND sg13cmos5l_fill_2
X_2870_ Tile_X0Y6_EE4BEG[7] _4519_/X VPWR VGND sg13cmos5l_buf_1
XFILLER_487_70 VPWR VGND sg13cmos5l_decap_8
XFILLER_309_209 VPWR VGND sg13cmos5l_decap_4
XFILLER_230_171 VPWR VGND sg13cmos5l_decap_8
X_1821_ _1821_/Q Tile_X0Y3_FrameData[12] VGND VPWR Tile_X0Y9_FrameStrobe[4] latch
XFILLER_714_228 VPWR VGND sg13cmos5l_fill_1
X_4540_ _4540_/X _4545_/X Tile_X0Y6_W6END[0] _4544_/X _4540_/A3 _2447_/Q _2446_/Q
+ VPWR VGND sg13cmos5l_mux4_1
X_1752_ _1752_/Q Tile_X0Y3_FrameData[17] VGND VPWR Tile_X0Y9_FrameStrobe[2] latch
XFILLER_637_84 VPWR VGND sg13cmos5l_decap_8
XFILLER_128_153 VPWR VGND sg13cmos5l_fill_1
XFILLER_209_35 VPWR VGND sg13cmos5l_decap_8
X_0703_ _0703_/Q Tile_X0Y9_FrameData[0] VGND VPWR Tile_X0Y9_FrameStrobe[0] latch
XFILLER_573_28 VPWR VGND sg13cmos5l_decap_8
XFILLER_356_63 VPWR VGND sg13cmos5l_decap_8
X_4471_ _4471_/X Tile_X0Y7_W2MID[6] Tile_X0Y7_W2END[6] Tile_X0Y7_W6END[6] _4671_/X
+ _0405_/Q _0404_/Q VPWR VGND sg13cmos5l_mux4_1
XFILLER_143_112 VPWR VGND sg13cmos5l_decap_8
X_1683_ _1683_/Q Tile_X0Y3_FrameData[22] VGND VPWR Tile_X0Y9_FrameStrobe[0] latch
XFILLER_289_105 VPWR VGND sg13cmos5l_decap_8
X_3422_ Tile_X0Y4_FrameData_O[13] Tile_X0Y4_FrameData[13] VPWR VGND sg13cmos5l_buf_1
XFILLER_99_91 VPWR VGND sg13cmos5l_decap_8
X_0634_ _0634_/Q Tile_X0Y8_FrameData[5] VGND VPWR Tile_X0Y9_FrameStrobe[6] latch
XFILLER_679_198 VPWR VGND sg13cmos5l_decap_4
XFILLER_694_146 VPWR VGND sg13cmos5l_decap_8
XFILLER_143_189 VPWR VGND sg13cmos5l_decap_8
XFILLER_506_77 VPWR VGND sg13cmos5l_decap_8
X_0565_ _0565_/Q Tile_X0Y8_FrameData[10] VGND VPWR Tile_X0Y9_FrameStrobe[4] latch
X_3353_ Tile_X0Y2_FrameData_O[24] Tile_X0Y2_FrameData[24] VPWR VGND sg13cmos5l_buf_1
XFILLER_694_168 VPWR VGND sg13cmos5l_decap_8
XFILLER_297_160 VPWR VGND sg13cmos5l_fill_2
XFILLER_225_56 VPWR VGND sg13cmos5l_decap_8
X_2304_ _2304_/Q Tile_X0Y5_FrameData[5] VGND VPWR Tile_X0Y9_FrameStrobe[3] latch
X_0496_ _0496_/Q Tile_X0Y8_FrameData[15] VGND VPWR Tile_X0Y9_FrameStrobe[2] latch
X_3284_ Tile_X0Y0_E6BEG[4] _3840_/X VPWR VGND sg13cmos5l_buf_1
XFILLER_57_107 VPWR VGND sg13cmos5l_fill_2
XFILLER_372_84 VPWR VGND sg13cmos5l_decap_8
XFILLER_522_21 VPWR VGND sg13cmos5l_decap_8
XFILLER_24_0 VPWR VGND sg13cmos5l_decap_8
X_2235_ _2235_/Q Tile_X0Y5_FrameData[10] VGND VPWR Tile_X0Y9_FrameStrobe[1] latch
X_2166_ _2166_/Q Tile_X0Y4_FrameData[15] VGND VPWR Tile_X0Y9_FrameStrobe[7] latch
XFILLER_598_14 VPWR VGND sg13cmos5l_decap_8
XFILLER_522_98 VPWR VGND sg13cmos5l_fill_1
XFILLER_65_162 VPWR VGND sg13cmos5l_decap_8
XFILLER_399_223 VPWR VGND sg13cmos5l_decap_4
X_1117_ _1117_/Q Tile_X0Y0_FrameData[14] VGND VPWR Tile_X0Y9_FrameStrobe[5] latch
XFILLER_241_77 VPWR VGND sg13cmos5l_decap_8
XFILLER_80_121 VPWR VGND sg13cmos5l_decap_8
X_2097_ _2097_/Q Tile_X0Y4_FrameData[20] VGND VPWR Tile_X0Y9_FrameStrobe[5] latch
XFILLER_213_105 VPWR VGND sg13cmos5l_decap_8
XANTENNA__3202__X Tile_X0Y0_N2BEG[2] VPWR VGND sg13cmos5l_antennanp
XFILLER_402_227 VPWR VGND sg13cmos5l_fill_2
XFILLER_80_154 VPWR VGND sg13cmos5l_decap_8
X_1048_ _1048_/Q Tile_X0Y0_FrameData[19] VGND VPWR Tile_X0Y9_FrameStrobe[3] latch
XFILLER_678_91 VPWR VGND sg13cmos5l_decap_8
XFILLER_397_70 VPWR VGND sg13cmos5l_decap_8
XFILLER_166_204 VPWR VGND sg13cmos5l_decap_8
X_4807_ _4807_/X _4783_/X Tile_X0Y9_N4END[7] _4782_/X _0074_/X _0457_/Q _0456_/Q VPWR
+ VGND sg13cmos5l_mux4_1
XFILLER_571_212 VPWR VGND sg13cmos5l_fill_1
X_2999_ Tile_X0Y5_E2BEG[2] _4374_/X VPWR VGND sg13cmos5l_buf_1
XFILLER_516_139 VPWR VGND sg13cmos5l_decap_4
X_4738_ _4738_/X Tile_X0Y8_W2END[5] AXI_M_SOC_RDATA13 _4789_/X _4788_/X _0571_/Q _0570_/Q
+ VPWR VGND sg13cmos5l_mux4_1
XFILLER_547_84 VPWR VGND sg13cmos5l_decap_8
XFILLER_119_35 VPWR VGND sg13cmos5l_decap_8
XFILLER_483_28 VPWR VGND sg13cmos5l_decap_8
XFILLER_266_63 VPWR VGND sg13cmos5l_decap_8
XFILLER_134_112 VPWR VGND sg13cmos5l_decap_8
X_4669_ _4669_/X _4585_/X _4701_/X _4700_/X _4584_/X _0183_/Q _0182_/Q VPWR VGND sg13cmos5l_mux4_1
XFILLER_79_28 VPWR VGND sg13cmos5l_decap_8
XFILLER_102_7 VPWR VGND sg13cmos5l_decap_8
XFILLER_416_77 VPWR VGND sg13cmos5l_decap_8
XFILLER_295_119 VPWR VGND sg13cmos5l_decap_4
XFILLER_135_56 VPWR VGND sg13cmos5l_decap_8
XFILLER_713_42 VPWR VGND sg13cmos5l_decap_8
XFILLER_282_84 VPWR VGND sg13cmos5l_decap_8
XFILLER_437_135 VPWR VGND sg13cmos5l_fill_2
XFILLER_432_21 VPWR VGND sg13cmos5l_decap_8
XFILLER_95_49 VPWR VGND sg13cmos5l_decap_8
XFILLER_471_7 VPWR VGND sg13cmos5l_decap_8
XFILLER_28_21 VPWR VGND sg13cmos5l_decap_8
XFILLER_569_7 VPWR VGND sg13cmos5l_decap_8
XFILLER_641_216 VPWR VGND sg13cmos5l_fill_1
XFILLER_432_98 VPWR VGND sg13cmos5l_decap_8
XFILLER_28_98 VPWR VGND sg13cmos5l_fill_2
XFILLER_56_173 VPWR VGND sg13cmos5l_decap_8
XFILLER_301_14 VPWR VGND sg13cmos5l_decap_8
XANTENNA__3112__X Tile_X0Y7_E6BEG[10] VPWR VGND sg13cmos5l_antennanp
XFILLER_204_105 VPWR VGND sg13cmos5l_decap_8
XFILLER_44_20 VPWR VGND sg13cmos5l_decap_8
XFILLER_658_28 VPWR VGND sg13cmos5l_decap_8
XFILLER_71_176 VPWR VGND sg13cmos5l_decap_8
XFILLER_588_91 VPWR VGND sg13cmos5l_decap_8
XANTENNA__2951__X Tile_X0Y8_EE4BEG[7] VPWR VGND sg13cmos5l_antennanp
XFILLER_44_75 VPWR VGND sg13cmos5l_decap_8
XFILLER_358_164 VPWR VGND sg13cmos5l_fill_1
XFILLER_157_204 VPWR VGND sg13cmos5l_decap_8
XFILLER_212_182 VPWR VGND sg13cmos5l_decap_8
XFILLER_562_212 VPWR VGND sg13cmos5l_fill_1
XFILLER_373_112 VPWR VGND sg13cmos5l_decap_8
XFILLER_358_186 VPWR VGND sg13cmos5l_decap_4
XFILLER_100_70 VPWR VGND sg13cmos5l_decap_8
XFILLER_226_0 VPWR VGND sg13cmos5l_decap_8
XFILLER_674_49 VPWR VGND sg13cmos5l_decap_8
XFILLER_60_63 VPWR VGND sg13cmos5l_decap_8
XFILLER_607_21 VPWR VGND sg13cmos5l_decap_8
XFILLER_393_28 VPWR VGND sg13cmos5l_decap_8
XFILLER_5_14 VPWR VGND sg13cmos5l_decap_8
XFILLER_176_96 VPWR VGND sg13cmos5l_decap_8
XFILLER_125_145 VPWR VGND sg13cmos5l_fill_1
XFILLER_530_131 VPWR VGND sg13cmos5l_decap_8
XFILLER_595_0 VPWR VGND sg13cmos5l_decap_8
XFILLER_473_72 VPWR VGND sg13cmos5l_fill_1
XFILLER_530_175 VPWR VGND sg13cmos5l_decap_4
XFILLER_140_126 VPWR VGND sg13cmos5l_decap_8
XFILLER_286_119 VPWR VGND sg13cmos5l_decap_8
XFILLER_691_105 VPWR VGND sg13cmos5l_decap_4
XFILLER_623_42 VPWR VGND sg13cmos5l_decap_8
XFILLER_140_159 VPWR VGND sg13cmos5l_decap_8
X_0350_ _0350_/Q Tile_X0Y7_FrameData[1] VGND VPWR Tile_X0Y9_FrameStrobe[5] latch
XFILLER_192_95 VPWR VGND sg13cmos5l_fill_1
XFILLER_342_21 VPWR VGND sg13cmos5l_decap_8
XFILLER_294_141 VPWR VGND sg13cmos5l_decap_8
X_0281_ _0281_/Q Tile_X0Y7_FrameData[6] VGND VPWR Tile_X0Y9_FrameStrobe[3] latch
XFILLER_428_168 VPWR VGND sg13cmos5l_decap_8
XFILLER_443_105 VPWR VGND sg13cmos5l_decap_8
XFILLER_294_185 VPWR VGND sg13cmos5l_fill_1
X_2020_ _2020_/Q Tile_X0Y4_FrameData[1] VGND VPWR Tile_X0Y9_FrameStrobe[2] latch
XFILLER_85_71 VPWR VGND sg13cmos5l_fill_2
XFILLER_342_98 VPWR VGND sg13cmos5l_decap_8
XFILLER_699_68 VPWR VGND sg13cmos5l_decap_8
XFILLER_211_14 VPWR VGND sg13cmos5l_decap_8
XANTENNA__3022__X Tile_X0Y5_E6BEG[9] VPWR VGND sg13cmos5l_antennanp
XFILLER_62_154 VPWR VGND sg13cmos5l_decap_8
XFILLER_568_28 VPWR VGND sg13cmos5l_decap_8
X_3971_ _3971_/X AXI_M_SOC_ARREADY _4012_/X _4016_/X _3995_/X _1267_/Q _1266_/Q VPWR
+ VGND sg13cmos5l_mux4_1
XANTENNA__2861__X Tile_X0Y6_E6BEG[10] VPWR VGND sg13cmos5l_antennanp
XFILLER_498_91 VPWR VGND sg13cmos5l_decap_8
X_2922_ Tile_X0Y8_E2BEG[6] _4734_/X VPWR VGND sg13cmos5l_buf_1
XFILLER_210_119 VPWR VGND sg13cmos5l_decap_8
XFILLER_600_179 VPWR VGND sg13cmos5l_fill_2
XFILLER_203_171 VPWR VGND sg13cmos5l_decap_8
X_2853_ Tile_X0Y6_E6BEG[2] _4530_/X VPWR VGND sg13cmos5l_buf_1
XFILLER_364_112 VPWR VGND sg13cmos5l_decap_8
XFILLER_349_197 VPWR VGND sg13cmos5l_decap_8
X_1804_ _1804_/Q Tile_X0Y3_FrameData[29] VGND VPWR Tile_X0Y9_FrameStrobe[4] latch
XFILLER_699_227 VPWR VGND sg13cmos5l_fill_2
XFILLER_584_49 VPWR VGND sg13cmos5l_decap_8
X_2784_ Tile_X0Y3_EE4BEG[10] _4174_/X VPWR VGND sg13cmos5l_buf_1
XFILLER_367_84 VPWR VGND sg13cmos5l_decap_8
XFILLER_517_21 VPWR VGND sg13cmos5l_decap_8
XFILLER_163_218 VPWR VGND sg13cmos5l_fill_1
X_4523_ _4523_/X Tile_X0Y6_WW4END[4] AXI_M_SOC_RDATA28 _4572_/X _4558_/X _2561_/Q
+ _2560_/Q VPWR VGND sg13cmos5l_mux4_1
X_1735_ _1735_/Q Tile_X0Y3_FrameData[2] VGND VPWR Tile_X0Y9_FrameStrobe[1] latch
XFILLER_506_161 VPWR VGND sg13cmos5l_decap_8
XANTENNA__3692__X AXI_M_SOC_WDATA2 VPWR VGND sg13cmos5l_antennanp
X_4454_ _4454_/X _4427_/X _0097_/X _4426_/X _0156_/X _2231_/Q _2230_/Q VPWR VGND sg13cmos5l_mux4_1
X_1666_ _1666_/Q Tile_X0Y2_FrameData[15] VGND VPWR Tile_X0Y9_FrameStrobe[7] latch
XFILLER_116_189 VPWR VGND sg13cmos5l_decap_8
X_3405_ Tile_X0Y2_E1BEG[0] _4036_/X VPWR VGND sg13cmos5l_buf_1
XFILLER_521_164 VPWR VGND sg13cmos5l_decap_8
XFILLER_236_77 VPWR VGND sg13cmos5l_decap_8
X_0617_ _0617_/Q Tile_X0Y8_FrameData[22] VGND VPWR Tile_X0Y9_FrameStrobe[6] latch
XFILLER_131_126 VPWR VGND sg13cmos5l_decap_8
X_4385_ _4385_/X Tile_X0Y5_W2END[2] AXI_M_SOC_RRESP0 _4432_/X _4431_/X _2333_/Q _2332_/Q
+ VPWR VGND sg13cmos5l_mux4_1
XFILLER_521_186 VPWR VGND sg13cmos5l_fill_2
XFILLER_277_119 VPWR VGND sg13cmos5l_decap_8
X_1597_ _1597_/Q Tile_X0Y2_FrameData[20] VGND VPWR Tile_X0Y9_FrameStrobe[5] latch
XFILLER_533_42 VPWR VGND sg13cmos5l_decap_8
X_3336_ Tile_X0Y2_FrameData_O[7] Tile_X0Y2_FrameData[7] VPWR VGND sg13cmos5l_buf_1
X_0548_ _0548_/Q Tile_X0Y8_FrameData[27] VGND VPWR Tile_X0Y9_FrameStrobe[4] latch
XFILLER_419_135 VPWR VGND sg13cmos5l_fill_2
XFILLER_252_21 VPWR VGND sg13cmos5l_decap_8
X_3267_ Tile_X0Y0_EE4BEG[3] _3823_/X VPWR VGND sg13cmos5l_buf_1
X_0479_ _0479_/Q Tile_X0Y8_FrameData[0] VGND VPWR Tile_X0Y9_FrameStrobe[1] latch
XFILLER_434_105 VPWR VGND sg13cmos5l_decap_8
XFILLER_690_171 VPWR VGND sg13cmos5l_fill_1
X_2218_ _2218_/Q Tile_X0Y5_FrameData[27] VGND VPWR Tile_X0Y9_FrameStrobe[1] latch
XFILLER_252_98 VPWR VGND sg13cmos5l_decap_8
X_3198_ Tile_X0Y0_N2BEGb[6] _3901_/X VPWR VGND sg13cmos5l_buf_1
XFILLER_402_35 VPWR VGND sg13cmos5l_decap_8
XFILLER_53_110 VPWR VGND sg13cmos5l_decap_8
XFILLER_121_14 VPWR VGND sg13cmos5l_decap_8
X_2149_ _2149_/Q Tile_X0Y4_FrameData[0] VGND VPWR Tile_X0Y9_FrameStrobe[6] latch
XFILLER_478_28 VPWR VGND sg13cmos5l_decap_8
XFILLER_53_187 VPWR VGND sg13cmos5l_fill_2
XANTENNA__2771__X Tile_X0Y3_FrameData_O[29] VPWR VGND sg13cmos5l_antennanp
XFILLER_529_220 VPWR VGND sg13cmos5l_fill_2
XFILLER_201_119 VPWR VGND sg13cmos5l_decap_4
XFILLER_201_91 VPWR VGND sg13cmos5l_decap_8
XFILLER_139_215 VPWR VGND sg13cmos5l_decap_4
XFILLER_14_56 VPWR VGND sg13cmos5l_decap_8
XFILLER_139_226 VPWR VGND sg13cmos5l_fill_2
XFILLER_355_112 VPWR VGND sg13cmos5l_decap_8
XFILLER_544_223 VPWR VGND sg13cmos5l_decap_4
XFILLER_708_42 VPWR VGND sg13cmos5l_decap_8
XFILLER_317_7 VPWR VGND sg13cmos5l_decap_8
XFILLER_494_49 VPWR VGND sg13cmos5l_decap_8
XFILLER_277_84 VPWR VGND sg13cmos5l_decap_8
XFILLER_427_21 VPWR VGND sg13cmos5l_decap_8
XFILLER_355_189 VPWR VGND sg13cmos5l_decap_8
XFILLER_5_228 VPWR VGND sg13cmos5l_fill_1
XFILLER_370_126 VPWR VGND sg13cmos5l_decap_8
XFILLER_107_112 VPWR VGND sg13cmos5l_decap_8
XFILLER_30_55 VPWR VGND sg13cmos5l_decap_8
XFILLER_427_98 VPWR VGND sg13cmos5l_decap_8
XFILLER_146_77 VPWR VGND sg13cmos5l_decap_8
XFILLER_686_7 VPWR VGND sg13cmos5l_decap_8
XFILLER_122_137 VPWR VGND sg13cmos5l_decap_8
XANTENNA__3107__X Tile_X0Y7_E6BEG[5] VPWR VGND sg13cmos5l_antennanp
XFILLER_443_42 VPWR VGND sg13cmos5l_decap_8
XFILLER_39_20 VPWR VGND sg13cmos5l_decap_8
XFILLER_122_159 VPWR VGND sg13cmos5l_fill_1
XFILLER_590_70 VPWR VGND sg13cmos5l_decap_8
XFILLER_162_21 VPWR VGND sg13cmos5l_decap_8
XFILLER_39_64 VPWR VGND sg13cmos5l_fill_1
XANTENNA__2946__X Tile_X0Y8_EE4BEG[2] VPWR VGND sg13cmos5l_antennanp
XFILLER_209_208 VPWR VGND sg13cmos5l_decap_4
XFILLER_425_105 VPWR VGND sg13cmos5l_decap_8
XFILLER_288_2 VPWR VGND sg13cmos5l_fill_1
XFILLER_312_35 VPWR VGND sg13cmos5l_decap_8
XFILLER_176_0 VPWR VGND sg13cmos5l_decap_8
XFILLER_669_49 VPWR VGND sg13cmos5l_decap_8
XFILLER_232_200 VPWR VGND sg13cmos5l_fill_2
XFILLER_55_63 VPWR VGND sg13cmos5l_decap_8
XFILLER_378_215 VPWR VGND sg13cmos5l_fill_2
XFILLER_579_175 VPWR VGND sg13cmos5l_decap_8
XFILLER_55_96 VPWR VGND sg13cmos5l_decap_4
XFILLER_388_28 VPWR VGND sg13cmos5l_decap_8
XFILLER_343_0 VPWR VGND sg13cmos5l_decap_8
XFILLER_393_207 VPWR VGND sg13cmos5l_decap_8
XFILLER_346_112 VPWR VGND sg13cmos5l_decap_8
XFILLER_510_0 VPWR VGND sg13cmos5l_decap_8
XFILLER_71_84 VPWR VGND sg13cmos5l_decap_8
XFILLER_608_0 VPWR VGND sg13cmos5l_decap_8
XFILLER_618_42 VPWR VGND sg13cmos5l_decap_8
XFILLER_346_156 VPWR VGND sg13cmos5l_decap_8
XFILLER_145_218 VPWR VGND sg13cmos5l_fill_1
XFILLER_337_21 VPWR VGND sg13cmos5l_decap_8
XFILLER_65_7 VPWR VGND sg13cmos5l_decap_8
XFILLER_361_126 VPWR VGND sg13cmos5l_decap_8
XFILLER_299_200 VPWR VGND sg13cmos5l_decap_8
XFILLER_484_82 VPWR VGND sg13cmos5l_decap_8
X_1520_ _1520_/Q Tile_X0Y2_FrameData[1] VGND VPWR Tile_X0Y9_FrameStrobe[2] latch
XFILLER_503_175 VPWR VGND sg13cmos5l_decap_8
X_1451_ _1451_/Q Tile_X0Y2_FrameData[6] VGND VPWR Tile_X0Y9_FrameStrobe[0] latch
XFILLER_634_63 VPWR VGND sg13cmos5l_decap_8
XFILLER_206_14 VPWR VGND sg13cmos5l_decap_8
XANTENNA__3017__X Tile_X0Y5_E6BEG[4] VPWR VGND sg13cmos5l_antennanp
XFILLER_353_42 VPWR VGND sg13cmos5l_decap_8
X_0402_ _0402_/Q Tile_X0Y7_FrameData[13] VGND VPWR Tile_X0Y9_FrameStrobe[7] latch
X_1382_ _1382_/Q Tile_X0Y1_FrameData[19] VGND VPWR Tile_X0Y9_FrameStrobe[6] latch
X_4170_ _4170_/X Tile_X0Y3_WW4END[9] AXI_M_SOC_WREADY _4231_/X _4207_/X _1801_/Q _1800_/Q
+ VPWR VGND sg13cmos5l_mux4_1
X_3121_ Tile_X0Y7_EE4BEG[7] _4635_/X VPWR VGND sg13cmos5l_buf_1
XFILLER_121_170 VPWR VGND sg13cmos5l_fill_2
XANTENNA__2856__X Tile_X0Y6_E6BEG[5] VPWR VGND sg13cmos5l_antennanp
X_0333_ _0333_/Q Tile_X0Y7_FrameData[18] VGND VPWR Tile_X0Y9_FrameStrobe[5] latch
XFILLER_416_105 VPWR VGND sg13cmos5l_fill_1
XFILLER_503_56 VPWR VGND sg13cmos5l_decap_8
X_0264_ _0264_/Q Tile_X0Y7_FrameData[23] VGND VPWR Tile_X0Y9_FrameStrobe[3] latch
X_3052_ Tile_X0Y5_FrameData_O[11] Tile_X0Y5_FrameData[11] VPWR VGND sg13cmos5l_buf_1
XFILLER_672_182 VPWR VGND sg13cmos5l_decap_8
XFILLER_282_133 VPWR VGND sg13cmos5l_decap_8
XFILLER_650_84 VPWR VGND sg13cmos5l_decap_8
XFILLER_416_149 VPWR VGND sg13cmos5l_decap_8
XFILLER_222_35 VPWR VGND sg13cmos5l_decap_8
XFILLER_409_190 VPWR VGND sg13cmos5l_fill_1
X_2003_ _2003_/Q Tile_X0Y4_FrameData[18] VGND VPWR Tile_X0Y9_FrameStrobe[2] latch
X_0195_ _0195_/Q Tile_X0Y7_FrameData[28] VGND VPWR Tile_X0Y9_FrameStrobe[1] latch
XFILLER_431_119 VPWR VGND sg13cmos5l_decap_8
XFILLER_282_188 VPWR VGND sg13cmos5l_decap_8
XFILLER_579_49 VPWR VGND sg13cmos5l_decap_8
XFILLER_369_204 VPWR VGND sg13cmos5l_decap_8
XFILLER_424_182 VPWR VGND sg13cmos5l_fill_1
XFILLER_298_28 VPWR VGND sg13cmos5l_decap_8
XFILLER_585_112 VPWR VGND sg13cmos5l_decap_4
XFILLER_50_113 VPWR VGND sg13cmos5l_decap_8
X_3954_ _3954_/X Tile_X0Y1_WW4END[9] AXI_M_SOC_ARREADY _4017_/X _3991_/X _1301_/Q
+ _1300_/Q VPWR VGND sg13cmos5l_mux4_1
XFILLER_585_156 VPWR VGND sg13cmos5l_fill_1
XFILLER_195_107 VPWR VGND sg13cmos5l_decap_8
XFILLER_91_0 VPWR VGND sg13cmos5l_decap_8
X_2905_ Tile_X0Y6_FrameData_O[26] Tile_X0Y6_FrameData[26] VPWR VGND sg13cmos5l_buf_1
X_3885_ _3885_/X _3848_/X _0067_/X Tile_X0Y0_S1END[0] Tile_X0Y0_S4END[0] _0987_/Q
+ _0986_/Q VPWR VGND sg13cmos5l_mux4_1
XFILLER_337_123 VPWR VGND sg13cmos5l_decap_8
XFILLER_528_42 VPWR VGND sg13cmos5l_decap_8
X_2836_ Tile_X0Y6_E2BEG[1] _4497_/X VPWR VGND sg13cmos5l_buf_1
XFILLER_675_70 VPWR VGND sg13cmos5l_decap_8
XFILLER_247_21 VPWR VGND sg13cmos5l_decap_8
XFILLER_352_126 VPWR VGND sg13cmos5l_decap_8
X_2767_ Tile_X0Y3_FrameData_O[25] Tile_X0Y3_FrameData[25] VPWR VGND sg13cmos5l_buf_1
XFILLER_498_119 VPWR VGND sg13cmos5l_decap_8
X_4506_ _4506_/X Tile_X0Y6_W2END[5] AXI_M_SOC_RDATA29 _4557_/X _4556_/X _2595_/Q _2594_/Q
+ VPWR VGND sg13cmos5l_mux4_1
X_1718_ _1718_/Q Tile_X0Y3_FrameData[19] VGND VPWR Tile_X0Y9_FrameStrobe[1] latch
X_2698_ _4086_/A3 VPWR VGND sg13cmos5l_tielo
X_4437_ _4437_/X Tile_X0Y9_W1END[0] Tile_X0Y9_WW4END[0] Tile_X0Y9_W6END[8] _4916_/X
+ _0903_/Q _0902_/Q VPWR VGND sg13cmos5l_mux4_1
XFILLER_544_63 VPWR VGND sg13cmos5l_decap_8
XFILLER_104_126 VPWR VGND sg13cmos5l_decap_8
X_1649_ _1649_/Q Tile_X0Y2_FrameData[0] VGND VPWR Tile_X0Y9_FrameStrobe[6] latch
XFILLER_116_14 VPWR VGND sg13cmos5l_decap_8
XFILLER_655_105 VPWR VGND sg13cmos5l_decap_8
XFILLER_691_91 VPWR VGND sg13cmos5l_decap_8
XFILLER_263_42 VPWR VGND sg13cmos5l_decap_8
X_4368_ _4368_/X _4418_/X _4417_/X AXI_M_SOC_RRESP1 _4416_/X _2367_/Q _2366_/Q VPWR
+ VGND sg13cmos5l_mux4_1
XANTENNA__2766__X Tile_X0Y3_FrameData_O[24] VPWR VGND sg13cmos5l_antennanp
X_3319_ Tile_X0Y4_EE4BEG[7] _4279_/X VPWR VGND sg13cmos5l_buf_1
X_4299_ _4299_/X AXI_M_SOC_BRESP1 _4336_/X _4340_/X _4312_/X _2015_/Q _2014_/Q VPWR
+ VGND sg13cmos5l_mux4_1
XFILLER_413_56 VPWR VGND sg13cmos5l_decap_8
XFILLER_273_133 VPWR VGND sg13cmos5l_decap_8
XFILLER_560_84 VPWR VGND sg13cmos5l_decap_8
XFILLER_132_35 VPWR VGND sg13cmos5l_decap_8
XFILLER_710_21 VPWR VGND sg13cmos5l_decap_8
XFILLER_422_119 VPWR VGND sg13cmos5l_decap_8
XFILLER_92_28 VPWR VGND sg13cmos5l_decap_8
XFILLER_489_49 VPWR VGND sg13cmos5l_decap_8
XFILLER_267_7 VPWR VGND sg13cmos5l_decap_8
XFILLER_710_98 VPWR VGND sg13cmos5l_decap_8
XFILLER_415_193 VPWR VGND sg13cmos5l_fill_1
XFILLER_26_165 VPWR VGND sg13cmos5l_fill_1
XFILLER_576_112 VPWR VGND sg13cmos5l_decap_8
XFILLER_26_187 VPWR VGND sg13cmos5l_decap_8
XANTENNA__3597__X Tile_X0Y9_FrameData_O[27] VPWR VGND sg13cmos5l_antennanp
XFILLER_434_7 VPWR VGND sg13cmos5l_decap_8
XFILLER_25_77 VPWR VGND sg13cmos5l_decap_8
XFILLER_576_178 VPWR VGND sg13cmos5l_decap_8
XFILLER_430_196 VPWR VGND sg13cmos5l_decap_8
XFILLER_328_101 VPWR VGND sg13cmos5l_fill_2
XFILLER_517_212 VPWR VGND sg13cmos5l_decap_8
XFILLER_41_10 VPWR VGND sg13cmos5l_decap_8
XFILLER_601_7 VPWR VGND sg13cmos5l_decap_8
XFILLER_438_42 VPWR VGND sg13cmos5l_decap_8
XFILLER_585_70 VPWR VGND sg13cmos5l_decap_8
XFILLER_532_204 VPWR VGND sg13cmos5l_decap_8
XFILLER_328_178 VPWR VGND sg13cmos5l_decap_8
XFILLER_157_21 VPWR VGND sg13cmos5l_decap_8
XFILLER_328_189 VPWR VGND sg13cmos5l_fill_2
XFILLER_489_119 VPWR VGND sg13cmos5l_decap_8
XFILLER_41_87 VPWR VGND sg13cmos5l_decap_8
XFILLER_41_98 VPWR VGND sg13cmos5l_fill_2
XFILLER_307_35 VPWR VGND sg13cmos5l_decap_8
XFILLER_671_28 VPWR VGND sg13cmos5l_decap_8
XFILLER_454_63 VPWR VGND sg13cmos5l_decap_8
XFILLER_500_112 VPWR VGND sg13cmos5l_decap_8
XFILLER_646_105 VPWR VGND sg13cmos5l_decap_8
XFILLER_497_196 VPWR VGND sg13cmos5l_decap_8
XFILLER_173_42 VPWR VGND sg13cmos5l_decap_8
XFILLER_110_107 VPWR VGND sg13cmos5l_decap_8
XFILLER_249_130 VPWR VGND sg13cmos5l_decap_8
XFILLER_49_224 VPWR VGND sg13cmos5l_decap_4
XFILLER_293_0 VPWR VGND sg13cmos5l_decap_8
XFILLER_604_77 VPWR VGND sg13cmos5l_decap_8
XFILLER_500_189 VPWR VGND sg13cmos5l_decap_8
XFILLER_453_200 VPWR VGND sg13cmos5l_decap_8
XFILLER_323_56 VPWR VGND sg13cmos5l_decap_8
XFILLER_654_182 VPWR VGND sg13cmos5l_decap_8
XFILLER_66_62 VPWR VGND sg13cmos5l_decap_8
XFILLER_620_21 VPWR VGND sg13cmos5l_decap_8
XFILLER_460_0 VPWR VGND sg13cmos5l_decap_8
XFILLER_264_155 VPWR VGND sg13cmos5l_decap_4
XFILLER_558_0 VPWR VGND sg13cmos5l_decap_8
XFILLER_399_49 VPWR VGND sg13cmos5l_decap_8
XFILLER_620_98 VPWR VGND sg13cmos5l_decap_8
XFILLER_696_14 VPWR VGND sg13cmos5l_decap_8
XFILLER_567_112 VPWR VGND sg13cmos5l_decap_8
XFILLER_479_93 VPWR VGND sg13cmos5l_fill_1
XANTENNA__3300__X Tile_X0Y0_E2BEG[0] VPWR VGND sg13cmos5l_antennanp
XFILLER_421_185 VPWR VGND sg13cmos5l_decap_8
XFILLER_709_161 VPWR VGND sg13cmos5l_decap_8
X_0951_ _0951_/Q Tile_X0Y0_FrameData[20] VGND VPWR Tile_X0Y9_FrameStrobe[0] latch
XFILLER_629_63 VPWR VGND sg13cmos5l_decap_8
XFILLER_582_126 VPWR VGND sg13cmos5l_decap_8
XFILLER_348_42 VPWR VGND sg13cmos5l_decap_8
XFILLER_582_159 VPWR VGND sg13cmos5l_decap_8
X_3670_ AXI_M_SOC_AWADDR31 Tile_X0Y4_W1END[3] Tile_X0Y4_WW4END[7] Tile_X0Y4_WW4END[15]
+ _4351_/X _1983_/Q _1982_/Q VPWR VGND sg13cmos5l_mux4_1
X_0882_ _0882_/Q Tile_X0Y9_FrameData[13] VGND VPWR Tile_X0Y9_FrameStrobe[6] latch
XFILLER_495_70 VPWR VGND sg13cmos5l_decap_8
X_2621_ _2621_/Q Tile_X0Y6_FrameData[10] VGND VPWR Tile_X0Y9_FrameStrobe[5] latch
XFILLER_185_195 VPWR VGND sg13cmos5l_decap_8
XFILLER_590_170 VPWR VGND sg13cmos5l_decap_4
XFILLER_334_126 VPWR VGND sg13cmos5l_decap_8
X_2552_ _2552_/Q Tile_X0Y6_FrameData[15] VGND VPWR Tile_X0Y9_FrameStrobe[3] latch
XFILLER_645_84 VPWR VGND sg13cmos5l_decap_8
XFILLER_217_35 VPWR VGND sg13cmos5l_decap_8
XFILLER_141_210 VPWR VGND sg13cmos5l_decap_8
X_1503_ _1503_/Q Tile_X0Y2_FrameData[18] VGND VPWR Tile_X0Y9_FrameStrobe[2] latch
XFILLER_581_28 VPWR VGND sg13cmos5l_decap_8
XFILLER_364_63 VPWR VGND sg13cmos5l_decap_8
X_2483_ _2483_/Q Tile_X0Y6_FrameData[20] VGND VPWR Tile_X0Y9_FrameStrobe[1] latch
XFILLER_637_105 VPWR VGND sg13cmos5l_decap_8
XFILLER_287_225 VPWR VGND sg13cmos5l_decap_4
X_4222_ _4222_/X _4195_/X _0089_/X _4194_/X Tile_X0Y0_S4END[12] _1729_/Q _1728_/Q
+ VPWR VGND sg13cmos5l_mux4_1
XFILLER_488_196 VPWR VGND sg13cmos5l_fill_2
XFILLER_99_179 VPWR VGND sg13cmos5l_decap_8
X_1434_ _1434_/Q Tile_X0Y2_FrameData[23] VGND VPWR Tile_X0Y9_FrameStrobe[0] latch
XFILLER_101_118 VPWR VGND sg13cmos5l_decap_8
XFILLER_514_77 VPWR VGND sg13cmos5l_decap_8
X_4153_ _4153_/X Tile_X0Y3_W2MID[2] AXI_M_SOC_BVALID _4209_/X _4208_/X _1835_/Q _1834_/Q
+ VPWR VGND sg13cmos5l_mux4_1
X_1365_ _1365_/Q Tile_X0Y1_FrameData[4] VGND VPWR Tile_X0Y9_FrameStrobe[5] latch
XFILLER_652_119 VPWR VGND sg13cmos5l_decap_8
XFILLER_255_122 VPWR VGND sg13cmos5l_decap_4
XFILLER_233_56 VPWR VGND sg13cmos5l_decap_8
X_3104_ Tile_X0Y7_E6BEG[2] _4646_/X VPWR VGND sg13cmos5l_buf_1
X_0316_ _0316_/Q Tile_X0Y7_FrameData[3] VGND VPWR Tile_X0Y9_FrameStrobe[4] latch
XFILLER_645_182 VPWR VGND sg13cmos5l_decap_8
XFILLER_255_133 VPWR VGND sg13cmos5l_decap_4
X_4084_ _4084_/X _4089_/X Tile_X0Y2_W6END[0] _4088_/X _4084_/A3 _1433_/Q _1432_/Q
+ VPWR VGND sg13cmos5l_mux4_1
XFILLER_55_216 VPWR VGND sg13cmos5l_fill_2
X_1296_ _1296_/Q Tile_X0Y1_FrameData[9] VGND VPWR Tile_X0Y9_FrameStrobe[3] latch
XFILLER_530_21 VPWR VGND sg13cmos5l_decap_8
X_3035_ Tile_X0Y5_EE4BEG[10] _4398_/X VPWR VGND sg13cmos5l_buf_1
XFILLER_404_108 VPWR VGND sg13cmos5l_decap_4
X_0247_ _0247_/Q Tile_X0Y7_FrameData[8] VGND VPWR Tile_X0Y9_FrameStrobe[2] latch
XFILLER_270_147 VPWR VGND sg13cmos5l_fill_1
X_0178_ _0178_/Q Tile_X0Y7_FrameData[13] VGND VPWR Tile_X0Y9_FrameStrobe[0] latch
XFILLER_102_49 VPWR VGND sg13cmos5l_decap_8
XFILLER_558_112 VPWR VGND sg13cmos5l_decap_8
XFILLER_270_169 VPWR VGND sg13cmos5l_fill_2
XFILLER_211_203 VPWR VGND sg13cmos5l_decap_8
XANTENNA__3210__X Tile_X0Y0_N1BEG[2] VPWR VGND sg13cmos5l_antennanp
XFILLER_412_185 VPWR VGND sg13cmos5l_decap_8
XFILLER_168_129 VPWR VGND sg13cmos5l_decap_8
X_3937_ _3937_/X Tile_X0Y1_W2MID[2] AXI_M_SOC_ARREADY _3993_/X _3992_/X _1335_/Q _1334_/Q
+ VPWR VGND sg13cmos5l_mux4_1
XFILLER_573_126 VPWR VGND sg13cmos5l_decap_8
XFILLER_539_63 VPWR VGND sg13cmos5l_decap_8
XFILLER_686_91 VPWR VGND sg13cmos5l_decap_8
XFILLER_258_42 VPWR VGND sg13cmos5l_decap_8
X_3868_ _3868_/X _3850_/X _0085_/X Tile_X0Y0_S1END[2] Tile_X0Y0_S4END[2] _0975_/Q
+ _0974_/Q VPWR VGND sg13cmos5l_mux4_1
XFILLER_715_153 VPWR VGND sg13cmos5l_decap_8
X_2819_ Tile_X0Y3_E1BEG[1] _4145_/X VPWR VGND sg13cmos5l_buf_1
XFILLER_325_126 VPWR VGND sg13cmos5l_fill_2
X_3799_ _3799_/X _3879_/X _3864_/X _3863_/X _3859_/X _1144_/Q _1143_/Q VPWR VGND sg13cmos5l_mux4_1
XFILLER_11_35 VPWR VGND sg13cmos5l_decap_8
XFILLER_408_56 VPWR VGND sg13cmos5l_decap_8
XFILLER_191_165 VPWR VGND sg13cmos5l_decap_8
XFILLER_555_84 VPWR VGND sg13cmos5l_decap_8
XFILLER_340_118 VPWR VGND sg13cmos5l_decap_4
XFILLER_127_35 VPWR VGND sg13cmos5l_decap_8
XFILLER_705_21 VPWR VGND sg13cmos5l_decap_8
XFILLER_491_28 VPWR VGND sg13cmos5l_decap_8
XFILLER_274_63 VPWR VGND sg13cmos5l_decap_8
XFILLER_87_28 VPWR VGND sg13cmos5l_decap_8
XFILLER_494_133 VPWR VGND sg13cmos5l_decap_8
XFILLER_705_98 VPWR VGND sg13cmos5l_decap_8
XFILLER_424_77 VPWR VGND sg13cmos5l_decap_8
XFILLER_384_7 VPWR VGND sg13cmos5l_decap_8
XFILLER_643_119 VPWR VGND sg13cmos5l_decap_8
XFILLER_246_111 VPWR VGND sg13cmos5l_decap_4
XFILLER_143_56 VPWR VGND sg13cmos5l_decap_8
XFILLER_246_133 VPWR VGND sg13cmos5l_decap_8
XFILLER_290_84 VPWR VGND sg13cmos5l_decap_8
XFILLER_440_21 VPWR VGND sg13cmos5l_decap_8
XFILLER_551_7 VPWR VGND sg13cmos5l_decap_8
XFILLER_261_103 VPWR VGND sg13cmos5l_decap_8
XFILLER_649_7 VPWR VGND sg13cmos5l_decap_8
XFILLER_450_225 VPWR VGND sg13cmos5l_decap_4
XFILLER_651_196 VPWR VGND sg13cmos5l_fill_2
XFILLER_36_65 VPWR VGND sg13cmos5l_decap_8
XFILLER_440_98 VPWR VGND sg13cmos5l_decap_8
XFILLER_403_152 VPWR VGND sg13cmos5l_decap_4
XFILLER_348_207 VPWR VGND sg13cmos5l_fill_1
XANTENNA__3120__X Tile_X0Y7_EE4BEG[6] VPWR VGND sg13cmos5l_antennanp
XFILLER_403_185 VPWR VGND sg13cmos5l_decap_8
XFILLER_52_31 VPWR VGND sg13cmos5l_decap_8
XFILLER_666_28 VPWR VGND sg13cmos5l_decap_8
XFILLER_564_126 VPWR VGND sg13cmos5l_decap_8
XFILLER_449_63 VPWR VGND sg13cmos5l_decap_8
XFILLER_168_42 VPWR VGND sg13cmos5l_decap_8
XFILLER_139_0 VPWR VGND sg13cmos5l_decap_8
XFILLER_52_97 VPWR VGND sg13cmos5l_decap_8
XFILLER_316_115 VPWR VGND sg13cmos5l_fill_1
XFILLER_371_210 VPWR VGND sg13cmos5l_decap_8
XFILLER_371_221 VPWR VGND sg13cmos5l_fill_1
XFILLER_306_0 VPWR VGND sg13cmos5l_decap_8
XFILLER_318_56 VPWR VGND sg13cmos5l_decap_8
XFILLER_682_49 VPWR VGND sg13cmos5l_decap_8
XFILLER_615_21 VPWR VGND sg13cmos5l_decap_8
XFILLER_520_218 VPWR VGND sg13cmos5l_fill_1
XFILLER_123_210 VPWR VGND sg13cmos5l_decap_8
XFILLER_184_63 VPWR VGND sg13cmos5l_decap_8
XFILLER_619_105 VPWR VGND sg13cmos5l_fill_2
XFILLER_269_225 VPWR VGND sg13cmos5l_decap_4
XFILLER_184_85 VPWR VGND sg13cmos5l_decap_8
XFILLER_615_98 VPWR VGND sg13cmos5l_decap_8
XFILLER_675_0 VPWR VGND sg13cmos5l_decap_8
XFILLER_334_77 VPWR VGND sg13cmos5l_decap_8
XFILLER_28_7 VPWR VGND sg13cmos5l_decap_8
XFILLER_284_228 VPWR VGND sg13cmos5l_fill_1
XFILLER_634_119 VPWR VGND sg13cmos5l_decap_8
XFILLER_631_42 VPWR VGND sg13cmos5l_decap_8
X_1150_ _1150_/Q Tile_X0Y0_FrameData[13] VGND VPWR Tile_X0Y9_FrameStrobe[6] latch
XFILLER_37_227 VPWR VGND sg13cmos5l_fill_2
XFILLER_350_21 VPWR VGND sg13cmos5l_decap_8
X_0101_ AXI_M_SOC_ARLEN6 _0933_/Q _3766_/X VPWR VGND sg13cmos5l_nor2b_1
XFILLER_237_177 VPWR VGND sg13cmos5l_decap_4
X_1081_ _1081_/Q Tile_X0Y0_FrameData[18] VGND VPWR Tile_X0Y9_FrameStrobe[4] latch
XFILLER_441_203 VPWR VGND sg13cmos5l_fill_1
XFILLER_587_207 VPWR VGND sg13cmos5l_decap_8
XFILLER_642_196 VPWR VGND sg13cmos5l_decap_8
XFILLER_350_98 VPWR VGND sg13cmos5l_decap_8
XFILLER_93_82 VPWR VGND sg13cmos5l_fill_2
XFILLER_500_35 VPWR VGND sg13cmos5l_decap_8
X_4840_ _4840_/X Tile_X0Y9_W1END[2] Tile_X0Y9_WW4END[14] Tile_X0Y9_W6END[6] _4918_/X
+ _0861_/Q _0860_/Q VPWR VGND sg13cmos5l_mux4_1
XANTENNA__3030__X Tile_X0Y5_EE4BEG[5] VPWR VGND sg13cmos5l_antennanp
XFILLER_576_28 VPWR VGND sg13cmos5l_decap_8
X_4771_ _4771_/X AXI_M_SOC_RDATA15 _4800_/X _4804_/X _4784_/X _0505_/Q _0504_/Q VPWR
+ VGND sg13cmos5l_mux4_1
XFILLER_359_63 VPWR VGND sg13cmos5l_decap_8
X_1983_ _1983_/Q Tile_X0Y4_FrameData[6] VGND VPWR Tile_X0Y9_FrameStrobe[1] latch
X_3722_ _3722_/X Tile_X0Y3_WW4END[7] Tile_X0Y3_WW4END[15] Tile_X0Y3_W6END[7] _4229_/X
+ _1743_/Q _1742_/Q VPWR VGND sg13cmos5l_mux4_1
X_0934_ _0934_/Q Tile_X0Y9_FrameData[25] VGND VPWR Tile_X0Y9_FrameStrobe[8] latch
X_3653_ AXI_M_SOC_AWADDR14 Tile_X0Y5_W1END[2] Tile_X0Y5_WW4END[6] Tile_X0Y5_WW4END[14]
+ _4465_/X _2243_/Q _2242_/Q VPWR VGND sg13cmos5l_mux4_1
XFILLER_509_77 VPWR VGND sg13cmos5l_decap_8
XFILLER_712_112 VPWR VGND sg13cmos5l_decap_8
X_0865_ _0865_/Q Tile_X0Y9_FrameData[30] VGND VPWR Tile_X0Y9_FrameStrobe[6] latch
XFILLER_307_159 VPWR VGND sg13cmos5l_fill_1
XFILLER_228_56 VPWR VGND sg13cmos5l_decap_8
X_2604_ _2604_/Q Tile_X0Y6_FrameData[27] VGND VPWR Tile_X0Y9_FrameStrobe[5] latch
X_3584_ Tile_X0Y9_FrameData_O[14] Tile_X0Y9_FrameData[14] VPWR VGND sg13cmos5l_buf_1
XFILLER_592_49 VPWR VGND sg13cmos5l_decap_8
XFILLER_511_207 VPWR VGND sg13cmos5l_decap_4
XFILLER_322_107 VPWR VGND sg13cmos5l_fill_2
X_0796_ _0796_/Q Tile_X0Y9_FrameData[3] VGND VPWR Tile_X0Y9_FrameStrobe[3] latch
XFILLER_54_0 VPWR VGND sg13cmos5l_fill_1
XFILLER_525_21 VPWR VGND sg13cmos5l_decap_8
XFILLER_712_189 VPWR VGND sg13cmos5l_decap_8
X_2535_ _2535_/Q Tile_X0Y6_FrameData[0] VGND VPWR Tile_X0Y9_FrameStrobe[2] latch
XFILLER_87_116 VPWR VGND sg13cmos5l_decap_8
X_2466_ _2466_/Q Tile_X0Y6_FrameData[5] VGND VPWR Tile_X0Y9_FrameStrobe[0] latch
XFILLER_476_144 VPWR VGND sg13cmos5l_fill_2
X_4205_ _4205_/X _4129_/X _4237_/X _4236_/X _4128_/X _1697_/Q _1696_/Q VPWR VGND sg13cmos5l_mux4_1
XFILLER_244_77 VPWR VGND sg13cmos5l_decap_8
X_1417_ _1417_/Q Tile_X0Y1_FrameData[16] VGND VPWR Tile_X0Y9_FrameStrobe[7] latch
XFILLER_275_228 VPWR VGND sg13cmos5l_fill_1
XANTENNA__3205__X Tile_X0Y0_N2BEG[5] VPWR VGND sg13cmos5l_antennanp
X_2397_ _2397_/Q Tile_X0Y5_FrameData[8] VGND VPWR Tile_X0Y9_FrameStrobe[6] latch
XFILLER_228_122 VPWR VGND sg13cmos5l_decap_8
XFILLER_541_42 VPWR VGND sg13cmos5l_decap_8
X_4136_ _4136_/X Tile_X0Y1_W1END[0] Tile_X0Y1_W2MID[3] Tile_X0Y1_W2END[3] _3994_/X
+ _1373_/Q _1372_/Q VPWR VGND sg13cmos5l_mux4_1
XFILLER_491_147 VPWR VGND sg13cmos5l_decap_8
XFILLER_3_91 VPWR VGND sg13cmos5l_decap_8
XFILLER_228_133 VPWR VGND sg13cmos5l_fill_2
X_1348_ _1348_/Q Tile_X0Y1_FrameData[21] VGND VPWR Tile_X0Y9_FrameStrobe[5] latch
XFILLER_260_21 VPWR VGND sg13cmos5l_decap_8
XFILLER_95_182 VPWR VGND sg13cmos5l_decap_8
XFILLER_228_177 VPWR VGND sg13cmos5l_fill_2
XFILLER_432_203 VPWR VGND sg13cmos5l_decap_8
X_4067_ _4067_/X Tile_X0Y2_WW4END[4] AXI_M_SOC_AWREADY _4120_/X _4102_/X _1539_/Q
+ _1538_/Q VPWR VGND sg13cmos5l_mux4_1
X_1279_ _1279_/Q Tile_X0Y1_FrameData[26] VGND VPWR Tile_X0Y9_FrameStrobe[3] latch
XFILLER_243_125 VPWR VGND sg13cmos5l_decap_8
XFILLER_633_185 VPWR VGND sg13cmos5l_fill_2
XFILLER_43_208 VPWR VGND sg13cmos5l_fill_2
X_3018_ Tile_X0Y5_E6BEG[5] _4409_/X VPWR VGND sg13cmos5l_buf_1
XFILLER_410_35 VPWR VGND sg13cmos5l_decap_8
XFILLER_486_28 VPWR VGND sg13cmos5l_decap_8
XFILLER_269_63 VPWR VGND sg13cmos5l_decap_8
XFILLER_400_155 VPWR VGND sg13cmos5l_decap_8
XFILLER_132_7 VPWR VGND sg13cmos5l_decap_8
XFILLER_400_199 VPWR VGND sg13cmos5l_decap_8
XFILLER_499_203 VPWR VGND sg13cmos5l_decap_8
XFILLER_419_77 VPWR VGND sg13cmos5l_decap_8
XFILLER_22_56 VPWR VGND sg13cmos5l_decap_8
XFILLER_703_112 VPWR VGND sg13cmos5l_decap_8
XFILLER_138_56 VPWR VGND sg13cmos5l_decap_8
XFILLER_285_84 VPWR VGND sg13cmos5l_decap_8
XFILLER_703_167 VPWR VGND sg13cmos5l_fill_1
XFILLER_164_187 VPWR VGND sg13cmos5l_fill_1
XFILLER_98_49 VPWR VGND sg13cmos5l_decap_8
XFILLER_435_21 VPWR VGND sg13cmos5l_decap_8
XFILLER_703_189 VPWR VGND sg13cmos5l_fill_2
XFILLER_599_7 VPWR VGND sg13cmos5l_decap_8
XFILLER_78_105 VPWR VGND sg13cmos5l_decap_8
XFILLER_435_98 VPWR VGND sg13cmos5l_decap_8
XFILLER_321_173 VPWR VGND sg13cmos5l_decap_8
XFILLER_304_14 VPWR VGND sg13cmos5l_decap_8
XANTENNA__3115__X Tile_X0Y7_EE4BEG[1] VPWR VGND sg13cmos5l_antennanp
XFILLER_609_160 VPWR VGND sg13cmos5l_decap_8
XFILLER_451_42 VPWR VGND sg13cmos5l_decap_8
XFILLER_47_31 VPWR VGND sg13cmos5l_decap_8
XFILLER_86_160 VPWR VGND sg13cmos5l_fill_1
XFILLER_19_216 VPWR VGND sg13cmos5l_fill_1
XFILLER_170_21 VPWR VGND sg13cmos5l_decap_8
XFILLER_86_182 VPWR VGND sg13cmos5l_decap_8
XANTENNA__2954__X Tile_X0Y8_EE4BEG[10] VPWR VGND sg13cmos5l_antennanp
XFILLER_601_56 VPWR VGND sg13cmos5l_decap_8
XFILLER_320_35 VPWR VGND sg13cmos5l_decap_8
XFILLER_103_70 VPWR VGND sg13cmos5l_decap_8
XFILLER_256_0 VPWR VGND sg13cmos5l_decap_8
XFILLER_677_49 VPWR VGND sg13cmos5l_decap_8
XFILLER_63_63 VPWR VGND sg13cmos5l_decap_8
XFILLER_242_180 VPWR VGND sg13cmos5l_decap_8
XFILLER_396_28 VPWR VGND sg13cmos5l_decap_8
XFILLER_179_63 VPWR VGND sg13cmos5l_fill_2
XFILLER_8_14 VPWR VGND sg13cmos5l_decap_8
XFILLER_423_0 VPWR VGND sg13cmos5l_decap_8
XFILLER_552_107 VPWR VGND sg13cmos5l_fill_1
XFILLER_552_118 VPWR VGND sg13cmos5l_decap_8
XFILLER_10_171 VPWR VGND sg13cmos5l_fill_1
XFILLER_545_192 VPWR VGND sg13cmos5l_decap_4
XFILLER_155_154 VPWR VGND sg13cmos5l_fill_1
XFILLER_626_42 VPWR VGND sg13cmos5l_decap_8
X_0650_ _0650_/Q Tile_X0Y8_FrameData[21] VGND VPWR Tile_X0Y9_FrameStrobe[7] latch
XFILLER_170_102 VPWR VGND sg13cmos5l_decap_8
XFILLER_155_187 VPWR VGND sg13cmos5l_fill_1
XFILLER_345_21 VPWR VGND sg13cmos5l_decap_8
X_0581_ _0581_/Q Tile_X0Y8_FrameData[26] VGND VPWR Tile_X0Y9_FrameStrobe[5] latch
X_2320_ _2320_/Q Tile_X0Y5_FrameData[21] VGND VPWR Tile_X0Y9_FrameStrobe[4] latch
XFILLER_69_105 VPWR VGND sg13cmos5l_decap_8
XFILLER_345_98 VPWR VGND sg13cmos5l_decap_8
XFILLER_458_155 VPWR VGND sg13cmos5l_fill_1
XFILLER_111_224 VPWR VGND sg13cmos5l_decap_4
XFILLER_458_177 VPWR VGND sg13cmos5l_decap_8
X_2251_ _2251_/Q Tile_X0Y5_FrameData[26] VGND VPWR Tile_X0Y9_FrameStrobe[2] latch
XFILLER_642_63 VPWR VGND sg13cmos5l_decap_8
XFILLER_257_228 VPWR VGND sg13cmos5l_fill_1
XFILLER_214_14 VPWR VGND sg13cmos5l_decap_8
XANTENNA__3025__X Tile_X0Y5_EE4BEG[0] VPWR VGND sg13cmos5l_antennanp
XFILLER_361_42 VPWR VGND sg13cmos5l_decap_8
XFILLER_84_119 VPWR VGND sg13cmos5l_decap_8
X_1202_ _1202_/Q Tile_X0Y1_FrameData[7] VGND VPWR Tile_X0Y9_FrameStrobe[0] latch
X_2182_ _2182_/Q Tile_X0Y4_FrameData[31] VGND VPWR Tile_X0Y9_FrameStrobe[0] latch
XANTENNA__2864__X Tile_X0Y6_EE4BEG[1] VPWR VGND sg13cmos5l_antennanp
X_1133_ _1133_/Q Tile_X0Y0_FrameData[30] VGND VPWR Tile_X0Y9_FrameStrobe[6] latch
XFILLER_511_56 VPWR VGND sg13cmos5l_decap_8
X_1064_ _1064_/Q Tile_X0Y0_FrameData[3] VGND VPWR Tile_X0Y9_FrameStrobe[3] latch
XFILLER_230_35 VPWR VGND sg13cmos5l_decap_8
XFILLER_587_49 VPWR VGND sg13cmos5l_decap_8
XFILLER_717_204 VPWR VGND sg13cmos5l_fill_1
X_4823_ _4823_/X Tile_X0Y7_W1END[3] Tile_X0Y7_W2MID[0] Tile_X0Y7_W2END[0] _4668_/X
+ _0357_/Q _0356_/Q VPWR VGND sg13cmos5l_mux4_1
XFILLER_583_210 VPWR VGND sg13cmos5l_fill_2
XANTENNA__3695__X AXI_M_SOC_WDATA5 VPWR VGND sg13cmos5l_antennanp
X_4754_ _4754_/X Tile_X0Y8_WW4END[5] AXI_M_SOC_RDATA13 _4805_/X _4788_/X _0539_/Q
+ _0538_/Q VPWR VGND sg13cmos5l_mux4_1
X_1966_ _1966_/Q Tile_X0Y4_FrameData[23] VGND VPWR Tile_X0Y9_FrameStrobe[1] latch
XFILLER_543_118 VPWR VGND sg13cmos5l_decap_8
X_3705_ AXI_M_SOC_WDATA15 Tile_X0Y7_W1END[3] Tile_X0Y7_WW4END[7] Tile_X0Y7_WW4END[15]
+ _4699_/X _0217_/Q _0216_/Q VPWR VGND sg13cmos5l_mux4_1
X_0917_ _0917_/Q Tile_X0Y9_FrameData[10] VGND VPWR Tile_X0Y9_FrameStrobe[7] latch
XFILLER_239_77 VPWR VGND sg13cmos5l_decap_8
X_4685_ _4685_/X _4663_/X Tile_X0Y9_N4END[9] _4662_/X _0055_/X _0213_/Q _0212_/Q VPWR
+ VGND sg13cmos5l_mux4_1
X_1897_ _1897_/Q Tile_X0Y3_FrameData[0] VGND VPWR Tile_X0Y9_FrameStrobe[6] latch
XFILLER_536_42 VPWR VGND sg13cmos5l_decap_8
X_3636_ Tile_X0Y9_S4BEG[14] _3636_/A VPWR VGND sg13cmos5l_buf_1
X_0848_ _0848_/Q Tile_X0Y9_FrameData[15] VGND VPWR Tile_X0Y9_FrameStrobe[5] latch
XFILLER_146_176 VPWR VGND sg13cmos5l_decap_8
XFILLER_697_144 VPWR VGND sg13cmos5l_fill_2
XFILLER_683_70 VPWR VGND sg13cmos5l_decap_8
XFILLER_255_21 VPWR VGND sg13cmos5l_decap_8
XFILLER_697_177 VPWR VGND sg13cmos5l_fill_1
X_3567_ Tile_X0Y9_EE4BEG[13] _4877_/X VPWR VGND sg13cmos5l_buf_1
XFILLER_496_228 VPWR VGND sg13cmos5l_fill_1
X_0779_ _0779_/Q Tile_X0Y9_FrameData[20] VGND VPWR Tile_X0Y9_FrameStrobe[3] latch
X_2518_ _2518_/Q Tile_X0Y6_FrameData[17] VGND VPWR Tile_X0Y9_FrameStrobe[2] latch
XFILLER_255_87 VPWR VGND sg13cmos5l_decap_8
X_3498_ Tile_X0Y1_E6BEG[8] _3972_/X VPWR VGND sg13cmos5l_buf_1
XFILLER_449_155 VPWR VGND sg13cmos5l_decap_8
XFILLER_405_35 VPWR VGND sg13cmos5l_decap_8
XFILLER_248_217 VPWR VGND sg13cmos5l_decap_4
XFILLER_552_63 VPWR VGND sg13cmos5l_decap_8
X_2449_ _2449_/Q Tile_X0Y6_FrameData[22] VGND VPWR Tile_X0Y9_FrameStrobe[0] latch
XFILLER_653_203 VPWR VGND sg13cmos5l_decap_8
XFILLER_405_79 VPWR VGND sg13cmos5l_fill_1
XFILLER_271_42 VPWR VGND sg13cmos5l_decap_8
XFILLER_124_47 VPWR VGND sg13cmos5l_decap_8
XFILLER_702_66 VPWR VGND sg13cmos5l_decap_8
XANTENNA__2774__X Tile_X0Y3_EE4BEG[0] VPWR VGND sg13cmos5l_antennanp
X_4119_ _4119_/X _4095_/X _0094_/X _4094_/X Tile_X0Y0_S4END[11] _1475_/Q _1474_/Q
+ VPWR VGND sg13cmos5l_mux4_1
XFILLER_405_203 VPWR VGND sg13cmos5l_decap_8
XFILLER_421_56 VPWR VGND sg13cmos5l_decap_8
XFILLER_204_91 VPWR VGND sg13cmos5l_decap_8
XFILLER_17_56 VPWR VGND sg13cmos5l_decap_8
XFILLER_140_35 VPWR VGND sg13cmos5l_decap_8
XFILLER_420_228 VPWR VGND sg13cmos5l_fill_1
XFILLER_621_188 VPWR VGND sg13cmos5l_fill_2
XFILLER_497_49 VPWR VGND sg13cmos5l_decap_8
XFILLER_347_7 VPWR VGND sg13cmos5l_decap_8
XFILLER_231_139 VPWR VGND sg13cmos5l_decap_8
XFILLER_574_210 VPWR VGND sg13cmos5l_decap_8
XFILLER_385_143 VPWR VGND sg13cmos5l_decap_8
XFILLER_514_7 VPWR VGND sg13cmos5l_decap_8
XFILLER_33_66 VPWR VGND sg13cmos5l_decap_8
XFILLER_326_221 VPWR VGND sg13cmos5l_decap_8
XFILLER_149_77 VPWR VGND sg13cmos5l_decap_8
XFILLER_137_154 VPWR VGND sg13cmos5l_decap_8
XFILLER_446_42 VPWR VGND sg13cmos5l_decap_8
XFILLER_593_70 VPWR VGND sg13cmos5l_decap_8
XFILLER_341_202 VPWR VGND sg13cmos5l_decap_8
XFILLER_688_155 VPWR VGND sg13cmos5l_decap_4
XFILLER_298_106 VPWR VGND sg13cmos5l_fill_1
XFILLER_165_21 VPWR VGND sg13cmos5l_decap_8
XFILLER_688_166 VPWR VGND sg13cmos5l_decap_8
XANTENNA__2949__X Tile_X0Y8_EE4BEG[5] VPWR VGND sg13cmos5l_antennanp
XFILLER_487_228 VPWR VGND sg13cmos5l_fill_1
XFILLER_688_188 VPWR VGND sg13cmos5l_decap_4
XFILLER_688_199 VPWR VGND sg13cmos5l_decap_8
XFILLER_315_35 VPWR VGND sg13cmos5l_decap_8
XFILLER_462_63 VPWR VGND sg13cmos5l_decap_8
XFILLER_455_103 VPWR VGND sg13cmos5l_decap_4
XFILLER_160_190 VPWR VGND sg13cmos5l_fill_1
XFILLER_644_203 VPWR VGND sg13cmos5l_decap_8
XFILLER_58_52 VPWR VGND sg13cmos5l_decap_8
XFILLER_66_108 VPWR VGND sg13cmos5l_decap_8
XFILLER_462_96 VPWR VGND sg13cmos5l_decap_8
XFILLER_181_42 VPWR VGND sg13cmos5l_decap_8
XFILLER_59_160 VPWR VGND sg13cmos5l_decap_8
XFILLER_373_0 VPWR VGND sg13cmos5l_decap_8
XFILLER_612_77 VPWR VGND sg13cmos5l_decap_8
XFILLER_331_56 VPWR VGND sg13cmos5l_decap_8
XFILLER_114_91 VPWR VGND sg13cmos5l_decap_8
XFILLER_207_147 VPWR VGND sg13cmos5l_decap_8
XFILLER_612_133 VPWR VGND sg13cmos5l_fill_2
XFILLER_540_0 VPWR VGND sg13cmos5l_decap_8
XFILLER_74_84 VPWR VGND sg13cmos5l_decap_8
XFILLER_638_0 VPWR VGND sg13cmos5l_decap_8
XFILLER_30_200 VPWR VGND sg13cmos5l_fill_1
XFILLER_95_7 VPWR VGND sg13cmos5l_decap_8
XFILLER_200_49 VPWR VGND sg13cmos5l_decap_8
XFILLER_30_222 VPWR VGND sg13cmos5l_decap_8
XFILLER_376_143 VPWR VGND sg13cmos5l_fill_2
X_1820_ _1820_/Q Tile_X0Y3_FrameData[13] VGND VPWR Tile_X0Y9_FrameStrobe[4] latch
XFILLER_90_83 VPWR VGND sg13cmos5l_decap_8
XFILLER_525_118 VPWR VGND sg13cmos5l_fill_1
XFILLER_391_124 VPWR VGND sg13cmos5l_decap_8
XFILLER_376_198 VPWR VGND sg13cmos5l_fill_2
X_1751_ _1751_/Q Tile_X0Y3_FrameData[18] VGND VPWR Tile_X0Y9_FrameStrobe[2] latch
XFILLER_637_63 VPWR VGND sg13cmos5l_decap_8
XFILLER_209_14 VPWR VGND sg13cmos5l_decap_8
X_0702_ _0702_/Q Tile_X0Y9_FrameData[1] VGND VPWR Tile_X0Y9_FrameStrobe[0] latch
XFILLER_356_42 VPWR VGND sg13cmos5l_decap_8
X_4470_ _4470_/X Tile_X0Y4_W2MID[6] Tile_X0Y4_W2END[6] Tile_X0Y4_W6END[9] _4315_/X
+ _2135_/Q _2134_/Q VPWR VGND sg13cmos5l_mux4_1
X_1682_ _1682_/Q Tile_X0Y3_FrameData[23] VGND VPWR Tile_X0Y9_FrameStrobe[0] latch
XFILLER_533_173 VPWR VGND sg13cmos5l_fill_2
XFILLER_99_70 VPWR VGND sg13cmos5l_decap_8
X_3421_ Tile_X0Y4_FrameData_O[12] Tile_X0Y4_FrameData[12] VPWR VGND sg13cmos5l_buf_1
XANTENNA__2859__X Tile_X0Y6_E6BEG[8] VPWR VGND sg13cmos5l_antennanp
X_0633_ _0633_/Q Tile_X0Y8_FrameData[6] VGND VPWR Tile_X0Y9_FrameStrobe[6] latch
XFILLER_506_56 VPWR VGND sg13cmos5l_decap_8
XFILLER_143_168 VPWR VGND sg13cmos5l_decap_8
X_3352_ Tile_X0Y2_FrameData_O[23] Tile_X0Y2_FrameData[23] VPWR VGND sg13cmos5l_buf_1
X_0564_ _0564_/Q Tile_X0Y8_FrameData[11] VGND VPWR Tile_X0Y9_FrameStrobe[4] latch
XFILLER_653_84 VPWR VGND sg13cmos5l_decap_8
XFILLER_225_35 VPWR VGND sg13cmos5l_decap_8
X_2303_ _2303_/Q Tile_X0Y5_FrameData[6] VGND VPWR Tile_X0Y9_FrameStrobe[3] latch
XFILLER_372_63 VPWR VGND sg13cmos5l_decap_8
X_3283_ Tile_X0Y0_E6BEG[3] _3839_/X VPWR VGND sg13cmos5l_buf_1
XFILLER_297_183 VPWR VGND sg13cmos5l_decap_8
X_0495_ _0495_/Q Tile_X0Y8_FrameData[16] VGND VPWR Tile_X0Y9_FrameStrobe[2] latch
X_2234_ _2234_/Q Tile_X0Y5_FrameData[11] VGND VPWR Tile_X0Y9_FrameStrobe[1] latch
XFILLER_245_209 VPWR VGND sg13cmos5l_fill_2
XFILLER_17_0 VPWR VGND sg13cmos5l_decap_8
XFILLER_650_217 VPWR VGND sg13cmos5l_fill_1
XFILLER_522_77 VPWR VGND sg13cmos5l_decap_8
XFILLER_461_117 VPWR VGND sg13cmos5l_decap_4
X_2165_ _2165_/Q Tile_X0Y4_FrameData[16] VGND VPWR Tile_X0Y9_FrameStrobe[7] latch
XFILLER_65_141 VPWR VGND sg13cmos5l_decap_8
XFILLER_650_228 VPWR VGND sg13cmos5l_fill_1
XFILLER_399_202 VPWR VGND sg13cmos5l_decap_8
XFILLER_253_220 VPWR VGND sg13cmos5l_decap_8
XFILLER_241_56 VPWR VGND sg13cmos5l_decap_8
X_1116_ _1116_/Q Tile_X0Y0_FrameData[15] VGND VPWR Tile_X0Y9_FrameStrobe[5] latch
XFILLER_603_133 VPWR VGND sg13cmos5l_fill_1
X_2096_ _2096_/Q Tile_X0Y4_FrameData[21] VGND VPWR Tile_X0Y9_FrameStrobe[5] latch
XFILLER_0_70 VPWR VGND sg13cmos5l_decap_8
X_1047_ _1047_/Q Tile_X0Y0_FrameData[20] VGND VPWR Tile_X0Y9_FrameStrobe[3] latch
XFILLER_678_70 VPWR VGND sg13cmos5l_decap_8
XFILLER_556_210 VPWR VGND sg13cmos5l_decap_8
XFILLER_110_49 VPWR VGND sg13cmos5l_decap_8
X_4806_ _4806_/X _4781_/X Tile_X0Y9_N4END[6] _4780_/X _0075_/X _0459_/Q _0458_/Q VPWR
+ VGND sg13cmos5l_mux4_1
XFILLER_367_165 VPWR VGND sg13cmos5l_fill_2
X_2998_ Tile_X0Y5_E2BEG[1] _4373_/X VPWR VGND sg13cmos5l_buf_1
XFILLER_547_63 VPWR VGND sg13cmos5l_decap_8
X_1949_ _1949_/Q Tile_X0Y4_FrameData[8] VGND VPWR Tile_X0Y9_FrameStrobe[0] latch
X_4737_ _4737_/X Tile_X0Y8_W2END[6] AXI_M_SOC_RDATA14 _4787_/X _4786_/X _0573_/Q _0572_/Q
+ VPWR VGND sg13cmos5l_mux4_1
XFILLER_119_14 VPWR VGND sg13cmos5l_decap_8
XFILLER_694_91 VPWR VGND sg13cmos5l_decap_8
XFILLER_181_208 VPWR VGND sg13cmos5l_decap_8
XFILLER_266_42 VPWR VGND sg13cmos5l_decap_8
X_4668_ _4668_/X _4599_/X _4715_/X _4714_/X _4598_/X _0169_/Q _0168_/Q VPWR VGND sg13cmos5l_mux4_1
XANTENNA__2769__X Tile_X0Y3_FrameData_O[27] VPWR VGND sg13cmos5l_antennanp
X_3619_ Tile_X0Y9_S2BEGb[5] _4937_/X VPWR VGND sg13cmos5l_buf_1
XFILLER_524_195 VPWR VGND sg13cmos5l_fill_1
X_4599_ _4599_/X Tile_X0Y8_W2MID[0] Tile_X0Y8_W2END[0] Tile_X0Y8_W6END[0] _4784_/X
+ _0649_/Q _0648_/Q VPWR VGND sg13cmos5l_mux4_1
XFILLER_685_125 VPWR VGND sg13cmos5l_decap_8
XFILLER_416_56 VPWR VGND sg13cmos5l_decap_8
XFILLER_563_84 VPWR VGND sg13cmos5l_decap_8
XFILLER_135_35 VPWR VGND sg13cmos5l_decap_8
XFILLER_713_21 VPWR VGND sg13cmos5l_decap_8
XFILLER_288_172 VPWR VGND sg13cmos5l_decap_8
XFILLER_282_63 VPWR VGND sg13cmos5l_decap_8
XFILLER_95_28 VPWR VGND sg13cmos5l_decap_8
XFILLER_297_7 VPWR VGND sg13cmos5l_decap_8
XFILLER_713_98 VPWR VGND sg13cmos5l_decap_8
XFILLER_452_117 VPWR VGND sg13cmos5l_decap_8
XFILLER_432_77 VPWR VGND sg13cmos5l_decap_8
XFILLER_464_7 VPWR VGND sg13cmos5l_decap_8
XFILLER_641_228 VPWR VGND sg13cmos5l_fill_1
XFILLER_28_77 VPWR VGND sg13cmos5l_decap_8
XFILLER_151_56 VPWR VGND sg13cmos5l_decap_8
XFILLER_151_89 VPWR VGND sg13cmos5l_fill_1
XFILLER_71_133 VPWR VGND sg13cmos5l_fill_2
XFILLER_631_7 VPWR VGND sg13cmos5l_decap_8
XFILLER_460_172 VPWR VGND sg13cmos5l_decap_4
XFILLER_460_183 VPWR VGND sg13cmos5l_fill_2
XFILLER_588_70 VPWR VGND sg13cmos5l_decap_8
XFILLER_44_54 VPWR VGND sg13cmos5l_decap_8
XFILLER_212_161 VPWR VGND sg13cmos5l_decap_8
XFILLER_562_202 VPWR VGND sg13cmos5l_decap_4
XFILLER_674_28 VPWR VGND sg13cmos5l_decap_8
XFILLER_60_42 VPWR VGND sg13cmos5l_decap_8
XFILLER_373_135 VPWR VGND sg13cmos5l_fill_2
XFILLER_457_63 VPWR VGND sg13cmos5l_decap_8
XFILLER_121_0 VPWR VGND sg13cmos5l_decap_8
XFILLER_219_0 VPWR VGND sg13cmos5l_decap_8
XFILLER_176_42 VPWR VGND sg13cmos5l_decap_8
XFILLER_373_179 VPWR VGND sg13cmos5l_fill_1
XFILLER_530_110 VPWR VGND sg13cmos5l_decap_8
XFILLER_607_77 VPWR VGND sg13cmos5l_decap_8
XFILLER_326_56 VPWR VGND sg13cmos5l_decap_8
XFILLER_140_105 VPWR VGND sg13cmos5l_decap_8
XFILLER_690_49 VPWR VGND sg13cmos5l_decap_8
XFILLER_623_21 VPWR VGND sg13cmos5l_decap_8
XFILLER_490_0 VPWR VGND sg13cmos5l_decap_8
XFILLER_69_84 VPWR VGND sg13cmos5l_decap_8
XFILLER_279_161 VPWR VGND sg13cmos5l_decap_8
XFILLER_588_0 VPWR VGND sg13cmos5l_decap_8
XFILLER_279_194 VPWR VGND sg13cmos5l_decap_8
XFILLER_617_225 VPWR VGND sg13cmos5l_decap_4
XFILLER_294_131 VPWR VGND sg13cmos5l_fill_2
XFILLER_428_147 VPWR VGND sg13cmos5l_decap_8
XFILLER_94_225 VPWR VGND sg13cmos5l_decap_4
X_0280_ _0280_/Q Tile_X0Y7_FrameData[7] VGND VPWR Tile_X0Y9_FrameStrobe[3] latch
XFILLER_623_98 VPWR VGND sg13cmos5l_decap_8
XFILLER_227_209 VPWR VGND sg13cmos5l_fill_2
XFILLER_342_77 VPWR VGND sg13cmos5l_decap_8
XFILLER_10_7 VPWR VGND sg13cmos5l_decap_8
XFILLER_699_47 VPWR VGND sg13cmos5l_decap_8
XFILLER_632_228 VPWR VGND sg13cmos5l_fill_1
XANTENNA__3303__X Tile_X0Y0_E2BEG[3] VPWR VGND sg13cmos5l_antennanp
XFILLER_436_180 VPWR VGND sg13cmos5l_decap_8
XFILLER_47_185 VPWR VGND sg13cmos5l_decap_4
XFILLER_62_133 VPWR VGND sg13cmos5l_decap_8
X_3970_ _3970_/X AXI_M_SOC_ARREADY _4013_/X _4017_/X _3993_/X _1269_/Q _1268_/Q VPWR
+ VGND sg13cmos5l_mux4_1
XFILLER_396_216 VPWR VGND sg13cmos5l_decap_8
XFILLER_597_176 VPWR VGND sg13cmos5l_decap_4
XFILLER_451_194 VPWR VGND sg13cmos5l_decap_8
XFILLER_396_227 VPWR VGND sg13cmos5l_fill_2
XFILLER_498_70 VPWR VGND sg13cmos5l_decap_8
X_2921_ Tile_X0Y8_E2BEG[5] _4733_/X VPWR VGND sg13cmos5l_buf_1
XFILLER_538_210 VPWR VGND sg13cmos5l_decap_8
XFILLER_349_154 VPWR VGND sg13cmos5l_decap_8
XFILLER_148_205 VPWR VGND sg13cmos5l_decap_8
X_2852_ Tile_X0Y6_E6BEG[1] _4529_/X VPWR VGND sg13cmos5l_buf_1
XFILLER_349_176 VPWR VGND sg13cmos5l_decap_8
XFILLER_203_194 VPWR VGND sg13cmos5l_fill_1
XFILLER_648_84 VPWR VGND sg13cmos5l_decap_8
X_1803_ _1803_/Q Tile_X0Y3_FrameData[30] VGND VPWR Tile_X0Y9_FrameStrobe[4] latch
XFILLER_584_28 VPWR VGND sg13cmos5l_decap_8
XFILLER_367_63 VPWR VGND sg13cmos5l_decap_8
X_2783_ Tile_X0Y3_EE4BEG[9] _4173_/X VPWR VGND sg13cmos5l_buf_1
X_4522_ _4522_/X Tile_X0Y6_WW4END[5] AXI_M_SOC_RDATA29 _4573_/X _4556_/X _2563_/Q
+ _2562_/Q VPWR VGND sg13cmos5l_mux4_1
XFILLER_506_140 VPWR VGND sg13cmos5l_decap_8
X_1734_ _1734_/Q Tile_X0Y3_FrameData[3] VGND VPWR Tile_X0Y9_FrameStrobe[1] latch
XFILLER_305_202 VPWR VGND sg13cmos5l_fill_1
XFILLER_305_224 VPWR VGND sg13cmos5l_decap_4
XFILLER_710_210 VPWR VGND sg13cmos5l_fill_2
X_4453_ _4453_/X _4424_/X _0100_/X _4423_/X _0140_/X _2233_/Q _2232_/Q VPWR VGND sg13cmos5l_mux4_1
XFILLER_517_77 VPWR VGND sg13cmos5l_decap_8
XFILLER_116_146 VPWR VGND sg13cmos5l_fill_1
X_1665_ _1665_/Q Tile_X0Y2_FrameData[16] VGND VPWR Tile_X0Y9_FrameStrobe[7] latch
XFILLER_236_56 VPWR VGND sg13cmos5l_decap_8
X_3404_ Tile_X0Y2_E2BEG[7] _4047_/X VPWR VGND sg13cmos5l_buf_1
XFILLER_131_105 VPWR VGND sg13cmos5l_decap_8
X_0616_ _0616_/Q Tile_X0Y8_FrameData[23] VGND VPWR Tile_X0Y9_FrameStrobe[6] latch
X_4384_ _4384_/X Tile_X0Y5_W2END[3] AXI_M_SOC_RRESP1 _4434_/X _4433_/X _2335_/Q _2334_/Q
+ VPWR VGND sg13cmos5l_mux4_1
XFILLER_383_84 VPWR VGND sg13cmos5l_fill_2
X_1596_ _1596_/Q Tile_X0Y2_FrameData[21] VGND VPWR Tile_X0Y9_FrameStrobe[5] latch
XFILLER_533_21 VPWR VGND sg13cmos5l_decap_8
X_3335_ Tile_X0Y2_FrameData_O[6] Tile_X0Y2_FrameData[6] VPWR VGND sg13cmos5l_buf_1
X_0547_ _0547_/Q Tile_X0Y8_FrameData[28] VGND VPWR Tile_X0Y9_FrameStrobe[4] latch
XFILLER_474_220 VPWR VGND sg13cmos5l_decap_8
X_3266_ Tile_X0Y0_EE4BEG[2] _3822_/X VPWR VGND sg13cmos5l_buf_1
X_0478_ _0478_/Q Tile_X0Y8_FrameData[1] VGND VPWR Tile_X0Y9_FrameStrobe[1] latch
XFILLER_419_169 VPWR VGND sg13cmos5l_decap_8
XFILLER_105_49 VPWR VGND sg13cmos5l_decap_8
XFILLER_285_186 VPWR VGND sg13cmos5l_fill_1
X_2217_ _2217_/Q Tile_X0Y5_FrameData[28] VGND VPWR Tile_X0Y9_FrameStrobe[1] latch
XFILLER_252_77 VPWR VGND sg13cmos5l_decap_8
XFILLER_402_14 VPWR VGND sg13cmos5l_decap_8
X_3197_ Tile_X0Y0_N2BEGb[5] _3899_/X VPWR VGND sg13cmos5l_buf_1
XANTENNA__3213__X Tile_X0Y0_FrameStrobe_O[1] VPWR VGND sg13cmos5l_antennanp
X_2148_ _2148_/Q Tile_X0Y4_FrameData[1] VGND VPWR Tile_X0Y9_FrameStrobe[6] latch
X_2079_ _2079_/Q Tile_X0Y4_FrameData[6] VGND VPWR Tile_X0Y9_FrameStrobe[4] latch
XFILLER_53_166 VPWR VGND sg13cmos5l_decap_8
XFILLER_201_70 VPWR VGND sg13cmos5l_decap_8
XFILLER_14_35 VPWR VGND sg13cmos5l_decap_8
XFILLER_558_84 VPWR VGND sg13cmos5l_decap_8
XFILLER_708_21 VPWR VGND sg13cmos5l_decap_8
XFILLER_494_28 VPWR VGND sg13cmos5l_decap_8
XFILLER_277_63 VPWR VGND sg13cmos5l_decap_8
XFILLER_355_168 VPWR VGND sg13cmos5l_decap_8
XFILLER_212_7 VPWR VGND sg13cmos5l_decap_8
XFILLER_708_98 VPWR VGND sg13cmos5l_decap_8
XFILLER_30_34 VPWR VGND sg13cmos5l_decap_8
XFILLER_107_135 VPWR VGND sg13cmos5l_fill_1
XFILLER_701_210 VPWR VGND sg13cmos5l_fill_2
XFILLER_427_77 VPWR VGND sg13cmos5l_decap_8
XFILLER_146_56 VPWR VGND sg13cmos5l_decap_8
XFILLER_122_116 VPWR VGND sg13cmos5l_decap_8
XFILLER_293_84 VPWR VGND sg13cmos5l_decap_8
XFILLER_443_21 VPWR VGND sg13cmos5l_decap_8
XFILLER_581_7 VPWR VGND sg13cmos5l_decap_8
XFILLER_679_7 VPWR VGND sg13cmos5l_decap_8
XFILLER_443_98 VPWR VGND sg13cmos5l_decap_8
XFILLER_130_182 VPWR VGND sg13cmos5l_decap_8
XFILLER_276_175 VPWR VGND sg13cmos5l_decap_8
XFILLER_276_186 VPWR VGND sg13cmos5l_fill_2
XFILLER_291_112 VPWR VGND sg13cmos5l_decap_8
XFILLER_614_228 VPWR VGND sg13cmos5l_fill_1
XFILLER_480_223 VPWR VGND sg13cmos5l_decap_4
XFILLER_312_14 VPWR VGND sg13cmos5l_decap_8
XFILLER_681_183 VPWR VGND sg13cmos5l_decap_8
XANTENNA__3123__X Tile_X0Y7_EE4BEG[9] VPWR VGND sg13cmos5l_antennanp
XFILLER_91_228 VPWR VGND sg13cmos5l_fill_1
XFILLER_669_28 VPWR VGND sg13cmos5l_decap_8
XFILLER_55_42 VPWR VGND sg13cmos5l_decap_8
XFILLER_599_91 VPWR VGND sg13cmos5l_decap_8
XFILLER_579_154 VPWR VGND sg13cmos5l_decap_8
XANTENNA__2962__X Tile_X0Y8_FrameData_O[2] VPWR VGND sg13cmos5l_antennanp
XFILLER_169_0 VPWR VGND sg13cmos5l_decap_8
XFILLER_433_194 VPWR VGND sg13cmos5l_decap_8
XFILLER_111_70 VPWR VGND sg13cmos5l_decap_8
XFILLER_336_0 VPWR VGND sg13cmos5l_decap_8
XFILLER_71_63 VPWR VGND sg13cmos5l_decap_8
XFILLER_685_49 VPWR VGND sg13cmos5l_decap_8
XFILLER_618_21 VPWR VGND sg13cmos5l_decap_8
XFILLER_503_0 VPWR VGND sg13cmos5l_decap_8
XFILLER_361_105 VPWR VGND sg13cmos5l_decap_8
XFILLER_200_197 VPWR VGND sg13cmos5l_fill_1
XFILLER_618_98 VPWR VGND sg13cmos5l_decap_8
XFILLER_550_227 VPWR VGND sg13cmos5l_fill_2
XFILLER_484_61 VPWR VGND sg13cmos5l_decap_8
XFILLER_337_77 VPWR VGND sg13cmos5l_decap_4
XFILLER_634_42 VPWR VGND sg13cmos5l_decap_8
XFILLER_503_154 VPWR VGND sg13cmos5l_decap_8
X_1450_ _1450_/Q Tile_X0Y2_FrameData[7] VGND VPWR Tile_X0Y9_FrameStrobe[0] latch
XFILLER_353_21 VPWR VGND sg13cmos5l_decap_8
XFILLER_302_227 VPWR VGND sg13cmos5l_fill_2
X_0401_ _0401_/Q Tile_X0Y7_FrameData[14] VGND VPWR Tile_X0Y9_FrameStrobe[7] latch
X_1381_ _1381_/Q Tile_X0Y1_FrameData[20] VGND VPWR Tile_X0Y9_FrameStrobe[6] latch
XFILLER_96_60 VPWR VGND sg13cmos5l_fill_1
X_3120_ Tile_X0Y7_EE4BEG[6] _4634_/X VPWR VGND sg13cmos5l_buf_1
X_0332_ _0332_/Q Tile_X0Y7_FrameData[19] VGND VPWR Tile_X0Y9_FrameStrobe[5] latch
XFILLER_353_98 VPWR VGND sg13cmos5l_decap_8
XFILLER_503_35 VPWR VGND sg13cmos5l_decap_8
XFILLER_282_112 VPWR VGND sg13cmos5l_decap_8
X_3051_ Tile_X0Y5_FrameData_O[10] Tile_X0Y5_FrameData[10] VPWR VGND sg13cmos5l_buf_1
XFILLER_650_63 VPWR VGND sg13cmos5l_decap_8
X_0263_ _0263_/Q Tile_X0Y7_FrameData[24] VGND VPWR Tile_X0Y9_FrameStrobe[3] latch
XFILLER_222_14 VPWR VGND sg13cmos5l_decap_8
XANTENNA__3033__X Tile_X0Y5_EE4BEG[8] VPWR VGND sg13cmos5l_antennanp
XFILLER_82_228 VPWR VGND sg13cmos5l_fill_1
X_2002_ _2002_/Q Tile_X0Y4_FrameData[19] VGND VPWR Tile_X0Y9_FrameStrobe[2] latch
XFILLER_579_28 VPWR VGND sg13cmos5l_decap_8
X_0194_ _0194_/Q Tile_X0Y7_FrameData[29] VGND VPWR Tile_X0Y9_FrameStrobe[1] latch
XFILLER_424_161 VPWR VGND sg13cmos5l_decap_8
XANTENNA__2872__X Tile_X0Y6_EE4BEG[9] VPWR VGND sg13cmos5l_antennanp
X_3953_ _3953_/X Tile_X0Y1_WW4END[10] AXI_M_SOC_ARREADY _4018_/X _3993_/X _1303_/Q
+ _1302_/Q VPWR VGND sg13cmos5l_mux4_1
XFILLER_188_160 VPWR VGND sg13cmos5l_decap_8
X_2904_ Tile_X0Y6_FrameData_O[25] Tile_X0Y6_FrameData[25] VPWR VGND sg13cmos5l_buf_1
XFILLER_188_171 VPWR VGND sg13cmos5l_fill_1
X_3884_ _3884_/X _3851_/X _0078_/X Tile_X0Y0_S1END[3] Tile_X0Y0_S4END[3] _0989_/Q
+ _0988_/Q VPWR VGND sg13cmos5l_mux4_1
XFILLER_595_49 VPWR VGND sg13cmos5l_decap_8
XFILLER_84_0 VPWR VGND sg13cmos5l_decap_8
XFILLER_528_21 VPWR VGND sg13cmos5l_decap_8
X_2835_ Tile_X0Y6_E2BEG[0] _4496_/X VPWR VGND sg13cmos5l_buf_1
XFILLER_136_208 VPWR VGND sg13cmos5l_decap_8
XFILLER_352_105 VPWR VGND sg13cmos5l_decap_8
XFILLER_337_179 VPWR VGND sg13cmos5l_decap_4
X_2766_ Tile_X0Y3_FrameData_O[24] Tile_X0Y3_FrameData[24] VPWR VGND sg13cmos5l_buf_1
X_1717_ _1717_/Q Tile_X0Y3_FrameData[20] VGND VPWR Tile_X0Y9_FrameStrobe[1] latch
X_4505_ _4505_/X Tile_X0Y6_W2END[6] AXI_M_SOC_RDATA30 _4555_/X _4554_/X _2597_/Q _2596_/Q
+ VPWR VGND sg13cmos5l_mux4_1
XFILLER_247_77 VPWR VGND sg13cmos5l_fill_2
X_2697_ _4087_/A3 VPWR VGND sg13cmos5l_tielo
XANTENNA__3208__X Tile_X0Y0_N1BEG[0] VPWR VGND sg13cmos5l_antennanp
XFILLER_544_42 VPWR VGND sg13cmos5l_decap_8
X_4436_ _4436_/X _4012_/X _4016_/X _4005_/X _3994_/X _1365_/Q _1364_/Q VPWR VGND sg13cmos5l_mux4_1
XFILLER_6_91 VPWR VGND sg13cmos5l_decap_8
XFILLER_104_116 VPWR VGND sg13cmos5l_fill_2
X_1648_ _1648_/Q Tile_X0Y2_FrameData[1] VGND VPWR Tile_X0Y9_FrameStrobe[6] latch
XFILLER_691_70 VPWR VGND sg13cmos5l_decap_8
XFILLER_263_21 VPWR VGND sg13cmos5l_decap_8
X_4367_ _4367_/X Tile_X0Y6_W2MID[0] Tile_X0Y6_W2END[0] Tile_X0Y6_W6END[0] _4552_/X
+ _2673_/Q _2672_/Q VPWR VGND sg13cmos5l_mux4_1
X_1579_ _1579_/Q Tile_X0Y2_FrameData[6] VGND VPWR Tile_X0Y9_FrameStrobe[4] latch
X_3318_ Tile_X0Y4_EE4BEG[6] _4278_/X VPWR VGND sg13cmos5l_buf_1
X_4298_ _4298_/X AXI_M_SOC_BRESP0 _4337_/X _4341_/X _4314_/X _2017_/Q _2016_/Q VPWR
+ VGND sg13cmos5l_mux4_1
XFILLER_413_35 VPWR VGND sg13cmos5l_decap_8
XFILLER_273_112 VPWR VGND sg13cmos5l_decap_8
XFILLER_258_186 VPWR VGND sg13cmos5l_decap_8
XFILLER_560_63 VPWR VGND sg13cmos5l_decap_8
X_3249_ Tile_X0Y0_FrameData_O[17] Tile_X0Y0_FrameData[17] VPWR VGND sg13cmos5l_buf_1
XFILLER_132_14 VPWR VGND sg13cmos5l_decap_8
XFILLER_73_228 VPWR VGND sg13cmos5l_fill_1
XFILLER_273_167 VPWR VGND sg13cmos5l_decap_4
XFILLER_489_28 VPWR VGND sg13cmos5l_decap_8
XANTENNA__2782__X Tile_X0Y3_EE4BEG[8] VPWR VGND sg13cmos5l_antennanp
XFILLER_710_77 VPWR VGND sg13cmos5l_decap_8
XFILLER_26_144 VPWR VGND sg13cmos5l_decap_8
XFILLER_162_7 VPWR VGND sg13cmos5l_decap_8
XFILLER_212_91 VPWR VGND sg13cmos5l_decap_8
XFILLER_41_125 VPWR VGND sg13cmos5l_fill_2
XFILLER_25_56 VPWR VGND sg13cmos5l_decap_8
XFILLER_430_175 VPWR VGND sg13cmos5l_decap_8
XFILLER_427_7 VPWR VGND sg13cmos5l_decap_8
XFILLER_288_84 VPWR VGND sg13cmos5l_decap_8
XFILLER_438_21 VPWR VGND sg13cmos5l_decap_8
XFILLER_328_157 VPWR VGND sg13cmos5l_decap_8
XFILLER_41_66 VPWR VGND sg13cmos5l_decap_8
XFILLER_343_105 VPWR VGND sg13cmos5l_decap_4
XFILLER_438_98 VPWR VGND sg13cmos5l_decap_4
XFILLER_336_190 VPWR VGND sg13cmos5l_fill_1
XFILLER_307_14 VPWR VGND sg13cmos5l_decap_8
XANTENNA__3118__X Tile_X0Y7_EE4BEG[4] VPWR VGND sg13cmos5l_antennanp
XFILLER_454_42 VPWR VGND sg13cmos5l_decap_8
XFILLER_351_182 VPWR VGND sg13cmos5l_decap_8
XFILLER_296_215 VPWR VGND sg13cmos5l_decap_4
XFILLER_173_21 VPWR VGND sg13cmos5l_decap_8
XFILLER_497_175 VPWR VGND sg13cmos5l_decap_8
XANTENNA__2957__X Tile_X0Y8_EE4BEG[13] VPWR VGND sg13cmos5l_antennanp
XFILLER_604_56 VPWR VGND sg13cmos5l_decap_8
XFILLER_500_168 VPWR VGND sg13cmos5l_decap_8
XFILLER_639_191 VPWR VGND sg13cmos5l_fill_1
XFILLER_173_98 VPWR VGND sg13cmos5l_fill_2
XFILLER_103_182 VPWR VGND sg13cmos5l_decap_8
XFILLER_323_35 VPWR VGND sg13cmos5l_decap_8
XFILLER_2_49 VPWR VGND sg13cmos5l_decap_8
XFILLER_264_101 VPWR VGND sg13cmos5l_decap_8
XFILLER_106_70 VPWR VGND sg13cmos5l_fill_1
XFILLER_654_161 VPWR VGND sg13cmos5l_decap_8
XFILLER_286_0 VPWR VGND sg13cmos5l_decap_8
XFILLER_66_41 VPWR VGND sg13cmos5l_decap_8
XFILLER_470_63 VPWR VGND sg13cmos5l_decap_8
XFILLER_64_206 VPWR VGND sg13cmos5l_decap_8
XFILLER_599_227 VPWR VGND sg13cmos5l_fill_2
XFILLER_64_228 VPWR VGND sg13cmos5l_fill_1
XFILLER_399_28 VPWR VGND sg13cmos5l_decap_8
XFILLER_453_0 VPWR VGND sg13cmos5l_decap_8
XFILLER_406_172 VPWR VGND sg13cmos5l_fill_1
XFILLER_205_212 VPWR VGND sg13cmos5l_fill_2
XFILLER_17_144 VPWR VGND sg13cmos5l_fill_1
XFILLER_620_77 VPWR VGND sg13cmos5l_decap_8
XFILLER_122_91 VPWR VGND sg13cmos5l_decap_4
XFILLER_32_114 VPWR VGND sg13cmos5l_decap_4
XFILLER_620_0 VPWR VGND sg13cmos5l_decap_8
XFILLER_32_136 VPWR VGND sg13cmos5l_fill_1
XFILLER_82_84 VPWR VGND sg13cmos5l_decap_8
XFILLER_709_140 VPWR VGND sg13cmos5l_decap_8
XFILLER_629_42 VPWR VGND sg13cmos5l_decap_8
XFILLER_582_105 VPWR VGND sg13cmos5l_decap_8
X_0950_ _0950_/Q Tile_X0Y0_FrameData[21] VGND VPWR Tile_X0Y9_FrameStrobe[0] latch
XFILLER_198_84 VPWR VGND sg13cmos5l_decap_8
XFILLER_348_21 VPWR VGND sg13cmos5l_decap_8
XFILLER_319_135 VPWR VGND sg13cmos5l_fill_2
X_0881_ _0881_/Q Tile_X0Y9_FrameData[14] VGND VPWR Tile_X0Y9_FrameStrobe[6] latch
X_2620_ _2620_/Q Tile_X0Y6_FrameData[11] VGND VPWR Tile_X0Y9_FrameStrobe[5] latch
XFILLER_334_105 VPWR VGND sg13cmos5l_decap_8
XFILLER_319_179 VPWR VGND sg13cmos5l_decap_8
XFILLER_523_216 VPWR VGND sg13cmos5l_decap_8
XFILLER_348_98 VPWR VGND sg13cmos5l_decap_8
XFILLER_523_227 VPWR VGND sg13cmos5l_fill_2
XFILLER_334_149 VPWR VGND sg13cmos5l_decap_8
X_2551_ _2551_/Q Tile_X0Y6_FrameData[16] VGND VPWR Tile_X0Y9_FrameStrobe[3] latch
XFILLER_645_63 VPWR VGND sg13cmos5l_decap_8
XFILLER_327_190 VPWR VGND sg13cmos5l_fill_2
XFILLER_217_14 VPWR VGND sg13cmos5l_decap_8
XANTENNA__3028__X Tile_X0Y5_EE4BEG[3] VPWR VGND sg13cmos5l_antennanp
X_1502_ _1502_/Q Tile_X0Y2_FrameData[19] VGND VPWR Tile_X0Y9_FrameStrobe[2] latch
XFILLER_364_42 VPWR VGND sg13cmos5l_decap_8
X_2482_ _2482_/Q Tile_X0Y6_FrameData[21] VGND VPWR Tile_X0Y9_FrameStrobe[1] latch
X_4221_ _4221_/X _4691_/X _4695_/X _4699_/X _4675_/X _0382_/Q _0381_/Q VPWR VGND sg13cmos5l_mux4_1
XANTENNA__2867__X Tile_X0Y6_EE4BEG[4] VPWR VGND sg13cmos5l_antennanp
X_1433_ _1433_/Q Tile_X0Y2_FrameData[24] VGND VPWR Tile_X0Y9_FrameStrobe[0] latch
XFILLER_514_56 VPWR VGND sg13cmos5l_decap_8
X_4152_ _4152_/X Tile_X0Y3_W2MID[3] AXI_M_SOC_WREADY _4211_/X _4210_/X _1837_/Q _1836_/Q
+ VPWR VGND sg13cmos5l_mux4_1
X_1364_ _1364_/Q Tile_X0Y1_FrameData[5] VGND VPWR Tile_X0Y9_FrameStrobe[5] latch
XFILLER_661_84 VPWR VGND sg13cmos5l_decap_8
XFILLER_233_35 VPWR VGND sg13cmos5l_decap_8
XFILLER_255_101 VPWR VGND sg13cmos5l_decap_8
X_3103_ Tile_X0Y7_E6BEG[1] _4645_/X VPWR VGND sg13cmos5l_buf_1
XFILLER_645_161 VPWR VGND sg13cmos5l_decap_8
X_0315_ _0315_/Q Tile_X0Y7_FrameData[4] VGND VPWR Tile_X0Y9_FrameStrobe[4] latch
XFILLER_380_63 VPWR VGND sg13cmos5l_decap_8
X_4083_ _4083_/X AXI_M_SOC_AWREADY _4116_/X _4120_/X _4096_/X _1507_/Q _1506_/Q VPWR
+ VGND sg13cmos5l_mux4_1
X_1295_ _1295_/Q Tile_X0Y1_FrameData[10] VGND VPWR Tile_X0Y9_FrameStrobe[3] latch
XFILLER_55_228 VPWR VGND sg13cmos5l_fill_1
X_3034_ Tile_X0Y5_EE4BEG[9] _4397_/X VPWR VGND sg13cmos5l_buf_1
X_0246_ _0246_/Q Tile_X0Y7_FrameData[9] VGND VPWR Tile_X0Y9_FrameStrobe[2] latch
XANTENNA__3698__X AXI_M_SOC_WDATA8 VPWR VGND sg13cmos5l_antennanp
XFILLER_270_126 VPWR VGND sg13cmos5l_decap_8
XFILLER_530_77 VPWR VGND sg13cmos5l_decap_8
XFILLER_102_28 VPWR VGND sg13cmos5l_decap_8
XFILLER_530_88 VPWR VGND sg13cmos5l_fill_1
X_0177_ _0177_/Q Tile_X0Y7_FrameData[14] VGND VPWR Tile_X0Y9_FrameStrobe[0] latch
XFILLER_412_120 VPWR VGND sg13cmos5l_fill_2
XFILLER_412_164 VPWR VGND sg13cmos5l_decap_8
XFILLER_168_108 VPWR VGND sg13cmos5l_decap_8
XFILLER_558_179 VPWR VGND sg13cmos5l_fill_2
XFILLER_539_42 VPWR VGND sg13cmos5l_decap_8
XFILLER_573_105 VPWR VGND sg13cmos5l_decap_8
X_3936_ _3936_/X Tile_X0Y1_W2MID[3] AXI_M_SOC_ARREADY _3995_/X _3994_/X _1337_/Q _1336_/Q
+ VPWR VGND sg13cmos5l_mux4_1
XFILLER_686_70 VPWR VGND sg13cmos5l_decap_8
XFILLER_258_21 VPWR VGND sg13cmos5l_decap_8
XFILLER_176_152 VPWR VGND sg13cmos5l_decap_8
XFILLER_715_132 VPWR VGND sg13cmos5l_decap_8
X_3867_ _3867_/X _3850_/X _0085_/X Tile_X0Y0_S1END[2] Tile_X0Y0_S4END[2] _0967_/Q
+ _0966_/Q VPWR VGND sg13cmos5l_mux4_1
XFILLER_176_174 VPWR VGND sg13cmos5l_decap_8
XFILLER_514_205 VPWR VGND sg13cmos5l_fill_1
X_2818_ Tile_X0Y3_E1BEG[0] _4144_/X VPWR VGND sg13cmos5l_buf_1
XFILLER_258_98 VPWR VGND sg13cmos5l_decap_4
XFILLER_11_14 VPWR VGND sg13cmos5l_decap_8
X_3798_ _3798_/X Tile_X0Y0_W1END[3] Tile_X0Y0_WW4END[3] Tile_X0Y0_W6END[11] _3884_/X
+ _1144_/Q _1143_/Q VPWR VGND sg13cmos5l_mux4_1
XFILLER_581_182 VPWR VGND sg13cmos5l_decap_8
XFILLER_408_35 VPWR VGND sg13cmos5l_decap_8
XFILLER_555_63 VPWR VGND sg13cmos5l_decap_8
XFILLER_127_14 VPWR VGND sg13cmos5l_decap_8
X_2749_ Tile_X0Y3_FrameData_O[7] Tile_X0Y3_FrameData[7] VPWR VGND sg13cmos5l_buf_1
XFILLER_274_42 VPWR VGND sg13cmos5l_decap_8
XFILLER_132_211 VPWR VGND sg13cmos5l_fill_2
XFILLER_494_112 VPWR VGND sg13cmos5l_decap_8
XANTENNA__2777__X Tile_X0Y3_EE4BEG[3] VPWR VGND sg13cmos5l_antennanp
XFILLER_705_77 VPWR VGND sg13cmos5l_decap_8
X_4419_ _4419_/X _4421_/X Tile_X0Y5_W6END[1] _4420_/X _4419_/A3 _2187_/Q _2186_/Q
+ VPWR VGND sg13cmos5l_mux4_1
XFILLER_424_56 VPWR VGND sg13cmos5l_decap_8
XFILLER_207_91 VPWR VGND sg13cmos5l_decap_8
XFILLER_571_84 VPWR VGND sg13cmos5l_decap_8
XFILLER_143_35 VPWR VGND sg13cmos5l_decap_8
XFILLER_494_189 VPWR VGND sg13cmos5l_decap_8
XFILLER_636_172 VPWR VGND sg13cmos5l_decap_8
XFILLER_290_63 VPWR VGND sg13cmos5l_decap_8
XFILLER_377_7 VPWR VGND sg13cmos5l_decap_8
XFILLER_46_228 VPWR VGND sg13cmos5l_fill_1
XFILLER_100_196 VPWR VGND sg13cmos5l_decap_8
XFILLER_450_215 VPWR VGND sg13cmos5l_decap_8
XFILLER_246_189 VPWR VGND sg13cmos5l_fill_2
XFILLER_651_175 VPWR VGND sg13cmos5l_decap_8
XFILLER_36_44 VPWR VGND sg13cmos5l_decap_8
XFILLER_440_77 VPWR VGND sg13cmos5l_decap_8
XFILLER_61_209 VPWR VGND sg13cmos5l_decap_8
XFILLER_544_7 VPWR VGND sg13cmos5l_decap_8
XANTENNA__3401__X Tile_X0Y2_E2BEG[4] VPWR VGND sg13cmos5l_antennanp
XFILLER_549_124 VPWR VGND sg13cmos5l_fill_1
XFILLER_202_204 VPWR VGND sg13cmos5l_fill_2
XFILLER_549_157 VPWR VGND sg13cmos5l_fill_2
XFILLER_711_7 VPWR VGND sg13cmos5l_decap_8
XFILLER_564_105 VPWR VGND sg13cmos5l_decap_8
XFILLER_449_42 VPWR VGND sg13cmos5l_decap_8
XFILLER_596_70 VPWR VGND sg13cmos5l_decap_8
XFILLER_168_21 VPWR VGND sg13cmos5l_decap_8
XFILLER_168_65 VPWR VGND sg13cmos5l_fill_1
XFILLER_182_100 VPWR VGND sg13cmos5l_decap_4
XFILLER_167_174 VPWR VGND sg13cmos5l_fill_2
XFILLER_706_154 VPWR VGND sg13cmos5l_fill_1
XFILLER_505_227 VPWR VGND sg13cmos5l_fill_2
XFILLER_572_182 VPWR VGND sg13cmos5l_decap_8
XFILLER_318_35 VPWR VGND sg13cmos5l_decap_8
XFILLER_682_28 VPWR VGND sg13cmos5l_decap_8
XFILLER_465_85 VPWR VGND sg13cmos5l_decap_4
XFILLER_331_108 VPWR VGND sg13cmos5l_decap_4
XFILLER_201_0 VPWR VGND sg13cmos5l_decap_8
XFILLER_184_42 VPWR VGND sg13cmos5l_decap_8
XFILLER_485_112 VPWR VGND sg13cmos5l_decap_8
XFILLER_615_77 VPWR VGND sg13cmos5l_decap_8
XFILLER_96_117 VPWR VGND sg13cmos5l_decap_4
XFILLER_334_56 VPWR VGND sg13cmos5l_decap_8
XFILLER_96_128 VPWR VGND sg13cmos5l_decap_8
XFILLER_284_218 VPWR VGND sg13cmos5l_decap_4
XFILLER_481_84 VPWR VGND sg13cmos5l_decap_8
XFILLER_570_0 VPWR VGND sg13cmos5l_decap_8
XFILLER_485_189 VPWR VGND sg13cmos5l_decap_8
XFILLER_237_101 VPWR VGND sg13cmos5l_decap_8
XFILLER_631_21 VPWR VGND sg13cmos5l_decap_8
XFILLER_77_84 VPWR VGND sg13cmos5l_decap_4
XFILLER_668_0 VPWR VGND sg13cmos5l_decap_8
XFILLER_237_134 VPWR VGND sg13cmos5l_fill_1
XFILLER_237_156 VPWR VGND sg13cmos5l_decap_4
X_0100_ _0100_/X _4445_/X _4446_/X _0895_/Q VPWR VGND sg13cmos5l_mux2_1
X_1080_ _1080_/Q Tile_X0Y0_FrameData[19] VGND VPWR Tile_X0Y9_FrameStrobe[4] latch
XFILLER_631_98 VPWR VGND sg13cmos5l_decap_8
XFILLER_203_49 VPWR VGND sg13cmos5l_decap_8
XFILLER_642_175 VPWR VGND sg13cmos5l_decap_8
XFILLER_350_77 VPWR VGND sg13cmos5l_decap_8
XFILLER_500_14 VPWR VGND sg13cmos5l_decap_8
XANTENNA__3311__X Tile_X0Y0_E1BEG[3] VPWR VGND sg13cmos5l_antennanp
XFILLER_555_105 VPWR VGND sg13cmos5l_decap_8
XFILLER_359_42 VPWR VGND sg13cmos5l_decap_8
XFILLER_555_116 VPWR VGND sg13cmos5l_fill_2
X_1982_ _1982_/Q Tile_X0Y4_FrameData[7] VGND VPWR Tile_X0Y9_FrameStrobe[1] latch
X_4770_ _4770_/X AXI_M_SOC_RDATA14 _4801_/X _4805_/X _4786_/X _0507_/Q _0506_/Q VPWR
+ VGND sg13cmos5l_mux4_1
X_0933_ _0933_/Q Tile_X0Y9_FrameData[24] VGND VPWR Tile_X0Y9_FrameStrobe[8] latch
X_3721_ AXI_M_SOC_WDATA31 Tile_X0Y6_W1END[3] Tile_X0Y6_WW4END[7] Tile_X0Y6_WW4END[15]
+ _4583_/X _2497_/Q _2496_/Q VPWR VGND sg13cmos5l_mux4_1
XFILLER_570_119 VPWR VGND sg13cmos5l_decap_8
XFILLER_509_56 VPWR VGND sg13cmos5l_decap_8
XFILLER_173_100 VPWR VGND sg13cmos5l_fill_1
X_0864_ _0864_/Q Tile_X0Y9_FrameData[31] VGND VPWR Tile_X0Y9_FrameStrobe[6] latch
X_3652_ AXI_M_SOC_AWADDR13 Tile_X0Y5_W1END[1] Tile_X0Y5_WW4END[5] Tile_X0Y5_WW4END[13]
+ _4464_/X _2245_/Q _2244_/Q VPWR VGND sg13cmos5l_mux4_1
XFILLER_307_127 VPWR VGND sg13cmos5l_fill_2
XFILLER_656_84 VPWR VGND sg13cmos5l_decap_8
XFILLER_228_35 VPWR VGND sg13cmos5l_decap_8
XFILLER_173_133 VPWR VGND sg13cmos5l_fill_2
X_2603_ _2603_/Q Tile_X0Y6_FrameData[28] VGND VPWR Tile_X0Y9_FrameStrobe[5] latch
XFILLER_592_28 VPWR VGND sg13cmos5l_decap_8
XFILLER_375_63 VPWR VGND sg13cmos5l_decap_8
X_3583_ Tile_X0Y9_FrameData_O[13] Tile_X0Y9_FrameData[13] VPWR VGND sg13cmos5l_buf_1
X_0795_ _0795_/Q Tile_X0Y9_FrameData[4] VGND VPWR Tile_X0Y9_FrameStrobe[3] latch
XFILLER_173_177 VPWR VGND sg13cmos5l_decap_8
XFILLER_712_168 VPWR VGND sg13cmos5l_decap_8
X_2534_ _2534_/Q Tile_X0Y6_FrameData[1] VGND VPWR Tile_X0Y9_FrameStrobe[2] latch
XFILLER_315_182 VPWR VGND sg13cmos5l_fill_1
XFILLER_47_0 VPWR VGND sg13cmos5l_fill_1
X_2465_ _2465_/Q Tile_X0Y6_FrameData[6] VGND VPWR Tile_X0Y9_FrameStrobe[0] latch
XFILLER_244_56 VPWR VGND sg13cmos5l_decap_8
X_1416_ _1416_/Q Tile_X0Y1_FrameData[17] VGND VPWR Tile_X0Y9_FrameStrobe[7] latch
X_4204_ _4204_/X _4143_/X _4251_/X _4250_/X _4142_/X _1683_/Q _1682_/Q VPWR VGND sg13cmos5l_mux4_1
XFILLER_330_185 VPWR VGND sg13cmos5l_decap_4
X_2396_ _2396_/Q Tile_X0Y5_FrameData[9] VGND VPWR Tile_X0Y9_FrameStrobe[6] latch
XFILLER_541_21 VPWR VGND sg13cmos5l_decap_8
XFILLER_491_126 VPWR VGND sg13cmos5l_decap_8
XFILLER_417_212 VPWR VGND sg13cmos5l_fill_2
XFILLER_3_70 VPWR VGND sg13cmos5l_decap_8
X_4135_ _4135_/X Tile_X0Y4_W2MID[4] Tile_X0Y4_W2END[4] Tile_X0Y4_W6END[4] _4319_/X
+ _2167_/Q _2166_/Q VPWR VGND sg13cmos5l_mux4_1
X_1347_ _1347_/Q Tile_X0Y1_FrameData[22] VGND VPWR Tile_X0Y9_FrameStrobe[5] latch
XFILLER_95_161 VPWR VGND sg13cmos5l_decap_8
XFILLER_228_156 VPWR VGND sg13cmos5l_decap_4
XFILLER_228_167 VPWR VGND sg13cmos5l_fill_2
X_4066_ _4066_/X Tile_X0Y2_WW4END[5] AXI_M_SOC_AWREADY _4121_/X _4100_/X _1541_/Q
+ _1540_/Q VPWR VGND sg13cmos5l_mux4_1
X_1278_ _1278_/Q Tile_X0Y1_FrameData[27] VGND VPWR Tile_X0Y9_FrameStrobe[3] latch
XFILLER_113_49 VPWR VGND sg13cmos5l_decap_8
X_3017_ Tile_X0Y5_E6BEG[4] _4408_/X VPWR VGND sg13cmos5l_buf_1
X_0229_ _0229_/Q Tile_X0Y7_FrameData[26] VGND VPWR Tile_X0Y9_FrameStrobe[2] latch
XFILLER_410_14 VPWR VGND sg13cmos5l_decap_8
XANTENNA__3221__X Tile_X0Y0_FrameStrobe_O[9] VPWR VGND sg13cmos5l_antennanp
XFILLER_697_91 VPWR VGND sg13cmos5l_decap_8
XFILLER_269_42 VPWR VGND sg13cmos5l_decap_8
XFILLER_400_134 VPWR VGND sg13cmos5l_decap_8
XFILLER_11_106 VPWR VGND sg13cmos5l_fill_2
X_3919_ _3919_/X _4120_/X _4124_/X _4113_/X _4097_/X _1649_/Q _1648_/Q VPWR VGND sg13cmos5l_mux4_1
X_4899_ _4899_/X Tile_X0Y8_W1END[3] Tile_X0Y8_W6END[11] _4815_/X _4775_/X _0629_/Q
+ _0628_/Q VPWR VGND sg13cmos5l_mux4_1
XFILLER_561_119 VPWR VGND sg13cmos5l_decap_8
XFILLER_419_56 VPWR VGND sg13cmos5l_decap_8
XFILLER_22_35 VPWR VGND sg13cmos5l_decap_8
XFILLER_353_200 VPWR VGND sg13cmos5l_decap_8
XFILLER_164_111 VPWR VGND sg13cmos5l_decap_8
XFILLER_164_122 VPWR VGND sg13cmos5l_fill_1
XFILLER_125_7 VPWR VGND sg13cmos5l_decap_8
XFILLER_566_84 VPWR VGND sg13cmos5l_decap_8
XFILLER_138_35 VPWR VGND sg13cmos5l_decap_8
XFILLER_716_21 VPWR VGND sg13cmos5l_decap_4
XFILLER_554_193 VPWR VGND sg13cmos5l_decap_8
XFILLER_164_144 VPWR VGND sg13cmos5l_fill_1
XFILLER_285_63 VPWR VGND sg13cmos5l_decap_8
XFILLER_98_28 VPWR VGND sg13cmos5l_decap_8
XFILLER_105_200 VPWR VGND sg13cmos5l_decap_8
XFILLER_306_171 VPWR VGND sg13cmos5l_decap_4
XFILLER_656_212 VPWR VGND sg13cmos5l_fill_1
XFILLER_435_77 VPWR VGND sg13cmos5l_decap_8
XFILLER_494_7 VPWR VGND sg13cmos5l_decap_8
XFILLER_154_56 VPWR VGND sg13cmos5l_decap_8
XFILLER_154_67 VPWR VGND sg13cmos5l_fill_1
XFILLER_451_21 VPWR VGND sg13cmos5l_decap_8
XFILLER_47_10 VPWR VGND sg13cmos5l_decap_8
XFILLER_661_7 VPWR VGND sg13cmos5l_decap_8
XFILLER_19_206 VPWR VGND sg13cmos5l_decap_4
XFILLER_19_228 VPWR VGND sg13cmos5l_fill_1
XFILLER_451_87 VPWR VGND sg13cmos5l_fill_1
XFILLER_601_35 VPWR VGND sg13cmos5l_decap_8
XFILLER_47_87 VPWR VGND sg13cmos5l_decap_4
XFILLER_569_208 VPWR VGND sg13cmos5l_decap_4
XFILLER_320_14 VPWR VGND sg13cmos5l_decap_8
XANTENNA__3131__X Tile_X0Y7_FrameData_O[1] VPWR VGND sg13cmos5l_antennanp
XFILLER_677_28 VPWR VGND sg13cmos5l_decap_8
XFILLER_63_42 VPWR VGND sg13cmos5l_decap_8
XFILLER_151_0 VPWR VGND sg13cmos5l_decap_8
XANTENNA__2970__X Tile_X0Y8_FrameData_O[10] VPWR VGND sg13cmos5l_antennanp
XFILLER_249_0 VPWR VGND sg13cmos5l_decap_8
XFILLER_179_42 VPWR VGND sg13cmos5l_decap_8
XFILLER_416_0 VPWR VGND sg13cmos5l_decap_8
XFILLER_329_56 VPWR VGND sg13cmos5l_decap_4
XFILLER_344_211 VPWR VGND sg13cmos5l_decap_4
XFILLER_155_111 VPWR VGND sg13cmos5l_decap_8
XFILLER_693_49 VPWR VGND sg13cmos5l_decap_8
XFILLER_626_21 VPWR VGND sg13cmos5l_decap_8
XFILLER_155_144 VPWR VGND sg13cmos5l_fill_1
XFILLER_195_63 VPWR VGND sg13cmos5l_fill_1
XFILLER_560_174 VPWR VGND sg13cmos5l_decap_8
X_0580_ _0580_/Q Tile_X0Y8_FrameData[27] VGND VPWR Tile_X0Y9_FrameStrobe[5] latch
XFILLER_626_98 VPWR VGND sg13cmos5l_decap_8
XFILLER_170_136 VPWR VGND sg13cmos5l_fill_2
XFILLER_40_7 VPWR VGND sg13cmos5l_decap_8
XFILLER_345_77 VPWR VGND sg13cmos5l_decap_8
XANTENNA__3306__X Tile_X0Y0_E2BEG[6] VPWR VGND sg13cmos5l_antennanp
XFILLER_642_42 VPWR VGND sg13cmos5l_decap_8
X_2250_ _2250_/Q Tile_X0Y5_FrameData[27] VGND VPWR Tile_X0Y9_FrameStrobe[2] latch
XFILLER_361_21 VPWR VGND sg13cmos5l_decap_8
X_1201_ _1201_/Q Tile_X0Y1_FrameData[8] VGND VPWR Tile_X0Y9_FrameStrobe[0] latch
XFILLER_473_137 VPWR VGND sg13cmos5l_decap_8
X_2181_ _2181_/Q Tile_X0Y4_FrameData[0] VGND VPWR Tile_X0Y9_FrameStrobe[7] latch
X_1132_ _1132_/Q Tile_X0Y0_FrameData[31] VGND VPWR Tile_X0Y9_FrameStrobe[6] latch
XFILLER_361_98 VPWR VGND sg13cmos5l_decap_8
XFILLER_511_35 VPWR VGND sg13cmos5l_decap_8
XFILLER_414_215 VPWR VGND sg13cmos5l_fill_1
XFILLER_92_153 VPWR VGND sg13cmos5l_decap_8
X_1063_ _1063_/Q Tile_X0Y0_FrameData[4] VGND VPWR Tile_X0Y9_FrameStrobe[3] latch
XFILLER_230_14 VPWR VGND sg13cmos5l_decap_8
XANTENNA__3041__X Tile_X0Y5_FrameData_O[0] VPWR VGND sg13cmos5l_antennanp
XFILLER_587_28 VPWR VGND sg13cmos5l_decap_8
XFILLER_178_203 VPWR VGND sg13cmos5l_decap_8
XANTENNA__2880__X Tile_X0Y6_FrameData_O[1] VPWR VGND sg13cmos5l_antennanp
X_4822_ _4822_/X Tile_X0Y7_W1END[2] Tile_X0Y7_W2MID[1] Tile_X0Y7_W2END[1] _4670_/X
+ _0359_/Q _0358_/Q VPWR VGND sg13cmos5l_mux4_1
XFILLER_379_185 VPWR VGND sg13cmos5l_fill_2
X_4753_ _4753_/X Tile_X0Y8_WW4END[6] AXI_M_SOC_RDATA14 _4806_/X _4786_/X _0541_/Q
+ _0540_/Q VPWR VGND sg13cmos5l_mux4_1
X_1965_ _1965_/Q Tile_X0Y4_FrameData[24] VGND VPWR Tile_X0Y9_FrameStrobe[1] latch
XFILLER_193_228 VPWR VGND sg13cmos5l_fill_1
XFILLER_239_56 VPWR VGND sg13cmos5l_decap_8
X_3704_ AXI_M_SOC_WDATA14 Tile_X0Y7_W1END[2] Tile_X0Y7_WW4END[6] Tile_X0Y7_WW4END[14]
+ _4698_/X _0219_/Q _0218_/Q VPWR VGND sg13cmos5l_mux4_1
X_0916_ _0916_/Q Tile_X0Y9_FrameData[11] VGND VPWR Tile_X0Y9_FrameStrobe[7] latch
X_1896_ _1896_/Q Tile_X0Y3_FrameData[1] VGND VPWR Tile_X0Y9_FrameStrobe[6] latch
X_4684_ _4684_/X _4661_/X Tile_X0Y9_N4END[8] _4660_/X _0056_/X _0215_/Q _0214_/Q VPWR
+ VGND sg13cmos5l_mux4_1
XFILLER_536_21 VPWR VGND sg13cmos5l_decap_8
XFILLER_697_112 VPWR VGND sg13cmos5l_decap_4
X_0847_ _0847_/Q Tile_X0Y9_FrameData[16] VGND VPWR Tile_X0Y9_FrameStrobe[5] latch
X_3635_ Tile_X0Y9_S4BEG[13] _3635_/A VPWR VGND sg13cmos5l_buf_1
XFILLER_350_214 VPWR VGND sg13cmos5l_fill_1
X_0778_ _0778_/Q Tile_X0Y9_FrameData[21] VGND VPWR Tile_X0Y9_FrameStrobe[3] latch
X_3566_ Tile_X0Y9_EE4BEG[12] _4876_/X VPWR VGND sg13cmos5l_buf_1
XFILLER_536_98 VPWR VGND sg13cmos5l_decap_8
XFILLER_108_49 VPWR VGND sg13cmos5l_decap_8
X_2517_ _2517_/Q Tile_X0Y6_FrameData[18] VGND VPWR Tile_X0Y9_FrameStrobe[2] latch
XFILLER_405_14 VPWR VGND sg13cmos5l_decap_8
X_3497_ Tile_X0Y1_E6BEG[7] _3971_/X VPWR VGND sg13cmos5l_buf_1
XANTENNA__3216__X Tile_X0Y0_FrameStrobe_O[4] VPWR VGND sg13cmos5l_antennanp
XFILLER_552_42 VPWR VGND sg13cmos5l_decap_8
X_2448_ _2448_/Q Tile_X0Y6_FrameData[23] VGND VPWR Tile_X0Y9_FrameStrobe[0] latch
XFILLER_653_215 VPWR VGND sg13cmos5l_fill_2
XFILLER_271_21 VPWR VGND sg13cmos5l_decap_8
XFILLER_124_26 VPWR VGND sg13cmos5l_decap_8
XFILLER_464_148 VPWR VGND sg13cmos5l_fill_1
X_2379_ _2379_/Q Tile_X0Y5_FrameData[26] VGND VPWR Tile_X0Y9_FrameStrobe[6] latch
XFILLER_702_45 VPWR VGND sg13cmos5l_decap_8
X_4118_ _4118_/X _4093_/X _0057_/X _4092_/X Tile_X0Y0_S4END[10] _1477_/Q _1476_/Q
+ VPWR VGND sg13cmos5l_mux4_1
XFILLER_271_98 VPWR VGND sg13cmos5l_fill_2
XFILLER_83_131 VPWR VGND sg13cmos5l_fill_1
XFILLER_421_35 VPWR VGND sg13cmos5l_decap_8
XFILLER_204_70 VPWR VGND sg13cmos5l_decap_8
XFILLER_216_126 VPWR VGND sg13cmos5l_decap_8
XFILLER_83_153 VPWR VGND sg13cmos5l_decap_8
XFILLER_621_112 VPWR VGND sg13cmos5l_decap_8
XFILLER_472_181 VPWR VGND sg13cmos5l_decap_8
XFILLER_17_35 VPWR VGND sg13cmos5l_decap_8
XFILLER_140_14 VPWR VGND sg13cmos5l_decap_8
X_4049_ _4049_/X Tile_X0Y2_W2END[6] AXI_M_SOC_AWREADY _4099_/X _4098_/X _1575_/Q _1574_/Q
+ VPWR VGND sg13cmos5l_mux4_1
XFILLER_497_28 VPWR VGND sg13cmos5l_decap_8
XFILLER_224_181 VPWR VGND sg13cmos5l_fill_1
XANTENNA__2790__X Tile_X0Y3_E6BEG[0] VPWR VGND sg13cmos5l_antennanp
XFILLER_242_7 VPWR VGND sg13cmos5l_decap_8
XFILLER_708_227 VPWR VGND sg13cmos5l_fill_2
XFILLER_220_91 VPWR VGND sg13cmos5l_decap_8
XFILLER_519_149 VPWR VGND sg13cmos5l_fill_2
XFILLER_33_45 VPWR VGND sg13cmos5l_decap_8
XFILLER_326_200 VPWR VGND sg13cmos5l_decap_8
XFILLER_149_56 VPWR VGND sg13cmos5l_decap_8
XFILLER_507_7 VPWR VGND sg13cmos5l_decap_8
XFILLER_296_84 VPWR VGND sg13cmos5l_decap_8
XFILLER_527_182 VPWR VGND sg13cmos5l_fill_2
XFILLER_446_21 VPWR VGND sg13cmos5l_decap_8
XFILLER_137_133 VPWR VGND sg13cmos5l_decap_8
XFILLER_152_114 VPWR VGND sg13cmos5l_decap_4
XFILLER_487_207 VPWR VGND sg13cmos5l_decap_8
XFILLER_446_98 VPWR VGND sg13cmos5l_fill_1
XFILLER_165_77 VPWR VGND sg13cmos5l_decap_8
XFILLER_315_14 VPWR VGND sg13cmos5l_decap_8
XANTENNA__3126__X Tile_X0Y7_EE4BEG[12] VPWR VGND sg13cmos5l_antennanp
XFILLER_462_42 VPWR VGND sg13cmos5l_decap_8
XFILLER_58_31 VPWR VGND sg13cmos5l_decap_8
XFILLER_181_21 VPWR VGND sg13cmos5l_decap_8
XANTENNA__2965__X Tile_X0Y8_FrameData_O[5] VPWR VGND sg13cmos5l_antennanp
XFILLER_199_0 VPWR VGND sg13cmos5l_decap_8
XFILLER_455_148 VPWR VGND sg13cmos5l_fill_1
XFILLER_181_76 VPWR VGND sg13cmos5l_decap_4
XFILLER_612_56 VPWR VGND sg13cmos5l_decap_8
XFILLER_470_118 VPWR VGND sg13cmos5l_decap_4
XFILLER_331_35 VPWR VGND sg13cmos5l_decap_8
XFILLER_114_70 VPWR VGND sg13cmos5l_decap_8
XFILLER_207_126 VPWR VGND sg13cmos5l_decap_8
XFILLER_366_0 VPWR VGND sg13cmos5l_decap_8
XFILLER_74_63 VPWR VGND sg13cmos5l_decap_8
XFILLER_688_49 VPWR VGND sg13cmos5l_decap_8
XFILLER_612_156 VPWR VGND sg13cmos5l_decap_8
XFILLER_411_207 VPWR VGND sg13cmos5l_decap_4
XFILLER_612_178 VPWR VGND sg13cmos5l_fill_2
XFILLER_533_0 VPWR VGND sg13cmos5l_decap_8
XFILLER_215_181 VPWR VGND sg13cmos5l_decap_8
XFILLER_565_200 VPWR VGND sg13cmos5l_decap_4
XFILLER_200_28 VPWR VGND sg13cmos5l_decap_8
XFILLER_130_91 VPWR VGND sg13cmos5l_decap_8
XFILLER_175_206 VPWR VGND sg13cmos5l_fill_1
XFILLER_88_7 VPWR VGND sg13cmos5l_decap_8
XFILLER_700_0 VPWR VGND sg13cmos5l_decap_8
XFILLER_580_203 VPWR VGND sg13cmos5l_fill_2
XFILLER_175_228 VPWR VGND sg13cmos5l_fill_1
XFILLER_637_42 VPWR VGND sg13cmos5l_decap_8
XFILLER_391_114 VPWR VGND sg13cmos5l_fill_2
X_1750_ _1750_/Q Tile_X0Y3_FrameData[19] VGND VPWR Tile_X0Y9_FrameStrobe[2] latch
XFILLER_518_193 VPWR VGND sg13cmos5l_decap_8
XFILLER_356_21 VPWR VGND sg13cmos5l_decap_8
X_0701_ _0701_/Q Tile_X0Y9_FrameData[2] VGND VPWR Tile_X0Y9_FrameStrobe[0] latch
XFILLER_391_169 VPWR VGND sg13cmos5l_fill_2
X_1681_ _1681_/Q Tile_X0Y3_FrameData[24] VGND VPWR Tile_X0Y9_FrameStrobe[0] latch
XFILLER_679_145 VPWR VGND sg13cmos5l_decap_8
XFILLER_533_163 VPWR VGND sg13cmos5l_fill_2
X_0632_ _0632_/Q Tile_X0Y8_FrameData[7] VGND VPWR Tile_X0Y9_FrameStrobe[6] latch
X_3420_ Tile_X0Y4_FrameData_O[11] Tile_X0Y4_FrameData[11] VPWR VGND sg13cmos5l_buf_1
XFILLER_356_98 VPWR VGND sg13cmos5l_decap_8
XFILLER_143_147 VPWR VGND sg13cmos5l_decap_8
XFILLER_506_35 VPWR VGND sg13cmos5l_decap_8
XFILLER_694_126 VPWR VGND sg13cmos5l_decap_8
X_3351_ Tile_X0Y2_FrameData_O[22] Tile_X0Y2_FrameData[22] VPWR VGND sg13cmos5l_buf_1
X_0563_ _0563_/Q Tile_X0Y8_FrameData[12] VGND VPWR Tile_X0Y9_FrameStrobe[4] latch
XFILLER_653_63 VPWR VGND sg13cmos5l_decap_8
XFILLER_225_14 VPWR VGND sg13cmos5l_decap_8
XANTENNA__3036__X Tile_X0Y5_EE4BEG[11] VPWR VGND sg13cmos5l_antennanp
X_2302_ _2302_/Q Tile_X0Y5_FrameData[7] VGND VPWR Tile_X0Y9_FrameStrobe[3] latch
XFILLER_372_42 VPWR VGND sg13cmos5l_decap_8
X_3282_ Tile_X0Y0_E6BEG[2] _3838_/X VPWR VGND sg13cmos5l_buf_1
X_0494_ _0494_/Q Tile_X0Y8_FrameData[17] VGND VPWR Tile_X0Y9_FrameStrobe[2] latch
X_2233_ _2233_/Q Tile_X0Y5_FrameData[12] VGND VPWR Tile_X0Y9_FrameStrobe[1] latch
XANTENNA__2875__X Tile_X0Y6_EE4BEG[12] VPWR VGND sg13cmos5l_antennanp
XFILLER_446_148 VPWR VGND sg13cmos5l_fill_2
XFILLER_522_56 VPWR VGND sg13cmos5l_decap_8
XFILLER_305_91 VPWR VGND sg13cmos5l_decap_8
X_2164_ _2164_/Q Tile_X0Y4_FrameData[17] VGND VPWR Tile_X0Y9_FrameStrobe[7] latch
XFILLER_65_120 VPWR VGND sg13cmos5l_decap_8
XFILLER_253_210 VPWR VGND sg13cmos5l_fill_2
XFILLER_241_35 VPWR VGND sg13cmos5l_decap_8
X_1115_ _1115_/Q Tile_X0Y0_FrameData[16] VGND VPWR Tile_X0Y9_FrameStrobe[5] latch
X_2095_ _2095_/Q Tile_X0Y4_FrameData[22] VGND VPWR Tile_X0Y9_FrameStrobe[5] latch
XFILLER_598_49 VPWR VGND sg13cmos5l_decap_8
XFILLER_65_197 VPWR VGND sg13cmos5l_decap_8
X_1046_ _1046_/Q Tile_X0Y0_FrameData[21] VGND VPWR Tile_X0Y9_FrameStrobe[3] latch
XFILLER_110_28 VPWR VGND sg13cmos5l_decap_8
X_4805_ _4805_/X _4779_/X Tile_X0Y9_N4END[5] _4778_/X _0076_/X _0461_/Q _0460_/Q VPWR
+ VGND sg13cmos5l_mux4_1
X_2997_ Tile_X0Y5_E2BEG[0] _4372_/X VPWR VGND sg13cmos5l_buf_1
XFILLER_571_203 VPWR VGND sg13cmos5l_decap_8
XFILLER_382_103 VPWR VGND sg13cmos5l_decap_8
XFILLER_367_188 VPWR VGND sg13cmos5l_decap_8
XFILLER_547_42 VPWR VGND sg13cmos5l_decap_8
XFILLER_9_91 VPWR VGND sg13cmos5l_decap_8
X_4736_ _4736_/X Tile_X0Y8_W2END[7] AXI_M_SOC_RDATA15 _4785_/X _4784_/X _0575_/Q _0574_/Q
+ VPWR VGND sg13cmos5l_mux4_1
X_1948_ _1948_/Q Tile_X0Y4_FrameData[9] VGND VPWR Tile_X0Y9_FrameStrobe[0] latch
XFILLER_694_70 VPWR VGND sg13cmos5l_decap_8
XFILLER_266_21 VPWR VGND sg13cmos5l_decap_8
X_4667_ _4667_/X Tile_X0Y8_W1END[3] Tile_X0Y8_W6END[7] _4815_/X _4775_/X _0665_/Q
+ _0664_/Q VPWR VGND sg13cmos5l_mux4_1
X_1879_ _1879_/Q Tile_X0Y3_FrameData[18] VGND VPWR Tile_X0Y9_FrameStrobe[6] latch
XFILLER_524_163 VPWR VGND sg13cmos5l_decap_8
XFILLER_323_225 VPWR VGND sg13cmos5l_decap_4
X_3618_ Tile_X0Y9_S2BEGb[4] _4936_/X VPWR VGND sg13cmos5l_buf_1
XFILLER_390_180 VPWR VGND sg13cmos5l_decap_8
XFILLER_266_98 VPWR VGND sg13cmos5l_decap_4
XFILLER_134_147 VPWR VGND sg13cmos5l_decap_4
X_4598_ _4598_/X Tile_X0Y5_W1END[3] Tile_X0Y5_W2MID[0] Tile_X0Y5_W2END[0] _4428_/X
+ _2381_/Q _2380_/Q VPWR VGND sg13cmos5l_mux4_1
XFILLER_416_35 VPWR VGND sg13cmos5l_decap_8
XFILLER_563_63 VPWR VGND sg13cmos5l_decap_8
XFILLER_135_14 VPWR VGND sg13cmos5l_decap_8
X_3549_ Tile_X0Y9_E6BEG[7] _4887_/X VPWR VGND sg13cmos5l_buf_1
XFILLER_282_42 VPWR VGND sg13cmos5l_decap_8
XFILLER_693_181 VPWR VGND sg13cmos5l_fill_1
XFILLER_437_137 VPWR VGND sg13cmos5l_fill_1
XANTENNA__2785__X Tile_X0Y3_EE4BEG[11] VPWR VGND sg13cmos5l_antennanp
XFILLER_713_77 VPWR VGND sg13cmos5l_decap_8
XFILLER_192_7 VPWR VGND sg13cmos5l_decap_8
XFILLER_437_159 VPWR VGND sg13cmos5l_decap_4
XFILLER_432_56 VPWR VGND sg13cmos5l_decap_8
XFILLER_215_91 VPWR VGND sg13cmos5l_decap_8
XFILLER_28_56 VPWR VGND sg13cmos5l_decap_8
XFILLER_445_170 VPWR VGND sg13cmos5l_fill_1
XFILLER_151_35 VPWR VGND sg13cmos5l_decap_8
XFILLER_71_112 VPWR VGND sg13cmos5l_decap_8
XFILLER_457_7 VPWR VGND sg13cmos5l_decap_8
XFILLER_71_156 VPWR VGND sg13cmos5l_decap_4
XFILLER_44_33 VPWR VGND sg13cmos5l_decap_8
XFILLER_301_49 VPWR VGND sg13cmos5l_decap_8
XFILLER_624_7 VPWR VGND sg13cmos5l_decap_8
XFILLER_212_140 VPWR VGND sg13cmos5l_decap_8
XFILLER_358_133 VPWR VGND sg13cmos5l_fill_1
XFILLER_507_119 VPWR VGND sg13cmos5l_decap_8
XFILLER_8_227 VPWR VGND sg13cmos5l_fill_2
XFILLER_60_21 VPWR VGND sg13cmos5l_decap_8
XFILLER_457_42 VPWR VGND sg13cmos5l_decap_8
XFILLER_100_94 VPWR VGND sg13cmos5l_decap_8
XFILLER_176_21 VPWR VGND sg13cmos5l_decap_8
XFILLER_373_169 VPWR VGND sg13cmos5l_fill_1
XFILLER_515_141 VPWR VGND sg13cmos5l_fill_1
XFILLER_60_98 VPWR VGND sg13cmos5l_decap_8
XFILLER_515_163 VPWR VGND sg13cmos5l_fill_2
XFILLER_114_0 VPWR VGND sg13cmos5l_decap_8
XFILLER_607_56 VPWR VGND sg13cmos5l_decap_8
XFILLER_326_35 VPWR VGND sg13cmos5l_decap_8
XFILLER_5_49 VPWR VGND sg13cmos5l_decap_8
XFILLER_109_70 VPWR VGND sg13cmos5l_fill_2
XFILLER_690_28 VPWR VGND sg13cmos5l_decap_8
XFILLER_473_63 VPWR VGND sg13cmos5l_decap_8
XFILLER_279_140 VPWR VGND sg13cmos5l_decap_8
XFILLER_69_63 VPWR VGND sg13cmos5l_decap_8
XFILLER_192_42 VPWR VGND sg13cmos5l_decap_8
XFILLER_617_204 VPWR VGND sg13cmos5l_decap_8
XFILLER_483_0 VPWR VGND sg13cmos5l_decap_8
XFILLER_428_126 VPWR VGND sg13cmos5l_decap_8
XFILLER_483_221 VPWR VGND sg13cmos5l_decap_8
XFILLER_623_77 VPWR VGND sg13cmos5l_decap_8
XFILLER_94_215 VPWR VGND sg13cmos5l_decap_8
XFILLER_699_26 VPWR VGND sg13cmos5l_decap_8
XFILLER_342_56 VPWR VGND sg13cmos5l_decap_8
XFILLER_294_176 VPWR VGND sg13cmos5l_decap_8
XFILLER_235_210 VPWR VGND sg13cmos5l_decap_8
XFILLER_650_0 VPWR VGND sg13cmos5l_decap_8
XFILLER_597_100 VPWR VGND sg13cmos5l_decap_4
XFILLER_62_112 VPWR VGND sg13cmos5l_decap_8
XFILLER_597_133 VPWR VGND sg13cmos5l_decap_4
XFILLER_451_151 VPWR VGND sg13cmos5l_fill_1
XFILLER_211_49 VPWR VGND sg13cmos5l_decap_8
X_2920_ Tile_X0Y8_E2BEG[4] _4732_/X VPWR VGND sg13cmos5l_buf_1
XFILLER_62_189 VPWR VGND sg13cmos5l_decap_8
XFILLER_349_133 VPWR VGND sg13cmos5l_decap_8
XFILLER_203_151 VPWR VGND sg13cmos5l_decap_8
XFILLER_203_162 VPWR VGND sg13cmos5l_fill_2
X_2851_ Tile_X0Y6_E6BEG[0] _4528_/X VPWR VGND sg13cmos5l_buf_1
XFILLER_648_63 VPWR VGND sg13cmos5l_decap_8
XFILLER_367_42 VPWR VGND sg13cmos5l_decap_8
X_1802_ _1802_/Q Tile_X0Y3_FrameData[31] VGND VPWR Tile_X0Y9_FrameStrobe[4] latch
X_2782_ Tile_X0Y3_EE4BEG[8] _4172_/X VPWR VGND sg13cmos5l_buf_1
XFILLER_364_158 VPWR VGND sg13cmos5l_fill_1
X_4521_ _4521_/X Tile_X0Y6_WW4END[6] AXI_M_SOC_RDATA30 _4574_/X _4554_/X _2565_/Q
+ _2564_/Q VPWR VGND sg13cmos5l_mux4_1
X_1733_ _1733_/Q Tile_X0Y3_FrameData[4] VGND VPWR Tile_X0Y9_FrameStrobe[1] latch
XFILLER_116_114 VPWR VGND sg13cmos5l_decap_8
XFILLER_517_56 VPWR VGND sg13cmos5l_decap_8
XFILLER_116_125 VPWR VGND sg13cmos5l_fill_1
X_4452_ _4452_/X _4421_/X _0159_/X _4420_/X _0145_/X _2235_/Q _2234_/Q VPWR VGND sg13cmos5l_mux4_1
X_1664_ _1664_/Q Tile_X0Y2_FrameData[17] VGND VPWR Tile_X0Y9_FrameStrobe[7] latch
XFILLER_664_84 VPWR VGND sg13cmos5l_decap_8
XFILLER_506_196 VPWR VGND sg13cmos5l_fill_2
XFILLER_236_35 VPWR VGND sg13cmos5l_decap_8
X_3403_ Tile_X0Y2_E2BEG[6] _4046_/X VPWR VGND sg13cmos5l_buf_1
XFILLER_383_63 VPWR VGND sg13cmos5l_decap_8
X_0615_ _0615_/Q Tile_X0Y8_FrameData[24] VGND VPWR Tile_X0Y9_FrameStrobe[6] latch
X_1595_ _1595_/Q Tile_X0Y2_FrameData[22] VGND VPWR Tile_X0Y9_FrameStrobe[5] latch
X_4383_ _4383_/X Tile_X0Y5_W2END[4] AXI_M_SOC_RVALID _4434_/X _4433_/X _2337_/Q _2336_/Q
+ VPWR VGND sg13cmos5l_mux4_1
XFILLER_320_228 VPWR VGND sg13cmos5l_fill_1
X_0546_ _0546_/Q Tile_X0Y8_FrameData[29] VGND VPWR Tile_X0Y9_FrameStrobe[4] latch
X_3334_ Tile_X0Y2_FrameData_O[5] Tile_X0Y2_FrameData[5] VPWR VGND sg13cmos5l_buf_1
XFILLER_675_181 VPWR VGND sg13cmos5l_fill_1
XFILLER_533_77 VPWR VGND sg13cmos5l_decap_8
XFILLER_419_137 VPWR VGND sg13cmos5l_fill_1
XFILLER_680_83 VPWR VGND sg13cmos5l_decap_8
XFILLER_105_28 VPWR VGND sg13cmos5l_decap_8
X_0477_ _0477_/Q Tile_X0Y8_FrameData[2] VGND VPWR Tile_X0Y9_FrameStrobe[1] latch
X_3265_ Tile_X0Y0_EE4BEG[1] _3821_/X VPWR VGND sg13cmos5l_buf_1
XFILLER_252_56 VPWR VGND sg13cmos5l_decap_8
X_2216_ _2216_/Q Tile_X0Y5_FrameData[29] VGND VPWR Tile_X0Y9_FrameStrobe[1] latch
X_3196_ Tile_X0Y0_N2BEGb[4] _3897_/X VPWR VGND sg13cmos5l_buf_1
X_2147_ _2147_/Q Tile_X0Y4_FrameData[2] VGND VPWR Tile_X0Y9_FrameStrobe[6] latch
XFILLER_689_81 VPWR VGND sg13cmos5l_decap_8
XFILLER_241_213 VPWR VGND sg13cmos5l_decap_8
X_2078_ _2078_/Q Tile_X0Y4_FrameData[7] VGND VPWR Tile_X0Y9_FrameStrobe[4] latch
XFILLER_53_145 VPWR VGND sg13cmos5l_decap_8
XFILLER_121_49 VPWR VGND sg13cmos5l_decap_8
XFILLER_387_217 VPWR VGND sg13cmos5l_decap_8
XFILLER_387_228 VPWR VGND sg13cmos5l_fill_1
X_1029_ _1029_/Q Tile_X0Y0_FrameData[6] VGND VPWR Tile_X0Y9_FrameStrobe[2] latch
XFILLER_53_189 VPWR VGND sg13cmos5l_fill_1
XFILLER_14_14 VPWR VGND sg13cmos5l_decap_8
XFILLER_558_63 VPWR VGND sg13cmos5l_decap_8
XFILLER_544_203 VPWR VGND sg13cmos5l_decap_8
XFILLER_139_228 VPWR VGND sg13cmos5l_fill_1
XFILLER_544_214 VPWR VGND sg13cmos5l_fill_2
XFILLER_277_42 VPWR VGND sg13cmos5l_decap_8
XFILLER_355_147 VPWR VGND sg13cmos5l_decap_8
XFILLER_708_77 VPWR VGND sg13cmos5l_decap_8
X_4719_ _4719_/X _4805_/X _4809_/X _4813_/X _4788_/X _0608_/Q _0607_/Q VPWR VGND sg13cmos5l_mux4_1
XFILLER_30_13 VPWR VGND sg13cmos5l_decap_8
XFILLER_427_56 VPWR VGND sg13cmos5l_decap_8
XFILLER_205_7 VPWR VGND sg13cmos5l_decap_8
XFILLER_574_84 VPWR VGND sg13cmos5l_decap_8
XFILLER_146_35 VPWR VGND sg13cmos5l_decap_8
XFILLER_293_63 VPWR VGND sg13cmos5l_decap_8
XFILLER_311_228 VPWR VGND sg13cmos5l_fill_1
XFILLER_512_199 VPWR VGND sg13cmos5l_decap_4
XFILLER_673_118 VPWR VGND sg13cmos5l_decap_8
XFILLER_465_221 VPWR VGND sg13cmos5l_decap_8
XFILLER_666_181 VPWR VGND sg13cmos5l_fill_1
XFILLER_443_77 VPWR VGND sg13cmos5l_decap_8
XFILLER_39_55 VPWR VGND sg13cmos5l_decap_8
XFILLER_574_7 VPWR VGND sg13cmos5l_decap_8
XFILLER_276_154 VPWR VGND sg13cmos5l_decap_8
XFILLER_162_56 VPWR VGND sg13cmos5l_decap_8
XANTENNA__3404__X Tile_X0Y2_E2BEG[7] VPWR VGND sg13cmos5l_antennanp
XFILLER_681_151 VPWR VGND sg13cmos5l_decap_8
XFILLER_418_170 VPWR VGND sg13cmos5l_decap_8
XFILLER_55_21 VPWR VGND sg13cmos5l_decap_8
XFILLER_433_140 VPWR VGND sg13cmos5l_decap_8
XFILLER_599_70 VPWR VGND sg13cmos5l_decap_8
XFILLER_579_133 VPWR VGND sg13cmos5l_decap_8
XFILLER_291_179 VPWR VGND sg13cmos5l_decap_8
XFILLER_433_173 VPWR VGND sg13cmos5l_decap_8
XFILLER_378_228 VPWR VGND sg13cmos5l_fill_1
XFILLER_594_158 VPWR VGND sg13cmos5l_decap_8
XFILLER_71_42 VPWR VGND sg13cmos5l_decap_8
XFILLER_685_28 VPWR VGND sg13cmos5l_decap_8
XFILLER_468_63 VPWR VGND sg13cmos5l_fill_1
XFILLER_197_161 VPWR VGND sg13cmos5l_decap_4
XFILLER_231_0 VPWR VGND sg13cmos5l_decap_8
XFILLER_468_85 VPWR VGND sg13cmos5l_decap_8
XFILLER_329_0 VPWR VGND sg13cmos5l_decap_8
XFILLER_187_42 VPWR VGND sg13cmos5l_decap_8
XFILLER_535_225 VPWR VGND sg13cmos5l_decap_4
XFILLER_346_147 VPWR VGND sg13cmos5l_fill_2
XFILLER_618_77 VPWR VGND sg13cmos5l_decap_8
XFILLER_187_97 VPWR VGND sg13cmos5l_decap_8
XFILLER_484_40 VPWR VGND sg13cmos5l_decap_8
XFILLER_337_56 VPWR VGND sg13cmos5l_decap_8
XFILLER_634_21 VPWR VGND sg13cmos5l_decap_8
XFILLER_503_133 VPWR VGND sg13cmos5l_decap_8
XFILLER_649_126 VPWR VGND sg13cmos5l_decap_8
XFILLER_698_0 VPWR VGND sg13cmos5l_decap_8
XFILLER_113_128 VPWR VGND sg13cmos5l_decap_4
X_0400_ _0400_/Q Tile_X0Y7_FrameData[15] VGND VPWR Tile_X0Y9_FrameStrobe[7] latch
X_1380_ _1380_/Q Tile_X0Y1_FrameData[21] VGND VPWR Tile_X0Y9_FrameStrobe[6] latch
XFILLER_634_98 VPWR VGND sg13cmos5l_decap_8
XFILLER_206_49 VPWR VGND sg13cmos5l_decap_8
XFILLER_267_132 VPWR VGND sg13cmos5l_fill_2
X_0331_ _0331_/Q Tile_X0Y7_FrameData[20] VGND VPWR Tile_X0Y9_FrameStrobe[5] latch
XFILLER_353_77 VPWR VGND sg13cmos5l_decap_8
XFILLER_503_14 VPWR VGND sg13cmos5l_decap_8
XFILLER_121_172 VPWR VGND sg13cmos5l_fill_1
XANTENNA__3314__X Tile_X0Y4_EE4BEG[2] VPWR VGND sg13cmos5l_antennanp
XFILLER_267_165 VPWR VGND sg13cmos5l_decap_8
XFILLER_650_42 VPWR VGND sg13cmos5l_decap_8
X_3050_ Tile_X0Y5_FrameData_O[9] Tile_X0Y5_FrameData[9] VPWR VGND sg13cmos5l_buf_1
X_0262_ _0262_/Q Tile_X0Y7_FrameData[25] VGND VPWR Tile_X0Y9_FrameStrobe[3] latch
XFILLER_208_210 VPWR VGND sg13cmos5l_decap_4
X_2001_ _2001_/Q Tile_X0Y4_FrameData[20] VGND VPWR Tile_X0Y9_FrameStrobe[2] latch
X_0193_ _0193_/Q Tile_X0Y7_FrameData[30] VGND VPWR Tile_X0Y9_FrameStrobe[1] latch
XFILLER_282_168 VPWR VGND sg13cmos5l_decap_8
XFILLER_424_140 VPWR VGND sg13cmos5l_decap_8
XFILLER_35_134 VPWR VGND sg13cmos5l_decap_4
XFILLER_302_70 VPWR VGND sg13cmos5l_decap_4
XFILLER_35_167 VPWR VGND sg13cmos5l_decap_8
X_3952_ _3952_/X Tile_X0Y1_WW4END[11] AXI_M_SOC_ARREADY _4019_/X _3995_/X _1305_/Q
+ _1304_/Q VPWR VGND sg13cmos5l_mux4_1
XFILLER_659_84 VPWR VGND sg13cmos5l_decap_8
X_2903_ Tile_X0Y6_FrameData_O[24] Tile_X0Y6_FrameData[24] VPWR VGND sg13cmos5l_buf_1
XFILLER_595_28 VPWR VGND sg13cmos5l_decap_8
XFILLER_378_63 VPWR VGND sg13cmos5l_decap_8
X_3883_ _3883_/X _3850_/X _0085_/X Tile_X0Y0_S1END[2] Tile_X0Y0_S4END[2] _0991_/Q
+ _0990_/Q VPWR VGND sg13cmos5l_mux4_1
X_2834_ Tile_X0Y6_E1BEG[3] _4495_/X VPWR VGND sg13cmos5l_buf_1
XFILLER_77_0 VPWR VGND sg13cmos5l_decap_8
XFILLER_528_77 VPWR VGND sg13cmos5l_decap_8
X_2765_ Tile_X0Y3_FrameData_O[23] Tile_X0Y3_FrameData[23] VPWR VGND sg13cmos5l_buf_1
XFILLER_528_88 VPWR VGND sg13cmos5l_fill_2
XFILLER_541_217 VPWR VGND sg13cmos5l_decap_8
XFILLER_541_228 VPWR VGND sg13cmos5l_fill_1
XFILLER_247_56 VPWR VGND sg13cmos5l_decap_8
X_4504_ _4504_/X Tile_X0Y6_W2END[7] AXI_M_SOC_RDATA31 _4553_/X _4552_/X _2599_/Q _2598_/Q
+ VPWR VGND sg13cmos5l_mux4_1
X_1716_ _1716_/Q Tile_X0Y3_FrameData[21] VGND VPWR Tile_X0Y9_FrameStrobe[1] latch
X_2696_ _2696_/Q Tile_X0Y6_FrameData[31] VGND VPWR Tile_X0Y9_FrameStrobe[0] latch
XFILLER_544_21 VPWR VGND sg13cmos5l_decap_8
XFILLER_6_70 VPWR VGND sg13cmos5l_decap_8
X_4435_ _4435_/X Tile_X0Y1_W1END[0] Tile_X0Y1_WW4END[12] Tile_X0Y1_W6END[4] _4008_/X
+ _1365_/Q _1364_/Q VPWR VGND sg13cmos5l_mux4_1
X_1647_ _1647_/Q Tile_X0Y2_FrameData[2] VGND VPWR Tile_X0Y9_FrameStrobe[6] latch
X_4366_ _4366_/X Tile_X0Y3_W1END[3] Tile_X0Y3_W2MID[0] Tile_X0Y3_W2END[0] _4204_/X
+ _1867_/Q _1866_/Q VPWR VGND sg13cmos5l_mux4_1
XFILLER_258_110 VPWR VGND sg13cmos5l_decap_4
XFILLER_116_49 VPWR VGND sg13cmos5l_decap_8
X_1578_ _1578_/Q Tile_X0Y2_FrameData[7] VGND VPWR Tile_X0Y9_FrameStrobe[4] latch
XFILLER_648_181 VPWR VGND sg13cmos5l_decap_8
X_3317_ Tile_X0Y4_EE4BEG[5] _4277_/X VPWR VGND sg13cmos5l_buf_1
XFILLER_58_215 VPWR VGND sg13cmos5l_fill_2
X_0529_ _0529_/Q Tile_X0Y8_FrameData[14] VGND VPWR Tile_X0Y9_FrameStrobe[3] latch
XFILLER_413_14 VPWR VGND sg13cmos5l_decap_8
XANTENNA__3224__X Tile_X0Y0_FrameStrobe_O[12] VPWR VGND sg13cmos5l_antennanp
X_4297_ _4297_/X AXI_M_SOC_BRESP1 _4338_/X _4342_/X _4316_/X _2019_/Q _2018_/Q VPWR
+ VGND sg13cmos5l_mux4_1
XFILLER_258_165 VPWR VGND sg13cmos5l_decap_8
XFILLER_560_42 VPWR VGND sg13cmos5l_decap_8
XFILLER_112_194 VPWR VGND sg13cmos5l_decap_8
X_3248_ Tile_X0Y0_FrameData_O[16] Tile_X0Y0_FrameData[16] VPWR VGND sg13cmos5l_buf_1
X_3179_ Tile_X0Y0_N4BEG[3] _3179_/A VPWR VGND sg13cmos5l_buf_1
XFILLER_273_179 VPWR VGND sg13cmos5l_fill_1
XFILLER_710_56 VPWR VGND sg13cmos5l_decap_8
XFILLER_415_184 VPWR VGND sg13cmos5l_decap_8
XFILLER_212_70 VPWR VGND sg13cmos5l_decap_8
XFILLER_25_35 VPWR VGND sg13cmos5l_decap_8
XFILLER_155_7 VPWR VGND sg13cmos5l_decap_8
XFILLER_430_154 VPWR VGND sg13cmos5l_decap_8
XFILLER_576_147 VPWR VGND sg13cmos5l_decap_8
XFILLER_569_84 VPWR VGND sg13cmos5l_decap_8
XFILLER_576_158 VPWR VGND sg13cmos5l_fill_2
XFILLER_41_159 VPWR VGND sg13cmos5l_decap_4
XFILLER_288_63 VPWR VGND sg13cmos5l_decap_8
XFILLER_517_225 VPWR VGND sg13cmos5l_decap_4
XFILLER_322_7 VPWR VGND sg13cmos5l_decap_8
XFILLER_41_45 VPWR VGND sg13cmos5l_decap_8
XFILLER_127_209 VPWR VGND sg13cmos5l_fill_1
XFILLER_194_164 VPWR VGND sg13cmos5l_decap_8
XFILLER_438_77 VPWR VGND sg13cmos5l_decap_8
XFILLER_194_186 VPWR VGND sg13cmos5l_fill_1
XFILLER_157_56 VPWR VGND sg13cmos5l_decap_8
XFILLER_454_21 VPWR VGND sg13cmos5l_decap_8
XFILLER_691_7 VPWR VGND sg13cmos5l_decap_8
XFILLER_351_161 VPWR VGND sg13cmos5l_decap_8
XFILLER_497_154 VPWR VGND sg13cmos5l_decap_8
XFILLER_500_147 VPWR VGND sg13cmos5l_decap_8
XFILLER_604_35 VPWR VGND sg13cmos5l_decap_8
XFILLER_173_77 VPWR VGND sg13cmos5l_decap_8
XFILLER_323_14 VPWR VGND sg13cmos5l_decap_8
XFILLER_2_28 VPWR VGND sg13cmos5l_decap_8
XANTENNA__3134__X Tile_X0Y7_FrameData_O[4] VPWR VGND sg13cmos5l_antennanp
XFILLER_654_140 VPWR VGND sg13cmos5l_decap_8
XFILLER_66_20 VPWR VGND sg13cmos5l_decap_8
XFILLER_470_42 VPWR VGND sg13cmos5l_decap_8
XFILLER_599_217 VPWR VGND sg13cmos5l_fill_2
XFILLER_181_0 VPWR VGND sg13cmos5l_decap_8
XANTENNA__2973__X Tile_X0Y8_FrameData_O[13] VPWR VGND sg13cmos5l_antennanp
XFILLER_279_0 VPWR VGND sg13cmos5l_decap_8
XFILLER_620_56 VPWR VGND sg13cmos5l_decap_8
XFILLER_403_91 VPWR VGND sg13cmos5l_decap_8
XFILLER_406_184 VPWR VGND sg13cmos5l_decap_4
XFILLER_122_70 VPWR VGND sg13cmos5l_decap_8
XFILLER_446_0 VPWR VGND sg13cmos5l_decap_8
XFILLER_82_63 VPWR VGND sg13cmos5l_decap_8
XFILLER_696_49 VPWR VGND sg13cmos5l_decap_8
XFILLER_567_147 VPWR VGND sg13cmos5l_decap_8
XFILLER_629_21 VPWR VGND sg13cmos5l_decap_8
XFILLER_198_63 VPWR VGND sg13cmos5l_decap_8
XFILLER_613_0 VPWR VGND sg13cmos5l_decap_8
XFILLER_508_203 VPWR VGND sg13cmos5l_decap_4
XFILLER_185_120 VPWR VGND sg13cmos5l_fill_1
XFILLER_374_220 VPWR VGND sg13cmos5l_decap_8
XFILLER_709_196 VPWR VGND sg13cmos5l_decap_8
X_0880_ _0880_/Q Tile_X0Y9_FrameData[15] VGND VPWR Tile_X0Y9_FrameStrobe[6] latch
XFILLER_629_98 VPWR VGND sg13cmos5l_decap_8
XFILLER_40_181 VPWR VGND sg13cmos5l_fill_1
XFILLER_185_153 VPWR VGND sg13cmos5l_fill_1
XFILLER_118_209 VPWR VGND sg13cmos5l_decap_8
XFILLER_70_7 VPWR VGND sg13cmos5l_decap_8
XFILLER_348_77 VPWR VGND sg13cmos5l_decap_8
XFILLER_185_175 VPWR VGND sg13cmos5l_decap_8
XFILLER_185_186 VPWR VGND sg13cmos5l_fill_2
XANTENNA__3309__X Tile_X0Y0_E1BEG[1] VPWR VGND sg13cmos5l_antennanp
XFILLER_645_42 VPWR VGND sg13cmos5l_decap_8
X_2550_ _2550_/Q Tile_X0Y6_FrameData[17] VGND VPWR Tile_X0Y9_FrameStrobe[3] latch
XFILLER_364_21 VPWR VGND sg13cmos5l_decap_8
X_1501_ _1501_/Q Tile_X0Y2_FrameData[20] VGND VPWR Tile_X0Y9_FrameStrobe[2] latch
X_2481_ _2481_/Q Tile_X0Y6_FrameData[22] VGND VPWR Tile_X0Y9_FrameStrobe[1] latch
XFILLER_287_216 VPWR VGND sg13cmos5l_decap_4
X_4220_ _4220_/X Tile_X0Y7_W1END[3] Tile_X0Y7_WW4END[3] Tile_X0Y7_W6END[11] _4687_/X
+ _0382_/Q _0381_/Q VPWR VGND sg13cmos5l_mux4_1
X_1432_ _1432_/Q Tile_X0Y2_FrameData[25] VGND VPWR Tile_X0Y9_FrameStrobe[0] latch
XFILLER_364_98 VPWR VGND sg13cmos5l_decap_8
XFILLER_429_210 VPWR VGND sg13cmos5l_decap_8
XFILLER_692_224 VPWR VGND sg13cmos5l_decap_4
XFILLER_514_35 VPWR VGND sg13cmos5l_decap_8
X_1363_ _1363_/Q Tile_X0Y1_FrameData[6] VGND VPWR Tile_X0Y9_FrameStrobe[5] latch
X_4151_ _4151_/X Tile_X0Y3_W2MID[4] AXI_M_SOC_BVALID _4211_/X _4210_/X _1839_/Q _1838_/Q
+ VPWR VGND sg13cmos5l_mux4_1
XFILLER_661_63 VPWR VGND sg13cmos5l_decap_8
XFILLER_233_14 VPWR VGND sg13cmos5l_decap_8
XANTENNA__3044__X Tile_X0Y5_FrameData_O[3] VPWR VGND sg13cmos5l_antennanp
XFILLER_645_140 VPWR VGND sg13cmos5l_decap_8
XFILLER_380_42 VPWR VGND sg13cmos5l_decap_8
X_0314_ _0314_/Q Tile_X0Y7_FrameData[5] VGND VPWR Tile_X0Y9_FrameStrobe[4] latch
X_3102_ Tile_X0Y7_E6BEG[0] _4644_/X VPWR VGND sg13cmos5l_buf_1
X_1294_ _1294_/Q Tile_X0Y1_FrameData[11] VGND VPWR Tile_X0Y9_FrameStrobe[3] latch
X_4082_ _4082_/X AXI_M_SOC_AWREADY _4117_/X _4121_/X _4098_/X _1509_/Q _1508_/Q VPWR
+ VGND sg13cmos5l_mux4_1
XFILLER_255_146 VPWR VGND sg13cmos5l_fill_2
XFILLER_55_218 VPWR VGND sg13cmos5l_fill_1
XANTENNA__2883__X Tile_X0Y6_FrameData_O[4] VPWR VGND sg13cmos5l_antennanp
X_0245_ _0245_/Q Tile_X0Y7_FrameData[10] VGND VPWR Tile_X0Y9_FrameStrobe[2] latch
X_3033_ Tile_X0Y5_EE4BEG[8] _4396_/X VPWR VGND sg13cmos5l_buf_1
XFILLER_270_105 VPWR VGND sg13cmos5l_decap_8
XFILLER_530_56 VPWR VGND sg13cmos5l_decap_8
X_0176_ _0176_/Q Tile_X0Y7_FrameData[15] VGND VPWR Tile_X0Y9_FrameStrobe[0] latch
XFILLER_660_187 VPWR VGND sg13cmos5l_decap_4
XFILLER_23_126 VPWR VGND sg13cmos5l_fill_2
XFILLER_539_21 VPWR VGND sg13cmos5l_decap_8
X_3935_ _3935_/X Tile_X0Y1_W2MID[4] AXI_M_SOC_ARREADY _3995_/X _3994_/X _1339_/Q _1338_/Q
+ VPWR VGND sg13cmos5l_mux4_1
XFILLER_715_111 VPWR VGND sg13cmos5l_decap_8
X_3866_ _3866_/X _4340_/X _4344_/X _4348_/X _4313_/X _2157_/Q _2156_/Q VPWR VGND sg13cmos5l_mux4_1
X_2817_ Tile_X0Y3_E2BEG[7] _4155_/X VPWR VGND sg13cmos5l_buf_1
XFILLER_258_77 VPWR VGND sg13cmos5l_decap_8
XFILLER_581_161 VPWR VGND sg13cmos5l_decap_8
XFILLER_408_14 VPWR VGND sg13cmos5l_decap_8
XFILLER_191_112 VPWR VGND sg13cmos5l_decap_8
X_3797_ _3797_/X _3887_/X _3868_/X _3867_/X _3857_/X _1147_/Q _1146_/Q VPWR VGND sg13cmos5l_mux4_1
XFILLER_325_128 VPWR VGND sg13cmos5l_fill_1
XANTENNA__3219__X Tile_X0Y0_FrameStrobe_O[7] VPWR VGND sg13cmos5l_antennanp
XFILLER_715_188 VPWR VGND sg13cmos5l_decap_8
XFILLER_555_42 VPWR VGND sg13cmos5l_decap_8
XFILLER_715_199 VPWR VGND sg13cmos5l_decap_8
X_2748_ Tile_X0Y3_FrameData_O[6] Tile_X0Y3_FrameData[6] VPWR VGND sg13cmos5l_buf_1
XFILLER_668_210 VPWR VGND sg13cmos5l_fill_1
XFILLER_274_21 VPWR VGND sg13cmos5l_decap_8
XFILLER_479_121 VPWR VGND sg13cmos5l_fill_1
XFILLER_479_143 VPWR VGND sg13cmos5l_fill_2
XFILLER_333_161 VPWR VGND sg13cmos5l_fill_1
X_2679_ _2679_/Q Tile_X0Y6_FrameData[16] VGND VPWR Tile_X0Y9_FrameStrobe[7] latch
XFILLER_705_56 VPWR VGND sg13cmos5l_decap_8
X_4418_ _4418_/X Tile_X0Y6_W1END[0] Tile_X0Y6_W6END[4] _4580_/X _4540_/X _2695_/Q
+ _2694_/Q VPWR VGND sg13cmos5l_mux4_1
XFILLER_479_198 VPWR VGND sg13cmos5l_decap_8
XFILLER_274_98 VPWR VGND sg13cmos5l_decap_8
XFILLER_424_35 VPWR VGND sg13cmos5l_decap_8
XFILLER_207_70 VPWR VGND sg13cmos5l_decap_8
XFILLER_571_63 VPWR VGND sg13cmos5l_decap_8
XFILLER_98_170 VPWR VGND sg13cmos5l_fill_1
X_4349_ _4349_/X _4305_/X _0158_/X _4304_/X _0111_/X _1955_/Q _1954_/Q VPWR VGND sg13cmos5l_mux4_1
XFILLER_494_168 VPWR VGND sg13cmos5l_decap_8
XFILLER_143_14 VPWR VGND sg13cmos5l_decap_8
XFILLER_290_42 VPWR VGND sg13cmos5l_decap_8
XFILLER_435_213 VPWR VGND sg13cmos5l_fill_1
XANTENNA__2793__X Tile_X0Y3_E6BEG[3] VPWR VGND sg13cmos5l_antennanp
XFILLER_272_7 VPWR VGND sg13cmos5l_decap_8
XFILLER_246_168 VPWR VGND sg13cmos5l_decap_8
XFILLER_651_154 VPWR VGND sg13cmos5l_decap_8
XFILLER_440_56 VPWR VGND sg13cmos5l_decap_8
XFILLER_223_91 VPWR VGND sg13cmos5l_decap_8
XFILLER_261_138 VPWR VGND sg13cmos5l_fill_2
XFILLER_537_7 VPWR VGND sg13cmos5l_decap_8
XFILLER_299_84 VPWR VGND sg13cmos5l_decap_8
XFILLER_449_21 VPWR VGND sg13cmos5l_decap_8
XFILLER_299_95 VPWR VGND sg13cmos5l_fill_1
XFILLER_167_120 VPWR VGND sg13cmos5l_decap_8
XFILLER_704_7 VPWR VGND sg13cmos5l_decap_8
XFILLER_52_66 VPWR VGND sg13cmos5l_decap_8
XFILLER_22_181 VPWR VGND sg13cmos5l_decap_4
XFILLER_167_153 VPWR VGND sg13cmos5l_decap_8
XFILLER_706_133 VPWR VGND sg13cmos5l_decap_8
XFILLER_572_161 VPWR VGND sg13cmos5l_decap_8
XFILLER_318_14 VPWR VGND sg13cmos5l_decap_8
XFILLER_167_197 VPWR VGND sg13cmos5l_decap_8
XANTENNA__3129__X Tile_X0Y7_EE4BEG[15] VPWR VGND sg13cmos5l_antennanp
XFILLER_465_42 VPWR VGND sg13cmos5l_decap_8
XFILLER_182_134 VPWR VGND sg13cmos5l_decap_8
XFILLER_182_156 VPWR VGND sg13cmos5l_decap_8
XFILLER_184_21 VPWR VGND sg13cmos5l_decap_8
XANTENNA__2968__X Tile_X0Y8_FrameData_O[8] VPWR VGND sg13cmos5l_antennanp
XFILLER_7_0 VPWR VGND sg13cmos5l_decap_8
XFILLER_619_107 VPWR VGND sg13cmos5l_fill_1
XFILLER_615_56 VPWR VGND sg13cmos5l_decap_8
XFILLER_674_224 VPWR VGND sg13cmos5l_decap_4
XFILLER_334_35 VPWR VGND sg13cmos5l_decap_8
XFILLER_117_70 VPWR VGND sg13cmos5l_decap_8
XFILLER_481_63 VPWR VGND sg13cmos5l_decap_8
XFILLER_396_0 VPWR VGND sg13cmos5l_decap_8
XFILLER_77_63 VPWR VGND sg13cmos5l_decap_8
XFILLER_627_140 VPWR VGND sg13cmos5l_fill_1
XFILLER_627_173 VPWR VGND sg13cmos5l_decap_4
XFILLER_563_0 VPWR VGND sg13cmos5l_decap_8
XFILLER_631_77 VPWR VGND sg13cmos5l_decap_8
XFILLER_203_28 VPWR VGND sg13cmos5l_decap_8
XFILLER_642_154 VPWR VGND sg13cmos5l_decap_8
XFILLER_252_105 VPWR VGND sg13cmos5l_decap_8
XFILLER_350_56 VPWR VGND sg13cmos5l_decap_8
XFILLER_133_91 VPWR VGND sg13cmos5l_decap_8
XFILLER_398_109 VPWR VGND sg13cmos5l_fill_1
XFILLER_252_149 VPWR VGND sg13cmos5l_fill_1
XFILLER_93_84 VPWR VGND sg13cmos5l_fill_1
XFILLER_60_221 VPWR VGND sg13cmos5l_fill_1
XFILLER_359_21 VPWR VGND sg13cmos5l_decap_8
XFILLER_260_182 VPWR VGND sg13cmos5l_fill_1
X_1981_ _1981_/Q Tile_X0Y4_FrameData[8] VGND VPWR Tile_X0Y9_FrameStrobe[1] latch
X_3720_ AXI_M_SOC_WDATA30 Tile_X0Y6_W1END[2] Tile_X0Y6_WW4END[6] Tile_X0Y6_WW4END[14]
+ _4582_/X _2499_/Q _2498_/Q VPWR VGND sg13cmos5l_mux4_1
X_0932_ _0932_/Q Tile_X0Y9_FrameData[23] VGND VPWR Tile_X0Y9_FrameStrobe[8] latch
XFILLER_359_98 VPWR VGND sg13cmos5l_decap_8
XFILLER_509_35 VPWR VGND sg13cmos5l_decap_8
X_3651_ AXI_M_SOC_AWADDR12 Tile_X0Y5_W1END[0] Tile_X0Y5_WW4END[4] Tile_X0Y5_WW4END[12]
+ _4463_/X _2247_/Q _2246_/Q VPWR VGND sg13cmos5l_mux4_1
XFILLER_656_63 VPWR VGND sg13cmos5l_decap_8
X_0863_ _0863_/Q Tile_X0Y9_FrameData[0] VGND VPWR Tile_X0Y9_FrameStrobe[5] latch
XFILLER_228_14 VPWR VGND sg13cmos5l_decap_8
XFILLER_173_112 VPWR VGND sg13cmos5l_fill_1
XANTENNA__3039__X Tile_X0Y5_EE4BEG[14] VPWR VGND sg13cmos5l_antennanp
XFILLER_563_172 VPWR VGND sg13cmos5l_decap_8
XFILLER_375_42 VPWR VGND sg13cmos5l_decap_8
X_2602_ _2602_/Q Tile_X0Y6_FrameData[29] VGND VPWR Tile_X0Y9_FrameStrobe[5] latch
X_3582_ Tile_X0Y9_FrameData_O[12] Tile_X0Y9_FrameData[12] VPWR VGND sg13cmos5l_buf_1
XFILLER_712_147 VPWR VGND sg13cmos5l_decap_8
X_0794_ _0794_/Q Tile_X0Y9_FrameData[5] VGND VPWR Tile_X0Y9_FrameStrobe[3] latch
XANTENNA__2878__X Tile_X0Y6_EE4BEG[15] VPWR VGND sg13cmos5l_antennanp
X_2533_ _2533_/Q Tile_X0Y6_FrameData[2] VGND VPWR Tile_X0Y9_FrameStrobe[2] latch
XFILLER_525_56 VPWR VGND sg13cmos5l_decap_8
XFILLER_476_113 VPWR VGND sg13cmos5l_decap_8
X_2464_ _2464_/Q Tile_X0Y6_FrameData[7] VGND VPWR Tile_X0Y9_FrameStrobe[0] latch
XFILLER_672_84 VPWR VGND sg13cmos5l_decap_4
XFILLER_244_35 VPWR VGND sg13cmos5l_decap_8
XFILLER_476_146 VPWR VGND sg13cmos5l_fill_1
X_4203_ _4203_/X Tile_X0Y4_W1END[3] Tile_X0Y4_W6END[7] _4351_/X _4309_/X _2175_/Q
+ _2174_/Q VPWR VGND sg13cmos5l_mux4_1
X_1415_ _1415_/Q Tile_X0Y1_FrameData[18] VGND VPWR Tile_X0Y9_FrameStrobe[7] latch
X_2395_ _2395_/Q Tile_X0Y5_FrameData[10] VGND VPWR Tile_X0Y9_FrameStrobe[6] latch
XFILLER_491_105 VPWR VGND sg13cmos5l_decap_8
XFILLER_476_179 VPWR VGND sg13cmos5l_fill_1
XFILLER_680_205 VPWR VGND sg13cmos5l_fill_1
X_4134_ _4134_/X Tile_X0Y1_W2MID[4] Tile_X0Y1_W2END[4] Tile_X0Y1_W6END[11] _3995_/X
+ _1375_/Q _1374_/Q VPWR VGND sg13cmos5l_mux4_1
XFILLER_680_227 VPWR VGND sg13cmos5l_fill_2
X_1346_ _1346_/Q Tile_X0Y1_FrameData[23] VGND VPWR Tile_X0Y9_FrameStrobe[5] latch
XFILLER_618_173 VPWR VGND sg13cmos5l_fill_1
XFILLER_541_77 VPWR VGND sg13cmos5l_decap_8
XFILLER_113_28 VPWR VGND sg13cmos5l_decap_8
X_4065_ _4065_/X Tile_X0Y2_WW4END[6] AXI_M_SOC_AWREADY _4122_/X _4098_/X _1543_/Q
+ _1542_/Q VPWR VGND sg13cmos5l_mux4_1
X_1277_ _1277_/Q Tile_X0Y1_FrameData[28] VGND VPWR Tile_X0Y9_FrameStrobe[3] latch
XFILLER_260_56 VPWR VGND sg13cmos5l_decap_8
XFILLER_243_116 VPWR VGND sg13cmos5l_fill_2
XANTENNA__3502__X Tile_X0Y1_E2BEGb[0] VPWR VGND sg13cmos5l_antennanp
X_3016_ Tile_X0Y5_E6BEG[3] _4407_/X VPWR VGND sg13cmos5l_buf_1
X_0228_ _0228_/Q Tile_X0Y7_FrameData[27] VGND VPWR Tile_X0Y9_FrameStrobe[2] latch
X_0159_ _0159_/X _4441_/X _4442_/X _0898_/Q VPWR VGND sg13cmos5l_mux2_1
XFILLER_51_221 VPWR VGND sg13cmos5l_decap_8
XFILLER_397_142 VPWR VGND sg13cmos5l_decap_4
XFILLER_697_70 VPWR VGND sg13cmos5l_decap_8
XFILLER_400_102 VPWR VGND sg13cmos5l_decap_8
XFILLER_269_21 VPWR VGND sg13cmos5l_decap_8
XFILLER_397_197 VPWR VGND sg13cmos5l_decap_8
X_3918_ _3918_/X Tile_X0Y2_W1END[0] Tile_X0Y2_WW4END[0] Tile_X0Y2_W6END[8] _4116_/X
+ _1649_/Q _1648_/Q VPWR VGND sg13cmos5l_mux4_1
XFILLER_269_98 VPWR VGND sg13cmos5l_decap_8
X_4898_ _4898_/X Tile_X0Y8_W1END[2] Tile_X0Y8_W6END[10] _4814_/X _4774_/X _0631_/Q
+ _0630_/Q VPWR VGND sg13cmos5l_mux4_1
XFILLER_419_35 VPWR VGND sg13cmos5l_decap_8
XFILLER_22_14 VPWR VGND sg13cmos5l_decap_8
XFILLER_566_63 VPWR VGND sg13cmos5l_decap_8
X_3849_ _3849_/X Tile_X0Y1_W1END[1] Tile_X0Y1_W6END[5] _4002_/X _3977_/X _1423_/Q
+ _1422_/Q VPWR VGND sg13cmos5l_mux4_1
XFILLER_138_14 VPWR VGND sg13cmos5l_decap_8
XFILLER_285_42 VPWR VGND sg13cmos5l_decap_8
XFILLER_118_7 VPWR VGND sg13cmos5l_decap_8
XFILLER_313_109 VPWR VGND sg13cmos5l_fill_1
XANTENNA__2788__X Tile_X0Y3_EE4BEG[14] VPWR VGND sg13cmos5l_antennanp
XFILLER_716_88 VPWR VGND sg13cmos5l_decap_8
XFILLER_435_56 VPWR VGND sg13cmos5l_decap_8
XFILLER_218_91 VPWR VGND sg13cmos5l_decap_8
XFILLER_0_7 VPWR VGND sg13cmos5l_decap_8
XFILLER_582_84 VPWR VGND sg13cmos5l_decap_8
XFILLER_154_35 VPWR VGND sg13cmos5l_decap_8
XFILLER_321_153 VPWR VGND sg13cmos5l_decap_4
XFILLER_78_129 VPWR VGND sg13cmos5l_decap_8
XFILLER_487_7 VPWR VGND sg13cmos5l_decap_8
XFILLER_467_179 VPWR VGND sg13cmos5l_fill_1
XFILLER_408_213 VPWR VGND sg13cmos5l_decap_8
XFILLER_86_140 VPWR VGND sg13cmos5l_fill_1
XFILLER_86_151 VPWR VGND sg13cmos5l_decap_8
XFILLER_304_49 VPWR VGND sg13cmos5l_decap_8
XFILLER_609_195 VPWR VGND sg13cmos5l_decap_8
XFILLER_475_190 VPWR VGND sg13cmos5l_fill_2
XFILLER_451_77 VPWR VGND sg13cmos5l_fill_2
XFILLER_654_7 VPWR VGND sg13cmos5l_decap_8
XFILLER_624_143 VPWR VGND sg13cmos5l_fill_2
XFILLER_601_14 VPWR VGND sg13cmos5l_decap_8
XFILLER_47_66 VPWR VGND sg13cmos5l_decap_8
XFILLER_423_205 VPWR VGND sg13cmos5l_decap_8
XFILLER_170_56 VPWR VGND sg13cmos5l_decap_8
XANTENNA__3412__X Tile_X0Y4_FrameData_O[3] VPWR VGND sg13cmos5l_antennanp
XFILLER_63_21 VPWR VGND sg13cmos5l_decap_8
XFILLER_388_131 VPWR VGND sg13cmos5l_decap_8
XFILLER_179_21 VPWR VGND sg13cmos5l_decap_8
XFILLER_400_70 VPWR VGND sg13cmos5l_decap_8
XFILLER_537_128 VPWR VGND sg13cmos5l_fill_2
XFILLER_179_65 VPWR VGND sg13cmos5l_fill_1
XFILLER_144_0 VPWR VGND sg13cmos5l_fill_2
XFILLER_329_220 VPWR VGND sg13cmos5l_fill_1
XFILLER_179_87 VPWR VGND sg13cmos5l_decap_4
XFILLER_8_49 VPWR VGND sg13cmos5l_decap_8
XFILLER_329_35 VPWR VGND sg13cmos5l_decap_8
XFILLER_693_28 VPWR VGND sg13cmos5l_decap_8
XFILLER_311_0 VPWR VGND sg13cmos5l_decap_8
XFILLER_545_183 VPWR VGND sg13cmos5l_fill_2
XFILLER_409_0 VPWR VGND sg13cmos5l_decap_8
XFILLER_195_42 VPWR VGND sg13cmos5l_decap_8
XFILLER_560_164 VPWR VGND sg13cmos5l_fill_2
XFILLER_626_77 VPWR VGND sg13cmos5l_decap_8
XFILLER_12_91 VPWR VGND sg13cmos5l_fill_2
XFILLER_560_197 VPWR VGND sg13cmos5l_decap_4
XFILLER_345_56 VPWR VGND sg13cmos5l_decap_8
XFILLER_647_224 VPWR VGND sg13cmos5l_decap_4
XFILLER_492_84 VPWR VGND sg13cmos5l_decap_8
XFILLER_680_0 VPWR VGND sg13cmos5l_decap_8
XFILLER_642_21 VPWR VGND sg13cmos5l_decap_8
XFILLER_458_146 VPWR VGND sg13cmos5l_decap_8
XFILLER_312_197 VPWR VGND sg13cmos5l_decap_8
XFILLER_473_116 VPWR VGND sg13cmos5l_decap_8
X_1200_ _1200_/Q Tile_X0Y1_FrameData[9] VGND VPWR Tile_X0Y9_FrameStrobe[0] latch
XFILLER_662_216 VPWR VGND sg13cmos5l_fill_2
X_2180_ _2180_/Q Tile_X0Y4_FrameData[1] VGND VPWR Tile_X0Y9_FrameStrobe[7] latch
XFILLER_642_98 VPWR VGND sg13cmos5l_decap_8
XFILLER_214_49 VPWR VGND sg13cmos5l_decap_8
XFILLER_361_77 VPWR VGND sg13cmos5l_decap_8
X_1131_ _1131_/Q Tile_X0Y0_FrameData[0] VGND VPWR Tile_X0Y9_FrameStrobe[5] latch
XFILLER_511_14 VPWR VGND sg13cmos5l_decap_8
XANTENNA__3322__X Tile_X0Y4_EE4BEG[10] VPWR VGND sg13cmos5l_antennanp
XFILLER_615_165 VPWR VGND sg13cmos5l_decap_8
XFILLER_414_227 VPWR VGND sg13cmos5l_fill_2
X_1062_ _1062_/Q Tile_X0Y0_FrameData[5] VGND VPWR Tile_X0Y9_FrameStrobe[3] latch
XFILLER_615_187 VPWR VGND sg13cmos5l_decap_8
XFILLER_225_149 VPWR VGND sg13cmos5l_fill_2
XFILLER_92_198 VPWR VGND sg13cmos5l_decap_4
X_4821_ _4821_/X Tile_X0Y7_W1END[1] Tile_X0Y7_W2MID[2] Tile_X0Y7_W2END[2] _4672_/X
+ _0361_/Q _0360_/Q VPWR VGND sg13cmos5l_mux4_1
XFILLER_178_226 VPWR VGND sg13cmos5l_fill_2
XFILLER_310_70 VPWR VGND sg13cmos5l_decap_4
X_4752_ _4752_/X Tile_X0Y8_WW4END[7] AXI_M_SOC_RDATA15 _4807_/X _4784_/X _0543_/Q
+ _0542_/Q VPWR VGND sg13cmos5l_mux4_1
X_1964_ _1964_/Q Tile_X0Y4_FrameData[25] VGND VPWR Tile_X0Y9_FrameStrobe[1] latch
XFILLER_667_84 VPWR VGND sg13cmos5l_decap_8
XFILLER_394_167 VPWR VGND sg13cmos5l_decap_8
XFILLER_239_35 VPWR VGND sg13cmos5l_decap_8
X_3703_ AXI_M_SOC_WDATA13 Tile_X0Y7_W1END[1] Tile_X0Y7_WW4END[5] Tile_X0Y7_WW4END[13]
+ _4697_/X _0221_/Q _0220_/Q VPWR VGND sg13cmos5l_mux4_1
XFILLER_394_189 VPWR VGND sg13cmos5l_decap_8
X_0915_ _0915_/Q Tile_X0Y9_FrameData[12] VGND VPWR Tile_X0Y9_FrameStrobe[7] latch
X_4683_ _4683_/X _4229_/X _4233_/X _4212_/X _4204_/X _1856_/Q _1855_/Q VPWR VGND sg13cmos5l_mux4_1
X_1895_ _1895_/Q Tile_X0Y3_FrameData[2] VGND VPWR Tile_X0Y9_FrameStrobe[6] latch
X_3634_ Tile_X0Y9_S4BEG[12] _3634_/A VPWR VGND sg13cmos5l_buf_1
X_0846_ _0846_/Q Tile_X0Y9_FrameData[17] VGND VPWR Tile_X0Y9_FrameStrobe[5] latch
XFILLER_697_146 VPWR VGND sg13cmos5l_fill_1
XFILLER_161_115 VPWR VGND sg13cmos5l_decap_8
XFILLER_536_77 VPWR VGND sg13cmos5l_decap_8
XFILLER_108_28 VPWR VGND sg13cmos5l_decap_8
X_3565_ Tile_X0Y9_EE4BEG[11] _4875_/X VPWR VGND sg13cmos5l_buf_1
XFILLER_697_168 VPWR VGND sg13cmos5l_decap_4
X_0777_ _0777_/Q Tile_X0Y9_FrameData[22] VGND VPWR Tile_X0Y9_FrameStrobe[3] latch
XFILLER_161_137 VPWR VGND sg13cmos5l_fill_2
XFILLER_700_128 VPWR VGND sg13cmos5l_decap_8
XFILLER_255_56 VPWR VGND sg13cmos5l_decap_8
XFILLER_449_102 VPWR VGND sg13cmos5l_decap_8
X_2516_ _2516_/Q Tile_X0Y6_FrameData[19] VGND VPWR Tile_X0Y9_FrameStrobe[2] latch
XFILLER_303_142 VPWR VGND sg13cmos5l_decap_8
X_3496_ Tile_X0Y1_E6BEG[6] _3970_/X VPWR VGND sg13cmos5l_buf_1
XFILLER_552_21 VPWR VGND sg13cmos5l_decap_8
XFILLER_303_153 VPWR VGND sg13cmos5l_fill_2
X_2447_ _2447_/Q Tile_X0Y6_FrameData[24] VGND VPWR Tile_X0Y9_FrameStrobe[0] latch
XFILLER_552_98 VPWR VGND sg13cmos5l_decap_8
X_2378_ _2378_/Q Tile_X0Y5_FrameData[27] VGND VPWR Tile_X0Y9_FrameStrobe[6] latch
XFILLER_606_121 VPWR VGND sg13cmos5l_fill_1
XFILLER_271_77 VPWR VGND sg13cmos5l_decap_8
X_4117_ _4117_/X _4091_/X _0064_/X _4090_/X Tile_X0Y0_S4END[9] _1479_/Q _1478_/Q VPWR
+ VGND sg13cmos5l_mux4_1
XFILLER_68_184 VPWR VGND sg13cmos5l_decap_8
X_1329_ _1329_/Q Tile_X0Y1_FrameData[8] VGND VPWR Tile_X0Y9_FrameStrobe[4] latch
XFILLER_606_143 VPWR VGND sg13cmos5l_decap_4
XFILLER_421_14 VPWR VGND sg13cmos5l_decap_8
XFILLER_216_105 VPWR VGND sg13cmos5l_decap_8
XANTENNA__3232__X Tile_X0Y0_FrameData_O[0] VPWR VGND sg13cmos5l_antennanp
XFILLER_606_165 VPWR VGND sg13cmos5l_fill_2
XFILLER_472_160 VPWR VGND sg13cmos5l_decap_8
XFILLER_17_14 VPWR VGND sg13cmos5l_decap_8
X_4048_ _4048_/X Tile_X0Y2_W2END[7] AXI_M_SOC_AWREADY _4097_/X _4096_/X _1577_/Q _1576_/Q
+ VPWR VGND sg13cmos5l_mux4_1
XFILLER_559_220 VPWR VGND sg13cmos5l_fill_2
XFILLER_224_160 VPWR VGND sg13cmos5l_decap_8
XFILLER_501_91 VPWR VGND sg13cmos5l_decap_8
XFILLER_519_106 VPWR VGND sg13cmos5l_fill_1
XFILLER_33_24 VPWR VGND sg13cmos5l_decap_8
XFILLER_220_70 VPWR VGND sg13cmos5l_decap_8
XFILLER_235_7 VPWR VGND sg13cmos5l_decap_8
XFILLER_577_84 VPWR VGND sg13cmos5l_decap_8
XFILLER_149_35 VPWR VGND sg13cmos5l_decap_8
XFILLER_385_178 VPWR VGND sg13cmos5l_decap_8
XFILLER_296_63 VPWR VGND sg13cmos5l_decap_8
XFILLER_137_112 VPWR VGND sg13cmos5l_decap_8
XFILLER_402_7 VPWR VGND sg13cmos5l_decap_8
XFILLER_137_189 VPWR VGND sg13cmos5l_decap_8
XFILLER_446_77 VPWR VGND sg13cmos5l_decap_8
XFILLER_542_186 VPWR VGND sg13cmos5l_decap_8
XANTENNA__3407__X Tile_X0Y2_E1BEG[2] VPWR VGND sg13cmos5l_antennanp
XFILLER_165_56 VPWR VGND sg13cmos5l_decap_8
XFILLER_629_213 VPWR VGND sg13cmos5l_decap_8
XFILLER_462_21 VPWR VGND sg13cmos5l_decap_8
XFILLER_58_10 VPWR VGND sg13cmos5l_decap_8
XFILLER_239_208 VPWR VGND sg13cmos5l_decap_8
XFILLER_612_35 VPWR VGND sg13cmos5l_decap_8
XFILLER_58_87 VPWR VGND sg13cmos5l_decap_4
XFILLER_331_14 VPWR VGND sg13cmos5l_decap_8
XFILLER_181_88 VPWR VGND sg13cmos5l_decap_8
XFILLER_59_195 VPWR VGND sg13cmos5l_decap_4
XFILLER_207_105 VPWR VGND sg13cmos5l_decap_8
XANTENNA__3142__X Tile_X0Y7_FrameData_O[12] VPWR VGND sg13cmos5l_antennanp
XFILLER_463_160 VPWR VGND sg13cmos5l_decap_8
XFILLER_688_28 VPWR VGND sg13cmos5l_decap_8
XFILLER_74_42 VPWR VGND sg13cmos5l_decap_8
XFILLER_74_176 VPWR VGND sg13cmos5l_decap_8
XFILLER_261_0 VPWR VGND sg13cmos5l_decap_8
XFILLER_359_0 VPWR VGND sg13cmos5l_decap_8
XANTENNA__2981__X Tile_X0Y8_FrameData_O[21] VPWR VGND sg13cmos5l_antennanp
XFILLER_215_160 VPWR VGND sg13cmos5l_decap_8
XFILLER_130_70 VPWR VGND sg13cmos5l_decap_8
XFILLER_526_0 VPWR VGND sg13cmos5l_decap_8
XFILLER_487_84 VPWR VGND sg13cmos5l_decap_8
XFILLER_637_21 VPWR VGND sg13cmos5l_decap_8
XFILLER_128_112 VPWR VGND sg13cmos5l_decap_8
X_0700_ _0700_/Q Tile_X0Y9_FrameData[3] VGND VPWR Tile_X0Y9_FrameStrobe[0] latch
XFILLER_533_131 VPWR VGND sg13cmos5l_decap_4
X_1680_ _1680_/Q Tile_X0Y3_FrameData[25] VGND VPWR Tile_X0Y9_FrameStrobe[0] latch
XFILLER_637_98 VPWR VGND sg13cmos5l_decap_8
XFILLER_209_49 VPWR VGND sg13cmos5l_decap_8
XFILLER_356_77 VPWR VGND sg13cmos5l_decap_8
XFILLER_128_189 VPWR VGND sg13cmos5l_fill_1
X_0631_ _0631_/Q Tile_X0Y8_FrameData[8] VGND VPWR Tile_X0Y9_FrameStrobe[6] latch
XFILLER_332_226 VPWR VGND sg13cmos5l_fill_2
XFILLER_143_126 VPWR VGND sg13cmos5l_decap_8
XFILLER_506_14 VPWR VGND sg13cmos5l_decap_8
XFILLER_289_119 VPWR VGND sg13cmos5l_decap_8
XANTENNA__3317__X Tile_X0Y4_EE4BEG[5] VPWR VGND sg13cmos5l_antennanp
XFILLER_694_105 VPWR VGND sg13cmos5l_decap_8
XFILLER_653_42 VPWR VGND sg13cmos5l_decap_8
X_3350_ Tile_X0Y2_FrameData_O[21] Tile_X0Y2_FrameData[21] VPWR VGND sg13cmos5l_buf_1
X_0562_ _0562_/Q Tile_X0Y8_FrameData[13] VGND VPWR Tile_X0Y9_FrameStrobe[4] latch
XFILLER_372_21 VPWR VGND sg13cmos5l_decap_8
X_2301_ _2301_/Q Tile_X0Y5_FrameData[8] VGND VPWR Tile_X0Y9_FrameStrobe[3] latch
X_3281_ Tile_X0Y0_E6BEG[1] _3837_/X VPWR VGND sg13cmos5l_buf_1
X_0493_ _0493_/Q Tile_X0Y8_FrameData[18] VGND VPWR Tile_X0Y9_FrameStrobe[2] latch
XFILLER_300_123 VPWR VGND sg13cmos5l_fill_1
X_2232_ _2232_/Q Tile_X0Y5_FrameData[13] VGND VPWR Tile_X0Y9_FrameStrobe[1] latch
XFILLER_635_227 VPWR VGND sg13cmos5l_fill_2
XFILLER_300_145 VPWR VGND sg13cmos5l_decap_8
XFILLER_372_98 VPWR VGND sg13cmos5l_decap_8
XFILLER_522_35 VPWR VGND sg13cmos5l_decap_8
XFILLER_305_70 VPWR VGND sg13cmos5l_decap_8
X_2163_ _2163_/Q Tile_X0Y4_FrameData[18] VGND VPWR Tile_X0Y9_FrameStrobe[7] latch
XFILLER_241_14 VPWR VGND sg13cmos5l_decap_8
XANTENNA__3052__X Tile_X0Y5_FrameData_O[11] VPWR VGND sg13cmos5l_antennanp
XFILLER_454_160 VPWR VGND sg13cmos5l_fill_1
X_1114_ _1114_/Q Tile_X0Y0_FrameData[17] VGND VPWR Tile_X0Y9_FrameStrobe[5] latch
XFILLER_598_28 VPWR VGND sg13cmos5l_decap_8
XFILLER_454_193 VPWR VGND sg13cmos5l_decap_8
XFILLER_80_102 VPWR VGND sg13cmos5l_decap_8
X_2094_ _2094_/Q Tile_X0Y4_FrameData[23] VGND VPWR Tile_X0Y9_FrameStrobe[5] latch
XFILLER_65_176 VPWR VGND sg13cmos5l_decap_8
XFILLER_80_113 VPWR VGND sg13cmos5l_fill_1
XANTENNA__2891__X Tile_X0Y6_FrameData_O[12] VPWR VGND sg13cmos5l_antennanp
XFILLER_80_135 VPWR VGND sg13cmos5l_decap_4
X_1045_ _1045_/Q Tile_X0Y0_FrameData[22] VGND VPWR Tile_X0Y9_FrameStrobe[3] latch
XFILLER_213_119 VPWR VGND sg13cmos5l_decap_8
XFILLER_206_182 VPWR VGND sg13cmos5l_decap_8
XFILLER_367_112 VPWR VGND sg13cmos5l_decap_8
X_4804_ _4804_/X _4777_/X Tile_X0Y9_N4END[4] _4776_/X _0077_/X _0463_/Q _0462_/Q VPWR
+ VGND sg13cmos5l_mux4_1
X_2996_ Tile_X0Y5_E1BEG[3] _4371_/X VPWR VGND sg13cmos5l_buf_1
XFILLER_166_218 VPWR VGND sg13cmos5l_fill_1
XFILLER_547_21 VPWR VGND sg13cmos5l_decap_8
XFILLER_9_70 VPWR VGND sg13cmos5l_decap_8
X_4735_ _4735_/X Tile_X0Y8_W2MID[0] AXI_M_SOC_RDATA15 _4785_/X _4784_/X _0577_/Q _0576_/Q
+ VPWR VGND sg13cmos5l_mux4_1
X_1947_ _1947_/Q Tile_X0Y4_FrameData[10] VGND VPWR Tile_X0Y9_FrameStrobe[0] latch
XFILLER_308_212 VPWR VGND sg13cmos5l_fill_2
XFILLER_713_220 VPWR VGND sg13cmos5l_fill_2
X_4666_ _4666_/X Tile_X0Y6_W1END[3] Tile_X0Y6_W6END[11] _4583_/X _4543_/X _2653_/Q
+ _2652_/Q VPWR VGND sg13cmos5l_mux4_1
XFILLER_547_98 VPWR VGND sg13cmos5l_decap_8
X_1878_ _1878_/Q Tile_X0Y3_FrameData[19] VGND VPWR Tile_X0Y9_FrameStrobe[6] latch
XFILLER_119_49 VPWR VGND sg13cmos5l_decap_8
X_3617_ Tile_X0Y9_S2BEGb[3] _4935_/X VPWR VGND sg13cmos5l_buf_1
XFILLER_266_77 VPWR VGND sg13cmos5l_decap_8
XFILLER_134_126 VPWR VGND sg13cmos5l_decap_8
X_0829_ _0829_/Q Tile_X0Y9_FrameData[2] VGND VPWR Tile_X0Y9_FrameStrobe[4] latch
XFILLER_416_14 VPWR VGND sg13cmos5l_decap_8
X_4597_ _4597_/X Tile_X0Y8_W2MID[1] Tile_X0Y8_W2END[1] Tile_X0Y8_W6END[1] _4786_/X
+ _0651_/Q _0650_/Q VPWR VGND sg13cmos5l_mux4_1
XFILLER_524_186 VPWR VGND sg13cmos5l_decap_8
XANTENNA__3227__X Tile_X0Y0_FrameStrobe_O[15] VPWR VGND sg13cmos5l_antennanp
XFILLER_685_105 VPWR VGND sg13cmos5l_decap_8
XFILLER_685_116 VPWR VGND sg13cmos5l_fill_2
XFILLER_563_42 VPWR VGND sg13cmos5l_decap_8
X_3548_ Tile_X0Y9_E6BEG[6] _4886_/X VPWR VGND sg13cmos5l_buf_1
XFILLER_282_21 VPWR VGND sg13cmos5l_decap_8
XFILLER_88_213 VPWR VGND sg13cmos5l_fill_2
X_3479_ Tile_X0Y1_EE4BEG[5] _3953_/X VPWR VGND sg13cmos5l_buf_1
XFILLER_437_105 VPWR VGND sg13cmos5l_decap_8
XFILLER_626_205 VPWR VGND sg13cmos5l_decap_8
XFILLER_713_56 VPWR VGND sg13cmos5l_decap_8
XFILLER_492_211 VPWR VGND sg13cmos5l_decap_4
XFILLER_288_196 VPWR VGND sg13cmos5l_decap_8
XFILLER_282_98 VPWR VGND sg13cmos5l_decap_8
XFILLER_432_35 VPWR VGND sg13cmos5l_decap_8
XFILLER_215_70 VPWR VGND sg13cmos5l_decap_8
XFILLER_28_35 VPWR VGND sg13cmos5l_decap_8
XFILLER_151_14 VPWR VGND sg13cmos5l_decap_8
XFILLER_185_7 VPWR VGND sg13cmos5l_decap_8
XFILLER_56_143 VPWR VGND sg13cmos5l_decap_8
XFILLER_445_193 VPWR VGND sg13cmos5l_fill_2
XFILLER_56_187 VPWR VGND sg13cmos5l_decap_8
XFILLER_352_7 VPWR VGND sg13cmos5l_decap_8
XFILLER_301_28 VPWR VGND sg13cmos5l_decap_8
XFILLER_204_119 VPWR VGND sg13cmos5l_decap_8
XFILLER_231_91 VPWR VGND sg13cmos5l_decap_4
XFILLER_71_168 VPWR VGND sg13cmos5l_decap_4
XFILLER_358_112 VPWR VGND sg13cmos5l_decap_8
XFILLER_44_89 VPWR VGND sg13cmos5l_decap_8
XFILLER_617_7 VPWR VGND sg13cmos5l_decap_8
XFILLER_457_21 VPWR VGND sg13cmos5l_decap_8
XFILLER_157_218 VPWR VGND sg13cmos5l_fill_1
XFILLER_8_217 VPWR VGND sg13cmos5l_fill_2
XFILLER_212_196 VPWR VGND sg13cmos5l_fill_2
XFILLER_100_84 VPWR VGND sg13cmos5l_fill_2
XFILLER_373_148 VPWR VGND sg13cmos5l_decap_8
XFILLER_60_77 VPWR VGND sg13cmos5l_decap_8
XFILLER_607_35 VPWR VGND sg13cmos5l_decap_8
XFILLER_326_14 VPWR VGND sg13cmos5l_decap_8
XFILLER_5_28 VPWR VGND sg13cmos5l_decap_8
XFILLER_515_186 VPWR VGND sg13cmos5l_fill_1
XANTENNA__3137__X Tile_X0Y7_FrameData_O[7] VPWR VGND sg13cmos5l_antennanp
XFILLER_676_105 VPWR VGND sg13cmos5l_fill_1
XFILLER_473_42 VPWR VGND sg13cmos5l_decap_8
XFILLER_107_0 VPWR VGND sg13cmos5l_decap_8
XFILLER_530_145 VPWR VGND sg13cmos5l_decap_8
XFILLER_69_42 VPWR VGND sg13cmos5l_decap_8
XFILLER_676_149 VPWR VGND sg13cmos5l_decap_8
XFILLER_192_21 VPWR VGND sg13cmos5l_decap_8
XANTENNA__2976__X Tile_X0Y8_FrameData_O[16] VPWR VGND sg13cmos5l_antennanp
XFILLER_428_105 VPWR VGND sg13cmos5l_decap_8
XFILLER_623_56 VPWR VGND sg13cmos5l_decap_8
XFILLER_294_133 VPWR VGND sg13cmos5l_fill_1
XFILLER_342_35 VPWR VGND sg13cmos5l_decap_8
XFILLER_294_155 VPWR VGND sg13cmos5l_decap_8
XFILLER_125_70 VPWR VGND sg13cmos5l_fill_1
XFILLER_476_0 VPWR VGND sg13cmos5l_decap_8
XFILLER_443_119 VPWR VGND sg13cmos5l_decap_8
XFILLER_85_63 VPWR VGND sg13cmos5l_fill_1
XFILLER_451_130 VPWR VGND sg13cmos5l_decap_8
XFILLER_643_0 VPWR VGND sg13cmos5l_decap_8
XFILLER_211_28 VPWR VGND sg13cmos5l_decap_8
XFILLER_451_163 VPWR VGND sg13cmos5l_fill_1
XFILLER_250_225 VPWR VGND sg13cmos5l_decap_4
XFILLER_141_91 VPWR VGND sg13cmos5l_decap_8
XANTENNA__3600__X Tile_X0Y9_FrameData_O[30] VPWR VGND sg13cmos5l_antennanp
XFILLER_62_168 VPWR VGND sg13cmos5l_decap_8
XFILLER_349_112 VPWR VGND sg13cmos5l_decap_8
XFILLER_648_42 VPWR VGND sg13cmos5l_decap_8
X_2850_ Tile_X0Y6_E2BEGb[7] _4511_/X VPWR VGND sg13cmos5l_buf_1
XFILLER_367_21 VPWR VGND sg13cmos5l_decap_8
XFILLER_203_185 VPWR VGND sg13cmos5l_decap_8
XFILLER_553_204 VPWR VGND sg13cmos5l_decap_8
X_1801_ _1801_/Q Tile_X0Y3_FrameData[0] VGND VPWR Tile_X0Y9_FrameStrobe[3] latch
XFILLER_364_126 VPWR VGND sg13cmos5l_fill_1
X_2781_ Tile_X0Y3_EE4BEG[7] _4171_/X VPWR VGND sg13cmos5l_buf_1
X_4520_ _4520_/X Tile_X0Y6_WW4END[7] AXI_M_SOC_RDATA31 _4575_/X _4552_/X _2567_/Q
+ _2566_/Q VPWR VGND sg13cmos5l_mux4_1
X_1732_ _1732_/Q Tile_X0Y3_FrameData[5] VGND VPWR Tile_X0Y9_FrameStrobe[1] latch
XFILLER_367_98 VPWR VGND sg13cmos5l_decap_8
XFILLER_517_35 VPWR VGND sg13cmos5l_decap_8
X_4451_ _4451_/X _4418_/X _0157_/X _4417_/X _0143_/X _2237_/Q _2236_/Q VPWR VGND sg13cmos5l_mux4_1
XFILLER_664_63 VPWR VGND sg13cmos5l_decap_8
XFILLER_506_175 VPWR VGND sg13cmos5l_decap_8
X_1663_ _1663_/Q Tile_X0Y2_FrameData[18] VGND VPWR Tile_X0Y9_FrameStrobe[7] latch
XFILLER_372_181 VPWR VGND sg13cmos5l_decap_8
XFILLER_236_14 VPWR VGND sg13cmos5l_decap_8
XFILLER_116_137 VPWR VGND sg13cmos5l_decap_8
XANTENNA__3047__X Tile_X0Y5_FrameData_O[6] VPWR VGND sg13cmos5l_antennanp
XFILLER_667_105 VPWR VGND sg13cmos5l_decap_4
X_3402_ Tile_X0Y2_E2BEG[5] _4045_/X VPWR VGND sg13cmos5l_buf_1
XFILLER_383_42 VPWR VGND sg13cmos5l_decap_8
X_0614_ _0614_/Q Tile_X0Y8_FrameData[25] VGND VPWR Tile_X0Y9_FrameStrobe[6] latch
XFILLER_521_145 VPWR VGND sg13cmos5l_decap_8
X_4382_ _4382_/X Tile_X0Y5_W2END[5] AXI_M_SOC_RLAST _4432_/X _4431_/X _2339_/Q _2338_/Q
+ VPWR VGND sg13cmos5l_mux4_1
XFILLER_521_156 VPWR VGND sg13cmos5l_fill_1
X_1594_ _1594_/Q Tile_X0Y2_FrameData[23] VGND VPWR Tile_X0Y9_FrameStrobe[5] latch
XANTENNA__2886__X Tile_X0Y6_FrameData_O[7] VPWR VGND sg13cmos5l_antennanp
X_3333_ Tile_X0Y2_FrameData_O[4] Tile_X0Y2_FrameData[4] VPWR VGND sg13cmos5l_buf_1
X_0545_ _0545_/Q Tile_X0Y8_FrameData[30] VGND VPWR Tile_X0Y9_FrameStrobe[4] latch
XFILLER_419_105 VPWR VGND sg13cmos5l_decap_4
XFILLER_680_62 VPWR VGND sg13cmos5l_decap_8
XFILLER_533_56 VPWR VGND sg13cmos5l_decap_8
XFILLER_608_227 VPWR VGND sg13cmos5l_fill_2
XFILLER_285_133 VPWR VGND sg13cmos5l_decap_8
X_3264_ Tile_X0Y0_EE4BEG[0] _3820_/X VPWR VGND sg13cmos5l_buf_1
X_0476_ _0476_/Q Tile_X0Y8_FrameData[3] VGND VPWR Tile_X0Y9_FrameStrobe[1] latch
XFILLER_252_35 VPWR VGND sg13cmos5l_decap_8
XFILLER_22_0 VPWR VGND sg13cmos5l_decap_8
XFILLER_690_130 VPWR VGND sg13cmos5l_decap_8
XFILLER_690_141 VPWR VGND sg13cmos5l_fill_2
X_2215_ _2215_/Q Tile_X0Y5_FrameData[30] VGND VPWR Tile_X0Y9_FrameStrobe[1] latch
X_3195_ Tile_X0Y0_N2BEGb[3] _3895_/X VPWR VGND sg13cmos5l_buf_1
XFILLER_434_119 VPWR VGND sg13cmos5l_decap_8
XFILLER_427_182 VPWR VGND sg13cmos5l_decap_8
X_2146_ _2146_/Q Tile_X0Y4_FrameData[3] VGND VPWR Tile_X0Y9_FrameStrobe[6] latch
XFILLER_588_112 VPWR VGND sg13cmos5l_decap_8
XFILLER_402_49 VPWR VGND sg13cmos5l_decap_8
XFILLER_38_176 VPWR VGND sg13cmos5l_fill_2
XFILLER_689_60 VPWR VGND sg13cmos5l_decap_8
XFILLER_442_141 VPWR VGND sg13cmos5l_fill_1
XFILLER_53_124 VPWR VGND sg13cmos5l_decap_8
XFILLER_121_28 VPWR VGND sg13cmos5l_decap_8
X_2077_ _2077_/Q Tile_X0Y4_FrameData[8] VGND VPWR Tile_X0Y9_FrameStrobe[4] latch
XFILLER_198_118 VPWR VGND sg13cmos5l_decap_8
XANTENNA__3510__X Tile_X0Y1_E2BEG[0] VPWR VGND sg13cmos5l_antennanp
XFILLER_442_185 VPWR VGND sg13cmos5l_decap_8
XFILLER_198_129 VPWR VGND sg13cmos5l_fill_2
X_1028_ _1028_/Q Tile_X0Y0_FrameData[7] VGND VPWR Tile_X0Y9_FrameStrobe[2] latch
XFILLER_558_42 VPWR VGND sg13cmos5l_decap_8
XFILLER_139_207 VPWR VGND sg13cmos5l_fill_1
XFILLER_277_21 VPWR VGND sg13cmos5l_decap_8
XFILLER_355_126 VPWR VGND sg13cmos5l_decap_8
X_2979_ Tile_X0Y8_FrameData_O[19] Tile_X0Y8_FrameData[19] VPWR VGND sg13cmos5l_buf_1
XFILLER_708_56 VPWR VGND sg13cmos5l_decap_8
X_4718_ _4718_/X Tile_X0Y8_W1END[1] Tile_X0Y8_WW4END[13] Tile_X0Y8_W6END[5] _4801_/X
+ _0608_/Q _0607_/Q VPWR VGND sg13cmos5l_mux4_1
XFILLER_277_98 VPWR VGND sg13cmos5l_decap_8
XFILLER_427_35 VPWR VGND sg13cmos5l_decap_8
XFILLER_107_126 VPWR VGND sg13cmos5l_fill_2
X_4649_ _4649_/X AXI_M_SOC_RDATA17 _4690_/X _4694_/X _4671_/X _0261_/Q _0260_/Q VPWR
+ VGND sg13cmos5l_mux4_1
XFILLER_574_63 VPWR VGND sg13cmos5l_decap_8
XFILLER_363_181 VPWR VGND sg13cmos5l_decap_8
XFILLER_146_14 VPWR VGND sg13cmos5l_decap_8
XFILLER_658_105 VPWR VGND sg13cmos5l_decap_8
XFILLER_30_69 VPWR VGND sg13cmos5l_decap_8
XFILLER_658_116 VPWR VGND sg13cmos5l_fill_2
XFILLER_293_42 VPWR VGND sg13cmos5l_decap_8
XFILLER_100_7 VPWR VGND sg13cmos5l_decap_8
XANTENNA__2796__X Tile_X0Y3_E6BEG[6] VPWR VGND sg13cmos5l_antennanp
XFILLER_465_200 VPWR VGND sg13cmos5l_decap_8
XFILLER_443_56 VPWR VGND sg13cmos5l_decap_8
XFILLER_39_34 VPWR VGND sg13cmos5l_decap_8
XFILLER_130_140 VPWR VGND sg13cmos5l_decap_8
XFILLER_276_133 VPWR VGND sg13cmos5l_decap_8
XFILLER_590_84 VPWR VGND sg13cmos5l_decap_8
XFILLER_162_35 VPWR VGND sg13cmos5l_decap_8
XFILLER_39_89 VPWR VGND sg13cmos5l_decap_4
XFILLER_130_195 VPWR VGND sg13cmos5l_decap_8
XFILLER_567_7 VPWR VGND sg13cmos5l_decap_8
XFILLER_425_119 VPWR VGND sg13cmos5l_decap_8
XFILLER_291_136 VPWR VGND sg13cmos5l_fill_1
XFILLER_579_112 VPWR VGND sg13cmos5l_decap_8
XFILLER_312_49 VPWR VGND sg13cmos5l_decap_8
XFILLER_55_77 VPWR VGND sg13cmos5l_decap_8
XFILLER_44_146 VPWR VGND sg13cmos5l_decap_4
XFILLER_232_225 VPWR VGND sg13cmos5l_decap_4
XANTENNA__3420__X Tile_X0Y4_FrameData_O[11] VPWR VGND sg13cmos5l_antennanp
XFILLER_55_88 VPWR VGND sg13cmos5l_fill_2
XFILLER_579_189 VPWR VGND sg13cmos5l_decap_8
XFILLER_71_21 VPWR VGND sg13cmos5l_decap_8
XFILLER_468_42 VPWR VGND sg13cmos5l_decap_8
XFILLER_197_173 VPWR VGND sg13cmos5l_fill_1
XFILLER_187_21 VPWR VGND sg13cmos5l_decap_8
XFILLER_346_126 VPWR VGND sg13cmos5l_decap_8
XFILLER_197_195 VPWR VGND sg13cmos5l_decap_8
XFILLER_71_98 VPWR VGND sg13cmos5l_decap_8
XFILLER_224_0 VPWR VGND sg13cmos5l_decap_8
XFILLER_618_56 VPWR VGND sg13cmos5l_decap_8
XFILLER_200_177 VPWR VGND sg13cmos5l_fill_2
XFILLER_337_35 VPWR VGND sg13cmos5l_decap_8
XFILLER_503_112 VPWR VGND sg13cmos5l_decap_8
XFILLER_299_214 VPWR VGND sg13cmos5l_decap_4
XFILLER_649_105 VPWR VGND sg13cmos5l_decap_8
XFILLER_299_225 VPWR VGND sg13cmos5l_decap_4
XFILLER_484_96 VPWR VGND sg13cmos5l_decap_8
XFILLER_113_107 VPWR VGND sg13cmos5l_decap_8
XFILLER_593_0 VPWR VGND sg13cmos5l_decap_8
XFILLER_503_189 VPWR VGND sg13cmos5l_decap_8
XFILLER_634_77 VPWR VGND sg13cmos5l_decap_8
XFILLER_206_28 VPWR VGND sg13cmos5l_decap_8
XFILLER_106_181 VPWR VGND sg13cmos5l_fill_1
XFILLER_353_56 VPWR VGND sg13cmos5l_decap_8
XFILLER_136_91 VPWR VGND sg13cmos5l_decap_8
X_0330_ _0330_/Q Tile_X0Y7_FrameData[21] VGND VPWR Tile_X0Y9_FrameStrobe[5] latch
XFILLER_67_205 VPWR VGND sg13cmos5l_decap_8
XFILLER_121_151 VPWR VGND sg13cmos5l_decap_8
XFILLER_650_21 VPWR VGND sg13cmos5l_decap_8
X_0261_ _0261_/Q Tile_X0Y7_FrameData[26] VGND VPWR Tile_X0Y9_FrameStrobe[3] latch
XFILLER_672_163 VPWR VGND sg13cmos5l_decap_4
X_2000_ _2000_/Q Tile_X0Y4_FrameData[21] VGND VPWR Tile_X0Y9_FrameStrobe[2] latch
XFILLER_282_147 VPWR VGND sg13cmos5l_decap_8
X_0192_ _0192_/Q Tile_X0Y7_FrameData[31] VGND VPWR Tile_X0Y9_FrameStrobe[1] latch
XFILLER_650_98 VPWR VGND sg13cmos5l_decap_8
XFILLER_35_102 VPWR VGND sg13cmos5l_fill_1
XFILLER_222_49 VPWR VGND sg13cmos5l_decap_8
XANTENNA__3330__X Tile_X0Y2_FrameData_O[1] VPWR VGND sg13cmos5l_antennanp
X_3951_ _3951_/X Tile_X0Y1_WW4END[12] AXI_M_SOC_ARREADY _4005_/X _3994_/X _1307_/Q
+ _1306_/Q VPWR VGND sg13cmos5l_mux4_1
XFILLER_659_63 VPWR VGND sg13cmos5l_decap_8
XFILLER_50_127 VPWR VGND sg13cmos5l_fill_2
X_2902_ Tile_X0Y6_FrameData_O[23] Tile_X0Y6_FrameData[23] VPWR VGND sg13cmos5l_buf_1
XFILLER_378_42 VPWR VGND sg13cmos5l_decap_8
X_3882_ _3882_/X _3849_/X _0086_/X Tile_X0Y0_S1END[1] Tile_X0Y0_S4END[1] _0993_/Q
+ _0992_/Q VPWR VGND sg13cmos5l_mux4_1
X_2833_ Tile_X0Y6_E1BEG[2] _4494_/X VPWR VGND sg13cmos5l_buf_1
XFILLER_526_215 VPWR VGND sg13cmos5l_fill_2
XFILLER_528_56 VPWR VGND sg13cmos5l_decap_8
X_2764_ Tile_X0Y3_FrameData_O[22] Tile_X0Y3_FrameData[22] VPWR VGND sg13cmos5l_buf_1
XFILLER_675_84 VPWR VGND sg13cmos5l_decap_8
XFILLER_247_35 VPWR VGND sg13cmos5l_decap_8
X_4503_ _4503_/X Tile_X0Y6_W2MID[0] AXI_M_SOC_RDATA31 _4553_/X _4552_/X _2601_/Q _2600_/Q
+ VPWR VGND sg13cmos5l_mux4_1
X_1715_ _1715_/Q Tile_X0Y3_FrameData[22] VGND VPWR Tile_X0Y9_FrameStrobe[1] latch
X_2695_ _2695_/Q Tile_X0Y6_FrameData[0] VGND VPWR Tile_X0Y9_FrameStrobe[7] latch
X_4434_ _4434_/X _4359_/X _4475_/X _4474_/X _4358_/X _2199_/Q _2198_/Q VPWR VGND sg13cmos5l_mux4_1
X_1646_ _1646_/Q Tile_X0Y2_FrameData[3] VGND VPWR Tile_X0Y9_FrameStrobe[6] latch
XFILLER_104_118 VPWR VGND sg13cmos5l_fill_1
XFILLER_544_77 VPWR VGND sg13cmos5l_decap_8
X_4365_ _4365_/X Tile_X0Y6_W2MID[1] Tile_X0Y6_W2END[1] Tile_X0Y6_W6END[1] _4554_/X
+ _2675_/Q _2674_/Q VPWR VGND sg13cmos5l_mux4_1
XFILLER_544_88 VPWR VGND sg13cmos5l_fill_2
XFILLER_116_28 VPWR VGND sg13cmos5l_decap_8
X_1577_ _1577_/Q Tile_X0Y2_FrameData[8] VGND VPWR Tile_X0Y9_FrameStrobe[4] latch
XFILLER_655_119 VPWR VGND sg13cmos5l_decap_8
XFILLER_648_160 VPWR VGND sg13cmos5l_decap_8
XFILLER_263_56 VPWR VGND sg13cmos5l_decap_8
XANTENNA__3505__X Tile_X0Y1_E2BEGb[3] VPWR VGND sg13cmos5l_antennanp
X_3316_ Tile_X0Y4_EE4BEG[4] _4276_/X VPWR VGND sg13cmos5l_buf_1
XFILLER_258_133 VPWR VGND sg13cmos5l_decap_8
X_0528_ _0528_/Q Tile_X0Y8_FrameData[15] VGND VPWR Tile_X0Y9_FrameStrobe[3] latch
X_4296_ _4296_/X AXI_M_SOC_BRESP0 _4339_/X _4343_/X _4318_/X _2021_/Q _2020_/Q VPWR
+ VGND sg13cmos5l_mux4_1
XFILLER_560_21 VPWR VGND sg13cmos5l_decap_8
XFILLER_112_173 VPWR VGND sg13cmos5l_decap_8
X_3247_ Tile_X0Y0_FrameData_O[15] Tile_X0Y0_FrameData[15] VPWR VGND sg13cmos5l_buf_1
X_0459_ _0459_/Q Tile_X0Y8_FrameData[20] VGND VPWR Tile_X0Y9_FrameStrobe[1] latch
XFILLER_73_208 VPWR VGND sg13cmos5l_decap_4
XFILLER_273_147 VPWR VGND sg13cmos5l_decap_4
XFILLER_560_98 VPWR VGND sg13cmos5l_decap_8
X_3178_ Tile_X0Y0_N4BEG[2] _3178_/A VPWR VGND sg13cmos5l_buf_1
XFILLER_132_49 VPWR VGND sg13cmos5l_decap_8
XFILLER_710_35 VPWR VGND sg13cmos5l_decap_8
XFILLER_214_203 VPWR VGND sg13cmos5l_decap_8
X_2129_ _2129_/Q Tile_X0Y4_FrameData[20] VGND VPWR Tile_X0Y9_FrameStrobe[6] latch
XANTENNA__3240__X Tile_X0Y0_FrameData_O[8] VPWR VGND sg13cmos5l_antennanp
XFILLER_214_225 VPWR VGND sg13cmos5l_decap_4
XFILLER_25_14 VPWR VGND sg13cmos5l_decap_8
XFILLER_430_133 VPWR VGND sg13cmos5l_decap_8
XFILLER_576_126 VPWR VGND sg13cmos5l_decap_8
XFILLER_569_63 VPWR VGND sg13cmos5l_decap_8
XFILLER_288_42 VPWR VGND sg13cmos5l_decap_8
XFILLER_148_7 VPWR VGND sg13cmos5l_decap_8
XFILLER_41_24 VPWR VGND sg13cmos5l_decap_8
XFILLER_438_56 VPWR VGND sg13cmos5l_decap_8
XFILLER_315_7 VPWR VGND sg13cmos5l_decap_8
XFILLER_585_84 VPWR VGND sg13cmos5l_decap_8
XFILLER_157_35 VPWR VGND sg13cmos5l_decap_8
XFILLER_532_218 VPWR VGND sg13cmos5l_decap_4
XFILLER_351_140 VPWR VGND sg13cmos5l_decap_8
XFILLER_497_133 VPWR VGND sg13cmos5l_decap_8
XFILLER_307_49 VPWR VGND sg13cmos5l_decap_8
XFILLER_454_77 VPWR VGND sg13cmos5l_decap_4
XFILLER_500_126 VPWR VGND sg13cmos5l_decap_8
XFILLER_684_7 VPWR VGND sg13cmos5l_decap_8
XFILLER_646_119 VPWR VGND sg13cmos5l_decap_8
XFILLER_604_14 VPWR VGND sg13cmos5l_decap_8
XANTENNA__3415__X Tile_X0Y4_FrameData_O[6] VPWR VGND sg13cmos5l_antennanp
XFILLER_173_56 VPWR VGND sg13cmos5l_decap_8
XFILLER_639_182 VPWR VGND sg13cmos5l_decap_8
XFILLER_249_144 VPWR VGND sg13cmos5l_decap_8
XFILLER_470_21 VPWR VGND sg13cmos5l_decap_8
XFILLER_249_155 VPWR VGND sg13cmos5l_fill_1
XFILLER_249_177 VPWR VGND sg13cmos5l_decap_8
XFILLER_453_214 VPWR VGND sg13cmos5l_decap_8
XFILLER_106_94 VPWR VGND sg13cmos5l_decap_8
XFILLER_453_225 VPWR VGND sg13cmos5l_decap_4
XFILLER_654_196 VPWR VGND sg13cmos5l_decap_8
XFILLER_66_87 VPWR VGND sg13cmos5l_decap_8
XFILLER_620_35 VPWR VGND sg13cmos5l_decap_8
XFILLER_403_70 VPWR VGND sg13cmos5l_decap_8
XFILLER_406_141 VPWR VGND sg13cmos5l_fill_1
XFILLER_174_0 VPWR VGND sg13cmos5l_decap_8
XFILLER_406_163 VPWR VGND sg13cmos5l_decap_8
XANTENNA__3150__X Tile_X0Y7_FrameData_O[20] VPWR VGND sg13cmos5l_antennanp
XFILLER_272_180 VPWR VGND sg13cmos5l_fill_1
XFILLER_421_133 VPWR VGND sg13cmos5l_decap_8
XFILLER_82_42 VPWR VGND sg13cmos5l_decap_8
XFILLER_696_28 VPWR VGND sg13cmos5l_decap_8
XFILLER_567_126 VPWR VGND sg13cmos5l_decap_8
XFILLER_479_63 VPWR VGND sg13cmos5l_decap_8
XFILLER_341_0 VPWR VGND sg13cmos5l_decap_8
XFILLER_439_0 VPWR VGND sg13cmos5l_decap_8
XFILLER_198_42 VPWR VGND sg13cmos5l_decap_8
XFILLER_220_228 VPWR VGND sg13cmos5l_fill_1
XFILLER_319_115 VPWR VGND sg13cmos5l_decap_4
XFILLER_709_175 VPWR VGND sg13cmos5l_decap_8
XFILLER_629_77 VPWR VGND sg13cmos5l_decap_8
XFILLER_15_91 VPWR VGND sg13cmos5l_decap_8
XFILLER_606_0 VPWR VGND sg13cmos5l_decap_8
XFILLER_348_56 VPWR VGND sg13cmos5l_decap_8
XFILLER_495_84 VPWR VGND sg13cmos5l_decap_8
XFILLER_645_21 VPWR VGND sg13cmos5l_decap_8
XFILLER_63_7 VPWR VGND sg13cmos5l_decap_8
XFILLER_327_192 VPWR VGND sg13cmos5l_fill_1
X_1500_ _1500_/Q Tile_X0Y2_FrameData[21] VGND VPWR Tile_X0Y9_FrameStrobe[2] latch
XFILLER_99_105 VPWR VGND sg13cmos5l_decap_8
XFILLER_488_133 VPWR VGND sg13cmos5l_decap_4
X_2480_ _2480_/Q Tile_X0Y6_FrameData[23] VGND VPWR Tile_X0Y9_FrameStrobe[1] latch
XFILLER_645_98 VPWR VGND sg13cmos5l_decap_8
XFILLER_342_151 VPWR VGND sg13cmos5l_fill_1
XFILLER_217_49 VPWR VGND sg13cmos5l_decap_8
XFILLER_342_173 VPWR VGND sg13cmos5l_decap_8
XFILLER_488_166 VPWR VGND sg13cmos5l_fill_2
XFILLER_342_184 VPWR VGND sg13cmos5l_fill_2
XFILLER_141_224 VPWR VGND sg13cmos5l_decap_4
X_1431_ _1431_/Q Tile_X0Y2_FrameData[26] VGND VPWR Tile_X0Y9_FrameStrobe[0] latch
XFILLER_364_77 VPWR VGND sg13cmos5l_decap_8
XFILLER_514_14 VPWR VGND sg13cmos5l_decap_8
XFILLER_692_214 VPWR VGND sg13cmos5l_fill_2
XFILLER_637_119 VPWR VGND sg13cmos5l_decap_8
XANTENNA__3325__X Tile_X0Y4_EE4BEG[13] VPWR VGND sg13cmos5l_antennanp
XFILLER_661_42 VPWR VGND sg13cmos5l_decap_8
X_4150_ _4150_/X Tile_X0Y3_W2MID[5] AXI_M_SOC_WREADY _4209_/X _4208_/X _1841_/Q _1840_/Q
+ VPWR VGND sg13cmos5l_mux4_1
X_1362_ _1362_/Q Tile_X0Y1_FrameData[7] VGND VPWR Tile_X0Y9_FrameStrobe[5] latch
XFILLER_380_21 VPWR VGND sg13cmos5l_decap_8
X_3101_ Tile_X0Y7_E2BEGb[7] _4627_/X VPWR VGND sg13cmos5l_buf_1
X_0313_ _0313_/Q Tile_X0Y7_FrameData[6] VGND VPWR Tile_X0Y9_FrameStrobe[4] latch
X_4081_ _4081_/X AXI_M_SOC_AWREADY _4118_/X _4122_/X _4100_/X _1511_/Q _1510_/Q VPWR
+ VGND sg13cmos5l_mux4_1
X_1293_ _1293_/Q Tile_X0Y1_FrameData[12] VGND VPWR Tile_X0Y9_FrameStrobe[3] latch
X_3032_ Tile_X0Y5_EE4BEG[7] _4395_/X VPWR VGND sg13cmos5l_buf_1
XFILLER_645_196 VPWR VGND sg13cmos5l_decap_8
X_0244_ _0244_/Q Tile_X0Y7_FrameData[11] VGND VPWR Tile_X0Y9_FrameStrobe[2] latch
XFILLER_530_35 VPWR VGND sg13cmos5l_decap_8
XFILLER_313_70 VPWR VGND sg13cmos5l_decap_8
XANTENNA__3060__X Tile_X0Y5_FrameData_O[19] VPWR VGND sg13cmos5l_antennanp
X_0175_ _0175_/Q Tile_X0Y7_FrameData[16] VGND VPWR Tile_X0Y9_FrameStrobe[0] latch
XFILLER_23_149 VPWR VGND sg13cmos5l_decap_4
XFILLER_211_228 VPWR VGND sg13cmos5l_fill_1
X_3934_ _3934_/X Tile_X0Y1_W2MID[5] AXI_M_SOC_ARREADY _3993_/X _3992_/X _1341_/Q _1340_/Q
+ VPWR VGND sg13cmos5l_mux4_1
XFILLER_412_199 VPWR VGND sg13cmos5l_decap_8
XFILLER_176_110 VPWR VGND sg13cmos5l_decap_4
XFILLER_539_77 VPWR VGND sg13cmos5l_decap_8
XFILLER_31_160 VPWR VGND sg13cmos5l_decap_8
X_3865_ _3865_/X Tile_X0Y4_W1END[0] Tile_X0Y4_WW4END[0] Tile_X0Y4_W6END[8] _4336_/X
+ _2157_/Q _2156_/Q VPWR VGND sg13cmos5l_mux4_1
XFILLER_539_88 VPWR VGND sg13cmos5l_fill_2
XFILLER_258_56 VPWR VGND sg13cmos5l_decap_8
X_2816_ Tile_X0Y3_E2BEG[6] _4154_/X VPWR VGND sg13cmos5l_buf_1
XFILLER_581_140 VPWR VGND sg13cmos5l_decap_8
X_3796_ _3796_/X Tile_X0Y0_W1END[2] Tile_X0Y0_WW4END[2] Tile_X0Y0_W6END[10] _3883_/X
+ _1147_/Q _1146_/Q VPWR VGND sg13cmos5l_mux4_1
XFILLER_715_167 VPWR VGND sg13cmos5l_decap_8
XFILLER_555_21 VPWR VGND sg13cmos5l_decap_8
X_2747_ Tile_X0Y3_FrameData_O[5] Tile_X0Y3_FrameData[5] VPWR VGND sg13cmos5l_buf_1
XFILLER_11_49 VPWR VGND sg13cmos5l_decap_8
XFILLER_555_98 VPWR VGND sg13cmos5l_decap_8
X_2678_ _2678_/Q Tile_X0Y6_FrameData[17] VGND VPWR Tile_X0Y9_FrameStrobe[7] latch
XFILLER_127_49 VPWR VGND sg13cmos5l_decap_8
XFILLER_705_35 VPWR VGND sg13cmos5l_decap_8
X_4417_ _4417_/X Tile_X0Y4_W1END[0] Tile_X0Y4_W6END[8] _4348_/X _4300_/X _2145_/Q
+ _2144_/Q VPWR VGND sg13cmos5l_mux4_1
XFILLER_274_77 VPWR VGND sg13cmos5l_decap_8
X_1629_ _1629_/Q Tile_X0Y2_FrameData[20] VGND VPWR Tile_X0Y9_FrameStrobe[6] latch
XFILLER_424_14 VPWR VGND sg13cmos5l_decap_8
XANTENNA__3235__X Tile_X0Y0_FrameData_O[3] VPWR VGND sg13cmos5l_antennanp
XFILLER_571_42 VPWR VGND sg13cmos5l_decap_8
XFILLER_494_147 VPWR VGND sg13cmos5l_decap_8
XFILLER_98_160 VPWR VGND sg13cmos5l_fill_1
X_4348_ _4348_/X _4302_/X _0099_/X _4301_/X _0112_/X _1957_/Q _1956_/Q VPWR VGND sg13cmos5l_mux4_1
XFILLER_290_21 VPWR VGND sg13cmos5l_decap_8
X_4279_ _4279_/X Tile_X0Y4_WW4END[8] AXI_M_SOC_BRESP1 _4344_/X _4313_/X _2055_/Q _2054_/Q
+ VPWR VGND sg13cmos5l_mux4_1
XFILLER_100_154 VPWR VGND sg13cmos5l_decap_8
XFILLER_504_91 VPWR VGND sg13cmos5l_decap_8
XFILLER_651_133 VPWR VGND sg13cmos5l_decap_8
XFILLER_290_98 VPWR VGND sg13cmos5l_decap_8
XFILLER_440_35 VPWR VGND sg13cmos5l_decap_8
XFILLER_36_13 VPWR VGND sg13cmos5l_decap_8
XFILLER_223_70 VPWR VGND sg13cmos5l_decap_8
XFILLER_265_7 VPWR VGND sg13cmos5l_decap_8
XFILLER_36_79 VPWR VGND sg13cmos5l_decap_8
XFILLER_299_63 VPWR VGND sg13cmos5l_decap_8
XFILLER_202_217 VPWR VGND sg13cmos5l_fill_2
XFILLER_432_7 VPWR VGND sg13cmos5l_decap_8
XFILLER_202_228 VPWR VGND sg13cmos5l_fill_1
XFILLER_403_199 VPWR VGND sg13cmos5l_decap_8
XFILLER_52_45 VPWR VGND sg13cmos5l_decap_8
XFILLER_356_210 VPWR VGND sg13cmos5l_decap_8
XFILLER_449_77 VPWR VGND sg13cmos5l_decap_4
XFILLER_706_112 VPWR VGND sg13cmos5l_decap_8
XFILLER_449_88 VPWR VGND sg13cmos5l_decap_8
XFILLER_167_143 VPWR VGND sg13cmos5l_fill_2
XFILLER_168_56 VPWR VGND sg13cmos5l_decap_8
XFILLER_572_140 VPWR VGND sg13cmos5l_decap_8
XFILLER_465_21 VPWR VGND sg13cmos5l_decap_8
XFILLER_182_113 VPWR VGND sg13cmos5l_decap_8
XFILLER_108_210 VPWR VGND sg13cmos5l_fill_1
XFILLER_659_211 VPWR VGND sg13cmos5l_fill_2
XFILLER_615_35 VPWR VGND sg13cmos5l_decap_8
XFILLER_324_173 VPWR VGND sg13cmos5l_decap_8
XFILLER_123_224 VPWR VGND sg13cmos5l_decap_4
XFILLER_190_190 VPWR VGND sg13cmos5l_decap_8
XFILLER_334_14 VPWR VGND sg13cmos5l_decap_8
XANTENNA__3145__X Tile_X0Y7_FrameData_O[15] VPWR VGND sg13cmos5l_antennanp
XFILLER_674_214 VPWR VGND sg13cmos5l_fill_2
XFILLER_184_99 VPWR VGND sg13cmos5l_decap_8
XFILLER_481_42 VPWR VGND sg13cmos5l_decap_8
XFILLER_77_42 VPWR VGND sg13cmos5l_decap_8
XFILLER_89_182 VPWR VGND sg13cmos5l_decap_4
XFILLER_291_0 VPWR VGND sg13cmos5l_decap_8
XFILLER_89_193 VPWR VGND sg13cmos5l_decap_4
XANTENNA__2984__X Tile_X0Y8_FrameData_O[24] VPWR VGND sg13cmos5l_antennanp
XFILLER_426_203 VPWR VGND sg13cmos5l_decap_8
XFILLER_389_0 VPWR VGND sg13cmos5l_decap_8
XFILLER_631_56 VPWR VGND sg13cmos5l_decap_8
XFILLER_414_91 VPWR VGND sg13cmos5l_decap_8
XFILLER_642_133 VPWR VGND sg13cmos5l_decap_8
XFILLER_350_35 VPWR VGND sg13cmos5l_decap_8
XFILLER_133_70 VPWR VGND sg13cmos5l_decap_8
XFILLER_556_0 VPWR VGND sg13cmos5l_decap_8
XFILLER_441_228 VPWR VGND sg13cmos5l_fill_1
XFILLER_245_180 VPWR VGND sg13cmos5l_fill_1
XFILLER_500_49 VPWR VGND sg13cmos5l_decap_8
XFILLER_260_172 VPWR VGND sg13cmos5l_fill_2
X_1980_ _1980_/Q Tile_X0Y4_FrameData[9] VGND VPWR Tile_X0Y9_FrameStrobe[1] latch
X_0931_ _0931_/Q Tile_X0Y9_FrameData[22] VGND VPWR Tile_X0Y9_FrameStrobe[8] latch
XFILLER_359_77 VPWR VGND sg13cmos5l_decap_8
XFILLER_347_221 VPWR VGND sg13cmos5l_fill_1
XFILLER_158_121 VPWR VGND sg13cmos5l_fill_1
XFILLER_509_14 VPWR VGND sg13cmos5l_decap_8
XFILLER_13_171 VPWR VGND sg13cmos5l_fill_1
XFILLER_548_192 VPWR VGND sg13cmos5l_decap_8
XFILLER_656_42 VPWR VGND sg13cmos5l_decap_8
X_3650_ AXI_M_SOC_AWADDR11 Tile_X0Y5_WW4END[3] Tile_X0Y5_WW4END[11] Tile_X0Y5_W6END[11]
+ _4462_/X _2249_/Q _2248_/Q VPWR VGND sg13cmos5l_mux4_1
X_0862_ _0862_/Q Tile_X0Y9_FrameData[1] VGND VPWR Tile_X0Y9_FrameStrobe[5] latch
XFILLER_375_21 VPWR VGND sg13cmos5l_decap_8
XFILLER_362_213 VPWR VGND sg13cmos5l_decap_4
XFILLER_173_124 VPWR VGND sg13cmos5l_fill_2
X_2601_ _2601_/Q Tile_X0Y6_FrameData[30] VGND VPWR Tile_X0Y9_FrameStrobe[5] latch
XFILLER_712_126 VPWR VGND sg13cmos5l_decap_8
X_3581_ Tile_X0Y9_FrameData_O[11] Tile_X0Y9_FrameData[11] VPWR VGND sg13cmos5l_buf_1
X_0793_ _0793_/Q Tile_X0Y9_FrameData[6] VGND VPWR Tile_X0Y9_FrameStrobe[3] latch
X_2532_ _2532_/Q Tile_X0Y6_FrameData[3] VGND VPWR Tile_X0Y9_FrameStrobe[2] latch
XFILLER_114_213 VPWR VGND sg13cmos5l_decap_8
XFILLER_525_35 VPWR VGND sg13cmos5l_decap_8
XFILLER_308_70 VPWR VGND sg13cmos5l_decap_4
XFILLER_672_63 VPWR VGND sg13cmos5l_decap_8
X_2463_ _2463_/Q Tile_X0Y6_FrameData[8] VGND VPWR Tile_X0Y9_FrameStrobe[0] latch
XFILLER_244_14 VPWR VGND sg13cmos5l_decap_8
XANTENNA__3055__X Tile_X0Y5_FrameData_O[14] VPWR VGND sg13cmos5l_antennanp
X_4202_ _4202_/X Tile_X0Y2_W1END[3] Tile_X0Y2_W6END[11] _4104_/X _4087_/X _1631_/Q
+ _1630_/Q VPWR VGND sg13cmos5l_mux4_1
XFILLER_391_42 VPWR VGND sg13cmos5l_decap_8
X_1414_ _1414_/Q Tile_X0Y1_FrameData[19] VGND VPWR Tile_X0Y9_FrameStrobe[7] latch
X_2394_ _2394_/Q Tile_X0Y5_FrameData[11] VGND VPWR Tile_X0Y9_FrameStrobe[6] latch
XFILLER_330_198 VPWR VGND sg13cmos5l_decap_8
XANTENNA__2894__X Tile_X0Y6_FrameData_O[15] VPWR VGND sg13cmos5l_antennanp
X_4133_ _4133_/X Tile_X0Y4_W2MID[5] Tile_X0Y4_W2END[5] Tile_X0Y4_W6END[5] _4317_/X
+ _2169_/Q _2168_/Q VPWR VGND sg13cmos5l_mux4_1
X_1345_ _1345_/Q Tile_X0Y1_FrameData[24] VGND VPWR Tile_X0Y9_FrameStrobe[5] latch
XFILLER_618_163 VPWR VGND sg13cmos5l_fill_2
XFILLER_541_56 VPWR VGND sg13cmos5l_decap_8
X_4064_ _4064_/X Tile_X0Y2_WW4END[7] AXI_M_SOC_AWREADY _4123_/X _4096_/X _1545_/Q
+ _1544_/Q VPWR VGND sg13cmos5l_mux4_1
X_1276_ _1276_/Q Tile_X0Y1_FrameData[29] VGND VPWR Tile_X0Y9_FrameStrobe[3] latch
XFILLER_260_35 VPWR VGND sg13cmos5l_decap_8
XFILLER_228_169 VPWR VGND sg13cmos5l_fill_1
X_3015_ Tile_X0Y5_E6BEG[2] _4406_/X VPWR VGND sg13cmos5l_buf_1
X_0227_ _0227_/Q Tile_X0Y7_FrameData[28] VGND VPWR Tile_X0Y9_FrameStrobe[2] latch
XFILLER_432_228 VPWR VGND sg13cmos5l_fill_1
XFILLER_243_139 VPWR VGND sg13cmos5l_decap_8
XFILLER_586_210 VPWR VGND sg13cmos5l_decap_8
X_0158_ _0158_/X _4326_/X _4327_/X _0642_/Q VPWR VGND sg13cmos5l_mux2_1
XFILLER_586_221 VPWR VGND sg13cmos5l_fill_1
XFILLER_410_49 VPWR VGND sg13cmos5l_decap_8
XFILLER_251_161 VPWR VGND sg13cmos5l_decap_4
XFILLER_397_154 VPWR VGND sg13cmos5l_fill_1
XFILLER_397_176 VPWR VGND sg13cmos5l_decap_8
X_0089_ _0089_/X _4213_/X _4214_/X _0389_/Q VPWR VGND sg13cmos5l_mux2_1
XFILLER_338_221 VPWR VGND sg13cmos5l_decap_8
XFILLER_269_77 VPWR VGND sg13cmos5l_decap_8
X_3917_ _3917_/X _4121_/X _4125_/X _4110_/X _4099_/X _1646_/Q _1645_/Q VPWR VGND sg13cmos5l_mux4_1
XFILLER_419_14 VPWR VGND sg13cmos5l_decap_8
X_4897_ _4897_/X Tile_X0Y8_W1END[1] Tile_X0Y8_W6END[9] _4813_/X _4773_/X _0633_/Q
+ _0632_/Q VPWR VGND sg13cmos5l_mux4_1
XFILLER_566_42 VPWR VGND sg13cmos5l_decap_8
XFILLER_149_154 VPWR VGND sg13cmos5l_decap_8
X_3848_ _3848_/X Tile_X0Y1_W1END[0] Tile_X0Y1_W6END[4] _4005_/X _3976_/X _1425_/Q
+ _1424_/Q VPWR VGND sg13cmos5l_mux4_1
XFILLER_285_21 VPWR VGND sg13cmos5l_decap_8
XFILLER_149_198 VPWR VGND sg13cmos5l_decap_4
XFILLER_703_126 VPWR VGND sg13cmos5l_fill_2
X_3779_ AXI_M_SOC_RREADY Tile_X0Y5_W2MID[0] Tile_X0Y5_W2END[0] Tile_X0Y5_W6END[0]
+ _4467_/X _2239_/Q _2238_/Q VPWR VGND sg13cmos5l_mux4_1
XFILLER_285_98 VPWR VGND sg13cmos5l_decap_8
XFILLER_435_35 VPWR VGND sg13cmos5l_decap_8
XFILLER_218_70 VPWR VGND sg13cmos5l_decap_8
XFILLER_306_184 VPWR VGND sg13cmos5l_fill_1
XFILLER_582_63 VPWR VGND sg13cmos5l_decap_8
XFILLER_510_221 VPWR VGND sg13cmos5l_fill_1
XFILLER_154_14 VPWR VGND sg13cmos5l_decap_8
XFILLER_467_125 VPWR VGND sg13cmos5l_decap_8
XFILLER_78_119 VPWR VGND sg13cmos5l_fill_2
XFILLER_120_227 VPWR VGND sg13cmos5l_fill_2
XFILLER_321_187 VPWR VGND sg13cmos5l_decap_8
XFILLER_671_206 VPWR VGND sg13cmos5l_decap_4
XANTENNA__0101__Y AXI_M_SOC_ARLEN6 VPWR VGND sg13cmos5l_antennanp
XFILLER_382_7 VPWR VGND sg13cmos5l_decap_8
XFILLER_304_28 VPWR VGND sg13cmos5l_decap_8
XFILLER_609_174 VPWR VGND sg13cmos5l_decap_8
XFILLER_451_56 VPWR VGND sg13cmos5l_decap_8
XFILLER_47_45 VPWR VGND sg13cmos5l_decap_8
XFILLER_170_35 VPWR VGND sg13cmos5l_decap_8
XFILLER_647_7 VPWR VGND sg13cmos5l_decap_8
XFILLER_490_183 VPWR VGND sg13cmos5l_decap_4
XFILLER_423_228 VPWR VGND sg13cmos5l_fill_1
XFILLER_577_221 VPWR VGND sg13cmos5l_fill_1
XFILLER_320_49 VPWR VGND sg13cmos5l_decap_8
XFILLER_103_84 VPWR VGND sg13cmos5l_decap_8
XFILLER_242_194 VPWR VGND sg13cmos5l_decap_8
XFILLER_8_28 VPWR VGND sg13cmos5l_decap_8
XFILLER_329_14 VPWR VGND sg13cmos5l_decap_8
XFILLER_137_0 VPWR VGND sg13cmos5l_decap_8
XFILLER_476_42 VPWR VGND sg13cmos5l_decap_8
XFILLER_195_21 VPWR VGND sg13cmos5l_decap_8
XANTENNA__2979__X Tile_X0Y8_FrameData_O[19] VPWR VGND sg13cmos5l_antennanp
XFILLER_476_97 VPWR VGND sg13cmos5l_decap_8
XFILLER_6_134 VPWR VGND sg13cmos5l_decap_4
XFILLER_560_132 VPWR VGND sg13cmos5l_decap_4
XFILLER_560_143 VPWR VGND sg13cmos5l_decap_8
XFILLER_304_0 VPWR VGND sg13cmos5l_decap_8
XFILLER_626_56 VPWR VGND sg13cmos5l_decap_8
XFILLER_12_70 VPWR VGND sg13cmos5l_decap_8
XFILLER_170_116 VPWR VGND sg13cmos5l_decap_4
XFILLER_345_35 VPWR VGND sg13cmos5l_decap_8
XFILLER_128_70 VPWR VGND sg13cmos5l_decap_8
XFILLER_702_170 VPWR VGND sg13cmos5l_fill_1
XFILLER_647_203 VPWR VGND sg13cmos5l_decap_8
XFILLER_501_210 VPWR VGND sg13cmos5l_decap_8
XFILLER_492_63 VPWR VGND sg13cmos5l_decap_8
XFILLER_458_103 VPWR VGND sg13cmos5l_decap_4
XFILLER_163_190 VPWR VGND sg13cmos5l_fill_2
XFILLER_312_132 VPWR VGND sg13cmos5l_decap_4
XFILLER_88_63 VPWR VGND sg13cmos5l_decap_4
XFILLER_69_119 VPWR VGND sg13cmos5l_decap_8
XFILLER_673_0 VPWR VGND sg13cmos5l_decap_8
XFILLER_642_77 VPWR VGND sg13cmos5l_decap_8
XFILLER_214_28 VPWR VGND sg13cmos5l_decap_8
XFILLER_26_7 VPWR VGND sg13cmos5l_decap_8
XFILLER_361_56 VPWR VGND sg13cmos5l_decap_8
XANTENNA__3603__X Tile_X0Y9_S1BEG[1] VPWR VGND sg13cmos5l_antennanp
XFILLER_144_91 VPWR VGND sg13cmos5l_decap_8
X_1130_ _1130_/Q Tile_X0Y0_FrameData[1] VGND VPWR Tile_X0Y9_FrameStrobe[5] latch
XFILLER_225_117 VPWR VGND sg13cmos5l_decap_8
X_1061_ _1061_/Q Tile_X0Y0_FrameData[6] VGND VPWR Tile_X0Y9_FrameStrobe[3] latch
XFILLER_230_49 VPWR VGND sg13cmos5l_decap_8
XFILLER_379_143 VPWR VGND sg13cmos5l_decap_4
X_4820_ _4820_/X Tile_X0Y7_W1END[0] Tile_X0Y7_W2MID[3] Tile_X0Y7_W2END[3] _4674_/X
+ _0363_/Q _0362_/Q VPWR VGND sg13cmos5l_mux4_1
XFILLER_394_113 VPWR VGND sg13cmos5l_decap_8
XFILLER_717_218 VPWR VGND sg13cmos5l_decap_8
X_1963_ _1963_/Q Tile_X0Y4_FrameData[26] VGND VPWR Tile_X0Y9_FrameStrobe[1] latch
X_4751_ _4751_/X Tile_X0Y8_WW4END[8] AXI_M_SOC_RDATA15 _4808_/X _4785_/X _0545_/Q
+ _0544_/Q VPWR VGND sg13cmos5l_mux4_1
XFILLER_667_63 VPWR VGND sg13cmos5l_decap_8
XFILLER_239_14 VPWR VGND sg13cmos5l_decap_8
XFILLER_386_42 VPWR VGND sg13cmos5l_decap_8
X_0914_ _0914_/Q Tile_X0Y9_FrameData[13] VGND VPWR Tile_X0Y9_FrameStrobe[7] latch
X_3702_ AXI_M_SOC_WDATA12 Tile_X0Y7_W1END[0] Tile_X0Y7_WW4END[4] Tile_X0Y7_WW4END[12]
+ _4696_/X _0223_/Q _0222_/Q VPWR VGND sg13cmos5l_mux4_1
X_4682_ _4682_/X Tile_X0Y3_W1END[3] Tile_X0Y3_WW4END[15] Tile_X0Y3_W6END[7] _4225_/X
+ _1856_/Q _1855_/Q VPWR VGND sg13cmos5l_mux4_1
X_1894_ _1894_/Q Tile_X0Y3_FrameData[3] VGND VPWR Tile_X0Y9_FrameStrobe[6] latch
X_3633_ Tile_X0Y9_S4BEG[11] _3633_/A VPWR VGND sg13cmos5l_buf_1
XANTENNA__2889__X Tile_X0Y6_FrameData_O[10] VPWR VGND sg13cmos5l_antennanp
X_0845_ _0845_/Q Tile_X0Y9_FrameData[18] VGND VPWR Tile_X0Y9_FrameStrobe[5] latch
XFILLER_536_56 VPWR VGND sg13cmos5l_decap_8
X_3564_ Tile_X0Y9_EE4BEG[10] _4874_/X VPWR VGND sg13cmos5l_buf_1
X_0776_ _0776_/Q Tile_X0Y9_FrameData[23] VGND VPWR Tile_X0Y9_FrameStrobe[3] latch
XFILLER_700_107 VPWR VGND sg13cmos5l_decap_8
XFILLER_683_84 VPWR VGND sg13cmos5l_decap_8
XFILLER_255_35 VPWR VGND sg13cmos5l_decap_8
XFILLER_52_0 VPWR VGND sg13cmos5l_fill_2
X_2515_ _2515_/Q Tile_X0Y6_FrameData[20] VGND VPWR Tile_X0Y9_FrameStrobe[2] latch
X_3495_ Tile_X0Y1_E6BEG[5] _3969_/X VPWR VGND sg13cmos5l_buf_1
X_2446_ _2446_/Q Tile_X0Y6_FrameData[25] VGND VPWR Tile_X0Y9_FrameStrobe[0] latch
XFILLER_405_49 VPWR VGND sg13cmos5l_decap_8
XFILLER_102_227 VPWR VGND sg13cmos5l_fill_2
XFILLER_552_77 VPWR VGND sg13cmos5l_decap_8
XFILLER_464_117 VPWR VGND sg13cmos5l_decap_8
XFILLER_653_217 VPWR VGND sg13cmos5l_fill_1
X_2377_ _2377_/Q Tile_X0Y5_FrameData[28] VGND VPWR Tile_X0Y9_FrameStrobe[6] latch
XFILLER_702_14 VPWR VGND sg13cmos5l_decap_8
XFILLER_702_25 VPWR VGND sg13cmos5l_fill_2
XFILLER_457_180 VPWR VGND sg13cmos5l_decap_8
XANTENNA__3513__X Tile_X0Y1_E2BEG[3] VPWR VGND sg13cmos5l_antennanp
XFILLER_68_163 VPWR VGND sg13cmos5l_decap_8
XFILLER_271_56 VPWR VGND sg13cmos5l_decap_8
X_4116_ _4116_/X _4089_/X _0079_/X _4088_/X Tile_X0Y0_S4END[8] _1481_/Q _1480_/Q VPWR
+ VGND sg13cmos5l_mux4_1
X_1328_ _1328_/Q Tile_X0Y1_FrameData[9] VGND VPWR Tile_X0Y9_FrameStrobe[4] latch
XFILLER_405_217 VPWR VGND sg13cmos5l_decap_8
X_4047_ _4047_/X Tile_X0Y2_W2MID[0] AXI_M_SOC_AWREADY _4097_/X _4096_/X _1579_/Q _1578_/Q
+ VPWR VGND sg13cmos5l_mux4_1
XFILLER_405_228 VPWR VGND sg13cmos5l_fill_1
X_1259_ _1259_/Q Tile_X0Y1_FrameData[14] VGND VPWR Tile_X0Y9_FrameStrobe[2] latch
XFILLER_606_188 VPWR VGND sg13cmos5l_decap_8
XFILLER_559_210 VPWR VGND sg13cmos5l_fill_2
XFILLER_140_49 VPWR VGND sg13cmos5l_decap_8
XFILLER_501_70 VPWR VGND sg13cmos5l_decap_8
XFILLER_169_205 VPWR VGND sg13cmos5l_decap_8
XFILLER_574_224 VPWR VGND sg13cmos5l_decap_4
XFILLER_577_63 VPWR VGND sg13cmos5l_decap_8
XFILLER_149_14 VPWR VGND sg13cmos5l_decap_8
XFILLER_296_42 VPWR VGND sg13cmos5l_decap_8
XFILLER_130_7 VPWR VGND sg13cmos5l_decap_8
XFILLER_228_7 VPWR VGND sg13cmos5l_decap_8
XANTENNA__2799__X Tile_X0Y3_E6BEG[9] VPWR VGND sg13cmos5l_antennanp
XFILLER_542_121 VPWR VGND sg13cmos5l_fill_2
XFILLER_527_195 VPWR VGND sg13cmos5l_decap_4
XFILLER_137_168 VPWR VGND sg13cmos5l_decap_8
XFILLER_446_56 VPWR VGND sg13cmos5l_decap_8
XFILLER_688_147 VPWR VGND sg13cmos5l_fill_1
XFILLER_593_84 VPWR VGND sg13cmos5l_decap_8
XFILLER_341_216 VPWR VGND sg13cmos5l_fill_2
XFILLER_152_127 VPWR VGND sg13cmos5l_fill_2
XFILLER_3_115 VPWR VGND sg13cmos5l_decap_8
XFILLER_341_227 VPWR VGND sg13cmos5l_fill_2
XFILLER_165_35 VPWR VGND sg13cmos5l_decap_8
XFILLER_629_225 VPWR VGND sg13cmos5l_decap_4
XFILLER_597_7 VPWR VGND sg13cmos5l_decap_8
XFILLER_696_191 VPWR VGND sg13cmos5l_fill_1
XFILLER_315_49 VPWR VGND sg13cmos5l_decap_8
XFILLER_644_217 VPWR VGND sg13cmos5l_fill_2
XFILLER_644_228 VPWR VGND sg13cmos5l_fill_1
XFILLER_612_14 VPWR VGND sg13cmos5l_decap_8
XFILLER_58_66 VPWR VGND sg13cmos5l_decap_8
XFILLER_462_88 VPWR VGND sg13cmos5l_fill_1
XFILLER_247_220 VPWR VGND sg13cmos5l_fill_2
XFILLER_181_56 VPWR VGND sg13cmos5l_decap_8
XANTENNA__3423__X Tile_X0Y4_FrameData_O[14] VPWR VGND sg13cmos5l_antennanp
XFILLER_181_67 VPWR VGND sg13cmos5l_fill_2
XFILLER_59_174 VPWR VGND sg13cmos5l_decap_8
XFILLER_74_21 VPWR VGND sg13cmos5l_decap_8
XFILLER_74_98 VPWR VGND sg13cmos5l_decap_8
XFILLER_411_70 VPWR VGND sg13cmos5l_decap_8
XFILLER_254_0 VPWR VGND sg13cmos5l_decap_8
XFILLER_620_191 VPWR VGND sg13cmos5l_decap_4
XFILLER_90_42 VPWR VGND sg13cmos5l_decap_8
XFILLER_487_63 VPWR VGND sg13cmos5l_decap_8
XFILLER_90_53 VPWR VGND sg13cmos5l_fill_2
XFILLER_421_0 VPWR VGND sg13cmos5l_decap_8
XFILLER_519_0 VPWR VGND sg13cmos5l_decap_8
XFILLER_90_97 VPWR VGND sg13cmos5l_decap_8
XFILLER_391_116 VPWR VGND sg13cmos5l_fill_1
XFILLER_317_202 VPWR VGND sg13cmos5l_decap_8
XFILLER_391_138 VPWR VGND sg13cmos5l_fill_2
XFILLER_637_77 VPWR VGND sg13cmos5l_decap_8
XFILLER_23_91 VPWR VGND sg13cmos5l_fill_1
XFILLER_209_28 VPWR VGND sg13cmos5l_decap_8
XFILLER_356_56 VPWR VGND sg13cmos5l_decap_8
XFILLER_143_105 VPWR VGND sg13cmos5l_decap_8
XFILLER_139_91 VPWR VGND sg13cmos5l_decap_8
X_0630_ _0630_/Q Tile_X0Y8_FrameData[9] VGND VPWR Tile_X0Y9_FrameStrobe[6] latch
XFILLER_533_165 VPWR VGND sg13cmos5l_fill_1
XFILLER_653_21 VPWR VGND sg13cmos5l_decap_8
XFILLER_99_84 VPWR VGND sg13cmos5l_decap_8
X_0561_ _0561_/Q Tile_X0Y8_FrameData[14] VGND VPWR Tile_X0Y9_FrameStrobe[4] latch
XFILLER_687_180 VPWR VGND sg13cmos5l_fill_2
X_2300_ _2300_/Q Tile_X0Y5_FrameData[9] VGND VPWR Tile_X0Y9_FrameStrobe[3] latch
XFILLER_297_142 VPWR VGND sg13cmos5l_decap_4
XFILLER_97_225 VPWR VGND sg13cmos5l_decap_4
X_3280_ Tile_X0Y0_E6BEG[0] _3836_/X VPWR VGND sg13cmos5l_buf_1
XFILLER_653_98 VPWR VGND sg13cmos5l_decap_8
XFILLER_297_153 VPWR VGND sg13cmos5l_decap_8
XFILLER_151_171 VPWR VGND sg13cmos5l_decap_8
X_0492_ _0492_/Q Tile_X0Y8_FrameData[19] VGND VPWR Tile_X0Y9_FrameStrobe[2] latch
XFILLER_225_49 VPWR VGND sg13cmos5l_decap_8
X_2231_ _2231_/Q Tile_X0Y5_FrameData[14] VGND VPWR Tile_X0Y9_FrameStrobe[1] latch
XFILLER_372_77 VPWR VGND sg13cmos5l_decap_8
XFILLER_522_14 VPWR VGND sg13cmos5l_decap_8
XANTENNA__3333__X Tile_X0Y2_FrameData_O[4] VPWR VGND sg13cmos5l_antennanp
X_2162_ _2162_/Q Tile_X0Y4_FrameData[19] VGND VPWR Tile_X0Y9_FrameStrobe[7] latch
X_1113_ _1113_/Q Tile_X0Y0_FrameData[18] VGND VPWR Tile_X0Y9_FrameStrobe[5] latch
XFILLER_253_212 VPWR VGND sg13cmos5l_fill_1
XFILLER_65_155 VPWR VGND sg13cmos5l_decap_8
X_2093_ _2093_/Q Tile_X0Y4_FrameData[24] VGND VPWR Tile_X0Y9_FrameStrobe[5] latch
XFILLER_399_216 VPWR VGND sg13cmos5l_decap_8
XFILLER_399_227 VPWR VGND sg13cmos5l_fill_2
XFILLER_602_91 VPWR VGND sg13cmos5l_decap_8
X_1044_ _1044_/Q Tile_X0Y0_FrameData[23] VGND VPWR Tile_X0Y9_FrameStrobe[3] latch
XFILLER_603_169 VPWR VGND sg13cmos5l_fill_2
XFILLER_321_70 VPWR VGND sg13cmos5l_decap_8
XFILLER_0_84 VPWR VGND sg13cmos5l_decap_4
XFILLER_80_147 VPWR VGND sg13cmos5l_decap_8
XFILLER_206_161 VPWR VGND sg13cmos5l_decap_8
XFILLER_678_84 VPWR VGND sg13cmos5l_decap_8
XFILLER_410_220 VPWR VGND sg13cmos5l_decap_8
XFILLER_556_224 VPWR VGND sg13cmos5l_decap_4
X_4803_ _4803_/X _4783_/X Tile_X0Y9_N4END[7] _4782_/X _0074_/X _0465_/Q _0464_/Q VPWR
+ VGND sg13cmos5l_mux4_1
XFILLER_397_63 VPWR VGND sg13cmos5l_decap_8
X_2995_ Tile_X0Y5_E1BEG[2] _4370_/X VPWR VGND sg13cmos5l_buf_1
X_4734_ _4734_/X Tile_X0Y8_W2MID[1] AXI_M_SOC_RDATA14 _4787_/X _4786_/X _0579_/Q _0578_/Q
+ VPWR VGND sg13cmos5l_mux4_1
XFILLER_119_102 VPWR VGND sg13cmos5l_decap_4
X_1946_ _1946_/Q Tile_X0Y4_FrameData[11] VGND VPWR Tile_X0Y9_FrameStrobe[0] latch
XFILLER_547_77 VPWR VGND sg13cmos5l_decap_8
XFILLER_524_121 VPWR VGND sg13cmos5l_decap_8
XFILLER_119_28 VPWR VGND sg13cmos5l_decap_8
XFILLER_119_146 VPWR VGND sg13cmos5l_decap_4
X_1877_ _1877_/Q Tile_X0Y3_FrameData[20] VGND VPWR Tile_X0Y9_FrameStrobe[6] latch
X_4665_ _4665_/X Tile_X0Y8_W1END[2] Tile_X0Y8_W6END[6] _4814_/X _4774_/X _0667_/Q
+ _0666_/Q VPWR VGND sg13cmos5l_mux4_1
XFILLER_266_56 VPWR VGND sg13cmos5l_decap_8
XFILLER_134_105 VPWR VGND sg13cmos5l_decap_8
XANTENNA__3508__X Tile_X0Y1_E2BEGb[6] VPWR VGND sg13cmos5l_antennanp
X_0828_ _0828_/Q Tile_X0Y9_FrameData[3] VGND VPWR Tile_X0Y9_FrameStrobe[4] latch
X_3616_ Tile_X0Y9_S2BEGb[2] _4934_/X VPWR VGND sg13cmos5l_buf_1
X_4596_ _4596_/X Tile_X0Y5_W1END[2] Tile_X0Y5_W2MID[1] Tile_X0Y5_W2END[1] _4429_/X
+ _2383_/Q _2382_/Q VPWR VGND sg13cmos5l_mux4_1
XFILLER_563_21 VPWR VGND sg13cmos5l_decap_8
X_0759_ _0759_/Q Tile_X0Y9_FrameData[8] VGND VPWR Tile_X0Y9_FrameStrobe[2] latch
X_3547_ Tile_X0Y9_E6BEG[5] _4885_/X VPWR VGND sg13cmos5l_buf_1
XFILLER_477_220 VPWR VGND sg13cmos5l_fill_2
XFILLER_288_131 VPWR VGND sg13cmos5l_fill_2
X_3478_ Tile_X0Y1_EE4BEG[4] _3952_/X VPWR VGND sg13cmos5l_buf_1
XFILLER_563_98 VPWR VGND sg13cmos5l_decap_8
XFILLER_135_49 VPWR VGND sg13cmos5l_decap_8
XFILLER_713_35 VPWR VGND sg13cmos5l_decap_8
XFILLER_142_182 VPWR VGND sg13cmos5l_decap_8
XFILLER_288_186 VPWR VGND sg13cmos5l_fill_2
XFILLER_282_77 VPWR VGND sg13cmos5l_decap_8
X_2429_ _2429_/Q Tile_X0Y5_FrameData[8] VGND VPWR Tile_X0Y9_FrameStrobe[7] latch
XFILLER_626_228 VPWR VGND sg13cmos5l_fill_1
XFILLER_432_14 VPWR VGND sg13cmos5l_decap_8
XANTENNA__3243__X Tile_X0Y0_FrameData_O[11] VPWR VGND sg13cmos5l_antennanp
XFILLER_28_14 VPWR VGND sg13cmos5l_decap_8
XFILLER_56_122 VPWR VGND sg13cmos5l_decap_8
XFILLER_244_212 VPWR VGND sg13cmos5l_decap_8
XFILLER_56_166 VPWR VGND sg13cmos5l_decap_8
XFILLER_178_7 VPWR VGND sg13cmos5l_decap_8
XFILLER_512_91 VPWR VGND sg13cmos5l_decap_8
XFILLER_44_13 VPWR VGND sg13cmos5l_decap_8
XFILLER_231_70 VPWR VGND sg13cmos5l_decap_8
XFILLER_345_7 VPWR VGND sg13cmos5l_decap_8
XFILLER_588_84 VPWR VGND sg13cmos5l_decap_8
XFILLER_401_220 VPWR VGND sg13cmos5l_fill_2
XFILLER_44_68 VPWR VGND sg13cmos5l_decap_8
XFILLER_212_175 VPWR VGND sg13cmos5l_decap_8
XFILLER_512_7 VPWR VGND sg13cmos5l_decap_8
XFILLER_373_105 VPWR VGND sg13cmos5l_decap_8
XFILLER_100_63 VPWR VGND sg13cmos5l_decap_8
XFILLER_60_56 VPWR VGND sg13cmos5l_decap_8
XFILLER_607_14 VPWR VGND sg13cmos5l_decap_8
XFILLER_176_56 VPWR VGND sg13cmos5l_decap_4
XANTENNA__3418__X Tile_X0Y4_FrameData_O[9] VPWR VGND sg13cmos5l_antennanp
XFILLER_125_116 VPWR VGND sg13cmos5l_fill_1
XFILLER_314_227 VPWR VGND sg13cmos5l_fill_2
XFILLER_176_89 VPWR VGND sg13cmos5l_decap_8
XFILLER_125_138 VPWR VGND sg13cmos5l_decap_8
XFILLER_473_21 VPWR VGND sg13cmos5l_decap_8
XFILLER_530_124 VPWR VGND sg13cmos5l_decap_8
XFILLER_69_21 VPWR VGND sg13cmos5l_decap_8
XFILLER_530_168 VPWR VGND sg13cmos5l_decap_8
XFILLER_140_119 VPWR VGND sg13cmos5l_decap_8
XFILLER_691_109 VPWR VGND sg13cmos5l_fill_1
XFILLER_623_35 VPWR VGND sg13cmos5l_decap_8
XFILLER_69_98 VPWR VGND sg13cmos5l_decap_8
XFILLER_406_70 VPWR VGND sg13cmos5l_decap_8
XFILLER_279_175 VPWR VGND sg13cmos5l_decap_4
XFILLER_294_112 VPWR VGND sg13cmos5l_decap_4
XFILLER_342_14 VPWR VGND sg13cmos5l_decap_8
XFILLER_192_88 VPWR VGND sg13cmos5l_decap_8
XANTENNA__3153__X Tile_X0Y7_FrameData_O[23] VPWR VGND sg13cmos5l_antennanp
XFILLER_85_42 VPWR VGND sg13cmos5l_decap_8
XFILLER_632_209 VPWR VGND sg13cmos5l_decap_8
XFILLER_47_122 VPWR VGND sg13cmos5l_decap_8
XFILLER_371_0 VPWR VGND sg13cmos5l_decap_8
XANTENNA__2992__X Tile_X0Y8_UserCLKo VPWR VGND sg13cmos5l_antennanp
XFILLER_469_0 VPWR VGND sg13cmos5l_decap_8
XFILLER_436_172 VPWR VGND sg13cmos5l_fill_1
XFILLER_422_91 VPWR VGND sg13cmos5l_decap_8
XFILLER_141_70 VPWR VGND sg13cmos5l_decap_8
XFILLER_636_0 VPWR VGND sg13cmos5l_decap_8
XFILLER_62_147 VPWR VGND sg13cmos5l_decap_8
XFILLER_451_175 VPWR VGND sg13cmos5l_fill_1
XFILLER_498_84 VPWR VGND sg13cmos5l_decap_8
XFILLER_648_21 VPWR VGND sg13cmos5l_decap_8
XFILLER_538_224 VPWR VGND sg13cmos5l_decap_4
XFILLER_93_7 VPWR VGND sg13cmos5l_decap_8
XFILLER_349_168 VPWR VGND sg13cmos5l_fill_1
XFILLER_364_105 VPWR VGND sg13cmos5l_decap_8
X_1800_ _1800_/Q Tile_X0Y3_FrameData[1] VGND VPWR Tile_X0Y9_FrameStrobe[3] latch
X_2780_ Tile_X0Y3_EE4BEG[6] _4170_/X VPWR VGND sg13cmos5l_buf_1
XFILLER_648_98 VPWR VGND sg13cmos5l_decap_8
X_1731_ _1731_/Q Tile_X0Y3_FrameData[6] VGND VPWR Tile_X0Y9_FrameStrobe[1] latch
XFILLER_367_77 VPWR VGND sg13cmos5l_decap_8
XFILLER_517_14 VPWR VGND sg13cmos5l_decap_8
XANTENNA__3328__X Tile_X0Y2_UserCLKo VPWR VGND sg13cmos5l_antennanp
XFILLER_664_42 VPWR VGND sg13cmos5l_decap_8
XFILLER_506_154 VPWR VGND sg13cmos5l_decap_8
X_1662_ _1662_/Q Tile_X0Y2_FrameData[19] VGND VPWR Tile_X0Y9_FrameStrobe[7] latch
X_4450_ _4450_/X _4923_/X _4927_/X _4931_/X _4907_/X _0894_/Q _0893_/Q VPWR VGND sg13cmos5l_mux4_1
XFILLER_383_21 VPWR VGND sg13cmos5l_decap_8
XFILLER_506_198 VPWR VGND sg13cmos5l_fill_1
X_0613_ _0613_/Q Tile_X0Y8_FrameData[26] VGND VPWR Tile_X0Y9_FrameStrobe[6] latch
X_3401_ Tile_X0Y2_E2BEG[4] _4044_/X VPWR VGND sg13cmos5l_buf_1
X_4381_ _4381_/X Tile_X0Y5_W2END[6] AXI_M_SOC_RRESP0 _4430_/X _4429_/X _2341_/Q _2340_/Q
+ VPWR VGND sg13cmos5l_mux4_1
X_1593_ _1593_/Q Tile_X0Y2_FrameData[24] VGND VPWR Tile_X0Y9_FrameStrobe[5] latch
XFILLER_131_119 VPWR VGND sg13cmos5l_decap_8
X_3332_ Tile_X0Y2_FrameData_O[3] Tile_X0Y2_FrameData[3] VPWR VGND sg13cmos5l_buf_1
X_0544_ _0544_/Q Tile_X0Y8_FrameData[31] VGND VPWR Tile_X0Y9_FrameStrobe[4] latch
XFILLER_680_41 VPWR VGND sg13cmos5l_decap_8
XFILLER_533_35 VPWR VGND sg13cmos5l_decap_8
XFILLER_316_70 VPWR VGND sg13cmos5l_decap_8
XFILLER_285_112 VPWR VGND sg13cmos5l_decap_8
X_3263_ Tile_X0Y0_FrameData_O[31] Tile_X0Y0_FrameData[31] VPWR VGND sg13cmos5l_buf_1
XFILLER_419_128 VPWR VGND sg13cmos5l_decap_8
XFILLER_252_14 VPWR VGND sg13cmos5l_decap_8
X_0475_ _0475_/Q Tile_X0Y8_FrameData[4] VGND VPWR Tile_X0Y9_FrameStrobe[1] latch
XANTENNA__3063__X Tile_X0Y5_FrameData_O[22] VPWR VGND sg13cmos5l_antennanp
XFILLER_85_228 VPWR VGND sg13cmos5l_fill_1
X_2214_ _2214_/Q Tile_X0Y5_FrameData[31] VGND VPWR Tile_X0Y9_FrameStrobe[1] latch
XFILLER_38_100 VPWR VGND sg13cmos5l_decap_4
X_3194_ Tile_X0Y0_N2BEGb[2] _3893_/X VPWR VGND sg13cmos5l_buf_1
XFILLER_690_164 VPWR VGND sg13cmos5l_decap_8
XFILLER_15_0 VPWR VGND sg13cmos5l_decap_8
XFILLER_427_161 VPWR VGND sg13cmos5l_decap_8
X_2145_ _2145_/Q Tile_X0Y4_FrameData[4] VGND VPWR Tile_X0Y9_FrameStrobe[6] latch
XFILLER_402_28 VPWR VGND sg13cmos5l_decap_8
XFILLER_53_103 VPWR VGND sg13cmos5l_decap_8
XFILLER_38_199 VPWR VGND sg13cmos5l_decap_4
X_2076_ _2076_/Q Tile_X0Y4_FrameData[9] VGND VPWR Tile_X0Y9_FrameStrobe[4] latch
X_1027_ _1027_/Q Tile_X0Y0_FrameData[8] VGND VPWR Tile_X0Y9_FrameStrobe[2] latch
XFILLER_558_21 VPWR VGND sg13cmos5l_decap_8
XFILLER_201_84 VPWR VGND sg13cmos5l_decap_8
XFILLER_14_49 VPWR VGND sg13cmos5l_decap_8
XFILLER_355_105 VPWR VGND sg13cmos5l_decap_8
XFILLER_558_98 VPWR VGND sg13cmos5l_decap_8
XFILLER_708_35 VPWR VGND sg13cmos5l_decap_8
X_2978_ Tile_X0Y8_FrameData_O[18] Tile_X0Y8_FrameData[18] VPWR VGND sg13cmos5l_buf_1
XFILLER_544_227 VPWR VGND sg13cmos5l_fill_2
XFILLER_277_77 VPWR VGND sg13cmos5l_decap_8
X_4717_ _4717_/X _4804_/X _4808_/X _4812_/X _4790_/X _0611_/Q _0610_/Q VPWR VGND sg13cmos5l_mux4_1
X_1929_ _1929_/Q Tile_X0Y4_FrameData[28] VGND VPWR Tile_X0Y9_FrameStrobe[0] latch
XFILLER_427_14 VPWR VGND sg13cmos5l_decap_8
XANTENNA__3238__X Tile_X0Y0_FrameData_O[6] VPWR VGND sg13cmos5l_antennanp
XFILLER_107_105 VPWR VGND sg13cmos5l_decap_8
XFILLER_574_42 VPWR VGND sg13cmos5l_decap_8
XFILLER_162_200 VPWR VGND sg13cmos5l_decap_4
XFILLER_162_211 VPWR VGND sg13cmos5l_decap_4
X_4648_ _4648_/X AXI_M_SOC_RDATA16 _4691_/X _4695_/X _4669_/X _0263_/Q _0262_/Q VPWR
+ VGND sg13cmos5l_mux4_1
XFILLER_30_48 VPWR VGND sg13cmos5l_decap_8
XFILLER_293_21 VPWR VGND sg13cmos5l_decap_8
X_4579_ _4579_/X _4551_/X Tile_X0Y9_N4END[15] _4550_/X _0150_/X _2473_/Q _2472_/Q
+ VPWR VGND sg13cmos5l_mux4_1
XFILLER_507_91 VPWR VGND sg13cmos5l_decap_8
XFILLER_512_179 VPWR VGND sg13cmos5l_fill_2
XFILLER_115_171 VPWR VGND sg13cmos5l_decap_8
XFILLER_293_98 VPWR VGND sg13cmos5l_decap_8
XFILLER_443_35 VPWR VGND sg13cmos5l_decap_8
XFILLER_39_13 VPWR VGND sg13cmos5l_decap_8
XFILLER_226_70 VPWR VGND sg13cmos5l_decap_8
XFILLER_276_112 VPWR VGND sg13cmos5l_decap_8
XFILLER_666_172 VPWR VGND sg13cmos5l_decap_8
XFILLER_590_63 VPWR VGND sg13cmos5l_decap_8
XFILLER_162_14 VPWR VGND sg13cmos5l_decap_8
XFILLER_295_7 VPWR VGND sg13cmos5l_decap_8
XFILLER_291_126 VPWR VGND sg13cmos5l_fill_2
XFILLER_312_28 VPWR VGND sg13cmos5l_decap_8
XFILLER_681_197 VPWR VGND sg13cmos5l_fill_2
XFILLER_462_7 VPWR VGND sg13cmos5l_decap_8
XANTENNA__3701__X AXI_M_SOC_WDATA11 VPWR VGND sg13cmos5l_antennanp
XFILLER_55_56 VPWR VGND sg13cmos5l_decap_8
XFILLER_579_168 VPWR VGND sg13cmos5l_decap_8
XFILLER_594_105 VPWR VGND sg13cmos5l_decap_4
XFILLER_468_21 VPWR VGND sg13cmos5l_decap_8
XFILLER_346_105 VPWR VGND sg13cmos5l_decap_8
XFILLER_71_77 VPWR VGND sg13cmos5l_decap_8
XFILLER_618_35 VPWR VGND sg13cmos5l_decap_8
XFILLER_339_190 VPWR VGND sg13cmos5l_decap_8
XFILLER_337_14 VPWR VGND sg13cmos5l_decap_8
XANTENNA__3148__X Tile_X0Y7_FrameData_O[18] VPWR VGND sg13cmos5l_antennanp
XFILLER_361_119 VPWR VGND sg13cmos5l_decap_8
XFILLER_217_0 VPWR VGND sg13cmos5l_decap_8
XFILLER_153_211 VPWR VGND sg13cmos5l_decap_4
XFILLER_354_182 VPWR VGND sg13cmos5l_decap_8
XFILLER_484_75 VPWR VGND sg13cmos5l_decap_8
XANTENNA__2987__X Tile_X0Y8_FrameData_O[27] VPWR VGND sg13cmos5l_antennanp
XFILLER_634_56 VPWR VGND sg13cmos5l_decap_8
XFILLER_503_168 VPWR VGND sg13cmos5l_decap_8
XFILLER_417_91 VPWR VGND sg13cmos5l_decap_8
XFILLER_20_70 VPWR VGND sg13cmos5l_decap_8
XFILLER_106_160 VPWR VGND sg13cmos5l_decap_8
XFILLER_20_81 VPWR VGND sg13cmos5l_fill_1
XFILLER_353_35 VPWR VGND sg13cmos5l_decap_8
XFILLER_136_70 VPWR VGND sg13cmos5l_decap_8
XFILLER_586_0 VPWR VGND sg13cmos5l_decap_8
XFILLER_121_130 VPWR VGND sg13cmos5l_decap_8
XFILLER_511_190 VPWR VGND sg13cmos5l_decap_8
XFILLER_121_163 VPWR VGND sg13cmos5l_decap_8
XFILLER_67_228 VPWR VGND sg13cmos5l_fill_1
XFILLER_96_96 VPWR VGND sg13cmos5l_decap_8
X_0260_ _0260_/Q Tile_X0Y7_FrameData[27] VGND VPWR Tile_X0Y9_FrameStrobe[3] latch
XFILLER_503_49 VPWR VGND sg13cmos5l_decap_8
XFILLER_672_175 VPWR VGND sg13cmos5l_decap_8
XFILLER_282_126 VPWR VGND sg13cmos5l_decap_8
XFILLER_650_77 VPWR VGND sg13cmos5l_decap_8
XFILLER_471_226 VPWR VGND sg13cmos5l_fill_2
XFILLER_409_172 VPWR VGND sg13cmos5l_decap_8
XFILLER_222_28 VPWR VGND sg13cmos5l_decap_8
X_0191_ _0191_/Q Tile_X0Y7_FrameData[0] VGND VPWR Tile_X0Y9_FrameStrobe[0] latch
XANTENNA__3611__X Tile_X0Y9_S2BEG[5] VPWR VGND sg13cmos5l_antennanp
XFILLER_424_175 VPWR VGND sg13cmos5l_decap_8
XFILLER_659_42 VPWR VGND sg13cmos5l_decap_8
XFILLER_585_105 VPWR VGND sg13cmos5l_decap_8
XFILLER_290_192 VPWR VGND sg13cmos5l_decap_8
X_3950_ _3950_/X Tile_X0Y1_WW4END[13] AXI_M_SOC_ARREADY _4002_/X _3992_/X _1309_/Q
+ _1308_/Q VPWR VGND sg13cmos5l_mux4_1
XFILLER_585_116 VPWR VGND sg13cmos5l_fill_2
XFILLER_50_106 VPWR VGND sg13cmos5l_decap_8
XFILLER_378_21 VPWR VGND sg13cmos5l_decap_8
XFILLER_188_130 VPWR VGND sg13cmos5l_fill_2
X_2901_ Tile_X0Y6_FrameData_O[22] Tile_X0Y6_FrameData[22] VPWR VGND sg13cmos5l_buf_1
X_3881_ _3881_/X _3848_/X _0067_/X Tile_X0Y0_S1END[0] Tile_X0Y0_S4END[0] _0995_/Q
+ _0994_/Q VPWR VGND sg13cmos5l_mux4_1
X_2832_ Tile_X0Y6_E1BEG[1] _4493_/X VPWR VGND sg13cmos5l_buf_1
XFILLER_337_116 VPWR VGND sg13cmos5l_decap_8
XFILLER_593_171 VPWR VGND sg13cmos5l_decap_8
XFILLER_528_35 VPWR VGND sg13cmos5l_decap_8
XFILLER_675_63 VPWR VGND sg13cmos5l_decap_8
XFILLER_247_14 VPWR VGND sg13cmos5l_decap_8
X_2763_ Tile_X0Y3_FrameData_O[21] Tile_X0Y3_FrameData[21] VPWR VGND sg13cmos5l_buf_1
XANTENNA__3058__X Tile_X0Y5_FrameData_O[17] VPWR VGND sg13cmos5l_antennanp
XFILLER_394_42 VPWR VGND sg13cmos5l_decap_8
XFILLER_352_119 VPWR VGND sg13cmos5l_decap_8
X_4502_ _4502_/X Tile_X0Y6_W2MID[1] AXI_M_SOC_RDATA30 _4555_/X _4554_/X _2603_/Q _2602_/Q
+ VPWR VGND sg13cmos5l_mux4_1
X_1714_ _1714_/Q Tile_X0Y3_FrameData[23] VGND VPWR Tile_X0Y9_FrameStrobe[1] latch
X_2694_ _2694_/Q Tile_X0Y6_FrameData[1] VGND VPWR Tile_X0Y9_FrameStrobe[7] latch
XANTENNA__2897__X Tile_X0Y6_FrameData_O[18] VPWR VGND sg13cmos5l_antennanp
X_1645_ _1645_/Q Tile_X0Y2_FrameData[4] VGND VPWR Tile_X0Y9_FrameStrobe[6] latch
X_4433_ _4433_/X _4361_/X _4477_/X _4476_/X _4360_/X _2197_/Q _2196_/Q VPWR VGND sg13cmos5l_mux4_1
XFILLER_544_56 VPWR VGND sg13cmos5l_decap_8
XFILLER_360_185 VPWR VGND sg13cmos5l_decap_4
X_1576_ _1576_/Q Tile_X0Y2_FrameData[9] VGND VPWR Tile_X0Y9_FrameStrobe[4] latch
X_4364_ _4364_/X Tile_X0Y3_W1END[2] Tile_X0Y3_W2MID[1] Tile_X0Y3_W2END[1] _4206_/X
+ _1869_/Q _1868_/Q VPWR VGND sg13cmos5l_mux4_1
XFILLER_691_84 VPWR VGND sg13cmos5l_decap_8
XFILLER_263_35 VPWR VGND sg13cmos5l_decap_8
X_0527_ _0527_/Q Tile_X0Y8_FrameData[16] VGND VPWR Tile_X0Y9_FrameStrobe[3] latch
X_3315_ Tile_X0Y4_EE4BEG[3] _4275_/X VPWR VGND sg13cmos5l_buf_1
XFILLER_112_141 VPWR VGND sg13cmos5l_decap_8
X_4295_ _4295_/X AXI_M_SOC_BRESP1 _4340_/X _4344_/X _4319_/X _2023_/Q _2022_/Q VPWR
+ VGND sg13cmos5l_mux4_1
XFILLER_663_120 VPWR VGND sg13cmos5l_decap_8
XFILLER_58_228 VPWR VGND sg13cmos5l_fill_1
X_3246_ Tile_X0Y0_FrameData_O[14] Tile_X0Y0_FrameData[14] VPWR VGND sg13cmos5l_buf_1
X_0458_ _0458_/Q Tile_X0Y8_FrameData[21] VGND VPWR Tile_X0Y9_FrameStrobe[1] latch
XFILLER_407_109 VPWR VGND sg13cmos5l_fill_2
XFILLER_413_49 VPWR VGND sg13cmos5l_decap_8
XFILLER_273_126 VPWR VGND sg13cmos5l_decap_8
XFILLER_560_77 VPWR VGND sg13cmos5l_decap_8
XFILLER_132_28 VPWR VGND sg13cmos5l_decap_8
XFILLER_710_14 VPWR VGND sg13cmos5l_decap_8
X_3177_ Tile_X0Y0_N4BEG[1] _3177_/A VPWR VGND sg13cmos5l_buf_1
X_0389_ _0389_/Q Tile_X0Y7_FrameData[26] VGND VPWR Tile_X0Y9_FrameStrobe[7] latch
XANTENNA__3521__X Tile_X0Y1_E1BEG[3] VPWR VGND sg13cmos5l_antennanp
X_2128_ _2128_/Q Tile_X0Y4_FrameData[21] VGND VPWR Tile_X0Y9_FrameStrobe[6] latch
XFILLER_430_112 VPWR VGND sg13cmos5l_decap_8
XFILLER_26_158 VPWR VGND sg13cmos5l_decap_8
XFILLER_576_105 VPWR VGND sg13cmos5l_decap_8
XFILLER_569_42 VPWR VGND sg13cmos5l_decap_8
X_2059_ _2059_/Q Tile_X0Y4_FrameData[26] VGND VPWR Tile_X0Y9_FrameStrobe[4] latch
XFILLER_288_21 VPWR VGND sg13cmos5l_decap_8
XFILLER_179_130 VPWR VGND sg13cmos5l_fill_1
XFILLER_179_152 VPWR VGND sg13cmos5l_decap_8
XFILLER_430_189 VPWR VGND sg13cmos5l_decap_8
XFILLER_517_205 VPWR VGND sg13cmos5l_decap_8
XFILLER_288_98 VPWR VGND sg13cmos5l_decap_8
XFILLER_584_182 VPWR VGND sg13cmos5l_decap_4
XFILLER_438_35 VPWR VGND sg13cmos5l_decap_8
XFILLER_584_193 VPWR VGND sg13cmos5l_decap_8
XFILLER_585_63 VPWR VGND sg13cmos5l_decap_8
XFILLER_157_14 VPWR VGND sg13cmos5l_decap_8
XFILLER_210_7 VPWR VGND sg13cmos5l_decap_8
XFILLER_308_7 VPWR VGND sg13cmos5l_decap_8
XFILLER_497_112 VPWR VGND sg13cmos5l_decap_8
XFILLER_307_28 VPWR VGND sg13cmos5l_decap_8
XFILLER_454_56 VPWR VGND sg13cmos5l_decap_8
XFILLER_500_105 VPWR VGND sg13cmos5l_decap_8
XFILLER_351_196 VPWR VGND sg13cmos5l_fill_2
XFILLER_173_35 VPWR VGND sg13cmos5l_decap_8
XFILLER_497_189 VPWR VGND sg13cmos5l_decap_8
XFILLER_639_161 VPWR VGND sg13cmos5l_decap_8
XFILLER_249_112 VPWR VGND sg13cmos5l_decap_4
XFILLER_249_123 VPWR VGND sg13cmos5l_decap_8
XFILLER_677_7 VPWR VGND sg13cmos5l_decap_8
XFILLER_103_152 VPWR VGND sg13cmos5l_fill_2
XFILLER_49_228 VPWR VGND sg13cmos5l_fill_1
XFILLER_103_196 VPWR VGND sg13cmos5l_decap_8
XFILLER_323_49 VPWR VGND sg13cmos5l_decap_8
XFILLER_654_175 VPWR VGND sg13cmos5l_decap_8
XFILLER_66_55 VPWR VGND sg13cmos5l_decap_8
XFILLER_470_77 VPWR VGND sg13cmos5l_fill_2
XFILLER_620_14 VPWR VGND sg13cmos5l_decap_8
XFILLER_264_159 VPWR VGND sg13cmos5l_fill_2
XANTENNA__3431__X Tile_X0Y4_FrameData_O[22] VPWR VGND sg13cmos5l_antennanp
XFILLER_82_21 VPWR VGND sg13cmos5l_decap_8
XFILLER_567_105 VPWR VGND sg13cmos5l_decap_8
XFILLER_479_42 VPWR VGND sg13cmos5l_decap_8
XFILLER_421_112 VPWR VGND sg13cmos5l_decap_8
XFILLER_167_0 VPWR VGND sg13cmos5l_decap_8
XFILLER_198_21 VPWR VGND sg13cmos5l_decap_8
XFILLER_479_86 VPWR VGND sg13cmos5l_decap_8
XFILLER_421_178 VPWR VGND sg13cmos5l_decap_8
XFILLER_82_98 VPWR VGND sg13cmos5l_decap_8
XFILLER_334_0 VPWR VGND sg13cmos5l_decap_8
XFILLER_709_154 VPWR VGND sg13cmos5l_decap_8
XFILLER_629_56 VPWR VGND sg13cmos5l_decap_8
XFILLER_582_119 VPWR VGND sg13cmos5l_decap_8
XFILLER_15_70 VPWR VGND sg13cmos5l_decap_8
XFILLER_198_98 VPWR VGND sg13cmos5l_fill_2
XFILLER_508_227 VPWR VGND sg13cmos5l_fill_2
XFILLER_40_161 VPWR VGND sg13cmos5l_decap_8
XFILLER_575_182 VPWR VGND sg13cmos5l_decap_8
XFILLER_348_35 VPWR VGND sg13cmos5l_decap_8
XFILLER_495_63 VPWR VGND sg13cmos5l_decap_8
XFILLER_501_0 VPWR VGND sg13cmos5l_decap_8
XFILLER_488_112 VPWR VGND sg13cmos5l_decap_8
XFILLER_31_80 VPWR VGND sg13cmos5l_decap_4
XFILLER_645_77 VPWR VGND sg13cmos5l_decap_8
XFILLER_677_223 VPWR VGND sg13cmos5l_decap_4
XFILLER_217_28 VPWR VGND sg13cmos5l_decap_8
XFILLER_141_203 VPWR VGND sg13cmos5l_decap_8
XANTENNA__3606__X Tile_X0Y9_S2BEG[0] VPWR VGND sg13cmos5l_antennanp
XFILLER_364_56 VPWR VGND sg13cmos5l_decap_8
XFILLER_147_91 VPWR VGND sg13cmos5l_decap_8
X_1430_ _1430_/Q Tile_X0Y2_FrameData[27] VGND VPWR Tile_X0Y9_FrameStrobe[0] latch
XFILLER_661_21 VPWR VGND sg13cmos5l_decap_8
X_1361_ _1361_/Q Tile_X0Y1_FrameData[8] VGND VPWR Tile_X0Y9_FrameStrobe[5] latch
X_3100_ Tile_X0Y7_E2BEGb[6] _4626_/X VPWR VGND sg13cmos5l_buf_1
X_0312_ _0312_/Q Tile_X0Y7_FrameData[7] VGND VPWR Tile_X0Y9_FrameStrobe[4] latch
X_4080_ _4080_/X AXI_M_SOC_AWREADY _4119_/X _4123_/X _4102_/X _1513_/Q _1512_/Q VPWR
+ VGND sg13cmos5l_mux4_1
X_1292_ _1292_/Q Tile_X0Y1_FrameData[13] VGND VPWR Tile_X0Y9_FrameStrobe[3] latch
XFILLER_661_98 VPWR VGND sg13cmos5l_decap_8
XFILLER_233_49 VPWR VGND sg13cmos5l_decap_8
XFILLER_255_115 VPWR VGND sg13cmos5l_decap_8
XFILLER_645_175 VPWR VGND sg13cmos5l_decap_8
X_3031_ Tile_X0Y5_EE4BEG[6] _4394_/X VPWR VGND sg13cmos5l_buf_1
XFILLER_380_77 VPWR VGND sg13cmos5l_decap_8
XFILLER_255_137 VPWR VGND sg13cmos5l_fill_2
X_0243_ _0243_/Q Tile_X0Y7_FrameData[12] VGND VPWR Tile_X0Y9_FrameStrobe[2] latch
XFILLER_55_209 VPWR VGND sg13cmos5l_decap_8
XFILLER_530_14 VPWR VGND sg13cmos5l_decap_8
XFILLER_660_123 VPWR VGND sg13cmos5l_fill_1
XANTENNA__3341__X Tile_X0Y2_FrameData_O[12] VPWR VGND sg13cmos5l_antennanp
X_0174_ _0174_/Q Tile_X0Y7_FrameData[17] VGND VPWR Tile_X0Y9_FrameStrobe[0] latch
XFILLER_558_105 VPWR VGND sg13cmos5l_decap_8
XFILLER_389_42 VPWR VGND sg13cmos5l_decap_8
XFILLER_23_106 VPWR VGND sg13cmos5l_fill_2
XFILLER_610_91 VPWR VGND sg13cmos5l_decap_8
X_3933_ _3933_/X Tile_X0Y1_W2MID[6] AXI_M_SOC_ARREADY _3991_/X _3990_/X _1343_/Q _1342_/Q
+ VPWR VGND sg13cmos5l_mux4_1
XFILLER_412_178 VPWR VGND sg13cmos5l_decap_8
XFILLER_539_56 VPWR VGND sg13cmos5l_decap_8
XFILLER_573_119 VPWR VGND sg13cmos5l_decap_8
X_3864_ _3864_/X _3851_/X _0078_/X Tile_X0Y0_S1END[3] Tile_X0Y0_S4END[3] _0973_/Q
+ _0972_/Q VPWR VGND sg13cmos5l_mux4_1
XFILLER_686_84 VPWR VGND sg13cmos5l_decap_8
XFILLER_82_0 VPWR VGND sg13cmos5l_decap_8
XFILLER_258_35 VPWR VGND sg13cmos5l_decap_8
X_2815_ Tile_X0Y3_E2BEG[5] _4153_/X VPWR VGND sg13cmos5l_buf_1
XFILLER_31_194 VPWR VGND sg13cmos5l_fill_2
XFILLER_715_146 VPWR VGND sg13cmos5l_decap_8
X_3795_ _3795_/X _3886_/X _3872_/X _3871_/X _3855_/X _1150_/Q _1149_/Q VPWR VGND sg13cmos5l_mux4_1
XFILLER_325_119 VPWR VGND sg13cmos5l_decap_8
XFILLER_176_188 VPWR VGND sg13cmos5l_fill_1
XFILLER_380_225 VPWR VGND sg13cmos5l_decap_4
XFILLER_318_171 VPWR VGND sg13cmos5l_fill_1
X_2746_ Tile_X0Y3_FrameData_O[4] Tile_X0Y3_FrameData[4] VPWR VGND sg13cmos5l_buf_1
XFILLER_408_49 VPWR VGND sg13cmos5l_decap_8
XFILLER_11_28 VPWR VGND sg13cmos5l_decap_8
XFILLER_479_101 VPWR VGND sg13cmos5l_decap_8
XFILLER_318_193 VPWR VGND sg13cmos5l_decap_8
XFILLER_191_158 VPWR VGND sg13cmos5l_decap_8
XFILLER_479_112 VPWR VGND sg13cmos5l_fill_2
XFILLER_555_77 VPWR VGND sg13cmos5l_decap_8
XFILLER_333_141 VPWR VGND sg13cmos5l_decap_8
XFILLER_127_28 VPWR VGND sg13cmos5l_decap_8
XFILLER_705_14 VPWR VGND sg13cmos5l_decap_8
X_2677_ _2677_/Q Tile_X0Y6_FrameData[18] VGND VPWR Tile_X0Y9_FrameStrobe[7] latch
XFILLER_333_152 VPWR VGND sg13cmos5l_fill_2
XFILLER_274_56 VPWR VGND sg13cmos5l_decap_8
XANTENNA__3516__X Tile_X0Y1_E2BEG[6] VPWR VGND sg13cmos5l_antennanp
X_4416_ _4416_/X _4418_/X Tile_X0Y5_W6END[0] _4417_/X _4416_/A3 _2189_/Q _2188_/Q
+ VPWR VGND sg13cmos5l_mux4_1
X_1628_ _1628_/Q Tile_X0Y2_FrameData[21] VGND VPWR Tile_X0Y9_FrameStrobe[6] latch
XFILLER_571_21 VPWR VGND sg13cmos5l_decap_8
XFILLER_494_126 VPWR VGND sg13cmos5l_decap_8
X_4347_ _4347_/X _4311_/X _0040_/X _4310_/X _0109_/X _1959_/Q _1958_/Q VPWR VGND sg13cmos5l_mux4_1
X_1559_ _1559_/Q Tile_X0Y2_FrameData[26] VGND VPWR Tile_X0Y9_FrameStrobe[4] latch
XFILLER_571_98 VPWR VGND sg13cmos5l_decap_8
XFILLER_246_104 VPWR VGND sg13cmos5l_decap_8
XFILLER_143_49 VPWR VGND sg13cmos5l_decap_8
X_4278_ _4278_/X Tile_X0Y4_WW4END[9] AXI_M_SOC_BRESP0 _4345_/X _4315_/X _2057_/Q _2056_/Q
+ VPWR VGND sg13cmos5l_mux4_1
XFILLER_246_115 VPWR VGND sg13cmos5l_fill_1
XFILLER_504_70 VPWR VGND sg13cmos5l_decap_8
XFILLER_290_77 VPWR VGND sg13cmos5l_decap_8
XFILLER_651_112 VPWR VGND sg13cmos5l_decap_8
X_3229_ Tile_X0Y0_FrameStrobe_O[17] Tile_X0Y9_FrameStrobe[17] VPWR VGND sg13cmos5l_buf_1
XFILLER_440_14 VPWR VGND sg13cmos5l_decap_8
XANTENNA__3251__X Tile_X0Y0_FrameData_O[19] VPWR VGND sg13cmos5l_antennanp
XFILLER_651_189 VPWR VGND sg13cmos5l_decap_8
XFILLER_36_58 VPWR VGND sg13cmos5l_decap_8
XFILLER_403_112 VPWR VGND sg13cmos5l_decap_4
XFILLER_299_42 VPWR VGND sg13cmos5l_decap_8
XFILLER_254_192 VPWR VGND sg13cmos5l_fill_1
XFILLER_160_7 VPWR VGND sg13cmos5l_decap_8
XFILLER_258_7 VPWR VGND sg13cmos5l_decap_8
XFILLER_403_145 VPWR VGND sg13cmos5l_decap_8
XFILLER_403_156 VPWR VGND sg13cmos5l_fill_1
XFILLER_52_24 VPWR VGND sg13cmos5l_decap_8
XFILLER_564_119 VPWR VGND sg13cmos5l_decap_8
XFILLER_449_56 VPWR VGND sg13cmos5l_decap_8
XFILLER_425_7 VPWR VGND sg13cmos5l_decap_8
XFILLER_596_84 VPWR VGND sg13cmos5l_decap_8
XFILLER_168_35 VPWR VGND sg13cmos5l_decap_8
XFILLER_557_193 VPWR VGND sg13cmos5l_fill_1
XFILLER_316_108 VPWR VGND sg13cmos5l_decap_8
XFILLER_371_203 VPWR VGND sg13cmos5l_decap_8
XFILLER_371_225 VPWR VGND sg13cmos5l_decap_4
XFILLER_572_196 VPWR VGND sg13cmos5l_decap_8
XFILLER_318_49 VPWR VGND sg13cmos5l_decap_8
XFILLER_714_190 VPWR VGND sg13cmos5l_decap_8
XFILLER_615_14 VPWR VGND sg13cmos5l_decap_8
XFILLER_123_203 VPWR VGND sg13cmos5l_decap_8
XFILLER_324_163 VPWR VGND sg13cmos5l_fill_2
XFILLER_184_56 VPWR VGND sg13cmos5l_decap_8
XANTENNA__3426__X Tile_X0Y4_FrameData_O[17] VPWR VGND sg13cmos5l_antennanp
XFILLER_269_218 VPWR VGND sg13cmos5l_decap_8
XFILLER_184_78 VPWR VGND sg13cmos5l_decap_8
XFILLER_324_196 VPWR VGND sg13cmos5l_decap_8
XFILLER_481_21 VPWR VGND sg13cmos5l_decap_8
XFILLER_77_21 VPWR VGND sg13cmos5l_decap_8
XFILLER_117_94 VPWR VGND sg13cmos5l_decap_8
XFILLER_481_98 VPWR VGND sg13cmos5l_decap_8
XFILLER_631_35 VPWR VGND sg13cmos5l_decap_8
XFILLER_414_70 VPWR VGND sg13cmos5l_decap_8
XFILLER_284_0 VPWR VGND sg13cmos5l_decap_8
XFILLER_642_112 VPWR VGND sg13cmos5l_decap_8
XFILLER_350_14 VPWR VGND sg13cmos5l_decap_8
XANTENNA__3161__X Tile_X0Y7_FrameData_O[31] VPWR VGND sg13cmos5l_antennanp
XFILLER_93_42 VPWR VGND sg13cmos5l_decap_8
XFILLER_93_53 VPWR VGND sg13cmos5l_fill_1
XFILLER_642_189 VPWR VGND sg13cmos5l_decap_8
XFILLER_451_0 VPWR VGND sg13cmos5l_decap_8
XFILLER_549_0 VPWR VGND sg13cmos5l_decap_8
XFILLER_500_28 VPWR VGND sg13cmos5l_decap_8
XFILLER_60_212 VPWR VGND sg13cmos5l_fill_1
XFILLER_430_91 VPWR VGND sg13cmos5l_decap_8
XFILLER_26_91 VPWR VGND sg13cmos5l_decap_8
XFILLER_716_0 VPWR VGND sg13cmos5l_fill_1
XFILLER_359_56 VPWR VGND sg13cmos5l_decap_8
X_0930_ _0930_/Q Tile_X0Y9_FrameData[21] VGND VPWR Tile_X0Y9_FrameStrobe[8] latch
XFILLER_656_21 VPWR VGND sg13cmos5l_decap_8
X_0861_ _0861_/Q Tile_X0Y9_FrameData[2] VGND VPWR Tile_X0Y9_FrameStrobe[5] latch
XFILLER_712_105 VPWR VGND sg13cmos5l_decap_8
X_2600_ _2600_/Q Tile_X0Y6_FrameData[31] VGND VPWR Tile_X0Y9_FrameStrobe[5] latch
X_0792_ _0792_/Q Tile_X0Y9_FrameData[7] VGND VPWR Tile_X0Y9_FrameStrobe[3] latch
X_3580_ Tile_X0Y9_FrameData_O[10] Tile_X0Y9_FrameData[10] VPWR VGND sg13cmos5l_buf_1
XFILLER_656_98 VPWR VGND sg13cmos5l_decap_8
XFILLER_228_49 VPWR VGND sg13cmos5l_decap_8
X_2531_ _2531_/Q Tile_X0Y6_FrameData[4] VGND VPWR Tile_X0Y9_FrameStrobe[2] latch
XFILLER_525_14 VPWR VGND sg13cmos5l_decap_8
XFILLER_315_152 VPWR VGND sg13cmos5l_fill_2
XANTENNA__3336__X Tile_X0Y2_FrameData_O[7] VPWR VGND sg13cmos5l_antennanp
XFILLER_672_42 VPWR VGND sg13cmos5l_decap_8
XFILLER_114_225 VPWR VGND sg13cmos5l_decap_4
X_2462_ _2462_/Q Tile_X0Y6_FrameData[9] VGND VPWR Tile_X0Y9_FrameStrobe[0] latch
XFILLER_476_104 VPWR VGND sg13cmos5l_fill_2
XFILLER_181_191 VPWR VGND sg13cmos5l_fill_2
XFILLER_391_21 VPWR VGND sg13cmos5l_decap_8
X_4201_ _4201_/X _4197_/X Tile_X0Y3_W6END[1] _4196_/X _4201_/A3 _1679_/Q _1678_/Q
+ VPWR VGND sg13cmos5l_mux4_1
XFILLER_476_137 VPWR VGND sg13cmos5l_decap_8
X_1413_ _1413_/Q Tile_X0Y1_FrameData[20] VGND VPWR Tile_X0Y9_FrameStrobe[7] latch
X_2393_ _2393_/Q Tile_X0Y5_FrameData[12] VGND VPWR Tile_X0Y9_FrameStrobe[6] latch
XFILLER_605_91 VPWR VGND sg13cmos5l_decap_4
X_1344_ _1344_/Q Tile_X0Y1_FrameData[25] VGND VPWR Tile_X0Y9_FrameStrobe[5] latch
X_4132_ _4132_/X Tile_X0Y1_W2MID[5] Tile_X0Y1_W2END[5] Tile_X0Y1_W6END[10] _3993_/X
+ _1377_/Q _1376_/Q VPWR VGND sg13cmos5l_mux4_1
XFILLER_541_35 VPWR VGND sg13cmos5l_decap_8
XFILLER_283_210 VPWR VGND sg13cmos5l_fill_1
XFILLER_228_115 VPWR VGND sg13cmos5l_decap_8
XFILLER_95_142 VPWR VGND sg13cmos5l_decap_8
XFILLER_484_170 VPWR VGND sg13cmos5l_fill_1
XFILLER_3_84 VPWR VGND sg13cmos5l_decap_8
XFILLER_283_221 VPWR VGND sg13cmos5l_fill_1
XFILLER_95_153 VPWR VGND sg13cmos5l_fill_1
XFILLER_633_112 VPWR VGND sg13cmos5l_decap_8
XFILLER_484_192 VPWR VGND sg13cmos5l_decap_8
XFILLER_260_14 VPWR VGND sg13cmos5l_decap_8
XFILLER_95_175 VPWR VGND sg13cmos5l_decap_8
X_1275_ _1275_/Q Tile_X0Y1_FrameData[30] VGND VPWR Tile_X0Y9_FrameStrobe[3] latch
X_4063_ _4063_/X Tile_X0Y2_WW4END[8] AXI_M_SOC_AWREADY _4124_/X _4097_/X _1547_/Q
+ _1546_/Q VPWR VGND sg13cmos5l_mux4_1
XANTENNA__3071__X Tile_X0Y5_FrameData_O[30] VPWR VGND sg13cmos5l_antennanp
X_0226_ _0226_/Q Tile_X0Y7_FrameData[29] VGND VPWR Tile_X0Y9_FrameStrobe[2] latch
X_3014_ Tile_X0Y5_E6BEG[1] _4405_/X VPWR VGND sg13cmos5l_buf_1
XFILLER_410_28 VPWR VGND sg13cmos5l_decap_8
X_0157_ _0157_/X _4437_/X _4438_/X _0901_/Q VPWR VGND sg13cmos5l_mux2_1
XFILLER_251_140 VPWR VGND sg13cmos5l_decap_8
X_0088_ _0088_/X _4216_/X _4217_/X _0386_/Q VPWR VGND sg13cmos5l_mux2_1
XFILLER_269_56 VPWR VGND sg13cmos5l_decap_8
XFILLER_196_228 VPWR VGND sg13cmos5l_fill_1
X_3916_ _3916_/X Tile_X0Y2_W1END[1] Tile_X0Y2_WW4END[1] Tile_X0Y2_W6END[9] _4117_/X
+ _1646_/Q _1645_/Q VPWR VGND sg13cmos5l_mux4_1
XFILLER_400_148 VPWR VGND sg13cmos5l_decap_8
X_4896_ _4896_/X Tile_X0Y8_W1END[0] Tile_X0Y8_W6END[8] _4812_/X _4772_/X _0635_/Q
+ _0634_/Q VPWR VGND sg13cmos5l_mux4_1
XFILLER_566_21 VPWR VGND sg13cmos5l_decap_8
X_3847_ _3847_/X Tile_X0Y0_W2MID[7] _3881_/X _3885_/X _3852_/X _1011_/Q _1010_/Q VPWR
+ VGND sg13cmos5l_mux4_1
XFILLER_149_177 VPWR VGND sg13cmos5l_decap_8
XFILLER_22_49 VPWR VGND sg13cmos5l_decap_8
XFILLER_703_105 VPWR VGND sg13cmos5l_decap_8
XFILLER_566_98 VPWR VGND sg13cmos5l_decap_8
XFILLER_499_218 VPWR VGND sg13cmos5l_fill_1
X_3778_ AXI_M_SOC_ARVALID Tile_X0Y1_WW4END[0] Tile_X0Y1_WW4END[8] Tile_X0Y1_W6END[0]
+ _4008_/X _1257_/Q _1256_/Q VPWR VGND sg13cmos5l_mux4_1
XFILLER_138_49 VPWR VGND sg13cmos5l_decap_8
XFILLER_285_77 VPWR VGND sg13cmos5l_decap_8
X_2729_ _3861_/A3 VPWR VGND sg13cmos5l_tielo
XFILLER_435_14 VPWR VGND sg13cmos5l_decap_8
XANTENNA__3246__X Tile_X0Y0_FrameData_O[14] VPWR VGND sg13cmos5l_antennanp
XFILLER_582_42 VPWR VGND sg13cmos5l_decap_8
XFILLER_105_225 VPWR VGND sg13cmos5l_decap_4
XFILLER_321_122 VPWR VGND sg13cmos5l_fill_2
XFILLER_711_182 VPWR VGND sg13cmos5l_decap_8
XFILLER_321_166 VPWR VGND sg13cmos5l_decap_8
XFILLER_515_91 VPWR VGND sg13cmos5l_decap_8
XFILLER_451_35 VPWR VGND sg13cmos5l_decap_8
XFILLER_234_70 VPWR VGND sg13cmos5l_decap_8
XFILLER_47_24 VPWR VGND sg13cmos5l_decap_8
XFILLER_624_112 VPWR VGND sg13cmos5l_fill_2
XFILLER_475_192 VPWR VGND sg13cmos5l_fill_1
XFILLER_170_14 VPWR VGND sg13cmos5l_decap_8
XFILLER_86_175 VPWR VGND sg13cmos5l_decap_8
XFILLER_451_79 VPWR VGND sg13cmos5l_fill_1
XFILLER_375_7 VPWR VGND sg13cmos5l_decap_8
XFILLER_490_140 VPWR VGND sg13cmos5l_decap_8
XFILLER_423_218 VPWR VGND sg13cmos5l_fill_1
XFILLER_601_49 VPWR VGND sg13cmos5l_decap_8
XFILLER_542_7 VPWR VGND sg13cmos5l_decap_8
XFILLER_320_28 VPWR VGND sg13cmos5l_decap_8
XFILLER_103_63 VPWR VGND sg13cmos5l_decap_8
XFILLER_42_223 VPWR VGND sg13cmos5l_decap_4
XFILLER_63_56 VPWR VGND sg13cmos5l_decap_8
XFILLER_242_173 VPWR VGND sg13cmos5l_decap_8
XFILLER_187_228 VPWR VGND sg13cmos5l_fill_1
XFILLER_179_56 VPWR VGND sg13cmos5l_decap_8
XFILLER_144_2 VPWR VGND sg13cmos5l_fill_1
XFILLER_476_21 VPWR VGND sg13cmos5l_decap_8
XFILLER_344_203 VPWR VGND sg13cmos5l_fill_1
XFILLER_155_136 VPWR VGND sg13cmos5l_fill_2
XFILLER_626_35 VPWR VGND sg13cmos5l_decap_8
XFILLER_409_70 VPWR VGND sg13cmos5l_decap_8
XFILLER_345_14 VPWR VGND sg13cmos5l_decap_8
XFILLER_560_166 VPWR VGND sg13cmos5l_fill_1
XANTENNA__3156__X Tile_X0Y7_FrameData_O[26] VPWR VGND sg13cmos5l_antennanp
XFILLER_492_42 VPWR VGND sg13cmos5l_decap_8
XFILLER_560_188 VPWR VGND sg13cmos5l_decap_4
XFILLER_312_111 VPWR VGND sg13cmos5l_decap_8
XFILLER_88_42 VPWR VGND sg13cmos5l_decap_8
XFILLER_88_75 VPWR VGND sg13cmos5l_fill_1
XANTENNA__2995__X Tile_X0Y5_E1BEG[2] VPWR VGND sg13cmos5l_antennanp
XFILLER_499_0 VPWR VGND sg13cmos5l_decap_8
XFILLER_88_97 VPWR VGND sg13cmos5l_decap_8
XFILLER_111_228 VPWR VGND sg13cmos5l_fill_1
XFILLER_642_56 VPWR VGND sg13cmos5l_decap_8
XFILLER_425_91 VPWR VGND sg13cmos5l_decap_8
XFILLER_361_35 VPWR VGND sg13cmos5l_decap_8
XFILLER_144_70 VPWR VGND sg13cmos5l_decap_8
XFILLER_666_0 VPWR VGND sg13cmos5l_decap_8
XFILLER_615_112 VPWR VGND sg13cmos5l_decap_8
XFILLER_19_7 VPWR VGND sg13cmos5l_decap_8
XFILLER_92_112 VPWR VGND sg13cmos5l_decap_8
XFILLER_92_123 VPWR VGND sg13cmos5l_fill_2
XFILLER_481_151 VPWR VGND sg13cmos5l_decap_8
XFILLER_280_202 VPWR VGND sg13cmos5l_decap_8
X_1060_ _1060_/Q Tile_X0Y0_FrameData[7] VGND VPWR Tile_X0Y9_FrameStrobe[3] latch
XFILLER_511_49 VPWR VGND sg13cmos5l_decap_8
XFILLER_379_111 VPWR VGND sg13cmos5l_decap_4
XFILLER_230_28 VPWR VGND sg13cmos5l_decap_8
XFILLER_33_212 VPWR VGND sg13cmos5l_decap_8
XFILLER_178_217 VPWR VGND sg13cmos5l_decap_4
XFILLER_178_228 VPWR VGND sg13cmos5l_fill_1
XFILLER_667_42 VPWR VGND sg13cmos5l_decap_8
X_4750_ _4750_/X Tile_X0Y8_WW4END[9] AXI_M_SOC_RDATA14 _4809_/X _4787_/X _0547_/Q
+ _0546_/Q VPWR VGND sg13cmos5l_mux4_1
X_1962_ _1962_/Q Tile_X0Y4_FrameData[27] VGND VPWR Tile_X0Y9_FrameStrobe[1] latch
XFILLER_386_21 VPWR VGND sg13cmos5l_decap_8
X_3701_ AXI_M_SOC_WDATA11 Tile_X0Y7_WW4END[3] Tile_X0Y7_WW4END[11] Tile_X0Y7_W6END[11]
+ _4695_/X _0225_/Q _0224_/Q VPWR VGND sg13cmos5l_mux4_1
X_0913_ _0913_/Q Tile_X0Y9_FrameData[14] VGND VPWR Tile_X0Y9_FrameStrobe[7] latch
X_4681_ _4681_/X _4228_/X _4232_/X _4215_/X _4206_/X _1859_/Q _1858_/Q VPWR VGND sg13cmos5l_mux4_1
X_1893_ _1893_/Q Tile_X0Y3_FrameData[4] VGND VPWR Tile_X0Y9_FrameStrobe[6] latch
X_3632_ Tile_X0Y9_S4BEG[10] _3632_/A VPWR VGND sg13cmos5l_buf_1
X_0844_ _0844_/Q Tile_X0Y9_FrameData[19] VGND VPWR Tile_X0Y9_FrameStrobe[5] latch
XFILLER_536_35 VPWR VGND sg13cmos5l_decap_8
XFILLER_551_133 VPWR VGND sg13cmos5l_decap_4
XFILLER_319_70 VPWR VGND sg13cmos5l_fill_2
XFILLER_551_144 VPWR VGND sg13cmos5l_decap_4
XFILLER_146_169 VPWR VGND sg13cmos5l_decap_8
XFILLER_683_63 VPWR VGND sg13cmos5l_decap_8
X_3563_ Tile_X0Y9_EE4BEG[9] _4873_/X VPWR VGND sg13cmos5l_buf_1
XFILLER_255_14 VPWR VGND sg13cmos5l_decap_8
XANTENNA__3066__X Tile_X0Y5_FrameData_O[25] VPWR VGND sg13cmos5l_antennanp
X_0775_ _0775_/Q Tile_X0Y9_FrameData[24] VGND VPWR Tile_X0Y9_FrameStrobe[3] latch
XFILLER_161_139 VPWR VGND sg13cmos5l_fill_1
X_2514_ _2514_/Q Tile_X0Y6_FrameData[21] VGND VPWR Tile_X0Y9_FrameStrobe[2] latch
XFILLER_154_191 VPWR VGND sg13cmos5l_fill_1
X_3494_ Tile_X0Y1_E6BEG[4] _3968_/X VPWR VGND sg13cmos5l_buf_1
XFILLER_45_0 VPWR VGND sg13cmos5l_fill_1
X_2445_ _2445_/Q Tile_X0Y6_FrameData[26] VGND VPWR Tile_X0Y9_FrameStrobe[0] latch
XFILLER_449_148 VPWR VGND sg13cmos5l_decap_8
XFILLER_405_28 VPWR VGND sg13cmos5l_decap_8
XFILLER_552_56 VPWR VGND sg13cmos5l_decap_8
XFILLER_335_91 VPWR VGND sg13cmos5l_decap_4
X_2376_ _2376_/Q Tile_X0Y5_FrameData[29] VGND VPWR Tile_X0Y9_FrameStrobe[6] latch
XFILLER_271_35 VPWR VGND sg13cmos5l_decap_8
XFILLER_68_142 VPWR VGND sg13cmos5l_decap_8
XFILLER_606_112 VPWR VGND sg13cmos5l_decap_8
X_4115_ _4115_/X _4575_/X _4579_/X _4583_/X _4559_/X _2662_/Q _2661_/Q VPWR VGND sg13cmos5l_mux4_1
X_1327_ _1327_/Q Tile_X0Y1_FrameData[10] VGND VPWR Tile_X0Y9_FrameStrobe[4] latch
XFILLER_702_59 VPWR VGND sg13cmos5l_decap_8
X_1258_ _1258_/Q Tile_X0Y1_FrameData[15] VGND VPWR Tile_X0Y9_FrameStrobe[2] latch
X_4046_ _4046_/X Tile_X0Y2_W2MID[1] AXI_M_SOC_AWREADY _4099_/X _4098_/X _1581_/Q _1580_/Q
+ VPWR VGND sg13cmos5l_mux4_1
XFILLER_421_49 VPWR VGND sg13cmos5l_decap_8
XFILLER_204_84 VPWR VGND sg13cmos5l_decap_8
XFILLER_621_126 VPWR VGND sg13cmos5l_fill_2
XFILLER_472_195 VPWR VGND sg13cmos5l_decap_8
XFILLER_17_49 VPWR VGND sg13cmos5l_decap_8
XFILLER_140_28 VPWR VGND sg13cmos5l_decap_8
X_0209_ _0209_/Q Tile_X0Y7_FrameData[14] VGND VPWR Tile_X0Y9_FrameStrobe[1] latch
X_1189_ _1189_/Q Tile_X0Y1_FrameData[20] VGND VPWR Tile_X0Y9_FrameStrobe[0] latch
XFILLER_169_228 VPWR VGND sg13cmos5l_fill_1
XFILLER_574_203 VPWR VGND sg13cmos5l_decap_8
XFILLER_577_42 VPWR VGND sg13cmos5l_decap_8
XFILLER_385_136 VPWR VGND sg13cmos5l_decap_8
XFILLER_33_59 VPWR VGND sg13cmos5l_decap_8
XFILLER_296_21 VPWR VGND sg13cmos5l_decap_8
X_4879_ _4879_/X Tile_X0Y9_WW4END[0] AXI_M_SOC_RDATA0 _4916_/X _4901_/X _0785_/Q _0784_/Q
+ VPWR VGND sg13cmos5l_mux4_1
XFILLER_326_214 VPWR VGND sg13cmos5l_decap_8
XFILLER_123_7 VPWR VGND sg13cmos5l_decap_8
XFILLER_296_98 VPWR VGND sg13cmos5l_decap_8
XFILLER_446_35 VPWR VGND sg13cmos5l_decap_8
XFILLER_137_147 VPWR VGND sg13cmos5l_decap_8
XFILLER_229_70 VPWR VGND sg13cmos5l_decap_8
XFILLER_688_126 VPWR VGND sg13cmos5l_decap_8
XFILLER_593_63 VPWR VGND sg13cmos5l_decap_8
XFILLER_165_14 VPWR VGND sg13cmos5l_decap_8
XFILLER_3_105 VPWR VGND sg13cmos5l_decap_4
XFILLER_492_7 VPWR VGND sg13cmos5l_decap_8
XFILLER_315_28 VPWR VGND sg13cmos5l_decap_8
XANTENNA__3704__X AXI_M_SOC_WDATA14 VPWR VGND sg13cmos5l_antennanp
XFILLER_462_56 VPWR VGND sg13cmos5l_decap_8
XFILLER_245_91 VPWR VGND sg13cmos5l_decap_8
XFILLER_58_45 VPWR VGND sg13cmos5l_decap_8
XFILLER_455_107 VPWR VGND sg13cmos5l_fill_2
XFILLER_181_35 VPWR VGND sg13cmos5l_decap_8
XFILLER_59_153 VPWR VGND sg13cmos5l_decap_8
XFILLER_331_49 VPWR VGND sg13cmos5l_decap_8
XFILLER_114_84 VPWR VGND sg13cmos5l_decap_8
XFILLER_74_77 VPWR VGND sg13cmos5l_decap_8
XFILLER_215_140 VPWR VGND sg13cmos5l_decap_8
XFILLER_215_151 VPWR VGND sg13cmos5l_fill_2
XFILLER_90_21 VPWR VGND sg13cmos5l_decap_8
XFILLER_487_42 VPWR VGND sg13cmos5l_decap_8
XFILLER_247_0 VPWR VGND sg13cmos5l_decap_8
XFILLER_376_136 VPWR VGND sg13cmos5l_decap_8
XFILLER_414_0 VPWR VGND sg13cmos5l_decap_8
XFILLER_637_56 VPWR VGND sg13cmos5l_decap_8
XFILLER_23_70 VPWR VGND sg13cmos5l_decap_8
XFILLER_356_35 VPWR VGND sg13cmos5l_decap_8
XFILLER_139_70 VPWR VGND sg13cmos5l_decap_8
XFILLER_679_137 VPWR VGND sg13cmos5l_fill_1
XFILLER_99_63 VPWR VGND sg13cmos5l_decap_8
XFILLER_332_228 VPWR VGND sg13cmos5l_fill_1
X_0560_ _0560_/Q Tile_X0Y8_FrameData[15] VGND VPWR Tile_X0Y9_FrameStrobe[4] latch
XFILLER_506_49 VPWR VGND sg13cmos5l_decap_8
XFILLER_297_132 VPWR VGND sg13cmos5l_fill_2
XFILLER_653_77 VPWR VGND sg13cmos5l_decap_8
XFILLER_225_28 VPWR VGND sg13cmos5l_decap_8
XFILLER_151_161 VPWR VGND sg13cmos5l_fill_2
X_0491_ _0491_/Q Tile_X0Y8_FrameData[20] VGND VPWR Tile_X0Y9_FrameStrobe[2] latch
XFILLER_372_56 VPWR VGND sg13cmos5l_decap_8
XANTENNA__3614__X Tile_X0Y9_S2BEGb[0] VPWR VGND sg13cmos5l_antennanp
XFILLER_297_176 VPWR VGND sg13cmos5l_decap_8
X_2230_ _2230_/Q Tile_X0Y5_FrameData[15] VGND VPWR Tile_X0Y9_FrameStrobe[1] latch
X_2161_ _2161_/Q Tile_X0Y4_FrameData[20] VGND VPWR Tile_X0Y9_FrameStrobe[7] latch
X_1112_ _1112_/Q Tile_X0Y0_FrameData[19] VGND VPWR Tile_X0Y9_FrameStrobe[5] latch
XFILLER_65_134 VPWR VGND sg13cmos5l_decap_8
X_2092_ _2092_/Q Tile_X0Y4_FrameData[25] VGND VPWR Tile_X0Y9_FrameStrobe[5] latch
XFILLER_241_49 VPWR VGND sg13cmos5l_decap_8
XFILLER_602_70 VPWR VGND sg13cmos5l_decap_8
X_1043_ _1043_/Q Tile_X0Y0_FrameData[24] VGND VPWR Tile_X0Y9_FrameStrobe[3] latch
XFILLER_206_140 VPWR VGND sg13cmos5l_decap_8
XFILLER_0_63 VPWR VGND sg13cmos5l_decap_8
XFILLER_678_63 VPWR VGND sg13cmos5l_decap_8
XFILLER_556_203 VPWR VGND sg13cmos5l_decap_8
X_4802_ _4802_/X _4781_/X Tile_X0Y9_N4END[6] _4780_/X _0075_/X _0467_/Q _0466_/Q VPWR
+ VGND sg13cmos5l_mux4_1
XFILLER_397_42 VPWR VGND sg13cmos5l_decap_8
X_2994_ Tile_X0Y5_E1BEG[1] _4369_/X VPWR VGND sg13cmos5l_buf_1
X_4733_ _4733_/X Tile_X0Y8_W2MID[2] AXI_M_SOC_RDATA13 _4789_/X _4788_/X _0581_/Q _0580_/Q
+ VPWR VGND sg13cmos5l_mux4_1
X_1945_ _1945_/Q Tile_X0Y4_FrameData[12] VGND VPWR Tile_X0Y9_FrameStrobe[0] latch
XFILLER_571_228 VPWR VGND sg13cmos5l_fill_1
XFILLER_308_214 VPWR VGND sg13cmos5l_fill_1
XFILLER_119_114 VPWR VGND sg13cmos5l_fill_1
XFILLER_547_56 VPWR VGND sg13cmos5l_decap_8
XFILLER_509_185 VPWR VGND sg13cmos5l_fill_2
XFILLER_713_211 VPWR VGND sg13cmos5l_decap_4
X_4664_ _4664_/X Tile_X0Y6_W1END[2] Tile_X0Y6_W6END[10] _4582_/X _4542_/X _2655_/Q
+ _2654_/Q VPWR VGND sg13cmos5l_mux4_1
X_1876_ _1876_/Q Tile_X0Y3_FrameData[21] VGND VPWR Tile_X0Y9_FrameStrobe[6] latch
XFILLER_694_84 VPWR VGND sg13cmos5l_decap_8
XFILLER_266_35 VPWR VGND sg13cmos5l_decap_8
X_3615_ Tile_X0Y9_S2BEGb[1] _4933_/X VPWR VGND sg13cmos5l_buf_1
X_0827_ _0827_/Q Tile_X0Y9_FrameData[4] VGND VPWR Tile_X0Y9_FrameStrobe[4] latch
X_4595_ _4595_/X Tile_X0Y8_W2MID[2] Tile_X0Y8_W2END[2] Tile_X0Y8_W6END[2] _4788_/X
+ _0653_/Q _0652_/Q VPWR VGND sg13cmos5l_mux4_1
XFILLER_390_194 VPWR VGND sg13cmos5l_decap_8
X_3546_ Tile_X0Y9_E6BEG[4] _4884_/X VPWR VGND sg13cmos5l_buf_1
X_0758_ _0758_/Q Tile_X0Y9_FrameData[9] VGND VPWR Tile_X0Y9_FrameStrobe[2] latch
XFILLER_477_210 VPWR VGND sg13cmos5l_fill_2
XFILLER_416_49 VPWR VGND sg13cmos5l_decap_8
XFILLER_563_77 VPWR VGND sg13cmos5l_decap_8
XFILLER_135_28 VPWR VGND sg13cmos5l_decap_8
XFILLER_713_14 VPWR VGND sg13cmos5l_decap_8
XFILLER_88_215 VPWR VGND sg13cmos5l_fill_1
XFILLER_142_161 VPWR VGND sg13cmos5l_decap_8
X_3477_ Tile_X0Y1_EE4BEG[3] _3951_/X VPWR VGND sg13cmos5l_buf_1
X_0689_ _0689_/Q Tile_X0Y9_FrameData[14] VGND VPWR Tile_X0Y9_FrameStrobe[0] latch
XFILLER_288_165 VPWR VGND sg13cmos5l_decap_8
XFILLER_282_56 VPWR VGND sg13cmos5l_decap_8
XANTENNA__3524__X Tile_X0Y9_E1BEG[2] VPWR VGND sg13cmos5l_antennanp
X_2428_ _2428_/Q Tile_X0Y5_FrameData[9] VGND VPWR Tile_X0Y9_FrameStrobe[7] latch
XFILLER_56_101 VPWR VGND sg13cmos5l_decap_8
X_2359_ _2359_/Q Tile_X0Y5_FrameData[14] VGND VPWR Tile_X0Y9_FrameStrobe[5] latch
XFILLER_151_49 VPWR VGND sg13cmos5l_decap_8
XFILLER_512_70 VPWR VGND sg13cmos5l_decap_8
XFILLER_460_132 VPWR VGND sg13cmos5l_decap_4
X_4029_ _4029_/X Tile_X0Y3_W2MID[3] Tile_X0Y3_W2END[3] Tile_X0Y3_W6END[3] _4210_/X
+ _1909_/Q _1908_/Q VPWR VGND sg13cmos5l_mux4_1
XFILLER_71_126 VPWR VGND sg13cmos5l_decap_8
XFILLER_588_63 VPWR VGND sg13cmos5l_decap_8
XFILLER_44_47 VPWR VGND sg13cmos5l_decap_8
XFILLER_602_192 VPWR VGND sg13cmos5l_decap_8
XFILLER_240_7 VPWR VGND sg13cmos5l_decap_8
XFILLER_212_154 VPWR VGND sg13cmos5l_decap_8
XFILLER_338_7 VPWR VGND sg13cmos5l_decap_8
XFILLER_100_42 VPWR VGND sg13cmos5l_decap_8
XANTENNA__0107__Y AXI_M_SOC_ARLEN2 VPWR VGND sg13cmos5l_antennanp
XFILLER_562_206 VPWR VGND sg13cmos5l_fill_2
XFILLER_212_198 VPWR VGND sg13cmos5l_fill_1
XFILLER_562_217 VPWR VGND sg13cmos5l_fill_2
XFILLER_373_128 VPWR VGND sg13cmos5l_decap_8
XFILLER_60_35 VPWR VGND sg13cmos5l_decap_8
XFILLER_562_228 VPWR VGND sg13cmos5l_fill_1
XFILLER_457_56 VPWR VGND sg13cmos5l_decap_8
XFILLER_100_86 VPWR VGND sg13cmos5l_fill_1
XFILLER_505_7 VPWR VGND sg13cmos5l_decap_8
XFILLER_176_35 VPWR VGND sg13cmos5l_decap_8
XFILLER_125_106 VPWR VGND sg13cmos5l_fill_2
XFILLER_180_223 VPWR VGND sg13cmos5l_decap_4
XFILLER_381_183 VPWR VGND sg13cmos5l_fill_2
XFILLER_326_49 VPWR VGND sg13cmos5l_decap_8
XFILLER_623_14 VPWR VGND sg13cmos5l_decap_8
XFILLER_279_154 VPWR VGND sg13cmos5l_decap_8
XFILLER_69_77 VPWR VGND sg13cmos5l_decap_8
XANTENNA__3434__X Tile_X0Y4_FrameData_O[25] VPWR VGND sg13cmos5l_antennanp
XFILLER_192_56 VPWR VGND sg13cmos5l_decap_4
XFILLER_133_194 VPWR VGND sg13cmos5l_decap_4
XFILLER_617_218 VPWR VGND sg13cmos5l_decap_8
XFILLER_294_124 VPWR VGND sg13cmos5l_decap_8
XFILLER_85_21 VPWR VGND sg13cmos5l_decap_8
XFILLER_197_0 VPWR VGND sg13cmos5l_decap_8
XFILLER_703_91 VPWR VGND sg13cmos5l_decap_8
XFILLER_85_87 VPWR VGND sg13cmos5l_decap_4
XFILLER_422_70 VPWR VGND sg13cmos5l_decap_8
XFILLER_85_98 VPWR VGND sg13cmos5l_decap_8
XFILLER_640_210 VPWR VGND sg13cmos5l_fill_2
XFILLER_436_195 VPWR VGND sg13cmos5l_decap_8
XFILLER_364_0 VPWR VGND sg13cmos5l_decap_8
XFILLER_640_221 VPWR VGND sg13cmos5l_fill_1
XFILLER_18_70 VPWR VGND sg13cmos5l_decap_8
XFILLER_18_81 VPWR VGND sg13cmos5l_fill_1
XFILLER_62_126 VPWR VGND sg13cmos5l_decap_8
XFILLER_396_209 VPWR VGND sg13cmos5l_decap_8
XFILLER_597_169 VPWR VGND sg13cmos5l_decap_8
XFILLER_600_118 VPWR VGND sg13cmos5l_decap_4
XFILLER_498_63 VPWR VGND sg13cmos5l_decap_8
XFILLER_451_187 VPWR VGND sg13cmos5l_decap_8
XFILLER_538_203 VPWR VGND sg13cmos5l_decap_8
XFILLER_531_0 VPWR VGND sg13cmos5l_decap_8
XFILLER_629_0 VPWR VGND sg13cmos5l_decap_8
XFILLER_349_147 VPWR VGND sg13cmos5l_decap_8
XFILLER_648_77 VPWR VGND sg13cmos5l_decap_8
XFILLER_86_7 VPWR VGND sg13cmos5l_decap_8
XFILLER_367_56 VPWR VGND sg13cmos5l_decap_8
XANTENNA__3609__X Tile_X0Y9_S2BEG[3] VPWR VGND sg13cmos5l_antennanp
X_1730_ _1730_/Q Tile_X0Y3_FrameData[7] VGND VPWR Tile_X0Y9_FrameStrobe[1] latch
XFILLER_506_133 VPWR VGND sg13cmos5l_decap_8
XFILLER_664_21 VPWR VGND sg13cmos5l_decap_8
X_1661_ _1661_/Q Tile_X0Y2_FrameData[20] VGND VPWR Tile_X0Y9_FrameStrobe[7] latch
XFILLER_305_217 VPWR VGND sg13cmos5l_decap_8
XFILLER_710_203 VPWR VGND sg13cmos5l_decap_8
XFILLER_305_228 VPWR VGND sg13cmos5l_fill_1
X_3400_ Tile_X0Y2_E2BEG[3] _4043_/X VPWR VGND sg13cmos5l_buf_1
X_0612_ _0612_/Q Tile_X0Y8_FrameData[27] VGND VPWR Tile_X0Y9_FrameStrobe[6] latch
X_4380_ _4380_/X Tile_X0Y5_W2END[7] AXI_M_SOC_RRESP1 _4467_/X _4428_/X _2343_/Q _2342_/Q
+ VPWR VGND sg13cmos5l_mux4_1
X_1592_ _1592_/Q Tile_X0Y2_FrameData[25] VGND VPWR Tile_X0Y9_FrameStrobe[5] latch
XFILLER_236_49 VPWR VGND sg13cmos5l_decap_8
XFILLER_459_221 VPWR VGND sg13cmos5l_decap_8
X_3331_ Tile_X0Y2_FrameData_O[2] Tile_X0Y2_FrameData[2] VPWR VGND sg13cmos5l_buf_1
XFILLER_383_77 VPWR VGND sg13cmos5l_decap_8
X_0543_ _0543_/Q Tile_X0Y8_FrameData[0] VGND VPWR Tile_X0Y9_FrameStrobe[3] latch
XFILLER_533_14 VPWR VGND sg13cmos5l_decap_8
XFILLER_124_172 VPWR VGND sg13cmos5l_fill_2
XANTENNA__3344__X Tile_X0Y2_FrameData_O[15] VPWR VGND sg13cmos5l_antennanp
XFILLER_419_118 VPWR VGND sg13cmos5l_fill_2
X_3262_ Tile_X0Y0_FrameData_O[30] Tile_X0Y0_FrameData[30] VPWR VGND sg13cmos5l_buf_1
XFILLER_474_213 VPWR VGND sg13cmos5l_decap_8
X_0474_ _0474_/Q Tile_X0Y8_FrameData[5] VGND VPWR Tile_X0Y9_FrameStrobe[1] latch
X_2213_ _2213_/Q Tile_X0Y5_FrameData[0] VGND VPWR Tile_X0Y9_FrameStrobe[0] latch
XFILLER_680_97 VPWR VGND sg13cmos5l_decap_8
X_3193_ Tile_X0Y0_N2BEGb[1] _3891_/X VPWR VGND sg13cmos5l_buf_1
XFILLER_427_140 VPWR VGND sg13cmos5l_decap_8
XFILLER_285_179 VPWR VGND sg13cmos5l_decap_8
XFILLER_613_91 VPWR VGND sg13cmos5l_decap_8
XFILLER_226_213 VPWR VGND sg13cmos5l_decap_4
X_2144_ _2144_/Q Tile_X0Y4_FrameData[5] VGND VPWR Tile_X0Y9_FrameStrobe[6] latch
XFILLER_332_70 VPWR VGND sg13cmos5l_decap_4
X_2075_ _2075_/Q Tile_X0Y4_FrameData[10] VGND VPWR Tile_X0Y9_FrameStrobe[4] latch
XFILLER_689_95 VPWR VGND sg13cmos5l_decap_8
XFILLER_241_227 VPWR VGND sg13cmos5l_fill_2
X_1026_ _1026_/Q Tile_X0Y0_FrameData[9] VGND VPWR Tile_X0Y9_FrameStrobe[2] latch
XFILLER_53_159 VPWR VGND sg13cmos5l_decap_8
XFILLER_529_225 VPWR VGND sg13cmos5l_decap_4
XFILLER_201_63 VPWR VGND sg13cmos5l_decap_8
XFILLER_61_181 VPWR VGND sg13cmos5l_decap_8
XFILLER_14_28 VPWR VGND sg13cmos5l_decap_8
XFILLER_558_77 VPWR VGND sg13cmos5l_decap_8
XFILLER_708_14 VPWR VGND sg13cmos5l_decap_8
X_2977_ Tile_X0Y8_FrameData_O[17] Tile_X0Y8_FrameData[17] VPWR VGND sg13cmos5l_buf_1
XANTENNA__3519__X Tile_X0Y1_E1BEG[1] VPWR VGND sg13cmos5l_antennanp
XFILLER_277_56 VPWR VGND sg13cmos5l_decap_8
XFILLER_147_220 VPWR VGND sg13cmos5l_fill_1
X_4716_ _4716_/X Tile_X0Y8_W1END[0] Tile_X0Y8_WW4END[12] Tile_X0Y8_W6END[4] _4800_/X
+ _0611_/Q _0610_/Q VPWR VGND sg13cmos5l_mux4_1
XFILLER_348_180 VPWR VGND sg13cmos5l_decap_8
X_1928_ _1928_/Q Tile_X0Y4_FrameData[29] VGND VPWR Tile_X0Y9_FrameStrobe[0] latch
XFILLER_698_210 VPWR VGND sg13cmos5l_fill_2
XFILLER_574_21 VPWR VGND sg13cmos5l_decap_8
X_4647_ _4647_/X Tile_X0Y9_N4END[11] _0053_/X _4692_/X _4696_/X _0265_/Q _0264_/Q
+ VPWR VGND sg13cmos5l_mux4_1
XFILLER_30_27 VPWR VGND sg13cmos5l_decap_8
X_1859_ _1859_/Q Tile_X0Y3_FrameData[6] VGND VPWR Tile_X0Y9_FrameStrobe[5] latch
XFILLER_574_98 VPWR VGND sg13cmos5l_decap_8
X_4578_ _4578_/X _4549_/X Tile_X0Y9_N4END[14] _4548_/X _0155_/X _2475_/Q _2474_/Q
+ VPWR VGND sg13cmos5l_mux4_1
XFILLER_146_49 VPWR VGND sg13cmos5l_decap_8
XFILLER_507_70 VPWR VGND sg13cmos5l_decap_8
XFILLER_122_109 VPWR VGND sg13cmos5l_decap_8
XFILLER_512_169 VPWR VGND sg13cmos5l_fill_2
XFILLER_293_77 VPWR VGND sg13cmos5l_decap_8
XFILLER_115_150 VPWR VGND sg13cmos5l_decap_8
X_3529_ Tile_X0Y9_E2BEG[3] _4851_/X VPWR VGND sg13cmos5l_buf_1
XFILLER_443_14 VPWR VGND sg13cmos5l_decap_8
XANTENNA__3254__X Tile_X0Y0_FrameData_O[22] VPWR VGND sg13cmos5l_antennanp
XFILLER_590_42 VPWR VGND sg13cmos5l_decap_8
XFILLER_276_168 VPWR VGND sg13cmos5l_decap_4
XFILLER_190_7 VPWR VGND sg13cmos5l_decap_8
XFILLER_130_175 VPWR VGND sg13cmos5l_decap_8
XFILLER_29_112 VPWR VGND sg13cmos5l_decap_8
XFILLER_291_105 VPWR VGND sg13cmos5l_decap_8
XFILLER_288_7 VPWR VGND sg13cmos5l_decap_8
XFILLER_681_165 VPWR VGND sg13cmos5l_decap_4
XFILLER_523_91 VPWR VGND sg13cmos5l_fill_2
XFILLER_681_176 VPWR VGND sg13cmos5l_decap_8
XFILLER_217_213 VPWR VGND sg13cmos5l_fill_2
XFILLER_480_227 VPWR VGND sg13cmos5l_fill_2
XFILLER_418_184 VPWR VGND sg13cmos5l_fill_2
XFILLER_242_70 VPWR VGND sg13cmos5l_decap_8
XFILLER_55_35 VPWR VGND sg13cmos5l_decap_8
XFILLER_44_104 VPWR VGND sg13cmos5l_decap_4
XFILLER_455_7 VPWR VGND sg13cmos5l_decap_8
XFILLER_433_154 VPWR VGND sg13cmos5l_decap_4
XFILLER_599_84 VPWR VGND sg13cmos5l_decap_8
XFILLER_579_147 VPWR VGND sg13cmos5l_decap_8
XFILLER_433_187 VPWR VGND sg13cmos5l_decap_8
XFILLER_594_117 VPWR VGND sg13cmos5l_decap_4
XFILLER_594_128 VPWR VGND sg13cmos5l_fill_2
XFILLER_622_7 VPWR VGND sg13cmos5l_decap_8
XFILLER_111_63 VPWR VGND sg13cmos5l_decap_8
XFILLER_587_191 VPWR VGND sg13cmos5l_decap_8
XFILLER_71_56 VPWR VGND sg13cmos5l_decap_8
XFILLER_618_14 VPWR VGND sg13cmos5l_decap_8
XFILLER_468_99 VPWR VGND sg13cmos5l_decap_8
XANTENNA__3429__X Tile_X0Y4_FrameData_O[20] VPWR VGND sg13cmos5l_antennanp
XFILLER_187_56 VPWR VGND sg13cmos5l_decap_4
XFILLER_354_161 VPWR VGND sg13cmos5l_decap_8
XFILLER_153_201 VPWR VGND sg13cmos5l_fill_2
XFILLER_484_54 VPWR VGND sg13cmos5l_decap_8
XFILLER_112_0 VPWR VGND sg13cmos5l_decap_8
XFILLER_634_35 VPWR VGND sg13cmos5l_decap_8
XFILLER_503_147 VPWR VGND sg13cmos5l_decap_8
XFILLER_417_70 VPWR VGND sg13cmos5l_decap_8
XFILLER_353_14 VPWR VGND sg13cmos5l_decap_8
XANTENNA__3164__X Tile_X0Y4_E6BEG[1] VPWR VGND sg13cmos5l_antennanp
XFILLER_310_220 VPWR VGND sg13cmos5l_fill_2
XFILLER_96_42 VPWR VGND sg13cmos5l_decap_8
XFILLER_481_0 VPWR VGND sg13cmos5l_decap_8
XFILLER_579_0 VPWR VGND sg13cmos5l_decap_8
XFILLER_503_28 VPWR VGND sg13cmos5l_decap_8
XFILLER_282_105 VPWR VGND sg13cmos5l_decap_8
XFILLER_267_179 VPWR VGND sg13cmos5l_fill_2
XFILLER_121_197 VPWR VGND sg13cmos5l_fill_2
XFILLER_650_56 VPWR VGND sg13cmos5l_decap_8
XFILLER_409_151 VPWR VGND sg13cmos5l_decap_4
XFILLER_433_91 VPWR VGND sg13cmos5l_decap_8
XFILLER_409_162 VPWR VGND sg13cmos5l_fill_2
X_0190_ _0190_/Q Tile_X0Y7_FrameData[1] VGND VPWR Tile_X0Y9_FrameStrobe[0] latch
XFILLER_152_70 VPWR VGND sg13cmos5l_decap_8
XFILLER_424_154 VPWR VGND sg13cmos5l_decap_8
XFILLER_659_21 VPWR VGND sg13cmos5l_decap_8
XFILLER_424_187 VPWR VGND sg13cmos5l_fill_2
XFILLER_302_95 VPWR VGND sg13cmos5l_fill_1
X_2900_ Tile_X0Y6_FrameData_O[21] Tile_X0Y6_FrameData[21] VPWR VGND sg13cmos5l_buf_1
XFILLER_50_129 VPWR VGND sg13cmos5l_fill_1
X_3880_ _3880_/X _3851_/X Tile_X0Y0_W6END[3] Tile_X0Y0_S1END[3] _3880_/A3 _0941_/Q
+ _1178_/Q VPWR VGND sg13cmos5l_mux4_1
XFILLER_659_98 VPWR VGND sg13cmos5l_decap_8
X_2831_ Tile_X0Y6_E1BEG[0] _4492_/X VPWR VGND sg13cmos5l_buf_1
XFILLER_378_77 VPWR VGND sg13cmos5l_decap_8
XFILLER_528_14 VPWR VGND sg13cmos5l_decap_8
XANTENNA__3339__X Tile_X0Y2_FrameData_O[10] VPWR VGND sg13cmos5l_antennanp
XFILLER_526_228 VPWR VGND sg13cmos5l_fill_1
XFILLER_675_42 VPWR VGND sg13cmos5l_decap_8
X_2762_ Tile_X0Y3_FrameData_O[20] Tile_X0Y3_FrameData[20] VPWR VGND sg13cmos5l_buf_1
XFILLER_394_21 VPWR VGND sg13cmos5l_decap_8
X_4501_ _4501_/X Tile_X0Y6_W2MID[2] AXI_M_SOC_RDATA29 _4557_/X _4556_/X _2605_/Q _2604_/Q
+ VPWR VGND sg13cmos5l_mux4_1
X_1713_ _1713_/Q Tile_X0Y3_FrameData[24] VGND VPWR Tile_X0Y9_FrameStrobe[1] latch
XFILLER_144_201 VPWR VGND sg13cmos5l_fill_1
X_2693_ _2693_/Q Tile_X0Y6_FrameData[2] VGND VPWR Tile_X0Y9_FrameStrobe[7] latch
XFILLER_608_91 VPWR VGND sg13cmos5l_decap_8
X_4432_ _4432_/X _4357_/X _4473_/X _4472_/X _4356_/X _2201_/Q _2200_/Q VPWR VGND sg13cmos5l_mux4_1
XFILLER_360_120 VPWR VGND sg13cmos5l_decap_8
X_1644_ _1644_/Q Tile_X0Y2_FrameData[5] VGND VPWR Tile_X0Y9_FrameStrobe[6] latch
XFILLER_394_98 VPWR VGND sg13cmos5l_fill_1
XFILLER_544_35 VPWR VGND sg13cmos5l_decap_8
XFILLER_6_84 VPWR VGND sg13cmos5l_decap_8
XFILLER_104_109 VPWR VGND sg13cmos5l_decap_8
XFILLER_691_63 VPWR VGND sg13cmos5l_decap_8
X_4363_ _4363_/X Tile_X0Y6_W2MID[2] Tile_X0Y6_W2END[2] Tile_X0Y6_W6END[2] _4556_/X
+ _2677_/Q _2676_/Q VPWR VGND sg13cmos5l_mux4_1
XFILLER_263_14 VPWR VGND sg13cmos5l_decap_8
XANTENNA__3074__X Tile_X0Y4_E2BEGb[0] VPWR VGND sg13cmos5l_antennanp
X_1575_ _1575_/Q Tile_X0Y2_FrameData[10] VGND VPWR Tile_X0Y9_FrameStrobe[4] latch
XFILLER_648_140 VPWR VGND sg13cmos5l_decap_4
XFILLER_258_102 VPWR VGND sg13cmos5l_fill_1
X_3314_ Tile_X0Y4_EE4BEG[2] _4274_/X VPWR VGND sg13cmos5l_buf_1
X_0526_ _0526_/Q Tile_X0Y8_FrameData[17] VGND VPWR Tile_X0Y9_FrameStrobe[3] latch
X_4294_ _4294_/X AXI_M_SOC_BRESP0 _4341_/X _4345_/X _4317_/X _2025_/Q _2024_/Q VPWR
+ VGND sg13cmos5l_mux4_1
XFILLER_648_195 VPWR VGND sg13cmos5l_fill_2
XFILLER_112_164 VPWR VGND sg13cmos5l_fill_2
X_3245_ Tile_X0Y0_FrameData_O[13] Tile_X0Y0_FrameData[13] VPWR VGND sg13cmos5l_buf_1
XFILLER_413_28 VPWR VGND sg13cmos5l_decap_8
X_0457_ _0457_/Q Tile_X0Y8_FrameData[22] VGND VPWR Tile_X0Y9_FrameStrobe[1] latch
XFILLER_273_105 VPWR VGND sg13cmos5l_decap_8
XFILLER_258_179 VPWR VGND sg13cmos5l_decap_8
XFILLER_560_56 VPWR VGND sg13cmos5l_decap_8
XFILLER_343_91 VPWR VGND sg13cmos5l_decap_8
X_3176_ Tile_X0Y0_N4BEG[0] _3176_/A VPWR VGND sg13cmos5l_buf_1
X_0388_ _0388_/Q Tile_X0Y7_FrameData[27] VGND VPWR Tile_X0Y9_FrameStrobe[7] latch
XFILLER_266_190 VPWR VGND sg13cmos5l_fill_2
X_2127_ _2127_/Q Tile_X0Y4_FrameData[22] VGND VPWR Tile_X0Y9_FrameStrobe[6] latch
XFILLER_26_137 VPWR VGND sg13cmos5l_decap_8
XFILLER_569_21 VPWR VGND sg13cmos5l_decap_8
XFILLER_281_182 VPWR VGND sg13cmos5l_decap_8
X_2058_ _2058_/Q Tile_X0Y4_FrameData[27] VGND VPWR Tile_X0Y9_FrameStrobe[4] latch
XFILLER_212_84 VPWR VGND sg13cmos5l_decap_8
XFILLER_25_49 VPWR VGND sg13cmos5l_decap_8
X_1009_ _1009_/Q Tile_X0Y0_FrameData[26] VGND VPWR Tile_X0Y9_FrameStrobe[2] latch
XFILLER_430_168 VPWR VGND sg13cmos5l_decap_8
XFILLER_569_98 VPWR VGND sg13cmos5l_decap_8
XFILLER_34_181 VPWR VGND sg13cmos5l_fill_1
XFILLER_288_77 VPWR VGND sg13cmos5l_decap_8
XFILLER_438_14 VPWR VGND sg13cmos5l_decap_8
XANTENNA__3249__X Tile_X0Y0_FrameData_O[17] VPWR VGND sg13cmos5l_antennanp
XFILLER_585_42 VPWR VGND sg13cmos5l_decap_8
XFILLER_41_59 VPWR VGND sg13cmos5l_decap_8
XFILLER_343_109 VPWR VGND sg13cmos5l_fill_1
XFILLER_518_91 VPWR VGND sg13cmos5l_fill_2
XFILLER_203_7 VPWR VGND sg13cmos5l_decap_8
XFILLER_454_35 VPWR VGND sg13cmos5l_decap_8
XFILLER_237_70 VPWR VGND sg13cmos5l_decap_8
XFILLER_351_175 VPWR VGND sg13cmos5l_decap_8
XFILLER_173_14 VPWR VGND sg13cmos5l_decap_8
XFILLER_497_168 VPWR VGND sg13cmos5l_decap_8
XFILLER_639_140 VPWR VGND sg13cmos5l_decap_8
XFILLER_604_49 VPWR VGND sg13cmos5l_decap_8
XFILLER_572_7 VPWR VGND sg13cmos5l_decap_8
XFILLER_323_28 VPWR VGND sg13cmos5l_decap_8
XFILLER_106_63 VPWR VGND sg13cmos5l_decap_8
XFILLER_654_154 VPWR VGND sg13cmos5l_decap_8
XFILLER_66_34 VPWR VGND sg13cmos5l_decap_8
XFILLER_470_56 VPWR VGND sg13cmos5l_decap_8
XFILLER_106_85 VPWR VGND sg13cmos5l_fill_2
XANTENNA__3712__X AXI_M_SOC_WDATA22 VPWR VGND sg13cmos5l_antennanp
XFILLER_72_210 VPWR VGND sg13cmos5l_fill_2
XFILLER_479_21 VPWR VGND sg13cmos5l_decap_8
XFILLER_17_159 VPWR VGND sg13cmos5l_decap_4
XFILLER_122_84 VPWR VGND sg13cmos5l_decap_8
XFILLER_32_107 VPWR VGND sg13cmos5l_decap_8
XFILLER_82_77 VPWR VGND sg13cmos5l_decap_8
XFILLER_709_133 VPWR VGND sg13cmos5l_decap_8
XFILLER_629_35 VPWR VGND sg13cmos5l_decap_8
XFILLER_198_77 VPWR VGND sg13cmos5l_decap_8
XFILLER_374_201 VPWR VGND sg13cmos5l_decap_4
XFILLER_575_161 VPWR VGND sg13cmos5l_decap_8
XFILLER_348_14 VPWR VGND sg13cmos5l_decap_8
XANTENNA__3159__X Tile_X0Y7_FrameData_O[29] VPWR VGND sg13cmos5l_antennanp
XFILLER_319_128 VPWR VGND sg13cmos5l_decap_8
XFILLER_327_0 VPWR VGND sg13cmos5l_decap_8
XFILLER_495_42 VPWR VGND sg13cmos5l_decap_8
XANTENNA__2998__X Tile_X0Y5_E2BEG[1] VPWR VGND sg13cmos5l_antennanp
XFILLER_327_183 VPWR VGND sg13cmos5l_decap_8
XFILLER_645_56 VPWR VGND sg13cmos5l_decap_8
XFILLER_428_91 VPWR VGND sg13cmos5l_decap_8
XFILLER_364_35 VPWR VGND sg13cmos5l_decap_8
XFILLER_147_70 VPWR VGND sg13cmos5l_decap_8
XFILLER_696_0 VPWR VGND sg13cmos5l_decap_8
XFILLER_692_216 VPWR VGND sg13cmos5l_fill_1
X_1360_ _1360_/Q Tile_X0Y1_FrameData[9] VGND VPWR Tile_X0Y9_FrameStrobe[5] latch
XFILLER_429_224 VPWR VGND sg13cmos5l_decap_4
XFILLER_514_49 VPWR VGND sg13cmos5l_decap_8
X_0311_ _0311_/Q Tile_X0Y7_FrameData[8] VGND VPWR Tile_X0Y9_FrameStrobe[4] latch
XFILLER_661_77 VPWR VGND sg13cmos5l_decap_8
XFILLER_233_28 VPWR VGND sg13cmos5l_decap_8
X_1291_ _1291_/Q Tile_X0Y1_FrameData[14] VGND VPWR Tile_X0Y9_FrameStrobe[3] latch
XFILLER_645_154 VPWR VGND sg13cmos5l_decap_8
XFILLER_380_56 VPWR VGND sg13cmos5l_decap_8
XANTENNA__3622__X Tile_X0Y9_S4BEG[0] VPWR VGND sg13cmos5l_antennanp
XFILLER_163_91 VPWR VGND sg13cmos5l_decap_8
X_3030_ Tile_X0Y5_EE4BEG[5] _4393_/X VPWR VGND sg13cmos5l_buf_1
XFILLER_444_227 VPWR VGND sg13cmos5l_fill_2
X_0242_ _0242_/Q Tile_X0Y7_FrameData[13] VGND VPWR Tile_X0Y9_FrameStrobe[2] latch
X_0173_ _0173_/Q Tile_X0Y7_FrameData[18] VGND VPWR Tile_X0Y9_FrameStrobe[0] latch
XFILLER_63_221 VPWR VGND sg13cmos5l_fill_1
XFILLER_389_21 VPWR VGND sg13cmos5l_decap_8
XFILLER_263_182 VPWR VGND sg13cmos5l_decap_8
XFILLER_412_113 VPWR VGND sg13cmos5l_decap_8
XFILLER_610_70 VPWR VGND sg13cmos5l_decap_8
X_3932_ _3932_/X Tile_X0Y1_W2MID[7] AXI_M_SOC_ARREADY _3989_/X _3988_/X _1345_/Q _1344_/Q
+ VPWR VGND sg13cmos5l_mux4_1
XFILLER_539_35 VPWR VGND sg13cmos5l_decap_8
X_3863_ _3863_/X _3851_/X _0078_/X Tile_X0Y0_S1END[3] Tile_X0Y0_S4END[3] _0965_/Q
+ _0964_/Q VPWR VGND sg13cmos5l_mux4_1
XFILLER_686_63 VPWR VGND sg13cmos5l_decap_8
XFILLER_566_161 VPWR VGND sg13cmos5l_decap_8
XFILLER_258_14 VPWR VGND sg13cmos5l_decap_8
XANTENNA__3069__X Tile_X0Y5_FrameData_O[28] VPWR VGND sg13cmos5l_antennanp
XFILLER_715_125 VPWR VGND sg13cmos5l_decap_8
X_2814_ Tile_X0Y3_E2BEG[4] _4152_/X VPWR VGND sg13cmos5l_buf_1
X_3794_ _3794_/X Tile_X0Y0_W1END[1] Tile_X0Y0_WW4END[1] Tile_X0Y0_W6END[9] _3882_/X
+ _1150_/Q _1149_/Q VPWR VGND sg13cmos5l_mux4_1
XFILLER_176_167 VPWR VGND sg13cmos5l_decap_8
XFILLER_75_0 VPWR VGND sg13cmos5l_decap_8
XFILLER_318_150 VPWR VGND sg13cmos5l_fill_1
XFILLER_380_215 VPWR VGND sg13cmos5l_decap_8
X_2745_ Tile_X0Y3_FrameData_O[3] Tile_X0Y3_FrameData[3] VPWR VGND sg13cmos5l_buf_1
XFILLER_581_175 VPWR VGND sg13cmos5l_decap_8
XFILLER_408_28 VPWR VGND sg13cmos5l_decap_8
XFILLER_191_126 VPWR VGND sg13cmos5l_decap_4
XFILLER_117_223 VPWR VGND sg13cmos5l_decap_4
XFILLER_581_197 VPWR VGND sg13cmos5l_decap_8
XFILLER_555_56 VPWR VGND sg13cmos5l_decap_8
XFILLER_338_91 VPWR VGND sg13cmos5l_decap_8
X_2676_ _2676_/Q Tile_X0Y6_FrameData[19] VGND VPWR Tile_X0Y9_FrameStrobe[7] latch
XFILLER_274_35 VPWR VGND sg13cmos5l_decap_8
X_4415_ _4415_/X AXI_M_SOC_RRESP1 _4451_/X _4455_/X _4428_/X _2273_/Q _2272_/Q VPWR
+ VGND sg13cmos5l_mux4_1
X_1627_ _1627_/Q Tile_X0Y2_FrameData[22] VGND VPWR Tile_X0Y9_FrameStrobe[6] latch
XFILLER_278_208 VPWR VGND sg13cmos5l_fill_2
XFILLER_494_105 VPWR VGND sg13cmos5l_decap_8
X_4346_ _4346_/X _4308_/X _0160_/X _4307_/X _0110_/X _1961_/Q _1960_/Q VPWR VGND sg13cmos5l_mux4_1
X_1558_ _1558_/Q Tile_X0Y2_FrameData[27] VGND VPWR Tile_X0Y9_FrameStrobe[4] latch
XFILLER_424_49 VPWR VGND sg13cmos5l_decap_8
XFILLER_207_84 VPWR VGND sg13cmos5l_decap_8
XFILLER_571_77 VPWR VGND sg13cmos5l_decap_8
XFILLER_100_101 VPWR VGND sg13cmos5l_decap_8
X_0509_ _0509_/Q Tile_X0Y8_FrameData[2] VGND VPWR Tile_X0Y9_FrameStrobe[2] latch
XFILLER_143_28 VPWR VGND sg13cmos5l_decap_8
XFILLER_98_195 VPWR VGND sg13cmos5l_fill_1
X_4277_ _4277_/X Tile_X0Y4_WW4END[10] AXI_M_SOC_BRESP1 _4346_/X _4317_/X _2059_/Q
+ _2058_/Q VPWR VGND sg13cmos5l_mux4_1
X_1489_ _1489_/Q Tile_X0Y2_FrameData[0] VGND VPWR Tile_X0Y9_FrameStrobe[1] latch
XANTENNA__3532__X Tile_X0Y9_E2BEG[6] VPWR VGND sg13cmos5l_antennanp
XFILLER_290_56 VPWR VGND sg13cmos5l_decap_8
X_3228_ Tile_X0Y0_FrameStrobe_O[16] Tile_X0Y9_FrameStrobe[16] VPWR VGND sg13cmos5l_buf_1
XFILLER_100_189 VPWR VGND sg13cmos5l_decap_8
X_3159_ Tile_X0Y7_FrameData_O[29] Tile_X0Y7_FrameData[29] VPWR VGND sg13cmos5l_buf_1
XFILLER_651_168 VPWR VGND sg13cmos5l_decap_8
XFILLER_450_208 VPWR VGND sg13cmos5l_decap_8
XFILLER_36_37 VPWR VGND sg13cmos5l_decap_8
XFILLER_299_21 VPWR VGND sg13cmos5l_decap_8
XFILLER_254_171 VPWR VGND sg13cmos5l_decap_8
XFILLER_549_117 VPWR VGND sg13cmos5l_decap_8
XFILLER_520_70 VPWR VGND sg13cmos5l_decap_8
XFILLER_153_7 VPWR VGND sg13cmos5l_decap_8
XFILLER_449_35 VPWR VGND sg13cmos5l_decap_8
XFILLER_596_63 VPWR VGND sg13cmos5l_decap_8
XFILLER_168_14 VPWR VGND sg13cmos5l_decap_8
XFILLER_22_162 VPWR VGND sg13cmos5l_decap_4
XFILLER_320_7 VPWR VGND sg13cmos5l_decap_8
XFILLER_167_145 VPWR VGND sg13cmos5l_fill_1
XFILLER_418_7 VPWR VGND sg13cmos5l_decap_8
XFILLER_167_167 VPWR VGND sg13cmos5l_decap_8
XFILLER_706_147 VPWR VGND sg13cmos5l_decap_8
XFILLER_529_90 VPWR VGND sg13cmos5l_fill_1
XFILLER_182_104 VPWR VGND sg13cmos5l_fill_2
XANTENNA__0115__Y AXI_M_SOC_ARSIZE0 VPWR VGND sg13cmos5l_antennanp
XFILLER_572_175 VPWR VGND sg13cmos5l_decap_8
XFILLER_318_28 VPWR VGND sg13cmos5l_decap_8
XFILLER_248_80 VPWR VGND sg13cmos5l_fill_2
XFILLER_465_56 VPWR VGND sg13cmos5l_fill_1
XFILLER_182_148 VPWR VGND sg13cmos5l_fill_1
XANTENNA__3707__X AXI_M_SOC_WDATA17 VPWR VGND sg13cmos5l_antennanp
XFILLER_659_202 VPWR VGND sg13cmos5l_fill_2
XFILLER_465_89 VPWR VGND sg13cmos5l_fill_1
XFILLER_324_153 VPWR VGND sg13cmos5l_fill_2
XFILLER_184_35 VPWR VGND sg13cmos5l_decap_8
XFILLER_485_105 VPWR VGND sg13cmos5l_decap_8
XANTENNA__0131__X AXI_M_SOC_AWSIZE1 VPWR VGND sg13cmos5l_antennanp
XFILLER_674_216 VPWR VGND sg13cmos5l_fill_1
XFILLER_485_127 VPWR VGND sg13cmos5l_fill_1
XFILLER_485_149 VPWR VGND sg13cmos5l_decap_4
XFILLER_334_49 VPWR VGND sg13cmos5l_decap_8
XFILLER_117_84 VPWR VGND sg13cmos5l_fill_2
XFILLER_481_77 VPWR VGND sg13cmos5l_decap_8
XFILLER_631_14 VPWR VGND sg13cmos5l_decap_8
XFILLER_77_77 VPWR VGND sg13cmos5l_decap_8
XANTENNA__3442__X Tile_X0Y1_FrameData_O[0] VPWR VGND sg13cmos5l_antennanp
XFILLER_493_182 VPWR VGND sg13cmos5l_decap_8
XFILLER_93_21 VPWR VGND sg13cmos5l_decap_8
XFILLER_277_0 VPWR VGND sg13cmos5l_decap_8
XFILLER_642_168 VPWR VGND sg13cmos5l_decap_8
XFILLER_252_119 VPWR VGND sg13cmos5l_fill_2
XFILLER_711_91 VPWR VGND sg13cmos5l_decap_8
XFILLER_595_201 VPWR VGND sg13cmos5l_fill_1
XFILLER_430_70 VPWR VGND sg13cmos5l_decap_8
XFILLER_444_0 VPWR VGND sg13cmos5l_decap_8
XFILLER_26_70 VPWR VGND sg13cmos5l_decap_8
XFILLER_260_174 VPWR VGND sg13cmos5l_fill_1
XFILLER_359_35 VPWR VGND sg13cmos5l_decap_8
XFILLER_13_140 VPWR VGND sg13cmos5l_fill_2
XFILLER_158_112 VPWR VGND sg13cmos5l_decap_8
XFILLER_611_0 VPWR VGND sg13cmos5l_decap_8
XFILLER_709_0 VPWR VGND sg13cmos5l_decap_8
XFILLER_13_184 VPWR VGND sg13cmos5l_fill_2
X_0860_ _0860_/Q Tile_X0Y9_FrameData[3] VGND VPWR Tile_X0Y9_FrameStrobe[5] latch
XFILLER_509_49 VPWR VGND sg13cmos5l_decap_8
XFILLER_362_204 VPWR VGND sg13cmos5l_fill_2
XFILLER_158_189 VPWR VGND sg13cmos5l_fill_2
XFILLER_656_77 VPWR VGND sg13cmos5l_decap_8
XFILLER_228_28 VPWR VGND sg13cmos5l_decap_8
X_0791_ _0791_/Q Tile_X0Y9_FrameData[8] VGND VPWR Tile_X0Y9_FrameStrobe[3] latch
XFILLER_375_56 VPWR VGND sg13cmos5l_decap_8
XANTENNA__3617__X Tile_X0Y9_S2BEGb[3] VPWR VGND sg13cmos5l_antennanp
XFILLER_158_91 VPWR VGND sg13cmos5l_decap_8
X_2530_ _2530_/Q Tile_X0Y6_FrameData[5] VGND VPWR Tile_X0Y9_FrameStrobe[2] latch
XFILLER_672_21 VPWR VGND sg13cmos5l_decap_8
XFILLER_181_170 VPWR VGND sg13cmos5l_decap_8
X_2461_ _2461_/Q Tile_X0Y6_FrameData[10] VGND VPWR Tile_X0Y9_FrameStrobe[0] latch
XFILLER_315_197 VPWR VGND sg13cmos5l_decap_4
X_4200_ _4200_/X Tile_X0Y4_W1END[2] Tile_X0Y4_W6END[6] _4350_/X _4306_/X _2177_/Q
+ _2176_/Q VPWR VGND sg13cmos5l_mux4_1
X_1412_ _1412_/Q Tile_X0Y1_FrameData[21] VGND VPWR Tile_X0Y9_FrameStrobe[7] latch
XFILLER_476_127 VPWR VGND sg13cmos5l_fill_2
X_2392_ _2392_/Q Tile_X0Y5_FrameData[13] VGND VPWR Tile_X0Y9_FrameStrobe[6] latch
XFILLER_244_49 VPWR VGND sg13cmos5l_decap_8
XFILLER_605_70 VPWR VGND sg13cmos5l_decap_8
XFILLER_469_190 VPWR VGND sg13cmos5l_decap_8
XFILLER_330_178 VPWR VGND sg13cmos5l_decap_8
X_4131_ _4131_/X Tile_X0Y4_W2MID[6] Tile_X0Y4_W2END[6] Tile_X0Y4_W6END[6] _4315_/X
+ _2171_/Q _2170_/Q VPWR VGND sg13cmos5l_mux4_1
XFILLER_330_189 VPWR VGND sg13cmos5l_fill_2
X_1343_ _1343_/Q Tile_X0Y1_FrameData[26] VGND VPWR Tile_X0Y9_FrameStrobe[5] latch
XFILLER_541_14 VPWR VGND sg13cmos5l_decap_8
XFILLER_95_121 VPWR VGND sg13cmos5l_decap_8
XFILLER_491_119 VPWR VGND sg13cmos5l_decap_8
XFILLER_3_63 VPWR VGND sg13cmos5l_decap_8
XANTENNA__3352__X Tile_X0Y2_FrameData_O[23] VPWR VGND sg13cmos5l_antennanp
XFILLER_618_165 VPWR VGND sg13cmos5l_fill_1
XFILLER_417_205 VPWR VGND sg13cmos5l_decap_8
X_4062_ _4062_/X Tile_X0Y2_WW4END[9] AXI_M_SOC_AWREADY _4125_/X _4099_/X _1549_/Q
+ _1548_/Q VPWR VGND sg13cmos5l_mux4_1
X_1274_ _1274_/Q Tile_X0Y1_FrameData[31] VGND VPWR Tile_X0Y9_FrameStrobe[3] latch
XFILLER_228_149 VPWR VGND sg13cmos5l_decap_8
X_3013_ Tile_X0Y5_E6BEG[0] _4404_/X VPWR VGND sg13cmos5l_buf_1
X_0225_ _0225_/Q Tile_X0Y7_FrameData[30] VGND VPWR Tile_X0Y9_FrameStrobe[2] latch
XFILLER_621_91 VPWR VGND sg13cmos5l_decap_8
X_0156_ _0156_/X _4447_/X _4448_/X _1354_/Q VPWR VGND sg13cmos5l_mux2_1
XFILLER_397_123 VPWR VGND sg13cmos5l_decap_4
X_0087_ _0087_/X _4218_/X _4219_/X _0383_/Q VPWR VGND sg13cmos5l_mux2_1
XFILLER_697_84 VPWR VGND sg13cmos5l_decap_8
XFILLER_400_116 VPWR VGND sg13cmos5l_decap_4
XFILLER_269_35 VPWR VGND sg13cmos5l_decap_8
XFILLER_400_127 VPWR VGND sg13cmos5l_decap_8
X_3915_ _3915_/X _4122_/X _4126_/X _4107_/X _4101_/X _1643_/Q _1642_/Q VPWR VGND sg13cmos5l_mux4_1
X_4895_ _4895_/X Tile_X0Y9_N1END[3] Tile_X0Y9_W6END[3] _4899_/X _4895_/A3 _0673_/Q
+ _0928_/Q VPWR VGND sg13cmos5l_mux4_1
X_3846_ _3846_/X Tile_X0Y0_W2MID[6] _3882_/X _3886_/X _3854_/X _1013_/Q _1012_/Q VPWR
+ VGND sg13cmos5l_mux4_1
XFILLER_419_49 VPWR VGND sg13cmos5l_decap_8
XFILLER_22_28 VPWR VGND sg13cmos5l_decap_8
XFILLER_164_104 VPWR VGND sg13cmos5l_decap_8
XFILLER_566_77 VPWR VGND sg13cmos5l_decap_8
XFILLER_138_28 VPWR VGND sg13cmos5l_decap_8
XFILLER_716_14 VPWR VGND sg13cmos5l_decap_8
X_3777_ _3777_/X Tile_X0Y0_WW4END[6] Tile_X0Y0_WW4END[14] Tile_X0Y0_W6END[6] _3887_/X
+ _0997_/Q _0996_/Q VPWR VGND sg13cmos5l_mux4_1
XFILLER_554_186 VPWR VGND sg13cmos5l_decap_8
XFILLER_164_137 VPWR VGND sg13cmos5l_decap_8
X_0989_ _0989_/Q Tile_X0Y0_FrameData[14] VGND VPWR Tile_X0Y9_FrameStrobe[1] latch
XANTENNA__3527__X Tile_X0Y9_E2BEG[1] VPWR VGND sg13cmos5l_antennanp
XFILLER_285_56 VPWR VGND sg13cmos5l_decap_8
X_2728_ _4893_/A3 VPWR VGND sg13cmos5l_tielo
XFILLER_582_21 VPWR VGND sg13cmos5l_decap_8
XFILLER_306_164 VPWR VGND sg13cmos5l_decap_8
XFILLER_321_101 VPWR VGND sg13cmos5l_decap_8
XFILLER_306_175 VPWR VGND sg13cmos5l_fill_2
XFILLER_711_161 VPWR VGND sg13cmos5l_decap_8
X_2659_ _2659_/Q Tile_X0Y6_FrameData[4] VGND VPWR Tile_X0Y9_FrameStrobe[6] latch
XFILLER_582_98 VPWR VGND sg13cmos5l_decap_8
XFILLER_154_49 VPWR VGND sg13cmos5l_decap_8
XFILLER_515_70 VPWR VGND sg13cmos5l_decap_8
X_4329_ _4329_/X _3887_/X _3868_/X _3867_/X _3854_/X _1111_/Q _1110_/Q VPWR VGND sg13cmos5l_mux4_1
XFILLER_451_14 VPWR VGND sg13cmos5l_decap_8
XFILLER_219_105 VPWR VGND sg13cmos5l_decap_4
XANTENNA__3262__X Tile_X0Y0_FrameData_O[30] VPWR VGND sg13cmos5l_antennanp
XFILLER_671_219 VPWR VGND sg13cmos5l_fill_2
XFILLER_408_227 VPWR VGND sg13cmos5l_fill_2
XFILLER_601_28 VPWR VGND sg13cmos5l_decap_8
XFILLER_270_7 VPWR VGND sg13cmos5l_decap_8
XFILLER_368_7 VPWR VGND sg13cmos5l_decap_8
XFILLER_227_182 VPWR VGND sg13cmos5l_decap_4
XFILLER_103_42 VPWR VGND sg13cmos5l_decap_8
XFILLER_227_193 VPWR VGND sg13cmos5l_decap_8
XFILLER_250_70 VPWR VGND sg13cmos5l_decap_8
XFILLER_63_35 VPWR VGND sg13cmos5l_decap_8
XFILLER_535_7 VPWR VGND sg13cmos5l_decap_8
XFILLER_179_35 VPWR VGND sg13cmos5l_decap_8
XFILLER_537_109 VPWR VGND sg13cmos5l_fill_2
XFILLER_329_212 VPWR VGND sg13cmos5l_fill_1
XFILLER_702_7 VPWR VGND sg13cmos5l_decap_8
XFILLER_329_49 VPWR VGND sg13cmos5l_decap_8
XFILLER_545_153 VPWR VGND sg13cmos5l_fill_2
XFILLER_155_104 VPWR VGND sg13cmos5l_decap_8
XFILLER_626_14 VPWR VGND sg13cmos5l_decap_8
XFILLER_560_112 VPWR VGND sg13cmos5l_decap_8
XFILLER_560_123 VPWR VGND sg13cmos5l_fill_2
XFILLER_195_56 VPWR VGND sg13cmos5l_decap_8
XANTENNA__3437__X Tile_X0Y4_FrameData_O[28] VPWR VGND sg13cmos5l_antennanp
XFILLER_492_21 VPWR VGND sg13cmos5l_decap_8
XFILLER_88_21 VPWR VGND sg13cmos5l_decap_8
XFILLER_163_192 VPWR VGND sg13cmos5l_fill_1
XFILLER_706_91 VPWR VGND sg13cmos5l_decap_8
XFILLER_5_0 VPWR VGND sg13cmos5l_decap_8
XFILLER_492_98 VPWR VGND sg13cmos5l_decap_8
XFILLER_642_35 VPWR VGND sg13cmos5l_decap_8
XFILLER_425_70 VPWR VGND sg13cmos5l_decap_8
XFILLER_111_218 VPWR VGND sg13cmos5l_fill_2
XFILLER_394_0 VPWR VGND sg13cmos5l_decap_8
XFILLER_361_14 VPWR VGND sg13cmos5l_decap_8
XANTENNA__3172__X Tile_X0Y4_E6BEG[9] VPWR VGND sg13cmos5l_antennanp
XFILLER_265_222 VPWR VGND sg13cmos5l_decap_8
XFILLER_561_0 VPWR VGND sg13cmos5l_decap_8
XFILLER_659_0 VPWR VGND sg13cmos5l_decap_8
XFILLER_511_28 VPWR VGND sg13cmos5l_decap_8
XFILLER_92_146 VPWR VGND sg13cmos5l_decap_8
XFILLER_630_105 VPWR VGND sg13cmos5l_decap_8
XFILLER_615_179 VPWR VGND sg13cmos5l_fill_1
XFILLER_481_174 VPWR VGND sg13cmos5l_fill_1
XFILLER_441_91 VPWR VGND sg13cmos5l_decap_8
XFILLER_481_196 VPWR VGND sg13cmos5l_decap_8
XFILLER_37_80 VPWR VGND sg13cmos5l_decap_8
XFILLER_218_182 VPWR VGND sg13cmos5l_fill_2
XFILLER_233_163 VPWR VGND sg13cmos5l_fill_2
XFILLER_667_21 VPWR VGND sg13cmos5l_decap_8
X_1961_ _1961_/Q Tile_X0Y4_FrameData[28] VGND VPWR Tile_X0Y9_FrameStrobe[1] latch
XFILLER_394_137 VPWR VGND sg13cmos5l_decap_4
X_3700_ AXI_M_SOC_WDATA10 Tile_X0Y7_WW4END[2] Tile_X0Y7_WW4END[10] Tile_X0Y7_W6END[10]
+ _4694_/X _0227_/Q _0226_/Q VPWR VGND sg13cmos5l_mux4_1
X_0912_ _0912_/Q Tile_X0Y9_FrameData[15] VGND VPWR Tile_X0Y9_FrameStrobe[7] latch
X_4680_ _4680_/X Tile_X0Y3_W1END[2] Tile_X0Y3_WW4END[14] Tile_X0Y3_W6END[6] _4224_/X
+ _1859_/Q _1858_/Q VPWR VGND sg13cmos5l_mux4_1
X_1892_ _1892_/Q Tile_X0Y3_FrameData[5] VGND VPWR Tile_X0Y9_FrameStrobe[6] latch
XFILLER_667_98 VPWR VGND sg13cmos5l_decap_8
XFILLER_239_49 VPWR VGND sg13cmos5l_decap_8
X_3631_ Tile_X0Y9_S4BEG[9] _3631_/A VPWR VGND sg13cmos5l_buf_1
X_0843_ _0843_/Q Tile_X0Y9_FrameData[20] VGND VPWR Tile_X0Y9_FrameStrobe[5] latch
XFILLER_536_175 VPWR VGND sg13cmos5l_fill_1
XFILLER_536_14 VPWR VGND sg13cmos5l_decap_8
XANTENNA__3347__X Tile_X0Y2_FrameData_O[18] VPWR VGND sg13cmos5l_antennanp
XFILLER_697_105 VPWR VGND sg13cmos5l_decap_8
XFILLER_536_197 VPWR VGND sg13cmos5l_fill_2
XFILLER_683_42 VPWR VGND sg13cmos5l_decap_8
X_3562_ Tile_X0Y9_EE4BEG[8] _4872_/X VPWR VGND sg13cmos5l_buf_1
X_0774_ _0774_/Q Tile_X0Y9_FrameData[25] VGND VPWR Tile_X0Y9_FrameStrobe[3] latch
X_2513_ _2513_/Q Tile_X0Y6_FrameData[22] VGND VPWR Tile_X0Y9_FrameStrobe[2] latch
X_3493_ Tile_X0Y1_E6BEG[3] _3967_/X VPWR VGND sg13cmos5l_buf_1
XFILLER_638_227 VPWR VGND sg13cmos5l_fill_2
XFILLER_616_91 VPWR VGND sg13cmos5l_decap_8
X_2444_ _2444_/Q Tile_X0Y6_FrameData[27] VGND VPWR Tile_X0Y9_FrameStrobe[0] latch
XFILLER_552_35 VPWR VGND sg13cmos5l_decap_8
XFILLER_335_70 VPWR VGND sg13cmos5l_decap_8
XFILLER_38_0 VPWR VGND sg13cmos5l_decap_4
XFILLER_271_14 VPWR VGND sg13cmos5l_decap_8
X_2375_ _2375_/Q Tile_X0Y5_FrameData[30] VGND VPWR Tile_X0Y9_FrameStrobe[6] latch
XFILLER_68_121 VPWR VGND sg13cmos5l_decap_8
XFILLER_124_19 VPWR VGND sg13cmos5l_decap_8
XANTENNA__3082__X Tile_X0Y7_E1BEG[0] VPWR VGND sg13cmos5l_antennanp
X_4114_ _4114_/X Tile_X0Y6_W1END[3] Tile_X0Y6_WW4END[3] Tile_X0Y6_W6END[11] _4571_/X
+ _2662_/Q _2661_/Q VPWR VGND sg13cmos5l_mux4_1
XFILLER_256_222 VPWR VGND sg13cmos5l_decap_8
X_1326_ _1326_/Q Tile_X0Y1_FrameData[11] VGND VPWR Tile_X0Y9_FrameStrobe[4] latch
XFILLER_702_38 VPWR VGND sg13cmos5l_decap_8
XFILLER_68_198 VPWR VGND sg13cmos5l_decap_8
X_4045_ _4045_/X Tile_X0Y2_W2MID[2] AXI_M_SOC_AWREADY _4101_/X _4100_/X _1583_/Q _1582_/Q
+ VPWR VGND sg13cmos5l_mux4_1
XFILLER_421_28 VPWR VGND sg13cmos5l_decap_8
XFILLER_271_203 VPWR VGND sg13cmos5l_decap_4
XFILLER_204_63 VPWR VGND sg13cmos5l_decap_8
X_1257_ _1257_/Q Tile_X0Y1_FrameData[16] VGND VPWR Tile_X0Y9_FrameStrobe[2] latch
XFILLER_216_119 VPWR VGND sg13cmos5l_decap_8
XFILLER_621_105 VPWR VGND sg13cmos5l_decap_8
XFILLER_17_28 VPWR VGND sg13cmos5l_decap_8
XFILLER_351_91 VPWR VGND sg13cmos5l_decap_8
XFILLER_209_182 VPWR VGND sg13cmos5l_decap_8
X_0208_ _0208_/Q Tile_X0Y7_FrameData[15] VGND VPWR Tile_X0Y9_FrameStrobe[1] latch
X_1188_ _1188_/Q Tile_X0Y1_FrameData[21] VGND VPWR Tile_X0Y9_FrameStrobe[0] latch
X_0139_ AXI_M_SOC_ARLEN0 _0933_/Q _3760_/X VPWR VGND sg13cmos5l_nor2b_1
XFILLER_224_174 VPWR VGND sg13cmos5l_decap_8
XFILLER_577_21 VPWR VGND sg13cmos5l_decap_8
XFILLER_224_196 VPWR VGND sg13cmos5l_fill_2
XFILLER_33_38 VPWR VGND sg13cmos5l_decap_8
XFILLER_220_84 VPWR VGND sg13cmos5l_decap_8
XFILLER_527_120 VPWR VGND sg13cmos5l_decap_8
XFILLER_577_98 VPWR VGND sg13cmos5l_decap_8
XFILLER_149_49 VPWR VGND sg13cmos5l_decap_8
X_4878_ _4878_/X Tile_X0Y9_WW4END[1] AXI_M_SOC_RDATA1 _4917_/X _4903_/X _0787_/Q _0786_/Q
+ VPWR VGND sg13cmos5l_mux4_1
XFILLER_527_153 VPWR VGND sg13cmos5l_fill_1
XFILLER_296_77 VPWR VGND sg13cmos5l_decap_8
XFILLER_137_126 VPWR VGND sg13cmos5l_decap_8
X_3829_ _3829_/X Tile_X0Y0_WW4END[6] Tile_X0Y0_WW4END[7] _3887_/X _3854_/X _1047_/Q
+ _1046_/Q VPWR VGND sg13cmos5l_mux4_1
XFILLER_446_14 VPWR VGND sg13cmos5l_decap_8
XANTENNA__3257__X Tile_X0Y0_FrameData_O[25] VPWR VGND sg13cmos5l_antennanp
XFILLER_393_192 VPWR VGND sg13cmos5l_fill_1
XFILLER_593_42 VPWR VGND sg13cmos5l_decap_8
XFILLER_152_107 VPWR VGND sg13cmos5l_decap_8
XFILLER_116_7 VPWR VGND sg13cmos5l_decap_8
XFILLER_152_118 VPWR VGND sg13cmos5l_fill_2
XFILLER_341_218 VPWR VGND sg13cmos5l_fill_1
XFILLER_495_200 VPWR VGND sg13cmos5l_fill_1
XFILLER_462_35 VPWR VGND sg13cmos5l_decap_8
XFILLER_245_70 VPWR VGND sg13cmos5l_decap_8
XFILLER_160_162 VPWR VGND sg13cmos5l_decap_8
XFILLER_58_24 VPWR VGND sg13cmos5l_decap_8
XFILLER_181_14 VPWR VGND sg13cmos5l_decap_8
XFILLER_485_7 VPWR VGND sg13cmos5l_decap_8
XFILLER_59_132 VPWR VGND sg13cmos5l_decap_8
XFILLER_448_182 VPWR VGND sg13cmos5l_fill_2
XFILLER_612_49 VPWR VGND sg13cmos5l_decap_8
XFILLER_331_28 VPWR VGND sg13cmos5l_decap_8
XFILLER_652_7 VPWR VGND sg13cmos5l_decap_8
XFILLER_207_119 VPWR VGND sg13cmos5l_decap_8
XFILLER_114_63 VPWR VGND sg13cmos5l_decap_8
XFILLER_74_146 VPWR VGND sg13cmos5l_fill_1
XFILLER_262_225 VPWR VGND sg13cmos5l_decap_4
XANTENNA__3720__X AXI_M_SOC_WDATA30 VPWR VGND sg13cmos5l_antennanp
XFILLER_74_168 VPWR VGND sg13cmos5l_decap_4
XFILLER_463_196 VPWR VGND sg13cmos5l_decap_8
XFILLER_74_56 VPWR VGND sg13cmos5l_decap_8
XFILLER_82_190 VPWR VGND sg13cmos5l_fill_2
XFILLER_411_94 VPWR VGND sg13cmos5l_decap_8
XFILLER_215_174 VPWR VGND sg13cmos5l_decap_8
XFILLER_487_21 VPWR VGND sg13cmos5l_decap_8
XFILLER_376_104 VPWR VGND sg13cmos5l_decap_4
XFILLER_565_204 VPWR VGND sg13cmos5l_fill_1
XFILLER_620_182 VPWR VGND sg13cmos5l_fill_2
XFILLER_565_215 VPWR VGND sg13cmos5l_fill_1
XFILLER_130_84 VPWR VGND sg13cmos5l_decap_8
XFILLER_142_0 VPWR VGND sg13cmos5l_decap_8
XFILLER_376_159 VPWR VGND sg13cmos5l_decap_4
XFILLER_487_98 VPWR VGND sg13cmos5l_decap_8
XFILLER_391_107 VPWR VGND sg13cmos5l_decap_8
XFILLER_637_35 VPWR VGND sg13cmos5l_decap_8
XFILLER_356_14 VPWR VGND sg13cmos5l_decap_8
XFILLER_679_105 VPWR VGND sg13cmos5l_decap_4
XANTENNA__3167__X Tile_X0Y4_E6BEG[4] VPWR VGND sg13cmos5l_antennanp
XFILLER_679_116 VPWR VGND sg13cmos5l_decap_4
XFILLER_407_0 VPWR VGND sg13cmos5l_decap_8
XFILLER_99_42 VPWR VGND sg13cmos5l_decap_8
XFILLER_332_207 VPWR VGND sg13cmos5l_decap_4
XFILLER_506_28 VPWR VGND sg13cmos5l_decap_8
XFILLER_694_119 VPWR VGND sg13cmos5l_decap_8
XFILLER_653_56 VPWR VGND sg13cmos5l_decap_8
XFILLER_436_91 VPWR VGND sg13cmos5l_decap_8
XFILLER_97_205 VPWR VGND sg13cmos5l_decap_4
XFILLER_687_182 VPWR VGND sg13cmos5l_fill_1
X_0490_ _0490_/Q Tile_X0Y8_FrameData[21] VGND VPWR Tile_X0Y9_FrameStrobe[2] latch
XFILLER_372_35 VPWR VGND sg13cmos5l_decap_8
XFILLER_155_70 VPWR VGND sg13cmos5l_decap_4
XFILLER_238_211 VPWR VGND sg13cmos5l_fill_1
X_2160_ _2160_/Q Tile_X0Y4_FrameData[21] VGND VPWR Tile_X0Y9_FrameStrobe[7] latch
XFILLER_522_49 VPWR VGND sg13cmos5l_decap_8
XFILLER_305_84 VPWR VGND sg13cmos5l_decap_8
XFILLER_454_130 VPWR VGND sg13cmos5l_decap_8
XFILLER_65_113 VPWR VGND sg13cmos5l_decap_8
X_1111_ _1111_/Q Tile_X0Y0_FrameData[20] VGND VPWR Tile_X0Y9_FrameStrobe[5] latch
XFILLER_253_203 VPWR VGND sg13cmos5l_decap_8
XFILLER_241_28 VPWR VGND sg13cmos5l_decap_8
X_2091_ _2091_/Q Tile_X0Y4_FrameData[26] VGND VPWR Tile_X0Y9_FrameStrobe[5] latch
XANTENNA__3630__X Tile_X0Y9_S4BEG[8] VPWR VGND sg13cmos5l_antennanp
X_1042_ _1042_/Q Tile_X0Y0_FrameData[25] VGND VPWR Tile_X0Y9_FrameStrobe[3] latch
XFILLER_0_42 VPWR VGND sg13cmos5l_decap_8
XFILLER_678_42 VPWR VGND sg13cmos5l_decap_8
XFILLER_321_94 VPWR VGND sg13cmos5l_decap_8
XFILLER_397_21 VPWR VGND sg13cmos5l_decap_8
XFILLER_206_196 VPWR VGND sg13cmos5l_decap_8
X_4801_ _4801_/X _4779_/X Tile_X0Y9_N4END[5] _4778_/X _0076_/X _0469_/Q _0468_/Q VPWR
+ VGND sg13cmos5l_mux4_1
X_2993_ Tile_X0Y5_E1BEG[0] _4368_/X VPWR VGND sg13cmos5l_buf_1
X_1944_ _1944_/Q Tile_X0Y4_FrameData[13] VGND VPWR Tile_X0Y9_FrameStrobe[0] latch
X_4732_ _4732_/X Tile_X0Y8_W2MID[3] AXI_M_SOC_RDATA12 _4791_/X _4790_/X _0583_/Q _0582_/Q
+ VPWR VGND sg13cmos5l_mux4_1
XFILLER_547_35 VPWR VGND sg13cmos5l_decap_8
XFILLER_9_84 VPWR VGND sg13cmos5l_decap_8
X_4663_ _4663_/X Tile_X0Y8_W1END[1] Tile_X0Y8_W6END[5] _4813_/X _4773_/X _0669_/Q
+ _0668_/Q VPWR VGND sg13cmos5l_mux4_1
XFILLER_694_63 VPWR VGND sg13cmos5l_decap_8
XFILLER_266_14 VPWR VGND sg13cmos5l_decap_8
XFILLER_174_221 VPWR VGND sg13cmos5l_decap_8
X_1875_ _1875_/Q Tile_X0Y3_FrameData[22] VGND VPWR Tile_X0Y9_FrameStrobe[6] latch
XANTENNA__3077__X Tile_X0Y4_E2BEGb[3] VPWR VGND sg13cmos5l_antennanp
X_3614_ Tile_X0Y9_S2BEGb[0] _4932_/X VPWR VGND sg13cmos5l_buf_1
X_0826_ _0826_/Q Tile_X0Y9_FrameData[5] VGND VPWR Tile_X0Y9_FrameStrobe[4] latch
X_4594_ _4594_/X Tile_X0Y5_W1END[1] Tile_X0Y5_W2MID[2] Tile_X0Y5_W2END[2] _4431_/X
+ _2385_/Q _2384_/Q VPWR VGND sg13cmos5l_mux4_1
XFILLER_323_218 VPWR VGND sg13cmos5l_decap_8
XFILLER_390_173 VPWR VGND sg13cmos5l_decap_8
X_3545_ Tile_X0Y9_E6BEG[3] _4883_/X VPWR VGND sg13cmos5l_buf_1
XFILLER_416_28 VPWR VGND sg13cmos5l_decap_8
X_0757_ _0757_/Q Tile_X0Y9_FrameData[10] VGND VPWR Tile_X0Y9_FrameStrobe[2] latch
XFILLER_563_56 VPWR VGND sg13cmos5l_decap_8
XFILLER_346_91 VPWR VGND sg13cmos5l_decap_8
XFILLER_142_140 VPWR VGND sg13cmos5l_decap_8
XFILLER_288_133 VPWR VGND sg13cmos5l_fill_1
X_3476_ Tile_X0Y1_EE4BEG[2] _3950_/X VPWR VGND sg13cmos5l_buf_1
X_0688_ _0688_/Q Tile_X0Y9_FrameData[15] VGND VPWR Tile_X0Y9_FrameStrobe[0] latch
XFILLER_288_155 VPWR VGND sg13cmos5l_decap_4
XFILLER_282_35 VPWR VGND sg13cmos5l_decap_8
X_2427_ _2427_/Q Tile_X0Y5_FrameData[10] VGND VPWR Tile_X0Y9_FrameStrobe[7] latch
XFILLER_437_119 VPWR VGND sg13cmos5l_fill_2
XFILLER_288_188 VPWR VGND sg13cmos5l_fill_1
X_2358_ _2358_/Q Tile_X0Y5_FrameData[15] VGND VPWR Tile_X0Y9_FrameStrobe[5] latch
XFILLER_432_49 VPWR VGND sg13cmos5l_decap_8
XFILLER_215_84 VPWR VGND sg13cmos5l_decap_8
XFILLER_28_49 VPWR VGND sg13cmos5l_decap_8
X_1309_ _1309_/Q Tile_X0Y1_FrameData[28] VGND VPWR Tile_X0Y9_FrameStrobe[4] latch
XFILLER_151_28 VPWR VGND sg13cmos5l_decap_8
X_2289_ _2289_/Q Tile_X0Y5_FrameData[20] VGND VPWR Tile_X0Y9_FrameStrobe[3] latch
XANTENNA__3540__X Tile_X0Y9_E2BEGb[6] VPWR VGND sg13cmos5l_antennanp
XFILLER_56_157 VPWR VGND sg13cmos5l_decap_4
XFILLER_445_185 VPWR VGND sg13cmos5l_fill_1
X_4028_ _4028_/X Tile_X0Y0_W1END[0] Tile_X0Y0_W2MID[3] Tile_X0Y0_W2END[3] _3858_/X
+ _1125_/Q _1124_/Q VPWR VGND sg13cmos5l_mux4_1
XFILLER_71_105 VPWR VGND sg13cmos5l_decap_8
XFILLER_588_42 VPWR VGND sg13cmos5l_decap_8
XFILLER_212_133 VPWR VGND sg13cmos5l_decap_8
XFILLER_358_126 VPWR VGND sg13cmos5l_decap_8
XFILLER_547_226 VPWR VGND sg13cmos5l_fill_2
XFILLER_100_21 VPWR VGND sg13cmos5l_decap_8
XFILLER_233_7 VPWR VGND sg13cmos5l_decap_8
XFILLER_60_14 VPWR VGND sg13cmos5l_decap_8
XFILLER_457_35 VPWR VGND sg13cmos5l_decap_8
XFILLER_176_14 VPWR VGND sg13cmos5l_decap_8
XFILLER_366_192 VPWR VGND sg13cmos5l_decap_8
XFILLER_400_7 VPWR VGND sg13cmos5l_decap_8
XFILLER_381_140 VPWR VGND sg13cmos5l_decap_4
XFILLER_180_202 VPWR VGND sg13cmos5l_decap_8
XFILLER_607_49 VPWR VGND sg13cmos5l_decap_8
XANTENNA__0123__Y AXI_M_SOC_ARSIZE2 VPWR VGND sg13cmos5l_antennanp
XFILLER_118_181 VPWR VGND sg13cmos5l_decap_8
XFILLER_326_28 VPWR VGND sg13cmos5l_decap_8
XFILLER_109_63 VPWR VGND sg13cmos5l_decap_8
XFILLER_468_200 VPWR VGND sg13cmos5l_fill_2
XFILLER_473_56 VPWR VGND sg13cmos5l_decap_8
XANTENNA__3715__X AXI_M_SOC_WDATA25 VPWR VGND sg13cmos5l_antennanp
XFILLER_133_140 VPWR VGND sg13cmos5l_decap_8
XFILLER_530_159 VPWR VGND sg13cmos5l_fill_2
XFILLER_279_133 VPWR VGND sg13cmos5l_decap_8
XFILLER_69_56 VPWR VGND sg13cmos5l_decap_8
XFILLER_192_35 VPWR VGND sg13cmos5l_decap_8
XFILLER_428_119 VPWR VGND sg13cmos5l_decap_8
XFILLER_94_208 VPWR VGND sg13cmos5l_decap_8
XFILLER_699_19 VPWR VGND sg13cmos5l_decap_8
XFILLER_436_130 VPWR VGND sg13cmos5l_decap_4
XFILLER_342_49 VPWR VGND sg13cmos5l_decap_8
XFILLER_294_169 VPWR VGND sg13cmos5l_decap_8
XFILLER_703_70 VPWR VGND sg13cmos5l_decap_8
XANTENNA__3450__X Tile_X0Y1_FrameData_O[8] VPWR VGND sg13cmos5l_antennanp
XFILLER_597_104 VPWR VGND sg13cmos5l_fill_1
XFILLER_451_144 VPWR VGND sg13cmos5l_decap_8
XFILLER_597_137 VPWR VGND sg13cmos5l_fill_1
XFILLER_250_206 VPWR VGND sg13cmos5l_decap_4
XFILLER_498_42 VPWR VGND sg13cmos5l_decap_8
XFILLER_357_0 VPWR VGND sg13cmos5l_decap_8
XFILLER_250_217 VPWR VGND sg13cmos5l_decap_4
XFILLER_349_126 VPWR VGND sg13cmos5l_decap_8
XFILLER_203_144 VPWR VGND sg13cmos5l_decap_8
XFILLER_70_182 VPWR VGND sg13cmos5l_decap_8
XFILLER_524_0 VPWR VGND sg13cmos5l_decap_8
XFILLER_648_56 VPWR VGND sg13cmos5l_decap_8
XFILLER_367_35 VPWR VGND sg13cmos5l_decap_8
XFILLER_34_92 VPWR VGND sg13cmos5l_fill_2
XFILLER_506_112 VPWR VGND sg13cmos5l_decap_8
XFILLER_79_7 VPWR VGND sg13cmos5l_decap_8
X_1660_ _1660_/Q Tile_X0Y2_FrameData[21] VGND VPWR Tile_X0Y9_FrameStrobe[7] latch
XFILLER_116_107 VPWR VGND sg13cmos5l_decap_8
XFILLER_517_49 VPWR VGND sg13cmos5l_decap_8
XFILLER_171_224 VPWR VGND sg13cmos5l_decap_4
X_0611_ _0611_/Q Tile_X0Y8_FrameData[28] VGND VPWR Tile_X0Y9_FrameStrobe[6] latch
XFILLER_664_77 VPWR VGND sg13cmos5l_decap_8
XFILLER_506_189 VPWR VGND sg13cmos5l_decap_8
XFILLER_372_195 VPWR VGND sg13cmos5l_decap_8
XFILLER_236_28 VPWR VGND sg13cmos5l_decap_8
X_1591_ _1591_/Q Tile_X0Y2_FrameData[26] VGND VPWR Tile_X0Y9_FrameStrobe[5] latch
XFILLER_109_192 VPWR VGND sg13cmos5l_fill_1
XANTENNA__3625__X Tile_X0Y9_S4BEG[3] VPWR VGND sg13cmos5l_antennanp
XFILLER_383_56 VPWR VGND sg13cmos5l_decap_8
X_3330_ Tile_X0Y2_FrameData_O[1] Tile_X0Y2_FrameData[1] VPWR VGND sg13cmos5l_buf_1
X_0542_ _0542_/Q Tile_X0Y8_FrameData[1] VGND VPWR Tile_X0Y9_FrameStrobe[3] latch
XFILLER_124_162 VPWR VGND sg13cmos5l_fill_2
XFILLER_680_21 VPWR VGND sg13cmos5l_fill_2
XFILLER_675_130 VPWR VGND sg13cmos5l_fill_2
X_3261_ Tile_X0Y0_FrameData_O[29] Tile_X0Y0_FrameData[29] VPWR VGND sg13cmos5l_buf_1
X_0473_ _0473_/Q Tile_X0Y8_FrameData[6] VGND VPWR Tile_X0Y9_FrameStrobe[1] latch
XFILLER_675_174 VPWR VGND sg13cmos5l_decap_8
XFILLER_316_94 VPWR VGND sg13cmos5l_decap_8
XFILLER_680_76 VPWR VGND sg13cmos5l_decap_8
X_2212_ _2212_/Q Tile_X0Y5_FrameData[1] VGND VPWR Tile_X0Y9_FrameStrobe[0] latch
XFILLER_675_196 VPWR VGND sg13cmos5l_fill_1
XFILLER_285_147 VPWR VGND sg13cmos5l_decap_4
X_3192_ Tile_X0Y0_N2BEGb[0] _3889_/X VPWR VGND sg13cmos5l_buf_1
XFILLER_252_49 VPWR VGND sg13cmos5l_decap_8
XFILLER_613_70 VPWR VGND sg13cmos5l_decap_8
X_2143_ _2143_/Q Tile_X0Y4_FrameData[6] VGND VPWR Tile_X0Y9_FrameStrobe[6] latch
XANTENNA__3360__X Tile_X0Y2_FrameData_O[31] VPWR VGND sg13cmos5l_antennanp
XFILLER_427_196 VPWR VGND sg13cmos5l_decap_8
XFILLER_332_82 VPWR VGND sg13cmos5l_fill_2
X_2074_ _2074_/Q Tile_X0Y4_FrameData[11] VGND VPWR Tile_X0Y9_FrameStrobe[4] latch
XFILLER_689_74 VPWR VGND sg13cmos5l_decap_8
XFILLER_53_138 VPWR VGND sg13cmos5l_decap_8
X_1025_ _1025_/Q Tile_X0Y0_FrameData[10] VGND VPWR Tile_X0Y9_FrameStrobe[2] latch
XFILLER_201_42 VPWR VGND sg13cmos5l_decap_8
XFILLER_61_160 VPWR VGND sg13cmos5l_decap_8
XFILLER_558_56 VPWR VGND sg13cmos5l_decap_8
X_2976_ Tile_X0Y8_FrameData_O[16] Tile_X0Y8_FrameData[16] VPWR VGND sg13cmos5l_buf_1
XFILLER_277_35 VPWR VGND sg13cmos5l_decap_8
X_4715_ _4715_/X Tile_X0Y9_W2MID[0] Tile_X0Y9_W2END[0] Tile_X0Y9_W6END[0] _4900_/X
+ _0905_/Q _0904_/Q VPWR VGND sg13cmos5l_mux4_1
X_1927_ _1927_/Q Tile_X0Y4_FrameData[30] VGND VPWR Tile_X0Y9_FrameStrobe[0] latch
X_1858_ _1858_/Q Tile_X0Y3_FrameData[7] VGND VPWR Tile_X0Y9_FrameStrobe[5] latch
X_4646_ _4646_/X Tile_X0Y9_N4END[10] _0054_/X _4693_/X _4697_/X _0267_/Q _0266_/Q
+ VPWR VGND sg13cmos5l_mux4_1
XFILLER_427_49 VPWR VGND sg13cmos5l_decap_8
X_0809_ _0809_/Q Tile_X0Y9_FrameData[22] VGND VPWR Tile_X0Y9_FrameStrobe[4] latch
XFILLER_574_77 VPWR VGND sg13cmos5l_decap_8
XFILLER_363_195 VPWR VGND sg13cmos5l_fill_1
XFILLER_146_28 VPWR VGND sg13cmos5l_decap_8
X_4577_ _4577_/X _4547_/X Tile_X0Y9_N4END[13] _4546_/X _0153_/X _2477_/Q _2476_/Q
+ VPWR VGND sg13cmos5l_mux4_1
X_1789_ _1789_/Q Tile_X0Y3_FrameData[12] VGND VPWR Tile_X0Y9_FrameStrobe[3] latch
XFILLER_293_56 VPWR VGND sg13cmos5l_decap_8
XANTENNA__3535__X Tile_X0Y9_E2BEGb[1] VPWR VGND sg13cmos5l_antennanp
X_3528_ Tile_X0Y9_E2BEG[2] _4850_/X VPWR VGND sg13cmos5l_buf_1
XFILLER_590_21 VPWR VGND sg13cmos5l_decap_8
XFILLER_666_152 VPWR VGND sg13cmos5l_decap_4
X_3459_ Tile_X0Y1_FrameData_O[17] Tile_X0Y1_FrameData[17] VPWR VGND sg13cmos5l_buf_1
XFILLER_465_214 VPWR VGND sg13cmos5l_decap_8
XFILLER_520_192 VPWR VGND sg13cmos5l_decap_8
XFILLER_39_48 VPWR VGND sg13cmos5l_decap_8
XFILLER_276_147 VPWR VGND sg13cmos5l_decap_8
XFILLER_590_98 VPWR VGND sg13cmos5l_decap_8
XFILLER_162_49 VPWR VGND sg13cmos5l_decap_8
XFILLER_681_144 VPWR VGND sg13cmos5l_decap_8
XFILLER_523_70 VPWR VGND sg13cmos5l_decap_8
XFILLER_291_128 VPWR VGND sg13cmos5l_fill_1
XFILLER_183_7 VPWR VGND sg13cmos5l_decap_8
XANTENNA__3270__X Tile_X0Y0_EE4BEG[6] VPWR VGND sg13cmos5l_antennanp
XFILLER_55_14 VPWR VGND sg13cmos5l_decap_8
XFILLER_418_196 VPWR VGND sg13cmos5l_decap_4
XFILLER_29_168 VPWR VGND sg13cmos5l_decap_8
XFILLER_599_63 VPWR VGND sg13cmos5l_decap_8
XFILLER_579_126 VPWR VGND sg13cmos5l_decap_8
XFILLER_433_133 VPWR VGND sg13cmos5l_decap_8
XFILLER_44_116 VPWR VGND sg13cmos5l_fill_2
XFILLER_433_166 VPWR VGND sg13cmos5l_decap_8
XFILLER_350_7 VPWR VGND sg13cmos5l_decap_8
XFILLER_448_7 VPWR VGND sg13cmos5l_decap_8
XFILLER_111_42 VPWR VGND sg13cmos5l_decap_8
XFILLER_52_160 VPWR VGND sg13cmos5l_fill_2
XANTENNA__0118__Y AXI_M_SOC_ARBURST1 VPWR VGND sg13cmos5l_antennanp
XFILLER_71_35 VPWR VGND sg13cmos5l_decap_8
XFILLER_111_86 VPWR VGND sg13cmos5l_fill_1
XFILLER_468_56 VPWR VGND sg13cmos5l_decap_8
XFILLER_615_7 VPWR VGND sg13cmos5l_decap_8
XFILLER_197_165 VPWR VGND sg13cmos5l_fill_1
XFILLER_535_207 VPWR VGND sg13cmos5l_decap_4
XFILLER_187_35 VPWR VGND sg13cmos5l_decap_8
XFILLER_535_218 VPWR VGND sg13cmos5l_fill_2
XFILLER_200_147 VPWR VGND sg13cmos5l_decap_4
XFILLER_138_221 VPWR VGND sg13cmos5l_fill_1
XFILLER_484_33 VPWR VGND sg13cmos5l_decap_8
XFILLER_354_140 VPWR VGND sg13cmos5l_decap_8
XFILLER_337_49 VPWR VGND sg13cmos5l_decap_8
XFILLER_634_14 VPWR VGND sg13cmos5l_decap_8
XFILLER_503_126 VPWR VGND sg13cmos5l_decap_8
XFILLER_649_119 VPWR VGND sg13cmos5l_decap_8
XFILLER_105_0 VPWR VGND sg13cmos5l_decap_8
XANTENNA__3445__X Tile_X0Y1_FrameData_O[3] VPWR VGND sg13cmos5l_antennanp
XFILLER_96_21 VPWR VGND sg13cmos5l_decap_8
XFILLER_456_225 VPWR VGND sg13cmos5l_decap_4
XFILLER_672_133 VPWR VGND sg13cmos5l_fill_2
XFILLER_650_35 VPWR VGND sg13cmos5l_decap_8
XFILLER_433_70 VPWR VGND sg13cmos5l_decap_8
XFILLER_474_0 VPWR VGND sg13cmos5l_decap_8
XFILLER_29_70 VPWR VGND sg13cmos5l_decap_8
XFILLER_208_203 VPWR VGND sg13cmos5l_decap_8
XFILLER_208_214 VPWR VGND sg13cmos5l_fill_1
XFILLER_471_228 VPWR VGND sg13cmos5l_fill_1
XANTENNA__3180__X Tile_X0Y0_N4BEG[4] VPWR VGND sg13cmos5l_antennanp
XFILLER_424_133 VPWR VGND sg13cmos5l_decap_8
XFILLER_641_0 VPWR VGND sg13cmos5l_decap_8
XFILLER_35_138 VPWR VGND sg13cmos5l_fill_1
XFILLER_290_161 VPWR VGND sg13cmos5l_fill_2
XFILLER_302_63 VPWR VGND sg13cmos5l_decap_8
XFILLER_223_228 VPWR VGND sg13cmos5l_fill_1
XFILLER_424_199 VPWR VGND sg13cmos5l_decap_8
XFILLER_45_80 VPWR VGND sg13cmos5l_fill_1
XFILLER_188_110 VPWR VGND sg13cmos5l_decap_8
XFILLER_659_77 VPWR VGND sg13cmos5l_decap_8
XFILLER_188_121 VPWR VGND sg13cmos5l_fill_2
XFILLER_377_221 VPWR VGND sg13cmos5l_decap_8
XFILLER_43_182 VPWR VGND sg13cmos5l_fill_1
XFILLER_378_56 VPWR VGND sg13cmos5l_decap_8
X_2830_ Tile_X0Y4_UserCLKo Tile_X0Y4_UserCLK VPWR VGND sg13cmos5l_buf_1
XFILLER_675_21 VPWR VGND sg13cmos5l_decap_8
XFILLER_593_162 VPWR VGND sg13cmos5l_fill_2
X_2761_ Tile_X0Y3_FrameData_O[19] Tile_X0Y3_FrameData[19] VPWR VGND sg13cmos5l_buf_1
XFILLER_61_90 VPWR VGND sg13cmos5l_decap_8
X_1712_ _1712_/Q Tile_X0Y3_FrameData[25] VGND VPWR Tile_X0Y9_FrameStrobe[1] latch
X_4500_ _4500_/X Tile_X0Y6_W2MID[3] AXI_M_SOC_RDATA28 _4559_/X _4558_/X _2607_/Q _2606_/Q
+ VPWR VGND sg13cmos5l_mux4_1
XFILLER_345_140 VPWR VGND sg13cmos5l_decap_8
X_2692_ _2692_/Q Tile_X0Y6_FrameData[3] VGND VPWR Tile_X0Y9_FrameStrobe[7] latch
XFILLER_675_98 VPWR VGND sg13cmos5l_decap_8
XFILLER_247_49 VPWR VGND sg13cmos5l_decap_8
XFILLER_608_70 VPWR VGND sg13cmos5l_decap_8
XFILLER_144_213 VPWR VGND sg13cmos5l_fill_1
XANTENNA_1 _3674_/X VPWR VGND sg13cmos5l_antennanp
X_4431_ _4431_/X _4363_/X _4479_/X _4478_/X _4362_/X _2195_/Q _2194_/Q VPWR VGND sg13cmos5l_mux4_1
X_1643_ _1643_/Q Tile_X0Y2_FrameData[6] VGND VPWR Tile_X0Y9_FrameStrobe[6] latch
XFILLER_544_14 VPWR VGND sg13cmos5l_decap_8
XANTENNA__3355__X Tile_X0Y2_FrameData_O[26] VPWR VGND sg13cmos5l_antennanp
XFILLER_6_63 VPWR VGND sg13cmos5l_decap_8
XFILLER_695_214 VPWR VGND sg13cmos5l_fill_2
XFILLER_691_42 VPWR VGND sg13cmos5l_decap_8
XFILLER_360_154 VPWR VGND sg13cmos5l_decap_4
X_4362_ _4362_/X Tile_X0Y3_W1END[1] Tile_X0Y3_W2MID[2] Tile_X0Y3_W2END[2] _4208_/X
+ _1871_/Q _1870_/Q VPWR VGND sg13cmos5l_mux4_1
X_1574_ _1574_/Q Tile_X0Y2_FrameData[11] VGND VPWR Tile_X0Y9_FrameStrobe[4] latch
X_3313_ Tile_X0Y4_EE4BEG[1] _4273_/X VPWR VGND sg13cmos5l_buf_1
X_0525_ _0525_/Q Tile_X0Y8_FrameData[18] VGND VPWR Tile_X0Y9_FrameStrobe[3] latch
X_4293_ _4293_/X AXI_M_SOC_BRESP1 _4342_/X _4346_/X _4315_/X _2027_/Q _2026_/Q VPWR
+ VGND sg13cmos5l_mux4_1
XFILLER_258_114 VPWR VGND sg13cmos5l_fill_2
XFILLER_648_174 VPWR VGND sg13cmos5l_decap_8
XFILLER_447_225 VPWR VGND sg13cmos5l_decap_4
XFILLER_58_208 VPWR VGND sg13cmos5l_decap_8
XFILLER_624_91 VPWR VGND sg13cmos5l_decap_8
X_3244_ Tile_X0Y0_FrameData_O[12] Tile_X0Y0_FrameData[12] VPWR VGND sg13cmos5l_buf_1
XFILLER_258_158 VPWR VGND sg13cmos5l_decap_8
X_0456_ _0456_/Q Tile_X0Y8_FrameData[23] VGND VPWR Tile_X0Y9_FrameStrobe[1] latch
XFILLER_560_35 VPWR VGND sg13cmos5l_decap_8
XFILLER_343_70 VPWR VGND sg13cmos5l_decap_8
XFILLER_20_0 VPWR VGND sg13cmos5l_decap_8
XFILLER_112_187 VPWR VGND sg13cmos5l_decap_8
X_3175_ Tile_X0Y0_UserCLKo Tile_X0Y0_UserCLK VPWR VGND sg13cmos5l_buf_1
XFILLER_462_228 VPWR VGND sg13cmos5l_fill_1
XANTENNA__3090__X Tile_X0Y7_E2BEG[4] VPWR VGND sg13cmos5l_antennanp
X_0387_ _0387_/Q Tile_X0Y7_FrameData[28] VGND VPWR Tile_X0Y9_FrameStrobe[7] latch
X_2126_ _2126_/Q Tile_X0Y4_FrameData[23] VGND VPWR Tile_X0Y9_FrameStrobe[6] latch
XFILLER_710_49 VPWR VGND sg13cmos5l_decap_8
XFILLER_281_161 VPWR VGND sg13cmos5l_decap_8
XFILLER_214_217 VPWR VGND sg13cmos5l_decap_4
XFILLER_415_177 VPWR VGND sg13cmos5l_decap_8
X_2057_ _2057_/Q Tile_X0Y4_FrameData[28] VGND VPWR Tile_X0Y9_FrameStrobe[4] latch
XFILLER_212_63 VPWR VGND sg13cmos5l_decap_8
XFILLER_25_28 VPWR VGND sg13cmos5l_decap_8
X_1008_ _1008_/Q Tile_X0Y0_FrameData[27] VGND VPWR Tile_X0Y9_FrameStrobe[2] latch
XFILLER_430_147 VPWR VGND sg13cmos5l_decap_8
XFILLER_569_77 VPWR VGND sg13cmos5l_decap_8
XFILLER_34_160 VPWR VGND sg13cmos5l_decap_8
XFILLER_288_56 VPWR VGND sg13cmos5l_decap_8
XFILLER_34_193 VPWR VGND sg13cmos5l_fill_2
XFILLER_179_187 VPWR VGND sg13cmos5l_fill_2
XFILLER_585_21 VPWR VGND sg13cmos5l_decap_8
X_2959_ Tile_X0Y8_EE4BEG[15] _4759_/X VPWR VGND sg13cmos5l_buf_1
XFILLER_41_38 VPWR VGND sg13cmos5l_decap_8
XFILLER_194_157 VPWR VGND sg13cmos5l_decap_8
XFILLER_194_179 VPWR VGND sg13cmos5l_decap_8
XFILLER_585_98 VPWR VGND sg13cmos5l_decap_8
XFILLER_135_202 VPWR VGND sg13cmos5l_fill_2
XFILLER_336_162 VPWR VGND sg13cmos5l_decap_4
XFILLER_157_49 VPWR VGND sg13cmos5l_decap_8
XFILLER_518_70 VPWR VGND sg13cmos5l_decap_8
XFILLER_540_210 VPWR VGND sg13cmos5l_fill_2
X_4629_ _4629_/X Tile_X0Y7_WW4END[14] AXI_M_SOC_RDATA17 _4698_/X _4670_/X _0301_/Q
+ _0300_/Q VPWR VGND sg13cmos5l_mux4_1
XFILLER_454_14 VPWR VGND sg13cmos5l_decap_8
XANTENNA__3265__X Tile_X0Y0_EE4BEG[1] VPWR VGND sg13cmos5l_antennanp
XFILLER_686_225 VPWR VGND sg13cmos5l_decap_4
XFILLER_351_154 VPWR VGND sg13cmos5l_decap_8
XFILLER_497_147 VPWR VGND sg13cmos5l_decap_8
XFILLER_237_93 VPWR VGND sg13cmos5l_fill_1
XFILLER_9_7 VPWR VGND sg13cmos5l_decap_8
XFILLER_1_215 VPWR VGND sg13cmos5l_fill_2
XFILLER_351_198 VPWR VGND sg13cmos5l_fill_1
XFILLER_604_28 VPWR VGND sg13cmos5l_decap_8
XFILLER_398_7 VPWR VGND sg13cmos5l_decap_8
XFILLER_639_196 VPWR VGND sg13cmos5l_decap_8
XFILLER_106_42 VPWR VGND sg13cmos5l_decap_8
XFILLER_654_133 VPWR VGND sg13cmos5l_decap_8
XFILLER_66_13 VPWR VGND sg13cmos5l_decap_8
XFILLER_470_35 VPWR VGND sg13cmos5l_decap_8
XFILLER_253_70 VPWR VGND sg13cmos5l_decap_8
XFILLER_565_7 VPWR VGND sg13cmos5l_decap_8
XFILLER_470_79 VPWR VGND sg13cmos5l_fill_1
XFILLER_406_111 VPWR VGND sg13cmos5l_decap_8
XFILLER_620_49 VPWR VGND sg13cmos5l_decap_8
XFILLER_403_84 VPWR VGND sg13cmos5l_decap_8
XFILLER_406_177 VPWR VGND sg13cmos5l_decap_8
XFILLER_205_228 VPWR VGND sg13cmos5l_fill_1
XFILLER_122_63 VPWR VGND sg13cmos5l_decap_8
XFILLER_406_188 VPWR VGND sg13cmos5l_fill_2
XFILLER_421_147 VPWR VGND sg13cmos5l_fill_2
XFILLER_82_56 VPWR VGND sg13cmos5l_decap_8
XFILLER_709_112 VPWR VGND sg13cmos5l_decap_8
XFILLER_700_93 VPWR VGND sg13cmos5l_decap_8
XFILLER_629_14 VPWR VGND sg13cmos5l_decap_8
XFILLER_198_56 VPWR VGND sg13cmos5l_decap_8
XFILLER_575_140 VPWR VGND sg13cmos5l_decap_8
XFILLER_185_102 VPWR VGND sg13cmos5l_decap_8
XFILLER_508_207 VPWR VGND sg13cmos5l_fill_2
XFILLER_495_21 VPWR VGND sg13cmos5l_decap_8
XFILLER_374_213 VPWR VGND sg13cmos5l_decap_8
XFILLER_709_189 VPWR VGND sg13cmos5l_decap_8
XFILLER_590_132 VPWR VGND sg13cmos5l_decap_8
XFILLER_40_196 VPWR VGND sg13cmos5l_decap_8
XFILLER_222_0 VPWR VGND sg13cmos5l_decap_8
XFILLER_709_91 VPWR VGND sg13cmos5l_decap_8
XFILLER_495_98 VPWR VGND sg13cmos5l_decap_8
XFILLER_645_35 VPWR VGND sg13cmos5l_decap_8
XFILLER_428_70 VPWR VGND sg13cmos5l_decap_8
XFILLER_364_14 VPWR VGND sg13cmos5l_decap_8
XFILLER_193_190 VPWR VGND sg13cmos5l_decap_8
XANTENNA__3175__X Tile_X0Y0_UserCLKo VPWR VGND sg13cmos5l_antennanp
XFILLER_99_119 VPWR VGND sg13cmos5l_fill_2
XFILLER_591_0 VPWR VGND sg13cmos5l_decap_8
XFILLER_689_0 VPWR VGND sg13cmos5l_decap_8
XFILLER_514_28 VPWR VGND sg13cmos5l_decap_8
XFILLER_429_203 VPWR VGND sg13cmos5l_decap_8
XFILLER_692_228 VPWR VGND sg13cmos5l_fill_1
XFILLER_661_56 VPWR VGND sg13cmos5l_decap_8
XFILLER_444_91 VPWR VGND sg13cmos5l_fill_1
X_0310_ _0310_/Q Tile_X0Y7_FrameData[9] VGND VPWR Tile_X0Y9_FrameStrobe[4] latch
XFILLER_645_133 VPWR VGND sg13cmos5l_decap_8
X_1290_ _1290_/Q Tile_X0Y1_FrameData[15] VGND VPWR Tile_X0Y9_FrameStrobe[3] latch
XFILLER_380_35 VPWR VGND sg13cmos5l_decap_8
X_0241_ _0241_/Q Tile_X0Y7_FrameData[14] VGND VPWR Tile_X0Y9_FrameStrobe[2] latch
XFILLER_248_180 VPWR VGND sg13cmos5l_fill_1
X_0172_ _0172_/Q Tile_X0Y7_FrameData[19] VGND VPWR Tile_X0Y9_FrameStrobe[0] latch
XFILLER_530_49 VPWR VGND sg13cmos5l_decap_8
XFILLER_601_225 VPWR VGND sg13cmos5l_decap_4
XFILLER_389_77 VPWR VGND sg13cmos5l_fill_1
XFILLER_16_160 VPWR VGND sg13cmos5l_fill_2
X_3931_ _3931_/X _3987_/X Tile_X0Y1_WW4END[7] _3986_/X AXI_M_SOC_ARREADY _1347_/Q
+ _1346_/Q VPWR VGND sg13cmos5l_mux4_1
XFILLER_539_14 VPWR VGND sg13cmos5l_decap_8
XFILLER_389_99 VPWR VGND sg13cmos5l_decap_4
XFILLER_686_42 VPWR VGND sg13cmos5l_decap_8
XFILLER_566_140 VPWR VGND sg13cmos5l_decap_8
X_3862_ _3862_/X _3848_/X Tile_X0Y0_W6END[0] Tile_X0Y0_S1END[0] _3862_/A3 _0947_/Q
+ _0946_/Q VPWR VGND sg13cmos5l_mux4_1
XFILLER_715_104 VPWR VGND sg13cmos5l_decap_8
XFILLER_31_174 VPWR VGND sg13cmos5l_fill_2
X_2813_ Tile_X0Y3_E2BEG[3] _4151_/X VPWR VGND sg13cmos5l_buf_1
X_3793_ _3793_/X _3885_/X _3876_/X _3875_/X _3853_/X _1153_/Q _1152_/Q VPWR VGND sg13cmos5l_mux4_1
XFILLER_619_91 VPWR VGND sg13cmos5l_decap_8
XFILLER_581_154 VPWR VGND sg13cmos5l_decap_8
XFILLER_191_105 VPWR VGND sg13cmos5l_decap_8
X_2744_ Tile_X0Y3_FrameData_O[2] Tile_X0Y3_FrameData[2] VPWR VGND sg13cmos5l_buf_1
XFILLER_318_162 VPWR VGND sg13cmos5l_decap_8
XFILLER_555_35 VPWR VGND sg13cmos5l_decap_8
XFILLER_338_70 VPWR VGND sg13cmos5l_decap_8
XFILLER_68_0 VPWR VGND sg13cmos5l_decap_4
X_2675_ _2675_/Q Tile_X0Y6_FrameData[20] VGND VPWR Tile_X0Y9_FrameStrobe[7] latch
XFILLER_274_14 VPWR VGND sg13cmos5l_decap_8
XANTENNA__3085__X Tile_X0Y7_E1BEG[3] VPWR VGND sg13cmos5l_antennanp
X_1626_ _1626_/Q Tile_X0Y2_FrameData[23] VGND VPWR Tile_X0Y9_FrameStrobe[6] latch
X_4414_ _4414_/X AXI_M_SOC_RRESP0 _4452_/X _4456_/X _4429_/X _2275_/Q _2274_/Q VPWR
+ VGND sg13cmos5l_mux4_1
XFILLER_705_49 VPWR VGND sg13cmos5l_decap_8
XFILLER_132_227 VPWR VGND sg13cmos5l_fill_2
XFILLER_424_28 VPWR VGND sg13cmos5l_decap_8
X_1557_ _1557_/Q Tile_X0Y2_FrameData[28] VGND VPWR Tile_X0Y9_FrameStrobe[4] latch
X_4345_ _4345_/X _4305_/X _0158_/X _4304_/X _0111_/X _1963_/Q _1962_/Q VPWR VGND sg13cmos5l_mux4_1
XFILLER_683_228 VPWR VGND sg13cmos5l_fill_1
XFILLER_207_63 VPWR VGND sg13cmos5l_decap_8
XFILLER_571_56 VPWR VGND sg13cmos5l_decap_8
XFILLER_354_91 VPWR VGND sg13cmos5l_decap_8
X_0508_ _0508_/Q Tile_X0Y8_FrameData[3] VGND VPWR Tile_X0Y9_FrameStrobe[2] latch
X_4276_ _4276_/X Tile_X0Y4_WW4END[11] AXI_M_SOC_BRESP0 _4347_/X _4319_/X _2061_/Q
+ _2060_/Q VPWR VGND sg13cmos5l_mux4_1
X_1488_ _1488_/Q Tile_X0Y2_FrameData[1] VGND VPWR Tile_X0Y9_FrameStrobe[1] latch
XFILLER_290_35 VPWR VGND sg13cmos5l_decap_8
X_3227_ Tile_X0Y0_FrameStrobe_O[15] Tile_X0Y9_FrameStrobe[15] VPWR VGND sg13cmos5l_buf_1
X_0439_ _0439_/Q Tile_X0Y8_FrameData[8] VGND VPWR Tile_X0Y9_FrameStrobe[0] latch
XFILLER_435_228 VPWR VGND sg13cmos5l_fill_1
XFILLER_100_168 VPWR VGND sg13cmos5l_decap_8
X_3158_ Tile_X0Y7_FrameData_O[28] Tile_X0Y7_FrameData[28] VPWR VGND sg13cmos5l_buf_1
XFILLER_651_147 VPWR VGND sg13cmos5l_decap_8
XFILLER_440_49 VPWR VGND sg13cmos5l_decap_8
XFILLER_223_84 VPWR VGND sg13cmos5l_decap_8
XFILLER_254_150 VPWR VGND sg13cmos5l_decap_8
X_2109_ _2109_/Q Tile_X0Y4_FrameData[8] VGND VPWR Tile_X0Y9_FrameStrobe[5] latch
X_3089_ Tile_X0Y7_E2BEG[3] _4615_/X VPWR VGND sg13cmos5l_buf_1
XFILLER_299_77 VPWR VGND sg13cmos5l_decap_8
XFILLER_449_14 VPWR VGND sg13cmos5l_decap_8
XFILLER_596_42 VPWR VGND sg13cmos5l_decap_8
XFILLER_146_7 VPWR VGND sg13cmos5l_decap_8
XFILLER_167_113 VPWR VGND sg13cmos5l_decap_8
XFILLER_52_59 VPWR VGND sg13cmos5l_decap_8
XFILLER_22_174 VPWR VGND sg13cmos5l_decap_8
XFILLER_706_126 VPWR VGND sg13cmos5l_decap_8
XFILLER_22_185 VPWR VGND sg13cmos5l_fill_2
XFILLER_572_154 VPWR VGND sg13cmos5l_decap_8
XFILLER_313_7 VPWR VGND sg13cmos5l_decap_8
XFILLER_465_35 VPWR VGND sg13cmos5l_decap_8
XFILLER_182_127 VPWR VGND sg13cmos5l_decap_8
XFILLER_248_70 VPWR VGND sg13cmos5l_fill_2
XFILLER_309_184 VPWR VGND sg13cmos5l_decap_4
XFILLER_184_14 VPWR VGND sg13cmos5l_decap_8
XFILLER_324_165 VPWR VGND sg13cmos5l_fill_1
XFILLER_615_49 VPWR VGND sg13cmos5l_decap_8
XFILLER_682_7 VPWR VGND sg13cmos5l_decap_8
XFILLER_334_28 VPWR VGND sg13cmos5l_decap_8
XFILLER_117_63 VPWR VGND sg13cmos5l_decap_8
XFILLER_674_228 VPWR VGND sg13cmos5l_fill_1
XFILLER_481_56 VPWR VGND sg13cmos5l_decap_8
XFILLER_77_56 VPWR VGND sg13cmos5l_decap_8
XFILLER_493_161 VPWR VGND sg13cmos5l_decap_8
XFILLER_627_177 VPWR VGND sg13cmos5l_fill_2
XFILLER_426_228 VPWR VGND sg13cmos5l_fill_1
XFILLER_642_147 VPWR VGND sg13cmos5l_decap_8
XFILLER_350_49 VPWR VGND sg13cmos5l_decap_8
XFILLER_133_84 VPWR VGND sg13cmos5l_decap_8
XFILLER_711_70 VPWR VGND sg13cmos5l_decap_8
XFILLER_172_0 VPWR VGND sg13cmos5l_decap_8
XFILLER_93_99 VPWR VGND sg13cmos5l_fill_1
XFILLER_260_142 VPWR VGND sg13cmos5l_decap_8
XFILLER_359_14 VPWR VGND sg13cmos5l_decap_8
XFILLER_437_0 VPWR VGND sg13cmos5l_decap_8
XFILLER_13_130 VPWR VGND sg13cmos5l_fill_2
XFILLER_402_180 VPWR VGND sg13cmos5l_decap_8
XFILLER_9_112 VPWR VGND sg13cmos5l_decap_8
XFILLER_509_28 VPWR VGND sg13cmos5l_decap_8
XFILLER_158_157 VPWR VGND sg13cmos5l_decap_4
XFILLER_604_0 VPWR VGND sg13cmos5l_decap_8
XFILLER_9_156 VPWR VGND sg13cmos5l_decap_4
XFILLER_656_56 VPWR VGND sg13cmos5l_decap_8
XFILLER_42_70 VPWR VGND sg13cmos5l_decap_8
XFILLER_439_91 VPWR VGND sg13cmos5l_decap_8
XANTENNA__2802__X Tile_X0Y3_E2BEGb[0] VPWR VGND sg13cmos5l_antennanp
XFILLER_563_165 VPWR VGND sg13cmos5l_decap_8
X_0790_ _0790_/Q Tile_X0Y9_FrameData[9] VGND VPWR Tile_X0Y9_FrameStrobe[3] latch
XFILLER_375_35 VPWR VGND sg13cmos5l_decap_8
XFILLER_362_227 VPWR VGND sg13cmos5l_fill_2
XFILLER_158_81 VPWR VGND sg13cmos5l_fill_2
XFILLER_504_221 VPWR VGND sg13cmos5l_fill_1
XFILLER_315_154 VPWR VGND sg13cmos5l_fill_1
X_2460_ _2460_/Q Tile_X0Y6_FrameData[11] VGND VPWR Tile_X0Y9_FrameStrobe[0] latch
XFILLER_525_49 VPWR VGND sg13cmos5l_decap_8
XFILLER_330_113 VPWR VGND sg13cmos5l_decap_4
XFILLER_181_193 VPWR VGND sg13cmos5l_fill_1
X_1411_ _1411_/Q Tile_X0Y1_FrameData[22] VGND VPWR Tile_X0Y9_FrameStrobe[7] latch
XFILLER_672_77 VPWR VGND sg13cmos5l_decap_8
XFILLER_665_217 VPWR VGND sg13cmos5l_fill_2
XFILLER_244_28 VPWR VGND sg13cmos5l_decap_8
X_2391_ _2391_/Q Tile_X0Y5_FrameData[14] VGND VPWR Tile_X0Y9_FrameStrobe[6] latch
XFILLER_672_88 VPWR VGND sg13cmos5l_fill_2
XFILLER_665_228 VPWR VGND sg13cmos5l_fill_1
XFILLER_391_56 VPWR VGND sg13cmos5l_decap_4
XANTENNA__3633__X Tile_X0Y9_S4BEG[11] VPWR VGND sg13cmos5l_antennanp
X_4130_ _4130_/X Tile_X0Y1_W2MID[6] Tile_X0Y1_W2END[6] Tile_X0Y1_W6END[9] _3991_/X
+ _1379_/Q _1378_/Q VPWR VGND sg13cmos5l_mux4_1
X_1342_ _1342_/Q Tile_X0Y1_FrameData[27] VGND VPWR Tile_X0Y9_FrameStrobe[5] latch
XFILLER_3_42 VPWR VGND sg13cmos5l_decap_8
X_4061_ _4061_/X Tile_X0Y2_WW4END[10] AXI_M_SOC_AWREADY _4126_/X _4101_/X _1551_/Q
+ _1550_/Q VPWR VGND sg13cmos5l_mux4_1
X_1273_ _1273_/Q Tile_X0Y1_FrameData[0] VGND VPWR Tile_X0Y9_FrameStrobe[2] latch
XFILLER_618_188 VPWR VGND sg13cmos5l_fill_1
XFILLER_417_228 VPWR VGND sg13cmos5l_fill_1
X_3012_ Tile_X0Y5_E2BEGb[7] _4387_/X VPWR VGND sg13cmos5l_buf_1
XFILLER_633_136 VPWR VGND sg13cmos5l_decap_8
X_0224_ _0224_/Q Tile_X0Y7_FrameData[31] VGND VPWR Tile_X0Y9_FrameStrobe[2] latch
XFILLER_260_49 VPWR VGND sg13cmos5l_decap_8
XFILLER_621_70 VPWR VGND sg13cmos5l_decap_8
XFILLER_36_222 VPWR VGND sg13cmos5l_decap_8
XFILLER_236_172 VPWR VGND sg13cmos5l_decap_8
X_0155_ _0155_/X _4564_/X _4565_/X _1605_/Q VPWR VGND sg13cmos5l_mux2_1
XFILLER_397_102 VPWR VGND sg13cmos5l_decap_8
XFILLER_51_214 VPWR VGND sg13cmos5l_decap_8
XFILLER_397_135 VPWR VGND sg13cmos5l_decap_8
XFILLER_340_82 VPWR VGND sg13cmos5l_decap_8
XFILLER_697_63 VPWR VGND sg13cmos5l_decap_8
X_0086_ _0086_/X _3869_/X _3870_/X _2152_/Q VPWR VGND sg13cmos5l_mux2_1
XFILLER_397_146 VPWR VGND sg13cmos5l_fill_1
XFILLER_269_14 VPWR VGND sg13cmos5l_decap_8
X_3914_ _3914_/X Tile_X0Y2_W1END[2] Tile_X0Y2_WW4END[2] Tile_X0Y2_W6END[10] _4118_/X
+ _1643_/Q _1642_/Q VPWR VGND sg13cmos5l_mux4_1
XFILLER_338_202 VPWR VGND sg13cmos5l_decap_8
X_4894_ _4894_/X Tile_X0Y9_N1END[2] Tile_X0Y9_W6END[2] _4898_/X _4894_/A3 _0675_/Q
+ _0674_/Q VPWR VGND sg13cmos5l_mux4_1
XFILLER_338_213 VPWR VGND sg13cmos5l_fill_1
XFILLER_149_113 VPWR VGND sg13cmos5l_decap_4
XFILLER_539_195 VPWR VGND sg13cmos5l_decap_4
X_3845_ _3845_/X Tile_X0Y0_W2MID[5] _3883_/X _3887_/X _3856_/X _1015_/Q _1014_/Q VPWR
+ VGND sg13cmos5l_mux4_1
XFILLER_419_28 VPWR VGND sg13cmos5l_decap_8
XFILLER_554_143 VPWR VGND sg13cmos5l_decap_4
XFILLER_149_168 VPWR VGND sg13cmos5l_fill_2
XFILLER_566_56 VPWR VGND sg13cmos5l_decap_8
XFILLER_554_154 VPWR VGND sg13cmos5l_decap_4
XFILLER_349_91 VPWR VGND sg13cmos5l_decap_8
X_0988_ _0988_/Q Tile_X0Y0_FrameData[15] VGND VPWR Tile_X0Y9_FrameStrobe[1] latch
X_3776_ _3776_/X Tile_X0Y0_WW4END[5] Tile_X0Y0_WW4END[13] Tile_X0Y0_W6END[5] _3886_/X
+ _0999_/Q _0998_/Q VPWR VGND sg13cmos5l_mux4_1
XFILLER_285_35 VPWR VGND sg13cmos5l_decap_8
X_2727_ _4894_/A3 VPWR VGND sg13cmos5l_tielo
XFILLER_711_140 VPWR VGND sg13cmos5l_decap_8
XFILLER_105_216 VPWR VGND sg13cmos5l_decap_4
X_2658_ _2658_/Q Tile_X0Y6_FrameData[5] VGND VPWR Tile_X0Y9_FrameStrobe[6] latch
XFILLER_435_49 VPWR VGND sg13cmos5l_decap_8
XFILLER_218_84 VPWR VGND sg13cmos5l_decap_8
XFILLER_321_124 VPWR VGND sg13cmos5l_fill_1
XFILLER_582_77 VPWR VGND sg13cmos5l_decap_8
XFILLER_154_28 VPWR VGND sg13cmos5l_decap_8
X_1609_ _1609_/Q Tile_X0Y2_FrameData[8] VGND VPWR Tile_X0Y9_FrameStrobe[5] latch
X_2589_ _2589_/Q Tile_X0Y6_FrameData[10] VGND VPWR Tile_X0Y9_FrameStrobe[4] latch
XFILLER_467_139 VPWR VGND sg13cmos5l_decap_4
XFILLER_321_157 VPWR VGND sg13cmos5l_fill_2
XFILLER_259_220 VPWR VGND sg13cmos5l_fill_2
XANTENNA__3543__X Tile_X0Y9_E6BEG[1] VPWR VGND sg13cmos5l_antennanp
XFILLER_86_100 VPWR VGND sg13cmos5l_decap_8
X_4328_ _4328_/X Tile_X0Y0_W1END[2] Tile_X0Y0_WW4END[14] Tile_X0Y0_W6END[6] _3883_/X
+ _1111_/Q _1110_/Q VPWR VGND sg13cmos5l_mux4_1
XFILLER_408_206 VPWR VGND sg13cmos5l_decap_8
X_4259_ _4259_/X Tile_X0Y4_W2MID[4] AXI_M_SOC_BRESP1 _4319_/X _4318_/X _2095_/Q _2094_/Q
+ VPWR VGND sg13cmos5l_mux4_1
XFILLER_624_114 VPWR VGND sg13cmos5l_fill_1
XFILLER_609_188 VPWR VGND sg13cmos5l_decap_8
XFILLER_47_59 VPWR VGND sg13cmos5l_decap_8
XFILLER_170_49 VPWR VGND sg13cmos5l_decap_8
XFILLER_531_70 VPWR VGND sg13cmos5l_decap_8
XFILLER_103_21 VPWR VGND sg13cmos5l_decap_8
XFILLER_531_81 VPWR VGND sg13cmos5l_fill_2
XFILLER_263_7 VPWR VGND sg13cmos5l_decap_8
XFILLER_388_102 VPWR VGND sg13cmos5l_decap_8
XFILLER_63_14 VPWR VGND sg13cmos5l_decap_8
XFILLER_577_202 VPWR VGND sg13cmos5l_decap_8
XFILLER_388_124 VPWR VGND sg13cmos5l_decap_8
XFILLER_179_14 VPWR VGND sg13cmos5l_decap_8
XFILLER_430_7 VPWR VGND sg13cmos5l_decap_8
XFILLER_400_63 VPWR VGND sg13cmos5l_decap_8
XFILLER_528_7 VPWR VGND sg13cmos5l_decap_8
XFILLER_592_227 VPWR VGND sg13cmos5l_fill_2
XFILLER_329_28 VPWR VGND sg13cmos5l_decap_8
XFILLER_545_143 VPWR VGND sg13cmos5l_fill_2
XANTENNA__3718__X AXI_M_SOC_WDATA28 VPWR VGND sg13cmos5l_antennanp
XFILLER_476_56 VPWR VGND sg13cmos5l_decap_4
XFILLER_10_155 VPWR VGND sg13cmos5l_fill_2
XFILLER_545_176 VPWR VGND sg13cmos5l_decap_8
XFILLER_195_35 VPWR VGND sg13cmos5l_decap_8
XFILLER_560_157 VPWR VGND sg13cmos5l_decap_8
XFILLER_12_84 VPWR VGND sg13cmos5l_decap_8
XFILLER_163_160 VPWR VGND sg13cmos5l_fill_1
XFILLER_345_49 VPWR VGND sg13cmos5l_decap_8
XFILLER_706_70 VPWR VGND sg13cmos5l_decap_8
XFILLER_647_217 VPWR VGND sg13cmos5l_decap_8
XFILLER_501_224 VPWR VGND sg13cmos5l_decap_4
XFILLER_492_77 VPWR VGND sg13cmos5l_decap_8
XFILLER_642_14 VPWR VGND sg13cmos5l_decap_8
XFILLER_647_228 VPWR VGND sg13cmos5l_fill_1
XANTENNA__3453__X Tile_X0Y1_FrameData_O[11] VPWR VGND sg13cmos5l_antennanp
XFILLER_473_109 VPWR VGND sg13cmos5l_decap_8
XFILLER_466_161 VPWR VGND sg13cmos5l_fill_1
XFILLER_265_201 VPWR VGND sg13cmos5l_decap_8
XFILLER_387_0 VPWR VGND sg13cmos5l_decap_8
XFILLER_466_183 VPWR VGND sg13cmos5l_fill_2
XFILLER_77_177 VPWR VGND sg13cmos5l_fill_1
XFILLER_615_158 VPWR VGND sg13cmos5l_decap_8
XFILLER_18_211 VPWR VGND sg13cmos5l_decap_8
XFILLER_441_70 VPWR VGND sg13cmos5l_decap_8
XFILLER_554_0 VPWR VGND sg13cmos5l_decap_8
XFILLER_568_202 VPWR VGND sg13cmos5l_decap_8
XFILLER_233_120 VPWR VGND sg13cmos5l_fill_1
XFILLER_310_63 VPWR VGND sg13cmos5l_decap_8
X_1960_ _1960_/Q Tile_X0Y4_FrameData[29] VGND VPWR Tile_X0Y9_FrameStrobe[1] latch
XFILLER_310_74 VPWR VGND sg13cmos5l_fill_2
XFILLER_394_127 VPWR VGND sg13cmos5l_fill_2
X_0911_ _0911_/Q Tile_X0Y9_FrameData[16] VGND VPWR Tile_X0Y9_FrameStrobe[7] latch
XFILLER_667_77 VPWR VGND sg13cmos5l_decap_8
XFILLER_239_28 VPWR VGND sg13cmos5l_decap_8
X_1891_ _1891_/Q Tile_X0Y3_FrameData[6] VGND VPWR Tile_X0Y9_FrameStrobe[6] latch
XFILLER_386_56 VPWR VGND sg13cmos5l_decap_8
XANTENNA__3628__X Tile_X0Y9_S4BEG[6] VPWR VGND sg13cmos5l_antennanp
XFILLER_169_91 VPWR VGND sg13cmos5l_fill_2
XFILLER_146_105 VPWR VGND sg13cmos5l_fill_1
X_0842_ _0842_/Q Tile_X0Y9_FrameData[21] VGND VPWR Tile_X0Y9_FrameStrobe[5] latch
X_3630_ Tile_X0Y9_S4BEG[8] _3630_/A VPWR VGND sg13cmos5l_buf_1
XFILLER_683_21 VPWR VGND sg13cmos5l_decap_8
X_0773_ _0773_/Q Tile_X0Y9_FrameData[26] VGND VPWR Tile_X0Y9_FrameStrobe[3] latch
X_3561_ Tile_X0Y9_EE4BEG[7] _4871_/X VPWR VGND sg13cmos5l_buf_1
XFILLER_161_108 VPWR VGND sg13cmos5l_decap_8
XANTENNA__0052__X AXI_M_SOC_AWBURST0 VPWR VGND sg13cmos5l_antennanp
X_2512_ _2512_/Q Tile_X0Y6_FrameData[23] VGND VPWR Tile_X0Y9_FrameStrobe[2] latch
X_3492_ Tile_X0Y1_E6BEG[2] _3966_/X VPWR VGND sg13cmos5l_buf_1
XFILLER_683_98 VPWR VGND sg13cmos5l_decap_8
XFILLER_255_49 VPWR VGND sg13cmos5l_decap_8
XFILLER_616_70 VPWR VGND sg13cmos5l_decap_8
X_2443_ _2443_/Q Tile_X0Y6_FrameData[28] VGND VPWR Tile_X0Y9_FrameStrobe[0] latch
XFILLER_303_135 VPWR VGND sg13cmos5l_decap_8
XFILLER_552_14 VPWR VGND sg13cmos5l_decap_8
XANTENNA__3363__X Tile_X0Y2_EE4BEG[2] VPWR VGND sg13cmos5l_antennanp
XFILLER_68_100 VPWR VGND sg13cmos5l_decap_8
X_2374_ _2374_/Q Tile_X0Y5_FrameData[31] VGND VPWR Tile_X0Y9_FrameStrobe[6] latch
XFILLER_464_109 VPWR VGND sg13cmos5l_fill_1
XFILLER_256_201 VPWR VGND sg13cmos5l_decap_8
X_1325_ _1325_/Q Tile_X0Y1_FrameData[12] VGND VPWR Tile_X0Y9_FrameStrobe[4] latch
X_4113_ _4113_/X _4089_/X _0079_/X _4088_/X Tile_X0Y0_S4END[8] _1457_/Q _1456_/Q VPWR
+ VGND sg13cmos5l_mux4_1
XFILLER_311_190 VPWR VGND sg13cmos5l_fill_2
XFILLER_68_177 VPWR VGND sg13cmos5l_decap_8
XFILLER_632_91 VPWR VGND sg13cmos5l_decap_8
XFILLER_606_136 VPWR VGND sg13cmos5l_decap_8
XFILLER_204_42 VPWR VGND sg13cmos5l_decap_8
X_1256_ _1256_/Q Tile_X0Y1_FrameData[17] VGND VPWR Tile_X0Y9_FrameStrobe[2] latch
X_4044_ _4044_/X Tile_X0Y2_W2MID[3] AXI_M_SOC_AWREADY _4103_/X _4102_/X _1585_/Q _1584_/Q
+ VPWR VGND sg13cmos5l_mux4_1
XFILLER_351_70 VPWR VGND sg13cmos5l_decap_8
XFILLER_271_215 VPWR VGND sg13cmos5l_decap_4
XFILLER_209_161 VPWR VGND sg13cmos5l_decap_8
X_0207_ _0207_/Q Tile_X0Y7_FrameData[16] VGND VPWR Tile_X0Y9_FrameStrobe[1] latch
X_1187_ _1187_/Q Tile_X0Y1_FrameData[22] VGND VPWR Tile_X0Y9_FrameStrobe[0] latch
XFILLER_621_139 VPWR VGND sg13cmos5l_decap_4
X_0138_ AXI_M_SOC_AWLEN0 _0940_/Q _3671_/X VPWR VGND sg13cmos5l_nor2b_1
XFILLER_224_153 VPWR VGND sg13cmos5l_decap_8
XFILLER_501_84 VPWR VGND sg13cmos5l_decap_8
XFILLER_91_191 VPWR VGND sg13cmos5l_fill_2
XFILLER_169_219 VPWR VGND sg13cmos5l_fill_2
XFILLER_220_63 VPWR VGND sg13cmos5l_decap_8
X_0069_ AXI_M_SOC_WSTRB2 _0935_/Q _3724_/X VPWR VGND sg13cmos5l_or2_1
XFILLER_33_17 VPWR VGND sg13cmos5l_decap_8
XFILLER_577_77 VPWR VGND sg13cmos5l_decap_8
XFILLER_149_28 VPWR VGND sg13cmos5l_decap_8
X_4877_ _4877_/X Tile_X0Y9_WW4END[2] AXI_M_SOC_RDATA2 _4918_/X _4905_/X _0789_/Q _0788_/Q
+ VPWR VGND sg13cmos5l_mux4_1
XFILLER_527_143 VPWR VGND sg13cmos5l_decap_4
XFILLER_296_56 VPWR VGND sg13cmos5l_decap_8
XANTENNA__3538__X Tile_X0Y9_E2BEGb[4] VPWR VGND sg13cmos5l_antennanp
XFILLER_137_105 VPWR VGND sg13cmos5l_decap_8
X_3828_ _3828_/X Tile_X0Y0_WW4END[7] Tile_X0Y0_WW4END[9] _3879_/X _3852_/X _1049_/Q
+ _1048_/Q VPWR VGND sg13cmos5l_mux4_1
XFILLER_192_222 VPWR VGND sg13cmos5l_decap_8
XFILLER_593_21 VPWR VGND sg13cmos5l_decap_8
X_3759_ AXI_M_SOC_ARADDR31 Tile_X0Y8_W1END[3] Tile_X0Y8_WW4END[7] Tile_X0Y8_WW4END[15]
+ _4815_/X _0473_/Q _0472_/Q VPWR VGND sg13cmos5l_mux4_1
XFILLER_542_179 VPWR VGND sg13cmos5l_decap_8
XFILLER_3_129 VPWR VGND sg13cmos5l_fill_1
XFILLER_165_49 VPWR VGND sg13cmos5l_decap_8
XFILLER_109_7 VPWR VGND sg13cmos5l_decap_8
XFILLER_526_70 VPWR VGND sg13cmos5l_decap_8
XFILLER_629_206 VPWR VGND sg13cmos5l_decap_8
XFILLER_495_212 VPWR VGND sg13cmos5l_fill_2
XFILLER_462_14 VPWR VGND sg13cmos5l_decap_8
XANTENNA__3273__X Tile_X0Y0_EE4BEG[9] VPWR VGND sg13cmos5l_antennanp
XFILLER_59_111 VPWR VGND sg13cmos5l_decap_8
XFILLER_612_28 VPWR VGND sg13cmos5l_decap_8
XFILLER_380_7 VPWR VGND sg13cmos5l_decap_8
XFILLER_478_7 VPWR VGND sg13cmos5l_decap_8
XFILLER_59_188 VPWR VGND sg13cmos5l_decap_8
XFILLER_114_42 VPWR VGND sg13cmos5l_decap_8
XFILLER_59_199 VPWR VGND sg13cmos5l_fill_1
XFILLER_262_204 VPWR VGND sg13cmos5l_decap_4
XFILLER_261_70 VPWR VGND sg13cmos5l_decap_8
XFILLER_261_81 VPWR VGND sg13cmos5l_fill_1
XFILLER_74_35 VPWR VGND sg13cmos5l_decap_8
XFILLER_645_7 VPWR VGND sg13cmos5l_decap_8
XFILLER_605_191 VPWR VGND sg13cmos5l_decap_8
XFILLER_411_84 VPWR VGND sg13cmos5l_decap_4
XFILLER_620_172 VPWR VGND sg13cmos5l_fill_2
XFILLER_215_197 VPWR VGND sg13cmos5l_decap_8
XFILLER_130_63 VPWR VGND sg13cmos5l_decap_8
XFILLER_487_77 VPWR VGND sg13cmos5l_decap_8
XFILLER_369_190 VPWR VGND sg13cmos5l_decap_8
XFILLER_230_178 VPWR VGND sg13cmos5l_fill_2
XFILLER_637_14 VPWR VGND sg13cmos5l_decap_8
XANTENNA__3448__X Tile_X0Y1_FrameData_O[6] VPWR VGND sg13cmos5l_antennanp
XFILLER_518_154 VPWR VGND sg13cmos5l_fill_1
XFILLER_135_0 VPWR VGND sg13cmos5l_decap_8
XFILLER_518_176 VPWR VGND sg13cmos5l_decap_8
XFILLER_384_171 VPWR VGND sg13cmos5l_fill_2
XFILLER_384_182 VPWR VGND sg13cmos5l_decap_4
XFILLER_533_124 VPWR VGND sg13cmos5l_decap_8
XFILLER_128_149 VPWR VGND sg13cmos5l_decap_4
XFILLER_99_21 VPWR VGND sg13cmos5l_decap_8
XFILLER_302_0 VPWR VGND sg13cmos5l_decap_8
XFILLER_143_119 VPWR VGND sg13cmos5l_decap_8
XFILLER_533_179 VPWR VGND sg13cmos5l_fill_1
XFILLER_332_219 VPWR VGND sg13cmos5l_decap_8
XFILLER_136_182 VPWR VGND sg13cmos5l_decap_8
XFILLER_653_35 VPWR VGND sg13cmos5l_decap_8
XFILLER_436_70 VPWR VGND sg13cmos5l_decap_8
XFILLER_99_98 VPWR VGND sg13cmos5l_decap_8
XFILLER_372_14 VPWR VGND sg13cmos5l_decap_8
XFILLER_297_134 VPWR VGND sg13cmos5l_fill_1
XANTENNA__3183__X Tile_X0Y0_N4BEG[7] VPWR VGND sg13cmos5l_antennanp
XFILLER_151_163 VPWR VGND sg13cmos5l_fill_1
XFILLER_671_0 VPWR VGND sg13cmos5l_decap_8
XFILLER_522_28 VPWR VGND sg13cmos5l_decap_8
XFILLER_24_7 VPWR VGND sg13cmos5l_decap_8
XFILLER_305_63 VPWR VGND sg13cmos5l_decap_8
X_1110_ _1110_/Q Tile_X0Y0_FrameData[21] VGND VPWR Tile_X0Y9_FrameStrobe[5] latch
XFILLER_48_80 VPWR VGND sg13cmos5l_decap_4
X_2090_ _2090_/Q Tile_X0Y4_FrameData[27] VGND VPWR Tile_X0Y9_FrameStrobe[5] latch
XFILLER_171_70 VPWR VGND sg13cmos5l_decap_8
XFILLER_0_21 VPWR VGND sg13cmos5l_decap_8
X_1041_ _1041_/Q Tile_X0Y0_FrameData[26] VGND VPWR Tile_X0Y9_FrameStrobe[3] latch
XFILLER_65_169 VPWR VGND sg13cmos5l_decap_8
XFILLER_80_128 VPWR VGND sg13cmos5l_decap_8
XFILLER_678_21 VPWR VGND sg13cmos5l_decap_8
XFILLER_80_139 VPWR VGND sg13cmos5l_fill_1
XFILLER_321_84 VPWR VGND sg13cmos5l_fill_2
XFILLER_206_175 VPWR VGND sg13cmos5l_decap_8
X_4800_ _4800_/X _4777_/X Tile_X0Y9_N4END[4] _4776_/X _0077_/X _0471_/Q _0470_/Q VPWR
+ VGND sg13cmos5l_mux4_1
XFILLER_367_105 VPWR VGND sg13cmos5l_decap_8
XFILLER_678_98 VPWR VGND sg13cmos5l_decap_8
X_2992_ Tile_X0Y8_UserCLKo Tile_X0Y8_UserCLK VPWR VGND sg13cmos5l_buf_1
XFILLER_21_228 VPWR VGND sg13cmos5l_fill_1
X_4731_ _4731_/X Tile_X0Y8_W2MID[4] AXI_M_SOC_RDATA11 _4791_/X _4790_/X _0585_/Q _0584_/Q
+ VPWR VGND sg13cmos5l_mux4_1
XFILLER_397_77 VPWR VGND sg13cmos5l_decap_4
X_1943_ _1943_/Q Tile_X0Y4_FrameData[14] VGND VPWR Tile_X0Y9_FrameStrobe[0] latch
XFILLER_547_14 VPWR VGND sg13cmos5l_decap_8
XFILLER_9_63 VPWR VGND sg13cmos5l_decap_8
XANTENNA__3358__X Tile_X0Y2_FrameData_O[29] VPWR VGND sg13cmos5l_antennanp
XFILLER_694_42 VPWR VGND sg13cmos5l_decap_8
XFILLER_174_200 VPWR VGND sg13cmos5l_decap_8
X_4662_ _4662_/X Tile_X0Y6_W1END[1] Tile_X0Y6_W6END[9] _4581_/X _4541_/X _2657_/Q
+ _2656_/Q VPWR VGND sg13cmos5l_mux4_1
X_1874_ _1874_/Q Tile_X0Y3_FrameData[23] VGND VPWR Tile_X0Y9_FrameStrobe[6] latch
XFILLER_509_187 VPWR VGND sg13cmos5l_fill_1
X_3613_ Tile_X0Y9_S2BEG[7] _4835_/X VPWR VGND sg13cmos5l_buf_1
XFILLER_524_135 VPWR VGND sg13cmos5l_decap_8
X_0825_ _0825_/Q Tile_X0Y9_FrameData[6] VGND VPWR Tile_X0Y9_FrameStrobe[4] latch
X_4593_ _4593_/X Tile_X0Y8_W2MID[3] Tile_X0Y8_W2END[3] Tile_X0Y8_W6END[3] _4790_/X
+ _0655_/Q _0654_/Q VPWR VGND sg13cmos5l_mux4_1
XFILLER_627_91 VPWR VGND sg13cmos5l_decap_8
XFILLER_134_119 VPWR VGND sg13cmos5l_decap_8
X_3544_ Tile_X0Y9_E6BEG[2] _4882_/X VPWR VGND sg13cmos5l_buf_1
X_0756_ _0756_/Q Tile_X0Y9_FrameData[11] VGND VPWR Tile_X0Y9_FrameStrobe[2] latch
XFILLER_563_35 VPWR VGND sg13cmos5l_decap_8
XFILLER_50_0 VPWR VGND sg13cmos5l_fill_1
XFILLER_346_70 VPWR VGND sg13cmos5l_decap_8
XFILLER_288_112 VPWR VGND sg13cmos5l_fill_1
XFILLER_477_212 VPWR VGND sg13cmos5l_fill_1
XFILLER_532_190 VPWR VGND sg13cmos5l_decap_8
XFILLER_282_14 VPWR VGND sg13cmos5l_decap_8
XANTENNA__3093__X Tile_X0Y7_E2BEG[7] VPWR VGND sg13cmos5l_antennanp
XFILLER_88_206 VPWR VGND sg13cmos5l_decap_8
X_0687_ _0687_/Q Tile_X0Y9_FrameData[16] VGND VPWR Tile_X0Y9_FrameStrobe[0] latch
X_3475_ Tile_X0Y1_EE4BEG[1] _3949_/X VPWR VGND sg13cmos5l_buf_1
X_2426_ _2426_/Q Tile_X0Y5_FrameData[11] VGND VPWR Tile_X0Y9_FrameStrobe[7] latch
XFILLER_713_49 VPWR VGND sg13cmos5l_decap_8
XFILLER_492_204 VPWR VGND sg13cmos5l_decap_8
XFILLER_142_196 VPWR VGND sg13cmos5l_decap_8
XFILLER_432_28 VPWR VGND sg13cmos5l_decap_8
XFILLER_215_63 VPWR VGND sg13cmos5l_decap_8
X_2357_ _2357_/Q Tile_X0Y5_FrameData[16] VGND VPWR Tile_X0Y9_FrameStrobe[5] latch
XFILLER_28_28 VPWR VGND sg13cmos5l_decap_8
XFILLER_362_91 VPWR VGND sg13cmos5l_decap_8
X_1308_ _1308_/Q Tile_X0Y1_FrameData[29] VGND VPWR Tile_X0Y9_FrameStrobe[4] latch
X_2288_ _2288_/Q Tile_X0Y5_FrameData[21] VGND VPWR Tile_X0Y9_FrameStrobe[3] latch
XFILLER_56_136 VPWR VGND sg13cmos5l_decap_8
XFILLER_244_226 VPWR VGND sg13cmos5l_fill_2
X_1239_ _1239_/Q Tile_X0Y1_FrameData[2] VGND VPWR Tile_X0Y9_FrameStrobe[1] latch
X_4027_ _4027_/X Tile_X0Y3_W2MID[4] Tile_X0Y3_W2END[4] Tile_X0Y3_W6END[4] _4211_/X
+ _1911_/Q _1910_/Q VPWR VGND sg13cmos5l_mux4_1
XFILLER_588_21 VPWR VGND sg13cmos5l_decap_8
XFILLER_44_27 VPWR VGND sg13cmos5l_fill_2
XFILLER_231_84 VPWR VGND sg13cmos5l_decap_8
XFILLER_231_95 VPWR VGND sg13cmos5l_fill_1
XFILLER_358_105 VPWR VGND sg13cmos5l_decap_8
XFILLER_212_112 VPWR VGND sg13cmos5l_decap_8
XFILLER_602_172 VPWR VGND sg13cmos5l_decap_8
XFILLER_602_183 VPWR VGND sg13cmos5l_fill_2
XFILLER_588_98 VPWR VGND sg13cmos5l_decap_8
XFILLER_12_228 VPWR VGND sg13cmos5l_fill_1
X_4929_ _4929_/X Tile_X0Y9_N1END[1] Tile_X0Y9_N4END[1] _4897_/X _0082_/X _0701_/Q
+ _0700_/Q VPWR VGND sg13cmos5l_mux4_1
XFILLER_457_14 VPWR VGND sg13cmos5l_decap_8
XFILLER_212_189 VPWR VGND sg13cmos5l_decap_8
XANTENNA__3268__X Tile_X0Y0_EE4BEG[4] VPWR VGND sg13cmos5l_antennanp
XFILLER_373_119 VPWR VGND sg13cmos5l_fill_2
XFILLER_100_77 VPWR VGND sg13cmos5l_decap_8
XFILLER_226_7 VPWR VGND sg13cmos5l_decap_8
XFILLER_165_211 VPWR VGND sg13cmos5l_fill_1
XFILLER_381_130 VPWR VGND sg13cmos5l_decap_4
XFILLER_607_28 VPWR VGND sg13cmos5l_decap_8
XFILLER_125_108 VPWR VGND sg13cmos5l_fill_1
XFILLER_537_91 VPWR VGND sg13cmos5l_decap_8
XANTENNA__2900__X Tile_X0Y6_FrameData_O[21] VPWR VGND sg13cmos5l_antennanp
XFILLER_118_160 VPWR VGND sg13cmos5l_decap_8
XFILLER_109_42 VPWR VGND sg13cmos5l_decap_8
XFILLER_381_196 VPWR VGND sg13cmos5l_decap_8
XFILLER_473_35 VPWR VGND sg13cmos5l_decap_8
XFILLER_256_70 VPWR VGND sg13cmos5l_decap_8
XFILLER_530_138 VPWR VGND sg13cmos5l_decap_8
XFILLER_279_112 VPWR VGND sg13cmos5l_decap_8
XFILLER_69_35 VPWR VGND sg13cmos5l_decap_8
XFILLER_468_223 VPWR VGND sg13cmos5l_decap_4
XFILLER_192_14 VPWR VGND sg13cmos5l_decap_8
XFILLER_595_7 VPWR VGND sg13cmos5l_decap_8
XFILLER_79_228 VPWR VGND sg13cmos5l_fill_1
XFILLER_623_49 VPWR VGND sg13cmos5l_decap_8
XFILLER_406_95 VPWR VGND sg13cmos5l_fill_2
XFILLER_342_28 VPWR VGND sg13cmos5l_decap_8
XFILLER_125_63 VPWR VGND sg13cmos5l_decap_8
XFILLER_294_148 VPWR VGND sg13cmos5l_decap_8
XANTENNA__3731__X AXI_M_SOC_ARADDR3 VPWR VGND sg13cmos5l_antennanp
XFILLER_272_91 VPWR VGND sg13cmos5l_decap_8
XFILLER_436_142 VPWR VGND sg13cmos5l_fill_2
XFILLER_85_56 VPWR VGND sg13cmos5l_decap_8
XFILLER_47_136 VPWR VGND sg13cmos5l_decap_8
XFILLER_451_123 VPWR VGND sg13cmos5l_decap_8
XFILLER_498_21 VPWR VGND sg13cmos5l_decap_8
XFILLER_141_84 VPWR VGND sg13cmos5l_decap_8
XFILLER_252_0 VPWR VGND sg13cmos5l_decap_8
XFILLER_203_112 VPWR VGND sg13cmos5l_decap_4
XFILLER_349_105 VPWR VGND sg13cmos5l_decap_8
XFILLER_70_161 VPWR VGND sg13cmos5l_decap_8
XFILLER_498_98 VPWR VGND sg13cmos5l_decap_8
XFILLER_648_35 VPWR VGND sg13cmos5l_decap_8
XFILLER_34_71 VPWR VGND sg13cmos5l_decap_8
XFILLER_203_178 VPWR VGND sg13cmos5l_decap_8
XFILLER_367_14 VPWR VGND sg13cmos5l_decap_8
XANTENNA__3178__X Tile_X0Y0_N4BEG[2] VPWR VGND sg13cmos5l_antennanp
XFILLER_517_0 VPWR VGND sg13cmos5l_decap_8
XFILLER_364_119 VPWR VGND sg13cmos5l_decap_8
XFILLER_357_182 VPWR VGND sg13cmos5l_decap_8
XFILLER_517_28 VPWR VGND sg13cmos5l_decap_8
XFILLER_664_56 VPWR VGND sg13cmos5l_decap_8
XFILLER_506_168 VPWR VGND sg13cmos5l_decap_8
XFILLER_447_91 VPWR VGND sg13cmos5l_fill_1
XFILLER_372_174 VPWR VGND sg13cmos5l_decap_8
XANTENNA__2810__X Tile_X0Y3_E2BEG[0] VPWR VGND sg13cmos5l_antennanp
X_0610_ _0610_/Q Tile_X0Y8_FrameData[29] VGND VPWR Tile_X0Y9_FrameStrobe[6] latch
X_1590_ _1590_/Q Tile_X0Y2_FrameData[27] VGND VPWR Tile_X0Y9_FrameStrobe[5] latch
XFILLER_521_116 VPWR VGND sg13cmos5l_fill_1
XFILLER_50_92 VPWR VGND sg13cmos5l_decap_8
XFILLER_667_109 VPWR VGND sg13cmos5l_fill_1
XFILLER_383_35 VPWR VGND sg13cmos5l_decap_8
XFILLER_166_70 VPWR VGND sg13cmos5l_decap_8
X_0541_ _0541_/Q Tile_X0Y8_FrameData[2] VGND VPWR Tile_X0Y9_FrameStrobe[3] latch
XFILLER_124_141 VPWR VGND sg13cmos5l_decap_8
X_0472_ _0472_/Q Tile_X0Y8_FrameData[7] VGND VPWR Tile_X0Y9_FrameStrobe[1] latch
X_3260_ Tile_X0Y0_FrameData_O[28] Tile_X0Y0_FrameData[28] VPWR VGND sg13cmos5l_buf_1
XFILLER_419_109 VPWR VGND sg13cmos5l_fill_2
XFILLER_680_55 VPWR VGND sg13cmos5l_decap_8
XFILLER_533_49 VPWR VGND sg13cmos5l_decap_8
XFILLER_285_126 VPWR VGND sg13cmos5l_decap_8
X_2211_ _2211_/Q Tile_X0Y5_FrameData[2] VGND VPWR Tile_X0Y9_FrameStrobe[0] latch
XFILLER_690_112 VPWR VGND sg13cmos5l_decap_8
XFILLER_59_90 VPWR VGND sg13cmos5l_decap_8
XFILLER_252_28 VPWR VGND sg13cmos5l_decap_8
X_3191_ Tile_X0Y0_N4BEG[15] _3191_/A VPWR VGND sg13cmos5l_buf_1
XANTENNA__3641__X AXI_M_SOC_AWADDR2 VPWR VGND sg13cmos5l_antennanp
X_2142_ _2142_/Q Tile_X0Y4_FrameData[7] VGND VPWR Tile_X0Y9_FrameStrobe[6] latch
XFILLER_427_175 VPWR VGND sg13cmos5l_decap_8
XFILLER_226_226 VPWR VGND sg13cmos5l_fill_2
XFILLER_588_105 VPWR VGND sg13cmos5l_decap_8
XFILLER_442_112 VPWR VGND sg13cmos5l_decap_4
X_2073_ _2073_/Q Tile_X0Y4_FrameData[12] VGND VPWR Tile_X0Y9_FrameStrobe[4] latch
XFILLER_689_53 VPWR VGND sg13cmos5l_decap_8
XFILLER_442_134 VPWR VGND sg13cmos5l_decap_8
XFILLER_53_117 VPWR VGND sg13cmos5l_decap_8
X_1024_ _1024_/Q Tile_X0Y0_FrameData[11] VGND VPWR Tile_X0Y9_FrameStrobe[2] latch
XFILLER_46_180 VPWR VGND sg13cmos5l_fill_2
XFILLER_201_21 VPWR VGND sg13cmos5l_decap_8
XFILLER_529_216 VPWR VGND sg13cmos5l_decap_4
XFILLER_395_222 VPWR VGND sg13cmos5l_decap_8
XFILLER_596_182 VPWR VGND sg13cmos5l_decap_4
XFILLER_558_35 VPWR VGND sg13cmos5l_decap_8
XFILLER_98_0 VPWR VGND sg13cmos5l_decap_8
XFILLER_277_14 VPWR VGND sg13cmos5l_decap_8
XFILLER_201_98 VPWR VGND sg13cmos5l_decap_8
X_2975_ Tile_X0Y8_FrameData_O[15] Tile_X0Y8_FrameData[15] VPWR VGND sg13cmos5l_buf_1
XANTENNA__3088__X Tile_X0Y7_E2BEG[2] VPWR VGND sg13cmos5l_antennanp
XFILLER_355_119 VPWR VGND sg13cmos5l_decap_8
X_4714_ _4714_/X Tile_X0Y6_W1END[3] Tile_X0Y6_W2MID[0] Tile_X0Y6_W2END[0] _4552_/X
+ _2637_/Q _2636_/Q VPWR VGND sg13cmos5l_mux4_1
X_1926_ _1926_/Q Tile_X0Y3_FrameData[31] VGND VPWR Tile_X0Y9_FrameStrobe[0] latch
XFILLER_708_49 VPWR VGND sg13cmos5l_decap_8
X_4645_ _4645_/X Tile_X0Y9_N4END[9] _0055_/X _4694_/X _4698_/X _0269_/Q _0268_/Q VPWR
+ VGND sg13cmos5l_mux4_1
XFILLER_427_28 VPWR VGND sg13cmos5l_decap_8
X_1857_ _1857_/Q Tile_X0Y3_FrameData[8] VGND VPWR Tile_X0Y9_FrameStrobe[5] latch
XFILLER_107_119 VPWR VGND sg13cmos5l_decap_8
XFILLER_574_56 VPWR VGND sg13cmos5l_decap_8
XFILLER_357_91 VPWR VGND sg13cmos5l_decap_8
XFILLER_512_105 VPWR VGND sg13cmos5l_decap_4
XFILLER_363_174 VPWR VGND sg13cmos5l_decap_8
X_0808_ _0808_/Q Tile_X0Y9_FrameData[23] VGND VPWR Tile_X0Y9_FrameStrobe[4] latch
X_4576_ _4576_/X _4545_/X Tile_X0Y9_N4END[12] _4544_/X _0152_/X _2479_/Q _2478_/Q
+ VPWR VGND sg13cmos5l_mux4_1
XFILLER_293_35 VPWR VGND sg13cmos5l_decap_8
X_1788_ _1788_/Q Tile_X0Y3_FrameData[13] VGND VPWR Tile_X0Y9_FrameStrobe[3] latch
XFILLER_512_138 VPWR VGND sg13cmos5l_fill_2
X_3527_ Tile_X0Y9_E2BEG[1] _4849_/X VPWR VGND sg13cmos5l_buf_1
X_0739_ _0739_/Q Tile_X0Y9_FrameData[28] VGND VPWR Tile_X0Y9_FrameStrobe[2] latch
XFILLER_115_185 VPWR VGND sg13cmos5l_decap_8
X_3458_ Tile_X0Y1_FrameData_O[16] Tile_X0Y1_FrameData[16] VPWR VGND sg13cmos5l_buf_1
XFILLER_443_49 VPWR VGND sg13cmos5l_decap_8
XFILLER_39_27 VPWR VGND sg13cmos5l_decap_8
XFILLER_226_84 VPWR VGND sg13cmos5l_fill_2
XFILLER_666_164 VPWR VGND sg13cmos5l_fill_1
XFILLER_130_133 VPWR VGND sg13cmos5l_decap_8
XFILLER_276_126 VPWR VGND sg13cmos5l_decap_8
XFILLER_590_77 VPWR VGND sg13cmos5l_decap_8
X_2409_ _2409_/Q Tile_X0Y5_FrameData[28] VGND VPWR Tile_X0Y9_FrameStrobe[7] latch
XFILLER_162_28 VPWR VGND sg13cmos5l_decap_8
X_3389_ Tile_X0Y2_E2BEGb[0] _4048_/X VPWR VGND sg13cmos5l_buf_1
XANTENNA__3551__X Tile_X0Y9_E6BEG[9] VPWR VGND sg13cmos5l_antennanp
XFILLER_217_215 VPWR VGND sg13cmos5l_fill_1
XFILLER_599_42 VPWR VGND sg13cmos5l_decap_8
XFILLER_433_112 VPWR VGND sg13cmos5l_decap_8
XFILLER_579_105 VPWR VGND sg13cmos5l_decap_8
XFILLER_176_7 VPWR VGND sg13cmos5l_decap_8
XFILLER_111_21 VPWR VGND sg13cmos5l_decap_8
XFILLER_343_7 VPWR VGND sg13cmos5l_decap_8
XFILLER_71_14 VPWR VGND sg13cmos5l_decap_8
XFILLER_587_182 VPWR VGND sg13cmos5l_fill_2
XFILLER_468_35 VPWR VGND sg13cmos5l_decap_8
XFILLER_187_14 VPWR VGND sg13cmos5l_decap_8
XFILLER_346_119 VPWR VGND sg13cmos5l_decap_8
XFILLER_197_188 VPWR VGND sg13cmos5l_decap_8
XFILLER_138_200 VPWR VGND sg13cmos5l_fill_2
XFILLER_510_7 VPWR VGND sg13cmos5l_decap_8
XFILLER_608_7 VPWR VGND sg13cmos5l_decap_8
XFILLER_618_49 VPWR VGND sg13cmos5l_decap_8
XFILLER_484_12 VPWR VGND sg13cmos5l_decap_8
XANTENNA__0134__Y AXI_M_SOC_AWLEN4 VPWR VGND sg13cmos5l_antennanp
XFILLER_337_28 VPWR VGND sg13cmos5l_decap_8
XFILLER_153_203 VPWR VGND sg13cmos5l_fill_1
XFILLER_267_91 VPWR VGND sg13cmos5l_decap_8
XANTENNA__3726__X AXI_M_SOC_WVALID VPWR VGND sg13cmos5l_antennanp
XFILLER_503_105 VPWR VGND sg13cmos5l_decap_8
XFILLER_299_207 VPWR VGND sg13cmos5l_decap_8
XFILLER_299_218 VPWR VGND sg13cmos5l_fill_1
XFILLER_354_196 VPWR VGND sg13cmos5l_decap_4
XFILLER_484_89 VPWR VGND sg13cmos5l_decap_8
XFILLER_106_152 VPWR VGND sg13cmos5l_fill_1
XFILLER_106_174 VPWR VGND sg13cmos5l_decap_8
XFILLER_353_49 VPWR VGND sg13cmos5l_decap_8
XFILLER_456_215 VPWR VGND sg13cmos5l_decap_4
XFILLER_136_84 VPWR VGND sg13cmos5l_decap_8
XFILLER_121_144 VPWR VGND sg13cmos5l_decap_8
XFILLER_714_92 VPWR VGND sg13cmos5l_decap_8
XFILLER_650_14 VPWR VGND sg13cmos5l_decap_8
XANTENNA__3461__X Tile_X0Y1_FrameData_O[19] VPWR VGND sg13cmos5l_antennanp
XFILLER_409_131 VPWR VGND sg13cmos5l_decap_4
XFILLER_672_156 VPWR VGND sg13cmos5l_decap_8
XFILLER_672_167 VPWR VGND sg13cmos5l_fill_1
XFILLER_409_164 VPWR VGND sg13cmos5l_fill_1
XFILLER_672_189 VPWR VGND sg13cmos5l_decap_4
XFILLER_467_0 VPWR VGND sg13cmos5l_decap_8
XFILLER_424_112 VPWR VGND sg13cmos5l_decap_8
XFILLER_409_186 VPWR VGND sg13cmos5l_decap_4
XFILLER_275_192 VPWR VGND sg13cmos5l_decap_4
XFILLER_613_223 VPWR VGND sg13cmos5l_decap_4
XFILLER_290_140 VPWR VGND sg13cmos5l_decap_8
XFILLER_302_42 VPWR VGND sg13cmos5l_decap_8
XFILLER_634_0 VPWR VGND sg13cmos5l_decap_8
XFILLER_659_56 VPWR VGND sg13cmos5l_decap_8
XANTENNA__2805__X Tile_X0Y3_E2BEGb[3] VPWR VGND sg13cmos5l_antennanp
XFILLER_578_182 VPWR VGND sg13cmos5l_decap_8
XFILLER_378_35 VPWR VGND sg13cmos5l_decap_8
XFILLER_91_7 VPWR VGND sg13cmos5l_decap_8
XFILLER_526_208 VPWR VGND sg13cmos5l_fill_2
XFILLER_129_200 VPWR VGND sg13cmos5l_decap_8
XFILLER_392_225 VPWR VGND sg13cmos5l_decap_4
XFILLER_129_211 VPWR VGND sg13cmos5l_fill_2
X_2760_ Tile_X0Y3_FrameData_O[18] Tile_X0Y3_FrameData[18] VPWR VGND sg13cmos5l_buf_1
XFILLER_593_196 VPWR VGND sg13cmos5l_decap_8
XFILLER_528_49 VPWR VGND sg13cmos5l_decap_8
X_1711_ _1711_/Q Tile_X0Y3_FrameData[26] VGND VPWR Tile_X0Y9_FrameStrobe[1] latch
XFILLER_675_77 VPWR VGND sg13cmos5l_decap_8
XFILLER_247_28 VPWR VGND sg13cmos5l_decap_8
X_2691_ _2691_/Q Tile_X0Y6_FrameData[4] VGND VPWR Tile_X0Y9_FrameStrobe[7] latch
XFILLER_394_56 VPWR VGND sg13cmos5l_decap_8
XANTENNA__3636__X Tile_X0Y9_S4BEG[14] VPWR VGND sg13cmos5l_antennanp
X_4430_ _4430_/X _4355_/X _4471_/X _4470_/X _4354_/X _2203_/Q _2202_/Q VPWR VGND sg13cmos5l_mux4_1
XANTENNA_2 AXI_M_SOC_RDATA13 VPWR VGND sg13cmos5l_antennanp
X_1642_ _1642_/Q Tile_X0Y2_FrameData[7] VGND VPWR Tile_X0Y9_FrameStrobe[6] latch
XFILLER_6_42 VPWR VGND sg13cmos5l_decap_8
XFILLER_691_21 VPWR VGND sg13cmos5l_decap_8
X_4361_ _4361_/X Tile_X0Y6_W2MID[3] Tile_X0Y6_W2END[3] Tile_X0Y6_W6END[3] _4558_/X
+ _2679_/Q _2678_/Q VPWR VGND sg13cmos5l_mux4_1
X_1573_ _1573_/Q Tile_X0Y2_FrameData[12] VGND VPWR Tile_X0Y9_FrameStrobe[4] latch
X_3312_ Tile_X0Y4_EE4BEG[0] _4272_/X VPWR VGND sg13cmos5l_buf_1
X_0524_ _0524_/Q Tile_X0Y8_FrameData[19] VGND VPWR Tile_X0Y9_FrameStrobe[3] latch
XFILLER_691_98 VPWR VGND sg13cmos5l_decap_8
XFILLER_648_153 VPWR VGND sg13cmos5l_decap_8
X_4292_ _4292_/X AXI_M_SOC_BRESP0 _4343_/X _4347_/X _4313_/X _2029_/Q _2028_/Q VPWR
+ VGND sg13cmos5l_mux4_1
XFILLER_263_49 VPWR VGND sg13cmos5l_decap_8
XFILLER_624_70 VPWR VGND sg13cmos5l_decap_8
XFILLER_502_182 VPWR VGND sg13cmos5l_decap_8
XFILLER_663_112 VPWR VGND sg13cmos5l_fill_1
X_0455_ _0455_/Q Tile_X0Y8_FrameData[24] VGND VPWR Tile_X0Y9_FrameStrobe[1] latch
X_3243_ Tile_X0Y0_FrameData_O[11] Tile_X0Y0_FrameData[11] VPWR VGND sg13cmos5l_buf_1
XFILLER_560_14 VPWR VGND sg13cmos5l_decap_8
XANTENNA__3371__X Tile_X0Y2_EE4BEG[10] VPWR VGND sg13cmos5l_antennanp
XFILLER_663_145 VPWR VGND sg13cmos5l_decap_4
XFILLER_663_156 VPWR VGND sg13cmos5l_decap_8
X_0386_ _0386_/Q Tile_X0Y7_FrameData[29] VGND VPWR Tile_X0Y9_FrameStrobe[7] latch
X_3174_ Tile_X0Y4_E6BEG[11] _4299_/X VPWR VGND sg13cmos5l_buf_1
XFILLER_13_0 VPWR VGND sg13cmos5l_decap_8
XFILLER_710_28 VPWR VGND sg13cmos5l_decap_8
X_2125_ _2125_/Q Tile_X0Y4_FrameData[24] VGND VPWR Tile_X0Y9_FrameStrobe[6] latch
XFILLER_604_223 VPWR VGND sg13cmos5l_decap_4
XFILLER_281_140 VPWR VGND sg13cmos5l_decap_8
XFILLER_640_91 VPWR VGND sg13cmos5l_decap_8
XFILLER_212_42 VPWR VGND sg13cmos5l_decap_8
X_2056_ _2056_/Q Tile_X0Y4_FrameData[29] VGND VPWR Tile_X0Y9_FrameStrobe[4] latch
XFILLER_430_126 VPWR VGND sg13cmos5l_decap_8
XFILLER_576_119 VPWR VGND sg13cmos5l_decap_8
XFILLER_569_56 VPWR VGND sg13cmos5l_decap_8
X_1007_ _1007_/Q Tile_X0Y0_FrameData[28] VGND VPWR Tile_X0Y9_FrameStrobe[2] latch
XFILLER_569_182 VPWR VGND sg13cmos5l_decap_8
XFILLER_288_35 VPWR VGND sg13cmos5l_decap_8
XFILLER_179_166 VPWR VGND sg13cmos5l_decap_8
XFILLER_584_174 VPWR VGND sg13cmos5l_fill_1
XFILLER_383_225 VPWR VGND sg13cmos5l_decap_4
XFILLER_41_17 VPWR VGND sg13cmos5l_decap_8
X_2958_ Tile_X0Y8_EE4BEG[14] _4758_/X VPWR VGND sg13cmos5l_buf_1
XFILLER_438_49 VPWR VGND sg13cmos5l_decap_8
XFILLER_585_77 VPWR VGND sg13cmos5l_decap_8
X_1909_ _1909_/Q Tile_X0Y3_FrameData[20] VGND VPWR Tile_X0Y9_FrameStrobe[7] latch
XFILLER_157_28 VPWR VGND sg13cmos5l_decap_8
X_2889_ Tile_X0Y6_FrameData_O[10] Tile_X0Y6_FrameData[10] VPWR VGND sg13cmos5l_buf_1
XANTENNA__3546__X Tile_X0Y9_E6BEG[4] VPWR VGND sg13cmos5l_antennanp
XFILLER_135_214 VPWR VGND sg13cmos5l_fill_2
X_4628_ _4628_/X Tile_X0Y7_WW4END[15] AXI_M_SOC_RDATA16 _4699_/X _4668_/X _0303_/Q
+ _0302_/Q VPWR VGND sg13cmos5l_mux4_1
XFILLER_518_93 VPWR VGND sg13cmos5l_fill_1
XFILLER_351_133 VPWR VGND sg13cmos5l_decap_8
XFILLER_497_126 VPWR VGND sg13cmos5l_decap_8
X_4559_ _4559_/X _4475_/X _4591_/X _4590_/X _4474_/X _2457_/Q _2456_/Q VPWR VGND sg13cmos5l_mux4_1
XFILLER_103_100 VPWR VGND sg13cmos5l_decap_8
XFILLER_500_119 VPWR VGND sg13cmos5l_decap_8
XFILLER_173_49 VPWR VGND sg13cmos5l_decap_8
XFILLER_534_70 VPWR VGND sg13cmos5l_decap_8
XFILLER_639_175 VPWR VGND sg13cmos5l_decap_8
XFILLER_534_81 VPWR VGND sg13cmos5l_fill_1
XFILLER_106_21 VPWR VGND sg13cmos5l_decap_8
XFILLER_654_112 VPWR VGND sg13cmos5l_decap_8
XFILLER_470_14 VPWR VGND sg13cmos5l_decap_8
XFILLER_293_7 VPWR VGND sg13cmos5l_decap_8
XANTENNA__3281__X Tile_X0Y0_E6BEG[1] VPWR VGND sg13cmos5l_antennanp
XFILLER_453_207 VPWR VGND sg13cmos5l_decap_8
XFILLER_654_189 VPWR VGND sg13cmos5l_decap_8
XFILLER_66_69 VPWR VGND sg13cmos5l_decap_4
XFILLER_620_28 VPWR VGND sg13cmos5l_decap_8
XFILLER_460_7 VPWR VGND sg13cmos5l_decap_8
XFILLER_403_63 VPWR VGND sg13cmos5l_decap_8
XFILLER_558_7 VPWR VGND sg13cmos5l_decap_8
XFILLER_72_212 VPWR VGND sg13cmos5l_fill_1
XFILLER_550_91 VPWR VGND sg13cmos5l_decap_8
XFILLER_406_156 VPWR VGND sg13cmos5l_decap_8
XFILLER_122_42 VPWR VGND sg13cmos5l_decap_8
XFILLER_272_173 VPWR VGND sg13cmos5l_decap_8
XFILLER_82_35 VPWR VGND sg13cmos5l_decap_8
XFILLER_479_56 VPWR VGND sg13cmos5l_decap_8
XFILLER_421_126 VPWR VGND sg13cmos5l_decap_8
XFILLER_700_72 VPWR VGND sg13cmos5l_decap_8
XFILLER_567_119 VPWR VGND sg13cmos5l_decap_8
XFILLER_198_35 VPWR VGND sg13cmos5l_decap_8
XFILLER_709_168 VPWR VGND sg13cmos5l_decap_8
XFILLER_319_119 VPWR VGND sg13cmos5l_fill_2
XFILLER_15_84 VPWR VGND sg13cmos5l_decap_8
XFILLER_575_196 VPWR VGND sg13cmos5l_decap_8
XFILLER_348_49 VPWR VGND sg13cmos5l_decap_8
XFILLER_709_70 VPWR VGND sg13cmos5l_decap_8
XFILLER_327_130 VPWR VGND sg13cmos5l_decap_8
XFILLER_495_77 VPWR VGND sg13cmos5l_decap_8
XFILLER_645_14 VPWR VGND sg13cmos5l_decap_8
XFILLER_215_0 VPWR VGND sg13cmos5l_decap_8
XANTENNA__3456__X Tile_X0Y1_FrameData_O[14] VPWR VGND sg13cmos5l_antennanp
XFILLER_488_126 VPWR VGND sg13cmos5l_decap_8
XFILLER_488_137 VPWR VGND sg13cmos5l_fill_1
XFILLER_141_217 VPWR VGND sg13cmos5l_decap_8
XFILLER_141_228 VPWR VGND sg13cmos5l_fill_1
XFILLER_661_35 VPWR VGND sg13cmos5l_decap_8
XFILLER_444_70 VPWR VGND sg13cmos5l_decap_8
XFILLER_645_112 VPWR VGND sg13cmos5l_decap_8
XFILLER_584_0 VPWR VGND sg13cmos5l_decap_8
XFILLER_380_14 VPWR VGND sg13cmos5l_decap_8
XANTENNA__3191__X Tile_X0Y0_N4BEG[15] VPWR VGND sg13cmos5l_antennanp
X_0240_ _0240_/Q Tile_X0Y7_FrameData[15] VGND VPWR Tile_X0Y9_FrameStrobe[2] latch
XFILLER_645_189 VPWR VGND sg13cmos5l_decap_8
X_0171_ _0171_/Q Tile_X0Y7_FrameData[20] VGND VPWR Tile_X0Y9_FrameStrobe[0] latch
XFILLER_530_28 VPWR VGND sg13cmos5l_decap_8
XFILLER_313_63 VPWR VGND sg13cmos5l_decap_8
XFILLER_598_211 VPWR VGND sg13cmos5l_fill_2
XFILLER_263_151 VPWR VGND sg13cmos5l_fill_2
XFILLER_56_80 VPWR VGND sg13cmos5l_decap_8
XFILLER_389_56 VPWR VGND sg13cmos5l_decap_8
X_3930_ _3930_/X _3985_/X Tile_X0Y1_WW4END[6] _3984_/X AXI_M_SOC_ARREADY _1349_/Q
+ _1348_/Q VPWR VGND sg13cmos5l_mux4_1
XFILLER_686_21 VPWR VGND sg13cmos5l_decap_8
X_3861_ _3861_/X _3850_/X Tile_X0Y0_W6END[2] Tile_X0Y0_S1END[2] _3861_/A3 _0943_/Q
+ _0942_/Q VPWR VGND sg13cmos5l_mux4_1
XFILLER_31_131 VPWR VGND sg13cmos5l_fill_1
XFILLER_176_103 VPWR VGND sg13cmos5l_decap_8
XFILLER_31_153 VPWR VGND sg13cmos5l_decap_8
X_2812_ Tile_X0Y3_E2BEG[2] _4150_/X VPWR VGND sg13cmos5l_buf_1
XFILLER_686_98 VPWR VGND sg13cmos5l_decap_8
X_3792_ _3792_/X Tile_X0Y0_W1END[0] Tile_X0Y0_WW4END[0] Tile_X0Y0_W6END[8] _3881_/X
+ _1153_/Q _1152_/Q VPWR VGND sg13cmos5l_mux4_1
XFILLER_258_49 VPWR VGND sg13cmos5l_decap_8
XFILLER_619_70 VPWR VGND sg13cmos5l_decap_8
XFILLER_581_133 VPWR VGND sg13cmos5l_decap_8
XFILLER_318_141 VPWR VGND sg13cmos5l_decap_8
X_2743_ Tile_X0Y3_FrameData_O[1] Tile_X0Y3_FrameData[1] VPWR VGND sg13cmos5l_buf_1
XFILLER_555_14 VPWR VGND sg13cmos5l_decap_8
XANTENNA__3366__X Tile_X0Y2_EE4BEG[5] VPWR VGND sg13cmos5l_antennanp
X_2674_ _2674_/Q Tile_X0Y6_FrameData[21] VGND VPWR Tile_X0Y9_FrameStrobe[7] latch
X_4413_ _4413_/X AXI_M_SOC_RLAST _4453_/X _4457_/X _4431_/X _2277_/Q _2276_/Q VPWR
+ VGND sg13cmos5l_mux4_1
XFILLER_705_28 VPWR VGND sg13cmos5l_decap_8
X_1625_ _1625_/Q Tile_X0Y2_FrameData[24] VGND VPWR Tile_X0Y9_FrameStrobe[6] latch
XFILLER_479_159 VPWR VGND sg13cmos5l_decap_4
XFILLER_635_91 VPWR VGND sg13cmos5l_decap_8
XFILLER_207_42 VPWR VGND sg13cmos5l_decap_8
XFILLER_98_120 VPWR VGND sg13cmos5l_decap_8
X_4344_ _4344_/X _4302_/X _0099_/X _4301_/X _0112_/X _1965_/Q _1964_/Q VPWR VGND sg13cmos5l_mux4_1
X_1556_ _1556_/Q Tile_X0Y2_FrameData[29] VGND VPWR Tile_X0Y9_FrameStrobe[4] latch
XFILLER_571_35 VPWR VGND sg13cmos5l_decap_8
XFILLER_354_70 VPWR VGND sg13cmos5l_decap_8
XFILLER_286_210 VPWR VGND sg13cmos5l_decap_8
XFILLER_98_153 VPWR VGND sg13cmos5l_decap_8
XFILLER_636_112 VPWR VGND sg13cmos5l_decap_8
X_0507_ _0507_/Q Tile_X0Y8_FrameData[4] VGND VPWR Tile_X0Y9_FrameStrobe[2] latch
XFILLER_290_14 VPWR VGND sg13cmos5l_decap_8
X_4275_ _4275_/X Tile_X0Y4_WW4END[12] AXI_M_SOC_BRESP1 _4348_/X _4318_/X _2063_/Q
+ _2062_/Q VPWR VGND sg13cmos5l_mux4_1
X_1487_ _1487_/Q Tile_X0Y2_FrameData[2] VGND VPWR Tile_X0Y9_FrameStrobe[1] latch
X_3226_ Tile_X0Y0_FrameStrobe_O[14] Tile_X0Y9_FrameStrobe[14] VPWR VGND sg13cmos5l_buf_1
X_0438_ _0438_/Q Tile_X0Y8_FrameData[9] VGND VPWR Tile_X0Y9_FrameStrobe[0] latch
XFILLER_100_147 VPWR VGND sg13cmos5l_decap_8
XFILLER_504_84 VPWR VGND sg13cmos5l_decap_8
XFILLER_651_126 VPWR VGND sg13cmos5l_decap_8
XFILLER_440_28 VPWR VGND sg13cmos5l_decap_8
XFILLER_223_63 VPWR VGND sg13cmos5l_decap_8
X_3157_ Tile_X0Y7_FrameData_O[27] Tile_X0Y7_FrameData[27] VPWR VGND sg13cmos5l_buf_1
XFILLER_54_201 VPWR VGND sg13cmos5l_decap_8
X_0369_ _0369_/Q Tile_X0Y7_FrameData[14] VGND VPWR Tile_X0Y9_FrameStrobe[6] latch
XFILLER_54_212 VPWR VGND sg13cmos5l_fill_2
XFILLER_370_91 VPWR VGND sg13cmos5l_decap_8
X_2108_ _2108_/Q Tile_X0Y4_FrameData[9] VGND VPWR Tile_X0Y9_FrameStrobe[5] latch
X_3088_ Tile_X0Y7_E2BEG[2] _4614_/X VPWR VGND sg13cmos5l_buf_1
XFILLER_299_56 VPWR VGND sg13cmos5l_decap_8
X_2039_ _2039_/Q Tile_X0Y4_FrameData[14] VGND VPWR Tile_X0Y9_FrameStrobe[3] latch
XFILLER_596_21 VPWR VGND sg13cmos5l_decap_8
XFILLER_557_141 VPWR VGND sg13cmos5l_fill_2
XFILLER_52_38 VPWR VGND sg13cmos5l_decap_8
XFILLER_167_103 VPWR VGND sg13cmos5l_fill_2
XFILLER_356_203 VPWR VGND sg13cmos5l_decap_8
XFILLER_411_181 VPWR VGND sg13cmos5l_decap_8
XFILLER_706_105 VPWR VGND sg13cmos5l_decap_8
XFILLER_411_192 VPWR VGND sg13cmos5l_fill_1
XFILLER_356_225 VPWR VGND sg13cmos5l_decap_4
XFILLER_168_49 VPWR VGND sg13cmos5l_decap_8
XFILLER_139_7 VPWR VGND sg13cmos5l_decap_8
XFILLER_529_70 VPWR VGND sg13cmos5l_decap_8
XFILLER_572_133 VPWR VGND sg13cmos5l_decap_8
XFILLER_529_81 VPWR VGND sg13cmos5l_fill_2
XFILLER_465_14 VPWR VGND sg13cmos5l_decap_8
XFILLER_108_203 VPWR VGND sg13cmos5l_decap_8
XANTENNA__3276__X Tile_X0Y0_EE4BEG[12] VPWR VGND sg13cmos5l_antennanp
XFILLER_371_217 VPWR VGND sg13cmos5l_decap_4
XFILLER_108_225 VPWR VGND sg13cmos5l_decap_4
XFILLER_248_82 VPWR VGND sg13cmos5l_fill_1
XFILLER_324_122 VPWR VGND sg13cmos5l_decap_8
XFILLER_306_7 VPWR VGND sg13cmos5l_decap_8
XFILLER_615_28 VPWR VGND sg13cmos5l_decap_8
XFILLER_324_155 VPWR VGND sg13cmos5l_fill_1
XFILLER_123_217 VPWR VGND sg13cmos5l_decap_8
XFILLER_123_228 VPWR VGND sg13cmos5l_fill_1
XFILLER_545_91 VPWR VGND sg13cmos5l_decap_8
XFILLER_117_42 VPWR VGND sg13cmos5l_decap_8
XFILLER_89_142 VPWR VGND sg13cmos5l_decap_4
XFILLER_481_35 VPWR VGND sg13cmos5l_decap_8
XFILLER_77_35 VPWR VGND sg13cmos5l_decap_8
XFILLER_627_112 VPWR VGND sg13cmos5l_fill_2
XFILLER_117_86 VPWR VGND sg13cmos5l_fill_1
XFILLER_89_175 VPWR VGND sg13cmos5l_decap_8
XFILLER_675_7 VPWR VGND sg13cmos5l_decap_8
XFILLER_493_140 VPWR VGND sg13cmos5l_decap_8
XFILLER_631_49 VPWR VGND sg13cmos5l_decap_8
XFILLER_414_84 VPWR VGND sg13cmos5l_decap_8
XFILLER_627_189 VPWR VGND sg13cmos5l_fill_1
XFILLER_642_126 VPWR VGND sg13cmos5l_decap_8
XFILLER_350_28 VPWR VGND sg13cmos5l_decap_8
XFILLER_133_63 VPWR VGND sg13cmos5l_decap_8
XFILLER_245_140 VPWR VGND sg13cmos5l_decap_8
XFILLER_280_91 VPWR VGND sg13cmos5l_decap_8
XFILLER_245_151 VPWR VGND sg13cmos5l_fill_1
XFILLER_245_173 VPWR VGND sg13cmos5l_decap_8
XFILLER_260_110 VPWR VGND sg13cmos5l_decap_8
XFILLER_245_195 VPWR VGND sg13cmos5l_decap_8
XFILLER_165_0 VPWR VGND sg13cmos5l_decap_8
XFILLER_260_165 VPWR VGND sg13cmos5l_decap_8
XFILLER_332_0 VPWR VGND sg13cmos5l_decap_8
XFILLER_13_142 VPWR VGND sg13cmos5l_fill_1
XFILLER_548_185 VPWR VGND sg13cmos5l_decap_8
XFILLER_347_225 VPWR VGND sg13cmos5l_decap_4
XFILLER_656_35 VPWR VGND sg13cmos5l_decap_8
XFILLER_439_70 VPWR VGND sg13cmos5l_decap_8
XFILLER_375_14 VPWR VGND sg13cmos5l_decap_8
XANTENNA__3186__X Tile_X0Y0_N4BEG[10] VPWR VGND sg13cmos5l_antennanp
XFILLER_712_119 VPWR VGND sg13cmos5l_decap_8
XFILLER_315_111 VPWR VGND sg13cmos5l_decap_8
XFILLER_315_133 VPWR VGND sg13cmos5l_decap_4
XFILLER_114_206 VPWR VGND sg13cmos5l_decap_8
XFILLER_54_7 VPWR VGND sg13cmos5l_decap_8
XFILLER_525_28 VPWR VGND sg13cmos5l_decap_8
XFILLER_308_63 VPWR VGND sg13cmos5l_decap_8
XFILLER_672_56 VPWR VGND sg13cmos5l_decap_8
X_1410_ _1410_/Q Tile_X0Y1_FrameData[23] VGND VPWR Tile_X0Y9_FrameStrobe[7] latch
XFILLER_330_136 VPWR VGND sg13cmos5l_decap_8
X_2390_ _2390_/Q Tile_X0Y5_FrameData[15] VGND VPWR Tile_X0Y9_FrameStrobe[6] latch
XFILLER_476_129 VPWR VGND sg13cmos5l_fill_1
XFILLER_391_35 VPWR VGND sg13cmos5l_decap_8
XFILLER_174_70 VPWR VGND sg13cmos5l_decap_8
XFILLER_618_112 VPWR VGND sg13cmos5l_decap_4
XFILLER_3_21 VPWR VGND sg13cmos5l_decap_8
X_1341_ _1341_/Q Tile_X0Y1_FrameData[28] VGND VPWR Tile_X0Y9_FrameStrobe[5] latch
XFILLER_618_156 VPWR VGND sg13cmos5l_decap_8
X_4060_ _4060_/X Tile_X0Y2_WW4END[11] AXI_M_SOC_AWREADY _4127_/X _4103_/X _1553_/Q
+ _1552_/Q VPWR VGND sg13cmos5l_mux4_1
X_1272_ _1272_/Q Tile_X0Y1_FrameData[1] VGND VPWR Tile_X0Y9_FrameStrobe[2] latch
XFILLER_541_49 VPWR VGND sg13cmos5l_decap_8
XFILLER_228_129 VPWR VGND sg13cmos5l_decap_4
XFILLER_3_98 VPWR VGND sg13cmos5l_decap_8
XFILLER_324_95 VPWR VGND sg13cmos5l_decap_8
X_3011_ Tile_X0Y5_E2BEGb[6] _4386_/X VPWR VGND sg13cmos5l_buf_1
XFILLER_260_28 VPWR VGND sg13cmos5l_decap_8
XFILLER_95_189 VPWR VGND sg13cmos5l_fill_2
X_0223_ _0223_/Q Tile_X0Y7_FrameData[0] VGND VPWR Tile_X0Y9_FrameStrobe[1] latch
XFILLER_36_212 VPWR VGND sg13cmos5l_fill_2
XFILLER_236_151 VPWR VGND sg13cmos5l_decap_8
X_0154_ _3183_/A _3912_/X _3913_/X _1638_/Q VPWR VGND sg13cmos5l_mux2_1
XFILLER_340_61 VPWR VGND sg13cmos5l_decap_8
XFILLER_697_42 VPWR VGND sg13cmos5l_decap_8
X_0085_ _0085_/X _3873_/X _3874_/X _2149_/Q VPWR VGND sg13cmos5l_mux2_1
XFILLER_251_154 VPWR VGND sg13cmos5l_decap_8
XFILLER_251_165 VPWR VGND sg13cmos5l_fill_1
X_3913_ _3913_/X _4123_/X _4127_/X _4104_/X _4103_/X _1640_/Q _1639_/Q VPWR VGND sg13cmos5l_mux4_1
XFILLER_251_187 VPWR VGND sg13cmos5l_decap_4
X_4893_ _4893_/X Tile_X0Y9_N1END[1] Tile_X0Y9_W6END[1] _4897_/X _4893_/A3 _0677_/Q
+ _0676_/Q VPWR VGND sg13cmos5l_mux4_1
XFILLER_539_163 VPWR VGND sg13cmos5l_decap_4
XFILLER_149_125 VPWR VGND sg13cmos5l_fill_1
X_3844_ _3844_/X Tile_X0Y0_W2MID[2] _3884_/X _3879_/X _3858_/X _1017_/Q _1016_/Q VPWR
+ VGND sg13cmos5l_mux4_1
XFILLER_80_0 VPWR VGND sg13cmos5l_decap_8
XFILLER_566_35 VPWR VGND sg13cmos5l_decap_8
XFILLER_554_133 VPWR VGND sg13cmos5l_fill_2
XFILLER_349_70 VPWR VGND sg13cmos5l_decap_8
XFILLER_285_14 VPWR VGND sg13cmos5l_decap_8
X_3775_ _3775_/X Tile_X0Y0_WW4END[4] Tile_X0Y0_WW4END[12] Tile_X0Y0_W6END[4] _3885_/X
+ _1001_/Q _1000_/Q VPWR VGND sg13cmos5l_mux4_1
XFILLER_353_217 VPWR VGND sg13cmos5l_fill_1
XANTENNA__3096__X Tile_X0Y7_E2BEGb[2] VPWR VGND sg13cmos5l_antennanp
X_0987_ _0987_/Q Tile_X0Y0_FrameData[16] VGND VPWR Tile_X0Y9_FrameStrobe[1] latch
XFILLER_353_228 VPWR VGND sg13cmos5l_fill_1
XFILLER_703_119 VPWR VGND sg13cmos5l_decap_8
X_2726_ _4895_/A3 VPWR VGND sg13cmos5l_tielo
XFILLER_435_28 VPWR VGND sg13cmos5l_decap_8
XFILLER_218_63 VPWR VGND sg13cmos5l_decap_8
X_2657_ _2657_/Q Tile_X0Y6_FrameData[6] VGND VPWR Tile_X0Y9_FrameStrobe[6] latch
XFILLER_582_56 VPWR VGND sg13cmos5l_decap_8
XFILLER_365_91 VPWR VGND sg13cmos5l_decap_8
X_1608_ _1608_/Q Tile_X0Y2_FrameData[9] VGND VPWR Tile_X0Y9_FrameStrobe[5] latch
XFILLER_510_225 VPWR VGND sg13cmos5l_decap_4
XFILLER_467_118 VPWR VGND sg13cmos5l_decap_8
XFILLER_711_196 VPWR VGND sg13cmos5l_decap_8
X_2588_ _2588_/Q Tile_X0Y6_FrameData[11] VGND VPWR Tile_X0Y9_FrameStrobe[4] latch
X_4327_ _4327_/X _4805_/X _4809_/X _4813_/X _4787_/X _0644_/Q _0643_/Q VPWR VGND sg13cmos5l_mux4_1
X_1539_ _1539_/Q Tile_X0Y2_FrameData[14] VGND VPWR Tile_X0Y9_FrameStrobe[3] latch
XFILLER_609_167 VPWR VGND sg13cmos5l_decap_8
X_4258_ _4258_/X Tile_X0Y4_W2MID[5] AXI_M_SOC_BRESP0 _4317_/X _4316_/X _2097_/Q _2096_/Q
+ VPWR VGND sg13cmos5l_mux4_1
XFILLER_451_49 VPWR VGND sg13cmos5l_decap_8
XFILLER_47_38 VPWR VGND sg13cmos5l_decap_8
X_3209_ Tile_X0Y0_N1BEG[1] _3781_/X VPWR VGND sg13cmos5l_buf_1
XFILLER_170_28 VPWR VGND sg13cmos5l_decap_8
X_4189_ _4189_/X AXI_M_SOC_BVALID _4224_/X _4228_/X _4208_/X _1763_/Q _1762_/Q VPWR
+ VGND sg13cmos5l_mux4_1
XFILLER_227_140 VPWR VGND sg13cmos5l_decap_8
XFILLER_490_176 VPWR VGND sg13cmos5l_decap_8
XFILLER_490_187 VPWR VGND sg13cmos5l_fill_1
XFILLER_103_77 VPWR VGND sg13cmos5l_decap_8
XFILLER_577_225 VPWR VGND sg13cmos5l_decap_4
XFILLER_256_7 VPWR VGND sg13cmos5l_decap_8
XFILLER_400_42 VPWR VGND sg13cmos5l_decap_8
XFILLER_242_187 VPWR VGND sg13cmos5l_decap_8
XFILLER_329_225 VPWR VGND sg13cmos5l_decap_4
XANTENNA__2903__X Tile_X0Y6_FrameData_O[24] VPWR VGND sg13cmos5l_antennanp
XFILLER_423_7 VPWR VGND sg13cmos5l_decap_8
XFILLER_476_35 VPWR VGND sg13cmos5l_decap_8
XFILLER_10_112 VPWR VGND sg13cmos5l_decap_8
XFILLER_259_92 VPWR VGND sg13cmos5l_decap_8
XFILLER_195_14 VPWR VGND sg13cmos5l_decap_8
XFILLER_6_105 VPWR VGND sg13cmos5l_fill_1
XFILLER_148_191 VPWR VGND sg13cmos5l_decap_8
XFILLER_626_49 VPWR VGND sg13cmos5l_decap_8
XFILLER_409_84 VPWR VGND sg13cmos5l_decap_4
XFILLER_12_63 VPWR VGND sg13cmos5l_decap_8
XFILLER_498_221 VPWR VGND sg13cmos5l_fill_1
XFILLER_699_181 VPWR VGND sg13cmos5l_fill_1
XFILLER_170_109 VPWR VGND sg13cmos5l_decap_8
XFILLER_345_28 VPWR VGND sg13cmos5l_decap_8
XFILLER_128_63 VPWR VGND sg13cmos5l_decap_8
XFILLER_501_203 VPWR VGND sg13cmos5l_decap_8
XFILLER_492_56 VPWR VGND sg13cmos5l_decap_8
XANTENNA__3734__X AXI_M_SOC_ARADDR6 VPWR VGND sg13cmos5l_antennanp
XFILLER_458_107 VPWR VGND sg13cmos5l_fill_1
XFILLER_275_91 VPWR VGND sg13cmos5l_decap_8
XFILLER_312_125 VPWR VGND sg13cmos5l_decap_8
XFILLER_88_56 VPWR VGND sg13cmos5l_decap_8
XFILLER_312_136 VPWR VGND sg13cmos5l_fill_1
XFILLER_88_67 VPWR VGND sg13cmos5l_fill_1
XFILLER_77_123 VPWR VGND sg13cmos5l_fill_2
XFILLER_361_49 VPWR VGND sg13cmos5l_decap_8
XFILLER_144_84 VPWR VGND sg13cmos5l_decap_8
XFILLER_615_126 VPWR VGND sg13cmos5l_decap_4
XFILLER_282_0 VPWR VGND sg13cmos5l_decap_8
XFILLER_547_0 VPWR VGND sg13cmos5l_decap_8
XFILLER_33_226 VPWR VGND sg13cmos5l_fill_2
XFILLER_379_147 VPWR VGND sg13cmos5l_fill_2
XFILLER_233_165 VPWR VGND sg13cmos5l_fill_1
XFILLER_310_42 VPWR VGND sg13cmos5l_decap_8
XFILLER_583_206 VPWR VGND sg13cmos5l_decap_4
XFILLER_394_106 VPWR VGND sg13cmos5l_decap_8
XFILLER_714_0 VPWR VGND sg13cmos5l_decap_8
XFILLER_667_56 VPWR VGND sg13cmos5l_decap_8
XFILLER_53_70 VPWR VGND sg13cmos5l_decap_8
XANTENNA__2813__X Tile_X0Y3_E2BEG[3] VPWR VGND sg13cmos5l_antennanp
X_0910_ _0910_/Q Tile_X0Y9_FrameData[17] VGND VPWR Tile_X0Y9_FrameStrobe[7] latch
XFILLER_310_97 VPWR VGND sg13cmos5l_decap_8
X_1890_ _1890_/Q Tile_X0Y3_FrameData[7] VGND VPWR Tile_X0Y9_FrameStrobe[6] latch
XFILLER_386_35 VPWR VGND sg13cmos5l_decap_8
XFILLER_169_70 VPWR VGND sg13cmos5l_decap_8
X_0841_ _0841_/Q Tile_X0Y9_FrameData[22] VGND VPWR Tile_X0Y9_FrameStrobe[5] latch
XFILLER_335_228 VPWR VGND sg13cmos5l_fill_1
XFILLER_536_199 VPWR VGND sg13cmos5l_fill_1
X_3560_ Tile_X0Y9_EE4BEG[6] _4870_/X VPWR VGND sg13cmos5l_buf_1
XFILLER_139_191 VPWR VGND sg13cmos5l_fill_1
X_0772_ _0772_/Q Tile_X0Y9_FrameData[27] VGND VPWR Tile_X0Y9_FrameStrobe[3] latch
XFILLER_536_49 VPWR VGND sg13cmos5l_decap_8
X_2511_ _2511_/Q Tile_X0Y6_FrameData[24] VGND VPWR Tile_X0Y9_FrameStrobe[2] latch
XFILLER_683_77 VPWR VGND sg13cmos5l_decap_8
XFILLER_255_28 VPWR VGND sg13cmos5l_decap_8
X_3491_ Tile_X0Y1_E6BEG[1] _3965_/X VPWR VGND sg13cmos5l_buf_1
XANTENNA__3644__X AXI_M_SOC_AWADDR5 VPWR VGND sg13cmos5l_antennanp
XFILLER_638_207 VPWR VGND sg13cmos5l_decap_8
X_2442_ _2442_/Q Tile_X0Y6_FrameData[29] VGND VPWR Tile_X0Y9_FrameStrobe[0] latch
XFILLER_449_118 VPWR VGND sg13cmos5l_fill_2
X_2373_ _2373_/Q Tile_X0Y5_FrameData[0] VGND VPWR Tile_X0Y9_FrameStrobe[5] latch
X_4112_ _4112_/X _4574_/X _4578_/X _4582_/X _4557_/X _2665_/Q _2664_/Q VPWR VGND sg13cmos5l_mux4_1
X_1324_ _1324_/Q Tile_X0Y1_FrameData[13] VGND VPWR Tile_X0Y9_FrameStrobe[4] latch
XFILLER_457_173 VPWR VGND sg13cmos5l_decap_8
XFILLER_271_49 VPWR VGND sg13cmos5l_decap_8
XFILLER_68_156 VPWR VGND sg13cmos5l_decap_8
XFILLER_632_70 VPWR VGND sg13cmos5l_decap_8
XFILLER_204_21 VPWR VGND sg13cmos5l_decap_8
X_4043_ _4043_/X Tile_X0Y2_W2MID[4] AXI_M_SOC_AWREADY _4103_/X _4102_/X _1587_/Q _1586_/Q
+ VPWR VGND sg13cmos5l_mux4_1
X_1255_ _1255_/Q Tile_X0Y1_FrameData[18] VGND VPWR Tile_X0Y9_FrameStrobe[2] latch
XFILLER_209_140 VPWR VGND sg13cmos5l_decap_8
X_0206_ _0206_/Q Tile_X0Y7_FrameData[17] VGND VPWR Tile_X0Y9_FrameStrobe[1] latch
XFILLER_204_98 VPWR VGND sg13cmos5l_decap_8
X_1186_ _1186_/Q Tile_X0Y1_FrameData[23] VGND VPWR Tile_X0Y9_FrameStrobe[0] latch
XFILLER_559_203 VPWR VGND sg13cmos5l_decap_8
XFILLER_559_225 VPWR VGND sg13cmos5l_decap_4
XFILLER_501_63 VPWR VGND sg13cmos5l_decap_8
X_0137_ AXI_M_SOC_AWLEN6 _0940_/Q _3677_/X VPWR VGND sg13cmos5l_nor2b_1
XFILLER_24_226 VPWR VGND sg13cmos5l_fill_2
XFILLER_220_42 VPWR VGND sg13cmos5l_decap_8
X_0068_ AXI_M_SOC_WSTRB3 _0935_/Q _3725_/X VPWR VGND sg13cmos5l_or2_1
XFILLER_224_198 VPWR VGND sg13cmos5l_fill_1
XFILLER_574_217 VPWR VGND sg13cmos5l_decap_8
XFILLER_577_56 VPWR VGND sg13cmos5l_decap_8
XFILLER_574_228 VPWR VGND sg13cmos5l_fill_1
X_4876_ _4876_/X Tile_X0Y9_WW4END[3] AXI_M_SOC_RDATA3 _4919_/X _4907_/X _0791_/Q _0790_/Q
+ VPWR VGND sg13cmos5l_mux4_1
XFILLER_378_191 VPWR VGND sg13cmos5l_decap_8
XFILLER_296_35 VPWR VGND sg13cmos5l_decap_8
X_3827_ _3827_/X Tile_X0Y0_WW4END[8] _3876_/X _3853_/X _3860_/X _1051_/Q _1050_/Q
+ VPWR VGND sg13cmos5l_mux4_1
XFILLER_192_201 VPWR VGND sg13cmos5l_decap_8
XFILLER_527_188 VPWR VGND sg13cmos5l_decap_8
XFILLER_393_183 VPWR VGND sg13cmos5l_fill_2
XFILLER_326_228 VPWR VGND sg13cmos5l_fill_1
X_3758_ AXI_M_SOC_ARADDR30 Tile_X0Y8_W1END[2] Tile_X0Y8_WW4END[6] Tile_X0Y8_WW4END[14]
+ _4814_/X _0475_/Q _0474_/Q VPWR VGND sg13cmos5l_mux4_1
XFILLER_446_49 VPWR VGND sg13cmos5l_decap_8
XFILLER_593_77 VPWR VGND sg13cmos5l_decap_8
XFILLER_341_209 VPWR VGND sg13cmos5l_decap_8
X_2709_ _4422_/A3 VPWR VGND sg13cmos5l_tielo
XFILLER_165_28 VPWR VGND sg13cmos5l_decap_8
X_3689_ AXI_M_SOC_AWVALID Tile_X0Y2_WW4END[0] Tile_X0Y2_WW4END[8] Tile_X0Y2_W6END[0]
+ _4116_/X _1505_/Q _1504_/Q VPWR VGND sg13cmos5l_mux4_1
XANTENNA__3554__X Tile_X0Y9_EE4BEG[0] VPWR VGND sg13cmos5l_antennanp
XFILLER_696_162 VPWR VGND sg13cmos5l_fill_1
XFILLER_550_191 VPWR VGND sg13cmos5l_decap_4
XFILLER_58_59 VPWR VGND sg13cmos5l_decap_8
XFILLER_247_213 VPWR VGND sg13cmos5l_decap_8
XFILLER_181_49 VPWR VGND sg13cmos5l_decap_8
XFILLER_542_70 VPWR VGND sg13cmos5l_decap_8
XFILLER_59_167 VPWR VGND sg13cmos5l_decap_8
XFILLER_114_21 VPWR VGND sg13cmos5l_decap_8
XFILLER_373_7 VPWR VGND sg13cmos5l_decap_8
XFILLER_74_14 VPWR VGND sg13cmos5l_decap_8
XFILLER_114_98 VPWR VGND sg13cmos5l_decap_8
XFILLER_404_221 VPWR VGND sg13cmos5l_fill_1
XFILLER_540_7 VPWR VGND sg13cmos5l_decap_8
XFILLER_411_63 VPWR VGND sg13cmos5l_decap_8
XFILLER_15_215 VPWR VGND sg13cmos5l_decap_4
XFILLER_638_7 VPWR VGND sg13cmos5l_decap_8
XFILLER_130_42 VPWR VGND sg13cmos5l_decap_8
XANTENNA__0137__Y AXI_M_SOC_AWLEN6 VPWR VGND sg13cmos5l_antennanp
XFILLER_230_124 VPWR VGND sg13cmos5l_decap_4
XFILLER_90_35 VPWR VGND sg13cmos5l_decap_8
XFILLER_620_195 VPWR VGND sg13cmos5l_fill_1
XFILLER_565_228 VPWR VGND sg13cmos5l_fill_1
XANTENNA__3729__X AXI_M_SOC_ARADDR1 VPWR VGND sg13cmos5l_antennanp
XFILLER_487_56 VPWR VGND sg13cmos5l_decap_8
XFILLER_580_209 VPWR VGND sg13cmos5l_fill_2
XFILLER_183_212 VPWR VGND sg13cmos5l_decap_8
XFILLER_317_228 VPWR VGND sg13cmos5l_fill_1
XFILLER_23_84 VPWR VGND sg13cmos5l_decap_8
XFILLER_128_0 VPWR VGND sg13cmos5l_decap_8
XFILLER_356_49 VPWR VGND sg13cmos5l_decap_8
XFILLER_139_84 VPWR VGND sg13cmos5l_decap_8
XFILLER_653_14 VPWR VGND sg13cmos5l_decap_8
XFILLER_136_161 VPWR VGND sg13cmos5l_decap_8
XFILLER_99_77 VPWR VGND sg13cmos5l_decap_8
XANTENNA__3464__X Tile_X0Y1_FrameData_O[22] VPWR VGND sg13cmos5l_antennanp
XFILLER_486_213 VPWR VGND sg13cmos5l_fill_1
XFILLER_151_131 VPWR VGND sg13cmos5l_decap_8
XFILLER_2_130 VPWR VGND sg13cmos5l_fill_1
XFILLER_151_153 VPWR VGND sg13cmos5l_fill_1
XFILLER_97_218 VPWR VGND sg13cmos5l_decap_4
XFILLER_497_0 VPWR VGND sg13cmos5l_decap_8
XFILLER_2_163 VPWR VGND sg13cmos5l_fill_2
XFILLER_439_140 VPWR VGND sg13cmos5l_fill_2
XFILLER_305_42 VPWR VGND sg13cmos5l_decap_8
XFILLER_643_210 VPWR VGND sg13cmos5l_fill_2
XFILLER_452_70 VPWR VGND sg13cmos5l_fill_2
XFILLER_664_0 VPWR VGND sg13cmos5l_decap_8
XFILLER_643_221 VPWR VGND sg13cmos5l_fill_1
XFILLER_454_121 VPWR VGND sg13cmos5l_fill_2
XANTENNA__2808__X Tile_X0Y3_E2BEGb[6] VPWR VGND sg13cmos5l_antennanp
XFILLER_17_7 VPWR VGND sg13cmos5l_decap_8
XFILLER_65_148 VPWR VGND sg13cmos5l_decap_8
XFILLER_399_209 VPWR VGND sg13cmos5l_decap_8
XFILLER_253_227 VPWR VGND sg13cmos5l_fill_2
X_1040_ _1040_/Q Tile_X0Y0_FrameData[27] VGND VPWR Tile_X0Y9_FrameStrobe[3] latch
XFILLER_602_84 VPWR VGND sg13cmos5l_decap_8
XFILLER_321_63 VPWR VGND sg13cmos5l_decap_8
XFILLER_206_154 VPWR VGND sg13cmos5l_decap_8
XFILLER_0_77 VPWR VGND sg13cmos5l_decap_8
XFILLER_678_77 VPWR VGND sg13cmos5l_decap_8
XANTENNA__0047__Y AXI_M_SOC_AWCACHE2 VPWR VGND sg13cmos5l_antennanp
X_2991_ Tile_X0Y8_FrameData_O[31] Tile_X0Y8_FrameData[31] VPWR VGND sg13cmos5l_buf_1
XFILLER_556_217 VPWR VGND sg13cmos5l_decap_8
XFILLER_21_207 VPWR VGND sg13cmos5l_decap_8
XANTENNA__3639__X AXI_M_SOC_AWADDR0 VPWR VGND sg13cmos5l_antennanp
XFILLER_556_228 VPWR VGND sg13cmos5l_fill_1
XFILLER_397_56 VPWR VGND sg13cmos5l_decap_8
X_4730_ _4730_/X Tile_X0Y8_W2MID[5] AXI_M_SOC_RDATA10 _4789_/X _4788_/X _0587_/Q _0586_/Q
+ VPWR VGND sg13cmos5l_mux4_1
XFILLER_9_42 VPWR VGND sg13cmos5l_decap_8
X_1942_ _1942_/Q Tile_X0Y4_FrameData[15] VGND VPWR Tile_X0Y9_FrameStrobe[0] latch
XFILLER_694_21 VPWR VGND sg13cmos5l_decap_8
XFILLER_509_133 VPWR VGND sg13cmos5l_fill_2
XFILLER_119_106 VPWR VGND sg13cmos5l_fill_1
X_4661_ _4661_/X Tile_X0Y8_W1END[0] Tile_X0Y8_W6END[4] _4812_/X _4772_/X _0671_/Q
+ _0670_/Q VPWR VGND sg13cmos5l_mux4_1
X_1873_ _1873_/Q Tile_X0Y3_FrameData[24] VGND VPWR Tile_X0Y9_FrameStrobe[6] latch
XFILLER_308_228 VPWR VGND sg13cmos5l_fill_1
X_3612_ Tile_X0Y9_S2BEG[6] _4834_/X VPWR VGND sg13cmos5l_buf_1
X_0824_ _0824_/Q Tile_X0Y9_FrameData[7] VGND VPWR Tile_X0Y9_FrameStrobe[4] latch
X_4592_ _4592_/X Tile_X0Y5_W1END[0] Tile_X0Y5_W2MID[3] Tile_X0Y5_W2END[3] _4433_/X
+ _2387_/Q _2386_/Q VPWR VGND sg13cmos5l_mux4_1
XFILLER_694_98 VPWR VGND sg13cmos5l_decap_8
XFILLER_266_49 VPWR VGND sg13cmos5l_decap_8
XFILLER_627_70 VPWR VGND sg13cmos5l_decap_8
XFILLER_390_142 VPWR VGND sg13cmos5l_decap_8
X_3543_ Tile_X0Y9_E6BEG[1] _4881_/X VPWR VGND sg13cmos5l_buf_1
XFILLER_563_14 VPWR VGND sg13cmos5l_decap_8
X_0755_ _0755_/Q Tile_X0Y9_FrameData[12] VGND VPWR Tile_X0Y9_FrameStrobe[2] latch
XANTENNA__3374__X Tile_X0Y2_EE4BEG[13] VPWR VGND sg13cmos5l_antennanp
X_3474_ Tile_X0Y1_EE4BEG[0] _3948_/X VPWR VGND sg13cmos5l_buf_1
XFILLER_288_124 VPWR VGND sg13cmos5l_decap_8
X_0686_ _0686_/Q Tile_X0Y9_FrameData[17] VGND VPWR Tile_X0Y9_FrameStrobe[0] latch
XFILLER_43_0 VPWR VGND sg13cmos5l_fill_1
XFILLER_713_28 VPWR VGND sg13cmos5l_decap_8
X_2425_ _2425_/Q Tile_X0Y5_FrameData[12] VGND VPWR Tile_X0Y9_FrameStrobe[7] latch
XFILLER_142_175 VPWR VGND sg13cmos5l_decap_8
XFILLER_288_179 VPWR VGND sg13cmos5l_decap_8
XFILLER_643_91 VPWR VGND sg13cmos5l_decap_8
XFILLER_215_42 VPWR VGND sg13cmos5l_decap_8
X_2356_ _2356_/Q Tile_X0Y5_FrameData[17] VGND VPWR Tile_X0Y9_FrameStrobe[5] latch
XFILLER_362_70 VPWR VGND sg13cmos5l_decap_8
XFILLER_445_121 VPWR VGND sg13cmos5l_fill_1
XFILLER_634_221 VPWR VGND sg13cmos5l_fill_1
X_1307_ _1307_/Q Tile_X0Y1_FrameData[30] VGND VPWR Tile_X0Y9_FrameStrobe[4] latch
XFILLER_56_115 VPWR VGND sg13cmos5l_decap_8
X_2287_ _2287_/Q Tile_X0Y5_FrameData[22] VGND VPWR Tile_X0Y9_FrameStrobe[3] latch
XFILLER_244_205 VPWR VGND sg13cmos5l_decap_8
X_4026_ _4026_/X Tile_X0Y0_W2MID[4] Tile_X0Y0_W2END[4] Tile_X0Y0_W6END[11] _3859_/X
+ _1127_/Q _1126_/Q VPWR VGND sg13cmos5l_mux4_1
X_1238_ _1238_/Q Tile_X0Y1_FrameData[3] VGND VPWR Tile_X0Y9_FrameStrobe[1] latch
XFILLER_512_84 VPWR VGND sg13cmos5l_decap_8
XFILLER_231_63 VPWR VGND sg13cmos5l_decap_8
X_1169_ _1169_/Q Tile_X0Y0_FrameData[26] VGND VPWR Tile_X0Y9_FrameStrobe[7] latch
XFILLER_64_192 VPWR VGND sg13cmos5l_decap_8
XFILLER_588_77 VPWR VGND sg13cmos5l_decap_8
XFILLER_547_228 VPWR VGND sg13cmos5l_fill_1
XANTENNA__3549__X Tile_X0Y9_E6BEG[7] VPWR VGND sg13cmos5l_antennanp
XFILLER_212_168 VPWR VGND sg13cmos5l_decap_8
X_4928_ _4928_/X Tile_X0Y9_N1END[0] Tile_X0Y9_N4END[0] _4896_/X _0083_/X _0703_/Q
+ _0702_/Q VPWR VGND sg13cmos5l_mux4_1
XFILLER_100_56 VPWR VGND sg13cmos5l_decap_8
X_4859_ _4859_/X Tile_X0Y9_W2END[4] AXI_M_SOC_RDATA4 _4907_/X _4906_/X _0825_/Q _0824_/Q
+ VPWR VGND sg13cmos5l_mux4_1
XFILLER_220_190 VPWR VGND sg13cmos5l_fill_2
XFILLER_60_49 VPWR VGND sg13cmos5l_decap_8
XFILLER_121_7 VPWR VGND sg13cmos5l_decap_8
XFILLER_176_49 VPWR VGND sg13cmos5l_decap_8
XFILLER_219_7 VPWR VGND sg13cmos5l_decap_8
XFILLER_537_70 VPWR VGND sg13cmos5l_decap_8
XFILLER_109_21 VPWR VGND sg13cmos5l_decap_8
XFILLER_314_209 VPWR VGND sg13cmos5l_decap_8
XFILLER_473_14 VPWR VGND sg13cmos5l_decap_8
XANTENNA__3284__X Tile_X0Y0_E6BEG[4] VPWR VGND sg13cmos5l_antennanp
XFILLER_530_117 VPWR VGND sg13cmos5l_decap_8
XFILLER_69_14 VPWR VGND sg13cmos5l_decap_8
XFILLER_669_173 VPWR VGND sg13cmos5l_decap_8
XFILLER_490_7 VPWR VGND sg13cmos5l_decap_8
XFILLER_623_28 VPWR VGND sg13cmos5l_decap_8
XFILLER_406_63 VPWR VGND sg13cmos5l_decap_8
XFILLER_279_168 VPWR VGND sg13cmos5l_decap_8
XFILLER_684_154 VPWR VGND sg13cmos5l_decap_8
XFILLER_588_7 VPWR VGND sg13cmos5l_decap_8
XFILLER_294_105 VPWR VGND sg13cmos5l_decap_8
XFILLER_279_179 VPWR VGND sg13cmos5l_fill_1
XFILLER_553_91 VPWR VGND sg13cmos5l_decap_8
XFILLER_294_116 VPWR VGND sg13cmos5l_fill_1
XFILLER_125_42 VPWR VGND sg13cmos5l_decap_8
XFILLER_272_70 VPWR VGND sg13cmos5l_decap_8
XFILLER_287_190 VPWR VGND sg13cmos5l_decap_4
XFILLER_85_35 VPWR VGND sg13cmos5l_decap_8
XFILLER_47_115 VPWR VGND sg13cmos5l_decap_8
XFILLER_436_187 VPWR VGND sg13cmos5l_decap_4
XFILLER_422_84 VPWR VGND sg13cmos5l_decap_8
XFILLER_141_63 VPWR VGND sg13cmos5l_decap_8
XFILLER_55_181 VPWR VGND sg13cmos5l_decap_8
XFILLER_70_140 VPWR VGND sg13cmos5l_decap_8
XFILLER_498_77 VPWR VGND sg13cmos5l_decap_8
XFILLER_648_14 VPWR VGND sg13cmos5l_decap_8
XFILLER_538_217 VPWR VGND sg13cmos5l_decap_8
XFILLER_538_228 VPWR VGND sg13cmos5l_fill_1
XFILLER_245_0 VPWR VGND sg13cmos5l_decap_8
XANTENNA__3459__X Tile_X0Y1_FrameData_O[17] VPWR VGND sg13cmos5l_antennanp
XFILLER_34_50 VPWR VGND sg13cmos5l_decap_8
XFILLER_34_94 VPWR VGND sg13cmos5l_fill_1
XFILLER_357_161 VPWR VGND sg13cmos5l_decap_8
XFILLER_412_0 VPWR VGND sg13cmos5l_decap_8
XFILLER_506_147 VPWR VGND sg13cmos5l_decap_8
XFILLER_664_35 VPWR VGND sg13cmos5l_decap_8
XFILLER_447_70 VPWR VGND sg13cmos5l_decap_8
XFILLER_50_71 VPWR VGND sg13cmos5l_decap_8
XFILLER_372_164 VPWR VGND sg13cmos5l_decap_4
XFILLER_383_14 VPWR VGND sg13cmos5l_decap_8
XANTENNA__3194__X Tile_X0Y0_N2BEGb[2] VPWR VGND sg13cmos5l_antennanp
XFILLER_313_220 VPWR VGND sg13cmos5l_fill_2
X_0540_ _0540_/Q Tile_X0Y8_FrameData[3] VGND VPWR Tile_X0Y9_FrameStrobe[3] latch
XFILLER_124_164 VPWR VGND sg13cmos5l_fill_1
XFILLER_680_34 VPWR VGND sg13cmos5l_decap_8
XFILLER_533_28 VPWR VGND sg13cmos5l_decap_8
XFILLER_316_63 VPWR VGND sg13cmos5l_decap_8
X_0471_ _0471_/Q Tile_X0Y8_FrameData[8] VGND VPWR Tile_X0Y9_FrameStrobe[1] latch
XFILLER_285_105 VPWR VGND sg13cmos5l_decap_8
XFILLER_316_85 VPWR VGND sg13cmos5l_fill_2
X_2210_ _2210_/Q Tile_X0Y5_FrameData[3] VGND VPWR Tile_X0Y9_FrameStrobe[0] latch
XFILLER_474_227 VPWR VGND sg13cmos5l_fill_2
X_3190_ Tile_X0Y0_N4BEG[14] _3190_/A VPWR VGND sg13cmos5l_buf_1
XFILLER_182_70 VPWR VGND sg13cmos5l_fill_2
XFILLER_38_104 VPWR VGND sg13cmos5l_fill_2
X_2141_ _2141_/Q Tile_X0Y4_FrameData[8] VGND VPWR Tile_X0Y9_FrameStrobe[6] latch
XFILLER_427_154 VPWR VGND sg13cmos5l_decap_8
XFILLER_93_221 VPWR VGND sg13cmos5l_fill_1
XFILLER_689_32 VPWR VGND sg13cmos5l_decap_8
X_2072_ _2072_/Q Tile_X0Y4_FrameData[13] VGND VPWR Tile_X0Y9_FrameStrobe[4] latch
X_1023_ _1023_/Q Tile_X0Y0_FrameData[12] VGND VPWR Tile_X0Y9_FrameStrobe[2] latch
XFILLER_558_14 VPWR VGND sg13cmos5l_decap_8
XANTENNA__3369__X Tile_X0Y2_EE4BEG[8] VPWR VGND sg13cmos5l_antennanp
XFILLER_201_77 VPWR VGND sg13cmos5l_decap_8
X_2974_ Tile_X0Y8_FrameData_O[14] Tile_X0Y8_FrameData[14] VPWR VGND sg13cmos5l_buf_1
XFILLER_61_195 VPWR VGND sg13cmos5l_decap_8
X_1925_ _1925_/Q Tile_X0Y3_FrameData[4] VGND VPWR Tile_X0Y9_FrameStrobe[7] latch
X_4713_ _4713_/X Tile_X0Y9_W2MID[1] Tile_X0Y9_W2END[1] Tile_X0Y9_W6END[1] _4902_/X
+ _0907_/Q _0906_/Q VPWR VGND sg13cmos5l_mux4_1
XFILLER_348_161 VPWR VGND sg13cmos5l_decap_4
XFILLER_147_201 VPWR VGND sg13cmos5l_fill_1
XFILLER_708_28 VPWR VGND sg13cmos5l_decap_8
XFILLER_638_91 VPWR VGND sg13cmos5l_decap_8
XFILLER_348_194 VPWR VGND sg13cmos5l_decap_4
X_4644_ _4644_/X Tile_X0Y9_N4END[8] _0056_/X _4695_/X _4699_/X _0271_/Q _0270_/Q VPWR
+ VGND sg13cmos5l_mux4_1
X_1856_ _1856_/Q Tile_X0Y3_FrameData[9] VGND VPWR Tile_X0Y9_FrameStrobe[5] latch
XFILLER_574_35 VPWR VGND sg13cmos5l_decap_8
XFILLER_357_70 VPWR VGND sg13cmos5l_decap_8
XFILLER_162_215 VPWR VGND sg13cmos5l_fill_1
X_0807_ _0807_/Q Tile_X0Y9_FrameData[24] VGND VPWR Tile_X0Y9_FrameStrobe[4] latch
XFILLER_293_14 VPWR VGND sg13cmos5l_decap_8
X_4575_ _4575_/X _4551_/X Tile_X0Y9_N4END[15] _4550_/X _0150_/X _2481_/Q _2480_/Q
+ VPWR VGND sg13cmos5l_mux4_1
X_1787_ _1787_/Q Tile_X0Y3_FrameData[14] VGND VPWR Tile_X0Y9_FrameStrobe[3] latch
X_3526_ Tile_X0Y9_E2BEG[0] _4848_/X VPWR VGND sg13cmos5l_buf_1
X_0738_ _0738_/Q Tile_X0Y9_FrameData[29] VGND VPWR Tile_X0Y9_FrameStrobe[2] latch
XFILLER_507_84 VPWR VGND sg13cmos5l_decap_8
XFILLER_115_164 VPWR VGND sg13cmos5l_decap_8
XFILLER_443_28 VPWR VGND sg13cmos5l_decap_8
X_3457_ Tile_X0Y1_FrameData_O[15] Tile_X0Y1_FrameData[15] VPWR VGND sg13cmos5l_buf_1
XFILLER_226_63 VPWR VGND sg13cmos5l_decap_8
XFILLER_130_112 VPWR VGND sg13cmos5l_decap_8
X_0669_ _0669_/Q Tile_X0Y8_FrameData[2] VGND VPWR Tile_X0Y9_FrameStrobe[7] latch
XFILLER_276_105 VPWR VGND sg13cmos5l_decap_8
XFILLER_590_56 VPWR VGND sg13cmos5l_decap_8
XFILLER_373_91 VPWR VGND sg13cmos5l_decap_8
X_2408_ _2408_/Q Tile_X0Y5_FrameData[29] VGND VPWR Tile_X0Y9_FrameStrobe[7] latch
X_3388_ Tile_X0Y2_E6BEG[11] _4083_/X VPWR VGND sg13cmos5l_buf_1
XFILLER_418_110 VPWR VGND sg13cmos5l_decap_4
XFILLER_130_189 VPWR VGND sg13cmos5l_fill_2
X_2339_ _2339_/Q Tile_X0Y5_FrameData[2] VGND VPWR Tile_X0Y9_FrameStrobe[4] latch
XFILLER_291_119 VPWR VGND sg13cmos5l_decap_8
XFILLER_599_21 VPWR VGND sg13cmos5l_decap_8
XFILLER_284_182 VPWR VGND sg13cmos5l_decap_8
XFILLER_55_49 VPWR VGND sg13cmos5l_decap_8
X_4009_ _4009_/X _3983_/X _0096_/X _3982_/X Tile_X0Y0_S4END[5] _1231_/Q _1230_/Q VPWR
+ VGND sg13cmos5l_mux4_1
XFILLER_599_98 VPWR VGND sg13cmos5l_decap_8
XFILLER_169_7 VPWR VGND sg13cmos5l_decap_8
XFILLER_594_109 VPWR VGND sg13cmos5l_fill_1
XFILLER_468_14 VPWR VGND sg13cmos5l_decap_8
XANTENNA__3279__X Tile_X0Y0_EE4BEG[15] VPWR VGND sg13cmos5l_antennanp
XFILLER_111_77 VPWR VGND sg13cmos5l_fill_2
XFILLER_336_7 VPWR VGND sg13cmos5l_decap_8
XFILLER_200_105 VPWR VGND sg13cmos5l_decap_8
XFILLER_618_28 VPWR VGND sg13cmos5l_decap_8
XFILLER_339_183 VPWR VGND sg13cmos5l_decap_8
XFILLER_548_91 VPWR VGND sg13cmos5l_decap_4
XANTENNA__2911__X Tile_X0Y6_UserCLKo VPWR VGND sg13cmos5l_antennanp
XFILLER_689_202 VPWR VGND sg13cmos5l_decap_4
XFILLER_543_220 VPWR VGND sg13cmos5l_decap_8
XFILLER_503_7 VPWR VGND sg13cmos5l_decap_8
XFILLER_267_70 VPWR VGND sg13cmos5l_decap_8
XFILLER_354_175 VPWR VGND sg13cmos5l_decap_8
XFILLER_484_68 VPWR VGND sg13cmos5l_decap_8
XFILLER_634_49 VPWR VGND sg13cmos5l_decap_8
XFILLER_20_63 VPWR VGND sg13cmos5l_decap_8
XFILLER_417_84 VPWR VGND sg13cmos5l_decap_8
XFILLER_657_132 VPWR VGND sg13cmos5l_decap_4
XFILLER_353_28 VPWR VGND sg13cmos5l_decap_8
XFILLER_136_63 VPWR VGND sg13cmos5l_decap_8
XFILLER_267_105 VPWR VGND sg13cmos5l_fill_2
XFILLER_121_123 VPWR VGND sg13cmos5l_decap_8
XANTENNA__3742__X AXI_M_SOC_ARADDR14 VPWR VGND sg13cmos5l_antennanp
XFILLER_714_71 VPWR VGND sg13cmos5l_decap_8
XFILLER_511_183 VPWR VGND sg13cmos5l_decap_8
XFILLER_283_91 VPWR VGND sg13cmos5l_decap_8
XFILLER_657_176 VPWR VGND sg13cmos5l_decap_4
XFILLER_96_56 VPWR VGND sg13cmos5l_decap_4
XFILLER_96_89 VPWR VGND sg13cmos5l_decap_8
XFILLER_195_0 VPWR VGND sg13cmos5l_decap_8
XFILLER_409_143 VPWR VGND sg13cmos5l_fill_1
XFILLER_282_119 VPWR VGND sg13cmos5l_decap_8
XFILLER_471_219 VPWR VGND sg13cmos5l_decap_8
XFILLER_275_171 VPWR VGND sg13cmos5l_decap_8
XFILLER_362_0 VPWR VGND sg13cmos5l_decap_8
XFILLER_302_21 VPWR VGND sg13cmos5l_decap_8
XFILLER_223_208 VPWR VGND sg13cmos5l_decap_4
XFILLER_424_168 VPWR VGND sg13cmos5l_decap_4
XFILLER_290_163 VPWR VGND sg13cmos5l_fill_1
XFILLER_659_35 VPWR VGND sg13cmos5l_decap_8
XFILLER_43_140 VPWR VGND sg13cmos5l_decap_8
XFILLER_578_161 VPWR VGND sg13cmos5l_decap_8
XFILLER_378_14 VPWR VGND sg13cmos5l_decap_8
XFILLER_43_151 VPWR VGND sg13cmos5l_fill_2
XANTENNA__3189__X Tile_X0Y0_N4BEG[13] VPWR VGND sg13cmos5l_antennanp
XFILLER_627_0 VPWR VGND sg13cmos5l_decap_8
XFILLER_188_167 VPWR VGND sg13cmos5l_decap_4
XFILLER_337_109 VPWR VGND sg13cmos5l_decap_8
XFILLER_84_7 VPWR VGND sg13cmos5l_decap_8
XFILLER_528_28 VPWR VGND sg13cmos5l_decap_8
XFILLER_675_56 VPWR VGND sg13cmos5l_decap_8
XANTENNA__2821__X Tile_X0Y3_E1BEG[3] VPWR VGND sg13cmos5l_antennanp
X_1710_ _1710_/Q Tile_X0Y3_FrameData[27] VGND VPWR Tile_X0Y9_FrameStrobe[1] latch
X_2690_ _2690_/Q Tile_X0Y6_FrameData[5] VGND VPWR Tile_X0Y9_FrameStrobe[7] latch
XFILLER_394_35 VPWR VGND sg13cmos5l_decap_8
XFILLER_177_70 VPWR VGND sg13cmos5l_decap_8
XFILLER_6_21 VPWR VGND sg13cmos5l_decap_8
XFILLER_177_92 VPWR VGND sg13cmos5l_decap_8
X_1641_ _1641_/Q Tile_X0Y2_FrameData[8] VGND VPWR Tile_X0Y9_FrameStrobe[6] latch
XANTENNA_3 AXI_M_SOC_RDATA13 VPWR VGND sg13cmos5l_antennanp
X_4360_ _4360_/X Tile_X0Y3_W1END[0] Tile_X0Y3_W2MID[3] Tile_X0Y3_W2END[3] _4210_/X
+ _1873_/Q _1872_/Q VPWR VGND sg13cmos5l_mux4_1
XFILLER_695_227 VPWR VGND sg13cmos5l_fill_2
X_1572_ _1572_/Q Tile_X0Y2_FrameData[13] VGND VPWR Tile_X0Y9_FrameStrobe[4] latch
XFILLER_544_49 VPWR VGND sg13cmos5l_decap_8
XFILLER_6_98 VPWR VGND sg13cmos5l_decap_8
XFILLER_360_167 VPWR VGND sg13cmos5l_decap_4
XFILLER_360_178 VPWR VGND sg13cmos5l_decap_8
XFILLER_327_95 VPWR VGND sg13cmos5l_decap_8
X_3311_ Tile_X0Y0_E1BEG[3] _3803_/X VPWR VGND sg13cmos5l_buf_1
XFILLER_691_77 VPWR VGND sg13cmos5l_decap_8
X_0523_ _0523_/Q Tile_X0Y8_FrameData[20] VGND VPWR Tile_X0Y9_FrameStrobe[3] latch
XFILLER_263_28 VPWR VGND sg13cmos5l_decap_8
X_4291_ _4291_/X _0040_/X _0109_/X _4344_/X _4348_/X _2031_/Q _2030_/Q VPWR VGND sg13cmos5l_mux4_1
XFILLER_502_161 VPWR VGND sg13cmos5l_decap_8
XANTENNA__3652__X AXI_M_SOC_AWADDR13 VPWR VGND sg13cmos5l_antennanp
XFILLER_447_216 VPWR VGND sg13cmos5l_fill_2
XFILLER_193_91 VPWR VGND sg13cmos5l_decap_8
X_3242_ Tile_X0Y0_FrameData_O[10] Tile_X0Y0_FrameData[10] VPWR VGND sg13cmos5l_buf_1
X_0454_ _0454_/Q Tile_X0Y8_FrameData[25] VGND VPWR Tile_X0Y9_FrameStrobe[1] latch
X_3173_ Tile_X0Y4_E6BEG[10] _4298_/X VPWR VGND sg13cmos5l_buf_1
X_0385_ _0385_/Q Tile_X0Y7_FrameData[30] VGND VPWR Tile_X0Y9_FrameStrobe[7] latch
X_2124_ _2124_/Q Tile_X0Y4_FrameData[25] VGND VPWR Tile_X0Y9_FrameStrobe[6] latch
XFILLER_640_70 VPWR VGND sg13cmos5l_decap_8
XFILLER_212_21 VPWR VGND sg13cmos5l_decap_8
XFILLER_415_146 VPWR VGND sg13cmos5l_fill_2
X_2055_ _2055_/Q Tile_X0Y4_FrameData[30] VGND VPWR Tile_X0Y9_FrameStrobe[4] latch
XFILLER_569_35 VPWR VGND sg13cmos5l_decap_8
XFILLER_430_105 VPWR VGND sg13cmos5l_decap_8
X_1006_ _1006_/Q Tile_X0Y0_FrameData[29] VGND VPWR Tile_X0Y9_FrameStrobe[2] latch
XFILLER_281_196 VPWR VGND sg13cmos5l_fill_2
XFILLER_212_98 VPWR VGND sg13cmos5l_decap_8
XFILLER_569_161 VPWR VGND sg13cmos5l_decap_8
XFILLER_288_14 VPWR VGND sg13cmos5l_decap_8
XANTENNA__3099__X Tile_X0Y7_E2BEGb[5] VPWR VGND sg13cmos5l_antennanp
XFILLER_383_215 VPWR VGND sg13cmos5l_decap_4
X_2957_ Tile_X0Y8_EE4BEG[13] _4757_/X VPWR VGND sg13cmos5l_buf_1
XFILLER_438_28 VPWR VGND sg13cmos5l_decap_8
XFILLER_585_56 VPWR VGND sg13cmos5l_decap_8
XFILLER_194_148 VPWR VGND sg13cmos5l_fill_2
XFILLER_368_91 VPWR VGND sg13cmos5l_decap_8
X_1908_ _1908_/Q Tile_X0Y3_FrameData[21] VGND VPWR Tile_X0Y9_FrameStrobe[7] latch
XFILLER_336_131 VPWR VGND sg13cmos5l_fill_2
X_2888_ Tile_X0Y6_FrameData_O[9] Tile_X0Y6_FrameData[9] VPWR VGND sg13cmos5l_buf_1
XFILLER_135_204 VPWR VGND sg13cmos5l_fill_1
X_1839_ _1839_/Q Tile_X0Y3_FrameData[26] VGND VPWR Tile_X0Y9_FrameStrobe[5] latch
X_4627_ _4627_/X Tile_X0Y7_W2END[0] AXI_M_SOC_RDATA16 _4669_/X _4668_/X _0305_/Q _0304_/Q
+ VPWR VGND sg13cmos5l_mux4_1
XFILLER_497_105 VPWR VGND sg13cmos5l_decap_8
XFILLER_351_112 VPWR VGND sg13cmos5l_decap_8
X_4558_ _4558_/X _4477_/X _4593_/X _4592_/X _4476_/X _2455_/Q _2454_/Q VPWR VGND sg13cmos5l_mux4_1
XFILLER_454_49 VPWR VGND sg13cmos5l_decap_8
XFILLER_351_189 VPWR VGND sg13cmos5l_decap_8
XFILLER_173_28 VPWR VGND sg13cmos5l_decap_8
X_3509_ Tile_X0Y1_E2BEGb[7] _3947_/X VPWR VGND sg13cmos5l_buf_1
XFILLER_1_228 VPWR VGND sg13cmos5l_fill_1
X_4489_ _4489_/X _4574_/X _4578_/X _4582_/X _4554_/X _2629_/Q _2628_/Q VPWR VGND sg13cmos5l_mux4_1
XFILLER_639_154 VPWR VGND sg13cmos5l_decap_8
XFILLER_249_105 VPWR VGND sg13cmos5l_decap_8
XANTENNA__3562__X Tile_X0Y9_EE4BEG[8] VPWR VGND sg13cmos5l_antennanp
XFILLER_103_189 VPWR VGND sg13cmos5l_decap_8
XFILLER_264_108 VPWR VGND sg13cmos5l_fill_1
XFILLER_654_168 VPWR VGND sg13cmos5l_decap_8
XFILLER_57_221 VPWR VGND sg13cmos5l_fill_1
XFILLER_286_7 VPWR VGND sg13cmos5l_decap_8
XFILLER_253_94 VPWR VGND sg13cmos5l_decap_8
XFILLER_66_48 VPWR VGND sg13cmos5l_decap_8
XFILLER_403_42 VPWR VGND sg13cmos5l_decap_8
XFILLER_257_182 VPWR VGND sg13cmos5l_decap_8
XFILLER_550_70 VPWR VGND sg13cmos5l_decap_8
XFILLER_122_21 VPWR VGND sg13cmos5l_decap_8
XANTENNA__2906__X Tile_X0Y6_FrameData_O[27] VPWR VGND sg13cmos5l_antennanp
XFILLER_453_7 VPWR VGND sg13cmos5l_decap_8
XFILLER_272_163 VPWR VGND sg13cmos5l_fill_2
XFILLER_205_208 VPWR VGND sg13cmos5l_decap_4
XFILLER_82_14 VPWR VGND sg13cmos5l_decap_8
XFILLER_479_35 VPWR VGND sg13cmos5l_decap_8
XFILLER_421_105 VPWR VGND sg13cmos5l_decap_8
XFILLER_700_51 VPWR VGND sg13cmos5l_decap_8
XFILLER_359_201 VPWR VGND sg13cmos5l_decap_4
XFILLER_359_212 VPWR VGND sg13cmos5l_decap_8
XFILLER_198_14 VPWR VGND sg13cmos5l_decap_8
XFILLER_479_79 VPWR VGND sg13cmos5l_decap_8
XFILLER_421_149 VPWR VGND sg13cmos5l_fill_1
XFILLER_620_7 VPWR VGND sg13cmos5l_decap_8
XFILLER_709_147 VPWR VGND sg13cmos5l_decap_8
XFILLER_629_49 VPWR VGND sg13cmos5l_decap_8
XFILLER_15_63 VPWR VGND sg13cmos5l_decap_8
XFILLER_575_175 VPWR VGND sg13cmos5l_decap_8
XFILLER_348_28 VPWR VGND sg13cmos5l_decap_8
XANTENNA__3737__X AXI_M_SOC_ARADDR9 VPWR VGND sg13cmos5l_antennanp
XFILLER_495_56 VPWR VGND sg13cmos5l_decap_8
XFILLER_278_91 VPWR VGND sg13cmos5l_decap_8
XFILLER_327_153 VPWR VGND sg13cmos5l_fill_2
XFILLER_531_212 VPWR VGND sg13cmos5l_decap_8
XFILLER_342_112 VPWR VGND sg13cmos5l_decap_4
XFILLER_31_73 VPWR VGND sg13cmos5l_decap_8
XFILLER_110_0 VPWR VGND sg13cmos5l_decap_8
XFILLER_488_105 VPWR VGND sg13cmos5l_decap_8
XFILLER_208_0 VPWR VGND sg13cmos5l_decap_8
XFILLER_677_227 VPWR VGND sg13cmos5l_fill_2
XFILLER_364_49 VPWR VGND sg13cmos5l_decap_8
XFILLER_147_84 VPWR VGND sg13cmos5l_decap_8
XFILLER_661_14 VPWR VGND sg13cmos5l_decap_8
XANTENNA__3472__X Tile_X0Y1_FrameData_O[30] VPWR VGND sg13cmos5l_antennanp
XFILLER_496_182 VPWR VGND sg13cmos5l_decap_8
XFILLER_577_0 VPWR VGND sg13cmos5l_decap_8
XFILLER_255_108 VPWR VGND sg13cmos5l_decap_8
XFILLER_163_83 VPWR VGND sg13cmos5l_fill_1
XFILLER_645_168 VPWR VGND sg13cmos5l_decap_8
XFILLER_660_105 VPWR VGND sg13cmos5l_decap_8
XFILLER_313_42 VPWR VGND sg13cmos5l_decap_8
X_0170_ _0170_/Q Tile_X0Y7_FrameData[21] VGND VPWR Tile_X0Y9_FrameStrobe[0] latch
XFILLER_63_202 VPWR VGND sg13cmos5l_fill_1
XANTENNA__2816__X Tile_X0Y3_E2BEG[6] VPWR VGND sg13cmos5l_antennanp
XFILLER_389_35 VPWR VGND sg13cmos5l_decap_8
XFILLER_610_84 VPWR VGND sg13cmos5l_decap_8
X_3860_ _3860_/X _3849_/X Tile_X0Y0_W6END[1] Tile_X0Y0_S1END[1] _3860_/A3 _0945_/Q
+ _0944_/Q VPWR VGND sg13cmos5l_mux4_1
XFILLER_539_49 VPWR VGND sg13cmos5l_decap_8
X_2811_ Tile_X0Y3_E2BEG[1] _4149_/X VPWR VGND sg13cmos5l_buf_1
XFILLER_420_182 VPWR VGND sg13cmos5l_decap_4
XFILLER_72_91 VPWR VGND sg13cmos5l_decap_4
XFILLER_686_77 VPWR VGND sg13cmos5l_decap_8
XFILLER_258_28 VPWR VGND sg13cmos5l_decap_8
X_3791_ _3791_/X Tile_X0Y0_W2MID[0] Tile_X0Y0_W2END[0] Tile_X0Y0_W6END[0] _3852_/X
+ _1155_/Q _1154_/Q VPWR VGND sg13cmos5l_mux4_1
XFILLER_420_193 VPWR VGND sg13cmos5l_decap_4
XFILLER_581_112 VPWR VGND sg13cmos5l_decap_8
XFILLER_31_176 VPWR VGND sg13cmos5l_fill_1
XFILLER_31_187 VPWR VGND sg13cmos5l_decap_8
XFILLER_188_91 VPWR VGND sg13cmos5l_decap_8
XANTENNA__3647__X AXI_M_SOC_AWADDR8 VPWR VGND sg13cmos5l_antennanp
XFILLER_715_139 VPWR VGND sg13cmos5l_decap_8
XFILLER_176_159 VPWR VGND sg13cmos5l_fill_1
X_2742_ Tile_X0Y3_FrameData_O[0] Tile_X0Y3_FrameData[0] VPWR VGND sg13cmos5l_buf_1
XFILLER_581_189 VPWR VGND sg13cmos5l_fill_1
X_2673_ _2673_/Q Tile_X0Y6_FrameData[22] VGND VPWR Tile_X0Y9_FrameStrobe[7] latch
XFILLER_333_123 VPWR VGND sg13cmos5l_decap_4
XANTENNA__0071__X AXI_M_SOC_WSTRB0 VPWR VGND sg13cmos5l_antennanp
X_4412_ _4412_/X AXI_M_SOC_RVALID _4454_/X _4458_/X _4433_/X _2279_/Q _2278_/Q VPWR
+ VGND sg13cmos5l_mux4_1
XFILLER_333_134 VPWR VGND sg13cmos5l_decap_8
X_1624_ _1624_/Q Tile_X0Y2_FrameData[25] VGND VPWR Tile_X0Y9_FrameStrobe[6] latch
XFILLER_274_49 VPWR VGND sg13cmos5l_decap_8
XFILLER_132_207 VPWR VGND sg13cmos5l_decap_4
XFILLER_635_70 VPWR VGND sg13cmos5l_decap_8
XFILLER_207_21 VPWR VGND sg13cmos5l_decap_8
X_4343_ _4343_/X _4311_/X _0040_/X _4310_/X _0109_/X _1967_/Q _1966_/Q VPWR VGND sg13cmos5l_mux4_1
X_1555_ _1555_/Q Tile_X0Y2_FrameData[30] VGND VPWR Tile_X0Y9_FrameStrobe[4] latch
XFILLER_571_14 VPWR VGND sg13cmos5l_decap_8
XANTENNA__3382__X Tile_X0Y2_E6BEG[5] VPWR VGND sg13cmos5l_antennanp
XFILLER_494_119 VPWR VGND sg13cmos5l_decap_8
XFILLER_487_171 VPWR VGND sg13cmos5l_decap_8
X_0506_ _0506_/Q Tile_X0Y8_FrameData[5] VGND VPWR Tile_X0Y9_FrameStrobe[2] latch
X_4274_ _4274_/X Tile_X0Y4_WW4END[13] AXI_M_SOC_BRESP0 _4349_/X _4316_/X _2065_/Q
+ _2064_/Q VPWR VGND sg13cmos5l_mux4_1
XFILLER_487_193 VPWR VGND sg13cmos5l_decap_8
X_1486_ _1486_/Q Tile_X0Y2_FrameData[3] VGND VPWR Tile_X0Y9_FrameStrobe[1] latch
XFILLER_207_98 VPWR VGND sg13cmos5l_decap_8
XFILLER_100_115 VPWR VGND sg13cmos5l_fill_1
X_3225_ Tile_X0Y0_FrameStrobe_O[13] Tile_X0Y9_FrameStrobe[13] VPWR VGND sg13cmos5l_buf_1
X_0437_ _0437_/Q Tile_X0Y8_FrameData[10] VGND VPWR Tile_X0Y9_FrameStrobe[0] latch
XFILLER_504_63 VPWR VGND sg13cmos5l_decap_8
XFILLER_100_137 VPWR VGND sg13cmos5l_fill_2
XFILLER_651_105 VPWR VGND sg13cmos5l_decap_8
XFILLER_651_91 VPWR VGND sg13cmos5l_decap_8
XFILLER_223_42 VPWR VGND sg13cmos5l_decap_8
X_3156_ Tile_X0Y7_FrameData_O[26] Tile_X0Y7_FrameData[26] VPWR VGND sg13cmos5l_buf_1
X_0368_ _0368_/Q Tile_X0Y7_FrameData[15] VGND VPWR Tile_X0Y9_FrameStrobe[6] latch
XFILLER_370_70 VPWR VGND sg13cmos5l_decap_8
X_2107_ _2107_/Q Tile_X0Y4_FrameData[10] VGND VPWR Tile_X0Y9_FrameStrobe[5] latch
X_3087_ Tile_X0Y7_E2BEG[1] _4613_/X VPWR VGND sg13cmos5l_buf_1
XFILLER_403_105 VPWR VGND sg13cmos5l_decap_8
X_0299_ _0299_/Q Tile_X0Y7_FrameData[20] VGND VPWR Tile_X0Y9_FrameStrobe[4] latch
XFILLER_299_35 VPWR VGND sg13cmos5l_decap_8
XFILLER_254_185 VPWR VGND sg13cmos5l_decap_8
XFILLER_403_116 VPWR VGND sg13cmos5l_fill_1
X_2038_ _2038_/Q Tile_X0Y4_FrameData[15] VGND VPWR Tile_X0Y9_FrameStrobe[3] latch
XFILLER_403_138 VPWR VGND sg13cmos5l_decap_8
XFILLER_520_84 VPWR VGND sg13cmos5l_decap_4
XFILLER_52_17 VPWR VGND sg13cmos5l_decap_8
XFILLER_449_49 VPWR VGND sg13cmos5l_decap_8
XFILLER_22_132 VPWR VGND sg13cmos5l_fill_2
XFILLER_596_77 VPWR VGND sg13cmos5l_decap_8
XFILLER_168_28 VPWR VGND sg13cmos5l_decap_8
XFILLER_572_112 VPWR VGND sg13cmos5l_decap_8
XFILLER_557_186 VPWR VGND sg13cmos5l_decap_8
X_3989_ _3989_/X _3888_/X _4021_/X _4020_/X Tile_X0Y0_S2MID[0] _1201_/Q _1200_/Q VPWR
+ VGND sg13cmos5l_mux4_1
XFILLER_557_197 VPWR VGND sg13cmos5l_decap_8
XANTENNA__3557__X Tile_X0Y9_EE4BEG[3] VPWR VGND sg13cmos5l_antennanp
XFILLER_572_189 VPWR VGND sg13cmos5l_decap_8
XFILLER_248_72 VPWR VGND sg13cmos5l_fill_1
XFILLER_309_197 VPWR VGND sg13cmos5l_decap_4
XFILLER_175_192 VPWR VGND sg13cmos5l_decap_8
XFILLER_714_183 VPWR VGND sg13cmos5l_decap_8
XFILLER_659_227 VPWR VGND sg13cmos5l_fill_2
XFILLER_201_7 VPWR VGND sg13cmos5l_decap_8
XFILLER_190_162 VPWR VGND sg13cmos5l_decap_8
XFILLER_184_49 VPWR VGND sg13cmos5l_decap_8
XFILLER_545_70 VPWR VGND sg13cmos5l_decap_8
XFILLER_117_21 VPWR VGND sg13cmos5l_decap_8
XFILLER_89_110 VPWR VGND sg13cmos5l_decap_8
XFILLER_324_189 VPWR VGND sg13cmos5l_decap_8
XFILLER_481_14 VPWR VGND sg13cmos5l_decap_8
XFILLER_485_119 VPWR VGND sg13cmos5l_fill_1
XANTENNA__3292__X Tile_X0Y0_E2BEGb[0] VPWR VGND sg13cmos5l_antennanp
XFILLER_77_14 VPWR VGND sg13cmos5l_decap_8
XFILLER_478_193 VPWR VGND sg13cmos5l_fill_1
XFILLER_631_28 VPWR VGND sg13cmos5l_decap_8
XFILLER_570_7 VPWR VGND sg13cmos5l_decap_8
XFILLER_414_63 VPWR VGND sg13cmos5l_decap_8
XFILLER_237_108 VPWR VGND sg13cmos5l_fill_1
XFILLER_292_214 VPWR VGND sg13cmos5l_fill_2
XFILLER_668_7 VPWR VGND sg13cmos5l_decap_8
XFILLER_642_105 VPWR VGND sg13cmos5l_decap_8
XFILLER_561_91 VPWR VGND sg13cmos5l_decap_8
XFILLER_493_196 VPWR VGND sg13cmos5l_decap_8
XFILLER_133_42 VPWR VGND sg13cmos5l_decap_8
XFILLER_280_70 VPWR VGND sg13cmos5l_decap_8
XFILLER_93_35 VPWR VGND sg13cmos5l_decap_8
XFILLER_650_182 VPWR VGND sg13cmos5l_decap_8
XFILLER_430_84 VPWR VGND sg13cmos5l_decap_8
XFILLER_26_84 VPWR VGND sg13cmos5l_decap_8
XFILLER_158_0 VPWR VGND sg13cmos5l_decap_8
XFILLER_359_49 VPWR VGND sg13cmos5l_decap_8
XFILLER_13_132 VPWR VGND sg13cmos5l_fill_1
XFILLER_656_14 VPWR VGND sg13cmos5l_decap_8
XFILLER_563_112 VPWR VGND sg13cmos5l_decap_8
XFILLER_13_176 VPWR VGND sg13cmos5l_fill_1
XANTENNA__3467__X Tile_X0Y1_FrameData_O[25] VPWR VGND sg13cmos5l_antennanp
XFILLER_325_0 VPWR VGND sg13cmos5l_decap_8
XFILLER_504_201 VPWR VGND sg13cmos5l_decap_8
XFILLER_158_83 VPWR VGND sg13cmos5l_fill_1
XFILLER_315_145 VPWR VGND sg13cmos5l_decap_8
XFILLER_308_42 VPWR VGND sg13cmos5l_decap_8
XFILLER_672_35 VPWR VGND sg13cmos5l_decap_8
XFILLER_694_0 VPWR VGND sg13cmos5l_decap_8
XFILLER_181_184 VPWR VGND sg13cmos5l_decap_8
XFILLER_391_14 VPWR VGND sg13cmos5l_decap_8
X_1340_ _1340_/Q Tile_X0Y1_FrameData[29] VGND VPWR Tile_X0Y9_FrameStrobe[5] latch
XFILLER_391_69 VPWR VGND sg13cmos5l_fill_2
XFILLER_605_84 VPWR VGND sg13cmos5l_decap_8
XFILLER_605_95 VPWR VGND sg13cmos5l_fill_2
XFILLER_541_28 VPWR VGND sg13cmos5l_decap_8
XFILLER_283_203 VPWR VGND sg13cmos5l_decap_8
XFILLER_95_135 VPWR VGND sg13cmos5l_decap_8
X_1271_ _1271_/Q Tile_X0Y1_FrameData[2] VGND VPWR Tile_X0Y9_FrameStrobe[2] latch
XFILLER_3_77 VPWR VGND sg13cmos5l_decap_8
XFILLER_633_105 VPWR VGND sg13cmos5l_decap_8
XFILLER_484_185 VPWR VGND sg13cmos5l_decap_8
XFILLER_471_91 VPWR VGND sg13cmos5l_decap_8
XFILLER_95_168 VPWR VGND sg13cmos5l_decap_8
X_3010_ Tile_X0Y5_E2BEGb[5] _4385_/X VPWR VGND sg13cmos5l_buf_1
X_0222_ _0222_/Q Tile_X0Y7_FrameData[1] VGND VPWR Tile_X0Y9_FrameStrobe[1] latch
X_0153_ _0153_/X _4562_/X _4563_/X _1608_/Q VPWR VGND sg13cmos5l_mux2_1
XFILLER_340_40 VPWR VGND sg13cmos5l_decap_8
XFILLER_697_21 VPWR VGND sg13cmos5l_decap_8
XFILLER_641_182 VPWR VGND sg13cmos5l_decap_8
XFILLER_251_133 VPWR VGND sg13cmos5l_decap_8
X_0084_ _0084_/X _4006_/X _4007_/X _2404_/Q VPWR VGND sg13cmos5l_mux2_1
X_3912_ _3912_/X Tile_X0Y2_W1END[3] Tile_X0Y2_WW4END[3] Tile_X0Y2_W6END[11] _4119_/X
+ _1640_/Q _1639_/Q VPWR VGND sg13cmos5l_mux4_1
XFILLER_539_131 VPWR VGND sg13cmos5l_decap_4
XFILLER_697_98 VPWR VGND sg13cmos5l_decap_8
X_4892_ _4892_/X Tile_X0Y9_N1END[0] Tile_X0Y9_W6END[0] _4896_/X _4892_/A3 _0679_/Q
+ _0678_/Q VPWR VGND sg13cmos5l_mux4_1
XFILLER_269_49 VPWR VGND sg13cmos5l_decap_8
X_3843_ _3843_/X _3885_/X _3876_/X _3859_/X _3880_/X _1019_/Q _1018_/Q VPWR VGND sg13cmos5l_mux4_1
XFILLER_566_14 VPWR VGND sg13cmos5l_decap_8
XFILLER_554_112 VPWR VGND sg13cmos5l_decap_8
XANTENNA__3377__X Tile_X0Y2_E6BEG[0] VPWR VGND sg13cmos5l_antennanp
X_3774_ _3774_/X Tile_X0Y0_WW4END[3] Tile_X0Y0_WW4END[11] Tile_X0Y0_W6END[3] _3884_/X
+ _1003_/Q _1002_/Q VPWR VGND sg13cmos5l_mux4_1
X_0986_ _0986_/Q Tile_X0Y0_FrameData[17] VGND VPWR Tile_X0Y9_FrameStrobe[1] latch
XFILLER_353_207 VPWR VGND sg13cmos5l_fill_2
XFILLER_73_0 VPWR VGND sg13cmos5l_decap_4
XFILLER_164_118 VPWR VGND sg13cmos5l_decap_4
X_2725_ _4772_/A3 VPWR VGND sg13cmos5l_tielo
XFILLER_306_123 VPWR VGND sg13cmos5l_decap_4
XFILLER_646_91 VPWR VGND sg13cmos5l_decap_8
XFILLER_218_42 VPWR VGND sg13cmos5l_decap_8
X_2656_ _2656_/Q Tile_X0Y6_FrameData[7] VGND VPWR Tile_X0Y9_FrameStrobe[6] latch
XFILLER_172_151 VPWR VGND sg13cmos5l_fill_1
XFILLER_105_207 VPWR VGND sg13cmos5l_fill_2
XFILLER_582_35 VPWR VGND sg13cmos5l_decap_8
XFILLER_365_70 VPWR VGND sg13cmos5l_decap_8
X_1607_ _1607_/Q Tile_X0Y2_FrameData[10] VGND VPWR Tile_X0Y9_FrameStrobe[5] latch
XFILLER_510_215 VPWR VGND sg13cmos5l_fill_2
XFILLER_321_115 VPWR VGND sg13cmos5l_decap_8
XFILLER_711_175 VPWR VGND sg13cmos5l_decap_8
X_2587_ _2587_/Q Tile_X0Y6_FrameData[12] VGND VPWR Tile_X0Y9_FrameStrobe[4] latch
XFILLER_609_102 VPWR VGND sg13cmos5l_fill_2
X_1538_ _1538_/Q Tile_X0Y2_FrameData[15] VGND VPWR Tile_X0Y9_FrameStrobe[3] latch
X_4326_ _4326_/X Tile_X0Y8_W1END[1] Tile_X0Y8_WW4END[1] Tile_X0Y8_W6END[9] _4801_/X
+ _0644_/Q _0643_/Q VPWR VGND sg13cmos5l_mux4_1
XFILLER_515_84 VPWR VGND sg13cmos5l_decap_8
XFILLER_609_135 VPWR VGND sg13cmos5l_decap_4
XFILLER_451_28 VPWR VGND sg13cmos5l_decap_8
X_4257_ _4257_/X Tile_X0Y4_W2MID[6] AXI_M_SOC_BRESP1 _4315_/X _4314_/X _2099_/Q _2098_/Q
+ VPWR VGND sg13cmos5l_mux4_1
XFILLER_234_63 VPWR VGND sg13cmos5l_decap_8
X_1469_ _1469_/Q Tile_X0Y2_FrameData[20] VGND VPWR Tile_X0Y9_FrameStrobe[1] latch
XFILLER_47_17 VPWR VGND sg13cmos5l_decap_8
XFILLER_624_105 VPWR VGND sg13cmos5l_decap_8
XFILLER_381_91 VPWR VGND sg13cmos5l_decap_4
XFILLER_86_168 VPWR VGND sg13cmos5l_decap_8
X_3208_ Tile_X0Y0_N1BEG[0] _3780_/X VPWR VGND sg13cmos5l_buf_1
XFILLER_490_133 VPWR VGND sg13cmos5l_decap_8
X_4188_ _4188_/X AXI_M_SOC_WREADY _4225_/X _4229_/X _4210_/X _1765_/Q _1764_/Q VPWR
+ VGND sg13cmos5l_mux4_1
XFILLER_617_190 VPWR VGND sg13cmos5l_decap_8
X_3139_ Tile_X0Y7_FrameData_O[9] Tile_X0Y7_FrameData[9] VPWR VGND sg13cmos5l_buf_1
XFILLER_242_111 VPWR VGND sg13cmos5l_fill_1
XFILLER_103_56 VPWR VGND sg13cmos5l_decap_8
XFILLER_242_133 VPWR VGND sg13cmos5l_decap_4
XFILLER_632_193 VPWR VGND sg13cmos5l_fill_1
XFILLER_400_21 VPWR VGND sg13cmos5l_decap_8
XFILLER_63_49 VPWR VGND sg13cmos5l_decap_8
XFILLER_42_227 VPWR VGND sg13cmos5l_fill_2
XFILLER_242_166 VPWR VGND sg13cmos5l_decap_8
XFILLER_151_7 VPWR VGND sg13cmos5l_decap_8
XFILLER_249_7 VPWR VGND sg13cmos5l_decap_8
XFILLER_179_49 VPWR VGND sg13cmos5l_decap_8
XFILLER_476_14 VPWR VGND sg13cmos5l_decap_8
XFILLER_396_181 VPWR VGND sg13cmos5l_decap_8
XANTENNA__3287__X Tile_X0Y0_E6BEG[7] VPWR VGND sg13cmos5l_antennanp
XFILLER_545_145 VPWR VGND sg13cmos5l_fill_1
XFILLER_416_7 VPWR VGND sg13cmos5l_decap_8
XFILLER_155_118 VPWR VGND sg13cmos5l_decap_4
XFILLER_626_28 VPWR VGND sg13cmos5l_decap_8
XFILLER_409_63 VPWR VGND sg13cmos5l_decap_8
XFILLER_12_42 VPWR VGND sg13cmos5l_decap_8
XFILLER_556_91 VPWR VGND sg13cmos5l_decap_8
XFILLER_163_140 VPWR VGND sg13cmos5l_decap_8
XFILLER_128_42 VPWR VGND sg13cmos5l_decap_8
XFILLER_492_35 VPWR VGND sg13cmos5l_decap_8
XFILLER_275_70 VPWR VGND sg13cmos5l_decap_8
XFILLER_88_35 VPWR VGND sg13cmos5l_decap_8
XFILLER_642_49 VPWR VGND sg13cmos5l_decap_8
XFILLER_425_84 VPWR VGND sg13cmos5l_decap_8
XFILLER_361_28 VPWR VGND sg13cmos5l_decap_8
XFILLER_144_63 VPWR VGND sg13cmos5l_decap_8
XFILLER_77_146 VPWR VGND sg13cmos5l_fill_2
XFILLER_615_105 VPWR VGND sg13cmos5l_decap_8
XFILLER_320_192 VPWR VGND sg13cmos5l_fill_1
XANTENNA__3750__X AXI_M_SOC_ARADDR22 VPWR VGND sg13cmos5l_antennanp
XFILLER_466_185 VPWR VGND sg13cmos5l_fill_1
XFILLER_291_91 VPWR VGND sg13cmos5l_decap_8
XFILLER_481_144 VPWR VGND sg13cmos5l_decap_8
XFILLER_275_0 VPWR VGND sg13cmos5l_decap_8
XFILLER_37_94 VPWR VGND sg13cmos5l_decap_8
XFILLER_623_193 VPWR VGND sg13cmos5l_fill_1
XFILLER_33_205 VPWR VGND sg13cmos5l_decap_8
XFILLER_442_0 VPWR VGND sg13cmos5l_decap_8
XFILLER_310_21 VPWR VGND sg13cmos5l_decap_8
XFILLER_667_35 VPWR VGND sg13cmos5l_decap_8
XFILLER_394_129 VPWR VGND sg13cmos5l_fill_1
XFILLER_536_112 VPWR VGND sg13cmos5l_decap_4
XFILLER_386_14 VPWR VGND sg13cmos5l_decap_8
XANTENNA__3197__X Tile_X0Y0_N2BEGb[5] VPWR VGND sg13cmos5l_antennanp
XFILLER_707_0 VPWR VGND sg13cmos5l_decap_8
X_0840_ _0840_/Q Tile_X0Y9_FrameData[23] VGND VPWR Tile_X0Y9_FrameStrobe[5] latch
XFILLER_536_145 VPWR VGND sg13cmos5l_fill_2
XFILLER_536_28 VPWR VGND sg13cmos5l_decap_8
X_0771_ _0771_/Q Tile_X0Y9_FrameData[28] VGND VPWR Tile_X0Y9_FrameStrobe[3] latch
XFILLER_551_126 VPWR VGND sg13cmos5l_decap_8
XFILLER_319_63 VPWR VGND sg13cmos5l_decap_8
XFILLER_489_200 VPWR VGND sg13cmos5l_fill_2
XFILLER_466_80 VPWR VGND sg13cmos5l_decap_8
XFILLER_683_56 VPWR VGND sg13cmos5l_decap_8
X_2510_ _2510_/Q Tile_X0Y6_FrameData[25] VGND VPWR Tile_X0Y9_FrameStrobe[2] latch
X_3490_ Tile_X0Y1_E6BEG[0] _3964_/X VPWR VGND sg13cmos5l_buf_1
X_2441_ _2441_/Q Tile_X0Y6_FrameData[30] VGND VPWR Tile_X0Y9_FrameStrobe[0] latch
X_2372_ _2372_/Q Tile_X0Y5_FrameData[1] VGND VPWR Tile_X0Y9_FrameStrobe[5] latch
XFILLER_552_49 VPWR VGND sg13cmos5l_decap_8
XFILLER_335_84 VPWR VGND sg13cmos5l_decap_8
X_4111_ _4111_/X Tile_X0Y6_W1END[2] Tile_X0Y6_WW4END[2] Tile_X0Y6_W6END[10] _4570_/X
+ _2665_/Q _2664_/Q VPWR VGND sg13cmos5l_mux4_1
X_1323_ _1323_/Q Tile_X0Y1_FrameData[14] VGND VPWR Tile_X0Y9_FrameStrobe[4] latch
XFILLER_271_28 VPWR VGND sg13cmos5l_decap_8
XFILLER_68_135 VPWR VGND sg13cmos5l_decap_8
XFILLER_606_105 VPWR VGND sg13cmos5l_decap_8
XFILLER_472_100 VPWR VGND sg13cmos5l_decap_8
XFILLER_311_192 VPWR VGND sg13cmos5l_fill_1
XANTENNA__3660__X AXI_M_SOC_AWADDR21 VPWR VGND sg13cmos5l_antennanp
X_4042_ _4042_/X Tile_X0Y2_W2MID[5] AXI_M_SOC_AWREADY _4101_/X _4100_/X _1589_/Q _1588_/Q
+ VPWR VGND sg13cmos5l_mux4_1
X_1254_ _1254_/Q Tile_X0Y1_FrameData[19] VGND VPWR Tile_X0Y9_FrameStrobe[2] latch
XFILLER_83_127 VPWR VGND sg13cmos5l_decap_4
X_0205_ _0205_/Q Tile_X0Y7_FrameData[18] VGND VPWR Tile_X0Y9_FrameStrobe[1] latch
XFILLER_204_77 VPWR VGND sg13cmos5l_decap_8
X_1185_ _1185_/Q Tile_X0Y1_FrameData[24] VGND VPWR Tile_X0Y9_FrameStrobe[0] latch
XFILLER_621_119 VPWR VGND sg13cmos5l_decap_8
XFILLER_472_188 VPWR VGND sg13cmos5l_decap_8
XFILLER_209_196 VPWR VGND sg13cmos5l_fill_2
XFILLER_501_42 VPWR VGND sg13cmos5l_decap_8
X_0136_ AXI_M_SOC_AWLEN3 _0940_/Q _3674_/X VPWR VGND sg13cmos5l_nor2b_1
XFILLER_91_160 VPWR VGND sg13cmos5l_decap_8
XFILLER_224_144 VPWR VGND sg13cmos5l_fill_2
XFILLER_220_21 VPWR VGND sg13cmos5l_decap_8
X_0067_ _0067_/X _3865_/X _3866_/X _2155_/Q VPWR VGND sg13cmos5l_mux2_1
XFILLER_577_35 VPWR VGND sg13cmos5l_decap_8
XFILLER_385_129 VPWR VGND sg13cmos5l_decap_8
XFILLER_527_112 VPWR VGND sg13cmos5l_fill_1
XFILLER_296_14 VPWR VGND sg13cmos5l_decap_8
XFILLER_220_98 VPWR VGND sg13cmos5l_decap_8
XFILLER_716_212 VPWR VGND sg13cmos5l_decap_8
X_4875_ _4875_/X Tile_X0Y9_WW4END[4] AXI_M_SOC_RDATA4 _4920_/X _4906_/X _0793_/Q _0792_/Q
+ VPWR VGND sg13cmos5l_mux4_1
XFILLER_527_134 VPWR VGND sg13cmos5l_fill_2
X_3826_ _3826_/X Tile_X0Y0_WW4END[9] _3872_/X _3855_/X _3862_/X _1053_/Q _1052_/Q
+ VPWR VGND sg13cmos5l_mux4_1
XFILLER_326_207 VPWR VGND sg13cmos5l_decap_8
XFILLER_446_28 VPWR VGND sg13cmos5l_decap_8
XFILLER_229_63 VPWR VGND sg13cmos5l_decap_8
X_0969_ _0969_/Q Tile_X0Y0_FrameData[2] VGND VPWR Tile_X0Y9_FrameStrobe[0] latch
X_3757_ AXI_M_SOC_ARADDR29 Tile_X0Y8_W1END[1] Tile_X0Y8_WW4END[5] Tile_X0Y8_WW4END[13]
+ _4813_/X _0477_/Q _0476_/Q VPWR VGND sg13cmos5l_mux4_1
XFILLER_593_56 VPWR VGND sg13cmos5l_decap_8
X_2708_ _4303_/A3 VPWR VGND sg13cmos5l_tielo
XFILLER_3_109 VPWR VGND sg13cmos5l_fill_2
X_3688_ _3688_/X Tile_X0Y3_WW4END[6] Tile_X0Y3_WW4END[14] Tile_X0Y3_W6END[6] _4228_/X
+ _1745_/Q _1744_/Q VPWR VGND sg13cmos5l_mux4_1
X_2639_ _2639_/Q Tile_X0Y6_FrameData[24] VGND VPWR Tile_X0Y9_FrameStrobe[6] latch
XFILLER_160_132 VPWR VGND sg13cmos5l_fill_2
XFILLER_462_49 VPWR VGND sg13cmos5l_decap_8
XFILLER_245_84 VPWR VGND sg13cmos5l_decap_8
XFILLER_58_38 VPWR VGND sg13cmos5l_decap_8
XFILLER_181_28 VPWR VGND sg13cmos5l_decap_8
X_4309_ _4309_/X _4311_/X Tile_X0Y4_W6END[3] _4310_/X _4309_/A3 _1927_/Q _2182_/Q
+ VPWR VGND sg13cmos5l_mux4_1
XFILLER_59_146 VPWR VGND sg13cmos5l_decap_8
XFILLER_247_225 VPWR VGND sg13cmos5l_decap_4
XFILLER_199_7 VPWR VGND sg13cmos5l_decap_8
XANTENNA__3570__X Tile_X0Y9_FrameData_O[0] VPWR VGND sg13cmos5l_antennanp
XFILLER_652_211 VPWR VGND sg13cmos5l_decap_8
XFILLER_74_105 VPWR VGND sg13cmos5l_decap_4
XFILLER_262_217 VPWR VGND sg13cmos5l_fill_2
XFILLER_114_77 VPWR VGND sg13cmos5l_decap_8
XFILLER_366_7 VPWR VGND sg13cmos5l_decap_8
XFILLER_404_200 VPWR VGND sg13cmos5l_decap_8
XFILLER_411_42 VPWR VGND sg13cmos5l_decap_8
XFILLER_605_182 VPWR VGND sg13cmos5l_fill_2
XFILLER_215_133 VPWR VGND sg13cmos5l_decap_8
XFILLER_130_21 VPWR VGND sg13cmos5l_decap_8
XANTENNA__2914__X Tile_X0Y8_E1BEG[2] VPWR VGND sg13cmos5l_antennanp
XFILLER_533_7 VPWR VGND sg13cmos5l_decap_8
XFILLER_215_188 VPWR VGND sg13cmos5l_fill_2
XFILLER_90_14 VPWR VGND sg13cmos5l_decap_8
XFILLER_620_174 VPWR VGND sg13cmos5l_fill_1
XFILLER_487_35 VPWR VGND sg13cmos5l_decap_8
XFILLER_230_136 VPWR VGND sg13cmos5l_decap_8
XFILLER_518_101 VPWR VGND sg13cmos5l_decap_8
XFILLER_130_98 VPWR VGND sg13cmos5l_decap_8
XFILLER_637_49 VPWR VGND sg13cmos5l_decap_8
XFILLER_23_63 VPWR VGND sg13cmos5l_decap_8
XFILLER_384_173 VPWR VGND sg13cmos5l_fill_1
XFILLER_356_28 VPWR VGND sg13cmos5l_decap_8
XFILLER_139_63 VPWR VGND sg13cmos5l_decap_8
XFILLER_286_91 VPWR VGND sg13cmos5l_decap_8
XANTENNA__3745__X AXI_M_SOC_ARADDR17 VPWR VGND sg13cmos5l_antennanp
XFILLER_136_140 VPWR VGND sg13cmos5l_decap_8
XFILLER_99_56 VPWR VGND sg13cmos5l_decap_8
XFILLER_297_125 VPWR VGND sg13cmos5l_decap_8
XFILLER_486_225 VPWR VGND sg13cmos5l_decap_4
XFILLER_3_0 VPWR VGND sg13cmos5l_decap_8
XFILLER_2_142 VPWR VGND sg13cmos5l_fill_1
XFILLER_372_49 VPWR VGND sg13cmos5l_decap_8
XFILLER_297_169 VPWR VGND sg13cmos5l_decap_8
XFILLER_392_0 VPWR VGND sg13cmos5l_decap_8
XFILLER_305_21 VPWR VGND sg13cmos5l_decap_8
XANTENNA__3480__X Tile_X0Y1_EE4BEG[6] VPWR VGND sg13cmos5l_antennanp
XFILLER_305_98 VPWR VGND sg13cmos5l_decap_4
XFILLER_65_127 VPWR VGND sg13cmos5l_decap_8
XFILLER_48_93 VPWR VGND sg13cmos5l_decap_8
XFILLER_657_0 VPWR VGND sg13cmos5l_decap_8
XFILLER_602_63 VPWR VGND sg13cmos5l_decap_8
XFILLER_321_42 VPWR VGND sg13cmos5l_decap_8
XFILLER_206_133 VPWR VGND sg13cmos5l_decap_8
XFILLER_0_56 VPWR VGND sg13cmos5l_decap_8
XFILLER_321_86 VPWR VGND sg13cmos5l_fill_1
XFILLER_678_56 VPWR VGND sg13cmos5l_decap_8
XFILLER_64_70 VPWR VGND sg13cmos5l_decap_4
XANTENNA__2824__X Tile_X0Y4_E2BEG[2] VPWR VGND sg13cmos5l_antennanp
XFILLER_64_92 VPWR VGND sg13cmos5l_decap_8
X_2990_ Tile_X0Y8_FrameData_O[30] Tile_X0Y8_FrameData[30] VPWR VGND sg13cmos5l_buf_1
XFILLER_397_35 VPWR VGND sg13cmos5l_decap_8
XFILLER_9_21 VPWR VGND sg13cmos5l_decap_8
XFILLER_611_196 VPWR VGND sg13cmos5l_fill_1
X_1941_ _1941_/Q Tile_X0Y4_FrameData[16] VGND VPWR Tile_X0Y9_FrameStrobe[0] latch
XFILLER_509_112 VPWR VGND sg13cmos5l_decap_8
X_1872_ _1872_/Q Tile_X0Y3_FrameData[25] VGND VPWR Tile_X0Y9_FrameStrobe[6] latch
X_4660_ _4660_/X Tile_X0Y6_W1END[0] Tile_X0Y6_W6END[8] _4580_/X _4540_/X _2659_/Q
+ _2658_/Q VPWR VGND sg13cmos5l_mux4_1
XFILLER_547_49 VPWR VGND sg13cmos5l_decap_8
XFILLER_9_98 VPWR VGND sg13cmos5l_decap_8
XFILLER_713_204 VPWR VGND sg13cmos5l_decap_8
XFILLER_713_215 VPWR VGND sg13cmos5l_fill_1
X_0823_ _0823_/Q Tile_X0Y9_FrameData[8] VGND VPWR Tile_X0Y9_FrameStrobe[4] latch
X_3611_ Tile_X0Y9_S2BEG[5] _4833_/X VPWR VGND sg13cmos5l_buf_1
XFILLER_694_77 VPWR VGND sg13cmos5l_decap_8
XFILLER_266_28 VPWR VGND sg13cmos5l_decap_8
XFILLER_390_121 VPWR VGND sg13cmos5l_decap_8
X_4591_ _4591_/X Tile_X0Y8_W2MID[4] Tile_X0Y8_W2END[4] Tile_X0Y8_W6END[4] _4791_/X
+ _0657_/Q _0656_/Q VPWR VGND sg13cmos5l_mux4_1
XANTENNA__3655__X AXI_M_SOC_AWADDR16 VPWR VGND sg13cmos5l_antennanp
X_0754_ _0754_/Q Tile_X0Y9_FrameData[13] VGND VPWR Tile_X0Y9_FrameStrobe[2] latch
X_3542_ Tile_X0Y9_E6BEG[0] _4880_/X VPWR VGND sg13cmos5l_buf_1
XFILLER_390_187 VPWR VGND sg13cmos5l_decap_8
X_3473_ Tile_X0Y1_FrameData_O[31] Tile_X0Y1_FrameData[31] VPWR VGND sg13cmos5l_buf_1
XFILLER_477_203 VPWR VGND sg13cmos5l_decap_8
X_0685_ _0685_/Q Tile_X0Y9_FrameData[18] VGND VPWR Tile_X0Y9_FrameStrobe[0] latch
XFILLER_142_154 VPWR VGND sg13cmos5l_decap_8
X_2424_ _2424_/Q Tile_X0Y5_FrameData[13] VGND VPWR Tile_X0Y9_FrameStrobe[7] latch
XFILLER_693_133 VPWR VGND sg13cmos5l_fill_2
XFILLER_282_49 VPWR VGND sg13cmos5l_decap_8
XFILLER_643_70 VPWR VGND sg13cmos5l_decap_8
XFILLER_215_21 VPWR VGND sg13cmos5l_decap_8
XFILLER_36_0 VPWR VGND sg13cmos5l_fill_1
X_2355_ _2355_/Q Tile_X0Y5_FrameData[18] VGND VPWR Tile_X0Y9_FrameStrobe[5] latch
XANTENNA__3390__X Tile_X0Y2_E2BEGb[1] VPWR VGND sg13cmos5l_antennanp
XFILLER_445_111 VPWR VGND sg13cmos5l_fill_2
XFILLER_229_225 VPWR VGND sg13cmos5l_decap_4
XFILLER_693_199 VPWR VGND sg13cmos5l_decap_4
X_1306_ _1306_/Q Tile_X0Y1_FrameData[31] VGND VPWR Tile_X0Y9_FrameStrobe[4] latch
X_2286_ _2286_/Q Tile_X0Y5_FrameData[23] VGND VPWR Tile_X0Y9_FrameStrobe[3] latch
XFILLER_215_98 VPWR VGND sg13cmos5l_decap_8
X_4025_ _4025_/X Tile_X0Y3_W2MID[5] Tile_X0Y3_W2END[5] Tile_X0Y3_W6END[5] _4209_/X
+ _1913_/Q _1912_/Q VPWR VGND sg13cmos5l_mux4_1
X_1237_ _1237_/Q Tile_X0Y1_FrameData[4] VGND VPWR Tile_X0Y9_FrameStrobe[1] latch
XFILLER_512_63 VPWR VGND sg13cmos5l_decap_8
XFILLER_244_228 VPWR VGND sg13cmos5l_fill_1
XFILLER_460_125 VPWR VGND sg13cmos5l_decap_8
XFILLER_460_136 VPWR VGND sg13cmos5l_fill_1
XFILLER_231_42 VPWR VGND sg13cmos5l_decap_8
X_1168_ _1168_/Q Tile_X0Y0_FrameData[27] VGND VPWR Tile_X0Y9_FrameStrobe[7] latch
XFILLER_64_171 VPWR VGND sg13cmos5l_decap_8
XFILLER_44_29 VPWR VGND sg13cmos5l_fill_1
XFILLER_588_56 VPWR VGND sg13cmos5l_decap_8
X_0119_ AXI_M_SOC_ARCACHE1 _0929_/Q _3775_/X VPWR VGND sg13cmos5l_or2_1
X_1099_ _1099_/Q Tile_X0Y0_FrameData[0] VGND VPWR Tile_X0Y9_FrameStrobe[4] latch
XFILLER_401_225 VPWR VGND sg13cmos5l_decap_4
XFILLER_212_147 VPWR VGND sg13cmos5l_decap_8
X_4927_ _4927_/X Tile_X0Y9_N1END[3] Tile_X0Y9_N4END[3] _4899_/X _0080_/X _0705_/Q
+ _0704_/Q VPWR VGND sg13cmos5l_mux4_1
XFILLER_100_35 VPWR VGND sg13cmos5l_decap_8
X_4858_ _4858_/X Tile_X0Y9_W2END[5] AXI_M_SOC_RDATA5 _4905_/X _4904_/X _0827_/Q _0826_/Q
+ VPWR VGND sg13cmos5l_mux4_1
XFILLER_60_28 VPWR VGND sg13cmos5l_decap_8
XFILLER_457_49 VPWR VGND sg13cmos5l_decap_8
XFILLER_165_202 VPWR VGND sg13cmos5l_decap_8
XFILLER_570_210 VPWR VGND sg13cmos5l_fill_1
X_3809_ _3809_/X Tile_X0Y0_W2MID[2] Tile_X0Y0_WW4END[15] _3857_/X _3856_/X _1087_/Q
+ _1086_/Q VPWR VGND sg13cmos5l_mux4_1
XFILLER_176_28 VPWR VGND sg13cmos5l_decap_8
XFILLER_515_137 VPWR VGND sg13cmos5l_decap_4
X_4789_ _4789_/X _4705_/X Tile_X0Y9_N2MID[2] _4818_/X _4704_/X _0435_/Q _0434_/Q VPWR
+ VGND sg13cmos5l_mux4_1
XANTENNA__3565__X Tile_X0Y9_EE4BEG[11] VPWR VGND sg13cmos5l_antennanp
XFILLER_180_216 VPWR VGND sg13cmos5l_decap_8
XFILLER_114_7 VPWR VGND sg13cmos5l_decap_8
XFILLER_180_227 VPWR VGND sg13cmos5l_fill_2
XFILLER_669_152 VPWR VGND sg13cmos5l_decap_8
XFILLER_118_195 VPWR VGND sg13cmos5l_decap_8
XFILLER_684_111 VPWR VGND sg13cmos5l_fill_1
XFILLER_133_154 VPWR VGND sg13cmos5l_decap_4
XFILLER_406_42 VPWR VGND sg13cmos5l_decap_8
XFILLER_279_147 VPWR VGND sg13cmos5l_decap_8
XFILLER_192_49 VPWR VGND sg13cmos5l_decap_8
XFILLER_553_70 VPWR VGND sg13cmos5l_decap_8
XFILLER_133_187 VPWR VGND sg13cmos5l_decap_8
XFILLER_125_21 VPWR VGND sg13cmos5l_decap_8
XANTENNA__2909__X Tile_X0Y6_FrameData_O[30] VPWR VGND sg13cmos5l_antennanp
XFILLER_483_7 VPWR VGND sg13cmos5l_decap_8
XFILLER_483_228 VPWR VGND sg13cmos5l_fill_1
XFILLER_625_200 VPWR VGND sg13cmos5l_fill_1
XFILLER_85_14 VPWR VGND sg13cmos5l_decap_8
XFILLER_703_84 VPWR VGND sg13cmos5l_decap_8
XFILLER_235_217 VPWR VGND sg13cmos5l_fill_2
XFILLER_650_7 VPWR VGND sg13cmos5l_decap_8
XFILLER_422_63 VPWR VGND sg13cmos5l_decap_8
XFILLER_640_203 VPWR VGND sg13cmos5l_decap_8
XFILLER_18_63 VPWR VGND sg13cmos5l_decap_8
XFILLER_141_42 VPWR VGND sg13cmos5l_decap_8
XFILLER_62_119 VPWR VGND sg13cmos5l_decap_8
XANTENNA__0148__Y AXI_M_SOC_ARCACHE2 VPWR VGND sg13cmos5l_antennanp
XFILLER_55_160 VPWR VGND sg13cmos5l_decap_8
XFILLER_498_56 VPWR VGND sg13cmos5l_decap_8
XFILLER_203_125 VPWR VGND sg13cmos5l_decap_4
XFILLER_203_158 VPWR VGND sg13cmos5l_decap_4
XFILLER_70_196 VPWR VGND sg13cmos5l_decap_8
XFILLER_140_0 VPWR VGND sg13cmos5l_decap_8
XFILLER_357_140 VPWR VGND sg13cmos5l_decap_8
XFILLER_238_0 VPWR VGND sg13cmos5l_decap_8
XFILLER_367_49 VPWR VGND sg13cmos5l_decap_8
XFILLER_211_191 VPWR VGND sg13cmos5l_fill_1
XFILLER_664_14 VPWR VGND sg13cmos5l_decap_8
XFILLER_506_126 VPWR VGND sg13cmos5l_decap_8
XANTENNA__3475__X Tile_X0Y1_EE4BEG[1] VPWR VGND sg13cmos5l_antennanp
XFILLER_50_50 VPWR VGND sg13cmos5l_decap_8
XFILLER_405_0 VPWR VGND sg13cmos5l_decap_8
XFILLER_124_110 VPWR VGND sg13cmos5l_decap_8
XFILLER_316_42 VPWR VGND sg13cmos5l_decap_8
X_0470_ _0470_/Q Tile_X0Y8_FrameData[9] VGND VPWR Tile_X0Y9_FrameStrobe[1] latch
XFILLER_474_206 VPWR VGND sg13cmos5l_decap_8
XANTENNA__2819__X Tile_X0Y3_E1BEG[1] VPWR VGND sg13cmos5l_antennanp
X_2140_ _2140_/Q Tile_X0Y4_FrameData[9] VGND VPWR Tile_X0Y9_FrameStrobe[6] latch
XFILLER_427_133 VPWR VGND sg13cmos5l_decap_8
XFILLER_182_93 VPWR VGND sg13cmos5l_decap_8
XFILLER_613_84 VPWR VGND sg13cmos5l_decap_8
XFILLER_226_217 VPWR VGND sg13cmos5l_fill_2
X_2071_ _2071_/Q Tile_X0Y4_FrameData[14] VGND VPWR Tile_X0Y9_FrameStrobe[4] latch
XFILLER_332_63 VPWR VGND sg13cmos5l_decap_8
XFILLER_226_228 VPWR VGND sg13cmos5l_fill_1
XFILLER_332_74 VPWR VGND sg13cmos5l_fill_1
X_1022_ _1022_/Q Tile_X0Y0_FrameData[13] VGND VPWR Tile_X0Y9_FrameStrobe[2] latch
XFILLER_75_91 VPWR VGND sg13cmos5l_fill_2
XFILLER_689_88 VPWR VGND sg13cmos5l_decap_8
XFILLER_46_182 VPWR VGND sg13cmos5l_fill_1
XFILLER_201_56 VPWR VGND sg13cmos5l_decap_8
XFILLER_61_174 VPWR VGND sg13cmos5l_decap_8
X_2973_ Tile_X0Y8_FrameData_O[13] Tile_X0Y8_FrameData[13] VPWR VGND sg13cmos5l_buf_1
XFILLER_348_140 VPWR VGND sg13cmos5l_decap_8
X_4712_ _4712_/X Tile_X0Y6_W1END[2] Tile_X0Y6_W2MID[1] Tile_X0Y6_W2END[1] _4554_/X
+ _2639_/Q _2638_/Q VPWR VGND sg13cmos5l_mux4_1
X_1924_ _1924_/Q Tile_X0Y3_FrameData[5] VGND VPWR Tile_X0Y9_FrameStrobe[7] latch
XFILLER_277_49 VPWR VGND sg13cmos5l_decap_8
XFILLER_638_70 VPWR VGND sg13cmos5l_decap_8
XFILLER_348_173 VPWR VGND sg13cmos5l_decap_8
XFILLER_202_191 VPWR VGND sg13cmos5l_fill_1
X_4643_ _4643_/X Tile_X0Y7_WW4END[0] AXI_M_SOC_RDATA16 _4684_/X _4669_/X _0273_/Q
+ _0272_/Q VPWR VGND sg13cmos5l_mux4_1
XFILLER_574_14 VPWR VGND sg13cmos5l_decap_8
X_1855_ _1855_/Q Tile_X0Y3_FrameData[10] VGND VPWR Tile_X0Y9_FrameStrobe[5] latch
XANTENNA__3385__X Tile_X0Y2_E6BEG[8] VPWR VGND sg13cmos5l_antennanp
XFILLER_363_154 VPWR VGND sg13cmos5l_decap_4
X_0806_ _0806_/Q Tile_X0Y9_FrameData[25] VGND VPWR Tile_X0Y9_FrameStrobe[4] latch
X_1786_ _1786_/Q Tile_X0Y3_FrameData[15] VGND VPWR Tile_X0Y9_FrameStrobe[3] latch
X_4574_ _4574_/X _4549_/X Tile_X0Y9_N4END[14] _4548_/X _0155_/X _2483_/Q _2482_/Q
+ VPWR VGND sg13cmos5l_mux4_1
XFILLER_162_227 VPWR VGND sg13cmos5l_fill_2
X_3525_ Tile_X0Y9_E1BEG[3] _4847_/X VPWR VGND sg13cmos5l_buf_1
XFILLER_507_63 VPWR VGND sg13cmos5l_decap_8
X_0737_ _0737_/Q Tile_X0Y9_FrameData[30] VGND VPWR Tile_X0Y9_FrameStrobe[2] latch
XFILLER_115_143 VPWR VGND sg13cmos5l_decap_8
XFILLER_654_91 VPWR VGND sg13cmos5l_decap_8
XFILLER_226_42 VPWR VGND sg13cmos5l_decap_8
X_0668_ _0668_/Q Tile_X0Y8_FrameData[3] VGND VPWR Tile_X0Y9_FrameStrobe[7] latch
X_3456_ Tile_X0Y1_FrameData_O[14] Tile_X0Y1_FrameData[14] VPWR VGND sg13cmos5l_buf_1
XFILLER_590_35 VPWR VGND sg13cmos5l_decap_8
XFILLER_373_70 VPWR VGND sg13cmos5l_decap_8
X_2407_ _2407_/Q Tile_X0Y5_FrameData[30] VGND VPWR Tile_X0Y9_FrameStrobe[7] latch
X_3387_ Tile_X0Y2_E6BEG[10] _4082_/X VPWR VGND sg13cmos5l_buf_1
XFILLER_465_228 VPWR VGND sg13cmos5l_fill_1
X_0599_ _0599_/Q Tile_X0Y8_FrameData[8] VGND VPWR Tile_X0Y9_FrameStrobe[5] latch
XFILLER_607_211 VPWR VGND sg13cmos5l_decap_4
XFILLER_607_222 VPWR VGND sg13cmos5l_decap_8
X_2338_ _2338_/Q Tile_X0Y5_FrameData[3] VGND VPWR Tile_X0Y9_FrameStrobe[4] latch
XFILLER_681_158 VPWR VGND sg13cmos5l_decap_8
XFILLER_418_144 VPWR VGND sg13cmos5l_decap_4
XFILLER_523_84 VPWR VGND sg13cmos5l_decap_8
XFILLER_284_161 VPWR VGND sg13cmos5l_decap_8
XFILLER_418_177 VPWR VGND sg13cmos5l_decap_8
XFILLER_242_63 VPWR VGND sg13cmos5l_decap_8
XFILLER_217_228 VPWR VGND sg13cmos5l_fill_1
X_2269_ _2269_/Q Tile_X0Y5_FrameData[8] VGND VPWR Tile_X0Y9_FrameStrobe[2] latch
XFILLER_55_28 VPWR VGND sg13cmos5l_decap_8
XFILLER_622_225 VPWR VGND sg13cmos5l_decap_4
XFILLER_44_108 VPWR VGND sg13cmos5l_fill_1
X_4008_ _4008_/X _3981_/X _0073_/X _3980_/X Tile_X0Y0_S4END[4] _1233_/Q _1232_/Q VPWR
+ VGND sg13cmos5l_mux4_1
XFILLER_599_77 VPWR VGND sg13cmos5l_decap_8
XFILLER_433_147 VPWR VGND sg13cmos5l_decap_8
XFILLER_433_158 VPWR VGND sg13cmos5l_fill_1
XFILLER_232_209 VPWR VGND sg13cmos5l_decap_8
XFILLER_240_220 VPWR VGND sg13cmos5l_fill_1
XFILLER_111_56 VPWR VGND sg13cmos5l_decap_8
XFILLER_71_49 VPWR VGND sg13cmos5l_decap_8
XFILLER_231_7 VPWR VGND sg13cmos5l_decap_8
XFILLER_329_7 VPWR VGND sg13cmos5l_decap_8
XFILLER_187_49 VPWR VGND sg13cmos5l_decap_8
XFILLER_548_70 VPWR VGND sg13cmos5l_decap_8
XFILLER_138_213 VPWR VGND sg13cmos5l_decap_4
XANTENNA__3295__X Tile_X0Y0_E2BEGb[3] VPWR VGND sg13cmos5l_antennanp
XFILLER_484_47 VPWR VGND sg13cmos5l_decap_8
XFILLER_354_154 VPWR VGND sg13cmos5l_decap_8
XFILLER_4_204 VPWR VGND sg13cmos5l_fill_2
XFILLER_634_28 VPWR VGND sg13cmos5l_decap_8
XFILLER_20_42 VPWR VGND sg13cmos5l_decap_8
XFILLER_417_63 VPWR VGND sg13cmos5l_decap_8
XFILLER_698_7 VPWR VGND sg13cmos5l_decap_8
XFILLER_564_91 VPWR VGND sg13cmos5l_decap_8
XFILLER_136_42 VPWR VGND sg13cmos5l_decap_8
XFILLER_121_102 VPWR VGND sg13cmos5l_decap_8
XFILLER_714_50 VPWR VGND sg13cmos5l_decap_8
XFILLER_283_70 VPWR VGND sg13cmos5l_decap_8
XFILLER_96_35 VPWR VGND sg13cmos5l_decap_8
XFILLER_267_128 VPWR VGND sg13cmos5l_decap_4
XFILLER_409_111 VPWR VGND sg13cmos5l_decap_4
XFILLER_75_200 VPWR VGND sg13cmos5l_fill_2
XFILLER_650_49 VPWR VGND sg13cmos5l_decap_8
XFILLER_433_84 VPWR VGND sg13cmos5l_decap_8
XFILLER_188_0 VPWR VGND sg13cmos5l_decap_8
XFILLER_152_63 VPWR VGND sg13cmos5l_decap_8
XFILLER_680_180 VPWR VGND sg13cmos5l_decap_8
XFILLER_424_147 VPWR VGND sg13cmos5l_decap_8
XFILLER_659_14 VPWR VGND sg13cmos5l_decap_8
XFILLER_355_0 VPWR VGND sg13cmos5l_decap_8
XFILLER_28_193 VPWR VGND sg13cmos5l_decap_4
XFILLER_578_140 VPWR VGND sg13cmos5l_decap_8
XFILLER_188_102 VPWR VGND sg13cmos5l_fill_1
XFILLER_522_0 VPWR VGND sg13cmos5l_decap_8
XFILLER_188_179 VPWR VGND sg13cmos5l_decap_8
XFILLER_675_35 VPWR VGND sg13cmos5l_decap_8
XFILLER_458_70 VPWR VGND sg13cmos5l_decap_8
XFILLER_77_7 VPWR VGND sg13cmos5l_decap_8
XFILLER_534_221 VPWR VGND sg13cmos5l_fill_1
XFILLER_394_14 VPWR VGND sg13cmos5l_decap_8
X_1640_ _1640_/Q Tile_X0Y2_FrameData[9] VGND VPWR Tile_X0Y9_FrameStrobe[6] latch
XANTENNA_4 AXI_M_SOC_RDATA13 VPWR VGND sg13cmos5l_antennanp
XFILLER_608_84 VPWR VGND sg13cmos5l_decap_8
XFILLER_360_113 VPWR VGND sg13cmos5l_decap_8
X_1571_ _1571_/Q Tile_X0Y2_FrameData[14] VGND VPWR Tile_X0Y9_FrameStrobe[4] latch
XFILLER_544_28 VPWR VGND sg13cmos5l_decap_8
XFILLER_6_77 VPWR VGND sg13cmos5l_decap_8
XFILLER_691_56 VPWR VGND sg13cmos5l_decap_8
XFILLER_499_191 VPWR VGND sg13cmos5l_fill_1
XFILLER_474_91 VPWR VGND sg13cmos5l_decap_4
X_0522_ _0522_/Q Tile_X0Y8_FrameData[21] VGND VPWR Tile_X0Y9_FrameStrobe[3] latch
X_3310_ Tile_X0Y0_E1BEG[2] _3802_/X VPWR VGND sg13cmos5l_buf_1
XFILLER_502_140 VPWR VGND sg13cmos5l_decap_8
X_4290_ _4290_/X _0160_/X _0110_/X _4345_/X _4349_/X _2033_/Q _2032_/Q VPWR VGND sg13cmos5l_mux4_1
XFILLER_648_133 VPWR VGND sg13cmos5l_decap_8
XFILLER_193_70 VPWR VGND sg13cmos5l_decap_8
X_3241_ Tile_X0Y0_FrameData_O[9] Tile_X0Y0_FrameData[9] VPWR VGND sg13cmos5l_buf_1
X_0453_ _0453_/Q Tile_X0Y8_FrameData[26] VGND VPWR Tile_X0Y9_FrameStrobe[1] latch
XFILLER_648_188 VPWR VGND sg13cmos5l_decap_8
XFILLER_112_157 VPWR VGND sg13cmos5l_decap_8
X_3172_ Tile_X0Y4_E6BEG[9] _4297_/X VPWR VGND sg13cmos5l_buf_1
X_0384_ _0384_/Q Tile_X0Y7_FrameData[31] VGND VPWR Tile_X0Y9_FrameStrobe[7] latch
XFILLER_560_49 VPWR VGND sg13cmos5l_decap_8
XFILLER_343_84 VPWR VGND sg13cmos5l_decap_8
X_2123_ _2123_/Q Tile_X0Y4_FrameData[26] VGND VPWR Tile_X0Y9_FrameStrobe[6] latch
XANTENNA__0069__X AXI_M_SOC_WSTRB2 VPWR VGND sg13cmos5l_antennanp
XFILLER_266_183 VPWR VGND sg13cmos5l_decap_8
X_2054_ _2054_/Q Tile_X0Y4_FrameData[31] VGND VPWR Tile_X0Y9_FrameStrobe[4] latch
XFILLER_569_14 VPWR VGND sg13cmos5l_decap_8
XFILLER_281_175 VPWR VGND sg13cmos5l_decap_8
X_1005_ _1005_/Q Tile_X0Y0_FrameData[30] VGND VPWR Tile_X0Y9_FrameStrobe[2] latch
XFILLER_569_140 VPWR VGND sg13cmos5l_decap_8
XFILLER_212_77 VPWR VGND sg13cmos5l_decap_8
XFILLER_34_174 VPWR VGND sg13cmos5l_decap_8
XFILLER_649_91 VPWR VGND sg13cmos5l_decap_8
X_2956_ Tile_X0Y8_EE4BEG[12] _4756_/X VPWR VGND sg13cmos5l_buf_1
XFILLER_585_35 VPWR VGND sg13cmos5l_decap_8
XFILLER_368_70 VPWR VGND sg13cmos5l_decap_8
X_1907_ _1907_/Q Tile_X0Y3_FrameData[22] VGND VPWR Tile_X0Y9_FrameStrobe[7] latch
XFILLER_525_221 VPWR VGND sg13cmos5l_fill_1
X_2887_ Tile_X0Y6_FrameData_O[8] Tile_X0Y6_FrameData[8] VPWR VGND sg13cmos5l_buf_1
X_4626_ _4626_/X Tile_X0Y7_W2END[1] AXI_M_SOC_RDATA17 _4671_/X _4670_/X _0307_/Q _0306_/Q
+ VPWR VGND sg13cmos5l_mux4_1
XFILLER_135_216 VPWR VGND sg13cmos5l_fill_1
X_1838_ _1838_/Q Tile_X0Y3_FrameData[27] VGND VPWR Tile_X0Y9_FrameStrobe[5] latch
XFILLER_518_84 VPWR VGND sg13cmos5l_decap_8
XFILLER_454_28 VPWR VGND sg13cmos5l_decap_8
XFILLER_237_63 VPWR VGND sg13cmos5l_decap_8
X_4557_ _4557_/X _4473_/X _4589_/X _4588_/X _4472_/X _2459_/Q _2458_/Q VPWR VGND sg13cmos5l_mux4_1
X_1769_ _1769_/Q Tile_X0Y3_FrameData[0] VGND VPWR Tile_X0Y9_FrameStrobe[2] latch
XFILLER_351_168 VPWR VGND sg13cmos5l_decap_8
XFILLER_1_207 VPWR VGND sg13cmos5l_fill_1
X_3508_ Tile_X0Y1_E2BEGb[6] _3946_/X VPWR VGND sg13cmos5l_buf_1
XFILLER_639_133 VPWR VGND sg13cmos5l_decap_8
X_4488_ _4488_/X Tile_X0Y6_W1END[2] Tile_X0Y6_WW4END[14] Tile_X0Y6_W6END[6] _4570_/X
+ _2629_/Q _2628_/Q VPWR VGND sg13cmos5l_mux4_1
XFILLER_438_228 VPWR VGND sg13cmos5l_fill_1
X_3439_ Tile_X0Y4_FrameData_O[30] Tile_X0Y4_FrameData[30] VPWR VGND sg13cmos5l_buf_1
XFILLER_106_56 VPWR VGND sg13cmos5l_decap_8
XFILLER_654_147 VPWR VGND sg13cmos5l_decap_8
XFILLER_66_27 VPWR VGND sg13cmos5l_decap_8
XFILLER_470_49 VPWR VGND sg13cmos5l_decap_8
XFILLER_106_78 VPWR VGND sg13cmos5l_decap_8
XFILLER_253_84 VPWR VGND sg13cmos5l_fill_2
XFILLER_403_21 VPWR VGND sg13cmos5l_decap_8
XFILLER_181_7 VPWR VGND sg13cmos5l_decap_8
XFILLER_406_125 VPWR VGND sg13cmos5l_decap_8
XFILLER_279_7 VPWR VGND sg13cmos5l_decap_8
XFILLER_461_220 VPWR VGND sg13cmos5l_fill_2
XFILLER_72_203 VPWR VGND sg13cmos5l_decap_8
XFILLER_403_98 VPWR VGND sg13cmos5l_decap_8
XFILLER_700_30 VPWR VGND sg13cmos5l_decap_8
XFILLER_479_14 VPWR VGND sg13cmos5l_decap_8
XFILLER_122_77 VPWR VGND sg13cmos5l_decap_8
XFILLER_610_228 VPWR VGND sg13cmos5l_fill_1
XFILLER_446_7 VPWR VGND sg13cmos5l_decap_8
XFILLER_709_126 VPWR VGND sg13cmos5l_decap_8
XFILLER_25_185 VPWR VGND sg13cmos5l_decap_4
XFILLER_629_28 VPWR VGND sg13cmos5l_decap_8
XFILLER_15_42 VPWR VGND sg13cmos5l_decap_8
XFILLER_575_154 VPWR VGND sg13cmos5l_decap_8
XFILLER_559_91 VPWR VGND sg13cmos5l_decap_8
XANTENNA__2922__X Tile_X0Y8_E2BEG[6] VPWR VGND sg13cmos5l_antennanp
XFILLER_613_7 VPWR VGND sg13cmos5l_decap_8
XFILLER_374_205 VPWR VGND sg13cmos5l_fill_1
XFILLER_185_116 VPWR VGND sg13cmos5l_decap_4
XFILLER_495_35 VPWR VGND sg13cmos5l_decap_8
XFILLER_374_227 VPWR VGND sg13cmos5l_fill_2
XFILLER_278_70 VPWR VGND sg13cmos5l_decap_8
XFILLER_185_149 VPWR VGND sg13cmos5l_decap_4
XFILLER_516_221 VPWR VGND sg13cmos5l_fill_1
XFILLER_590_146 VPWR VGND sg13cmos5l_fill_2
XFILLER_193_160 VPWR VGND sg13cmos5l_fill_2
XFILLER_126_216 VPWR VGND sg13cmos5l_fill_2
XFILLER_31_52 VPWR VGND sg13cmos5l_decap_8
XFILLER_645_49 VPWR VGND sg13cmos5l_decap_8
XFILLER_428_84 VPWR VGND sg13cmos5l_decap_8
XFILLER_364_28 VPWR VGND sg13cmos5l_decap_8
XFILLER_147_63 VPWR VGND sg13cmos5l_decap_8
XFILLER_294_91 VPWR VGND sg13cmos5l_decap_8
XFILLER_103_0 VPWR VGND sg13cmos5l_decap_8
XANTENNA__3753__X AXI_M_SOC_ARADDR25 VPWR VGND sg13cmos5l_antennanp
XFILLER_496_161 VPWR VGND sg13cmos5l_decap_8
XFILLER_429_217 VPWR VGND sg13cmos5l_decap_8
XFILLER_429_228 VPWR VGND sg13cmos5l_fill_1
XFILLER_645_147 VPWR VGND sg13cmos5l_decap_8
XFILLER_380_49 VPWR VGND sg13cmos5l_decap_8
XFILLER_313_21 VPWR VGND sg13cmos5l_decap_8
XFILLER_472_0 VPWR VGND sg13cmos5l_decap_8
XFILLER_248_161 VPWR VGND sg13cmos5l_decap_4
XFILLER_263_153 VPWR VGND sg13cmos5l_fill_1
XFILLER_389_14 VPWR VGND sg13cmos5l_decap_8
XFILLER_313_98 VPWR VGND sg13cmos5l_decap_8
XFILLER_412_106 VPWR VGND sg13cmos5l_decap_8
XFILLER_610_63 VPWR VGND sg13cmos5l_decap_8
XFILLER_204_220 VPWR VGND sg13cmos5l_fill_2
XFILLER_539_28 VPWR VGND sg13cmos5l_decap_8
XFILLER_16_196 VPWR VGND sg13cmos5l_decap_8
XFILLER_72_70 VPWR VGND sg13cmos5l_decap_8
XFILLER_686_56 VPWR VGND sg13cmos5l_decap_8
XFILLER_566_154 VPWR VGND sg13cmos5l_decap_8
XANTENNA__2832__X Tile_X0Y6_E1BEG[1] VPWR VGND sg13cmos5l_antennanp
X_2810_ Tile_X0Y3_E2BEG[0] _4148_/X VPWR VGND sg13cmos5l_buf_1
XFILLER_365_205 VPWR VGND sg13cmos5l_decap_8
X_3790_ _3790_/X Tile_X0Y0_W2MID[1] Tile_X0Y0_W2END[1] Tile_X0Y0_W6END[1] _3854_/X
+ _1157_/Q _1156_/Q VPWR VGND sg13cmos5l_mux4_1
XFILLER_365_227 VPWR VGND sg13cmos5l_fill_2
XFILLER_715_118 VPWR VGND sg13cmos5l_decap_8
XFILLER_188_70 VPWR VGND sg13cmos5l_decap_8
XFILLER_318_121 VPWR VGND sg13cmos5l_decap_8
X_2741_ Tile_X0Y3_UserCLKo Tile_X0Y3_UserCLK VPWR VGND sg13cmos5l_buf_1
XFILLER_318_132 VPWR VGND sg13cmos5l_fill_2
XFILLER_581_168 VPWR VGND sg13cmos5l_decap_8
XFILLER_191_119 VPWR VGND sg13cmos5l_decap_8
X_2672_ _2672_/Q Tile_X0Y6_FrameData[23] VGND VPWR Tile_X0Y9_FrameStrobe[7] latch
XFILLER_555_49 VPWR VGND sg13cmos5l_decap_8
XFILLER_338_84 VPWR VGND sg13cmos5l_decap_8
XFILLER_117_227 VPWR VGND sg13cmos5l_fill_2
XFILLER_184_193 VPWR VGND sg13cmos5l_fill_1
X_4411_ _4411_/X AXI_M_SOC_RRESP1 _4455_/X _4459_/X _4434_/X _2281_/Q _2280_/Q VPWR
+ VGND sg13cmos5l_mux4_1
X_1623_ _1623_/Q Tile_X0Y2_FrameData[26] VGND VPWR Tile_X0Y9_FrameStrobe[6] latch
XFILLER_274_28 VPWR VGND sg13cmos5l_decap_8
XANTENNA__3663__X AXI_M_SOC_AWADDR24 VPWR VGND sg13cmos5l_antennanp
X_4342_ _4342_/X _4308_/X _0160_/X _4307_/X _0110_/X _1969_/Q _1968_/Q VPWR VGND sg13cmos5l_mux4_1
X_1554_ _1554_/Q Tile_X0Y2_FrameData[31] VGND VPWR Tile_X0Y9_FrameStrobe[4] latch
X_0505_ _0505_/Q Tile_X0Y8_FrameData[6] VGND VPWR Tile_X0Y9_FrameStrobe[2] latch
XFILLER_207_77 VPWR VGND sg13cmos5l_decap_8
X_1485_ _1485_/Q Tile_X0Y2_FrameData[4] VGND VPWR Tile_X0Y9_FrameStrobe[1] latch
X_4273_ _4273_/X Tile_X0Y4_WW4END[14] AXI_M_SOC_BRESP1 _4350_/X _4314_/X _2067_/Q
+ _2066_/Q VPWR VGND sg13cmos5l_mux4_1
XFILLER_504_42 VPWR VGND sg13cmos5l_decap_8
X_0436_ _0436_/Q Tile_X0Y8_FrameData[11] VGND VPWR Tile_X0Y9_FrameStrobe[0] latch
X_3224_ Tile_X0Y0_FrameStrobe_O[12] Tile_X0Y9_FrameStrobe[12] VPWR VGND sg13cmos5l_buf_1
.ends
