* NGSPICE file created from AXI_M_IO_W.ext - technology: ihp-sg13cmos5l

* Black-box entry subcircuit for sg13cmos5l_decap_8 abstract view
.subckt sg13cmos5l_decap_8 VDD VSS
.ends

* Black-box entry subcircuit for sg13cmos5l_fill_1 abstract view
.subckt sg13cmos5l_fill_1 VDD VSS
.ends

* Black-box entry subcircuit for latch abstract view
.subckt latch Q D VSS VDD GATE
.ends

* Black-box entry subcircuit for sg13cmos5l_buf_1 abstract view
.subckt sg13cmos5l_buf_1 X A VDD VSS
.ends

* Black-box entry subcircuit for sg13cmos5l_decap_4 abstract view
.subckt sg13cmos5l_decap_4 VDD VSS
.ends

* Black-box entry subcircuit for sg13cmos5l_antennanp abstract view
.subckt sg13cmos5l_antennanp A VDD VSS
.ends

* Black-box entry subcircuit for sg13cmos5l_fill_2 abstract view
.subckt sg13cmos5l_fill_2 VDD VSS
.ends

* Black-box entry subcircuit for sg13cmos5l_mux4_1 abstract view
.subckt sg13cmos5l_mux4_1 X A0 A1 A2 A3 S0 S1 VDD VSS
.ends

* Black-box entry subcircuit for sg13cmos5l_mux2_1 abstract view
.subckt sg13cmos5l_mux2_1 X A0 A1 S VDD VSS
.ends

* Black-box entry subcircuit for sg13cmos5l_tielo abstract view
.subckt sg13cmos5l_tielo L_LO VDD VSS
.ends

* Black-box entry subcircuit for sg13cmos5l_nor2b_1 abstract view
.subckt sg13cmos5l_nor2b_1 Y A B_N VDD VSS
.ends

* Black-box entry subcircuit for sg13cmos5l_or2_1 abstract view
.subckt sg13cmos5l_or2_1 X A B VDD VSS
.ends

.subckt AXI_M_IO_W AXI_M_SOC_ARADDR0 AXI_M_SOC_ARADDR1 AXI_M_SOC_ARADDR10 AXI_M_SOC_ARADDR11
+ AXI_M_SOC_ARADDR12 AXI_M_SOC_ARADDR13 AXI_M_SOC_ARADDR14 AXI_M_SOC_ARADDR15 AXI_M_SOC_ARADDR16
+ AXI_M_SOC_ARADDR17 AXI_M_SOC_ARADDR18 AXI_M_SOC_ARADDR19 AXI_M_SOC_ARADDR2 AXI_M_SOC_ARADDR20
+ AXI_M_SOC_ARADDR21 AXI_M_SOC_ARADDR22 AXI_M_SOC_ARADDR23 AXI_M_SOC_ARADDR24 AXI_M_SOC_ARADDR25
+ AXI_M_SOC_ARADDR26 AXI_M_SOC_ARADDR27 AXI_M_SOC_ARADDR28 AXI_M_SOC_ARADDR29 AXI_M_SOC_ARADDR3
+ AXI_M_SOC_ARADDR30 AXI_M_SOC_ARADDR31 AXI_M_SOC_ARADDR4 AXI_M_SOC_ARADDR5 AXI_M_SOC_ARADDR6
+ AXI_M_SOC_ARADDR7 AXI_M_SOC_ARADDR8 AXI_M_SOC_ARADDR9 AXI_M_SOC_ARBURST0 AXI_M_SOC_ARBURST1
+ AXI_M_SOC_ARCACHE0 AXI_M_SOC_ARCACHE1 AXI_M_SOC_ARCACHE2 AXI_M_SOC_ARCACHE3 AXI_M_SOC_ARLEN0
+ AXI_M_SOC_ARLEN1 AXI_M_SOC_ARLEN2 AXI_M_SOC_ARLEN3 AXI_M_SOC_ARLEN4 AXI_M_SOC_ARLEN5
+ AXI_M_SOC_ARLEN6 AXI_M_SOC_ARLEN7 AXI_M_SOC_ARLOCK AXI_M_SOC_ARREADY AXI_M_SOC_ARSIZE0
+ AXI_M_SOC_ARSIZE1 AXI_M_SOC_ARSIZE2 AXI_M_SOC_ARVALID AXI_M_SOC_AWADDR0 AXI_M_SOC_AWADDR1
+ AXI_M_SOC_AWADDR10 AXI_M_SOC_AWADDR11 AXI_M_SOC_AWADDR12 AXI_M_SOC_AWADDR13 AXI_M_SOC_AWADDR14
+ AXI_M_SOC_AWADDR15 AXI_M_SOC_AWADDR16 AXI_M_SOC_AWADDR17 AXI_M_SOC_AWADDR18 AXI_M_SOC_AWADDR19
+ AXI_M_SOC_AWADDR2 AXI_M_SOC_AWADDR20 AXI_M_SOC_AWADDR21 AXI_M_SOC_AWADDR22 AXI_M_SOC_AWADDR23
+ AXI_M_SOC_AWADDR24 AXI_M_SOC_AWADDR25 AXI_M_SOC_AWADDR26 AXI_M_SOC_AWADDR27 AXI_M_SOC_AWADDR28
+ AXI_M_SOC_AWADDR29 AXI_M_SOC_AWADDR3 AXI_M_SOC_AWADDR30 AXI_M_SOC_AWADDR31 AXI_M_SOC_AWADDR4
+ AXI_M_SOC_AWADDR5 AXI_M_SOC_AWADDR6 AXI_M_SOC_AWADDR7 AXI_M_SOC_AWADDR8 AXI_M_SOC_AWADDR9
+ AXI_M_SOC_AWBURST0 AXI_M_SOC_AWBURST1 AXI_M_SOC_AWCACHE0 AXI_M_SOC_AWCACHE1 AXI_M_SOC_AWCACHE2
+ AXI_M_SOC_AWCACHE3 AXI_M_SOC_AWLEN0 AXI_M_SOC_AWLEN1 AXI_M_SOC_AWLEN2 AXI_M_SOC_AWLEN3
+ AXI_M_SOC_AWLEN4 AXI_M_SOC_AWLEN5 AXI_M_SOC_AWLEN6 AXI_M_SOC_AWLEN7 AXI_M_SOC_AWLOCK
+ AXI_M_SOC_AWREADY AXI_M_SOC_AWSIZE0 AXI_M_SOC_AWSIZE1 AXI_M_SOC_AWSIZE2 AXI_M_SOC_AWVALID
+ AXI_M_SOC_BREADY AXI_M_SOC_BRESP0 AXI_M_SOC_BRESP1 AXI_M_SOC_BVALID AXI_M_SOC_RDATA0
+ AXI_M_SOC_RDATA1 AXI_M_SOC_RDATA10 AXI_M_SOC_RDATA11 AXI_M_SOC_RDATA12 AXI_M_SOC_RDATA13
+ AXI_M_SOC_RDATA14 AXI_M_SOC_RDATA15 AXI_M_SOC_RDATA16 AXI_M_SOC_RDATA17 AXI_M_SOC_RDATA18
+ AXI_M_SOC_RDATA19 AXI_M_SOC_RDATA2 AXI_M_SOC_RDATA20 AXI_M_SOC_RDATA21 AXI_M_SOC_RDATA22
+ AXI_M_SOC_RDATA23 AXI_M_SOC_RDATA24 AXI_M_SOC_RDATA25 AXI_M_SOC_RDATA26 AXI_M_SOC_RDATA27
+ AXI_M_SOC_RDATA28 AXI_M_SOC_RDATA29 AXI_M_SOC_RDATA3 AXI_M_SOC_RDATA30 AXI_M_SOC_RDATA31
+ AXI_M_SOC_RDATA4 AXI_M_SOC_RDATA5 AXI_M_SOC_RDATA6 AXI_M_SOC_RDATA7 AXI_M_SOC_RDATA8
+ AXI_M_SOC_RDATA9 AXI_M_SOC_RLAST AXI_M_SOC_RREADY AXI_M_SOC_RRESP0 AXI_M_SOC_RRESP1
+ AXI_M_SOC_RVALID AXI_M_SOC_WDATA0 AXI_M_SOC_WDATA1 AXI_M_SOC_WDATA10 AXI_M_SOC_WDATA11
+ AXI_M_SOC_WDATA12 AXI_M_SOC_WDATA13 AXI_M_SOC_WDATA14 AXI_M_SOC_WDATA15 AXI_M_SOC_WDATA16
+ AXI_M_SOC_WDATA17 AXI_M_SOC_WDATA18 AXI_M_SOC_WDATA19 AXI_M_SOC_WDATA2 AXI_M_SOC_WDATA20
+ AXI_M_SOC_WDATA21 AXI_M_SOC_WDATA22 AXI_M_SOC_WDATA23 AXI_M_SOC_WDATA24 AXI_M_SOC_WDATA25
+ AXI_M_SOC_WDATA26 AXI_M_SOC_WDATA27 AXI_M_SOC_WDATA28 AXI_M_SOC_WDATA29 AXI_M_SOC_WDATA3
+ AXI_M_SOC_WDATA30 AXI_M_SOC_WDATA31 AXI_M_SOC_WDATA4 AXI_M_SOC_WDATA5 AXI_M_SOC_WDATA6
+ AXI_M_SOC_WDATA7 AXI_M_SOC_WDATA8 AXI_M_SOC_WDATA9 AXI_M_SOC_WLAST AXI_M_SOC_WREADY
+ AXI_M_SOC_WSTRB0 AXI_M_SOC_WSTRB1 AXI_M_SOC_WSTRB2 AXI_M_SOC_WSTRB3 AXI_M_SOC_WVALID
+ Tile_X0Y0_E1BEG[0] Tile_X0Y0_E1BEG[1] Tile_X0Y0_E1BEG[2] Tile_X0Y0_E1BEG[3] Tile_X0Y0_E2BEG[0]
+ Tile_X0Y0_E2BEG[1] Tile_X0Y0_E2BEG[2] Tile_X0Y0_E2BEG[3] Tile_X0Y0_E2BEG[4] Tile_X0Y0_E2BEG[5]
+ Tile_X0Y0_E2BEG[6] Tile_X0Y0_E2BEG[7] Tile_X0Y0_E2BEGb[0] Tile_X0Y0_E2BEGb[1] Tile_X0Y0_E2BEGb[2]
+ Tile_X0Y0_E2BEGb[3] Tile_X0Y0_E2BEGb[4] Tile_X0Y0_E2BEGb[5] Tile_X0Y0_E2BEGb[6]
+ Tile_X0Y0_E2BEGb[7] Tile_X0Y0_E6BEG[0] Tile_X0Y0_E6BEG[10] Tile_X0Y0_E6BEG[11] Tile_X0Y0_E6BEG[1]
+ Tile_X0Y0_E6BEG[2] Tile_X0Y0_E6BEG[3] Tile_X0Y0_E6BEG[4] Tile_X0Y0_E6BEG[5] Tile_X0Y0_E6BEG[6]
+ Tile_X0Y0_E6BEG[7] Tile_X0Y0_E6BEG[8] Tile_X0Y0_E6BEG[9] Tile_X0Y0_EE4BEG[0] Tile_X0Y0_EE4BEG[10]
+ Tile_X0Y0_EE4BEG[11] Tile_X0Y0_EE4BEG[12] Tile_X0Y0_EE4BEG[13] Tile_X0Y0_EE4BEG[14]
+ Tile_X0Y0_EE4BEG[15] Tile_X0Y0_EE4BEG[1] Tile_X0Y0_EE4BEG[2] Tile_X0Y0_EE4BEG[3]
+ Tile_X0Y0_EE4BEG[4] Tile_X0Y0_EE4BEG[5] Tile_X0Y0_EE4BEG[6] Tile_X0Y0_EE4BEG[7]
+ Tile_X0Y0_EE4BEG[8] Tile_X0Y0_EE4BEG[9] Tile_X0Y0_FrameData[0] Tile_X0Y0_FrameData[10]
+ Tile_X0Y0_FrameData[11] Tile_X0Y0_FrameData[12] Tile_X0Y0_FrameData[13] Tile_X0Y0_FrameData[14]
+ Tile_X0Y0_FrameData[15] Tile_X0Y0_FrameData[16] Tile_X0Y0_FrameData[17] Tile_X0Y0_FrameData[18]
+ Tile_X0Y0_FrameData[19] Tile_X0Y0_FrameData[1] Tile_X0Y0_FrameData[20] Tile_X0Y0_FrameData[21]
+ Tile_X0Y0_FrameData[22] Tile_X0Y0_FrameData[23] Tile_X0Y0_FrameData[24] Tile_X0Y0_FrameData[25]
+ Tile_X0Y0_FrameData[26] Tile_X0Y0_FrameData[27] Tile_X0Y0_FrameData[28] Tile_X0Y0_FrameData[29]
+ Tile_X0Y0_FrameData[2] Tile_X0Y0_FrameData[30] Tile_X0Y0_FrameData[31] Tile_X0Y0_FrameData[3]
+ Tile_X0Y0_FrameData[4] Tile_X0Y0_FrameData[5] Tile_X0Y0_FrameData[6] Tile_X0Y0_FrameData[7]
+ Tile_X0Y0_FrameData[8] Tile_X0Y0_FrameData[9] Tile_X0Y0_FrameData_O[0] Tile_X0Y0_FrameData_O[10]
+ Tile_X0Y0_FrameData_O[11] Tile_X0Y0_FrameData_O[12] Tile_X0Y0_FrameData_O[13] Tile_X0Y0_FrameData_O[14]
+ Tile_X0Y0_FrameData_O[15] Tile_X0Y0_FrameData_O[16] Tile_X0Y0_FrameData_O[17] Tile_X0Y0_FrameData_O[18]
+ Tile_X0Y0_FrameData_O[19] Tile_X0Y0_FrameData_O[1] Tile_X0Y0_FrameData_O[20] Tile_X0Y0_FrameData_O[21]
+ Tile_X0Y0_FrameData_O[22] Tile_X0Y0_FrameData_O[23] Tile_X0Y0_FrameData_O[24] Tile_X0Y0_FrameData_O[25]
+ Tile_X0Y0_FrameData_O[26] Tile_X0Y0_FrameData_O[27] Tile_X0Y0_FrameData_O[28] Tile_X0Y0_FrameData_O[29]
+ Tile_X0Y0_FrameData_O[2] Tile_X0Y0_FrameData_O[30] Tile_X0Y0_FrameData_O[31] Tile_X0Y0_FrameData_O[3]
+ Tile_X0Y0_FrameData_O[4] Tile_X0Y0_FrameData_O[5] Tile_X0Y0_FrameData_O[6] Tile_X0Y0_FrameData_O[7]
+ Tile_X0Y0_FrameData_O[8] Tile_X0Y0_FrameData_O[9] Tile_X0Y0_FrameStrobe_O[0] Tile_X0Y0_FrameStrobe_O[10]
+ Tile_X0Y0_FrameStrobe_O[11] Tile_X0Y0_FrameStrobe_O[12] Tile_X0Y0_FrameStrobe_O[13]
+ Tile_X0Y0_FrameStrobe_O[14] Tile_X0Y0_FrameStrobe_O[15] Tile_X0Y0_FrameStrobe_O[16]
+ Tile_X0Y0_FrameStrobe_O[17] Tile_X0Y0_FrameStrobe_O[18] Tile_X0Y0_FrameStrobe_O[19]
+ Tile_X0Y0_FrameStrobe_O[1] Tile_X0Y0_FrameStrobe_O[2] Tile_X0Y0_FrameStrobe_O[3]
+ Tile_X0Y0_FrameStrobe_O[4] Tile_X0Y0_FrameStrobe_O[5] Tile_X0Y0_FrameStrobe_O[6]
+ Tile_X0Y0_FrameStrobe_O[7] Tile_X0Y0_FrameStrobe_O[8] Tile_X0Y0_FrameStrobe_O[9]
+ Tile_X0Y0_N1BEG[0] Tile_X0Y0_N1BEG[1] Tile_X0Y0_N1BEG[2] Tile_X0Y0_N1BEG[3] Tile_X0Y0_N2BEG[0]
+ Tile_X0Y0_N2BEG[1] Tile_X0Y0_N2BEG[2] Tile_X0Y0_N2BEG[3] Tile_X0Y0_N2BEG[4] Tile_X0Y0_N2BEG[5]
+ Tile_X0Y0_N2BEG[6] Tile_X0Y0_N2BEG[7] Tile_X0Y0_N2BEGb[0] Tile_X0Y0_N2BEGb[1] Tile_X0Y0_N2BEGb[2]
+ Tile_X0Y0_N2BEGb[3] Tile_X0Y0_N2BEGb[4] Tile_X0Y0_N2BEGb[5] Tile_X0Y0_N2BEGb[6]
+ Tile_X0Y0_N2BEGb[7] Tile_X0Y0_N4BEG[0] Tile_X0Y0_N4BEG[10] Tile_X0Y0_N4BEG[11] Tile_X0Y0_N4BEG[12]
+ Tile_X0Y0_N4BEG[13] Tile_X0Y0_N4BEG[14] Tile_X0Y0_N4BEG[15] Tile_X0Y0_N4BEG[1] Tile_X0Y0_N4BEG[2]
+ Tile_X0Y0_N4BEG[3] Tile_X0Y0_N4BEG[4] Tile_X0Y0_N4BEG[5] Tile_X0Y0_N4BEG[6] Tile_X0Y0_N4BEG[7]
+ Tile_X0Y0_N4BEG[8] Tile_X0Y0_N4BEG[9] Tile_X0Y0_S1END[0] Tile_X0Y0_S1END[1] Tile_X0Y0_S1END[2]
+ Tile_X0Y0_S1END[3] Tile_X0Y0_S2END[0] Tile_X0Y0_S2END[1] Tile_X0Y0_S2END[2] Tile_X0Y0_S2END[3]
+ Tile_X0Y0_S2END[4] Tile_X0Y0_S2END[5] Tile_X0Y0_S2END[6] Tile_X0Y0_S2END[7] Tile_X0Y0_S2MID[0]
+ Tile_X0Y0_S2MID[1] Tile_X0Y0_S2MID[2] Tile_X0Y0_S2MID[3] Tile_X0Y0_S2MID[4] Tile_X0Y0_S2MID[5]
+ Tile_X0Y0_S2MID[6] Tile_X0Y0_S2MID[7] Tile_X0Y0_S4END[0] Tile_X0Y0_S4END[10] Tile_X0Y0_S4END[11]
+ Tile_X0Y0_S4END[12] Tile_X0Y0_S4END[13] Tile_X0Y0_S4END[14] Tile_X0Y0_S4END[15]
+ Tile_X0Y0_S4END[1] Tile_X0Y0_S4END[2] Tile_X0Y0_S4END[3] Tile_X0Y0_S4END[4] Tile_X0Y0_S4END[5]
+ Tile_X0Y0_S4END[6] Tile_X0Y0_S4END[7] Tile_X0Y0_S4END[8] Tile_X0Y0_S4END[9] Tile_X0Y0_UserCLK
+ Tile_X0Y0_UserCLKo Tile_X0Y0_W1END[0] Tile_X0Y0_W1END[1] Tile_X0Y0_W1END[2] Tile_X0Y0_W1END[3]
+ Tile_X0Y0_W2END[0] Tile_X0Y0_W2END[1] Tile_X0Y0_W2END[2] Tile_X0Y0_W2END[3] Tile_X0Y0_W2END[4]
+ Tile_X0Y0_W2END[5] Tile_X0Y0_W2END[6] Tile_X0Y0_W2END[7] Tile_X0Y0_W2MID[0] Tile_X0Y0_W2MID[1]
+ Tile_X0Y0_W2MID[2] Tile_X0Y0_W2MID[3] Tile_X0Y0_W2MID[4] Tile_X0Y0_W2MID[5] Tile_X0Y0_W2MID[6]
+ Tile_X0Y0_W2MID[7] Tile_X0Y0_W6END[0] Tile_X0Y0_W6END[10] Tile_X0Y0_W6END[11] Tile_X0Y0_W6END[1]
+ Tile_X0Y0_W6END[2] Tile_X0Y0_W6END[3] Tile_X0Y0_W6END[4] Tile_X0Y0_W6END[5] Tile_X0Y0_W6END[6]
+ Tile_X0Y0_W6END[7] Tile_X0Y0_W6END[8] Tile_X0Y0_W6END[9] Tile_X0Y0_WW4END[0] Tile_X0Y0_WW4END[10]
+ Tile_X0Y0_WW4END[11] Tile_X0Y0_WW4END[12] Tile_X0Y0_WW4END[13] Tile_X0Y0_WW4END[14]
+ Tile_X0Y0_WW4END[15] Tile_X0Y0_WW4END[1] Tile_X0Y0_WW4END[2] Tile_X0Y0_WW4END[3]
+ Tile_X0Y0_WW4END[4] Tile_X0Y0_WW4END[5] Tile_X0Y0_WW4END[6] Tile_X0Y0_WW4END[7]
+ Tile_X0Y0_WW4END[8] Tile_X0Y0_WW4END[9] Tile_X0Y1_E1BEG[0] Tile_X0Y1_E1BEG[1] Tile_X0Y1_E1BEG[2]
+ Tile_X0Y1_E1BEG[3] Tile_X0Y1_E2BEG[0] Tile_X0Y1_E2BEG[1] Tile_X0Y1_E2BEG[2] Tile_X0Y1_E2BEG[3]
+ Tile_X0Y1_E2BEG[4] Tile_X0Y1_E2BEG[5] Tile_X0Y1_E2BEG[6] Tile_X0Y1_E2BEG[7] Tile_X0Y1_E2BEGb[0]
+ Tile_X0Y1_E2BEGb[1] Tile_X0Y1_E2BEGb[2] Tile_X0Y1_E2BEGb[3] Tile_X0Y1_E2BEGb[4]
+ Tile_X0Y1_E2BEGb[5] Tile_X0Y1_E2BEGb[6] Tile_X0Y1_E2BEGb[7] Tile_X0Y1_E6BEG[0] Tile_X0Y1_E6BEG[10]
+ Tile_X0Y1_E6BEG[11] Tile_X0Y1_E6BEG[1] Tile_X0Y1_E6BEG[2] Tile_X0Y1_E6BEG[3] Tile_X0Y1_E6BEG[4]
+ Tile_X0Y1_E6BEG[5] Tile_X0Y1_E6BEG[6] Tile_X0Y1_E6BEG[7] Tile_X0Y1_E6BEG[8] Tile_X0Y1_E6BEG[9]
+ Tile_X0Y1_EE4BEG[0] Tile_X0Y1_EE4BEG[10] Tile_X0Y1_EE4BEG[11] Tile_X0Y1_EE4BEG[12]
+ Tile_X0Y1_EE4BEG[13] Tile_X0Y1_EE4BEG[14] Tile_X0Y1_EE4BEG[15] Tile_X0Y1_EE4BEG[1]
+ Tile_X0Y1_EE4BEG[2] Tile_X0Y1_EE4BEG[3] Tile_X0Y1_EE4BEG[4] Tile_X0Y1_EE4BEG[5]
+ Tile_X0Y1_EE4BEG[6] Tile_X0Y1_EE4BEG[7] Tile_X0Y1_EE4BEG[8] Tile_X0Y1_EE4BEG[9]
+ Tile_X0Y1_FrameData[0] Tile_X0Y1_FrameData[10] Tile_X0Y1_FrameData[11] Tile_X0Y1_FrameData[12]
+ Tile_X0Y1_FrameData[13] Tile_X0Y1_FrameData[14] Tile_X0Y1_FrameData[15] Tile_X0Y1_FrameData[16]
+ Tile_X0Y1_FrameData[17] Tile_X0Y1_FrameData[18] Tile_X0Y1_FrameData[19] Tile_X0Y1_FrameData[1]
+ Tile_X0Y1_FrameData[20] Tile_X0Y1_FrameData[21] Tile_X0Y1_FrameData[22] Tile_X0Y1_FrameData[23]
+ Tile_X0Y1_FrameData[24] Tile_X0Y1_FrameData[25] Tile_X0Y1_FrameData[26] Tile_X0Y1_FrameData[27]
+ Tile_X0Y1_FrameData[28] Tile_X0Y1_FrameData[29] Tile_X0Y1_FrameData[2] Tile_X0Y1_FrameData[30]
+ Tile_X0Y1_FrameData[31] Tile_X0Y1_FrameData[3] Tile_X0Y1_FrameData[4] Tile_X0Y1_FrameData[5]
+ Tile_X0Y1_FrameData[6] Tile_X0Y1_FrameData[7] Tile_X0Y1_FrameData[8] Tile_X0Y1_FrameData[9]
+ Tile_X0Y1_FrameData_O[0] Tile_X0Y1_FrameData_O[10] Tile_X0Y1_FrameData_O[11] Tile_X0Y1_FrameData_O[12]
+ Tile_X0Y1_FrameData_O[13] Tile_X0Y1_FrameData_O[14] Tile_X0Y1_FrameData_O[15] Tile_X0Y1_FrameData_O[16]
+ Tile_X0Y1_FrameData_O[17] Tile_X0Y1_FrameData_O[18] Tile_X0Y1_FrameData_O[19] Tile_X0Y1_FrameData_O[1]
+ Tile_X0Y1_FrameData_O[20] Tile_X0Y1_FrameData_O[21] Tile_X0Y1_FrameData_O[22] Tile_X0Y1_FrameData_O[23]
+ Tile_X0Y1_FrameData_O[24] Tile_X0Y1_FrameData_O[25] Tile_X0Y1_FrameData_O[26] Tile_X0Y1_FrameData_O[27]
+ Tile_X0Y1_FrameData_O[28] Tile_X0Y1_FrameData_O[29] Tile_X0Y1_FrameData_O[2] Tile_X0Y1_FrameData_O[30]
+ Tile_X0Y1_FrameData_O[31] Tile_X0Y1_FrameData_O[3] Tile_X0Y1_FrameData_O[4] Tile_X0Y1_FrameData_O[5]
+ Tile_X0Y1_FrameData_O[6] Tile_X0Y1_FrameData_O[7] Tile_X0Y1_FrameData_O[8] Tile_X0Y1_FrameData_O[9]
+ Tile_X0Y1_UserCLK Tile_X0Y1_UserCLKo Tile_X0Y1_W1END[0] Tile_X0Y1_W1END[1] Tile_X0Y1_W1END[2]
+ Tile_X0Y1_W1END[3] Tile_X0Y1_W2END[0] Tile_X0Y1_W2END[1] Tile_X0Y1_W2END[2] Tile_X0Y1_W2END[3]
+ Tile_X0Y1_W2END[4] Tile_X0Y1_W2END[5] Tile_X0Y1_W2END[6] Tile_X0Y1_W2END[7] Tile_X0Y1_W2MID[0]
+ Tile_X0Y1_W2MID[1] Tile_X0Y1_W2MID[2] Tile_X0Y1_W2MID[3] Tile_X0Y1_W2MID[4] Tile_X0Y1_W2MID[5]
+ Tile_X0Y1_W2MID[6] Tile_X0Y1_W2MID[7] Tile_X0Y1_W6END[0] Tile_X0Y1_W6END[10] Tile_X0Y1_W6END[11]
+ Tile_X0Y1_W6END[1] Tile_X0Y1_W6END[2] Tile_X0Y1_W6END[3] Tile_X0Y1_W6END[4] Tile_X0Y1_W6END[5]
+ Tile_X0Y1_W6END[6] Tile_X0Y1_W6END[7] Tile_X0Y1_W6END[8] Tile_X0Y1_W6END[9] Tile_X0Y1_WW4END[0]
+ Tile_X0Y1_WW4END[10] Tile_X0Y1_WW4END[11] Tile_X0Y1_WW4END[12] Tile_X0Y1_WW4END[13]
+ Tile_X0Y1_WW4END[14] Tile_X0Y1_WW4END[15] Tile_X0Y1_WW4END[1] Tile_X0Y1_WW4END[2]
+ Tile_X0Y1_WW4END[3] Tile_X0Y1_WW4END[4] Tile_X0Y1_WW4END[5] Tile_X0Y1_WW4END[6]
+ Tile_X0Y1_WW4END[7] Tile_X0Y1_WW4END[8] Tile_X0Y1_WW4END[9] Tile_X0Y2_E1BEG[0] Tile_X0Y2_E1BEG[1]
+ Tile_X0Y2_E1BEG[2] Tile_X0Y2_E1BEG[3] Tile_X0Y2_E2BEG[0] Tile_X0Y2_E2BEG[1] Tile_X0Y2_E2BEG[2]
+ Tile_X0Y2_E2BEG[3] Tile_X0Y2_E2BEG[4] Tile_X0Y2_E2BEG[5] Tile_X0Y2_E2BEG[6] Tile_X0Y2_E2BEG[7]
+ Tile_X0Y2_E2BEGb[0] Tile_X0Y2_E2BEGb[1] Tile_X0Y2_E2BEGb[2] Tile_X0Y2_E2BEGb[3]
+ Tile_X0Y2_E2BEGb[4] Tile_X0Y2_E2BEGb[5] Tile_X0Y2_E2BEGb[6] Tile_X0Y2_E2BEGb[7]
+ Tile_X0Y2_E6BEG[0] Tile_X0Y2_E6BEG[10] Tile_X0Y2_E6BEG[11] Tile_X0Y2_E6BEG[1] Tile_X0Y2_E6BEG[2]
+ Tile_X0Y2_E6BEG[3] Tile_X0Y2_E6BEG[4] Tile_X0Y2_E6BEG[5] Tile_X0Y2_E6BEG[6] Tile_X0Y2_E6BEG[7]
+ Tile_X0Y2_E6BEG[8] Tile_X0Y2_E6BEG[9] Tile_X0Y2_EE4BEG[0] Tile_X0Y2_EE4BEG[10] Tile_X0Y2_EE4BEG[11]
+ Tile_X0Y2_EE4BEG[12] Tile_X0Y2_EE4BEG[13] Tile_X0Y2_EE4BEG[14] Tile_X0Y2_EE4BEG[15]
+ Tile_X0Y2_EE4BEG[1] Tile_X0Y2_EE4BEG[2] Tile_X0Y2_EE4BEG[3] Tile_X0Y2_EE4BEG[4]
+ Tile_X0Y2_EE4BEG[5] Tile_X0Y2_EE4BEG[6] Tile_X0Y2_EE4BEG[7] Tile_X0Y2_EE4BEG[8]
+ Tile_X0Y2_EE4BEG[9] Tile_X0Y2_FrameData[0] Tile_X0Y2_FrameData[10] Tile_X0Y2_FrameData[11]
+ Tile_X0Y2_FrameData[12] Tile_X0Y2_FrameData[13] Tile_X0Y2_FrameData[14] Tile_X0Y2_FrameData[15]
+ Tile_X0Y2_FrameData[16] Tile_X0Y2_FrameData[17] Tile_X0Y2_FrameData[18] Tile_X0Y2_FrameData[19]
+ Tile_X0Y2_FrameData[1] Tile_X0Y2_FrameData[20] Tile_X0Y2_FrameData[21] Tile_X0Y2_FrameData[22]
+ Tile_X0Y2_FrameData[23] Tile_X0Y2_FrameData[24] Tile_X0Y2_FrameData[25] Tile_X0Y2_FrameData[26]
+ Tile_X0Y2_FrameData[27] Tile_X0Y2_FrameData[28] Tile_X0Y2_FrameData[29] Tile_X0Y2_FrameData[2]
+ Tile_X0Y2_FrameData[30] Tile_X0Y2_FrameData[31] Tile_X0Y2_FrameData[3] Tile_X0Y2_FrameData[4]
+ Tile_X0Y2_FrameData[5] Tile_X0Y2_FrameData[6] Tile_X0Y2_FrameData[7] Tile_X0Y2_FrameData[8]
+ Tile_X0Y2_FrameData[9] Tile_X0Y2_FrameData_O[0] Tile_X0Y2_FrameData_O[10] Tile_X0Y2_FrameData_O[11]
+ Tile_X0Y2_FrameData_O[12] Tile_X0Y2_FrameData_O[13] Tile_X0Y2_FrameData_O[14] Tile_X0Y2_FrameData_O[15]
+ Tile_X0Y2_FrameData_O[16] Tile_X0Y2_FrameData_O[17] Tile_X0Y2_FrameData_O[18] Tile_X0Y2_FrameData_O[19]
+ Tile_X0Y2_FrameData_O[1] Tile_X0Y2_FrameData_O[20] Tile_X0Y2_FrameData_O[21] Tile_X0Y2_FrameData_O[22]
+ Tile_X0Y2_FrameData_O[23] Tile_X0Y2_FrameData_O[24] Tile_X0Y2_FrameData_O[25] Tile_X0Y2_FrameData_O[26]
+ Tile_X0Y2_FrameData_O[27] Tile_X0Y2_FrameData_O[28] Tile_X0Y2_FrameData_O[29] Tile_X0Y2_FrameData_O[2]
+ Tile_X0Y2_FrameData_O[30] Tile_X0Y2_FrameData_O[31] Tile_X0Y2_FrameData_O[3] Tile_X0Y2_FrameData_O[4]
+ Tile_X0Y2_FrameData_O[5] Tile_X0Y2_FrameData_O[6] Tile_X0Y2_FrameData_O[7] Tile_X0Y2_FrameData_O[8]
+ Tile_X0Y2_FrameData_O[9] Tile_X0Y2_UserCLK Tile_X0Y2_UserCLKo Tile_X0Y2_W1END[0]
+ Tile_X0Y2_W1END[1] Tile_X0Y2_W1END[2] Tile_X0Y2_W1END[3] Tile_X0Y2_W2END[0] Tile_X0Y2_W2END[1]
+ Tile_X0Y2_W2END[2] Tile_X0Y2_W2END[3] Tile_X0Y2_W2END[4] Tile_X0Y2_W2END[5] Tile_X0Y2_W2END[6]
+ Tile_X0Y2_W2END[7] Tile_X0Y2_W2MID[0] Tile_X0Y2_W2MID[1] Tile_X0Y2_W2MID[2] Tile_X0Y2_W2MID[3]
+ Tile_X0Y2_W2MID[4] Tile_X0Y2_W2MID[5] Tile_X0Y2_W2MID[6] Tile_X0Y2_W2MID[7] Tile_X0Y2_W6END[0]
+ Tile_X0Y2_W6END[10] Tile_X0Y2_W6END[11] Tile_X0Y2_W6END[1] Tile_X0Y2_W6END[2] Tile_X0Y2_W6END[3]
+ Tile_X0Y2_W6END[4] Tile_X0Y2_W6END[5] Tile_X0Y2_W6END[6] Tile_X0Y2_W6END[7] Tile_X0Y2_W6END[8]
+ Tile_X0Y2_W6END[9] Tile_X0Y2_WW4END[0] Tile_X0Y2_WW4END[10] Tile_X0Y2_WW4END[11]
+ Tile_X0Y2_WW4END[12] Tile_X0Y2_WW4END[13] Tile_X0Y2_WW4END[14] Tile_X0Y2_WW4END[15]
+ Tile_X0Y2_WW4END[1] Tile_X0Y2_WW4END[2] Tile_X0Y2_WW4END[3] Tile_X0Y2_WW4END[4]
+ Tile_X0Y2_WW4END[5] Tile_X0Y2_WW4END[6] Tile_X0Y2_WW4END[7] Tile_X0Y2_WW4END[8]
+ Tile_X0Y2_WW4END[9] Tile_X0Y3_E1BEG[0] Tile_X0Y3_E1BEG[1] Tile_X0Y3_E1BEG[2] Tile_X0Y3_E1BEG[3]
+ Tile_X0Y3_E2BEG[0] Tile_X0Y3_E2BEG[1] Tile_X0Y3_E2BEG[2] Tile_X0Y3_E2BEG[3] Tile_X0Y3_E2BEG[4]
+ Tile_X0Y3_E2BEG[5] Tile_X0Y3_E2BEG[6] Tile_X0Y3_E2BEG[7] Tile_X0Y3_E2BEGb[0] Tile_X0Y3_E2BEGb[1]
+ Tile_X0Y3_E2BEGb[2] Tile_X0Y3_E2BEGb[3] Tile_X0Y3_E2BEGb[4] Tile_X0Y3_E2BEGb[5]
+ Tile_X0Y3_E2BEGb[6] Tile_X0Y3_E2BEGb[7] Tile_X0Y3_E6BEG[0] Tile_X0Y3_E6BEG[10] Tile_X0Y3_E6BEG[11]
+ Tile_X0Y3_E6BEG[1] Tile_X0Y3_E6BEG[2] Tile_X0Y3_E6BEG[3] Tile_X0Y3_E6BEG[4] Tile_X0Y3_E6BEG[5]
+ Tile_X0Y3_E6BEG[6] Tile_X0Y3_E6BEG[7] Tile_X0Y3_E6BEG[8] Tile_X0Y3_E6BEG[9] Tile_X0Y3_EE4BEG[0]
+ Tile_X0Y3_EE4BEG[10] Tile_X0Y3_EE4BEG[11] Tile_X0Y3_EE4BEG[12] Tile_X0Y3_EE4BEG[13]
+ Tile_X0Y3_EE4BEG[14] Tile_X0Y3_EE4BEG[15] Tile_X0Y3_EE4BEG[1] Tile_X0Y3_EE4BEG[2]
+ Tile_X0Y3_EE4BEG[3] Tile_X0Y3_EE4BEG[4] Tile_X0Y3_EE4BEG[5] Tile_X0Y3_EE4BEG[6]
+ Tile_X0Y3_EE4BEG[7] Tile_X0Y3_EE4BEG[8] Tile_X0Y3_EE4BEG[9] Tile_X0Y3_FrameData[0]
+ Tile_X0Y3_FrameData[10] Tile_X0Y3_FrameData[11] Tile_X0Y3_FrameData[12] Tile_X0Y3_FrameData[13]
+ Tile_X0Y3_FrameData[14] Tile_X0Y3_FrameData[15] Tile_X0Y3_FrameData[16] Tile_X0Y3_FrameData[17]
+ Tile_X0Y3_FrameData[18] Tile_X0Y3_FrameData[19] Tile_X0Y3_FrameData[1] Tile_X0Y3_FrameData[20]
+ Tile_X0Y3_FrameData[21] Tile_X0Y3_FrameData[22] Tile_X0Y3_FrameData[23] Tile_X0Y3_FrameData[24]
+ Tile_X0Y3_FrameData[25] Tile_X0Y3_FrameData[26] Tile_X0Y3_FrameData[27] Tile_X0Y3_FrameData[28]
+ Tile_X0Y3_FrameData[29] Tile_X0Y3_FrameData[2] Tile_X0Y3_FrameData[30] Tile_X0Y3_FrameData[31]
+ Tile_X0Y3_FrameData[3] Tile_X0Y3_FrameData[4] Tile_X0Y3_FrameData[5] Tile_X0Y3_FrameData[6]
+ Tile_X0Y3_FrameData[7] Tile_X0Y3_FrameData[8] Tile_X0Y3_FrameData[9] Tile_X0Y3_FrameData_O[0]
+ Tile_X0Y3_FrameData_O[10] Tile_X0Y3_FrameData_O[11] Tile_X0Y3_FrameData_O[12] Tile_X0Y3_FrameData_O[13]
+ Tile_X0Y3_FrameData_O[14] Tile_X0Y3_FrameData_O[15] Tile_X0Y3_FrameData_O[16] Tile_X0Y3_FrameData_O[17]
+ Tile_X0Y3_FrameData_O[18] Tile_X0Y3_FrameData_O[19] Tile_X0Y3_FrameData_O[1] Tile_X0Y3_FrameData_O[20]
+ Tile_X0Y3_FrameData_O[21] Tile_X0Y3_FrameData_O[22] Tile_X0Y3_FrameData_O[23] Tile_X0Y3_FrameData_O[24]
+ Tile_X0Y3_FrameData_O[25] Tile_X0Y3_FrameData_O[26] Tile_X0Y3_FrameData_O[27] Tile_X0Y3_FrameData_O[28]
+ Tile_X0Y3_FrameData_O[29] Tile_X0Y3_FrameData_O[2] Tile_X0Y3_FrameData_O[30] Tile_X0Y3_FrameData_O[31]
+ Tile_X0Y3_FrameData_O[3] Tile_X0Y3_FrameData_O[4] Tile_X0Y3_FrameData_O[5] Tile_X0Y3_FrameData_O[6]
+ Tile_X0Y3_FrameData_O[7] Tile_X0Y3_FrameData_O[8] Tile_X0Y3_FrameData_O[9] Tile_X0Y3_UserCLK
+ Tile_X0Y3_UserCLKo Tile_X0Y3_W1END[0] Tile_X0Y3_W1END[1] Tile_X0Y3_W1END[2] Tile_X0Y3_W1END[3]
+ Tile_X0Y3_W2END[0] Tile_X0Y3_W2END[1] Tile_X0Y3_W2END[2] Tile_X0Y3_W2END[3] Tile_X0Y3_W2END[4]
+ Tile_X0Y3_W2END[5] Tile_X0Y3_W2END[6] Tile_X0Y3_W2END[7] Tile_X0Y3_W2MID[0] Tile_X0Y3_W2MID[1]
+ Tile_X0Y3_W2MID[2] Tile_X0Y3_W2MID[3] Tile_X0Y3_W2MID[4] Tile_X0Y3_W2MID[5] Tile_X0Y3_W2MID[6]
+ Tile_X0Y3_W2MID[7] Tile_X0Y3_W6END[0] Tile_X0Y3_W6END[10] Tile_X0Y3_W6END[11] Tile_X0Y3_W6END[1]
+ Tile_X0Y3_W6END[2] Tile_X0Y3_W6END[3] Tile_X0Y3_W6END[4] Tile_X0Y3_W6END[5] Tile_X0Y3_W6END[6]
+ Tile_X0Y3_W6END[7] Tile_X0Y3_W6END[8] Tile_X0Y3_W6END[9] Tile_X0Y3_WW4END[0] Tile_X0Y3_WW4END[10]
+ Tile_X0Y3_WW4END[11] Tile_X0Y3_WW4END[12] Tile_X0Y3_WW4END[13] Tile_X0Y3_WW4END[14]
+ Tile_X0Y3_WW4END[15] Tile_X0Y3_WW4END[1] Tile_X0Y3_WW4END[2] Tile_X0Y3_WW4END[3]
+ Tile_X0Y3_WW4END[4] Tile_X0Y3_WW4END[5] Tile_X0Y3_WW4END[6] Tile_X0Y3_WW4END[7]
+ Tile_X0Y3_WW4END[8] Tile_X0Y3_WW4END[9] Tile_X0Y4_E1BEG[0] Tile_X0Y4_E1BEG[1] Tile_X0Y4_E1BEG[2]
+ Tile_X0Y4_E1BEG[3] Tile_X0Y4_E2BEG[0] Tile_X0Y4_E2BEG[1] Tile_X0Y4_E2BEG[2] Tile_X0Y4_E2BEG[3]
+ Tile_X0Y4_E2BEG[4] Tile_X0Y4_E2BEG[5] Tile_X0Y4_E2BEG[6] Tile_X0Y4_E2BEG[7] Tile_X0Y4_E2BEGb[0]
+ Tile_X0Y4_E2BEGb[1] Tile_X0Y4_E2BEGb[2] Tile_X0Y4_E2BEGb[3] Tile_X0Y4_E2BEGb[4]
+ Tile_X0Y4_E2BEGb[5] Tile_X0Y4_E2BEGb[6] Tile_X0Y4_E2BEGb[7] Tile_X0Y4_E6BEG[0] Tile_X0Y4_E6BEG[10]
+ Tile_X0Y4_E6BEG[11] Tile_X0Y4_E6BEG[1] Tile_X0Y4_E6BEG[2] Tile_X0Y4_E6BEG[3] Tile_X0Y4_E6BEG[4]
+ Tile_X0Y4_E6BEG[5] Tile_X0Y4_E6BEG[6] Tile_X0Y4_E6BEG[7] Tile_X0Y4_E6BEG[8] Tile_X0Y4_E6BEG[9]
+ Tile_X0Y4_EE4BEG[0] Tile_X0Y4_EE4BEG[10] Tile_X0Y4_EE4BEG[11] Tile_X0Y4_EE4BEG[12]
+ Tile_X0Y4_EE4BEG[13] Tile_X0Y4_EE4BEG[14] Tile_X0Y4_EE4BEG[15] Tile_X0Y4_EE4BEG[1]
+ Tile_X0Y4_EE4BEG[2] Tile_X0Y4_EE4BEG[3] Tile_X0Y4_EE4BEG[4] Tile_X0Y4_EE4BEG[5]
+ Tile_X0Y4_EE4BEG[6] Tile_X0Y4_EE4BEG[7] Tile_X0Y4_EE4BEG[8] Tile_X0Y4_EE4BEG[9]
+ Tile_X0Y4_FrameData[0] Tile_X0Y4_FrameData[10] Tile_X0Y4_FrameData[11] Tile_X0Y4_FrameData[12]
+ Tile_X0Y4_FrameData[13] Tile_X0Y4_FrameData[14] Tile_X0Y4_FrameData[15] Tile_X0Y4_FrameData[16]
+ Tile_X0Y4_FrameData[17] Tile_X0Y4_FrameData[18] Tile_X0Y4_FrameData[19] Tile_X0Y4_FrameData[1]
+ Tile_X0Y4_FrameData[20] Tile_X0Y4_FrameData[21] Tile_X0Y4_FrameData[22] Tile_X0Y4_FrameData[23]
+ Tile_X0Y4_FrameData[24] Tile_X0Y4_FrameData[25] Tile_X0Y4_FrameData[26] Tile_X0Y4_FrameData[27]
+ Tile_X0Y4_FrameData[28] Tile_X0Y4_FrameData[29] Tile_X0Y4_FrameData[2] Tile_X0Y4_FrameData[30]
+ Tile_X0Y4_FrameData[31] Tile_X0Y4_FrameData[3] Tile_X0Y4_FrameData[4] Tile_X0Y4_FrameData[5]
+ Tile_X0Y4_FrameData[6] Tile_X0Y4_FrameData[7] Tile_X0Y4_FrameData[8] Tile_X0Y4_FrameData[9]
+ Tile_X0Y4_FrameData_O[0] Tile_X0Y4_FrameData_O[10] Tile_X0Y4_FrameData_O[11] Tile_X0Y4_FrameData_O[12]
+ Tile_X0Y4_FrameData_O[13] Tile_X0Y4_FrameData_O[14] Tile_X0Y4_FrameData_O[15] Tile_X0Y4_FrameData_O[16]
+ Tile_X0Y4_FrameData_O[17] Tile_X0Y4_FrameData_O[18] Tile_X0Y4_FrameData_O[19] Tile_X0Y4_FrameData_O[1]
+ Tile_X0Y4_FrameData_O[20] Tile_X0Y4_FrameData_O[21] Tile_X0Y4_FrameData_O[22] Tile_X0Y4_FrameData_O[23]
+ Tile_X0Y4_FrameData_O[24] Tile_X0Y4_FrameData_O[25] Tile_X0Y4_FrameData_O[26] Tile_X0Y4_FrameData_O[27]
+ Tile_X0Y4_FrameData_O[28] Tile_X0Y4_FrameData_O[29] Tile_X0Y4_FrameData_O[2] Tile_X0Y4_FrameData_O[30]
+ Tile_X0Y4_FrameData_O[31] Tile_X0Y4_FrameData_O[3] Tile_X0Y4_FrameData_O[4] Tile_X0Y4_FrameData_O[5]
+ Tile_X0Y4_FrameData_O[6] Tile_X0Y4_FrameData_O[7] Tile_X0Y4_FrameData_O[8] Tile_X0Y4_FrameData_O[9]
+ Tile_X0Y4_UserCLK Tile_X0Y4_UserCLKo Tile_X0Y4_W1END[0] Tile_X0Y4_W1END[1] Tile_X0Y4_W1END[2]
+ Tile_X0Y4_W1END[3] Tile_X0Y4_W2END[0] Tile_X0Y4_W2END[1] Tile_X0Y4_W2END[2] Tile_X0Y4_W2END[3]
+ Tile_X0Y4_W2END[4] Tile_X0Y4_W2END[5] Tile_X0Y4_W2END[6] Tile_X0Y4_W2END[7] Tile_X0Y4_W2MID[0]
+ Tile_X0Y4_W2MID[1] Tile_X0Y4_W2MID[2] Tile_X0Y4_W2MID[3] Tile_X0Y4_W2MID[4] Tile_X0Y4_W2MID[5]
+ Tile_X0Y4_W2MID[6] Tile_X0Y4_W2MID[7] Tile_X0Y4_W6END[0] Tile_X0Y4_W6END[10] Tile_X0Y4_W6END[11]
+ Tile_X0Y4_W6END[1] Tile_X0Y4_W6END[2] Tile_X0Y4_W6END[3] Tile_X0Y4_W6END[4] Tile_X0Y4_W6END[5]
+ Tile_X0Y4_W6END[6] Tile_X0Y4_W6END[7] Tile_X0Y4_W6END[8] Tile_X0Y4_W6END[9] Tile_X0Y4_WW4END[0]
+ Tile_X0Y4_WW4END[10] Tile_X0Y4_WW4END[11] Tile_X0Y4_WW4END[12] Tile_X0Y4_WW4END[13]
+ Tile_X0Y4_WW4END[14] Tile_X0Y4_WW4END[15] Tile_X0Y4_WW4END[1] Tile_X0Y4_WW4END[2]
+ Tile_X0Y4_WW4END[3] Tile_X0Y4_WW4END[4] Tile_X0Y4_WW4END[5] Tile_X0Y4_WW4END[6]
+ Tile_X0Y4_WW4END[7] Tile_X0Y4_WW4END[8] Tile_X0Y4_WW4END[9] Tile_X0Y5_E1BEG[0] Tile_X0Y5_E1BEG[1]
+ Tile_X0Y5_E1BEG[2] Tile_X0Y5_E1BEG[3] Tile_X0Y5_E2BEG[0] Tile_X0Y5_E2BEG[1] Tile_X0Y5_E2BEG[2]
+ Tile_X0Y5_E2BEG[3] Tile_X0Y5_E2BEG[4] Tile_X0Y5_E2BEG[5] Tile_X0Y5_E2BEG[6] Tile_X0Y5_E2BEG[7]
+ Tile_X0Y5_E2BEGb[0] Tile_X0Y5_E2BEGb[1] Tile_X0Y5_E2BEGb[2] Tile_X0Y5_E2BEGb[3]
+ Tile_X0Y5_E2BEGb[4] Tile_X0Y5_E2BEGb[5] Tile_X0Y5_E2BEGb[6] Tile_X0Y5_E2BEGb[7]
+ Tile_X0Y5_E6BEG[0] Tile_X0Y5_E6BEG[10] Tile_X0Y5_E6BEG[11] Tile_X0Y5_E6BEG[1] Tile_X0Y5_E6BEG[2]
+ Tile_X0Y5_E6BEG[3] Tile_X0Y5_E6BEG[4] Tile_X0Y5_E6BEG[5] Tile_X0Y5_E6BEG[6] Tile_X0Y5_E6BEG[7]
+ Tile_X0Y5_E6BEG[8] Tile_X0Y5_E6BEG[9] Tile_X0Y5_EE4BEG[0] Tile_X0Y5_EE4BEG[10] Tile_X0Y5_EE4BEG[11]
+ Tile_X0Y5_EE4BEG[12] Tile_X0Y5_EE4BEG[13] Tile_X0Y5_EE4BEG[14] Tile_X0Y5_EE4BEG[15]
+ Tile_X0Y5_EE4BEG[1] Tile_X0Y5_EE4BEG[2] Tile_X0Y5_EE4BEG[3] Tile_X0Y5_EE4BEG[4]
+ Tile_X0Y5_EE4BEG[5] Tile_X0Y5_EE4BEG[6] Tile_X0Y5_EE4BEG[7] Tile_X0Y5_EE4BEG[8]
+ Tile_X0Y5_EE4BEG[9] Tile_X0Y5_FrameData[0] Tile_X0Y5_FrameData[10] Tile_X0Y5_FrameData[11]
+ Tile_X0Y5_FrameData[12] Tile_X0Y5_FrameData[13] Tile_X0Y5_FrameData[14] Tile_X0Y5_FrameData[15]
+ Tile_X0Y5_FrameData[16] Tile_X0Y5_FrameData[17] Tile_X0Y5_FrameData[18] Tile_X0Y5_FrameData[19]
+ Tile_X0Y5_FrameData[1] Tile_X0Y5_FrameData[20] Tile_X0Y5_FrameData[21] Tile_X0Y5_FrameData[22]
+ Tile_X0Y5_FrameData[23] Tile_X0Y5_FrameData[24] Tile_X0Y5_FrameData[25] Tile_X0Y5_FrameData[26]
+ Tile_X0Y5_FrameData[27] Tile_X0Y5_FrameData[28] Tile_X0Y5_FrameData[29] Tile_X0Y5_FrameData[2]
+ Tile_X0Y5_FrameData[30] Tile_X0Y5_FrameData[31] Tile_X0Y5_FrameData[3] Tile_X0Y5_FrameData[4]
+ Tile_X0Y5_FrameData[5] Tile_X0Y5_FrameData[6] Tile_X0Y5_FrameData[7] Tile_X0Y5_FrameData[8]
+ Tile_X0Y5_FrameData[9] Tile_X0Y5_FrameData_O[0] Tile_X0Y5_FrameData_O[10] Tile_X0Y5_FrameData_O[11]
+ Tile_X0Y5_FrameData_O[12] Tile_X0Y5_FrameData_O[13] Tile_X0Y5_FrameData_O[14] Tile_X0Y5_FrameData_O[15]
+ Tile_X0Y5_FrameData_O[16] Tile_X0Y5_FrameData_O[17] Tile_X0Y5_FrameData_O[18] Tile_X0Y5_FrameData_O[19]
+ Tile_X0Y5_FrameData_O[1] Tile_X0Y5_FrameData_O[20] Tile_X0Y5_FrameData_O[21] Tile_X0Y5_FrameData_O[22]
+ Tile_X0Y5_FrameData_O[23] Tile_X0Y5_FrameData_O[24] Tile_X0Y5_FrameData_O[25] Tile_X0Y5_FrameData_O[26]
+ Tile_X0Y5_FrameData_O[27] Tile_X0Y5_FrameData_O[28] Tile_X0Y5_FrameData_O[29] Tile_X0Y5_FrameData_O[2]
+ Tile_X0Y5_FrameData_O[30] Tile_X0Y5_FrameData_O[31] Tile_X0Y5_FrameData_O[3] Tile_X0Y5_FrameData_O[4]
+ Tile_X0Y5_FrameData_O[5] Tile_X0Y5_FrameData_O[6] Tile_X0Y5_FrameData_O[7] Tile_X0Y5_FrameData_O[8]
+ Tile_X0Y5_FrameData_O[9] Tile_X0Y5_UserCLK Tile_X0Y5_UserCLKo Tile_X0Y5_W1END[0]
+ Tile_X0Y5_W1END[1] Tile_X0Y5_W1END[2] Tile_X0Y5_W1END[3] Tile_X0Y5_W2END[0] Tile_X0Y5_W2END[1]
+ Tile_X0Y5_W2END[2] Tile_X0Y5_W2END[3] Tile_X0Y5_W2END[4] Tile_X0Y5_W2END[5] Tile_X0Y5_W2END[6]
+ Tile_X0Y5_W2END[7] Tile_X0Y5_W2MID[0] Tile_X0Y5_W2MID[1] Tile_X0Y5_W2MID[2] Tile_X0Y5_W2MID[3]
+ Tile_X0Y5_W2MID[4] Tile_X0Y5_W2MID[5] Tile_X0Y5_W2MID[6] Tile_X0Y5_W2MID[7] Tile_X0Y5_W6END[0]
+ Tile_X0Y5_W6END[10] Tile_X0Y5_W6END[11] Tile_X0Y5_W6END[1] Tile_X0Y5_W6END[2] Tile_X0Y5_W6END[3]
+ Tile_X0Y5_W6END[4] Tile_X0Y5_W6END[5] Tile_X0Y5_W6END[6] Tile_X0Y5_W6END[7] Tile_X0Y5_W6END[8]
+ Tile_X0Y5_W6END[9] Tile_X0Y5_WW4END[0] Tile_X0Y5_WW4END[10] Tile_X0Y5_WW4END[11]
+ Tile_X0Y5_WW4END[12] Tile_X0Y5_WW4END[13] Tile_X0Y5_WW4END[14] Tile_X0Y5_WW4END[15]
+ Tile_X0Y5_WW4END[1] Tile_X0Y5_WW4END[2] Tile_X0Y5_WW4END[3] Tile_X0Y5_WW4END[4]
+ Tile_X0Y5_WW4END[5] Tile_X0Y5_WW4END[6] Tile_X0Y5_WW4END[7] Tile_X0Y5_WW4END[8]
+ Tile_X0Y5_WW4END[9] Tile_X0Y6_E1BEG[0] Tile_X0Y6_E1BEG[1] Tile_X0Y6_E1BEG[2] Tile_X0Y6_E1BEG[3]
+ Tile_X0Y6_E2BEG[0] Tile_X0Y6_E2BEG[1] Tile_X0Y6_E2BEG[2] Tile_X0Y6_E2BEG[3] Tile_X0Y6_E2BEG[4]
+ Tile_X0Y6_E2BEG[5] Tile_X0Y6_E2BEG[6] Tile_X0Y6_E2BEG[7] Tile_X0Y6_E2BEGb[0] Tile_X0Y6_E2BEGb[1]
+ Tile_X0Y6_E2BEGb[2] Tile_X0Y6_E2BEGb[3] Tile_X0Y6_E2BEGb[4] Tile_X0Y6_E2BEGb[5]
+ Tile_X0Y6_E2BEGb[6] Tile_X0Y6_E2BEGb[7] Tile_X0Y6_E6BEG[0] Tile_X0Y6_E6BEG[10] Tile_X0Y6_E6BEG[11]
+ Tile_X0Y6_E6BEG[1] Tile_X0Y6_E6BEG[2] Tile_X0Y6_E6BEG[3] Tile_X0Y6_E6BEG[4] Tile_X0Y6_E6BEG[5]
+ Tile_X0Y6_E6BEG[6] Tile_X0Y6_E6BEG[7] Tile_X0Y6_E6BEG[8] Tile_X0Y6_E6BEG[9] Tile_X0Y6_EE4BEG[0]
+ Tile_X0Y6_EE4BEG[10] Tile_X0Y6_EE4BEG[11] Tile_X0Y6_EE4BEG[12] Tile_X0Y6_EE4BEG[13]
+ Tile_X0Y6_EE4BEG[14] Tile_X0Y6_EE4BEG[15] Tile_X0Y6_EE4BEG[1] Tile_X0Y6_EE4BEG[2]
+ Tile_X0Y6_EE4BEG[3] Tile_X0Y6_EE4BEG[4] Tile_X0Y6_EE4BEG[5] Tile_X0Y6_EE4BEG[6]
+ Tile_X0Y6_EE4BEG[7] Tile_X0Y6_EE4BEG[8] Tile_X0Y6_EE4BEG[9] Tile_X0Y6_FrameData[0]
+ Tile_X0Y6_FrameData[10] Tile_X0Y6_FrameData[11] Tile_X0Y6_FrameData[12] Tile_X0Y6_FrameData[13]
+ Tile_X0Y6_FrameData[14] Tile_X0Y6_FrameData[15] Tile_X0Y6_FrameData[16] Tile_X0Y6_FrameData[17]
+ Tile_X0Y6_FrameData[18] Tile_X0Y6_FrameData[19] Tile_X0Y6_FrameData[1] Tile_X0Y6_FrameData[20]
+ Tile_X0Y6_FrameData[21] Tile_X0Y6_FrameData[22] Tile_X0Y6_FrameData[23] Tile_X0Y6_FrameData[24]
+ Tile_X0Y6_FrameData[25] Tile_X0Y6_FrameData[26] Tile_X0Y6_FrameData[27] Tile_X0Y6_FrameData[28]
+ Tile_X0Y6_FrameData[29] Tile_X0Y6_FrameData[2] Tile_X0Y6_FrameData[30] Tile_X0Y6_FrameData[31]
+ Tile_X0Y6_FrameData[3] Tile_X0Y6_FrameData[4] Tile_X0Y6_FrameData[5] Tile_X0Y6_FrameData[6]
+ Tile_X0Y6_FrameData[7] Tile_X0Y6_FrameData[8] Tile_X0Y6_FrameData[9] Tile_X0Y6_FrameData_O[0]
+ Tile_X0Y6_FrameData_O[10] Tile_X0Y6_FrameData_O[11] Tile_X0Y6_FrameData_O[12] Tile_X0Y6_FrameData_O[13]
+ Tile_X0Y6_FrameData_O[14] Tile_X0Y6_FrameData_O[15] Tile_X0Y6_FrameData_O[16] Tile_X0Y6_FrameData_O[17]
+ Tile_X0Y6_FrameData_O[18] Tile_X0Y6_FrameData_O[19] Tile_X0Y6_FrameData_O[1] Tile_X0Y6_FrameData_O[20]
+ Tile_X0Y6_FrameData_O[21] Tile_X0Y6_FrameData_O[22] Tile_X0Y6_FrameData_O[23] Tile_X0Y6_FrameData_O[24]
+ Tile_X0Y6_FrameData_O[25] Tile_X0Y6_FrameData_O[26] Tile_X0Y6_FrameData_O[27] Tile_X0Y6_FrameData_O[28]
+ Tile_X0Y6_FrameData_O[29] Tile_X0Y6_FrameData_O[2] Tile_X0Y6_FrameData_O[30] Tile_X0Y6_FrameData_O[31]
+ Tile_X0Y6_FrameData_O[3] Tile_X0Y6_FrameData_O[4] Tile_X0Y6_FrameData_O[5] Tile_X0Y6_FrameData_O[6]
+ Tile_X0Y6_FrameData_O[7] Tile_X0Y6_FrameData_O[8] Tile_X0Y6_FrameData_O[9] Tile_X0Y6_UserCLK
+ Tile_X0Y6_UserCLKo Tile_X0Y6_W1END[0] Tile_X0Y6_W1END[1] Tile_X0Y6_W1END[2] Tile_X0Y6_W1END[3]
+ Tile_X0Y6_W2END[0] Tile_X0Y6_W2END[1] Tile_X0Y6_W2END[2] Tile_X0Y6_W2END[3] Tile_X0Y6_W2END[4]
+ Tile_X0Y6_W2END[5] Tile_X0Y6_W2END[6] Tile_X0Y6_W2END[7] Tile_X0Y6_W2MID[0] Tile_X0Y6_W2MID[1]
+ Tile_X0Y6_W2MID[2] Tile_X0Y6_W2MID[3] Tile_X0Y6_W2MID[4] Tile_X0Y6_W2MID[5] Tile_X0Y6_W2MID[6]
+ Tile_X0Y6_W2MID[7] Tile_X0Y6_W6END[0] Tile_X0Y6_W6END[10] Tile_X0Y6_W6END[11] Tile_X0Y6_W6END[1]
+ Tile_X0Y6_W6END[2] Tile_X0Y6_W6END[3] Tile_X0Y6_W6END[4] Tile_X0Y6_W6END[5] Tile_X0Y6_W6END[6]
+ Tile_X0Y6_W6END[7] Tile_X0Y6_W6END[8] Tile_X0Y6_W6END[9] Tile_X0Y6_WW4END[0] Tile_X0Y6_WW4END[10]
+ Tile_X0Y6_WW4END[11] Tile_X0Y6_WW4END[12] Tile_X0Y6_WW4END[13] Tile_X0Y6_WW4END[14]
+ Tile_X0Y6_WW4END[15] Tile_X0Y6_WW4END[1] Tile_X0Y6_WW4END[2] Tile_X0Y6_WW4END[3]
+ Tile_X0Y6_WW4END[4] Tile_X0Y6_WW4END[5] Tile_X0Y6_WW4END[6] Tile_X0Y6_WW4END[7]
+ Tile_X0Y6_WW4END[8] Tile_X0Y6_WW4END[9] Tile_X0Y7_E1BEG[0] Tile_X0Y7_E1BEG[1] Tile_X0Y7_E1BEG[2]
+ Tile_X0Y7_E1BEG[3] Tile_X0Y7_E2BEG[0] Tile_X0Y7_E2BEG[1] Tile_X0Y7_E2BEG[2] Tile_X0Y7_E2BEG[3]
+ Tile_X0Y7_E2BEG[4] Tile_X0Y7_E2BEG[5] Tile_X0Y7_E2BEG[6] Tile_X0Y7_E2BEG[7] Tile_X0Y7_E2BEGb[0]
+ Tile_X0Y7_E2BEGb[1] Tile_X0Y7_E2BEGb[2] Tile_X0Y7_E2BEGb[3] Tile_X0Y7_E2BEGb[4]
+ Tile_X0Y7_E2BEGb[5] Tile_X0Y7_E2BEGb[6] Tile_X0Y7_E2BEGb[7] Tile_X0Y7_E6BEG[0] Tile_X0Y7_E6BEG[10]
+ Tile_X0Y7_E6BEG[11] Tile_X0Y7_E6BEG[1] Tile_X0Y7_E6BEG[2] Tile_X0Y7_E6BEG[3] Tile_X0Y7_E6BEG[4]
+ Tile_X0Y7_E6BEG[5] Tile_X0Y7_E6BEG[6] Tile_X0Y7_E6BEG[7] Tile_X0Y7_E6BEG[8] Tile_X0Y7_E6BEG[9]
+ Tile_X0Y7_EE4BEG[0] Tile_X0Y7_EE4BEG[10] Tile_X0Y7_EE4BEG[11] Tile_X0Y7_EE4BEG[12]
+ Tile_X0Y7_EE4BEG[13] Tile_X0Y7_EE4BEG[14] Tile_X0Y7_EE4BEG[15] Tile_X0Y7_EE4BEG[1]
+ Tile_X0Y7_EE4BEG[2] Tile_X0Y7_EE4BEG[3] Tile_X0Y7_EE4BEG[4] Tile_X0Y7_EE4BEG[5]
+ Tile_X0Y7_EE4BEG[6] Tile_X0Y7_EE4BEG[7] Tile_X0Y7_EE4BEG[8] Tile_X0Y7_EE4BEG[9]
+ Tile_X0Y7_FrameData[0] Tile_X0Y7_FrameData[10] Tile_X0Y7_FrameData[11] Tile_X0Y7_FrameData[12]
+ Tile_X0Y7_FrameData[13] Tile_X0Y7_FrameData[14] Tile_X0Y7_FrameData[15] Tile_X0Y7_FrameData[16]
+ Tile_X0Y7_FrameData[17] Tile_X0Y7_FrameData[18] Tile_X0Y7_FrameData[19] Tile_X0Y7_FrameData[1]
+ Tile_X0Y7_FrameData[20] Tile_X0Y7_FrameData[21] Tile_X0Y7_FrameData[22] Tile_X0Y7_FrameData[23]
+ Tile_X0Y7_FrameData[24] Tile_X0Y7_FrameData[25] Tile_X0Y7_FrameData[26] Tile_X0Y7_FrameData[27]
+ Tile_X0Y7_FrameData[28] Tile_X0Y7_FrameData[29] Tile_X0Y7_FrameData[2] Tile_X0Y7_FrameData[30]
+ Tile_X0Y7_FrameData[31] Tile_X0Y7_FrameData[3] Tile_X0Y7_FrameData[4] Tile_X0Y7_FrameData[5]
+ Tile_X0Y7_FrameData[6] Tile_X0Y7_FrameData[7] Tile_X0Y7_FrameData[8] Tile_X0Y7_FrameData[9]
+ Tile_X0Y7_FrameData_O[0] Tile_X0Y7_FrameData_O[10] Tile_X0Y7_FrameData_O[11] Tile_X0Y7_FrameData_O[12]
+ Tile_X0Y7_FrameData_O[13] Tile_X0Y7_FrameData_O[14] Tile_X0Y7_FrameData_O[15] Tile_X0Y7_FrameData_O[16]
+ Tile_X0Y7_FrameData_O[17] Tile_X0Y7_FrameData_O[18] Tile_X0Y7_FrameData_O[19] Tile_X0Y7_FrameData_O[1]
+ Tile_X0Y7_FrameData_O[20] Tile_X0Y7_FrameData_O[21] Tile_X0Y7_FrameData_O[22] Tile_X0Y7_FrameData_O[23]
+ Tile_X0Y7_FrameData_O[24] Tile_X0Y7_FrameData_O[25] Tile_X0Y7_FrameData_O[26] Tile_X0Y7_FrameData_O[27]
+ Tile_X0Y7_FrameData_O[28] Tile_X0Y7_FrameData_O[29] Tile_X0Y7_FrameData_O[2] Tile_X0Y7_FrameData_O[30]
+ Tile_X0Y7_FrameData_O[31] Tile_X0Y7_FrameData_O[3] Tile_X0Y7_FrameData_O[4] Tile_X0Y7_FrameData_O[5]
+ Tile_X0Y7_FrameData_O[6] Tile_X0Y7_FrameData_O[7] Tile_X0Y7_FrameData_O[8] Tile_X0Y7_FrameData_O[9]
+ Tile_X0Y7_UserCLK Tile_X0Y7_UserCLKo Tile_X0Y7_W1END[0] Tile_X0Y7_W1END[1] Tile_X0Y7_W1END[2]
+ Tile_X0Y7_W1END[3] Tile_X0Y7_W2END[0] Tile_X0Y7_W2END[1] Tile_X0Y7_W2END[2] Tile_X0Y7_W2END[3]
+ Tile_X0Y7_W2END[4] Tile_X0Y7_W2END[5] Tile_X0Y7_W2END[6] Tile_X0Y7_W2END[7] Tile_X0Y7_W2MID[0]
+ Tile_X0Y7_W2MID[1] Tile_X0Y7_W2MID[2] Tile_X0Y7_W2MID[3] Tile_X0Y7_W2MID[4] Tile_X0Y7_W2MID[5]
+ Tile_X0Y7_W2MID[6] Tile_X0Y7_W2MID[7] Tile_X0Y7_W6END[0] Tile_X0Y7_W6END[10] Tile_X0Y7_W6END[11]
+ Tile_X0Y7_W6END[1] Tile_X0Y7_W6END[2] Tile_X0Y7_W6END[3] Tile_X0Y7_W6END[4] Tile_X0Y7_W6END[5]
+ Tile_X0Y7_W6END[6] Tile_X0Y7_W6END[7] Tile_X0Y7_W6END[8] Tile_X0Y7_W6END[9] Tile_X0Y7_WW4END[0]
+ Tile_X0Y7_WW4END[10] Tile_X0Y7_WW4END[11] Tile_X0Y7_WW4END[12] Tile_X0Y7_WW4END[13]
+ Tile_X0Y7_WW4END[14] Tile_X0Y7_WW4END[15] Tile_X0Y7_WW4END[1] Tile_X0Y7_WW4END[2]
+ Tile_X0Y7_WW4END[3] Tile_X0Y7_WW4END[4] Tile_X0Y7_WW4END[5] Tile_X0Y7_WW4END[6]
+ Tile_X0Y7_WW4END[7] Tile_X0Y7_WW4END[8] Tile_X0Y7_WW4END[9] Tile_X0Y8_E1BEG[0] Tile_X0Y8_E1BEG[1]
+ Tile_X0Y8_E1BEG[2] Tile_X0Y8_E1BEG[3] Tile_X0Y8_E2BEG[0] Tile_X0Y8_E2BEG[1] Tile_X0Y8_E2BEG[2]
+ Tile_X0Y8_E2BEG[3] Tile_X0Y8_E2BEG[4] Tile_X0Y8_E2BEG[5] Tile_X0Y8_E2BEG[6] Tile_X0Y8_E2BEG[7]
+ Tile_X0Y8_E2BEGb[0] Tile_X0Y8_E2BEGb[1] Tile_X0Y8_E2BEGb[2] Tile_X0Y8_E2BEGb[3]
+ Tile_X0Y8_E2BEGb[4] Tile_X0Y8_E2BEGb[5] Tile_X0Y8_E2BEGb[6] Tile_X0Y8_E2BEGb[7]
+ Tile_X0Y8_E6BEG[0] Tile_X0Y8_E6BEG[10] Tile_X0Y8_E6BEG[11] Tile_X0Y8_E6BEG[1] Tile_X0Y8_E6BEG[2]
+ Tile_X0Y8_E6BEG[3] Tile_X0Y8_E6BEG[4] Tile_X0Y8_E6BEG[5] Tile_X0Y8_E6BEG[6] Tile_X0Y8_E6BEG[7]
+ Tile_X0Y8_E6BEG[8] Tile_X0Y8_E6BEG[9] Tile_X0Y8_EE4BEG[0] Tile_X0Y8_EE4BEG[10] Tile_X0Y8_EE4BEG[11]
+ Tile_X0Y8_EE4BEG[12] Tile_X0Y8_EE4BEG[13] Tile_X0Y8_EE4BEG[14] Tile_X0Y8_EE4BEG[15]
+ Tile_X0Y8_EE4BEG[1] Tile_X0Y8_EE4BEG[2] Tile_X0Y8_EE4BEG[3] Tile_X0Y8_EE4BEG[4]
+ Tile_X0Y8_EE4BEG[5] Tile_X0Y8_EE4BEG[6] Tile_X0Y8_EE4BEG[7] Tile_X0Y8_EE4BEG[8]
+ Tile_X0Y8_EE4BEG[9] Tile_X0Y8_FrameData[0] Tile_X0Y8_FrameData[10] Tile_X0Y8_FrameData[11]
+ Tile_X0Y8_FrameData[12] Tile_X0Y8_FrameData[13] Tile_X0Y8_FrameData[14] Tile_X0Y8_FrameData[15]
+ Tile_X0Y8_FrameData[16] Tile_X0Y8_FrameData[17] Tile_X0Y8_FrameData[18] Tile_X0Y8_FrameData[19]
+ Tile_X0Y8_FrameData[1] Tile_X0Y8_FrameData[20] Tile_X0Y8_FrameData[21] Tile_X0Y8_FrameData[22]
+ Tile_X0Y8_FrameData[23] Tile_X0Y8_FrameData[24] Tile_X0Y8_FrameData[25] Tile_X0Y8_FrameData[26]
+ Tile_X0Y8_FrameData[27] Tile_X0Y8_FrameData[28] Tile_X0Y8_FrameData[29] Tile_X0Y8_FrameData[2]
+ Tile_X0Y8_FrameData[30] Tile_X0Y8_FrameData[31] Tile_X0Y8_FrameData[3] Tile_X0Y8_FrameData[4]
+ Tile_X0Y8_FrameData[5] Tile_X0Y8_FrameData[6] Tile_X0Y8_FrameData[7] Tile_X0Y8_FrameData[8]
+ Tile_X0Y8_FrameData[9] Tile_X0Y8_FrameData_O[0] Tile_X0Y8_FrameData_O[10] Tile_X0Y8_FrameData_O[11]
+ Tile_X0Y8_FrameData_O[12] Tile_X0Y8_FrameData_O[13] Tile_X0Y8_FrameData_O[14] Tile_X0Y8_FrameData_O[15]
+ Tile_X0Y8_FrameData_O[16] Tile_X0Y8_FrameData_O[17] Tile_X0Y8_FrameData_O[18] Tile_X0Y8_FrameData_O[19]
+ Tile_X0Y8_FrameData_O[1] Tile_X0Y8_FrameData_O[20] Tile_X0Y8_FrameData_O[21] Tile_X0Y8_FrameData_O[22]
+ Tile_X0Y8_FrameData_O[23] Tile_X0Y8_FrameData_O[24] Tile_X0Y8_FrameData_O[25] Tile_X0Y8_FrameData_O[26]
+ Tile_X0Y8_FrameData_O[27] Tile_X0Y8_FrameData_O[28] Tile_X0Y8_FrameData_O[29] Tile_X0Y8_FrameData_O[2]
+ Tile_X0Y8_FrameData_O[30] Tile_X0Y8_FrameData_O[31] Tile_X0Y8_FrameData_O[3] Tile_X0Y8_FrameData_O[4]
+ Tile_X0Y8_FrameData_O[5] Tile_X0Y8_FrameData_O[6] Tile_X0Y8_FrameData_O[7] Tile_X0Y8_FrameData_O[8]
+ Tile_X0Y8_FrameData_O[9] Tile_X0Y8_UserCLK Tile_X0Y8_UserCLKo Tile_X0Y8_W1END[0]
+ Tile_X0Y8_W1END[1] Tile_X0Y8_W1END[2] Tile_X0Y8_W1END[3] Tile_X0Y8_W2END[0] Tile_X0Y8_W2END[1]
+ Tile_X0Y8_W2END[2] Tile_X0Y8_W2END[3] Tile_X0Y8_W2END[4] Tile_X0Y8_W2END[5] Tile_X0Y8_W2END[6]
+ Tile_X0Y8_W2END[7] Tile_X0Y8_W2MID[0] Tile_X0Y8_W2MID[1] Tile_X0Y8_W2MID[2] Tile_X0Y8_W2MID[3]
+ Tile_X0Y8_W2MID[4] Tile_X0Y8_W2MID[5] Tile_X0Y8_W2MID[6] Tile_X0Y8_W2MID[7] Tile_X0Y8_W6END[0]
+ Tile_X0Y8_W6END[10] Tile_X0Y8_W6END[11] Tile_X0Y8_W6END[1] Tile_X0Y8_W6END[2] Tile_X0Y8_W6END[3]
+ Tile_X0Y8_W6END[4] Tile_X0Y8_W6END[5] Tile_X0Y8_W6END[6] Tile_X0Y8_W6END[7] Tile_X0Y8_W6END[8]
+ Tile_X0Y8_W6END[9] Tile_X0Y8_WW4END[0] Tile_X0Y8_WW4END[10] Tile_X0Y8_WW4END[11]
+ Tile_X0Y8_WW4END[12] Tile_X0Y8_WW4END[13] Tile_X0Y8_WW4END[14] Tile_X0Y8_WW4END[15]
+ Tile_X0Y8_WW4END[1] Tile_X0Y8_WW4END[2] Tile_X0Y8_WW4END[3] Tile_X0Y8_WW4END[4]
+ Tile_X0Y8_WW4END[5] Tile_X0Y8_WW4END[6] Tile_X0Y8_WW4END[7] Tile_X0Y8_WW4END[8]
+ Tile_X0Y8_WW4END[9] Tile_X0Y9_E1BEG[0] Tile_X0Y9_E1BEG[1] Tile_X0Y9_E1BEG[2] Tile_X0Y9_E1BEG[3]
+ Tile_X0Y9_E2BEG[0] Tile_X0Y9_E2BEG[1] Tile_X0Y9_E2BEG[2] Tile_X0Y9_E2BEG[3] Tile_X0Y9_E2BEG[4]
+ Tile_X0Y9_E2BEG[5] Tile_X0Y9_E2BEG[6] Tile_X0Y9_E2BEG[7] Tile_X0Y9_E2BEGb[0] Tile_X0Y9_E2BEGb[1]
+ Tile_X0Y9_E2BEGb[2] Tile_X0Y9_E2BEGb[3] Tile_X0Y9_E2BEGb[4] Tile_X0Y9_E2BEGb[5]
+ Tile_X0Y9_E2BEGb[6] Tile_X0Y9_E2BEGb[7] Tile_X0Y9_E6BEG[0] Tile_X0Y9_E6BEG[10] Tile_X0Y9_E6BEG[11]
+ Tile_X0Y9_E6BEG[1] Tile_X0Y9_E6BEG[2] Tile_X0Y9_E6BEG[3] Tile_X0Y9_E6BEG[4] Tile_X0Y9_E6BEG[5]
+ Tile_X0Y9_E6BEG[6] Tile_X0Y9_E6BEG[7] Tile_X0Y9_E6BEG[8] Tile_X0Y9_E6BEG[9] Tile_X0Y9_EE4BEG[0]
+ Tile_X0Y9_EE4BEG[10] Tile_X0Y9_EE4BEG[11] Tile_X0Y9_EE4BEG[12] Tile_X0Y9_EE4BEG[13]
+ Tile_X0Y9_EE4BEG[14] Tile_X0Y9_EE4BEG[15] Tile_X0Y9_EE4BEG[1] Tile_X0Y9_EE4BEG[2]
+ Tile_X0Y9_EE4BEG[3] Tile_X0Y9_EE4BEG[4] Tile_X0Y9_EE4BEG[5] Tile_X0Y9_EE4BEG[6]
+ Tile_X0Y9_EE4BEG[7] Tile_X0Y9_EE4BEG[8] Tile_X0Y9_EE4BEG[9] Tile_X0Y9_FrameData[0]
+ Tile_X0Y9_FrameData[10] Tile_X0Y9_FrameData[11] Tile_X0Y9_FrameData[12] Tile_X0Y9_FrameData[13]
+ Tile_X0Y9_FrameData[14] Tile_X0Y9_FrameData[15] Tile_X0Y9_FrameData[16] Tile_X0Y9_FrameData[17]
+ Tile_X0Y9_FrameData[18] Tile_X0Y9_FrameData[19] Tile_X0Y9_FrameData[1] Tile_X0Y9_FrameData[20]
+ Tile_X0Y9_FrameData[21] Tile_X0Y9_FrameData[22] Tile_X0Y9_FrameData[23] Tile_X0Y9_FrameData[24]
+ Tile_X0Y9_FrameData[25] Tile_X0Y9_FrameData[26] Tile_X0Y9_FrameData[27] Tile_X0Y9_FrameData[28]
+ Tile_X0Y9_FrameData[29] Tile_X0Y9_FrameData[2] Tile_X0Y9_FrameData[30] Tile_X0Y9_FrameData[31]
+ Tile_X0Y9_FrameData[3] Tile_X0Y9_FrameData[4] Tile_X0Y9_FrameData[5] Tile_X0Y9_FrameData[6]
+ Tile_X0Y9_FrameData[7] Tile_X0Y9_FrameData[8] Tile_X0Y9_FrameData[9] Tile_X0Y9_FrameData_O[0]
+ Tile_X0Y9_FrameData_O[10] Tile_X0Y9_FrameData_O[11] Tile_X0Y9_FrameData_O[12] Tile_X0Y9_FrameData_O[13]
+ Tile_X0Y9_FrameData_O[14] Tile_X0Y9_FrameData_O[15] Tile_X0Y9_FrameData_O[16] Tile_X0Y9_FrameData_O[17]
+ Tile_X0Y9_FrameData_O[18] Tile_X0Y9_FrameData_O[19] Tile_X0Y9_FrameData_O[1] Tile_X0Y9_FrameData_O[20]
+ Tile_X0Y9_FrameData_O[21] Tile_X0Y9_FrameData_O[22] Tile_X0Y9_FrameData_O[23] Tile_X0Y9_FrameData_O[24]
+ Tile_X0Y9_FrameData_O[25] Tile_X0Y9_FrameData_O[26] Tile_X0Y9_FrameData_O[27] Tile_X0Y9_FrameData_O[28]
+ Tile_X0Y9_FrameData_O[29] Tile_X0Y9_FrameData_O[2] Tile_X0Y9_FrameData_O[30] Tile_X0Y9_FrameData_O[31]
+ Tile_X0Y9_FrameData_O[3] Tile_X0Y9_FrameData_O[4] Tile_X0Y9_FrameData_O[5] Tile_X0Y9_FrameData_O[6]
+ Tile_X0Y9_FrameData_O[7] Tile_X0Y9_FrameData_O[8] Tile_X0Y9_FrameData_O[9] Tile_X0Y9_FrameStrobe[0]
+ Tile_X0Y9_FrameStrobe[10] Tile_X0Y9_FrameStrobe[11] Tile_X0Y9_FrameStrobe[12] Tile_X0Y9_FrameStrobe[13]
+ Tile_X0Y9_FrameStrobe[14] Tile_X0Y9_FrameStrobe[15] Tile_X0Y9_FrameStrobe[16] Tile_X0Y9_FrameStrobe[17]
+ Tile_X0Y9_FrameStrobe[18] Tile_X0Y9_FrameStrobe[19] Tile_X0Y9_FrameStrobe[1] Tile_X0Y9_FrameStrobe[2]
+ Tile_X0Y9_FrameStrobe[3] Tile_X0Y9_FrameStrobe[4] Tile_X0Y9_FrameStrobe[5] Tile_X0Y9_FrameStrobe[6]
+ Tile_X0Y9_FrameStrobe[7] Tile_X0Y9_FrameStrobe[8] Tile_X0Y9_FrameStrobe[9] Tile_X0Y9_N1END[0]
+ Tile_X0Y9_N1END[1] Tile_X0Y9_N1END[2] Tile_X0Y9_N1END[3] Tile_X0Y9_N2END[0] Tile_X0Y9_N2END[1]
+ Tile_X0Y9_N2END[2] Tile_X0Y9_N2END[3] Tile_X0Y9_N2END[4] Tile_X0Y9_N2END[5] Tile_X0Y9_N2END[6]
+ Tile_X0Y9_N2END[7] Tile_X0Y9_N2MID[0] Tile_X0Y9_N2MID[1] Tile_X0Y9_N2MID[2] Tile_X0Y9_N2MID[3]
+ Tile_X0Y9_N2MID[4] Tile_X0Y9_N2MID[5] Tile_X0Y9_N2MID[6] Tile_X0Y9_N2MID[7] Tile_X0Y9_N4END[0]
+ Tile_X0Y9_N4END[10] Tile_X0Y9_N4END[11] Tile_X0Y9_N4END[12] Tile_X0Y9_N4END[13]
+ Tile_X0Y9_N4END[14] Tile_X0Y9_N4END[15] Tile_X0Y9_N4END[1] Tile_X0Y9_N4END[2] Tile_X0Y9_N4END[3]
+ Tile_X0Y9_N4END[4] Tile_X0Y9_N4END[5] Tile_X0Y9_N4END[6] Tile_X0Y9_N4END[7] Tile_X0Y9_N4END[8]
+ Tile_X0Y9_N4END[9] Tile_X0Y9_S1BEG[0] Tile_X0Y9_S1BEG[1] Tile_X0Y9_S1BEG[2] Tile_X0Y9_S1BEG[3]
+ Tile_X0Y9_S2BEG[0] Tile_X0Y9_S2BEG[1] Tile_X0Y9_S2BEG[2] Tile_X0Y9_S2BEG[3] Tile_X0Y9_S2BEG[4]
+ Tile_X0Y9_S2BEG[5] Tile_X0Y9_S2BEG[6] Tile_X0Y9_S2BEG[7] Tile_X0Y9_S2BEGb[0] Tile_X0Y9_S2BEGb[1]
+ Tile_X0Y9_S2BEGb[2] Tile_X0Y9_S2BEGb[3] Tile_X0Y9_S2BEGb[4] Tile_X0Y9_S2BEGb[5]
+ Tile_X0Y9_S2BEGb[6] Tile_X0Y9_S2BEGb[7] Tile_X0Y9_S4BEG[0] Tile_X0Y9_S4BEG[10] Tile_X0Y9_S4BEG[11]
+ Tile_X0Y9_S4BEG[12] Tile_X0Y9_S4BEG[13] Tile_X0Y9_S4BEG[14] Tile_X0Y9_S4BEG[15]
+ Tile_X0Y9_S4BEG[1] Tile_X0Y9_S4BEG[2] Tile_X0Y9_S4BEG[3] Tile_X0Y9_S4BEG[4] Tile_X0Y9_S4BEG[5]
+ Tile_X0Y9_S4BEG[6] Tile_X0Y9_S4BEG[7] Tile_X0Y9_S4BEG[8] Tile_X0Y9_S4BEG[9] Tile_X0Y9_UserCLK
+ Tile_X0Y9_UserCLKo Tile_X0Y9_W1END[0] Tile_X0Y9_W1END[1] Tile_X0Y9_W1END[2] Tile_X0Y9_W1END[3]
+ Tile_X0Y9_W2END[0] Tile_X0Y9_W2END[1] Tile_X0Y9_W2END[2] Tile_X0Y9_W2END[3] Tile_X0Y9_W2END[4]
+ Tile_X0Y9_W2END[5] Tile_X0Y9_W2END[6] Tile_X0Y9_W2END[7] Tile_X0Y9_W2MID[0] Tile_X0Y9_W2MID[1]
+ Tile_X0Y9_W2MID[2] Tile_X0Y9_W2MID[3] Tile_X0Y9_W2MID[4] Tile_X0Y9_W2MID[5] Tile_X0Y9_W2MID[6]
+ Tile_X0Y9_W2MID[7] Tile_X0Y9_W6END[0] Tile_X0Y9_W6END[10] Tile_X0Y9_W6END[11] Tile_X0Y9_W6END[1]
+ Tile_X0Y9_W6END[2] Tile_X0Y9_W6END[3] Tile_X0Y9_W6END[4] Tile_X0Y9_W6END[5] Tile_X0Y9_W6END[6]
+ Tile_X0Y9_W6END[7] Tile_X0Y9_W6END[8] Tile_X0Y9_W6END[9] Tile_X0Y9_WW4END[0] Tile_X0Y9_WW4END[10]
+ Tile_X0Y9_WW4END[11] Tile_X0Y9_WW4END[12] Tile_X0Y9_WW4END[13] Tile_X0Y9_WW4END[14]
+ Tile_X0Y9_WW4END[15] Tile_X0Y9_WW4END[1] Tile_X0Y9_WW4END[2] Tile_X0Y9_WW4END[3]
+ Tile_X0Y9_WW4END[4] Tile_X0Y9_WW4END[5] Tile_X0Y9_WW4END[6] Tile_X0Y9_WW4END[7]
+ Tile_X0Y9_WW4END[8] Tile_X0Y9_WW4END[9] VGND VPWR
XFILLER_290_49 VPWR VGND sg13cmos5l_decap_8
XFILLER_651_70 VPWR VGND sg13cmos5l_decap_8
XFILLER_223_21 VPWR VGND sg13cmos5l_decap_8
XFILLER_239_183 VPWR VGND sg13cmos5l_fill_1
X_0367_ _0367_/Q Tile_X0Y7_FrameData[16] VGND VPWR Tile_X0Y9_FrameStrobe[6] latch
X_3155_ Tile_X0Y7_FrameData_O[25] Tile_X0Y7_FrameData[25] VPWR VGND sg13cmos5l_buf_1
XFILLER_589_213 VPWR VGND sg13cmos5l_decap_4
X_2106_ _2106_/Q Tile_X0Y4_FrameData[11] VGND VPWR Tile_X0Y9_FrameStrobe[5] latch
XFILLER_223_87 VPWR VGND sg13cmos5l_decap_8
X_3086_ Tile_X0Y7_E2BEG[0] _4612_/X VPWR VGND sg13cmos5l_buf_1
XFILLER_299_14 VPWR VGND sg13cmos5l_decap_8
X_0298_ _0298_/Q Tile_X0Y7_FrameData[21] VGND VPWR Tile_X0Y9_FrameStrobe[4] latch
X_2037_ _2037_/Q Tile_X0Y4_FrameData[16] VGND VPWR Tile_X0Y9_FrameStrobe[3] latch
XFILLER_520_63 VPWR VGND sg13cmos5l_decap_8
XFILLER_449_28 VPWR VGND sg13cmos5l_decap_8
XFILLER_596_56 VPWR VGND sg13cmos5l_decap_8
XFILLER_22_133 VPWR VGND sg13cmos5l_decap_8
XANTENNA__2742__X Tile_X0Y3_FrameData_O[0] VPWR VGND sg13cmos5l_antennanp
XFILLER_411_172 VPWR VGND sg13cmos5l_fill_2
X_3988_ _3988_/X _3902_/X _4035_/X _4034_/X Tile_X0Y0_S2MID[7] _1187_/Q _1186_/Q VPWR
+ VGND sg13cmos5l_mux4_1
XFILLER_596_89 VPWR VGND sg13cmos5l_fill_2
X_2939_ Tile_X0Y8_E6BEG[7] _4767_/X VPWR VGND sg13cmos5l_buf_1
XFILLER_309_143 VPWR VGND sg13cmos5l_decap_8
XFILLER_572_168 VPWR VGND sg13cmos5l_decap_8
XFILLER_108_205 VPWR VGND sg13cmos5l_fill_2
XFILLER_714_140 VPWR VGND sg13cmos5l_decap_8
XFILLER_108_216 VPWR VGND sg13cmos5l_fill_2
XFILLER_465_49 VPWR VGND sg13cmos5l_fill_1
XFILLER_175_193 VPWR VGND sg13cmos5l_decap_8
X_4609_ _4609_/X _4663_/X _4662_/X AXI_M_SOC_RDATA18 AXI_M_SOC_RDATA22 _0341_/Q _0340_/Q
+ VPWR VGND sg13cmos5l_mux4_1
XFILLER_324_146 VPWR VGND sg13cmos5l_decap_8
XFILLER_190_152 VPWR VGND sg13cmos5l_decap_8
XANTENNA__3573__X Tile_X0Y9_FrameData_O[3] VPWR VGND sg13cmos5l_antennanp
XFILLER_190_174 VPWR VGND sg13cmos5l_fill_2
XFILLER_7_7 VPWR VGND sg13cmos5l_decap_8
XFILLER_89_144 VPWR VGND sg13cmos5l_decap_8
XFILLER_117_77 VPWR VGND sg13cmos5l_decap_8
XFILLER_89_155 VPWR VGND sg13cmos5l_fill_1
XFILLER_396_7 VPWR VGND sg13cmos5l_decap_8
XFILLER_77_48 VPWR VGND sg13cmos5l_decap_8
XFILLER_89_177 VPWR VGND sg13cmos5l_decap_4
XFILLER_414_42 VPWR VGND sg13cmos5l_decap_8
XFILLER_561_70 VPWR VGND sg13cmos5l_decap_8
XFILLER_133_21 VPWR VGND sg13cmos5l_decap_8
XFILLER_493_175 VPWR VGND sg13cmos5l_decap_8
XFILLER_493_186 VPWR VGND sg13cmos5l_fill_2
XFILLER_563_7 VPWR VGND sg13cmos5l_decap_8
XANTENNA__2917__X Tile_X0Y8_E2BEG[1] VPWR VGND sg13cmos5l_antennanp
XFILLER_93_14 VPWR VGND sg13cmos5l_decap_8
XFILLER_133_65 VPWR VGND sg13cmos5l_decap_8
XFILLER_711_84 VPWR VGND sg13cmos5l_decap_8
XFILLER_650_161 VPWR VGND sg13cmos5l_decap_8
XFILLER_430_63 VPWR VGND sg13cmos5l_decap_8
XFILLER_245_197 VPWR VGND sg13cmos5l_decap_8
XFILLER_60_217 VPWR VGND sg13cmos5l_fill_1
XFILLER_359_28 VPWR VGND sg13cmos5l_decap_8
XFILLER_548_132 VPWR VGND sg13cmos5l_decap_8
XANTENNA__3748__X AXI_M_SOC_ARADDR20 VPWR VGND sg13cmos5l_antennanp
XFILLER_289_91 VPWR VGND sg13cmos5l_fill_1
XFILLER_402_183 VPWR VGND sg13cmos5l_decap_8
XFILLER_347_216 VPWR VGND sg13cmos5l_fill_2
XFILLER_9_115 VPWR VGND sg13cmos5l_fill_1
XFILLER_439_94 VPWR VGND sg13cmos5l_decap_4
XFILLER_220_0 VPWR VGND sg13cmos5l_decap_8
XFILLER_318_0 VPWR VGND sg13cmos5l_decap_8
XFILLER_315_135 VPWR VGND sg13cmos5l_decap_4
XFILLER_672_14 VPWR VGND sg13cmos5l_decap_8
XFILLER_315_146 VPWR VGND sg13cmos5l_decap_8
XFILLER_54_9 VPWR VGND sg13cmos5l_decap_8
XANTENNA__3483__X Tile_X0Y1_EE4BEG[9] VPWR VGND sg13cmos5l_antennanp
XFILLER_455_71 VPWR VGND sg13cmos5l_decap_8
XFILLER_308_98 VPWR VGND sg13cmos5l_decap_8
XFILLER_687_0 VPWR VGND sg13cmos5l_decap_8
XFILLER_174_72 VPWR VGND sg13cmos5l_decap_8
XFILLER_605_63 VPWR VGND sg13cmos5l_fill_1
XFILLER_618_125 VPWR VGND sg13cmos5l_decap_8
XFILLER_3_56 VPWR VGND sg13cmos5l_decap_8
X_1270_ _1270_/Q Tile_X0Y1_FrameData[3] VGND VPWR Tile_X0Y9_FrameStrobe[2] latch
XFILLER_283_204 VPWR VGND sg13cmos5l_fill_1
XFILLER_283_215 VPWR VGND sg13cmos5l_fill_2
XFILLER_471_81 VPWR VGND sg13cmos5l_decap_8
X_0221_ _0221_/Q Tile_X0Y7_FrameData[2] VGND VPWR Tile_X0Y9_FrameStrobe[1] latch
XANTENNA__2827__X Tile_X0Y4_E2BEG[5] VPWR VGND sg13cmos5l_antennanp
X_0152_ _0152_/X _4560_/X _4561_/X _1611_/Q VPWR VGND sg13cmos5l_mux2_1
XFILLER_621_84 VPWR VGND sg13cmos5l_decap_8
XFILLER_621_95 VPWR VGND sg13cmos5l_fill_2
XFILLER_641_161 VPWR VGND sg13cmos5l_decap_8
XFILLER_340_63 VPWR VGND sg13cmos5l_decap_8
X_0083_ _0083_/X _4908_/X _4909_/X _2377_/Q VPWR VGND sg13cmos5l_mux2_1
XFILLER_397_127 VPWR VGND sg13cmos5l_decap_8
XFILLER_539_110 VPWR VGND sg13cmos5l_decap_8
XFILLER_251_156 VPWR VGND sg13cmos5l_decap_8
X_3911_ _3911_/X _4012_/X _4016_/X _4005_/X _3989_/X _1401_/Q _1400_/Q VPWR VGND sg13cmos5l_mux4_1
XFILLER_697_77 VPWR VGND sg13cmos5l_decap_8
XFILLER_269_28 VPWR VGND sg13cmos5l_decap_8
XFILLER_251_178 VPWR VGND sg13cmos5l_decap_8
X_4891_ _4891_/X AXI_M_SOC_RDATA7 _4916_/X _4920_/X _4900_/X _0761_/Q _0760_/Q VPWR
+ VGND sg13cmos5l_mux4_1
XANTENNA__3658__X AXI_M_SOC_AWADDR19 VPWR VGND sg13cmos5l_antennanp
X_3842_ _3842_/X Tile_X0Y0_W6END[9] _3886_/X _3872_/X _3857_/X _1021_/Q _1020_/Q VPWR
+ VGND sg13cmos5l_mux4_1
XFILLER_338_216 VPWR VGND sg13cmos5l_fill_2
XFILLER_80_2 VPWR VGND sg13cmos5l_fill_1
X_3773_ _3773_/X Tile_X0Y0_WW4END[2] Tile_X0Y0_WW4END[10] Tile_X0Y0_W6END[2] _3883_/X
+ _1005_/Q _1004_/Q VPWR VGND sg13cmos5l_mux4_1
X_0985_ _0985_/Q Tile_X0Y0_FrameData[18] VGND VPWR Tile_X0Y9_FrameStrobe[1] latch
XFILLER_554_179 VPWR VGND sg13cmos5l_decap_8
X_2724_ _4658_/A3 VPWR VGND sg13cmos5l_tielo
XFILLER_285_49 VPWR VGND sg13cmos5l_decap_8
XFILLER_646_70 VPWR VGND sg13cmos5l_decap_8
XFILLER_8_181 VPWR VGND sg13cmos5l_fill_1
XFILLER_218_21 VPWR VGND sg13cmos5l_decap_8
XFILLER_582_14 VPWR VGND sg13cmos5l_decap_8
XFILLER_306_146 VPWR VGND sg13cmos5l_decap_8
X_2655_ _2655_/Q Tile_X0Y6_FrameData[8] VGND VPWR Tile_X0Y9_FrameStrobe[6] latch
XANTENNA__3393__X Tile_X0Y2_E2BEGb[4] VPWR VGND sg13cmos5l_antennanp
XFILLER_711_154 VPWR VGND sg13cmos5l_decap_8
X_1606_ _1606_/Q Tile_X0Y2_FrameData[11] VGND VPWR Tile_X0Y9_FrameStrobe[5] latch
XFILLER_218_87 VPWR VGND sg13cmos5l_fill_1
X_2586_ _2586_/Q Tile_X0Y6_FrameData[13] VGND VPWR Tile_X0Y9_FrameStrobe[4] latch
X_4325_ _4325_/X _3886_/X _3872_/X _3871_/X _3856_/X _1114_/Q _1113_/Q VPWR VGND sg13cmos5l_mux4_1
X_1537_ _1537_/Q Tile_X0Y2_FrameData[16] VGND VPWR Tile_X0Y9_FrameStrobe[3] latch
XFILLER_515_63 VPWR VGND sg13cmos5l_decap_8
XFILLER_662_91 VPWR VGND sg13cmos5l_fill_2
X_4256_ _4256_/X Tile_X0Y4_W2MID[7] AXI_M_SOC_BRESP0 _4313_/X _4312_/X _2101_/Q _2100_/Q
+ VPWR VGND sg13cmos5l_mux4_1
X_1468_ _1468_/Q Tile_X0Y2_FrameData[21] VGND VPWR Tile_X0Y9_FrameStrobe[1] latch
XFILLER_86_147 VPWR VGND sg13cmos5l_fill_1
XFILLER_624_106 VPWR VGND sg13cmos5l_fill_1
XFILLER_86_169 VPWR VGND sg13cmos5l_decap_8
X_3207_ Tile_X0Y0_N2BEG[7] _3791_/X VPWR VGND sg13cmos5l_buf_1
XFILLER_490_112 VPWR VGND sg13cmos5l_decap_8
XANTENNA__2737__X Tile_X0Y4_E1BEG[0] VPWR VGND sg13cmos5l_antennanp
X_0419_ _0419_/Q Tile_X0Y8_FrameData[28] VGND VPWR Tile_X0Y9_FrameStrobe[0] latch
X_1399_ _1399_/Q Tile_X0Y1_FrameData[2] VGND VPWR Tile_X0Y9_FrameStrobe[6] latch
X_4187_ _4187_/X AXI_M_SOC_BVALID _4226_/X _4230_/X _4211_/X _1767_/Q _1766_/Q VPWR
+ VGND sg13cmos5l_mux4_1
XFILLER_227_142 VPWR VGND sg13cmos5l_fill_1
X_3138_ Tile_X0Y7_FrameData_O[8] Tile_X0Y7_FrameData[8] VPWR VGND sg13cmos5l_buf_1
XFILLER_103_35 VPWR VGND sg13cmos5l_decap_8
XFILLER_388_105 VPWR VGND sg13cmos5l_decap_8
XFILLER_250_63 VPWR VGND sg13cmos5l_decap_8
X_3069_ Tile_X0Y5_FrameData_O[28] Tile_X0Y5_FrameData[28] VPWR VGND sg13cmos5l_buf_1
XFILLER_63_28 VPWR VGND sg13cmos5l_decap_8
XFILLER_242_134 VPWR VGND sg13cmos5l_decap_8
XFILLER_250_85 VPWR VGND sg13cmos5l_decap_8
XFILLER_63_39 VPWR VGND sg13cmos5l_fill_1
XANTENNA__3568__X Tile_X0Y9_EE4BEG[14] VPWR VGND sg13cmos5l_antennanp
XFILLER_329_205 VPWR VGND sg13cmos5l_decap_8
XFILLER_329_216 VPWR VGND sg13cmos5l_fill_2
XFILLER_195_211 VPWR VGND sg13cmos5l_fill_1
XFILLER_545_102 VPWR VGND sg13cmos5l_decap_8
XFILLER_10_125 VPWR VGND sg13cmos5l_fill_2
XFILLER_259_83 VPWR VGND sg13cmos5l_fill_1
XFILLER_545_157 VPWR VGND sg13cmos5l_fill_1
XFILLER_12_21 VPWR VGND sg13cmos5l_decap_8
XFILLER_560_105 VPWR VGND sg13cmos5l_fill_2
XFILLER_545_179 VPWR VGND sg13cmos5l_fill_2
XFILLER_409_42 VPWR VGND sg13cmos5l_decap_8
XFILLER_311_7 VPWR VGND sg13cmos5l_decap_8
XFILLER_409_7 VPWR VGND sg13cmos5l_decap_8
XFILLER_195_49 VPWR VGND sg13cmos5l_decap_8
XFILLER_556_70 VPWR VGND sg13cmos5l_decap_8
XFILLER_128_21 VPWR VGND sg13cmos5l_decap_8
XFILLER_699_161 VPWR VGND sg13cmos5l_decap_8
XFILLER_492_14 VPWR VGND sg13cmos5l_decap_8
XFILLER_88_14 VPWR VGND sg13cmos5l_decap_4
XFILLER_163_163 VPWR VGND sg13cmos5l_decap_8
XFILLER_12_98 VPWR VGND sg13cmos5l_decap_8
XFILLER_88_25 VPWR VGND sg13cmos5l_decap_8
XFILLER_706_84 VPWR VGND sg13cmos5l_decap_8
XFILLER_88_47 VPWR VGND sg13cmos5l_decap_8
XFILLER_680_7 VPWR VGND sg13cmos5l_decap_8
XFILLER_642_28 VPWR VGND sg13cmos5l_decap_8
XFILLER_425_63 VPWR VGND sg13cmos5l_decap_8
XFILLER_144_20 VPWR VGND sg13cmos5l_decap_8
XFILLER_572_91 VPWR VGND sg13cmos5l_decap_8
XFILLER_466_142 VPWR VGND sg13cmos5l_decap_8
XFILLER_291_70 VPWR VGND sg13cmos5l_decap_8
XFILLER_144_75 VPWR VGND sg13cmos5l_decap_4
XFILLER_615_117 VPWR VGND sg13cmos5l_fill_2
XFILLER_608_180 VPWR VGND sg13cmos5l_fill_2
XFILLER_481_145 VPWR VGND sg13cmos5l_decap_8
XFILLER_481_156 VPWR VGND sg13cmos5l_fill_2
XFILLER_170_0 VPWR VGND sg13cmos5l_decap_8
XFILLER_268_0 VPWR VGND sg13cmos5l_fill_2
XFILLER_379_116 VPWR VGND sg13cmos5l_decap_4
XFILLER_233_134 VPWR VGND sg13cmos5l_decap_8
XFILLER_379_127 VPWR VGND sg13cmos5l_decap_8
XFILLER_667_14 VPWR VGND sg13cmos5l_decap_8
XFILLER_435_0 VPWR VGND sg13cmos5l_decap_8
XFILLER_394_108 VPWR VGND sg13cmos5l_decap_8
XANTENNA__3478__X Tile_X0Y1_EE4BEG[4] VPWR VGND sg13cmos5l_antennanp
XFILLER_387_171 VPWR VGND sg13cmos5l_decap_8
XFILLER_53_94 VPWR VGND sg13cmos5l_decap_8
XFILLER_169_72 VPWR VGND sg13cmos5l_decap_8
XFILLER_602_0 VPWR VGND sg13cmos5l_decap_8
X_0770_ _0770_/Q Tile_X0Y9_FrameData[29] VGND VPWR Tile_X0Y9_FrameStrobe[3] latch
XFILLER_683_35 VPWR VGND sg13cmos5l_decap_8
XFILLER_139_182 VPWR VGND sg13cmos5l_decap_8
X_2440_ _2440_/Q Tile_X0Y5_FrameData[31] VGND VPWR Tile_X0Y9_FrameStrobe[0] latch
XFILLER_616_84 VPWR VGND sg13cmos5l_decap_8
XFILLER_552_28 VPWR VGND sg13cmos5l_decap_8
X_2371_ _2371_/Q Tile_X0Y5_FrameData[2] VGND VPWR Tile_X0Y9_FrameStrobe[5] latch
XFILLER_335_74 VPWR VGND sg13cmos5l_fill_2
X_4110_ _4110_/X _4091_/X _0064_/X _4090_/X Tile_X0Y0_S4END[9] _1455_/Q _1454_/Q VPWR
+ VGND sg13cmos5l_mux4_1
X_1322_ _1322_/Q Tile_X0Y1_FrameData[15] VGND VPWR Tile_X0Y9_FrameStrobe[4] latch
X_1253_ _1253_/Q Tile_X0Y1_FrameData[20] VGND VPWR Tile_X0Y9_FrameStrobe[2] latch
X_4041_ _4041_/X Tile_X0Y2_W2MID[6] AXI_M_SOC_AWREADY _4099_/X _4098_/X _1591_/Q _1590_/Q
+ VPWR VGND sg13cmos5l_mux4_1
XFILLER_68_169 VPWR VGND sg13cmos5l_decap_8
XFILLER_83_106 VPWR VGND sg13cmos5l_decap_4
XFILLER_83_117 VPWR VGND sg13cmos5l_decap_8
XFILLER_204_56 VPWR VGND sg13cmos5l_decap_8
X_0204_ _0204_/Q Tile_X0Y7_FrameData[19] VGND VPWR Tile_X0Y9_FrameStrobe[1] latch
X_1184_ _1184_/Q Tile_X0Y1_FrameData[25] VGND VPWR Tile_X0Y9_FrameStrobe[0] latch
XFILLER_351_84 VPWR VGND sg13cmos5l_decap_8
XFILLER_501_21 VPWR VGND sg13cmos5l_decap_8
X_0135_ AXI_M_SOC_AWLEN5 _0940_/Q _3676_/X VPWR VGND sg13cmos5l_nor2b_1
XFILLER_24_217 VPWR VGND sg13cmos5l_fill_1
X_0066_ _3635_/A _4838_/X _4839_/X _0862_/Q VPWR VGND sg13cmos5l_mux2_1
XFILLER_501_98 VPWR VGND sg13cmos5l_decap_8
XFILLER_577_14 VPWR VGND sg13cmos5l_decap_8
XANTENNA__3388__X Tile_X0Y2_E6BEG[11] VPWR VGND sg13cmos5l_antennanp
XFILLER_220_88 VPWR VGND sg13cmos5l_decap_8
X_4874_ _4874_/X Tile_X0Y9_WW4END[5] AXI_M_SOC_RDATA5 _4921_/X _4904_/X _0795_/Q _0794_/Q
+ VPWR VGND sg13cmos5l_mux4_1
XFILLER_527_102 VPWR VGND sg13cmos5l_decap_4
XFILLER_378_182 VPWR VGND sg13cmos5l_decap_4
X_3825_ _3825_/X Tile_X0Y0_WW4END[10] Tile_X0Y0_WW4END[15] _3868_/X _3857_/X _1055_/Q
+ _1054_/Q VPWR VGND sg13cmos5l_mux4_1
XFILLER_192_203 VPWR VGND sg13cmos5l_fill_2
XFILLER_137_119 VPWR VGND sg13cmos5l_decap_8
XFILLER_657_91 VPWR VGND sg13cmos5l_decap_8
XFILLER_393_174 VPWR VGND sg13cmos5l_decap_8
XFILLER_229_42 VPWR VGND sg13cmos5l_decap_8
X_3756_ AXI_M_SOC_ARADDR28 Tile_X0Y8_W1END[0] Tile_X0Y8_WW4END[4] Tile_X0Y8_WW4END[12]
+ _4812_/X _0479_/Q _0478_/Q VPWR VGND sg13cmos5l_mux4_1
X_0968_ _0968_/Q Tile_X0Y0_FrameData[3] VGND VPWR Tile_X0Y9_FrameStrobe[0] latch
XFILLER_593_35 VPWR VGND sg13cmos5l_decap_8
XFILLER_542_138 VPWR VGND sg13cmos5l_fill_2
X_2707_ _4306_/A3 VPWR VGND sg13cmos5l_tielo
X_3687_ _3687_/X Tile_X0Y3_WW4END[5] Tile_X0Y3_WW4END[13] Tile_X0Y3_W6END[5] _4227_/X
+ _1747_/Q _1746_/Q VPWR VGND sg13cmos5l_mux4_1
XFILLER_593_79 VPWR VGND sg13cmos5l_decap_4
X_0899_ _0899_/Q Tile_X0Y9_FrameData[28] VGND VPWR Tile_X0Y9_FrameStrobe[7] latch
XFILLER_696_142 VPWR VGND sg13cmos5l_decap_8
X_2638_ _2638_/Q Tile_X0Y6_FrameData[25] VGND VPWR Tile_X0Y9_FrameStrobe[6] latch
XFILLER_495_215 VPWR VGND sg13cmos5l_fill_2
XFILLER_160_133 VPWR VGND sg13cmos5l_decap_8
XFILLER_462_28 VPWR VGND sg13cmos5l_decap_8
XFILLER_245_63 VPWR VGND sg13cmos5l_decap_8
X_2569_ _2569_/Q Tile_X0Y6_FrameData[30] VGND VPWR Tile_X0Y9_FrameStrobe[4] latch
XFILLER_392_80 VPWR VGND sg13cmos5l_fill_1
XFILLER_448_131 VPWR VGND sg13cmos5l_decap_8
X_4308_ _4308_/X Tile_X0Y5_W1END[2] Tile_X0Y5_W6END[6] _4465_/X _4422_/X _2435_/Q
+ _2434_/Q VPWR VGND sg13cmos5l_mux4_1
XFILLER_463_101 VPWR VGND sg13cmos5l_fill_2
XFILLER_448_186 VPWR VGND sg13cmos5l_decap_8
XFILLER_59_169 VPWR VGND sg13cmos5l_decap_8
X_4239_ _4239_/X Tile_X0Y5_W2MID[6] Tile_X0Y5_W2END[6] Tile_X0Y5_W6END[6] _4430_/X
+ _2429_/Q _2428_/Q VPWR VGND sg13cmos5l_mux4_1
XFILLER_114_34 VPWR VGND sg13cmos5l_decap_8
XFILLER_463_145 VPWR VGND sg13cmos5l_decap_4
XFILLER_463_156 VPWR VGND sg13cmos5l_decap_4
XFILLER_463_167 VPWR VGND sg13cmos5l_fill_1
XFILLER_261_84 VPWR VGND sg13cmos5l_decap_8
XFILLER_411_21 VPWR VGND sg13cmos5l_decap_8
XFILLER_215_112 VPWR VGND sg13cmos5l_decap_4
XFILLER_261_7 VPWR VGND sg13cmos5l_decap_8
XFILLER_359_7 VPWR VGND sg13cmos5l_decap_8
XFILLER_82_172 VPWR VGND sg13cmos5l_fill_2
XFILLER_82_183 VPWR VGND sg13cmos5l_fill_1
XFILLER_487_14 VPWR VGND sg13cmos5l_decap_8
XANTENNA__3298__X Tile_X0Y0_E2BEGb[6] VPWR VGND sg13cmos5l_antennanp
XFILLER_620_186 VPWR VGND sg13cmos5l_fill_2
XFILLER_168_200 VPWR VGND sg13cmos5l_decap_8
XFILLER_130_77 VPWR VGND sg13cmos5l_decap_8
XFILLER_230_148 VPWR VGND sg13cmos5l_decap_8
XFILLER_526_7 VPWR VGND sg13cmos5l_decap_8
XFILLER_518_124 VPWR VGND sg13cmos5l_decap_8
XFILLER_384_130 VPWR VGND sg13cmos5l_decap_8
XFILLER_637_28 VPWR VGND sg13cmos5l_decap_8
XFILLER_23_42 VPWR VGND sg13cmos5l_decap_8
XFILLER_23_53 VPWR VGND sg13cmos5l_fill_1
XFILLER_567_91 VPWR VGND sg13cmos5l_decap_8
XFILLER_518_179 VPWR VGND sg13cmos5l_decap_8
XFILLER_139_42 VPWR VGND sg13cmos5l_decap_8
XANTENNA__2930__X Tile_X0Y8_E2BEGb[6] VPWR VGND sg13cmos5l_antennanp
XFILLER_99_13 VPWR VGND sg13cmos5l_decap_8
XFILLER_286_70 VPWR VGND sg13cmos5l_decap_8
XFILLER_436_62 VPWR VGND sg13cmos5l_decap_8
XFILLER_653_49 VPWR VGND sg13cmos5l_decap_8
XFILLER_151_122 VPWR VGND sg13cmos5l_decap_8
XFILLER_372_28 VPWR VGND sg13cmos5l_decap_8
XFILLER_155_63 VPWR VGND sg13cmos5l_fill_1
XFILLER_151_166 VPWR VGND sg13cmos5l_fill_1
XFILLER_151_188 VPWR VGND sg13cmos5l_decap_8
XFILLER_643_201 VPWR VGND sg13cmos5l_fill_1
XFILLER_48_50 VPWR VGND sg13cmos5l_decap_8
XFILLER_385_0 VPWR VGND sg13cmos5l_decap_8
XFILLER_452_94 VPWR VGND sg13cmos5l_decap_4
XFILLER_305_88 VPWR VGND sg13cmos5l_decap_8
XFILLER_65_117 VPWR VGND sg13cmos5l_decap_8
XFILLER_602_42 VPWR VGND sg13cmos5l_decap_8
XFILLER_602_53 VPWR VGND sg13cmos5l_fill_1
XFILLER_58_180 VPWR VGND sg13cmos5l_decap_8
XFILLER_321_21 VPWR VGND sg13cmos5l_decap_8
XFILLER_552_0 VPWR VGND sg13cmos5l_decap_8
XFILLER_0_35 VPWR VGND sg13cmos5l_decap_8
XFILLER_678_35 VPWR VGND sg13cmos5l_decap_8
XFILLER_73_183 VPWR VGND sg13cmos5l_decap_4
XFILLER_611_142 VPWR VGND sg13cmos5l_decap_8
XFILLER_397_14 VPWR VGND sg13cmos5l_decap_8
XFILLER_64_93 VPWR VGND sg13cmos5l_decap_8
X_1940_ _1940_/Q Tile_X0Y4_FrameData[17] VGND VPWR Tile_X0Y9_FrameStrobe[0] latch
XANTENNA__3001__X Tile_X0Y5_E2BEG[4] VPWR VGND sg13cmos5l_antennanp
XFILLER_375_130 VPWR VGND sg13cmos5l_fill_1
XFILLER_547_28 VPWR VGND sg13cmos5l_decap_8
XFILLER_9_77 VPWR VGND sg13cmos5l_decap_8
X_1871_ _1871_/Q Tile_X0Y3_FrameData[26] VGND VPWR Tile_X0Y9_FrameStrobe[6] latch
XFILLER_9_88 VPWR VGND sg13cmos5l_fill_2
XFILLER_80_70 VPWR VGND sg13cmos5l_decap_8
XFILLER_694_56 VPWR VGND sg13cmos5l_decap_8
XFILLER_509_168 VPWR VGND sg13cmos5l_decap_8
XANTENNA__2840__X Tile_X0Y6_E2BEG[5] VPWR VGND sg13cmos5l_antennanp
X_3610_ Tile_X0Y9_S2BEG[4] _4832_/X VPWR VGND sg13cmos5l_buf_1
X_0822_ _0822_/Q Tile_X0Y9_FrameData[9] VGND VPWR Tile_X0Y9_FrameStrobe[4] latch
X_4590_ _4590_/X Tile_X0Y5_W2MID[4] Tile_X0Y5_W2END[4] Tile_X0Y5_W6END[11] _4434_/X
+ _2389_/Q _2388_/Q VPWR VGND sg13cmos5l_mux4_1
XFILLER_375_196 VPWR VGND sg13cmos5l_decap_8
X_3541_ Tile_X0Y9_E2BEGb[7] _4863_/X VPWR VGND sg13cmos5l_buf_1
XFILLER_517_190 VPWR VGND sg13cmos5l_decap_8
X_0753_ _0753_/Q Tile_X0Y9_FrameData[14] VGND VPWR Tile_X0Y9_FrameStrobe[2] latch
XFILLER_331_200 VPWR VGND sg13cmos5l_decap_8
X_3472_ Tile_X0Y1_FrameData_O[30] Tile_X0Y1_FrameData[30] VPWR VGND sg13cmos5l_buf_1
XFILLER_563_49 VPWR VGND sg13cmos5l_decap_8
X_0684_ _0684_/Q Tile_X0Y9_FrameData[19] VGND VPWR Tile_X0Y9_FrameStrobe[0] latch
XFILLER_532_182 VPWR VGND sg13cmos5l_fill_2
XFILLER_346_84 VPWR VGND sg13cmos5l_decap_8
XFILLER_693_112 VPWR VGND sg13cmos5l_fill_1
XFILLER_678_186 VPWR VGND sg13cmos5l_decap_4
X_2423_ _2423_/Q Tile_X0Y5_FrameData[14] VGND VPWR Tile_X0Y9_FrameStrobe[7] latch
XFILLER_282_28 VPWR VGND sg13cmos5l_decap_8
XFILLER_693_123 VPWR VGND sg13cmos5l_fill_2
X_2354_ _2354_/Q Tile_X0Y5_FrameData[19] VGND VPWR Tile_X0Y9_FrameStrobe[5] latch
XFILLER_693_167 VPWR VGND sg13cmos5l_fill_2
XFILLER_229_215 VPWR VGND sg13cmos5l_fill_2
XFILLER_29_0 VPWR VGND sg13cmos5l_fill_2
X_1305_ _1305_/Q Tile_X0Y1_FrameData[0] VGND VPWR Tile_X0Y9_FrameStrobe[3] latch
XFILLER_215_77 VPWR VGND sg13cmos5l_decap_8
X_2285_ _2285_/Q Tile_X0Y5_FrameData[24] VGND VPWR Tile_X0Y9_FrameStrobe[3] latch
XFILLER_512_42 VPWR VGND sg13cmos5l_decap_8
XFILLER_244_207 VPWR VGND sg13cmos5l_fill_2
X_4024_ _4024_/X Tile_X0Y0_W2MID[5] Tile_X0Y0_W2END[5] Tile_X0Y0_W6END[10] _3857_/X
+ _1129_/Q _1128_/Q VPWR VGND sg13cmos5l_mux4_1
X_1236_ _1236_/Q Tile_X0Y1_FrameData[5] VGND VPWR Tile_X0Y9_FrameStrobe[1] latch
XFILLER_231_21 VPWR VGND sg13cmos5l_decap_8
XFILLER_460_137 VPWR VGND sg13cmos5l_fill_2
X_1167_ _1167_/Q Tile_X0Y0_FrameData[28] VGND VPWR Tile_X0Y9_FrameStrobe[7] latch
XFILLER_588_35 VPWR VGND sg13cmos5l_decap_8
X_0118_ AXI_M_SOC_ARBURST1 _0931_/Q _3772_/X VPWR VGND sg13cmos5l_nor2b_1
XFILLER_212_104 VPWR VGND sg13cmos5l_decap_8
X_1098_ _1098_/Q Tile_X0Y0_FrameData[1] VGND VPWR Tile_X0Y9_FrameStrobe[4] latch
XFILLER_358_119 VPWR VGND sg13cmos5l_decap_8
XFILLER_12_209 VPWR VGND sg13cmos5l_fill_1
X_0049_ AXI_M_SOC_AWCACHE0 _0936_/Q _3685_/X VPWR VGND sg13cmos5l_or2_1
X_4926_ _4926_/X Tile_X0Y9_N1END[2] Tile_X0Y9_N4END[2] _4898_/X _0081_/X _0707_/Q
+ _0706_/Q VPWR VGND sg13cmos5l_mux4_1
XFILLER_457_28 VPWR VGND sg13cmos5l_decap_8
X_4857_ _4857_/X Tile_X0Y9_W2END[6] AXI_M_SOC_RDATA6 _4903_/X _4902_/X _0829_/Q _0828_/Q
+ VPWR VGND sg13cmos5l_mux4_1
XFILLER_100_69 VPWR VGND sg13cmos5l_fill_1
XFILLER_387_91 VPWR VGND sg13cmos5l_fill_2
XFILLER_366_174 VPWR VGND sg13cmos5l_fill_2
XANTENNA__2750__X Tile_X0Y3_FrameData_O[8] VPWR VGND sg13cmos5l_antennanp
X_3808_ _3808_/X Tile_X0Y0_W2MID[3] Tile_X0Y0_WW4END[8] _3859_/X _3858_/X _1089_/Q
+ _1088_/Q VPWR VGND sg13cmos5l_mux4_1
X_4788_ _4788_/X _4711_/X Tile_X0Y9_N2MID[5] _4821_/X _4710_/X _0429_/Q _0428_/Q VPWR
+ VGND sg13cmos5l_mux4_1
XFILLER_515_138 VPWR VGND sg13cmos5l_decap_4
XFILLER_515_149 VPWR VGND sg13cmos5l_decap_8
XFILLER_118_141 VPWR VGND sg13cmos5l_decap_8
X_3739_ AXI_M_SOC_ARADDR11 Tile_X0Y9_WW4END[3] Tile_X0Y9_WW4END[11] Tile_X0Y9_W6END[11]
+ _4927_/X _0737_/Q _0736_/Q VPWR VGND sg13cmos5l_mux4_1
XFILLER_180_206 VPWR VGND sg13cmos5l_fill_2
XFILLER_118_163 VPWR VGND sg13cmos5l_decap_8
XFILLER_133_100 VPWR VGND sg13cmos5l_decap_8
XFILLER_279_104 VPWR VGND sg13cmos5l_decap_8
XFILLER_107_7 VPWR VGND sg13cmos5l_decap_4
XFILLER_473_49 VPWR VGND sg13cmos5l_decap_4
XFILLER_406_21 VPWR VGND sg13cmos5l_decap_8
XFILLER_256_95 VPWR VGND sg13cmos5l_fill_1
XFILLER_133_133 VPWR VGND sg13cmos5l_decap_8
XFILLER_109_89 VPWR VGND sg13cmos5l_decap_8
XFILLER_192_28 VPWR VGND sg13cmos5l_decap_8
XFILLER_684_145 VPWR VGND sg13cmos5l_fill_2
XANTENNA__3581__X Tile_X0Y9_FrameData_O[11] VPWR VGND sg13cmos5l_antennanp
XFILLER_294_107 VPWR VGND sg13cmos5l_decap_8
XFILLER_287_181 VPWR VGND sg13cmos5l_decap_8
XFILLER_125_77 VPWR VGND sg13cmos5l_decap_8
XFILLER_703_63 VPWR VGND sg13cmos5l_decap_8
XFILLER_476_7 VPWR VGND sg13cmos5l_decap_8
XFILLER_422_42 VPWR VGND sg13cmos5l_decap_8
XFILLER_18_42 VPWR VGND sg13cmos5l_decap_8
XFILLER_643_7 VPWR VGND sg13cmos5l_decap_8
XANTENNA__2925__X Tile_X0Y8_E2BEGb[1] VPWR VGND sg13cmos5l_antennanp
XFILLER_498_35 VPWR VGND sg13cmos5l_decap_8
XFILLER_451_159 VPWR VGND sg13cmos5l_decap_8
XFILLER_203_126 VPWR VGND sg13cmos5l_decap_8
XFILLER_70_164 VPWR VGND sg13cmos5l_decap_8
XFILLER_34_41 VPWR VGND sg13cmos5l_decap_8
XFILLER_245_2 VPWR VGND sg13cmos5l_fill_1
XFILLER_648_49 VPWR VGND sg13cmos5l_decap_8
XFILLER_34_85 VPWR VGND sg13cmos5l_decap_8
XFILLER_367_28 VPWR VGND sg13cmos5l_decap_8
XFILLER_34_96 VPWR VGND sg13cmos5l_fill_1
XFILLER_133_0 VPWR VGND sg13cmos5l_decap_8
XANTENNA__3756__X AXI_M_SOC_ARADDR28 VPWR VGND sg13cmos5l_antennanp
XFILLER_297_91 VPWR VGND sg13cmos5l_decap_8
XFILLER_357_196 VPWR VGND sg13cmos5l_decap_8
XFILLER_50_51 VPWR VGND sg13cmos5l_decap_8
XFILLER_50_73 VPWR VGND sg13cmos5l_decap_8
XFILLER_300_0 VPWR VGND sg13cmos5l_decap_8
XFILLER_50_84 VPWR VGND sg13cmos5l_fill_2
XFILLER_521_119 VPWR VGND sg13cmos5l_decap_4
XFILLER_514_160 VPWR VGND sg13cmos5l_decap_8
XFILLER_383_49 VPWR VGND sg13cmos5l_fill_1
XFILLER_166_84 VPWR VGND sg13cmos5l_decap_8
XFILLER_514_182 VPWR VGND sg13cmos5l_decap_8
XFILLER_459_215 VPWR VGND sg13cmos5l_fill_2
XFILLER_124_133 VPWR VGND sg13cmos5l_decap_8
XFILLER_316_21 VPWR VGND sg13cmos5l_decap_8
XFILLER_166_95 VPWR VGND sg13cmos5l_fill_2
XFILLER_680_14 VPWR VGND sg13cmos5l_decap_8
XFILLER_316_54 VPWR VGND sg13cmos5l_decap_8
XANTENNA__3491__X Tile_X0Y1_E6BEG[1] VPWR VGND sg13cmos5l_antennanp
XFILLER_59_60 VPWR VGND sg13cmos5l_decap_8
XFILLER_463_82 VPWR VGND sg13cmos5l_decap_8
XFILLER_316_76 VPWR VGND sg13cmos5l_decap_8
XFILLER_675_167 VPWR VGND sg13cmos5l_fill_2
XFILLER_463_93 VPWR VGND sg13cmos5l_fill_1
XFILLER_427_112 VPWR VGND sg13cmos5l_decap_8
XFILLER_22_7 VPWR VGND sg13cmos5l_decap_8
XFILLER_613_63 VPWR VGND sg13cmos5l_decap_8
XFILLER_93_201 VPWR VGND sg13cmos5l_fill_1
XFILLER_332_42 VPWR VGND sg13cmos5l_decap_8
X_2070_ _2070_/Q Tile_X0Y4_FrameData[15] VGND VPWR Tile_X0Y9_FrameStrobe[4] latch
XFILLER_427_189 VPWR VGND sg13cmos5l_fill_2
XFILLER_293_184 VPWR VGND sg13cmos5l_decap_4
XFILLER_689_56 VPWR VGND sg13cmos5l_decap_8
XFILLER_442_126 VPWR VGND sg13cmos5l_decap_8
XANTENNA__2835__X Tile_X0Y6_E2BEG[0] VPWR VGND sg13cmos5l_antennanp
X_1021_ _1021_/Q Tile_X0Y0_FrameData[14] VGND VPWR Tile_X0Y9_FrameStrobe[2] latch
XFILLER_442_137 VPWR VGND sg13cmos5l_fill_1
XFILLER_442_159 VPWR VGND sg13cmos5l_decap_8
XFILLER_46_194 VPWR VGND sg13cmos5l_fill_2
XFILLER_201_35 VPWR VGND sg13cmos5l_decap_8
XFILLER_529_208 VPWR VGND sg13cmos5l_decap_4
X_2972_ Tile_X0Y8_FrameData_O[12] Tile_X0Y8_FrameData[12] VPWR VGND sg13cmos5l_buf_1
XFILLER_61_186 VPWR VGND sg13cmos5l_decap_8
XFILLER_558_49 VPWR VGND sg13cmos5l_decap_8
X_4711_ _4711_/X Tile_X0Y9_W2MID[2] Tile_X0Y9_W2END[2] Tile_X0Y9_W6END[2] _4904_/X
+ _0909_/Q _0908_/Q VPWR VGND sg13cmos5l_mux4_1
X_1923_ _1923_/Q Tile_X0Y3_FrameData[6] VGND VPWR Tile_X0Y9_FrameStrobe[7] latch
XFILLER_277_28 VPWR VGND sg13cmos5l_decap_8
XANTENNA__3666__X AXI_M_SOC_AWADDR27 VPWR VGND sg13cmos5l_antennanp
X_4642_ _4642_/X Tile_X0Y7_WW4END[1] AXI_M_SOC_RDATA17 _4685_/X _4671_/X _0275_/Q
+ _0274_/Q VPWR VGND sg13cmos5l_mux4_1
X_1854_ _1854_/Q Tile_X0Y3_FrameData[11] VGND VPWR Tile_X0Y9_FrameStrobe[5] latch
XFILLER_363_144 VPWR VGND sg13cmos5l_fill_2
X_0805_ _0805_/Q Tile_X0Y9_FrameData[26] VGND VPWR Tile_X0Y9_FrameStrobe[4] latch
X_4573_ _4573_/X _4547_/X Tile_X0Y9_N4END[13] _4546_/X _0153_/X _2485_/Q _2484_/Q
+ VPWR VGND sg13cmos5l_mux4_1
X_1785_ _1785_/Q Tile_X0Y3_FrameData[16] VGND VPWR Tile_X0Y9_FrameStrobe[3] latch
XFILLER_162_217 VPWR VGND sg13cmos5l_fill_1
XFILLER_512_119 VPWR VGND sg13cmos5l_decap_4
X_3524_ Tile_X0Y9_E1BEG[2] _4846_/X VPWR VGND sg13cmos5l_buf_1
XFILLER_507_42 VPWR VGND sg13cmos5l_decap_8
X_0736_ _0736_/Q Tile_X0Y9_FrameData[31] VGND VPWR Tile_X0Y9_FrameStrobe[2] latch
XFILLER_293_49 VPWR VGND sg13cmos5l_decap_8
XFILLER_115_122 VPWR VGND sg13cmos5l_decap_8
XFILLER_654_70 VPWR VGND sg13cmos5l_decap_8
XFILLER_520_130 VPWR VGND sg13cmos5l_decap_4
X_3455_ Tile_X0Y1_FrameData_O[13] Tile_X0Y1_FrameData[13] VPWR VGND sg13cmos5l_buf_1
XFILLER_590_14 VPWR VGND sg13cmos5l_decap_8
XFILLER_520_141 VPWR VGND sg13cmos5l_fill_1
X_0667_ _0667_/Q Tile_X0Y8_FrameData[4] VGND VPWR Tile_X0Y9_FrameStrobe[7] latch
XFILLER_115_177 VPWR VGND sg13cmos5l_fill_1
X_2406_ _2406_/Q Tile_X0Y5_FrameData[31] VGND VPWR Tile_X0Y9_FrameStrobe[7] latch
X_3386_ Tile_X0Y2_E6BEG[9] _4081_/X VPWR VGND sg13cmos5l_buf_1
XFILLER_590_69 VPWR VGND sg13cmos5l_fill_1
XFILLER_269_170 VPWR VGND sg13cmos5l_decap_8
XFILLER_130_147 VPWR VGND sg13cmos5l_decap_8
X_0598_ _0598_/Q Tile_X0Y8_FrameData[9] VGND VPWR Tile_X0Y9_FrameStrobe[5] latch
XFILLER_681_126 VPWR VGND sg13cmos5l_decap_8
XFILLER_418_112 VPWR VGND sg13cmos5l_decap_8
X_2337_ _2337_/Q Tile_X0Y5_FrameData[4] VGND VPWR Tile_X0Y9_FrameStrobe[4] latch
XFILLER_242_20 VPWR VGND sg13cmos5l_decap_8
XFILLER_284_140 VPWR VGND sg13cmos5l_decap_8
XFILLER_242_31 VPWR VGND sg13cmos5l_fill_2
XFILLER_670_91 VPWR VGND sg13cmos5l_decap_8
XFILLER_418_178 VPWR VGND sg13cmos5l_fill_2
X_2268_ _2268_/Q Tile_X0Y5_FrameData[9] VGND VPWR Tile_X0Y9_FrameStrobe[2] latch
XFILLER_242_75 VPWR VGND sg13cmos5l_decap_8
X_4007_ _4007_/X _4458_/X _4462_/X _4466_/X _4434_/X _2406_/Q _2405_/Q VPWR VGND sg13cmos5l_mux4_1
XFILLER_599_56 VPWR VGND sg13cmos5l_fill_2
XANTENNA__2745__X Tile_X0Y3_FrameData_O[3] VPWR VGND sg13cmos5l_antennanp
X_1219_ _1219_/Q Tile_X0Y1_FrameData[22] VGND VPWR Tile_X0Y9_FrameStrobe[1] latch
X_2199_ _2199_/Q Tile_X0Y5_FrameData[14] VGND VPWR Tile_X0Y9_FrameStrobe[0] latch
XFILLER_240_210 VPWR VGND sg13cmos5l_fill_2
XFILLER_111_68 VPWR VGND sg13cmos5l_decap_8
XFILLER_587_185 VPWR VGND sg13cmos5l_fill_1
XFILLER_52_186 VPWR VGND sg13cmos5l_fill_1
XFILLER_468_49 VPWR VGND sg13cmos5l_decap_8
XFILLER_197_169 VPWR VGND sg13cmos5l_decap_8
XFILLER_187_28 VPWR VGND sg13cmos5l_decap_8
X_4909_ _4909_/X _4455_/X _4459_/X _4463_/X _4433_/X _2379_/Q _2378_/Q VPWR VGND sg13cmos5l_mux4_1
XANTENNA__3576__X Tile_X0Y9_FrameData_O[6] VPWR VGND sg13cmos5l_antennanp
XFILLER_224_7 VPWR VGND sg13cmos5l_decap_8
XFILLER_354_133 VPWR VGND sg13cmos5l_decap_8
XFILLER_217_6 VPWR VGND sg13cmos5l_decap_8
XFILLER_153_217 VPWR VGND sg13cmos5l_fill_1
XFILLER_354_177 VPWR VGND sg13cmos5l_decap_8
XFILLER_503_119 VPWR VGND sg13cmos5l_decap_8
XFILLER_417_42 VPWR VGND sg13cmos5l_decap_8
XFILLER_20_21 VPWR VGND sg13cmos5l_decap_8
XFILLER_564_70 VPWR VGND sg13cmos5l_decap_8
XFILLER_136_21 VPWR VGND sg13cmos5l_decap_8
XFILLER_657_112 VPWR VGND sg13cmos5l_decap_8
XFILLER_657_123 VPWR VGND sg13cmos5l_fill_2
XFILLER_593_7 VPWR VGND sg13cmos5l_decap_8
XFILLER_657_134 VPWR VGND sg13cmos5l_fill_1
XFILLER_96_14 VPWR VGND sg13cmos5l_decap_8
XFILLER_310_214 VPWR VGND sg13cmos5l_decap_4
XFILLER_106_188 VPWR VGND sg13cmos5l_fill_2
XFILLER_267_118 VPWR VGND sg13cmos5l_fill_1
XFILLER_136_98 VPWR VGND sg13cmos5l_decap_8
XFILLER_714_84 VPWR VGND sg13cmos5l_decap_8
XFILLER_672_137 VPWR VGND sg13cmos5l_decap_4
XFILLER_650_28 VPWR VGND sg13cmos5l_decap_8
XFILLER_433_63 VPWR VGND sg13cmos5l_decap_8
XFILLER_29_41 VPWR VGND sg13cmos5l_decap_8
XFILLER_672_148 VPWR VGND sg13cmos5l_decap_4
XFILLER_409_134 VPWR VGND sg13cmos5l_decap_4
XFILLER_195_2 VPWR VGND sg13cmos5l_fill_1
XFILLER_672_159 VPWR VGND sg13cmos5l_decap_8
XFILLER_275_151 VPWR VGND sg13cmos5l_fill_1
XFILLER_152_42 VPWR VGND sg13cmos5l_decap_8
XFILLER_275_173 VPWR VGND sg13cmos5l_decap_8
XFILLER_409_178 VPWR VGND sg13cmos5l_decap_8
XFILLER_409_189 VPWR VGND sg13cmos5l_fill_1
XFILLER_275_184 VPWR VGND sg13cmos5l_fill_1
XFILLER_613_215 VPWR VGND sg13cmos5l_fill_2
XFILLER_290_176 VPWR VGND sg13cmos5l_decap_8
XFILLER_302_78 VPWR VGND sg13cmos5l_fill_2
XFILLER_432_170 VPWR VGND sg13cmos5l_decap_8
XFILLER_250_0 VPWR VGND sg13cmos5l_decap_8
XFILLER_377_214 VPWR VGND sg13cmos5l_decap_4
XFILLER_348_0 VPWR VGND sg13cmos5l_decap_8
XFILLER_43_164 VPWR VGND sg13cmos5l_fill_2
XFILLER_378_49 VPWR VGND sg13cmos5l_fill_1
XFILLER_675_14 VPWR VGND sg13cmos5l_decap_8
XFILLER_392_206 VPWR VGND sg13cmos5l_decap_4
XFILLER_392_217 VPWR VGND sg13cmos5l_fill_1
XANTENNA__3486__X Tile_X0Y1_EE4BEG[12] VPWR VGND sg13cmos5l_antennanp
XFILLER_515_0 VPWR VGND sg13cmos5l_decap_8
XFILLER_458_93 VPWR VGND sg13cmos5l_decap_4
XFILLER_345_155 VPWR VGND sg13cmos5l_decap_8
XFILLER_608_63 VPWR VGND sg13cmos5l_decap_8
XFILLER_345_166 VPWR VGND sg13cmos5l_fill_2
XANTENNA_5 AXI_M_SOC_RDATA27 VPWR VGND sg13cmos5l_antennanp
XFILLER_6_56 VPWR VGND sg13cmos5l_decap_8
X_1570_ _1570_/Q Tile_X0Y2_FrameData[15] VGND VPWR Tile_X0Y9_FrameStrobe[4] latch
XFILLER_691_35 VPWR VGND sg13cmos5l_decap_8
XFILLER_327_64 VPWR VGND sg13cmos5l_decap_8
XFILLER_298_210 VPWR VGND sg13cmos5l_fill_2
XFILLER_327_75 VPWR VGND sg13cmos5l_fill_2
XFILLER_648_112 VPWR VGND sg13cmos5l_decap_8
X_0521_ _0521_/Q Tile_X0Y8_FrameData[22] VGND VPWR Tile_X0Y9_FrameStrobe[3] latch
XFILLER_360_169 VPWR VGND sg13cmos5l_decap_8
XFILLER_301_203 VPWR VGND sg13cmos5l_fill_1
X_3240_ Tile_X0Y0_FrameData_O[8] Tile_X0Y0_FrameData[8] VPWR VGND sg13cmos5l_buf_1
X_0452_ _0452_/Q Tile_X0Y8_FrameData[27] VGND VPWR Tile_X0Y9_FrameStrobe[1] latch
XFILLER_258_129 VPWR VGND sg13cmos5l_fill_2
XFILLER_624_84 VPWR VGND sg13cmos5l_decap_8
XFILLER_502_196 VPWR VGND sg13cmos5l_decap_8
XFILLER_648_189 VPWR VGND sg13cmos5l_decap_8
XFILLER_560_28 VPWR VGND sg13cmos5l_decap_8
XFILLER_343_63 VPWR VGND sg13cmos5l_decap_8
X_3171_ Tile_X0Y4_E6BEG[8] _4296_/X VPWR VGND sg13cmos5l_buf_1
X_0383_ _0383_/Q Tile_X0Y7_FrameData[0] VGND VPWR Tile_X0Y9_FrameStrobe[6] latch
XFILLER_490_91 VPWR VGND sg13cmos5l_decap_8
X_2122_ _2122_/Q Tile_X0Y4_FrameData[27] VGND VPWR Tile_X0Y9_FrameStrobe[6] latch
XFILLER_604_215 VPWR VGND sg13cmos5l_fill_2
XFILLER_81_215 VPWR VGND sg13cmos5l_fill_2
X_2053_ _2053_/Q Tile_X0Y4_FrameData[0] VGND VPWR Tile_X0Y9_FrameStrobe[3] latch
XFILLER_212_34 VPWR VGND sg13cmos5l_decap_8
XFILLER_281_154 VPWR VGND sg13cmos5l_decap_8
X_1004_ _1004_/Q Tile_X0Y0_FrameData[31] VGND VPWR Tile_X0Y9_FrameStrobe[2] latch
XFILLER_222_210 VPWR VGND sg13cmos5l_decap_8
XFILLER_34_142 VPWR VGND sg13cmos5l_fill_2
XFILLER_423_192 VPWR VGND sg13cmos5l_decap_4
XFILLER_288_49 VPWR VGND sg13cmos5l_decap_8
XFILLER_96_0 VPWR VGND sg13cmos5l_decap_8
XFILLER_649_70 VPWR VGND sg13cmos5l_decap_8
XFILLER_584_155 VPWR VGND sg13cmos5l_fill_2
X_2955_ Tile_X0Y8_EE4BEG[11] _4755_/X VPWR VGND sg13cmos5l_buf_1
XFILLER_585_14 VPWR VGND sg13cmos5l_decap_8
XANTENNA__3396__X Tile_X0Y2_E2BEGb[7] VPWR VGND sg13cmos5l_antennanp
XFILLER_336_100 VPWR VGND sg13cmos5l_decap_8
X_1906_ _1906_/Q Tile_X0Y3_FrameData[23] VGND VPWR Tile_X0Y9_FrameStrobe[7] latch
XFILLER_584_199 VPWR VGND sg13cmos5l_decap_4
X_2886_ Tile_X0Y6_FrameData_O[7] Tile_X0Y6_FrameData[7] VPWR VGND sg13cmos5l_buf_1
X_4625_ _4625_/X Tile_X0Y7_W2END[2] AXI_M_SOC_RDATA18 _4673_/X _4672_/X _0309_/Q _0308_/Q
+ VPWR VGND sg13cmos5l_mux4_1
X_1837_ _1837_/Q Tile_X0Y3_FrameData[28] VGND VPWR Tile_X0Y9_FrameStrobe[5] latch
XFILLER_518_63 VPWR VGND sg13cmos5l_decap_8
XFILLER_665_91 VPWR VGND sg13cmos5l_decap_8
XFILLER_686_207 VPWR VGND sg13cmos5l_fill_1
X_4556_ _4556_/X _4479_/X _4595_/X _4594_/X _4478_/X _2453_/Q _2452_/Q VPWR VGND sg13cmos5l_mux4_1
X_1768_ _1768_/Q Tile_X0Y3_FrameData[1] VGND VPWR Tile_X0Y9_FrameStrobe[2] latch
XFILLER_351_147 VPWR VGND sg13cmos5l_fill_1
XFILLER_639_112 VPWR VGND sg13cmos5l_decap_8
X_3507_ Tile_X0Y1_E2BEGb[5] _3945_/X VPWR VGND sg13cmos5l_buf_1
X_0719_ _0719_/Q Tile_X0Y9_FrameData[16] VGND VPWR Tile_X0Y9_FrameStrobe[1] latch
X_4487_ _4487_/X _4573_/X _4577_/X _4581_/X _4556_/X _2632_/Q _2631_/Q VPWR VGND sg13cmos5l_mux4_1
X_1699_ _1699_/Q Tile_X0Y3_FrameData[6] VGND VPWR Tile_X0Y9_FrameStrobe[0] latch
X_3438_ Tile_X0Y4_FrameData_O[29] Tile_X0Y4_FrameData[29] VPWR VGND sg13cmos5l_buf_1
XFILLER_639_189 VPWR VGND sg13cmos5l_fill_2
XFILLER_470_28 VPWR VGND sg13cmos5l_decap_8
X_3369_ Tile_X0Y2_EE4BEG[8] _4064_/X VPWR VGND sg13cmos5l_buf_1
XFILLER_66_28 VPWR VGND sg13cmos5l_decap_8
XFILLER_106_79 VPWR VGND sg13cmos5l_decap_8
XFILLER_403_44 VPWR VGND sg13cmos5l_fill_1
XFILLER_550_83 VPWR VGND sg13cmos5l_decap_8
XFILLER_550_94 VPWR VGND sg13cmos5l_fill_1
XFILLER_174_7 VPWR VGND sg13cmos5l_decap_8
XFILLER_700_42 VPWR VGND sg13cmos5l_decap_8
XFILLER_82_27 VPWR VGND sg13cmos5l_decap_8
XFILLER_414_170 VPWR VGND sg13cmos5l_decap_4
XFILLER_709_105 VPWR VGND sg13cmos5l_decap_8
XFILLER_341_7 VPWR VGND sg13cmos5l_decap_8
XFILLER_15_21 VPWR VGND sg13cmos5l_decap_8
XFILLER_439_7 VPWR VGND sg13cmos5l_decap_8
XFILLER_198_49 VPWR VGND sg13cmos5l_decap_8
XFILLER_575_133 VPWR VGND sg13cmos5l_decap_8
XFILLER_559_70 VPWR VGND sg13cmos5l_decap_8
XFILLER_40_134 VPWR VGND sg13cmos5l_decap_8
XFILLER_495_14 VPWR VGND sg13cmos5l_decap_8
XFILLER_374_217 VPWR VGND sg13cmos5l_fill_1
XFILLER_327_100 VPWR VGND sg13cmos5l_fill_1
XFILLER_606_7 VPWR VGND sg13cmos5l_decap_8
XFILLER_178_191 VPWR VGND sg13cmos5l_decap_8
XFILLER_709_84 VPWR VGND sg13cmos5l_decap_8
XFILLER_31_20 VPWR VGND sg13cmos5l_decap_8
XFILLER_327_155 VPWR VGND sg13cmos5l_decap_8
XFILLER_645_28 VPWR VGND sg13cmos5l_decap_8
XFILLER_428_63 VPWR VGND sg13cmos5l_decap_8
XFILLER_327_166 VPWR VGND sg13cmos5l_fill_2
XFILLER_193_161 VPWR VGND sg13cmos5l_decap_8
XFILLER_31_64 VPWR VGND sg13cmos5l_fill_1
XFILLER_193_172 VPWR VGND sg13cmos5l_fill_2
XFILLER_575_91 VPWR VGND sg13cmos5l_decap_8
XFILLER_147_42 VPWR VGND sg13cmos5l_fill_2
XFILLER_31_97 VPWR VGND sg13cmos5l_fill_1
XFILLER_208_2 VPWR VGND sg13cmos5l_fill_1
XFILLER_294_70 VPWR VGND sg13cmos5l_decap_8
XFILLER_342_169 VPWR VGND sg13cmos5l_decap_8
XFILLER_147_97 VPWR VGND sg13cmos5l_fill_1
XFILLER_496_140 VPWR VGND sg13cmos5l_decap_8
XFILLER_661_49 VPWR VGND sg13cmos5l_decap_8
XFILLER_645_126 VPWR VGND sg13cmos5l_decap_8
XFILLER_380_28 VPWR VGND sg13cmos5l_decap_8
XFILLER_298_0 VPWR VGND sg13cmos5l_decap_8
XFILLER_163_74 VPWR VGND sg13cmos5l_decap_8
XFILLER_660_107 VPWR VGND sg13cmos5l_fill_1
XFILLER_102_191 VPWR VGND sg13cmos5l_fill_2
XFILLER_452_210 VPWR VGND sg13cmos5l_decap_8
XFILLER_263_121 VPWR VGND sg13cmos5l_fill_2
XFILLER_465_0 VPWR VGND sg13cmos5l_decap_8
XFILLER_610_42 VPWR VGND sg13cmos5l_decap_8
XFILLER_632_0 VPWR VGND sg13cmos5l_decap_8
XFILLER_610_97 VPWR VGND sg13cmos5l_fill_1
XFILLER_686_35 VPWR VGND sg13cmos5l_decap_8
XFILLER_420_140 VPWR VGND sg13cmos5l_decap_8
XFILLER_566_133 VPWR VGND sg13cmos5l_decap_8
XFILLER_420_151 VPWR VGND sg13cmos5l_fill_1
XFILLER_420_173 VPWR VGND sg13cmos5l_decap_4
XFILLER_566_177 VPWR VGND sg13cmos5l_fill_1
XFILLER_365_217 VPWR VGND sg13cmos5l_fill_1
XFILLER_82_6 VPWR VGND sg13cmos5l_decap_8
XFILLER_176_139 VPWR VGND sg13cmos5l_fill_2
XFILLER_169_180 VPWR VGND sg13cmos5l_decap_4
X_2740_ Tile_X0Y4_E1BEG[3] _4255_/X VPWR VGND sg13cmos5l_buf_1
XFILLER_619_84 VPWR VGND sg13cmos5l_decap_8
XFILLER_318_133 VPWR VGND sg13cmos5l_fill_2
XFILLER_619_95 VPWR VGND sg13cmos5l_fill_2
XFILLER_581_169 VPWR VGND sg13cmos5l_decap_4
XFILLER_555_28 VPWR VGND sg13cmos5l_decap_8
X_2671_ _2671_/Q Tile_X0Y6_FrameData[24] VGND VPWR Tile_X0Y9_FrameStrobe[7] latch
XFILLER_318_166 VPWR VGND sg13cmos5l_decap_8
XFILLER_117_217 VPWR VGND sg13cmos5l_fill_1
XFILLER_184_172 VPWR VGND sg13cmos5l_decap_8
XFILLER_184_183 VPWR VGND sg13cmos5l_decap_4
X_4410_ _4410_/X AXI_M_SOC_RRESP0 _4456_/X _4460_/X _4432_/X _2283_/Q _2282_/Q VPWR
+ VGND sg13cmos5l_mux4_1
XFILLER_485_91 VPWR VGND sg13cmos5l_decap_8
XFILLER_338_96 VPWR VGND sg13cmos5l_decap_8
X_1622_ _1622_/Q Tile_X0Y2_FrameData[27] VGND VPWR Tile_X0Y9_FrameStrobe[6] latch
X_4341_ _4341_/X _4305_/X _0158_/X _4304_/X _0111_/X _1971_/Q _1970_/Q VPWR VGND sg13cmos5l_mux4_1
X_1553_ _1553_/Q Tile_X0Y2_FrameData[0] VGND VPWR Tile_X0Y9_FrameStrobe[3] latch
XFILLER_207_34 VPWR VGND sg13cmos5l_decap_8
X_0504_ _0504_/Q Tile_X0Y8_FrameData[7] VGND VPWR Tile_X0Y9_FrameStrobe[2] latch
XFILLER_98_145 VPWR VGND sg13cmos5l_fill_1
X_4272_ _4272_/X Tile_X0Y4_WW4END[15] AXI_M_SOC_BRESP0 _4351_/X _4312_/X _2069_/Q
+ _2068_/Q VPWR VGND sg13cmos5l_mux4_1
X_1484_ _1484_/Q Tile_X0Y2_FrameData[5] VGND VPWR Tile_X0Y9_FrameStrobe[1] latch
XFILLER_571_49 VPWR VGND sg13cmos5l_decap_8
XFILLER_354_84 VPWR VGND sg13cmos5l_decap_8
XFILLER_504_21 VPWR VGND sg13cmos5l_decap_8
XFILLER_636_126 VPWR VGND sg13cmos5l_decap_8
X_3223_ Tile_X0Y0_FrameStrobe_O[11] Tile_X0Y9_FrameStrobe[11] VPWR VGND sg13cmos5l_buf_1
XFILLER_290_28 VPWR VGND sg13cmos5l_decap_8
X_0435_ _0435_/Q Tile_X0Y8_FrameData[12] VGND VPWR Tile_X0Y9_FrameStrobe[0] latch
XFILLER_100_117 VPWR VGND sg13cmos5l_decap_8
XFILLER_239_162 VPWR VGND sg13cmos5l_decap_8
X_3154_ Tile_X0Y7_FrameData_O[24] Tile_X0Y7_FrameData[24] VPWR VGND sg13cmos5l_buf_1
X_0366_ _0366_/Q Tile_X0Y7_FrameData[17] VGND VPWR Tile_X0Y9_FrameStrobe[6] latch
XFILLER_504_98 VPWR VGND sg13cmos5l_decap_8
XFILLER_11_0 VPWR VGND sg13cmos5l_decap_8
X_2105_ _2105_/Q Tile_X0Y4_FrameData[12] VGND VPWR Tile_X0Y9_FrameStrobe[5] latch
XFILLER_254_132 VPWR VGND sg13cmos5l_decap_4
X_3085_ Tile_X0Y7_E1BEG[3] _4611_/X VPWR VGND sg13cmos5l_buf_1
X_0297_ _0297_/Q Tile_X0Y7_FrameData[22] VGND VPWR Tile_X0Y9_FrameStrobe[4] latch
XFILLER_520_42 VPWR VGND sg13cmos5l_decap_8
X_2036_ _2036_/Q Tile_X0Y4_FrameData[17] VGND VPWR Tile_X0Y9_FrameStrobe[3] latch
XFILLER_596_35 VPWR VGND sg13cmos5l_decap_8
X_3987_ _3987_/X Tile_X0Y2_W1END[3] Tile_X0Y2_W6END[7] _4104_/X _4087_/X _1667_/Q
+ _1666_/Q VPWR VGND sg13cmos5l_mux4_1
XFILLER_596_79 VPWR VGND sg13cmos5l_decap_4
XFILLER_356_217 VPWR VGND sg13cmos5l_fill_1
XFILLER_706_119 VPWR VGND sg13cmos5l_decap_8
X_2938_ Tile_X0Y8_E6BEG[6] _4766_/X VPWR VGND sg13cmos5l_buf_1
XFILLER_572_147 VPWR VGND sg13cmos5l_decap_8
XFILLER_465_28 VPWR VGND sg13cmos5l_decap_8
X_2869_ Tile_X0Y6_EE4BEG[6] _4518_/X VPWR VGND sg13cmos5l_buf_1
XFILLER_175_172 VPWR VGND sg13cmos5l_decap_8
X_4608_ _4608_/X _4661_/X _4660_/X AXI_M_SOC_RDATA19 AXI_M_SOC_RDATA23 _0343_/Q _0342_/Q
+ VPWR VGND sg13cmos5l_mux4_1
XFILLER_714_196 VPWR VGND sg13cmos5l_decap_4
X_4539_ _4539_/X AXI_M_SOC_RDATA31 _4568_/X _4572_/X _4552_/X _2529_/Q _2528_/Q VPWR
+ VGND sg13cmos5l_mux4_1
XFILLER_89_123 VPWR VGND sg13cmos5l_decap_4
XFILLER_77_27 VPWR VGND sg13cmos5l_decap_8
XFILLER_481_49 VPWR VGND sg13cmos5l_decap_8
XFILLER_264_84 VPWR VGND sg13cmos5l_decap_8
XFILLER_478_195 VPWR VGND sg13cmos5l_decap_4
XFILLER_414_21 VPWR VGND sg13cmos5l_decap_8
XFILLER_291_7 VPWR VGND sg13cmos5l_decap_8
XFILLER_493_154 VPWR VGND sg13cmos5l_decap_8
XFILLER_389_7 VPWR VGND sg13cmos5l_decap_8
XFILLER_493_198 VPWR VGND sg13cmos5l_decap_8
XFILLER_711_63 VPWR VGND sg13cmos5l_decap_8
XFILLER_556_7 VPWR VGND sg13cmos5l_decap_8
XFILLER_650_140 VPWR VGND sg13cmos5l_decap_8
XFILLER_430_42 VPWR VGND sg13cmos5l_decap_8
XFILLER_260_102 VPWR VGND sg13cmos5l_fill_1
XFILLER_245_176 VPWR VGND sg13cmos5l_decap_8
XFILLER_26_42 VPWR VGND sg13cmos5l_decap_8
XFILLER_260_124 VPWR VGND sg13cmos5l_fill_2
XFILLER_595_217 VPWR VGND sg13cmos5l_fill_1
XANTENNA__2933__X Tile_X0Y8_E6BEG[1] VPWR VGND sg13cmos5l_antennanp
XFILLER_13_112 VPWR VGND sg13cmos5l_fill_2
XFILLER_289_70 VPWR VGND sg13cmos5l_decap_8
XFILLER_402_162 VPWR VGND sg13cmos5l_decap_8
XFILLER_548_188 VPWR VGND sg13cmos5l_decap_8
XFILLER_42_30 VPWR VGND sg13cmos5l_decap_8
XFILLER_656_49 VPWR VGND sg13cmos5l_decap_8
XFILLER_586_90 VPWR VGND sg13cmos5l_fill_2
XFILLER_362_209 VPWR VGND sg13cmos5l_fill_1
XFILLER_375_28 VPWR VGND sg13cmos5l_decap_8
XFILLER_158_74 VPWR VGND sg13cmos5l_decap_4
XFILLER_504_203 VPWR VGND sg13cmos5l_decap_8
XFILLER_213_0 VPWR VGND sg13cmos5l_decap_8
XFILLER_181_120 VPWR VGND sg13cmos5l_decap_4
XFILLER_605_42 VPWR VGND sg13cmos5l_decap_8
XFILLER_330_139 VPWR VGND sg13cmos5l_decap_8
XFILLER_582_0 VPWR VGND sg13cmos5l_decap_8
XFILLER_3_35 VPWR VGND sg13cmos5l_decap_8
XFILLER_324_21 VPWR VGND sg13cmos5l_decap_8
XFILLER_484_154 VPWR VGND sg13cmos5l_fill_1
X_0220_ _0220_/Q Tile_X0Y7_FrameData[3] VGND VPWR Tile_X0Y9_FrameStrobe[1] latch
XFILLER_236_132 VPWR VGND sg13cmos5l_decap_8
X_0151_ AXI_M_SOC_AWLEN2 _0940_/Q _3673_/X VPWR VGND sg13cmos5l_nor2b_1
XFILLER_621_63 VPWR VGND sg13cmos5l_decap_8
XFILLER_641_140 VPWR VGND sg13cmos5l_decap_8
XANTENNA__3004__X Tile_X0Y5_E2BEG[7] VPWR VGND sg13cmos5l_antennanp
XFILLER_340_42 VPWR VGND sg13cmos5l_decap_8
XFILLER_251_113 VPWR VGND sg13cmos5l_fill_1
XFILLER_397_106 VPWR VGND sg13cmos5l_decap_8
X_0082_ _0082_/X _4910_/X _4911_/X _2374_/Q VPWR VGND sg13cmos5l_mux2_1
XFILLER_586_206 VPWR VGND sg13cmos5l_decap_4
XFILLER_586_217 VPWR VGND sg13cmos5l_fill_1
XFILLER_251_135 VPWR VGND sg13cmos5l_decap_8
XFILLER_697_56 VPWR VGND sg13cmos5l_decap_8
XANTENNA__2843__X Tile_X0Y6_E2BEGb[0] VPWR VGND sg13cmos5l_antennanp
X_3910_ _3910_/X Tile_X0Y1_W1END[0] Tile_X0Y1_WW4END[0] Tile_X0Y1_W6END[8] _4008_/X
+ _1401_/Q _1400_/Q VPWR VGND sg13cmos5l_mux4_1
XFILLER_83_92 VPWR VGND sg13cmos5l_decap_8
X_4890_ _4890_/X AXI_M_SOC_RDATA6 _4917_/X _4921_/X _4902_/X _0763_/Q _0762_/Q VPWR
+ VGND sg13cmos5l_mux4_1
XFILLER_199_70 VPWR VGND sg13cmos5l_decap_8
XFILLER_199_81 VPWR VGND sg13cmos5l_fill_1
X_3841_ _3841_/X Tile_X0Y0_W6END[1] _3887_/X _3868_/X _3855_/X _1023_/Q _1022_/Q VPWR
+ VGND sg13cmos5l_mux4_1
XFILLER_539_166 VPWR VGND sg13cmos5l_fill_2
XFILLER_149_128 VPWR VGND sg13cmos5l_decap_8
X_3772_ _3772_/X Tile_X0Y0_WW4END[1] Tile_X0Y0_WW4END[9] Tile_X0Y0_W6END[1] _3882_/X
+ _1007_/Q _1006_/Q VPWR VGND sg13cmos5l_mux4_1
XFILLER_554_136 VPWR VGND sg13cmos5l_decap_4
X_0984_ _0984_/Q Tile_X0Y0_FrameData[19] VGND VPWR Tile_X0Y9_FrameStrobe[1] latch
XFILLER_566_49 VPWR VGND sg13cmos5l_decap_8
XFILLER_554_147 VPWR VGND sg13cmos5l_decap_4
XFILLER_349_84 VPWR VGND sg13cmos5l_decap_8
X_2723_ _4540_/A3 VPWR VGND sg13cmos5l_tielo
XFILLER_285_28 VPWR VGND sg13cmos5l_decap_8
XFILLER_172_120 VPWR VGND sg13cmos5l_decap_8
X_2654_ _2654_/Q Tile_X0Y6_FrameData[9] VGND VPWR Tile_X0Y9_FrameStrobe[6] latch
XFILLER_711_133 VPWR VGND sg13cmos5l_decap_8
XFILLER_59_0 VPWR VGND sg13cmos5l_fill_2
XFILLER_306_169 VPWR VGND sg13cmos5l_fill_2
X_1605_ _1605_/Q Tile_X0Y2_FrameData[12] VGND VPWR Tile_X0Y9_FrameStrobe[5] latch
XFILLER_218_77 VPWR VGND sg13cmos5l_fill_1
X_2585_ _2585_/Q Tile_X0Y6_FrameData[14] VGND VPWR Tile_X0Y9_FrameStrobe[4] latch
X_4324_ _4324_/X Tile_X0Y0_W1END[1] Tile_X0Y0_WW4END[13] Tile_X0Y0_W6END[5] _3882_/X
+ _1114_/Q _1113_/Q VPWR VGND sg13cmos5l_mux4_1
XFILLER_515_42 VPWR VGND sg13cmos5l_decap_8
XFILLER_259_213 VPWR VGND sg13cmos5l_decap_4
X_1536_ _1536_/Q Tile_X0Y2_FrameData[17] VGND VPWR Tile_X0Y9_FrameStrobe[3] latch
XFILLER_662_70 VPWR VGND sg13cmos5l_decap_8
XFILLER_234_21 VPWR VGND sg13cmos5l_decap_8
X_4255_ _4255_/X _4311_/X _4310_/X AXI_M_SOC_BRESP0 _4309_/X _2103_/Q _2102_/Q VPWR
+ VGND sg13cmos5l_mux4_1
XFILLER_609_148 VPWR VGND sg13cmos5l_fill_1
XFILLER_86_126 VPWR VGND sg13cmos5l_decap_8
X_1467_ _1467_/Q Tile_X0Y2_FrameData[22] VGND VPWR Tile_X0Y9_FrameStrobe[1] latch
X_3206_ Tile_X0Y0_N2BEG[6] _3790_/X VPWR VGND sg13cmos5l_buf_1
X_0418_ _0418_/Q Tile_X0Y8_FrameData[29] VGND VPWR Tile_X0Y9_FrameStrobe[0] latch
X_4186_ _4186_/X AXI_M_SOC_WREADY _4227_/X _4231_/X _4209_/X _1769_/Q _1768_/Q VPWR
+ VGND sg13cmos5l_mux4_1
X_1398_ _1398_/Q Tile_X0Y1_FrameData[3] VGND VPWR Tile_X0Y9_FrameStrobe[6] latch
X_3137_ Tile_X0Y7_FrameData_O[7] Tile_X0Y7_FrameData[7] VPWR VGND sg13cmos5l_buf_1
X_0349_ _0349_/Q Tile_X0Y7_FrameData[2] VGND VPWR Tile_X0Y9_FrameStrobe[5] latch
XFILLER_103_14 VPWR VGND sg13cmos5l_decap_8
XFILLER_94_181 VPWR VGND sg13cmos5l_decap_8
XFILLER_250_42 VPWR VGND sg13cmos5l_decap_8
XFILLER_632_151 VPWR VGND sg13cmos5l_decap_4
XFILLER_632_162 VPWR VGND sg13cmos5l_decap_4
XFILLER_242_113 VPWR VGND sg13cmos5l_decap_8
X_3068_ Tile_X0Y5_FrameData_O[27] Tile_X0Y5_FrameData[27] VPWR VGND sg13cmos5l_buf_1
XFILLER_577_217 VPWR VGND sg13cmos5l_fill_1
XANTENNA__2753__X Tile_X0Y3_FrameData_O[11] VPWR VGND sg13cmos5l_antennanp
X_2019_ _2019_/Q Tile_X0Y4_FrameData[2] VGND VPWR Tile_X0Y9_FrameStrobe[2] latch
XFILLER_137_7 VPWR VGND sg13cmos5l_decap_8
XFILLER_409_21 VPWR VGND sg13cmos5l_decap_8
XFILLER_195_28 VPWR VGND sg13cmos5l_decap_8
XFILLER_6_119 VPWR VGND sg13cmos5l_fill_2
XANTENNA__3584__X Tile_X0Y9_FrameData_O[14] VPWR VGND sg13cmos5l_antennanp
XFILLER_560_128 VPWR VGND sg13cmos5l_decap_8
XFILLER_560_139 VPWR VGND sg13cmos5l_fill_1
XFILLER_304_7 VPWR VGND sg13cmos5l_decap_8
XFILLER_163_131 VPWR VGND sg13cmos5l_decap_8
XFILLER_12_77 VPWR VGND sg13cmos5l_decap_8
XFILLER_706_63 VPWR VGND sg13cmos5l_decap_8
XFILLER_501_217 VPWR VGND sg13cmos5l_fill_1
XFILLER_425_42 VPWR VGND sg13cmos5l_decap_8
XFILLER_572_70 VPWR VGND sg13cmos5l_decap_8
XFILLER_466_110 VPWR VGND sg13cmos5l_decap_4
XFILLER_77_115 VPWR VGND sg13cmos5l_decap_8
XFILLER_673_7 VPWR VGND sg13cmos5l_decap_8
XANTENNA__2928__X Tile_X0Y8_E2BEGb[4] VPWR VGND sg13cmos5l_antennanp
XFILLER_670_213 VPWR VGND sg13cmos5l_decap_4
XFILLER_18_204 VPWR VGND sg13cmos5l_decap_8
XFILLER_441_63 VPWR VGND sg13cmos5l_decap_8
XFILLER_37_41 VPWR VGND sg13cmos5l_decap_8
XFILLER_280_208 VPWR VGND sg13cmos5l_fill_1
XFILLER_218_154 VPWR VGND sg13cmos5l_fill_2
XFILLER_85_181 VPWR VGND sg13cmos5l_fill_2
XFILLER_623_140 VPWR VGND sg13cmos5l_fill_1
XFILLER_623_162 VPWR VGND sg13cmos5l_decap_8
XFILLER_233_113 VPWR VGND sg13cmos5l_decap_8
XFILLER_163_0 VPWR VGND sg13cmos5l_decap_8
XANTENNA__3759__X AXI_M_SOC_ARADDR31 VPWR VGND sg13cmos5l_antennanp
XFILLER_310_45 VPWR VGND sg13cmos5l_decap_8
XFILLER_310_56 VPWR VGND sg13cmos5l_fill_1
XFILLER_310_78 VPWR VGND sg13cmos5l_decap_8
XFILLER_667_59 VPWR VGND sg13cmos5l_decap_8
XFILLER_53_73 VPWR VGND sg13cmos5l_decap_8
XFILLER_330_0 VPWR VGND sg13cmos5l_decap_8
XFILLER_169_40 VPWR VGND sg13cmos5l_decap_8
XFILLER_428_0 VPWR VGND sg13cmos5l_decap_8
XFILLER_386_49 VPWR VGND sg13cmos5l_decap_8
XFILLER_319_21 VPWR VGND sg13cmos5l_decap_8
XFILLER_139_161 VPWR VGND sg13cmos5l_decap_8
XFILLER_683_14 VPWR VGND sg13cmos5l_decap_8
XFILLER_551_106 VPWR VGND sg13cmos5l_decap_4
XANTENNA__3494__X Tile_X0Y1_E6BEG[4] VPWR VGND sg13cmos5l_antennanp
XFILLER_616_63 VPWR VGND sg13cmos5l_decap_8
XFILLER_335_42 VPWR VGND sg13cmos5l_decap_8
X_2370_ _2370_/Q Tile_X0Y5_FrameData[3] VGND VPWR Tile_X0Y9_FrameStrobe[5] latch
XFILLER_482_70 VPWR VGND sg13cmos5l_decap_8
XFILLER_646_210 VPWR VGND sg13cmos5l_decap_8
XFILLER_78_70 VPWR VGND sg13cmos5l_decap_8
X_1321_ _1321_/Q Tile_X0Y1_FrameData[16] VGND VPWR Tile_X0Y9_FrameStrobe[4] latch
XFILLER_335_97 VPWR VGND sg13cmos5l_decap_4
XFILLER_311_150 VPWR VGND sg13cmos5l_fill_1
XANTENNA__2838__X Tile_X0Y6_E2BEG[3] VPWR VGND sg13cmos5l_antennanp
XFILLER_457_143 VPWR VGND sg13cmos5l_decap_8
XFILLER_78_92 VPWR VGND sg13cmos5l_decap_4
XFILLER_457_154 VPWR VGND sg13cmos5l_fill_1
XFILLER_311_172 VPWR VGND sg13cmos5l_decap_4
XFILLER_256_205 VPWR VGND sg13cmos5l_decap_4
XFILLER_68_148 VPWR VGND sg13cmos5l_decap_8
XFILLER_457_176 VPWR VGND sg13cmos5l_fill_2
X_4040_ _4040_/X Tile_X0Y2_W2MID[7] AXI_M_SOC_AWREADY _4097_/X _4096_/X _1593_/Q _1592_/Q
+ VPWR VGND sg13cmos5l_mux4_1
X_1252_ _1252_/Q Tile_X0Y1_FrameData[21] VGND VPWR Tile_X0Y9_FrameStrobe[2] latch
XFILLER_472_113 VPWR VGND sg13cmos5l_decap_8
XFILLER_632_84 VPWR VGND sg13cmos5l_decap_8
XFILLER_606_129 VPWR VGND sg13cmos5l_fill_1
XFILLER_204_35 VPWR VGND sg13cmos5l_decap_8
X_0203_ _0203_/Q Tile_X0Y7_FrameData[20] VGND VPWR Tile_X0Y9_FrameStrobe[1] latch
XFILLER_351_63 VPWR VGND sg13cmos5l_decap_8
X_1183_ _1183_/Q Tile_X0Y1_FrameData[26] VGND VPWR Tile_X0Y9_FrameStrobe[0] latch
XFILLER_209_154 VPWR VGND sg13cmos5l_decap_4
X_0134_ AXI_M_SOC_AWLEN4 _0940_/Q _3675_/X VPWR VGND sg13cmos5l_nor2b_1
XFILLER_91_151 VPWR VGND sg13cmos5l_decap_4
XANTENNA__3669__X AXI_M_SOC_AWADDR30 VPWR VGND sg13cmos5l_antennanp
XFILLER_501_77 VPWR VGND sg13cmos5l_decap_8
X_0065_ _3627_/A _4602_/X _4603_/X _0350_/Q VPWR VGND sg13cmos5l_mux2_1
XFILLER_224_179 VPWR VGND sg13cmos5l_fill_2
XFILLER_220_56 VPWR VGND sg13cmos5l_decap_8
XFILLER_378_161 VPWR VGND sg13cmos5l_decap_8
X_4873_ _4873_/X Tile_X0Y9_WW4END[6] AXI_M_SOC_RDATA6 _4922_/X _4902_/X _0797_/Q _0796_/Q
+ VPWR VGND sg13cmos5l_mux4_1
X_3824_ _3824_/X Tile_X0Y0_WW4END[8] Tile_X0Y0_WW4END[11] _3864_/X _3859_/X _1057_/Q
+ _1056_/Q VPWR VGND sg13cmos5l_mux4_1
XFILLER_393_142 VPWR VGND sg13cmos5l_decap_4
XFILLER_296_49 VPWR VGND sg13cmos5l_decap_8
XFILLER_657_70 VPWR VGND sg13cmos5l_decap_8
XFILLER_229_21 VPWR VGND sg13cmos5l_decap_8
X_3755_ AXI_M_SOC_ARADDR27 Tile_X0Y8_WW4END[3] Tile_X0Y8_WW4END[11] Tile_X0Y8_W6END[11]
+ _4811_/X _0481_/Q _0480_/Q VPWR VGND sg13cmos5l_mux4_1
XFILLER_593_14 VPWR VGND sg13cmos5l_decap_8
X_0967_ _0967_/Q Tile_X0Y0_FrameData[4] VGND VPWR Tile_X0Y9_FrameStrobe[0] latch
XFILLER_145_120 VPWR VGND sg13cmos5l_fill_2
X_2706_ _4198_/A3 VPWR VGND sg13cmos5l_tielo
XFILLER_376_82 VPWR VGND sg13cmos5l_decap_8
X_3686_ _3686_/X Tile_X0Y3_WW4END[4] Tile_X0Y3_WW4END[12] Tile_X0Y3_W6END[4] _4226_/X
+ _1749_/Q _1748_/Q VPWR VGND sg13cmos5l_mux4_1
XFILLER_229_98 VPWR VGND sg13cmos5l_fill_2
X_0898_ _0898_/Q Tile_X0Y9_FrameData[29] VGND VPWR Tile_X0Y9_FrameStrobe[7] latch
X_2637_ _2637_/Q Tile_X0Y6_FrameData[26] VGND VPWR Tile_X0Y9_FrameStrobe[6] latch
XFILLER_245_20 VPWR VGND sg13cmos5l_decap_8
XFILLER_160_112 VPWR VGND sg13cmos5l_decap_8
X_2568_ _2568_/Q Tile_X0Y6_FrameData[31] VGND VPWR Tile_X0Y9_FrameStrobe[4] latch
XFILLER_448_110 VPWR VGND sg13cmos5l_decap_8
XANTENNA__2748__X Tile_X0Y3_FrameData_O[6] VPWR VGND sg13cmos5l_antennanp
X_1519_ _1519_/Q Tile_X0Y2_FrameData[2] VGND VPWR Tile_X0Y9_FrameStrobe[2] latch
X_4307_ _4307_/X Tile_X0Y3_W1END[2] Tile_X0Y3_W6END[10] _4215_/X _4192_/X _1885_/Q
+ _1884_/Q VPWR VGND sg13cmos5l_mux4_1
XFILLER_59_126 VPWR VGND sg13cmos5l_fill_2
X_2499_ _2499_/Q Tile_X0Y6_FrameData[4] VGND VPWR Tile_X0Y9_FrameStrobe[1] latch
XFILLER_302_183 VPWR VGND sg13cmos5l_decap_8
X_4238_ _4238_/X Tile_X0Y2_W2MID[6] Tile_X0Y2_W2END[6] Tile_X0Y2_W6END[9] _4099_/X
+ _1627_/Q _1626_/Q VPWR VGND sg13cmos5l_mux4_1
XFILLER_114_13 VPWR VGND sg13cmos5l_decap_8
XFILLER_74_129 VPWR VGND sg13cmos5l_decap_8
XFILLER_261_63 VPWR VGND sg13cmos5l_decap_8
X_4169_ _4169_/X Tile_X0Y3_WW4END[10] AXI_M_SOC_BVALID _4232_/X _4209_/X _1803_/Q
+ _1802_/Q VPWR VGND sg13cmos5l_mux4_1
XFILLER_74_28 VPWR VGND sg13cmos5l_decap_8
XFILLER_114_79 VPWR VGND sg13cmos5l_decap_8
XFILLER_74_39 VPWR VGND sg13cmos5l_fill_1
XANTENNA__3579__X Tile_X0Y9_FrameData_O[9] VPWR VGND sg13cmos5l_antennanp
XFILLER_411_77 VPWR VGND sg13cmos5l_decap_4
XFILLER_620_143 VPWR VGND sg13cmos5l_decap_8
XFILLER_254_7 VPWR VGND sg13cmos5l_decap_8
XFILLER_215_179 VPWR VGND sg13cmos5l_decap_4
XFILLER_130_56 VPWR VGND sg13cmos5l_decap_8
XFILLER_230_127 VPWR VGND sg13cmos5l_decap_8
XFILLER_90_49 VPWR VGND sg13cmos5l_decap_8
XFILLER_518_103 VPWR VGND sg13cmos5l_decap_8
XFILLER_421_7 VPWR VGND sg13cmos5l_decap_8
XFILLER_369_194 VPWR VGND sg13cmos5l_decap_8
XFILLER_23_21 VPWR VGND sg13cmos5l_decap_8
XFILLER_519_7 VPWR VGND sg13cmos5l_decap_8
XFILLER_567_70 VPWR VGND sg13cmos5l_decap_8
XFILLER_139_21 VPWR VGND sg13cmos5l_decap_8
XFILLER_183_215 VPWR VGND sg13cmos5l_fill_2
XFILLER_384_186 VPWR VGND sg13cmos5l_decap_8
XFILLER_717_51 VPWR VGND sg13cmos5l_decap_8
XFILLER_526_180 VPWR VGND sg13cmos5l_fill_1
XFILLER_717_73 VPWR VGND sg13cmos5l_decap_4
XFILLER_139_98 VPWR VGND sg13cmos5l_decap_8
XFILLER_717_84 VPWR VGND sg13cmos5l_fill_1
XFILLER_717_95 VPWR VGND sg13cmos5l_decap_8
XFILLER_436_41 VPWR VGND sg13cmos5l_decap_8
XFILLER_687_132 VPWR VGND sg13cmos5l_fill_1
XFILLER_653_28 VPWR VGND sg13cmos5l_decap_8
XFILLER_151_101 VPWR VGND sg13cmos5l_decap_8
XFILLER_136_175 VPWR VGND sg13cmos5l_decap_4
XFILLER_687_154 VPWR VGND sg13cmos5l_decap_8
XFILLER_583_91 VPWR VGND sg13cmos5l_decap_8
XFILLER_2_144 VPWR VGND sg13cmos5l_decap_4
XFILLER_439_121 VPWR VGND sg13cmos5l_decap_8
XFILLER_439_132 VPWR VGND sg13cmos5l_fill_2
XFILLER_602_21 VPWR VGND sg13cmos5l_decap_8
XFILLER_280_0 VPWR VGND sg13cmos5l_decap_8
XFILLER_48_95 VPWR VGND sg13cmos5l_decap_8
XFILLER_378_0 VPWR VGND sg13cmos5l_decap_8
XFILLER_171_63 VPWR VGND sg13cmos5l_decap_8
XFILLER_0_14 VPWR VGND sg13cmos5l_decap_8
XFILLER_678_14 VPWR VGND sg13cmos5l_decap_8
XFILLER_545_0 VPWR VGND sg13cmos5l_decap_8
XANTENNA__3489__X Tile_X0Y1_EE4BEG[15] VPWR VGND sg13cmos5l_antennanp
XFILLER_64_72 VPWR VGND sg13cmos5l_decap_8
XFILLER_712_0 VPWR VGND sg13cmos5l_decap_8
XFILLER_509_125 VPWR VGND sg13cmos5l_fill_1
XFILLER_9_56 VPWR VGND sg13cmos5l_decap_8
X_1870_ _1870_/Q Tile_X0Y3_FrameData[27] VGND VPWR Tile_X0Y9_FrameStrobe[6] latch
XFILLER_694_35 VPWR VGND sg13cmos5l_decap_8
XFILLER_509_147 VPWR VGND sg13cmos5l_decap_8
XFILLER_80_60 VPWR VGND sg13cmos5l_fill_2
X_0821_ _0821_/Q Tile_X0Y9_FrameData[10] VGND VPWR Tile_X0Y9_FrameStrobe[4] latch
XFILLER_390_101 VPWR VGND sg13cmos5l_decap_4
XFILLER_713_217 VPWR VGND sg13cmos5l_fill_1
XFILLER_524_128 VPWR VGND sg13cmos5l_fill_1
X_3540_ Tile_X0Y9_E2BEGb[6] _4862_/X VPWR VGND sg13cmos5l_buf_1
X_0752_ _0752_/Q Tile_X0Y9_FrameData[15] VGND VPWR Tile_X0Y9_FrameStrobe[2] latch
XFILLER_627_84 VPWR VGND sg13cmos5l_decap_8
XFILLER_390_156 VPWR VGND sg13cmos5l_decap_4
XFILLER_390_189 VPWR VGND sg13cmos5l_decap_8
X_3471_ Tile_X0Y1_FrameData_O[29] Tile_X0Y1_FrameData[29] VPWR VGND sg13cmos5l_buf_1
XFILLER_563_28 VPWR VGND sg13cmos5l_decap_8
XFILLER_346_63 VPWR VGND sg13cmos5l_decap_8
X_0683_ _0683_/Q Tile_X0Y9_FrameData[20] VGND VPWR Tile_X0Y9_FrameStrobe[0] latch
XFILLER_493_91 VPWR VGND sg13cmos5l_decap_8
X_2422_ _2422_/Q Tile_X0Y5_FrameData[15] VGND VPWR Tile_X0Y9_FrameStrobe[7] latch
XFILLER_288_127 VPWR VGND sg13cmos5l_decap_8
XFILLER_693_146 VPWR VGND sg13cmos5l_decap_8
X_2353_ _2353_/Q Tile_X0Y5_FrameData[20] VGND VPWR Tile_X0Y9_FrameStrobe[5] latch
XFILLER_215_56 VPWR VGND sg13cmos5l_decap_8
X_1304_ _1304_/Q Tile_X0Y1_FrameData[1] VGND VPWR Tile_X0Y9_FrameStrobe[3] latch
X_2284_ _2284_/Q Tile_X0Y5_FrameData[25] VGND VPWR Tile_X0Y9_FrameStrobe[3] latch
XFILLER_512_21 VPWR VGND sg13cmos5l_decap_8
X_4023_ _4023_/X Tile_X0Y3_W2MID[6] Tile_X0Y3_W2END[6] Tile_X0Y3_W6END[6] _4207_/X
+ _1915_/Q _1914_/Q VPWR VGND sg13cmos5l_mux4_1
X_1235_ _1235_/Q Tile_X0Y1_FrameData[6] VGND VPWR Tile_X0Y9_FrameStrobe[1] latch
XFILLER_445_157 VPWR VGND sg13cmos5l_fill_1
XFILLER_460_105 VPWR VGND sg13cmos5l_decap_4
XFILLER_445_179 VPWR VGND sg13cmos5l_decap_8
X_1166_ _1166_/Q Tile_X0Y0_FrameData[29] VGND VPWR Tile_X0Y9_FrameStrobe[7] latch
XFILLER_588_14 VPWR VGND sg13cmos5l_decap_8
XFILLER_512_98 VPWR VGND sg13cmos5l_decap_8
XFILLER_398_201 VPWR VGND sg13cmos5l_fill_1
XANTENNA__3399__X Tile_X0Y2_E2BEG[2] VPWR VGND sg13cmos5l_antennanp
X_0117_ AXI_M_SOC_ARCACHE0 _3774_/X _0929_/Q VPWR VGND sg13cmos5l_or2_1
XFILLER_64_195 VPWR VGND sg13cmos5l_decap_8
X_1097_ _1097_/Q Tile_X0Y0_FrameData[2] VGND VPWR Tile_X0Y9_FrameStrobe[4] latch
XFILLER_401_205 VPWR VGND sg13cmos5l_fill_1
XFILLER_602_165 VPWR VGND sg13cmos5l_fill_1
X_0048_ AXI_M_SOC_AWCACHE1 _0936_/Q _3686_/X VPWR VGND sg13cmos5l_or2_1
X_4925_ _4925_/X Tile_X0Y9_N1END[1] Tile_X0Y9_N4END[1] _4897_/X _0082_/X _0709_/Q
+ _0708_/Q VPWR VGND sg13cmos5l_mux4_1
XFILLER_602_198 VPWR VGND sg13cmos5l_fill_1
XFILLER_100_48 VPWR VGND sg13cmos5l_decap_8
X_4856_ _4856_/X Tile_X0Y9_W2END[7] AXI_M_SOC_RDATA7 _4901_/X _4900_/X _0831_/Q _0830_/Q
+ VPWR VGND sg13cmos5l_mux4_1
XFILLER_165_215 VPWR VGND sg13cmos5l_fill_2
X_3807_ _3807_/X Tile_X0Y0_W2MID[4] Tile_X0Y0_WW4END[1] _3859_/X _3858_/X _1091_/Q
+ _1090_/Q VPWR VGND sg13cmos5l_mux4_1
XFILLER_515_117 VPWR VGND sg13cmos5l_decap_8
X_1999_ _1999_/Q Tile_X0Y4_FrameData[22] VGND VPWR Tile_X0Y9_FrameStrobe[2] latch
X_4787_ _4787_/X _4703_/X Tile_X0Y9_N2MID[1] _4817_/X _4702_/X _0437_/Q _0436_/Q VPWR
+ VGND sg13cmos5l_mux4_1
XFILLER_381_123 VPWR VGND sg13cmos5l_decap_8
XFILLER_366_197 VPWR VGND sg13cmos5l_decap_8
X_3738_ AXI_M_SOC_ARADDR10 Tile_X0Y9_WW4END[2] Tile_X0Y9_WW4END[10] Tile_X0Y9_W6END[10]
+ _4926_/X _0739_/Q _0738_/Q VPWR VGND sg13cmos5l_mux4_1
XFILLER_669_121 VPWR VGND sg13cmos5l_fill_1
XFILLER_381_178 VPWR VGND sg13cmos5l_decap_8
XFILLER_473_28 VPWR VGND sg13cmos5l_decap_8
XFILLER_133_112 VPWR VGND sg13cmos5l_decap_8
XFILLER_109_68 VPWR VGND sg13cmos5l_decap_8
X_3669_ AXI_M_SOC_AWADDR30 Tile_X0Y4_W1END[2] Tile_X0Y4_WW4END[6] Tile_X0Y4_WW4END[14]
+ _4350_/X _1985_/Q _1984_/Q VPWR VGND sg13cmos5l_mux4_1
XFILLER_69_39 VPWR VGND sg13cmos5l_decap_8
XFILLER_468_216 VPWR VGND sg13cmos5l_fill_2
XFILLER_523_194 VPWR VGND sg13cmos5l_decap_8
XFILLER_287_160 VPWR VGND sg13cmos5l_decap_8
XFILLER_703_42 VPWR VGND sg13cmos5l_decap_8
XFILLER_436_113 VPWR VGND sg13cmos5l_decap_8
XFILLER_272_84 VPWR VGND sg13cmos5l_decap_8
XFILLER_422_21 VPWR VGND sg13cmos5l_decap_8
XFILLER_85_49 VPWR VGND sg13cmos5l_decap_8
XFILLER_371_7 VPWR VGND sg13cmos5l_decap_8
XFILLER_18_21 VPWR VGND sg13cmos5l_decap_8
XFILLER_469_7 VPWR VGND sg13cmos5l_decap_8
XFILLER_640_205 VPWR VGND sg13cmos5l_fill_1
XFILLER_640_216 VPWR VGND sg13cmos5l_fill_2
XFILLER_597_109 VPWR VGND sg13cmos5l_fill_2
XFILLER_422_98 VPWR VGND sg13cmos5l_decap_8
XFILLER_498_14 VPWR VGND sg13cmos5l_decap_8
XFILLER_141_55 VPWR VGND sg13cmos5l_decap_8
XFILLER_141_66 VPWR VGND sg13cmos5l_fill_1
XFILLER_636_7 VPWR VGND sg13cmos5l_decap_8
XFILLER_141_88 VPWR VGND sg13cmos5l_decap_8
XFILLER_55_195 VPWR VGND sg13cmos5l_decap_8
XFILLER_203_105 VPWR VGND sg13cmos5l_decap_8
XANTENNA__3102__X Tile_X0Y7_E6BEG[0] VPWR VGND sg13cmos5l_antennanp
XFILLER_70_143 VPWR VGND sg13cmos5l_decap_8
XFILLER_34_20 VPWR VGND sg13cmos5l_decap_8
XFILLER_648_28 VPWR VGND sg13cmos5l_decap_8
XFILLER_578_91 VPWR VGND sg13cmos5l_decap_8
XFILLER_11_210 VPWR VGND sg13cmos5l_fill_1
XANTENNA__2941__X Tile_X0Y8_E6BEG[9] VPWR VGND sg13cmos5l_antennanp
XFILLER_238_2 VPWR VGND sg13cmos5l_fill_1
XFILLER_297_70 VPWR VGND sg13cmos5l_decap_8
XFILLER_211_182 VPWR VGND sg13cmos5l_decap_4
XFILLER_7_203 VPWR VGND sg13cmos5l_decap_8
XFILLER_357_175 VPWR VGND sg13cmos5l_decap_8
XFILLER_50_30 VPWR VGND sg13cmos5l_decap_8
XFILLER_126_0 VPWR VGND sg13cmos5l_decap_8
XFILLER_372_156 VPWR VGND sg13cmos5l_fill_1
XFILLER_664_49 VPWR VGND sg13cmos5l_decap_8
XFILLER_372_178 VPWR VGND sg13cmos5l_decap_4
XFILLER_383_28 VPWR VGND sg13cmos5l_decap_8
XFILLER_166_63 VPWR VGND sg13cmos5l_decap_8
XFILLER_124_112 VPWR VGND sg13cmos5l_decap_8
XFILLER_495_0 VPWR VGND sg13cmos5l_decap_8
XFILLER_182_62 VPWR VGND sg13cmos5l_decap_8
XFILLER_613_42 VPWR VGND sg13cmos5l_decap_8
XFILLER_278_182 VPWR VGND sg13cmos5l_decap_8
XFILLER_662_0 VPWR VGND sg13cmos5l_decap_8
XFILLER_332_21 VPWR VGND sg13cmos5l_decap_8
XFILLER_293_130 VPWR VGND sg13cmos5l_fill_1
XFILLER_427_168 VPWR VGND sg13cmos5l_decap_8
XFILLER_15_7 VPWR VGND sg13cmos5l_decap_8
XFILLER_689_35 VPWR VGND sg13cmos5l_decap_8
XFILLER_442_105 VPWR VGND sg13cmos5l_decap_8
X_1020_ _1020_/Q Tile_X0Y0_FrameData[15] VGND VPWR Tile_X0Y9_FrameStrobe[2] latch
XFILLER_631_216 VPWR VGND sg13cmos5l_fill_2
XFILLER_689_79 VPWR VGND sg13cmos5l_fill_1
XFILLER_46_162 VPWR VGND sg13cmos5l_decap_4
XFILLER_201_14 VPWR VGND sg13cmos5l_decap_8
XANTENNA__3012__X Tile_X0Y5_E2BEGb[7] VPWR VGND sg13cmos5l_antennanp
XFILLER_450_171 VPWR VGND sg13cmos5l_decap_8
XFILLER_395_204 VPWR VGND sg13cmos5l_fill_1
X_2971_ Tile_X0Y8_FrameData_O[11] Tile_X0Y8_FrameData[11] VPWR VGND sg13cmos5l_buf_1
XFILLER_61_165 VPWR VGND sg13cmos5l_decap_8
XFILLER_558_28 VPWR VGND sg13cmos5l_decap_8
XFILLER_488_91 VPWR VGND sg13cmos5l_decap_8
XFILLER_91_81 VPWR VGND sg13cmos5l_decap_8
X_4710_ _4710_/X Tile_X0Y6_W1END[1] Tile_X0Y6_W2MID[2] Tile_X0Y6_W2END[2] _4556_/X
+ _2641_/Q _2640_/Q VPWR VGND sg13cmos5l_mux4_1
XANTENNA__2851__X Tile_X0Y6_E6BEG[0] VPWR VGND sg13cmos5l_antennanp
X_1922_ _1922_/Q Tile_X0Y3_FrameData[7] VGND VPWR Tile_X0Y9_FrameStrobe[7] latch
X_1853_ _1853_/Q Tile_X0Y3_FrameData[12] VGND VPWR Tile_X0Y9_FrameStrobe[5] latch
X_4641_ _4641_/X Tile_X0Y7_WW4END[2] AXI_M_SOC_RDATA18 _4686_/X _4673_/X _0277_/Q
+ _0276_/Q VPWR VGND sg13cmos5l_mux4_1
XFILLER_363_101 VPWR VGND sg13cmos5l_decap_8
XFILLER_348_186 VPWR VGND sg13cmos5l_decap_4
X_0804_ _0804_/Q Tile_X0Y9_FrameData[27] VGND VPWR Tile_X0Y9_FrameStrobe[4] latch
X_4572_ _4572_/X _4545_/X Tile_X0Y9_N4END[12] _4544_/X _0152_/X _2487_/Q _2486_/Q
+ VPWR VGND sg13cmos5l_mux4_1
X_1784_ _1784_/Q Tile_X0Y3_FrameData[17] VGND VPWR Tile_X0Y9_FrameStrobe[3] latch
XFILLER_574_49 VPWR VGND sg13cmos5l_decap_8
XFILLER_357_84 VPWR VGND sg13cmos5l_decap_8
XFILLER_507_21 VPWR VGND sg13cmos5l_decap_8
XFILLER_293_28 VPWR VGND sg13cmos5l_decap_8
X_0735_ _0735_/Q Tile_X0Y9_FrameData[0] VGND VPWR Tile_X0Y9_FrameStrobe[1] latch
X_3523_ Tile_X0Y9_E1BEG[1] _4845_/X VPWR VGND sg13cmos5l_buf_1
XFILLER_505_172 VPWR VGND sg13cmos5l_decap_8
XFILLER_505_183 VPWR VGND sg13cmos5l_fill_1
X_3454_ Tile_X0Y1_FrameData_O[12] Tile_X0Y1_FrameData[12] VPWR VGND sg13cmos5l_buf_1
X_0666_ _0666_/Q Tile_X0Y8_FrameData[5] VGND VPWR Tile_X0Y9_FrameStrobe[7] latch
XFILLER_507_98 VPWR VGND sg13cmos5l_decap_8
XFILLER_226_66 VPWR VGND sg13cmos5l_fill_2
X_2405_ _2405_/Q Tile_X0Y5_FrameData[0] VGND VPWR Tile_X0Y9_FrameStrobe[6] latch
XFILLER_226_77 VPWR VGND sg13cmos5l_fill_1
XFILLER_130_126 VPWR VGND sg13cmos5l_decap_8
X_3385_ Tile_X0Y2_E6BEG[8] _4080_/X VPWR VGND sg13cmos5l_buf_1
X_0597_ _0597_/Q Tile_X0Y8_FrameData[10] VGND VPWR Tile_X0Y9_FrameStrobe[5] latch
XFILLER_226_99 VPWR VGND sg13cmos5l_decap_8
XFILLER_523_42 VPWR VGND sg13cmos5l_decap_4
X_2336_ _2336_/Q Tile_X0Y5_FrameData[5] VGND VPWR Tile_X0Y9_FrameStrobe[4] latch
XFILLER_670_70 VPWR VGND sg13cmos5l_decap_8
XFILLER_418_135 VPWR VGND sg13cmos5l_decap_8
XFILLER_29_107 VPWR VGND sg13cmos5l_fill_1
XFILLER_29_129 VPWR VGND sg13cmos5l_fill_2
X_2267_ _2267_/Q Tile_X0Y5_FrameData[10] VGND VPWR Tile_X0Y9_FrameStrobe[2] latch
XFILLER_433_105 VPWR VGND sg13cmos5l_decap_8
XFILLER_622_205 VPWR VGND sg13cmos5l_decap_4
XFILLER_599_35 VPWR VGND sg13cmos5l_decap_8
XFILLER_433_116 VPWR VGND sg13cmos5l_fill_2
X_4006_ _4006_/X Tile_X0Y5_W1END[3] Tile_X0Y5_WW4END[3] Tile_X0Y5_W6END[11] _4454_/X
+ _2406_/Q _2405_/Q VPWR VGND sg13cmos5l_mux4_1
X_1218_ _1218_/Q Tile_X0Y1_FrameData[23] VGND VPWR Tile_X0Y9_FrameStrobe[1] latch
XFILLER_37_140 VPWR VGND sg13cmos5l_fill_1
XFILLER_242_98 VPWR VGND sg13cmos5l_fill_1
X_2198_ _2198_/Q Tile_X0Y5_FrameData[15] VGND VPWR Tile_X0Y9_FrameStrobe[0] latch
XFILLER_37_162 VPWR VGND sg13cmos5l_decap_4
XFILLER_587_120 VPWR VGND sg13cmos5l_fill_2
X_1149_ _1149_/Q Tile_X0Y0_FrameData[14] VGND VPWR Tile_X0Y9_FrameStrobe[6] latch
XFILLER_52_121 VPWR VGND sg13cmos5l_decap_8
XFILLER_111_14 VPWR VGND sg13cmos5l_decap_8
XFILLER_111_25 VPWR VGND sg13cmos5l_fill_1
XFILLER_111_47 VPWR VGND sg13cmos5l_decap_8
XFILLER_197_115 VPWR VGND sg13cmos5l_decap_8
XFILLER_587_175 VPWR VGND sg13cmos5l_fill_2
XFILLER_468_28 VPWR VGND sg13cmos5l_decap_8
XANTENNA__2761__X Tile_X0Y3_FrameData_O[19] VPWR VGND sg13cmos5l_antennanp
X_4908_ _4908_/X Tile_X0Y5_W1END[0] Tile_X0Y5_WW4END[12] Tile_X0Y5_W6END[4] _4451_/X
+ _2379_/Q _2378_/Q VPWR VGND sg13cmos5l_mux4_1
XFILLER_200_119 VPWR VGND sg13cmos5l_fill_2
X_4839_ _4839_/X _4921_/X _4925_/X _4929_/X _4904_/X _0864_/Q _0863_/Q VPWR VGND sg13cmos5l_mux4_1
XFILLER_354_112 VPWR VGND sg13cmos5l_decap_8
XFILLER_339_197 VPWR VGND sg13cmos5l_decap_8
XFILLER_484_49 VPWR VGND sg13cmos5l_decap_8
XFILLER_267_84 VPWR VGND sg13cmos5l_decap_8
XFILLER_417_21 VPWR VGND sg13cmos5l_decap_8
XANTENNA__3592__X Tile_X0Y9_FrameData_O[22] VPWR VGND sg13cmos5l_antennanp
XFILLER_20_77 VPWR VGND sg13cmos5l_fill_1
XFILLER_417_98 VPWR VGND sg13cmos5l_decap_8
XFILLER_511_164 VPWR VGND sg13cmos5l_fill_1
XFILLER_20_99 VPWR VGND sg13cmos5l_decap_8
XFILLER_121_115 VPWR VGND sg13cmos5l_decap_4
XFILLER_267_108 VPWR VGND sg13cmos5l_fill_1
XFILLER_136_77 VPWR VGND sg13cmos5l_decap_8
XFILLER_714_63 VPWR VGND sg13cmos5l_decap_8
XFILLER_586_7 VPWR VGND sg13cmos5l_decap_8
XFILLER_121_148 VPWR VGND sg13cmos5l_decap_4
XFILLER_96_59 VPWR VGND sg13cmos5l_decap_8
XFILLER_433_42 VPWR VGND sg13cmos5l_decap_8
XFILLER_29_20 VPWR VGND sg13cmos5l_decap_8
XFILLER_121_159 VPWR VGND sg13cmos5l_decap_8
XFILLER_409_113 VPWR VGND sg13cmos5l_decap_8
XFILLER_665_190 VPWR VGND sg13cmos5l_decap_8
XFILLER_152_21 VPWR VGND sg13cmos5l_decap_8
XFILLER_409_157 VPWR VGND sg13cmos5l_decap_8
XANTENNA__2936__X Tile_X0Y8_E6BEG[4] VPWR VGND sg13cmos5l_antennanp
XFILLER_424_105 VPWR VGND sg13cmos5l_decap_8
XFILLER_275_196 VPWR VGND sg13cmos5l_decap_8
XFILLER_90_205 VPWR VGND sg13cmos5l_fill_1
XFILLER_90_216 VPWR VGND sg13cmos5l_fill_2
XFILLER_302_35 VPWR VGND sg13cmos5l_decap_8
XFILLER_290_155 VPWR VGND sg13cmos5l_decap_8
XFILLER_302_57 VPWR VGND sg13cmos5l_decap_8
XFILLER_659_49 VPWR VGND sg13cmos5l_decap_8
XFILLER_378_28 VPWR VGND sg13cmos5l_decap_8
XFILLER_43_187 VPWR VGND sg13cmos5l_decap_8
XFILLER_243_0 VPWR VGND sg13cmos5l_decap_8
XFILLER_593_134 VPWR VGND sg13cmos5l_decap_8
XFILLER_593_145 VPWR VGND sg13cmos5l_fill_1
XFILLER_101_80 VPWR VGND sg13cmos5l_decap_8
XFILLER_345_112 VPWR VGND sg13cmos5l_fill_1
XFILLER_410_0 VPWR VGND sg13cmos5l_decap_8
XFILLER_61_95 VPWR VGND sg13cmos5l_decap_8
XFILLER_508_0 VPWR VGND sg13cmos5l_decap_8
XFILLER_608_42 VPWR VGND sg13cmos5l_decap_8
XFILLER_394_49 VPWR VGND sg13cmos5l_decap_4
XFILLER_327_21 VPWR VGND sg13cmos5l_decap_8
XFILLER_177_95 VPWR VGND sg13cmos5l_decap_8
XFILLER_6_35 VPWR VGND sg13cmos5l_decap_8
XANTENNA_6 AXI_M_SOC_RDATA27 VPWR VGND sg13cmos5l_antennanp
XFILLER_691_14 VPWR VGND sg13cmos5l_decap_8
X_0520_ _0520_/Q Tile_X0Y8_FrameData[23] VGND VPWR Tile_X0Y9_FrameStrobe[3] latch
XFILLER_499_182 VPWR VGND sg13cmos5l_decap_8
XFILLER_499_193 VPWR VGND sg13cmos5l_fill_2
XFILLER_327_98 VPWR VGND sg13cmos5l_fill_2
XFILLER_258_108 VPWR VGND sg13cmos5l_decap_8
X_0451_ _0451_/Q Tile_X0Y8_FrameData[28] VGND VPWR Tile_X0Y9_FrameStrobe[1] latch
XFILLER_624_63 VPWR VGND sg13cmos5l_decap_8
XFILLER_502_175 VPWR VGND sg13cmos5l_decap_8
XFILLER_193_83 VPWR VGND sg13cmos5l_fill_2
XFILLER_648_168 VPWR VGND sg13cmos5l_decap_8
XANTENNA__3007__X Tile_X0Y5_E2BEGb[2] VPWR VGND sg13cmos5l_antennanp
XFILLER_663_116 VPWR VGND sg13cmos5l_fill_2
XFILLER_343_42 VPWR VGND sg13cmos5l_decap_8
X_3170_ Tile_X0Y4_E6BEG[7] _4295_/X VPWR VGND sg13cmos5l_buf_1
X_0382_ _0382_/Q Tile_X0Y7_FrameData[1] VGND VPWR Tile_X0Y9_FrameStrobe[6] latch
XFILLER_490_70 VPWR VGND sg13cmos5l_decap_8
X_2121_ _2121_/Q Tile_X0Y4_FrameData[28] VGND VPWR Tile_X0Y9_FrameStrobe[6] latch
XANTENNA__2846__X Tile_X0Y6_E2BEGb[3] VPWR VGND sg13cmos5l_antennanp
XFILLER_120_181 VPWR VGND sg13cmos5l_decap_8
X_2052_ _2052_/Q Tile_X0Y4_FrameData[1] VGND VPWR Tile_X0Y9_FrameStrobe[3] latch
XFILLER_671_182 VPWR VGND sg13cmos5l_fill_1
XFILLER_281_133 VPWR VGND sg13cmos5l_decap_8
XFILLER_212_13 VPWR VGND sg13cmos5l_decap_8
XFILLER_81_205 VPWR VGND sg13cmos5l_decap_8
XFILLER_640_84 VPWR VGND sg13cmos5l_decap_8
XFILLER_415_149 VPWR VGND sg13cmos5l_decap_8
X_1003_ _1003_/Q Tile_X0Y0_FrameData[0] VGND VPWR Tile_X0Y9_FrameStrobe[1] latch
XFILLER_569_49 VPWR VGND sg13cmos5l_decap_8
XFILLER_430_119 VPWR VGND sg13cmos5l_decap_8
XFILLER_34_132 VPWR VGND sg13cmos5l_fill_2
XFILLER_569_175 VPWR VGND sg13cmos5l_decap_8
XFILLER_288_28 VPWR VGND sg13cmos5l_decap_8
XFILLER_584_134 VPWR VGND sg13cmos5l_decap_8
X_2954_ Tile_X0Y8_EE4BEG[10] _4754_/X VPWR VGND sg13cmos5l_buf_1
XFILLER_89_0 VPWR VGND sg13cmos5l_decap_8
X_1905_ _1905_/Q Tile_X0Y3_FrameData[24] VGND VPWR Tile_X0Y9_FrameStrobe[7] latch
X_2885_ Tile_X0Y6_FrameData_O[6] Tile_X0Y6_FrameData[6] VPWR VGND sg13cmos5l_buf_1
XFILLER_368_94 VPWR VGND sg13cmos5l_fill_1
XFILLER_518_42 VPWR VGND sg13cmos5l_decap_8
X_4624_ _4624_/X Tile_X0Y7_W2END[3] AXI_M_SOC_RDATA19 _4675_/X _4674_/X _0311_/Q _0310_/Q
+ VPWR VGND sg13cmos5l_mux4_1
X_1836_ _1836_/Q Tile_X0Y3_FrameData[29] VGND VPWR Tile_X0Y9_FrameStrobe[5] latch
XFILLER_336_156 VPWR VGND sg13cmos5l_decap_8
XFILLER_665_70 VPWR VGND sg13cmos5l_decap_8
XFILLER_336_178 VPWR VGND sg13cmos5l_decap_8
XFILLER_237_21 VPWR VGND sg13cmos5l_decap_8
XFILLER_540_215 VPWR VGND sg13cmos5l_fill_2
X_1767_ _1767_/Q Tile_X0Y3_FrameData[2] VGND VPWR Tile_X0Y9_FrameStrobe[2] latch
X_4555_ _4555_/X _4471_/X _4587_/X _4586_/X _4470_/X _2461_/Q _2460_/Q VPWR VGND sg13cmos5l_mux4_1
XFILLER_497_119 VPWR VGND sg13cmos5l_decap_8
XFILLER_351_126 VPWR VGND sg13cmos5l_decap_8
XFILLER_351_159 VPWR VGND sg13cmos5l_decap_8
X_0718_ _0718_/Q Tile_X0Y9_FrameData[17] VGND VPWR Tile_X0Y9_FrameStrobe[1] latch
X_3506_ Tile_X0Y1_E2BEGb[4] _3944_/X VPWR VGND sg13cmos5l_buf_1
XFILLER_1_209 VPWR VGND sg13cmos5l_decap_8
X_1698_ _1698_/Q Tile_X0Y3_FrameData[7] VGND VPWR Tile_X0Y9_FrameStrobe[0] latch
X_4486_ _4486_/X Tile_X0Y6_W1END[1] Tile_X0Y6_WW4END[13] Tile_X0Y6_W6END[5] _4569_/X
+ _2632_/Q _2631_/Q VPWR VGND sg13cmos5l_mux4_1
XFILLER_534_63 VPWR VGND sg13cmos5l_fill_1
X_0649_ _0649_/Q Tile_X0Y8_FrameData[22] VGND VPWR Tile_X0Y9_FrameStrobe[7] latch
X_3437_ Tile_X0Y4_FrameData_O[28] Tile_X0Y4_FrameData[28] VPWR VGND sg13cmos5l_buf_1
XFILLER_639_168 VPWR VGND sg13cmos5l_decap_8
XFILLER_106_14 VPWR VGND sg13cmos5l_decap_8
XFILLER_654_105 VPWR VGND sg13cmos5l_decap_8
XFILLER_106_36 VPWR VGND sg13cmos5l_decap_8
XFILLER_253_42 VPWR VGND sg13cmos5l_decap_4
XFILLER_253_53 VPWR VGND sg13cmos5l_decap_8
X_3368_ Tile_X0Y2_EE4BEG[7] _4063_/X VPWR VGND sg13cmos5l_buf_1
XFILLER_106_58 VPWR VGND sg13cmos5l_decap_8
XANTENNA__2756__X Tile_X0Y3_FrameData_O[14] VPWR VGND sg13cmos5l_antennanp
XFILLER_257_163 VPWR VGND sg13cmos5l_fill_2
X_2319_ _2319_/Q Tile_X0Y5_FrameData[22] VGND VPWR Tile_X0Y9_FrameStrobe[4] latch
XFILLER_111_181 VPWR VGND sg13cmos5l_decap_4
X_3299_ Tile_X0Y0_E2BEGb[7] _3819_/X VPWR VGND sg13cmos5l_buf_1
XFILLER_406_105 VPWR VGND sg13cmos5l_decap_4
XFILLER_550_62 VPWR VGND sg13cmos5l_decap_8
XFILLER_272_133 VPWR VGND sg13cmos5l_decap_4
XFILLER_72_216 VPWR VGND sg13cmos5l_fill_2
XFILLER_272_144 VPWR VGND sg13cmos5l_decap_4
XFILLER_122_35 VPWR VGND sg13cmos5l_decap_8
XFILLER_700_21 VPWR VGND sg13cmos5l_decap_8
XFILLER_272_155 VPWR VGND sg13cmos5l_decap_4
XFILLER_421_119 VPWR VGND sg13cmos5l_fill_2
XFILLER_167_7 VPWR VGND sg13cmos5l_decap_8
XFILLER_122_79 VPWR VGND sg13cmos5l_decap_8
XFILLER_479_49 VPWR VGND sg13cmos5l_decap_8
XFILLER_198_28 VPWR VGND sg13cmos5l_decap_8
XFILLER_700_98 VPWR VGND sg13cmos5l_decap_8
XFILLER_575_112 VPWR VGND sg13cmos5l_decap_8
XANTENNA__3587__X Tile_X0Y9_FrameData_O[17] VPWR VGND sg13cmos5l_antennanp
XFILLER_334_7 VPWR VGND sg13cmos5l_decap_8
XFILLER_40_157 VPWR VGND sg13cmos5l_decap_8
XFILLER_178_170 VPWR VGND sg13cmos5l_decap_8
XFILLER_575_189 VPWR VGND sg13cmos5l_decap_8
XFILLER_709_63 VPWR VGND sg13cmos5l_decap_8
XFILLER_717_161 VPWR VGND sg13cmos5l_decap_8
XFILLER_501_7 VPWR VGND sg13cmos5l_decap_8
XFILLER_428_42 VPWR VGND sg13cmos5l_decap_8
XFILLER_575_70 VPWR VGND sg13cmos5l_decap_8
XFILLER_147_21 VPWR VGND sg13cmos5l_decap_8
XFILLER_531_215 VPWR VGND sg13cmos5l_fill_2
XFILLER_342_115 VPWR VGND sg13cmos5l_decap_4
XFILLER_342_148 VPWR VGND sg13cmos5l_decap_8
XFILLER_661_28 VPWR VGND sg13cmos5l_decap_8
XFILLER_645_105 VPWR VGND sg13cmos5l_decap_8
XFILLER_496_196 VPWR VGND sg13cmos5l_decap_4
XFILLER_193_0 VPWR VGND sg13cmos5l_fill_2
XFILLER_263_100 VPWR VGND sg13cmos5l_fill_2
XFILLER_452_200 VPWR VGND sg13cmos5l_fill_2
XFILLER_248_185 VPWR VGND sg13cmos5l_decap_8
XFILLER_653_171 VPWR VGND sg13cmos5l_decap_8
XFILLER_610_21 VPWR VGND sg13cmos5l_decap_8
XFILLER_360_0 VPWR VGND sg13cmos5l_fill_2
XFILLER_313_89 VPWR VGND sg13cmos5l_decap_8
XFILLER_458_0 VPWR VGND sg13cmos5l_decap_8
XFILLER_56_95 VPWR VGND sg13cmos5l_decap_8
XFILLER_412_119 VPWR VGND sg13cmos5l_decap_8
XFILLER_16_121 VPWR VGND sg13cmos5l_decap_4
XFILLER_389_49 VPWR VGND sg13cmos5l_decap_8
XFILLER_263_199 VPWR VGND sg13cmos5l_decap_8
XFILLER_405_182 VPWR VGND sg13cmos5l_decap_4
XFILLER_686_14 VPWR VGND sg13cmos5l_decap_8
XFILLER_566_112 VPWR VGND sg13cmos5l_decap_8
XFILLER_625_0 VPWR VGND sg13cmos5l_decap_8
XANTENNA__3497__X Tile_X0Y1_E6BEG[7] VPWR VGND sg13cmos5l_antennanp
XFILLER_72_83 VPWR VGND sg13cmos5l_decap_8
XFILLER_420_185 VPWR VGND sg13cmos5l_decap_8
XFILLER_420_196 VPWR VGND sg13cmos5l_decap_8
XFILLER_619_63 VPWR VGND sg13cmos5l_decap_8
XFILLER_75_6 VPWR VGND sg13cmos5l_decap_8
XFILLER_338_42 VPWR VGND sg13cmos5l_decap_8
X_2670_ _2670_/Q Tile_X0Y6_FrameData[25] VGND VPWR Tile_X0Y9_FrameStrobe[7] latch
XFILLER_485_70 VPWR VGND sg13cmos5l_decap_8
X_1621_ _1621_/Q Tile_X0Y2_FrameData[28] VGND VPWR Tile_X0Y9_FrameStrobe[6] latch
XFILLER_333_115 VPWR VGND sg13cmos5l_decap_8
XFILLER_522_215 VPWR VGND sg13cmos5l_fill_2
XFILLER_333_126 VPWR VGND sg13cmos5l_fill_1
XFILLER_333_148 VPWR VGND sg13cmos5l_decap_8
X_1552_ _1552_/Q Tile_X0Y2_FrameData[1] VGND VPWR Tile_X0Y9_FrameStrobe[3] latch
X_4340_ _4340_/X _4302_/X _0099_/X _4301_/X _0112_/X _1973_/Q _1972_/Q VPWR VGND sg13cmos5l_mux4_1
XFILLER_207_13 VPWR VGND sg13cmos5l_decap_8
XFILLER_635_84 VPWR VGND sg13cmos5l_decap_8
X_0503_ _0503_/Q Tile_X0Y8_FrameData[8] VGND VPWR Tile_X0Y9_FrameStrobe[2] latch
XFILLER_487_152 VPWR VGND sg13cmos5l_decap_4
XFILLER_140_210 VPWR VGND sg13cmos5l_fill_2
X_4271_ _4271_/X Tile_X0Y4_W2END[0] AXI_M_SOC_BRESP0 _4313_/X _4312_/X _2071_/Q _2070_/Q
+ VPWR VGND sg13cmos5l_mux4_1
XFILLER_571_28 VPWR VGND sg13cmos5l_decap_8
XFILLER_354_63 VPWR VGND sg13cmos5l_decap_8
X_1483_ _1483_/Q Tile_X0Y2_FrameData[6] VGND VPWR Tile_X0Y9_FrameStrobe[1] latch
XFILLER_487_163 VPWR VGND sg13cmos5l_decap_4
XFILLER_636_105 VPWR VGND sg13cmos5l_decap_8
X_3222_ Tile_X0Y0_FrameStrobe_O[10] Tile_X0Y9_FrameStrobe[10] VPWR VGND sg13cmos5l_buf_1
X_0434_ _0434_/Q Tile_X0Y8_FrameData[13] VGND VPWR Tile_X0Y9_FrameStrobe[0] latch
XFILLER_636_149 VPWR VGND sg13cmos5l_decap_8
X_3153_ Tile_X0Y7_FrameData_O[23] Tile_X0Y7_FrameData[23] VPWR VGND sg13cmos5l_buf_1
XFILLER_504_77 VPWR VGND sg13cmos5l_decap_8
X_0365_ _0365_/Q Tile_X0Y7_FrameData[18] VGND VPWR Tile_X0Y9_FrameStrobe[6] latch
XFILLER_651_119 VPWR VGND sg13cmos5l_decap_8
XFILLER_223_56 VPWR VGND sg13cmos5l_decap_8
X_2104_ _2104_/Q Tile_X0Y4_FrameData[13] VGND VPWR Tile_X0Y9_FrameStrobe[5] latch
XFILLER_254_122 VPWR VGND sg13cmos5l_fill_2
XFILLER_644_182 VPWR VGND sg13cmos5l_decap_8
X_3084_ Tile_X0Y7_E1BEG[2] _4610_/X VPWR VGND sg13cmos5l_buf_1
XFILLER_370_84 VPWR VGND sg13cmos5l_fill_2
XFILLER_254_144 VPWR VGND sg13cmos5l_decap_8
X_0296_ _0296_/Q Tile_X0Y7_FrameData[23] VGND VPWR Tile_X0Y9_FrameStrobe[4] latch
XFILLER_54_216 VPWR VGND sg13cmos5l_fill_2
XFILLER_520_21 VPWR VGND sg13cmos5l_decap_8
X_2035_ _2035_/Q Tile_X0Y4_FrameData[18] VGND VPWR Tile_X0Y9_FrameStrobe[3] latch
XFILLER_596_14 VPWR VGND sg13cmos5l_decap_8
XFILLER_520_98 VPWR VGND sg13cmos5l_decap_8
XFILLER_557_156 VPWR VGND sg13cmos5l_fill_1
X_3986_ _3986_/X Tile_X0Y0_W1END[3] Tile_X0Y0_W6END[11] _3863_/X _3880_/X _1135_/Q
+ _1134_/Q VPWR VGND sg13cmos5l_mux4_1
XANTENNA__3200__X Tile_X0Y0_N2BEG[0] VPWR VGND sg13cmos5l_antennanp
XFILLER_557_178 VPWR VGND sg13cmos5l_decap_4
XFILLER_411_196 VPWR VGND sg13cmos5l_decap_4
XFILLER_22_168 VPWR VGND sg13cmos5l_fill_1
X_2937_ Tile_X0Y8_E6BEG[5] _4765_/X VPWR VGND sg13cmos5l_buf_1
XFILLER_572_126 VPWR VGND sg13cmos5l_decap_8
XFILLER_529_63 VPWR VGND sg13cmos5l_decap_8
XFILLER_248_42 VPWR VGND sg13cmos5l_fill_2
XFILLER_175_151 VPWR VGND sg13cmos5l_decap_8
XFILLER_108_207 VPWR VGND sg13cmos5l_fill_1
X_2868_ Tile_X0Y6_EE4BEG[5] _4517_/X VPWR VGND sg13cmos5l_buf_1
XFILLER_309_189 VPWR VGND sg13cmos5l_decap_8
X_4607_ _4607_/X _4691_/X _4695_/X _4699_/X _4668_/X _0346_/Q _0345_/Q VPWR VGND sg13cmos5l_mux4_1
XFILLER_714_175 VPWR VGND sg13cmos5l_decap_8
X_1819_ _1819_/Q Tile_X0Y3_FrameData[14] VGND VPWR Tile_X0Y9_FrameStrobe[4] latch
X_2799_ Tile_X0Y3_E6BEG[9] _4189_/X VPWR VGND sg13cmos5l_buf_1
X_4538_ _4538_/X AXI_M_SOC_RDATA30 _4569_/X _4573_/X _4554_/X _2531_/Q _2530_/Q VPWR
+ VGND sg13cmos5l_mux4_1
XFILLER_545_84 VPWR VGND sg13cmos5l_decap_8
XFILLER_481_28 VPWR VGND sg13cmos5l_decap_8
XFILLER_264_63 VPWR VGND sg13cmos5l_decap_8
XFILLER_89_135 VPWR VGND sg13cmos5l_fill_2
XFILLER_478_163 VPWR VGND sg13cmos5l_decap_4
X_4469_ _4469_/X Tile_X0Y7_W2MID[7] Tile_X0Y7_W2END[7] Tile_X0Y7_W6END[7] _4669_/X
+ _0407_/Q _0406_/Q VPWR VGND sg13cmos5l_mux4_1
XFILLER_627_105 VPWR VGND sg13cmos5l_decap_4
XFILLER_478_174 VPWR VGND sg13cmos5l_decap_8
XFILLER_493_133 VPWR VGND sg13cmos5l_decap_8
XFILLER_292_206 VPWR VGND sg13cmos5l_decap_8
XFILLER_414_77 VPWR VGND sg13cmos5l_decap_8
XFILLER_292_217 VPWR VGND sg13cmos5l_fill_1
XFILLER_642_119 VPWR VGND sg13cmos5l_decap_8
XFILLER_434_200 VPWR VGND sg13cmos5l_decap_8
XFILLER_284_7 VPWR VGND sg13cmos5l_decap_8
XFILLER_635_160 VPWR VGND sg13cmos5l_decap_8
XFILLER_245_122 VPWR VGND sg13cmos5l_decap_8
XFILLER_133_56 VPWR VGND sg13cmos5l_fill_2
XFILLER_711_42 VPWR VGND sg13cmos5l_decap_8
XFILLER_245_133 VPWR VGND sg13cmos5l_fill_1
XFILLER_280_84 VPWR VGND sg13cmos5l_decap_8
XFILLER_430_21 VPWR VGND sg13cmos5l_decap_8
XFILLER_245_155 VPWR VGND sg13cmos5l_decap_8
XFILLER_93_49 VPWR VGND sg13cmos5l_decap_8
XFILLER_26_21 VPWR VGND sg13cmos5l_decap_8
XFILLER_451_7 VPWR VGND sg13cmos5l_decap_8
XFILLER_549_7 VPWR VGND sg13cmos5l_decap_8
XFILLER_650_196 VPWR VGND sg13cmos5l_decap_8
XFILLER_60_208 VPWR VGND sg13cmos5l_fill_1
XFILLER_548_112 VPWR VGND sg13cmos5l_decap_8
XFILLER_430_98 VPWR VGND sg13cmos5l_decap_8
XFILLER_13_135 VPWR VGND sg13cmos5l_decap_8
XFILLER_548_167 VPWR VGND sg13cmos5l_decap_8
XANTENNA__3110__X Tile_X0Y7_E6BEG[8] VPWR VGND sg13cmos5l_antennanp
XFILLER_656_28 VPWR VGND sg13cmos5l_decap_8
XFILLER_439_63 VPWR VGND sg13cmos5l_decap_8
XFILLER_308_34 VPWR VGND sg13cmos5l_decap_8
XFILLER_181_132 VPWR VGND sg13cmos5l_decap_8
XFILLER_181_165 VPWR VGND sg13cmos5l_fill_1
XFILLER_672_49 VPWR VGND sg13cmos5l_decap_8
XFILLER_605_21 VPWR VGND sg13cmos5l_decap_8
XFILLER_391_28 VPWR VGND sg13cmos5l_decap_8
XFILLER_122_210 VPWR VGND sg13cmos5l_fill_2
XFILLER_3_14 VPWR VGND sg13cmos5l_decap_8
XFILLER_323_192 VPWR VGND sg13cmos5l_decap_8
XFILLER_484_111 VPWR VGND sg13cmos5l_decap_8
XFILLER_484_122 VPWR VGND sg13cmos5l_fill_1
XFILLER_469_196 VPWR VGND sg13cmos5l_decap_8
XFILLER_575_0 VPWR VGND sg13cmos5l_decap_8
XFILLER_107_90 VPWR VGND sg13cmos5l_decap_8
XFILLER_283_217 VPWR VGND sg13cmos5l_fill_1
XFILLER_633_119 VPWR VGND sg13cmos5l_decap_8
XFILLER_236_111 VPWR VGND sg13cmos5l_decap_8
XFILLER_67_94 VPWR VGND sg13cmos5l_decap_8
XFILLER_621_42 VPWR VGND sg13cmos5l_decap_8
X_0150_ _0150_/X _4566_/X _4567_/X _1602_/Q VPWR VGND sg13cmos5l_mux2_1
XFILLER_190_84 VPWR VGND sg13cmos5l_fill_2
XFILLER_340_21 VPWR VGND sg13cmos5l_decap_8
XFILLER_236_177 VPWR VGND sg13cmos5l_decap_8
X_0081_ _0081_/X _4912_/X _4913_/X _2371_/Q VPWR VGND sg13cmos5l_mux2_1
XFILLER_697_35 VPWR VGND sg13cmos5l_decap_8
XFILLER_189_210 VPWR VGND sg13cmos5l_decap_8
XFILLER_83_71 VPWR VGND sg13cmos5l_decap_8
XFILLER_641_196 VPWR VGND sg13cmos5l_fill_2
X_3840_ _3840_/X Tile_X0Y0_WW4END[11] _3879_/X _3864_/X _3853_/X _1025_/Q _1024_/Q
+ VPWR VGND sg13cmos5l_mux4_1
XANTENNA__3020__X Tile_X0Y5_E6BEG[7] VPWR VGND sg13cmos5l_antennanp
XFILLER_539_189 VPWR VGND sg13cmos5l_decap_8
XFILLER_566_28 VPWR VGND sg13cmos5l_decap_8
XFILLER_349_63 VPWR VGND sg13cmos5l_decap_8
X_0983_ _0983_/Q Tile_X0Y0_FrameData[20] VGND VPWR Tile_X0Y9_FrameStrobe[1] latch
X_3771_ _3771_/X Tile_X0Y0_WW4END[0] Tile_X0Y0_WW4END[8] Tile_X0Y0_W6END[0] _3881_/X
+ _1009_/Q _1008_/Q VPWR VGND sg13cmos5l_mux4_1
XFILLER_496_91 VPWR VGND sg13cmos5l_decap_8
X_2722_ _4657_/A3 VPWR VGND sg13cmos5l_tielo
X_2653_ _2653_/Q Tile_X0Y6_FrameData[10] VGND VPWR Tile_X0Y9_FrameStrobe[6] latch
XFILLER_711_112 VPWR VGND sg13cmos5l_decap_8
XFILLER_218_56 VPWR VGND sg13cmos5l_decap_8
X_1604_ _1604_/Q Tile_X0Y2_FrameData[13] VGND VPWR Tile_X0Y9_FrameStrobe[5] latch
X_2584_ _2584_/Q Tile_X0Y6_FrameData[15] VGND VPWR Tile_X0Y9_FrameStrobe[4] latch
XFILLER_582_49 VPWR VGND sg13cmos5l_decap_8
XFILLER_515_21 VPWR VGND sg13cmos5l_decap_8
XFILLER_172_198 VPWR VGND sg13cmos5l_fill_1
XFILLER_711_189 VPWR VGND sg13cmos5l_fill_2
X_4323_ _4323_/X _4804_/X _4808_/X _4812_/X _4785_/X _0647_/Q _0646_/Q VPWR VGND sg13cmos5l_mux4_1
X_1535_ _1535_/Q Tile_X0Y2_FrameData[18] VGND VPWR Tile_X0Y9_FrameStrobe[3] latch
XFILLER_609_105 VPWR VGND sg13cmos5l_fill_1
XFILLER_314_192 VPWR VGND sg13cmos5l_decap_8
XANTENNA__3690__X AXI_M_SOC_WDATA0 VPWR VGND sg13cmos5l_antennanp
XFILLER_609_127 VPWR VGND sg13cmos5l_decap_8
XFILLER_475_133 VPWR VGND sg13cmos5l_decap_8
X_1466_ _1466_/Q Tile_X0Y2_FrameData[23] VGND VPWR Tile_X0Y9_FrameStrobe[1] latch
X_4254_ _4254_/X _4308_/X _4307_/X AXI_M_SOC_BRESP1 _4306_/X _2105_/Q _2104_/Q VPWR
+ VGND sg13cmos5l_mux4_1
XFILLER_475_155 VPWR VGND sg13cmos5l_decap_8
X_0417_ _0417_/Q Tile_X0Y8_FrameData[30] VGND VPWR Tile_X0Y9_FrameStrobe[0] latch
X_3205_ Tile_X0Y0_N2BEG[5] _3789_/X VPWR VGND sg13cmos5l_buf_1
XFILLER_274_217 VPWR VGND sg13cmos5l_fill_1
X_1397_ _1397_/Q Tile_X0Y1_FrameData[4] VGND VPWR Tile_X0Y9_FrameStrobe[6] latch
X_4185_ _4185_/X AXI_M_SOC_BVALID _4228_/X _4232_/X _4207_/X _1771_/Q _1770_/Q VPWR
+ VGND sg13cmos5l_mux4_1
XFILLER_416_211 VPWR VGND sg13cmos5l_fill_1
XFILLER_531_42 VPWR VGND sg13cmos5l_decap_8
XFILLER_227_133 VPWR VGND sg13cmos5l_decap_8
X_0348_ _0348_/Q Tile_X0Y7_FrameData[3] VGND VPWR Tile_X0Y9_FrameStrobe[5] latch
X_3136_ Tile_X0Y7_FrameData_O[6] Tile_X0Y7_FrameData[6] VPWR VGND sg13cmos5l_buf_1
XFILLER_490_169 VPWR VGND sg13cmos5l_decap_4
XFILLER_250_21 VPWR VGND sg13cmos5l_decap_8
X_3067_ Tile_X0Y5_FrameData_O[26] Tile_X0Y5_FrameData[26] VPWR VGND sg13cmos5l_buf_1
XFILLER_431_203 VPWR VGND sg13cmos5l_decap_8
X_0279_ _0279_/Q Tile_X0Y7_FrameData[8] VGND VPWR Tile_X0Y9_FrameStrobe[3] latch
XFILLER_227_199 VPWR VGND sg13cmos5l_decap_8
XFILLER_577_207 VPWR VGND sg13cmos5l_decap_4
X_2018_ _2018_/Q Tile_X0Y4_FrameData[3] VGND VPWR Tile_X0Y9_FrameStrobe[2] latch
XFILLER_242_169 VPWR VGND sg13cmos5l_decap_8
XFILLER_400_35 VPWR VGND sg13cmos5l_decap_8
XFILLER_476_28 VPWR VGND sg13cmos5l_decap_8
XFILLER_259_63 VPWR VGND sg13cmos5l_decap_8
X_3969_ _3969_/X AXI_M_SOC_ARREADY _4014_/X _4018_/X _3991_/X _1271_/Q _1270_/Q VPWR
+ VGND sg13cmos5l_mux4_1
XFILLER_545_137 VPWR VGND sg13cmos5l_decap_8
XFILLER_10_127 VPWR VGND sg13cmos5l_fill_1
XFILLER_10_149 VPWR VGND sg13cmos5l_fill_1
XFILLER_163_110 VPWR VGND sg13cmos5l_decap_8
XFILLER_12_56 VPWR VGND sg13cmos5l_decap_8
XFILLER_702_112 VPWR VGND sg13cmos5l_decap_8
XFILLER_409_99 VPWR VGND sg13cmos5l_decap_8
XFILLER_128_56 VPWR VGND sg13cmos5l_decap_8
XFILLER_706_42 VPWR VGND sg13cmos5l_decap_8
XFILLER_492_49 VPWR VGND sg13cmos5l_decap_8
XFILLER_275_84 VPWR VGND sg13cmos5l_decap_8
XFILLER_425_21 VPWR VGND sg13cmos5l_decap_8
XFILLER_128_89 VPWR VGND sg13cmos5l_decap_8
XFILLER_312_129 VPWR VGND sg13cmos5l_fill_2
XFILLER_104_210 VPWR VGND sg13cmos5l_fill_2
XFILLER_702_189 VPWR VGND sg13cmos5l_fill_2
XFILLER_499_7 VPWR VGND sg13cmos5l_decap_8
XFILLER_425_98 VPWR VGND sg13cmos5l_decap_8
XFILLER_144_55 VPWR VGND sg13cmos5l_decap_4
XFILLER_481_103 VPWR VGND sg13cmos5l_fill_1
XFILLER_320_195 VPWR VGND sg13cmos5l_fill_1
XFILLER_666_7 VPWR VGND sg13cmos5l_decap_8
XFILLER_291_94 VPWR VGND sg13cmos5l_decap_4
XANTENNA__3105__X Tile_X0Y7_E6BEG[3] VPWR VGND sg13cmos5l_antennanp
XFILLER_441_42 VPWR VGND sg13cmos5l_decap_8
XFILLER_37_20 VPWR VGND sg13cmos5l_decap_8
XFILLER_160_32 VPWR VGND sg13cmos5l_decap_8
XFILLER_218_177 VPWR VGND sg13cmos5l_decap_4
XFILLER_218_188 VPWR VGND sg13cmos5l_fill_1
XANTENNA__2944__X Tile_X0Y8_EE4BEG[0] VPWR VGND sg13cmos5l_antennanp
XFILLER_268_2 VPWR VGND sg13cmos5l_fill_1
XFILLER_233_169 VPWR VGND sg13cmos5l_decap_8
XFILLER_156_0 VPWR VGND sg13cmos5l_decap_8
XFILLER_667_38 VPWR VGND sg13cmos5l_decap_8
XFILLER_53_52 VPWR VGND sg13cmos5l_decap_8
XFILLER_386_28 VPWR VGND sg13cmos5l_decap_8
XFILLER_169_63 VPWR VGND sg13cmos5l_fill_2
XFILLER_536_137 VPWR VGND sg13cmos5l_decap_8
XFILLER_323_0 VPWR VGND sg13cmos5l_decap_8
XFILLER_139_140 VPWR VGND sg13cmos5l_decap_8
XFILLER_466_72 VPWR VGND sg13cmos5l_decap_8
XFILLER_319_66 VPWR VGND sg13cmos5l_fill_1
XFILLER_319_88 VPWR VGND sg13cmos5l_decap_8
XFILLER_5_131 VPWR VGND sg13cmos5l_fill_1
XFILLER_544_192 VPWR VGND sg13cmos5l_decap_8
XFILLER_616_42 VPWR VGND sg13cmos5l_decap_8
XFILLER_185_84 VPWR VGND sg13cmos5l_fill_2
XFILLER_154_187 VPWR VGND sg13cmos5l_fill_1
XFILLER_692_0 VPWR VGND sg13cmos5l_decap_8
XFILLER_335_21 VPWR VGND sg13cmos5l_decap_8
X_1320_ _1320_/Q Tile_X0Y1_FrameData[17] VGND VPWR Tile_X0Y9_FrameStrobe[4] latch
XFILLER_311_140 VPWR VGND sg13cmos5l_fill_1
XFILLER_457_133 VPWR VGND sg13cmos5l_fill_2
XFILLER_68_127 VPWR VGND sg13cmos5l_decap_8
XFILLER_256_217 VPWR VGND sg13cmos5l_fill_1
X_1251_ _1251_/Q Tile_X0Y1_FrameData[22] VGND VPWR Tile_X0Y9_FrameStrobe[2] latch
XFILLER_632_63 VPWR VGND sg13cmos5l_decap_8
XFILLER_204_14 VPWR VGND sg13cmos5l_decap_8
XANTENNA__3015__X Tile_X0Y5_E6BEG[2] VPWR VGND sg13cmos5l_antennanp
X_0202_ _0202_/Q Tile_X0Y7_FrameData[21] VGND VPWR Tile_X0Y9_FrameStrobe[1] latch
XFILLER_472_136 VPWR VGND sg13cmos5l_decap_8
XFILLER_351_42 VPWR VGND sg13cmos5l_decap_8
XFILLER_209_133 VPWR VGND sg13cmos5l_decap_8
X_1182_ _1182_/Q Tile_X0Y1_FrameData[27] VGND VPWR Tile_X0Y9_FrameStrobe[0] latch
XFILLER_94_70 VPWR VGND sg13cmos5l_decap_8
X_0133_ AXI_M_SOC_AWSIZE2 _0939_/Q _3681_/X VPWR VGND sg13cmos5l_nor2b_1
XFILLER_209_177 VPWR VGND sg13cmos5l_decap_8
XANTENNA__2854__X Tile_X0Y6_E6BEG[3] VPWR VGND sg13cmos5l_antennanp
XFILLER_501_56 VPWR VGND sg13cmos5l_decap_8
X_0064_ _0064_/X _4108_/X _4109_/X _2666_/Q VPWR VGND sg13cmos5l_mux2_1
XFILLER_220_35 VPWR VGND sg13cmos5l_decap_8
X_4872_ _4872_/X Tile_X0Y9_WW4END[7] AXI_M_SOC_RDATA7 _4923_/X _4900_/X _0799_/Q _0798_/Q
+ VPWR VGND sg13cmos5l_mux4_1
XFILLER_577_49 VPWR VGND sg13cmos5l_decap_8
X_3823_ _3823_/X Tile_X0Y0_WW4END[6] Tile_X0Y0_WW4END[12] _3875_/X _3858_/X _1059_/Q
+ _1058_/Q VPWR VGND sg13cmos5l_mux4_1
XFILLER_393_121 VPWR VGND sg13cmos5l_decap_8
XFILLER_296_28 VPWR VGND sg13cmos5l_decap_8
X_3754_ AXI_M_SOC_ARADDR26 Tile_X0Y8_WW4END[2] Tile_X0Y8_WW4END[10] Tile_X0Y8_W6END[10]
+ _4810_/X _0483_/Q _0482_/Q VPWR VGND sg13cmos5l_mux4_1
X_0966_ _0966_/Q Tile_X0Y0_FrameData[5] VGND VPWR Tile_X0Y9_FrameStrobe[0] latch
XFILLER_542_107 VPWR VGND sg13cmos5l_fill_2
X_2705_ _4309_/A3 VPWR VGND sg13cmos5l_tielo
X_3685_ _3685_/X Tile_X0Y3_WW4END[3] Tile_X0Y3_WW4END[11] Tile_X0Y3_W6END[3] _4225_/X
+ _1751_/Q _1750_/Q VPWR VGND sg13cmos5l_mux4_1
X_0897_ _0897_/Q Tile_X0Y9_FrameData[30] VGND VPWR Tile_X0Y9_FrameStrobe[7] latch
XFILLER_526_42 VPWR VGND sg13cmos5l_fill_2
X_2636_ _2636_/Q Tile_X0Y6_FrameData[27] VGND VPWR Tile_X0Y9_FrameStrobe[6] latch
XFILLER_673_70 VPWR VGND sg13cmos5l_decap_8
XFILLER_550_173 VPWR VGND sg13cmos5l_decap_8
XFILLER_495_217 VPWR VGND sg13cmos5l_fill_1
X_2567_ _2567_/Q Tile_X0Y6_FrameData[0] VGND VPWR Tile_X0Y9_FrameStrobe[3] latch
XFILLER_392_71 VPWR VGND sg13cmos5l_decap_8
XFILLER_160_168 VPWR VGND sg13cmos5l_decap_4
X_4306_ _4306_/X _4308_/X Tile_X0Y4_W6END[2] _4307_/X _4306_/A3 _1929_/Q _1928_/Q
+ VPWR VGND sg13cmos5l_mux4_1
XFILLER_59_105 VPWR VGND sg13cmos5l_decap_8
X_1518_ _1518_/Q Tile_X0Y2_FrameData[3] VGND VPWR Tile_X0Y9_FrameStrobe[2] latch
XFILLER_245_98 VPWR VGND sg13cmos5l_decap_8
X_2498_ _2498_/Q Tile_X0Y6_FrameData[5] VGND VPWR Tile_X0Y9_FrameStrobe[1] latch
XFILLER_59_138 VPWR VGND sg13cmos5l_decap_4
XFILLER_247_217 VPWR VGND sg13cmos5l_fill_1
X_4237_ _4237_/X Tile_X0Y5_W2MID[7] Tile_X0Y5_W2END[7] Tile_X0Y5_W6END[7] _4467_/X
+ _2431_/Q _2430_/Q VPWR VGND sg13cmos5l_mux4_1
XFILLER_652_203 VPWR VGND sg13cmos5l_decap_8
X_1449_ _1449_/Q Tile_X0Y2_FrameData[8] VGND VPWR Tile_X0Y9_FrameStrobe[0] latch
XFILLER_74_108 VPWR VGND sg13cmos5l_decap_8
XFILLER_261_42 VPWR VGND sg13cmos5l_decap_8
X_4168_ _4168_/X Tile_X0Y3_WW4END[11] AXI_M_SOC_WREADY _4233_/X _4211_/X _1805_/Q
+ _1804_/Q VPWR VGND sg13cmos5l_mux4_1
XANTENNA__2764__X Tile_X0Y3_FrameData_O[22] VPWR VGND sg13cmos5l_antennanp
X_3119_ Tile_X0Y7_EE4BEG[5] _4633_/X VPWR VGND sg13cmos5l_buf_1
X_4099_ _4099_/X _4023_/X _4131_/X _4130_/X _4022_/X _1447_/Q _1446_/Q VPWR VGND sg13cmos5l_mux4_1
XFILLER_605_185 VPWR VGND sg13cmos5l_decap_8
XFILLER_411_56 VPWR VGND sg13cmos5l_decap_8
XFILLER_130_35 VPWR VGND sg13cmos5l_decap_8
XFILLER_230_106 VPWR VGND sg13cmos5l_decap_8
XFILLER_90_28 VPWR VGND sg13cmos5l_decap_8
XFILLER_620_188 VPWR VGND sg13cmos5l_fill_1
XFILLER_247_7 VPWR VGND sg13cmos5l_decap_8
XFILLER_487_49 VPWR VGND sg13cmos5l_decap_8
XFILLER_223_191 VPWR VGND sg13cmos5l_decap_8
XFILLER_573_210 VPWR VGND sg13cmos5l_decap_8
XFILLER_210_90 VPWR VGND sg13cmos5l_decap_8
XANTENNA__3595__X Tile_X0Y9_FrameData_O[25] VPWR VGND sg13cmos5l_antennanp
XFILLER_414_7 VPWR VGND sg13cmos5l_decap_8
XFILLER_384_165 VPWR VGND sg13cmos5l_decap_8
XFILLER_139_77 VPWR VGND sg13cmos5l_decap_8
XFILLER_436_20 VPWR VGND sg13cmos5l_decap_8
XFILLER_526_192 VPWR VGND sg13cmos5l_decap_8
XFILLER_99_59 VPWR VGND sg13cmos5l_decap_8
XFILLER_687_111 VPWR VGND sg13cmos5l_decap_4
XFILLER_136_154 VPWR VGND sg13cmos5l_decap_8
XFILLER_541_140 VPWR VGND sg13cmos5l_decap_8
XFILLER_583_70 VPWR VGND sg13cmos5l_decap_8
XFILLER_541_162 VPWR VGND sg13cmos5l_decap_8
XFILLER_155_21 VPWR VGND sg13cmos5l_fill_1
XFILLER_541_195 VPWR VGND sg13cmos5l_decap_4
XFILLER_436_97 VPWR VGND sg13cmos5l_decap_8
XFILLER_2_123 VPWR VGND sg13cmos5l_decap_8
XANTENNA__2939__X Tile_X0Y8_E6BEG[7] VPWR VGND sg13cmos5l_antennanp
XFILLER_151_157 VPWR VGND sg13cmos5l_decap_8
XFILLER_2_167 VPWR VGND sg13cmos5l_decap_4
XFILLER_305_13 VPWR VGND sg13cmos5l_decap_8
XFILLER_305_24 VPWR VGND sg13cmos5l_fill_2
XFILLER_439_155 VPWR VGND sg13cmos5l_fill_1
XFILLER_439_177 VPWR VGND sg13cmos5l_decap_8
XFILLER_171_42 VPWR VGND sg13cmos5l_decap_8
XFILLER_273_0 VPWR VGND sg13cmos5l_decap_8
XFILLER_171_97 VPWR VGND sg13cmos5l_decap_4
XFILLER_73_141 VPWR VGND sg13cmos5l_fill_1
XFILLER_206_125 VPWR VGND sg13cmos5l_decap_8
XFILLER_611_122 VPWR VGND sg13cmos5l_fill_2
XFILLER_64_51 VPWR VGND sg13cmos5l_decap_8
XFILLER_440_0 VPWR VGND sg13cmos5l_decap_8
XFILLER_321_89 VPWR VGND sg13cmos5l_fill_2
XFILLER_538_0 VPWR VGND sg13cmos5l_decap_8
XFILLER_221_128 VPWR VGND sg13cmos5l_decap_8
XFILLER_397_49 VPWR VGND sg13cmos5l_decap_8
XFILLER_9_35 VPWR VGND sg13cmos5l_decap_8
XFILLER_694_14 VPWR VGND sg13cmos5l_decap_8
XFILLER_705_0 VPWR VGND sg13cmos5l_decap_8
X_0820_ _0820_/Q Tile_X0Y9_FrameData[11] VGND VPWR Tile_X0Y9_FrameStrobe[4] latch
XFILLER_390_124 VPWR VGND sg13cmos5l_decap_8
XFILLER_196_83 VPWR VGND sg13cmos5l_decap_8
X_0751_ _0751_/Q Tile_X0Y9_FrameData[16] VGND VPWR Tile_X0Y9_FrameStrobe[2] latch
XFILLER_627_63 VPWR VGND sg13cmos5l_decap_8
XFILLER_678_100 VPWR VGND sg13cmos5l_decap_8
XFILLER_678_111 VPWR VGND sg13cmos5l_fill_1
XFILLER_127_154 VPWR VGND sg13cmos5l_decap_8
XFILLER_346_42 VPWR VGND sg13cmos5l_decap_8
X_0682_ _0682_/Q Tile_X0Y9_FrameData[21] VGND VPWR Tile_X0Y9_FrameStrobe[0] latch
X_3470_ Tile_X0Y1_FrameData_O[28] Tile_X0Y1_FrameData[28] VPWR VGND sg13cmos5l_buf_1
XFILLER_493_70 VPWR VGND sg13cmos5l_decap_8
XFILLER_532_184 VPWR VGND sg13cmos5l_fill_1
XFILLER_288_117 VPWR VGND sg13cmos5l_fill_2
X_2421_ _2421_/Q Tile_X0Y5_FrameData[16] VGND VPWR Tile_X0Y9_FrameStrobe[7] latch
XFILLER_477_217 VPWR VGND sg13cmos5l_fill_1
XANTENNA__2849__X Tile_X0Y6_E2BEGb[6] VPWR VGND sg13cmos5l_antennanp
XFILLER_142_157 VPWR VGND sg13cmos5l_decap_8
X_2352_ _2352_/Q Tile_X0Y5_FrameData[21] VGND VPWR Tile_X0Y9_FrameStrobe[5] latch
XFILLER_643_84 VPWR VGND sg13cmos5l_decap_8
XFILLER_215_35 VPWR VGND sg13cmos5l_decap_8
XFILLER_229_217 VPWR VGND sg13cmos5l_fill_1
X_1303_ _1303_/Q Tile_X0Y1_FrameData[2] VGND VPWR Tile_X0Y9_FrameStrobe[3] latch
XFILLER_150_190 VPWR VGND sg13cmos5l_fill_1
X_2283_ _2283_/Q Tile_X0Y5_FrameData[26] VGND VPWR Tile_X0Y9_FrameStrobe[3] latch
XFILLER_29_2 VPWR VGND sg13cmos5l_fill_1
XFILLER_296_194 VPWR VGND sg13cmos5l_decap_8
X_1234_ _1234_/Q Tile_X0Y1_FrameData[7] VGND VPWR Tile_X0Y9_FrameStrobe[1] latch
X_4022_ _4022_/X Tile_X0Y0_W2MID[6] Tile_X0Y0_W2END[6] Tile_X0Y0_W6END[9] _3855_/X
+ _1131_/Q _1130_/Q VPWR VGND sg13cmos5l_mux4_1
XFILLER_512_77 VPWR VGND sg13cmos5l_decap_8
X_1165_ _1165_/Q Tile_X0Y0_FrameData[30] VGND VPWR Tile_X0Y9_FrameStrobe[7] latch
X_0116_ AXI_M_SOC_ARLEN7 _0933_/Q _3767_/X VPWR VGND sg13cmos5l_nor2b_1
XFILLER_64_174 VPWR VGND sg13cmos5l_decap_8
X_1096_ _1096_/Q Tile_X0Y0_FrameData[3] VGND VPWR Tile_X0Y9_FrameStrobe[4] latch
X_0047_ AXI_M_SOC_AWCACHE2 _0936_/Q _3687_/X VPWR VGND sg13cmos5l_nor2b_1
X_4924_ _4924_/X Tile_X0Y9_N1END[0] Tile_X0Y9_N4END[0] _4896_/X _0083_/X _0711_/Q
+ _0710_/Q VPWR VGND sg13cmos5l_mux4_1
XFILLER_212_139 VPWR VGND sg13cmos5l_decap_8
XFILLER_100_27 VPWR VGND sg13cmos5l_decap_8
X_4855_ _4855_/X Tile_X0Y9_W2MID[0] AXI_M_SOC_RDATA7 _4901_/X _4900_/X _0833_/Q _0832_/Q
+ VPWR VGND sg13cmos5l_mux4_1
X_3806_ _3806_/X Tile_X0Y0_W2MID[5] Tile_X0Y0_W2END[2] _3857_/X _3856_/X _1093_/Q
+ _1092_/Q VPWR VGND sg13cmos5l_mux4_1
XFILLER_387_93 VPWR VGND sg13cmos5l_fill_1
X_4786_ _4786_/X _4713_/X Tile_X0Y9_N2MID[6] _4822_/X _4712_/X _0427_/Q _0426_/Q VPWR
+ VGND sg13cmos5l_mux4_1
X_1998_ _1998_/Q Tile_X0Y4_FrameData[23] VGND VPWR Tile_X0Y9_FrameStrobe[2] latch
XFILLER_508_170 VPWR VGND sg13cmos5l_decap_8
X_3737_ AXI_M_SOC_ARADDR9 Tile_X0Y9_WW4END[1] Tile_X0Y9_WW4END[9] Tile_X0Y9_W6END[9]
+ _4925_/X _0741_/Q _0740_/Q VPWR VGND sg13cmos5l_mux4_1
XFILLER_109_14 VPWR VGND sg13cmos5l_decap_4
X_0949_ _0949_/Q Tile_X0Y0_FrameData[22] VGND VPWR Tile_X0Y9_FrameStrobe[0] latch
XFILLER_180_208 VPWR VGND sg13cmos5l_fill_1
XFILLER_256_42 VPWR VGND sg13cmos5l_decap_8
XFILLER_537_96 VPWR VGND sg13cmos5l_decap_8
X_3668_ AXI_M_SOC_AWADDR29 Tile_X0Y4_W1END[1] Tile_X0Y4_WW4END[5] Tile_X0Y4_WW4END[13]
+ _4349_/X _1987_/Q _1986_/Q VPWR VGND sg13cmos5l_mux4_1
XFILLER_118_187 VPWR VGND sg13cmos5l_fill_1
XFILLER_69_18 VPWR VGND sg13cmos5l_decap_8
XFILLER_523_173 VPWR VGND sg13cmos5l_decap_8
XANTENNA__2759__X Tile_X0Y3_FrameData_O[17] VPWR VGND sg13cmos5l_antennanp
X_2619_ _2619_/Q Tile_X0Y6_FrameData[12] VGND VPWR Tile_X0Y9_FrameStrobe[5] latch
XFILLER_669_177 VPWR VGND sg13cmos5l_fill_1
X_3599_ Tile_X0Y9_FrameData_O[29] Tile_X0Y9_FrameData[29] VPWR VGND sg13cmos5l_buf_1
XFILLER_133_168 VPWR VGND sg13cmos5l_fill_2
XFILLER_684_147 VPWR VGND sg13cmos5l_fill_1
XFILLER_553_84 VPWR VGND sg13cmos5l_decap_8
XFILLER_684_169 VPWR VGND sg13cmos5l_decap_4
XFILLER_125_35 VPWR VGND sg13cmos5l_decap_8
XFILLER_703_21 VPWR VGND sg13cmos5l_decap_8
XFILLER_141_190 VPWR VGND sg13cmos5l_decap_8
XFILLER_272_63 VPWR VGND sg13cmos5l_decap_8
XFILLER_85_28 VPWR VGND sg13cmos5l_decap_8
XFILLER_197_7 VPWR VGND sg13cmos5l_decap_8
XFILLER_47_119 VPWR VGND sg13cmos5l_fill_2
XFILLER_703_98 VPWR VGND sg13cmos5l_decap_8
XFILLER_451_117 VPWR VGND sg13cmos5l_decap_4
XFILLER_422_77 VPWR VGND sg13cmos5l_decap_8
XFILLER_364_7 VPWR VGND sg13cmos5l_decap_8
XFILLER_141_34 VPWR VGND sg13cmos5l_decap_8
XFILLER_444_180 VPWR VGND sg13cmos5l_decap_4
XFILLER_70_122 VPWR VGND sg13cmos5l_decap_8
XFILLER_531_7 VPWR VGND sg13cmos5l_decap_8
XFILLER_629_7 VPWR VGND sg13cmos5l_decap_8
XFILLER_578_70 VPWR VGND sg13cmos5l_decap_8
XFILLER_70_199 VPWR VGND sg13cmos5l_decap_8
XFILLER_211_161 VPWR VGND sg13cmos5l_decap_8
XFILLER_357_154 VPWR VGND sg13cmos5l_decap_8
XFILLER_372_124 VPWR VGND sg13cmos5l_decap_8
XFILLER_664_28 VPWR VGND sg13cmos5l_decap_8
XFILLER_594_80 VPWR VGND sg13cmos5l_decap_8
XFILLER_171_208 VPWR VGND sg13cmos5l_fill_2
XFILLER_166_42 VPWR VGND sg13cmos5l_decap_8
XFILLER_119_0 VPWR VGND sg13cmos5l_decap_8
XFILLER_459_206 VPWR VGND sg13cmos5l_decap_4
XFILLER_459_217 VPWR VGND sg13cmos5l_fill_1
XFILLER_1_0 VPWR VGND sg13cmos5l_decap_8
XFILLER_124_179 VPWR VGND sg13cmos5l_fill_1
XFILLER_680_49 VPWR VGND sg13cmos5l_decap_8
XFILLER_182_41 VPWR VGND sg13cmos5l_decap_8
XFILLER_613_21 VPWR VGND sg13cmos5l_decap_8
XFILLER_390_0 VPWR VGND sg13cmos5l_decap_8
XFILLER_278_161 VPWR VGND sg13cmos5l_decap_8
XFILLER_690_106 VPWR VGND sg13cmos5l_fill_1
XFILLER_488_0 VPWR VGND sg13cmos5l_decap_8
XFILLER_690_128 VPWR VGND sg13cmos5l_fill_1
XFILLER_182_85 VPWR VGND sg13cmos5l_decap_8
XFILLER_38_119 VPWR VGND sg13cmos5l_decap_8
XFILLER_427_147 VPWR VGND sg13cmos5l_decap_8
XFILLER_613_98 VPWR VGND sg13cmos5l_decap_8
XFILLER_689_14 VPWR VGND sg13cmos5l_decap_8
XFILLER_655_0 VPWR VGND sg13cmos5l_decap_8
XFILLER_450_150 VPWR VGND sg13cmos5l_decap_8
XFILLER_61_144 VPWR VGND sg13cmos5l_fill_2
X_2970_ Tile_X0Y8_FrameData_O[10] Tile_X0Y8_FrameData[10] VPWR VGND sg13cmos5l_buf_1
XFILLER_395_216 VPWR VGND sg13cmos5l_fill_2
XFILLER_488_70 VPWR VGND sg13cmos5l_decap_8
XFILLER_450_194 VPWR VGND sg13cmos5l_decap_8
XFILLER_91_60 VPWR VGND sg13cmos5l_decap_8
X_1921_ _1921_/Q Tile_X0Y3_FrameData[8] VGND VPWR Tile_X0Y9_FrameStrobe[7] latch
X_4640_ _4640_/X Tile_X0Y7_WW4END[3] AXI_M_SOC_RDATA19 _4687_/X _4675_/X _0279_/Q
+ _0278_/Q VPWR VGND sg13cmos5l_mux4_1
XFILLER_147_216 VPWR VGND sg13cmos5l_fill_2
X_1852_ _1852_/Q Tile_X0Y3_FrameData[13] VGND VPWR Tile_X0Y9_FrameStrobe[5] latch
XFILLER_638_84 VPWR VGND sg13cmos5l_decap_8
XFILLER_552_202 VPWR VGND sg13cmos5l_decap_8
X_0803_ _0803_/Q Tile_X0Y9_FrameData[28] VGND VPWR Tile_X0Y9_FrameStrobe[4] latch
XFILLER_574_28 VPWR VGND sg13cmos5l_decap_8
X_4571_ _4571_/X _4551_/X Tile_X0Y9_N4END[15] _4550_/X _0150_/X _2489_/Q _2488_/Q
+ VPWR VGND sg13cmos5l_mux4_1
XFILLER_363_146 VPWR VGND sg13cmos5l_fill_1
XFILLER_357_63 VPWR VGND sg13cmos5l_decap_8
X_1783_ _1783_/Q Tile_X0Y3_FrameData[18] VGND VPWR Tile_X0Y9_FrameStrobe[3] latch
X_3522_ Tile_X0Y9_E1BEG[0] _4844_/X VPWR VGND sg13cmos5l_buf_1
X_0734_ _0734_/Q Tile_X0Y9_FrameData[1] VGND VPWR Tile_X0Y9_FrameStrobe[1] latch
XFILLER_505_151 VPWR VGND sg13cmos5l_decap_8
XFILLER_507_77 VPWR VGND sg13cmos5l_decap_8
X_3453_ Tile_X0Y1_FrameData_O[11] Tile_X0Y1_FrameData[11] VPWR VGND sg13cmos5l_buf_1
X_0665_ _0665_/Q Tile_X0Y8_FrameData[6] VGND VPWR Tile_X0Y9_FrameStrobe[7] latch
XFILLER_115_157 VPWR VGND sg13cmos5l_decap_8
XFILLER_666_125 VPWR VGND sg13cmos5l_decap_8
XFILLER_373_51 VPWR VGND sg13cmos5l_fill_1
XFILLER_130_105 VPWR VGND sg13cmos5l_decap_8
X_2404_ _2404_/Q Tile_X0Y5_FrameData[1] VGND VPWR Tile_X0Y9_FrameStrobe[6] latch
XFILLER_590_49 VPWR VGND sg13cmos5l_decap_8
X_0596_ _0596_/Q Tile_X0Y8_FrameData[11] VGND VPWR Tile_X0Y9_FrameStrobe[5] latch
X_3384_ Tile_X0Y2_E6BEG[7] _4079_/X VPWR VGND sg13cmos5l_buf_1
XFILLER_523_21 VPWR VGND sg13cmos5l_decap_8
XFILLER_34_0 VPWR VGND sg13cmos5l_fill_2
XFILLER_520_198 VPWR VGND sg13cmos5l_decap_8
X_2335_ _2335_/Q Tile_X0Y5_FrameData[6] VGND VPWR Tile_X0Y9_FrameStrobe[4] latch
X_2266_ _2266_/Q Tile_X0Y5_FrameData[11] VGND VPWR Tile_X0Y9_FrameStrobe[2] latch
XFILLER_599_14 VPWR VGND sg13cmos5l_decap_8
X_4005_ _4005_/X _3981_/X _0073_/X _3980_/X Tile_X0Y0_S4END[4] _1209_/Q _1208_/Q VPWR
+ VGND sg13cmos5l_mux4_1
X_1217_ _1217_/Q Tile_X0Y1_FrameData[24] VGND VPWR Tile_X0Y9_FrameStrobe[1] latch
X_2197_ _2197_/Q Tile_X0Y5_FrameData[16] VGND VPWR Tile_X0Y9_FrameStrobe[0] latch
XANTENNA__3203__X Tile_X0Y0_N2BEG[3] VPWR VGND sg13cmos5l_antennanp
XFILLER_37_174 VPWR VGND sg13cmos5l_decap_4
XFILLER_1_91 VPWR VGND sg13cmos5l_fill_2
XFILLER_52_100 VPWR VGND sg13cmos5l_decap_8
X_1148_ _1148_/Q Tile_X0Y0_FrameData[15] VGND VPWR Tile_X0Y9_FrameStrobe[6] latch
XFILLER_197_105 VPWR VGND sg13cmos5l_fill_2
XFILLER_52_144 VPWR VGND sg13cmos5l_decap_8
X_1079_ _1079_/Q Tile_X0Y0_FrameData[20] VGND VPWR Tile_X0Y9_FrameStrobe[4] latch
XFILLER_441_194 VPWR VGND sg13cmos5l_decap_8
X_4907_ _4907_/X Tile_X0Y9_N2MID[3] Tile_X0Y9_N2END[3] _4935_/X _4819_/X _0689_/Q
+ _0688_/Q VPWR VGND sg13cmos5l_mux4_1
X_4838_ _4838_/X Tile_X0Y9_W1END[1] Tile_X0Y9_WW4END[13] Tile_X0Y9_W6END[5] _4917_/X
+ _0864_/Q _0863_/Q VPWR VGND sg13cmos5l_mux4_1
XFILLER_138_216 VPWR VGND sg13cmos5l_fill_2
XFILLER_548_84 VPWR VGND sg13cmos5l_decap_8
XFILLER_689_217 VPWR VGND sg13cmos5l_fill_1
XFILLER_484_28 VPWR VGND sg13cmos5l_decap_8
XFILLER_267_63 VPWR VGND sg13cmos5l_decap_8
X_4769_ _4769_/X AXI_M_SOC_RDATA13 _4802_/X _4806_/X _4788_/X _0509_/Q _0508_/Q VPWR
+ VGND sg13cmos5l_mux4_1
XFILLER_354_168 VPWR VGND sg13cmos5l_fill_1
XFILLER_4_207 VPWR VGND sg13cmos5l_decap_8
XFILLER_112_7 VPWR VGND sg13cmos5l_decap_8
XFILLER_105_6 VPWR VGND sg13cmos5l_decap_8
XFILLER_511_121 VPWR VGND sg13cmos5l_decap_8
XFILLER_417_77 VPWR VGND sg13cmos5l_decap_8
XFILLER_106_146 VPWR VGND sg13cmos5l_decap_8
XFILLER_136_56 VPWR VGND sg13cmos5l_decap_8
XFILLER_714_42 VPWR VGND sg13cmos5l_decap_8
XFILLER_456_209 VPWR VGND sg13cmos5l_decap_8
XFILLER_283_84 VPWR VGND sg13cmos5l_decap_8
XFILLER_96_38 VPWR VGND sg13cmos5l_decap_8
XFILLER_433_21 VPWR VGND sg13cmos5l_decap_8
XFILLER_481_7 VPWR VGND sg13cmos5l_decap_8
XFILLER_579_7 VPWR VGND sg13cmos5l_decap_8
XFILLER_75_214 VPWR VGND sg13cmos5l_decap_4
XFILLER_433_98 VPWR VGND sg13cmos5l_decap_8
XFILLER_290_112 VPWR VGND sg13cmos5l_decap_8
XFILLER_613_217 VPWR VGND sg13cmos5l_fill_1
XFILLER_302_14 VPWR VGND sg13cmos5l_decap_8
XFILLER_28_141 VPWR VGND sg13cmos5l_decap_8
XFILLER_152_88 VPWR VGND sg13cmos5l_decap_8
XFILLER_28_152 VPWR VGND sg13cmos5l_fill_2
XANTENNA__3113__X Tile_X0Y7_E6BEG[11] VPWR VGND sg13cmos5l_antennanp
XFILLER_43_100 VPWR VGND sg13cmos5l_fill_1
XFILLER_659_28 VPWR VGND sg13cmos5l_decap_8
XFILLER_45_42 VPWR VGND sg13cmos5l_decap_8
XFILLER_43_122 VPWR VGND sg13cmos5l_decap_4
XFILLER_28_196 VPWR VGND sg13cmos5l_decap_4
XFILLER_578_154 VPWR VGND sg13cmos5l_decap_8
XANTENNA__2952__X Tile_X0Y8_EE4BEG[8] VPWR VGND sg13cmos5l_antennanp
XFILLER_578_165 VPWR VGND sg13cmos5l_fill_2
XFILLER_188_127 VPWR VGND sg13cmos5l_decap_8
XFILLER_593_113 VPWR VGND sg13cmos5l_decap_8
XFILLER_519_210 VPWR VGND sg13cmos5l_fill_1
XFILLER_236_0 VPWR VGND sg13cmos5l_decap_8
XFILLER_61_41 VPWR VGND sg13cmos5l_fill_2
XFILLER_61_52 VPWR VGND sg13cmos5l_fill_1
XFILLER_458_73 VPWR VGND sg13cmos5l_decap_4
XFILLER_675_49 VPWR VGND sg13cmos5l_decap_8
XFILLER_534_202 VPWR VGND sg13cmos5l_fill_2
XFILLER_61_74 VPWR VGND sg13cmos5l_decap_8
XFILLER_608_21 VPWR VGND sg13cmos5l_decap_8
XFILLER_394_28 VPWR VGND sg13cmos5l_decap_8
XFILLER_177_63 VPWR VGND sg13cmos5l_decap_4
XFILLER_6_14 VPWR VGND sg13cmos5l_decap_8
XFILLER_403_0 VPWR VGND sg13cmos5l_decap_8
XANTENNA_7 AXI_M_SOC_RDATA27 VPWR VGND sg13cmos5l_antennanp
XFILLER_298_201 VPWR VGND sg13cmos5l_fill_2
XFILLER_499_161 VPWR VGND sg13cmos5l_decap_8
XFILLER_474_72 VPWR VGND sg13cmos5l_decap_4
XFILLER_474_94 VPWR VGND sg13cmos5l_fill_2
XFILLER_624_42 VPWR VGND sg13cmos5l_decap_8
XFILLER_502_154 VPWR VGND sg13cmos5l_decap_8
XFILLER_193_62 VPWR VGND sg13cmos5l_decap_8
X_0450_ _0450_/Q Tile_X0Y8_FrameData[29] VGND VPWR Tile_X0Y9_FrameStrobe[1] latch
XFILLER_648_147 VPWR VGND sg13cmos5l_decap_8
XFILLER_447_209 VPWR VGND sg13cmos5l_decap_8
XFILLER_343_21 VPWR VGND sg13cmos5l_decap_8
XFILLER_112_149 VPWR VGND sg13cmos5l_fill_2
XFILLER_105_190 VPWR VGND sg13cmos5l_decap_8
X_0381_ _0381_/Q Tile_X0Y7_FrameData[2] VGND VPWR Tile_X0Y9_FrameStrobe[6] latch
XFILLER_663_139 VPWR VGND sg13cmos5l_decap_8
X_2120_ _2120_/Q Tile_X0Y4_FrameData[29] VGND VPWR Tile_X0Y9_FrameStrobe[6] latch
XFILLER_266_164 VPWR VGND sg13cmos5l_decap_8
XFILLER_266_175 VPWR VGND sg13cmos5l_fill_1
XFILLER_470_201 VPWR VGND sg13cmos5l_fill_2
XFILLER_281_112 VPWR VGND sg13cmos5l_decap_8
X_2051_ _2051_/Q Tile_X0Y4_FrameData[2] VGND VPWR Tile_X0Y9_FrameStrobe[3] latch
XFILLER_604_217 VPWR VGND sg13cmos5l_fill_1
XFILLER_266_197 VPWR VGND sg13cmos5l_decap_8
XFILLER_640_63 VPWR VGND sg13cmos5l_decap_8
XFILLER_415_128 VPWR VGND sg13cmos5l_decap_8
XFILLER_81_217 VPWR VGND sg13cmos5l_fill_1
XANTENNA__3023__X Tile_X0Y5_E6BEG[10] VPWR VGND sg13cmos5l_antennanp
X_1002_ _1002_/Q Tile_X0Y0_FrameData[1] VGND VPWR Tile_X0Y9_FrameStrobe[1] latch
XFILLER_569_28 VPWR VGND sg13cmos5l_decap_8
XFILLER_34_111 VPWR VGND sg13cmos5l_decap_8
XFILLER_212_69 VPWR VGND sg13cmos5l_decap_8
XFILLER_281_189 VPWR VGND sg13cmos5l_decap_8
XFILLER_569_154 VPWR VGND sg13cmos5l_decap_8
XFILLER_499_91 VPWR VGND sg13cmos5l_decap_8
XFILLER_423_172 VPWR VGND sg13cmos5l_decap_8
XANTENNA__2862__X Tile_X0Y6_E6BEG[11] VPWR VGND sg13cmos5l_antennanp
XFILLER_368_216 VPWR VGND sg13cmos5l_fill_2
XFILLER_584_124 VPWR VGND sg13cmos5l_fill_2
XFILLER_34_188 VPWR VGND sg13cmos5l_decap_8
X_2953_ Tile_X0Y8_EE4BEG[9] _4753_/X VPWR VGND sg13cmos5l_buf_1
XFILLER_584_157 VPWR VGND sg13cmos5l_fill_1
XFILLER_194_119 VPWR VGND sg13cmos5l_decap_4
X_1904_ _1904_/Q Tile_X0Y3_FrameData[25] VGND VPWR Tile_X0Y9_FrameStrobe[7] latch
XFILLER_584_179 VPWR VGND sg13cmos5l_decap_4
X_2884_ Tile_X0Y6_FrameData_O[5] Tile_X0Y6_FrameData[5] VPWR VGND sg13cmos5l_buf_1
XFILLER_585_49 VPWR VGND sg13cmos5l_decap_8
XFILLER_525_213 VPWR VGND sg13cmos5l_decap_4
XFILLER_518_21 VPWR VGND sg13cmos5l_decap_8
X_4623_ _4623_/X Tile_X0Y7_W2END[4] AXI_M_SOC_RDATA20 _4675_/X _4674_/X _0313_/Q _0312_/Q
+ VPWR VGND sg13cmos5l_mux4_1
XFILLER_336_135 VPWR VGND sg13cmos5l_decap_8
X_1835_ _1835_/Q Tile_X0Y3_FrameData[30] VGND VPWR Tile_X0Y9_FrameStrobe[5] latch
XANTENNA__3693__X AXI_M_SOC_WDATA3 VPWR VGND sg13cmos5l_antennanp
XFILLER_351_105 VPWR VGND sg13cmos5l_decap_8
X_4554_ _4554_/X _4481_/X _4597_/X _4596_/X _4480_/X _2451_/Q _2450_/Q VPWR VGND sg13cmos5l_mux4_1
X_1766_ _1766_/Q Tile_X0Y3_FrameData[3] VGND VPWR Tile_X0Y9_FrameStrobe[2] latch
XFILLER_289_201 VPWR VGND sg13cmos5l_decap_8
X_3505_ Tile_X0Y1_E2BEGb[3] _3943_/X VPWR VGND sg13cmos5l_buf_1
X_0717_ _0717_/Q Tile_X0Y9_FrameData[18] VGND VPWR Tile_X0Y9_FrameStrobe[1] latch
X_4485_ _4485_/X _4572_/X _4576_/X _4580_/X _4558_/X _2635_/Q _2634_/Q VPWR VGND sg13cmos5l_mux4_1
X_1697_ _1697_/Q Tile_X0Y3_FrameData[8] VGND VPWR Tile_X0Y9_FrameStrobe[0] latch
XFILLER_237_99 VPWR VGND sg13cmos5l_decap_8
XFILLER_639_147 VPWR VGND sg13cmos5l_decap_8
XFILLER_534_42 VPWR VGND sg13cmos5l_decap_8
X_3436_ Tile_X0Y4_FrameData_O[27] Tile_X0Y4_FrameData[27] VPWR VGND sg13cmos5l_buf_1
XFILLER_534_53 VPWR VGND sg13cmos5l_fill_1
X_0648_ _0648_/Q Tile_X0Y8_FrameData[23] VGND VPWR Tile_X0Y9_FrameStrobe[7] latch
XFILLER_681_70 VPWR VGND sg13cmos5l_decap_8
XFILLER_253_21 VPWR VGND sg13cmos5l_decap_8
XFILLER_103_138 VPWR VGND sg13cmos5l_decap_8
X_3367_ Tile_X0Y2_EE4BEG[6] _4062_/X VPWR VGND sg13cmos5l_buf_1
X_0579_ _0579_/Q Tile_X0Y8_FrameData[28] VGND VPWR Tile_X0Y9_FrameStrobe[5] latch
XFILLER_654_139 VPWR VGND sg13cmos5l_decap_8
XFILLER_111_160 VPWR VGND sg13cmos5l_decap_8
X_2318_ _2318_/Q Tile_X0Y5_FrameData[23] VGND VPWR Tile_X0Y9_FrameStrobe[4] latch
X_3298_ Tile_X0Y0_E2BEGb[6] _3818_/X VPWR VGND sg13cmos5l_buf_1
XFILLER_403_35 VPWR VGND sg13cmos5l_decap_8
XFILLER_461_201 VPWR VGND sg13cmos5l_decap_8
XFILLER_662_161 VPWR VGND sg13cmos5l_decap_4
XFILLER_272_112 VPWR VGND sg13cmos5l_decap_8
XFILLER_257_186 VPWR VGND sg13cmos5l_decap_4
XFILLER_122_14 VPWR VGND sg13cmos5l_decap_8
X_2249_ _2249_/Q Tile_X0Y5_FrameData[28] VGND VPWR Tile_X0Y9_FrameStrobe[2] latch
XFILLER_122_58 VPWR VGND sg13cmos5l_decap_8
XFILLER_479_28 VPWR VGND sg13cmos5l_decap_8
XFILLER_25_122 VPWR VGND sg13cmos5l_fill_1
XANTENNA__2772__X Tile_X0Y3_FrameData_O[30] VPWR VGND sg13cmos5l_antennanp
XFILLER_700_77 VPWR VGND sg13cmos5l_decap_8
XFILLER_202_91 VPWR VGND sg13cmos5l_decap_8
XFILLER_15_56 VPWR VGND sg13cmos5l_decap_8
XFILLER_575_168 VPWR VGND sg13cmos5l_decap_8
XFILLER_185_119 VPWR VGND sg13cmos5l_decap_8
XFILLER_709_42 VPWR VGND sg13cmos5l_decap_8
XFILLER_717_140 VPWR VGND sg13cmos5l_decap_8
XFILLER_495_49 VPWR VGND sg13cmos5l_decap_8
XFILLER_327_7 VPWR VGND sg13cmos5l_decap_8
XFILLER_278_84 VPWR VGND sg13cmos5l_decap_8
XFILLER_590_127 VPWR VGND sg13cmos5l_decap_8
XFILLER_428_21 VPWR VGND sg13cmos5l_decap_8
XFILLER_327_168 VPWR VGND sg13cmos5l_fill_1
XFILLER_31_55 VPWR VGND sg13cmos5l_decap_8
XFILLER_193_185 VPWR VGND sg13cmos5l_fill_1
XFILLER_428_98 VPWR VGND sg13cmos5l_decap_8
XFILLER_696_7 VPWR VGND sg13cmos5l_decap_8
XANTENNA__3108__X Tile_X0Y7_E6BEG[6] VPWR VGND sg13cmos5l_antennanp
XFILLER_444_42 VPWR VGND sg13cmos5l_decap_8
XFILLER_591_70 VPWR VGND sg13cmos5l_decap_8
XFILLER_496_175 VPWR VGND sg13cmos5l_decap_8
XFILLER_444_86 VPWR VGND sg13cmos5l_decap_8
XFILLER_163_54 VPWR VGND sg13cmos5l_decap_4
XANTENNA__2947__X Tile_X0Y8_EE4BEG[3] VPWR VGND sg13cmos5l_antennanp
XFILLER_638_180 VPWR VGND sg13cmos5l_fill_1
XFILLER_48_203 VPWR VGND sg13cmos5l_fill_2
XFILLER_248_164 VPWR VGND sg13cmos5l_decap_8
XFILLER_186_0 VPWR VGND sg13cmos5l_decap_8
XFILLER_56_41 VPWR VGND sg13cmos5l_fill_2
XFILLER_460_74 VPWR VGND sg13cmos5l_fill_2
XFILLER_313_68 VPWR VGND sg13cmos5l_decap_8
XFILLER_56_74 VPWR VGND sg13cmos5l_decap_8
XFILLER_389_28 VPWR VGND sg13cmos5l_decap_8
XFILLER_263_178 VPWR VGND sg13cmos5l_decap_8
XFILLER_405_161 VPWR VGND sg13cmos5l_decap_8
XFILLER_353_0 VPWR VGND sg13cmos5l_decap_8
XANTENNA__3778__X AXI_M_SOC_ARVALID VPWR VGND sg13cmos5l_antennanp
XFILLER_610_77 VPWR VGND sg13cmos5l_fill_1
XFILLER_610_88 VPWR VGND sg13cmos5l_decap_8
XFILLER_16_177 VPWR VGND sg13cmos5l_decap_8
XFILLER_16_188 VPWR VGND sg13cmos5l_fill_2
XFILLER_72_62 VPWR VGND sg13cmos5l_decap_8
XFILLER_469_83 VPWR VGND sg13cmos5l_decap_8
XFILLER_520_0 VPWR VGND sg13cmos5l_decap_8
XFILLER_469_94 VPWR VGND sg13cmos5l_fill_2
XFILLER_31_147 VPWR VGND sg13cmos5l_fill_1
XFILLER_566_168 VPWR VGND sg13cmos5l_decap_8
XFILLER_618_0 VPWR VGND sg13cmos5l_decap_8
XFILLER_708_140 VPWR VGND sg13cmos5l_decap_8
XFILLER_619_42 VPWR VGND sg13cmos5l_decap_8
XFILLER_169_171 VPWR VGND sg13cmos5l_fill_2
XFILLER_318_113 VPWR VGND sg13cmos5l_decap_8
XFILLER_338_21 VPWR VGND sg13cmos5l_decap_8
XFILLER_318_124 VPWR VGND sg13cmos5l_fill_2
XFILLER_184_152 VPWR VGND sg13cmos5l_decap_8
XFILLER_184_163 VPWR VGND sg13cmos5l_fill_2
X_1620_ _1620_/Q Tile_X0Y2_FrameData[29] VGND VPWR Tile_X0Y9_FrameStrobe[6] latch
XFILLER_338_87 VPWR VGND sg13cmos5l_fill_2
X_1551_ _1551_/Q Tile_X0Y2_FrameData[2] VGND VPWR Tile_X0Y9_FrameStrobe[3] latch
XFILLER_635_63 VPWR VGND sg13cmos5l_decap_8
XANTENNA__3018__X Tile_X0Y5_E6BEG[5] VPWR VGND sg13cmos5l_antennanp
XFILLER_354_42 VPWR VGND sg13cmos5l_decap_8
X_0502_ _0502_/Q Tile_X0Y8_FrameData[9] VGND VPWR Tile_X0Y9_FrameStrobe[2] latch
X_4270_ _4270_/X Tile_X0Y4_W2END[1] AXI_M_SOC_BRESP1 _4315_/X _4314_/X _2073_/Q _2072_/Q
+ VPWR VGND sg13cmos5l_mux4_1
XFILLER_341_171 VPWR VGND sg13cmos5l_fill_1
XFILLER_286_204 VPWR VGND sg13cmos5l_decap_8
XFILLER_98_136 VPWR VGND sg13cmos5l_decap_8
X_1482_ _1482_/Q Tile_X0Y2_FrameData[7] VGND VPWR Tile_X0Y9_FrameStrobe[1] latch
XFILLER_207_69 VPWR VGND sg13cmos5l_decap_8
X_3221_ Tile_X0Y0_FrameStrobe_O[9] Tile_X0Y9_FrameStrobe[9] VPWR VGND sg13cmos5l_buf_1
XFILLER_98_169 VPWR VGND sg13cmos5l_decap_4
X_0433_ _0433_/Q Tile_X0Y8_FrameData[14] VGND VPWR Tile_X0Y9_FrameStrobe[0] latch
XANTENNA__2857__X Tile_X0Y6_E6BEG[6] VPWR VGND sg13cmos5l_antennanp
XFILLER_39_203 VPWR VGND sg13cmos5l_decap_4
XFILLER_504_56 VPWR VGND sg13cmos5l_decap_8
X_3152_ Tile_X0Y7_FrameData_O[22] Tile_X0Y7_FrameData[22] VPWR VGND sg13cmos5l_buf_1
X_0364_ _0364_/Q Tile_X0Y7_FrameData[19] VGND VPWR Tile_X0Y9_FrameStrobe[6] latch
XFILLER_651_84 VPWR VGND sg13cmos5l_decap_8
XFILLER_223_35 VPWR VGND sg13cmos5l_decap_8
XFILLER_644_161 VPWR VGND sg13cmos5l_decap_8
X_2103_ _2103_/Q Tile_X0Y4_FrameData[14] VGND VPWR Tile_X0Y9_FrameStrobe[5] latch
X_0295_ _0295_/Q Tile_X0Y7_FrameData[24] VGND VPWR Tile_X0Y9_FrameStrobe[4] latch
X_3083_ Tile_X0Y7_E1BEG[1] _4609_/X VPWR VGND sg13cmos5l_buf_1
X_2034_ _2034_/Q Tile_X0Y4_FrameData[19] VGND VPWR Tile_X0Y9_FrameStrobe[3] latch
XFILLER_299_28 VPWR VGND sg13cmos5l_decap_8
XFILLER_403_109 VPWR VGND sg13cmos5l_decap_8
XFILLER_254_178 VPWR VGND sg13cmos5l_decap_8
XFILLER_520_77 VPWR VGND sg13cmos5l_decap_8
XFILLER_557_135 VPWR VGND sg13cmos5l_decap_8
X_3985_ _3985_/X Tile_X0Y2_W1END[2] Tile_X0Y2_W6END[6] _4107_/X _4086_/X _1669_/Q
+ _1668_/Q VPWR VGND sg13cmos5l_mux4_1
XFILLER_167_108 VPWR VGND sg13cmos5l_decap_8
XFILLER_572_105 VPWR VGND sg13cmos5l_decap_8
XFILLER_529_42 VPWR VGND sg13cmos5l_decap_8
X_2936_ Tile_X0Y8_E6BEG[4] _4764_/X VPWR VGND sg13cmos5l_buf_1
XFILLER_676_70 VPWR VGND sg13cmos5l_fill_2
XFILLER_248_21 VPWR VGND sg13cmos5l_decap_8
XFILLER_175_130 VPWR VGND sg13cmos5l_decap_8
X_2867_ Tile_X0Y6_EE4BEG[4] _4516_/X VPWR VGND sg13cmos5l_buf_1
XFILLER_395_60 VPWR VGND sg13cmos5l_fill_1
XFILLER_30_191 VPWR VGND sg13cmos5l_fill_1
XFILLER_714_154 VPWR VGND sg13cmos5l_decap_8
X_4606_ _4606_/X Tile_X0Y7_W1END[3] Tile_X0Y7_WW4END[15] Tile_X0Y7_W6END[7] _4687_/X
+ _0346_/Q _0345_/Q VPWR VGND sg13cmos5l_mux4_1
X_1818_ _1818_/Q Tile_X0Y3_FrameData[15] VGND VPWR Tile_X0Y9_FrameStrobe[4] latch
XFILLER_513_216 VPWR VGND sg13cmos5l_fill_2
XFILLER_190_122 VPWR VGND sg13cmos5l_fill_2
X_2798_ Tile_X0Y3_E6BEG[8] _4188_/X VPWR VGND sg13cmos5l_buf_1
X_4537_ _4537_/X AXI_M_SOC_RDATA29 _4570_/X _4574_/X _4556_/X _2533_/Q _2532_/Q VPWR
+ VGND sg13cmos5l_mux4_1
XFILLER_545_63 VPWR VGND sg13cmos5l_decap_8
X_1749_ _1749_/Q Tile_X0Y3_FrameData[20] VGND VPWR Tile_X0Y9_FrameStrobe[2] latch
XFILLER_190_166 VPWR VGND sg13cmos5l_fill_1
XFILLER_117_14 VPWR VGND sg13cmos5l_decap_8
XFILLER_692_91 VPWR VGND sg13cmos5l_decap_4
XFILLER_332_160 VPWR VGND sg13cmos5l_decap_8
XFILLER_264_42 VPWR VGND sg13cmos5l_decap_8
X_4468_ _4468_/X Tile_X0Y4_W2MID[7] Tile_X0Y4_W2END[7] Tile_X0Y4_W6END[8] _4313_/X
+ _2137_/Q _2136_/Q VPWR VGND sg13cmos5l_mux4_1
XFILLER_332_182 VPWR VGND sg13cmos5l_decap_8
XFILLER_493_112 VPWR VGND sg13cmos5l_decap_8
XANTENNA__2767__X Tile_X0Y3_FrameData_O[25] VPWR VGND sg13cmos5l_antennanp
X_3419_ Tile_X0Y4_FrameData_O[10] Tile_X0Y4_FrameData[10] VPWR VGND sg13cmos5l_buf_1
X_4399_ _4399_/X Tile_X0Y5_WW4END[4] AXI_M_SOC_RVALID _4455_/X _4433_/X _2305_/Q _2304_/Q
+ VPWR VGND sg13cmos5l_mux4_1
XFILLER_627_139 VPWR VGND sg13cmos5l_decap_4
XFILLER_414_56 VPWR VGND sg13cmos5l_decap_8
XFILLER_97_180 VPWR VGND sg13cmos5l_decap_8
XFILLER_561_84 VPWR VGND sg13cmos5l_decap_8
XFILLER_133_35 VPWR VGND sg13cmos5l_decap_8
XFILLER_711_21 VPWR VGND sg13cmos5l_decap_8
XFILLER_245_112 VPWR VGND sg13cmos5l_fill_2
XFILLER_280_63 VPWR VGND sg13cmos5l_decap_8
XFILLER_45_206 VPWR VGND sg13cmos5l_fill_2
XFILLER_93_28 VPWR VGND sg13cmos5l_decap_8
XFILLER_277_7 VPWR VGND sg13cmos5l_decap_8
XFILLER_133_79 VPWR VGND sg13cmos5l_decap_8
XFILLER_711_98 VPWR VGND sg13cmos5l_decap_8
XANTENNA__3598__X Tile_X0Y9_FrameData_O[28] VPWR VGND sg13cmos5l_antennanp
XFILLER_650_175 VPWR VGND sg13cmos5l_decap_8
XFILLER_260_126 VPWR VGND sg13cmos5l_fill_1
XFILLER_430_77 VPWR VGND sg13cmos5l_decap_8
XFILLER_444_7 VPWR VGND sg13cmos5l_decap_8
XFILLER_260_148 VPWR VGND sg13cmos5l_decap_4
XFILLER_548_146 VPWR VGND sg13cmos5l_decap_8
XFILLER_158_108 VPWR VGND sg13cmos5l_decap_8
XFILLER_611_7 VPWR VGND sg13cmos5l_decap_8
XFILLER_563_105 VPWR VGND sg13cmos5l_decap_8
XFILLER_439_42 VPWR VGND sg13cmos5l_decap_8
XFILLER_709_7 VPWR VGND sg13cmos5l_decap_8
XFILLER_158_21 VPWR VGND sg13cmos5l_decap_8
XFILLER_158_43 VPWR VGND sg13cmos5l_decap_8
XFILLER_308_13 VPWR VGND sg13cmos5l_decap_8
XFILLER_166_185 VPWR VGND sg13cmos5l_decap_4
XFILLER_571_182 VPWR VGND sg13cmos5l_decap_8
XFILLER_672_28 VPWR VGND sg13cmos5l_decap_8
XFILLER_308_57 VPWR VGND sg13cmos5l_decap_4
XFILLER_181_155 VPWR VGND sg13cmos5l_decap_4
XFILLER_101_0 VPWR VGND sg13cmos5l_decap_8
XFILLER_455_85 VPWR VGND sg13cmos5l_fill_2
XFILLER_330_119 VPWR VGND sg13cmos5l_fill_2
XFILLER_181_188 VPWR VGND sg13cmos5l_decap_4
XFILLER_469_175 VPWR VGND sg13cmos5l_decap_8
XFILLER_95_128 VPWR VGND sg13cmos5l_decap_4
XFILLER_324_56 VPWR VGND sg13cmos5l_decap_4
XFILLER_95_139 VPWR VGND sg13cmos5l_decap_8
XFILLER_88_191 VPWR VGND sg13cmos5l_decap_8
XFILLER_67_73 VPWR VGND sg13cmos5l_decap_8
XFILLER_621_21 VPWR VGND sg13cmos5l_decap_8
XFILLER_471_95 VPWR VGND sg13cmos5l_decap_8
XFILLER_470_0 VPWR VGND sg13cmos5l_decap_8
XFILLER_568_0 VPWR VGND sg13cmos5l_decap_8
XFILLER_190_63 VPWR VGND sg13cmos5l_decap_8
X_0080_ _0080_/X _4914_/X _4915_/X _2368_/Q VPWR VGND sg13cmos5l_mux2_1
XFILLER_697_14 VPWR VGND sg13cmos5l_decap_8
XFILLER_440_204 VPWR VGND sg13cmos5l_decap_8
XFILLER_83_50 VPWR VGND sg13cmos5l_decap_8
XFILLER_340_77 VPWR VGND sg13cmos5l_decap_8
XANTENNA__3301__X Tile_X0Y0_E2BEG[1] VPWR VGND sg13cmos5l_antennanp
XFILLER_338_208 VPWR VGND sg13cmos5l_fill_1
XFILLER_554_105 VPWR VGND sg13cmos5l_fill_1
XFILLER_349_42 VPWR VGND sg13cmos5l_decap_8
X_3770_ _3770_/X Tile_X0Y1_WW4END[3] Tile_X0Y1_WW4END[11] Tile_X0Y1_W6END[11] _4019_/X
+ _1235_/Q _1234_/Q VPWR VGND sg13cmos5l_mux4_1
X_0982_ _0982_/Q Tile_X0Y0_FrameData[21] VGND VPWR Tile_X0Y9_FrameStrobe[1] latch
XFILLER_554_127 VPWR VGND sg13cmos5l_fill_2
XFILLER_496_70 VPWR VGND sg13cmos5l_decap_8
X_2721_ _4659_/A3 VPWR VGND sg13cmos5l_tielo
XFILLER_157_163 VPWR VGND sg13cmos5l_fill_1
XFILLER_157_185 VPWR VGND sg13cmos5l_decap_8
X_2652_ _2652_/Q Tile_X0Y6_FrameData[11] VGND VPWR Tile_X0Y9_FrameStrobe[6] latch
XFILLER_306_116 VPWR VGND sg13cmos5l_fill_2
XFILLER_646_84 VPWR VGND sg13cmos5l_decap_8
XFILLER_562_182 VPWR VGND sg13cmos5l_decap_8
XFILLER_218_35 VPWR VGND sg13cmos5l_decap_8
X_1603_ _1603_/Q Tile_X0Y2_FrameData[14] VGND VPWR Tile_X0Y9_FrameStrobe[5] latch
XFILLER_582_28 VPWR VGND sg13cmos5l_decap_8
XFILLER_172_155 VPWR VGND sg13cmos5l_decap_8
XFILLER_365_63 VPWR VGND sg13cmos5l_decap_8
X_2583_ _2583_/Q Tile_X0Y6_FrameData[16] VGND VPWR Tile_X0Y9_FrameStrobe[4] latch
XFILLER_711_168 VPWR VGND sg13cmos5l_decap_8
XFILLER_321_119 VPWR VGND sg13cmos5l_decap_8
X_4322_ _4322_/X Tile_X0Y8_W1END[0] Tile_X0Y8_WW4END[0] Tile_X0Y8_W6END[8] _4800_/X
+ _0647_/Q _0646_/Q VPWR VGND sg13cmos5l_mux4_1
X_1534_ _1534_/Q Tile_X0Y2_FrameData[19] VGND VPWR Tile_X0Y9_FrameStrobe[3] latch
XFILLER_259_204 VPWR VGND sg13cmos5l_decap_4
XFILLER_113_211 VPWR VGND sg13cmos5l_fill_1
X_4253_ _4253_/X _4305_/X _4304_/X AXI_M_SOC_BRESP0 _4303_/X _2107_/Q _2106_/Q VPWR
+ VGND sg13cmos5l_mux4_1
XFILLER_515_77 VPWR VGND sg13cmos5l_decap_4
X_1465_ _1465_/Q Tile_X0Y2_FrameData[24] VGND VPWR Tile_X0Y9_FrameStrobe[1] latch
XFILLER_515_88 VPWR VGND sg13cmos5l_decap_4
XFILLER_515_99 VPWR VGND sg13cmos5l_decap_8
X_3204_ Tile_X0Y0_N2BEG[4] _3788_/X VPWR VGND sg13cmos5l_buf_1
X_0416_ _0416_/Q Tile_X0Y7_FrameData[31] VGND VPWR Tile_X0Y9_FrameStrobe[0] latch
X_4184_ _4184_/X AXI_M_SOC_WREADY _4229_/X _4233_/X _4205_/X _1773_/Q _1772_/Q VPWR
+ VGND sg13cmos5l_mux4_1
X_1396_ _1396_/Q Tile_X0Y1_FrameData[5] VGND VPWR Tile_X0Y9_FrameStrobe[6] latch
XFILLER_531_21 VPWR VGND sg13cmos5l_decap_8
XFILLER_227_112 VPWR VGND sg13cmos5l_decap_8
XFILLER_490_126 VPWR VGND sg13cmos5l_decap_8
X_3135_ Tile_X0Y7_FrameData_O[5] Tile_X0Y7_FrameData[5] VPWR VGND sg13cmos5l_buf_1
X_0347_ _0347_/Q Tile_X0Y7_FrameData[4] VGND VPWR Tile_X0Y9_FrameStrobe[5] latch
XFILLER_617_194 VPWR VGND sg13cmos5l_decap_8
X_3066_ Tile_X0Y5_FrameData_O[25] Tile_X0Y5_FrameData[25] VPWR VGND sg13cmos5l_buf_1
XFILLER_531_98 VPWR VGND sg13cmos5l_decap_8
XFILLER_227_178 VPWR VGND sg13cmos5l_decap_8
XFILLER_103_49 VPWR VGND sg13cmos5l_decap_8
X_0278_ _0278_/Q Tile_X0Y7_FrameData[9] VGND VPWR Tile_X0Y9_FrameStrobe[3] latch
XFILLER_632_175 VPWR VGND sg13cmos5l_fill_2
XFILLER_388_119 VPWR VGND sg13cmos5l_decap_4
XFILLER_250_77 VPWR VGND sg13cmos5l_fill_1
X_2017_ _2017_/Q Tile_X0Y4_FrameData[4] VGND VPWR Tile_X0Y9_FrameStrobe[2] latch
XFILLER_400_14 VPWR VGND sg13cmos5l_decap_8
XFILLER_242_148 VPWR VGND sg13cmos5l_decap_8
XFILLER_250_99 VPWR VGND sg13cmos5l_decap_8
XANTENNA__3211__X Tile_X0Y0_N1BEG[3] VPWR VGND sg13cmos5l_antennanp
XFILLER_400_69 VPWR VGND sg13cmos5l_decap_4
XFILLER_250_181 VPWR VGND sg13cmos5l_decap_8
XFILLER_396_174 VPWR VGND sg13cmos5l_decap_8
XFILLER_259_42 VPWR VGND sg13cmos5l_decap_8
XFILLER_545_116 VPWR VGND sg13cmos5l_decap_8
X_3968_ _3968_/X AXI_M_SOC_ARREADY _4015_/X _4019_/X _3989_/X _1273_/Q _1272_/Q VPWR
+ VGND sg13cmos5l_mux4_1
X_2919_ Tile_X0Y8_E2BEG[3] _4731_/X VPWR VGND sg13cmos5l_buf_1
X_3899_ _3899_/X Tile_X0Y1_W2MID[2] Tile_X0Y1_W2END[2] Tile_X0Y1_W6END[2] _3992_/X
+ _1407_/Q _1406_/Q VPWR VGND sg13cmos5l_mux4_1
XFILLER_148_163 VPWR VGND sg13cmos5l_decap_8
XFILLER_12_35 VPWR VGND sg13cmos5l_decap_8
XFILLER_409_56 VPWR VGND sg13cmos5l_decap_8
XFILLER_556_84 VPWR VGND sg13cmos5l_decap_8
XFILLER_128_35 VPWR VGND sg13cmos5l_decap_8
XFILLER_706_21 VPWR VGND sg13cmos5l_decap_8
XFILLER_699_175 VPWR VGND sg13cmos5l_decap_8
XFILLER_699_197 VPWR VGND sg13cmos5l_fill_1
XFILLER_492_28 VPWR VGND sg13cmos5l_decap_8
XFILLER_275_63 VPWR VGND sg13cmos5l_decap_8
XFILLER_163_177 VPWR VGND sg13cmos5l_decap_8
XFILLER_706_98 VPWR VGND sg13cmos5l_decap_8
XFILLER_5_7 VPWR VGND sg13cmos5l_decap_8
XFILLER_305_193 VPWR VGND sg13cmos5l_decap_8
XFILLER_208_90 VPWR VGND sg13cmos5l_decap_8
XFILLER_425_77 VPWR VGND sg13cmos5l_decap_8
XFILLER_394_7 VPWR VGND sg13cmos5l_decap_8
XFILLER_144_34 VPWR VGND sg13cmos5l_decap_8
XFILLER_265_207 VPWR VGND sg13cmos5l_fill_1
XFILLER_291_84 VPWR VGND sg13cmos5l_fill_2
XFILLER_441_21 VPWR VGND sg13cmos5l_decap_8
XFILLER_561_7 VPWR VGND sg13cmos5l_decap_8
XFILLER_659_7 VPWR VGND sg13cmos5l_decap_8
XFILLER_85_183 VPWR VGND sg13cmos5l_fill_1
XFILLER_310_14 VPWR VGND sg13cmos5l_decap_8
XFILLER_233_148 VPWR VGND sg13cmos5l_decap_8
XANTENNA__3121__X Tile_X0Y7_EE4BEG[7] VPWR VGND sg13cmos5l_antennanp
XFILLER_53_20 VPWR VGND sg13cmos5l_fill_2
XFILLER_53_31 VPWR VGND sg13cmos5l_decap_8
XFILLER_667_28 VPWR VGND sg13cmos5l_decap_4
XFILLER_241_181 VPWR VGND sg13cmos5l_fill_2
XFILLER_149_0 VPWR VGND sg13cmos5l_fill_2
XANTENNA__2960__X Tile_X0Y8_FrameData_O[0] VPWR VGND sg13cmos5l_antennanp
XFILLER_387_185 VPWR VGND sg13cmos5l_decap_8
XFILLER_316_0 VPWR VGND sg13cmos5l_decap_8
XFILLER_154_111 VPWR VGND sg13cmos5l_decap_8
XFILLER_139_196 VPWR VGND sg13cmos5l_decap_4
XFILLER_683_49 VPWR VGND sg13cmos5l_decap_8
XFILLER_466_84 VPWR VGND sg13cmos5l_decap_4
XFILLER_616_21 VPWR VGND sg13cmos5l_decap_8
XFILLER_5_143 VPWR VGND sg13cmos5l_fill_1
XFILLER_185_63 VPWR VGND sg13cmos5l_decap_8
XFILLER_5_154 VPWR VGND sg13cmos5l_decap_4
XFILLER_52_9 VPWR VGND sg13cmos5l_decap_8
XFILLER_5_165 VPWR VGND sg13cmos5l_fill_2
XFILLER_685_0 VPWR VGND sg13cmos5l_decap_8
XFILLER_68_106 VPWR VGND sg13cmos5l_decap_8
XFILLER_632_42 VPWR VGND sg13cmos5l_decap_8
X_1250_ _1250_/Q Tile_X0Y1_FrameData[23] VGND VPWR Tile_X0Y9_FrameStrobe[2] latch
XFILLER_311_185 VPWR VGND sg13cmos5l_decap_8
XFILLER_457_178 VPWR VGND sg13cmos5l_fill_1
XFILLER_351_21 VPWR VGND sg13cmos5l_decap_8
XFILLER_209_112 VPWR VGND sg13cmos5l_decap_8
X_0201_ _0201_/Q Tile_X0Y7_FrameData[22] VGND VPWR Tile_X0Y9_FrameStrobe[1] latch
XFILLER_76_161 VPWR VGND sg13cmos5l_decap_4
X_1181_ _1181_/Q Tile_X0Y1_FrameData[28] VGND VPWR Tile_X0Y9_FrameStrobe[0] latch
XFILLER_614_131 VPWR VGND sg13cmos5l_decap_8
X_0132_ AXI_M_SOC_AWLEN7 _0940_/Q _3678_/X VPWR VGND sg13cmos5l_nor2b_1
XFILLER_351_98 VPWR VGND sg13cmos5l_decap_8
XFILLER_501_35 VPWR VGND sg13cmos5l_decap_8
XFILLER_614_175 VPWR VGND sg13cmos5l_decap_8
XFILLER_91_164 VPWR VGND sg13cmos5l_decap_8
X_0063_ _3628_/A _4604_/X _4605_/X _0347_/Q VPWR VGND sg13cmos5l_mux2_1
X_4940_ _4940_/X Tile_X0Y3_WW4END[3] Tile_X0Y3_WW4END[11] Tile_X0Y3_W6END[11] _4233_/X
+ _1735_/Q _1734_/Q VPWR VGND sg13cmos5l_mux4_1
XFILLER_614_197 VPWR VGND sg13cmos5l_decap_4
XFILLER_220_14 VPWR VGND sg13cmos5l_decap_8
XANTENNA__3031__X Tile_X0Y5_EE4BEG[6] VPWR VGND sg13cmos5l_antennanp
X_4871_ _4871_/X Tile_X0Y9_WW4END[8] AXI_M_SOC_RDATA7 _4924_/X _4901_/X _0801_/Q _0800_/Q
+ VPWR VGND sg13cmos5l_mux4_1
XFILLER_577_28 VPWR VGND sg13cmos5l_decap_8
XFILLER_177_203 VPWR VGND sg13cmos5l_decap_8
X_3822_ _3822_/X Tile_X0Y0_WW4END[5] Tile_X0Y0_WW4END[13] _3871_/X _3856_/X _1061_/Q
+ _1060_/Q VPWR VGND sg13cmos5l_mux4_1
XANTENNA__2870__X Tile_X0Y6_EE4BEG[7] VPWR VGND sg13cmos5l_antennanp
XFILLER_527_127 VPWR VGND sg13cmos5l_fill_2
XFILLER_300_91 VPWR VGND sg13cmos5l_decap_8
X_3753_ AXI_M_SOC_ARADDR25 Tile_X0Y8_WW4END[1] Tile_X0Y8_WW4END[9] Tile_X0Y8_W6END[9]
+ _4809_/X _0485_/Q _0484_/Q VPWR VGND sg13cmos5l_mux4_1
X_0965_ _0965_/Q Tile_X0Y0_FrameData[6] VGND VPWR Tile_X0Y9_FrameStrobe[0] latch
XFILLER_393_188 VPWR VGND sg13cmos5l_decap_4
XFILLER_229_56 VPWR VGND sg13cmos5l_decap_8
X_2704_ _4193_/A3 VPWR VGND sg13cmos5l_tielo
X_3684_ _3684_/X Tile_X0Y3_WW4END[2] Tile_X0Y3_WW4END[10] Tile_X0Y3_W6END[2] _4224_/X
+ _1753_/Q _1752_/Q VPWR VGND sg13cmos5l_mux4_1
XFILLER_593_49 VPWR VGND sg13cmos5l_decap_8
XFILLER_535_171 VPWR VGND sg13cmos5l_decap_4
X_0896_ _0896_/Q Tile_X0Y9_FrameData[31] VGND VPWR Tile_X0Y9_FrameStrobe[7] latch
XFILLER_526_21 VPWR VGND sg13cmos5l_decap_8
XFILLER_145_144 VPWR VGND sg13cmos5l_decap_8
XFILLER_696_112 VPWR VGND sg13cmos5l_fill_2
XFILLER_145_155 VPWR VGND sg13cmos5l_fill_2
X_2635_ _2635_/Q Tile_X0Y6_FrameData[28] VGND VPWR Tile_X0Y9_FrameStrobe[6] latch
XFILLER_550_141 VPWR VGND sg13cmos5l_decap_8
X_2566_ _2566_/Q Tile_X0Y6_FrameData[1] VGND VPWR Tile_X0Y9_FrameStrobe[3] latch
XFILLER_448_101 VPWR VGND sg13cmos5l_fill_2
XFILLER_160_147 VPWR VGND sg13cmos5l_decap_8
X_4305_ _4305_/X Tile_X0Y5_W1END[1] Tile_X0Y5_W6END[5] _4464_/X _4419_/X _2437_/Q
+ _2436_/Q VPWR VGND sg13cmos5l_mux4_1
X_1517_ _1517_/Q Tile_X0Y2_FrameData[4] VGND VPWR Tile_X0Y9_FrameStrobe[2] latch
XFILLER_245_77 VPWR VGND sg13cmos5l_decap_8
X_2497_ _2497_/Q Tile_X0Y6_FrameData[6] VGND VPWR Tile_X0Y9_FrameStrobe[1] latch
XFILLER_448_145 VPWR VGND sg13cmos5l_decap_8
XFILLER_302_163 VPWR VGND sg13cmos5l_decap_4
XANTENNA__3206__X Tile_X0Y0_N2BEG[6] VPWR VGND sg13cmos5l_antennanp
XFILLER_542_42 VPWR VGND sg13cmos5l_decap_8
X_4236_ _4236_/X Tile_X0Y2_W2MID[7] Tile_X0Y2_W2END[7] Tile_X0Y2_W6END[8] _4097_/X
+ _1629_/Q _1628_/Q VPWR VGND sg13cmos5l_mux4_1
XFILLER_4_91 VPWR VGND sg13cmos5l_decap_8
X_1448_ _1448_/Q Tile_X0Y2_FrameData[9] VGND VPWR Tile_X0Y9_FrameStrobe[0] latch
XFILLER_261_21 VPWR VGND sg13cmos5l_decap_8
XFILLER_67_150 VPWR VGND sg13cmos5l_fill_1
XFILLER_114_48 VPWR VGND sg13cmos5l_decap_8
X_4167_ _4167_/X Tile_X0Y3_WW4END[12] AXI_M_SOC_BVALID _4234_/X _4210_/X _1807_/Q
+ _1806_/Q VPWR VGND sg13cmos5l_mux4_1
X_1379_ _1379_/Q Tile_X0Y1_FrameData[22] VGND VPWR Tile_X0Y9_FrameStrobe[6] latch
XFILLER_67_183 VPWR VGND sg13cmos5l_decap_8
X_3118_ Tile_X0Y7_EE4BEG[4] _4632_/X VPWR VGND sg13cmos5l_buf_1
XFILLER_261_98 VPWR VGND sg13cmos5l_decap_8
X_4098_ _4098_/X _4033_/X _4141_/X _4140_/X _4032_/X _1437_/Q _1436_/Q VPWR VGND sg13cmos5l_mux4_1
XFILLER_411_35 VPWR VGND sg13cmos5l_decap_8
XFILLER_82_153 VPWR VGND sg13cmos5l_decap_4
XFILLER_15_209 VPWR VGND sg13cmos5l_decap_8
X_3049_ Tile_X0Y5_FrameData_O[8] Tile_X0Y5_FrameData[8] VPWR VGND sg13cmos5l_buf_1
XFILLER_620_123 VPWR VGND sg13cmos5l_fill_2
XFILLER_130_14 VPWR VGND sg13cmos5l_decap_8
XFILLER_215_159 VPWR VGND sg13cmos5l_decap_4
XFILLER_487_28 VPWR VGND sg13cmos5l_decap_8
XFILLER_369_163 VPWR VGND sg13cmos5l_fill_2
XFILLER_168_214 VPWR VGND sg13cmos5l_decap_4
XANTENNA__2780__X Tile_X0Y3_EE4BEG[6] VPWR VGND sg13cmos5l_antennanp
XFILLER_142_7 VPWR VGND sg13cmos5l_decap_8
XFILLER_518_138 VPWR VGND sg13cmos5l_fill_1
XFILLER_384_144 VPWR VGND sg13cmos5l_decap_8
XFILLER_183_217 VPWR VGND sg13cmos5l_fill_1
XFILLER_533_119 VPWR VGND sg13cmos5l_decap_8
XFILLER_325_200 VPWR VGND sg13cmos5l_decap_8
XFILLER_139_56 VPWR VGND sg13cmos5l_decap_8
XFILLER_325_211 VPWR VGND sg13cmos5l_fill_1
XFILLER_99_27 VPWR VGND sg13cmos5l_decap_8
XFILLER_407_7 VPWR VGND sg13cmos5l_decap_8
XFILLER_286_84 VPWR VGND sg13cmos5l_decap_8
XFILLER_136_133 VPWR VGND sg13cmos5l_decap_8
XFILLER_340_203 VPWR VGND sg13cmos5l_fill_2
XFILLER_136_188 VPWR VGND sg13cmos5l_fill_1
XFILLER_436_76 VPWR VGND sg13cmos5l_decap_8
XFILLER_2_102 VPWR VGND sg13cmos5l_decap_4
XFILLER_297_118 VPWR VGND sg13cmos5l_decap_4
XFILLER_297_129 VPWR VGND sg13cmos5l_decap_4
XFILLER_2_179 VPWR VGND sg13cmos5l_decap_8
XFILLER_155_99 VPWR VGND sg13cmos5l_decap_8
XANTENNA__3116__X Tile_X0Y7_EE4BEG[2] VPWR VGND sg13cmos5l_antennanp
XFILLER_452_42 VPWR VGND sg13cmos5l_decap_8
XFILLER_305_58 VPWR VGND sg13cmos5l_fill_1
XFILLER_171_21 VPWR VGND sg13cmos5l_fill_2
XFILLER_48_64 VPWR VGND sg13cmos5l_decap_8
XFILLER_454_137 VPWR VGND sg13cmos5l_decap_8
XFILLER_454_148 VPWR VGND sg13cmos5l_fill_1
XANTENNA__2955__X Tile_X0Y8_EE4BEG[11] VPWR VGND sg13cmos5l_antennanp
XFILLER_58_194 VPWR VGND sg13cmos5l_decap_4
XFILLER_206_104 VPWR VGND sg13cmos5l_decap_8
XFILLER_602_89 VPWR VGND sg13cmos5l_decap_8
XFILLER_0_49 VPWR VGND sg13cmos5l_decap_8
XFILLER_73_153 VPWR VGND sg13cmos5l_decap_8
XFILLER_64_30 VPWR VGND sg13cmos5l_decap_8
XFILLER_321_57 VPWR VGND sg13cmos5l_decap_4
XFILLER_266_0 VPWR VGND sg13cmos5l_decap_8
XFILLER_321_68 VPWR VGND sg13cmos5l_decap_8
XFILLER_206_148 VPWR VGND sg13cmos5l_decap_8
XFILLER_678_49 VPWR VGND sg13cmos5l_decap_8
XFILLER_611_156 VPWR VGND sg13cmos5l_fill_1
XFILLER_397_28 VPWR VGND sg13cmos5l_decap_8
XFILLER_611_189 VPWR VGND sg13cmos5l_fill_1
XFILLER_401_90 VPWR VGND sg13cmos5l_decap_8
XFILLER_9_14 VPWR VGND sg13cmos5l_decap_8
XFILLER_433_0 VPWR VGND sg13cmos5l_decap_8
XFILLER_375_100 VPWR VGND sg13cmos5l_decap_8
XFILLER_375_111 VPWR VGND sg13cmos5l_fill_1
XFILLER_80_62 VPWR VGND sg13cmos5l_fill_1
XFILLER_375_166 VPWR VGND sg13cmos5l_decap_8
XFILLER_600_0 VPWR VGND sg13cmos5l_decap_8
XFILLER_80_84 VPWR VGND sg13cmos5l_decap_8
XFILLER_80_95 VPWR VGND sg13cmos5l_fill_2
XFILLER_524_119 VPWR VGND sg13cmos5l_decap_8
XFILLER_196_62 VPWR VGND sg13cmos5l_decap_8
XFILLER_627_42 VPWR VGND sg13cmos5l_decap_8
X_0750_ _0750_/Q Tile_X0Y9_FrameData[17] VGND VPWR Tile_X0Y9_FrameStrobe[2] latch
XFILLER_346_21 VPWR VGND sg13cmos5l_decap_8
X_0681_ _0681_/Q Tile_X0Y9_FrameData[22] VGND VPWR Tile_X0Y9_FrameStrobe[0] latch
XFILLER_532_152 VPWR VGND sg13cmos5l_fill_2
XFILLER_127_177 VPWR VGND sg13cmos5l_decap_8
X_2420_ _2420_/Q Tile_X0Y5_FrameData[17] VGND VPWR Tile_X0Y9_FrameStrobe[7] latch
XFILLER_127_199 VPWR VGND sg13cmos5l_decap_4
XFILLER_142_136 VPWR VGND sg13cmos5l_decap_8
XFILLER_346_98 VPWR VGND sg13cmos5l_decap_8
X_2351_ _2351_/Q Tile_X0Y5_FrameData[22] VGND VPWR Tile_X0Y9_FrameStrobe[5] latch
XFILLER_643_63 VPWR VGND sg13cmos5l_decap_8
XFILLER_215_14 VPWR VGND sg13cmos5l_decap_8
XANTENNA__3026__X Tile_X0Y5_EE4BEG[1] VPWR VGND sg13cmos5l_antennanp
XFILLER_362_42 VPWR VGND sg13cmos5l_decap_8
XFILLER_296_151 VPWR VGND sg13cmos5l_decap_8
X_1302_ _1302_/Q Tile_X0Y1_FrameData[3] VGND VPWR Tile_X0Y9_FrameStrobe[3] latch
X_2282_ _2282_/Q Tile_X0Y5_FrameData[27] VGND VPWR Tile_X0Y9_FrameStrobe[3] latch
X_4021_ _4021_/X Tile_X0Y3_W2MID[7] Tile_X0Y3_W2END[7] Tile_X0Y3_W6END[7] _4205_/X
+ _1917_/Q _1916_/Q VPWR VGND sg13cmos5l_mux4_1
XFILLER_56_109 VPWR VGND sg13cmos5l_decap_8
X_1233_ _1233_/Q Tile_X0Y1_FrameData[8] VGND VPWR Tile_X0Y9_FrameStrobe[1] latch
XANTENNA__2865__X Tile_X0Y6_EE4BEG[2] VPWR VGND sg13cmos5l_antennanp
XFILLER_512_56 VPWR VGND sg13cmos5l_decap_8
XFILLER_599_130 VPWR VGND sg13cmos5l_decap_8
X_1164_ _1164_/Q Tile_X0Y0_FrameData[31] VGND VPWR Tile_X0Y9_FrameStrobe[7] latch
XFILLER_64_142 VPWR VGND sg13cmos5l_decap_8
X_0115_ AXI_M_SOC_ARSIZE0 _0932_/Q _3768_/X VPWR VGND sg13cmos5l_nor2b_1
X_1095_ _1095_/Q Tile_X0Y0_FrameData[4] VGND VPWR Tile_X0Y9_FrameStrobe[4] latch
XFILLER_602_145 VPWR VGND sg13cmos5l_decap_4
XFILLER_212_118 VPWR VGND sg13cmos5l_decap_8
X_0046_ _0046_/X _4220_/X _4221_/X _0380_/Q VPWR VGND sg13cmos5l_mux2_1
X_4923_ _4923_/X Tile_X0Y9_N1END[3] Tile_X0Y9_N4END[3] _4899_/X _0080_/X _0713_/Q
+ _0712_/Q VPWR VGND sg13cmos5l_mux4_1
XANTENNA__3696__X AXI_M_SOC_WDATA6 VPWR VGND sg13cmos5l_antennanp
XFILLER_366_100 VPWR VGND sg13cmos5l_decap_8
XFILLER_668_82 VPWR VGND sg13cmos5l_decap_8
X_4854_ _4854_/X Tile_X0Y9_W2MID[1] AXI_M_SOC_RDATA6 _4903_/X _4902_/X _0835_/Q _0834_/Q
+ VPWR VGND sg13cmos5l_mux4_1
XFILLER_668_93 VPWR VGND sg13cmos5l_fill_2
XFILLER_220_151 VPWR VGND sg13cmos5l_decap_8
X_3805_ _3805_/X Tile_X0Y0_W2MID[3] Tile_X0Y0_W2MID[6] _3855_/X _3854_/X _1095_/Q
+ _1094_/Q VPWR VGND sg13cmos5l_mux4_1
X_4785_ _4785_/X _4701_/X Tile_X0Y9_N2MID[0] _4816_/X _4700_/X _0439_/Q _0438_/Q VPWR
+ VGND sg13cmos5l_mux4_1
XFILLER_220_184 VPWR VGND sg13cmos5l_fill_2
XFILLER_165_217 VPWR VGND sg13cmos5l_fill_1
X_1997_ _1997_/Q Tile_X0Y4_FrameData[24] VGND VPWR Tile_X0Y9_FrameStrobe[2] latch
XFILLER_570_203 VPWR VGND sg13cmos5l_fill_2
XFILLER_118_100 VPWR VGND sg13cmos5l_decap_4
XFILLER_537_42 VPWR VGND sg13cmos5l_decap_8
X_3736_ AXI_M_SOC_ARADDR8 Tile_X0Y9_WW4END[0] Tile_X0Y9_WW4END[8] Tile_X0Y9_W6END[8]
+ _4924_/X _0743_/Q _0742_/Q VPWR VGND sg13cmos5l_mux4_1
X_0948_ _0948_/Q Tile_X0Y0_FrameData[23] VGND VPWR Tile_X0Y9_FrameStrobe[0] latch
XFILLER_684_70 VPWR VGND sg13cmos5l_decap_8
XFILLER_669_101 VPWR VGND sg13cmos5l_fill_1
XFILLER_256_21 VPWR VGND sg13cmos5l_decap_8
X_3667_ AXI_M_SOC_AWADDR28 Tile_X0Y4_W1END[0] Tile_X0Y4_WW4END[4] Tile_X0Y4_WW4END[12]
+ _4348_/X _1989_/Q _1988_/Q VPWR VGND sg13cmos5l_mux4_1
X_0879_ _0879_/Q Tile_X0Y9_FrameData[16] VGND VPWR Tile_X0Y9_FrameStrobe[6] latch
XFILLER_118_177 VPWR VGND sg13cmos5l_fill_2
XFILLER_669_145 VPWR VGND sg13cmos5l_decap_8
X_2618_ _2618_/Q Tile_X0Y6_FrameData[13] VGND VPWR Tile_X0Y9_FrameStrobe[5] latch
XFILLER_279_118 VPWR VGND sg13cmos5l_decap_8
X_3598_ Tile_X0Y9_FrameData_O[28] Tile_X0Y9_FrameData[28] VPWR VGND sg13cmos5l_buf_1
XFILLER_406_35 VPWR VGND sg13cmos5l_decap_8
XFILLER_133_147 VPWR VGND sg13cmos5l_decap_8
XFILLER_684_115 VPWR VGND sg13cmos5l_decap_8
XFILLER_684_126 VPWR VGND sg13cmos5l_fill_2
XFILLER_553_63 VPWR VGND sg13cmos5l_decap_8
X_2549_ _2549_/Q Tile_X0Y6_FrameData[18] VGND VPWR Tile_X0Y9_FrameStrobe[3] latch
XFILLER_125_14 VPWR VGND sg13cmos5l_decap_8
XFILLER_272_42 VPWR VGND sg13cmos5l_decap_8
XFILLER_436_104 VPWR VGND sg13cmos5l_fill_2
XFILLER_491_210 VPWR VGND sg13cmos5l_fill_2
XFILLER_287_195 VPWR VGND sg13cmos5l_decap_4
XANTENNA__2775__X Tile_X0Y3_EE4BEG[1] VPWR VGND sg13cmos5l_antennanp
X_4219_ _4219_/X _4690_/X _4694_/X _4698_/X _4673_/X _0385_/Q _0384_/Q VPWR VGND sg13cmos5l_mux4_1
XFILLER_703_77 VPWR VGND sg13cmos5l_decap_8
XFILLER_422_56 VPWR VGND sg13cmos5l_decap_8
XFILLER_205_91 VPWR VGND sg13cmos5l_decap_8
XFILLER_451_107 VPWR VGND sg13cmos5l_fill_2
XFILLER_141_13 VPWR VGND sg13cmos5l_decap_8
XFILLER_18_56 VPWR VGND sg13cmos5l_decap_8
XFILLER_498_49 VPWR VGND sg13cmos5l_decap_8
XFILLER_357_7 VPWR VGND sg13cmos5l_decap_8
XFILLER_70_178 VPWR VGND sg13cmos5l_decap_8
XFILLER_34_55 VPWR VGND sg13cmos5l_fill_2
XFILLER_524_7 VPWR VGND sg13cmos5l_decap_8
XFILLER_357_133 VPWR VGND sg13cmos5l_decap_8
XFILLER_211_140 VPWR VGND sg13cmos5l_decap_8
XFILLER_372_103 VPWR VGND sg13cmos5l_decap_8
XFILLER_211_195 VPWR VGND sg13cmos5l_fill_2
XFILLER_447_42 VPWR VGND sg13cmos5l_decap_4
XFILLER_447_53 VPWR VGND sg13cmos5l_decap_8
XFILLER_166_21 VPWR VGND sg13cmos5l_decap_8
XFILLER_109_144 VPWR VGND sg13cmos5l_decap_8
XFILLER_50_65 VPWR VGND sg13cmos5l_fill_1
XFILLER_675_104 VPWR VGND sg13cmos5l_decap_4
XFILLER_316_35 VPWR VGND sg13cmos5l_decap_8
XFILLER_59_30 VPWR VGND sg13cmos5l_fill_1
XFILLER_316_46 VPWR VGND sg13cmos5l_fill_1
XFILLER_680_28 VPWR VGND sg13cmos5l_decap_8
XFILLER_59_41 VPWR VGND sg13cmos5l_fill_1
XFILLER_316_68 VPWR VGND sg13cmos5l_fill_1
XFILLER_182_20 VPWR VGND sg13cmos5l_decap_8
XFILLER_59_74 VPWR VGND sg13cmos5l_decap_8
XFILLER_427_126 VPWR VGND sg13cmos5l_decap_8
XFILLER_383_0 VPWR VGND sg13cmos5l_decap_8
XFILLER_293_121 VPWR VGND sg13cmos5l_decap_8
XFILLER_613_77 VPWR VGND sg13cmos5l_decap_8
XFILLER_332_56 VPWR VGND sg13cmos5l_decap_8
XFILLER_332_67 VPWR VGND sg13cmos5l_fill_1
XFILLER_75_73 VPWR VGND sg13cmos5l_fill_2
XFILLER_550_0 VPWR VGND sg13cmos5l_decap_8
XFILLER_332_89 VPWR VGND sg13cmos5l_decap_4
XFILLER_234_210 VPWR VGND sg13cmos5l_fill_1
XFILLER_648_0 VPWR VGND sg13cmos5l_fill_2
XFILLER_61_123 VPWR VGND sg13cmos5l_decap_8
XFILLER_596_133 VPWR VGND sg13cmos5l_decap_8
XFILLER_201_49 VPWR VGND sg13cmos5l_decap_8
XFILLER_131_90 VPWR VGND sg13cmos5l_fill_1
XFILLER_596_188 VPWR VGND sg13cmos5l_decap_8
X_1920_ _1920_/Q Tile_X0Y3_FrameData[9] VGND VPWR Tile_X0Y9_FrameStrobe[7] latch
XFILLER_348_133 VPWR VGND sg13cmos5l_decap_8
XFILLER_202_151 VPWR VGND sg13cmos5l_fill_2
XFILLER_348_155 VPWR VGND sg13cmos5l_decap_8
X_1851_ _1851_/Q Tile_X0Y3_FrameData[14] VGND VPWR Tile_X0Y9_FrameStrobe[5] latch
XFILLER_638_63 VPWR VGND sg13cmos5l_decap_8
X_0802_ _0802_/Q Tile_X0Y9_FrameData[29] VGND VPWR Tile_X0Y9_FrameStrobe[4] latch
XFILLER_357_42 VPWR VGND sg13cmos5l_decap_8
X_4570_ _4570_/X _4549_/X Tile_X0Y9_N4END[14] _4548_/X _0155_/X _2491_/Q _2490_/Q
+ VPWR VGND sg13cmos5l_mux4_1
X_1782_ _1782_/Q Tile_X0Y3_FrameData[19] VGND VPWR Tile_X0Y9_FrameStrobe[3] latch
X_3521_ Tile_X0Y1_E1BEG[3] _3931_/X VPWR VGND sg13cmos5l_buf_1
X_0733_ _0733_/Q Tile_X0Y9_FrameData[2] VGND VPWR Tile_X0Y9_FrameStrobe[1] latch
XFILLER_507_56 VPWR VGND sg13cmos5l_decap_8
X_3452_ Tile_X0Y1_FrameData_O[10] Tile_X0Y1_FrameData[10] VPWR VGND sg13cmos5l_buf_1
XFILLER_226_13 VPWR VGND sg13cmos5l_decap_8
X_0664_ _0664_/Q Tile_X0Y8_FrameData[7] VGND VPWR Tile_X0Y9_FrameStrobe[7] latch
XFILLER_654_84 VPWR VGND sg13cmos5l_decap_8
X_2403_ _2403_/Q Tile_X0Y5_FrameData[2] VGND VPWR Tile_X0Y9_FrameStrobe[6] latch
XFILLER_590_28 VPWR VGND sg13cmos5l_decap_8
X_3383_ Tile_X0Y2_E6BEG[6] _4078_/X VPWR VGND sg13cmos5l_buf_1
X_0595_ _0595_/Q Tile_X0Y8_FrameData[12] VGND VPWR Tile_X0Y9_FrameStrobe[5] latch
XFILLER_520_177 VPWR VGND sg13cmos5l_decap_8
XFILLER_123_180 VPWR VGND sg13cmos5l_fill_1
X_2334_ _2334_/Q Tile_X0Y5_FrameData[7] VGND VPWR Tile_X0Y9_FrameStrobe[4] latch
XFILLER_269_184 VPWR VGND sg13cmos5l_decap_8
XFILLER_27_0 VPWR VGND sg13cmos5l_decap_8
XFILLER_84_215 VPWR VGND sg13cmos5l_fill_2
X_2265_ _2265_/Q Tile_X0Y5_FrameData[12] VGND VPWR Tile_X0Y9_FrameStrobe[2] latch
XFILLER_284_154 VPWR VGND sg13cmos5l_decap_8
X_4004_ _4004_/X _4457_/X _4461_/X _4465_/X _4432_/X _2409_/Q _2408_/Q VPWR VGND sg13cmos5l_mux4_1
X_1216_ _1216_/Q Tile_X0Y1_FrameData[25] VGND VPWR Tile_X0Y9_FrameStrobe[1] latch
XFILLER_284_187 VPWR VGND sg13cmos5l_decap_8
XFILLER_37_131 VPWR VGND sg13cmos5l_decap_8
X_2196_ _2196_/Q Tile_X0Y5_FrameData[17] VGND VPWR Tile_X0Y9_FrameStrobe[0] latch
XFILLER_1_70 VPWR VGND sg13cmos5l_decap_8
X_1147_ _1147_/Q Tile_X0Y0_FrameData[16] VGND VPWR Tile_X0Y9_FrameStrobe[6] latch
XFILLER_37_186 VPWR VGND sg13cmos5l_decap_8
XFILLER_679_70 VPWR VGND sg13cmos5l_decap_8
XFILLER_441_173 VPWR VGND sg13cmos5l_decap_8
X_1078_ _1078_/Q Tile_X0Y0_FrameData[21] VGND VPWR Tile_X0Y9_FrameStrobe[4] latch
XFILLER_587_177 VPWR VGND sg13cmos5l_fill_1
XFILLER_528_200 VPWR VGND sg13cmos5l_decap_8
X_4906_ _4906_/X Tile_X0Y9_N2MID[4] Tile_X0Y9_N2END[4] _4936_/X _4820_/X _0687_/Q
+ _0686_/Q VPWR VGND sg13cmos5l_mux4_1
X_4837_ _4837_/X _4920_/X _4924_/X _4928_/X _4906_/X _0867_/Q _0866_/Q VPWR VGND sg13cmos5l_mux4_1
XFILLER_548_63 VPWR VGND sg13cmos5l_decap_8
XFILLER_695_91 VPWR VGND sg13cmos5l_decap_8
XFILLER_543_203 VPWR VGND sg13cmos5l_decap_4
XFILLER_267_42 VPWR VGND sg13cmos5l_decap_8
X_4768_ _4768_/X AXI_M_SOC_RDATA12 _4803_/X _4807_/X _4790_/X _0511_/Q _0510_/Q VPWR
+ VGND sg13cmos5l_mux4_1
XFILLER_354_147 VPWR VGND sg13cmos5l_decap_8
XFILLER_153_209 VPWR VGND sg13cmos5l_fill_2
X_3719_ AXI_M_SOC_WDATA29 Tile_X0Y6_W1END[1] Tile_X0Y6_WW4END[5] Tile_X0Y6_WW4END[13]
+ _4581_/X _2501_/Q _2500_/Q VPWR VGND sg13cmos5l_mux4_1
X_4699_ _4699_/X _4667_/X Tile_X0Y9_N4END[11] _4666_/X _0053_/X _0185_/Q _0184_/Q
+ VPWR VGND sg13cmos5l_mux4_1
XFILLER_417_56 VPWR VGND sg13cmos5l_decap_8
XFILLER_20_35 VPWR VGND sg13cmos5l_decap_8
XFILLER_106_125 VPWR VGND sg13cmos5l_decap_8
XFILLER_564_84 VPWR VGND sg13cmos5l_decap_8
XFILLER_136_35 VPWR VGND sg13cmos5l_decap_8
XFILLER_714_21 VPWR VGND sg13cmos5l_decap_8
XFILLER_283_63 VPWR VGND sg13cmos5l_decap_8
XFILLER_96_28 VPWR VGND sg13cmos5l_fill_2
XFILLER_672_107 VPWR VGND sg13cmos5l_decap_8
XFILLER_714_98 VPWR VGND sg13cmos5l_decap_8
XFILLER_75_204 VPWR VGND sg13cmos5l_fill_2
XFILLER_433_77 VPWR VGND sg13cmos5l_decap_8
XFILLER_580_83 VPWR VGND sg13cmos5l_decap_8
XFILLER_474_7 VPWR VGND sg13cmos5l_decap_8
XFILLER_152_56 VPWR VGND sg13cmos5l_decap_4
XFILLER_613_207 VPWR VGND sg13cmos5l_fill_1
XFILLER_152_67 VPWR VGND sg13cmos5l_decap_8
XFILLER_216_210 VPWR VGND sg13cmos5l_fill_1
XFILLER_290_135 VPWR VGND sg13cmos5l_decap_8
XFILLER_290_146 VPWR VGND sg13cmos5l_fill_2
XFILLER_641_7 VPWR VGND sg13cmos5l_decap_8
XFILLER_589_70 VPWR VGND sg13cmos5l_decap_8
XFILLER_432_184 VPWR VGND sg13cmos5l_decap_8
XFILLER_675_28 VPWR VGND sg13cmos5l_decap_8
XFILLER_131_0 VPWR VGND sg13cmos5l_fill_2
XFILLER_229_0 VPWR VGND sg13cmos5l_decap_8
XFILLER_196_194 VPWR VGND sg13cmos5l_decap_8
XFILLER_177_42 VPWR VGND sg13cmos5l_decap_8
XFILLER_608_77 VPWR VGND sg13cmos5l_fill_1
XANTENNA_8 AXI_M_SOC_RDATA27 VPWR VGND sg13cmos5l_antennanp
XFILLER_608_99 VPWR VGND sg13cmos5l_decap_8
XFILLER_499_140 VPWR VGND sg13cmos5l_decap_8
XFILLER_360_128 VPWR VGND sg13cmos5l_decap_4
XFILLER_691_49 VPWR VGND sg13cmos5l_decap_8
XFILLER_502_133 VPWR VGND sg13cmos5l_decap_8
XFILLER_193_41 VPWR VGND sg13cmos5l_decap_8
XFILLER_648_126 VPWR VGND sg13cmos5l_decap_8
XFILLER_624_21 VPWR VGND sg13cmos5l_decap_8
XFILLER_499_195 VPWR VGND sg13cmos5l_fill_1
XFILLER_598_0 VPWR VGND sg13cmos5l_decap_8
XFILLER_112_106 VPWR VGND sg13cmos5l_fill_2
X_0380_ _0380_/Q Tile_X0Y7_FrameData[3] VGND VPWR Tile_X0Y9_FrameStrobe[6] latch
XFILLER_455_210 VPWR VGND sg13cmos5l_fill_1
XFILLER_343_77 VPWR VGND sg13cmos5l_decap_8
XFILLER_20_7 VPWR VGND sg13cmos5l_decap_8
XFILLER_120_150 VPWR VGND sg13cmos5l_decap_8
XFILLER_266_143 VPWR VGND sg13cmos5l_decap_8
XFILLER_671_140 VPWR VGND sg13cmos5l_decap_8
XANTENNA__3304__X Tile_X0Y0_E2BEG[4] VPWR VGND sg13cmos5l_antennanp
XFILLER_86_94 VPWR VGND sg13cmos5l_decap_4
XFILLER_640_42 VPWR VGND sg13cmos5l_decap_8
XFILLER_415_107 VPWR VGND sg13cmos5l_decap_8
X_2050_ _2050_/Q Tile_X0Y4_FrameData[3] VGND VPWR Tile_X0Y9_FrameStrobe[3] latch
XFILLER_19_142 VPWR VGND sg13cmos5l_fill_2
X_1001_ _1001_/Q Tile_X0Y0_FrameData[2] VGND VPWR Tile_X0Y9_FrameStrobe[1] latch
XFILLER_212_48 VPWR VGND sg13cmos5l_decap_8
XFILLER_281_168 VPWR VGND sg13cmos5l_decap_8
XFILLER_569_133 VPWR VGND sg13cmos5l_decap_8
XFILLER_499_70 VPWR VGND sg13cmos5l_decap_8
XFILLER_34_134 VPWR VGND sg13cmos5l_fill_1
X_2952_ Tile_X0Y8_EE4BEG[8] _4752_/X VPWR VGND sg13cmos5l_buf_1
XFILLER_649_84 VPWR VGND sg13cmos5l_decap_8
X_1903_ _1903_/Q Tile_X0Y3_FrameData[26] VGND VPWR Tile_X0Y9_FrameStrobe[7] latch
XFILLER_187_150 VPWR VGND sg13cmos5l_decap_4
XFILLER_585_28 VPWR VGND sg13cmos5l_decap_8
X_2883_ Tile_X0Y6_FrameData_O[4] Tile_X0Y6_FrameData[4] VPWR VGND sg13cmos5l_buf_1
XFILLER_336_114 VPWR VGND sg13cmos5l_fill_2
XFILLER_187_183 VPWR VGND sg13cmos5l_fill_2
X_1834_ _1834_/Q Tile_X0Y3_FrameData[31] VGND VPWR Tile_X0Y9_FrameStrobe[5] latch
X_4622_ _4622_/X Tile_X0Y7_W2END[5] AXI_M_SOC_RDATA21 _4673_/X _4672_/X _0315_/Q _0314_/Q
+ VPWR VGND sg13cmos5l_mux4_1
X_4553_ _4553_/X _4469_/X _4585_/X _4584_/X _4468_/X _2463_/Q _2462_/Q VPWR VGND sg13cmos5l_mux4_1
XFILLER_518_77 VPWR VGND sg13cmos5l_decap_4
X_1765_ _1765_/Q Tile_X0Y3_FrameData[4] VGND VPWR Tile_X0Y9_FrameStrobe[2] latch
XFILLER_540_217 VPWR VGND sg13cmos5l_fill_1
XFILLER_384_51 VPWR VGND sg13cmos5l_decap_8
X_0716_ _0716_/Q Tile_X0Y9_FrameData[19] VGND VPWR Tile_X0Y9_FrameStrobe[1] latch
X_3504_ Tile_X0Y1_E2BEGb[2] _3942_/X VPWR VGND sg13cmos5l_buf_1
X_4484_ _4484_/X Tile_X0Y6_W1END[0] Tile_X0Y6_WW4END[12] Tile_X0Y6_W6END[4] _4568_/X
+ _2635_/Q _2634_/Q VPWR VGND sg13cmos5l_mux4_1
X_1696_ _1696_/Q Tile_X0Y3_FrameData[9] VGND VPWR Tile_X0Y9_FrameStrobe[0] latch
XFILLER_639_126 VPWR VGND sg13cmos5l_decap_8
XFILLER_534_21 VPWR VGND sg13cmos5l_decap_8
X_3435_ Tile_X0Y4_FrameData_O[26] Tile_X0Y4_FrameData[26] VPWR VGND sg13cmos5l_buf_1
X_0647_ _0647_/Q Tile_X0Y8_FrameData[24] VGND VPWR Tile_X0Y9_FrameStrobe[7] latch
X_3366_ Tile_X0Y2_EE4BEG[5] _4061_/X VPWR VGND sg13cmos5l_buf_1
X_0578_ _0578_/Q Tile_X0Y8_FrameData[29] VGND VPWR Tile_X0Y9_FrameStrobe[5] latch
X_2317_ _2317_/Q Tile_X0Y5_FrameData[24] VGND VPWR Tile_X0Y9_FrameStrobe[4] latch
XFILLER_403_14 VPWR VGND sg13cmos5l_decap_8
XFILLER_253_88 VPWR VGND sg13cmos5l_decap_4
X_3297_ Tile_X0Y0_E2BEGb[5] _3817_/X VPWR VGND sg13cmos5l_buf_1
XFILLER_253_99 VPWR VGND sg13cmos5l_decap_8
XANTENNA__3214__X Tile_X0Y0_FrameStrobe_O[2] VPWR VGND sg13cmos5l_antennanp
XFILLER_550_42 VPWR VGND sg13cmos5l_decap_8
X_2248_ _2248_/Q Tile_X0Y5_FrameData[29] VGND VPWR Tile_X0Y9_FrameStrobe[2] latch
X_2179_ _2179_/Q Tile_X0Y4_FrameData[2] VGND VPWR Tile_X0Y9_FrameStrobe[7] latch
XFILLER_414_140 VPWR VGND sg13cmos5l_decap_8
XFILLER_700_56 VPWR VGND sg13cmos5l_decap_8
XFILLER_414_151 VPWR VGND sg13cmos5l_fill_1
XFILLER_359_206 VPWR VGND sg13cmos5l_decap_8
XFILLER_359_217 VPWR VGND sg13cmos5l_fill_1
XFILLER_202_70 VPWR VGND sg13cmos5l_decap_8
XFILLER_709_119 VPWR VGND sg13cmos5l_decap_8
XFILLER_25_178 VPWR VGND sg13cmos5l_decap_8
XFILLER_15_35 VPWR VGND sg13cmos5l_decap_8
XFILLER_40_115 VPWR VGND sg13cmos5l_decap_8
XFILLER_40_126 VPWR VGND sg13cmos5l_fill_1
XFILLER_575_147 VPWR VGND sg13cmos5l_decap_8
XFILLER_559_84 VPWR VGND sg13cmos5l_decap_8
XFILLER_709_21 VPWR VGND sg13cmos5l_decap_8
XFILLER_495_28 VPWR VGND sg13cmos5l_decap_8
XFILLER_278_63 VPWR VGND sg13cmos5l_decap_8
XFILLER_717_174 VPWR VGND sg13cmos5l_decap_4
XFILLER_222_7 VPWR VGND sg13cmos5l_decap_8
XFILLER_193_131 VPWR VGND sg13cmos5l_decap_8
XFILLER_709_98 VPWR VGND sg13cmos5l_decap_8
XFILLER_31_34 VPWR VGND sg13cmos5l_decap_8
XFILLER_126_209 VPWR VGND sg13cmos5l_fill_2
XFILLER_428_77 VPWR VGND sg13cmos5l_decap_8
XFILLER_531_217 VPWR VGND sg13cmos5l_fill_1
XFILLER_294_84 VPWR VGND sg13cmos5l_decap_8
XFILLER_685_210 VPWR VGND sg13cmos5l_fill_1
XFILLER_444_21 VPWR VGND sg13cmos5l_decap_8
XFILLER_350_150 VPWR VGND sg13cmos5l_decap_4
XFILLER_591_7 VPWR VGND sg13cmos5l_decap_8
XFILLER_496_154 VPWR VGND sg13cmos5l_decap_8
XFILLER_689_7 VPWR VGND sg13cmos5l_decap_8
XFILLER_163_33 VPWR VGND sg13cmos5l_decap_8
XFILLER_313_14 VPWR VGND sg13cmos5l_decap_8
XFILLER_193_2 VPWR VGND sg13cmos5l_fill_1
XFILLER_163_88 VPWR VGND sg13cmos5l_decap_8
XFILLER_102_172 VPWR VGND sg13cmos5l_decap_4
XFILLER_653_140 VPWR VGND sg13cmos5l_decap_8
XFILLER_313_25 VPWR VGND sg13cmos5l_fill_1
XANTENNA__3124__X Tile_X0Y7_EE4BEG[10] VPWR VGND sg13cmos5l_antennanp
XFILLER_56_20 VPWR VGND sg13cmos5l_decap_8
XFILLER_460_42 VPWR VGND sg13cmos5l_decap_4
XFILLER_452_202 VPWR VGND sg13cmos5l_fill_1
XFILLER_598_217 VPWR VGND sg13cmos5l_fill_1
XFILLER_56_53 VPWR VGND sg13cmos5l_decap_8
XFILLER_360_2 VPWR VGND sg13cmos5l_fill_1
XFILLER_179_0 VPWR VGND sg13cmos5l_decap_8
XANTENNA__2963__X Tile_X0Y8_FrameData_O[3] VPWR VGND sg13cmos5l_antennanp
XFILLER_610_56 VPWR VGND sg13cmos5l_decap_8
XFILLER_405_151 VPWR VGND sg13cmos5l_fill_2
XFILLER_204_202 VPWR VGND sg13cmos5l_fill_2
XFILLER_16_134 VPWR VGND sg13cmos5l_decap_4
XFILLER_420_110 VPWR VGND sg13cmos5l_fill_2
XFILLER_112_70 VPWR VGND sg13cmos5l_decap_8
XFILLER_346_0 VPWR VGND sg13cmos5l_decap_8
XFILLER_31_115 VPWR VGND sg13cmos5l_decap_8
XFILLER_686_49 VPWR VGND sg13cmos5l_decap_8
XFILLER_566_147 VPWR VGND sg13cmos5l_decap_8
XFILLER_619_21 VPWR VGND sg13cmos5l_decap_8
XFILLER_169_150 VPWR VGND sg13cmos5l_decap_8
XFILLER_188_63 VPWR VGND sg13cmos5l_decap_8
XFILLER_513_0 VPWR VGND sg13cmos5l_decap_8
XFILLER_522_217 VPWR VGND sg13cmos5l_fill_1
XFILLER_635_42 VPWR VGND sg13cmos5l_decap_8
X_1550_ _1550_/Q Tile_X0Y2_FrameData[3] VGND VPWR Tile_X0Y9_FrameStrobe[3] latch
XFILLER_487_110 VPWR VGND sg13cmos5l_fill_2
XFILLER_354_21 VPWR VGND sg13cmos5l_decap_8
X_0501_ _0501_/Q Tile_X0Y8_FrameData[10] VGND VPWR Tile_X0Y9_FrameStrobe[2] latch
XFILLER_98_115 VPWR VGND sg13cmos5l_decap_8
X_1481_ _1481_/Q Tile_X0Y2_FrameData[8] VGND VPWR Tile_X0Y9_FrameStrobe[1] latch
XFILLER_207_48 VPWR VGND sg13cmos5l_decap_8
X_3220_ Tile_X0Y0_FrameStrobe_O[8] Tile_X0Y9_FrameStrobe[8] VPWR VGND sg13cmos5l_buf_1
XFILLER_98_159 VPWR VGND sg13cmos5l_fill_2
X_0432_ _0432_/Q Tile_X0Y8_FrameData[15] VGND VPWR Tile_X0Y9_FrameStrobe[0] latch
XFILLER_354_98 VPWR VGND sg13cmos5l_decap_8
XFILLER_504_35 VPWR VGND sg13cmos5l_decap_8
X_3151_ Tile_X0Y7_FrameData_O[21] Tile_X0Y7_FrameData[21] VPWR VGND sg13cmos5l_buf_1
XFILLER_651_63 VPWR VGND sg13cmos5l_decap_8
XFILLER_629_192 VPWR VGND sg13cmos5l_decap_4
X_0363_ _0363_/Q Tile_X0Y7_FrameData[20] VGND VPWR Tile_X0Y9_FrameStrobe[6] latch
XFILLER_223_14 VPWR VGND sg13cmos5l_decap_8
XANTENNA__3034__X Tile_X0Y5_EE4BEG[9] VPWR VGND sg13cmos5l_antennanp
XFILLER_644_140 VPWR VGND sg13cmos5l_decap_8
X_2102_ _2102_/Q Tile_X0Y4_FrameData[15] VGND VPWR Tile_X0Y9_FrameStrobe[5] latch
XFILLER_370_42 VPWR VGND sg13cmos5l_decap_8
XFILLER_239_176 VPWR VGND sg13cmos5l_decap_8
X_3082_ Tile_X0Y7_E1BEG[0] _4608_/X VPWR VGND sg13cmos5l_buf_1
XFILLER_254_124 VPWR VGND sg13cmos5l_fill_1
XFILLER_239_198 VPWR VGND sg13cmos5l_fill_2
X_0294_ _0294_/Q Tile_X0Y7_FrameData[25] VGND VPWR Tile_X0Y9_FrameStrobe[4] latch
XFILLER_589_217 VPWR VGND sg13cmos5l_fill_1
X_2033_ _2033_/Q Tile_X0Y4_FrameData[20] VGND VPWR Tile_X0Y9_FrameStrobe[3] latch
XANTENNA__2873__X Tile_X0Y6_EE4BEG[10] VPWR VGND sg13cmos5l_antennanp
XFILLER_520_56 VPWR VGND sg13cmos5l_decap_8
XFILLER_557_114 VPWR VGND sg13cmos5l_fill_2
XFILLER_596_49 VPWR VGND sg13cmos5l_decap_8
XFILLER_22_126 VPWR VGND sg13cmos5l_decap_8
X_3984_ _3984_/X Tile_X0Y0_W1END[2] Tile_X0Y0_W6END[10] _3867_/X _3861_/X _1137_/Q
+ _1136_/Q VPWR VGND sg13cmos5l_mux4_1
XFILLER_94_0 VPWR VGND sg13cmos5l_fill_2
XFILLER_529_21 VPWR VGND sg13cmos5l_decap_8
XFILLER_379_95 VPWR VGND sg13cmos5l_decap_8
X_2935_ Tile_X0Y8_E6BEG[3] _4763_/X VPWR VGND sg13cmos5l_buf_1
XFILLER_309_114 VPWR VGND sg13cmos5l_decap_4
XFILLER_565_180 VPWR VGND sg13cmos5l_fill_1
XFILLER_309_136 VPWR VGND sg13cmos5l_decap_8
XFILLER_248_44 VPWR VGND sg13cmos5l_fill_1
X_2866_ Tile_X0Y6_EE4BEG[3] _4515_/X VPWR VGND sg13cmos5l_buf_1
XFILLER_714_133 VPWR VGND sg13cmos5l_decap_8
XFILLER_248_66 VPWR VGND sg13cmos5l_decap_4
X_4605_ _4605_/X _4690_/X _4694_/X _4698_/X _4670_/X _0349_/Q _0348_/Q VPWR VGND sg13cmos5l_mux4_1
X_1817_ _1817_/Q Tile_X0Y3_FrameData[16] VGND VPWR Tile_X0Y9_FrameStrobe[4] latch
XFILLER_175_186 VPWR VGND sg13cmos5l_decap_8
X_2797_ Tile_X0Y3_E6BEG[7] _4187_/X VPWR VGND sg13cmos5l_buf_1
XANTENNA__3209__X Tile_X0Y0_N1BEG[1] VPWR VGND sg13cmos5l_antennanp
XFILLER_545_42 VPWR VGND sg13cmos5l_decap_8
XFILLER_7_91 VPWR VGND sg13cmos5l_decap_8
XFILLER_317_180 VPWR VGND sg13cmos5l_decap_4
XFILLER_190_145 VPWR VGND sg13cmos5l_decap_8
X_1748_ _1748_/Q Tile_X0Y3_FrameData[21] VGND VPWR Tile_X0Y9_FrameStrobe[2] latch
X_4536_ _4536_/X AXI_M_SOC_RDATA28 _4571_/X _4575_/X _4558_/X _2535_/Q _2534_/Q VPWR
+ VGND sg13cmos5l_mux4_1
XFILLER_692_70 VPWR VGND sg13cmos5l_decap_8
XFILLER_264_21 VPWR VGND sg13cmos5l_decap_8
X_1679_ _1679_/Q Tile_X0Y3_FrameData[26] VGND VPWR Tile_X0Y9_FrameStrobe[0] latch
X_4467_ _4467_/X _4353_/X _4469_/X _4468_/X _4352_/X _2205_/Q _2204_/Q VPWR VGND sg13cmos5l_mux4_1
X_3418_ Tile_X0Y4_FrameData_O[9] Tile_X0Y4_FrameData[9] VPWR VGND sg13cmos5l_buf_1
XFILLER_264_98 VPWR VGND sg13cmos5l_decap_8
X_4398_ _4398_/X Tile_X0Y5_WW4END[5] AXI_M_SOC_RLAST _4456_/X _4431_/X _2307_/Q _2306_/Q
+ VPWR VGND sg13cmos5l_mux4_1
XFILLER_414_35 VPWR VGND sg13cmos5l_decap_8
X_3349_ Tile_X0Y2_FrameData_O[20] Tile_X0Y2_FrameData[20] VPWR VGND sg13cmos5l_buf_1
XFILLER_561_63 VPWR VGND sg13cmos5l_decap_8
XFILLER_133_14 VPWR VGND sg13cmos5l_decap_8
XFILLER_493_168 VPWR VGND sg13cmos5l_decap_8
XFILLER_280_42 VPWR VGND sg13cmos5l_decap_8
XFILLER_711_77 VPWR VGND sg13cmos5l_decap_8
XANTENNA__2783__X Tile_X0Y3_EE4BEG[9] VPWR VGND sg13cmos5l_antennanp
XFILLER_172_7 VPWR VGND sg13cmos5l_decap_8
XFILLER_650_154 VPWR VGND sg13cmos5l_decap_8
XFILLER_430_56 VPWR VGND sg13cmos5l_decap_8
XFILLER_213_91 VPWR VGND sg13cmos5l_decap_8
XFILLER_26_56 VPWR VGND sg13cmos5l_decap_8
XFILLER_399_194 VPWR VGND sg13cmos5l_fill_1
XFILLER_437_7 VPWR VGND sg13cmos5l_decap_8
XFILLER_289_84 VPWR VGND sg13cmos5l_decap_8
XFILLER_439_21 VPWR VGND sg13cmos5l_decap_8
XFILLER_402_176 VPWR VGND sg13cmos5l_decap_8
XFILLER_42_44 VPWR VGND sg13cmos5l_decap_4
XFILLER_604_7 VPWR VGND sg13cmos5l_decap_8
XFILLER_439_87 VPWR VGND sg13cmos5l_decap_8
XFILLER_556_191 VPWR VGND sg13cmos5l_fill_2
XFILLER_439_98 VPWR VGND sg13cmos5l_fill_2
XFILLER_42_77 VPWR VGND sg13cmos5l_fill_2
XFILLER_166_142 VPWR VGND sg13cmos5l_decap_8
XFILLER_705_133 VPWR VGND sg13cmos5l_fill_1
XFILLER_571_161 VPWR VGND sg13cmos5l_decap_8
XFILLER_504_217 VPWR VGND sg13cmos5l_fill_1
XFILLER_315_128 VPWR VGND sg13cmos5l_decap_8
XANTENNA__3119__X Tile_X0Y7_EE4BEG[5] VPWR VGND sg13cmos5l_antennanp
XFILLER_705_199 VPWR VGND sg13cmos5l_fill_2
XFILLER_455_42 VPWR VGND sg13cmos5l_fill_1
XFILLER_308_191 VPWR VGND sg13cmos5l_decap_8
XFILLER_658_210 VPWR VGND sg13cmos5l_fill_2
XFILLER_174_21 VPWR VGND sg13cmos5l_decap_8
XFILLER_323_161 VPWR VGND sg13cmos5l_fill_2
XANTENNA__2958__X Tile_X0Y8_EE4BEG[14] VPWR VGND sg13cmos5l_antennanp
XFILLER_174_65 VPWR VGND sg13cmos5l_decap_8
XFILLER_268_216 VPWR VGND sg13cmos5l_fill_2
XFILLER_673_202 VPWR VGND sg13cmos5l_fill_2
XFILLER_605_56 VPWR VGND sg13cmos5l_decap_8
XFILLER_95_107 VPWR VGND sg13cmos5l_decap_8
XFILLER_3_49 VPWR VGND sg13cmos5l_decap_8
XFILLER_296_0 VPWR VGND sg13cmos5l_decap_8
XFILLER_88_170 VPWR VGND sg13cmos5l_decap_8
XFILLER_67_52 VPWR VGND sg13cmos5l_decap_8
XFILLER_471_74 VPWR VGND sg13cmos5l_decap_8
XFILLER_190_42 VPWR VGND sg13cmos5l_decap_8
XFILLER_425_202 VPWR VGND sg13cmos5l_fill_2
XFILLER_36_207 VPWR VGND sg13cmos5l_fill_2
XFILLER_463_0 VPWR VGND sg13cmos5l_decap_8
XFILLER_236_146 VPWR VGND sg13cmos5l_fill_2
XFILLER_190_86 VPWR VGND sg13cmos5l_fill_1
XFILLER_621_77 VPWR VGND sg13cmos5l_decap_8
XFILLER_641_154 VPWR VGND sg13cmos5l_decap_8
XFILLER_340_56 VPWR VGND sg13cmos5l_decap_8
XFILLER_630_0 VPWR VGND sg13cmos5l_decap_8
XFILLER_251_149 VPWR VGND sg13cmos5l_decap_8
XFILLER_539_103 VPWR VGND sg13cmos5l_decap_8
XFILLER_349_21 VPWR VGND sg13cmos5l_decap_8
X_0981_ _0981_/Q Tile_X0Y0_FrameData[22] VGND VPWR Tile_X0Y9_FrameStrobe[1] latch
XFILLER_80_6 VPWR VGND sg13cmos5l_decap_8
X_2720_ _4775_/A3 VPWR VGND sg13cmos5l_tielo
XFILLER_157_131 VPWR VGND sg13cmos5l_decap_8
XFILLER_349_98 VPWR VGND sg13cmos5l_decap_8
XFILLER_12_181 VPWR VGND sg13cmos5l_decap_8
XFILLER_8_152 VPWR VGND sg13cmos5l_fill_1
X_2651_ _2651_/Q Tile_X0Y6_FrameData[12] VGND VPWR Tile_X0Y9_FrameStrobe[6] latch
XFILLER_646_63 VPWR VGND sg13cmos5l_decap_8
XFILLER_218_14 VPWR VGND sg13cmos5l_decap_8
XFILLER_361_212 VPWR VGND sg13cmos5l_decap_4
XFILLER_172_134 VPWR VGND sg13cmos5l_decap_8
XANTENNA__3029__X Tile_X0Y5_EE4BEG[4] VPWR VGND sg13cmos5l_antennanp
XFILLER_8_196 VPWR VGND sg13cmos5l_decap_8
X_1602_ _1602_/Q Tile_X0Y2_FrameData[15] VGND VPWR Tile_X0Y9_FrameStrobe[5] latch
XFILLER_365_42 VPWR VGND sg13cmos5l_decap_8
X_2582_ _2582_/Q Tile_X0Y6_FrameData[17] VGND VPWR Tile_X0Y9_FrameStrobe[4] latch
XFILLER_711_147 VPWR VGND sg13cmos5l_decap_8
XFILLER_649_210 VPWR VGND sg13cmos5l_decap_8
X_1533_ _1533_/Q Tile_X0Y2_FrameData[20] VGND VPWR Tile_X0Y9_FrameStrobe[3] latch
X_4321_ _4321_/X _3885_/X _3876_/X _3875_/X _3858_/X _1117_/Q _1116_/Q VPWR VGND sg13cmos5l_mux4_1
XANTENNA__2868__X Tile_X0Y6_EE4BEG[5] VPWR VGND sg13cmos5l_antennanp
XFILLER_314_183 VPWR VGND sg13cmos5l_fill_2
XFILLER_515_56 VPWR VGND sg13cmos5l_decap_8
X_4252_ _4252_/X _4302_/X _4301_/X AXI_M_SOC_BRESP1 _4300_/X _2109_/Q _2108_/Q VPWR
+ VGND sg13cmos5l_mux4_1
X_1464_ _1464_/Q Tile_X0Y2_FrameData[25] VGND VPWR Tile_X0Y9_FrameStrobe[1] latch
XFILLER_662_84 VPWR VGND sg13cmos5l_decap_8
XFILLER_234_35 VPWR VGND sg13cmos5l_decap_4
X_3203_ Tile_X0Y0_N2BEG[3] _3787_/X VPWR VGND sg13cmos5l_buf_1
X_0415_ _0415_/Q Tile_X0Y7_FrameData[0] VGND VPWR Tile_X0Y9_FrameStrobe[7] latch
XFILLER_234_57 VPWR VGND sg13cmos5l_fill_1
X_4183_ _4183_/X _0046_/X Tile_X0Y0_S4END[15] _4230_/X _4234_/X _1775_/Q _1774_/Q
+ VPWR VGND sg13cmos5l_mux4_1
X_1395_ _1395_/Q Tile_X0Y1_FrameData[6] VGND VPWR Tile_X0Y9_FrameStrobe[6] latch
XFILLER_234_79 VPWR VGND sg13cmos5l_decap_4
XFILLER_490_105 VPWR VGND sg13cmos5l_decap_8
X_3134_ Tile_X0Y7_FrameData_O[4] Tile_X0Y7_FrameData[4] VPWR VGND sg13cmos5l_buf_1
XFILLER_617_162 VPWR VGND sg13cmos5l_decap_8
X_0346_ _0346_/Q Tile_X0Y7_FrameData[5] VGND VPWR Tile_X0Y9_FrameStrobe[5] latch
XFILLER_314_90 VPWR VGND sg13cmos5l_decap_8
XANTENNA__3699__X AXI_M_SOC_WDATA9 VPWR VGND sg13cmos5l_antennanp
XFILLER_531_77 VPWR VGND sg13cmos5l_decap_4
X_3065_ Tile_X0Y5_FrameData_O[24] Tile_X0Y5_FrameData[24] VPWR VGND sg13cmos5l_buf_1
XFILLER_94_195 VPWR VGND sg13cmos5l_decap_8
X_0277_ _0277_/Q Tile_X0Y7_FrameData[10] VGND VPWR Tile_X0Y9_FrameStrobe[3] latch
XFILLER_250_56 VPWR VGND sg13cmos5l_decap_8
X_2016_ _2016_/Q Tile_X0Y4_FrameData[5] VGND VPWR Tile_X0Y9_FrameStrobe[2] latch
XFILLER_687_70 VPWR VGND sg13cmos5l_decap_4
XFILLER_396_142 VPWR VGND sg13cmos5l_decap_4
XFILLER_259_21 VPWR VGND sg13cmos5l_decap_8
X_3967_ _3967_/X _0084_/X Tile_X0Y0_S4END[7] _4016_/X _4005_/X _1275_/Q _1274_/Q VPWR
+ VGND sg13cmos5l_mux4_1
XFILLER_148_120 VPWR VGND sg13cmos5l_decap_8
X_2918_ Tile_X0Y8_E2BEG[2] _4730_/X VPWR VGND sg13cmos5l_buf_1
XFILLER_259_98 VPWR VGND sg13cmos5l_decap_8
X_3898_ _3898_/X Tile_X0Y2_W2MID[2] Tile_X0Y2_W2END[2] Tile_X0Y2_W6END[2] _4100_/X
+ _1655_/Q _1654_/Q VPWR VGND sg13cmos5l_mux4_1
XFILLER_409_35 VPWR VGND sg13cmos5l_decap_8
XFILLER_12_14 VPWR VGND sg13cmos5l_decap_8
XFILLER_556_63 VPWR VGND sg13cmos5l_decap_8
XFILLER_352_201 VPWR VGND sg13cmos5l_fill_2
XFILLER_128_14 VPWR VGND sg13cmos5l_decap_8
X_2849_ Tile_X0Y6_E2BEGb[6] _4510_/X VPWR VGND sg13cmos5l_buf_1
XFILLER_553_172 VPWR VGND sg13cmos5l_decap_4
XFILLER_275_42 VPWR VGND sg13cmos5l_decap_8
XFILLER_163_145 VPWR VGND sg13cmos5l_decap_8
XFILLER_163_156 VPWR VGND sg13cmos5l_decap_8
XANTENNA__2778__X Tile_X0Y3_EE4BEG[4] VPWR VGND sg13cmos5l_antennanp
XFILLER_706_77 VPWR VGND sg13cmos5l_decap_8
X_4519_ _4519_/X Tile_X0Y6_WW4END[8] AXI_M_SOC_RDATA31 _4576_/X _4553_/X _2569_/Q
+ _2568_/Q VPWR VGND sg13cmos5l_mux4_1
XFILLER_305_172 VPWR VGND sg13cmos5l_decap_8
XFILLER_425_56 VPWR VGND sg13cmos5l_decap_8
XFILLER_144_13 VPWR VGND sg13cmos5l_decap_8
XFILLER_572_84 VPWR VGND sg13cmos5l_decap_8
XFILLER_291_63 VPWR VGND sg13cmos5l_decap_8
XFILLER_144_68 VPWR VGND sg13cmos5l_decap_8
XFILLER_144_79 VPWR VGND sg13cmos5l_fill_2
XFILLER_387_7 VPWR VGND sg13cmos5l_decap_8
XFILLER_481_138 VPWR VGND sg13cmos5l_decap_8
XFILLER_623_121 VPWR VGND sg13cmos5l_fill_1
XFILLER_441_77 VPWR VGND sg13cmos5l_decap_4
XFILLER_37_55 VPWR VGND sg13cmos5l_decap_4
XFILLER_554_7 VPWR VGND sg13cmos5l_decap_8
XANTENNA__3402__X Tile_X0Y2_E2BEG[5] VPWR VGND sg13cmos5l_antennanp
XFILLER_37_99 VPWR VGND sg13cmos5l_fill_2
XFILLER_379_109 VPWR VGND sg13cmos5l_decap_8
XFILLER_233_127 VPWR VGND sg13cmos5l_decap_8
XFILLER_160_78 VPWR VGND sg13cmos5l_decap_4
XFILLER_169_21 VPWR VGND sg13cmos5l_decap_8
XFILLER_387_164 VPWR VGND sg13cmos5l_decap_8
XFILLER_169_32 VPWR VGND sg13cmos5l_fill_1
XFILLER_53_87 VPWR VGND sg13cmos5l_decap_8
XFILLER_319_35 VPWR VGND sg13cmos5l_fill_2
XFILLER_139_175 VPWR VGND sg13cmos5l_decap_8
XFILLER_683_28 VPWR VGND sg13cmos5l_decap_8
XFILLER_211_0 VPWR VGND sg13cmos5l_decap_8
XFILLER_466_96 VPWR VGND sg13cmos5l_decap_8
XFILLER_309_0 VPWR VGND sg13cmos5l_decap_8
XFILLER_185_42 VPWR VGND sg13cmos5l_decap_8
XFILLER_616_77 VPWR VGND sg13cmos5l_decap_8
XFILLER_5_188 VPWR VGND sg13cmos5l_fill_1
XFILLER_45_9 VPWR VGND sg13cmos5l_decap_8
XFILLER_335_56 VPWR VGND sg13cmos5l_decap_4
XFILLER_457_102 VPWR VGND sg13cmos5l_fill_2
XFILLER_335_67 VPWR VGND sg13cmos5l_decap_8
XFILLER_457_135 VPWR VGND sg13cmos5l_fill_1
XFILLER_632_21 VPWR VGND sg13cmos5l_decap_8
XFILLER_580_0 VPWR VGND sg13cmos5l_decap_8
XFILLER_110_204 VPWR VGND sg13cmos5l_decap_4
XFILLER_678_0 VPWR VGND sg13cmos5l_decap_8
XFILLER_472_105 VPWR VGND sg13cmos5l_decap_4
X_0200_ _0200_/Q Tile_X0Y7_FrameData[23] VGND VPWR Tile_X0Y9_FrameStrobe[1] latch
XFILLER_76_140 VPWR VGND sg13cmos5l_decap_8
X_1180_ _1180_/Q Tile_X0Y1_FrameData[29] VGND VPWR Tile_X0Y9_FrameStrobe[0] latch
XFILLER_632_98 VPWR VGND sg13cmos5l_decap_8
XFILLER_204_49 VPWR VGND sg13cmos5l_decap_8
X_0131_ AXI_M_SOC_AWSIZE1 _0939_/Q _3680_/X VPWR VGND sg13cmos5l_or2_1
XFILLER_351_77 VPWR VGND sg13cmos5l_decap_8
XFILLER_501_14 VPWR VGND sg13cmos5l_decap_8
XFILLER_91_132 VPWR VGND sg13cmos5l_decap_4
XFILLER_413_205 VPWR VGND sg13cmos5l_decap_4
XANTENNA__3312__X Tile_X0Y4_EE4BEG[0] VPWR VGND sg13cmos5l_antennanp
XFILLER_480_171 VPWR VGND sg13cmos5l_decap_4
XFILLER_413_216 VPWR VGND sg13cmos5l_fill_2
XFILLER_224_127 VPWR VGND sg13cmos5l_fill_2
X_0062_ _3629_/A _4606_/X _4607_/X _0344_/Q VPWR VGND sg13cmos5l_mux2_1
X_4870_ _4870_/X Tile_X0Y9_WW4END[9] AXI_M_SOC_RDATA6 _4925_/X _4903_/X _0803_/Q _0802_/Q
+ VPWR VGND sg13cmos5l_mux4_1
XFILLER_177_215 VPWR VGND sg13cmos5l_fill_2
X_3821_ _3821_/X Tile_X0Y0_WW4END[4] Tile_X0Y0_WW4END[14] _3867_/X _3854_/X _1063_/Q
+ _1062_/Q VPWR VGND sg13cmos5l_mux4_1
XFILLER_378_175 VPWR VGND sg13cmos5l_decap_8
XFILLER_378_186 VPWR VGND sg13cmos5l_fill_1
X_0964_ _0964_/Q Tile_X0Y0_FrameData[7] VGND VPWR Tile_X0Y9_FrameStrobe[0] latch
X_3752_ AXI_M_SOC_ARADDR24 Tile_X0Y8_WW4END[0] Tile_X0Y8_WW4END[8] Tile_X0Y8_W6END[8]
+ _4808_/X _0487_/Q _0486_/Q VPWR VGND sg13cmos5l_mux4_1
XFILLER_657_84 VPWR VGND sg13cmos5l_decap_8
XFILLER_393_167 VPWR VGND sg13cmos5l_decap_8
XFILLER_229_35 VPWR VGND sg13cmos5l_decap_8
XFILLER_542_109 VPWR VGND sg13cmos5l_fill_1
X_2703_ _4192_/A3 VPWR VGND sg13cmos5l_tielo
XFILLER_593_28 VPWR VGND sg13cmos5l_decap_8
X_0895_ _0895_/Q Tile_X0Y9_FrameData[0] VGND VPWR Tile_X0Y9_FrameStrobe[6] latch
X_3683_ _3683_/X Tile_X0Y3_WW4END[1] Tile_X0Y3_WW4END[9] Tile_X0Y3_W6END[1] _4223_/X
+ _1755_/Q _1754_/Q VPWR VGND sg13cmos5l_mux4_1
XFILLER_376_96 VPWR VGND sg13cmos5l_decap_4
X_2634_ _2634_/Q Tile_X0Y6_FrameData[29] VGND VPWR Tile_X0Y9_FrameStrobe[6] latch
XFILLER_526_44 VPWR VGND sg13cmos5l_fill_1
XFILLER_309_90 VPWR VGND sg13cmos5l_decap_8
XFILLER_145_178 VPWR VGND sg13cmos5l_decap_4
XFILLER_57_0 VPWR VGND sg13cmos5l_decap_8
XFILLER_526_77 VPWR VGND sg13cmos5l_decap_4
X_2565_ _2565_/Q Tile_X0Y6_FrameData[2] VGND VPWR Tile_X0Y9_FrameStrobe[3] latch
XFILLER_495_208 VPWR VGND sg13cmos5l_decap_4
XFILLER_245_34 VPWR VGND sg13cmos5l_fill_1
XFILLER_160_126 VPWR VGND sg13cmos5l_decap_8
XFILLER_673_94 VPWR VGND sg13cmos5l_decap_8
XFILLER_299_160 VPWR VGND sg13cmos5l_decap_8
XFILLER_526_99 VPWR VGND sg13cmos5l_fill_2
X_1516_ _1516_/Q Tile_X0Y2_FrameData[5] VGND VPWR Tile_X0Y9_FrameStrobe[2] latch
X_4304_ _4304_/X Tile_X0Y3_W1END[1] Tile_X0Y3_W6END[9] _4235_/X _4201_/X _1887_/Q
+ _1886_/Q VPWR VGND sg13cmos5l_mux4_1
XFILLER_448_124 VPWR VGND sg13cmos5l_decap_8
X_2496_ _2496_/Q Tile_X0Y6_FrameData[7] VGND VPWR Tile_X0Y9_FrameStrobe[1] latch
XFILLER_542_21 VPWR VGND sg13cmos5l_decap_8
XFILLER_4_70 VPWR VGND sg13cmos5l_decap_8
X_1447_ _1447_/Q Tile_X0Y2_FrameData[10] VGND VPWR Tile_X0Y9_FrameStrobe[0] latch
X_4235_ _4235_/X _4197_/X _0088_/X _4196_/X Tile_X0Y0_S4END[13] _1703_/Q _1702_/Q
+ VPWR VGND sg13cmos5l_mux4_1
XFILLER_448_179 VPWR VGND sg13cmos5l_decap_8
XFILLER_114_27 VPWR VGND sg13cmos5l_decap_8
X_4166_ _4166_/X Tile_X0Y3_WW4END[13] AXI_M_SOC_WREADY _4235_/X _4208_/X _1809_/Q
+ _1808_/Q VPWR VGND sg13cmos5l_mux4_1
XFILLER_463_138 VPWR VGND sg13cmos5l_decap_8
X_1378_ _1378_/Q Tile_X0Y1_FrameData[23] VGND VPWR Tile_X0Y9_FrameStrobe[6] latch
XFILLER_261_77 VPWR VGND sg13cmos5l_decap_8
X_0329_ _0329_/Q Tile_X0Y7_FrameData[22] VGND VPWR Tile_X0Y9_FrameStrobe[5] latch
X_3117_ Tile_X0Y7_EE4BEG[3] _4631_/X VPWR VGND sg13cmos5l_buf_1
XFILLER_411_14 VPWR VGND sg13cmos5l_decap_8
X_4097_ _4097_/X _4021_/X _4129_/X _4128_/X _4020_/X _1449_/Q _1448_/Q VPWR VGND sg13cmos5l_mux4_1
XANTENNA__3222__X Tile_X0Y0_FrameStrobe_O[10] VPWR VGND sg13cmos5l_antennanp
XFILLER_215_116 VPWR VGND sg13cmos5l_fill_1
X_3048_ Tile_X0Y5_FrameData_O[7] Tile_X0Y5_FrameData[7] VPWR VGND sg13cmos5l_buf_1
XFILLER_82_165 VPWR VGND sg13cmos5l_decap_8
XFILLER_698_91 VPWR VGND sg13cmos5l_decap_8
XFILLER_369_131 VPWR VGND sg13cmos5l_decap_8
XFILLER_620_179 VPWR VGND sg13cmos5l_decap_8
XFILLER_223_171 VPWR VGND sg13cmos5l_decap_4
XFILLER_518_117 VPWR VGND sg13cmos5l_decap_8
XFILLER_384_123 VPWR VGND sg13cmos5l_decap_8
XFILLER_23_35 VPWR VGND sg13cmos5l_decap_8
XFILLER_135_7 VPWR VGND sg13cmos5l_decap_8
XFILLER_567_84 VPWR VGND sg13cmos5l_decap_8
XFILLER_139_35 VPWR VGND sg13cmos5l_decap_8
XFILLER_286_63 VPWR VGND sg13cmos5l_decap_8
XFILLER_136_112 VPWR VGND sg13cmos5l_decap_8
XFILLER_717_65 VPWR VGND sg13cmos5l_decap_4
XFILLER_302_7 VPWR VGND sg13cmos5l_decap_8
XFILLER_541_131 VPWR VGND sg13cmos5l_fill_2
XFILLER_436_55 VPWR VGND sg13cmos5l_decap_8
XFILLER_340_215 VPWR VGND sg13cmos5l_fill_2
XFILLER_151_115 VPWR VGND sg13cmos5l_decap_8
XFILLER_452_21 VPWR VGND sg13cmos5l_decap_8
XFILLER_695_190 VPWR VGND sg13cmos5l_fill_1
XFILLER_671_7 VPWR VGND sg13cmos5l_decap_8
XFILLER_48_43 VPWR VGND sg13cmos5l_decap_8
XFILLER_643_216 VPWR VGND sg13cmos5l_fill_2
XFILLER_452_87 VPWR VGND sg13cmos5l_decap_8
XFILLER_452_98 VPWR VGND sg13cmos5l_fill_2
XFILLER_602_35 VPWR VGND sg13cmos5l_decap_8
XFILLER_58_173 VPWR VGND sg13cmos5l_decap_8
XFILLER_171_77 VPWR VGND sg13cmos5l_decap_4
XFILLER_321_14 VPWR VGND sg13cmos5l_decap_8
XFILLER_0_28 VPWR VGND sg13cmos5l_decap_8
XANTENNA__3132__X Tile_X0Y7_FrameData_O[2] VPWR VGND sg13cmos5l_antennanp
XFILLER_104_82 VPWR VGND sg13cmos5l_decap_8
XFILLER_678_28 VPWR VGND sg13cmos5l_decap_8
XFILLER_462_193 VPWR VGND sg13cmos5l_decap_8
XFILLER_73_176 VPWR VGND sg13cmos5l_decap_8
XFILLER_611_124 VPWR VGND sg13cmos5l_fill_1
XFILLER_611_135 VPWR VGND sg13cmos5l_decap_8
XFILLER_161_0 VPWR VGND sg13cmos5l_decap_8
XFILLER_73_187 VPWR VGND sg13cmos5l_fill_1
XFILLER_259_0 VPWR VGND sg13cmos5l_decap_8
XANTENNA__2971__X Tile_X0Y8_FrameData_O[11] VPWR VGND sg13cmos5l_antennanp
XFILLER_64_86 VPWR VGND sg13cmos5l_decap_8
XFILLER_410_208 VPWR VGND sg13cmos5l_fill_1
XFILLER_214_182 VPWR VGND sg13cmos5l_decap_8
XFILLER_159_215 VPWR VGND sg13cmos5l_fill_2
XFILLER_426_0 VPWR VGND sg13cmos5l_decap_8
XFILLER_80_41 VPWR VGND sg13cmos5l_decap_4
XFILLER_694_49 VPWR VGND sg13cmos5l_decap_8
XFILLER_627_21 VPWR VGND sg13cmos5l_decap_8
XFILLER_196_41 VPWR VGND sg13cmos5l_decap_8
XFILLER_375_189 VPWR VGND sg13cmos5l_decap_8
XFILLER_517_183 VPWR VGND sg13cmos5l_decap_8
X_0680_ _0680_/Q Tile_X0Y9_FrameData[23] VGND VPWR Tile_X0Y9_FrameStrobe[0] latch
XFILLER_627_98 VPWR VGND sg13cmos5l_decap_8
XFILLER_129_90 VPWR VGND sg13cmos5l_decap_4
XFILLER_346_77 VPWR VGND sg13cmos5l_decap_8
XFILLER_331_215 VPWR VGND sg13cmos5l_fill_2
XFILLER_288_119 VPWR VGND sg13cmos5l_fill_1
XFILLER_693_105 VPWR VGND sg13cmos5l_decap_8
XANTENNA__3307__X Tile_X0Y0_E2BEG[7] VPWR VGND sg13cmos5l_antennanp
XFILLER_643_42 VPWR VGND sg13cmos5l_decap_8
XFILLER_43_6 VPWR VGND sg13cmos5l_decap_8
X_2350_ _2350_/Q Tile_X0Y5_FrameData[23] VGND VPWR Tile_X0Y9_FrameStrobe[5] latch
XFILLER_296_130 VPWR VGND sg13cmos5l_decap_8
XFILLER_362_21 VPWR VGND sg13cmos5l_decap_8
XFILLER_96_213 VPWR VGND sg13cmos5l_decap_4
X_1301_ _1301_/Q Tile_X0Y1_FrameData[4] VGND VPWR Tile_X0Y9_FrameStrobe[3] latch
X_2281_ _2281_/Q Tile_X0Y5_FrameData[28] VGND VPWR Tile_X0Y9_FrameStrobe[3] latch
X_4020_ _4020_/X Tile_X0Y0_W2MID[7] Tile_X0Y0_W2END[7] Tile_X0Y0_W6END[8] _3853_/X
+ _1133_/Q _1132_/Q VPWR VGND sg13cmos5l_mux4_1
XFILLER_634_216 VPWR VGND sg13cmos5l_fill_2
X_1232_ _1232_/Q Tile_X0Y1_FrameData[9] VGND VPWR Tile_X0Y9_FrameStrobe[1] latch
XFILLER_512_35 VPWR VGND sg13cmos5l_decap_8
X_1163_ _1163_/Q Tile_X0Y0_FrameData[0] VGND VPWR Tile_X0Y9_FrameStrobe[6] latch
XFILLER_231_14 VPWR VGND sg13cmos5l_decap_8
XFILLER_64_121 VPWR VGND sg13cmos5l_decap_8
XANTENNA__3042__X Tile_X0Y5_FrameData_O[1] VPWR VGND sg13cmos5l_antennanp
XFILLER_453_171 VPWR VGND sg13cmos5l_decap_8
X_0114_ AXI_M_SOC_ARLOCK _0930_/Q _3773_/X VPWR VGND sg13cmos5l_nor2b_1
XFILLER_453_182 VPWR VGND sg13cmos5l_fill_1
XFILLER_588_28 VPWR VGND sg13cmos5l_decap_8
XFILLER_398_215 VPWR VGND sg13cmos5l_fill_2
XFILLER_231_58 VPWR VGND sg13cmos5l_fill_1
X_1094_ _1094_/Q Tile_X0Y0_FrameData[5] VGND VPWR Tile_X0Y9_FrameStrobe[4] latch
XANTENNA__2881__X Tile_X0Y6_FrameData_O[2] VPWR VGND sg13cmos5l_antennanp
X_0045_ _3626_/A _4600_/X _4601_/X _0353_/Q VPWR VGND sg13cmos5l_mux2_1
X_4922_ _4922_/X Tile_X0Y9_N1END[2] Tile_X0Y9_N4END[2] _4898_/X _0081_/X _0715_/Q
+ _0714_/Q VPWR VGND sg13cmos5l_mux4_1
XFILLER_668_61 VPWR VGND sg13cmos5l_decap_8
XFILLER_205_182 VPWR VGND sg13cmos5l_decap_4
X_4853_ _4853_/X Tile_X0Y9_W2MID[2] AXI_M_SOC_RDATA5 _4905_/X _4904_/X _0837_/Q _0836_/Q
+ VPWR VGND sg13cmos5l_mux4_1
XFILLER_220_130 VPWR VGND sg13cmos5l_decap_8
X_3804_ _3804_/X Tile_X0Y0_W2MID[0] Tile_X0Y0_W2MID[7] _3853_/X _3852_/X _1097_/Q
+ _1096_/Q VPWR VGND sg13cmos5l_mux4_1
XFILLER_366_145 VPWR VGND sg13cmos5l_fill_1
X_4784_ _4784_/X _4715_/X Tile_X0Y9_N2MID[7] _4823_/X _4714_/X _0425_/Q _0424_/Q VPWR
+ VGND sg13cmos5l_mux4_1
XFILLER_387_84 VPWR VGND sg13cmos5l_decap_8
XFILLER_366_167 VPWR VGND sg13cmos5l_decap_8
X_1996_ _1996_/Q Tile_X0Y4_FrameData[25] VGND VPWR Tile_X0Y9_FrameStrobe[2] latch
XFILLER_537_21 VPWR VGND sg13cmos5l_decap_8
X_3735_ AXI_M_SOC_ARADDR7 Tile_X0Y9_WW4END[7] Tile_X0Y9_WW4END[15] Tile_X0Y9_W6END[7]
+ _4923_/X _0745_/Q _0744_/Q VPWR VGND sg13cmos5l_mux4_1
X_0947_ _0947_/Q Tile_X0Y0_FrameData[24] VGND VPWR Tile_X0Y9_FrameStrobe[0] latch
XFILLER_118_134 VPWR VGND sg13cmos5l_decap_8
XFILLER_118_156 VPWR VGND sg13cmos5l_decap_8
X_3666_ AXI_M_SOC_AWADDR27 Tile_X0Y4_WW4END[3] Tile_X0Y4_WW4END[11] Tile_X0Y4_W6END[11]
+ _4347_/X _1991_/Q _1990_/Q VPWR VGND sg13cmos5l_mux4_1
X_0878_ _0878_/Q Tile_X0Y9_FrameData[17] VGND VPWR Tile_X0Y9_FrameStrobe[6] latch
XFILLER_322_204 VPWR VGND sg13cmos5l_decap_4
XFILLER_322_215 VPWR VGND sg13cmos5l_fill_2
X_2617_ _2617_/Q Tile_X0Y6_FrameData[14] VGND VPWR Tile_X0Y9_FrameStrobe[5] latch
XFILLER_133_126 VPWR VGND sg13cmos5l_decap_8
XFILLER_406_14 VPWR VGND sg13cmos5l_decap_8
X_3597_ Tile_X0Y9_FrameData_O[27] Tile_X0Y9_FrameData[27] VPWR VGND sg13cmos5l_buf_1
XANTENNA__3217__X Tile_X0Y0_FrameStrobe_O[5] VPWR VGND sg13cmos5l_antennanp
XFILLER_553_42 VPWR VGND sg13cmos5l_decap_8
X_2548_ _2548_/Q Tile_X0Y6_FrameData[19] VGND VPWR Tile_X0Y9_FrameStrobe[3] latch
XFILLER_272_21 VPWR VGND sg13cmos5l_decap_8
XFILLER_141_170 VPWR VGND sg13cmos5l_decap_8
XFILLER_141_181 VPWR VGND sg13cmos5l_fill_2
XFILLER_287_174 VPWR VGND sg13cmos5l_decap_8
X_2479_ _2479_/Q Tile_X0Y6_FrameData[24] VGND VPWR Tile_X0Y9_FrameStrobe[1] latch
XFILLER_703_56 VPWR VGND sg13cmos5l_decap_8
X_4218_ _4218_/X Tile_X0Y7_W1END[2] Tile_X0Y7_WW4END[2] Tile_X0Y7_W6END[10] _4686_/X
+ _0385_/Q _0384_/Q VPWR VGND sg13cmos5l_mux4_1
XFILLER_272_98 VPWR VGND sg13cmos5l_decap_8
XFILLER_436_149 VPWR VGND sg13cmos5l_fill_2
XFILLER_429_190 VPWR VGND sg13cmos5l_decap_8
XFILLER_422_35 VPWR VGND sg13cmos5l_decap_8
XFILLER_205_70 VPWR VGND sg13cmos5l_decap_8
XFILLER_18_35 VPWR VGND sg13cmos5l_decap_8
X_4149_ _4149_/X Tile_X0Y3_W2MID[6] AXI_M_SOC_BVALID _4207_/X _4206_/X _1843_/Q _1842_/Q
+ VPWR VGND sg13cmos5l_mux4_1
XFILLER_444_171 VPWR VGND sg13cmos5l_fill_2
XFILLER_55_154 VPWR VGND sg13cmos5l_decap_4
XFILLER_498_28 VPWR VGND sg13cmos5l_decap_8
XANTENNA__2791__X Tile_X0Y3_E6BEG[1] VPWR VGND sg13cmos5l_antennanp
XFILLER_252_7 VPWR VGND sg13cmos5l_decap_8
XFILLER_203_119 VPWR VGND sg13cmos5l_decap_8
XFILLER_70_157 VPWR VGND sg13cmos5l_decap_8
XFILLER_34_34 VPWR VGND sg13cmos5l_decap_8
XFILLER_221_91 VPWR VGND sg13cmos5l_decap_8
XFILLER_245_6 VPWR VGND sg13cmos5l_decap_8
XFILLER_357_112 VPWR VGND sg13cmos5l_decap_8
XFILLER_34_78 VPWR VGND sg13cmos5l_decap_8
XFILLER_517_7 VPWR VGND sg13cmos5l_decap_8
XFILLER_297_84 VPWR VGND sg13cmos5l_decap_8
XFILLER_447_21 VPWR VGND sg13cmos5l_decap_8
XFILLER_7_217 VPWR VGND sg13cmos5l_fill_1
XFILLER_357_189 VPWR VGND sg13cmos5l_decap_8
XFILLER_50_44 VPWR VGND sg13cmos5l_decap_8
XFILLER_447_98 VPWR VGND sg13cmos5l_decap_8
XFILLER_514_153 VPWR VGND sg13cmos5l_decap_8
XFILLER_313_215 VPWR VGND sg13cmos5l_fill_2
XFILLER_514_175 VPWR VGND sg13cmos5l_decap_8
XFILLER_166_77 VPWR VGND sg13cmos5l_decap_8
XFILLER_124_126 VPWR VGND sg13cmos5l_decap_8
XFILLER_316_14 VPWR VGND sg13cmos5l_decap_8
XANTENNA__3127__X Tile_X0Y7_EE4BEG[13] VPWR VGND sg13cmos5l_antennanp
XFILLER_463_42 VPWR VGND sg13cmos5l_decap_4
XFILLER_463_75 VPWR VGND sg13cmos5l_decap_8
XFILLER_278_130 VPWR VGND sg13cmos5l_fill_2
XANTENNA__2966__X Tile_X0Y8_FrameData_O[6] VPWR VGND sg13cmos5l_antennanp
XFILLER_427_105 VPWR VGND sg13cmos5l_decap_8
XFILLER_132_192 VPWR VGND sg13cmos5l_decap_8
XFILLER_613_56 VPWR VGND sg13cmos5l_decap_8
XFILLER_278_196 VPWR VGND sg13cmos5l_decap_8
XFILLER_332_35 VPWR VGND sg13cmos5l_decap_8
XFILLER_115_70 VPWR VGND sg13cmos5l_decap_8
XFILLER_376_0 VPWR VGND sg13cmos5l_fill_2
XFILLER_689_49 VPWR VGND sg13cmos5l_decap_8
XFILLER_442_119 VPWR VGND sg13cmos5l_decap_8
XFILLER_596_112 VPWR VGND sg13cmos5l_decap_8
XFILLER_61_102 VPWR VGND sg13cmos5l_decap_8
XFILLER_543_0 VPWR VGND sg13cmos5l_decap_8
XFILLER_46_187 VPWR VGND sg13cmos5l_decap_8
XFILLER_201_28 VPWR VGND sg13cmos5l_decap_8
XFILLER_450_185 VPWR VGND sg13cmos5l_fill_2
XFILLER_61_179 VPWR VGND sg13cmos5l_decap_8
XFILLER_98_7 VPWR VGND sg13cmos5l_decap_8
XFILLER_348_112 VPWR VGND sg13cmos5l_decap_8
XFILLER_710_0 VPWR VGND sg13cmos5l_decap_8
XFILLER_91_95 VPWR VGND sg13cmos5l_decap_8
XFILLER_638_42 VPWR VGND sg13cmos5l_decap_8
X_1850_ _1850_/Q Tile_X0Y3_FrameData[15] VGND VPWR Tile_X0Y9_FrameStrobe[5] latch
XFILLER_202_174 VPWR VGND sg13cmos5l_decap_4
XFILLER_357_21 VPWR VGND sg13cmos5l_decap_8
XFILLER_348_178 VPWR VGND sg13cmos5l_fill_2
X_0801_ _0801_/Q Tile_X0Y9_FrameData[30] VGND VPWR Tile_X0Y9_FrameStrobe[4] latch
X_1781_ _1781_/Q Tile_X0Y3_FrameData[20] VGND VPWR Tile_X0Y9_FrameStrobe[3] latch
XFILLER_363_137 VPWR VGND sg13cmos5l_decap_8
X_3520_ Tile_X0Y1_E1BEG[2] _3930_/X VPWR VGND sg13cmos5l_buf_1
X_0732_ _0732_/Q Tile_X0Y9_FrameData[3] VGND VPWR Tile_X0Y9_FrameStrobe[1] latch
XFILLER_357_98 VPWR VGND sg13cmos5l_decap_8
XFILLER_507_35 VPWR VGND sg13cmos5l_decap_8
XFILLER_115_115 VPWR VGND sg13cmos5l_decap_8
X_0663_ _0663_/Q Tile_X0Y8_FrameData[8] VGND VPWR Tile_X0Y9_FrameStrobe[7] latch
X_3451_ Tile_X0Y1_FrameData_O[9] Tile_X0Y1_FrameData[9] VPWR VGND sg13cmos5l_buf_1
XFILLER_654_63 VPWR VGND sg13cmos5l_decap_8
XFILLER_520_112 VPWR VGND sg13cmos5l_decap_4
XFILLER_520_123 VPWR VGND sg13cmos5l_decap_8
XFILLER_371_192 VPWR VGND sg13cmos5l_decap_8
XANTENNA__3037__X Tile_X0Y5_EE4BEG[12] VPWR VGND sg13cmos5l_antennanp
XFILLER_373_42 VPWR VGND sg13cmos5l_decap_8
X_2402_ _2402_/Q Tile_X0Y5_FrameData[3] VGND VPWR Tile_X0Y9_FrameStrobe[6] latch
X_3382_ Tile_X0Y2_E6BEG[5] _4077_/X VPWR VGND sg13cmos5l_buf_1
X_0594_ _0594_/Q Tile_X0Y8_FrameData[13] VGND VPWR Tile_X0Y9_FrameStrobe[5] latch
XFILLER_666_149 VPWR VGND sg13cmos5l_decap_8
XFILLER_34_2 VPWR VGND sg13cmos5l_fill_1
X_2333_ _2333_/Q Tile_X0Y5_FrameData[8] VGND VPWR Tile_X0Y9_FrameStrobe[4] latch
XFILLER_269_163 VPWR VGND sg13cmos5l_decap_8
XANTENNA__2876__X Tile_X0Y6_EE4BEG[13] VPWR VGND sg13cmos5l_antennanp
XFILLER_681_119 VPWR VGND sg13cmos5l_decap_8
XFILLER_607_205 VPWR VGND sg13cmos5l_decap_4
XFILLER_242_13 VPWR VGND sg13cmos5l_decap_8
X_2264_ _2264_/Q Tile_X0Y5_FrameData[13] VGND VPWR Tile_X0Y9_FrameStrobe[2] latch
XFILLER_284_133 VPWR VGND sg13cmos5l_decap_8
XFILLER_674_193 VPWR VGND sg13cmos5l_decap_8
XFILLER_670_84 VPWR VGND sg13cmos5l_decap_8
XFILLER_523_89 VPWR VGND sg13cmos5l_decap_4
X_1215_ _1215_/Q Tile_X0Y1_FrameData[26] VGND VPWR Tile_X0Y9_FrameStrobe[1] latch
X_4003_ _4003_/X Tile_X0Y5_W1END[2] Tile_X0Y5_WW4END[2] Tile_X0Y5_W6END[10] _4453_/X
+ _2409_/Q _2408_/Q VPWR VGND sg13cmos5l_mux4_1
XFILLER_242_68 VPWR VGND sg13cmos5l_decap_8
X_2195_ _2195_/Q Tile_X0Y5_FrameData[18] VGND VPWR Tile_X0Y9_FrameStrobe[0] latch
XFILLER_599_49 VPWR VGND sg13cmos5l_decap_8
XFILLER_426_182 VPWR VGND sg13cmos5l_decap_8
X_1146_ _1146_/Q Tile_X0Y0_FrameData[17] VGND VPWR Tile_X0Y9_FrameStrobe[6] latch
XFILLER_587_112 VPWR VGND sg13cmos5l_fill_1
XFILLER_1_93 VPWR VGND sg13cmos5l_fill_1
X_1077_ _1077_/Q Tile_X0Y0_FrameData[22] VGND VPWR Tile_X0Y9_FrameStrobe[4] latch
XFILLER_679_93 VPWR VGND sg13cmos5l_fill_2
XFILLER_52_135 VPWR VGND sg13cmos5l_fill_2
XFILLER_197_107 VPWR VGND sg13cmos5l_fill_1
XANTENNA__3500__X Tile_X0Y1_E6BEG[10] VPWR VGND sg13cmos5l_antennanp
XFILLER_587_167 VPWR VGND sg13cmos5l_fill_1
XFILLER_197_129 VPWR VGND sg13cmos5l_decap_4
X_4905_ _4905_/X Tile_X0Y9_N2MID[2] Tile_X0Y9_N2END[2] _4934_/X _4818_/X _0691_/Q
+ _0690_/Q VPWR VGND sg13cmos5l_mux4_1
XFILLER_52_179 VPWR VGND sg13cmos5l_decap_8
XFILLER_548_42 VPWR VGND sg13cmos5l_decap_8
X_4836_ _4836_/X Tile_X0Y9_W1END[0] Tile_X0Y9_WW4END[12] Tile_X0Y9_W6END[4] _4916_/X
+ _0867_/Q _0866_/Q VPWR VGND sg13cmos5l_mux4_1
XFILLER_695_70 VPWR VGND sg13cmos5l_decap_8
XFILLER_267_21 VPWR VGND sg13cmos5l_decap_8
XFILLER_354_126 VPWR VGND sg13cmos5l_decap_8
X_4767_ _4767_/X AXI_M_SOC_RDATA11 _4804_/X _4808_/X _4791_/X _0513_/Q _0512_/Q VPWR
+ VGND sg13cmos5l_mux4_1
X_1979_ _1979_/Q Tile_X0Y4_FrameData[10] VGND VPWR Tile_X0Y9_FrameStrobe[1] latch
X_3718_ AXI_M_SOC_WDATA28 Tile_X0Y6_W1END[0] Tile_X0Y6_WW4END[4] Tile_X0Y6_WW4END[12]
+ _4580_/X _2503_/Q _2502_/Q VPWR VGND sg13cmos5l_mux4_1
XFILLER_267_98 VPWR VGND sg13cmos5l_fill_1
X_4698_ _4698_/X _4665_/X Tile_X0Y9_N4END[10] _4664_/X _0054_/X _0187_/Q _0186_/Q
+ VPWR VGND sg13cmos5l_mux4_1
XFILLER_417_35 VPWR VGND sg13cmos5l_decap_8
XFILLER_20_14 VPWR VGND sg13cmos5l_decap_8
XFILLER_564_63 VPWR VGND sg13cmos5l_decap_8
X_3649_ AXI_M_SOC_AWADDR10 Tile_X0Y5_WW4END[2] Tile_X0Y5_WW4END[10] Tile_X0Y5_W6END[10]
+ _4461_/X _2251_/Q _2250_/Q VPWR VGND sg13cmos5l_mux4_1
XFILLER_136_14 VPWR VGND sg13cmos5l_decap_8
XFILLER_657_105 VPWR VGND sg13cmos5l_decap_8
XFILLER_283_42 VPWR VGND sg13cmos5l_decap_8
XANTENNA__2786__X Tile_X0Y3_EE4BEG[12] VPWR VGND sg13cmos5l_antennanp
XFILLER_714_77 VPWR VGND sg13cmos5l_decap_8
XFILLER_433_56 VPWR VGND sg13cmos5l_decap_8
XFILLER_29_34 VPWR VGND sg13cmos5l_decap_8
XFILLER_409_127 VPWR VGND sg13cmos5l_decap_8
XFILLER_409_138 VPWR VGND sg13cmos5l_fill_1
XFILLER_152_35 VPWR VGND sg13cmos5l_decap_8
XFILLER_424_119 VPWR VGND sg13cmos5l_decap_8
XFILLER_467_7 VPWR VGND sg13cmos5l_decap_8
XFILLER_45_22 VPWR VGND sg13cmos5l_fill_1
XFILLER_578_112 VPWR VGND sg13cmos5l_decap_8
XFILLER_302_49 VPWR VGND sg13cmos5l_fill_1
XFILLER_290_169 VPWR VGND sg13cmos5l_decap_8
XFILLER_232_90 VPWR VGND sg13cmos5l_decap_8
XFILLER_432_152 VPWR VGND sg13cmos5l_decap_8
XFILLER_634_7 VPWR VGND sg13cmos5l_decap_8
XFILLER_43_135 VPWR VGND sg13cmos5l_fill_1
XFILLER_377_207 VPWR VGND sg13cmos5l_decap_8
XANTENNA__3410__X Tile_X0Y4_FrameData_O[1] VPWR VGND sg13cmos5l_antennanp
XFILLER_458_42 VPWR VGND sg13cmos5l_fill_2
XFILLER_101_94 VPWR VGND sg13cmos5l_decap_8
XFILLER_177_21 VPWR VGND sg13cmos5l_decap_8
XFILLER_534_204 VPWR VGND sg13cmos5l_fill_1
XFILLER_458_86 VPWR VGND sg13cmos5l_decap_8
XFILLER_458_97 VPWR VGND sg13cmos5l_fill_1
XFILLER_345_148 VPWR VGND sg13cmos5l_decap_8
XFILLER_124_0 VPWR VGND sg13cmos5l_decap_8
XFILLER_608_56 VPWR VGND sg13cmos5l_decap_8
XFILLER_327_35 VPWR VGND sg13cmos5l_fill_1
XANTENNA_9 AXI_M_SOC_RDATA27 VPWR VGND sg13cmos5l_antennanp
XFILLER_6_49 VPWR VGND sg13cmos5l_decap_8
XFILLER_691_28 VPWR VGND sg13cmos5l_decap_8
XFILLER_327_57 VPWR VGND sg13cmos5l_decap_8
XFILLER_502_112 VPWR VGND sg13cmos5l_decap_8
XFILLER_193_20 VPWR VGND sg13cmos5l_decap_8
XFILLER_648_105 VPWR VGND sg13cmos5l_decap_8
XFILLER_493_0 VPWR VGND sg13cmos5l_decap_8
XFILLER_112_129 VPWR VGND sg13cmos5l_decap_4
XFILLER_624_77 VPWR VGND sg13cmos5l_decap_8
XFILLER_502_189 VPWR VGND sg13cmos5l_decap_8
XFILLER_10_91 VPWR VGND sg13cmos5l_decap_8
XFILLER_343_56 VPWR VGND sg13cmos5l_decap_8
XFILLER_490_84 VPWR VGND sg13cmos5l_decap_8
XFILLER_660_0 VPWR VGND sg13cmos5l_decap_8
XFILLER_640_21 VPWR VGND sg13cmos5l_decap_8
XFILLER_13_7 VPWR VGND sg13cmos5l_decap_8
XFILLER_604_208 VPWR VGND sg13cmos5l_fill_2
XFILLER_120_195 VPWR VGND sg13cmos5l_fill_2
X_1000_ _1000_/Q Tile_X0Y0_FrameData[3] VGND VPWR Tile_X0Y9_FrameStrobe[1] latch
XFILLER_281_147 VPWR VGND sg13cmos5l_decap_8
XFILLER_212_27 VPWR VGND sg13cmos5l_decap_8
XFILLER_640_98 VPWR VGND sg13cmos5l_decap_8
XFILLER_569_112 VPWR VGND sg13cmos5l_decap_8
XFILLER_19_187 VPWR VGND sg13cmos5l_fill_2
XFILLER_222_203 VPWR VGND sg13cmos5l_decap_8
XANTENNA__3320__X Tile_X0Y4_EE4BEG[8] VPWR VGND sg13cmos5l_antennanp
XFILLER_569_189 VPWR VGND sg13cmos5l_fill_1
X_2951_ Tile_X0Y8_EE4BEG[7] _4751_/X VPWR VGND sg13cmos5l_buf_1
XFILLER_649_63 VPWR VGND sg13cmos5l_decap_8
XFILLER_584_126 VPWR VGND sg13cmos5l_fill_1
XFILLER_584_148 VPWR VGND sg13cmos5l_decap_8
XFILLER_368_42 VPWR VGND sg13cmos5l_decap_4
X_1902_ _1902_/Q Tile_X0Y3_FrameData[27] VGND VPWR Tile_X0Y9_FrameStrobe[7] latch
X_2882_ Tile_X0Y6_FrameData_O[3] Tile_X0Y6_FrameData[3] VPWR VGND sg13cmos5l_buf_1
X_4621_ _4621_/X Tile_X0Y7_W2END[6] AXI_M_SOC_RDATA22 _4671_/X _4670_/X _0317_/Q _0316_/Q
+ VPWR VGND sg13cmos5l_mux4_1
X_1833_ _1833_/Q Tile_X0Y3_FrameData[0] VGND VPWR Tile_X0Y9_FrameStrobe[4] latch
XFILLER_592_192 VPWR VGND sg13cmos5l_decap_8
XFILLER_518_56 VPWR VGND sg13cmos5l_decap_8
X_4552_ _4552_/X _4483_/X _4599_/X _4598_/X _4482_/X _2449_/Q _2448_/Q VPWR VGND sg13cmos5l_mux4_1
X_1764_ _1764_/Q Tile_X0Y3_FrameData[5] VGND VPWR Tile_X0Y9_FrameStrobe[2] latch
XFILLER_665_84 VPWR VGND sg13cmos5l_decap_8
X_3503_ Tile_X0Y1_E2BEGb[1] _3941_/X VPWR VGND sg13cmos5l_buf_1
X_0715_ _0715_/Q Tile_X0Y9_FrameData[20] VGND VPWR Tile_X0Y9_FrameStrobe[1] latch
XFILLER_344_181 VPWR VGND sg13cmos5l_fill_2
X_4483_ _4483_/X Tile_X0Y7_W2MID[0] Tile_X0Y7_W2END[0] Tile_X0Y7_W6END[0] _4668_/X
+ _0393_/Q _0392_/Q VPWR VGND sg13cmos5l_mux4_1
X_1695_ _1695_/Q Tile_X0Y3_FrameData[10] VGND VPWR Tile_X0Y9_FrameStrobe[0] latch
XFILLER_639_105 VPWR VGND sg13cmos5l_decap_8
X_3434_ Tile_X0Y4_FrameData_O[25] Tile_X0Y4_FrameData[25] VPWR VGND sg13cmos5l_buf_1
X_0646_ _0646_/Q Tile_X0Y8_FrameData[25] VGND VPWR Tile_X0Y9_FrameStrobe[7] latch
XFILLER_103_118 VPWR VGND sg13cmos5l_decap_4
XFILLER_106_28 VPWR VGND sg13cmos5l_fill_1
X_0577_ _0577_/Q Tile_X0Y8_FrameData[30] VGND VPWR Tile_X0Y9_FrameStrobe[5] latch
X_3365_ Tile_X0Y2_EE4BEG[4] _4060_/X VPWR VGND sg13cmos5l_buf_1
XFILLER_654_119 VPWR VGND sg13cmos5l_fill_2
XFILLER_253_67 VPWR VGND sg13cmos5l_decap_8
X_2316_ _2316_/Q Tile_X0Y5_FrameData[25] VGND VPWR Tile_X0Y9_FrameStrobe[4] latch
XFILLER_647_182 VPWR VGND sg13cmos5l_decap_8
X_3296_ Tile_X0Y0_E2BEGb[4] _3816_/X VPWR VGND sg13cmos5l_buf_1
XFILLER_550_21 VPWR VGND sg13cmos5l_decap_8
X_2247_ _2247_/Q Tile_X0Y5_FrameData[30] VGND VPWR Tile_X0Y9_FrameStrobe[2] latch
XFILLER_257_199 VPWR VGND sg13cmos5l_decap_8
XFILLER_550_76 VPWR VGND sg13cmos5l_decap_8
X_2178_ _2178_/Q Tile_X0Y4_FrameData[3] VGND VPWR Tile_X0Y9_FrameStrobe[7] latch
XFILLER_122_49 VPWR VGND sg13cmos5l_fill_2
XFILLER_700_35 VPWR VGND sg13cmos5l_decap_8
XFILLER_25_102 VPWR VGND sg13cmos5l_decap_8
X_1129_ _1129_/Q Tile_X0Y0_FrameData[2] VGND VPWR Tile_X0Y9_FrameStrobe[5] latch
XANTENNA__3230__X Tile_X0Y0_FrameStrobe_O[18] VPWR VGND sg13cmos5l_antennanp
XFILLER_15_14 VPWR VGND sg13cmos5l_decap_8
XFILLER_575_126 VPWR VGND sg13cmos5l_decap_8
XFILLER_559_63 VPWR VGND sg13cmos5l_decap_8
XFILLER_278_42 VPWR VGND sg13cmos5l_decap_8
XFILLER_178_184 VPWR VGND sg13cmos5l_decap_8
XFILLER_709_77 VPWR VGND sg13cmos5l_decap_8
X_4819_ _4819_/X Tile_X0Y7_W2MID[4] Tile_X0Y7_W2END[4] Tile_X0Y7_W6END[11] _4675_/X
+ _0365_/Q _0364_/Q VPWR VGND sg13cmos5l_mux4_1
XFILLER_327_126 VPWR VGND sg13cmos5l_fill_1
XFILLER_31_13 VPWR VGND sg13cmos5l_decap_8
XFILLER_717_197 VPWR VGND sg13cmos5l_fill_2
XFILLER_428_56 VPWR VGND sg13cmos5l_decap_8
XFILLER_193_154 VPWR VGND sg13cmos5l_decap_8
XFILLER_215_7 VPWR VGND sg13cmos5l_decap_8
XFILLER_575_84 VPWR VGND sg13cmos5l_decap_8
XFILLER_147_35 VPWR VGND sg13cmos5l_decap_8
XFILLER_335_170 VPWR VGND sg13cmos5l_decap_8
XFILLER_294_63 VPWR VGND sg13cmos5l_decap_8
XFILLER_208_6 VPWR VGND sg13cmos5l_decap_8
XFILLER_496_133 VPWR VGND sg13cmos5l_decap_8
XFILLER_350_162 VPWR VGND sg13cmos5l_decap_8
XFILLER_295_217 VPWR VGND sg13cmos5l_fill_1
XFILLER_584_7 VPWR VGND sg13cmos5l_decap_8
XFILLER_248_100 VPWR VGND sg13cmos5l_decap_4
XFILLER_645_119 VPWR VGND sg13cmos5l_decap_8
XFILLER_437_211 VPWR VGND sg13cmos5l_decap_8
XANTENNA__3405__X Tile_X0Y2_E1BEG[0] VPWR VGND sg13cmos5l_antennanp
XFILLER_163_67 VPWR VGND sg13cmos5l_decap_8
XFILLER_102_151 VPWR VGND sg13cmos5l_decap_8
XFILLER_460_21 VPWR VGND sg13cmos5l_decap_8
XFILLER_102_184 VPWR VGND sg13cmos5l_decap_8
XFILLER_263_114 VPWR VGND sg13cmos5l_decap_8
XFILLER_248_199 VPWR VGND sg13cmos5l_decap_8
XFILLER_598_207 VPWR VGND sg13cmos5l_fill_2
XFILLER_460_76 VPWR VGND sg13cmos5l_fill_1
XFILLER_460_98 VPWR VGND sg13cmos5l_decap_8
XFILLER_610_35 VPWR VGND sg13cmos5l_decap_8
XFILLER_405_130 VPWR VGND sg13cmos5l_decap_8
XANTENNA__3140__X Tile_X0Y7_FrameData_O[10] VPWR VGND sg13cmos5l_antennanp
XFILLER_16_168 VPWR VGND sg13cmos5l_fill_2
XFILLER_72_42 VPWR VGND sg13cmos5l_decap_8
XFILLER_686_28 VPWR VGND sg13cmos5l_decap_8
XFILLER_420_133 VPWR VGND sg13cmos5l_decap_8
XFILLER_72_53 VPWR VGND sg13cmos5l_fill_2
XFILLER_566_126 VPWR VGND sg13cmos5l_decap_8
XFILLER_241_0 VPWR VGND sg13cmos5l_decap_8
XFILLER_339_0 VPWR VGND sg13cmos5l_decap_8
XFILLER_188_42 VPWR VGND sg13cmos5l_decap_8
XFILLER_420_177 VPWR VGND sg13cmos5l_fill_1
XFILLER_72_97 VPWR VGND sg13cmos5l_decap_8
XFILLER_169_184 VPWR VGND sg13cmos5l_fill_1
XFILLER_619_77 VPWR VGND sg13cmos5l_decap_8
XFILLER_507_215 VPWR VGND sg13cmos5l_fill_2
XFILLER_188_97 VPWR VGND sg13cmos5l_fill_2
XFILLER_574_192 VPWR VGND sg13cmos5l_decap_8
XFILLER_506_0 VPWR VGND sg13cmos5l_decap_8
XFILLER_338_56 VPWR VGND sg13cmos5l_fill_2
XFILLER_318_159 VPWR VGND sg13cmos5l_decap_8
XFILLER_485_84 VPWR VGND sg13cmos5l_decap_8
XFILLER_68_8 VPWR VGND sg13cmos5l_decap_8
XFILLER_635_21 VPWR VGND sg13cmos5l_decap_8
X_0500_ _0500_/Q Tile_X0Y8_FrameData[11] VGND VPWR Tile_X0Y9_FrameStrobe[2] latch
XFILLER_207_27 VPWR VGND sg13cmos5l_decap_8
XFILLER_98_105 VPWR VGND sg13cmos5l_fill_2
X_1480_ _1480_/Q Tile_X0Y2_FrameData[9] VGND VPWR Tile_X0Y9_FrameStrobe[1] latch
XFILLER_487_133 VPWR VGND sg13cmos5l_decap_4
XFILLER_635_98 VPWR VGND sg13cmos5l_decap_8
X_0431_ _0431_/Q Tile_X0Y8_FrameData[16] VGND VPWR Tile_X0Y9_FrameStrobe[0] latch
XFILLER_354_77 VPWR VGND sg13cmos5l_decap_8
XFILLER_636_119 VPWR VGND sg13cmos5l_decap_8
XFILLER_504_14 VPWR VGND sg13cmos5l_decap_8
XANTENNA__3315__X Tile_X0Y4_EE4BEG[3] VPWR VGND sg13cmos5l_antennanp
XFILLER_651_42 VPWR VGND sg13cmos5l_decap_8
XFILLER_239_122 VPWR VGND sg13cmos5l_decap_4
XFILLER_629_182 VPWR VGND sg13cmos5l_fill_2
X_0362_ _0362_/Q Tile_X0Y7_FrameData[21] VGND VPWR Tile_X0Y9_FrameStrobe[6] latch
X_3150_ Tile_X0Y7_FrameData_O[20] Tile_X0Y7_FrameData[20] VPWR VGND sg13cmos5l_buf_1
XFILLER_370_21 VPWR VGND sg13cmos5l_decap_8
XFILLER_239_155 VPWR VGND sg13cmos5l_decap_8
X_2101_ _2101_/Q Tile_X0Y4_FrameData[16] VGND VPWR Tile_X0Y9_FrameStrobe[5] latch
X_3081_ Tile_X0Y4_E2BEGb[7] _4271_/X VPWR VGND sg13cmos5l_buf_1
X_0293_ _0293_/Q Tile_X0Y7_FrameData[26] VGND VPWR Tile_X0Y9_FrameStrobe[4] latch
XFILLER_254_136 VPWR VGND sg13cmos5l_fill_1
X_2032_ _2032_/Q Tile_X0Y4_FrameData[21] VGND VPWR Tile_X0Y9_FrameStrobe[3] latch
XFILLER_644_196 VPWR VGND sg13cmos5l_decap_8
XFILLER_254_158 VPWR VGND sg13cmos5l_decap_4
XFILLER_520_35 VPWR VGND sg13cmos5l_decap_8
XFILLER_600_200 VPWR VGND sg13cmos5l_decap_8
XANTENNA__3050__X Tile_X0Y5_FrameData_O[9] VPWR VGND sg13cmos5l_antennanp
XFILLER_596_28 VPWR VGND sg13cmos5l_decap_8
XFILLER_557_126 VPWR VGND sg13cmos5l_fill_2
XFILLER_379_63 VPWR VGND sg13cmos5l_decap_4
X_3983_ _3983_/X Tile_X0Y2_W1END[1] Tile_X0Y2_W6END[5] _4110_/X _4085_/X _1671_/Q
+ _1670_/Q VPWR VGND sg13cmos5l_mux4_1
XFILLER_210_206 VPWR VGND sg13cmos5l_fill_1
XFILLER_22_149 VPWR VGND sg13cmos5l_decap_4
X_2934_ Tile_X0Y8_E6BEG[2] _4762_/X VPWR VGND sg13cmos5l_buf_1
XFILLER_309_104 VPWR VGND sg13cmos5l_fill_2
XFILLER_87_0 VPWR VGND sg13cmos5l_decap_8
XFILLER_676_72 VPWR VGND sg13cmos5l_fill_1
XFILLER_364_210 VPWR VGND sg13cmos5l_fill_2
XFILLER_714_112 VPWR VGND sg13cmos5l_decap_8
X_2865_ Tile_X0Y6_EE4BEG[2] _4514_/X VPWR VGND sg13cmos5l_buf_1
XFILLER_30_182 VPWR VGND sg13cmos5l_decap_8
X_4604_ _4604_/X Tile_X0Y7_W1END[2] Tile_X0Y7_WW4END[14] Tile_X0Y7_W6END[6] _4686_/X
+ _0349_/Q _0348_/Q VPWR VGND sg13cmos5l_mux4_1
XFILLER_175_165 VPWR VGND sg13cmos5l_decap_8
X_1816_ _1816_/Q Tile_X0Y3_FrameData[17] VGND VPWR Tile_X0Y9_FrameStrobe[4] latch
X_2796_ Tile_X0Y3_E6BEG[6] _4186_/X VPWR VGND sg13cmos5l_buf_1
XFILLER_545_21 VPWR VGND sg13cmos5l_decap_8
XFILLER_7_70 VPWR VGND sg13cmos5l_decap_8
XFILLER_714_189 VPWR VGND sg13cmos5l_decap_8
X_4535_ _4535_/X AXI_M_SOC_RDATA27 _4572_/X _4576_/X _4559_/X _2537_/Q _2536_/Q VPWR
+ VGND sg13cmos5l_mux4_1
X_1747_ _1747_/Q Tile_X0Y3_FrameData[22] VGND VPWR Tile_X0Y9_FrameStrobe[2] latch
XFILLER_317_192 VPWR VGND sg13cmos5l_decap_4
XFILLER_478_111 VPWR VGND sg13cmos5l_fill_1
XFILLER_478_133 VPWR VGND sg13cmos5l_fill_2
X_4466_ _4466_/X _4427_/X _0097_/X _4426_/X _0156_/X _2207_/Q _2206_/Q VPWR VGND sg13cmos5l_mux4_1
X_1678_ _1678_/Q Tile_X0Y3_FrameData[27] VGND VPWR Tile_X0Y9_FrameStrobe[0] latch
XFILLER_264_77 VPWR VGND sg13cmos5l_decap_8
X_3417_ Tile_X0Y4_FrameData_O[8] Tile_X0Y4_FrameData[8] VPWR VGND sg13cmos5l_buf_1
X_0629_ _0629_/Q Tile_X0Y8_FrameData[10] VGND VPWR Tile_X0Y9_FrameStrobe[6] latch
XFILLER_478_188 VPWR VGND sg13cmos5l_decap_8
XFILLER_414_14 VPWR VGND sg13cmos5l_decap_8
X_4397_ _4397_/X Tile_X0Y5_WW4END[6] AXI_M_SOC_RRESP0 _4457_/X _4429_/X _2309_/Q _2308_/Q
+ VPWR VGND sg13cmos5l_mux4_1
XFILLER_478_199 VPWR VGND sg13cmos5l_fill_1
XANTENNA__3225__X Tile_X0Y0_FrameStrobe_O[13] VPWR VGND sg13cmos5l_antennanp
XFILLER_561_42 VPWR VGND sg13cmos5l_decap_8
XFILLER_493_147 VPWR VGND sg13cmos5l_decap_8
X_3348_ Tile_X0Y2_FrameData_O[19] Tile_X0Y2_FrameData[19] VPWR VGND sg13cmos5l_buf_1
XFILLER_280_21 VPWR VGND sg13cmos5l_decap_8
XFILLER_434_214 VPWR VGND sg13cmos5l_decap_4
XFILLER_245_114 VPWR VGND sg13cmos5l_fill_1
X_3279_ Tile_X0Y0_EE4BEG[15] _3835_/X VPWR VGND sg13cmos5l_buf_1
XFILLER_711_56 VPWR VGND sg13cmos5l_decap_8
XFILLER_650_133 VPWR VGND sg13cmos5l_decap_8
XFILLER_280_98 VPWR VGND sg13cmos5l_decap_8
XFILLER_430_35 VPWR VGND sg13cmos5l_decap_8
XFILLER_245_169 VPWR VGND sg13cmos5l_decap_8
XFILLER_213_70 VPWR VGND sg13cmos5l_decap_8
XFILLER_26_35 VPWR VGND sg13cmos5l_decap_8
XFILLER_399_151 VPWR VGND sg13cmos5l_decap_8
XFILLER_165_7 VPWR VGND sg13cmos5l_decap_8
XFILLER_253_180 VPWR VGND sg13cmos5l_decap_8
XFILLER_548_126 VPWR VGND sg13cmos5l_fill_2
XFILLER_289_63 VPWR VGND sg13cmos5l_decap_8
XFILLER_402_155 VPWR VGND sg13cmos5l_decap_8
XFILLER_201_206 VPWR VGND sg13cmos5l_fill_1
XFILLER_13_149 VPWR VGND sg13cmos5l_fill_2
XFILLER_332_7 VPWR VGND sg13cmos5l_decap_8
XFILLER_42_23 VPWR VGND sg13cmos5l_decap_8
XFILLER_439_77 VPWR VGND sg13cmos5l_fill_2
XFILLER_166_121 VPWR VGND sg13cmos5l_decap_8
XFILLER_705_112 VPWR VGND sg13cmos5l_decap_8
XFILLER_571_140 VPWR VGND sg13cmos5l_decap_8
XFILLER_158_78 VPWR VGND sg13cmos5l_fill_2
XFILLER_181_113 VPWR VGND sg13cmos5l_decap_8
XFILLER_455_21 VPWR VGND sg13cmos5l_decap_8
XFILLER_181_124 VPWR VGND sg13cmos5l_fill_1
XFILLER_455_98 VPWR VGND sg13cmos5l_decap_8
XFILLER_605_35 VPWR VGND sg13cmos5l_decap_8
XFILLER_324_14 VPWR VGND sg13cmos5l_decap_8
XFILLER_3_28 VPWR VGND sg13cmos5l_decap_8
XANTENNA__3135__X Tile_X0Y7_FrameData_O[5] VPWR VGND sg13cmos5l_antennanp
XFILLER_471_42 VPWR VGND sg13cmos5l_decap_4
XFILLER_67_31 VPWR VGND sg13cmos5l_decap_8
XFILLER_471_53 VPWR VGND sg13cmos5l_decap_8
XFILLER_283_209 VPWR VGND sg13cmos5l_fill_2
XFILLER_190_21 VPWR VGND sg13cmos5l_decap_8
XFILLER_191_0 VPWR VGND sg13cmos5l_fill_2
XFILLER_289_0 VPWR VGND sg13cmos5l_decap_8
XANTENNA__2974__X Tile_X0Y8_FrameData_O[14] VPWR VGND sg13cmos5l_antennanp
XFILLER_236_125 VPWR VGND sg13cmos5l_decap_8
XFILLER_621_56 VPWR VGND sg13cmos5l_decap_8
XFILLER_641_133 VPWR VGND sg13cmos5l_decap_8
XFILLER_340_35 VPWR VGND sg13cmos5l_decap_8
XFILLER_456_0 VPWR VGND sg13cmos5l_decap_8
XFILLER_251_106 VPWR VGND sg13cmos5l_decap_8
XFILLER_251_128 VPWR VGND sg13cmos5l_decap_8
XFILLER_697_49 VPWR VGND sg13cmos5l_decap_8
XFILLER_83_85 VPWR VGND sg13cmos5l_decap_8
XFILLER_199_63 VPWR VGND sg13cmos5l_decap_8
XFILLER_623_0 VPWR VGND sg13cmos5l_decap_8
X_0980_ _0980_/Q Tile_X0Y0_FrameData[23] VGND VPWR Tile_X0Y9_FrameStrobe[1] latch
XFILLER_157_110 VPWR VGND sg13cmos5l_decap_8
XFILLER_349_77 VPWR VGND sg13cmos5l_decap_8
XFILLER_646_42 VPWR VGND sg13cmos5l_decap_8
X_2650_ _2650_/Q Tile_X0Y6_FrameData[13] VGND VPWR Tile_X0Y9_FrameStrobe[6] latch
XFILLER_365_21 VPWR VGND sg13cmos5l_decap_8
XFILLER_172_113 VPWR VGND sg13cmos5l_decap_8
X_1601_ _1601_/Q Tile_X0Y2_FrameData[16] VGND VPWR Tile_X0Y9_FrameStrobe[5] latch
XFILLER_711_126 VPWR VGND sg13cmos5l_decap_8
X_2581_ _2581_/Q Tile_X0Y6_FrameData[18] VGND VPWR Tile_X0Y9_FrameStrobe[4] latch
X_4320_ _4320_/X Tile_X0Y0_W1END[0] Tile_X0Y0_WW4END[12] Tile_X0Y0_W6END[4] _3881_/X
+ _1117_/Q _1116_/Q VPWR VGND sg13cmos5l_mux4_1
X_1532_ _1532_/Q Tile_X0Y2_FrameData[21] VGND VPWR Tile_X0Y9_FrameStrobe[3] latch
XFILLER_314_162 VPWR VGND sg13cmos5l_decap_8
XFILLER_113_202 VPWR VGND sg13cmos5l_decap_8
XFILLER_515_35 VPWR VGND sg13cmos5l_decap_8
XFILLER_259_217 VPWR VGND sg13cmos5l_fill_1
X_4251_ _4251_/X Tile_X0Y5_W2MID[0] Tile_X0Y5_W2END[0] Tile_X0Y5_W6END[0] _4428_/X
+ _2417_/Q _2416_/Q VPWR VGND sg13cmos5l_mux4_1
XFILLER_662_63 VPWR VGND sg13cmos5l_decap_8
XFILLER_234_14 VPWR VGND sg13cmos5l_decap_8
X_1463_ _1463_/Q Tile_X0Y2_FrameData[26] VGND VPWR Tile_X0Y9_FrameStrobe[1] latch
XANTENNA__3045__X Tile_X0Y5_FrameData_O[4] VPWR VGND sg13cmos5l_antennanp
XFILLER_381_42 VPWR VGND sg13cmos5l_fill_1
X_3202_ Tile_X0Y0_N2BEG[2] _3786_/X VPWR VGND sg13cmos5l_buf_1
X_0414_ _0414_/Q Tile_X0Y7_FrameData[1] VGND VPWR Tile_X0Y9_FrameStrobe[7] latch
XFILLER_475_147 VPWR VGND sg13cmos5l_decap_4
X_1394_ _1394_/Q Tile_X0Y1_FrameData[7] VGND VPWR Tile_X0Y9_FrameStrobe[6] latch
X_4182_ _4182_/X _0087_/X Tile_X0Y0_S4END[14] _4231_/X _4235_/X _1777_/Q _1776_/Q
+ VPWR VGND sg13cmos5l_mux4_1
XFILLER_381_64 VPWR VGND sg13cmos5l_decap_4
XFILLER_475_169 VPWR VGND sg13cmos5l_decap_4
X_3133_ Tile_X0Y7_FrameData_O[3] Tile_X0Y7_FrameData[3] VPWR VGND sg13cmos5l_buf_1
XANTENNA__2884__X Tile_X0Y6_FrameData_O[5] VPWR VGND sg13cmos5l_antennanp
X_0345_ _0345_/Q Tile_X0Y7_FrameData[6] VGND VPWR Tile_X0Y9_FrameStrobe[5] latch
XFILLER_227_147 VPWR VGND sg13cmos5l_fill_2
X_0276_ _0276_/Q Tile_X0Y7_FrameData[11] VGND VPWR Tile_X0Y9_FrameStrobe[3] latch
X_3064_ Tile_X0Y5_FrameData_O[23] Tile_X0Y5_FrameData[23] VPWR VGND sg13cmos5l_buf_1
XFILLER_531_89 VPWR VGND sg13cmos5l_fill_2
XFILLER_250_35 VPWR VGND sg13cmos5l_decap_8
XFILLER_242_106 VPWR VGND sg13cmos5l_decap_8
XFILLER_632_166 VPWR VGND sg13cmos5l_fill_2
X_2015_ _2015_/Q Tile_X0Y4_FrameData[6] VGND VPWR Tile_X0Y9_FrameStrobe[2] latch
XFILLER_632_177 VPWR VGND sg13cmos5l_fill_1
XFILLER_431_217 VPWR VGND sg13cmos5l_fill_1
XFILLER_400_49 VPWR VGND sg13cmos5l_decap_4
XFILLER_330_90 VPWR VGND sg13cmos5l_fill_1
XFILLER_687_82 VPWR VGND sg13cmos5l_decap_4
X_3966_ _3966_/X _0095_/X Tile_X0Y0_S4END[6] _4017_/X _4002_/X _1277_/Q _1276_/Q VPWR
+ VGND sg13cmos5l_mux4_1
XFILLER_10_108 VPWR VGND sg13cmos5l_fill_2
XFILLER_538_170 VPWR VGND sg13cmos5l_decap_8
X_2917_ Tile_X0Y8_E2BEG[1] _4729_/X VPWR VGND sg13cmos5l_buf_1
XFILLER_409_14 VPWR VGND sg13cmos5l_decap_8
X_3897_ _3897_/X Tile_X0Y1_W2MID[3] Tile_X0Y1_W2END[3] Tile_X0Y1_W6END[3] _3994_/X
+ _1409_/Q _1408_/Q VPWR VGND sg13cmos5l_mux4_1
XFILLER_556_42 VPWR VGND sg13cmos5l_decap_8
X_2848_ Tile_X0Y6_E2BEGb[5] _4509_/X VPWR VGND sg13cmos5l_buf_1
XFILLER_553_151 VPWR VGND sg13cmos5l_decap_8
XFILLER_163_102 VPWR VGND sg13cmos5l_fill_1
XFILLER_275_21 VPWR VGND sg13cmos5l_decap_8
XFILLER_163_124 VPWR VGND sg13cmos5l_decap_8
X_2779_ Tile_X0Y3_EE4BEG[5] _4169_/X VPWR VGND sg13cmos5l_buf_1
XFILLER_706_56 VPWR VGND sg13cmos5l_decap_8
X_4518_ _4518_/X Tile_X0Y6_WW4END[9] AXI_M_SOC_RDATA30 _4577_/X _4555_/X _2571_/Q
+ _2570_/Q VPWR VGND sg13cmos5l_mux4_1
XFILLER_702_159 VPWR VGND sg13cmos5l_fill_2
XFILLER_305_151 VPWR VGND sg13cmos5l_decap_8
XFILLER_275_98 VPWR VGND sg13cmos5l_decap_8
XFILLER_425_35 VPWR VGND sg13cmos5l_decap_8
XFILLER_572_63 VPWR VGND sg13cmos5l_decap_8
XFILLER_466_103 VPWR VGND sg13cmos5l_decap_8
X_4449_ _4449_/X Tile_X0Y9_W1END[3] Tile_X0Y9_WW4END[3] Tile_X0Y9_W6END[11] _4919_/X
+ _0894_/Q _0893_/Q VPWR VGND sg13cmos5l_mux4_1
XFILLER_466_114 VPWR VGND sg13cmos5l_fill_1
XFILLER_77_108 VPWR VGND sg13cmos5l_decap_8
XFILLER_466_136 VPWR VGND sg13cmos5l_fill_2
XFILLER_291_42 VPWR VGND sg13cmos5l_decap_8
XFILLER_291_86 VPWR VGND sg13cmos5l_fill_1
XANTENNA__2794__X Tile_X0Y3_E6BEG[4] VPWR VGND sg13cmos5l_antennanp
XFILLER_670_217 VPWR VGND sg13cmos5l_fill_1
XFILLER_407_203 VPWR VGND sg13cmos5l_fill_2
XFILLER_282_7 VPWR VGND sg13cmos5l_decap_8
XFILLER_441_56 VPWR VGND sg13cmos5l_decap_8
XFILLER_37_34 VPWR VGND sg13cmos5l_decap_8
XFILLER_218_147 VPWR VGND sg13cmos5l_decap_8
XFILLER_85_174 VPWR VGND sg13cmos5l_decap_8
XFILLER_160_13 VPWR VGND sg13cmos5l_decap_4
XFILLER_233_106 VPWR VGND sg13cmos5l_decap_8
XFILLER_160_46 VPWR VGND sg13cmos5l_decap_4
XFILLER_547_7 VPWR VGND sg13cmos5l_decap_8
XFILLER_226_180 VPWR VGND sg13cmos5l_fill_2
XFILLER_576_210 VPWR VGND sg13cmos5l_decap_8
XFILLER_310_38 VPWR VGND sg13cmos5l_decap_8
XFILLER_241_150 VPWR VGND sg13cmos5l_fill_2
XFILLER_714_7 VPWR VGND sg13cmos5l_decap_8
XFILLER_53_66 VPWR VGND sg13cmos5l_decap_8
XFILLER_149_2 VPWR VGND sg13cmos5l_fill_1
XFILLER_536_107 VPWR VGND sg13cmos5l_fill_2
XFILLER_319_14 VPWR VGND sg13cmos5l_decap_8
XFILLER_139_154 VPWR VGND sg13cmos5l_decap_8
XFILLER_466_42 VPWR VGND sg13cmos5l_fill_2
XFILLER_185_21 VPWR VGND sg13cmos5l_decap_8
XFILLER_154_146 VPWR VGND sg13cmos5l_decap_4
XANTENNA__2969__X Tile_X0Y8_FrameData_O[9] VPWR VGND sg13cmos5l_antennanp
XFILLER_204_0 VPWR VGND sg13cmos5l_decap_8
XFILLER_616_56 VPWR VGND sg13cmos5l_decap_8
XFILLER_335_35 VPWR VGND sg13cmos5l_decap_8
XFILLER_118_70 VPWR VGND sg13cmos5l_decap_8
XFILLER_646_203 VPWR VGND sg13cmos5l_decap_8
XFILLER_482_63 VPWR VGND sg13cmos5l_decap_8
XFILLER_701_192 VPWR VGND sg13cmos5l_decap_8
XFILLER_38_9 VPWR VGND sg13cmos5l_decap_4
XFILLER_78_85 VPWR VGND sg13cmos5l_decap_8
XFILLER_311_165 VPWR VGND sg13cmos5l_decap_8
XFILLER_311_176 VPWR VGND sg13cmos5l_fill_2
XFILLER_256_209 VPWR VGND sg13cmos5l_fill_1
XFILLER_573_0 VPWR VGND sg13cmos5l_decap_8
XFILLER_632_77 VPWR VGND sg13cmos5l_decap_8
XFILLER_661_217 VPWR VGND sg13cmos5l_fill_1
XFILLER_204_28 VPWR VGND sg13cmos5l_decap_8
XFILLER_351_56 VPWR VGND sg13cmos5l_decap_8
XFILLER_134_91 VPWR VGND sg13cmos5l_decap_8
X_0130_ AXI_M_SOC_AWSIZE0 _0939_/Q _3679_/X VPWR VGND sg13cmos5l_nor2b_1
XFILLER_209_147 VPWR VGND sg13cmos5l_decap_8
XFILLER_76_174 VPWR VGND sg13cmos5l_decap_4
XFILLER_209_158 VPWR VGND sg13cmos5l_fill_2
XFILLER_94_95 VPWR VGND sg13cmos5l_decap_8
XFILLER_91_144 VPWR VGND sg13cmos5l_decap_8
X_0061_ _3176_/A _3926_/X _3927_/X _1899_/Q VPWR VGND sg13cmos5l_mux2_1
XFILLER_91_155 VPWR VGND sg13cmos5l_fill_2
XFILLER_220_49 VPWR VGND sg13cmos5l_decap_8
XFILLER_378_154 VPWR VGND sg13cmos5l_decap_8
X_3820_ _3820_/X Tile_X0Y0_WW4END[7] Tile_X0Y0_WW4END[15] _3863_/X _3852_/X _1065_/Q
+ _1064_/Q VPWR VGND sg13cmos5l_mux4_1
XFILLER_527_129 VPWR VGND sg13cmos5l_fill_1
XFILLER_393_135 VPWR VGND sg13cmos5l_decap_8
X_3751_ AXI_M_SOC_ARADDR23 Tile_X0Y8_WW4END[7] Tile_X0Y8_WW4END[15] Tile_X0Y8_W6END[7]
+ _4807_/X _0489_/Q _0488_/Q VPWR VGND sg13cmos5l_mux4_1
XFILLER_657_63 VPWR VGND sg13cmos5l_decap_8
X_0963_ _0963_/Q Tile_X0Y0_FrameData[8] VGND VPWR Tile_X0Y9_FrameStrobe[0] latch
XFILLER_376_20 VPWR VGND sg13cmos5l_decap_8
XFILLER_229_14 VPWR VGND sg13cmos5l_decap_8
X_2702_ _4201_/A3 VPWR VGND sg13cmos5l_tielo
X_3682_ _3682_/X Tile_X0Y3_WW4END[0] Tile_X0Y3_WW4END[8] Tile_X0Y3_W6END[0] _4222_/X
+ _1757_/Q _1756_/Q VPWR VGND sg13cmos5l_mux4_1
X_0894_ _0894_/Q Tile_X0Y9_FrameData[1] VGND VPWR Tile_X0Y9_FrameStrobe[6] latch
XFILLER_145_113 VPWR VGND sg13cmos5l_decap_8
X_2633_ _2633_/Q Tile_X0Y6_FrameData[30] VGND VPWR Tile_X0Y9_FrameStrobe[6] latch
XANTENNA__2879__X Tile_X0Y6_FrameData_O[0] VPWR VGND sg13cmos5l_antennanp
XFILLER_245_13 VPWR VGND sg13cmos5l_decap_8
X_2564_ _2564_/Q Tile_X0Y6_FrameData[3] VGND VPWR Tile_X0Y9_FrameStrobe[3] latch
XFILLER_550_187 VPWR VGND sg13cmos5l_decap_8
X_4303_ _4303_/X _4305_/X Tile_X0Y4_W6END[1] _4304_/X _4303_/A3 _1931_/Q _1930_/Q
+ VPWR VGND sg13cmos5l_mux4_1
X_1515_ _1515_/Q Tile_X0Y2_FrameData[6] VGND VPWR Tile_X0Y9_FrameStrobe[2] latch
XFILLER_299_183 VPWR VGND sg13cmos5l_fill_2
X_2495_ _2495_/Q Tile_X0Y6_FrameData[8] VGND VPWR Tile_X0Y9_FrameStrobe[1] latch
XFILLER_59_119 VPWR VGND sg13cmos5l_decap_8
X_4234_ _4234_/X _4195_/X _0089_/X _4194_/X Tile_X0Y0_S4END[12] _1705_/Q _1704_/Q
+ VPWR VGND sg13cmos5l_mux4_1
X_1446_ _1446_/Q Tile_X0Y2_FrameData[11] VGND VPWR Tile_X0Y9_FrameStrobe[0] latch
XFILLER_302_176 VPWR VGND sg13cmos5l_decap_8
XFILLER_247_209 VPWR VGND sg13cmos5l_fill_1
XFILLER_652_217 VPWR VGND sg13cmos5l_fill_1
XFILLER_542_77 VPWR VGND sg13cmos5l_fill_2
X_4165_ _4165_/X Tile_X0Y3_WW4END[14] AXI_M_SOC_BVALID _4215_/X _4206_/X _1811_/Q
+ _1810_/Q VPWR VGND sg13cmos5l_mux4_1
X_1377_ _1377_/Q Tile_X0Y1_FrameData[24] VGND VPWR Tile_X0Y9_FrameStrobe[6] latch
XFILLER_605_100 VPWR VGND sg13cmos5l_decap_4
XFILLER_261_56 VPWR VGND sg13cmos5l_decap_8
XANTENNA__3503__X Tile_X0Y1_E2BEGb[1] VPWR VGND sg13cmos5l_antennanp
X_3116_ Tile_X0Y7_EE4BEG[2] _4630_/X VPWR VGND sg13cmos5l_buf_1
X_0328_ _0328_/Q Tile_X0Y7_FrameData[23] VGND VPWR Tile_X0Y9_FrameStrobe[5] latch
XFILLER_605_133 VPWR VGND sg13cmos5l_decap_4
X_4096_ _4096_/X _4035_/X _4143_/X _4142_/X _4034_/X _1435_/Q _1434_/Q VPWR VGND sg13cmos5l_mux4_1
XFILLER_404_206 VPWR VGND sg13cmos5l_decap_4
XFILLER_404_217 VPWR VGND sg13cmos5l_fill_1
X_3047_ Tile_X0Y5_FrameData_O[6] Tile_X0Y5_FrameData[6] VPWR VGND sg13cmos5l_buf_1
X_0259_ _0259_/Q Tile_X0Y7_FrameData[28] VGND VPWR Tile_X0Y9_FrameStrobe[3] latch
XFILLER_698_70 VPWR VGND sg13cmos5l_decap_8
XFILLER_620_136 VPWR VGND sg13cmos5l_decap_8
XFILLER_369_110 VPWR VGND sg13cmos5l_decap_8
XFILLER_130_49 VPWR VGND sg13cmos5l_decap_8
XFILLER_223_161 VPWR VGND sg13cmos5l_fill_2
XFILLER_369_165 VPWR VGND sg13cmos5l_fill_1
XFILLER_369_187 VPWR VGND sg13cmos5l_decap_8
XFILLER_23_14 VPWR VGND sg13cmos5l_decap_8
XFILLER_567_63 VPWR VGND sg13cmos5l_decap_8
X_3949_ _3949_/X Tile_X0Y1_WW4END[14] AXI_M_SOC_ARREADY _3999_/X _3990_/X _1311_/Q
+ _1310_/Q VPWR VGND sg13cmos5l_mux4_1
XFILLER_139_14 VPWR VGND sg13cmos5l_decap_8
XFILLER_526_140 VPWR VGND sg13cmos5l_fill_1
XFILLER_286_42 VPWR VGND sg13cmos5l_decap_8
XFILLER_384_179 VPWR VGND sg13cmos5l_decap_8
XFILLER_128_7 VPWR VGND sg13cmos5l_decap_8
XFILLER_717_44 VPWR VGND sg13cmos5l_decap_8
XFILLER_526_162 VPWR VGND sg13cmos5l_decap_8
XANTENNA__2789__X Tile_X0Y3_EE4BEG[15] VPWR VGND sg13cmos5l_antennanp
XFILLER_541_110 VPWR VGND sg13cmos5l_decap_8
XFILLER_436_34 VPWR VGND sg13cmos5l_decap_8
XFILLER_717_88 VPWR VGND sg13cmos5l_decap_8
XFILLER_136_168 VPWR VGND sg13cmos5l_decap_8
XFILLER_136_179 VPWR VGND sg13cmos5l_fill_2
XFILLER_583_84 VPWR VGND sg13cmos5l_decap_8
XFILLER_541_176 VPWR VGND sg13cmos5l_fill_1
XFILLER_2_137 VPWR VGND sg13cmos5l_decap_8
XFILLER_144_190 VPWR VGND sg13cmos5l_decap_8
XFILLER_439_114 VPWR VGND sg13cmos5l_decap_8
XFILLER_2_148 VPWR VGND sg13cmos5l_fill_1
XFILLER_497_7 VPWR VGND sg13cmos5l_decap_8
XFILLER_2_159 VPWR VGND sg13cmos5l_decap_4
XFILLER_48_22 VPWR VGND sg13cmos5l_decap_8
XFILLER_171_23 VPWR VGND sg13cmos5l_fill_1
XFILLER_664_7 VPWR VGND sg13cmos5l_decap_8
XFILLER_602_14 VPWR VGND sg13cmos5l_decap_8
XFILLER_58_152 VPWR VGND sg13cmos5l_decap_8
XFILLER_171_56 VPWR VGND sg13cmos5l_decap_8
XANTENNA__3413__X Tile_X0Y4_FrameData_O[4] VPWR VGND sg13cmos5l_antennanp
XFILLER_48_88 VPWR VGND sg13cmos5l_decap_8
XFILLER_104_61 VPWR VGND sg13cmos5l_decap_8
XFILLER_462_172 VPWR VGND sg13cmos5l_decap_8
XFILLER_206_139 VPWR VGND sg13cmos5l_fill_2
XFILLER_64_65 VPWR VGND sg13cmos5l_decap_8
XFILLER_14_211 VPWR VGND sg13cmos5l_fill_1
XFILLER_154_0 VPWR VGND sg13cmos5l_fill_2
XFILLER_80_20 VPWR VGND sg13cmos5l_decap_8
XFILLER_9_49 VPWR VGND sg13cmos5l_decap_8
XFILLER_120_71 VPWR VGND sg13cmos5l_decap_8
XFILLER_694_28 VPWR VGND sg13cmos5l_decap_8
XFILLER_80_53 VPWR VGND sg13cmos5l_decap_8
XFILLER_321_0 VPWR VGND sg13cmos5l_decap_8
XFILLER_196_20 VPWR VGND sg13cmos5l_decap_8
XFILLER_419_0 VPWR VGND sg13cmos5l_decap_8
XFILLER_390_105 VPWR VGND sg13cmos5l_fill_1
XFILLER_627_77 VPWR VGND sg13cmos5l_decap_8
XFILLER_532_121 VPWR VGND sg13cmos5l_decap_8
XFILLER_13_91 VPWR VGND sg13cmos5l_decap_8
XFILLER_127_146 VPWR VGND sg13cmos5l_fill_1
XFILLER_127_168 VPWR VGND sg13cmos5l_fill_2
XFILLER_678_136 VPWR VGND sg13cmos5l_decap_4
XFILLER_346_56 VPWR VGND sg13cmos5l_decap_8
XFILLER_493_84 VPWR VGND sg13cmos5l_decap_8
XFILLER_690_0 VPWR VGND sg13cmos5l_decap_8
XFILLER_643_21 VPWR VGND sg13cmos5l_decap_8
XFILLER_619_203 VPWR VGND sg13cmos5l_fill_1
XFILLER_686_180 VPWR VGND sg13cmos5l_fill_2
X_1300_ _1300_/Q Tile_X0Y1_FrameData[5] VGND VPWR Tile_X0Y9_FrameStrobe[3] latch
X_2280_ _2280_/Q Tile_X0Y5_FrameData[29] VGND VPWR Tile_X0Y9_FrameStrobe[3] latch
XFILLER_643_98 VPWR VGND sg13cmos5l_decap_8
XFILLER_215_49 VPWR VGND sg13cmos5l_decap_8
X_1231_ _1231_/Q Tile_X0Y1_FrameData[10] VGND VPWR Tile_X0Y9_FrameStrobe[1] latch
XFILLER_49_130 VPWR VGND sg13cmos5l_decap_4
XFILLER_445_128 VPWR VGND sg13cmos5l_fill_1
XFILLER_512_14 VPWR VGND sg13cmos5l_decap_8
XFILLER_49_141 VPWR VGND sg13cmos5l_decap_8
XFILLER_438_180 VPWR VGND sg13cmos5l_decap_8
XANTENNA__3323__X Tile_X0Y4_EE4BEG[11] VPWR VGND sg13cmos5l_antennanp
XFILLER_64_100 VPWR VGND sg13cmos5l_decap_8
X_1162_ _1162_/Q Tile_X0Y0_FrameData[1] VGND VPWR Tile_X0Y9_FrameStrobe[6] latch
XFILLER_453_150 VPWR VGND sg13cmos5l_decap_8
X_0113_ _3185_/A _3908_/X _3909_/X _1396_/Q VPWR VGND sg13cmos5l_mux2_1
X_1093_ _1093_/Q Tile_X0Y0_FrameData[6] VGND VPWR Tile_X0Y9_FrameStrobe[4] latch
XFILLER_602_114 VPWR VGND sg13cmos5l_fill_2
X_0044_ _3633_/A _4722_/X _4723_/X _0600_/Q VPWR VGND sg13cmos5l_mux2_1
X_4921_ _4921_/X Tile_X0Y9_N1END[1] Tile_X0Y9_N4END[1] _4897_/X _0082_/X _0717_/Q
+ _0716_/Q VPWR VGND sg13cmos5l_mux4_1
XFILLER_64_188 VPWR VGND sg13cmos5l_decap_8
XFILLER_602_158 VPWR VGND sg13cmos5l_decap_8
XFILLER_668_40 VPWR VGND sg13cmos5l_decap_8
XFILLER_205_161 VPWR VGND sg13cmos5l_decap_8
X_4852_ _4852_/X Tile_X0Y9_W2MID[3] AXI_M_SOC_RDATA4 _4907_/X _4906_/X _0839_/Q _0838_/Q
+ VPWR VGND sg13cmos5l_mux4_1
XFILLER_610_180 VPWR VGND sg13cmos5l_decap_4
X_3803_ _3803_/X _3851_/X Tile_X0Y0_WW4END[4] Tile_X0Y0_WW4END[5] Tile_X0Y0_S1END[3]
+ _1099_/Q _1098_/Q VPWR VGND sg13cmos5l_mux4_1
XFILLER_366_135 VPWR VGND sg13cmos5l_fill_2
X_4783_ _4783_/X Tile_X0Y9_W1END[3] Tile_X0Y9_W6END[7] _4931_/X _4895_/X _0921_/Q
+ _0920_/Q VPWR VGND sg13cmos5l_mux4_1
XFILLER_387_74 VPWR VGND sg13cmos5l_fill_2
X_1995_ _1995_/Q Tile_X0Y4_FrameData[26] VGND VPWR Tile_X0Y9_FrameStrobe[2] latch
XFILLER_165_208 VPWR VGND sg13cmos5l_decap_8
XFILLER_220_186 VPWR VGND sg13cmos5l_fill_1
X_3734_ AXI_M_SOC_ARADDR6 Tile_X0Y9_WW4END[6] Tile_X0Y9_WW4END[14] Tile_X0Y9_W6END[6]
+ _4922_/X _0747_/Q _0746_/Q VPWR VGND sg13cmos5l_mux4_1
X_0946_ _0946_/Q Tile_X0Y0_FrameData[25] VGND VPWR Tile_X0Y9_FrameStrobe[0] latch
XFILLER_381_116 VPWR VGND sg13cmos5l_decap_8
XFILLER_381_138 VPWR VGND sg13cmos5l_decap_4
XFILLER_508_184 VPWR VGND sg13cmos5l_decap_8
XFILLER_537_77 VPWR VGND sg13cmos5l_decap_4
X_3665_ AXI_M_SOC_AWADDR26 Tile_X0Y4_WW4END[2] Tile_X0Y4_WW4END[10] Tile_X0Y4_W6END[10]
+ _4346_/X _1993_/Q _1992_/Q VPWR VGND sg13cmos5l_mux4_1
X_0877_ _0877_/Q Tile_X0Y9_FrameData[18] VGND VPWR Tile_X0Y9_FrameStrobe[6] latch
XFILLER_109_39 VPWR VGND sg13cmos5l_decap_4
XFILLER_256_56 VPWR VGND sg13cmos5l_decap_8
XFILLER_669_136 VPWR VGND sg13cmos5l_fill_2
XFILLER_118_179 VPWR VGND sg13cmos5l_fill_1
X_2616_ _2616_/Q Tile_X0Y6_FrameData[15] VGND VPWR Tile_X0Y9_FrameStrobe[5] latch
X_3596_ Tile_X0Y9_FrameData_O[26] Tile_X0Y9_FrameData[26] VPWR VGND sg13cmos5l_buf_1
XFILLER_553_21 VPWR VGND sg13cmos5l_decap_8
XFILLER_523_187 VPWR VGND sg13cmos5l_decap_8
X_2547_ _2547_/Q Tile_X0Y6_FrameData[20] VGND VPWR Tile_X0Y9_FrameStrobe[3] latch
XFILLER_287_131 VPWR VGND sg13cmos5l_decap_8
XFILLER_553_98 VPWR VGND sg13cmos5l_decap_8
X_2478_ _2478_/Q Tile_X0Y6_FrameData[25] VGND VPWR Tile_X0Y9_FrameStrobe[1] latch
XFILLER_125_49 VPWR VGND sg13cmos5l_decap_8
XFILLER_703_35 VPWR VGND sg13cmos5l_decap_8
X_4217_ _4217_/X _4689_/X _4693_/X _4697_/X _4671_/X _0388_/Q _0387_/Q VPWR VGND sg13cmos5l_mux4_1
XFILLER_272_77 VPWR VGND sg13cmos5l_decap_8
X_1429_ _1429_/Q Tile_X0Y2_FrameData[28] VGND VPWR Tile_X0Y9_FrameStrobe[0] latch
XFILLER_422_14 VPWR VGND sg13cmos5l_decap_8
XANTENNA__3233__X Tile_X0Y0_FrameData_O[1] VPWR VGND sg13cmos5l_antennanp
XFILLER_18_14 VPWR VGND sg13cmos5l_decap_8
X_4148_ _4148_/X Tile_X0Y3_W2MID[7] AXI_M_SOC_WREADY _4205_/X _4204_/X _1845_/Q _1844_/Q
+ VPWR VGND sg13cmos5l_mux4_1
XFILLER_451_109 VPWR VGND sg13cmos5l_fill_1
XFILLER_243_201 VPWR VGND sg13cmos5l_decap_8
XFILLER_141_48 VPWR VGND sg13cmos5l_decap_8
X_4079_ _4079_/X AXI_M_SOC_AWREADY _4120_/X _4124_/X _4103_/X _1515_/Q _1514_/Q VPWR
+ VGND sg13cmos5l_mux4_1
XFILLER_502_91 VPWR VGND sg13cmos5l_decap_8
XFILLER_55_188 VPWR VGND sg13cmos5l_decap_8
XFILLER_34_13 VPWR VGND sg13cmos5l_decap_8
XFILLER_70_136 VPWR VGND sg13cmos5l_decap_8
XFILLER_578_84 VPWR VGND sg13cmos5l_decap_8
XFILLER_297_63 VPWR VGND sg13cmos5l_decap_8
XFILLER_238_6 VPWR VGND sg13cmos5l_decap_8
XFILLER_211_175 VPWR VGND sg13cmos5l_decap_8
XFILLER_357_168 VPWR VGND sg13cmos5l_decap_8
XFILLER_156_208 VPWR VGND sg13cmos5l_fill_2
XFILLER_211_186 VPWR VGND sg13cmos5l_fill_1
XFILLER_561_205 VPWR VGND sg13cmos5l_fill_1
XFILLER_412_7 VPWR VGND sg13cmos5l_decap_8
XFILLER_50_23 VPWR VGND sg13cmos5l_decap_8
XFILLER_372_138 VPWR VGND sg13cmos5l_decap_4
XFILLER_372_149 VPWR VGND sg13cmos5l_decap_8
XFILLER_109_168 VPWR VGND sg13cmos5l_decap_4
XANTENNA__3408__X Tile_X0Y2_E1BEG[3] VPWR VGND sg13cmos5l_antennanp
XFILLER_166_56 VPWR VGND sg13cmos5l_decap_8
XFILLER_124_105 VPWR VGND sg13cmos5l_decap_8
XFILLER_463_21 VPWR VGND sg13cmos5l_decap_8
XFILLER_380_193 VPWR VGND sg13cmos5l_decap_4
XFILLER_675_117 VPWR VGND sg13cmos5l_fill_1
XFILLER_117_190 VPWR VGND sg13cmos5l_decap_8
XFILLER_675_128 VPWR VGND sg13cmos5l_decap_8
XFILLER_59_54 VPWR VGND sg13cmos5l_fill_1
XFILLER_668_191 VPWR VGND sg13cmos5l_fill_2
XFILLER_132_171 VPWR VGND sg13cmos5l_decap_8
XFILLER_683_150 VPWR VGND sg13cmos5l_fill_2
XFILLER_613_35 VPWR VGND sg13cmos5l_decap_8
XFILLER_278_175 VPWR VGND sg13cmos5l_decap_8
XFILLER_182_55 VPWR VGND sg13cmos5l_decap_8
XFILLER_59_98 VPWR VGND sg13cmos5l_decap_8
XFILLER_332_14 VPWR VGND sg13cmos5l_decap_8
XANTENNA__3143__X Tile_X0Y7_FrameData_O[13] VPWR VGND sg13cmos5l_antennanp
XFILLER_75_20 VPWR VGND sg13cmos5l_decap_8
XFILLER_689_28 VPWR VGND sg13cmos5l_decap_8
XFILLER_46_111 VPWR VGND sg13cmos5l_fill_1
XFILLER_271_0 VPWR VGND sg13cmos5l_decap_8
XFILLER_369_0 VPWR VGND sg13cmos5l_decap_8
XANTENNA__2982__X Tile_X0Y8_FrameData_O[22] VPWR VGND sg13cmos5l_antennanp
XFILLER_648_2 VPWR VGND sg13cmos5l_fill_1
XFILLER_46_166 VPWR VGND sg13cmos5l_fill_2
XFILLER_412_91 VPWR VGND sg13cmos5l_decap_8
XFILLER_450_164 VPWR VGND sg13cmos5l_decap_8
XFILLER_61_158 VPWR VGND sg13cmos5l_decap_8
XFILLER_536_0 VPWR VGND sg13cmos5l_decap_8
XFILLER_199_171 VPWR VGND sg13cmos5l_decap_8
XFILLER_537_202 VPWR VGND sg13cmos5l_decap_4
XFILLER_488_84 VPWR VGND sg13cmos5l_decap_8
XFILLER_91_74 VPWR VGND sg13cmos5l_decap_8
XFILLER_199_193 VPWR VGND sg13cmos5l_decap_8
XFILLER_638_21 VPWR VGND sg13cmos5l_decap_8
XFILLER_703_0 VPWR VGND sg13cmos5l_decap_8
XFILLER_147_208 VPWR VGND sg13cmos5l_fill_1
X_0800_ _0800_/Q Tile_X0Y9_FrameData[31] VGND VPWR Tile_X0Y9_FrameStrobe[4] latch
X_1780_ _1780_/Q Tile_X0Y3_FrameData[21] VGND VPWR Tile_X0Y9_FrameStrobe[3] latch
XFILLER_638_98 VPWR VGND sg13cmos5l_decap_8
XFILLER_552_216 VPWR VGND sg13cmos5l_fill_2
X_0731_ _0731_/Q Tile_X0Y9_FrameData[4] VGND VPWR Tile_X0Y9_FrameStrobe[1] latch
XFILLER_357_77 VPWR VGND sg13cmos5l_decap_8
XFILLER_507_14 VPWR VGND sg13cmos5l_decap_8
XANTENNA__3318__X Tile_X0Y4_EE4BEG[6] VPWR VGND sg13cmos5l_antennanp
XFILLER_654_42 VPWR VGND sg13cmos5l_decap_8
X_3450_ Tile_X0Y1_FrameData_O[8] Tile_X0Y1_FrameData[8] VPWR VGND sg13cmos5l_buf_1
XFILLER_505_165 VPWR VGND sg13cmos5l_decap_8
XFILLER_371_160 VPWR VGND sg13cmos5l_fill_1
XFILLER_304_216 VPWR VGND sg13cmos5l_fill_2
X_0662_ _0662_/Q Tile_X0Y8_FrameData[9] VGND VPWR Tile_X0Y9_FrameStrobe[7] latch
XFILLER_373_21 VPWR VGND sg13cmos5l_decap_8
XFILLER_505_198 VPWR VGND sg13cmos5l_decap_4
X_2401_ _2401_/Q Tile_X0Y5_FrameData[4] VGND VPWR Tile_X0Y9_FrameStrobe[6] latch
X_3381_ Tile_X0Y2_E6BEG[4] _4076_/X VPWR VGND sg13cmos5l_buf_1
X_0593_ _0593_/Q Tile_X0Y8_FrameData[14] VGND VPWR Tile_X0Y9_FrameStrobe[5] latch
XFILLER_666_139 VPWR VGND sg13cmos5l_fill_2
XFILLER_130_119 VPWR VGND sg13cmos5l_decap_8
XFILLER_69_214 VPWR VGND sg13cmos5l_decap_4
XFILLER_269_142 VPWR VGND sg13cmos5l_decap_8
X_2332_ _2332_/Q Tile_X0Y5_FrameData[9] VGND VPWR Tile_X0Y9_FrameStrobe[4] latch
XFILLER_523_35 VPWR VGND sg13cmos5l_decap_8
XFILLER_674_150 VPWR VGND sg13cmos5l_fill_1
XFILLER_523_46 VPWR VGND sg13cmos5l_fill_2
XFILLER_284_112 VPWR VGND sg13cmos5l_decap_8
XFILLER_674_172 VPWR VGND sg13cmos5l_decap_8
XFILLER_670_63 VPWR VGND sg13cmos5l_decap_8
XFILLER_418_128 VPWR VGND sg13cmos5l_decap_8
X_2263_ _2263_/Q Tile_X0Y5_FrameData[14] VGND VPWR Tile_X0Y9_FrameStrobe[2] latch
XANTENNA__3053__X Tile_X0Y5_FrameData_O[12] VPWR VGND sg13cmos5l_antennanp
XFILLER_84_217 VPWR VGND sg13cmos5l_fill_1
X_4002_ _4002_/X _3983_/X _0096_/X _3982_/X Tile_X0Y0_S4END[5] _1207_/Q _1206_/Q VPWR
+ VGND sg13cmos5l_mux4_1
X_1214_ _1214_/Q Tile_X0Y1_FrameData[27] VGND VPWR Tile_X0Y9_FrameStrobe[1] latch
XFILLER_599_28 VPWR VGND sg13cmos5l_decap_8
X_2194_ _2194_/Q Tile_X0Y5_FrameData[19] VGND VPWR Tile_X0Y9_FrameStrobe[0] latch
XFILLER_225_201 VPWR VGND sg13cmos5l_fill_1
XFILLER_426_161 VPWR VGND sg13cmos5l_decap_8
XANTENNA__2892__X Tile_X0Y6_FrameData_O[13] VPWR VGND sg13cmos5l_antennanp
X_1145_ _1145_/Q Tile_X0Y0_FrameData[18] VGND VPWR Tile_X0Y9_FrameStrobe[6] latch
XFILLER_37_155 VPWR VGND sg13cmos5l_decap_8
XFILLER_37_166 VPWR VGND sg13cmos5l_fill_1
XFILLER_52_114 VPWR VGND sg13cmos5l_decap_8
X_1076_ _1076_/Q Tile_X0Y0_FrameData[23] VGND VPWR Tile_X0Y9_FrameStrobe[4] latch
XFILLER_240_215 VPWR VGND sg13cmos5l_fill_2
X_4904_ _4904_/X Tile_X0Y9_N2MID[5] Tile_X0Y9_N2END[5] _4937_/X _4821_/X _0685_/Q
+ _0684_/Q VPWR VGND sg13cmos5l_mux4_1
XFILLER_398_73 VPWR VGND sg13cmos5l_fill_2
XFILLER_339_113 VPWR VGND sg13cmos5l_decap_4
XFILLER_548_21 VPWR VGND sg13cmos5l_decap_8
X_4835_ _4835_/X Tile_X0Y9_W1END[3] Tile_X0Y9_W2MID[0] Tile_X0Y9_W2END[0] _4900_/X
+ _0869_/Q _0868_/Q VPWR VGND sg13cmos5l_mux4_1
XFILLER_354_105 VPWR VGND sg13cmos5l_decap_8
XFILLER_339_179 VPWR VGND sg13cmos5l_decap_4
X_4766_ _4766_/X AXI_M_SOC_RDATA10 _4805_/X _4809_/X _4789_/X _0515_/Q _0514_/Q VPWR
+ VGND sg13cmos5l_mux4_1
XFILLER_548_98 VPWR VGND sg13cmos5l_decap_8
X_1978_ _1978_/Q Tile_X0Y4_FrameData[11] VGND VPWR Tile_X0Y9_FrameStrobe[1] latch
X_3717_ AXI_M_SOC_WDATA27 Tile_X0Y6_WW4END[3] Tile_X0Y6_WW4END[11] Tile_X0Y6_W6END[11]
+ _4579_/X _2505_/Q _2504_/Q VPWR VGND sg13cmos5l_mux4_1
XFILLER_267_77 VPWR VGND sg13cmos5l_decap_8
X_0929_ _0929_/Q Tile_X0Y9_FrameData[20] VGND VPWR Tile_X0Y9_FrameStrobe[8] latch
XFILLER_417_14 VPWR VGND sg13cmos5l_decap_8
X_4697_ _4697_/X _4663_/X Tile_X0Y9_N4END[9] _4662_/X _0055_/X _0189_/Q _0188_/Q VPWR
+ VGND sg13cmos5l_mux4_1
XANTENNA__3228__X Tile_X0Y0_FrameStrobe_O[16] VPWR VGND sg13cmos5l_antennanp
XFILLER_564_42 VPWR VGND sg13cmos5l_decap_8
XFILLER_161_200 VPWR VGND sg13cmos5l_decap_8
X_3648_ AXI_M_SOC_AWADDR9 Tile_X0Y5_WW4END[1] Tile_X0Y5_WW4END[9] Tile_X0Y5_W6END[9]
+ _4460_/X _2253_/Q _2252_/Q VPWR VGND sg13cmos5l_mux4_1
XFILLER_161_211 VPWR VGND sg13cmos5l_fill_1
XFILLER_362_182 VPWR VGND sg13cmos5l_decap_8
XFILLER_283_21 VPWR VGND sg13cmos5l_decap_8
X_3579_ Tile_X0Y9_FrameData_O[9] Tile_X0Y9_FrameData[9] VPWR VGND sg13cmos5l_buf_1
XFILLER_511_157 VPWR VGND sg13cmos5l_decap_8
XFILLER_121_108 VPWR VGND sg13cmos5l_decap_8
XFILLER_714_56 VPWR VGND sg13cmos5l_decap_8
XFILLER_121_119 VPWR VGND sg13cmos5l_fill_1
XFILLER_283_98 VPWR VGND sg13cmos5l_decap_8
XFILLER_665_150 VPWR VGND sg13cmos5l_decap_4
XFILLER_433_35 VPWR VGND sg13cmos5l_decap_8
XFILLER_409_106 VPWR VGND sg13cmos5l_decap_8
XFILLER_29_13 VPWR VGND sg13cmos5l_decap_8
XFILLER_216_70 VPWR VGND sg13cmos5l_decap_8
XFILLER_275_112 VPWR VGND sg13cmos5l_decap_8
XFILLER_580_63 VPWR VGND sg13cmos5l_fill_2
XFILLER_152_14 VPWR VGND sg13cmos5l_decap_8
XFILLER_75_206 VPWR VGND sg13cmos5l_fill_1
XFILLER_195_7 VPWR VGND sg13cmos5l_decap_8
XFILLER_28_111 VPWR VGND sg13cmos5l_fill_2
XFILLER_680_153 VPWR VGND sg13cmos5l_decap_8
XFILLER_275_189 VPWR VGND sg13cmos5l_decap_8
XFILLER_290_126 VPWR VGND sg13cmos5l_fill_2
XFILLER_362_7 VPWR VGND sg13cmos5l_decap_8
XFILLER_302_28 VPWR VGND sg13cmos5l_decap_8
XFILLER_627_7 VPWR VGND sg13cmos5l_decap_8
XFILLER_593_127 VPWR VGND sg13cmos5l_decap_8
XFILLER_458_21 VPWR VGND sg13cmos5l_decap_8
XFILLER_101_73 VPWR VGND sg13cmos5l_decap_8
XFILLER_196_152 VPWR VGND sg13cmos5l_decap_4
XFILLER_345_105 VPWR VGND sg13cmos5l_decap_8
XFILLER_131_2 VPWR VGND sg13cmos5l_fill_1
XFILLER_61_88 VPWR VGND sg13cmos5l_decap_8
XFILLER_608_35 VPWR VGND sg13cmos5l_decap_8
XFILLER_6_28 VPWR VGND sg13cmos5l_decap_8
XFILLER_327_14 VPWR VGND sg13cmos5l_decap_8
XANTENNA__3138__X Tile_X0Y7_FrameData_O[8] VPWR VGND sg13cmos5l_antennanp
XFILLER_474_42 VPWR VGND sg13cmos5l_fill_2
XFILLER_117_0 VPWR VGND sg13cmos5l_decap_8
XFILLER_3_210 VPWR VGND sg13cmos5l_decap_8
XFILLER_298_215 VPWR VGND sg13cmos5l_fill_2
XFILLER_499_175 VPWR VGND sg13cmos5l_decap_8
XANTENNA__2977__X Tile_X0Y8_FrameData_O[17] VPWR VGND sg13cmos5l_antennanp
XFILLER_112_108 VPWR VGND sg13cmos5l_fill_1
XFILLER_624_56 VPWR VGND sg13cmos5l_decap_8
XFILLER_502_168 VPWR VGND sg13cmos5l_decap_8
XFILLER_193_76 VPWR VGND sg13cmos5l_decap_8
XFILLER_10_70 VPWR VGND sg13cmos5l_decap_8
XFILLER_105_182 VPWR VGND sg13cmos5l_fill_1
XFILLER_343_35 VPWR VGND sg13cmos5l_decap_8
XFILLER_486_0 VPWR VGND sg13cmos5l_decap_8
XFILLER_656_172 VPWR VGND sg13cmos5l_fill_1
XFILLER_490_63 VPWR VGND sg13cmos5l_decap_8
XFILLER_66_217 VPWR VGND sg13cmos5l_fill_1
XFILLER_120_174 VPWR VGND sg13cmos5l_decap_8
XFILLER_653_0 VPWR VGND sg13cmos5l_decap_8
XFILLER_281_126 VPWR VGND sg13cmos5l_decap_8
XFILLER_19_144 VPWR VGND sg13cmos5l_fill_1
XFILLER_640_77 VPWR VGND sg13cmos5l_decap_8
XANTENNA__3601__X Tile_X0Y9_FrameData_O[31] VPWR VGND sg13cmos5l_antennanp
XFILLER_34_125 VPWR VGND sg13cmos5l_decap_8
XFILLER_569_168 VPWR VGND sg13cmos5l_decap_8
XFILLER_649_42 VPWR VGND sg13cmos5l_decap_8
X_2950_ Tile_X0Y8_EE4BEG[6] _4750_/X VPWR VGND sg13cmos5l_buf_1
XFILLER_368_21 VPWR VGND sg13cmos5l_decap_8
X_1901_ _1901_/Q Tile_X0Y3_FrameData[28] VGND VPWR Tile_X0Y9_FrameStrobe[7] latch
X_2881_ Tile_X0Y6_FrameData_O[2] Tile_X0Y6_FrameData[2] VPWR VGND sg13cmos5l_buf_1
X_4620_ _4620_/X Tile_X0Y7_W2END[7] AXI_M_SOC_RDATA23 _4669_/X _4668_/X _0319_/Q _0318_/Q
+ VPWR VGND sg13cmos5l_mux4_1
X_1832_ _1832_/Q Tile_X0Y3_FrameData[1] VGND VPWR Tile_X0Y9_FrameStrobe[4] latch
XFILLER_336_116 VPWR VGND sg13cmos5l_fill_1
XFILLER_187_185 VPWR VGND sg13cmos5l_fill_1
XFILLER_518_35 VPWR VGND sg13cmos5l_decap_8
XFILLER_336_149 VPWR VGND sg13cmos5l_decap_8
X_4551_ _4551_/X Tile_X0Y7_W1END[3] Tile_X0Y7_W6END[7] _4699_/X _4659_/X _0409_/Q
+ _0408_/Q VPWR VGND sg13cmos5l_mux4_1
XFILLER_665_63 VPWR VGND sg13cmos5l_decap_8
XFILLER_329_190 VPWR VGND sg13cmos5l_decap_8
X_1763_ _1763_/Q Tile_X0Y3_FrameData[6] VGND VPWR Tile_X0Y9_FrameStrobe[2] latch
XFILLER_237_14 VPWR VGND sg13cmos5l_decap_8
XFILLER_540_208 VPWR VGND sg13cmos5l_decap_8
XANTENNA__3048__X Tile_X0Y5_FrameData_O[7] VPWR VGND sg13cmos5l_antennanp
X_3502_ Tile_X0Y1_E2BEGb[0] _3940_/X VPWR VGND sg13cmos5l_buf_1
XFILLER_351_119 VPWR VGND sg13cmos5l_decap_8
X_0714_ _0714_/Q Tile_X0Y9_FrameData[21] VGND VPWR Tile_X0Y9_FrameStrobe[1] latch
X_4482_ _4482_/X Tile_X0Y4_W1END[3] Tile_X0Y4_W2MID[0] Tile_X0Y4_W2END[0] _4312_/X
+ _2123_/Q _2122_/Q VPWR VGND sg13cmos5l_mux4_1
X_1694_ _1694_/Q Tile_X0Y3_FrameData[11] VGND VPWR Tile_X0Y9_FrameStrobe[0] latch
XFILLER_289_215 VPWR VGND sg13cmos5l_fill_2
X_3433_ Tile_X0Y4_FrameData_O[24] Tile_X0Y4_FrameData[24] VPWR VGND sg13cmos5l_buf_1
XANTENNA__2887__X Tile_X0Y6_FrameData_O[8] VPWR VGND sg13cmos5l_antennanp
X_0645_ _0645_/Q Tile_X0Y8_FrameData[26] VGND VPWR Tile_X0Y9_FrameStrobe[7] latch
X_3364_ Tile_X0Y2_EE4BEG[3] _4059_/X VPWR VGND sg13cmos5l_buf_1
X_0576_ _0576_/Q Tile_X0Y8_FrameData[31] VGND VPWR Tile_X0Y9_FrameStrobe[5] latch
XFILLER_253_35 VPWR VGND sg13cmos5l_decap_8
XFILLER_647_161 VPWR VGND sg13cmos5l_decap_8
XFILLER_446_212 VPWR VGND sg13cmos5l_decap_4
X_2315_ _2315_/Q Tile_X0Y5_FrameData[26] VGND VPWR Tile_X0Y9_FrameStrobe[4] latch
X_3295_ Tile_X0Y0_E2BEGb[3] _3815_/X VPWR VGND sg13cmos5l_buf_1
XFILLER_111_174 VPWR VGND sg13cmos5l_decap_8
XFILLER_662_142 VPWR VGND sg13cmos5l_fill_2
XFILLER_111_185 VPWR VGND sg13cmos5l_fill_1
X_2246_ _2246_/Q Tile_X0Y5_FrameData[31] VGND VPWR Tile_X0Y9_FrameStrobe[2] latch
XFILLER_406_109 VPWR VGND sg13cmos5l_fill_1
XFILLER_272_126 VPWR VGND sg13cmos5l_decap_8
XFILLER_72_209 VPWR VGND sg13cmos5l_decap_8
XFILLER_662_186 VPWR VGND sg13cmos5l_decap_4
XFILLER_700_14 VPWR VGND sg13cmos5l_decap_8
XFILLER_122_28 VPWR VGND sg13cmos5l_decap_8
X_2177_ _2177_/Q Tile_X0Y4_FrameData[4] VGND VPWR Tile_X0Y9_FrameStrobe[7] latch
XFILLER_272_159 VPWR VGND sg13cmos5l_fill_2
XANTENNA__3511__X Tile_X0Y1_E2BEG[1] VPWR VGND sg13cmos5l_antennanp
X_1128_ _1128_/Q Tile_X0Y0_FrameData[3] VGND VPWR Tile_X0Y9_FrameStrobe[5] latch
XFILLER_213_204 VPWR VGND sg13cmos5l_fill_2
XFILLER_25_158 VPWR VGND sg13cmos5l_decap_4
XFILLER_559_42 VPWR VGND sg13cmos5l_decap_8
XFILLER_575_105 VPWR VGND sg13cmos5l_decap_8
X_1059_ _1059_/Q Tile_X0Y0_FrameData[8] VGND VPWR Tile_X0Y9_FrameStrobe[3] latch
XFILLER_278_21 VPWR VGND sg13cmos5l_decap_8
XFILLER_568_190 VPWR VGND sg13cmos5l_decap_8
XFILLER_709_56 VPWR VGND sg13cmos5l_decap_8
XFILLER_717_154 VPWR VGND sg13cmos5l_decap_8
X_4818_ _4818_/X Tile_X0Y7_W2MID[5] Tile_X0Y7_W2END[5] Tile_X0Y7_W6END[10] _4673_/X
+ _0367_/Q _0366_/Q VPWR VGND sg13cmos5l_mux4_1
XFILLER_278_98 VPWR VGND sg13cmos5l_decap_8
XFILLER_717_187 VPWR VGND sg13cmos5l_fill_1
XFILLER_583_182 VPWR VGND sg13cmos5l_decap_8
XFILLER_428_35 VPWR VGND sg13cmos5l_decap_8
XFILLER_575_63 VPWR VGND sg13cmos5l_decap_8
XFILLER_147_14 VPWR VGND sg13cmos5l_decap_8
X_4749_ _4749_/X Tile_X0Y8_WW4END[10] AXI_M_SOC_RDATA13 _4810_/X _4789_/X _0549_/Q
+ _0548_/Q VPWR VGND sg13cmos5l_mux4_1
XFILLER_531_208 VPWR VGND sg13cmos5l_fill_1
XFILLER_342_119 VPWR VGND sg13cmos5l_fill_1
XFILLER_294_42 VPWR VGND sg13cmos5l_decap_8
XFILLER_110_7 VPWR VGND sg13cmos5l_decap_4
XFILLER_496_112 VPWR VGND sg13cmos5l_decap_8
XANTENNA__2797__X Tile_X0Y3_E6BEG[7] VPWR VGND sg13cmos5l_antennanp
XFILLER_444_56 VPWR VGND sg13cmos5l_fill_2
XFILLER_227_91 VPWR VGND sg13cmos5l_decap_8
XFILLER_0_213 VPWR VGND sg13cmos5l_decap_4
XFILLER_496_189 VPWR VGND sg13cmos5l_decap_8
XFILLER_577_7 VPWR VGND sg13cmos5l_decap_8
XFILLER_248_134 VPWR VGND sg13cmos5l_fill_2
XFILLER_248_178 VPWR VGND sg13cmos5l_decap_8
XFILLER_653_164 VPWR VGND sg13cmos5l_decap_8
XFILLER_610_14 VPWR VGND sg13cmos5l_decap_8
XANTENNA__3421__X Tile_X0Y4_FrameData_O[12] VPWR VGND sg13cmos5l_antennanp
XFILLER_56_88 VPWR VGND sg13cmos5l_decap_8
XFILLER_405_153 VPWR VGND sg13cmos5l_fill_1
XFILLER_16_125 VPWR VGND sg13cmos5l_fill_2
XFILLER_405_175 VPWR VGND sg13cmos5l_decap_8
XFILLER_72_21 VPWR VGND sg13cmos5l_decap_8
XFILLER_405_186 VPWR VGND sg13cmos5l_fill_2
XFILLER_566_105 VPWR VGND sg13cmos5l_decap_8
XFILLER_469_42 VPWR VGND sg13cmos5l_decap_4
XFILLER_188_21 VPWR VGND sg13cmos5l_decap_8
XFILLER_72_76 VPWR VGND sg13cmos5l_decap_8
XFILLER_234_0 VPWR VGND sg13cmos5l_decap_8
XFILLER_708_154 VPWR VGND sg13cmos5l_fill_2
XFILLER_619_56 VPWR VGND sg13cmos5l_decap_8
XFILLER_574_171 VPWR VGND sg13cmos5l_decap_8
XFILLER_338_35 VPWR VGND sg13cmos5l_decap_8
XFILLER_485_63 VPWR VGND sg13cmos5l_decap_8
XFILLER_401_0 VPWR VGND sg13cmos5l_decap_8
XFILLER_522_208 VPWR VGND sg13cmos5l_decap_4
XFILLER_635_77 VPWR VGND sg13cmos5l_decap_8
XFILLER_487_145 VPWR VGND sg13cmos5l_decap_8
XFILLER_354_56 VPWR VGND sg13cmos5l_decap_8
XFILLER_137_91 VPWR VGND sg13cmos5l_decap_8
X_0430_ _0430_/Q Tile_X0Y8_FrameData[17] VGND VPWR Tile_X0Y9_FrameStrobe[0] latch
XFILLER_487_167 VPWR VGND sg13cmos5l_fill_1
XFILLER_487_178 VPWR VGND sg13cmos5l_decap_4
XFILLER_651_21 VPWR VGND sg13cmos5l_decap_8
XFILLER_629_161 VPWR VGND sg13cmos5l_decap_8
X_0361_ _0361_/Q Tile_X0Y7_FrameData[22] VGND VPWR Tile_X0Y9_FrameStrobe[6] latch
XFILLER_239_134 VPWR VGND sg13cmos5l_decap_8
X_2100_ _2100_/Q Tile_X0Y4_FrameData[17] VGND VPWR Tile_X0Y9_FrameStrobe[5] latch
X_3080_ Tile_X0Y4_E2BEGb[6] _4270_/X VPWR VGND sg13cmos5l_buf_1
XFILLER_651_98 VPWR VGND sg13cmos5l_decap_8
X_0292_ _0292_/Q Tile_X0Y7_FrameData[27] VGND VPWR Tile_X0Y9_FrameStrobe[4] latch
XFILLER_254_115 VPWR VGND sg13cmos5l_decap_8
XFILLER_223_49 VPWR VGND sg13cmos5l_decap_8
XFILLER_644_175 VPWR VGND sg13cmos5l_decap_8
X_2031_ _2031_/Q Tile_X0Y4_FrameData[22] VGND VPWR Tile_X0Y9_FrameStrobe[3] latch
XFILLER_520_14 VPWR VGND sg13cmos5l_decap_8
XANTENNA__3331__X Tile_X0Y2_FrameData_O[2] VPWR VGND sg13cmos5l_antennanp
XFILLER_557_105 VPWR VGND sg13cmos5l_fill_2
X_3982_ _3982_/X Tile_X0Y0_W1END[1] Tile_X0Y0_W6END[9] _3871_/X _3860_/X _1139_/Q
+ _1138_/Q VPWR VGND sg13cmos5l_mux4_1
XFILLER_557_149 VPWR VGND sg13cmos5l_decap_8
XFILLER_94_2 VPWR VGND sg13cmos5l_fill_1
X_2933_ Tile_X0Y8_E6BEG[1] _4761_/X VPWR VGND sg13cmos5l_buf_1
XFILLER_411_189 VPWR VGND sg13cmos5l_decap_8
XFILLER_572_119 VPWR VGND sg13cmos5l_decap_8
XFILLER_529_56 VPWR VGND sg13cmos5l_decap_8
X_2864_ Tile_X0Y6_EE4BEG[1] _4513_/X VPWR VGND sg13cmos5l_buf_1
XFILLER_565_171 VPWR VGND sg13cmos5l_decap_8
XFILLER_248_35 VPWR VGND sg13cmos5l_decap_8
XFILLER_175_144 VPWR VGND sg13cmos5l_decap_8
X_1815_ _1815_/Q Tile_X0Y3_FrameData[18] VGND VPWR Tile_X0Y9_FrameStrobe[4] latch
X_4603_ _4603_/X _4689_/X _4693_/X _4697_/X _4672_/X _0352_/Q _0351_/Q VPWR VGND sg13cmos5l_mux4_1
X_2795_ Tile_X0Y3_E6BEG[5] _4185_/X VPWR VGND sg13cmos5l_buf_1
XFILLER_714_168 VPWR VGND sg13cmos5l_decap_8
XFILLER_324_119 VPWR VGND sg13cmos5l_decap_4
X_4534_ _4534_/X AXI_M_SOC_RDATA26 _4573_/X _4577_/X _4557_/X _2539_/Q _2538_/Q VPWR
+ VGND sg13cmos5l_mux4_1
X_1746_ _1746_/Q Tile_X0Y3_FrameData[23] VGND VPWR Tile_X0Y9_FrameStrobe[2] latch
XFILLER_545_77 VPWR VGND sg13cmos5l_decap_8
X_4465_ _4465_/X _4424_/X _0100_/X _4423_/X _0140_/X _2209_/Q _2208_/Q VPWR VGND sg13cmos5l_mux4_1
XFILLER_117_28 VPWR VGND sg13cmos5l_decap_8
X_1677_ _1677_/Q Tile_X0Y3_FrameData[28] VGND VPWR Tile_X0Y9_FrameStrobe[0] latch
XANTENNA__3506__X Tile_X0Y1_E2BEGb[4] VPWR VGND sg13cmos5l_antennanp
XFILLER_264_56 VPWR VGND sg13cmos5l_decap_8
X_3416_ Tile_X0Y4_FrameData_O[7] Tile_X0Y4_FrameData[7] VPWR VGND sg13cmos5l_buf_1
X_0628_ _0628_/Q Tile_X0Y8_FrameData[11] VGND VPWR Tile_X0Y9_FrameStrobe[6] latch
X_4396_ _4396_/X Tile_X0Y5_WW4END[7] AXI_M_SOC_RRESP1 _4458_/X _4428_/X _2311_/Q _2310_/Q
+ VPWR VGND sg13cmos5l_mux4_1
XFILLER_627_109 VPWR VGND sg13cmos5l_fill_1
XFILLER_561_21 VPWR VGND sg13cmos5l_decap_8
XFILLER_493_126 VPWR VGND sg13cmos5l_decap_8
X_3347_ Tile_X0Y2_FrameData_O[18] Tile_X0Y2_FrameData[18] VPWR VGND sg13cmos5l_buf_1
X_0559_ _0559_/Q Tile_X0Y8_FrameData[16] VGND VPWR Tile_X0Y9_FrameStrobe[4] latch
XFILLER_561_98 VPWR VGND sg13cmos5l_decap_8
X_3278_ Tile_X0Y0_EE4BEG[14] _3834_/X VPWR VGND sg13cmos5l_buf_1
XFILLER_133_49 VPWR VGND sg13cmos5l_decap_8
XFILLER_711_35 VPWR VGND sg13cmos5l_decap_8
XFILLER_650_112 VPWR VGND sg13cmos5l_decap_8
XFILLER_280_77 VPWR VGND sg13cmos5l_decap_8
X_2229_ _2229_/Q Tile_X0Y5_FrameData[16] VGND VPWR Tile_X0Y9_FrameStrobe[1] latch
XFILLER_430_14 VPWR VGND sg13cmos5l_decap_8
XANTENNA__3241__X Tile_X0Y0_FrameData_O[9] VPWR VGND sg13cmos5l_antennanp
XFILLER_26_14 VPWR VGND sg13cmos5l_decap_8
XFILLER_650_189 VPWR VGND sg13cmos5l_decap_8
XFILLER_289_42 VPWR VGND sg13cmos5l_decap_8
XFILLER_548_105 VPWR VGND sg13cmos5l_decap_8
XFILLER_158_7 VPWR VGND sg13cmos5l_decap_8
XFILLER_563_119 VPWR VGND sg13cmos5l_decap_4
XFILLER_439_56 VPWR VGND sg13cmos5l_decap_8
XFILLER_325_7 VPWR VGND sg13cmos5l_decap_8
XFILLER_556_193 VPWR VGND sg13cmos5l_fill_1
XFILLER_158_57 VPWR VGND sg13cmos5l_decap_8
XFILLER_181_103 VPWR VGND sg13cmos5l_fill_2
XFILLER_308_27 VPWR VGND sg13cmos5l_decap_8
XFILLER_571_196 VPWR VGND sg13cmos5l_fill_2
XFILLER_323_130 VPWR VGND sg13cmos5l_fill_1
XFILLER_694_7 VPWR VGND sg13cmos5l_decap_8
XFILLER_605_14 VPWR VGND sg13cmos5l_decap_8
XFILLER_469_134 VPWR VGND sg13cmos5l_fill_2
XFILLER_323_163 VPWR VGND sg13cmos5l_fill_1
XANTENNA__3416__X Tile_X0Y4_FrameData_O[7] VPWR VGND sg13cmos5l_antennanp
XFILLER_484_104 VPWR VGND sg13cmos5l_decap_8
XFILLER_673_204 VPWR VGND sg13cmos5l_fill_1
XFILLER_471_21 VPWR VGND sg13cmos5l_decap_8
XFILLER_469_189 VPWR VGND sg13cmos5l_decap_8
XFILLER_67_10 VPWR VGND sg13cmos5l_decap_8
XFILLER_107_83 VPWR VGND sg13cmos5l_decap_8
XFILLER_236_104 VPWR VGND sg13cmos5l_decap_8
XFILLER_67_87 VPWR VGND sg13cmos5l_decap_8
XFILLER_626_164 VPWR VGND sg13cmos5l_fill_1
XFILLER_621_35 VPWR VGND sg13cmos5l_decap_8
XFILLER_404_70 VPWR VGND sg13cmos5l_decap_8
XFILLER_641_112 VPWR VGND sg13cmos5l_decap_8
XFILLER_190_77 VPWR VGND sg13cmos5l_decap_8
XFILLER_184_0 VPWR VGND sg13cmos5l_decap_8
XFILLER_36_209 VPWR VGND sg13cmos5l_fill_1
XFILLER_236_148 VPWR VGND sg13cmos5l_fill_1
XFILLER_340_14 VPWR VGND sg13cmos5l_decap_8
XANTENNA__3151__X Tile_X0Y7_FrameData_O[21] VPWR VGND sg13cmos5l_antennanp
XFILLER_123_71 VPWR VGND sg13cmos5l_decap_8
XFILLER_697_28 VPWR VGND sg13cmos5l_decap_8
XFILLER_83_64 VPWR VGND sg13cmos5l_decap_8
XFILLER_351_0 VPWR VGND sg13cmos5l_decap_8
XFILLER_189_203 VPWR VGND sg13cmos5l_decap_8
XFILLER_449_0 VPWR VGND sg13cmos5l_decap_8
XFILLER_199_42 VPWR VGND sg13cmos5l_decap_8
XANTENNA__2990__X Tile_X0Y8_FrameData_O[30] VPWR VGND sg13cmos5l_antennanp
XFILLER_420_91 VPWR VGND sg13cmos5l_decap_8
XFILLER_616_0 VPWR VGND sg13cmos5l_decap_8
XFILLER_349_56 VPWR VGND sg13cmos5l_decap_8
XFILLER_547_171 VPWR VGND sg13cmos5l_fill_2
XFILLER_496_84 VPWR VGND sg13cmos5l_decap_8
XFILLER_646_21 VPWR VGND sg13cmos5l_decap_8
XFILLER_73_7 VPWR VGND sg13cmos5l_decap_8
X_1600_ _1600_/Q Tile_X0Y2_FrameData[17] VGND VPWR Tile_X0Y9_FrameStrobe[5] latch
XFILLER_157_199 VPWR VGND sg13cmos5l_fill_1
XFILLER_711_105 VPWR VGND sg13cmos5l_decap_8
X_2580_ _2580_/Q Tile_X0Y6_FrameData[19] VGND VPWR Tile_X0Y9_FrameStrobe[4] latch
XFILLER_646_98 VPWR VGND sg13cmos5l_decap_8
XFILLER_562_196 VPWR VGND sg13cmos5l_decap_8
XFILLER_218_49 VPWR VGND sg13cmos5l_decap_8
X_1531_ _1531_/Q Tile_X0Y2_FrameData[22] VGND VPWR Tile_X0Y9_FrameStrobe[3] latch
XFILLER_365_77 VPWR VGND sg13cmos5l_fill_2
XFILLER_515_14 VPWR VGND sg13cmos5l_decap_8
XANTENNA__3326__X Tile_X0Y4_EE4BEG[14] VPWR VGND sg13cmos5l_antennanp
XFILLER_662_42 VPWR VGND sg13cmos5l_decap_8
X_4250_ _4250_/X Tile_X0Y2_W1END[3] Tile_X0Y2_W2MID[0] Tile_X0Y2_W2END[0] _4096_/X
+ _1615_/Q _1614_/Q VPWR VGND sg13cmos5l_mux4_1
X_1462_ _1462_/Q Tile_X0Y2_FrameData[27] VGND VPWR Tile_X0Y9_FrameStrobe[1] latch
XFILLER_381_21 VPWR VGND sg13cmos5l_decap_8
X_3201_ Tile_X0Y0_N2BEG[1] _3785_/X VPWR VGND sg13cmos5l_buf_1
X_0413_ _0413_/Q Tile_X0Y7_FrameData[2] VGND VPWR Tile_X0Y9_FrameStrobe[7] latch
X_4181_ _4181_/X _0088_/X Tile_X0Y0_S4END[13] _4232_/X _4215_/X _1779_/Q _1778_/Q
+ VPWR VGND sg13cmos5l_mux4_1
X_1393_ _1393_/Q Tile_X0Y1_FrameData[8] VGND VPWR Tile_X0Y9_FrameStrobe[6] latch
XFILLER_617_120 VPWR VGND sg13cmos5l_decap_4
X_3132_ Tile_X0Y7_FrameData_O[2] Tile_X0Y7_FrameData[2] VPWR VGND sg13cmos5l_buf_1
X_0344_ _0344_/Q Tile_X0Y7_FrameData[7] VGND VPWR Tile_X0Y9_FrameStrobe[5] latch
XFILLER_416_204 VPWR VGND sg13cmos5l_fill_2
XFILLER_531_35 VPWR VGND sg13cmos5l_decap_8
XFILLER_227_126 VPWR VGND sg13cmos5l_decap_8
XFILLER_632_112 VPWR VGND sg13cmos5l_decap_8
XFILLER_27_209 VPWR VGND sg13cmos5l_fill_2
X_3063_ Tile_X0Y5_FrameData_O[22] Tile_X0Y5_FrameData[22] VPWR VGND sg13cmos5l_buf_1
XFILLER_250_14 VPWR VGND sg13cmos5l_decap_8
X_0275_ _0275_/Q Tile_X0Y7_FrameData[12] VGND VPWR Tile_X0Y9_FrameStrobe[3] latch
XANTENNA__3061__X Tile_X0Y5_FrameData_O[20] VPWR VGND sg13cmos5l_antennanp
X_2014_ _2014_/Q Tile_X0Y4_FrameData[7] VGND VPWR Tile_X0Y9_FrameStrobe[2] latch
XFILLER_400_28 VPWR VGND sg13cmos5l_decap_8
X_3965_ _3965_/X _0096_/X Tile_X0Y0_S4END[5] _4018_/X _3999_/X _1279_/Q _1278_/Q VPWR
+ VGND sg13cmos5l_mux4_1
XFILLER_250_195 VPWR VGND sg13cmos5l_decap_8
XFILLER_259_56 VPWR VGND sg13cmos5l_decap_8
X_2916_ Tile_X0Y8_E2BEG[0] _4728_/X VPWR VGND sg13cmos5l_buf_1
X_3896_ _3896_/X Tile_X0Y2_W2MID[3] Tile_X0Y2_W2END[3] Tile_X0Y2_W6END[3] _4102_/X
+ _1657_/Q _1656_/Q VPWR VGND sg13cmos5l_mux4_1
XFILLER_556_21 VPWR VGND sg13cmos5l_decap_8
XFILLER_148_155 VPWR VGND sg13cmos5l_fill_1
X_2847_ Tile_X0Y6_E2BEGb[4] _4508_/X VPWR VGND sg13cmos5l_buf_1
XFILLER_699_134 VPWR VGND sg13cmos5l_decap_4
XFILLER_148_177 VPWR VGND sg13cmos5l_decap_4
XFILLER_12_49 VPWR VGND sg13cmos5l_decap_8
XFILLER_702_105 VPWR VGND sg13cmos5l_decap_8
X_2778_ Tile_X0Y3_EE4BEG[4] _4168_/X VPWR VGND sg13cmos5l_buf_1
XFILLER_556_98 VPWR VGND sg13cmos5l_decap_8
XFILLER_128_49 VPWR VGND sg13cmos5l_decap_8
XFILLER_706_35 VPWR VGND sg13cmos5l_decap_8
XFILLER_699_189 VPWR VGND sg13cmos5l_fill_1
XFILLER_275_77 VPWR VGND sg13cmos5l_decap_8
X_1729_ _1729_/Q Tile_X0Y3_FrameData[8] VGND VPWR Tile_X0Y9_FrameStrobe[1] latch
X_4517_ _4517_/X Tile_X0Y6_WW4END[10] AXI_M_SOC_RDATA29 _4578_/X _4557_/X _2573_/Q
+ _2572_/Q VPWR VGND sg13cmos5l_mux4_1
XFILLER_425_14 VPWR VGND sg13cmos5l_decap_8
XANTENNA__3236__X Tile_X0Y0_FrameData_O[4] VPWR VGND sg13cmos5l_antennanp
XFILLER_572_42 VPWR VGND sg13cmos5l_decap_8
X_4448_ _4448_/X _4015_/X _4019_/X _3996_/X _3988_/X _1356_/Q _1355_/Q VPWR VGND sg13cmos5l_mux4_1
XFILLER_710_182 VPWR VGND sg13cmos5l_decap_8
XFILLER_291_21 VPWR VGND sg13cmos5l_decap_8
XFILLER_710_193 VPWR VGND sg13cmos5l_fill_2
XFILLER_144_48 VPWR VGND sg13cmos5l_decap_8
X_4379_ _4379_/X Tile_X0Y5_W2MID[0] AXI_M_SOC_RRESP1 _4467_/X _4428_/X _2345_/Q _2344_/Q
+ VPWR VGND sg13cmos5l_mux4_1
XFILLER_144_59 VPWR VGND sg13cmos5l_fill_2
XFILLER_320_188 VPWR VGND sg13cmos5l_decap_8
XFILLER_505_91 VPWR VGND sg13cmos5l_decap_4
XFILLER_291_98 VPWR VGND sg13cmos5l_fill_2
XFILLER_441_35 VPWR VGND sg13cmos5l_decap_8
XFILLER_37_13 VPWR VGND sg13cmos5l_decap_8
XFILLER_474_192 VPWR VGND sg13cmos5l_decap_8
XFILLER_275_7 VPWR VGND sg13cmos5l_decap_8
XFILLER_160_25 VPWR VGND sg13cmos5l_decap_8
XFILLER_37_68 VPWR VGND sg13cmos5l_decap_4
XFILLER_422_207 VPWR VGND sg13cmos5l_fill_2
XFILLER_442_7 VPWR VGND sg13cmos5l_decap_8
XFILLER_310_28 VPWR VGND sg13cmos5l_fill_2
XFILLER_387_122 VPWR VGND sg13cmos5l_decap_8
XFILLER_53_45 VPWR VGND sg13cmos5l_decap_8
XFILLER_387_144 VPWR VGND sg13cmos5l_fill_2
XFILLER_186_206 VPWR VGND sg13cmos5l_fill_2
XFILLER_169_56 VPWR VGND sg13cmos5l_decap_8
XFILLER_387_199 VPWR VGND sg13cmos5l_decap_8
XFILLER_707_7 VPWR VGND sg13cmos5l_decap_8
XFILLER_466_21 VPWR VGND sg13cmos5l_decap_8
XFILLER_139_133 VPWR VGND sg13cmos5l_decap_8
XFILLER_319_37 VPWR VGND sg13cmos5l_fill_1
XFILLER_319_59 VPWR VGND sg13cmos5l_decap_8
XFILLER_544_185 VPWR VGND sg13cmos5l_decap_8
XFILLER_616_35 VPWR VGND sg13cmos5l_decap_8
XFILLER_185_77 VPWR VGND sg13cmos5l_decap_8
XFILLER_335_14 VPWR VGND sg13cmos5l_decap_8
XANTENNA__3146__X Tile_X0Y7_FrameData_O[16] VPWR VGND sg13cmos5l_antennanp
XFILLER_482_42 VPWR VGND sg13cmos5l_decap_8
XFILLER_701_160 VPWR VGND sg13cmos5l_decap_8
XFILLER_457_104 VPWR VGND sg13cmos5l_fill_1
XFILLER_311_122 VPWR VGND sg13cmos5l_decap_4
XFILLER_311_133 VPWR VGND sg13cmos5l_decap_8
XFILLER_399_0 VPWR VGND sg13cmos5l_decap_8
XANTENNA__2985__X Tile_X0Y8_FrameData_O[25] VPWR VGND sg13cmos5l_antennanp
XFILLER_632_56 VPWR VGND sg13cmos5l_decap_8
XFILLER_415_91 VPWR VGND sg13cmos5l_decap_8
XFILLER_472_129 VPWR VGND sg13cmos5l_decap_8
XFILLER_351_35 VPWR VGND sg13cmos5l_decap_8
XFILLER_134_70 VPWR VGND sg13cmos5l_decap_8
XFILLER_209_126 VPWR VGND sg13cmos5l_decap_8
XFILLER_566_0 VPWR VGND sg13cmos5l_decap_8
XFILLER_94_63 VPWR VGND sg13cmos5l_decap_8
X_0060_ _3177_/A _3924_/X _3925_/X _1896_/Q VPWR VGND sg13cmos5l_mux2_1
XFILLER_501_49 VPWR VGND sg13cmos5l_decap_8
XFILLER_224_129 VPWR VGND sg13cmos5l_fill_1
XFILLER_217_181 VPWR VGND sg13cmos5l_decap_4
XFILLER_91_178 VPWR VGND sg13cmos5l_decap_8
XFILLER_27_90 VPWR VGND sg13cmos5l_decap_4
XFILLER_220_28 VPWR VGND sg13cmos5l_decap_8
XFILLER_177_217 VPWR VGND sg13cmos5l_fill_1
XFILLER_657_42 VPWR VGND sg13cmos5l_decap_8
XFILLER_393_114 VPWR VGND sg13cmos5l_decap_8
X_3750_ AXI_M_SOC_ARADDR22 Tile_X0Y8_WW4END[6] Tile_X0Y8_WW4END[14] Tile_X0Y8_W6END[6]
+ _4806_/X _0491_/Q _0490_/Q VPWR VGND sg13cmos5l_mux4_1
X_0962_ _0962_/Q Tile_X0Y0_FrameData[9] VGND VPWR Tile_X0Y9_FrameStrobe[0] latch
X_2701_ _4084_/A3 VPWR VGND sg13cmos5l_tielo
X_3681_ _3681_/X Tile_X0Y2_WW4END[3] Tile_X0Y2_WW4END[11] Tile_X0Y2_W6END[11] _4127_/X
+ _1483_/Q _1482_/Q VPWR VGND sg13cmos5l_mux4_1
X_0893_ _0893_/Q Tile_X0Y9_FrameData[2] VGND VPWR Tile_X0Y9_FrameStrobe[6] latch
X_2632_ _2632_/Q Tile_X0Y6_FrameData[31] VGND VPWR Tile_X0Y9_FrameStrobe[6] latch
XFILLER_145_136 VPWR VGND sg13cmos5l_fill_1
XFILLER_526_35 VPWR VGND sg13cmos5l_decap_8
X_2563_ _2563_/Q Tile_X0Y6_FrameData[4] VGND VPWR Tile_X0Y9_FrameStrobe[3] latch
XFILLER_673_63 VPWR VGND sg13cmos5l_decap_8
XANTENNA__3056__X Tile_X0Y5_FrameData_O[15] VPWR VGND sg13cmos5l_antennanp
XFILLER_392_42 VPWR VGND sg13cmos5l_decap_8
X_1514_ _1514_/Q Tile_X0Y2_FrameData[7] VGND VPWR Tile_X0Y9_FrameStrobe[2] latch
X_4302_ _4302_/X Tile_X0Y5_W1END[0] Tile_X0Y5_W6END[4] _4463_/X _4416_/X _2439_/Q
+ _2438_/Q VPWR VGND sg13cmos5l_mux4_1
XFILLER_392_64 VPWR VGND sg13cmos5l_decap_8
XFILLER_153_191 VPWR VGND sg13cmos5l_decap_8
X_2494_ _2494_/Q Tile_X0Y6_FrameData[9] VGND VPWR Tile_X0Y9_FrameStrobe[1] latch
XFILLER_302_122 VPWR VGND sg13cmos5l_decap_8
XFILLER_302_133 VPWR VGND sg13cmos5l_fill_2
X_4233_ _4233_/X _4203_/X _0046_/X _4202_/X Tile_X0Y0_S4END[15] _1707_/Q _1706_/Q
+ VPWR VGND sg13cmos5l_mux4_1
X_1445_ _1445_/Q Tile_X0Y2_FrameData[12] VGND VPWR Tile_X0Y9_FrameStrobe[0] latch
XFILLER_101_206 VPWR VGND sg13cmos5l_fill_1
XANTENNA__2895__X Tile_X0Y6_FrameData_O[16] VPWR VGND sg13cmos5l_antennanp
XFILLER_448_159 VPWR VGND sg13cmos5l_decap_4
XFILLER_325_91 VPWR VGND sg13cmos5l_decap_8
X_4164_ _4164_/X Tile_X0Y3_WW4END[15] AXI_M_SOC_WREADY _4212_/X _4204_/X _1813_/Q
+ _1812_/Q VPWR VGND sg13cmos5l_mux4_1
X_1376_ _1376_/Q Tile_X0Y1_FrameData[25] VGND VPWR Tile_X0Y9_FrameStrobe[6] latch
XFILLER_261_35 VPWR VGND sg13cmos5l_decap_8
XFILLER_456_181 VPWR VGND sg13cmos5l_decap_8
X_3115_ Tile_X0Y7_EE4BEG[1] _4629_/X VPWR VGND sg13cmos5l_buf_1
X_0327_ _0327_/Q Tile_X0Y7_FrameData[24] VGND VPWR Tile_X0Y9_FrameStrobe[5] latch
X_4095_ _4095_/X Tile_X0Y3_W1END[3] Tile_X0Y3_W6END[7] _4212_/X _4193_/X _1919_/Q
+ _1918_/Q VPWR VGND sg13cmos5l_mux4_1
XFILLER_67_197 VPWR VGND sg13cmos5l_fill_1
X_3046_ Tile_X0Y5_FrameData_O[5] Tile_X0Y5_FrameData[5] VPWR VGND sg13cmos5l_buf_1
X_0258_ _0258_/Q Tile_X0Y7_FrameData[29] VGND VPWR Tile_X0Y9_FrameStrobe[3] latch
XFILLER_411_49 VPWR VGND sg13cmos5l_decap_8
XFILLER_130_28 VPWR VGND sg13cmos5l_decap_8
X_0189_ _0189_/Q Tile_X0Y7_FrameData[2] VGND VPWR Tile_X0Y9_FrameStrobe[0] latch
XFILLER_223_184 VPWR VGND sg13cmos5l_decap_8
XFILLER_573_203 VPWR VGND sg13cmos5l_decap_4
XFILLER_384_103 VPWR VGND sg13cmos5l_fill_1
XFILLER_567_42 VPWR VGND sg13cmos5l_decap_8
XFILLER_210_83 VPWR VGND sg13cmos5l_decap_8
X_3948_ _3948_/X Tile_X0Y1_WW4END[15] AXI_M_SOC_ARREADY _3996_/X _3988_/X _1313_/Q
+ _1312_/Q VPWR VGND sg13cmos5l_mux4_1
XFILLER_286_21 VPWR VGND sg13cmos5l_decap_8
XFILLER_384_158 VPWR VGND sg13cmos5l_decap_8
X_3879_ _3879_/X _3851_/X _0078_/X Tile_X0Y0_S1END[3] Tile_X0Y0_S4END[3] _0981_/Q
+ _0980_/Q VPWR VGND sg13cmos5l_mux4_1
XFILLER_526_185 VPWR VGND sg13cmos5l_decap_8
XFILLER_436_13 VPWR VGND sg13cmos5l_decap_8
XFILLER_286_98 VPWR VGND sg13cmos5l_fill_1
XFILLER_136_147 VPWR VGND sg13cmos5l_decap_8
XFILLER_687_115 VPWR VGND sg13cmos5l_fill_1
XFILLER_583_63 VPWR VGND sg13cmos5l_decap_8
XFILLER_541_155 VPWR VGND sg13cmos5l_decap_8
XFILLER_155_14 VPWR VGND sg13cmos5l_decap_8
XFILLER_340_217 VPWR VGND sg13cmos5l_fill_1
XFILLER_2_116 VPWR VGND sg13cmos5l_decap_8
XFILLER_541_188 VPWR VGND sg13cmos5l_decap_8
XFILLER_541_199 VPWR VGND sg13cmos5l_fill_1
XFILLER_3_7 VPWR VGND sg13cmos5l_decap_8
XANTENNA__0102__Y AXI_M_SOC_ARLEN5 VPWR VGND sg13cmos5l_antennanp
XFILLER_439_148 VPWR VGND sg13cmos5l_decap_8
XFILLER_392_7 VPWR VGND sg13cmos5l_decap_8
XFILLER_452_56 VPWR VGND sg13cmos5l_decap_4
XFILLER_58_131 VPWR VGND sg13cmos5l_decap_8
XFILLER_246_210 VPWR VGND sg13cmos5l_fill_2
XFILLER_171_35 VPWR VGND sg13cmos5l_decap_8
XFILLER_48_78 VPWR VGND sg13cmos5l_fill_2
XFILLER_657_7 VPWR VGND sg13cmos5l_decap_8
XFILLER_104_40 VPWR VGND sg13cmos5l_decap_8
XFILLER_261_202 VPWR VGND sg13cmos5l_fill_2
XFILLER_73_134 VPWR VGND sg13cmos5l_decap_8
XFILLER_206_118 VPWR VGND sg13cmos5l_decap_8
XFILLER_64_44 VPWR VGND sg13cmos5l_decap_8
XFILLER_611_115 VPWR VGND sg13cmos5l_decap_8
XFILLER_401_60 VPWR VGND sg13cmos5l_fill_2
XFILLER_159_206 VPWR VGND sg13cmos5l_decap_4
XFILLER_159_217 VPWR VGND sg13cmos5l_fill_1
XFILLER_9_28 VPWR VGND sg13cmos5l_decap_8
XFILLER_477_42 VPWR VGND sg13cmos5l_decap_8
XFILLER_147_0 VPWR VGND sg13cmos5l_decap_8
XFILLER_477_53 VPWR VGND sg13cmos5l_fill_1
XFILLER_120_94 VPWR VGND sg13cmos5l_decap_8
XFILLER_477_75 VPWR VGND sg13cmos5l_fill_2
XFILLER_390_117 VPWR VGND sg13cmos5l_decap_8
XFILLER_314_0 VPWR VGND sg13cmos5l_decap_8
XFILLER_196_76 VPWR VGND sg13cmos5l_decap_8
XFILLER_627_56 VPWR VGND sg13cmos5l_decap_8
XFILLER_532_100 VPWR VGND sg13cmos5l_decap_8
XFILLER_13_70 VPWR VGND sg13cmos5l_decap_8
XFILLER_346_35 VPWR VGND sg13cmos5l_decap_8
XFILLER_493_63 VPWR VGND sg13cmos5l_decap_8
XFILLER_142_106 VPWR VGND sg13cmos5l_fill_2
XFILLER_50_9 VPWR VGND sg13cmos5l_decap_8
XFILLER_331_217 VPWR VGND sg13cmos5l_fill_1
XFILLER_135_180 VPWR VGND sg13cmos5l_fill_1
XFILLER_683_0 VPWR VGND sg13cmos5l_decap_8
XFILLER_643_77 VPWR VGND sg13cmos5l_decap_8
XFILLER_36_7 VPWR VGND sg13cmos5l_decap_8
XFILLER_215_28 VPWR VGND sg13cmos5l_decap_8
XFILLER_150_183 VPWR VGND sg13cmos5l_decap_8
XANTENNA__3604__X Tile_X0Y9_S1BEG[2] VPWR VGND sg13cmos5l_antennanp
XFILLER_362_56 VPWR VGND sg13cmos5l_fill_2
X_1230_ _1230_/Q Tile_X0Y1_FrameData[11] VGND VPWR Tile_X0Y9_FrameStrobe[1] latch
XFILLER_296_187 VPWR VGND sg13cmos5l_decap_8
XFILLER_29_6 VPWR VGND sg13cmos5l_decap_8
XFILLER_438_192 VPWR VGND sg13cmos5l_fill_2
X_1161_ _1161_/Q Tile_X0Y0_FrameData[2] VGND VPWR Tile_X0Y9_FrameStrobe[6] latch
XFILLER_599_122 VPWR VGND sg13cmos5l_decap_4
X_0112_ _0112_/X _4320_/X _4321_/X _1115_/Q VPWR VGND sg13cmos5l_mux2_1
XFILLER_599_144 VPWR VGND sg13cmos5l_decap_4
XFILLER_599_155 VPWR VGND sg13cmos5l_decap_4
X_1092_ _1092_/Q Tile_X0Y0_FrameData[7] VGND VPWR Tile_X0Y9_FrameStrobe[4] latch
XFILLER_599_166 VPWR VGND sg13cmos5l_decap_4
XFILLER_64_156 VPWR VGND sg13cmos5l_fill_1
XFILLER_398_217 VPWR VGND sg13cmos5l_fill_1
XFILLER_64_167 VPWR VGND sg13cmos5l_decap_8
XFILLER_599_177 VPWR VGND sg13cmos5l_decap_4
X_0043_ _3632_/A _4720_/X _4721_/X _0603_/Q VPWR VGND sg13cmos5l_mux2_1
X_4920_ _4920_/X Tile_X0Y9_N1END[0] Tile_X0Y9_N4END[0] _4896_/X _0083_/X _0719_/Q
+ _0718_/Q VPWR VGND sg13cmos5l_mux4_1
XFILLER_205_140 VPWR VGND sg13cmos5l_decap_8
XFILLER_311_60 VPWR VGND sg13cmos5l_decap_8
XFILLER_311_82 VPWR VGND sg13cmos5l_decap_8
X_4851_ _4851_/X Tile_X0Y9_W2MID[4] AXI_M_SOC_RDATA3 _4907_/X _4906_/X _0841_/Q _0840_/Q
+ VPWR VGND sg13cmos5l_mux4_1
XFILLER_205_195 VPWR VGND sg13cmos5l_decap_8
XFILLER_387_42 VPWR VGND sg13cmos5l_decap_4
X_3802_ _3802_/X _3850_/X Tile_X0Y0_W2END[6] Tile_X0Y0_W2END[7] Tile_X0Y0_S1END[2]
+ _1101_/Q _1100_/Q VPWR VGND sg13cmos5l_mux4_1
XFILLER_20_215 VPWR VGND sg13cmos5l_fill_2
X_1994_ _1994_/Q Tile_X0Y4_FrameData[27] VGND VPWR Tile_X0Y9_FrameStrobe[2] latch
X_4782_ _4782_/X Tile_X0Y7_W1END[3] Tile_X0Y7_W6END[11] _4699_/X _4659_/X _0373_/Q
+ _0372_/Q VPWR VGND sg13cmos5l_mux4_1
XFILLER_220_165 VPWR VGND sg13cmos5l_decap_4
XFILLER_508_130 VPWR VGND sg13cmos5l_decap_4
X_0945_ _0945_/Q Tile_X0Y0_FrameData[26] VGND VPWR Tile_X0Y9_FrameStrobe[0] latch
X_3733_ AXI_M_SOC_ARADDR5 Tile_X0Y9_WW4END[5] Tile_X0Y9_WW4END[13] Tile_X0Y9_W6END[5]
+ _4921_/X _0749_/Q _0748_/Q VPWR VGND sg13cmos5l_mux4_1
XFILLER_381_106 VPWR VGND sg13cmos5l_fill_2
XFILLER_508_163 VPWR VGND sg13cmos5l_decap_8
X_0876_ _0876_/Q Tile_X0Y9_FrameData[19] VGND VPWR Tile_X0Y9_FrameStrobe[6] latch
X_3664_ AXI_M_SOC_AWADDR25 Tile_X0Y4_WW4END[1] Tile_X0Y4_WW4END[9] Tile_X0Y4_W6END[9]
+ _4345_/X _1995_/Q _1994_/Q VPWR VGND sg13cmos5l_mux4_1
XFILLER_684_84 VPWR VGND sg13cmos5l_decap_4
XFILLER_537_89 VPWR VGND sg13cmos5l_decap_8
XFILLER_256_35 VPWR VGND sg13cmos5l_decap_8
XFILLER_669_126 VPWR VGND sg13cmos5l_fill_2
X_2615_ _2615_/Q Tile_X0Y6_FrameData[16] VGND VPWR Tile_X0Y9_FrameStrobe[5] latch
X_3595_ Tile_X0Y9_FrameData_O[25] Tile_X0Y9_FrameData[25] VPWR VGND sg13cmos5l_buf_1
XFILLER_523_166 VPWR VGND sg13cmos5l_decap_8
XFILLER_322_217 VPWR VGND sg13cmos5l_fill_1
XFILLER_126_180 VPWR VGND sg13cmos5l_fill_2
X_2546_ _2546_/Q Tile_X0Y6_FrameData[21] VGND VPWR Tile_X0Y9_FrameStrobe[3] latch
XFILLER_476_210 VPWR VGND sg13cmos5l_fill_1
XFILLER_406_49 VPWR VGND sg13cmos5l_fill_2
XFILLER_553_77 VPWR VGND sg13cmos5l_decap_8
XFILLER_87_215 VPWR VGND sg13cmos5l_fill_2
XFILLER_125_28 VPWR VGND sg13cmos5l_decap_8
X_2477_ _2477_/Q Tile_X0Y6_FrameData[26] VGND VPWR Tile_X0Y9_FrameStrobe[1] latch
XFILLER_703_14 VPWR VGND sg13cmos5l_decap_8
XANTENNA__3514__X Tile_X0Y1_E2BEG[4] VPWR VGND sg13cmos5l_antennanp
XFILLER_272_56 VPWR VGND sg13cmos5l_decap_8
XFILLER_491_202 VPWR VGND sg13cmos5l_decap_4
X_1428_ _1428_/Q Tile_X0Y2_FrameData[29] VGND VPWR Tile_X0Y9_FrameStrobe[0] latch
X_4216_ _4216_/X Tile_X0Y7_W1END[1] Tile_X0Y7_WW4END[1] Tile_X0Y7_W6END[9] _4685_/X
+ _0388_/Q _0387_/Q VPWR VGND sg13cmos5l_mux4_1
X_4147_ _4147_/X _4203_/X _4202_/X AXI_M_SOC_WREADY _4201_/X _1847_/Q _1846_/Q VPWR
+ VGND sg13cmos5l_mux4_1
X_1359_ _1359_/Q Tile_X0Y1_FrameData[10] VGND VPWR Tile_X0Y9_FrameStrobe[5] latch
XFILLER_55_123 VPWR VGND sg13cmos5l_fill_2
XFILLER_141_27 VPWR VGND sg13cmos5l_decap_8
X_4078_ _4078_/X AXI_M_SOC_AWREADY _4121_/X _4125_/X _4101_/X _1517_/Q _1516_/Q VPWR
+ VGND sg13cmos5l_mux4_1
XFILLER_502_70 VPWR VGND sg13cmos5l_decap_8
XFILLER_389_217 VPWR VGND sg13cmos5l_fill_1
XFILLER_55_167 VPWR VGND sg13cmos5l_decap_8
X_3029_ Tile_X0Y5_EE4BEG[4] _4392_/X VPWR VGND sg13cmos5l_buf_1
XFILLER_70_115 VPWR VGND sg13cmos5l_decap_8
XFILLER_578_63 VPWR VGND sg13cmos5l_decap_8
XFILLER_297_42 VPWR VGND sg13cmos5l_decap_8
XFILLER_140_7 VPWR VGND sg13cmos5l_decap_8
XFILLER_11_215 VPWR VGND sg13cmos5l_fill_2
XFILLER_357_147 VPWR VGND sg13cmos5l_decap_8
XFILLER_211_154 VPWR VGND sg13cmos5l_decap_8
XFILLER_109_103 VPWR VGND sg13cmos5l_fill_1
XFILLER_561_217 VPWR VGND sg13cmos5l_fill_1
XFILLER_372_117 VPWR VGND sg13cmos5l_decap_8
XFILLER_109_125 VPWR VGND sg13cmos5l_decap_4
XFILLER_405_7 VPWR VGND sg13cmos5l_decap_8
XFILLER_365_180 VPWR VGND sg13cmos5l_decap_4
XFILLER_166_35 VPWR VGND sg13cmos5l_decap_8
XFILLER_109_158 VPWR VGND sg13cmos5l_fill_2
XFILLER_380_150 VPWR VGND sg13cmos5l_fill_1
XFILLER_313_206 VPWR VGND sg13cmos5l_decap_4
XFILLER_313_217 VPWR VGND sg13cmos5l_fill_1
XFILLER_59_11 VPWR VGND sg13cmos5l_decap_8
XFILLER_78_215 VPWR VGND sg13cmos5l_fill_2
XFILLER_613_14 VPWR VGND sg13cmos5l_decap_8
XFILLER_278_154 VPWR VGND sg13cmos5l_decap_8
XFILLER_182_34 VPWR VGND sg13cmos5l_decap_8
XFILLER_59_88 VPWR VGND sg13cmos5l_decap_4
XANTENNA__3424__X Tile_X0Y4_FrameData_O[15] VPWR VGND sg13cmos5l_antennanp
XFILLER_182_78 VPWR VGND sg13cmos5l_decap_8
XFILLER_376_2 VPWR VGND sg13cmos5l_fill_1
XFILLER_412_70 VPWR VGND sg13cmos5l_decap_8
XFILLER_450_121 VPWR VGND sg13cmos5l_fill_1
XFILLER_264_0 VPWR VGND sg13cmos5l_decap_8
XFILLER_46_178 VPWR VGND sg13cmos5l_fill_2
XFILLER_450_143 VPWR VGND sg13cmos5l_decap_8
XFILLER_61_137 VPWR VGND sg13cmos5l_decap_8
XFILLER_596_147 VPWR VGND sg13cmos5l_fill_1
XFILLER_488_63 VPWR VGND sg13cmos5l_decap_8
XFILLER_91_53 VPWR VGND sg13cmos5l_decap_8
XFILLER_431_0 VPWR VGND sg13cmos5l_decap_8
XFILLER_529_0 VPWR VGND sg13cmos5l_decap_8
XFILLER_348_169 VPWR VGND sg13cmos5l_decap_4
XFILLER_638_77 VPWR VGND sg13cmos5l_decap_8
XFILLER_357_56 VPWR VGND sg13cmos5l_decap_8
X_0730_ _0730_/Q Tile_X0Y9_FrameData[5] VGND VPWR Tile_X0Y9_FrameStrobe[1] latch
XFILLER_654_21 VPWR VGND sg13cmos5l_decap_8
X_0661_ _0661_/Q Tile_X0Y8_FrameData[10] VGND VPWR Tile_X0Y9_FrameStrobe[7] latch
X_2400_ _2400_/Q Tile_X0Y5_FrameData[5] VGND VPWR Tile_X0Y9_FrameStrobe[6] latch
X_3380_ Tile_X0Y2_E6BEG[3] _4075_/X VPWR VGND sg13cmos5l_buf_1
XFILLER_666_118 VPWR VGND sg13cmos5l_decap_8
X_0592_ _0592_/Q Tile_X0Y8_FrameData[15] VGND VPWR Tile_X0Y9_FrameStrobe[5] latch
XFILLER_654_98 VPWR VGND sg13cmos5l_decap_8
XFILLER_659_170 VPWR VGND sg13cmos5l_fill_1
X_2331_ _2331_/Q Tile_X0Y5_FrameData[10] VGND VPWR Tile_X0Y9_FrameStrobe[4] latch
XFILLER_523_14 VPWR VGND sg13cmos5l_decap_8
XANTENNA__3334__X Tile_X0Y2_FrameData_O[5] VPWR VGND sg13cmos5l_antennanp
XFILLER_670_42 VPWR VGND sg13cmos5l_decap_8
X_2262_ _2262_/Q Tile_X0Y5_FrameData[15] VGND VPWR Tile_X0Y9_FrameStrobe[2] latch
XFILLER_523_69 VPWR VGND sg13cmos5l_fill_2
XFILLER_269_198 VPWR VGND sg13cmos5l_decap_8
X_4001_ _4001_/X _4456_/X _4460_/X _4464_/X _4430_/X _2412_/Q _2411_/Q VPWR VGND sg13cmos5l_mux4_1
X_1213_ _1213_/Q Tile_X0Y1_FrameData[28] VGND VPWR Tile_X0Y9_FrameStrobe[1] latch
XFILLER_37_101 VPWR VGND sg13cmos5l_fill_1
X_2193_ _2193_/Q Tile_X0Y5_FrameData[20] VGND VPWR Tile_X0Y9_FrameStrobe[0] latch
XFILLER_284_168 VPWR VGND sg13cmos5l_decap_4
XFILLER_426_140 VPWR VGND sg13cmos5l_decap_8
X_1144_ _1144_/Q Tile_X0Y0_FrameData[19] VGND VPWR Tile_X0Y9_FrameStrobe[6] latch
XFILLER_322_70 VPWR VGND sg13cmos5l_decap_8
XFILLER_426_195 VPWR VGND sg13cmos5l_decap_4
XFILLER_1_84 VPWR VGND sg13cmos5l_decap_8
XFILLER_37_178 VPWR VGND sg13cmos5l_fill_1
X_1075_ _1075_/Q Tile_X0Y0_FrameData[24] VGND VPWR Tile_X0Y9_FrameStrobe[4] latch
XFILLER_679_84 VPWR VGND sg13cmos5l_fill_2
XFILLER_386_209 VPWR VGND sg13cmos5l_fill_2
X_4903_ _4903_/X Tile_X0Y9_N2MID[1] Tile_X0Y9_N2END[1] _4933_/X _4817_/X _0693_/Q
+ _0692_/Q VPWR VGND sg13cmos5l_mux4_1
XFILLER_441_187 VPWR VGND sg13cmos5l_decap_8
XFILLER_339_125 VPWR VGND sg13cmos5l_fill_1
X_4834_ _4834_/X Tile_X0Y9_W1END[2] Tile_X0Y9_W2MID[1] Tile_X0Y9_W2END[1] _4902_/X
+ _0871_/Q _0870_/Q VPWR VGND sg13cmos5l_mux4_1
XFILLER_339_147 VPWR VGND sg13cmos5l_fill_1
XFILLER_548_77 VPWR VGND sg13cmos5l_decap_8
X_4765_ _4765_/X AXI_M_SOC_RDATA9 _4806_/X _4810_/X _4787_/X _0517_/Q _0516_/Q VPWR
+ VGND sg13cmos5l_mux4_1
X_1977_ _1977_/Q Tile_X0Y4_FrameData[12] VGND VPWR Tile_X0Y9_FrameStrobe[1] latch
XFILLER_267_56 VPWR VGND sg13cmos5l_decap_8
XANTENNA__3509__X Tile_X0Y1_E2BEGb[7] VPWR VGND sg13cmos5l_antennanp
X_3716_ AXI_M_SOC_WDATA26 Tile_X0Y6_WW4END[2] Tile_X0Y6_WW4END[10] Tile_X0Y6_W6END[10]
+ _4578_/X _2507_/Q _2506_/Q VPWR VGND sg13cmos5l_mux4_1
X_0928_ _0928_/Q Tile_X0Y9_FrameData[31] VGND VPWR Tile_X0Y9_FrameStrobe[0] latch
X_4696_ _4696_/X _4661_/X Tile_X0Y9_N4END[8] _4660_/X _0056_/X _0191_/Q _0190_/Q VPWR
+ VGND sg13cmos5l_mux4_1
XFILLER_564_21 VPWR VGND sg13cmos5l_decap_8
X_0859_ _0859_/Q Tile_X0Y9_FrameData[4] VGND VPWR Tile_X0Y9_FrameStrobe[5] latch
X_3647_ AXI_M_SOC_AWADDR8 Tile_X0Y5_WW4END[0] Tile_X0Y5_WW4END[8] Tile_X0Y5_W6END[8]
+ _4459_/X _2255_/Q _2254_/Q VPWR VGND sg13cmos5l_mux4_1
XFILLER_20_49 VPWR VGND sg13cmos5l_decap_4
XFILLER_106_139 VPWR VGND sg13cmos5l_decap_8
XFILLER_564_98 VPWR VGND sg13cmos5l_decap_8
XFILLER_136_49 VPWR VGND sg13cmos5l_decap_8
XFILLER_714_35 VPWR VGND sg13cmos5l_decap_8
X_3578_ Tile_X0Y9_FrameData_O[8] Tile_X0Y9_FrameData[8] VPWR VGND sg13cmos5l_buf_1
XFILLER_283_77 VPWR VGND sg13cmos5l_decap_8
X_2529_ _2529_/Q Tile_X0Y6_FrameData[6] VGND VPWR Tile_X0Y9_FrameStrobe[2] latch
XFILLER_433_14 VPWR VGND sg13cmos5l_decap_8
XANTENNA__3244__X Tile_X0Y0_FrameData_O[12] VPWR VGND sg13cmos5l_antennanp
XFILLER_580_42 VPWR VGND sg13cmos5l_decap_8
XFILLER_580_97 VPWR VGND sg13cmos5l_decap_4
XFILLER_290_105 VPWR VGND sg13cmos5l_decap_8
XFILLER_188_7 VPWR VGND sg13cmos5l_decap_8
XFILLER_28_134 VPWR VGND sg13cmos5l_decap_8
XFILLER_45_35 VPWR VGND sg13cmos5l_decap_8
XFILLER_28_189 VPWR VGND sg13cmos5l_decap_8
XFILLER_355_7 VPWR VGND sg13cmos5l_decap_8
XFILLER_43_126 VPWR VGND sg13cmos5l_fill_2
XFILLER_231_205 VPWR VGND sg13cmos5l_decap_4
XFILLER_578_147 VPWR VGND sg13cmos5l_decap_8
XFILLER_593_106 VPWR VGND sg13cmos5l_decap_8
XFILLER_432_198 VPWR VGND sg13cmos5l_fill_1
XFILLER_101_52 VPWR VGND sg13cmos5l_decap_8
XANTENNA__0108__X AXI_M_SOC_ARBURST0 VPWR VGND sg13cmos5l_antennanp
XFILLER_522_7 VPWR VGND sg13cmos5l_decap_8
XFILLER_458_44 VPWR VGND sg13cmos5l_fill_1
XFILLER_61_34 VPWR VGND sg13cmos5l_decap_8
XFILLER_458_77 VPWR VGND sg13cmos5l_fill_2
XFILLER_61_67 VPWR VGND sg13cmos5l_decap_8
XFILLER_608_14 VPWR VGND sg13cmos5l_decap_8
XFILLER_177_56 VPWR VGND sg13cmos5l_decap_8
XANTENNA__3419__X Tile_X0Y4_FrameData_O[10] VPWR VGND sg13cmos5l_antennanp
XFILLER_338_180 VPWR VGND sg13cmos5l_decap_8
XFILLER_474_21 VPWR VGND sg13cmos5l_decap_8
XFILLER_499_154 VPWR VGND sg13cmos5l_decap_8
XFILLER_353_172 VPWR VGND sg13cmos5l_decap_8
XFILLER_474_76 VPWR VGND sg13cmos5l_fill_1
XFILLER_474_87 VPWR VGND sg13cmos5l_decap_8
XFILLER_502_147 VPWR VGND sg13cmos5l_decap_8
XFILLER_193_55 VPWR VGND sg13cmos5l_decap_8
XFILLER_624_35 VPWR VGND sg13cmos5l_decap_8
XFILLER_343_14 VPWR VGND sg13cmos5l_decap_8
XANTENNA__3154__X Tile_X0Y7_FrameData_O[24] VPWR VGND sg13cmos5l_antennanp
XFILLER_490_42 VPWR VGND sg13cmos5l_decap_8
XFILLER_510_180 VPWR VGND sg13cmos5l_fill_1
XFILLER_381_0 VPWR VGND sg13cmos5l_decap_8
XFILLER_120_164 VPWR VGND sg13cmos5l_fill_2
XFILLER_479_0 VPWR VGND sg13cmos5l_decap_8
XFILLER_266_157 VPWR VGND sg13cmos5l_decap_8
XANTENNA__2993__X Tile_X0Y5_E1BEG[0] VPWR VGND sg13cmos5l_antennanp
XFILLER_671_154 VPWR VGND sg13cmos5l_fill_2
XFILLER_281_105 VPWR VGND sg13cmos5l_decap_8
XFILLER_640_56 VPWR VGND sg13cmos5l_decap_8
XFILLER_470_216 VPWR VGND sg13cmos5l_fill_2
XFILLER_423_91 VPWR VGND sg13cmos5l_decap_8
XFILLER_646_0 VPWR VGND sg13cmos5l_decap_8
XFILLER_34_104 VPWR VGND sg13cmos5l_decap_8
XFILLER_423_143 VPWR VGND sg13cmos5l_fill_1
XFILLER_569_147 VPWR VGND sg13cmos5l_decap_8
XFILLER_499_84 VPWR VGND sg13cmos5l_decap_8
XFILLER_649_21 VPWR VGND sg13cmos5l_decap_8
XFILLER_423_187 VPWR VGND sg13cmos5l_fill_1
X_1900_ _1900_/Q Tile_X0Y3_FrameData[29] VGND VPWR Tile_X0Y9_FrameStrobe[7] latch
X_2880_ Tile_X0Y6_FrameData_O[1] Tile_X0Y6_FrameData[1] VPWR VGND sg13cmos5l_buf_1
XFILLER_649_98 VPWR VGND sg13cmos5l_decap_8
X_1831_ _1831_/Q Tile_X0Y3_FrameData[2] VGND VPWR Tile_X0Y9_FrameStrobe[4] latch
XFILLER_525_217 VPWR VGND sg13cmos5l_fill_1
XFILLER_518_14 VPWR VGND sg13cmos5l_decap_8
XFILLER_336_128 VPWR VGND sg13cmos5l_decap_8
XANTENNA__3329__X Tile_X0Y2_FrameData_O[0] VPWR VGND sg13cmos5l_antennanp
XFILLER_665_42 VPWR VGND sg13cmos5l_decap_8
X_1762_ _1762_/Q Tile_X0Y3_FrameData[7] VGND VPWR Tile_X0Y9_FrameStrobe[2] latch
X_4550_ _4550_/X Tile_X0Y5_W1END[3] Tile_X0Y5_W6END[11] _4466_/X _4425_/X _2397_/Q
+ _2396_/Q VPWR VGND sg13cmos5l_mux4_1
XFILLER_384_21 VPWR VGND sg13cmos5l_decap_8
X_0713_ _0713_/Q Tile_X0Y9_FrameData[22] VGND VPWR Tile_X0Y9_FrameStrobe[1] latch
X_3501_ Tile_X0Y1_E6BEG[11] _3975_/X VPWR VGND sg13cmos5l_buf_1
XFILLER_384_43 VPWR VGND sg13cmos5l_fill_1
X_1693_ _1693_/Q Tile_X0Y3_FrameData[12] VGND VPWR Tile_X0Y9_FrameStrobe[0] latch
X_4481_ _4481_/X Tile_X0Y7_W2MID[1] Tile_X0Y7_W2END[1] Tile_X0Y7_W6END[1] _4670_/X
+ _0395_/Q _0394_/Q VPWR VGND sg13cmos5l_mux4_1
XFILLER_237_59 VPWR VGND sg13cmos5l_decap_4
XFILLER_384_65 VPWR VGND sg13cmos5l_decap_4
XFILLER_694_202 VPWR VGND sg13cmos5l_fill_2
X_0644_ _0644_/Q Tile_X0Y8_FrameData[27] VGND VPWR Tile_X0Y9_FrameStrobe[7] latch
X_3432_ Tile_X0Y4_FrameData_O[23] Tile_X0Y4_FrameData[23] VPWR VGND sg13cmos5l_buf_1
XFILLER_534_35 VPWR VGND sg13cmos5l_decap_8
XFILLER_317_81 VPWR VGND sg13cmos5l_decap_8
X_3363_ Tile_X0Y2_EE4BEG[2] _4058_/X VPWR VGND sg13cmos5l_buf_1
XFILLER_681_63 VPWR VGND sg13cmos5l_decap_8
XFILLER_253_14 VPWR VGND sg13cmos5l_decap_8
X_0575_ _0575_/Q Tile_X0Y8_FrameData[0] VGND VPWR Tile_X0Y9_FrameStrobe[4] latch
XFILLER_647_140 VPWR VGND sg13cmos5l_decap_8
XANTENNA__3064__X Tile_X0Y5_FrameData_O[23] VPWR VGND sg13cmos5l_antennanp
XFILLER_257_102 VPWR VGND sg13cmos5l_fill_2
X_2314_ _2314_/Q Tile_X0Y5_FrameData[27] VGND VPWR Tile_X0Y9_FrameStrobe[4] latch
X_3294_ Tile_X0Y0_E2BEGb[2] _3814_/X VPWR VGND sg13cmos5l_buf_1
XFILLER_111_153 VPWR VGND sg13cmos5l_decap_8
XFILLER_25_0 VPWR VGND sg13cmos5l_decap_8
XFILLER_257_157 VPWR VGND sg13cmos5l_fill_2
X_2245_ _2245_/Q Tile_X0Y5_FrameData[0] VGND VPWR Tile_X0Y9_FrameStrobe[1] latch
XFILLER_403_28 VPWR VGND sg13cmos5l_decap_8
XFILLER_272_105 VPWR VGND sg13cmos5l_decap_8
XFILLER_550_56 VPWR VGND sg13cmos5l_fill_2
XFILLER_461_216 VPWR VGND sg13cmos5l_fill_2
X_2176_ _2176_/Q Tile_X0Y4_FrameData[5] VGND VPWR Tile_X0Y9_FrameStrobe[7] latch
XFILLER_603_210 VPWR VGND sg13cmos5l_fill_2
X_1127_ _1127_/Q Tile_X0Y0_FrameData[4] VGND VPWR Tile_X0Y9_FrameStrobe[5] latch
XFILLER_559_21 VPWR VGND sg13cmos5l_decap_8
X_1058_ _1058_/Q Tile_X0Y0_FrameData[9] VGND VPWR Tile_X0Y9_FrameStrobe[3] latch
XFILLER_202_84 VPWR VGND sg13cmos5l_decap_8
XFILLER_15_49 VPWR VGND sg13cmos5l_decap_8
XFILLER_178_131 VPWR VGND sg13cmos5l_decap_8
XFILLER_559_98 VPWR VGND sg13cmos5l_fill_1
XFILLER_33_181 VPWR VGND sg13cmos5l_fill_1
XFILLER_717_133 VPWR VGND sg13cmos5l_decap_4
XFILLER_709_35 VPWR VGND sg13cmos5l_decap_8
X_4817_ _4817_/X Tile_X0Y7_W2MID[6] Tile_X0Y7_W2END[6] Tile_X0Y7_W6END[9] _4671_/X
+ _0369_/Q _0368_/Q VPWR VGND sg13cmos5l_mux4_1
XFILLER_278_77 VPWR VGND sg13cmos5l_decap_8
XFILLER_583_161 VPWR VGND sg13cmos5l_decap_8
XFILLER_428_14 VPWR VGND sg13cmos5l_decap_8
XFILLER_516_217 VPWR VGND sg13cmos5l_fill_1
XANTENNA__3239__X Tile_X0Y0_FrameData_O[7] VPWR VGND sg13cmos5l_antennanp
XFILLER_575_42 VPWR VGND sg13cmos5l_decap_8
XFILLER_717_199 VPWR VGND sg13cmos5l_fill_1
XFILLER_193_145 VPWR VGND sg13cmos5l_decap_4
X_4748_ _4748_/X Tile_X0Y8_WW4END[11] AXI_M_SOC_RDATA12 _4811_/X _4791_/X _0551_/Q
+ _0550_/Q VPWR VGND sg13cmos5l_mux4_1
XFILLER_31_48 VPWR VGND sg13cmos5l_decap_8
XFILLER_294_21 VPWR VGND sg13cmos5l_decap_8
X_4679_ _4679_/X _4227_/X _4231_/X _4235_/X _4208_/X _1862_/Q _1861_/Q VPWR VGND sg13cmos5l_mux4_1
XFILLER_335_194 VPWR VGND sg13cmos5l_fill_1
XFILLER_103_7 VPWR VGND sg13cmos5l_decap_8
XFILLER_294_98 VPWR VGND sg13cmos5l_fill_2
XFILLER_444_35 VPWR VGND sg13cmos5l_decap_8
XFILLER_227_70 VPWR VGND sg13cmos5l_decap_8
XFILLER_591_63 VPWR VGND sg13cmos5l_decap_8
XFILLER_496_168 VPWR VGND sg13cmos5l_decap_8
XFILLER_163_14 VPWR VGND sg13cmos5l_decap_4
XFILLER_638_140 VPWR VGND sg13cmos5l_decap_4
XFILLER_444_79 VPWR VGND sg13cmos5l_decap_8
XFILLER_163_47 VPWR VGND sg13cmos5l_decap_8
XFILLER_102_120 VPWR VGND sg13cmos5l_decap_8
XFILLER_638_162 VPWR VGND sg13cmos5l_decap_8
XFILLER_163_58 VPWR VGND sg13cmos5l_fill_2
XFILLER_248_157 VPWR VGND sg13cmos5l_decap_8
XFILLER_472_7 VPWR VGND sg13cmos5l_decap_8
XFILLER_653_154 VPWR VGND sg13cmos5l_fill_2
XFILLER_56_34 VPWR VGND sg13cmos5l_decap_8
XANTENNA__3702__X AXI_M_SOC_WDATA12 VPWR VGND sg13cmos5l_antennanp
XFILLER_56_67 VPWR VGND sg13cmos5l_decap_8
XFILLER_263_149 VPWR VGND sg13cmos5l_fill_1
XFILLER_71_210 VPWR VGND sg13cmos5l_decap_8
XFILLER_469_21 VPWR VGND sg13cmos5l_decap_8
XFILLER_271_171 VPWR VGND sg13cmos5l_fill_1
XFILLER_420_102 VPWR VGND sg13cmos5l_fill_1
XFILLER_469_76 VPWR VGND sg13cmos5l_decap_8
XFILLER_24_181 VPWR VGND sg13cmos5l_fill_1
XFILLER_708_133 VPWR VGND sg13cmos5l_decap_8
XFILLER_619_35 VPWR VGND sg13cmos5l_decap_8
XFILLER_169_164 VPWR VGND sg13cmos5l_decap_8
XFILLER_574_150 VPWR VGND sg13cmos5l_decap_8
XFILLER_318_106 VPWR VGND sg13cmos5l_decap_8
XFILLER_188_77 VPWR VGND sg13cmos5l_decap_4
XFILLER_507_206 VPWR VGND sg13cmos5l_decap_4
XFILLER_338_14 VPWR VGND sg13cmos5l_decap_8
XFILLER_507_217 VPWR VGND sg13cmos5l_fill_1
XFILLER_708_177 VPWR VGND sg13cmos5l_fill_2
XANTENNA__3149__X Tile_X0Y7_FrameData_O[19] VPWR VGND sg13cmos5l_antennanp
XFILLER_485_42 VPWR VGND sg13cmos5l_decap_8
XFILLER_227_0 VPWR VGND sg13cmos5l_fill_2
XFILLER_184_145 VPWR VGND sg13cmos5l_decap_8
XFILLER_338_58 VPWR VGND sg13cmos5l_fill_1
XANTENNA__2988__X Tile_X0Y8_FrameData_O[28] VPWR VGND sg13cmos5l_antennanp
XFILLER_635_56 VPWR VGND sg13cmos5l_decap_8
XFILLER_487_102 VPWR VGND sg13cmos5l_fill_1
XFILLER_418_91 VPWR VGND sg13cmos5l_decap_8
XFILLER_98_107 VPWR VGND sg13cmos5l_fill_1
XFILLER_354_35 VPWR VGND sg13cmos5l_decap_8
XFILLER_137_70 VPWR VGND sg13cmos5l_decap_8
XFILLER_98_129 VPWR VGND sg13cmos5l_decap_8
XFILLER_596_0 VPWR VGND sg13cmos5l_decap_8
XFILLER_341_164 VPWR VGND sg13cmos5l_decap_8
XFILLER_140_215 VPWR VGND sg13cmos5l_fill_2
XFILLER_428_202 VPWR VGND sg13cmos5l_decap_8
XFILLER_239_113 VPWR VGND sg13cmos5l_fill_2
X_0360_ _0360_/Q Tile_X0Y7_FrameData[23] VGND VPWR Tile_X0Y9_FrameStrobe[6] latch
XFILLER_504_49 VPWR VGND sg13cmos5l_decap_8
XFILLER_629_184 VPWR VGND sg13cmos5l_fill_1
XFILLER_39_207 VPWR VGND sg13cmos5l_fill_1
XFILLER_495_190 VPWR VGND sg13cmos5l_fill_1
XFILLER_651_77 VPWR VGND sg13cmos5l_decap_8
XFILLER_223_28 VPWR VGND sg13cmos5l_decap_8
X_0291_ _0291_/Q Tile_X0Y7_FrameData[28] VGND VPWR Tile_X0Y9_FrameStrobe[4] latch
XFILLER_644_154 VPWR VGND sg13cmos5l_decap_8
XANTENNA__3612__X Tile_X0Y9_S2BEG[6] VPWR VGND sg13cmos5l_antennanp
XFILLER_443_216 VPWR VGND sg13cmos5l_fill_2
X_2030_ _2030_/Q Tile_X0Y4_FrameData[23] VGND VPWR Tile_X0Y9_FrameStrobe[3] latch
XFILLER_379_21 VPWR VGND sg13cmos5l_decap_8
X_3981_ _3981_/X Tile_X0Y2_W1END[0] Tile_X0Y2_W6END[4] _4113_/X _4084_/X _1673_/Q
+ _1672_/Q VPWR VGND sg13cmos5l_mux4_1
XFILLER_600_70 VPWR VGND sg13cmos5l_decap_8
XFILLER_411_146 VPWR VGND sg13cmos5l_fill_1
X_2932_ Tile_X0Y8_E6BEG[0] _4760_/X VPWR VGND sg13cmos5l_buf_1
XFILLER_411_168 VPWR VGND sg13cmos5l_decap_4
XFILLER_15_170 VPWR VGND sg13cmos5l_fill_2
XFILLER_529_35 VPWR VGND sg13cmos5l_decap_8
XFILLER_309_106 VPWR VGND sg13cmos5l_fill_1
XFILLER_676_63 VPWR VGND sg13cmos5l_decap_8
XFILLER_364_201 VPWR VGND sg13cmos5l_fill_2
XFILLER_30_140 VPWR VGND sg13cmos5l_fill_1
X_2863_ Tile_X0Y6_EE4BEG[0] _4512_/X VPWR VGND sg13cmos5l_buf_1
XFILLER_248_14 VPWR VGND sg13cmos5l_decap_8
XFILLER_175_123 VPWR VGND sg13cmos5l_decap_8
XANTENNA__3059__X Tile_X0Y5_FrameData_O[18] VPWR VGND sg13cmos5l_antennanp
XFILLER_395_42 VPWR VGND sg13cmos5l_decap_8
X_4602_ _4602_/X Tile_X0Y7_W1END[1] Tile_X0Y7_WW4END[13] Tile_X0Y7_W6END[5] _4685_/X
+ _0352_/Q _0351_/Q VPWR VGND sg13cmos5l_mux4_1
X_1814_ _1814_/Q Tile_X0Y3_FrameData[19] VGND VPWR Tile_X0Y9_FrameStrobe[4] latch
XFILLER_580_131 VPWR VGND sg13cmos5l_fill_2
XFILLER_714_147 VPWR VGND sg13cmos5l_decap_8
X_2794_ Tile_X0Y3_E6BEG[4] _4184_/X VPWR VGND sg13cmos5l_buf_1
XFILLER_395_75 VPWR VGND sg13cmos5l_fill_2
XFILLER_513_209 VPWR VGND sg13cmos5l_decap_8
XFILLER_190_115 VPWR VGND sg13cmos5l_decap_8
X_4533_ _4533_/X AXI_M_SOC_RDATA25 _4574_/X _4578_/X _4555_/X _2541_/Q _2540_/Q VPWR
+ VGND sg13cmos5l_mux4_1
XANTENNA__2898__X Tile_X0Y6_FrameData_O[19] VPWR VGND sg13cmos5l_antennanp
X_1745_ _1745_/Q Tile_X0Y3_FrameData[24] VGND VPWR Tile_X0Y9_FrameStrobe[2] latch
XFILLER_545_56 VPWR VGND sg13cmos5l_decap_8
XFILLER_328_80 VPWR VGND sg13cmos5l_decap_8
XFILLER_190_159 VPWR VGND sg13cmos5l_decap_8
X_4464_ _4464_/X _4421_/X _0159_/X _4420_/X _0145_/X _2211_/Q _2210_/Q VPWR VGND sg13cmos5l_mux4_1
XFILLER_692_84 VPWR VGND sg13cmos5l_decap_8
X_1676_ _1676_/Q Tile_X0Y3_FrameData[29] VGND VPWR Tile_X0Y9_FrameStrobe[0] latch
XFILLER_264_35 VPWR VGND sg13cmos5l_decap_8
X_3415_ Tile_X0Y4_FrameData_O[6] Tile_X0Y4_FrameData[6] VPWR VGND sg13cmos5l_buf_1
XFILLER_332_175 VPWR VGND sg13cmos5l_decap_8
X_0627_ _0627_/Q Tile_X0Y8_FrameData[12] VGND VPWR Tile_X0Y9_FrameStrobe[6] latch
X_4395_ _4395_/X Tile_X0Y5_WW4END[8] AXI_M_SOC_RRESP1 _4459_/X _4467_/X _2313_/Q _2312_/Q
+ VPWR VGND sg13cmos5l_mux4_1
XFILLER_493_105 VPWR VGND sg13cmos5l_decap_8
XFILLER_682_205 VPWR VGND sg13cmos5l_fill_2
XFILLER_97_140 VPWR VGND sg13cmos5l_decap_8
X_0558_ _0558_/Q Tile_X0Y8_FrameData[17] VGND VPWR Tile_X0Y9_FrameStrobe[4] latch
X_3346_ Tile_X0Y2_FrameData_O[17] Tile_X0Y2_FrameData[17] VPWR VGND sg13cmos5l_buf_1
XFILLER_414_49 VPWR VGND sg13cmos5l_decap_8
XFILLER_97_173 VPWR VGND sg13cmos5l_decap_8
XFILLER_561_77 VPWR VGND sg13cmos5l_decap_8
XFILLER_133_28 VPWR VGND sg13cmos5l_decap_8
XFILLER_711_14 VPWR VGND sg13cmos5l_decap_8
X_0489_ _0489_/Q Tile_X0Y8_FrameData[22] VGND VPWR Tile_X0Y9_FrameStrobe[2] latch
X_3277_ Tile_X0Y0_EE4BEG[13] _3833_/X VPWR VGND sg13cmos5l_buf_1
XFILLER_245_105 VPWR VGND sg13cmos5l_decap_8
XFILLER_280_56 VPWR VGND sg13cmos5l_decap_8
XANTENNA__3522__X Tile_X0Y9_E1BEG[0] VPWR VGND sg13cmos5l_antennanp
X_2228_ _2228_/Q Tile_X0Y5_FrameData[17] VGND VPWR Tile_X0Y9_FrameStrobe[1] latch
X_2159_ _2159_/Q Tile_X0Y4_FrameData[22] VGND VPWR Tile_X0Y9_FrameStrobe[7] latch
XFILLER_650_168 VPWR VGND sg13cmos5l_decap_8
XFILLER_289_21 VPWR VGND sg13cmos5l_decap_8
XFILLER_402_124 VPWR VGND sg13cmos5l_fill_2
XFILLER_510_70 VPWR VGND sg13cmos5l_decap_8
XFILLER_548_139 VPWR VGND sg13cmos5l_decap_8
XFILLER_439_35 VPWR VGND sg13cmos5l_decap_8
XFILLER_158_14 VPWR VGND sg13cmos5l_decap_8
XFILLER_439_79 VPWR VGND sg13cmos5l_fill_1
XFILLER_158_36 VPWR VGND sg13cmos5l_decap_8
XFILLER_220_7 VPWR VGND sg13cmos5l_decap_8
XFILLER_318_7 VPWR VGND sg13cmos5l_decap_8
XFILLER_166_156 VPWR VGND sg13cmos5l_fill_1
XFILLER_166_189 VPWR VGND sg13cmos5l_fill_2
XFILLER_705_169 VPWR VGND sg13cmos5l_fill_2
XFILLER_370_215 VPWR VGND sg13cmos5l_fill_2
XANTENNA__0105__Y AXI_M_SOC_ARLEN4 VPWR VGND sg13cmos5l_antennanp
XFILLER_571_175 VPWR VGND sg13cmos5l_decap_8
XFILLER_238_80 VPWR VGND sg13cmos5l_fill_2
XFILLER_181_148 VPWR VGND sg13cmos5l_decap_8
XFILLER_181_159 VPWR VGND sg13cmos5l_fill_2
XFILLER_455_78 VPWR VGND sg13cmos5l_decap_8
XFILLER_174_35 VPWR VGND sg13cmos5l_fill_2
XFILLER_469_168 VPWR VGND sg13cmos5l_decap_8
XFILLER_687_7 VPWR VGND sg13cmos5l_decap_8
XFILLER_174_79 VPWR VGND sg13cmos5l_decap_8
XFILLER_673_216 VPWR VGND sg13cmos5l_fill_2
XFILLER_107_62 VPWR VGND sg13cmos5l_decap_8
XFILLER_626_121 VPWR VGND sg13cmos5l_fill_1
XFILLER_88_184 VPWR VGND sg13cmos5l_decap_8
XFILLER_67_66 VPWR VGND sg13cmos5l_decap_8
XFILLER_621_14 VPWR VGND sg13cmos5l_decap_8
XFILLER_471_88 VPWR VGND sg13cmos5l_decap_8
XFILLER_191_2 VPWR VGND sg13cmos5l_fill_1
XFILLER_190_56 VPWR VGND sg13cmos5l_decap_8
XANTENNA__3432__X Tile_X0Y4_FrameData_O[23] VPWR VGND sg13cmos5l_antennanp
XFILLER_492_193 VPWR VGND sg13cmos5l_decap_8
XFILLER_83_21 VPWR VGND sg13cmos5l_decap_8
XFILLER_177_0 VPWR VGND sg13cmos5l_decap_8
XFILLER_83_43 VPWR VGND sg13cmos5l_decap_8
XFILLER_701_91 VPWR VGND sg13cmos5l_decap_8
XFILLER_199_21 VPWR VGND sg13cmos5l_decap_8
XFILLER_244_182 VPWR VGND sg13cmos5l_decap_4
XFILLER_539_117 VPWR VGND sg13cmos5l_decap_4
XFILLER_420_70 VPWR VGND sg13cmos5l_decap_8
XFILLER_539_128 VPWR VGND sg13cmos5l_fill_2
XFILLER_344_0 VPWR VGND sg13cmos5l_decap_8
XFILLER_349_35 VPWR VGND sg13cmos5l_decap_8
XFILLER_496_63 VPWR VGND sg13cmos5l_decap_8
XFILLER_12_151 VPWR VGND sg13cmos5l_fill_2
XFILLER_511_0 VPWR VGND sg13cmos5l_decap_8
XFILLER_609_0 VPWR VGND sg13cmos5l_decap_8
XFILLER_547_194 VPWR VGND sg13cmos5l_decap_8
XFILLER_12_195 VPWR VGND sg13cmos5l_decap_8
XFILLER_562_142 VPWR VGND sg13cmos5l_fill_2
XFILLER_646_77 VPWR VGND sg13cmos5l_decap_8
XFILLER_562_175 VPWR VGND sg13cmos5l_decap_8
XFILLER_32_91 VPWR VGND sg13cmos5l_fill_1
XFILLER_218_28 VPWR VGND sg13cmos5l_decap_8
XFILLER_172_148 VPWR VGND sg13cmos5l_decap_8
XFILLER_148_80 VPWR VGND sg13cmos5l_decap_8
XFILLER_365_56 VPWR VGND sg13cmos5l_decap_8
XANTENNA__3607__X Tile_X0Y9_S2BEG[1] VPWR VGND sg13cmos5l_antennanp
X_1530_ _1530_/Q Tile_X0Y2_FrameData[23] VGND VPWR Tile_X0Y9_FrameStrobe[3] latch
XFILLER_662_21 VPWR VGND sg13cmos5l_decap_8
XFILLER_113_215 VPWR VGND sg13cmos5l_fill_2
X_1461_ _1461_/Q Tile_X0Y2_FrameData[28] VGND VPWR Tile_X0Y9_FrameStrobe[1] latch
XFILLER_259_208 VPWR VGND sg13cmos5l_fill_1
XFILLER_180_170 VPWR VGND sg13cmos5l_fill_1
X_0412_ _0412_/Q Tile_X0Y7_FrameData[3] VGND VPWR Tile_X0Y9_FrameStrobe[7] latch
X_3200_ Tile_X0Y0_N2BEG[0] _3784_/X VPWR VGND sg13cmos5l_buf_1
XFILLER_664_216 VPWR VGND sg13cmos5l_fill_2
X_1392_ _1392_/Q Tile_X0Y1_FrameData[9] VGND VPWR Tile_X0Y9_FrameStrobe[6] latch
X_4180_ _4180_/X _0089_/X Tile_X0Y0_S4END[12] _4233_/X _4212_/X _1781_/Q _1780_/Q
+ VPWR VGND sg13cmos5l_mux4_1
XFILLER_381_77 VPWR VGND sg13cmos5l_fill_1
XFILLER_79_184 VPWR VGND sg13cmos5l_decap_8
X_0343_ _0343_/Q Tile_X0Y7_FrameData[8] VGND VPWR Tile_X0Y9_FrameStrobe[5] latch
X_3131_ Tile_X0Y7_FrameData_O[1] Tile_X0Y7_FrameData[1] VPWR VGND sg13cmos5l_buf_1
XFILLER_531_14 VPWR VGND sg13cmos5l_decap_8
XFILLER_617_154 VPWR VGND sg13cmos5l_fill_1
XFILLER_490_119 VPWR VGND sg13cmos5l_decap_8
XFILLER_314_60 VPWR VGND sg13cmos5l_fill_1
XFILLER_227_105 VPWR VGND sg13cmos5l_decap_8
XANTENNA__3342__X Tile_X0Y2_FrameData_O[13] VPWR VGND sg13cmos5l_antennanp
XFILLER_94_132 VPWR VGND sg13cmos5l_fill_2
XFILLER_617_176 VPWR VGND sg13cmos5l_decap_4
X_3062_ Tile_X0Y5_FrameData_O[21] Tile_X0Y5_FrameData[21] VPWR VGND sg13cmos5l_buf_1
XFILLER_617_187 VPWR VGND sg13cmos5l_decap_8
X_0274_ _0274_/Q Tile_X0Y7_FrameData[13] VGND VPWR Tile_X0Y9_FrameStrobe[3] latch
XFILLER_227_149 VPWR VGND sg13cmos5l_fill_1
X_2013_ _2013_/Q Tile_X0Y4_FrameData[8] VGND VPWR Tile_X0Y9_FrameStrobe[2] latch
XFILLER_396_112 VPWR VGND sg13cmos5l_fill_2
XFILLER_330_70 VPWR VGND sg13cmos5l_fill_2
X_3964_ _3964_/X _0073_/X Tile_X0Y0_S4END[4] _4019_/X _3996_/X _1281_/Q _1280_/Q VPWR
+ VGND sg13cmos5l_mux4_1
XFILLER_250_174 VPWR VGND sg13cmos5l_decap_8
XFILLER_92_0 VPWR VGND sg13cmos5l_decap_8
XFILLER_259_35 VPWR VGND sg13cmos5l_decap_8
XFILLER_545_109 VPWR VGND sg13cmos5l_decap_8
XFILLER_148_101 VPWR VGND sg13cmos5l_decap_4
X_2915_ Tile_X0Y8_E1BEG[3] _4727_/X VPWR VGND sg13cmos5l_buf_1
X_3895_ _3895_/X Tile_X0Y1_W2MID[4] Tile_X0Y1_W2END[4] Tile_X0Y1_W6END[4] _3995_/X
+ _1411_/Q _1410_/Q VPWR VGND sg13cmos5l_mux4_1
X_2846_ Tile_X0Y6_E2BEGb[3] _4507_/X VPWR VGND sg13cmos5l_buf_1
XFILLER_409_49 VPWR VGND sg13cmos5l_decap_8
XFILLER_12_28 VPWR VGND sg13cmos5l_decap_8
XFILLER_556_77 VPWR VGND sg13cmos5l_decap_8
XFILLER_128_28 VPWR VGND sg13cmos5l_decap_8
XFILLER_706_14 VPWR VGND sg13cmos5l_decap_8
XFILLER_699_168 VPWR VGND sg13cmos5l_decap_8
X_2777_ Tile_X0Y3_EE4BEG[3] _4167_/X VPWR VGND sg13cmos5l_buf_1
XFILLER_275_56 VPWR VGND sg13cmos5l_decap_8
XANTENNA__3517__X Tile_X0Y1_E2BEG[7] VPWR VGND sg13cmos5l_antennanp
X_4516_ _4516_/X Tile_X0Y6_WW4END[11] AXI_M_SOC_RDATA28 _4579_/X _4559_/X _2575_/Q
+ _2574_/Q VPWR VGND sg13cmos5l_mux4_1
X_1728_ _1728_/Q Tile_X0Y3_FrameData[9] VGND VPWR Tile_X0Y9_FrameStrobe[1] latch
XFILLER_305_142 VPWR VGND sg13cmos5l_fill_2
XFILLER_572_21 VPWR VGND sg13cmos5l_decap_8
XFILLER_104_215 VPWR VGND sg13cmos5l_fill_2
XFILLER_710_161 VPWR VGND sg13cmos5l_decap_8
X_4447_ _4447_/X Tile_X0Y1_W1END[3] Tile_X0Y1_WW4END[15] Tile_X0Y1_W6END[7] _4011_/X
+ _1356_/Q _1355_/Q VPWR VGND sg13cmos5l_mux4_1
XFILLER_305_186 VPWR VGND sg13cmos5l_decap_8
XFILLER_208_83 VPWR VGND sg13cmos5l_decap_8
X_1659_ _1659_/Q Tile_X0Y2_FrameData[22] VGND VPWR Tile_X0Y9_FrameStrobe[7] latch
XFILLER_655_216 VPWR VGND sg13cmos5l_fill_2
XFILLER_144_27 VPWR VGND sg13cmos5l_decap_8
XFILLER_572_98 VPWR VGND sg13cmos5l_decap_8
XFILLER_320_156 VPWR VGND sg13cmos5l_decap_4
X_4378_ _4378_/X Tile_X0Y5_W2MID[1] AXI_M_SOC_RRESP0 _4430_/X _4429_/X _2347_/Q _2346_/Q
+ VPWR VGND sg13cmos5l_mux4_1
XFILLER_466_149 VPWR VGND sg13cmos5l_decap_4
XFILLER_505_70 VPWR VGND sg13cmos5l_decap_8
XFILLER_291_77 VPWR VGND sg13cmos5l_decap_8
X_3329_ Tile_X0Y2_FrameData_O[0] Tile_X0Y2_FrameData[0] VPWR VGND sg13cmos5l_buf_1
XFILLER_670_208 VPWR VGND sg13cmos5l_fill_1
XFILLER_481_108 VPWR VGND sg13cmos5l_fill_2
XFILLER_441_14 VPWR VGND sg13cmos5l_decap_8
XFILLER_608_154 VPWR VGND sg13cmos5l_fill_1
XFILLER_273_200 VPWR VGND sg13cmos5l_decap_4
XANTENNA__3252__X Tile_X0Y0_FrameData_O[20] VPWR VGND sg13cmos5l_antennanp
XFILLER_608_176 VPWR VGND sg13cmos5l_decap_4
XFILLER_474_171 VPWR VGND sg13cmos5l_decap_8
XFILLER_85_154 VPWR VGND sg13cmos5l_decap_4
XFILLER_170_7 VPWR VGND sg13cmos5l_decap_4
XFILLER_268_7 VPWR VGND sg13cmos5l_decap_8
XFILLER_226_160 VPWR VGND sg13cmos5l_decap_8
XFILLER_387_101 VPWR VGND sg13cmos5l_decap_8
XFILLER_53_13 VPWR VGND sg13cmos5l_decap_8
XFILLER_241_152 VPWR VGND sg13cmos5l_fill_1
XFILLER_435_7 VPWR VGND sg13cmos5l_decap_8
XFILLER_387_178 VPWR VGND sg13cmos5l_decap_8
XFILLER_139_112 VPWR VGND sg13cmos5l_decap_8
XFILLER_529_172 VPWR VGND sg13cmos5l_decap_8
XFILLER_169_79 VPWR VGND sg13cmos5l_fill_1
XFILLER_602_7 VPWR VGND sg13cmos5l_decap_8
XFILLER_154_104 VPWR VGND sg13cmos5l_decap_8
XFILLER_139_189 VPWR VGND sg13cmos5l_decap_8
XFILLER_544_175 VPWR VGND sg13cmos5l_decap_4
XFILLER_466_88 VPWR VGND sg13cmos5l_fill_1
XFILLER_616_14 VPWR VGND sg13cmos5l_decap_8
XANTENNA__3427__X Tile_X0Y4_FrameData_O[18] VPWR VGND sg13cmos5l_antennanp
XFILLER_185_56 VPWR VGND sg13cmos5l_decap_8
XFILLER_482_21 VPWR VGND sg13cmos5l_decap_8
XFILLER_78_21 VPWR VGND sg13cmos5l_decap_8
XFILLER_632_35 VPWR VGND sg13cmos5l_decap_8
XFILLER_415_70 VPWR VGND sg13cmos5l_decap_8
XFILLER_294_0 VPWR VGND sg13cmos5l_decap_8
XFILLER_351_14 VPWR VGND sg13cmos5l_decap_8
XFILLER_661_208 VPWR VGND sg13cmos5l_fill_2
XFILLER_209_105 VPWR VGND sg13cmos5l_decap_8
XANTENNA__3162__X Tile_X0Y7_UserCLKo VPWR VGND sg13cmos5l_antennanp
XFILLER_76_154 VPWR VGND sg13cmos5l_decap_8
XFILLER_465_182 VPWR VGND sg13cmos5l_decap_8
XFILLER_76_165 VPWR VGND sg13cmos5l_fill_2
XFILLER_465_193 VPWR VGND sg13cmos5l_fill_2
XFILLER_91_102 VPWR VGND sg13cmos5l_decap_8
XFILLER_461_0 VPWR VGND sg13cmos5l_decap_8
XFILLER_614_146 VPWR VGND sg13cmos5l_fill_1
XFILLER_559_0 VPWR VGND sg13cmos5l_decap_8
XFILLER_480_141 VPWR VGND sg13cmos5l_fill_1
XFILLER_501_28 VPWR VGND sg13cmos5l_decap_8
XFILLER_614_168 VPWR VGND sg13cmos5l_decap_8
XFILLER_217_160 VPWR VGND sg13cmos5l_decap_8
XFILLER_431_91 VPWR VGND sg13cmos5l_decap_8
XFILLER_232_174 VPWR VGND sg13cmos5l_decap_4
XFILLER_657_21 VPWR VGND sg13cmos5l_decap_8
XFILLER_300_73 VPWR VGND sg13cmos5l_decap_4
X_0961_ _0961_/Q Tile_X0Y0_FrameData[10] VGND VPWR Tile_X0Y9_FrameStrobe[0] latch
XFILLER_300_84 VPWR VGND sg13cmos5l_decap_8
X_2700_ _3976_/A3 VPWR VGND sg13cmos5l_tielo
X_3680_ _3680_/X Tile_X0Y2_WW4END[2] Tile_X0Y2_WW4END[10] Tile_X0Y2_W6END[10] _4126_/X
+ _1485_/Q _1484_/Q VPWR VGND sg13cmos5l_mux4_1
XFILLER_657_98 VPWR VGND sg13cmos5l_decap_8
X_0892_ _0892_/Q Tile_X0Y9_FrameData[3] VGND VPWR Tile_X0Y9_FrameStrobe[6] latch
XFILLER_229_49 VPWR VGND sg13cmos5l_decap_8
X_2631_ _2631_/Q Tile_X0Y6_FrameData[0] VGND VPWR Tile_X0Y9_FrameStrobe[5] latch
XFILLER_535_175 VPWR VGND sg13cmos5l_fill_2
XFILLER_526_14 VPWR VGND sg13cmos5l_decap_8
XFILLER_696_105 VPWR VGND sg13cmos5l_decap_8
XANTENNA__3337__X Tile_X0Y2_FrameData_O[8] VPWR VGND sg13cmos5l_antennanp
XFILLER_673_42 VPWR VGND sg13cmos5l_decap_8
X_2562_ _2562_/Q Tile_X0Y6_FrameData[5] VGND VPWR Tile_X0Y9_FrameStrobe[3] latch
XFILLER_696_149 VPWR VGND sg13cmos5l_fill_1
XFILLER_392_21 VPWR VGND sg13cmos5l_decap_8
X_4301_ _4301_/X Tile_X0Y3_W1END[0] Tile_X0Y3_W6END[8] _4234_/X _4198_/X _1889_/Q
+ _1888_/Q VPWR VGND sg13cmos5l_mux4_1
X_1513_ _1513_/Q Tile_X0Y2_FrameData[8] VGND VPWR Tile_X0Y9_FrameStrobe[2] latch
XFILLER_302_101 VPWR VGND sg13cmos5l_decap_8
XFILLER_153_170 VPWR VGND sg13cmos5l_decap_8
X_2493_ _2493_/Q Tile_X0Y6_FrameData[10] VGND VPWR Tile_X0Y9_FrameStrobe[1] latch
X_4232_ _4232_/X _4200_/X _0087_/X _4199_/X Tile_X0Y0_S4END[14] _1709_/Q _1708_/Q
+ VPWR VGND sg13cmos5l_mux4_1
XFILLER_448_138 VPWR VGND sg13cmos5l_decap_8
X_1444_ _1444_/Q Tile_X0Y2_FrameData[13] VGND VPWR Tile_X0Y9_FrameStrobe[0] latch
XFILLER_542_35 VPWR VGND sg13cmos5l_decap_8
XFILLER_325_70 VPWR VGND sg13cmos5l_decap_8
XFILLER_302_167 VPWR VGND sg13cmos5l_fill_2
XFILLER_4_84 VPWR VGND sg13cmos5l_decap_8
X_1375_ _1375_/Q Tile_X0Y1_FrameData[26] VGND VPWR Tile_X0Y9_FrameStrobe[6] latch
X_4163_ _4163_/X Tile_X0Y3_W2END[0] AXI_M_SOC_WREADY _4205_/X _4204_/X _1815_/Q _1814_/Q
+ VPWR VGND sg13cmos5l_mux4_1
XFILLER_261_14 VPWR VGND sg13cmos5l_decap_8
XANTENNA__3072__X Tile_X0Y5_FrameData_O[31] VPWR VGND sg13cmos5l_antennanp
XFILLER_456_160 VPWR VGND sg13cmos5l_decap_8
XFILLER_255_211 VPWR VGND sg13cmos5l_fill_1
XFILLER_67_143 VPWR VGND sg13cmos5l_decap_8
X_0326_ _0326_/Q Tile_X0Y7_FrameData[25] VGND VPWR Tile_X0Y9_FrameStrobe[5] latch
X_3114_ Tile_X0Y7_EE4BEG[0] _4628_/X VPWR VGND sg13cmos5l_buf_1
XFILLER_82_102 VPWR VGND sg13cmos5l_decap_8
X_4094_ _4094_/X Tile_X0Y1_W1END[3] Tile_X0Y1_W6END[11] _3996_/X _3979_/X _1383_/Q
+ _1382_/Q VPWR VGND sg13cmos5l_mux4_1
XFILLER_67_176 VPWR VGND sg13cmos5l_decap_8
XFILLER_605_146 VPWR VGND sg13cmos5l_decap_4
XFILLER_471_141 VPWR VGND sg13cmos5l_fill_2
XFILLER_411_28 VPWR VGND sg13cmos5l_decap_8
X_0257_ _0257_/Q Tile_X0Y7_FrameData[30] VGND VPWR Tile_X0Y9_FrameStrobe[3] latch
X_3045_ Tile_X0Y5_FrameData_O[4] Tile_X0Y5_FrameData[4] VPWR VGND sg13cmos5l_buf_1
XFILLER_270_203 VPWR VGND sg13cmos5l_decap_4
XFILLER_82_146 VPWR VGND sg13cmos5l_decap_8
XFILLER_620_105 VPWR VGND sg13cmos5l_decap_8
XFILLER_208_171 VPWR VGND sg13cmos5l_decap_8
XFILLER_82_157 VPWR VGND sg13cmos5l_fill_1
XFILLER_341_91 VPWR VGND sg13cmos5l_decap_8
X_0188_ _0188_/Q Tile_X0Y7_FrameData[3] VGND VPWR Tile_X0Y9_FrameStrobe[0] latch
XFILLER_223_130 VPWR VGND sg13cmos5l_decap_8
XFILLER_223_163 VPWR VGND sg13cmos5l_fill_1
XFILLER_369_156 VPWR VGND sg13cmos5l_decap_8
XFILLER_168_207 VPWR VGND sg13cmos5l_decap_8
XFILLER_567_21 VPWR VGND sg13cmos5l_decap_8
XFILLER_210_62 VPWR VGND sg13cmos5l_decap_8
X_3947_ _3947_/X Tile_X0Y1_W2END[0] AXI_M_SOC_ARREADY _3989_/X _3988_/X _1315_/Q _1314_/Q
+ VPWR VGND sg13cmos5l_mux4_1
XFILLER_384_137 VPWR VGND sg13cmos5l_decap_8
XFILLER_23_49 VPWR VGND sg13cmos5l_decap_4
XFILLER_526_120 VPWR VGND sg13cmos5l_decap_4
XFILLER_567_98 VPWR VGND sg13cmos5l_decap_8
X_3878_ _3878_/X _4343_/X _4347_/X _4351_/X _4319_/X _2148_/Q _2147_/Q VPWR VGND sg13cmos5l_mux4_1
XFILLER_139_49 VPWR VGND sg13cmos5l_decap_8
XFILLER_325_215 VPWR VGND sg13cmos5l_fill_2
XFILLER_286_77 VPWR VGND sg13cmos5l_decap_8
XFILLER_136_126 VPWR VGND sg13cmos5l_decap_8
X_2829_ Tile_X0Y4_E2BEG[7] _4263_/X VPWR VGND sg13cmos5l_buf_1
XANTENNA__3247__X Tile_X0Y0_FrameData_O[15] VPWR VGND sg13cmos5l_antennanp
XFILLER_583_42 VPWR VGND sg13cmos5l_decap_8
XFILLER_436_69 VPWR VGND sg13cmos5l_decap_8
XFILLER_151_129 VPWR VGND sg13cmos5l_decap_8
XFILLER_452_35 VPWR VGND sg13cmos5l_decap_8
XFILLER_58_110 VPWR VGND sg13cmos5l_decap_8
XFILLER_171_14 VPWR VGND sg13cmos5l_decap_8
XFILLER_48_57 VPWR VGND sg13cmos5l_decap_8
XFILLER_385_7 VPWR VGND sg13cmos5l_decap_8
XFILLER_602_49 VPWR VGND sg13cmos5l_decap_4
XFILLER_73_102 VPWR VGND sg13cmos5l_decap_8
XFILLER_58_187 VPWR VGND sg13cmos5l_decap_8
XFILLER_58_198 VPWR VGND sg13cmos5l_fill_2
XFILLER_552_7 VPWR VGND sg13cmos5l_decap_8
XFILLER_321_28 VPWR VGND sg13cmos5l_fill_1
XFILLER_64_23 VPWR VGND sg13cmos5l_decap_8
XANTENNA__3710__X AXI_M_SOC_WDATA20 VPWR VGND sg13cmos5l_antennanp
XFILLER_104_96 VPWR VGND sg13cmos5l_decap_8
XFILLER_611_149 VPWR VGND sg13cmos5l_decap_8
XFILLER_214_141 VPWR VGND sg13cmos5l_decap_8
XFILLER_214_152 VPWR VGND sg13cmos5l_fill_2
XFILLER_401_83 VPWR VGND sg13cmos5l_decap_8
XFILLER_154_2 VPWR VGND sg13cmos5l_fill_1
XFILLER_477_21 VPWR VGND sg13cmos5l_decap_8
XFILLER_375_126 VPWR VGND sg13cmos5l_decap_4
XFILLER_375_159 VPWR VGND sg13cmos5l_decap_8
XFILLER_80_77 VPWR VGND sg13cmos5l_decap_8
XFILLER_517_142 VPWR VGND sg13cmos5l_decap_4
XFILLER_627_35 VPWR VGND sg13cmos5l_decap_8
XFILLER_196_55 VPWR VGND sg13cmos5l_decap_8
XFILLER_127_104 VPWR VGND sg13cmos5l_decap_4
XFILLER_316_204 VPWR VGND sg13cmos5l_decap_4
XFILLER_127_115 VPWR VGND sg13cmos5l_fill_2
XFILLER_316_215 VPWR VGND sg13cmos5l_fill_2
XFILLER_346_14 VPWR VGND sg13cmos5l_decap_8
XFILLER_517_197 VPWR VGND sg13cmos5l_decap_8
XANTENNA__3157__X Tile_X0Y7_FrameData_O[27] VPWR VGND sg13cmos5l_antennanp
XFILLER_493_42 VPWR VGND sg13cmos5l_decap_8
XFILLER_307_0 VPWR VGND sg13cmos5l_decap_8
XFILLER_129_82 VPWR VGND sg13cmos5l_fill_1
XFILLER_331_207 VPWR VGND sg13cmos5l_fill_2
XANTENNA__2996__X Tile_X0Y5_E1BEG[3] VPWR VGND sg13cmos5l_antennanp
XFILLER_135_192 VPWR VGND sg13cmos5l_decap_8
XFILLER_643_56 VPWR VGND sg13cmos5l_decap_8
XFILLER_426_91 VPWR VGND sg13cmos5l_decap_8
XFILLER_296_144 VPWR VGND sg13cmos5l_decap_8
XFILLER_362_35 VPWR VGND sg13cmos5l_decap_8
XFILLER_150_162 VPWR VGND sg13cmos5l_decap_8
XFILLER_676_0 VPWR VGND sg13cmos5l_decap_8
XFILLER_145_92 VPWR VGND sg13cmos5l_decap_8
XFILLER_1_183 VPWR VGND sg13cmos5l_fill_1
X_1160_ _1160_/Q Tile_X0Y0_FrameData[3] VGND VPWR Tile_X0Y9_FrameStrobe[6] latch
XFILLER_599_101 VPWR VGND sg13cmos5l_decap_8
XFILLER_512_49 VPWR VGND sg13cmos5l_decap_8
XFILLER_49_176 VPWR VGND sg13cmos5l_fill_1
XFILLER_453_141 VPWR VGND sg13cmos5l_fill_2
X_0111_ _0111_/X _4324_/X _4325_/X _1112_/Q VPWR VGND sg13cmos5l_mux2_1
XFILLER_252_203 VPWR VGND sg13cmos5l_decap_4
XFILLER_231_28 VPWR VGND sg13cmos5l_fill_2
X_1091_ _1091_/Q Tile_X0Y0_FrameData[8] VGND VPWR Tile_X0Y9_FrameStrobe[4] latch
XFILLER_64_135 VPWR VGND sg13cmos5l_decap_8
XFILLER_161_80 VPWR VGND sg13cmos5l_decap_8
XANTENNA__3620__X Tile_X0Y9_S2BEGb[6] VPWR VGND sg13cmos5l_antennanp
XFILLER_602_116 VPWR VGND sg13cmos5l_fill_1
X_0042_ _3631_/A _4718_/X _4719_/X _0606_/Q VPWR VGND sg13cmos5l_mux2_1
XFILLER_602_149 VPWR VGND sg13cmos5l_fill_2
X_4850_ _4850_/X Tile_X0Y9_W2MID[5] AXI_M_SOC_RDATA2 _4905_/X _4904_/X _0843_/Q _0842_/Q
+ VPWR VGND sg13cmos5l_mux4_1
XFILLER_610_160 VPWR VGND sg13cmos5l_decap_8
XFILLER_387_21 VPWR VGND sg13cmos5l_decap_8
XFILLER_668_75 VPWR VGND sg13cmos5l_decap_8
XFILLER_610_171 VPWR VGND sg13cmos5l_fill_2
X_3801_ _3801_/X _3849_/X Tile_X0Y0_W2END[4] Tile_X0Y0_W2END[5] Tile_X0Y0_S1END[1]
+ _1103_/Q _1102_/Q VPWR VGND sg13cmos5l_mux4_1
XFILLER_555_215 VPWR VGND sg13cmos5l_fill_2
X_4781_ _4781_/X Tile_X0Y9_W1END[2] Tile_X0Y9_W6END[6] _4930_/X _4894_/X _0923_/Q
+ _0922_/Q VPWR VGND sg13cmos5l_mux4_1
XFILLER_610_193 VPWR VGND sg13cmos5l_decap_4
XFILLER_220_144 VPWR VGND sg13cmos5l_decap_8
X_1993_ _1993_/Q Tile_X0Y4_FrameData[28] VGND VPWR Tile_X0Y9_FrameStrobe[2] latch
XFILLER_366_137 VPWR VGND sg13cmos5l_fill_1
XFILLER_387_76 VPWR VGND sg13cmos5l_fill_1
XFILLER_220_177 VPWR VGND sg13cmos5l_decap_8
X_3732_ AXI_M_SOC_ARADDR4 Tile_X0Y9_WW4END[4] Tile_X0Y9_WW4END[12] Tile_X0Y9_W6END[4]
+ _4920_/X _0751_/Q _0750_/Q VPWR VGND sg13cmos5l_mux4_1
X_0944_ _0944_/Q Tile_X0Y0_FrameData[27] VGND VPWR Tile_X0Y9_FrameStrobe[0] latch
XFILLER_508_142 VPWR VGND sg13cmos5l_decap_8
XFILLER_537_35 VPWR VGND sg13cmos5l_decap_8
XFILLER_118_104 VPWR VGND sg13cmos5l_fill_2
XFILLER_684_63 VPWR VGND sg13cmos5l_decap_8
XFILLER_523_101 VPWR VGND sg13cmos5l_decap_8
X_3663_ AXI_M_SOC_AWADDR24 Tile_X0Y4_WW4END[0] Tile_X0Y4_WW4END[8] Tile_X0Y4_W6END[8]
+ _4344_/X _1997_/Q _1996_/Q VPWR VGND sg13cmos5l_mux4_1
XFILLER_374_181 VPWR VGND sg13cmos5l_decap_4
XFILLER_256_14 VPWR VGND sg13cmos5l_decap_8
X_0875_ _0875_/Q Tile_X0Y9_FrameData[20] VGND VPWR Tile_X0Y9_FrameStrobe[6] latch
XFILLER_669_105 VPWR VGND sg13cmos5l_decap_8
XFILLER_118_148 VPWR VGND sg13cmos5l_decap_4
XANTENNA__3067__X Tile_X0Y5_FrameData_O[26] VPWR VGND sg13cmos5l_antennanp
X_2614_ _2614_/Q Tile_X0Y6_FrameData[17] VGND VPWR Tile_X0Y9_FrameStrobe[5] latch
XFILLER_133_107 VPWR VGND sg13cmos5l_fill_1
X_3594_ Tile_X0Y9_FrameData_O[24] Tile_X0Y9_FrameData[24] VPWR VGND sg13cmos5l_buf_1
XFILLER_55_0 VPWR VGND sg13cmos5l_fill_2
X_2545_ _2545_/Q Tile_X0Y6_FrameData[22] VGND VPWR Tile_X0Y9_FrameStrobe[3] latch
XFILLER_684_108 VPWR VGND sg13cmos5l_decap_8
XFILLER_406_28 VPWR VGND sg13cmos5l_decap_8
XFILLER_553_56 VPWR VGND sg13cmos5l_decap_8
X_2476_ _2476_/Q Tile_X0Y6_FrameData[27] VGND VPWR Tile_X0Y9_FrameStrobe[1] latch
XFILLER_677_193 VPWR VGND sg13cmos5l_decap_8
XFILLER_272_35 VPWR VGND sg13cmos5l_decap_8
X_4215_ _4215_/X _4200_/X _0087_/X _4199_/X Tile_X0Y0_S4END[14] _1701_/Q _1700_/Q
+ VPWR VGND sg13cmos5l_mux4_1
X_1427_ _1427_/Q Tile_X0Y2_FrameData[30] VGND VPWR Tile_X0Y9_FrameStrobe[0] latch
XFILLER_287_188 VPWR VGND sg13cmos5l_decap_8
X_4146_ _4146_/X _4200_/X _4199_/X AXI_M_SOC_BVALID _4198_/X _1849_/Q _1848_/Q VPWR
+ VGND sg13cmos5l_mux4_1
X_1358_ _1358_/Q Tile_X0Y1_FrameData[11] VGND VPWR Tile_X0Y9_FrameStrobe[5] latch
XFILLER_55_102 VPWR VGND sg13cmos5l_decap_8
XFILLER_422_49 VPWR VGND sg13cmos5l_decap_8
XFILLER_205_84 VPWR VGND sg13cmos5l_decap_8
XFILLER_18_49 VPWR VGND sg13cmos5l_decap_8
X_0309_ _0309_/Q Tile_X0Y7_FrameData[10] VGND VPWR Tile_X0Y9_FrameStrobe[4] latch
X_4077_ _4077_/X AXI_M_SOC_AWREADY _4122_/X _4126_/X _4099_/X _1519_/Q _1518_/Q VPWR
+ VGND sg13cmos5l_mux4_1
X_1289_ _1289_/Q Tile_X0Y1_FrameData[16] VGND VPWR Tile_X0Y9_FrameStrobe[3] latch
XANTENNA__3530__X Tile_X0Y9_E2BEG[4] VPWR VGND sg13cmos5l_antennanp
X_3028_ Tile_X0Y5_EE4BEG[3] _4391_/X VPWR VGND sg13cmos5l_buf_1
XFILLER_578_42 VPWR VGND sg13cmos5l_decap_8
XFILLER_34_48 VPWR VGND sg13cmos5l_decap_8
XFILLER_400_211 VPWR VGND sg13cmos5l_fill_1
XFILLER_297_21 VPWR VGND sg13cmos5l_decap_8
XFILLER_211_133 VPWR VGND sg13cmos5l_decap_8
XFILLER_357_126 VPWR VGND sg13cmos5l_decap_8
XFILLER_133_7 VPWR VGND sg13cmos5l_decap_8
XFILLER_297_98 VPWR VGND sg13cmos5l_decap_4
XFILLER_447_35 VPWR VGND sg13cmos5l_decap_8
XFILLER_164_210 VPWR VGND sg13cmos5l_decap_8
XFILLER_703_201 VPWR VGND sg13cmos5l_fill_2
XFILLER_447_68 VPWR VGND sg13cmos5l_fill_2
XFILLER_166_14 VPWR VGND sg13cmos5l_decap_8
XFILLER_109_137 VPWR VGND sg13cmos5l_decap_8
XFILLER_50_58 VPWR VGND sg13cmos5l_decap_8
XFILLER_300_7 VPWR VGND sg13cmos5l_decap_8
XFILLER_514_167 VPWR VGND sg13cmos5l_fill_1
XFILLER_514_189 VPWR VGND sg13cmos5l_fill_1
XFILLER_675_108 VPWR VGND sg13cmos5l_fill_2
XFILLER_316_28 VPWR VGND sg13cmos5l_decap_8
XANTENNA__3705__X AXI_M_SOC_WDATA15 VPWR VGND sg13cmos5l_antennanp
XFILLER_182_13 VPWR VGND sg13cmos5l_decap_8
XFILLER_132_140 VPWR VGND sg13cmos5l_fill_2
XFILLER_668_193 VPWR VGND sg13cmos5l_fill_1
XFILLER_59_67 VPWR VGND sg13cmos5l_decap_8
XFILLER_463_89 VPWR VGND sg13cmos5l_decap_4
XFILLER_683_152 VPWR VGND sg13cmos5l_fill_1
XFILLER_482_203 VPWR VGND sg13cmos5l_fill_2
XFILLER_427_119 VPWR VGND sg13cmos5l_decap_8
XFILLER_293_114 VPWR VGND sg13cmos5l_decap_8
XFILLER_219_200 VPWR VGND sg13cmos5l_decap_8
XFILLER_683_174 VPWR VGND sg13cmos5l_decap_4
XFILLER_219_211 VPWR VGND sg13cmos5l_fill_1
XFILLER_332_49 VPWR VGND sg13cmos5l_decap_8
XFILLER_435_152 VPWR VGND sg13cmos5l_decap_8
XFILLER_450_100 VPWR VGND sg13cmos5l_decap_8
XANTENNA__3440__X Tile_X0Y4_FrameData_O[31] VPWR VGND sg13cmos5l_antennanp
XFILLER_596_126 VPWR VGND sg13cmos5l_decap_8
XFILLER_61_116 VPWR VGND sg13cmos5l_decap_8
XFILLER_91_21 VPWR VGND sg13cmos5l_decap_8
XFILLER_257_0 VPWR VGND sg13cmos5l_decap_8
XFILLER_488_42 VPWR VGND sg13cmos5l_decap_8
XFILLER_131_83 VPWR VGND sg13cmos5l_decap_8
XFILLER_348_126 VPWR VGND sg13cmos5l_decap_8
XFILLER_202_144 VPWR VGND sg13cmos5l_decap_8
XFILLER_424_0 VPWR VGND sg13cmos5l_decap_8
XFILLER_348_148 VPWR VGND sg13cmos5l_decap_8
XFILLER_638_56 VPWR VGND sg13cmos5l_decap_8
XFILLER_357_35 VPWR VGND sg13cmos5l_decap_8
XFILLER_155_210 VPWR VGND sg13cmos5l_fill_1
XFILLER_371_140 VPWR VGND sg13cmos5l_decap_8
X_0660_ _0660_/Q Tile_X0Y8_FrameData[11] VGND VPWR Tile_X0Y9_FrameStrobe[7] latch
XFILLER_507_49 VPWR VGND sg13cmos5l_decap_8
XFILLER_115_129 VPWR VGND sg13cmos5l_decap_8
XFILLER_654_77 VPWR VGND sg13cmos5l_decap_8
X_0591_ _0591_/Q Tile_X0Y8_FrameData[16] VGND VPWR Tile_X0Y9_FrameStrobe[5] latch
XANTENNA__3615__X Tile_X0Y9_S2BEGb[1] VPWR VGND sg13cmos5l_antennanp
X_2330_ _2330_/Q Tile_X0Y5_FrameData[11] VGND VPWR Tile_X0Y9_FrameStrobe[4] latch
XFILLER_670_21 VPWR VGND sg13cmos5l_decap_8
X_2261_ _2261_/Q Tile_X0Y5_FrameData[16] VGND VPWR Tile_X0Y9_FrameStrobe[2] latch
XFILLER_418_119 VPWR VGND sg13cmos5l_fill_2
XFILLER_84_208 VPWR VGND sg13cmos5l_decap_8
X_4000_ _4000_/X Tile_X0Y5_W1END[1] Tile_X0Y5_WW4END[1] Tile_X0Y5_W6END[9] _4452_/X
+ _2412_/Q _2411_/Q VPWR VGND sg13cmos5l_mux4_1
XFILLER_242_27 VPWR VGND sg13cmos5l_decap_4
X_1212_ _1212_/Q Tile_X0Y1_FrameData[29] VGND VPWR Tile_X0Y9_FrameStrobe[1] latch
XFILLER_284_147 VPWR VGND sg13cmos5l_decap_8
X_2192_ _2192_/Q Tile_X0Y5_FrameData[21] VGND VPWR Tile_X0Y9_FrameStrobe[0] latch
XFILLER_670_98 VPWR VGND sg13cmos5l_fill_1
XFILLER_172_90 VPWR VGND sg13cmos5l_fill_2
X_1143_ _1143_/Q Tile_X0Y0_FrameData[20] VGND VPWR Tile_X0Y9_FrameStrobe[6] latch
XFILLER_1_63 VPWR VGND sg13cmos5l_decap_8
XANTENNA__3350__X Tile_X0Y2_FrameData_O[21] VPWR VGND sg13cmos5l_antennanp
X_1074_ _1074_/Q Tile_X0Y0_FrameData[25] VGND VPWR Tile_X0Y9_FrameStrobe[4] latch
XFILLER_679_63 VPWR VGND sg13cmos5l_decap_8
XFILLER_322_93 VPWR VGND sg13cmos5l_decap_8
XFILLER_441_166 VPWR VGND sg13cmos5l_decap_8
XFILLER_240_206 VPWR VGND sg13cmos5l_decap_4
X_4902_ _4902_/X Tile_X0Y9_N2MID[6] Tile_X0Y9_N2END[6] _4938_/X _4822_/X _0683_/Q
+ _0682_/Q VPWR VGND sg13cmos5l_mux4_1
XFILLER_398_42 VPWR VGND sg13cmos5l_fill_2
XFILLER_240_217 VPWR VGND sg13cmos5l_fill_1
X_4833_ _4833_/X Tile_X0Y9_W1END[1] Tile_X0Y9_W2MID[2] Tile_X0Y9_W2END[2] _4904_/X
+ _0873_/Q _0872_/Q VPWR VGND sg13cmos5l_mux4_1
XFILLER_528_215 VPWR VGND sg13cmos5l_fill_2
XFILLER_60_182 VPWR VGND sg13cmos5l_decap_8
XFILLER_548_56 VPWR VGND sg13cmos5l_decap_8
X_4764_ _4764_/X AXI_M_SOC_RDATA8 _4807_/X _4811_/X _4785_/X _0519_/Q _0518_/Q VPWR
+ VGND sg13cmos5l_mux4_1
X_1976_ _1976_/Q Tile_X0Y4_FrameData[13] VGND VPWR Tile_X0Y9_FrameStrobe[1] latch
XFILLER_695_84 VPWR VGND sg13cmos5l_decap_8
XFILLER_267_35 VPWR VGND sg13cmos5l_decap_8
X_3715_ AXI_M_SOC_WDATA25 Tile_X0Y6_WW4END[1] Tile_X0Y6_WW4END[9] Tile_X0Y6_W6END[9]
+ _4577_/X _2509_/Q _2508_/Q VPWR VGND sg13cmos5l_mux4_1
X_0927_ _0927_/Q Tile_X0Y9_FrameData[0] VGND VPWR Tile_X0Y9_FrameStrobe[7] latch
X_4695_ _4695_/X _4667_/X Tile_X0Y9_N4END[11] _4666_/X _0053_/X _0193_/Q _0192_/Q
+ VPWR VGND sg13cmos5l_mux4_1
X_3646_ AXI_M_SOC_AWADDR7 Tile_X0Y5_WW4END[7] Tile_X0Y5_WW4END[15] Tile_X0Y5_W6END[7]
+ _4458_/X _2257_/Q _2256_/Q VPWR VGND sg13cmos5l_mux4_1
X_0858_ _0858_/Q Tile_X0Y9_FrameData[5] VGND VPWR Tile_X0Y9_FrameStrobe[5] latch
XFILLER_417_49 VPWR VGND sg13cmos5l_decap_8
XFILLER_20_28 VPWR VGND sg13cmos5l_decap_8
XFILLER_564_77 VPWR VGND sg13cmos5l_decap_8
XFILLER_714_14 VPWR VGND sg13cmos5l_decap_8
XFILLER_136_28 VPWR VGND sg13cmos5l_decap_8
X_3577_ Tile_X0Y9_FrameData_O[7] Tile_X0Y9_FrameData[7] VPWR VGND sg13cmos5l_buf_1
XFILLER_657_119 VPWR VGND sg13cmos5l_decap_4
X_0789_ _0789_/Q Tile_X0Y9_FrameData[10] VGND VPWR Tile_X0Y9_FrameStrobe[3] latch
XFILLER_283_56 VPWR VGND sg13cmos5l_decap_8
XANTENNA__3525__X Tile_X0Y9_E1BEG[3] VPWR VGND sg13cmos5l_antennanp
X_2528_ _2528_/Q Tile_X0Y6_FrameData[7] VGND VPWR Tile_X0Y9_FrameStrobe[2] latch
XFILLER_580_21 VPWR VGND sg13cmos5l_decap_8
XFILLER_464_203 VPWR VGND sg13cmos5l_fill_2
X_2459_ _2459_/Q Tile_X0Y6_FrameData[12] VGND VPWR Tile_X0Y9_FrameStrobe[0] latch
XFILLER_680_100 VPWR VGND sg13cmos5l_fill_1
XFILLER_580_76 VPWR VGND sg13cmos5l_decap_8
XFILLER_152_49 VPWR VGND sg13cmos5l_decap_8
XFILLER_513_70 VPWR VGND sg13cmos5l_decap_8
X_4129_ _4129_/X Tile_X0Y4_W2MID[7] Tile_X0Y4_W2END[7] Tile_X0Y4_W6END[7] _4313_/X
+ _2173_/Q _2172_/Q VPWR VGND sg13cmos5l_mux4_1
XANTENNA__3260__X Tile_X0Y0_FrameData_O[28] VPWR VGND sg13cmos5l_antennanp
XFILLER_589_63 VPWR VGND sg13cmos5l_decap_8
XFILLER_578_126 VPWR VGND sg13cmos5l_fill_2
XFILLER_432_177 VPWR VGND sg13cmos5l_decap_8
XFILLER_250_7 VPWR VGND sg13cmos5l_decap_8
XFILLER_348_7 VPWR VGND sg13cmos5l_decap_8
XFILLER_519_215 VPWR VGND sg13cmos5l_fill_2
XFILLER_61_13 VPWR VGND sg13cmos5l_fill_2
XFILLER_196_165 VPWR VGND sg13cmos5l_fill_1
XFILLER_515_7 VPWR VGND sg13cmos5l_decap_8
XFILLER_196_187 VPWR VGND sg13cmos5l_decap_8
XFILLER_177_35 VPWR VGND sg13cmos5l_decap_8
XANTENNA__0124__X AXI_M_SOC_ARSIZE1 VPWR VGND sg13cmos5l_antennanp
XFILLER_353_140 VPWR VGND sg13cmos5l_decap_8
XFILLER_499_133 VPWR VGND sg13cmos5l_decap_8
XFILLER_298_217 VPWR VGND sg13cmos5l_fill_1
XFILLER_502_126 VPWR VGND sg13cmos5l_decap_8
XFILLER_193_34 VPWR VGND sg13cmos5l_decap_8
XFILLER_648_119 VPWR VGND sg13cmos5l_decap_8
XFILLER_624_14 VPWR VGND sg13cmos5l_decap_8
XFILLER_499_199 VPWR VGND sg13cmos5l_fill_2
XANTENNA__3435__X Tile_X0Y4_FrameData_O[26] VPWR VGND sg13cmos5l_antennanp
XFILLER_407_82 VPWR VGND sg13cmos5l_decap_8
XFILLER_105_151 VPWR VGND sg13cmos5l_decap_8
XFILLER_490_21 VPWR VGND sg13cmos5l_decap_8
XFILLER_86_21 VPWR VGND sg13cmos5l_decap_8
XFILLER_120_143 VPWR VGND sg13cmos5l_decap_8
XFILLER_266_136 VPWR VGND sg13cmos5l_decap_8
XFILLER_86_65 VPWR VGND sg13cmos5l_fill_1
XFILLER_704_91 VPWR VGND sg13cmos5l_decap_8
XFILLER_671_133 VPWR VGND sg13cmos5l_decap_8
XFILLER_490_98 VPWR VGND sg13cmos5l_decap_8
XFILLER_86_87 VPWR VGND sg13cmos5l_decap_8
XFILLER_640_35 VPWR VGND sg13cmos5l_decap_8
XFILLER_423_70 VPWR VGND sg13cmos5l_decap_8
XFILLER_374_0 VPWR VGND sg13cmos5l_decap_8
XANTENNA__3170__X Tile_X0Y4_E6BEG[7] VPWR VGND sg13cmos5l_antennanp
XFILLER_569_126 VPWR VGND sg13cmos5l_decap_8
XFILLER_499_63 VPWR VGND sg13cmos5l_decap_8
XFILLER_541_0 VPWR VGND sg13cmos5l_decap_8
XFILLER_639_0 VPWR VGND sg13cmos5l_decap_8
XFILLER_222_217 VPWR VGND sg13cmos5l_fill_1
XFILLER_649_77 VPWR VGND sg13cmos5l_decap_8
XFILLER_96_7 VPWR VGND sg13cmos5l_decap_8
XFILLER_577_192 VPWR VGND sg13cmos5l_decap_8
XFILLER_187_154 VPWR VGND sg13cmos5l_fill_1
X_1830_ _1830_/Q Tile_X0Y3_FrameData[3] VGND VPWR Tile_X0Y9_FrameStrobe[4] latch
XFILLER_336_107 VPWR VGND sg13cmos5l_decap_8
XFILLER_592_162 VPWR VGND sg13cmos5l_decap_8
XFILLER_391_202 VPWR VGND sg13cmos5l_decap_4
XFILLER_665_21 VPWR VGND sg13cmos5l_decap_8
X_1761_ _1761_/Q Tile_X0Y3_FrameData[8] VGND VPWR Tile_X0Y9_FrameStrobe[2] latch
X_3500_ Tile_X0Y1_E6BEG[10] _3974_/X VPWR VGND sg13cmos5l_buf_1
XFILLER_51_90 VPWR VGND sg13cmos5l_decap_8
X_0712_ _0712_/Q Tile_X0Y9_FrameData[23] VGND VPWR Tile_X0Y9_FrameStrobe[1] latch
X_4480_ _4480_/X Tile_X0Y4_W1END[2] Tile_X0Y4_W2MID[1] Tile_X0Y4_W2END[1] _4314_/X
+ _2125_/Q _2124_/Q VPWR VGND sg13cmos5l_mux4_1
XFILLER_665_98 VPWR VGND sg13cmos5l_decap_8
X_1692_ _1692_/Q Tile_X0Y3_FrameData[13] VGND VPWR Tile_X0Y9_FrameStrobe[0] latch
XFILLER_289_217 VPWR VGND sg13cmos5l_fill_1
X_3431_ Tile_X0Y4_FrameData_O[22] Tile_X0Y4_FrameData[22] VPWR VGND sg13cmos5l_buf_1
X_0643_ _0643_/Q Tile_X0Y8_FrameData[28] VGND VPWR Tile_X0Y9_FrameStrobe[7] latch
XFILLER_534_14 VPWR VGND sg13cmos5l_decap_8
XFILLER_639_119 VPWR VGND sg13cmos5l_decap_8
XFILLER_384_99 VPWR VGND sg13cmos5l_decap_4
XANTENNA__3345__X Tile_X0Y2_FrameData_O[16] VPWR VGND sg13cmos5l_antennanp
XFILLER_681_42 VPWR VGND sg13cmos5l_decap_8
X_3362_ Tile_X0Y2_EE4BEG[1] _4057_/X VPWR VGND sg13cmos5l_buf_1
X_0574_ _0574_/Q Tile_X0Y8_FrameData[1] VGND VPWR Tile_X0Y9_FrameStrobe[4] latch
X_2313_ _2313_/Q Tile_X0Y5_FrameData[28] VGND VPWR Tile_X0Y9_FrameStrobe[4] latch
XFILLER_300_210 VPWR VGND sg13cmos5l_decap_8
X_3293_ Tile_X0Y0_E2BEGb[1] _3813_/X VPWR VGND sg13cmos5l_buf_1
XFILLER_257_125 VPWR VGND sg13cmos5l_decap_4
XFILLER_647_196 VPWR VGND sg13cmos5l_decap_8
X_2244_ _2244_/Q Tile_X0Y5_FrameData[1] VGND VPWR Tile_X0Y9_FrameStrobe[1] latch
XFILLER_550_35 VPWR VGND sg13cmos5l_decap_8
XFILLER_18_0 VPWR VGND sg13cmos5l_decap_8
X_2175_ _2175_/Q Tile_X0Y4_FrameData[6] VGND VPWR Tile_X0Y9_FrameStrobe[7] latch
XANTENNA__3080__X Tile_X0Y4_E2BEGb[6] VPWR VGND sg13cmos5l_antennanp
X_1126_ _1126_/Q Tile_X0Y0_FrameData[5] VGND VPWR Tile_X0Y9_FrameStrobe[5] latch
XFILLER_700_49 VPWR VGND sg13cmos5l_decap_8
XFILLER_280_161 VPWR VGND sg13cmos5l_decap_8
XFILLER_202_63 VPWR VGND sg13cmos5l_decap_8
X_1057_ _1057_/Q Tile_X0Y0_FrameData[10] VGND VPWR Tile_X0Y9_FrameStrobe[3] latch
XFILLER_15_28 VPWR VGND sg13cmos5l_decap_8
XFILLER_178_110 VPWR VGND sg13cmos5l_decap_8
XFILLER_559_77 VPWR VGND sg13cmos5l_decap_8
XFILLER_709_14 VPWR VGND sg13cmos5l_decap_8
XFILLER_278_56 VPWR VGND sg13cmos5l_decap_8
X_4816_ _4816_/X Tile_X0Y7_W2MID[7] Tile_X0Y7_W2END[7] Tile_X0Y7_W6END[8] _4669_/X
+ _0371_/Q _0370_/Q VPWR VGND sg13cmos5l_mux4_1
XFILLER_583_140 VPWR VGND sg13cmos5l_decap_8
XFILLER_575_21 VPWR VGND sg13cmos5l_decap_8
XFILLER_382_213 VPWR VGND sg13cmos5l_decap_4
XFILLER_193_124 VPWR VGND sg13cmos5l_decap_8
XFILLER_178_198 VPWR VGND sg13cmos5l_decap_8
X_4747_ _4747_/X Tile_X0Y8_WW4END[12] AXI_M_SOC_RDATA11 _4812_/X _4790_/X _0553_/Q
+ _0552_/Q VPWR VGND sg13cmos5l_mux4_1
XFILLER_31_27 VPWR VGND sg13cmos5l_decap_8
X_1959_ _1959_/Q Tile_X0Y4_FrameData[30] VGND VPWR Tile_X0Y9_FrameStrobe[1] latch
XFILLER_193_168 VPWR VGND sg13cmos5l_decap_4
X_4678_ _4678_/X Tile_X0Y3_W1END[1] Tile_X0Y3_WW4END[13] Tile_X0Y3_W6END[5] _4223_/X
+ _1862_/Q _1861_/Q VPWR VGND sg13cmos5l_mux4_1
XFILLER_575_98 VPWR VGND sg13cmos5l_decap_8
XFILLER_508_70 VPWR VGND sg13cmos5l_decap_8
XFILLER_294_77 VPWR VGND sg13cmos5l_decap_8
X_3629_ Tile_X0Y9_S4BEG[7] _3629_/A VPWR VGND sg13cmos5l_buf_1
XFILLER_444_14 VPWR VGND sg13cmos5l_decap_8
XFILLER_350_143 VPWR VGND sg13cmos5l_decap_8
XANTENNA__3255__X Tile_X0Y0_FrameData_O[23] VPWR VGND sg13cmos5l_antennanp
XFILLER_591_42 VPWR VGND sg13cmos5l_decap_8
XFILLER_496_147 VPWR VGND sg13cmos5l_decap_8
XFILLER_350_154 VPWR VGND sg13cmos5l_fill_1
XFILLER_163_26 VPWR VGND sg13cmos5l_decap_8
XFILLER_350_198 VPWR VGND sg13cmos5l_decap_8
XFILLER_298_7 VPWR VGND sg13cmos5l_decap_8
XFILLER_524_91 VPWR VGND sg13cmos5l_decap_4
XFILLER_102_165 VPWR VGND sg13cmos5l_decap_8
XFILLER_653_133 VPWR VGND sg13cmos5l_decap_8
XFILLER_193_6 VPWR VGND sg13cmos5l_decap_8
XFILLER_102_176 VPWR VGND sg13cmos5l_fill_1
XFILLER_56_13 VPWR VGND sg13cmos5l_decap_8
XFILLER_460_35 VPWR VGND sg13cmos5l_decap_8
XFILLER_263_106 VPWR VGND sg13cmos5l_fill_1
XFILLER_56_46 VPWR VGND sg13cmos5l_decap_8
XFILLER_452_217 VPWR VGND sg13cmos5l_fill_1
XFILLER_465_7 VPWR VGND sg13cmos5l_decap_8
XFILLER_256_191 VPWR VGND sg13cmos5l_decap_8
XFILLER_405_144 VPWR VGND sg13cmos5l_decap_8
XFILLER_610_49 VPWR VGND sg13cmos5l_decap_8
XFILLER_16_138 VPWR VGND sg13cmos5l_fill_1
XANTENNA__0119__X AXI_M_SOC_ARCACHE1 VPWR VGND sg13cmos5l_antennanp
XFILLER_632_7 VPWR VGND sg13cmos5l_decap_8
XFILLER_112_63 VPWR VGND sg13cmos5l_decap_8
XFILLER_271_183 VPWR VGND sg13cmos5l_decap_4
XFILLER_31_108 VPWR VGND sg13cmos5l_decap_8
XFILLER_420_147 VPWR VGND sg13cmos5l_decap_4
XFILLER_358_210 VPWR VGND sg13cmos5l_decap_8
XFILLER_708_112 VPWR VGND sg13cmos5l_decap_8
XFILLER_619_14 VPWR VGND sg13cmos5l_decap_8
XFILLER_169_143 VPWR VGND sg13cmos5l_decap_8
XFILLER_188_56 VPWR VGND sg13cmos5l_decap_8
XFILLER_485_21 VPWR VGND sg13cmos5l_decap_8
XFILLER_373_213 VPWR VGND sg13cmos5l_decap_4
XFILLER_184_113 VPWR VGND sg13cmos5l_decap_4
XFILLER_184_124 VPWR VGND sg13cmos5l_decap_8
XFILLER_122_0 VPWR VGND sg13cmos5l_decap_8
XFILLER_326_151 VPWR VGND sg13cmos5l_decap_8
XFILLER_485_98 VPWR VGND sg13cmos5l_decap_8
XFILLER_635_35 VPWR VGND sg13cmos5l_decap_8
XFILLER_418_70 VPWR VGND sg13cmos5l_decap_8
XFILLER_354_14 VPWR VGND sg13cmos5l_decap_8
XANTENNA__3165__X Tile_X0Y4_E6BEG[2] VPWR VGND sg13cmos5l_antennanp
XFILLER_715_90 VPWR VGND sg13cmos5l_decap_8
XFILLER_491_0 VPWR VGND sg13cmos5l_decap_8
XFILLER_589_0 VPWR VGND sg13cmos5l_decap_8
XFILLER_504_28 VPWR VGND sg13cmos5l_decap_8
XFILLER_651_56 VPWR VGND sg13cmos5l_decap_8
XFILLER_629_196 VPWR VGND sg13cmos5l_fill_1
XFILLER_434_91 VPWR VGND sg13cmos5l_decap_8
X_0290_ _0290_/Q Tile_X0Y7_FrameData[29] VGND VPWR Tile_X0Y9_FrameStrobe[4] latch
XFILLER_644_133 VPWR VGND sg13cmos5l_decap_8
XFILLER_370_35 VPWR VGND sg13cmos5l_decap_8
XFILLER_239_169 VPWR VGND sg13cmos5l_decap_8
XFILLER_153_70 VPWR VGND sg13cmos5l_fill_1
XFILLER_254_106 VPWR VGND sg13cmos5l_fill_2
XFILLER_11_7 VPWR VGND sg13cmos5l_decap_8
XFILLER_247_180 VPWR VGND sg13cmos5l_fill_1
XFILLER_62_200 VPWR VGND sg13cmos5l_decap_8
XFILLER_520_49 VPWR VGND sg13cmos5l_decap_8
XFILLER_303_95 VPWR VGND sg13cmos5l_decap_8
X_3980_ _3980_/X Tile_X0Y0_W1END[0] Tile_X0Y0_W6END[8] _3875_/X _3862_/X _1141_/Q
+ _1140_/Q VPWR VGND sg13cmos5l_mux4_1
XFILLER_22_119 VPWR VGND sg13cmos5l_decap_8
X_2931_ Tile_X0Y8_E2BEGb[7] _4743_/X VPWR VGND sg13cmos5l_buf_1
XFILLER_529_14 VPWR VGND sg13cmos5l_decap_8
XFILLER_379_88 VPWR VGND sg13cmos5l_decap_8
XFILLER_676_42 VPWR VGND sg13cmos5l_decap_8
XFILLER_565_140 VPWR VGND sg13cmos5l_decap_8
X_2862_ Tile_X0Y6_E6BEG[11] _4539_/X VPWR VGND sg13cmos5l_buf_1
XFILLER_175_102 VPWR VGND sg13cmos5l_decap_8
XFILLER_30_152 VPWR VGND sg13cmos5l_fill_2
XFILLER_309_118 VPWR VGND sg13cmos5l_fill_1
XFILLER_395_21 VPWR VGND sg13cmos5l_decap_8
X_4601_ _4601_/X _4688_/X _4692_/X _4696_/X _4674_/X _0355_/Q _0354_/Q VPWR VGND sg13cmos5l_mux4_1
X_1813_ _1813_/Q Tile_X0Y3_FrameData[20] VGND VPWR Tile_X0Y9_FrameStrobe[4] latch
XFILLER_714_126 VPWR VGND sg13cmos5l_decap_8
X_2793_ Tile_X0Y3_E6BEG[3] _4183_/X VPWR VGND sg13cmos5l_buf_1
XFILLER_175_179 VPWR VGND sg13cmos5l_decap_8
X_4532_ _4532_/X AXI_M_SOC_RDATA24 _4575_/X _4579_/X _4553_/X _2543_/Q _2542_/Q VPWR
+ VGND sg13cmos5l_mux4_1
XFILLER_580_154 VPWR VGND sg13cmos5l_fill_2
X_1744_ _1744_/Q Tile_X0Y3_FrameData[25] VGND VPWR Tile_X0Y9_FrameStrobe[2] latch
XFILLER_317_151 VPWR VGND sg13cmos5l_fill_1
XFILLER_7_84 VPWR VGND sg13cmos5l_decap_8
XFILLER_580_187 VPWR VGND sg13cmos5l_fill_2
XFILLER_545_35 VPWR VGND sg13cmos5l_decap_8
XFILLER_317_184 VPWR VGND sg13cmos5l_fill_1
XFILLER_692_63 VPWR VGND sg13cmos5l_decap_8
X_4463_ _4463_/X _4418_/X _0157_/X _4417_/X _0143_/X _2213_/Q _2212_/Q VPWR VGND sg13cmos5l_mux4_1
XFILLER_264_14 VPWR VGND sg13cmos5l_decap_8
X_1675_ _1675_/Q Tile_X0Y3_FrameData[30] VGND VPWR Tile_X0Y9_FrameStrobe[0] latch
XANTENNA__3075__X Tile_X0Y4_E2BEGb[1] VPWR VGND sg13cmos5l_antennanp
X_3414_ Tile_X0Y4_FrameData_O[5] Tile_X0Y4_FrameData[5] VPWR VGND sg13cmos5l_buf_1
X_0626_ _0626_/Q Tile_X0Y8_FrameData[13] VGND VPWR Tile_X0Y9_FrameStrobe[6] latch
XFILLER_131_216 VPWR VGND sg13cmos5l_fill_2
X_4394_ _4394_/X Tile_X0Y5_WW4END[9] AXI_M_SOC_RRESP0 _4460_/X _4430_/X _2315_/Q _2314_/Q
+ VPWR VGND sg13cmos5l_mux4_1
XFILLER_419_203 VPWR VGND sg13cmos5l_fill_2
X_3345_ Tile_X0Y2_FrameData_O[16] Tile_X0Y2_FrameData[16] VPWR VGND sg13cmos5l_buf_1
XFILLER_414_28 VPWR VGND sg13cmos5l_decap_8
X_0557_ _0557_/Q Tile_X0Y8_FrameData[18] VGND VPWR Tile_X0Y9_FrameStrobe[4] latch
XFILLER_561_56 VPWR VGND sg13cmos5l_decap_8
XFILLER_344_91 VPWR VGND sg13cmos5l_decap_8
X_3276_ Tile_X0Y0_EE4BEG[12] _3832_/X VPWR VGND sg13cmos5l_buf_1
XFILLER_280_35 VPWR VGND sg13cmos5l_decap_8
X_0488_ _0488_/Q Tile_X0Y8_FrameData[23] VGND VPWR Tile_X0Y9_FrameStrobe[2] latch
X_2227_ _2227_/Q Tile_X0Y5_FrameData[18] VGND VPWR Tile_X0Y9_FrameStrobe[1] latch
XFILLER_238_180 VPWR VGND sg13cmos5l_decap_8
XFILLER_650_147 VPWR VGND sg13cmos5l_decap_8
XFILLER_53_200 VPWR VGND sg13cmos5l_fill_1
X_2158_ _2158_/Q Tile_X0Y4_FrameData[23] VGND VPWR Tile_X0Y9_FrameStrobe[7] latch
XFILLER_430_49 VPWR VGND sg13cmos5l_decap_8
XFILLER_213_84 VPWR VGND sg13cmos5l_decap_8
XFILLER_26_49 VPWR VGND sg13cmos5l_decap_8
X_1109_ _1109_/Q Tile_X0Y0_FrameData[22] VGND VPWR Tile_X0Y9_FrameStrobe[5] latch
XFILLER_399_165 VPWR VGND sg13cmos5l_fill_1
XFILLER_198_216 VPWR VGND sg13cmos5l_fill_2
X_2089_ _2089_/Q Tile_X0Y4_FrameData[28] VGND VPWR Tile_X0Y9_FrameStrobe[5] latch
XFILLER_399_187 VPWR VGND sg13cmos5l_decap_8
XFILLER_289_77 VPWR VGND sg13cmos5l_decap_8
XFILLER_510_93 VPWR VGND sg13cmos5l_fill_2
XFILLER_439_14 VPWR VGND sg13cmos5l_decap_8
XFILLER_402_169 VPWR VGND sg13cmos5l_decap_8
XFILLER_586_42 VPWR VGND sg13cmos5l_decap_8
XFILLER_42_37 VPWR VGND sg13cmos5l_decap_8
XFILLER_42_48 VPWR VGND sg13cmos5l_fill_1
XFILLER_355_202 VPWR VGND sg13cmos5l_fill_2
XFILLER_586_86 VPWR VGND sg13cmos5l_decap_4
XFILLER_21_174 VPWR VGND sg13cmos5l_decap_4
XFILLER_166_135 VPWR VGND sg13cmos5l_decap_8
XFILLER_705_126 VPWR VGND sg13cmos5l_decap_8
XFILLER_519_80 VPWR VGND sg13cmos5l_fill_1
XFILLER_571_154 VPWR VGND sg13cmos5l_decap_8
XFILLER_308_140 VPWR VGND sg13cmos5l_decap_4
XFILLER_181_105 VPWR VGND sg13cmos5l_fill_1
XFILLER_213_7 VPWR VGND sg13cmos5l_decap_8
XFILLER_455_35 VPWR VGND sg13cmos5l_decap_8
XFILLER_308_184 VPWR VGND sg13cmos5l_decap_8
XFILLER_206_6 VPWR VGND sg13cmos5l_decap_8
XFILLER_469_103 VPWR VGND sg13cmos5l_fill_2
XFILLER_174_14 VPWR VGND sg13cmos5l_decap_8
XFILLER_174_58 VPWR VGND sg13cmos5l_decap_8
XFILLER_605_49 VPWR VGND sg13cmos5l_decap_8
XFILLER_107_41 VPWR VGND sg13cmos5l_decap_8
XFILLER_582_7 VPWR VGND sg13cmos5l_decap_8
XANTENNA__3713__X AXI_M_SOC_WDATA23 VPWR VGND sg13cmos5l_antennanp
XFILLER_88_163 VPWR VGND sg13cmos5l_decap_8
XFILLER_67_45 VPWR VGND sg13cmos5l_decap_8
XFILLER_471_67 VPWR VGND sg13cmos5l_decap_8
XFILLER_190_35 VPWR VGND sg13cmos5l_decap_8
XFILLER_492_172 VPWR VGND sg13cmos5l_decap_8
XFILLER_236_139 VPWR VGND sg13cmos5l_decap_8
XFILLER_229_180 VPWR VGND sg13cmos5l_fill_2
XFILLER_641_147 VPWR VGND sg13cmos5l_decap_8
XFILLER_340_49 VPWR VGND sg13cmos5l_decap_8
XFILLER_701_70 VPWR VGND sg13cmos5l_decap_8
XFILLER_594_202 VPWR VGND sg13cmos5l_decap_4
XFILLER_83_99 VPWR VGND sg13cmos5l_decap_8
XFILLER_594_213 VPWR VGND sg13cmos5l_decap_4
XFILLER_199_77 VPWR VGND sg13cmos5l_decap_4
XFILLER_349_14 VPWR VGND sg13cmos5l_decap_8
XFILLER_337_0 VPWR VGND sg13cmos5l_decap_8
XFILLER_496_42 VPWR VGND sg13cmos5l_decap_8
XFILLER_8_101 VPWR VGND sg13cmos5l_fill_1
XFILLER_157_124 VPWR VGND sg13cmos5l_decap_8
XFILLER_12_174 VPWR VGND sg13cmos5l_decap_8
XFILLER_8_123 VPWR VGND sg13cmos5l_fill_1
XANTENNA__2999__X Tile_X0Y5_E2BEG[2] VPWR VGND sg13cmos5l_antennanp
XFILLER_562_121 VPWR VGND sg13cmos5l_decap_8
XFILLER_504_0 VPWR VGND sg13cmos5l_fill_2
XFILLER_646_56 VPWR VGND sg13cmos5l_decap_8
XFILLER_429_91 VPWR VGND sg13cmos5l_decap_8
XFILLER_562_165 VPWR VGND sg13cmos5l_fill_2
XFILLER_361_205 VPWR VGND sg13cmos5l_decap_8
XFILLER_361_216 VPWR VGND sg13cmos5l_fill_2
XFILLER_365_35 VPWR VGND sg13cmos5l_decap_8
XFILLER_172_127 VPWR VGND sg13cmos5l_decap_8
XFILLER_649_203 VPWR VGND sg13cmos5l_decap_8
XFILLER_503_210 VPWR VGND sg13cmos5l_decap_8
X_1460_ _1460_/Q Tile_X0Y2_FrameData[29] VGND VPWR Tile_X0Y9_FrameStrobe[1] latch
XFILLER_314_176 VPWR VGND sg13cmos5l_decap_8
XFILLER_515_49 VPWR VGND sg13cmos5l_decap_8
X_0411_ _0411_/Q Tile_X0Y7_FrameData[4] VGND VPWR Tile_X0Y9_FrameStrobe[7] latch
XFILLER_662_77 VPWR VGND sg13cmos5l_decap_8
XFILLER_234_28 VPWR VGND sg13cmos5l_decap_8
X_1391_ _1391_/Q Tile_X0Y1_FrameData[10] VGND VPWR Tile_X0Y9_FrameStrobe[6] latch
XFILLER_79_152 VPWR VGND sg13cmos5l_decap_4
XFILLER_164_80 VPWR VGND sg13cmos5l_decap_8
XANTENNA__3623__X Tile_X0Y9_S4BEG[1] VPWR VGND sg13cmos5l_antennanp
X_3130_ Tile_X0Y7_FrameData_O[0] Tile_X0Y7_FrameData[0] VPWR VGND sg13cmos5l_buf_1
X_0342_ _0342_/Q Tile_X0Y7_FrameData[9] VGND VPWR Tile_X0Y9_FrameStrobe[5] latch
XFILLER_416_206 VPWR VGND sg13cmos5l_fill_1
X_3061_ Tile_X0Y5_FrameData_O[20] Tile_X0Y5_FrameData[20] VPWR VGND sg13cmos5l_buf_1
XFILLER_94_155 VPWR VGND sg13cmos5l_decap_4
X_0273_ _0273_/Q Tile_X0Y7_FrameData[14] VGND VPWR Tile_X0Y9_FrameStrobe[3] latch
XFILLER_94_188 VPWR VGND sg13cmos5l_decap_8
X_2012_ _2012_/Q Tile_X0Y4_FrameData[9] VGND VPWR Tile_X0Y9_FrameStrobe[2] latch
XFILLER_35_211 VPWR VGND sg13cmos5l_fill_1
XFILLER_250_49 VPWR VGND sg13cmos5l_decap_8
XFILLER_611_70 VPWR VGND sg13cmos5l_decap_4
XFILLER_250_120 VPWR VGND sg13cmos5l_fill_2
XFILLER_396_135 VPWR VGND sg13cmos5l_decap_8
X_3963_ _3963_/X Tile_X0Y1_WW4END[0] AXI_M_SOC_ARREADY _4008_/X _3989_/X _1283_/Q
+ _1282_/Q VPWR VGND sg13cmos5l_mux4_1
XFILLER_687_63 VPWR VGND sg13cmos5l_decap_8
XFILLER_259_14 VPWR VGND sg13cmos5l_decap_8
XFILLER_687_74 VPWR VGND sg13cmos5l_fill_1
X_2914_ Tile_X0Y8_E1BEG[2] _4726_/X VPWR VGND sg13cmos5l_buf_1
X_3894_ _3894_/X Tile_X0Y2_W2MID[4] Tile_X0Y2_W2END[4] Tile_X0Y2_W6END[4] _4103_/X
+ _1659_/Q _1658_/Q VPWR VGND sg13cmos5l_mux4_1
XFILLER_148_113 VPWR VGND sg13cmos5l_decap_8
XFILLER_85_0 VPWR VGND sg13cmos5l_decap_8
XFILLER_538_184 VPWR VGND sg13cmos5l_fill_1
X_2845_ Tile_X0Y6_E2BEGb[2] _4506_/X VPWR VGND sg13cmos5l_buf_1
XFILLER_409_28 VPWR VGND sg13cmos5l_decap_8
XFILLER_556_56 VPWR VGND sg13cmos5l_decap_8
XFILLER_339_91 VPWR VGND sg13cmos5l_fill_1
XFILLER_699_147 VPWR VGND sg13cmos5l_decap_8
XFILLER_553_165 VPWR VGND sg13cmos5l_decap_8
X_2776_ Tile_X0Y3_EE4BEG[2] _4166_/X VPWR VGND sg13cmos5l_buf_1
XFILLER_553_176 VPWR VGND sg13cmos5l_fill_2
XFILLER_275_35 VPWR VGND sg13cmos5l_decap_8
XFILLER_163_138 VPWR VGND sg13cmos5l_decap_8
X_4515_ _4515_/X Tile_X0Y6_WW4END[12] AXI_M_SOC_RDATA27 _4580_/X _4558_/X _2577_/Q
+ _2576_/Q VPWR VGND sg13cmos5l_mux4_1
X_1727_ _1727_/Q Tile_X0Y3_FrameData[10] VGND VPWR Tile_X0Y9_FrameStrobe[1] latch
XFILLER_305_165 VPWR VGND sg13cmos5l_decap_8
XFILLER_208_62 VPWR VGND sg13cmos5l_decap_8
XFILLER_710_140 VPWR VGND sg13cmos5l_decap_8
X_4446_ _4446_/X _4922_/X _4926_/X _4930_/X _4905_/X _0897_/Q _0896_/Q VPWR VGND sg13cmos5l_mux4_1
X_1658_ _1658_/Q Tile_X0Y2_FrameData[23] VGND VPWR Tile_X0Y9_FrameStrobe[7] latch
XFILLER_425_49 VPWR VGND sg13cmos5l_decap_8
XFILLER_572_77 VPWR VGND sg13cmos5l_decap_8
X_0609_ _0609_/Q Tile_X0Y8_FrameData[30] VGND VPWR Tile_X0Y9_FrameStrobe[6] latch
X_4377_ _4377_/X Tile_X0Y5_W2MID[2] AXI_M_SOC_RLAST _4432_/X _4431_/X _2349_/Q _2348_/Q
+ VPWR VGND sg13cmos5l_mux4_1
X_1589_ _1589_/Q Tile_X0Y2_FrameData[28] VGND VPWR Tile_X0Y9_FrameStrobe[5] latch
XANTENNA__3533__X Tile_X0Y9_E2BEG[7] VPWR VGND sg13cmos5l_antennanp
XFILLER_291_56 VPWR VGND sg13cmos5l_decap_8
X_3328_ Tile_X0Y2_UserCLKo Tile_X0Y2_UserCLK VPWR VGND sg13cmos5l_buf_1
XFILLER_85_122 VPWR VGND sg13cmos5l_decap_8
XFILLER_85_144 VPWR VGND sg13cmos5l_fill_2
X_3259_ Tile_X0Y0_FrameData_O[27] Tile_X0Y0_FrameData[27] VPWR VGND sg13cmos5l_buf_1
XFILLER_37_48 VPWR VGND sg13cmos5l_decap_8
XFILLER_623_136 VPWR VGND sg13cmos5l_decap_4
XFILLER_37_59 VPWR VGND sg13cmos5l_fill_2
XFILLER_521_81 VPWR VGND sg13cmos5l_fill_1
XFILLER_163_7 VPWR VGND sg13cmos5l_decap_8
XFILLER_240_60 VPWR VGND sg13cmos5l_fill_2
XFILLER_53_25 VPWR VGND sg13cmos5l_fill_1
XFILLER_387_146 VPWR VGND sg13cmos5l_fill_1
XFILLER_169_14 VPWR VGND sg13cmos5l_decap_8
XFILLER_186_208 VPWR VGND sg13cmos5l_fill_1
XFILLER_330_7 VPWR VGND sg13cmos5l_decap_8
XFILLER_169_47 VPWR VGND sg13cmos5l_fill_2
XFILLER_428_7 VPWR VGND sg13cmos5l_decap_8
XANTENNA__0116__Y AXI_M_SOC_ARLEN7 VPWR VGND sg13cmos5l_antennanp
XFILLER_395_190 VPWR VGND sg13cmos5l_decap_8
XFILLER_319_28 VPWR VGND sg13cmos5l_decap_8
XFILLER_544_132 VPWR VGND sg13cmos5l_decap_4
XFILLER_139_168 VPWR VGND sg13cmos5l_decap_8
XANTENNA__3708__X AXI_M_SOC_WDATA18 VPWR VGND sg13cmos5l_antennanp
XFILLER_544_165 VPWR VGND sg13cmos5l_fill_2
XFILLER_185_35 VPWR VGND sg13cmos5l_decap_8
XFILLER_335_49 VPWR VGND sg13cmos5l_decap_8
XFILLER_311_113 VPWR VGND sg13cmos5l_fill_2
XFILLER_162_182 VPWR VGND sg13cmos5l_decap_8
XFILLER_646_217 VPWR VGND sg13cmos5l_fill_1
XFILLER_482_77 VPWR VGND sg13cmos5l_fill_2
XFILLER_632_14 VPWR VGND sg13cmos5l_decap_8
XFILLER_78_77 VPWR VGND sg13cmos5l_fill_1
XFILLER_110_208 VPWR VGND sg13cmos5l_fill_1
XANTENNA__3443__X Tile_X0Y1_FrameData_O[1] VPWR VGND sg13cmos5l_antennanp
XFILLER_472_109 VPWR VGND sg13cmos5l_fill_1
XFILLER_264_201 VPWR VGND sg13cmos5l_decap_8
XFILLER_465_161 VPWR VGND sg13cmos5l_decap_8
XFILLER_287_0 VPWR VGND sg13cmos5l_decap_8
XFILLER_712_91 VPWR VGND sg13cmos5l_decap_8
XFILLER_91_136 VPWR VGND sg13cmos5l_fill_1
XFILLER_431_70 VPWR VGND sg13cmos5l_decap_8
XFILLER_480_175 VPWR VGND sg13cmos5l_fill_1
XFILLER_454_0 VPWR VGND sg13cmos5l_decap_8
XFILLER_480_197 VPWR VGND sg13cmos5l_decap_4
XFILLER_217_194 VPWR VGND sg13cmos5l_decap_4
XFILLER_378_113 VPWR VGND sg13cmos5l_decap_4
XFILLER_300_30 VPWR VGND sg13cmos5l_fill_1
XFILLER_621_0 VPWR VGND sg13cmos5l_decap_8
XFILLER_378_168 VPWR VGND sg13cmos5l_decap_8
X_0960_ _0960_/Q Tile_X0Y0_FrameData[11] VGND VPWR Tile_X0Y9_FrameStrobe[0] latch
XFILLER_582_216 VPWR VGND sg13cmos5l_fill_2
XFILLER_535_110 VPWR VGND sg13cmos5l_decap_8
XFILLER_657_77 VPWR VGND sg13cmos5l_decap_8
XFILLER_229_28 VPWR VGND sg13cmos5l_decap_8
X_0891_ _0891_/Q Tile_X0Y9_FrameData[4] VGND VPWR Tile_X0Y9_FrameStrobe[6] latch
XANTENNA__3618__X Tile_X0Y9_S2BEGb[4] VPWR VGND sg13cmos5l_antennanp
XFILLER_71_6 VPWR VGND sg13cmos5l_decap_8
X_2630_ _2630_/Q Tile_X0Y6_FrameData[1] VGND VPWR Tile_X0Y9_FrameStrobe[5] latch
XFILLER_334_216 VPWR VGND sg13cmos5l_fill_2
XFILLER_550_102 VPWR VGND sg13cmos5l_fill_2
XFILLER_673_21 VPWR VGND sg13cmos5l_decap_8
XFILLER_309_61 VPWR VGND sg13cmos5l_fill_1
XFILLER_138_190 VPWR VGND sg13cmos5l_fill_1
X_2561_ _2561_/Q Tile_X0Y6_FrameData[6] VGND VPWR Tile_X0Y9_FrameStrobe[3] latch
XFILLER_309_83 VPWR VGND sg13cmos5l_decap_8
XFILLER_299_131 VPWR VGND sg13cmos5l_fill_1
X_4300_ _4300_/X _4302_/X Tile_X0Y4_W6END[0] _4301_/X _4300_/A3 _1933_/Q _1932_/Q
+ VPWR VGND sg13cmos5l_mux4_1
XFILLER_160_119 VPWR VGND sg13cmos5l_decap_8
X_1512_ _1512_/Q Tile_X0Y2_FrameData[9] VGND VPWR Tile_X0Y9_FrameStrobe[2] latch
XFILLER_245_27 VPWR VGND sg13cmos5l_decap_8
XFILLER_299_153 VPWR VGND sg13cmos5l_decap_8
X_2492_ _2492_/Q Tile_X0Y6_FrameData[11] VGND VPWR Tile_X0Y9_FrameStrobe[1] latch
X_4231_ _4231_/X _4197_/X _0088_/X _4196_/X Tile_X0Y0_S4END[13] _1711_/Q _1710_/Q
+ VPWR VGND sg13cmos5l_mux4_1
XFILLER_448_117 VPWR VGND sg13cmos5l_decap_8
X_1443_ _1443_/Q Tile_X0Y2_FrameData[14] VGND VPWR Tile_X0Y9_FrameStrobe[0] latch
XFILLER_542_14 VPWR VGND sg13cmos5l_decap_8
XFILLER_4_63 VPWR VGND sg13cmos5l_decap_8
XANTENNA__3353__X Tile_X0Y2_FrameData_O[24] VPWR VGND sg13cmos5l_antennanp
X_4162_ _4162_/X Tile_X0Y3_W2END[1] AXI_M_SOC_BVALID _4207_/X _4206_/X _1817_/Q _1816_/Q
+ VPWR VGND sg13cmos5l_mux4_1
X_1374_ _1374_/Q Tile_X0Y1_FrameData[27] VGND VPWR Tile_X0Y9_FrameStrobe[6] latch
XFILLER_67_122 VPWR VGND sg13cmos5l_decap_8
X_3113_ Tile_X0Y7_E6BEG[11] _4655_/X VPWR VGND sg13cmos5l_buf_1
X_0325_ _0325_/Q Tile_X0Y7_FrameData[26] VGND VPWR Tile_X0Y9_FrameStrobe[5] latch
X_4093_ _4093_/X Tile_X0Y3_W1END[2] Tile_X0Y3_W6END[6] _4215_/X _4192_/X _1921_/Q
+ _1920_/Q VPWR VGND sg13cmos5l_mux4_1
XFILLER_622_91 VPWR VGND sg13cmos5l_decap_8
X_3044_ Tile_X0Y5_FrameData_O[3] Tile_X0Y5_FrameData[3] VPWR VGND sg13cmos5l_buf_1
X_0256_ _0256_/Q Tile_X0Y7_FrameData[31] VGND VPWR Tile_X0Y9_FrameStrobe[3] latch
XFILLER_341_70 VPWR VGND sg13cmos5l_decap_8
X_0187_ _0187_/Q Tile_X0Y7_FrameData[4] VGND VPWR Tile_X0Y9_FrameStrobe[0] latch
XFILLER_698_84 VPWR VGND sg13cmos5l_decap_8
XFILLER_558_202 VPWR VGND sg13cmos5l_decap_4
XFILLER_369_124 VPWR VGND sg13cmos5l_decap_8
XFILLER_223_175 VPWR VGND sg13cmos5l_fill_2
XFILLER_210_41 VPWR VGND sg13cmos5l_decap_8
XFILLER_384_116 VPWR VGND sg13cmos5l_decap_8
X_3946_ _3946_/X Tile_X0Y1_W2END[1] AXI_M_SOC_ARREADY _3991_/X _3990_/X _1317_/Q _1316_/Q
+ VPWR VGND sg13cmos5l_mux4_1
XFILLER_23_28 VPWR VGND sg13cmos5l_decap_8
XFILLER_567_77 VPWR VGND sg13cmos5l_decap_8
XFILLER_139_28 VPWR VGND sg13cmos5l_decap_8
X_3877_ _3877_/X Tile_X0Y4_W1END[3] Tile_X0Y4_WW4END[3] Tile_X0Y4_W6END[11] _4339_/X
+ _2148_/Q _2147_/Q VPWR VGND sg13cmos5l_mux4_1
XFILLER_717_25 VPWR VGND sg13cmos5l_fill_1
XFILLER_286_56 VPWR VGND sg13cmos5l_decap_8
XFILLER_136_105 VPWR VGND sg13cmos5l_decap_8
XANTENNA__3528__X Tile_X0Y9_E2BEG[2] VPWR VGND sg13cmos5l_antennanp
X_2828_ Tile_X0Y4_E2BEG[6] _4262_/X VPWR VGND sg13cmos5l_buf_1
XFILLER_717_58 VPWR VGND sg13cmos5l_decap_8
XFILLER_526_176 VPWR VGND sg13cmos5l_decap_4
XFILLER_717_69 VPWR VGND sg13cmos5l_fill_1
XFILLER_583_21 VPWR VGND sg13cmos5l_decap_8
XFILLER_541_124 VPWR VGND sg13cmos5l_decap_8
XFILLER_436_48 VPWR VGND sg13cmos5l_decap_8
X_2759_ Tile_X0Y3_FrameData_O[17] Tile_X0Y3_FrameData[17] VPWR VGND sg13cmos5l_buf_1
XFILLER_151_108 VPWR VGND sg13cmos5l_decap_8
XFILLER_583_98 VPWR VGND sg13cmos5l_decap_8
XFILLER_516_70 VPWR VGND sg13cmos5l_fill_2
X_4429_ _4429_/X _4365_/X _4481_/X _4480_/X _4364_/X _2193_/Q _2192_/Q VPWR VGND sg13cmos5l_mux4_1
XFILLER_628_217 VPWR VGND sg13cmos5l_fill_1
XFILLER_439_128 VPWR VGND sg13cmos5l_decap_4
XFILLER_695_183 VPWR VGND sg13cmos5l_decap_8
XFILLER_452_14 VPWR VGND sg13cmos5l_decap_8
XANTENNA__3263__X Tile_X0Y0_FrameData_O[31] VPWR VGND sg13cmos5l_antennanp
XFILLER_48_36 VPWR VGND sg13cmos5l_decap_8
XFILLER_602_28 VPWR VGND sg13cmos5l_decap_8
XFILLER_447_172 VPWR VGND sg13cmos5l_decap_8
XFILLER_280_7 VPWR VGND sg13cmos5l_decap_8
XFILLER_58_166 VPWR VGND sg13cmos5l_decap_8
XFILLER_462_120 VPWR VGND sg13cmos5l_decap_8
XFILLER_378_7 VPWR VGND sg13cmos5l_decap_8
XFILLER_261_204 VPWR VGND sg13cmos5l_fill_1
XFILLER_104_75 VPWR VGND sg13cmos5l_decap_8
XFILLER_462_186 VPWR VGND sg13cmos5l_decap_8
XFILLER_73_169 VPWR VGND sg13cmos5l_decap_8
XFILLER_545_7 VPWR VGND sg13cmos5l_decap_8
XFILLER_604_180 VPWR VGND sg13cmos5l_decap_8
XFILLER_64_79 VPWR VGND sg13cmos5l_decap_8
XFILLER_14_203 VPWR VGND sg13cmos5l_fill_1
XFILLER_81_191 VPWR VGND sg13cmos5l_decap_8
XFILLER_120_41 VPWR VGND sg13cmos5l_decap_8
XANTENNA__0127__X AXI_M_SOC_WLAST VPWR VGND sg13cmos5l_antennanp
XFILLER_712_7 VPWR VGND sg13cmos5l_decap_8
XFILLER_80_34 VPWR VGND sg13cmos5l_decap_8
XFILLER_80_45 VPWR VGND sg13cmos5l_fill_1
XFILLER_627_14 VPWR VGND sg13cmos5l_decap_8
XFILLER_196_34 VPWR VGND sg13cmos5l_decap_8
XANTENNA__3438__X Tile_X0Y4_FrameData_O[29] VPWR VGND sg13cmos5l_antennanp
XFILLER_517_154 VPWR VGND sg13cmos5l_fill_1
XFILLER_493_21 VPWR VGND sg13cmos5l_decap_8
XFILLER_532_135 VPWR VGND sg13cmos5l_decap_4
XFILLER_202_0 VPWR VGND sg13cmos5l_decap_8
XFILLER_129_94 VPWR VGND sg13cmos5l_fill_1
XFILLER_707_91 VPWR VGND sg13cmos5l_decap_8
XFILLER_89_65 VPWR VGND sg13cmos5l_fill_2
XFILLER_493_98 VPWR VGND sg13cmos5l_decap_8
XFILLER_643_35 VPWR VGND sg13cmos5l_decap_8
XFILLER_426_70 VPWR VGND sg13cmos5l_decap_8
XFILLER_619_217 VPWR VGND sg13cmos5l_fill_1
XFILLER_296_123 VPWR VGND sg13cmos5l_decap_8
XFILLER_362_14 VPWR VGND sg13cmos5l_decap_8
XFILLER_96_206 VPWR VGND sg13cmos5l_decap_8
XFILLER_96_217 VPWR VGND sg13cmos5l_fill_1
XANTENNA__3173__X Tile_X0Y4_E6BEG[10] VPWR VGND sg13cmos5l_antennanp
XFILLER_571_0 VPWR VGND sg13cmos5l_decap_8
XFILLER_1_195 VPWR VGND sg13cmos5l_decap_8
XFILLER_237_212 VPWR VGND sg13cmos5l_decap_4
XFILLER_669_0 VPWR VGND sg13cmos5l_decap_8
XFILLER_512_28 VPWR VGND sg13cmos5l_decap_8
XFILLER_438_194 VPWR VGND sg13cmos5l_fill_1
XFILLER_442_91 VPWR VGND sg13cmos5l_decap_8
X_0110_ _0110_/X _4328_/X _4329_/X _1109_/Q VPWR VGND sg13cmos5l_mux2_1
XFILLER_64_114 VPWR VGND sg13cmos5l_decap_8
X_1090_ _1090_/Q Tile_X0Y0_FrameData[9] VGND VPWR Tile_X0Y9_FrameStrobe[4] latch
XFILLER_453_164 VPWR VGND sg13cmos5l_decap_8
X_0041_ _3630_/A _4716_/X _4717_/X _0609_/Q VPWR VGND sg13cmos5l_mux2_1
XFILLER_668_21 VPWR VGND sg13cmos5l_decap_8
XFILLER_668_54 VPWR VGND sg13cmos5l_decap_8
XFILLER_205_175 VPWR VGND sg13cmos5l_decap_8
XFILLER_205_186 VPWR VGND sg13cmos5l_fill_2
X_3800_ _3800_/X _3848_/X Tile_X0Y0_W2END[0] Tile_X0Y0_W2END[1] Tile_X0Y0_S1END[0]
+ _1105_/Q _1104_/Q VPWR VGND sg13cmos5l_mux4_1
X_4780_ _4780_/X Tile_X0Y7_W1END[2] Tile_X0Y7_W6END[10] _4698_/X _4658_/X _0375_/Q
+ _0374_/Q VPWR VGND sg13cmos5l_mux4_1
X_1992_ _1992_/Q Tile_X0Y4_FrameData[29] VGND VPWR Tile_X0Y9_FrameStrobe[2] latch
XFILLER_20_206 VPWR VGND sg13cmos5l_fill_2
XFILLER_20_217 VPWR VGND sg13cmos5l_fill_1
X_3731_ AXI_M_SOC_ARADDR3 Tile_X0Y9_WW4END[3] Tile_X0Y9_WW4END[11] Tile_X0Y9_W6END[3]
+ _4919_/X _0753_/Q _0752_/Q VPWR VGND sg13cmos5l_mux4_1
X_0943_ _0943_/Q Tile_X0Y0_FrameData[28] VGND VPWR Tile_X0Y9_FrameStrobe[0] latch
XFILLER_537_14 VPWR VGND sg13cmos5l_decap_8
XFILLER_381_108 VPWR VGND sg13cmos5l_fill_1
XANTENNA__3348__X Tile_X0Y2_FrameData_O[19] VPWR VGND sg13cmos5l_antennanp
XFILLER_684_42 VPWR VGND sg13cmos5l_decap_8
XFILLER_374_160 VPWR VGND sg13cmos5l_decap_8
X_3662_ AXI_M_SOC_AWADDR23 Tile_X0Y4_WW4END[7] Tile_X0Y4_WW4END[15] Tile_X0Y4_W6END[7]
+ _4343_/X _1999_/Q _1998_/Q VPWR VGND sg13cmos5l_mux4_1
X_0874_ _0874_/Q Tile_X0Y9_FrameData[21] VGND VPWR Tile_X0Y9_FrameStrobe[6] latch
XFILLER_118_127 VPWR VGND sg13cmos5l_decap_8
XFILLER_508_198 VPWR VGND sg13cmos5l_decap_8
X_2613_ _2613_/Q Tile_X0Y6_FrameData[18] VGND VPWR Tile_X0Y9_FrameStrobe[5] latch
XFILLER_684_97 VPWR VGND sg13cmos5l_decap_4
XFILLER_523_135 VPWR VGND sg13cmos5l_fill_2
XFILLER_669_128 VPWR VGND sg13cmos5l_fill_1
X_3593_ Tile_X0Y9_FrameData_O[23] Tile_X0Y9_FrameData[23] VPWR VGND sg13cmos5l_buf_1
XFILLER_322_208 VPWR VGND sg13cmos5l_fill_1
XFILLER_133_119 VPWR VGND sg13cmos5l_decap_8
XFILLER_617_91 VPWR VGND sg13cmos5l_decap_8
X_2544_ _2544_/Q Tile_X0Y6_FrameData[23] VGND VPWR Tile_X0Y9_FrameStrobe[3] latch
XFILLER_553_35 VPWR VGND sg13cmos5l_decap_8
XFILLER_272_14 VPWR VGND sg13cmos5l_decap_8
X_2475_ _2475_/Q Tile_X0Y6_FrameData[28] VGND VPWR Tile_X0Y9_FrameStrobe[1] latch
XANTENNA__3083__X Tile_X0Y7_E1BEG[1] VPWR VGND sg13cmos5l_antennanp
XFILLER_87_217 VPWR VGND sg13cmos5l_fill_1
XFILLER_141_163 VPWR VGND sg13cmos5l_decap_8
X_4214_ _4214_/X _4688_/X _4692_/X _4696_/X _4669_/X _0391_/Q _0390_/Q VPWR VGND sg13cmos5l_mux4_1
X_1426_ _1426_/Q Tile_X0Y1_FrameData[31] VGND VPWR Tile_X0Y9_FrameStrobe[0] latch
XFILLER_287_167 VPWR VGND sg13cmos5l_decap_8
XFILLER_703_49 VPWR VGND sg13cmos5l_decap_8
XFILLER_429_161 VPWR VGND sg13cmos5l_decap_4
XFILLER_228_212 VPWR VGND sg13cmos5l_decap_4
X_4145_ _4145_/X _4197_/X Tile_X0Y3_WW4END[7] _4196_/X AXI_M_SOC_WREADY _1851_/Q _1850_/Q
+ VPWR VGND sg13cmos5l_mux4_1
XFILLER_422_28 VPWR VGND sg13cmos5l_decap_8
XFILLER_205_63 VPWR VGND sg13cmos5l_decap_8
X_1357_ _1357_/Q Tile_X0Y1_FrameData[12] VGND VPWR Tile_X0Y9_FrameStrobe[5] latch
XFILLER_429_183 VPWR VGND sg13cmos5l_decap_8
XFILLER_352_91 VPWR VGND sg13cmos5l_decap_8
XFILLER_18_28 VPWR VGND sg13cmos5l_decap_8
X_0308_ _0308_/Q Tile_X0Y7_FrameData[11] VGND VPWR Tile_X0Y9_FrameStrobe[4] latch
XFILLER_55_125 VPWR VGND sg13cmos5l_fill_1
X_4076_ _4076_/X AXI_M_SOC_AWREADY _4123_/X _4127_/X _4097_/X _1521_/Q _1520_/Q VPWR
+ VGND sg13cmos5l_mux4_1
X_1288_ _1288_/Q Tile_X0Y1_FrameData[17] VGND VPWR Tile_X0Y9_FrameStrobe[3] latch
XFILLER_243_215 VPWR VGND sg13cmos5l_fill_2
XFILLER_55_147 VPWR VGND sg13cmos5l_decap_8
XFILLER_55_158 VPWR VGND sg13cmos5l_fill_2
X_3027_ Tile_X0Y5_EE4BEG[2] _4390_/X VPWR VGND sg13cmos5l_buf_1
X_0239_ _0239_/Q Tile_X0Y7_FrameData[16] VGND VPWR Tile_X0Y9_FrameStrobe[2] latch
XFILLER_578_21 VPWR VGND sg13cmos5l_decap_8
XFILLER_34_27 VPWR VGND sg13cmos5l_decap_8
XFILLER_221_84 VPWR VGND sg13cmos5l_decap_8
XFILLER_211_112 VPWR VGND sg13cmos5l_decap_8
XFILLER_601_172 VPWR VGND sg13cmos5l_decap_8
XFILLER_357_105 VPWR VGND sg13cmos5l_decap_8
XFILLER_578_98 VPWR VGND sg13cmos5l_decap_8
XFILLER_11_217 VPWR VGND sg13cmos5l_fill_1
XFILLER_297_77 VPWR VGND sg13cmos5l_decap_8
X_3929_ _3929_/X _3983_/X Tile_X0Y1_WW4END[5] _3982_/X AXI_M_SOC_ARREADY _1351_/Q
+ _1350_/Q VPWR VGND sg13cmos5l_mux4_1
XFILLER_447_14 VPWR VGND sg13cmos5l_decap_8
XANTENNA__3258__X Tile_X0Y0_FrameData_O[26] VPWR VGND sg13cmos5l_antennanp
XFILLER_594_42 VPWR VGND sg13cmos5l_decap_8
XFILLER_50_37 VPWR VGND sg13cmos5l_decap_8
XFILLER_126_7 VPWR VGND sg13cmos5l_decap_8
XFILLER_514_124 VPWR VGND sg13cmos5l_fill_1
XFILLER_124_119 VPWR VGND sg13cmos5l_decap_8
XFILLER_463_35 VPWR VGND sg13cmos5l_decap_8
XFILLER_117_182 VPWR VGND sg13cmos5l_fill_1
XFILLER_463_46 VPWR VGND sg13cmos5l_fill_1
XFILLER_668_161 VPWR VGND sg13cmos5l_decap_8
XFILLER_278_112 VPWR VGND sg13cmos5l_decap_8
XFILLER_495_7 VPWR VGND sg13cmos5l_decap_8
XFILLER_78_217 VPWR VGND sg13cmos5l_fill_1
XFILLER_132_185 VPWR VGND sg13cmos5l_decap_8
XFILLER_613_49 VPWR VGND sg13cmos5l_decap_8
XFILLER_278_189 VPWR VGND sg13cmos5l_decap_8
XFILLER_182_69 VPWR VGND sg13cmos5l_fill_2
XFILLER_332_28 VPWR VGND sg13cmos5l_decap_8
XFILLER_662_7 VPWR VGND sg13cmos5l_decap_8
XFILLER_293_148 VPWR VGND sg13cmos5l_fill_1
XFILLER_115_63 VPWR VGND sg13cmos5l_decap_8
XFILLER_75_34 VPWR VGND sg13cmos5l_decap_8
XANTENNA__3721__X AXI_M_SOC_WDATA31 VPWR VGND sg13cmos5l_antennanp
XFILLER_596_105 VPWR VGND sg13cmos5l_decap_8
XFILLER_435_197 VPWR VGND sg13cmos5l_decap_4
XFILLER_488_21 VPWR VGND sg13cmos5l_decap_8
XFILLER_199_130 VPWR VGND sg13cmos5l_fill_1
XFILLER_450_178 VPWR VGND sg13cmos5l_decap_8
XFILLER_199_152 VPWR VGND sg13cmos5l_decap_8
XFILLER_202_112 VPWR VGND sg13cmos5l_decap_4
XFILLER_199_163 VPWR VGND sg13cmos5l_fill_1
XFILLER_152_0 VPWR VGND sg13cmos5l_decap_8
XFILLER_348_105 VPWR VGND sg13cmos5l_decap_8
XFILLER_488_98 VPWR VGND sg13cmos5l_decap_8
XFILLER_91_88 VPWR VGND sg13cmos5l_decap_8
XFILLER_638_35 VPWR VGND sg13cmos5l_decap_8
XFILLER_357_14 VPWR VGND sg13cmos5l_decap_8
XFILLER_202_178 VPWR VGND sg13cmos5l_fill_2
XFILLER_363_108 VPWR VGND sg13cmos5l_fill_1
XFILLER_24_93 VPWR VGND sg13cmos5l_decap_8
XANTENNA__3168__X Tile_X0Y4_E6BEG[5] VPWR VGND sg13cmos5l_antennanp
XFILLER_417_0 VPWR VGND sg13cmos5l_decap_8
XFILLER_507_28 VPWR VGND sg13cmos5l_decap_8
XFILLER_115_108 VPWR VGND sg13cmos5l_decap_8
XFILLER_170_203 VPWR VGND sg13cmos5l_decap_4
XFILLER_654_56 VPWR VGND sg13cmos5l_decap_8
XANTENNA__2800__X Tile_X0Y3_E6BEG[10] VPWR VGND sg13cmos5l_antennanp
XFILLER_520_105 VPWR VGND sg13cmos5l_decap_8
XFILLER_505_179 VPWR VGND sg13cmos5l_decap_4
XFILLER_371_185 VPWR VGND sg13cmos5l_decap_8
X_0590_ _0590_/Q Tile_X0Y8_FrameData[17] VGND VPWR Tile_X0Y9_FrameStrobe[5] latch
XFILLER_373_35 VPWR VGND sg13cmos5l_decap_8
XFILLER_513_190 VPWR VGND sg13cmos5l_decap_8
XFILLER_123_141 VPWR VGND sg13cmos5l_decap_8
XFILLER_269_156 VPWR VGND sg13cmos5l_decap_8
XFILLER_34_6 VPWR VGND sg13cmos5l_decap_8
X_2260_ _2260_/Q Tile_X0Y5_FrameData[17] VGND VPWR Tile_X0Y9_FrameStrobe[2] latch
XFILLER_306_95 VPWR VGND sg13cmos5l_fill_2
XFILLER_284_126 VPWR VGND sg13cmos5l_decap_8
X_1211_ _1211_/Q Tile_X0Y1_FrameData[30] VGND VPWR Tile_X0Y9_FrameStrobe[1] latch
XFILLER_674_186 VPWR VGND sg13cmos5l_decap_8
XFILLER_670_77 VPWR VGND sg13cmos5l_decap_8
X_2191_ _2191_/Q Tile_X0Y5_FrameData[22] VGND VPWR Tile_X0Y9_FrameStrobe[0] latch
XANTENNA__3631__X Tile_X0Y9_S4BEG[9] VPWR VGND sg13cmos5l_antennanp
X_1142_ _1142_/Q Tile_X0Y0_FrameData[21] VGND VPWR Tile_X0Y9_FrameStrobe[6] latch
XFILLER_1_42 VPWR VGND sg13cmos5l_decap_8
XFILLER_426_175 VPWR VGND sg13cmos5l_decap_8
XFILLER_679_42 VPWR VGND sg13cmos5l_decap_8
XFILLER_587_105 VPWR VGND sg13cmos5l_decap_8
XFILLER_292_192 VPWR VGND sg13cmos5l_decap_8
X_1073_ _1073_/Q Tile_X0Y0_FrameData[26] VGND VPWR Tile_X0Y9_FrameStrobe[4] latch
XFILLER_441_134 VPWR VGND sg13cmos5l_decap_4
XFILLER_398_21 VPWR VGND sg13cmos5l_decap_8
X_4901_ _4901_/X Tile_X0Y9_N2MID[0] Tile_X0Y9_N2END[0] _4932_/X _4816_/X _0695_/Q
+ _0694_/Q VPWR VGND sg13cmos5l_mux4_1
XFILLER_45_180 VPWR VGND sg13cmos5l_fill_1
X_4832_ _4832_/X Tile_X0Y9_W1END[0] Tile_X0Y9_W2MID[3] Tile_X0Y9_W2END[3] _4906_/X
+ _0875_/Q _0874_/Q VPWR VGND sg13cmos5l_mux4_1
XFILLER_60_161 VPWR VGND sg13cmos5l_decap_8
XFILLER_595_171 VPWR VGND sg13cmos5l_fill_1
XFILLER_548_35 VPWR VGND sg13cmos5l_decap_8
XFILLER_695_63 VPWR VGND sg13cmos5l_decap_8
XFILLER_267_14 VPWR VGND sg13cmos5l_decap_8
X_1975_ _1975_/Q Tile_X0Y4_FrameData[14] VGND VPWR Tile_X0Y9_FrameStrobe[1] latch
X_4763_ _4763_/X Tile_X0Y9_N4END[7] _0074_/X _4808_/X _4812_/X _0521_/Q _0520_/Q VPWR
+ VGND sg13cmos5l_mux4_1
XANTENNA__3078__X Tile_X0Y4_E2BEGb[4] VPWR VGND sg13cmos5l_antennanp
XFILLER_354_119 VPWR VGND sg13cmos5l_decap_8
XFILLER_146_200 VPWR VGND sg13cmos5l_decap_8
X_0926_ _0926_/Q Tile_X0Y9_FrameData[1] VGND VPWR Tile_X0Y9_FrameStrobe[7] latch
X_3714_ AXI_M_SOC_WDATA24 Tile_X0Y6_WW4END[0] Tile_X0Y6_WW4END[8] Tile_X0Y6_W6END[8]
+ _4576_/X _2511_/Q _2510_/Q VPWR VGND sg13cmos5l_mux4_1
X_4694_ _4694_/X _4665_/X Tile_X0Y9_N4END[10] _4664_/X _0054_/X _0195_/Q _0194_/Q
+ VPWR VGND sg13cmos5l_mux4_1
XFILLER_417_28 VPWR VGND sg13cmos5l_decap_8
X_0857_ _0857_/Q Tile_X0Y9_FrameData[6] VGND VPWR Tile_X0Y9_FrameStrobe[5] latch
X_3645_ AXI_M_SOC_AWADDR6 Tile_X0Y5_WW4END[6] Tile_X0Y5_WW4END[14] Tile_X0Y5_W6END[6]
+ _4457_/X _2259_/Q _2258_/Q VPWR VGND sg13cmos5l_mux4_1
XFILLER_564_56 VPWR VGND sg13cmos5l_decap_8
XFILLER_347_91 VPWR VGND sg13cmos5l_decap_8
X_3576_ Tile_X0Y9_FrameData_O[6] Tile_X0Y9_FrameData[6] VPWR VGND sg13cmos5l_buf_1
XFILLER_362_196 VPWR VGND sg13cmos5l_fill_2
X_0788_ _0788_/Q Tile_X0Y9_FrameData[11] VGND VPWR Tile_X0Y9_FrameStrobe[3] latch
XFILLER_283_35 VPWR VGND sg13cmos5l_decap_8
X_2527_ _2527_/Q Tile_X0Y6_FrameData[8] VGND VPWR Tile_X0Y9_FrameStrobe[2] latch
X_2458_ _2458_/Q Tile_X0Y6_FrameData[13] VGND VPWR Tile_X0Y9_FrameStrobe[0] latch
XFILLER_433_49 VPWR VGND sg13cmos5l_decap_8
XFILLER_363_90 VPWR VGND sg13cmos5l_fill_1
XFILLER_29_27 VPWR VGND sg13cmos5l_decap_8
XFILLER_275_126 VPWR VGND sg13cmos5l_fill_2
X_1409_ _1409_/Q Tile_X0Y1_FrameData[24] VGND VPWR Tile_X0Y9_FrameStrobe[7] latch
XFILLER_152_28 VPWR VGND sg13cmos5l_decap_8
XFILLER_680_123 VPWR VGND sg13cmos5l_fill_2
XFILLER_665_197 VPWR VGND sg13cmos5l_decap_8
X_2389_ _2389_/Q Tile_X0Y5_FrameData[16] VGND VPWR Tile_X0Y9_FrameStrobe[6] latch
XANTENNA__3541__X Tile_X0Y9_E2BEGb[7] VPWR VGND sg13cmos5l_antennanp
X_4128_ _4128_/X Tile_X0Y1_W2MID[7] Tile_X0Y1_W2END[7] Tile_X0Y1_W6END[8] _3989_/X
+ _1381_/Q _1380_/Q VPWR VGND sg13cmos5l_mux4_1
XFILLER_216_215 VPWR VGND sg13cmos5l_fill_2
XFILLER_283_170 VPWR VGND sg13cmos5l_fill_1
XFILLER_432_112 VPWR VGND sg13cmos5l_decap_8
XFILLER_589_42 VPWR VGND sg13cmos5l_decap_8
XFILLER_578_105 VPWR VGND sg13cmos5l_decap_8
XFILLER_283_192 VPWR VGND sg13cmos5l_decap_8
X_4059_ _4059_/X Tile_X0Y2_WW4END[12] AXI_M_SOC_AWREADY _4113_/X _4102_/X _1555_/Q
+ _1554_/Q VPWR VGND sg13cmos5l_mux4_1
XFILLER_232_83 VPWR VGND sg13cmos5l_decap_8
XFILLER_432_145 VPWR VGND sg13cmos5l_decap_8
XFILLER_578_138 VPWR VGND sg13cmos5l_fill_2
XFILLER_385_211 VPWR VGND sg13cmos5l_fill_1
XFILLER_243_7 VPWR VGND sg13cmos5l_decap_8
XFILLER_458_35 VPWR VGND sg13cmos5l_decap_8
XFILLER_101_87 VPWR VGND sg13cmos5l_decap_8
XFILLER_177_14 VPWR VGND sg13cmos5l_decap_8
XFILLER_410_7 VPWR VGND sg13cmos5l_decap_8
XFILLER_137_211 VPWR VGND sg13cmos5l_fill_1
XFILLER_508_7 VPWR VGND sg13cmos5l_decap_8
XFILLER_608_49 VPWR VGND sg13cmos5l_decap_8
XFILLER_538_90 VPWR VGND sg13cmos5l_fill_2
XFILLER_499_112 VPWR VGND sg13cmos5l_decap_8
XFILLER_327_28 VPWR VGND sg13cmos5l_decap_8
XANTENNA__3716__X AXI_M_SOC_WDATA26 VPWR VGND sg13cmos5l_antennanp
XFILLER_502_105 VPWR VGND sg13cmos5l_decap_8
XFILLER_193_13 VPWR VGND sg13cmos5l_decap_8
XFILLER_105_130 VPWR VGND sg13cmos5l_decap_8
XFILLER_10_84 VPWR VGND sg13cmos5l_decap_8
XFILLER_266_104 VPWR VGND sg13cmos5l_decap_4
XFILLER_126_73 VPWR VGND sg13cmos5l_decap_8
XFILLER_343_49 VPWR VGND sg13cmos5l_decap_8
XFILLER_704_70 VPWR VGND sg13cmos5l_decap_8
XFILLER_490_77 VPWR VGND sg13cmos5l_decap_8
XFILLER_640_14 VPWR VGND sg13cmos5l_decap_8
XFILLER_120_166 VPWR VGND sg13cmos5l_fill_1
XANTENNA__3451__X Tile_X0Y1_FrameData_O[9] VPWR VGND sg13cmos5l_antennanp
XFILLER_120_188 VPWR VGND sg13cmos5l_decap_8
XFILLER_671_156 VPWR VGND sg13cmos5l_fill_1
XFILLER_470_207 VPWR VGND sg13cmos5l_fill_2
XFILLER_207_204 VPWR VGND sg13cmos5l_fill_2
XFILLER_671_178 VPWR VGND sg13cmos5l_decap_4
XFILLER_612_201 VPWR VGND sg13cmos5l_decap_8
XFILLER_569_105 VPWR VGND sg13cmos5l_decap_8
XFILLER_499_42 VPWR VGND sg13cmos5l_decap_8
XFILLER_423_112 VPWR VGND sg13cmos5l_decap_4
XFILLER_367_0 VPWR VGND sg13cmos5l_decap_8
XFILLER_534_0 VPWR VGND sg13cmos5l_decap_8
XFILLER_649_56 VPWR VGND sg13cmos5l_decap_8
XFILLER_376_200 VPWR VGND sg13cmos5l_fill_1
XFILLER_35_70 VPWR VGND sg13cmos5l_decap_8
XFILLER_42_150 VPWR VGND sg13cmos5l_decap_4
XFILLER_42_161 VPWR VGND sg13cmos5l_decap_8
XFILLER_577_182 VPWR VGND sg13cmos5l_fill_2
XFILLER_368_35 VPWR VGND sg13cmos5l_decap_8
XFILLER_368_46 VPWR VGND sg13cmos5l_fill_1
XFILLER_89_7 VPWR VGND sg13cmos5l_decap_8
XFILLER_701_0 VPWR VGND sg13cmos5l_decap_8
X_1760_ _1760_/Q Tile_X0Y3_FrameData[9] VGND VPWR Tile_X0Y9_FrameStrobe[2] latch
XFILLER_592_185 VPWR VGND sg13cmos5l_decap_8
XFILLER_518_49 VPWR VGND sg13cmos5l_decap_8
X_0711_ _0711_/Q Tile_X0Y9_FrameData[24] VGND VPWR Tile_X0Y9_FrameStrobe[1] latch
XFILLER_665_77 VPWR VGND sg13cmos5l_decap_8
XFILLER_237_28 VPWR VGND sg13cmos5l_fill_2
X_1691_ _1691_/Q Tile_X0Y3_FrameData[14] VGND VPWR Tile_X0Y9_FrameStrobe[0] latch
XANTENNA__3626__X Tile_X0Y9_S4BEG[4] VPWR VGND sg13cmos5l_antennanp
X_3430_ Tile_X0Y4_FrameData_O[21] Tile_X0Y4_FrameData[21] VPWR VGND sg13cmos5l_buf_1
X_0642_ _0642_/Q Tile_X0Y8_FrameData[29] VGND VPWR Tile_X0Y9_FrameStrobe[7] latch
XFILLER_694_204 VPWR VGND sg13cmos5l_fill_1
XFILLER_681_21 VPWR VGND sg13cmos5l_decap_8
X_3361_ Tile_X0Y2_EE4BEG[0] _4056_/X VPWR VGND sg13cmos5l_buf_1
X_0573_ _0573_/Q Tile_X0Y8_FrameData[2] VGND VPWR Tile_X0Y9_FrameStrobe[4] latch
X_2312_ _2312_/Q Tile_X0Y5_FrameData[29] VGND VPWR Tile_X0Y9_FrameStrobe[4] latch
X_3292_ Tile_X0Y0_E2BEGb[0] _3812_/X VPWR VGND sg13cmos5l_buf_1
XFILLER_446_204 VPWR VGND sg13cmos5l_fill_1
XFILLER_614_70 VPWR VGND sg13cmos5l_decap_8
XFILLER_501_182 VPWR VGND sg13cmos5l_decap_8
XFILLER_183_90 VPWR VGND sg13cmos5l_decap_8
XFILLER_647_175 VPWR VGND sg13cmos5l_decap_8
X_2243_ _2243_/Q Tile_X0Y5_FrameData[2] VGND VPWR Tile_X0Y9_FrameStrobe[1] latch
XFILLER_550_14 VPWR VGND sg13cmos5l_decap_8
XANTENNA__3361__X Tile_X0Y2_EE4BEG[0] VPWR VGND sg13cmos5l_antennanp
X_2174_ _2174_/Q Tile_X0Y4_FrameData[7] VGND VPWR Tile_X0Y9_FrameStrobe[7] latch
XFILLER_550_69 VPWR VGND sg13cmos5l_decap_8
XFILLER_414_112 VPWR VGND sg13cmos5l_decap_8
XFILLER_265_181 VPWR VGND sg13cmos5l_decap_4
X_1125_ _1125_/Q Tile_X0Y0_FrameData[6] VGND VPWR Tile_X0Y9_FrameStrobe[5] latch
XFILLER_700_28 VPWR VGND sg13cmos5l_decap_8
XFILLER_80_201 VPWR VGND sg13cmos5l_decap_4
XFILLER_280_140 VPWR VGND sg13cmos5l_decap_8
XFILLER_630_91 VPWR VGND sg13cmos5l_decap_8
XFILLER_202_42 VPWR VGND sg13cmos5l_decap_8
X_1056_ _1056_/Q Tile_X0Y0_FrameData[11] VGND VPWR Tile_X0Y9_FrameStrobe[3] latch
XFILLER_18_180 VPWR VGND sg13cmos5l_fill_1
XFILLER_280_184 VPWR VGND sg13cmos5l_decap_4
XFILLER_559_56 VPWR VGND sg13cmos5l_decap_8
XFILLER_575_119 VPWR VGND sg13cmos5l_decap_8
XFILLER_367_211 VPWR VGND sg13cmos5l_decap_8
XFILLER_717_102 VPWR VGND sg13cmos5l_fill_1
XFILLER_717_113 VPWR VGND sg13cmos5l_fill_2
XFILLER_568_182 VPWR VGND sg13cmos5l_decap_4
XFILLER_33_172 VPWR VGND sg13cmos5l_decap_8
XFILLER_278_35 VPWR VGND sg13cmos5l_decap_8
X_4815_ _4815_/X _4783_/X Tile_X0Y9_N4END[7] _4782_/X _0074_/X _0441_/Q _0440_/Q VPWR
+ VGND sg13cmos5l_mux4_1
XFILLER_178_177 VPWR VGND sg13cmos5l_decap_8
XFILLER_717_168 VPWR VGND sg13cmos5l_fill_2
X_4746_ _4746_/X Tile_X0Y8_WW4END[13] AXI_M_SOC_RDATA10 _4813_/X _4788_/X _0555_/Q
+ _0554_/Q VPWR VGND sg13cmos5l_mux4_1
X_1958_ _1958_/Q Tile_X0Y4_FrameData[31] VGND VPWR Tile_X0Y9_FrameStrobe[1] latch
XFILLER_583_196 VPWR VGND sg13cmos5l_decap_8
XFILLER_428_49 VPWR VGND sg13cmos5l_decap_8
XFILLER_575_77 VPWR VGND sg13cmos5l_decap_8
XFILLER_147_28 VPWR VGND sg13cmos5l_decap_8
X_0909_ _0909_/Q Tile_X0Y9_FrameData[18] VGND VPWR Tile_X0Y9_FrameStrobe[7] latch
X_1889_ _1889_/Q Tile_X0Y3_FrameData[8] VGND VPWR Tile_X0Y9_FrameStrobe[6] latch
X_4677_ _4677_/X _4226_/X _4230_/X _4234_/X _4210_/X _1865_/Q _1864_/Q VPWR VGND sg13cmos5l_mux4_1
XFILLER_335_163 VPWR VGND sg13cmos5l_decap_8
XFILLER_294_56 VPWR VGND sg13cmos5l_decap_8
XANTENNA__3536__X Tile_X0Y9_E2BEGb[2] VPWR VGND sg13cmos5l_antennanp
X_3628_ Tile_X0Y9_S4BEG[6] _3628_/A VPWR VGND sg13cmos5l_buf_1
XFILLER_591_21 VPWR VGND sg13cmos5l_decap_8
XFILLER_496_126 VPWR VGND sg13cmos5l_decap_8
X_3559_ Tile_X0Y9_EE4BEG[5] _4869_/X VPWR VGND sg13cmos5l_buf_1
XFILLER_437_204 VPWR VGND sg13cmos5l_decap_8
XFILLER_248_104 VPWR VGND sg13cmos5l_fill_2
XFILLER_102_144 VPWR VGND sg13cmos5l_decap_8
XFILLER_653_112 VPWR VGND sg13cmos5l_decap_8
XFILLER_460_14 VPWR VGND sg13cmos5l_decap_8
XANTENNA__3271__X Tile_X0Y0_EE4BEG[7] VPWR VGND sg13cmos5l_antennanp
XFILLER_653_156 VPWR VGND sg13cmos5l_fill_1
XFILLER_243_93 VPWR VGND sg13cmos5l_decap_4
XFILLER_653_178 VPWR VGND sg13cmos5l_fill_2
XFILLER_256_170 VPWR VGND sg13cmos5l_decap_8
XFILLER_405_123 VPWR VGND sg13cmos5l_decap_8
XFILLER_610_28 VPWR VGND sg13cmos5l_decap_8
XFILLER_360_7 VPWR VGND sg13cmos5l_decap_8
XFILLER_458_7 VPWR VGND sg13cmos5l_decap_8
XFILLER_112_42 VPWR VGND sg13cmos5l_decap_8
XFILLER_72_35 VPWR VGND sg13cmos5l_decap_8
XFILLER_566_119 VPWR VGND sg13cmos5l_decap_8
XFILLER_625_7 VPWR VGND sg13cmos5l_decap_8
XFILLER_169_122 VPWR VGND sg13cmos5l_decap_8
XFILLER_188_35 VPWR VGND sg13cmos5l_decap_8
XFILLER_708_179 VPWR VGND sg13cmos5l_fill_1
XFILLER_574_185 VPWR VGND sg13cmos5l_decap_8
XFILLER_227_2 VPWR VGND sg13cmos5l_fill_1
XFILLER_338_49 VPWR VGND sg13cmos5l_decap_8
XFILLER_485_77 VPWR VGND sg13cmos5l_decap_8
XFILLER_635_14 VPWR VGND sg13cmos5l_decap_8
XFILLER_326_141 VPWR VGND sg13cmos5l_fill_2
XANTENNA__3446__X Tile_X0Y1_FrameData_O[4] VPWR VGND sg13cmos5l_antennanp
XFILLER_326_174 VPWR VGND sg13cmos5l_decap_4
XFILLER_115_0 VPWR VGND sg13cmos5l_decap_8
XFILLER_530_211 VPWR VGND sg13cmos5l_fill_1
XFILLER_676_215 VPWR VGND sg13cmos5l_fill_2
XFILLER_21_94 VPWR VGND sg13cmos5l_decap_4
XFILLER_97_21 VPWR VGND sg13cmos5l_decap_8
XFILLER_487_137 VPWR VGND sg13cmos5l_fill_1
XFILLER_140_206 VPWR VGND sg13cmos5l_decap_4
XFILLER_140_217 VPWR VGND sg13cmos5l_fill_1
XFILLER_97_65 VPWR VGND sg13cmos5l_decap_8
XFILLER_651_35 VPWR VGND sg13cmos5l_decap_8
XFILLER_434_70 VPWR VGND sg13cmos5l_decap_8
XFILLER_428_215 VPWR VGND sg13cmos5l_fill_2
XFILLER_629_175 VPWR VGND sg13cmos5l_decap_8
XFILLER_484_0 VPWR VGND sg13cmos5l_decap_8
XFILLER_239_126 VPWR VGND sg13cmos5l_fill_1
XFILLER_644_112 VPWR VGND sg13cmos5l_decap_8
XFILLER_370_14 VPWR VGND sg13cmos5l_decap_8
XFILLER_239_148 VPWR VGND sg13cmos5l_decap_8
XANTENNA__3181__X Tile_X0Y0_N4BEG[5] VPWR VGND sg13cmos5l_antennanp
XFILLER_651_0 VPWR VGND sg13cmos5l_decap_8
XFILLER_644_189 VPWR VGND sg13cmos5l_decap_8
XFILLER_520_28 VPWR VGND sg13cmos5l_decap_8
XFILLER_262_162 VPWR VGND sg13cmos5l_decap_4
X_2930_ Tile_X0Y8_E2BEGb[6] _4742_/X VPWR VGND sg13cmos5l_buf_1
XFILLER_676_21 VPWR VGND sg13cmos5l_decap_8
XFILLER_15_172 VPWR VGND sg13cmos5l_fill_1
XFILLER_15_194 VPWR VGND sg13cmos5l_decap_8
X_2861_ Tile_X0Y6_E6BEG[10] _4538_/X VPWR VGND sg13cmos5l_buf_1
XFILLER_714_105 VPWR VGND sg13cmos5l_decap_8
X_4600_ _4600_/X Tile_X0Y7_W1END[0] Tile_X0Y7_WW4END[12] Tile_X0Y7_W6END[4] _4684_/X
+ _0355_/Q _0354_/Q VPWR VGND sg13cmos5l_mux4_1
X_1812_ _1812_/Q Tile_X0Y3_FrameData[21] VGND VPWR Tile_X0Y9_FrameStrobe[4] latch
XFILLER_30_175 VPWR VGND sg13cmos5l_decap_8
X_2792_ Tile_X0Y3_E6BEG[2] _4182_/X VPWR VGND sg13cmos5l_buf_1
XFILLER_609_70 VPWR VGND sg13cmos5l_decap_8
XFILLER_175_158 VPWR VGND sg13cmos5l_decap_8
XFILLER_395_77 VPWR VGND sg13cmos5l_fill_1
X_1743_ _1743_/Q Tile_X0Y3_FrameData[26] VGND VPWR Tile_X0Y9_FrameStrobe[2] latch
X_4531_ _4531_/X Tile_X0Y9_N4END[15] _0150_/X _4576_/X _4580_/X _2545_/Q _2544_/Q
+ VPWR VGND sg13cmos5l_mux4_1
XFILLER_545_14 VPWR VGND sg13cmos5l_decap_8
XFILLER_7_63 VPWR VGND sg13cmos5l_decap_8
XFILLER_395_99 VPWR VGND sg13cmos5l_decap_8
XANTENNA__3356__X Tile_X0Y2_FrameData_O[27] VPWR VGND sg13cmos5l_antennanp
XFILLER_692_42 VPWR VGND sg13cmos5l_decap_8
X_1674_ _1674_/Q Tile_X0Y2_FrameData[31] VGND VPWR Tile_X0Y9_FrameStrobe[0] latch
X_4462_ _4462_/X _4427_/X _0097_/X _4426_/X _0156_/X _2215_/Q _2214_/Q VPWR VGND sg13cmos5l_mux4_1
XFILLER_667_204 VPWR VGND sg13cmos5l_decap_8
XFILLER_478_104 VPWR VGND sg13cmos5l_decap_8
XFILLER_317_196 VPWR VGND sg13cmos5l_fill_2
XFILLER_667_215 VPWR VGND sg13cmos5l_fill_2
X_0625_ _0625_/Q Tile_X0Y8_FrameData[14] VGND VPWR Tile_X0Y9_FrameStrobe[6] latch
X_3413_ Tile_X0Y4_FrameData_O[4] Tile_X0Y4_FrameData[4] VPWR VGND sg13cmos5l_buf_1
X_4393_ _4393_/X Tile_X0Y5_WW4END[10] AXI_M_SOC_RLAST _4461_/X _4432_/X _2317_/Q _2316_/Q
+ VPWR VGND sg13cmos5l_mux4_1
XFILLER_625_91 VPWR VGND sg13cmos5l_decap_8
X_3344_ Tile_X0Y2_FrameData_O[15] Tile_X0Y2_FrameData[15] VPWR VGND sg13cmos5l_buf_1
X_0556_ _0556_/Q Tile_X0Y8_FrameData[19] VGND VPWR Tile_X0Y9_FrameStrobe[4] latch
XFILLER_561_35 VPWR VGND sg13cmos5l_decap_8
XFILLER_344_70 VPWR VGND sg13cmos5l_decap_8
XFILLER_30_0 VPWR VGND sg13cmos5l_decap_8
XFILLER_635_112 VPWR VGND sg13cmos5l_decap_8
XFILLER_280_14 VPWR VGND sg13cmos5l_decap_8
X_3275_ Tile_X0Y0_EE4BEG[11] _3831_/X VPWR VGND sg13cmos5l_buf_1
XFILLER_635_123 VPWR VGND sg13cmos5l_fill_2
X_0487_ _0487_/Q Tile_X0Y8_FrameData[24] VGND VPWR Tile_X0Y9_FrameStrobe[2] latch
XANTENNA__3091__X Tile_X0Y7_E2BEG[5] VPWR VGND sg13cmos5l_antennanp
X_2226_ _2226_/Q Tile_X0Y5_FrameData[19] VGND VPWR Tile_X0Y9_FrameStrobe[1] latch
XFILLER_635_167 VPWR VGND sg13cmos5l_fill_2
XFILLER_434_207 VPWR VGND sg13cmos5l_decap_8
XFILLER_711_49 VPWR VGND sg13cmos5l_decap_8
XFILLER_245_129 VPWR VGND sg13cmos5l_decap_4
XFILLER_650_126 VPWR VGND sg13cmos5l_decap_8
XFILLER_430_28 VPWR VGND sg13cmos5l_decap_8
XFILLER_399_100 VPWR VGND sg13cmos5l_fill_1
X_2157_ _2157_/Q Tile_X0Y4_FrameData[24] VGND VPWR Tile_X0Y9_FrameStrobe[7] latch
XFILLER_213_63 VPWR VGND sg13cmos5l_decap_8
XFILLER_253_140 VPWR VGND sg13cmos5l_fill_1
XFILLER_26_28 VPWR VGND sg13cmos5l_decap_8
XFILLER_399_144 VPWR VGND sg13cmos5l_decap_8
XFILLER_360_91 VPWR VGND sg13cmos5l_fill_2
X_1108_ _1108_/Q Tile_X0Y0_FrameData[23] VGND VPWR Tile_X0Y9_FrameStrobe[5] latch
XFILLER_253_162 VPWR VGND sg13cmos5l_decap_8
XFILLER_253_173 VPWR VGND sg13cmos5l_fill_2
X_2088_ _2088_/Q Tile_X0Y4_FrameData[29] VGND VPWR Tile_X0Y9_FrameStrobe[5] latch
XFILLER_253_195 VPWR VGND sg13cmos5l_decap_8
XFILLER_402_126 VPWR VGND sg13cmos5l_fill_1
XFILLER_289_56 VPWR VGND sg13cmos5l_decap_8
XFILLER_548_119 VPWR VGND sg13cmos5l_decap_8
X_1039_ _1039_/Q Tile_X0Y0_FrameData[28] VGND VPWR Tile_X0Y9_FrameStrobe[3] latch
XFILLER_399_199 VPWR VGND sg13cmos5l_fill_2
XFILLER_586_21 VPWR VGND sg13cmos5l_decap_8
XFILLER_556_130 VPWR VGND sg13cmos5l_fill_2
XFILLER_166_114 VPWR VGND sg13cmos5l_decap_8
XFILLER_705_105 VPWR VGND sg13cmos5l_decap_8
XFILLER_21_186 VPWR VGND sg13cmos5l_fill_2
XFILLER_571_133 VPWR VGND sg13cmos5l_decap_8
XFILLER_519_70 VPWR VGND sg13cmos5l_fill_2
X_4729_ _4729_/X Tile_X0Y8_W2MID[6] AXI_M_SOC_RDATA9 _4787_/X _4786_/X _0589_/Q _0588_/Q
+ VPWR VGND sg13cmos5l_mux4_1
XFILLER_455_14 VPWR VGND sg13cmos5l_decap_8
XFILLER_308_152 VPWR VGND sg13cmos5l_decap_8
XFILLER_370_217 VPWR VGND sg13cmos5l_fill_1
XFILLER_107_203 VPWR VGND sg13cmos5l_decap_4
XANTENNA__3266__X Tile_X0Y0_EE4BEG[2] VPWR VGND sg13cmos5l_antennanp
XFILLER_181_139 VPWR VGND sg13cmos5l_fill_2
XFILLER_238_82 VPWR VGND sg13cmos5l_fill_1
XFILLER_713_182 VPWR VGND sg13cmos5l_decap_4
XFILLER_658_215 VPWR VGND sg13cmos5l_fill_2
XFILLER_605_28 VPWR VGND sg13cmos5l_decap_8
XFILLER_323_199 VPWR VGND sg13cmos5l_fill_1
XFILLER_484_118 VPWR VGND sg13cmos5l_decap_4
XFILLER_471_35 VPWR VGND sg13cmos5l_decap_8
XFILLER_88_142 VPWR VGND sg13cmos5l_decap_8
XFILLER_67_24 VPWR VGND sg13cmos5l_decap_8
XFILLER_626_112 VPWR VGND sg13cmos5l_decap_8
XFILLER_190_14 VPWR VGND sg13cmos5l_decap_8
XFILLER_107_97 VPWR VGND sg13cmos5l_decap_8
XFILLER_575_7 VPWR VGND sg13cmos5l_decap_8
XFILLER_492_140 VPWR VGND sg13cmos5l_decap_8
XFILLER_291_213 VPWR VGND sg13cmos5l_decap_4
XFILLER_236_118 VPWR VGND sg13cmos5l_decap_8
XFILLER_621_49 VPWR VGND sg13cmos5l_decap_8
XFILLER_641_126 VPWR VGND sg13cmos5l_decap_8
XFILLER_579_200 VPWR VGND sg13cmos5l_decap_8
XFILLER_340_28 VPWR VGND sg13cmos5l_decap_8
XFILLER_244_140 VPWR VGND sg13cmos5l_decap_8
XFILLER_270_91 VPWR VGND sg13cmos5l_decap_8
XFILLER_83_78 VPWR VGND sg13cmos5l_decap_8
XFILLER_189_217 VPWR VGND sg13cmos5l_fill_1
XFILLER_199_56 VPWR VGND sg13cmos5l_decap_8
XFILLER_496_21 VPWR VGND sg13cmos5l_decap_8
XFILLER_16_94 VPWR VGND sg13cmos5l_decap_4
XFILLER_157_103 VPWR VGND sg13cmos5l_decap_8
XFILLER_496_98 VPWR VGND sg13cmos5l_decap_8
XFILLER_646_35 VPWR VGND sg13cmos5l_decap_8
XFILLER_429_70 VPWR VGND sg13cmos5l_decap_8
XFILLER_365_14 VPWR VGND sg13cmos5l_decap_8
XANTENNA__3176__X Tile_X0Y0_N4BEG[0] VPWR VGND sg13cmos5l_antennanp
XFILLER_711_119 VPWR VGND sg13cmos5l_decap_8
XFILLER_699_0 VPWR VGND sg13cmos5l_decap_8
XFILLER_515_28 VPWR VGND sg13cmos5l_decap_8
XFILLER_113_217 VPWR VGND sg13cmos5l_fill_1
XFILLER_662_56 VPWR VGND sg13cmos5l_decap_8
X_0410_ _0410_/Q Tile_X0Y7_FrameData[5] VGND VPWR Tile_X0Y9_FrameStrobe[7] latch
XFILLER_314_199 VPWR VGND sg13cmos5l_decap_8
XFILLER_79_120 VPWR VGND sg13cmos5l_decap_8
X_1390_ _1390_/Q Tile_X0Y1_FrameData[11] VGND VPWR Tile_X0Y9_FrameStrobe[6] latch
XFILLER_381_35 VPWR VGND sg13cmos5l_decap_8
XFILLER_617_112 VPWR VGND sg13cmos5l_fill_1
X_0341_ _0341_/Q Tile_X0Y7_FrameData[10] VGND VPWR Tile_X0Y9_FrameStrobe[5] latch
XFILLER_381_68 VPWR VGND sg13cmos5l_fill_2
X_3060_ Tile_X0Y5_FrameData_O[19] Tile_X0Y5_FrameData[19] VPWR VGND sg13cmos5l_buf_1
X_0272_ _0272_/Q Tile_X0Y7_FrameData[15] VGND VPWR Tile_X0Y9_FrameStrobe[3] latch
X_2011_ _2011_/Q Tile_X0Y4_FrameData[10] VGND VPWR Tile_X0Y9_FrameStrobe[2] latch
XFILLER_250_28 VPWR VGND sg13cmos5l_decap_8
XFILLER_687_42 VPWR VGND sg13cmos5l_decap_8
XFILLER_640_192 VPWR VGND sg13cmos5l_fill_2
XFILLER_330_83 VPWR VGND sg13cmos5l_decap_8
XFILLER_250_143 VPWR VGND sg13cmos5l_fill_2
X_3962_ _3962_/X Tile_X0Y1_WW4END[1] AXI_M_SOC_ARREADY _4009_/X _3991_/X _1285_/Q
+ _1284_/Q VPWR VGND sg13cmos5l_mux4_1
XFILLER_687_86 VPWR VGND sg13cmos5l_fill_1
X_2913_ Tile_X0Y8_E1BEG[1] _4725_/X VPWR VGND sg13cmos5l_buf_1
X_3893_ _3893_/X Tile_X0Y1_W2MID[5] Tile_X0Y1_W2END[5] Tile_X0Y1_W6END[5] _3993_/X
+ _1413_/Q _1412_/Q VPWR VGND sg13cmos5l_mux4_1
XFILLER_337_203 VPWR VGND sg13cmos5l_fill_2
XFILLER_538_163 VPWR VGND sg13cmos5l_decap_8
X_2844_ Tile_X0Y6_E2BEGb[1] _4505_/X VPWR VGND sg13cmos5l_buf_1
XFILLER_556_35 VPWR VGND sg13cmos5l_decap_8
XFILLER_339_70 VPWR VGND sg13cmos5l_decap_8
XFILLER_78_0 VPWR VGND sg13cmos5l_decap_8
XFILLER_275_14 VPWR VGND sg13cmos5l_decap_8
XFILLER_163_117 VPWR VGND sg13cmos5l_decap_8
X_2775_ Tile_X0Y3_EE4BEG[1] _4165_/X VPWR VGND sg13cmos5l_buf_1
XANTENNA__3086__X Tile_X0Y7_E2BEG[0] VPWR VGND sg13cmos5l_antennanp
XFILLER_702_119 VPWR VGND sg13cmos5l_decap_4
X_4514_ _4514_/X Tile_X0Y6_WW4END[13] AXI_M_SOC_RDATA26 _4581_/X _4556_/X _2579_/Q
+ _2578_/Q VPWR VGND sg13cmos5l_mux4_1
XFILLER_156_180 VPWR VGND sg13cmos5l_decap_8
X_1726_ _1726_/Q Tile_X0Y3_FrameData[11] VGND VPWR Tile_X0Y9_FrameStrobe[1] latch
XFILLER_706_49 VPWR VGND sg13cmos5l_decap_8
XFILLER_305_133 VPWR VGND sg13cmos5l_fill_2
XFILLER_208_41 VPWR VGND sg13cmos5l_decap_8
XFILLER_104_206 VPWR VGND sg13cmos5l_decap_4
X_1657_ _1657_/Q Tile_X0Y2_FrameData[24] VGND VPWR Tile_X0Y9_FrameStrobe[7] latch
X_4445_ _4445_/X Tile_X0Y9_W1END[2] Tile_X0Y9_WW4END[2] Tile_X0Y9_W6END[10] _4918_/X
+ _0897_/Q _0896_/Q VPWR VGND sg13cmos5l_mux4_1
XFILLER_425_28 VPWR VGND sg13cmos5l_decap_8
XFILLER_104_217 VPWR VGND sg13cmos5l_fill_1
XFILLER_572_56 VPWR VGND sg13cmos5l_decap_8
XFILLER_355_91 VPWR VGND sg13cmos5l_decap_8
XFILLER_171_194 VPWR VGND sg13cmos5l_decap_8
X_0608_ _0608_/Q Tile_X0Y8_FrameData[31] VGND VPWR Tile_X0Y9_FrameStrobe[6] latch
X_1588_ _1588_/Q Tile_X0Y2_FrameData[29] VGND VPWR Tile_X0Y9_FrameStrobe[5] latch
X_4376_ _4376_/X Tile_X0Y5_W2MID[3] AXI_M_SOC_RVALID _4434_/X _4433_/X _2351_/Q _2350_/Q
+ VPWR VGND sg13cmos5l_mux4_1
XFILLER_291_35 VPWR VGND sg13cmos5l_decap_8
XFILLER_608_123 VPWR VGND sg13cmos5l_decap_4
XFILLER_459_192 VPWR VGND sg13cmos5l_decap_8
X_0539_ _0539_/Q Tile_X0Y8_FrameData[4] VGND VPWR Tile_X0Y9_FrameStrobe[3] latch
X_3327_ Tile_X0Y4_EE4BEG[15] _4287_/X VPWR VGND sg13cmos5l_buf_1
XFILLER_85_112 VPWR VGND sg13cmos5l_fill_2
X_3258_ Tile_X0Y0_FrameData_O[26] Tile_X0Y0_FrameData[26] VPWR VGND sg13cmos5l_buf_1
XFILLER_441_49 VPWR VGND sg13cmos5l_decap_8
XFILLER_37_27 VPWR VGND sg13cmos5l_decap_8
XFILLER_224_84 VPWR VGND sg13cmos5l_decap_4
XFILLER_371_90 VPWR VGND sg13cmos5l_decap_8
XFILLER_85_167 VPWR VGND sg13cmos5l_decap_8
XFILLER_160_17 VPWR VGND sg13cmos5l_fill_1
X_2209_ _2209_/Q Tile_X0Y5_FrameData[4] VGND VPWR Tile_X0Y9_FrameStrobe[0] latch
XFILLER_160_39 VPWR VGND sg13cmos5l_decap_8
X_3189_ Tile_X0Y0_N4BEG[13] _3189_/A VPWR VGND sg13cmos5l_buf_1
XFILLER_576_203 VPWR VGND sg13cmos5l_decap_8
XFILLER_597_42 VPWR VGND sg13cmos5l_decap_4
XFILLER_41_204 VPWR VGND sg13cmos5l_fill_2
XFILLER_241_143 VPWR VGND sg13cmos5l_decap_8
XFILLER_387_136 VPWR VGND sg13cmos5l_fill_1
XFILLER_156_7 VPWR VGND sg13cmos5l_decap_8
XFILLER_53_59 VPWR VGND sg13cmos5l_decap_8
XFILLER_597_97 VPWR VGND sg13cmos5l_decap_4
XFILLER_149_6 VPWR VGND sg13cmos5l_decap_8
XFILLER_529_163 VPWR VGND sg13cmos5l_fill_2
XFILLER_544_100 VPWR VGND sg13cmos5l_decap_4
XFILLER_323_7 VPWR VGND sg13cmos5l_decap_8
XFILLER_139_147 VPWR VGND sg13cmos5l_decap_8
XFILLER_466_35 VPWR VGND sg13cmos5l_decap_8
XFILLER_185_14 VPWR VGND sg13cmos5l_decap_8
XFILLER_466_79 VPWR VGND sg13cmos5l_fill_2
XFILLER_544_199 VPWR VGND sg13cmos5l_decap_8
XFILLER_616_49 VPWR VGND sg13cmos5l_decap_8
XFILLER_698_170 VPWR VGND sg13cmos5l_fill_1
XFILLER_162_150 VPWR VGND sg13cmos5l_decap_4
XANTENNA__0132__Y AXI_M_SOC_AWLEN7 VPWR VGND sg13cmos5l_antennanp
XFILLER_692_7 VPWR VGND sg13cmos5l_decap_8
XFILLER_335_28 VPWR VGND sg13cmos5l_decap_8
XFILLER_118_63 VPWR VGND sg13cmos5l_decap_8
XFILLER_500_203 VPWR VGND sg13cmos5l_decap_4
XFILLER_482_56 VPWR VGND sg13cmos5l_decap_8
XFILLER_701_174 VPWR VGND sg13cmos5l_decap_8
XFILLER_701_185 VPWR VGND sg13cmos5l_decap_8
XFILLER_249_210 VPWR VGND sg13cmos5l_fill_2
XFILLER_311_158 VPWR VGND sg13cmos5l_decap_8
XFILLER_465_140 VPWR VGND sg13cmos5l_decap_8
XFILLER_351_49 VPWR VGND sg13cmos5l_decap_8
XFILLER_134_84 VPWR VGND sg13cmos5l_decap_8
XFILLER_712_70 VPWR VGND sg13cmos5l_decap_8
XFILLER_182_0 VPWR VGND sg13cmos5l_fill_2
XFILLER_76_178 VPWR VGND sg13cmos5l_fill_1
XFILLER_94_77 VPWR VGND sg13cmos5l_decap_4
XFILLER_94_88 VPWR VGND sg13cmos5l_decap_8
XFILLER_27_60 VPWR VGND sg13cmos5l_fill_2
XFILLER_567_203 VPWR VGND sg13cmos5l_fill_2
XFILLER_447_0 VPWR VGND sg13cmos5l_decap_8
XFILLER_378_147 VPWR VGND sg13cmos5l_decap_8
XFILLER_614_0 VPWR VGND sg13cmos5l_decap_8
XFILLER_657_56 VPWR VGND sg13cmos5l_decap_8
XFILLER_393_128 VPWR VGND sg13cmos5l_decap_8
XFILLER_376_13 VPWR VGND sg13cmos5l_decap_8
XANTENNA__2803__X Tile_X0Y3_E2BEGb[1] VPWR VGND sg13cmos5l_antennanp
X_0890_ _0890_/Q Tile_X0Y9_FrameData[5] VGND VPWR Tile_X0Y9_FrameStrobe[6] latch
XFILLER_334_206 VPWR VGND sg13cmos5l_fill_2
X_2560_ _2560_/Q Tile_X0Y6_FrameData[7] VGND VPWR Tile_X0Y9_FrameStrobe[3] latch
XFILLER_550_125 VPWR VGND sg13cmos5l_decap_4
X_1511_ _1511_/Q Tile_X0Y2_FrameData[10] VGND VPWR Tile_X0Y9_FrameStrobe[2] latch
XFILLER_153_150 VPWR VGND sg13cmos5l_decap_8
XFILLER_673_77 VPWR VGND sg13cmos5l_decap_8
X_2491_ _2491_/Q Tile_X0Y6_FrameData[12] VGND VPWR Tile_X0Y9_FrameStrobe[1] latch
XFILLER_153_161 VPWR VGND sg13cmos5l_fill_2
XFILLER_392_56 VPWR VGND sg13cmos5l_fill_1
XANTENNA__3634__X Tile_X0Y9_S4BEG[12] VPWR VGND sg13cmos5l_antennanp
XFILLER_299_176 VPWR VGND sg13cmos5l_decap_8
X_1442_ _1442_/Q Tile_X0Y2_FrameData[15] VGND VPWR Tile_X0Y9_FrameStrobe[0] latch
X_4230_ _4230_/X _4195_/X _0089_/X _4194_/X Tile_X0Y0_S4END[12] _1713_/Q _1712_/Q
+ VPWR VGND sg13cmos5l_mux4_1
XFILLER_4_42 VPWR VGND sg13cmos5l_decap_8
XFILLER_392_78 VPWR VGND sg13cmos5l_fill_2
X_4161_ _4161_/X Tile_X0Y3_W2END[2] AXI_M_SOC_WREADY _4209_/X _4208_/X _1819_/Q _1818_/Q
+ VPWR VGND sg13cmos5l_mux4_1
X_1373_ _1373_/Q Tile_X0Y1_FrameData[28] VGND VPWR Tile_X0Y9_FrameStrobe[6] latch
XFILLER_67_101 VPWR VGND sg13cmos5l_decap_8
XFILLER_456_140 VPWR VGND sg13cmos5l_decap_8
XFILLER_456_151 VPWR VGND sg13cmos5l_fill_2
X_0324_ _0324_/Q Tile_X0Y7_FrameData[27] VGND VPWR Tile_X0Y9_FrameStrobe[5] latch
X_3112_ Tile_X0Y7_E6BEG[10] _4654_/X VPWR VGND sg13cmos5l_buf_1
XFILLER_310_180 VPWR VGND sg13cmos5l_fill_2
X_4092_ _4092_/X Tile_X0Y1_W1END[2] Tile_X0Y1_W6END[10] _3999_/X _3978_/X _1385_/Q
+ _1384_/Q VPWR VGND sg13cmos5l_mux4_1
XFILLER_605_104 VPWR VGND sg13cmos5l_fill_1
XFILLER_261_49 VPWR VGND sg13cmos5l_decap_8
XFILLER_622_70 VPWR VGND sg13cmos5l_decap_8
XFILLER_456_195 VPWR VGND sg13cmos5l_decap_8
XFILLER_605_126 VPWR VGND sg13cmos5l_decap_8
X_3043_ Tile_X0Y5_FrameData_O[2] Tile_X0Y5_FrameData[2] VPWR VGND sg13cmos5l_buf_1
XFILLER_605_137 VPWR VGND sg13cmos5l_fill_2
X_0255_ _0255_/Q Tile_X0Y7_FrameData[0] VGND VPWR Tile_X0Y9_FrameStrobe[2] latch
XFILLER_471_154 VPWR VGND sg13cmos5l_fill_2
XFILLER_82_137 VPWR VGND sg13cmos5l_fill_2
XFILLER_698_63 VPWR VGND sg13cmos5l_decap_8
X_0186_ _0186_/Q Tile_X0Y7_FrameData[5] VGND VPWR Tile_X0Y9_FrameStrobe[0] latch
XFILLER_369_103 VPWR VGND sg13cmos5l_decap_8
XFILLER_23_215 VPWR VGND sg13cmos5l_fill_2
XFILLER_223_154 VPWR VGND sg13cmos5l_decap_8
XFILLER_210_20 VPWR VGND sg13cmos5l_decap_8
X_3945_ _3945_/X Tile_X0Y1_W2END[2] AXI_M_SOC_ARREADY _3993_/X _3992_/X _1319_/Q _1318_/Q
+ VPWR VGND sg13cmos5l_mux4_1
XFILLER_223_198 VPWR VGND sg13cmos5l_decap_8
XFILLER_573_217 VPWR VGND sg13cmos5l_fill_1
XFILLER_567_56 VPWR VGND sg13cmos5l_decap_8
XFILLER_210_97 VPWR VGND sg13cmos5l_decap_8
X_3876_ _3876_/X _3848_/X _0067_/X Tile_X0Y0_S1END[0] Tile_X0Y0_S4END[0] _0979_/Q
+ _0978_/Q VPWR VGND sg13cmos5l_mux4_1
XFILLER_286_35 VPWR VGND sg13cmos5l_decap_8
XFILLER_526_133 VPWR VGND sg13cmos5l_decap_8
XFILLER_526_155 VPWR VGND sg13cmos5l_decap_8
X_2827_ Tile_X0Y4_E2BEG[5] _4261_/X VPWR VGND sg13cmos5l_buf_1
XFILLER_325_217 VPWR VGND sg13cmos5l_fill_1
XFILLER_541_103 VPWR VGND sg13cmos5l_decap_8
XFILLER_526_199 VPWR VGND sg13cmos5l_decap_4
XFILLER_436_27 VPWR VGND sg13cmos5l_decap_8
X_2758_ Tile_X0Y3_FrameData_O[16] Tile_X0Y3_FrameData[16] VPWR VGND sg13cmos5l_buf_1
XFILLER_541_147 VPWR VGND sg13cmos5l_fill_1
XFILLER_583_77 VPWR VGND sg13cmos5l_decap_8
XFILLER_541_169 VPWR VGND sg13cmos5l_decap_8
X_1709_ _1709_/Q Tile_X0Y3_FrameData[28] VGND VPWR Tile_X0Y9_FrameStrobe[1] latch
X_2689_ _2689_/Q Tile_X0Y6_FrameData[6] VGND VPWR Tile_X0Y9_FrameStrobe[7] latch
XFILLER_144_183 VPWR VGND sg13cmos5l_decap_8
XANTENNA__3544__X Tile_X0Y9_E6BEG[2] VPWR VGND sg13cmos5l_antennanp
XFILLER_439_107 VPWR VGND sg13cmos5l_decap_8
X_4428_ _4428_/X _4367_/X _4483_/X _4482_/X _4366_/X _2191_/Q _2190_/Q VPWR VGND sg13cmos5l_mux4_1
XFILLER_695_173 VPWR VGND sg13cmos5l_fill_2
XFILLER_235_61 VPWR VGND sg13cmos5l_decap_4
XFILLER_235_72 VPWR VGND sg13cmos5l_decap_8
X_4359_ _4359_/X Tile_X0Y6_W2MID[4] Tile_X0Y6_W2END[4] Tile_X0Y6_W6END[4] _4559_/X
+ _2681_/Q _2680_/Q VPWR VGND sg13cmos5l_mux4_1
XFILLER_58_145 VPWR VGND sg13cmos5l_decap_8
XFILLER_171_49 VPWR VGND sg13cmos5l_decap_8
XFILLER_651_210 VPWR VGND sg13cmos5l_decap_8
XFILLER_532_70 VPWR VGND sg13cmos5l_fill_2
XFILLER_273_7 VPWR VGND sg13cmos5l_decap_8
XFILLER_104_54 VPWR VGND sg13cmos5l_decap_8
XFILLER_462_165 VPWR VGND sg13cmos5l_decap_8
XFILLER_261_216 VPWR VGND sg13cmos5l_fill_2
XFILLER_64_58 VPWR VGND sg13cmos5l_decap_8
XFILLER_549_214 VPWR VGND sg13cmos5l_decap_4
XFILLER_440_7 VPWR VGND sg13cmos5l_decap_8
XFILLER_81_170 VPWR VGND sg13cmos5l_decap_8
XFILLER_120_20 VPWR VGND sg13cmos5l_decap_8
XFILLER_538_7 VPWR VGND sg13cmos5l_decap_8
XFILLER_80_13 VPWR VGND sg13cmos5l_decap_8
XANTENNA__3719__X AXI_M_SOC_WDATA29 VPWR VGND sg13cmos5l_antennanp
XFILLER_196_13 VPWR VGND sg13cmos5l_decap_8
XFILLER_705_7 VPWR VGND sg13cmos5l_decap_8
XFILLER_316_217 VPWR VGND sg13cmos5l_fill_1
XFILLER_127_117 VPWR VGND sg13cmos5l_fill_1
XFILLER_532_114 VPWR VGND sg13cmos5l_decap_8
XFILLER_383_183 VPWR VGND sg13cmos5l_decap_4
XFILLER_13_84 VPWR VGND sg13cmos5l_decap_8
XFILLER_127_139 VPWR VGND sg13cmos5l_decap_8
XFILLER_678_107 VPWR VGND sg13cmos5l_decap_4
XFILLER_346_49 VPWR VGND sg13cmos5l_decap_8
XFILLER_707_70 VPWR VGND sg13cmos5l_decap_8
XFILLER_493_77 VPWR VGND sg13cmos5l_decap_8
XFILLER_643_14 VPWR VGND sg13cmos5l_decap_8
XANTENNA__3454__X Tile_X0Y1_FrameData_O[12] VPWR VGND sg13cmos5l_antennanp
XFILLER_89_88 VPWR VGND sg13cmos5l_decap_8
XFILLER_8_0 VPWR VGND sg13cmos5l_decap_8
XFILLER_150_153 VPWR VGND sg13cmos5l_fill_2
XFILLER_397_0 VPWR VGND sg13cmos5l_decap_8
XFILLER_49_101 VPWR VGND sg13cmos5l_fill_1
XFILLER_564_0 VPWR VGND sg13cmos5l_decap_8
X_0040_ _0040_/X _4334_/X _4335_/X _0636_/Q VPWR VGND sg13cmos5l_mux2_1
XFILLER_602_107 VPWR VGND sg13cmos5l_decap_8
XFILLER_668_33 VPWR VGND sg13cmos5l_decap_8
XFILLER_205_154 VPWR VGND sg13cmos5l_decap_8
XFILLER_72_181 VPWR VGND sg13cmos5l_decap_8
XFILLER_311_74 VPWR VGND sg13cmos5l_fill_1
XFILLER_311_96 VPWR VGND sg13cmos5l_fill_2
XFILLER_220_102 VPWR VGND sg13cmos5l_decap_8
XFILLER_555_206 VPWR VGND sg13cmos5l_fill_2
X_1991_ _1991_/Q Tile_X0Y4_FrameData[30] VGND VPWR Tile_X0Y9_FrameStrobe[2] latch
XFILLER_610_184 VPWR VGND sg13cmos5l_fill_2
XFILLER_555_217 VPWR VGND sg13cmos5l_fill_1
XANTENNA__3629__X Tile_X0Y9_S4BEG[7] VPWR VGND sg13cmos5l_antennanp
X_3730_ AXI_M_SOC_ARADDR2 Tile_X0Y9_WW4END[2] Tile_X0Y9_WW4END[10] Tile_X0Y9_W6END[2]
+ _4918_/X _0755_/Q _0754_/Q VPWR VGND sg13cmos5l_mux4_1
XFILLER_387_67 VPWR VGND sg13cmos5l_decap_8
X_0942_ _0942_/Q Tile_X0Y0_FrameData[29] VGND VPWR Tile_X0Y9_FrameStrobe[0] latch
XFILLER_684_21 VPWR VGND sg13cmos5l_decap_8
X_3661_ AXI_M_SOC_AWADDR22 Tile_X0Y4_WW4END[6] Tile_X0Y4_WW4END[14] Tile_X0Y4_W6END[6]
+ _4342_/X _2001_/Q _2000_/Q VPWR VGND sg13cmos5l_mux4_1
XFILLER_307_217 VPWR VGND sg13cmos5l_fill_1
X_0873_ _0873_/Q Tile_X0Y9_FrameData[22] VGND VPWR Tile_X0Y9_FrameStrobe[6] latch
XFILLER_508_177 VPWR VGND sg13cmos5l_decap_8
X_2612_ _2612_/Q Tile_X0Y6_FrameData[19] VGND VPWR Tile_X0Y9_FrameStrobe[5] latch
X_3592_ Tile_X0Y9_FrameData_O[22] Tile_X0Y9_FrameData[22] VPWR VGND sg13cmos5l_buf_1
XFILLER_617_70 VPWR VGND sg13cmos5l_decap_8
XFILLER_126_150 VPWR VGND sg13cmos5l_decap_4
XFILLER_55_2 VPWR VGND sg13cmos5l_fill_1
X_2543_ _2543_/Q Tile_X0Y6_FrameData[24] VGND VPWR Tile_X0Y9_FrameStrobe[3] latch
XFILLER_553_14 VPWR VGND sg13cmos5l_decap_8
XANTENNA__3364__X Tile_X0Y2_EE4BEG[3] VPWR VGND sg13cmos5l_antennanp
XFILLER_141_131 VPWR VGND sg13cmos5l_decap_8
XFILLER_336_93 VPWR VGND sg13cmos5l_decap_8
X_2474_ _2474_/Q Tile_X0Y6_FrameData[29] VGND VPWR Tile_X0Y9_FrameStrobe[1] latch
X_4213_ _4213_/X Tile_X0Y7_W1END[0] Tile_X0Y7_WW4END[0] Tile_X0Y7_W6END[8] _4684_/X
+ _0391_/Q _0390_/Q VPWR VGND sg13cmos5l_mux4_1
X_1425_ _1425_/Q Tile_X0Y1_FrameData[8] VGND VPWR Tile_X0Y9_FrameStrobe[7] latch
XFILLER_703_28 VPWR VGND sg13cmos5l_decap_8
XFILLER_429_140 VPWR VGND sg13cmos5l_decap_8
XFILLER_141_197 VPWR VGND sg13cmos5l_decap_8
XFILLER_633_91 VPWR VGND sg13cmos5l_decap_8
XFILLER_205_42 VPWR VGND sg13cmos5l_decap_8
X_1356_ _1356_/Q Tile_X0Y1_FrameData[13] VGND VPWR Tile_X0Y9_FrameStrobe[5] latch
X_4144_ _4144_/X _4195_/X Tile_X0Y3_WW4END[6] _4194_/X AXI_M_SOC_BVALID _1853_/Q _1852_/Q
+ VPWR VGND sg13cmos5l_mux4_1
XFILLER_429_173 VPWR VGND sg13cmos5l_fill_2
XFILLER_352_70 VPWR VGND sg13cmos5l_decap_8
X_0307_ _0307_/Q Tile_X0Y7_FrameData[12] VGND VPWR Tile_X0Y9_FrameStrobe[4] latch
X_1287_ _1287_/Q Tile_X0Y1_FrameData[18] VGND VPWR Tile_X0Y9_FrameStrobe[3] latch
X_4075_ _4075_/X _0094_/X Tile_X0Y0_S4END[11] _4124_/X _4113_/X _1523_/Q _1522_/Q
+ VPWR VGND sg13cmos5l_mux4_1
X_0238_ _0238_/Q Tile_X0Y7_FrameData[17] VGND VPWR Tile_X0Y9_FrameStrobe[2] latch
X_3026_ Tile_X0Y5_EE4BEG[1] _4389_/X VPWR VGND sg13cmos5l_buf_1
XFILLER_502_84 VPWR VGND sg13cmos5l_decap_8
XFILLER_70_129 VPWR VGND sg13cmos5l_decap_8
X_0169_ _0169_/Q Tile_X0Y7_FrameData[22] VGND VPWR Tile_X0Y9_FrameStrobe[0] latch
XFILLER_601_151 VPWR VGND sg13cmos5l_decap_8
XFILLER_400_202 VPWR VGND sg13cmos5l_decap_4
XFILLER_578_77 VPWR VGND sg13cmos5l_decap_8
XFILLER_546_217 VPWR VGND sg13cmos5l_fill_1
XANTENNA__3539__X Tile_X0Y9_E2BEGb[5] VPWR VGND sg13cmos5l_antennanp
XFILLER_297_56 VPWR VGND sg13cmos5l_decap_8
X_3928_ _3928_/X _3981_/X Tile_X0Y1_WW4END[4] _3980_/X AXI_M_SOC_ARREADY _1353_/Q
+ _1352_/Q VPWR VGND sg13cmos5l_mux4_1
XFILLER_211_168 VPWR VGND sg13cmos5l_decap_8
XFILLER_594_21 VPWR VGND sg13cmos5l_decap_8
XFILLER_50_16 VPWR VGND sg13cmos5l_decap_8
X_3859_ _3859_/X _3895_/X _3894_/X Tile_X0Y0_S2MID[3] Tile_X0Y0_S2END[3] _0957_/Q
+ _0956_/Q VPWR VGND sg13cmos5l_mux4_1
XFILLER_703_203 VPWR VGND sg13cmos5l_fill_1
XFILLER_594_87 VPWR VGND sg13cmos5l_decap_4
XFILLER_166_49 VPWR VGND sg13cmos5l_decap_8
XFILLER_119_7 VPWR VGND sg13cmos5l_decap_8
XFILLER_463_14 VPWR VGND sg13cmos5l_decap_8
XFILLER_117_161 VPWR VGND sg13cmos5l_decap_8
XFILLER_380_197 VPWR VGND sg13cmos5l_fill_2
XANTENNA__3274__X Tile_X0Y0_EE4BEG[10] VPWR VGND sg13cmos5l_antennanp
XFILLER_467_202 VPWR VGND sg13cmos5l_decap_4
XFILLER_1_7 VPWR VGND sg13cmos5l_decap_8
XFILLER_59_47 VPWR VGND sg13cmos5l_decap_8
XFILLER_132_142 VPWR VGND sg13cmos5l_fill_1
XFILLER_668_184 VPWR VGND sg13cmos5l_decap_8
XFILLER_683_121 VPWR VGND sg13cmos5l_fill_1
XFILLER_278_146 VPWR VGND sg13cmos5l_fill_1
XFILLER_132_164 VPWR VGND sg13cmos5l_decap_8
XFILLER_613_28 VPWR VGND sg13cmos5l_decap_8
XFILLER_390_7 VPWR VGND sg13cmos5l_decap_8
XFILLER_278_168 VPWR VGND sg13cmos5l_decap_8
XFILLER_182_48 VPWR VGND sg13cmos5l_decap_8
XFILLER_488_7 VPWR VGND sg13cmos5l_decap_8
XFILLER_482_216 VPWR VGND sg13cmos5l_fill_2
XFILLER_115_42 VPWR VGND sg13cmos5l_decap_8
XFILLER_75_13 VPWR VGND sg13cmos5l_decap_8
XFILLER_286_190 VPWR VGND sg13cmos5l_decap_8
XFILLER_46_104 VPWR VGND sg13cmos5l_decap_8
XFILLER_655_7 VPWR VGND sg13cmos5l_decap_8
XFILLER_46_126 VPWR VGND sg13cmos5l_fill_1
XFILLER_412_84 VPWR VGND sg13cmos5l_decap_8
XFILLER_131_41 VPWR VGND sg13cmos5l_decap_8
XFILLER_450_157 VPWR VGND sg13cmos5l_decap_8
XFILLER_488_77 VPWR VGND sg13cmos5l_decap_8
XFILLER_91_67 VPWR VGND sg13cmos5l_decap_8
XFILLER_537_206 VPWR VGND sg13cmos5l_fill_2
XFILLER_638_14 VPWR VGND sg13cmos5l_decap_8
XFILLER_199_186 VPWR VGND sg13cmos5l_decap_8
XFILLER_145_0 VPWR VGND sg13cmos5l_decap_8
XANTENNA__3449__X Tile_X0Y1_FrameData_O[7] VPWR VGND sg13cmos5l_antennanp
XFILLER_356_161 VPWR VGND sg13cmos5l_decap_8
XFILLER_312_0 VPWR VGND sg13cmos5l_decap_8
XFILLER_505_125 VPWR VGND sg13cmos5l_decap_4
XFILLER_654_35 VPWR VGND sg13cmos5l_decap_8
XFILLER_437_70 VPWR VGND sg13cmos5l_decap_8
XFILLER_505_158 VPWR VGND sg13cmos5l_decap_8
XFILLER_108_150 VPWR VGND sg13cmos5l_decap_8
XFILLER_373_14 VPWR VGND sg13cmos5l_decap_8
XANTENNA__3184__X Tile_X0Y0_N4BEG[8] VPWR VGND sg13cmos5l_antennanp
XFILLER_513_180 VPWR VGND sg13cmos5l_fill_2
XFILLER_269_135 VPWR VGND sg13cmos5l_decap_8
XFILLER_681_0 VPWR VGND sg13cmos5l_decap_8
XFILLER_523_28 VPWR VGND sg13cmos5l_decap_8
XFILLER_306_63 VPWR VGND sg13cmos5l_decap_4
XFILLER_306_74 VPWR VGND sg13cmos5l_fill_2
XFILLER_284_105 VPWR VGND sg13cmos5l_decap_8
XFILLER_670_56 VPWR VGND sg13cmos5l_decap_8
X_1210_ _1210_/Q Tile_X0Y1_FrameData[31] VGND VPWR Tile_X0Y9_FrameStrobe[1] latch
X_2190_ _2190_/Q Tile_X0Y5_FrameData[23] VGND VPWR Tile_X0Y9_FrameStrobe[0] latch
XFILLER_1_21 VPWR VGND sg13cmos5l_decap_8
X_1141_ _1141_/Q Tile_X0Y0_FrameData[22] VGND VPWR Tile_X0Y9_FrameStrobe[6] latch
XFILLER_92_210 VPWR VGND sg13cmos5l_fill_2
XFILLER_603_83 VPWR VGND sg13cmos5l_fill_2
XFILLER_426_154 VPWR VGND sg13cmos5l_decap_8
XFILLER_679_21 VPWR VGND sg13cmos5l_decap_8
XFILLER_37_148 VPWR VGND sg13cmos5l_decap_8
XFILLER_225_216 VPWR VGND sg13cmos5l_fill_2
X_1072_ _1072_/Q Tile_X0Y0_FrameData[27] VGND VPWR Tile_X0Y9_FrameStrobe[4] latch
XFILLER_52_107 VPWR VGND sg13cmos5l_decap_8
XANTENNA__0048__X AXI_M_SOC_AWCACHE1 VPWR VGND sg13cmos5l_antennanp
X_4900_ _4900_/X Tile_X0Y9_N2MID[7] Tile_X0Y9_N2END[7] _4939_/X _4823_/X _0681_/Q
+ _0680_/Q VPWR VGND sg13cmos5l_mux4_1
XFILLER_398_44 VPWR VGND sg13cmos5l_fill_1
X_4831_ _4831_/X Tile_X0Y9_W2MID[4] Tile_X0Y9_W2END[4] Tile_X0Y9_W6END[11] _4907_/X
+ _0877_/Q _0876_/Q VPWR VGND sg13cmos5l_mux4_1
XFILLER_60_140 VPWR VGND sg13cmos5l_decap_8
XFILLER_548_14 VPWR VGND sg13cmos5l_decap_8
XFILLER_339_117 VPWR VGND sg13cmos5l_fill_1
XFILLER_528_217 VPWR VGND sg13cmos5l_fill_1
XANTENNA__3359__X Tile_X0Y2_FrameData_O[30] VPWR VGND sg13cmos5l_antennanp
XFILLER_695_42 VPWR VGND sg13cmos5l_decap_8
XFILLER_595_183 VPWR VGND sg13cmos5l_fill_2
X_4762_ _4762_/X Tile_X0Y9_N4END[6] _0075_/X _4809_/X _4813_/X _0523_/Q _0522_/Q VPWR
+ VGND sg13cmos5l_mux4_1
X_1974_ _1974_/Q Tile_X0Y4_FrameData[15] VGND VPWR Tile_X0Y9_FrameStrobe[1] latch
X_3713_ AXI_M_SOC_WDATA23 Tile_X0Y6_WW4END[7] Tile_X0Y6_WW4END[15] Tile_X0Y6_W6END[7]
+ _4575_/X _2513_/Q _2512_/Q VPWR VGND sg13cmos5l_mux4_1
X_0925_ _0925_/Q Tile_X0Y9_FrameData[2] VGND VPWR Tile_X0Y9_FrameStrobe[7] latch
X_4693_ _4693_/X _4663_/X Tile_X0Y9_N4END[9] _4662_/X _0055_/X _0197_/Q _0196_/Q VPWR
+ VGND sg13cmos5l_mux4_1
XFILLER_347_172 VPWR VGND sg13cmos5l_fill_2
XFILLER_628_91 VPWR VGND sg13cmos5l_decap_8
X_3644_ AXI_M_SOC_AWADDR5 Tile_X0Y5_WW4END[5] Tile_X0Y5_WW4END[13] Tile_X0Y5_W6END[5]
+ _4456_/X _2261_/Q _2260_/Q VPWR VGND sg13cmos5l_mux4_1
X_0856_ _0856_/Q Tile_X0Y9_FrameData[7] VGND VPWR Tile_X0Y9_FrameStrobe[5] latch
XFILLER_60_0 VPWR VGND sg13cmos5l_decap_4
XFILLER_564_35 VPWR VGND sg13cmos5l_decap_8
XFILLER_362_142 VPWR VGND sg13cmos5l_decap_8
XFILLER_362_153 VPWR VGND sg13cmos5l_fill_1
XFILLER_347_70 VPWR VGND sg13cmos5l_decap_8
XFILLER_161_215 VPWR VGND sg13cmos5l_fill_2
XFILLER_283_14 VPWR VGND sg13cmos5l_decap_8
X_3575_ Tile_X0Y9_FrameData_O[5] Tile_X0Y9_FrameData[5] VPWR VGND sg13cmos5l_buf_1
X_0787_ _0787_/Q Tile_X0Y9_FrameData[12] VGND VPWR Tile_X0Y9_FrameStrobe[3] latch
XFILLER_700_217 VPWR VGND sg13cmos5l_fill_1
XFILLER_511_128 VPWR VGND sg13cmos5l_fill_1
XANTENNA__3094__X Tile_X0Y7_E2BEGb[0] VPWR VGND sg13cmos5l_antennanp
X_2526_ _2526_/Q Tile_X0Y6_FrameData[9] VGND VPWR Tile_X0Y9_FrameStrobe[2] latch
XFILLER_714_49 VPWR VGND sg13cmos5l_decap_8
XFILLER_114_175 VPWR VGND sg13cmos5l_fill_2
XFILLER_433_28 VPWR VGND sg13cmos5l_decap_8
XFILLER_216_63 VPWR VGND sg13cmos5l_decap_8
X_2457_ _2457_/Q Tile_X0Y6_FrameData[14] VGND VPWR Tile_X0Y9_FrameStrobe[0] latch
XFILLER_665_154 VPWR VGND sg13cmos5l_fill_1
XFILLER_464_205 VPWR VGND sg13cmos5l_fill_1
XFILLER_275_105 VPWR VGND sg13cmos5l_decap_8
XFILLER_580_56 VPWR VGND sg13cmos5l_decap_8
XFILLER_665_176 VPWR VGND sg13cmos5l_decap_8
X_1408_ _1408_/Q Tile_X0Y1_FrameData[25] VGND VPWR Tile_X0Y9_FrameStrobe[7] latch
XFILLER_275_149 VPWR VGND sg13cmos5l_fill_2
X_2388_ _2388_/Q Tile_X0Y5_FrameData[17] VGND VPWR Tile_X0Y9_FrameStrobe[6] latch
XFILLER_680_146 VPWR VGND sg13cmos5l_decap_8
XFILLER_28_104 VPWR VGND sg13cmos5l_decap_8
X_4127_ _4127_/X _4095_/X _0094_/X _4094_/X Tile_X0Y0_S4END[11] _1459_/Q _1458_/Q
+ VPWR VGND sg13cmos5l_mux4_1
X_1339_ _1339_/Q Tile_X0Y1_FrameData[30] VGND VPWR Tile_X0Y9_FrameStrobe[5] latch
XFILLER_290_119 VPWR VGND sg13cmos5l_decap_8
XFILLER_589_21 VPWR VGND sg13cmos5l_decap_8
XFILLER_28_148 VPWR VGND sg13cmos5l_decap_4
XFILLER_232_62 VPWR VGND sg13cmos5l_decap_8
XFILLER_45_16 VPWR VGND sg13cmos5l_fill_2
X_4058_ _4058_/X Tile_X0Y2_WW4END[13] AXI_M_SOC_AWREADY _4110_/X _4100_/X _1557_/Q
+ _1556_/Q VPWR VGND sg13cmos5l_mux4_1
XFILLER_45_49 VPWR VGND sg13cmos5l_decap_4
X_3009_ Tile_X0Y5_E2BEGb[4] _4384_/X VPWR VGND sg13cmos5l_buf_1
XFILLER_51_140 VPWR VGND sg13cmos5l_fill_1
XFILLER_458_14 VPWR VGND sg13cmos5l_decap_8
XFILLER_519_217 VPWR VGND sg13cmos5l_fill_1
XFILLER_440_190 VPWR VGND sg13cmos5l_decap_8
XANTENNA__3269__X Tile_X0Y0_EE4BEG[5] VPWR VGND sg13cmos5l_antennanp
XFILLER_51_173 VPWR VGND sg13cmos5l_fill_2
XFILLER_101_66 VPWR VGND sg13cmos5l_decap_8
XFILLER_196_145 VPWR VGND sg13cmos5l_decap_8
XFILLER_236_7 VPWR VGND sg13cmos5l_decap_8
XFILLER_196_156 VPWR VGND sg13cmos5l_fill_2
XFILLER_61_48 VPWR VGND sg13cmos5l_decap_4
XFILLER_131_6 VPWR VGND sg13cmos5l_decap_8
XFILLER_137_201 VPWR VGND sg13cmos5l_decap_4
XFILLER_608_28 VPWR VGND sg13cmos5l_decap_8
XFILLER_403_7 VPWR VGND sg13cmos5l_decap_8
XANTENNA__2901__X Tile_X0Y6_FrameData_O[22] VPWR VGND sg13cmos5l_antennanp
XFILLER_474_35 VPWR VGND sg13cmos5l_decap_8
XFILLER_257_81 VPWR VGND sg13cmos5l_decap_8
XFILLER_3_203 VPWR VGND sg13cmos5l_decap_8
XFILLER_499_168 VPWR VGND sg13cmos5l_decap_8
XFILLER_193_69 VPWR VGND sg13cmos5l_decap_8
XFILLER_624_49 VPWR VGND sg13cmos5l_decap_8
XFILLER_10_63 VPWR VGND sg13cmos5l_decap_8
XFILLER_343_28 VPWR VGND sg13cmos5l_decap_8
XFILLER_120_101 VPWR VGND sg13cmos5l_decap_8
XFILLER_656_143 VPWR VGND sg13cmos5l_decap_8
XFILLER_105_197 VPWR VGND sg13cmos5l_decap_4
XFILLER_490_56 VPWR VGND sg13cmos5l_decap_8
XFILLER_273_91 VPWR VGND sg13cmos5l_decap_8
XANTENNA__3732__X AXI_M_SOC_ARADDR4 VPWR VGND sg13cmos5l_antennanp
XFILLER_19_115 VPWR VGND sg13cmos5l_decap_4
XFILLER_281_119 VPWR VGND sg13cmos5l_decap_8
XFILLER_499_21 VPWR VGND sg13cmos5l_decap_8
XFILLER_408_176 VPWR VGND sg13cmos5l_fill_2
XFILLER_262_0 VPWR VGND sg13cmos5l_decap_8
XFILLER_34_118 VPWR VGND sg13cmos5l_decap_8
XFILLER_499_98 VPWR VGND sg13cmos5l_decap_8
XFILLER_27_181 VPWR VGND sg13cmos5l_decap_8
XFILLER_649_35 VPWR VGND sg13cmos5l_decap_8
XFILLER_423_179 VPWR VGND sg13cmos5l_decap_4
XFILLER_577_161 VPWR VGND sg13cmos5l_decap_8
XFILLER_368_14 VPWR VGND sg13cmos5l_decap_8
XANTENNA__3179__X Tile_X0Y0_N4BEG[3] VPWR VGND sg13cmos5l_antennanp
XFILLER_527_0 VPWR VGND sg13cmos5l_decap_8
XFILLER_592_153 VPWR VGND sg13cmos5l_fill_2
XFILLER_128_201 VPWR VGND sg13cmos5l_fill_1
XFILLER_518_28 VPWR VGND sg13cmos5l_decap_8
XFILLER_448_80 VPWR VGND sg13cmos5l_decap_8
XFILLER_329_183 VPWR VGND sg13cmos5l_decap_8
XFILLER_665_56 VPWR VGND sg13cmos5l_decap_8
XANTENNA__2811__X Tile_X0Y3_E2BEG[1] VPWR VGND sg13cmos5l_antennanp
X_0710_ _0710_/Q Tile_X0Y9_FrameData[25] VGND VPWR Tile_X0Y9_FrameStrobe[1] latch
X_1690_ _1690_/Q Tile_X0Y3_FrameData[15] VGND VPWR Tile_X0Y9_FrameStrobe[0] latch
XFILLER_289_208 VPWR VGND sg13cmos5l_decap_4
X_0641_ _0641_/Q Tile_X0Y8_FrameData[30] VGND VPWR Tile_X0Y9_FrameStrobe[7] latch
XFILLER_694_216 VPWR VGND sg13cmos5l_fill_2
X_0572_ _0572_/Q Tile_X0Y8_FrameData[3] VGND VPWR Tile_X0Y9_FrameStrobe[4] latch
X_3360_ Tile_X0Y2_FrameData_O[31] Tile_X0Y2_FrameData[31] VPWR VGND sg13cmos5l_buf_1
XFILLER_534_49 VPWR VGND sg13cmos5l_decap_4
XFILLER_317_95 VPWR VGND sg13cmos5l_decap_4
XANTENNA__0050__Y AXI_M_SOC_AWLOCK VPWR VGND sg13cmos5l_antennanp
X_2311_ _2311_/Q Tile_X0Y5_FrameData[30] VGND VPWR Tile_X0Y9_FrameStrobe[4] latch
XFILLER_681_77 VPWR VGND sg13cmos5l_decap_8
XFILLER_253_28 VPWR VGND sg13cmos5l_decap_8
XFILLER_501_161 VPWR VGND sg13cmos5l_decap_8
X_3291_ Tile_X0Y0_E6BEG[11] _3847_/X VPWR VGND sg13cmos5l_buf_1
XFILLER_647_154 VPWR VGND sg13cmos5l_decap_8
XFILLER_111_123 VPWR VGND sg13cmos5l_fill_2
XANTENNA__3642__X AXI_M_SOC_AWADDR3 VPWR VGND sg13cmos5l_antennanp
XFILLER_446_216 VPWR VGND sg13cmos5l_fill_2
X_2242_ _2242_/Q Tile_X0Y5_FrameData[3] VGND VPWR Tile_X0Y9_FrameStrobe[1] latch
XFILLER_111_167 VPWR VGND sg13cmos5l_decap_8
X_2173_ _2173_/Q Tile_X0Y4_FrameData[8] VGND VPWR Tile_X0Y9_FrameStrobe[7] latch
XFILLER_461_208 VPWR VGND sg13cmos5l_fill_1
XFILLER_272_119 VPWR VGND sg13cmos5l_decap_8
X_1124_ _1124_/Q Tile_X0Y0_FrameData[7] VGND VPWR Tile_X0Y9_FrameStrobe[5] latch
XFILLER_630_70 VPWR VGND sg13cmos5l_decap_8
XFILLER_202_21 VPWR VGND sg13cmos5l_decap_8
XFILLER_25_118 VPWR VGND sg13cmos5l_decap_4
X_1055_ _1055_/Q Tile_X0Y0_FrameData[12] VGND VPWR Tile_X0Y9_FrameStrobe[3] latch
XFILLER_559_35 VPWR VGND sg13cmos5l_decap_8
XFILLER_568_161 VPWR VGND sg13cmos5l_decap_8
XFILLER_278_14 VPWR VGND sg13cmos5l_decap_8
XFILLER_202_98 VPWR VGND sg13cmos5l_decap_8
XANTENNA__3089__X Tile_X0Y7_E2BEG[3] VPWR VGND sg13cmos5l_antennanp
X_4814_ _4814_/X _4781_/X Tile_X0Y9_N4END[6] _4780_/X _0075_/X _0443_/Q _0442_/Q VPWR
+ VGND sg13cmos5l_mux4_1
XFILLER_178_145 VPWR VGND sg13cmos5l_decap_4
XFILLER_717_147 VPWR VGND sg13cmos5l_decap_8
XFILLER_709_49 VPWR VGND sg13cmos5l_decap_8
X_4745_ _4745_/X Tile_X0Y8_WW4END[14] AXI_M_SOC_RDATA9 _4814_/X _4786_/X _0557_/Q
+ _0556_/Q VPWR VGND sg13cmos5l_mux4_1
XFILLER_583_175 VPWR VGND sg13cmos5l_decap_8
XFILLER_428_28 VPWR VGND sg13cmos5l_decap_8
X_1957_ _1957_/Q Tile_X0Y4_FrameData[0] VGND VPWR Tile_X0Y9_FrameStrobe[0] latch
XFILLER_575_56 VPWR VGND sg13cmos5l_decap_8
XFILLER_358_91 VPWR VGND sg13cmos5l_decap_8
X_0908_ _0908_/Q Tile_X0Y9_FrameData[19] VGND VPWR Tile_X0Y9_FrameStrobe[7] latch
X_4676_ _4676_/X Tile_X0Y3_W1END[0] Tile_X0Y3_WW4END[12] Tile_X0Y3_W6END[4] _4222_/X
+ _1865_/Q _1864_/Q VPWR VGND sg13cmos5l_mux4_1
XFILLER_294_35 VPWR VGND sg13cmos5l_decap_8
X_1888_ _1888_/Q Tile_X0Y3_FrameData[9] VGND VPWR Tile_X0Y9_FrameStrobe[6] latch
X_3627_ Tile_X0Y9_S4BEG[5] _3627_/A VPWR VGND sg13cmos5l_buf_1
X_0839_ _0839_/Q Tile_X0Y9_FrameData[24] VGND VPWR Tile_X0Y9_FrameStrobe[5] latch
XFILLER_350_112 VPWR VGND sg13cmos5l_decap_8
XFILLER_508_94 VPWR VGND sg13cmos5l_fill_1
XFILLER_496_105 VPWR VGND sg13cmos5l_decap_8
X_3558_ Tile_X0Y9_EE4BEG[4] _4868_/X VPWR VGND sg13cmos5l_buf_1
XFILLER_444_49 VPWR VGND sg13cmos5l_decap_8
XFILLER_227_84 VPWR VGND sg13cmos5l_decap_8
XFILLER_0_206 VPWR VGND sg13cmos5l_decap_8
XFILLER_591_77 VPWR VGND sg13cmos5l_decap_4
XFILLER_0_217 VPWR VGND sg13cmos5l_fill_1
X_2509_ _2509_/Q Tile_X0Y6_FrameData[26] VGND VPWR Tile_X0Y9_FrameStrobe[2] latch
X_3489_ Tile_X0Y1_EE4BEG[15] _3963_/X VPWR VGND sg13cmos5l_buf_1
XANTENNA__3552__X Tile_X0Y9_E6BEG[10] VPWR VGND sg13cmos5l_antennanp
XFILLER_102_134 VPWR VGND sg13cmos5l_fill_2
XFILLER_638_176 VPWR VGND sg13cmos5l_decap_4
XFILLER_248_127 VPWR VGND sg13cmos5l_decap_8
XFILLER_186_7 VPWR VGND sg13cmos5l_decap_8
XFILLER_405_102 VPWR VGND sg13cmos5l_decap_8
XFILLER_112_21 VPWR VGND sg13cmos5l_decap_8
XFILLER_405_168 VPWR VGND sg13cmos5l_decap_8
XFILLER_353_7 VPWR VGND sg13cmos5l_decap_8
XFILLER_72_14 VPWR VGND sg13cmos5l_decap_8
XFILLER_469_35 VPWR VGND sg13cmos5l_decap_8
XFILLER_469_46 VPWR VGND sg13cmos5l_fill_2
XFILLER_169_101 VPWR VGND sg13cmos5l_decap_8
XFILLER_188_14 VPWR VGND sg13cmos5l_decap_8
XFILLER_559_172 VPWR VGND sg13cmos5l_decap_4
XFILLER_413_190 VPWR VGND sg13cmos5l_fill_1
XFILLER_72_69 VPWR VGND sg13cmos5l_decap_8
XFILLER_520_7 VPWR VGND sg13cmos5l_decap_8
XFILLER_618_7 VPWR VGND sg13cmos5l_decap_8
XFILLER_708_147 VPWR VGND sg13cmos5l_decap_8
XFILLER_619_49 VPWR VGND sg13cmos5l_decap_8
XFILLER_373_204 VPWR VGND sg13cmos5l_fill_2
XFILLER_574_164 VPWR VGND sg13cmos5l_decap_8
XANTENNA__0135__Y AXI_M_SOC_AWLEN5 VPWR VGND sg13cmos5l_antennanp
XFILLER_338_28 VPWR VGND sg13cmos5l_decap_8
XFILLER_485_56 VPWR VGND sg13cmos5l_decap_8
XANTENNA__3727__X AXI_M_SOC_BREADY VPWR VGND sg13cmos5l_antennanp
XFILLER_326_120 VPWR VGND sg13cmos5l_decap_8
XFILLER_184_159 VPWR VGND sg13cmos5l_decap_4
XANTENNA_80 Tile_X0Y9_N2MID[5] VPWR VGND sg13cmos5l_antennanp
XFILLER_21_51 VPWR VGND sg13cmos5l_fill_1
XFILLER_192_170 VPWR VGND sg13cmos5l_decap_4
XFILLER_530_201 VPWR VGND sg13cmos5l_decap_4
XFILLER_108_0 VPWR VGND sg13cmos5l_decap_8
XFILLER_354_49 VPWR VGND sg13cmos5l_decap_8
XFILLER_137_84 VPWR VGND sg13cmos5l_decap_8
XFILLER_629_132 VPWR VGND sg13cmos5l_decap_4
XFILLER_651_14 VPWR VGND sg13cmos5l_decap_8
XFILLER_629_154 VPWR VGND sg13cmos5l_decap_8
XANTENNA__3462__X Tile_X0Y1_FrameData_O[20] VPWR VGND sg13cmos5l_antennanp
XFILLER_495_182 VPWR VGND sg13cmos5l_fill_2
XFILLER_477_0 VPWR VGND sg13cmos5l_decap_8
XFILLER_644_168 VPWR VGND sg13cmos5l_decap_8
XFILLER_247_160 VPWR VGND sg13cmos5l_fill_2
XFILLER_644_0 VPWR VGND sg13cmos5l_decap_8
XFILLER_450_81 VPWR VGND sg13cmos5l_decap_4
XANTENNA__2806__X Tile_X0Y3_E2BEGb[4] VPWR VGND sg13cmos5l_antennanp
XFILLER_262_174 VPWR VGND sg13cmos5l_fill_2
XFILLER_600_84 VPWR VGND sg13cmos5l_fill_2
X_2860_ Tile_X0Y6_E6BEG[9] _4537_/X VPWR VGND sg13cmos5l_buf_1
XFILLER_529_49 VPWR VGND sg13cmos5l_decap_8
XFILLER_565_164 VPWR VGND sg13cmos5l_decap_8
X_1811_ _1811_/Q Tile_X0Y3_FrameData[22] VGND VPWR Tile_X0Y9_FrameStrobe[4] latch
XFILLER_364_215 VPWR VGND sg13cmos5l_fill_2
XFILLER_580_101 VPWR VGND sg13cmos5l_fill_2
XFILLER_248_28 VPWR VGND sg13cmos5l_decap_8
X_2791_ Tile_X0Y3_E6BEG[1] _4181_/X VPWR VGND sg13cmos5l_buf_1
XFILLER_175_137 VPWR VGND sg13cmos5l_decap_8
XANTENNA__3637__X Tile_X0Y9_S4BEG[15] VPWR VGND sg13cmos5l_antennanp
XFILLER_395_56 VPWR VGND sg13cmos5l_decap_4
X_4530_ _4530_/X Tile_X0Y9_N4END[14] _0155_/X _4577_/X _4581_/X _2547_/Q _2546_/Q
+ VPWR VGND sg13cmos5l_mux4_1
XFILLER_7_42 VPWR VGND sg13cmos5l_decap_8
X_1742_ _1742_/Q Tile_X0Y3_FrameData[27] VGND VPWR Tile_X0Y9_FrameStrobe[2] latch
XFILLER_580_156 VPWR VGND sg13cmos5l_fill_1
XFILLER_317_142 VPWR VGND sg13cmos5l_decap_8
XFILLER_692_21 VPWR VGND sg13cmos5l_decap_8
XFILLER_116_204 VPWR VGND sg13cmos5l_fill_2
XFILLER_580_178 VPWR VGND sg13cmos5l_fill_2
X_4461_ _4461_/X _4424_/X _0100_/X _4423_/X _0140_/X _2217_/Q _2216_/Q VPWR VGND sg13cmos5l_mux4_1
XFILLER_580_189 VPWR VGND sg13cmos5l_fill_1
X_1673_ _1673_/Q Tile_X0Y2_FrameData[8] VGND VPWR Tile_X0Y9_FrameStrobe[7] latch
X_3412_ Tile_X0Y4_FrameData_O[3] Tile_X0Y4_FrameData[3] VPWR VGND sg13cmos5l_buf_1
X_0624_ _0624_/Q Tile_X0Y8_FrameData[15] VGND VPWR Tile_X0Y9_FrameStrobe[6] latch
X_4392_ _4392_/X Tile_X0Y5_WW4END[11] AXI_M_SOC_RVALID _4462_/X _4434_/X _2319_/Q
+ _2318_/Q VPWR VGND sg13cmos5l_mux4_1
XFILLER_264_49 VPWR VGND sg13cmos5l_decap_8
XFILLER_625_70 VPWR VGND sg13cmos5l_decap_8
XFILLER_332_167 VPWR VGND sg13cmos5l_fill_1
XFILLER_332_189 VPWR VGND sg13cmos5l_decap_8
X_3343_ Tile_X0Y2_FrameData_O[14] Tile_X0Y2_FrameData[14] VPWR VGND sg13cmos5l_buf_1
XFILLER_561_14 VPWR VGND sg13cmos5l_decap_8
X_0555_ _0555_/Q Tile_X0Y8_FrameData[20] VGND VPWR Tile_X0Y9_FrameStrobe[4] latch
XFILLER_493_119 VPWR VGND sg13cmos5l_decap_8
XANTENNA__3372__X Tile_X0Y2_EE4BEG[11] VPWR VGND sg13cmos5l_antennanp
XFILLER_419_216 VPWR VGND sg13cmos5l_fill_2
XFILLER_97_154 VPWR VGND sg13cmos5l_decap_4
X_3274_ Tile_X0Y0_EE4BEG[10] _3830_/X VPWR VGND sg13cmos5l_buf_1
X_0486_ _0486_/Q Tile_X0Y8_FrameData[25] VGND VPWR Tile_X0Y9_FrameStrobe[2] latch
XFILLER_23_0 VPWR VGND sg13cmos5l_decap_8
XFILLER_97_187 VPWR VGND sg13cmos5l_decap_4
XFILLER_97_198 VPWR VGND sg13cmos5l_decap_8
XFILLER_711_28 VPWR VGND sg13cmos5l_decap_8
X_2225_ _2225_/Q Tile_X0Y5_FrameData[20] VGND VPWR Tile_X0Y9_FrameStrobe[1] latch
XFILLER_650_105 VPWR VGND sg13cmos5l_decap_8
XFILLER_641_91 VPWR VGND sg13cmos5l_decap_8
XFILLER_213_42 VPWR VGND sg13cmos5l_decap_8
X_2156_ _2156_/Q Tile_X0Y4_FrameData[25] VGND VPWR Tile_X0Y9_FrameStrobe[7] latch
XFILLER_360_70 VPWR VGND sg13cmos5l_decap_8
X_1107_ _1107_/Q Tile_X0Y0_FrameData[24] VGND VPWR Tile_X0Y9_FrameStrobe[5] latch
X_2087_ _2087_/Q Tile_X0Y4_FrameData[30] VGND VPWR Tile_X0Y9_FrameStrobe[5] latch
XFILLER_289_35 VPWR VGND sg13cmos5l_decap_8
X_1038_ _1038_/Q Tile_X0Y0_FrameData[29] VGND VPWR Tile_X0Y9_FrameStrobe[3] latch
XFILLER_510_84 VPWR VGND sg13cmos5l_fill_2
XFILLER_510_95 VPWR VGND sg13cmos5l_fill_1
XFILLER_439_49 VPWR VGND sg13cmos5l_decap_8
XFILLER_355_204 VPWR VGND sg13cmos5l_fill_1
XFILLER_355_215 VPWR VGND sg13cmos5l_fill_2
XFILLER_158_28 VPWR VGND sg13cmos5l_fill_1
XFILLER_571_112 VPWR VGND sg13cmos5l_decap_8
X_2989_ Tile_X0Y8_FrameData_O[29] Tile_X0Y8_FrameData[29] VPWR VGND sg13cmos5l_buf_1
XFILLER_586_99 VPWR VGND sg13cmos5l_decap_8
XANTENNA__3547__X Tile_X0Y9_E6BEG[5] VPWR VGND sg13cmos5l_antennanp
X_4728_ _4728_/X Tile_X0Y8_W2MID[7] AXI_M_SOC_RDATA8 _4785_/X _4784_/X _0591_/Q _0590_/Q
+ VPWR VGND sg13cmos5l_mux4_1
XFILLER_238_50 VPWR VGND sg13cmos5l_decap_8
XFILLER_107_215 VPWR VGND sg13cmos5l_fill_2
XFILLER_571_189 VPWR VGND sg13cmos5l_decap_8
XFILLER_713_161 VPWR VGND sg13cmos5l_decap_8
X_4659_ _4659_/X _4667_/X Tile_X0Y7_W6END[3] _4666_/X _4659_/A3 _0161_/Q _0416_/Q
+ VPWR VGND sg13cmos5l_mux4_1
XFILLER_469_105 VPWR VGND sg13cmos5l_fill_1
XFILLER_101_7 VPWR VGND sg13cmos5l_fill_2
XFILLER_471_14 VPWR VGND sg13cmos5l_decap_8
XANTENNA__3282__X Tile_X0Y0_E6BEG[2] VPWR VGND sg13cmos5l_antennanp
XFILLER_107_76 VPWR VGND sg13cmos5l_decap_8
XFILLER_254_93 VPWR VGND sg13cmos5l_fill_2
XFILLER_626_157 VPWR VGND sg13cmos5l_decap_8
XFILLER_621_28 VPWR VGND sg13cmos5l_decap_8
XFILLER_470_7 VPWR VGND sg13cmos5l_decap_8
XFILLER_404_63 VPWR VGND sg13cmos5l_decap_8
XFILLER_568_7 VPWR VGND sg13cmos5l_decap_8
XFILLER_641_105 VPWR VGND sg13cmos5l_decap_8
XFILLER_270_70 VPWR VGND sg13cmos5l_decap_8
XFILLER_123_64 VPWR VGND sg13cmos5l_decap_8
XFILLER_83_57 VPWR VGND sg13cmos5l_decap_8
XFILLER_199_35 VPWR VGND sg13cmos5l_decap_8
XFILLER_420_84 VPWR VGND sg13cmos5l_decap_8
XFILLER_349_49 VPWR VGND sg13cmos5l_decap_8
XFILLER_279_90 VPWR VGND sg13cmos5l_decap_8
XFILLER_496_77 VPWR VGND sg13cmos5l_decap_8
XFILLER_646_14 VPWR VGND sg13cmos5l_decap_8
XFILLER_562_112 VPWR VGND sg13cmos5l_fill_2
XANTENNA__3457__X Tile_X0Y1_FrameData_O[15] VPWR VGND sg13cmos5l_antennanp
XFILLER_157_159 VPWR VGND sg13cmos5l_decap_4
XFILLER_504_2 VPWR VGND sg13cmos5l_fill_1
XFILLER_562_167 VPWR VGND sg13cmos5l_fill_1
XFILLER_562_189 VPWR VGND sg13cmos5l_decap_8
XFILLER_165_181 VPWR VGND sg13cmos5l_decap_4
XFILLER_148_94 VPWR VGND sg13cmos5l_decap_8
XFILLER_180_151 VPWR VGND sg13cmos5l_fill_1
XFILLER_662_35 VPWR VGND sg13cmos5l_decap_8
XFILLER_594_0 VPWR VGND sg13cmos5l_decap_8
XFILLER_381_14 VPWR VGND sg13cmos5l_decap_8
XANTENNA__3192__X Tile_X0Y0_N2BEGb[0] VPWR VGND sg13cmos5l_antennanp
X_0340_ _0340_/Q Tile_X0Y7_FrameData[11] VGND VPWR Tile_X0Y9_FrameStrobe[5] latch
XFILLER_617_124 VPWR VGND sg13cmos5l_fill_2
XFILLER_94_102 VPWR VGND sg13cmos5l_fill_2
XFILLER_483_130 VPWR VGND sg13cmos5l_decap_8
XFILLER_79_198 VPWR VGND sg13cmos5l_decap_8
XFILLER_483_152 VPWR VGND sg13cmos5l_fill_2
X_0271_ _0271_/Q Tile_X0Y7_FrameData[16] VGND VPWR Tile_X0Y9_FrameStrobe[3] latch
XFILLER_531_28 VPWR VGND sg13cmos5l_decap_8
XFILLER_282_203 VPWR VGND sg13cmos5l_fill_2
XFILLER_227_119 VPWR VGND sg13cmos5l_decap_8
XFILLER_632_105 VPWR VGND sg13cmos5l_decap_8
XFILLER_461_80 VPWR VGND sg13cmos5l_decap_4
X_2010_ _2010_/Q Tile_X0Y4_FrameData[11] VGND VPWR Tile_X0Y9_FrameStrobe[2] latch
XFILLER_687_21 VPWR VGND sg13cmos5l_decap_8
XFILLER_640_182 VPWR VGND sg13cmos5l_fill_2
X_3961_ _3961_/X Tile_X0Y1_WW4END[2] AXI_M_SOC_ARREADY _4010_/X _3993_/X _1287_/Q
+ _1286_/Q VPWR VGND sg13cmos5l_mux4_1
X_2912_ Tile_X0Y8_E1BEG[0] _4724_/X VPWR VGND sg13cmos5l_buf_1
XFILLER_250_188 VPWR VGND sg13cmos5l_decap_8
X_3892_ _3892_/X Tile_X0Y2_W2MID[5] Tile_X0Y2_W2END[5] Tile_X0Y2_W6END[5] _4101_/X
+ _1661_/Q _1660_/Q VPWR VGND sg13cmos5l_mux4_1
XFILLER_538_142 VPWR VGND sg13cmos5l_decap_8
XFILLER_259_49 VPWR VGND sg13cmos5l_decap_8
X_2843_ Tile_X0Y6_E2BEGb[0] _4504_/X VPWR VGND sg13cmos5l_buf_1
XFILLER_556_14 VPWR VGND sg13cmos5l_decap_8
XFILLER_553_112 VPWR VGND sg13cmos5l_decap_4
XFILLER_699_105 VPWR VGND sg13cmos5l_fill_1
XANTENNA__3367__X Tile_X0Y2_EE4BEG[6] VPWR VGND sg13cmos5l_antennanp
XFILLER_699_138 VPWR VGND sg13cmos5l_fill_2
X_2774_ Tile_X0Y3_EE4BEG[0] _4164_/X VPWR VGND sg13cmos5l_buf_1
X_4513_ _4513_/X Tile_X0Y6_WW4END[14] AXI_M_SOC_RDATA25 _4582_/X _4554_/X _2581_/Q
+ _2580_/Q VPWR VGND sg13cmos5l_mux4_1
XFILLER_706_28 VPWR VGND sg13cmos5l_decap_8
X_1725_ _1725_/Q Tile_X0Y3_FrameData[12] VGND VPWR Tile_X0Y9_FrameStrobe[1] latch
XFILLER_208_20 VPWR VGND sg13cmos5l_decap_8
XFILLER_636_91 VPWR VGND sg13cmos5l_decap_8
X_4444_ _4444_/X _4014_/X _4018_/X _3999_/X _3990_/X _1359_/Q _1358_/Q VPWR VGND sg13cmos5l_mux4_1
X_1656_ _1656_/Q Tile_X0Y2_FrameData[25] VGND VPWR Tile_X0Y9_FrameStrobe[7] latch
XFILLER_572_35 VPWR VGND sg13cmos5l_decap_8
XFILLER_355_70 VPWR VGND sg13cmos5l_decap_8
XFILLER_320_115 VPWR VGND sg13cmos5l_decap_4
XFILLER_710_175 VPWR VGND sg13cmos5l_decap_8
X_0607_ _0607_/Q Tile_X0Y8_FrameData[0] VGND VPWR Tile_X0Y9_FrameStrobe[5] latch
XFILLER_291_14 VPWR VGND sg13cmos5l_decap_8
XFILLER_208_97 VPWR VGND sg13cmos5l_decap_8
X_4375_ _4375_/X Tile_X0Y5_W2MID[4] AXI_M_SOC_RRESP1 _4434_/X _4433_/X _2353_/Q _2352_/Q
+ VPWR VGND sg13cmos5l_mux4_1
X_1587_ _1587_/Q Tile_X0Y2_FrameData[30] VGND VPWR Tile_X0Y9_FrameStrobe[5] latch
XFILLER_459_171 VPWR VGND sg13cmos5l_decap_8
X_3326_ Tile_X0Y4_EE4BEG[14] _4286_/X VPWR VGND sg13cmos5l_buf_1
XFILLER_608_113 VPWR VGND sg13cmos5l_fill_2
X_0538_ _0538_/Q Tile_X0Y8_FrameData[5] VGND VPWR Tile_X0Y9_FrameStrobe[3] latch
XFILLER_505_84 VPWR VGND sg13cmos5l_decap_8
XFILLER_608_146 VPWR VGND sg13cmos5l_fill_1
XFILLER_505_95 VPWR VGND sg13cmos5l_fill_2
XFILLER_441_28 VPWR VGND sg13cmos5l_decap_8
X_3257_ Tile_X0Y0_FrameData_O[25] Tile_X0Y0_FrameData[25] VPWR VGND sg13cmos5l_buf_1
XFILLER_85_146 VPWR VGND sg13cmos5l_fill_1
X_0469_ _0469_/Q Tile_X0Y8_FrameData[10] VGND VPWR Tile_X0Y9_FrameStrobe[1] latch
XFILLER_474_185 VPWR VGND sg13cmos5l_decap_8
XFILLER_224_96 VPWR VGND sg13cmos5l_fill_2
X_2208_ _2208_/Q Tile_X0Y5_FrameData[5] VGND VPWR Tile_X0Y9_FrameStrobe[0] latch
X_3188_ Tile_X0Y0_N4BEG[12] _3188_/A VPWR VGND sg13cmos5l_buf_1
X_2139_ _2139_/Q Tile_X0Y4_FrameData[10] VGND VPWR Tile_X0Y9_FrameStrobe[6] latch
XFILLER_597_21 VPWR VGND sg13cmos5l_decap_8
XFILLER_241_122 VPWR VGND sg13cmos5l_decap_8
XFILLER_387_115 VPWR VGND sg13cmos5l_decap_8
XFILLER_53_38 VPWR VGND sg13cmos5l_decap_8
XFILLER_41_216 VPWR VGND sg13cmos5l_fill_2
XFILLER_591_207 VPWR VGND sg13cmos5l_decap_4
XFILLER_194_210 VPWR VGND sg13cmos5l_fill_2
XFILLER_139_126 VPWR VGND sg13cmos5l_decap_8
XFILLER_466_14 VPWR VGND sg13cmos5l_decap_8
XANTENNA__3277__X Tile_X0Y0_EE4BEG[13] VPWR VGND sg13cmos5l_antennanp
XFILLER_316_7 VPWR VGND sg13cmos5l_decap_8
XFILLER_544_167 VPWR VGND sg13cmos5l_fill_1
XFILLER_154_118 VPWR VGND sg13cmos5l_decap_8
XFILLER_616_28 VPWR VGND sg13cmos5l_decap_8
XFILLER_5_139 VPWR VGND sg13cmos5l_decap_4
XFILLER_147_181 VPWR VGND sg13cmos5l_decap_8
XFILLER_147_192 VPWR VGND sg13cmos5l_fill_2
XFILLER_546_91 VPWR VGND sg13cmos5l_decap_8
XFILLER_118_42 VPWR VGND sg13cmos5l_decap_8
XFILLER_482_35 VPWR VGND sg13cmos5l_decap_8
XFILLER_78_35 VPWR VGND sg13cmos5l_decap_8
XFILLER_500_215 VPWR VGND sg13cmos5l_fill_2
XFILLER_685_7 VPWR VGND sg13cmos5l_decap_8
XFILLER_311_148 VPWR VGND sg13cmos5l_fill_2
XFILLER_632_49 VPWR VGND sg13cmos5l_decap_8
XFILLER_415_84 VPWR VGND sg13cmos5l_decap_8
XFILLER_351_28 VPWR VGND sg13cmos5l_decap_8
XFILLER_209_119 VPWR VGND sg13cmos5l_decap_8
XFILLER_134_63 VPWR VGND sg13cmos5l_decap_8
XANTENNA__3740__X AXI_M_SOC_ARADDR12 VPWR VGND sg13cmos5l_antennanp
XFILLER_480_111 VPWR VGND sg13cmos5l_fill_2
XFILLER_281_91 VPWR VGND sg13cmos5l_decap_8
XFILLER_94_56 VPWR VGND sg13cmos5l_decap_8
XFILLER_614_138 VPWR VGND sg13cmos5l_fill_1
XFILLER_17_202 VPWR VGND sg13cmos5l_decap_4
XFILLER_175_0 VPWR VGND sg13cmos5l_decap_8
XFILLER_217_174 VPWR VGND sg13cmos5l_decap_8
XFILLER_217_185 VPWR VGND sg13cmos5l_fill_2
XFILLER_150_62 VPWR VGND sg13cmos5l_fill_2
XFILLER_27_94 VPWR VGND sg13cmos5l_fill_2
XFILLER_300_21 VPWR VGND sg13cmos5l_decap_8
XFILLER_342_0 VPWR VGND sg13cmos5l_decap_8
XFILLER_393_107 VPWR VGND sg13cmos5l_decap_8
XFILLER_232_199 VPWR VGND sg13cmos5l_decap_8
XFILLER_657_35 VPWR VGND sg13cmos5l_decap_8
XFILLER_319_215 VPWR VGND sg13cmos5l_fill_2
XFILLER_300_98 VPWR VGND sg13cmos5l_decap_8
XFILLER_43_93 VPWR VGND sg13cmos5l_decap_8
XANTENNA__3187__X Tile_X0Y0_N4BEG[11] VPWR VGND sg13cmos5l_antennanp
XFILLER_607_0 VPWR VGND sg13cmos5l_decap_8
XFILLER_159_82 VPWR VGND sg13cmos5l_decap_8
XFILLER_145_129 VPWR VGND sg13cmos5l_decap_8
XFILLER_526_28 VPWR VGND sg13cmos5l_decap_8
XFILLER_673_56 VPWR VGND sg13cmos5l_decap_8
XFILLER_550_148 VPWR VGND sg13cmos5l_decap_4
X_1510_ _1510_/Q Tile_X0Y2_FrameData[11] VGND VPWR Tile_X0Y9_FrameStrobe[2] latch
X_2490_ _2490_/Q Tile_X0Y6_FrameData[13] VGND VPWR Tile_X0Y9_FrameStrobe[1] latch
XFILLER_392_35 VPWR VGND sg13cmos5l_decap_8
XFILLER_175_70 VPWR VGND sg13cmos5l_decap_4
XFILLER_175_81 VPWR VGND sg13cmos5l_decap_8
XFILLER_4_21 VPWR VGND sg13cmos5l_decap_8
XFILLER_4_172 VPWR VGND sg13cmos5l_decap_4
XFILLER_302_115 VPWR VGND sg13cmos5l_decap_8
X_1441_ _1441_/Q Tile_X0Y2_FrameData[16] VGND VPWR Tile_X0Y9_FrameStrobe[0] latch
X_4160_ _4160_/X Tile_X0Y3_W2END[3] AXI_M_SOC_BVALID _4211_/X _4210_/X _1821_/Q _1820_/Q
+ VPWR VGND sg13cmos5l_mux4_1
X_1372_ _1372_/Q Tile_X0Y1_FrameData[29] VGND VPWR Tile_X0Y9_FrameStrobe[6] latch
XFILLER_542_49 VPWR VGND sg13cmos5l_decap_8
XFILLER_4_98 VPWR VGND sg13cmos5l_decap_4
XFILLER_472_90 VPWR VGND sg13cmos5l_fill_1
XFILLER_325_84 VPWR VGND sg13cmos5l_decap_8
X_3111_ Tile_X0Y7_E6BEG[9] _4653_/X VPWR VGND sg13cmos5l_buf_1
X_0323_ _0323_/Q Tile_X0Y7_FrameData[28] VGND VPWR Tile_X0Y9_FrameStrobe[5] latch
XFILLER_261_28 VPWR VGND sg13cmos5l_decap_8
X_4091_ _4091_/X Tile_X0Y3_W1END[1] Tile_X0Y3_W6END[5] _4235_/X _4201_/X _1923_/Q
+ _1922_/Q VPWR VGND sg13cmos5l_mux4_1
XFILLER_456_174 VPWR VGND sg13cmos5l_decap_8
XANTENNA__3650__X AXI_M_SOC_AWADDR11 VPWR VGND sg13cmos5l_antennanp
X_3042_ Tile_X0Y5_FrameData_O[1] Tile_X0Y5_FrameData[1] VPWR VGND sg13cmos5l_buf_1
X_0254_ _0254_/Q Tile_X0Y7_FrameData[1] VGND VPWR Tile_X0Y9_FrameStrobe[2] latch
XFILLER_208_152 VPWR VGND sg13cmos5l_fill_1
XFILLER_698_42 VPWR VGND sg13cmos5l_decap_8
XFILLER_471_177 VPWR VGND sg13cmos5l_fill_2
X_0185_ _0185_/Q Tile_X0Y7_FrameData[6] VGND VPWR Tile_X0Y9_FrameStrobe[0] latch
XFILLER_620_119 VPWR VGND sg13cmos5l_decap_4
XFILLER_23_205 VPWR VGND sg13cmos5l_decap_8
XFILLER_223_144 VPWR VGND sg13cmos5l_fill_2
XFILLER_90_182 VPWR VGND sg13cmos5l_decap_8
X_3944_ _3944_/X Tile_X0Y1_W2END[3] AXI_M_SOC_ARREADY _3995_/X _3994_/X _1321_/Q _1320_/Q
+ VPWR VGND sg13cmos5l_mux4_1
XFILLER_90_0 VPWR VGND sg13cmos5l_decap_8
XFILLER_567_35 VPWR VGND sg13cmos5l_decap_8
XFILLER_210_76 VPWR VGND sg13cmos5l_decap_8
XFILLER_715_201 VPWR VGND sg13cmos5l_fill_2
XFILLER_526_101 VPWR VGND sg13cmos5l_fill_1
XFILLER_286_14 VPWR VGND sg13cmos5l_decap_8
X_3875_ _3875_/X _3848_/X _0067_/X Tile_X0Y0_S1END[0] Tile_X0Y0_S4END[0] _0971_/Q
+ _0970_/Q VPWR VGND sg13cmos5l_mux4_1
XANTENNA__3097__X Tile_X0Y7_E2BEGb[3] VPWR VGND sg13cmos5l_antennanp
X_2826_ Tile_X0Y4_E2BEG[4] _4260_/X VPWR VGND sg13cmos5l_buf_1
XFILLER_325_207 VPWR VGND sg13cmos5l_decap_4
XFILLER_219_41 VPWR VGND sg13cmos5l_decap_8
X_2757_ Tile_X0Y3_FrameData_O[15] Tile_X0Y3_FrameData[15] VPWR VGND sg13cmos5l_buf_1
XFILLER_479_200 VPWR VGND sg13cmos5l_decap_8
XFILLER_583_56 VPWR VGND sg13cmos5l_decap_8
X_1708_ _1708_/Q Tile_X0Y3_FrameData[29] VGND VPWR Tile_X0Y9_FrameStrobe[1] latch
XFILLER_2_109 VPWR VGND sg13cmos5l_decap_8
X_2688_ _2688_/Q Tile_X0Y6_FrameData[7] VGND VPWR Tile_X0Y9_FrameStrobe[7] latch
X_4427_ _4427_/X Tile_X0Y6_W1END[3] Tile_X0Y6_W6END[7] _4583_/X _4543_/X _2689_/Q
+ _2688_/Q VPWR VGND sg13cmos5l_mux4_1
XFILLER_516_72 VPWR VGND sg13cmos5l_fill_1
XFILLER_494_203 VPWR VGND sg13cmos5l_fill_1
X_1639_ _1639_/Q Tile_X0Y2_FrameData[10] VGND VPWR Tile_X0Y9_FrameStrobe[6] latch
XFILLER_516_94 VPWR VGND sg13cmos5l_fill_2
X_4358_ _4358_/X Tile_X0Y3_W2MID[4] Tile_X0Y3_W2END[4] Tile_X0Y3_W6END[11] _4211_/X
+ _1875_/Q _1874_/Q VPWR VGND sg13cmos5l_mux4_1
XFILLER_452_49 VPWR VGND sg13cmos5l_decap_8
XFILLER_58_124 VPWR VGND sg13cmos5l_decap_8
XFILLER_100_210 VPWR VGND sg13cmos5l_fill_2
X_3309_ Tile_X0Y0_E1BEG[1] _3801_/X VPWR VGND sg13cmos5l_buf_1
XFILLER_171_28 VPWR VGND sg13cmos5l_decap_8
X_4289_ _4289_/X _0158_/X _0111_/X _4346_/X _4350_/X _2035_/Q _2034_/Q VPWR VGND sg13cmos5l_mux4_1
XANTENNA__3560__X Tile_X0Y9_EE4BEG[6] VPWR VGND sg13cmos5l_antennanp
XFILLER_104_11 VPWR VGND sg13cmos5l_fill_1
XFILLER_532_93 VPWR VGND sg13cmos5l_decap_8
XFILLER_64_37 VPWR VGND sg13cmos5l_decap_8
XFILLER_403_200 VPWR VGND sg13cmos5l_decap_8
XFILLER_266_7 VPWR VGND sg13cmos5l_decap_8
XFILLER_403_211 VPWR VGND sg13cmos5l_fill_1
XFILLER_401_42 VPWR VGND sg13cmos5l_decap_8
XFILLER_433_7 VPWR VGND sg13cmos5l_decap_8
XFILLER_401_97 VPWR VGND sg13cmos5l_decap_8
XANTENNA__2904__X Tile_X0Y6_FrameData_O[25] VPWR VGND sg13cmos5l_antennanp
XFILLER_375_107 VPWR VGND sg13cmos5l_decap_4
XFILLER_564_207 VPWR VGND sg13cmos5l_fill_2
XFILLER_477_35 VPWR VGND sg13cmos5l_decap_8
XFILLER_120_87 VPWR VGND sg13cmos5l_decap_8
XFILLER_368_170 VPWR VGND sg13cmos5l_decap_8
XFILLER_600_7 VPWR VGND sg13cmos5l_decap_8
XFILLER_627_49 VPWR VGND sg13cmos5l_decap_8
XFILLER_196_69 VPWR VGND sg13cmos5l_decap_8
XFILLER_13_63 VPWR VGND sg13cmos5l_decap_8
XFILLER_346_28 VPWR VGND sg13cmos5l_decap_8
XFILLER_493_56 VPWR VGND sg13cmos5l_decap_8
XANTENNA__3735__X AXI_M_SOC_ARADDR7 VPWR VGND sg13cmos5l_antennanp
XFILLER_532_148 VPWR VGND sg13cmos5l_decap_4
XFILLER_276_91 VPWR VGND sg13cmos5l_decap_8
XFILLER_135_140 VPWR VGND sg13cmos5l_decap_8
XFILLER_135_173 VPWR VGND sg13cmos5l_decap_8
XFILLER_296_158 VPWR VGND sg13cmos5l_fill_1
XFILLER_145_73 VPWR VGND sg13cmos5l_decap_4
XFILLER_362_49 VPWR VGND sg13cmos5l_decap_8
XFILLER_150_176 VPWR VGND sg13cmos5l_decap_8
XFILLER_292_0 VPWR VGND sg13cmos5l_decap_8
XANTENNA__3470__X Tile_X0Y1_FrameData_O[28] VPWR VGND sg13cmos5l_antennanp
XFILLER_642_211 VPWR VGND sg13cmos5l_fill_1
XFILLER_599_115 VPWR VGND sg13cmos5l_decap_8
XFILLER_453_133 VPWR VGND sg13cmos5l_fill_1
XFILLER_599_137 VPWR VGND sg13cmos5l_decap_8
XFILLER_557_0 VPWR VGND sg13cmos5l_decap_8
XFILLER_64_149 VPWR VGND sg13cmos5l_decap_8
XFILLER_161_94 VPWR VGND sg13cmos5l_decap_8
XFILLER_311_42 VPWR VGND sg13cmos5l_decap_4
XFILLER_311_53 VPWR VGND sg13cmos5l_decap_8
XFILLER_72_160 VPWR VGND sg13cmos5l_decap_8
XFILLER_610_130 VPWR VGND sg13cmos5l_fill_2
XANTENNA__2814__X Tile_X0Y3_E2BEG[4] VPWR VGND sg13cmos5l_antennanp
X_1990_ _1990_/Q Tile_X0Y4_FrameData[31] VGND VPWR Tile_X0Y9_FrameStrobe[2] latch
XFILLER_387_35 VPWR VGND sg13cmos5l_decap_8
XFILLER_668_89 VPWR VGND sg13cmos5l_decap_4
XFILLER_20_208 VPWR VGND sg13cmos5l_fill_1
X_0941_ _0941_/Q Tile_X0Y0_FrameData[30] VGND VPWR Tile_X0Y9_FrameStrobe[0] latch
XFILLER_220_158 VPWR VGND sg13cmos5l_decap_8
XFILLER_220_169 VPWR VGND sg13cmos5l_fill_1
XFILLER_508_134 VPWR VGND sg13cmos5l_fill_1
X_3660_ AXI_M_SOC_AWADDR21 Tile_X0Y4_WW4END[5] Tile_X0Y4_WW4END[13] Tile_X0Y4_W6END[5]
+ _4341_/X _2003_/Q _2002_/Q VPWR VGND sg13cmos5l_mux4_1
XFILLER_508_156 VPWR VGND sg13cmos5l_decap_8
X_0872_ _0872_/Q Tile_X0Y9_FrameData[23] VGND VPWR Tile_X0Y9_FrameStrobe[6] latch
XFILLER_173_202 VPWR VGND sg13cmos5l_decap_8
X_2611_ _2611_/Q Tile_X0Y6_FrameData[20] VGND VPWR Tile_X0Y9_FrameStrobe[5] latch
XFILLER_684_77 VPWR VGND sg13cmos5l_decap_8
XFILLER_523_115 VPWR VGND sg13cmos5l_decap_4
XFILLER_684_88 VPWR VGND sg13cmos5l_fill_2
XFILLER_256_28 VPWR VGND sg13cmos5l_decap_8
X_3591_ Tile_X0Y9_FrameData_O[21] Tile_X0Y9_FrameData[21] VPWR VGND sg13cmos5l_buf_1
XFILLER_669_119 VPWR VGND sg13cmos5l_fill_2
XFILLER_523_137 VPWR VGND sg13cmos5l_fill_1
XANTENNA__3645__X AXI_M_SOC_AWADDR6 VPWR VGND sg13cmos5l_antennanp
X_2542_ _2542_/Q Tile_X0Y6_FrameData[25] VGND VPWR Tile_X0Y9_FrameStrobe[3] latch
XFILLER_141_110 VPWR VGND sg13cmos5l_decap_8
XFILLER_531_170 VPWR VGND sg13cmos5l_fill_2
X_2473_ _2473_/Q Tile_X0Y6_FrameData[30] VGND VPWR Tile_X0Y9_FrameStrobe[1] latch
XFILLER_677_185 VPWR VGND sg13cmos5l_fill_1
X_4212_ _4212_/X _4203_/X _0046_/X _4202_/X Tile_X0Y0_S4END[15] _1699_/Q _1698_/Q
+ VPWR VGND sg13cmos5l_mux4_1
X_1424_ _1424_/Q Tile_X0Y1_FrameData[9] VGND VPWR Tile_X0Y9_FrameStrobe[7] latch
XFILLER_272_49 VPWR VGND sg13cmos5l_decap_8
XFILLER_633_70 VPWR VGND sg13cmos5l_decap_8
XFILLER_205_21 VPWR VGND sg13cmos5l_decap_8
X_4143_ _4143_/X Tile_X0Y4_W2MID[0] Tile_X0Y4_W2END[0] Tile_X0Y4_W6END[0] _4312_/X
+ _2159_/Q _2158_/Q VPWR VGND sg13cmos5l_mux4_1
X_1355_ _1355_/Q Tile_X0Y1_FrameData[14] VGND VPWR Tile_X0Y9_FrameStrobe[5] latch
XFILLER_444_100 VPWR VGND sg13cmos5l_fill_2
XANTENNA__3380__X Tile_X0Y2_E6BEG[3] VPWR VGND sg13cmos5l_antennanp
XFILLER_444_122 VPWR VGND sg13cmos5l_decap_8
X_0306_ _0306_/Q Tile_X0Y7_FrameData[13] VGND VPWR Tile_X0Y9_FrameStrobe[4] latch
X_4074_ _4074_/X _0057_/X Tile_X0Y0_S4END[10] _4125_/X _4110_/X _1525_/Q _1524_/Q
+ VPWR VGND sg13cmos5l_mux4_1
XFILLER_55_116 VPWR VGND sg13cmos5l_decap_8
XFILLER_205_98 VPWR VGND sg13cmos5l_decap_8
X_1286_ _1286_/Q Tile_X0Y1_FrameData[19] VGND VPWR Tile_X0Y9_FrameStrobe[3] latch
X_3025_ Tile_X0Y5_EE4BEG[0] _4388_/X VPWR VGND sg13cmos5l_buf_1
XFILLER_243_217 VPWR VGND sg13cmos5l_fill_1
X_0237_ _0237_/Q Tile_X0Y7_FrameData[18] VGND VPWR Tile_X0Y9_FrameStrobe[2] latch
XFILLER_502_63 VPWR VGND sg13cmos5l_decap_8
XFILLER_70_108 VPWR VGND sg13cmos5l_decap_8
XFILLER_221_42 VPWR VGND sg13cmos5l_decap_8
X_0168_ _0168_/Q Tile_X0Y7_FrameData[23] VGND VPWR Tile_X0Y9_FrameStrobe[0] latch
XFILLER_578_56 VPWR VGND sg13cmos5l_decap_8
X_0099_ _0099_/X _4322_/X _4323_/X _0645_/Q VPWR VGND sg13cmos5l_mux2_1
XFILLER_297_35 VPWR VGND sg13cmos5l_decap_8
XFILLER_211_147 VPWR VGND sg13cmos5l_decap_8
X_3927_ _3927_/X _4226_/X _4230_/X _4234_/X _4205_/X _1901_/Q _1900_/Q VPWR VGND sg13cmos5l_mux4_1
X_3858_ _3858_/X _3897_/X _3896_/X Tile_X0Y0_S2MID[4] Tile_X0Y0_S2END[4] _0955_/Q
+ _0954_/Q VPWR VGND sg13cmos5l_mux4_1
XFILLER_365_173 VPWR VGND sg13cmos5l_decap_8
XFILLER_109_129 VPWR VGND sg13cmos5l_fill_1
XFILLER_365_184 VPWR VGND sg13cmos5l_fill_1
X_2809_ Tile_X0Y3_E2BEGb[7] _4163_/X VPWR VGND sg13cmos5l_buf_1
XFILLER_166_28 VPWR VGND sg13cmos5l_decap_8
X_3789_ _3789_/X Tile_X0Y0_W2MID[2] Tile_X0Y0_W2END[2] Tile_X0Y0_W6END[2] _3856_/X
+ _1159_/Q _1158_/Q VPWR VGND sg13cmos5l_mux4_1
XFILLER_527_60 VPWR VGND sg13cmos5l_decap_8
XFILLER_380_143 VPWR VGND sg13cmos5l_decap_8
XANTENNA__3555__X Tile_X0Y9_EE4BEG[1] VPWR VGND sg13cmos5l_antennanp
XFILLER_117_140 VPWR VGND sg13cmos5l_decap_8
XFILLER_668_130 VPWR VGND sg13cmos5l_decap_8
XFILLER_246_61 VPWR VGND sg13cmos5l_decap_4
XFILLER_522_170 VPWR VGND sg13cmos5l_fill_2
XFILLER_321_210 VPWR VGND sg13cmos5l_fill_1
XFILLER_182_27 VPWR VGND sg13cmos5l_decap_8
XFILLER_115_21 VPWR VGND sg13cmos5l_decap_8
XFILLER_543_92 VPWR VGND sg13cmos5l_decap_8
XFILLER_383_7 VPWR VGND sg13cmos5l_decap_8
XFILLER_293_128 VPWR VGND sg13cmos5l_fill_2
XANTENNA__3290__X Tile_X0Y0_E6BEG[10] VPWR VGND sg13cmos5l_antennanp
XFILLER_435_133 VPWR VGND sg13cmos5l_decap_4
XFILLER_376_6 VPWR VGND sg13cmos5l_decap_8
XFILLER_75_69 VPWR VGND sg13cmos5l_decap_4
XFILLER_435_166 VPWR VGND sg13cmos5l_fill_2
XFILLER_234_206 VPWR VGND sg13cmos5l_decap_4
XFILLER_550_7 VPWR VGND sg13cmos5l_decap_8
XFILLER_412_63 VPWR VGND sg13cmos5l_decap_8
XFILLER_39_190 VPWR VGND sg13cmos5l_decap_4
XFILLER_648_7 VPWR VGND sg13cmos5l_decap_8
XFILLER_450_114 VPWR VGND sg13cmos5l_decap_8
XFILLER_131_20 VPWR VGND sg13cmos5l_decap_8
XFILLER_199_110 VPWR VGND sg13cmos5l_decap_4
XFILLER_54_160 VPWR VGND sg13cmos5l_decap_8
XANTENNA__0138__Y AXI_M_SOC_AWLEN0 VPWR VGND sg13cmos5l_antennanp
XFILLER_589_181 VPWR VGND sg13cmos5l_decap_8
XFILLER_488_56 VPWR VGND sg13cmos5l_decap_8
XFILLER_91_46 VPWR VGND sg13cmos5l_decap_8
XFILLER_138_0 VPWR VGND sg13cmos5l_decap_8
XFILLER_356_140 VPWR VGND sg13cmos5l_decap_8
XFILLER_357_49 VPWR VGND sg13cmos5l_decap_8
XFILLER_6_201 VPWR VGND sg13cmos5l_decap_8
XFILLER_210_191 VPWR VGND sg13cmos5l_decap_4
XFILLER_654_14 VPWR VGND sg13cmos5l_decap_8
XFILLER_305_0 VPWR VGND sg13cmos5l_fill_2
XANTENNA__3465__X Tile_X0Y1_FrameData_O[23] VPWR VGND sg13cmos5l_antennanp
XFILLER_40_83 VPWR VGND sg13cmos5l_decap_4
XFILLER_156_72 VPWR VGND sg13cmos5l_decap_8
XFILLER_373_59 VPWR VGND sg13cmos5l_fill_1
XFILLER_306_42 VPWR VGND sg13cmos5l_decap_8
XFILLER_123_176 VPWR VGND sg13cmos5l_decap_4
XFILLER_670_35 VPWR VGND sg13cmos5l_decap_8
XFILLER_674_0 VPWR VGND sg13cmos5l_decap_8
XFILLER_27_7 VPWR VGND sg13cmos5l_decap_8
XANTENNA__2809__X Tile_X0Y3_E2BEGb[7] VPWR VGND sg13cmos5l_antennanp
XFILLER_615_200 VPWR VGND sg13cmos5l_decap_8
XFILLER_49_92 VPWR VGND sg13cmos5l_fill_2
XFILLER_615_211 VPWR VGND sg13cmos5l_fill_1
X_1140_ _1140_/Q Tile_X0Y0_FrameData[23] VGND VPWR Tile_X0Y9_FrameStrobe[6] latch
XFILLER_426_133 VPWR VGND sg13cmos5l_decap_8
XFILLER_37_138 VPWR VGND sg13cmos5l_fill_2
XFILLER_322_63 VPWR VGND sg13cmos5l_decap_8
XFILLER_292_172 VPWR VGND sg13cmos5l_decap_8
X_1071_ _1071_/Q Tile_X0Y0_FrameData[28] VGND VPWR Tile_X0Y9_FrameStrobe[4] latch
XFILLER_292_183 VPWR VGND sg13cmos5l_fill_2
XFILLER_1_77 VPWR VGND sg13cmos5l_decap_8
XFILLER_679_77 VPWR VGND sg13cmos5l_decap_8
XFILLER_45_160 VPWR VGND sg13cmos5l_fill_2
X_4830_ _4830_/X Tile_X0Y9_W2MID[5] Tile_X0Y9_W2END[5] Tile_X0Y9_W6END[10] _4905_/X
+ _0879_/Q _0878_/Q VPWR VGND sg13cmos5l_mux4_1
XFILLER_528_207 VPWR VGND sg13cmos5l_decap_4
XFILLER_394_202 VPWR VGND sg13cmos5l_decap_4
XFILLER_695_21 VPWR VGND sg13cmos5l_decap_8
X_4761_ _4761_/X Tile_X0Y9_N4END[5] _0076_/X _4810_/X _4814_/X _0525_/Q _0524_/Q VPWR
+ VGND sg13cmos5l_mux4_1
X_1973_ _1973_/Q Tile_X0Y4_FrameData[16] VGND VPWR Tile_X0Y9_FrameStrobe[1] latch
XFILLER_60_196 VPWR VGND sg13cmos5l_decap_4
X_3712_ AXI_M_SOC_WDATA22 Tile_X0Y6_WW4END[6] Tile_X0Y6_WW4END[14] Tile_X0Y6_W6END[6]
+ _4574_/X _2515_/Q _2514_/Q VPWR VGND sg13cmos5l_mux4_1
X_0924_ _0924_/Q Tile_X0Y9_FrameData[3] VGND VPWR Tile_X0Y9_FrameStrobe[7] latch
X_4692_ _4692_/X _4661_/X Tile_X0Y9_N4END[8] _4660_/X _0056_/X _0199_/Q _0198_/Q VPWR
+ VGND sg13cmos5l_mux4_1
XFILLER_695_98 VPWR VGND sg13cmos5l_decap_8
XFILLER_267_49 VPWR VGND sg13cmos5l_decap_8
XFILLER_628_70 VPWR VGND sg13cmos5l_decap_8
XFILLER_201_191 VPWR VGND sg13cmos5l_fill_1
X_3643_ AXI_M_SOC_AWADDR4 Tile_X0Y5_WW4END[4] Tile_X0Y5_WW4END[12] Tile_X0Y5_W6END[4]
+ _4455_/X _2263_/Q _2262_/Q VPWR VGND sg13cmos5l_mux4_1
XFILLER_362_121 VPWR VGND sg13cmos5l_decap_8
X_0855_ _0855_/Q Tile_X0Y9_FrameData[8] VGND VPWR Tile_X0Y9_FrameStrobe[5] latch
XFILLER_564_14 VPWR VGND sg13cmos5l_decap_8
XANTENNA__3375__X Tile_X0Y2_EE4BEG[14] VPWR VGND sg13cmos5l_antennanp
X_3574_ Tile_X0Y9_FrameData_O[4] Tile_X0Y9_FrameData[4] VPWR VGND sg13cmos5l_buf_1
X_0786_ _0786_/Q Tile_X0Y9_FrameData[13] VGND VPWR Tile_X0Y9_FrameStrobe[3] latch
XFILLER_700_207 VPWR VGND sg13cmos5l_fill_2
X_2525_ _2525_/Q Tile_X0Y6_FrameData[10] VGND VPWR Tile_X0Y9_FrameStrobe[2] latch
XFILLER_714_28 VPWR VGND sg13cmos5l_decap_8
XFILLER_114_154 VPWR VGND sg13cmos5l_decap_8
XFILLER_644_91 VPWR VGND sg13cmos5l_decap_8
XFILLER_216_42 VPWR VGND sg13cmos5l_decap_8
X_2456_ _2456_/Q Tile_X0Y6_FrameData[15] VGND VPWR Tile_X0Y9_FrameStrobe[0] latch
XFILLER_580_35 VPWR VGND sg13cmos5l_decap_8
X_1407_ _1407_/Q Tile_X0Y1_FrameData[26] VGND VPWR Tile_X0Y9_FrameStrobe[7] latch
XFILLER_464_217 VPWR VGND sg13cmos5l_fill_1
X_2387_ _2387_/Q Tile_X0Y5_FrameData[18] VGND VPWR Tile_X0Y9_FrameStrobe[6] latch
X_4126_ _4126_/X _4093_/X _0057_/X _4092_/X Tile_X0Y0_S4END[10] _1461_/Q _1460_/Q
+ VPWR VGND sg13cmos5l_mux4_1
XFILLER_417_133 VPWR VGND sg13cmos5l_fill_1
X_1338_ _1338_/Q Tile_X0Y1_FrameData[31] VGND VPWR Tile_X0Y9_FrameStrobe[5] latch
XFILLER_417_144 VPWR VGND sg13cmos5l_decap_4
XFILLER_232_41 VPWR VGND sg13cmos5l_decap_8
XFILLER_216_206 VPWR VGND sg13cmos5l_decap_4
XFILLER_283_161 VPWR VGND sg13cmos5l_decap_8
XFILLER_216_217 VPWR VGND sg13cmos5l_fill_1
X_4057_ _4057_/X Tile_X0Y2_WW4END[14] AXI_M_SOC_AWREADY _4107_/X _4098_/X _1559_/Q
+ _1558_/Q VPWR VGND sg13cmos5l_mux4_1
X_1269_ _1269_/Q Tile_X0Y1_FrameData[4] VGND VPWR Tile_X0Y9_FrameStrobe[2] latch
XFILLER_45_28 VPWR VGND sg13cmos5l_decap_8
X_3008_ Tile_X0Y5_E2BEGb[3] _4383_/X VPWR VGND sg13cmos5l_buf_1
XFILLER_589_77 VPWR VGND sg13cmos5l_fill_1
XFILLER_231_209 VPWR VGND sg13cmos5l_fill_2
XFILLER_36_182 VPWR VGND sg13cmos5l_decap_4
XFILLER_385_202 VPWR VGND sg13cmos5l_decap_8
XFILLER_101_45 VPWR VGND sg13cmos5l_decap_8
XFILLER_61_27 VPWR VGND sg13cmos5l_decap_8
XFILLER_229_7 VPWR VGND sg13cmos5l_decap_8
XFILLER_177_49 VPWR VGND sg13cmos5l_decap_8
XFILLER_338_173 VPWR VGND sg13cmos5l_decap_8
XFILLER_538_92 VPWR VGND sg13cmos5l_fill_1
XFILLER_474_14 VPWR VGND sg13cmos5l_decap_8
XFILLER_257_60 VPWR VGND sg13cmos5l_decap_8
XANTENNA__3285__X Tile_X0Y0_E6BEG[5] VPWR VGND sg13cmos5l_antennanp
XFILLER_499_147 VPWR VGND sg13cmos5l_decap_8
XFILLER_353_165 VPWR VGND sg13cmos5l_decap_8
XFILLER_152_216 VPWR VGND sg13cmos5l_fill_2
XFILLER_193_48 VPWR VGND sg13cmos5l_decap_8
XFILLER_624_28 VPWR VGND sg13cmos5l_decap_8
XFILLER_10_42 VPWR VGND sg13cmos5l_decap_8
XFILLER_598_7 VPWR VGND sg13cmos5l_decap_8
XFILLER_554_91 VPWR VGND sg13cmos5l_decap_8
XFILLER_407_96 VPWR VGND sg13cmos5l_decap_8
XFILLER_105_165 VPWR VGND sg13cmos5l_decap_4
XFILLER_490_35 VPWR VGND sg13cmos5l_decap_8
XFILLER_273_70 VPWR VGND sg13cmos5l_decap_8
XFILLER_510_173 VPWR VGND sg13cmos5l_decap_8
XFILLER_120_124 VPWR VGND sg13cmos5l_decap_4
XFILLER_120_157 VPWR VGND sg13cmos5l_decap_8
XFILLER_671_147 VPWR VGND sg13cmos5l_decap_8
XFILLER_640_49 VPWR VGND sg13cmos5l_decap_8
XFILLER_423_84 VPWR VGND sg13cmos5l_decap_8
XFILLER_274_161 VPWR VGND sg13cmos5l_decap_8
XFILLER_207_206 VPWR VGND sg13cmos5l_fill_1
XFILLER_19_95 VPWR VGND sg13cmos5l_decap_4
XFILLER_499_77 VPWR VGND sg13cmos5l_decap_8
XFILLER_649_14 VPWR VGND sg13cmos5l_decap_8
XFILLER_255_0 VPWR VGND sg13cmos5l_decap_8
XFILLER_577_140 VPWR VGND sg13cmos5l_decap_8
XFILLER_187_102 VPWR VGND sg13cmos5l_decap_8
XFILLER_577_184 VPWR VGND sg13cmos5l_fill_1
XFILLER_422_0 VPWR VGND sg13cmos5l_decap_8
XFILLER_329_151 VPWR VGND sg13cmos5l_decap_8
XFILLER_665_35 VPWR VGND sg13cmos5l_decap_8
XFILLER_384_14 VPWR VGND sg13cmos5l_decap_8
XFILLER_344_143 VPWR VGND sg13cmos5l_fill_2
XANTENNA__3195__X Tile_X0Y0_N2BEGb[3] VPWR VGND sg13cmos5l_antennanp
X_0640_ _0640_/Q Tile_X0Y8_FrameData[31] VGND VPWR Tile_X0Y9_FrameStrobe[7] latch
XFILLER_384_58 VPWR VGND sg13cmos5l_decap_8
XFILLER_384_69 VPWR VGND sg13cmos5l_fill_2
XFILLER_344_187 VPWR VGND sg13cmos5l_decap_4
XFILLER_344_198 VPWR VGND sg13cmos5l_decap_4
XFILLER_534_28 VPWR VGND sg13cmos5l_decap_8
X_0571_ _0571_/Q Tile_X0Y8_FrameData[4] VGND VPWR Tile_X0Y9_FrameStrobe[4] latch
XFILLER_681_56 VPWR VGND sg13cmos5l_decap_8
X_2310_ _2310_/Q Tile_X0Y5_FrameData[31] VGND VPWR Tile_X0Y9_FrameStrobe[4] latch
XFILLER_647_133 VPWR VGND sg13cmos5l_decap_8
XFILLER_501_140 VPWR VGND sg13cmos5l_decap_8
X_3290_ Tile_X0Y0_E6BEG[10] _3846_/X VPWR VGND sg13cmos5l_buf_1
XFILLER_111_102 VPWR VGND sg13cmos5l_decap_8
X_2241_ _2241_/Q Tile_X0Y5_FrameData[4] VGND VPWR Tile_X0Y9_FrameStrobe[1] latch
XFILLER_111_146 VPWR VGND sg13cmos5l_decap_8
XFILLER_662_114 VPWR VGND sg13cmos5l_decap_4
XFILLER_614_94 VPWR VGND sg13cmos5l_decap_4
X_2172_ _2172_/Q Tile_X0Y4_FrameData[9] VGND VPWR Tile_X0Y9_FrameStrobe[7] latch
XFILLER_550_49 VPWR VGND sg13cmos5l_decap_8
X_1123_ _1123_/Q Tile_X0Y0_FrameData[8] VGND VPWR Tile_X0Y9_FrameStrobe[5] latch
XFILLER_414_147 VPWR VGND sg13cmos5l_decap_4
X_1054_ _1054_/Q Tile_X0Y0_FrameData[13] VGND VPWR Tile_X0Y9_FrameStrobe[3] latch
XFILLER_559_14 VPWR VGND sg13cmos5l_decap_8
XFILLER_18_171 VPWR VGND sg13cmos5l_decap_8
XFILLER_280_175 VPWR VGND sg13cmos5l_decap_4
XFILLER_568_140 VPWR VGND sg13cmos5l_decap_8
XFILLER_202_77 VPWR VGND sg13cmos5l_decap_8
XFILLER_280_197 VPWR VGND sg13cmos5l_decap_8
XFILLER_367_202 VPWR VGND sg13cmos5l_fill_2
XFILLER_178_124 VPWR VGND sg13cmos5l_decap_8
XFILLER_717_115 VPWR VGND sg13cmos5l_fill_1
X_4813_ _4813_/X _4779_/X Tile_X0Y9_N4END[5] _4778_/X _0076_/X _0445_/Q _0444_/Q VPWR
+ VGND sg13cmos5l_mux4_1
XFILLER_709_28 VPWR VGND sg13cmos5l_decap_8
XFILLER_717_126 VPWR VGND sg13cmos5l_decap_8
XFILLER_639_91 VPWR VGND sg13cmos5l_decap_8
XFILLER_583_154 VPWR VGND sg13cmos5l_decap_8
X_1956_ _1956_/Q Tile_X0Y4_FrameData[1] VGND VPWR Tile_X0Y9_FrameStrobe[0] latch
X_4744_ _4744_/X Tile_X0Y8_WW4END[15] AXI_M_SOC_RDATA8 _4815_/X _4784_/X _0559_/Q
+ _0558_/Q VPWR VGND sg13cmos5l_mux4_1
XFILLER_575_35 VPWR VGND sg13cmos5l_decap_8
XFILLER_358_70 VPWR VGND sg13cmos5l_decap_8
XFILLER_193_138 VPWR VGND sg13cmos5l_decap_8
XFILLER_193_149 VPWR VGND sg13cmos5l_fill_1
X_0907_ _0907_/Q Tile_X0Y9_FrameData[20] VGND VPWR Tile_X0Y9_FrameStrobe[7] latch
X_4675_ _4675_/X _4591_/X _4707_/X _4706_/X _4590_/X _0177_/Q _0176_/Q VPWR VGND sg13cmos5l_mux4_1
XFILLER_294_14 VPWR VGND sg13cmos5l_decap_8
X_1887_ _1887_/Q Tile_X0Y3_FrameData[10] VGND VPWR Tile_X0Y9_FrameStrobe[6] latch
X_3626_ Tile_X0Y9_S4BEG[4] _3626_/A VPWR VGND sg13cmos5l_buf_1
X_0838_ _0838_/Q Tile_X0Y9_FrameData[25] VGND VPWR Tile_X0Y9_FrameStrobe[5] latch
XFILLER_508_84 VPWR VGND sg13cmos5l_fill_2
XFILLER_227_41 VPWR VGND sg13cmos5l_decap_8
XFILLER_444_28 VPWR VGND sg13cmos5l_decap_8
X_3557_ Tile_X0Y9_EE4BEG[3] _4867_/X VPWR VGND sg13cmos5l_buf_1
XFILLER_227_63 VPWR VGND sg13cmos5l_decap_8
X_0769_ _0769_/Q Tile_X0Y9_FrameData[30] VGND VPWR Tile_X0Y9_FrameStrobe[3] latch
XFILLER_591_56 VPWR VGND sg13cmos5l_decap_8
XFILLER_489_191 VPWR VGND sg13cmos5l_decap_8
X_2508_ _2508_/Q Tile_X0Y6_FrameData[27] VGND VPWR Tile_X0Y9_FrameStrobe[2] latch
XFILLER_163_18 VPWR VGND sg13cmos5l_fill_1
XFILLER_638_133 VPWR VGND sg13cmos5l_decap_8
X_3488_ Tile_X0Y1_EE4BEG[14] _3962_/X VPWR VGND sg13cmos5l_buf_1
XFILLER_102_113 VPWR VGND sg13cmos5l_decap_8
XFILLER_638_155 VPWR VGND sg13cmos5l_decap_8
X_2439_ _2439_/Q Tile_X0Y5_FrameData[30] VGND VPWR Tile_X0Y9_FrameStrobe[8] latch
XFILLER_653_147 VPWR VGND sg13cmos5l_decap_8
XFILLER_56_27 VPWR VGND sg13cmos5l_decap_8
X_4109_ _4109_/X _4573_/X _4577_/X _4581_/X _4555_/X _2668_/Q _2667_/Q VPWR VGND sg13cmos5l_mux4_1
XFILLER_179_7 VPWR VGND sg13cmos5l_decap_8
XFILLER_469_14 VPWR VGND sg13cmos5l_decap_8
XFILLER_112_77 VPWR VGND sg13cmos5l_fill_1
XFILLER_346_7 VPWR VGND sg13cmos5l_decap_8
XFILLER_708_126 VPWR VGND sg13cmos5l_decap_8
XFILLER_619_28 VPWR VGND sg13cmos5l_decap_8
XFILLER_169_157 VPWR VGND sg13cmos5l_decap_8
XFILLER_574_143 VPWR VGND sg13cmos5l_decap_8
XFILLER_549_91 VPWR VGND sg13cmos5l_decap_8
XFILLER_513_7 VPWR VGND sg13cmos5l_decap_8
XANTENNA__2912__X Tile_X0Y8_E1BEG[0] VPWR VGND sg13cmos5l_antennanp
XFILLER_485_35 VPWR VGND sg13cmos5l_decap_8
XFILLER_268_70 VPWR VGND sg13cmos5l_decap_8
XFILLER_184_138 VPWR VGND sg13cmos5l_decap_8
XANTENNA_70 Tile_X0Y9_N2MID[1] VPWR VGND sg13cmos5l_antennanp
XANTENNA_81 Tile_X0Y9_N2MID[5] VPWR VGND sg13cmos5l_antennanp
XFILLER_326_143 VPWR VGND sg13cmos5l_fill_1
XFILLER_326_165 VPWR VGND sg13cmos5l_fill_2
XFILLER_635_49 VPWR VGND sg13cmos5l_decap_8
XFILLER_418_84 VPWR VGND sg13cmos5l_decap_8
XFILLER_676_217 VPWR VGND sg13cmos5l_fill_1
XANTENNA__0151__Y AXI_M_SOC_AWLEN2 VPWR VGND sg13cmos5l_antennanp
XFILLER_354_28 VPWR VGND sg13cmos5l_decap_8
XFILLER_137_63 VPWR VGND sg13cmos5l_decap_8
XANTENNA__3743__X AXI_M_SOC_ARADDR15 VPWR VGND sg13cmos5l_antennanp
XFILLER_284_91 VPWR VGND sg13cmos5l_decap_8
XFILLER_629_144 VPWR VGND sg13cmos5l_fill_2
XFILLER_495_161 VPWR VGND sg13cmos5l_decap_8
XFILLER_294_201 VPWR VGND sg13cmos5l_decap_8
XFILLER_428_217 VPWR VGND sg13cmos5l_fill_1
XFILLER_644_147 VPWR VGND sg13cmos5l_decap_8
XFILLER_370_49 VPWR VGND sg13cmos5l_decap_4
XFILLER_443_209 VPWR VGND sg13cmos5l_decap_8
XFILLER_372_0 VPWR VGND sg13cmos5l_decap_8
XFILLER_303_21 VPWR VGND sg13cmos5l_decap_8
XFILLER_46_60 VPWR VGND sg13cmos5l_decap_8
XFILLER_450_93 VPWR VGND sg13cmos5l_decap_8
XFILLER_379_14 VPWR VGND sg13cmos5l_decap_8
XFILLER_637_0 VPWR VGND sg13cmos5l_decap_8
XFILLER_600_63 VPWR VGND sg13cmos5l_decap_8
XFILLER_411_139 VPWR VGND sg13cmos5l_decap_8
XFILLER_15_163 VPWR VGND sg13cmos5l_decap_8
XFILLER_30_100 VPWR VGND sg13cmos5l_decap_8
XFILLER_94_7 VPWR VGND sg13cmos5l_decap_8
XFILLER_529_28 VPWR VGND sg13cmos5l_decap_8
XFILLER_459_80 VPWR VGND sg13cmos5l_decap_8
XFILLER_30_122 VPWR VGND sg13cmos5l_decap_4
XFILLER_676_56 VPWR VGND sg13cmos5l_decap_8
XFILLER_30_133 VPWR VGND sg13cmos5l_decap_8
X_1810_ _1810_/Q Tile_X0Y3_FrameData[23] VGND VPWR Tile_X0Y9_FrameStrobe[4] latch
XANTENNA__2822__X Tile_X0Y4_E2BEG[0] VPWR VGND sg13cmos5l_antennanp
XFILLER_175_116 VPWR VGND sg13cmos5l_decap_8
X_2790_ Tile_X0Y3_E6BEG[0] _4180_/X VPWR VGND sg13cmos5l_buf_1
XFILLER_395_35 VPWR VGND sg13cmos5l_decap_8
XFILLER_7_21 VPWR VGND sg13cmos5l_decap_8
XFILLER_580_124 VPWR VGND sg13cmos5l_decap_4
X_1741_ _1741_/Q Tile_X0Y3_FrameData[28] VGND VPWR Tile_X0Y9_FrameStrobe[2] latch
XFILLER_395_68 VPWR VGND sg13cmos5l_decap_8
XFILLER_317_121 VPWR VGND sg13cmos5l_decap_8
XFILLER_30_199 VPWR VGND sg13cmos5l_decap_8
XFILLER_609_94 VPWR VGND sg13cmos5l_decap_4
XFILLER_190_108 VPWR VGND sg13cmos5l_decap_8
X_4460_ _4460_/X _4421_/X _0159_/X _4420_/X _0145_/X _2219_/Q _2218_/Q VPWR VGND sg13cmos5l_mux4_1
X_1672_ _1672_/Q Tile_X0Y2_FrameData[9] VGND VPWR Tile_X0Y9_FrameStrobe[7] latch
XFILLER_545_49 VPWR VGND sg13cmos5l_decap_8
XFILLER_7_98 VPWR VGND sg13cmos5l_fill_2
XFILLER_183_193 VPWR VGND sg13cmos5l_decap_8
X_3411_ Tile_X0Y4_FrameData_O[2] Tile_X0Y4_FrameData[2] VPWR VGND sg13cmos5l_buf_1
XFILLER_692_77 VPWR VGND sg13cmos5l_decap_8
X_0623_ _0623_/Q Tile_X0Y8_FrameData[16] VGND VPWR Tile_X0Y9_FrameStrobe[6] latch
XFILLER_667_217 VPWR VGND sg13cmos5l_fill_1
XFILLER_264_28 VPWR VGND sg13cmos5l_decap_8
X_4391_ _4391_/X Tile_X0Y5_WW4END[12] AXI_M_SOC_RRESP1 _4463_/X _4433_/X _2321_/Q
+ _2320_/Q VPWR VGND sg13cmos5l_mux4_1
XFILLER_194_91 VPWR VGND sg13cmos5l_decap_8
XANTENNA__3653__X AXI_M_SOC_AWADDR14 VPWR VGND sg13cmos5l_antennanp
XFILLER_97_100 VPWR VGND sg13cmos5l_decap_8
X_3342_ Tile_X0Y2_FrameData_O[13] Tile_X0Y2_FrameData[13] VPWR VGND sg13cmos5l_buf_1
XFILLER_97_111 VPWR VGND sg13cmos5l_fill_1
X_0554_ _0554_/Q Tile_X0Y8_FrameData[21] VGND VPWR Tile_X0Y9_FrameStrobe[4] latch
XFILLER_486_150 VPWR VGND sg13cmos5l_decap_8
XFILLER_285_212 VPWR VGND sg13cmos5l_decap_4
X_3273_ Tile_X0Y0_EE4BEG[9] _3829_/X VPWR VGND sg13cmos5l_buf_1
XFILLER_97_166 VPWR VGND sg13cmos5l_decap_8
X_0485_ _0485_/Q Tile_X0Y8_FrameData[26] VGND VPWR Tile_X0Y9_FrameStrobe[2] latch
XFILLER_486_194 VPWR VGND sg13cmos5l_fill_2
X_2224_ _2224_/Q Tile_X0Y5_FrameData[21] VGND VPWR Tile_X0Y9_FrameStrobe[1] latch
XFILLER_280_49 VPWR VGND sg13cmos5l_decap_8
XFILLER_641_70 VPWR VGND sg13cmos5l_decap_8
XFILLER_238_150 VPWR VGND sg13cmos5l_fill_2
XFILLER_635_169 VPWR VGND sg13cmos5l_fill_1
XFILLER_213_21 VPWR VGND sg13cmos5l_decap_8
XFILLER_16_0 VPWR VGND sg13cmos5l_decap_8
X_2155_ _2155_/Q Tile_X0Y4_FrameData[26] VGND VPWR Tile_X0Y9_FrameStrobe[7] latch
XFILLER_253_120 VPWR VGND sg13cmos5l_decap_4
XFILLER_253_131 VPWR VGND sg13cmos5l_decap_8
XFILLER_588_213 VPWR VGND sg13cmos5l_decap_4
X_1106_ _1106_/Q Tile_X0Y0_FrameData[25] VGND VPWR Tile_X0Y9_FrameStrobe[5] latch
X_2086_ _2086_/Q Tile_X0Y4_FrameData[31] VGND VPWR Tile_X0Y9_FrameStrobe[5] latch
XFILLER_289_14 VPWR VGND sg13cmos5l_decap_8
XFILLER_213_98 VPWR VGND sg13cmos5l_decap_8
XFILLER_253_175 VPWR VGND sg13cmos5l_fill_1
XFILLER_402_117 VPWR VGND sg13cmos5l_decap_8
X_1037_ _1037_/Q Tile_X0Y0_FrameData[30] VGND VPWR Tile_X0Y9_FrameStrobe[3] latch
XFILLER_510_63 VPWR VGND sg13cmos5l_decap_8
XFILLER_439_28 VPWR VGND sg13cmos5l_decap_8
XFILLER_586_56 VPWR VGND sg13cmos5l_fill_2
X_2988_ Tile_X0Y8_FrameData_O[28] Tile_X0Y8_FrameData[28] VPWR VGND sg13cmos5l_buf_1
XFILLER_556_176 VPWR VGND sg13cmos5l_decap_4
XFILLER_21_188 VPWR VGND sg13cmos5l_fill_1
XFILLER_166_149 VPWR VGND sg13cmos5l_decap_8
XFILLER_519_72 VPWR VGND sg13cmos5l_fill_1
X_4727_ _4727_/X _4783_/X _4782_/X AXI_M_SOC_RDATA8 AXI_M_SOC_RDATA12 _0593_/Q _0592_/Q
+ VPWR VGND sg13cmos5l_mux4_1
X_1939_ _1939_/Q Tile_X0Y4_FrameData[18] VGND VPWR Tile_X0Y9_FrameStrobe[0] latch
XFILLER_571_168 VPWR VGND sg13cmos5l_decap_8
XFILLER_713_140 VPWR VGND sg13cmos5l_decap_8
XFILLER_174_160 VPWR VGND sg13cmos5l_fill_1
XFILLER_174_171 VPWR VGND sg13cmos5l_decap_8
X_4658_ _4658_/X _4665_/X Tile_X0Y7_W6END[2] _4664_/X _4658_/A3 _0163_/Q _0162_/Q
+ VPWR VGND sg13cmos5l_mux4_1
XFILLER_308_198 VPWR VGND sg13cmos5l_decap_8
XFILLER_658_217 VPWR VGND sg13cmos5l_fill_1
XFILLER_174_28 VPWR VGND sg13cmos5l_decap_8
X_3609_ Tile_X0Y9_S2BEG[3] _4831_/X VPWR VGND sg13cmos5l_buf_1
X_4589_ _4589_/X Tile_X0Y8_W2MID[5] Tile_X0Y8_W2END[5] Tile_X0Y8_W6END[5] _4789_/X
+ _0659_/Q _0658_/Q VPWR VGND sg13cmos5l_mux4_1
XFILLER_107_11 VPWR VGND sg13cmos5l_fill_2
XANTENNA__3563__X Tile_X0Y9_EE4BEG[9] VPWR VGND sg13cmos5l_antennanp
XFILLER_535_93 VPWR VGND sg13cmos5l_fill_2
XFILLER_107_55 VPWR VGND sg13cmos5l_decap_8
XFILLER_477_172 VPWR VGND sg13cmos5l_decap_8
XFILLER_296_7 VPWR VGND sg13cmos5l_decap_8
XFILLER_88_177 VPWR VGND sg13cmos5l_decap_8
XFILLER_67_59 VPWR VGND sg13cmos5l_decap_8
XFILLER_404_42 VPWR VGND sg13cmos5l_decap_8
XFILLER_191_6 VPWR VGND sg13cmos5l_decap_8
XFILLER_190_49 VPWR VGND sg13cmos5l_decap_8
XFILLER_123_21 VPWR VGND sg13cmos5l_decap_8
XFILLER_551_92 VPWR VGND sg13cmos5l_decap_8
XFILLER_492_186 VPWR VGND sg13cmos5l_decap_8
XFILLER_463_7 VPWR VGND sg13cmos5l_decap_8
XANTENNA__2907__X Tile_X0Y6_FrameData_O[28] VPWR VGND sg13cmos5l_antennanp
XFILLER_83_14 VPWR VGND sg13cmos5l_decap_8
XFILLER_44_203 VPWR VGND sg13cmos5l_fill_2
XFILLER_83_36 VPWR VGND sg13cmos5l_decap_8
XFILLER_199_14 VPWR VGND sg13cmos5l_decap_8
XFILLER_701_84 VPWR VGND sg13cmos5l_decap_8
XFILLER_630_7 VPWR VGND sg13cmos5l_decap_8
XFILLER_420_63 VPWR VGND sg13cmos5l_decap_8
XFILLER_398_190 VPWR VGND sg13cmos5l_decap_8
XANTENNA__0146__Y AXI_M_SOC_ARCACHE3 VPWR VGND sg13cmos5l_antennanp
XFILLER_349_28 VPWR VGND sg13cmos5l_decap_8
XFILLER_200_201 VPWR VGND sg13cmos5l_fill_2
XANTENNA__3738__X AXI_M_SOC_ARADDR10 VPWR VGND sg13cmos5l_antennanp
XFILLER_496_56 VPWR VGND sg13cmos5l_decap_8
XFILLER_401_161 VPWR VGND sg13cmos5l_decap_8
XFILLER_12_144 VPWR VGND sg13cmos5l_decap_8
XFILLER_346_216 VPWR VGND sg13cmos5l_fill_2
XFILLER_12_188 VPWR VGND sg13cmos5l_decap_8
XFILLER_562_135 VPWR VGND sg13cmos5l_decap_8
XFILLER_120_0 VPWR VGND sg13cmos5l_fill_2
XFILLER_218_0 VPWR VGND sg13cmos5l_decap_8
XFILLER_704_140 VPWR VGND sg13cmos5l_fill_2
XFILLER_148_73 VPWR VGND sg13cmos5l_decap_8
XFILLER_365_49 VPWR VGND sg13cmos5l_decap_8
XFILLER_314_124 VPWR VGND sg13cmos5l_fill_2
XFILLER_165_193 VPWR VGND sg13cmos5l_decap_8
XFILLER_649_217 VPWR VGND sg13cmos5l_fill_1
XFILLER_662_14 VPWR VGND sg13cmos5l_decap_8
XANTENNA__3473__X Tile_X0Y1_FrameData_O[31] VPWR VGND sg13cmos5l_antennanp
XFILLER_445_71 VPWR VGND sg13cmos5l_fill_1
XFILLER_164_61 VPWR VGND sg13cmos5l_decap_8
XFILLER_587_0 VPWR VGND sg13cmos5l_decap_8
XFILLER_164_72 VPWR VGND sg13cmos5l_fill_1
XFILLER_468_172 VPWR VGND sg13cmos5l_decap_4
XFILLER_322_190 VPWR VGND sg13cmos5l_decap_8
XFILLER_79_177 VPWR VGND sg13cmos5l_decap_8
XFILLER_314_42 VPWR VGND sg13cmos5l_decap_8
XFILLER_617_147 VPWR VGND sg13cmos5l_decap_8
XFILLER_94_125 VPWR VGND sg13cmos5l_decap_8
X_0270_ _0270_/Q Tile_X0Y7_FrameData[17] VGND VPWR Tile_X0Y9_FrameStrobe[3] latch
XFILLER_617_169 VPWR VGND sg13cmos5l_decap_8
XFILLER_483_175 VPWR VGND sg13cmos5l_fill_1
XFILLER_282_215 VPWR VGND sg13cmos5l_fill_2
XFILLER_314_97 VPWR VGND sg13cmos5l_decap_8
XANTENNA__2817__X Tile_X0Y3_E2BEG[7] VPWR VGND sg13cmos5l_antennanp
XFILLER_57_81 VPWR VGND sg13cmos5l_decap_8
XFILLER_180_93 VPWR VGND sg13cmos5l_decap_8
XFILLER_640_161 VPWR VGND sg13cmos5l_decap_8
XFILLER_396_105 VPWR VGND sg13cmos5l_decap_8
XFILLER_330_63 VPWR VGND sg13cmos5l_decap_8
X_3960_ _3960_/X Tile_X0Y1_WW4END[3] AXI_M_SOC_ARREADY _4011_/X _3995_/X _1289_/Q
+ _1288_/Q VPWR VGND sg13cmos5l_mux4_1
XFILLER_585_216 VPWR VGND sg13cmos5l_fill_2
XFILLER_50_206 VPWR VGND sg13cmos5l_fill_2
XFILLER_250_145 VPWR VGND sg13cmos5l_fill_1
XFILLER_73_80 VPWR VGND sg13cmos5l_fill_1
X_2911_ Tile_X0Y6_UserCLKo Tile_X0Y6_UserCLK VPWR VGND sg13cmos5l_buf_1
XFILLER_259_28 VPWR VGND sg13cmos5l_decap_8
X_3891_ _3891_/X Tile_X0Y1_W2MID[6] Tile_X0Y1_W2END[6] Tile_X0Y1_W6END[6] _3991_/X
+ _1415_/Q _1414_/Q VPWR VGND sg13cmos5l_mux4_1
XANTENNA__3648__X AXI_M_SOC_AWADDR9 VPWR VGND sg13cmos5l_antennanp
XFILLER_189_91 VPWR VGND sg13cmos5l_decap_8
XFILLER_148_105 VPWR VGND sg13cmos5l_fill_1
X_2842_ Tile_X0Y6_E2BEG[7] _4503_/X VPWR VGND sg13cmos5l_buf_1
X_2773_ Tile_X0Y3_FrameData_O[31] Tile_X0Y3_FrameData[31] VPWR VGND sg13cmos5l_buf_1
X_1724_ _1724_/Q Tile_X0Y3_FrameData[13] VGND VPWR Tile_X0Y9_FrameStrobe[1] latch
X_4512_ _4512_/X Tile_X0Y6_WW4END[15] AXI_M_SOC_RDATA24 _4583_/X _4552_/X _2583_/Q
+ _2582_/Q VPWR VGND sg13cmos5l_mux4_1
XFILLER_305_102 VPWR VGND sg13cmos5l_decap_8
XFILLER_7_170 VPWR VGND sg13cmos5l_fill_2
XFILLER_275_49 VPWR VGND sg13cmos5l_decap_8
XFILLER_7_181 VPWR VGND sg13cmos5l_fill_1
XFILLER_636_70 VPWR VGND sg13cmos5l_decap_8
X_1655_ _1655_/Q Tile_X0Y2_FrameData[26] VGND VPWR Tile_X0Y9_FrameStrobe[7] latch
X_4443_ _4443_/X Tile_X0Y1_W1END[2] Tile_X0Y1_WW4END[14] Tile_X0Y1_W6END[6] _4010_/X
+ _1359_/Q _1358_/Q VPWR VGND sg13cmos5l_mux4_1
XFILLER_572_14 VPWR VGND sg13cmos5l_decap_8
XANTENNA__3383__X Tile_X0Y2_E6BEG[6] VPWR VGND sg13cmos5l_antennanp
XFILLER_305_179 VPWR VGND sg13cmos5l_decap_8
XFILLER_208_76 VPWR VGND sg13cmos5l_decap_8
XFILLER_710_154 VPWR VGND sg13cmos5l_decap_8
X_0606_ _0606_/Q Tile_X0Y8_FrameData[1] VGND VPWR Tile_X0Y9_FrameStrobe[5] latch
XFILLER_320_105 VPWR VGND sg13cmos5l_fill_2
X_4374_ _4374_/X Tile_X0Y5_W2MID[5] AXI_M_SOC_RRESP0 _4432_/X _4431_/X _2355_/Q _2354_/Q
+ VPWR VGND sg13cmos5l_mux4_1
X_1586_ _1586_/Q Tile_X0Y2_FrameData[31] VGND VPWR Tile_X0Y9_FrameStrobe[5] latch
XFILLER_320_149 VPWR VGND sg13cmos5l_decap_8
X_3325_ Tile_X0Y4_EE4BEG[13] _4285_/X VPWR VGND sg13cmos5l_buf_1
X_0537_ _0537_/Q Tile_X0Y8_FrameData[6] VGND VPWR Tile_X0Y9_FrameStrobe[3] latch
XFILLER_505_63 VPWR VGND sg13cmos5l_decap_8
XFILLER_652_91 VPWR VGND sg13cmos5l_decap_8
XFILLER_608_136 VPWR VGND sg13cmos5l_fill_2
XFILLER_474_131 VPWR VGND sg13cmos5l_fill_1
XFILLER_85_114 VPWR VGND sg13cmos5l_fill_1
XFILLER_224_42 VPWR VGND sg13cmos5l_decap_4
X_3256_ Tile_X0Y0_FrameData_O[24] Tile_X0Y0_FrameData[24] VPWR VGND sg13cmos5l_buf_1
XFILLER_224_53 VPWR VGND sg13cmos5l_fill_2
XFILLER_85_136 VPWR VGND sg13cmos5l_fill_1
X_0468_ _0468_/Q Tile_X0Y8_FrameData[11] VGND VPWR Tile_X0Y9_FrameStrobe[1] latch
XFILLER_273_204 VPWR VGND sg13cmos5l_fill_2
XFILLER_85_158 VPWR VGND sg13cmos5l_fill_2
X_2207_ _2207_/Q Tile_X0Y5_FrameData[6] VGND VPWR Tile_X0Y9_FrameStrobe[0] latch
X_3187_ Tile_X0Y0_N4BEG[11] _3187_/A VPWR VGND sg13cmos5l_buf_1
X_0399_ _0399_/Q Tile_X0Y7_FrameData[16] VGND VPWR Tile_X0Y9_FrameStrobe[7] latch
X_2138_ _2138_/Q Tile_X0Y4_FrameData[11] VGND VPWR Tile_X0Y9_FrameStrobe[6] latch
XFILLER_226_153 VPWR VGND sg13cmos5l_decap_8
XFILLER_241_101 VPWR VGND sg13cmos5l_decap_8
X_2069_ _2069_/Q Tile_X0Y4_FrameData[16] VGND VPWR Tile_X0Y9_FrameStrobe[4] latch
XFILLER_631_183 VPWR VGND sg13cmos5l_fill_1
XFILLER_169_28 VPWR VGND sg13cmos5l_decap_4
XANTENNA__3558__X Tile_X0Y9_EE4BEG[4] VPWR VGND sg13cmos5l_antennanp
XFILLER_139_105 VPWR VGND sg13cmos5l_decap_8
XFILLER_328_205 VPWR VGND sg13cmos5l_fill_1
XFILLER_249_83 VPWR VGND sg13cmos5l_decap_4
XFILLER_544_179 VPWR VGND sg13cmos5l_fill_2
XFILLER_211_7 VPWR VGND sg13cmos5l_decap_8
XFILLER_147_171 VPWR VGND sg13cmos5l_fill_2
XFILLER_5_129 VPWR VGND sg13cmos5l_fill_2
XFILLER_309_7 VPWR VGND sg13cmos5l_decap_8
XFILLER_185_49 VPWR VGND sg13cmos5l_decap_8
XFILLER_546_70 VPWR VGND sg13cmos5l_decap_8
XFILLER_118_21 VPWR VGND sg13cmos5l_decap_8
XFILLER_482_14 VPWR VGND sg13cmos5l_decap_8
XANTENNA__3293__X Tile_X0Y0_E2BEGb[1] VPWR VGND sg13cmos5l_antennanp
XFILLER_78_14 VPWR VGND sg13cmos5l_decap_8
XFILLER_162_196 VPWR VGND sg13cmos5l_decap_8
XFILLER_632_28 VPWR VGND sg13cmos5l_decap_8
XFILLER_580_7 VPWR VGND sg13cmos5l_decap_8
XFILLER_415_63 VPWR VGND sg13cmos5l_decap_8
XFILLER_678_7 VPWR VGND sg13cmos5l_decap_8
XFILLER_562_91 VPWR VGND sg13cmos5l_decap_8
XFILLER_134_42 VPWR VGND sg13cmos5l_decap_8
XFILLER_281_70 VPWR VGND sg13cmos5l_decap_8
XFILLER_264_215 VPWR VGND sg13cmos5l_fill_2
XFILLER_76_147 VPWR VGND sg13cmos5l_decap_8
XFILLER_465_175 VPWR VGND sg13cmos5l_decap_8
XFILLER_182_2 VPWR VGND sg13cmos5l_fill_1
XFILLER_480_134 VPWR VGND sg13cmos5l_fill_2
XFILLER_217_153 VPWR VGND sg13cmos5l_decap_8
XFILLER_431_84 VPWR VGND sg13cmos5l_decap_8
XFILLER_168_0 VPWR VGND sg13cmos5l_decap_8
XFILLER_32_206 VPWR VGND sg13cmos5l_fill_1
XFILLER_32_217 VPWR VGND sg13cmos5l_fill_1
XFILLER_657_14 VPWR VGND sg13cmos5l_decap_8
XANTENNA__3468__X Tile_X0Y1_FrameData_O[26] VPWR VGND sg13cmos5l_antennanp
XFILLER_335_0 VPWR VGND sg13cmos5l_decap_8
XFILLER_300_66 VPWR VGND sg13cmos5l_decap_8
XFILLER_319_205 VPWR VGND sg13cmos5l_decap_8
XFILLER_185_211 VPWR VGND sg13cmos5l_fill_1
XFILLER_43_72 VPWR VGND sg13cmos5l_decap_8
XFILLER_535_124 VPWR VGND sg13cmos5l_decap_4
XFILLER_159_61 VPWR VGND sg13cmos5l_decap_8
XFILLER_535_135 VPWR VGND sg13cmos5l_decap_4
XFILLER_376_59 VPWR VGND sg13cmos5l_fill_2
XFILLER_502_0 VPWR VGND sg13cmos5l_decap_8
XFILLER_334_208 VPWR VGND sg13cmos5l_fill_1
XFILLER_673_35 VPWR VGND sg13cmos5l_decap_8
XFILLER_456_70 VPWR VGND sg13cmos5l_fill_2
XFILLER_689_161 VPWR VGND sg13cmos5l_decap_8
XFILLER_392_14 VPWR VGND sg13cmos5l_decap_8
XFILLER_57_7 VPWR VGND sg13cmos5l_decap_8
XFILLER_309_97 VPWR VGND sg13cmos5l_decap_8
XFILLER_99_206 VPWR VGND sg13cmos5l_fill_2
X_1440_ _1440_/Q Tile_X0Y2_FrameData[17] VGND VPWR Tile_X0Y9_FrameStrobe[0] latch
XFILLER_299_167 VPWR VGND sg13cmos5l_fill_2
XFILLER_542_28 VPWR VGND sg13cmos5l_decap_8
X_1371_ _1371_/Q Tile_X0Y1_FrameData[30] VGND VPWR Tile_X0Y9_FrameStrobe[6] latch
XFILLER_4_77 VPWR VGND sg13cmos5l_decap_8
XFILLER_325_63 VPWR VGND sg13cmos5l_decap_8
X_3110_ Tile_X0Y7_E6BEG[8] _4652_/X VPWR VGND sg13cmos5l_buf_1
X_0322_ _0322_/Q Tile_X0Y7_FrameData[29] VGND VPWR Tile_X0Y9_FrameStrobe[5] latch
X_4090_ _4090_/X Tile_X0Y1_W1END[1] Tile_X0Y1_W6END[9] _4002_/X _3977_/X _1387_/Q
+ _1386_/Q VPWR VGND sg13cmos5l_mux4_1
XFILLER_67_136 VPWR VGND sg13cmos5l_decap_8
XFILLER_255_215 VPWR VGND sg13cmos5l_fill_2
XFILLER_191_92 VPWR VGND sg13cmos5l_fill_2
X_3041_ Tile_X0Y5_FrameData_O[0] Tile_X0Y5_FrameData[0] VPWR VGND sg13cmos5l_buf_1
X_0253_ _0253_/Q Tile_X0Y7_FrameData[2] VGND VPWR Tile_X0Y9_FrameStrobe[2] latch
XFILLER_698_21 VPWR VGND sg13cmos5l_decap_8
X_0184_ _0184_/Q Tile_X0Y7_FrameData[7] VGND VPWR Tile_X0Y9_FrameStrobe[0] latch
XFILLER_341_84 VPWR VGND sg13cmos5l_decap_8
XFILLER_208_164 VPWR VGND sg13cmos5l_decap_8
XFILLER_223_101 VPWR VGND sg13cmos5l_decap_8
XFILLER_223_123 VPWR VGND sg13cmos5l_decap_8
XFILLER_90_150 VPWR VGND sg13cmos5l_fill_1
XFILLER_698_98 VPWR VGND sg13cmos5l_decap_8
XFILLER_23_217 VPWR VGND sg13cmos5l_fill_1
XFILLER_369_138 VPWR VGND sg13cmos5l_decap_4
XFILLER_369_149 VPWR VGND sg13cmos5l_decap_8
X_3943_ _3943_/X Tile_X0Y1_W2END[4] AXI_M_SOC_ARREADY _3995_/X _3994_/X _1323_/Q _1322_/Q
+ VPWR VGND sg13cmos5l_mux4_1
XFILLER_567_14 VPWR VGND sg13cmos5l_decap_8
XFILLER_210_55 VPWR VGND sg13cmos5l_decap_8
XFILLER_384_108 VPWR VGND sg13cmos5l_decap_4
XANTENNA__3378__X Tile_X0Y2_E6BEG[1] VPWR VGND sg13cmos5l_antennanp
X_3874_ _3874_/X _4342_/X _4346_/X _4350_/X _4317_/X _2151_/Q _2150_/Q VPWR VGND sg13cmos5l_mux4_1
XFILLER_83_0 VPWR VGND sg13cmos5l_decap_8
XFILLER_377_193 VPWR VGND sg13cmos5l_decap_8
XFILLER_526_124 VPWR VGND sg13cmos5l_fill_2
X_2825_ Tile_X0Y4_E2BEG[3] _4259_/X VPWR VGND sg13cmos5l_buf_1
XFILLER_219_20 VPWR VGND sg13cmos5l_decap_8
XFILLER_392_163 VPWR VGND sg13cmos5l_decap_8
XFILLER_647_91 VPWR VGND sg13cmos5l_decap_8
XFILLER_136_119 VPWR VGND sg13cmos5l_decap_8
X_2756_ Tile_X0Y3_FrameData_O[14] Tile_X0Y3_FrameData[14] VPWR VGND sg13cmos5l_buf_1
XFILLER_583_35 VPWR VGND sg13cmos5l_decap_8
XFILLER_366_70 VPWR VGND sg13cmos5l_fill_2
X_1707_ _1707_/Q Tile_X0Y3_FrameData[30] VGND VPWR Tile_X0Y9_FrameStrobe[1] latch
X_2687_ _2687_/Q Tile_X0Y6_FrameData[8] VGND VPWR Tile_X0Y9_FrameStrobe[7] latch
XFILLER_695_142 VPWR VGND sg13cmos5l_decap_4
X_1638_ _1638_/Q Tile_X0Y2_FrameData[11] VGND VPWR Tile_X0Y9_FrameStrobe[6] latch
X_4426_ _4426_/X Tile_X0Y4_W1END[3] Tile_X0Y4_W6END[11] _4351_/X _4309_/X _2139_/Q
+ _2138_/Q VPWR VGND sg13cmos5l_mux4_1
XFILLER_695_175 VPWR VGND sg13cmos5l_fill_1
XFILLER_452_28 VPWR VGND sg13cmos5l_decap_8
X_1569_ _1569_/Q Tile_X0Y2_FrameData[16] VGND VPWR Tile_X0Y9_FrameStrobe[4] latch
X_4357_ _4357_/X Tile_X0Y6_W2MID[5] Tile_X0Y6_W2END[5] Tile_X0Y6_W6END[5] _4557_/X
+ _2683_/Q _2682_/Q VPWR VGND sg13cmos5l_mux4_1
XFILLER_58_103 VPWR VGND sg13cmos5l_decap_8
XFILLER_382_91 VPWR VGND sg13cmos5l_decap_8
X_3308_ Tile_X0Y0_E1BEG[0] _3800_/X VPWR VGND sg13cmos5l_buf_1
X_4288_ _4288_/X _0099_/X _0112_/X _4347_/X _4351_/X _2037_/Q _2036_/Q VPWR VGND sg13cmos5l_mux4_1
XFILLER_246_215 VPWR VGND sg13cmos5l_fill_2
XFILLER_447_186 VPWR VGND sg13cmos5l_fill_2
X_3239_ Tile_X0Y0_FrameData_O[7] Tile_X0Y0_FrameData[7] VPWR VGND sg13cmos5l_buf_1
XFILLER_64_16 VPWR VGND sg13cmos5l_decap_8
XFILLER_251_84 VPWR VGND sg13cmos5l_fill_1
XFILLER_401_21 VPWR VGND sg13cmos5l_decap_8
XFILLER_214_112 VPWR VGND sg13cmos5l_decap_8
XFILLER_214_123 VPWR VGND sg13cmos5l_fill_1
XFILLER_161_7 VPWR VGND sg13cmos5l_decap_8
XFILLER_214_134 VPWR VGND sg13cmos5l_decap_8
XFILLER_604_194 VPWR VGND sg13cmos5l_decap_8
XFILLER_259_7 VPWR VGND sg13cmos5l_decap_8
XFILLER_154_6 VPWR VGND sg13cmos5l_decap_8
XFILLER_477_14 VPWR VGND sg13cmos5l_decap_8
XFILLER_214_189 VPWR VGND sg13cmos5l_fill_1
XANTENNA__3288__X Tile_X0Y0_E6BEG[8] VPWR VGND sg13cmos5l_antennanp
XFILLER_375_119 VPWR VGND sg13cmos5l_decap_8
XFILLER_426_7 VPWR VGND sg13cmos5l_decap_8
XFILLER_517_102 VPWR VGND sg13cmos5l_decap_8
XFILLER_517_113 VPWR VGND sg13cmos5l_fill_1
XFILLER_627_28 VPWR VGND sg13cmos5l_decap_8
XFILLER_517_146 VPWR VGND sg13cmos5l_fill_1
XFILLER_196_48 VPWR VGND sg13cmos5l_decap_8
XFILLER_13_42 VPWR VGND sg13cmos5l_decap_8
XFILLER_316_208 VPWR VGND sg13cmos5l_fill_1
XFILLER_557_91 VPWR VGND sg13cmos5l_decap_8
XANTENNA__2920__X Tile_X0Y8_E2BEG[4] VPWR VGND sg13cmos5l_antennanp
XFILLER_493_35 VPWR VGND sg13cmos5l_decap_8
XFILLER_276_70 VPWR VGND sg13cmos5l_decap_8
XFILLER_129_75 VPWR VGND sg13cmos5l_decap_8
XFILLER_135_185 VPWR VGND sg13cmos5l_decap_8
XFILLER_686_153 VPWR VGND sg13cmos5l_fill_2
XFILLER_643_49 VPWR VGND sg13cmos5l_decap_8
XFILLER_426_84 VPWR VGND sg13cmos5l_decap_8
XFILLER_362_28 VPWR VGND sg13cmos5l_decap_8
XANTENNA__3751__X AXI_M_SOC_ARADDR23 VPWR VGND sg13cmos5l_antennanp
XFILLER_145_85 VPWR VGND sg13cmos5l_decap_8
XFILLER_438_164 VPWR VGND sg13cmos5l_fill_2
XFILLER_453_101 VPWR VGND sg13cmos5l_decap_8
XFILLER_285_0 VPWR VGND sg13cmos5l_decap_8
XFILLER_64_128 VPWR VGND sg13cmos5l_decap_8
XFILLER_252_207 VPWR VGND sg13cmos5l_fill_1
XFILLER_161_73 VPWR VGND sg13cmos5l_decap_8
XFILLER_453_178 VPWR VGND sg13cmos5l_decap_4
XFILLER_452_0 VPWR VGND sg13cmos5l_decap_8
XFILLER_311_21 VPWR VGND sg13cmos5l_decap_8
XFILLER_205_112 VPWR VGND sg13cmos5l_decap_8
XFILLER_311_98 VPWR VGND sg13cmos5l_fill_1
XFILLER_668_68 VPWR VGND sg13cmos5l_decap_8
XFILLER_387_14 VPWR VGND sg13cmos5l_decap_8
XFILLER_54_93 VPWR VGND sg13cmos5l_decap_8
XANTENNA__3198__X Tile_X0Y0_N2BEGb[6] VPWR VGND sg13cmos5l_antennanp
XFILLER_717_0 VPWR VGND sg13cmos5l_fill_1
XFILLER_359_160 VPWR VGND sg13cmos5l_decap_8
XFILLER_220_137 VPWR VGND sg13cmos5l_decap_8
X_0940_ _0940_/Q Tile_X0Y9_FrameData[31] VGND VPWR Tile_X0Y9_FrameStrobe[8] latch
XFILLER_610_197 VPWR VGND sg13cmos5l_fill_2
XFILLER_508_102 VPWR VGND sg13cmos5l_decap_8
X_0871_ _0871_/Q Tile_X0Y9_FrameData[24] VGND VPWR Tile_X0Y9_FrameStrobe[6] latch
XFILLER_537_28 VPWR VGND sg13cmos5l_decap_8
XFILLER_684_56 VPWR VGND sg13cmos5l_decap_8
XFILLER_70_70 VPWR VGND sg13cmos5l_decap_8
XFILLER_374_174 VPWR VGND sg13cmos5l_decap_8
XANTENNA__2830__X Tile_X0Y4_UserCLKo VPWR VGND sg13cmos5l_antennanp
X_2610_ _2610_/Q Tile_X0Y6_FrameData[21] VGND VPWR Tile_X0Y9_FrameStrobe[5] latch
XFILLER_712_216 VPWR VGND sg13cmos5l_fill_2
X_3590_ Tile_X0Y9_FrameData_O[20] Tile_X0Y9_FrameData[20] VPWR VGND sg13cmos5l_buf_1
XFILLER_186_70 VPWR VGND sg13cmos5l_decap_8
X_2541_ _2541_/Q Tile_X0Y6_FrameData[26] VGND VPWR Tile_X0Y9_FrameStrobe[3] latch
XFILLER_186_92 VPWR VGND sg13cmos5l_decap_8
X_2472_ _2472_/Q Tile_X0Y6_FrameData[31] VGND VPWR Tile_X0Y9_FrameStrobe[1] latch
XFILLER_553_49 VPWR VGND sg13cmos5l_decap_8
XFILLER_677_175 VPWR VGND sg13cmos5l_fill_2
XFILLER_531_193 VPWR VGND sg13cmos5l_decap_8
X_1423_ _1423_/Q Tile_X0Y1_FrameData[10] VGND VPWR Tile_X0Y9_FrameStrobe[7] latch
X_4211_ _4211_/X _4135_/X _4243_/X _4242_/X _4134_/X _1691_/Q _1690_/Q VPWR VGND sg13cmos5l_mux4_1
XFILLER_272_28 VPWR VGND sg13cmos5l_decap_8
XFILLER_692_123 VPWR VGND sg13cmos5l_fill_2
XFILLER_141_177 VPWR VGND sg13cmos5l_decap_4
XANTENNA__3661__X AXI_M_SOC_AWADDR22 VPWR VGND sg13cmos5l_antennanp
X_4142_ _4142_/X Tile_X0Y1_W1END[3] Tile_X0Y1_W2MID[0] Tile_X0Y1_W2END[0] _3988_/X
+ _1367_/Q _1366_/Q VPWR VGND sg13cmos5l_mux4_1
X_1354_ _1354_/Q Tile_X0Y1_FrameData[15] VGND VPWR Tile_X0Y9_FrameStrobe[5] latch
XFILLER_429_175 VPWR VGND sg13cmos5l_fill_1
XFILLER_295_181 VPWR VGND sg13cmos5l_decap_8
X_0305_ _0305_/Q Tile_X0Y7_FrameData[14] VGND VPWR Tile_X0Y9_FrameStrobe[4] latch
X_4073_ _4073_/X _0064_/X Tile_X0Y0_S4END[9] _4126_/X _4107_/X _1527_/Q _1526_/Q VPWR
+ VGND sg13cmos5l_mux4_1
XFILLER_429_197 VPWR VGND sg13cmos5l_decap_8
XFILLER_205_77 VPWR VGND sg13cmos5l_decap_8
X_1285_ _1285_/Q Tile_X0Y1_FrameData[20] VGND VPWR Tile_X0Y9_FrameStrobe[3] latch
X_3024_ Tile_X0Y5_E6BEG[11] _4415_/X VPWR VGND sg13cmos5l_buf_1
XFILLER_502_42 VPWR VGND sg13cmos5l_decap_8
X_0236_ _0236_/Q Tile_X0Y7_FrameData[19] VGND VPWR Tile_X0Y9_FrameStrobe[2] latch
XFILLER_444_167 VPWR VGND sg13cmos5l_decap_4
XFILLER_221_21 VPWR VGND sg13cmos5l_decap_8
X_0167_ _0167_/Q Tile_X0Y7_FrameData[24] VGND VPWR Tile_X0Y9_FrameStrobe[0] latch
XFILLER_601_120 VPWR VGND sg13cmos5l_decap_8
XFILLER_63_172 VPWR VGND sg13cmos5l_decap_8
XFILLER_598_182 VPWR VGND sg13cmos5l_decap_8
XFILLER_578_35 VPWR VGND sg13cmos5l_decap_8
XFILLER_297_14 VPWR VGND sg13cmos5l_decap_8
XFILLER_221_98 VPWR VGND sg13cmos5l_decap_8
X_0098_ _3634_/A _4836_/X _4837_/X _0865_/Q VPWR VGND sg13cmos5l_mux2_1
XFILLER_400_215 VPWR VGND sg13cmos5l_fill_2
XFILLER_546_208 VPWR VGND sg13cmos5l_fill_1
XFILLER_211_126 VPWR VGND sg13cmos5l_decap_8
XFILLER_357_119 VPWR VGND sg13cmos5l_decap_8
XFILLER_149_200 VPWR VGND sg13cmos5l_decap_4
XFILLER_149_211 VPWR VGND sg13cmos5l_fill_1
X_3926_ _3926_/X Tile_X0Y3_W1END[0] Tile_X0Y3_WW4END[0] Tile_X0Y3_W6END[8] _4222_/X
+ _1901_/Q _1900_/Q VPWR VGND sg13cmos5l_mux4_1
XFILLER_447_28 VPWR VGND sg13cmos5l_decap_8
X_3857_ _3857_/X _3893_/X _3892_/X Tile_X0Y0_S2MID[2] Tile_X0Y0_S2END[2] _0959_/Q
+ _0958_/Q VPWR VGND sg13cmos5l_mux4_1
XFILLER_365_152 VPWR VGND sg13cmos5l_decap_8
XFILLER_164_203 VPWR VGND sg13cmos5l_decap_8
XANTENNA__2740__X Tile_X0Y4_E1BEG[3] VPWR VGND sg13cmos5l_antennanp
X_2808_ Tile_X0Y3_E2BEGb[6] _4162_/X VPWR VGND sg13cmos5l_buf_1
X_3788_ _3788_/X Tile_X0Y0_W2MID[3] Tile_X0Y0_W2END[3] Tile_X0Y0_W6END[3] _3858_/X
+ _1161_/Q _1160_/Q VPWR VGND sg13cmos5l_mux4_1
X_2739_ Tile_X0Y4_E1BEG[2] _4254_/X VPWR VGND sg13cmos5l_buf_1
XFILLER_393_90 VPWR VGND sg13cmos5l_decap_8
XFILLER_132_133 VPWR VGND sg13cmos5l_decap_8
XFILLER_278_126 VPWR VGND sg13cmos5l_decap_4
XFILLER_246_95 VPWR VGND sg13cmos5l_decap_4
X_4409_ _4409_/X AXI_M_SOC_RLAST _4457_/X _4461_/X _4430_/X _2285_/Q _2284_/Q VPWR
+ VGND sg13cmos5l_mux4_1
XANTENNA__3571__X Tile_X0Y9_FrameData_O[1] VPWR VGND sg13cmos5l_antennanp
XFILLER_132_199 VPWR VGND sg13cmos5l_fill_2
XFILLER_683_178 VPWR VGND sg13cmos5l_fill_2
XFILLER_219_215 VPWR VGND sg13cmos5l_fill_2
XFILLER_435_112 VPWR VGND sg13cmos5l_decap_8
XFILLER_115_77 VPWR VGND sg13cmos5l_fill_2
XFILLER_435_145 VPWR VGND sg13cmos5l_decap_8
XFILLER_412_42 VPWR VGND sg13cmos5l_decap_8
XFILLER_435_189 VPWR VGND sg13cmos5l_fill_1
XFILLER_61_109 VPWR VGND sg13cmos5l_decap_8
XFILLER_596_119 VPWR VGND sg13cmos5l_decap_8
XFILLER_543_7 VPWR VGND sg13cmos5l_decap_8
XFILLER_388_211 VPWR VGND sg13cmos5l_fill_1
XANTENNA__2915__X Tile_X0Y8_E1BEG[3] VPWR VGND sg13cmos5l_antennanp
XFILLER_91_14 VPWR VGND sg13cmos5l_decap_8
XFILLER_488_35 VPWR VGND sg13cmos5l_decap_8
XFILLER_131_76 VPWR VGND sg13cmos5l_decap_8
XFILLER_348_119 VPWR VGND sg13cmos5l_decap_8
XFILLER_710_7 VPWR VGND sg13cmos5l_decap_8
XFILLER_638_49 VPWR VGND sg13cmos5l_decap_8
XFILLER_24_63 VPWR VGND sg13cmos5l_fill_2
XFILLER_357_28 VPWR VGND sg13cmos5l_decap_8
XFILLER_287_91 VPWR VGND sg13cmos5l_decap_8
XANTENNA__3746__X AXI_M_SOC_ARADDR18 VPWR VGND sg13cmos5l_antennanp
XFILLER_356_185 VPWR VGND sg13cmos5l_fill_1
XFILLER_356_196 VPWR VGND sg13cmos5l_decap_8
XFILLER_371_133 VPWR VGND sg13cmos5l_decap_8
XFILLER_108_141 VPWR VGND sg13cmos5l_fill_2
XFILLER_200_0 VPWR VGND sg13cmos5l_decap_8
XFILLER_156_51 VPWR VGND sg13cmos5l_decap_8
XFILLER_123_100 VPWR VGND sg13cmos5l_decap_8
XFILLER_371_199 VPWR VGND sg13cmos5l_decap_8
XFILLER_123_111 VPWR VGND sg13cmos5l_fill_2
XFILLER_458_204 VPWR VGND sg13cmos5l_decap_4
XFILLER_373_49 VPWR VGND sg13cmos5l_fill_2
XFILLER_513_182 VPWR VGND sg13cmos5l_fill_1
XFILLER_306_21 VPWR VGND sg13cmos5l_decap_8
XFILLER_123_155 VPWR VGND sg13cmos5l_decap_8
XFILLER_670_14 VPWR VGND sg13cmos5l_decap_8
XANTENNA__3481__X Tile_X0Y1_EE4BEG[7] VPWR VGND sg13cmos5l_antennanp
XFILLER_306_76 VPWR VGND sg13cmos5l_fill_1
XFILLER_306_87 VPWR VGND sg13cmos5l_fill_1
XFILLER_667_0 VPWR VGND sg13cmos5l_decap_8
XFILLER_426_112 VPWR VGND sg13cmos5l_decap_8
XFILLER_603_63 VPWR VGND sg13cmos5l_decap_4
XFILLER_172_83 VPWR VGND sg13cmos5l_decap_8
XFILLER_603_85 VPWR VGND sg13cmos5l_fill_1
XFILLER_322_42 VPWR VGND sg13cmos5l_decap_8
XFILLER_292_151 VPWR VGND sg13cmos5l_decap_8
XFILLER_1_56 VPWR VGND sg13cmos5l_decap_8
X_1070_ _1070_/Q Tile_X0Y0_FrameData[29] VGND VPWR Tile_X0Y9_FrameStrobe[4] latch
XFILLER_322_86 VPWR VGND sg13cmos5l_decap_8
XFILLER_679_56 VPWR VGND sg13cmos5l_decap_8
XANTENNA__2825__X Tile_X0Y4_E2BEG[3] VPWR VGND sg13cmos5l_antennanp
XFILLER_398_35 VPWR VGND sg13cmos5l_decap_8
X_4760_ _4760_/X Tile_X0Y9_N4END[4] _0077_/X _4811_/X _4815_/X _0527_/Q _0526_/Q VPWR
+ VGND sg13cmos5l_mux4_1
XFILLER_60_175 VPWR VGND sg13cmos5l_decap_8
X_1972_ _1972_/Q Tile_X0Y4_FrameData[17] VGND VPWR Tile_X0Y9_FrameStrobe[1] latch
XFILLER_548_49 VPWR VGND sg13cmos5l_decap_8
X_3711_ AXI_M_SOC_WDATA21 Tile_X0Y6_WW4END[5] Tile_X0Y6_WW4END[13] Tile_X0Y6_W6END[5]
+ _4573_/X _2517_/Q _2516_/Q VPWR VGND sg13cmos5l_mux4_1
XFILLER_695_77 VPWR VGND sg13cmos5l_decap_8
X_0923_ _0923_/Q Tile_X0Y9_FrameData[4] VGND VPWR Tile_X0Y9_FrameStrobe[7] latch
XFILLER_347_141 VPWR VGND sg13cmos5l_decap_8
XFILLER_267_28 VPWR VGND sg13cmos5l_decap_8
X_4691_ _4691_/X _4667_/X Tile_X0Y9_N4END[11] _4666_/X _0053_/X _0201_/Q _0200_/Q
+ VPWR VGND sg13cmos5l_mux4_1
XANTENNA__3656__X AXI_M_SOC_AWADDR17 VPWR VGND sg13cmos5l_antennanp
XFILLER_362_100 VPWR VGND sg13cmos5l_decap_8
XFILLER_197_91 VPWR VGND sg13cmos5l_decap_8
X_0854_ _0854_/Q Tile_X0Y9_FrameData[9] VGND VPWR Tile_X0Y9_FrameStrobe[5] latch
X_3642_ AXI_M_SOC_AWADDR3 Tile_X0Y5_WW4END[3] Tile_X0Y5_WW4END[11] Tile_X0Y5_W6END[3]
+ _4454_/X _2265_/Q _2264_/Q VPWR VGND sg13cmos5l_mux4_1
XFILLER_347_196 VPWR VGND sg13cmos5l_decap_8
X_0785_ _0785_/Q Tile_X0Y9_FrameData[14] VGND VPWR Tile_X0Y9_FrameStrobe[3] latch
X_3573_ Tile_X0Y9_FrameData_O[3] Tile_X0Y9_FrameData[3] VPWR VGND sg13cmos5l_buf_1
XFILLER_161_217 VPWR VGND sg13cmos5l_fill_1
XFILLER_303_200 VPWR VGND sg13cmos5l_decap_8
X_2524_ _2524_/Q Tile_X0Y6_FrameData[11] VGND VPWR Tile_X0Y9_FrameStrobe[2] latch
XFILLER_283_49 VPWR VGND sg13cmos5l_decap_8
XFILLER_644_70 VPWR VGND sg13cmos5l_decap_8
XFILLER_504_182 VPWR VGND sg13cmos5l_decap_8
XFILLER_449_215 VPWR VGND sg13cmos5l_fill_2
XFILLER_46_0 VPWR VGND sg13cmos5l_fill_2
XFILLER_216_21 VPWR VGND sg13cmos5l_decap_8
X_2455_ _2455_/Q Tile_X0Y6_FrameData[16] VGND VPWR Tile_X0Y9_FrameStrobe[0] latch
XFILLER_580_14 VPWR VGND sg13cmos5l_decap_8
XANTENNA__3391__X Tile_X0Y2_E2BEGb[2] VPWR VGND sg13cmos5l_antennanp
X_1406_ _1406_/Q Tile_X0Y1_FrameData[27] VGND VPWR Tile_X0Y9_FrameStrobe[7] latch
X_2386_ _2386_/Q Tile_X0Y5_FrameData[19] VGND VPWR Tile_X0Y9_FrameStrobe[6] latch
XFILLER_580_69 VPWR VGND sg13cmos5l_decap_8
XFILLER_417_112 VPWR VGND sg13cmos5l_decap_8
X_1337_ _1337_/Q Tile_X0Y1_FrameData[0] VGND VPWR Tile_X0Y9_FrameStrobe[4] latch
X_4125_ _4125_/X _4091_/X _0064_/X _4090_/X Tile_X0Y0_S4END[9] _1463_/Q _1462_/Q VPWR
+ VGND sg13cmos5l_mux4_1
XFILLER_513_63 VPWR VGND sg13cmos5l_decap_8
XFILLER_232_20 VPWR VGND sg13cmos5l_decap_8
XFILLER_283_140 VPWR VGND sg13cmos5l_decap_8
XFILLER_660_91 VPWR VGND sg13cmos5l_decap_8
X_1268_ _1268_/Q Tile_X0Y1_FrameData[5] VGND VPWR Tile_X0Y9_FrameStrobe[2] latch
X_4056_ _4056_/X Tile_X0Y2_WW4END[15] AXI_M_SOC_AWREADY _4104_/X _4096_/X _1561_/Q
+ _1560_/Q VPWR VGND sg13cmos5l_mux4_1
XFILLER_45_18 VPWR VGND sg13cmos5l_fill_1
XFILLER_589_56 VPWR VGND sg13cmos5l_decap_8
XFILLER_578_119 VPWR VGND sg13cmos5l_decap_8
X_0219_ _0219_/Q Tile_X0Y7_FrameData[4] VGND VPWR Tile_X0Y9_FrameStrobe[1] latch
X_3007_ Tile_X0Y5_E2BEGb[2] _4382_/X VPWR VGND sg13cmos5l_buf_1
XFILLER_232_97 VPWR VGND sg13cmos5l_fill_2
X_1199_ _1199_/Q Tile_X0Y1_FrameData[10] VGND VPWR Tile_X0Y9_FrameStrobe[0] latch
XFILLER_432_159 VPWR VGND sg13cmos5l_decap_4
XFILLER_586_141 VPWR VGND sg13cmos5l_decap_8
X_3909_ _3909_/X _4013_/X _4017_/X _4002_/X _3991_/X _1398_/Q _1397_/Q VPWR VGND sg13cmos5l_mux4_1
XFILLER_177_28 VPWR VGND sg13cmos5l_decap_8
XFILLER_338_152 VPWR VGND sg13cmos5l_decap_8
X_4889_ _4889_/X AXI_M_SOC_RDATA5 _4918_/X _4922_/X _4904_/X _0765_/Q _0764_/Q VPWR
+ VGND sg13cmos5l_mux4_1
XANTENNA__3566__X Tile_X0Y9_EE4BEG[12] VPWR VGND sg13cmos5l_antennanp
XFILLER_542_200 VPWR VGND sg13cmos5l_decap_8
XFILLER_124_7 VPWR VGND sg13cmos5l_decap_8
XFILLER_353_133 VPWR VGND sg13cmos5l_decap_8
XFILLER_499_126 VPWR VGND sg13cmos5l_decap_8
XFILLER_502_119 VPWR VGND sg13cmos5l_decap_8
XFILLER_407_42 VPWR VGND sg13cmos5l_decap_4
XFILLER_193_27 VPWR VGND sg13cmos5l_decap_8
XFILLER_10_21 VPWR VGND sg13cmos5l_decap_8
XFILLER_554_70 VPWR VGND sg13cmos5l_decap_8
XFILLER_407_75 VPWR VGND sg13cmos5l_decap_8
XFILLER_126_21 VPWR VGND sg13cmos5l_decap_8
XFILLER_105_144 VPWR VGND sg13cmos5l_decap_8
XFILLER_510_130 VPWR VGND sg13cmos5l_decap_8
XFILLER_490_14 VPWR VGND sg13cmos5l_decap_8
XFILLER_493_7 VPWR VGND sg13cmos5l_decap_8
XFILLER_86_14 VPWR VGND sg13cmos5l_decap_8
XFILLER_266_129 VPWR VGND sg13cmos5l_decap_8
XFILLER_120_136 VPWR VGND sg13cmos5l_decap_8
XFILLER_704_84 VPWR VGND sg13cmos5l_decap_8
XFILLER_86_58 VPWR VGND sg13cmos5l_decap_8
XFILLER_671_126 VPWR VGND sg13cmos5l_decap_8
XFILLER_660_7 VPWR VGND sg13cmos5l_decap_8
XFILLER_640_28 VPWR VGND sg13cmos5l_decap_8
XFILLER_423_63 VPWR VGND sg13cmos5l_decap_8
XFILLER_408_134 VPWR VGND sg13cmos5l_decap_8
XFILLER_74_201 VPWR VGND sg13cmos5l_decap_8
XFILLER_274_140 VPWR VGND sg13cmos5l_decap_8
XFILLER_570_91 VPWR VGND sg13cmos5l_decap_8
XFILLER_142_42 VPWR VGND sg13cmos5l_decap_8
XFILLER_19_85 VPWR VGND sg13cmos5l_fill_2
XANTENNA__0149__Y AXI_M_SOC_AWLEN1 VPWR VGND sg13cmos5l_antennanp
XFILLER_612_215 VPWR VGND sg13cmos5l_fill_2
XFILLER_499_56 VPWR VGND sg13cmos5l_decap_8
XFILLER_569_119 VPWR VGND sg13cmos5l_decap_8
XFILLER_150_0 VPWR VGND sg13cmos5l_decap_8
XFILLER_35_84 VPWR VGND sg13cmos5l_fill_2
XFILLER_248_0 VPWR VGND sg13cmos5l_decap_8
XFILLER_187_125 VPWR VGND sg13cmos5l_decap_4
XFILLER_42_175 VPWR VGND sg13cmos5l_decap_4
XFILLER_665_14 VPWR VGND sg13cmos5l_decap_8
XFILLER_391_206 VPWR VGND sg13cmos5l_fill_2
XFILLER_415_0 VPWR VGND sg13cmos5l_decap_8
XANTENNA__3476__X Tile_X0Y1_EE4BEG[2] VPWR VGND sg13cmos5l_antennanp
XFILLER_592_199 VPWR VGND sg13cmos5l_decap_4
XFILLER_533_200 VPWR VGND sg13cmos5l_decap_8
XFILLER_51_83 VPWR VGND sg13cmos5l_decap_8
XFILLER_167_50 VPWR VGND sg13cmos5l_decap_8
XFILLER_167_72 VPWR VGND sg13cmos5l_decap_8
XFILLER_143_217 VPWR VGND sg13cmos5l_fill_1
XFILLER_344_177 VPWR VGND sg13cmos5l_decap_4
XFILLER_317_42 VPWR VGND sg13cmos5l_decap_8
X_0570_ _0570_/Q Tile_X0Y8_FrameData[5] VGND VPWR Tile_X0Y9_FrameStrobe[4] latch
XFILLER_681_35 VPWR VGND sg13cmos5l_decap_8
XFILLER_647_112 VPWR VGND sg13cmos5l_decap_8
XFILLER_300_203 VPWR VGND sg13cmos5l_decap_8
XFILLER_32_6 VPWR VGND sg13cmos5l_decap_8
X_2240_ _2240_/Q Tile_X0Y5_FrameData[5] VGND VPWR Tile_X0Y9_FrameStrobe[1] latch
XFILLER_614_84 VPWR VGND sg13cmos5l_decap_4
XFILLER_501_196 VPWR VGND sg13cmos5l_decap_8
XFILLER_647_189 VPWR VGND sg13cmos5l_decap_8
X_2171_ _2171_/Q Tile_X0Y4_FrameData[10] VGND VPWR Tile_X0Y9_FrameStrobe[7] latch
XFILLER_550_28 VPWR VGND sg13cmos5l_decap_8
XFILLER_480_80 VPWR VGND sg13cmos5l_decap_4
XFILLER_480_91 VPWR VGND sg13cmos5l_decap_4
XFILLER_265_151 VPWR VGND sg13cmos5l_fill_2
X_1122_ _1122_/Q Tile_X0Y0_FrameData[9] VGND VPWR Tile_X0Y9_FrameStrobe[5] latch
XFILLER_76_91 VPWR VGND sg13cmos5l_decap_8
XFILLER_25_109 VPWR VGND sg13cmos5l_fill_2
X_1053_ _1053_/Q Tile_X0Y0_FrameData[14] VGND VPWR Tile_X0Y9_FrameStrobe[3] latch
XFILLER_80_215 VPWR VGND sg13cmos5l_fill_2
XFILLER_414_159 VPWR VGND sg13cmos5l_fill_1
XFILLER_280_154 VPWR VGND sg13cmos5l_decap_8
XFILLER_202_56 VPWR VGND sg13cmos5l_decap_8
XFILLER_178_103 VPWR VGND sg13cmos5l_decap_8
XFILLER_422_181 VPWR VGND sg13cmos5l_fill_1
X_4812_ _4812_/X _4777_/X Tile_X0Y9_N4END[4] _4776_/X _0077_/X _0447_/Q _0446_/Q VPWR
+ VGND sg13cmos5l_mux4_1
XFILLER_278_49 VPWR VGND sg13cmos5l_decap_8
XFILLER_639_70 VPWR VGND sg13cmos5l_decap_8
X_4743_ _4743_/X Tile_X0Y8_W2END[0] AXI_M_SOC_RDATA8 _4785_/X _4784_/X _0561_/Q _0560_/Q
+ VPWR VGND sg13cmos5l_mux4_1
XFILLER_575_14 VPWR VGND sg13cmos5l_decap_8
XFILLER_382_206 VPWR VGND sg13cmos5l_decap_8
X_1955_ _1955_/Q Tile_X0Y4_FrameData[2] VGND VPWR Tile_X0Y9_FrameStrobe[0] latch
XFILLER_382_217 VPWR VGND sg13cmos5l_fill_1
XANTENNA__3386__X Tile_X0Y2_E6BEG[9] VPWR VGND sg13cmos5l_antennanp
XFILLER_524_200 VPWR VGND sg13cmos5l_fill_2
X_0906_ _0906_/Q Tile_X0Y9_FrameData[21] VGND VPWR Tile_X0Y9_FrameStrobe[7] latch
X_4674_ _4674_/X _4593_/X _4709_/X _4708_/X _4592_/X _0175_/Q _0174_/Q VPWR VGND sg13cmos5l_mux4_1
XFILLER_335_122 VPWR VGND sg13cmos5l_decap_4
X_1886_ _1886_/Q Tile_X0Y3_FrameData[11] VGND VPWR Tile_X0Y9_FrameStrobe[6] latch
X_3625_ Tile_X0Y9_S4BEG[3] _3625_/A VPWR VGND sg13cmos5l_buf_1
X_0837_ _0837_/Q Tile_X0Y9_FrameData[26] VGND VPWR Tile_X0Y9_FrameStrobe[5] latch
XFILLER_508_63 VPWR VGND sg13cmos5l_decap_8
XFILLER_335_177 VPWR VGND sg13cmos5l_fill_2
XFILLER_227_20 VPWR VGND sg13cmos5l_decap_8
XFILLER_655_91 VPWR VGND sg13cmos5l_decap_8
X_3556_ Tile_X0Y9_EE4BEG[2] _4866_/X VPWR VGND sg13cmos5l_buf_1
XFILLER_350_136 VPWR VGND sg13cmos5l_decap_8
X_0768_ _0768_/Q Tile_X0Y9_FrameData[31] VGND VPWR Tile_X0Y9_FrameStrobe[3] latch
XFILLER_591_35 VPWR VGND sg13cmos5l_decap_8
XFILLER_638_112 VPWR VGND sg13cmos5l_decap_8
XFILLER_374_92 VPWR VGND sg13cmos5l_decap_8
XFILLER_350_169 VPWR VGND sg13cmos5l_fill_1
X_2507_ _2507_/Q Tile_X0Y6_FrameData[28] VGND VPWR Tile_X0Y9_FrameStrobe[2] latch
X_0699_ _0699_/Q Tile_X0Y9_FrameData[4] VGND VPWR Tile_X0Y9_FrameStrobe[0] latch
X_3487_ Tile_X0Y1_EE4BEG[13] _3961_/X VPWR VGND sg13cmos5l_buf_1
XFILLER_102_136 VPWR VGND sg13cmos5l_fill_1
X_2438_ _2438_/Q Tile_X0Y5_FrameData[31] VGND VPWR Tile_X0Y9_FrameStrobe[8] latch
XFILLER_524_84 VPWR VGND sg13cmos5l_decap_8
XFILLER_102_158 VPWR VGND sg13cmos5l_decap_8
XFILLER_653_126 VPWR VGND sg13cmos5l_decap_8
XFILLER_460_28 VPWR VGND sg13cmos5l_decap_8
XFILLER_243_63 VPWR VGND sg13cmos5l_fill_2
X_2369_ _2369_/Q Tile_X0Y5_FrameData[4] VGND VPWR Tile_X0Y9_FrameStrobe[5] latch
XFILLER_256_151 VPWR VGND sg13cmos5l_decap_8
XFILLER_243_85 VPWR VGND sg13cmos5l_fill_1
X_4108_ _4108_/X Tile_X0Y6_W1END[1] Tile_X0Y6_WW4END[1] Tile_X0Y6_W6END[9] _4569_/X
+ _2668_/Q _2667_/Q VPWR VGND sg13cmos5l_mux4_1
XFILLER_110_191 VPWR VGND sg13cmos5l_decap_4
XFILLER_256_184 VPWR VGND sg13cmos5l_decap_8
XFILLER_405_137 VPWR VGND sg13cmos5l_decap_8
X_4039_ _4039_/X _4095_/X Tile_X0Y2_WW4END[7] _4094_/X AXI_M_SOC_AWREADY _1595_/Q
+ _1594_/Q VPWR VGND sg13cmos5l_mux4_1
XFILLER_661_192 VPWR VGND sg13cmos5l_decap_8
XFILLER_271_143 VPWR VGND sg13cmos5l_decap_4
XFILLER_271_176 VPWR VGND sg13cmos5l_decap_8
XFILLER_112_56 VPWR VGND sg13cmos5l_decap_8
XFILLER_271_187 VPWR VGND sg13cmos5l_fill_2
XFILLER_559_141 VPWR VGND sg13cmos5l_fill_2
XFILLER_358_203 VPWR VGND sg13cmos5l_decap_8
XFILLER_72_49 VPWR VGND sg13cmos5l_decap_4
XFILLER_708_105 VPWR VGND sg13cmos5l_decap_8
XFILLER_559_185 VPWR VGND sg13cmos5l_decap_8
XFILLER_241_7 VPWR VGND sg13cmos5l_decap_8
XFILLER_169_136 VPWR VGND sg13cmos5l_decap_8
XFILLER_574_122 VPWR VGND sg13cmos5l_decap_8
XFILLER_559_196 VPWR VGND sg13cmos5l_fill_2
XFILLER_339_7 VPWR VGND sg13cmos5l_decap_8
XFILLER_188_49 VPWR VGND sg13cmos5l_decap_8
XFILLER_549_70 VPWR VGND sg13cmos5l_decap_8
XFILLER_184_106 VPWR VGND sg13cmos5l_decap_8
XFILLER_485_14 VPWR VGND sg13cmos5l_decap_8
XFILLER_373_217 VPWR VGND sg13cmos5l_fill_1
XANTENNA__3296__X Tile_X0Y0_E2BEGb[4] VPWR VGND sg13cmos5l_antennanp
XFILLER_326_100 VPWR VGND sg13cmos5l_decap_8
XFILLER_574_199 VPWR VGND sg13cmos5l_decap_8
XFILLER_515_211 VPWR VGND sg13cmos5l_fill_1
XFILLER_326_111 VPWR VGND sg13cmos5l_fill_2
XANTENNA_60 Tile_X0Y9_FrameStrobe[11] VPWR VGND sg13cmos5l_antennanp
XFILLER_506_7 VPWR VGND sg13cmos5l_decap_8
XANTENNA_71 Tile_X0Y9_N2MID[1] VPWR VGND sg13cmos5l_antennanp
XANTENNA_82 Tile_X0Y9_N2MID[6] VPWR VGND sg13cmos5l_antennanp
XFILLER_635_28 VPWR VGND sg13cmos5l_decap_8
XFILLER_418_63 VPWR VGND sg13cmos5l_decap_8
XFILLER_21_42 VPWR VGND sg13cmos5l_decap_8
XFILLER_565_91 VPWR VGND sg13cmos5l_decap_8
XFILLER_137_42 VPWR VGND sg13cmos5l_decap_8
XFILLER_341_125 VPWR VGND sg13cmos5l_decap_4
XFILLER_284_70 VPWR VGND sg13cmos5l_decap_8
XFILLER_97_35 VPWR VGND sg13cmos5l_fill_2
XFILLER_715_83 VPWR VGND sg13cmos5l_decap_8
XFILLER_495_140 VPWR VGND sg13cmos5l_decap_8
XFILLER_651_49 VPWR VGND sg13cmos5l_decap_8
XFILLER_434_84 VPWR VGND sg13cmos5l_decap_8
XFILLER_644_126 VPWR VGND sg13cmos5l_decap_8
XFILLER_370_28 VPWR VGND sg13cmos5l_decap_8
XFILLER_198_0 VPWR VGND sg13cmos5l_decap_8
XFILLER_365_0 VPWR VGND sg13cmos5l_decap_8
XFILLER_303_88 VPWR VGND sg13cmos5l_decap_8
XFILLER_600_42 VPWR VGND sg13cmos5l_decap_8
XFILLER_600_207 VPWR VGND sg13cmos5l_decap_4
XFILLER_262_176 VPWR VGND sg13cmos5l_fill_1
XFILLER_532_0 VPWR VGND sg13cmos5l_decap_8
XFILLER_15_142 VPWR VGND sg13cmos5l_decap_8
XFILLER_600_86 VPWR VGND sg13cmos5l_fill_1
XFILLER_676_35 VPWR VGND sg13cmos5l_decap_8
XFILLER_565_133 VPWR VGND sg13cmos5l_decap_8
XFILLER_87_7 VPWR VGND sg13cmos5l_decap_8
XFILLER_395_14 VPWR VGND sg13cmos5l_decap_8
XFILLER_62_93 VPWR VGND sg13cmos5l_decap_8
XFILLER_364_217 VPWR VGND sg13cmos5l_fill_1
XFILLER_714_119 VPWR VGND sg13cmos5l_decap_8
XFILLER_565_188 VPWR VGND sg13cmos5l_decap_8
XFILLER_178_82 VPWR VGND sg13cmos5l_decap_8
X_1740_ _1740_/Q Tile_X0Y3_FrameData[29] VGND VPWR Tile_X0Y9_FrameStrobe[2] latch
XFILLER_30_189 VPWR VGND sg13cmos5l_fill_2
XFILLER_328_52 VPWR VGND sg13cmos5l_decap_8
XFILLER_545_28 VPWR VGND sg13cmos5l_decap_8
XFILLER_7_77 VPWR VGND sg13cmos5l_decap_8
X_1671_ _1671_/Q Tile_X0Y2_FrameData[10] VGND VPWR Tile_X0Y9_FrameStrobe[7] latch
XFILLER_183_172 VPWR VGND sg13cmos5l_decap_8
XFILLER_116_217 VPWR VGND sg13cmos5l_fill_1
XFILLER_692_56 VPWR VGND sg13cmos5l_decap_8
X_3410_ Tile_X0Y4_FrameData_O[1] Tile_X0Y4_FrameData[1] VPWR VGND sg13cmos5l_buf_1
X_0622_ _0622_/Q Tile_X0Y8_FrameData[17] VGND VPWR Tile_X0Y9_FrameStrobe[6] latch
X_4390_ _4390_/X Tile_X0Y5_WW4END[13] AXI_M_SOC_RRESP0 _4464_/X _4431_/X _2323_/Q
+ _2322_/Q VPWR VGND sg13cmos5l_mux4_1
XFILLER_194_70 VPWR VGND sg13cmos5l_decap_8
X_0553_ _0553_/Q Tile_X0Y8_FrameData[22] VGND VPWR Tile_X0Y9_FrameStrobe[4] latch
X_3341_ Tile_X0Y2_FrameData_O[12] Tile_X0Y2_FrameData[12] VPWR VGND sg13cmos5l_buf_1
X_0484_ _0484_/Q Tile_X0Y8_FrameData[27] VGND VPWR Tile_X0Y9_FrameStrobe[2] latch
X_3272_ Tile_X0Y0_EE4BEG[8] _3828_/X VPWR VGND sg13cmos5l_buf_1
XFILLER_561_49 VPWR VGND sg13cmos5l_decap_8
XFILLER_344_84 VPWR VGND sg13cmos5l_decap_8
XFILLER_280_28 VPWR VGND sg13cmos5l_decap_8
X_2223_ _2223_/Q Tile_X0Y5_FrameData[22] VGND VPWR Tile_X0Y9_FrameStrobe[1] latch
X_2154_ _2154_/Q Tile_X0Y4_FrameData[27] VGND VPWR Tile_X0Y9_FrameStrobe[7] latch
X_1105_ _1105_/Q Tile_X0Y0_FrameData[26] VGND VPWR Tile_X0Y9_FrameStrobe[5] latch
XFILLER_213_77 VPWR VGND sg13cmos5l_decap_8
X_2085_ _2085_/Q Tile_X0Y4_FrameData[0] VGND VPWR Tile_X0Y9_FrameStrobe[4] latch
XFILLER_53_215 VPWR VGND sg13cmos5l_fill_2
XFILLER_399_158 VPWR VGND sg13cmos5l_decap_8
XFILLER_510_42 VPWR VGND sg13cmos5l_decap_8
X_1036_ _1036_/Q Tile_X0Y0_FrameData[31] VGND VPWR Tile_X0Y9_FrameStrobe[3] latch
XFILLER_253_187 VPWR VGND sg13cmos5l_decap_4
XFILLER_586_35 VPWR VGND sg13cmos5l_decap_8
XFILLER_369_70 VPWR VGND sg13cmos5l_decap_8
XFILLER_369_81 VPWR VGND sg13cmos5l_fill_1
XFILLER_410_162 VPWR VGND sg13cmos5l_decap_8
XFILLER_355_217 VPWR VGND sg13cmos5l_fill_1
X_2987_ Tile_X0Y8_FrameData_O[27] Tile_X0Y8_FrameData[27] VPWR VGND sg13cmos5l_buf_1
XFILLER_586_79 VPWR VGND sg13cmos5l_decap_8
XFILLER_166_128 VPWR VGND sg13cmos5l_decap_8
XFILLER_705_119 VPWR VGND sg13cmos5l_decap_8
XFILLER_21_178 VPWR VGND sg13cmos5l_fill_1
X_4726_ _4726_/X _4781_/X _4780_/X AXI_M_SOC_RDATA9 AXI_M_SOC_RDATA13 _0595_/Q _0594_/Q
+ VPWR VGND sg13cmos5l_mux4_1
XFILLER_159_191 VPWR VGND sg13cmos5l_fill_1
X_1938_ _1938_/Q Tile_X0Y4_FrameData[19] VGND VPWR Tile_X0Y9_FrameStrobe[0] latch
XFILLER_571_147 VPWR VGND sg13cmos5l_decap_8
XFILLER_308_133 VPWR VGND sg13cmos5l_decap_8
XFILLER_308_144 VPWR VGND sg13cmos5l_fill_1
XFILLER_238_41 VPWR VGND sg13cmos5l_fill_2
XFILLER_370_209 VPWR VGND sg13cmos5l_fill_2
XFILLER_174_150 VPWR VGND sg13cmos5l_fill_1
XFILLER_455_28 VPWR VGND sg13cmos5l_decap_8
X_4657_ _4657_/X _4663_/X Tile_X0Y7_W6END[1] _4662_/X _4657_/A3 _0165_/Q _0164_/Q
+ VPWR VGND sg13cmos5l_mux4_1
XFILLER_308_166 VPWR VGND sg13cmos5l_decap_4
XFILLER_107_217 VPWR VGND sg13cmos5l_fill_1
X_1869_ _1869_/Q Tile_X0Y3_FrameData[28] VGND VPWR Tile_X0Y9_FrameStrobe[6] latch
XFILLER_308_177 VPWR VGND sg13cmos5l_decap_8
X_3608_ Tile_X0Y9_S2BEG[2] _4830_/X VPWR VGND sg13cmos5l_buf_1
XFILLER_713_196 VPWR VGND sg13cmos5l_decap_4
X_4588_ _4588_/X Tile_X0Y5_W2MID[5] Tile_X0Y5_W2END[5] Tile_X0Y5_W6END[10] _4432_/X
+ _2391_/Q _2390_/Q VPWR VGND sg13cmos5l_mux4_1
XFILLER_101_9 VPWR VGND sg13cmos5l_fill_1
X_3539_ Tile_X0Y9_E2BEGb[5] _4861_/X VPWR VGND sg13cmos5l_buf_1
XFILLER_331_180 VPWR VGND sg13cmos5l_fill_1
XFILLER_88_156 VPWR VGND sg13cmos5l_decap_8
XFILLER_67_38 VPWR VGND sg13cmos5l_decap_8
XFILLER_404_21 VPWR VGND sg13cmos5l_decap_8
XFILLER_190_28 VPWR VGND sg13cmos5l_decap_8
XFILLER_551_71 VPWR VGND sg13cmos5l_decap_8
XFILLER_492_165 VPWR VGND sg13cmos5l_decap_8
XFILLER_289_7 VPWR VGND sg13cmos5l_decap_8
XFILLER_634_170 VPWR VGND sg13cmos5l_decap_8
XFILLER_701_63 VPWR VGND sg13cmos5l_decap_8
XFILLER_456_7 VPWR VGND sg13cmos5l_decap_8
XFILLER_420_42 VPWR VGND sg13cmos5l_decap_8
XFILLER_16_42 VPWR VGND sg13cmos5l_decap_8
XFILLER_594_217 VPWR VGND sg13cmos5l_fill_1
XFILLER_623_7 VPWR VGND sg13cmos5l_decap_8
XANTENNA__2923__X Tile_X0Y8_E2BEG[7] VPWR VGND sg13cmos5l_antennanp
XFILLER_496_35 VPWR VGND sg13cmos5l_decap_8
XFILLER_12_112 VPWR VGND sg13cmos5l_decap_4
XFILLER_157_117 VPWR VGND sg13cmos5l_decap_8
XFILLER_8_116 VPWR VGND sg13cmos5l_decap_8
XFILLER_32_41 VPWR VGND sg13cmos5l_decap_8
XFILLER_646_49 VPWR VGND sg13cmos5l_decap_8
XFILLER_429_84 VPWR VGND sg13cmos5l_decap_8
XFILLER_365_28 VPWR VGND sg13cmos5l_decap_8
XFILLER_165_161 VPWR VGND sg13cmos5l_decap_8
XFILLER_165_172 VPWR VGND sg13cmos5l_fill_2
XFILLER_503_203 VPWR VGND sg13cmos5l_decap_8
XFILLER_113_0 VPWR VGND sg13cmos5l_decap_8
XANTENNA__3754__X AXI_M_SOC_ARADDR26 VPWR VGND sg13cmos5l_antennanp
XFILLER_295_91 VPWR VGND sg13cmos5l_decap_8
XFILLER_180_142 VPWR VGND sg13cmos5l_decap_8
XFILLER_113_209 VPWR VGND sg13cmos5l_fill_2
XFILLER_314_169 VPWR VGND sg13cmos5l_decap_8
XFILLER_468_151 VPWR VGND sg13cmos5l_decap_8
XFILLER_79_134 VPWR VGND sg13cmos5l_decap_4
XFILLER_79_145 VPWR VGND sg13cmos5l_decap_8
XFILLER_314_21 VPWR VGND sg13cmos5l_decap_8
XFILLER_483_121 VPWR VGND sg13cmos5l_fill_2
XFILLER_482_0 VPWR VGND sg13cmos5l_decap_8
XFILLER_57_60 VPWR VGND sg13cmos5l_decap_8
XFILLER_94_159 VPWR VGND sg13cmos5l_fill_1
XFILLER_35_204 VPWR VGND sg13cmos5l_decap_8
XFILLER_611_63 VPWR VGND sg13cmos5l_decap_8
XFILLER_35_215 VPWR VGND sg13cmos5l_fill_2
XFILLER_180_83 VPWR VGND sg13cmos5l_decap_4
XFILLER_640_140 VPWR VGND sg13cmos5l_decap_8
XFILLER_611_85 VPWR VGND sg13cmos5l_fill_2
XFILLER_330_42 VPWR VGND sg13cmos5l_decap_8
XFILLER_235_176 VPWR VGND sg13cmos5l_fill_2
XFILLER_250_113 VPWR VGND sg13cmos5l_decap_8
XFILLER_640_184 VPWR VGND sg13cmos5l_fill_1
XFILLER_687_56 VPWR VGND sg13cmos5l_decap_8
XFILLER_538_100 VPWR VGND sg13cmos5l_decap_4
XANTENNA__2833__X Tile_X0Y6_E1BEG[2] VPWR VGND sg13cmos5l_antennanp
X_2910_ Tile_X0Y6_FrameData_O[31] Tile_X0Y6_FrameData[31] VPWR VGND sg13cmos5l_buf_1
X_3890_ _3890_/X Tile_X0Y2_W2MID[6] Tile_X0Y2_W2END[6] Tile_X0Y2_W6END[6] _4099_/X
+ _1663_/Q _1662_/Q VPWR VGND sg13cmos5l_mux4_1
XFILLER_538_133 VPWR VGND sg13cmos5l_decap_4
XFILLER_189_70 VPWR VGND sg13cmos5l_decap_8
X_2841_ Tile_X0Y6_E2BEG[6] _4502_/X VPWR VGND sg13cmos5l_buf_1
X_2772_ Tile_X0Y3_FrameData_O[30] Tile_X0Y3_FrameData[30] VPWR VGND sg13cmos5l_buf_1
XFILLER_556_49 VPWR VGND sg13cmos5l_decap_8
XFILLER_339_84 VPWR VGND sg13cmos5l_decap_8
XFILLER_553_158 VPWR VGND sg13cmos5l_decap_8
X_4511_ _4511_/X Tile_X0Y6_W2END[0] AXI_M_SOC_RDATA24 _4553_/X _4552_/X _2585_/Q _2584_/Q
+ VPWR VGND sg13cmos5l_mux4_1
XANTENNA__0072__Y AXI_M_SOC_AWCACHE3 VPWR VGND sg13cmos5l_antennanp
X_1723_ _1723_/Q Tile_X0Y3_FrameData[14] VGND VPWR Tile_X0Y9_FrameStrobe[1] latch
XFILLER_275_28 VPWR VGND sg13cmos5l_decap_8
XFILLER_156_172 VPWR VGND sg13cmos5l_fill_1
XANTENNA__3664__X AXI_M_SOC_AWADDR25 VPWR VGND sg13cmos5l_antennanp
XFILLER_156_194 VPWR VGND sg13cmos5l_decap_8
X_4442_ _4442_/X _4921_/X _4925_/X _4929_/X _4903_/X _0900_/Q _0899_/Q VPWR VGND sg13cmos5l_mux4_1
X_1654_ _1654_/Q Tile_X0Y2_FrameData[27] VGND VPWR Tile_X0Y9_FrameStrobe[7] latch
XFILLER_710_133 VPWR VGND sg13cmos5l_decap_8
XFILLER_305_158 VPWR VGND sg13cmos5l_decap_8
XFILLER_208_55 VPWR VGND sg13cmos5l_decap_8
X_0605_ _0605_/Q Tile_X0Y8_FrameData[2] VGND VPWR Tile_X0Y9_FrameStrobe[5] latch
XFILLER_171_175 VPWR VGND sg13cmos5l_decap_4
X_4373_ _4373_/X Tile_X0Y5_W2MID[6] AXI_M_SOC_RLAST _4430_/X _4429_/X _2357_/Q _2356_/Q
+ VPWR VGND sg13cmos5l_mux4_1
X_1585_ _1585_/Q Tile_X0Y2_FrameData[0] VGND VPWR Tile_X0Y9_FrameStrobe[4] latch
XFILLER_505_42 VPWR VGND sg13cmos5l_decap_8
XFILLER_258_202 VPWR VGND sg13cmos5l_decap_4
XFILLER_710_199 VPWR VGND sg13cmos5l_fill_1
X_3324_ Tile_X0Y4_EE4BEG[12] _4284_/X VPWR VGND sg13cmos5l_buf_1
XFILLER_313_180 VPWR VGND sg13cmos5l_decap_8
X_0536_ _0536_/Q Tile_X0Y8_FrameData[7] VGND VPWR Tile_X0Y9_FrameStrobe[3] latch
XFILLER_291_49 VPWR VGND sg13cmos5l_decap_8
XFILLER_652_70 VPWR VGND sg13cmos5l_decap_8
XFILLER_608_115 VPWR VGND sg13cmos5l_fill_1
XFILLER_474_110 VPWR VGND sg13cmos5l_fill_2
XFILLER_224_21 VPWR VGND sg13cmos5l_decap_8
X_0467_ _0467_/Q Tile_X0Y8_FrameData[12] VGND VPWR Tile_X0Y9_FrameStrobe[1] latch
X_3255_ Tile_X0Y0_FrameData_O[23] Tile_X0Y0_FrameData[23] VPWR VGND sg13cmos5l_buf_1
XFILLER_273_216 VPWR VGND sg13cmos5l_fill_2
X_2206_ _2206_/Q Tile_X0Y5_FrameData[7] VGND VPWR Tile_X0Y9_FrameStrobe[0] latch
XFILLER_224_98 VPWR VGND sg13cmos5l_fill_1
X_0398_ _0398_/Q Tile_X0Y7_FrameData[17] VGND VPWR Tile_X0Y9_FrameStrobe[7] latch
X_3186_ Tile_X0Y0_N4BEG[10] _3186_/A VPWR VGND sg13cmos5l_buf_1
X_2137_ _2137_/Q Tile_X0Y4_FrameData[12] VGND VPWR Tile_X0Y9_FrameStrobe[6] latch
XFILLER_240_42 VPWR VGND sg13cmos5l_decap_8
XFILLER_226_176 VPWR VGND sg13cmos5l_decap_4
X_2068_ _2068_/Q Tile_X0Y4_FrameData[17] VGND VPWR Tile_X0Y9_FrameStrobe[4] latch
XFILLER_576_217 VPWR VGND sg13cmos5l_fill_1
XFILLER_529_100 VPWR VGND sg13cmos5l_decap_4
XANTENNA__2743__X Tile_X0Y3_FrameData_O[1] VPWR VGND sg13cmos5l_antennanp
X_1019_ _1019_/Q Tile_X0Y0_FrameData[16] VGND VPWR Tile_X0Y9_FrameStrobe[2] latch
XFILLER_395_183 VPWR VGND sg13cmos5l_decap_8
XFILLER_544_136 VPWR VGND sg13cmos5l_fill_1
X_4709_ _4709_/X Tile_X0Y9_W2MID[3] Tile_X0Y9_W2END[3] Tile_X0Y9_W6END[3] _4906_/X
+ _0911_/Q _0910_/Q VPWR VGND sg13cmos5l_mux4_1
XFILLER_185_28 VPWR VGND sg13cmos5l_decap_8
XANTENNA__3574__X Tile_X0Y9_FrameData_O[4] VPWR VGND sg13cmos5l_antennanp
XFILLER_698_151 VPWR VGND sg13cmos5l_decap_8
XFILLER_698_162 VPWR VGND sg13cmos5l_fill_1
XFILLER_204_7 VPWR VGND sg13cmos5l_decap_8
XFILLER_701_144 VPWR VGND sg13cmos5l_fill_2
XFILLER_118_77 VPWR VGND sg13cmos5l_fill_2
XFILLER_311_106 VPWR VGND sg13cmos5l_decap_8
XFILLER_500_217 VPWR VGND sg13cmos5l_fill_1
XFILLER_701_199 VPWR VGND sg13cmos5l_fill_2
XFILLER_415_42 VPWR VGND sg13cmos5l_decap_8
XFILLER_304_180 VPWR VGND sg13cmos5l_fill_1
XFILLER_562_70 VPWR VGND sg13cmos5l_decap_8
XFILLER_134_21 VPWR VGND sg13cmos5l_decap_8
XFILLER_573_7 VPWR VGND sg13cmos5l_decap_8
XANTENNA__2918__X Tile_X0Y8_E2BEG[2] VPWR VGND sg13cmos5l_antennanp
XFILLER_465_154 VPWR VGND sg13cmos5l_decap_8
XFILLER_94_14 VPWR VGND sg13cmos5l_decap_8
XFILLER_614_107 VPWR VGND sg13cmos5l_fill_2
XFILLER_480_102 VPWR VGND sg13cmos5l_fill_2
XFILLER_712_84 VPWR VGND sg13cmos5l_decap_8
XFILLER_134_98 VPWR VGND sg13cmos5l_decap_8
XFILLER_217_132 VPWR VGND sg13cmos5l_decap_8
XFILLER_431_63 VPWR VGND sg13cmos5l_decap_8
XFILLER_84_192 VPWR VGND sg13cmos5l_decap_8
XFILLER_150_42 VPWR VGND sg13cmos5l_decap_8
XFILLER_150_53 VPWR VGND sg13cmos5l_fill_2
XFILLER_622_173 VPWR VGND sg13cmos5l_decap_4
XFILLER_217_198 VPWR VGND sg13cmos5l_fill_1
XFILLER_150_64 VPWR VGND sg13cmos5l_fill_1
XFILLER_378_117 VPWR VGND sg13cmos5l_fill_2
XANTENNA__3749__X AXI_M_SOC_ARADDR21 VPWR VGND sg13cmos5l_antennanp
XFILLER_709_200 VPWR VGND sg13cmos5l_fill_2
XFILLER_319_217 VPWR VGND sg13cmos5l_fill_1
XFILLER_230_0 VPWR VGND sg13cmos5l_decap_8
XFILLER_535_103 VPWR VGND sg13cmos5l_decap_8
XFILLER_376_27 VPWR VGND sg13cmos5l_decap_4
XFILLER_328_0 VPWR VGND sg13cmos5l_decap_8
XFILLER_309_21 VPWR VGND sg13cmos5l_decap_8
XFILLER_673_14 VPWR VGND sg13cmos5l_decap_8
XFILLER_64_9 VPWR VGND sg13cmos5l_decap_8
XFILLER_138_183 VPWR VGND sg13cmos5l_decap_8
XANTENNA__3484__X Tile_X0Y1_EE4BEG[10] VPWR VGND sg13cmos5l_antennanp
XFILLER_299_124 VPWR VGND sg13cmos5l_decap_8
XFILLER_299_146 VPWR VGND sg13cmos5l_decap_8
XFILLER_697_0 VPWR VGND sg13cmos5l_decap_8
XFILLER_4_56 VPWR VGND sg13cmos5l_decap_8
XFILLER_325_42 VPWR VGND sg13cmos5l_decap_8
X_1370_ _1370_/Q Tile_X0Y1_FrameData[31] VGND VPWR Tile_X0Y9_FrameStrobe[6] latch
XFILLER_645_210 VPWR VGND sg13cmos5l_decap_8
XFILLER_456_121 VPWR VGND sg13cmos5l_decap_4
X_0321_ _0321_/Q Tile_X0Y7_FrameData[30] VGND VPWR Tile_X0Y9_FrameStrobe[5] latch
XANTENNA__2828__X Tile_X0Y4_E2BEG[6] VPWR VGND sg13cmos5l_antennanp
XFILLER_67_115 VPWR VGND sg13cmos5l_decap_8
XFILLER_68_92 VPWR VGND sg13cmos5l_decap_8
XFILLER_471_102 VPWR VGND sg13cmos5l_decap_8
X_0252_ _0252_/Q Tile_X0Y7_FrameData[3] VGND VPWR Tile_X0Y9_FrameStrobe[2] latch
X_3040_ Tile_X0Y5_EE4BEG[15] _4403_/X VPWR VGND sg13cmos5l_buf_1
XFILLER_622_84 VPWR VGND sg13cmos5l_decap_8
XFILLER_341_63 VPWR VGND sg13cmos5l_decap_8
X_0183_ _0183_/Q Tile_X0Y7_FrameData[8] VGND VPWR Tile_X0Y9_FrameStrobe[0] latch
XFILLER_84_80 VPWR VGND sg13cmos5l_fill_1
XFILLER_84_91 VPWR VGND sg13cmos5l_fill_2
XFILLER_698_77 VPWR VGND sg13cmos5l_decap_8
XFILLER_558_206 VPWR VGND sg13cmos5l_fill_2
XFILLER_369_117 VPWR VGND sg13cmos5l_decap_8
XFILLER_223_146 VPWR VGND sg13cmos5l_fill_1
XANTENNA__3659__X AXI_M_SOC_AWADDR20 VPWR VGND sg13cmos5l_antennanp
X_3942_ _3942_/X Tile_X0Y1_W2END[5] AXI_M_SOC_ARREADY _3993_/X _3992_/X _1325_/Q _1324_/Q
+ VPWR VGND sg13cmos5l_mux4_1
XFILLER_210_34 VPWR VGND sg13cmos5l_decap_8
X_3873_ _3873_/X Tile_X0Y4_W1END[2] Tile_X0Y4_WW4END[2] Tile_X0Y4_W6END[10] _4338_/X
+ _2151_/Q _2150_/Q VPWR VGND sg13cmos5l_mux4_1
XFILLER_377_172 VPWR VGND sg13cmos5l_decap_8
XFILLER_231_190 VPWR VGND sg13cmos5l_fill_1
X_2824_ Tile_X0Y4_E2BEG[2] _4258_/X VPWR VGND sg13cmos5l_buf_1
XFILLER_286_49 VPWR VGND sg13cmos5l_decap_8
XFILLER_647_70 VPWR VGND sg13cmos5l_decap_8
XFILLER_76_0 VPWR VGND sg13cmos5l_decap_8
XFILLER_392_153 VPWR VGND sg13cmos5l_fill_2
XFILLER_526_169 VPWR VGND sg13cmos5l_decap_8
XFILLER_583_14 VPWR VGND sg13cmos5l_decap_8
X_2755_ Tile_X0Y3_FrameData_O[13] Tile_X0Y3_FrameData[13] VPWR VGND sg13cmos5l_buf_1
XFILLER_541_117 VPWR VGND sg13cmos5l_decap_8
XANTENNA__3394__X Tile_X0Y2_E2BEGb[5] VPWR VGND sg13cmos5l_antennanp
X_1706_ _1706_/Q Tile_X0Y3_FrameData[31] VGND VPWR Tile_X0Y9_FrameStrobe[1] latch
XFILLER_534_191 VPWR VGND sg13cmos5l_decap_4
XFILLER_144_142 VPWR VGND sg13cmos5l_decap_8
X_2686_ _2686_/Q Tile_X0Y6_FrameData[9] VGND VPWR Tile_X0Y9_FrameStrobe[7] latch
XFILLER_144_164 VPWR VGND sg13cmos5l_decap_4
X_4425_ _4425_/X _4427_/X Tile_X0Y5_W6END[3] _4426_/X _4425_/A3 _2183_/Q _2440_/Q
+ VPWR VGND sg13cmos5l_mux4_1
XFILLER_695_132 VPWR VGND sg13cmos5l_fill_2
X_1637_ _1637_/Q Tile_X0Y2_FrameData[12] VGND VPWR Tile_X0Y9_FrameStrobe[6] latch
XFILLER_516_63 VPWR VGND sg13cmos5l_decap_8
XFILLER_144_197 VPWR VGND sg13cmos5l_decap_8
XFILLER_663_91 VPWR VGND sg13cmos5l_decap_8
X_4356_ _4356_/X Tile_X0Y3_W2MID[5] Tile_X0Y3_W2END[5] Tile_X0Y3_W6END[10] _4209_/X
+ _1877_/Q _1876_/Q VPWR VGND sg13cmos5l_mux4_1
X_1568_ _1568_/Q Tile_X0Y2_FrameData[17] VGND VPWR Tile_X0Y9_FrameStrobe[4] latch
XFILLER_695_198 VPWR VGND sg13cmos5l_decap_8
XFILLER_382_70 VPWR VGND sg13cmos5l_decap_8
XFILLER_48_29 VPWR VGND sg13cmos5l_decap_8
X_3307_ Tile_X0Y0_E2BEG[7] _3811_/X VPWR VGND sg13cmos5l_buf_1
XANTENNA__2738__X Tile_X0Y4_E1BEG[1] VPWR VGND sg13cmos5l_antennanp
X_0519_ _0519_/Q Tile_X0Y8_FrameData[24] VGND VPWR Tile_X0Y9_FrameStrobe[3] latch
X_4287_ _4287_/X Tile_X0Y4_WW4END[0] AXI_M_SOC_BRESP0 _4336_/X _4313_/X _2039_/Q _2038_/Q
+ VPWR VGND sg13cmos5l_mux4_1
X_1499_ _1499_/Q Tile_X0Y2_FrameData[22] VGND VPWR Tile_X0Y9_FrameStrobe[2] latch
XFILLER_447_165 VPWR VGND sg13cmos5l_decap_8
XFILLER_58_159 VPWR VGND sg13cmos5l_decap_8
XFILLER_301_194 VPWR VGND sg13cmos5l_decap_8
X_3238_ Tile_X0Y0_FrameData_O[6] Tile_X0Y0_FrameData[6] VPWR VGND sg13cmos5l_buf_1
XFILLER_462_113 VPWR VGND sg13cmos5l_decap_8
X_3169_ Tile_X0Y4_E6BEG[6] _4294_/X VPWR VGND sg13cmos5l_buf_1
XFILLER_462_179 VPWR VGND sg13cmos5l_decap_8
XFILLER_604_173 VPWR VGND sg13cmos5l_decap_8
XFILLER_549_206 VPWR VGND sg13cmos5l_decap_4
XANTENNA__3569__X Tile_X0Y9_EE4BEG[15] VPWR VGND sg13cmos5l_antennanp
XFILLER_81_184 VPWR VGND sg13cmos5l_decap_8
XFILLER_120_34 VPWR VGND sg13cmos5l_decap_8
XFILLER_80_27 VPWR VGND sg13cmos5l_decap_8
XFILLER_167_201 VPWR VGND sg13cmos5l_decap_8
XFILLER_120_78 VPWR VGND sg13cmos5l_fill_2
XFILLER_196_27 VPWR VGND sg13cmos5l_decap_8
XFILLER_321_7 VPWR VGND sg13cmos5l_decap_8
XFILLER_13_21 VPWR VGND sg13cmos5l_decap_8
XFILLER_419_7 VPWR VGND sg13cmos5l_decap_8
XFILLER_557_70 VPWR VGND sg13cmos5l_decap_8
XFILLER_129_21 VPWR VGND sg13cmos5l_decap_8
XFILLER_493_14 VPWR VGND sg13cmos5l_decap_8
XFILLER_89_14 VPWR VGND sg13cmos5l_decap_8
XFILLER_532_128 VPWR VGND sg13cmos5l_decap_8
XFILLER_13_98 VPWR VGND sg13cmos5l_decap_8
XFILLER_532_139 VPWR VGND sg13cmos5l_fill_2
XFILLER_707_84 VPWR VGND sg13cmos5l_decap_8
XFILLER_89_58 VPWR VGND sg13cmos5l_decap_8
XFILLER_690_7 VPWR VGND sg13cmos5l_decap_8
XFILLER_643_28 VPWR VGND sg13cmos5l_decap_8
XFILLER_426_63 VPWR VGND sg13cmos5l_decap_8
XFILLER_573_91 VPWR VGND sg13cmos5l_decap_8
XFILLER_485_216 VPWR VGND sg13cmos5l_fill_2
XFILLER_296_116 VPWR VGND sg13cmos5l_decap_8
XFILLER_686_176 VPWR VGND sg13cmos5l_decap_4
XFILLER_145_42 VPWR VGND sg13cmos5l_fill_2
XFILLER_292_70 VPWR VGND sg13cmos5l_decap_8
XFILLER_438_143 VPWR VGND sg13cmos5l_decap_4
XFILLER_1_188 VPWR VGND sg13cmos5l_decap_8
XFILLER_237_205 VPWR VGND sg13cmos5l_decap_8
XFILLER_237_216 VPWR VGND sg13cmos5l_fill_2
XFILLER_38_40 VPWR VGND sg13cmos5l_fill_2
XFILLER_438_187 VPWR VGND sg13cmos5l_fill_2
XFILLER_161_30 VPWR VGND sg13cmos5l_fill_1
XFILLER_64_107 VPWR VGND sg13cmos5l_decap_8
XFILLER_180_0 VPWR VGND sg13cmos5l_fill_2
XFILLER_278_0 VPWR VGND sg13cmos5l_decap_8
XFILLER_161_52 VPWR VGND sg13cmos5l_decap_8
XFILLER_453_157 VPWR VGND sg13cmos5l_decap_8
XFILLER_668_14 VPWR VGND sg13cmos5l_decap_8
XANTENNA__3479__X Tile_X0Y1_EE4BEG[5] VPWR VGND sg13cmos5l_antennanp
XFILLER_445_0 VPWR VGND sg13cmos5l_decap_8
XFILLER_668_47 VPWR VGND sg13cmos5l_decap_8
XFILLER_54_72 VPWR VGND sg13cmos5l_decap_8
XFILLER_205_168 VPWR VGND sg13cmos5l_decap_8
XFILLER_72_195 VPWR VGND sg13cmos5l_decap_8
XFILLER_220_116 VPWR VGND sg13cmos5l_decap_8
XFILLER_612_0 VPWR VGND sg13cmos5l_decap_8
XFILLER_374_120 VPWR VGND sg13cmos5l_decap_4
X_0870_ _0870_/Q Tile_X0Y9_FrameData[25] VGND VPWR Tile_X0Y9_FrameStrobe[6] latch
XFILLER_684_35 VPWR VGND sg13cmos5l_decap_8
XFILLER_467_70 VPWR VGND sg13cmos5l_decap_4
XFILLER_374_153 VPWR VGND sg13cmos5l_decap_8
XFILLER_307_209 VPWR VGND sg13cmos5l_fill_1
XFILLER_62_6 VPWR VGND sg13cmos5l_fill_1
XFILLER_523_128 VPWR VGND sg13cmos5l_decap_8
X_2540_ _2540_/Q Tile_X0Y6_FrameData[27] VGND VPWR Tile_X0Y9_FrameStrobe[3] latch
XFILLER_516_180 VPWR VGND sg13cmos5l_fill_2
XFILLER_617_84 VPWR VGND sg13cmos5l_decap_8
XFILLER_553_28 VPWR VGND sg13cmos5l_decap_8
XFILLER_336_63 VPWR VGND sg13cmos5l_decap_4
X_2471_ _2471_/Q Tile_X0Y6_FrameData[0] VGND VPWR Tile_X0Y9_FrameStrobe[0] latch
XFILLER_287_105 VPWR VGND sg13cmos5l_decap_4
X_4210_ _4210_/X _4137_/X _4245_/X _4244_/X _4136_/X _1689_/Q _1688_/Q VPWR VGND sg13cmos5l_mux4_1
X_1422_ _1422_/Q Tile_X0Y1_FrameData[11] VGND VPWR Tile_X0Y9_FrameStrobe[7] latch
XFILLER_287_138 VPWR VGND sg13cmos5l_fill_1
XFILLER_141_145 VPWR VGND sg13cmos5l_decap_4
XFILLER_141_156 VPWR VGND sg13cmos5l_decap_8
X_4141_ _4141_/X Tile_X0Y4_W2MID[1] Tile_X0Y4_W2END[1] Tile_X0Y4_W6END[1] _4314_/X
+ _2161_/Q _2160_/Q VPWR VGND sg13cmos5l_mux4_1
X_1353_ _1353_/Q Tile_X0Y1_FrameData[16] VGND VPWR Tile_X0Y9_FrameStrobe[5] latch
XFILLER_429_154 VPWR VGND sg13cmos5l_decap_8
XFILLER_228_205 VPWR VGND sg13cmos5l_decap_8
XFILLER_429_165 VPWR VGND sg13cmos5l_fill_1
XFILLER_228_216 VPWR VGND sg13cmos5l_fill_2
XFILLER_205_56 VPWR VGND sg13cmos5l_decap_8
X_0304_ _0304_/Q Tile_X0Y7_FrameData[15] VGND VPWR Tile_X0Y9_FrameStrobe[4] latch
XFILLER_444_113 VPWR VGND sg13cmos5l_fill_2
X_4072_ _4072_/X _0079_/X Tile_X0Y0_S4END[8] _4127_/X _4104_/X _1529_/Q _1528_/Q VPWR
+ VGND sg13cmos5l_mux4_1
X_1284_ _1284_/Q Tile_X0Y1_FrameData[21] VGND VPWR Tile_X0Y9_FrameStrobe[3] latch
XFILLER_352_84 VPWR VGND sg13cmos5l_decap_8
XFILLER_502_21 VPWR VGND sg13cmos5l_decap_8
X_3023_ Tile_X0Y5_E6BEG[10] _4414_/X VPWR VGND sg13cmos5l_buf_1
X_0235_ _0235_/Q Tile_X0Y7_FrameData[20] VGND VPWR Tile_X0Y9_FrameStrobe[2] latch
XFILLER_243_208 VPWR VGND sg13cmos5l_fill_1
X_0166_ _0166_/Q Tile_X0Y7_FrameData[25] VGND VPWR Tile_X0Y9_FrameStrobe[0] latch
XFILLER_598_150 VPWR VGND sg13cmos5l_decap_4
XFILLER_502_98 VPWR VGND sg13cmos5l_decap_8
XFILLER_63_151 VPWR VGND sg13cmos5l_decap_8
XFILLER_578_14 VPWR VGND sg13cmos5l_decap_8
XANTENNA__3389__X Tile_X0Y2_E2BEGb[0] VPWR VGND sg13cmos5l_antennanp
X_0097_ _0097_/X _4449_/X _4450_/X _0892_/Q VPWR VGND sg13cmos5l_mux2_1
XFILLER_211_105 VPWR VGND sg13cmos5l_decap_8
XFILLER_601_165 VPWR VGND sg13cmos5l_decap_8
X_3925_ _3925_/X _4227_/X _4231_/X _4235_/X _4207_/X _1898_/Q _1897_/Q VPWR VGND sg13cmos5l_mux4_1
X_3856_ _3856_/X _3899_/X _3898_/X Tile_X0Y0_S2MID[5] Tile_X0Y0_S2END[5] _0953_/Q
+ _0952_/Q VPWR VGND sg13cmos5l_mux4_1
XFILLER_594_35 VPWR VGND sg13cmos5l_decap_8
X_2807_ Tile_X0Y3_E2BEGb[5] _4161_/X VPWR VGND sg13cmos5l_buf_1
X_3787_ _3787_/X Tile_X0Y0_W2MID[4] Tile_X0Y0_W2END[4] Tile_X0Y0_W6END[4] _3859_/X
+ _1163_/Q _1162_/Q VPWR VGND sg13cmos5l_mux4_1
X_0999_ _0999_/Q Tile_X0Y0_FrameData[4] VGND VPWR Tile_X0Y9_FrameStrobe[1] latch
X_2738_ Tile_X0Y4_E1BEG[1] _4253_/X VPWR VGND sg13cmos5l_buf_1
XFILLER_463_28 VPWR VGND sg13cmos5l_decap_8
XFILLER_117_175 VPWR VGND sg13cmos5l_decap_8
XFILLER_132_112 VPWR VGND sg13cmos5l_decap_8
X_2669_ _2669_/Q Tile_X0Y6_FrameData[26] VGND VPWR Tile_X0Y9_FrameStrobe[7] latch
XFILLER_668_154 VPWR VGND sg13cmos5l_decap_8
XFILLER_522_172 VPWR VGND sg13cmos5l_fill_1
XFILLER_278_105 VPWR VGND sg13cmos5l_decap_8
XFILLER_117_197 VPWR VGND sg13cmos5l_fill_1
XFILLER_59_28 VPWR VGND sg13cmos5l_fill_2
X_4408_ _4408_/X AXI_M_SOC_RVALID _4458_/X _4462_/X _4467_/X _2287_/Q _2286_/Q VPWR
+ VGND sg13cmos5l_mux4_1
XFILLER_132_178 VPWR VGND sg13cmos5l_decap_8
XFILLER_86_210 VPWR VGND sg13cmos5l_fill_2
X_4339_ _4339_/X _4311_/X _0040_/X _4310_/X _0109_/X _1975_/Q _1974_/Q VPWR VGND sg13cmos5l_mux4_1
XFILLER_115_56 VPWR VGND sg13cmos5l_decap_8
XFILLER_75_27 VPWR VGND sg13cmos5l_decap_8
XFILLER_412_21 VPWR VGND sg13cmos5l_decap_8
XFILLER_271_7 VPWR VGND sg13cmos5l_decap_8
XFILLER_369_7 VPWR VGND sg13cmos5l_decap_8
XFILLER_589_150 VPWR VGND sg13cmos5l_decap_8
XFILLER_488_14 VPWR VGND sg13cmos5l_decap_8
XFILLER_412_98 VPWR VGND sg13cmos5l_decap_8
XANTENNA__3299__X Tile_X0Y0_E2BEGb[7] VPWR VGND sg13cmos5l_antennanp
XFILLER_199_145 VPWR VGND sg13cmos5l_decap_8
XFILLER_536_7 VPWR VGND sg13cmos5l_decap_8
XFILLER_202_105 VPWR VGND sg13cmos5l_decap_8
XFILLER_199_178 VPWR VGND sg13cmos5l_fill_1
XFILLER_638_28 VPWR VGND sg13cmos5l_decap_8
XFILLER_24_42 VPWR VGND sg13cmos5l_decap_8
XFILLER_568_91 VPWR VGND sg13cmos5l_decap_8
XFILLER_703_7 VPWR VGND sg13cmos5l_decap_8
XANTENNA__2931__X Tile_X0Y8_E2BEGb[7] VPWR VGND sg13cmos5l_antennanp
XFILLER_287_70 VPWR VGND sg13cmos5l_decap_8
XFILLER_356_175 VPWR VGND sg13cmos5l_decap_4
XFILLER_108_120 VPWR VGND sg13cmos5l_decap_8
XFILLER_305_2 VPWR VGND sg13cmos5l_fill_1
XFILLER_654_49 VPWR VGND sg13cmos5l_decap_8
XFILLER_170_207 VPWR VGND sg13cmos5l_fill_1
XFILLER_437_84 VPWR VGND sg13cmos5l_fill_1
XFILLER_371_178 VPWR VGND sg13cmos5l_decap_8
XFILLER_108_164 VPWR VGND sg13cmos5l_decap_4
XFILLER_513_150 VPWR VGND sg13cmos5l_decap_8
XFILLER_108_175 VPWR VGND sg13cmos5l_fill_2
XFILLER_373_28 VPWR VGND sg13cmos5l_decap_8
XFILLER_269_105 VPWR VGND sg13cmos5l_fill_2
XFILLER_458_216 VPWR VGND sg13cmos5l_fill_2
XFILLER_6_0 VPWR VGND sg13cmos5l_decap_8
XFILLER_674_124 VPWR VGND sg13cmos5l_fill_1
XFILLER_269_149 VPWR VGND sg13cmos5l_decap_8
XFILLER_674_146 VPWR VGND sg13cmos5l_decap_4
XFILLER_49_50 VPWR VGND sg13cmos5l_decap_8
XFILLER_395_0 VPWR VGND sg13cmos5l_decap_8
XFILLER_77_210 VPWR VGND sg13cmos5l_decap_8
XFILLER_453_83 VPWR VGND sg13cmos5l_decap_4
XFILLER_284_119 VPWR VGND sg13cmos5l_decap_8
XFILLER_674_179 VPWR VGND sg13cmos5l_decap_8
XFILLER_453_94 VPWR VGND sg13cmos5l_decap_8
XFILLER_603_42 VPWR VGND sg13cmos5l_decap_8
XFILLER_562_0 VPWR VGND sg13cmos5l_decap_8
XFILLER_322_21 VPWR VGND sg13cmos5l_decap_8
XFILLER_1_35 VPWR VGND sg13cmos5l_decap_8
XFILLER_426_168 VPWR VGND sg13cmos5l_decap_8
XFILLER_679_35 VPWR VGND sg13cmos5l_decap_8
XFILLER_398_14 VPWR VGND sg13cmos5l_decap_8
XFILLER_379_201 VPWR VGND sg13cmos5l_decap_8
XFILLER_65_82 VPWR VGND sg13cmos5l_decap_8
XANTENNA__3002__X Tile_X0Y5_E2BEG[5] VPWR VGND sg13cmos5l_antennanp
XFILLER_60_154 VPWR VGND sg13cmos5l_decap_8
XFILLER_548_28 VPWR VGND sg13cmos5l_decap_8
XFILLER_394_215 VPWR VGND sg13cmos5l_fill_2
X_1971_ _1971_/Q Tile_X0Y4_FrameData[18] VGND VPWR Tile_X0Y9_FrameStrobe[1] latch
XFILLER_695_56 VPWR VGND sg13cmos5l_decap_8
XANTENNA__2841__X Tile_X0Y6_E2BEG[6] VPWR VGND sg13cmos5l_antennanp
X_3710_ AXI_M_SOC_WDATA20 Tile_X0Y6_WW4END[4] Tile_X0Y6_WW4END[12] Tile_X0Y6_W6END[4]
+ _4572_/X _2519_/Q _2518_/Q VPWR VGND sg13cmos5l_mux4_1
X_0922_ _0922_/Q Tile_X0Y9_FrameData[5] VGND VPWR Tile_X0Y9_FrameStrobe[7] latch
X_4690_ _4690_/X _4665_/X Tile_X0Y9_N4END[10] _4664_/X _0054_/X _0203_/Q _0202_/Q
+ VPWR VGND sg13cmos5l_mux4_1
XFILLER_197_70 VPWR VGND sg13cmos5l_decap_8
XFILLER_146_215 VPWR VGND sg13cmos5l_fill_2
X_3641_ AXI_M_SOC_AWADDR2 Tile_X0Y5_WW4END[2] Tile_X0Y5_WW4END[10] Tile_X0Y5_W6END[2]
+ _4453_/X _2267_/Q _2266_/Q VPWR VGND sg13cmos5l_mux4_1
X_0853_ _0853_/Q Tile_X0Y9_FrameData[10] VGND VPWR Tile_X0Y9_FrameStrobe[5] latch
X_3572_ Tile_X0Y9_FrameData_O[2] Tile_X0Y9_FrameData[2] VPWR VGND sg13cmos5l_buf_1
XFILLER_564_49 VPWR VGND sg13cmos5l_decap_8
X_0784_ _0784_/Q Tile_X0Y9_FrameData[15] VGND VPWR Tile_X0Y9_FrameStrobe[3] latch
XFILLER_347_84 VPWR VGND sg13cmos5l_decap_8
XFILLER_161_207 VPWR VGND sg13cmos5l_decap_4
X_2523_ _2523_/Q Tile_X0Y6_FrameData[12] VGND VPWR Tile_X0Y9_FrameStrobe[2] latch
XFILLER_362_189 VPWR VGND sg13cmos5l_decap_8
XFILLER_283_28 VPWR VGND sg13cmos5l_decap_8
XFILLER_504_161 VPWR VGND sg13cmos5l_decap_8
X_2454_ _2454_/Q Tile_X0Y6_FrameData[17] VGND VPWR Tile_X0Y9_FrameStrobe[0] latch
X_1405_ _1405_/Q Tile_X0Y1_FrameData[28] VGND VPWR Tile_X0Y9_FrameStrobe[7] latch
XFILLER_216_77 VPWR VGND sg13cmos5l_decap_8
X_2385_ _2385_/Q Tile_X0Y5_FrameData[20] VGND VPWR Tile_X0Y9_FrameStrobe[6] latch
XFILLER_275_119 VPWR VGND sg13cmos5l_decap_8
XFILLER_513_42 VPWR VGND sg13cmos5l_decap_8
X_4124_ _4124_/X _4089_/X _0079_/X _4088_/X Tile_X0Y0_S4END[8] _1465_/Q _1464_/Q VPWR
+ VGND sg13cmos5l_mux4_1
X_1336_ _1336_/Q Tile_X0Y1_FrameData[1] VGND VPWR Tile_X0Y9_FrameStrobe[4] latch
XFILLER_660_70 VPWR VGND sg13cmos5l_decap_8
XFILLER_83_202 VPWR VGND sg13cmos5l_decap_8
X_4055_ _4055_/X Tile_X0Y2_W2END[0] AXI_M_SOC_AWREADY _4097_/X _4096_/X _1563_/Q _1562_/Q
+ VPWR VGND sg13cmos5l_mux4_1
X_1267_ _1267_/Q Tile_X0Y1_FrameData[6] VGND VPWR Tile_X0Y9_FrameStrobe[2] latch
XFILLER_589_35 VPWR VGND sg13cmos5l_decap_8
XFILLER_432_105 VPWR VGND sg13cmos5l_decap_8
XFILLER_232_76 VPWR VGND sg13cmos5l_decap_8
X_3006_ Tile_X0Y5_E2BEGb[1] _4381_/X VPWR VGND sg13cmos5l_buf_1
X_0218_ _0218_/Q Tile_X0Y7_FrameData[5] VGND VPWR Tile_X0Y9_FrameStrobe[1] latch
X_1198_ _1198_/Q Tile_X0Y1_FrameData[11] VGND VPWR Tile_X0Y9_FrameStrobe[0] latch
XFILLER_586_120 VPWR VGND sg13cmos5l_decap_8
X_0149_ AXI_M_SOC_AWLEN1 _0940_/Q _3672_/X VPWR VGND sg13cmos5l_nor2b_1
XFILLER_196_115 VPWR VGND sg13cmos5l_fill_2
XFILLER_440_182 VPWR VGND sg13cmos5l_fill_1
XFILLER_385_215 VPWR VGND sg13cmos5l_fill_2
XFILLER_458_28 VPWR VGND sg13cmos5l_decap_8
XANTENNA__2751__X Tile_X0Y3_FrameData_O[9] VPWR VGND sg13cmos5l_antennanp
X_3908_ _3908_/X Tile_X0Y1_W1END[1] Tile_X0Y1_WW4END[1] Tile_X0Y1_W6END[9] _4009_/X
+ _1398_/Q _1397_/Q VPWR VGND sg13cmos5l_mux4_1
X_4888_ _4888_/X AXI_M_SOC_RDATA4 _4919_/X _4923_/X _4906_/X _0767_/Q _0766_/Q VPWR
+ VGND sg13cmos5l_mux4_1
X_3839_ _3839_/X _0078_/X Tile_X0Y0_S4END[3] _3876_/X _3875_/X _1027_/Q _1026_/Q VPWR
+ VGND sg13cmos5l_mux4_1
XFILLER_538_83 VPWR VGND sg13cmos5l_decap_8
XFILLER_499_105 VPWR VGND sg13cmos5l_decap_8
XFILLER_353_112 VPWR VGND sg13cmos5l_decap_8
XFILLER_688_216 VPWR VGND sg13cmos5l_fill_2
XFILLER_117_7 VPWR VGND sg13cmos5l_decap_8
XFILLER_257_95 VPWR VGND sg13cmos5l_decap_8
XFILLER_407_21 VPWR VGND sg13cmos5l_decap_8
XFILLER_3_217 VPWR VGND sg13cmos5l_fill_1
XFILLER_105_123 VPWR VGND sg13cmos5l_decap_8
XANTENNA__3582__X Tile_X0Y9_FrameData_O[12] VPWR VGND sg13cmos5l_antennanp
XFILLER_10_77 VPWR VGND sg13cmos5l_decap_8
XFILLER_105_178 VPWR VGND sg13cmos5l_decap_4
XFILLER_126_66 VPWR VGND sg13cmos5l_decap_8
XFILLER_704_63 VPWR VGND sg13cmos5l_decap_8
XFILLER_656_157 VPWR VGND sg13cmos5l_decap_4
XFILLER_656_168 VPWR VGND sg13cmos5l_decap_4
XFILLER_486_7 VPWR VGND sg13cmos5l_decap_8
XFILLER_510_197 VPWR VGND sg13cmos5l_decap_8
XFILLER_259_160 VPWR VGND sg13cmos5l_fill_2
XFILLER_423_42 VPWR VGND sg13cmos5l_decap_8
XFILLER_19_42 VPWR VGND sg13cmos5l_decap_8
XFILLER_570_70 VPWR VGND sg13cmos5l_decap_8
XFILLER_142_21 VPWR VGND sg13cmos5l_decap_8
XFILLER_653_7 VPWR VGND sg13cmos5l_decap_8
XANTENNA__2926__X Tile_X0Y8_E2BEGb[2] VPWR VGND sg13cmos5l_antennanp
XFILLER_423_105 VPWR VGND sg13cmos5l_decap_8
XFILLER_499_35 VPWR VGND sg13cmos5l_decap_8
XFILLER_423_116 VPWR VGND sg13cmos5l_fill_2
XFILLER_27_195 VPWR VGND sg13cmos5l_decap_8
XFILLER_649_49 VPWR VGND sg13cmos5l_decap_8
XFILLER_42_143 VPWR VGND sg13cmos5l_decap_8
XFILLER_431_182 VPWR VGND sg13cmos5l_decap_8
XFILLER_376_215 VPWR VGND sg13cmos5l_fill_2
XFILLER_577_175 VPWR VGND sg13cmos5l_decap_8
XFILLER_368_28 VPWR VGND sg13cmos5l_decap_8
XFILLER_143_0 VPWR VGND sg13cmos5l_decap_8
XANTENNA__3757__X AXI_M_SOC_ARADDR29 VPWR VGND sg13cmos5l_antennanp
XFILLER_592_178 VPWR VGND sg13cmos5l_decap_8
XFILLER_51_62 VPWR VGND sg13cmos5l_decap_8
XFILLER_310_0 VPWR VGND sg13cmos5l_decap_8
XFILLER_679_205 VPWR VGND sg13cmos5l_decap_4
XFILLER_448_94 VPWR VGND sg13cmos5l_decap_8
XFILLER_344_123 VPWR VGND sg13cmos5l_decap_4
XFILLER_329_197 VPWR VGND sg13cmos5l_fill_1
XFILLER_408_0 VPWR VGND sg13cmos5l_decap_8
XFILLER_143_207 VPWR VGND sg13cmos5l_fill_2
XFILLER_317_21 VPWR VGND sg13cmos5l_decap_8
XFILLER_681_14 VPWR VGND sg13cmos5l_decap_8
XANTENNA__3492__X Tile_X0Y1_E6BEG[2] VPWR VGND sg13cmos5l_antennanp
XFILLER_297_211 VPWR VGND sg13cmos5l_fill_1
XFILLER_498_182 VPWR VGND sg13cmos5l_decap_8
XFILLER_183_61 VPWR VGND sg13cmos5l_fill_1
XFILLER_501_175 VPWR VGND sg13cmos5l_decap_8
XFILLER_183_83 VPWR VGND sg13cmos5l_decap_8
XFILLER_647_168 VPWR VGND sg13cmos5l_decap_8
XFILLER_614_63 VPWR VGND sg13cmos5l_decap_8
XFILLER_333_42 VPWR VGND sg13cmos5l_decap_8
XFILLER_662_127 VPWR VGND sg13cmos5l_decap_4
X_2170_ _2170_/Q Tile_X0Y4_FrameData[11] VGND VPWR Tile_X0Y9_FrameStrobe[7] latch
XFILLER_662_138 VPWR VGND sg13cmos5l_decap_4
XFILLER_65_202 VPWR VGND sg13cmos5l_fill_1
XFILLER_76_70 VPWR VGND sg13cmos5l_decap_8
X_1121_ _1121_/Q Tile_X0Y0_FrameData[10] VGND VPWR Tile_X0Y9_FrameStrobe[5] latch
XANTENNA__2836__X Tile_X0Y6_E2BEG[1] VPWR VGND sg13cmos5l_antennanp
XFILLER_265_174 VPWR VGND sg13cmos5l_fill_2
XFILLER_265_185 VPWR VGND sg13cmos5l_fill_1
X_1052_ _1052_/Q Tile_X0Y0_FrameData[15] VGND VPWR Tile_X0Y9_FrameStrobe[3] latch
XFILLER_280_133 VPWR VGND sg13cmos5l_decap_8
XFILLER_630_84 VPWR VGND sg13cmos5l_decap_8
XFILLER_202_35 VPWR VGND sg13cmos5l_decap_8
XFILLER_18_195 VPWR VGND sg13cmos5l_fill_2
XFILLER_280_188 VPWR VGND sg13cmos5l_fill_2
XFILLER_559_49 VPWR VGND sg13cmos5l_decap_8
X_4811_ _4811_/X _4783_/X Tile_X0Y9_N4END[7] _4782_/X _0074_/X _0449_/Q _0448_/Q VPWR
+ VGND sg13cmos5l_mux4_1
XFILLER_717_106 VPWR VGND sg13cmos5l_decap_8
XFILLER_568_175 VPWR VGND sg13cmos5l_decap_8
XFILLER_33_165 VPWR VGND sg13cmos5l_decap_8
XFILLER_278_28 VPWR VGND sg13cmos5l_decap_8
XFILLER_568_197 VPWR VGND sg13cmos5l_decap_4
XANTENNA__3667__X AXI_M_SOC_AWADDR28 VPWR VGND sg13cmos5l_antennanp
X_4742_ _4742_/X Tile_X0Y8_W2END[1] AXI_M_SOC_RDATA9 _4787_/X _4786_/X _0563_/Q _0562_/Q
+ VPWR VGND sg13cmos5l_mux4_1
X_1954_ _1954_/Q Tile_X0Y4_FrameData[3] VGND VPWR Tile_X0Y9_FrameStrobe[0] latch
X_0905_ _0905_/Q Tile_X0Y9_FrameData[22] VGND VPWR Tile_X0Y9_FrameStrobe[7] latch
XFILLER_583_189 VPWR VGND sg13cmos5l_decap_8
X_4673_ _4673_/X _4589_/X _4705_/X _4704_/X _4588_/X _0179_/Q _0178_/Q VPWR VGND sg13cmos5l_mux4_1
X_1885_ _1885_/Q Tile_X0Y3_FrameData[12] VGND VPWR Tile_X0Y9_FrameStrobe[6] latch
XFILLER_186_192 VPWR VGND sg13cmos5l_decap_8
X_3624_ Tile_X0Y9_S4BEG[2] _3624_/A VPWR VGND sg13cmos5l_buf_1
XFILLER_508_42 VPWR VGND sg13cmos5l_decap_8
X_0836_ _0836_/Q Tile_X0Y9_FrameData[27] VGND VPWR Tile_X0Y9_FrameStrobe[5] latch
XFILLER_335_156 VPWR VGND sg13cmos5l_decap_8
XFILLER_294_49 VPWR VGND sg13cmos5l_decap_8
XFILLER_134_207 VPWR VGND sg13cmos5l_fill_2
XFILLER_655_70 VPWR VGND sg13cmos5l_decap_8
XFILLER_508_86 VPWR VGND sg13cmos5l_fill_1
X_3555_ Tile_X0Y9_EE4BEG[1] _4865_/X VPWR VGND sg13cmos5l_buf_1
XFILLER_591_14 VPWR VGND sg13cmos5l_decap_8
XFILLER_350_126 VPWR VGND sg13cmos5l_fill_2
X_0767_ _0767_/Q Tile_X0Y9_FrameData[0] VGND VPWR Tile_X0Y9_FrameStrobe[2] latch
XFILLER_496_119 VPWR VGND sg13cmos5l_decap_8
X_2506_ _2506_/Q Tile_X0Y6_FrameData[29] VGND VPWR Tile_X0Y9_FrameStrobe[2] latch
X_3486_ Tile_X0Y1_EE4BEG[12] _3960_/X VPWR VGND sg13cmos5l_buf_1
XFILLER_227_98 VPWR VGND sg13cmos5l_decap_8
X_0698_ _0698_/Q Tile_X0Y9_FrameData[5] VGND VPWR Tile_X0Y9_FrameStrobe[0] latch
X_2437_ _2437_/Q Tile_X0Y5_FrameData[0] VGND VPWR Tile_X0Y9_FrameStrobe[7] latch
XFILLER_653_105 VPWR VGND sg13cmos5l_decap_8
XFILLER_243_42 VPWR VGND sg13cmos5l_decap_8
X_2368_ _2368_/Q Tile_X0Y5_FrameData[5] VGND VPWR Tile_X0Y9_FrameStrobe[5] latch
XFILLER_390_70 VPWR VGND sg13cmos5l_fill_2
X_4107_ _4107_/X _4093_/X _0057_/X _4092_/X Tile_X0Y0_S4END[10] _1453_/Q _1452_/Q
+ VPWR VGND sg13cmos5l_mux4_1
XANTENNA__2746__X Tile_X0Y3_FrameData_O[4] VPWR VGND sg13cmos5l_antennanp
X_1319_ _1319_/Q Tile_X0Y1_FrameData[18] VGND VPWR Tile_X0Y9_FrameStrobe[4] latch
X_2299_ _2299_/Q Tile_X0Y5_FrameData[10] VGND VPWR Tile_X0Y9_FrameStrobe[3] latch
XFILLER_405_116 VPWR VGND sg13cmos5l_decap_8
XFILLER_540_62 VPWR VGND sg13cmos5l_decap_4
X_4038_ _4038_/X _4093_/X Tile_X0Y2_WW4END[6] _4092_/X AXI_M_SOC_AWREADY _1597_/Q
+ _1596_/Q VPWR VGND sg13cmos5l_mux4_1
XFILLER_112_35 VPWR VGND sg13cmos5l_decap_8
XFILLER_559_120 VPWR VGND sg13cmos5l_decap_8
XFILLER_24_121 VPWR VGND sg13cmos5l_decap_8
XFILLER_72_28 VPWR VGND sg13cmos5l_decap_8
XFILLER_169_115 VPWR VGND sg13cmos5l_decap_8
XFILLER_188_28 VPWR VGND sg13cmos5l_decap_8
XFILLER_574_101 VPWR VGND sg13cmos5l_decap_8
XANTENNA__3577__X Tile_X0Y9_FrameData_O[7] VPWR VGND sg13cmos5l_antennanp
XFILLER_234_7 VPWR VGND sg13cmos5l_decap_8
XFILLER_574_178 VPWR VGND sg13cmos5l_decap_8
XFILLER_227_6 VPWR VGND sg13cmos5l_decap_8
XANTENNA_50 Tile_X0Y0_S2MID[7] VPWR VGND sg13cmos5l_antennanp
XANTENNA_61 Tile_X0Y9_FrameStrobe[12] VPWR VGND sg13cmos5l_antennanp
XANTENNA_72 Tile_X0Y9_N2MID[1] VPWR VGND sg13cmos5l_antennanp
XFILLER_326_134 VPWR VGND sg13cmos5l_decap_8
XANTENNA_83 Tile_X0Y9_N2MID[6] VPWR VGND sg13cmos5l_antennanp
XFILLER_418_42 VPWR VGND sg13cmos5l_decap_8
XFILLER_401_7 VPWR VGND sg13cmos5l_decap_8
XFILLER_21_21 VPWR VGND sg13cmos5l_decap_8
XFILLER_565_70 VPWR VGND sg13cmos5l_decap_8
XFILLER_137_21 VPWR VGND sg13cmos5l_decap_8
XFILLER_326_178 VPWR VGND sg13cmos5l_fill_1
XFILLER_279_200 VPWR VGND sg13cmos5l_fill_2
XFILLER_97_14 VPWR VGND sg13cmos5l_decap_8
XFILLER_21_98 VPWR VGND sg13cmos5l_fill_1
XFILLER_715_62 VPWR VGND sg13cmos5l_decap_8
XFILLER_137_98 VPWR VGND sg13cmos5l_decap_8
XFILLER_97_58 VPWR VGND sg13cmos5l_decap_8
XFILLER_629_146 VPWR VGND sg13cmos5l_fill_1
XFILLER_651_28 VPWR VGND sg13cmos5l_decap_8
XFILLER_434_63 VPWR VGND sg13cmos5l_decap_8
XFILLER_629_168 VPWR VGND sg13cmos5l_decap_8
XFILLER_644_105 VPWR VGND sg13cmos5l_decap_8
XFILLER_153_42 VPWR VGND sg13cmos5l_decap_4
XFILLER_101_192 VPWR VGND sg13cmos5l_decap_8
XFILLER_652_182 VPWR VGND sg13cmos5l_decap_8
XFILLER_600_21 VPWR VGND sg13cmos5l_decap_8
XFILLER_262_155 VPWR VGND sg13cmos5l_decap_8
XFILLER_260_0 VPWR VGND sg13cmos5l_decap_8
XFILLER_262_166 VPWR VGND sg13cmos5l_fill_1
XFILLER_358_0 VPWR VGND sg13cmos5l_decap_8
XFILLER_404_182 VPWR VGND sg13cmos5l_decap_8
XFILLER_676_14 VPWR VGND sg13cmos5l_decap_8
XFILLER_565_112 VPWR VGND sg13cmos5l_decap_8
XANTENNA__3487__X Tile_X0Y1_EE4BEG[13] VPWR VGND sg13cmos5l_antennanp
XFILLER_525_0 VPWR VGND sg13cmos5l_decap_8
XFILLER_62_72 VPWR VGND sg13cmos5l_decap_8
XFILLER_178_50 VPWR VGND sg13cmos5l_fill_1
XFILLER_565_178 VPWR VGND sg13cmos5l_fill_2
XFILLER_178_61 VPWR VGND sg13cmos5l_decap_8
XFILLER_609_63 VPWR VGND sg13cmos5l_decap_8
XFILLER_707_183 VPWR VGND sg13cmos5l_decap_4
XFILLER_328_42 VPWR VGND sg13cmos5l_fill_2
XFILLER_7_56 VPWR VGND sg13cmos5l_decap_8
X_1670_ _1670_/Q Tile_X0Y2_FrameData[11] VGND VPWR Tile_X0Y9_FrameStrobe[7] latch
XFILLER_692_35 VPWR VGND sg13cmos5l_decap_8
XFILLER_475_81 VPWR VGND sg13cmos5l_fill_2
XFILLER_521_204 VPWR VGND sg13cmos5l_fill_1
X_0621_ _0621_/Q Tile_X0Y8_FrameData[18] VGND VPWR Tile_X0Y9_FrameStrobe[6] latch
X_3340_ Tile_X0Y2_FrameData_O[11] Tile_X0Y2_FrameData[11] VPWR VGND sg13cmos5l_buf_1
X_0552_ _0552_/Q Tile_X0Y8_FrameData[23] VGND VPWR Tile_X0Y9_FrameStrobe[4] latch
XFILLER_625_84 VPWR VGND sg13cmos5l_decap_8
XFILLER_561_28 VPWR VGND sg13cmos5l_decap_8
X_3271_ Tile_X0Y0_EE4BEG[7] _3827_/X VPWR VGND sg13cmos5l_buf_1
XFILLER_344_63 VPWR VGND sg13cmos5l_decap_8
X_0483_ _0483_/Q Tile_X0Y8_FrameData[28] VGND VPWR Tile_X0Y9_FrameStrobe[2] latch
XFILLER_635_105 VPWR VGND sg13cmos5l_decap_8
XFILLER_491_91 VPWR VGND sg13cmos5l_decap_8
XFILLER_340_192 VPWR VGND sg13cmos5l_decap_8
X_2222_ _2222_/Q Tile_X0Y5_FrameData[23] VGND VPWR Tile_X0Y9_FrameStrobe[1] latch
X_2153_ _2153_/Q Tile_X0Y4_FrameData[28] VGND VPWR Tile_X0Y9_FrameStrobe[7] latch
XFILLER_650_119 VPWR VGND sg13cmos5l_decap_8
XFILLER_213_56 VPWR VGND sg13cmos5l_decap_8
X_1104_ _1104_/Q Tile_X0Y0_FrameData[27] VGND VPWR Tile_X0Y9_FrameStrobe[5] latch
XFILLER_399_115 VPWR VGND sg13cmos5l_fill_1
XFILLER_643_182 VPWR VGND sg13cmos5l_decap_8
X_2084_ _2084_/Q Tile_X0Y4_FrameData[1] VGND VPWR Tile_X0Y9_FrameStrobe[4] latch
XFILLER_643_193 VPWR VGND sg13cmos5l_fill_2
XFILLER_360_84 VPWR VGND sg13cmos5l_decap_8
XFILLER_510_21 VPWR VGND sg13cmos5l_decap_8
X_1035_ _1035_/Q Tile_X0Y0_FrameData[0] VGND VPWR Tile_X0Y9_FrameStrobe[2] latch
XFILLER_289_49 VPWR VGND sg13cmos5l_decap_8
XFILLER_586_14 VPWR VGND sg13cmos5l_decap_8
XFILLER_556_112 VPWR VGND sg13cmos5l_decap_8
XANTENNA__3397__X Tile_X0Y2_E2BEG[0] VPWR VGND sg13cmos5l_antennanp
XFILLER_166_107 VPWR VGND sg13cmos5l_decap_8
X_2986_ Tile_X0Y8_FrameData_O[26] Tile_X0Y8_FrameData[26] VPWR VGND sg13cmos5l_buf_1
XFILLER_556_167 VPWR VGND sg13cmos5l_fill_2
XFILLER_159_170 VPWR VGND sg13cmos5l_decap_8
X_1937_ _1937_/Q Tile_X0Y4_FrameData[20] VGND VPWR Tile_X0Y9_FrameStrobe[0] latch
X_4725_ _4725_/X _4779_/X _4778_/X AXI_M_SOC_RDATA10 AXI_M_SOC_RDATA14 _0597_/Q _0596_/Q
+ VPWR VGND sg13cmos5l_mux4_1
XFILLER_571_126 VPWR VGND sg13cmos5l_decap_8
XFILLER_519_63 VPWR VGND sg13cmos5l_decap_8
XFILLER_308_112 VPWR VGND sg13cmos5l_decap_8
XFILLER_238_20 VPWR VGND sg13cmos5l_decap_8
X_4656_ _4656_/X _4661_/X Tile_X0Y7_W6END[0] _4660_/X _4656_/A3 _0167_/Q _0166_/Q
+ VPWR VGND sg13cmos5l_mux4_1
XFILLER_107_207 VPWR VGND sg13cmos5l_fill_2
X_1868_ _1868_/Q Tile_X0Y3_FrameData[29] VGND VPWR Tile_X0Y9_FrameStrobe[6] latch
XFILLER_512_204 VPWR VGND sg13cmos5l_decap_8
X_3607_ Tile_X0Y9_S2BEG[1] _4829_/X VPWR VGND sg13cmos5l_buf_1
XFILLER_713_175 VPWR VGND sg13cmos5l_decap_8
X_0819_ _0819_/Q Tile_X0Y9_FrameData[12] VGND VPWR Tile_X0Y9_FrameStrobe[4] latch
X_4587_ _4587_/X Tile_X0Y8_W2MID[6] Tile_X0Y8_W2END[6] Tile_X0Y8_W6END[6] _4787_/X
+ _0661_/Q _0660_/Q VPWR VGND sg13cmos5l_mux4_1
X_1799_ _1799_/Q Tile_X0Y3_FrameData[2] VGND VPWR Tile_X0Y9_FrameStrobe[3] latch
X_3538_ Tile_X0Y9_E2BEGb[4] _4860_/X VPWR VGND sg13cmos5l_buf_1
XFILLER_477_130 VPWR VGND sg13cmos5l_decap_8
XFILLER_535_95 VPWR VGND sg13cmos5l_fill_1
XFILLER_88_124 VPWR VGND sg13cmos5l_decap_4
XFILLER_88_135 VPWR VGND sg13cmos5l_decap_8
XFILLER_471_28 VPWR VGND sg13cmos5l_decap_8
X_3469_ Tile_X0Y1_FrameData_O[27] Tile_X0Y1_FrameData[27] VPWR VGND sg13cmos5l_buf_1
XFILLER_67_17 VPWR VGND sg13cmos5l_decap_8
XFILLER_626_105 VPWR VGND sg13cmos5l_decap_8
XFILLER_492_133 VPWR VGND sg13cmos5l_decap_8
XFILLER_291_217 VPWR VGND sg13cmos5l_fill_1
XFILLER_404_77 VPWR VGND sg13cmos5l_fill_1
XFILLER_184_7 VPWR VGND sg13cmos5l_decap_8
XFILLER_641_119 VPWR VGND sg13cmos5l_decap_8
XFILLER_404_99 VPWR VGND sg13cmos5l_decap_8
XFILLER_433_211 VPWR VGND sg13cmos5l_fill_1
XFILLER_701_42 VPWR VGND sg13cmos5l_decap_8
XFILLER_579_215 VPWR VGND sg13cmos5l_fill_2
XFILLER_244_133 VPWR VGND sg13cmos5l_decap_8
XFILLER_270_84 VPWR VGND sg13cmos5l_decap_8
XFILLER_123_78 VPWR VGND sg13cmos5l_fill_1
XFILLER_44_216 VPWR VGND sg13cmos5l_fill_2
XFILLER_420_21 VPWR VGND sg13cmos5l_decap_8
XFILLER_351_7 VPWR VGND sg13cmos5l_decap_8
XFILLER_16_21 VPWR VGND sg13cmos5l_decap_8
XFILLER_449_7 VPWR VGND sg13cmos5l_decap_8
XFILLER_199_49 VPWR VGND sg13cmos5l_decap_8
XFILLER_496_14 VPWR VGND sg13cmos5l_decap_8
XFILLER_420_98 VPWR VGND sg13cmos5l_decap_4
XFILLER_401_130 VPWR VGND sg13cmos5l_decap_8
XFILLER_16_98 VPWR VGND sg13cmos5l_fill_2
XFILLER_616_7 VPWR VGND sg13cmos5l_decap_8
XFILLER_547_167 VPWR VGND sg13cmos5l_decap_4
XANTENNA__3100__X Tile_X0Y7_E2BEGb[6] VPWR VGND sg13cmos5l_antennanp
XFILLER_401_196 VPWR VGND sg13cmos5l_decap_8
XFILLER_32_20 VPWR VGND sg13cmos5l_decap_8
XFILLER_646_28 VPWR VGND sg13cmos5l_decap_8
XFILLER_429_63 VPWR VGND sg13cmos5l_decap_8
XFILLER_576_91 VPWR VGND sg13cmos5l_decap_8
XFILLER_32_75 VPWR VGND sg13cmos5l_decap_8
XFILLER_148_42 VPWR VGND sg13cmos5l_decap_8
XFILLER_120_2 VPWR VGND sg13cmos5l_fill_1
XFILLER_295_70 VPWR VGND sg13cmos5l_decap_8
XFILLER_314_104 VPWR VGND sg13cmos5l_decap_4
XFILLER_314_126 VPWR VGND sg13cmos5l_fill_1
XFILLER_180_121 VPWR VGND sg13cmos5l_decap_8
XFILLER_106_0 VPWR VGND sg13cmos5l_decap_8
XFILLER_662_49 VPWR VGND sg13cmos5l_decap_8
XFILLER_468_130 VPWR VGND sg13cmos5l_decap_8
XFILLER_79_113 VPWR VGND sg13cmos5l_decap_8
XFILLER_381_28 VPWR VGND sg13cmos5l_decap_8
XFILLER_617_105 VPWR VGND sg13cmos5l_decap_8
XFILLER_461_50 VPWR VGND sg13cmos5l_decap_4
XFILLER_57_50 VPWR VGND sg13cmos5l_fill_1
XFILLER_475_0 VPWR VGND sg13cmos5l_decap_8
XFILLER_461_72 VPWR VGND sg13cmos5l_fill_1
XFILLER_282_217 VPWR VGND sg13cmos5l_fill_1
XFILLER_632_119 VPWR VGND sg13cmos5l_decap_4
XFILLER_611_42 VPWR VGND sg13cmos5l_decap_8
XFILLER_235_122 VPWR VGND sg13cmos5l_decap_4
XFILLER_642_0 VPWR VGND sg13cmos5l_decap_8
XFILLER_330_21 VPWR VGND sg13cmos5l_decap_8
XFILLER_235_155 VPWR VGND sg13cmos5l_decap_8
XFILLER_687_35 VPWR VGND sg13cmos5l_decap_8
XFILLER_50_208 VPWR VGND sg13cmos5l_fill_1
XFILLER_330_76 VPWR VGND sg13cmos5l_decap_8
X_2840_ Tile_X0Y6_E2BEG[5] _4501_/X VPWR VGND sg13cmos5l_buf_1
XFILLER_538_156 VPWR VGND sg13cmos5l_decap_8
XANTENNA__3010__X Tile_X0Y5_E2BEGb[5] VPWR VGND sg13cmos5l_antennanp
XFILLER_556_28 VPWR VGND sg13cmos5l_decap_8
X_2771_ Tile_X0Y3_FrameData_O[29] Tile_X0Y3_FrameData[29] VPWR VGND sg13cmos5l_buf_1
XFILLER_339_63 VPWR VGND sg13cmos5l_decap_8
X_4510_ _4510_/X Tile_X0Y6_W2END[1] AXI_M_SOC_RDATA25 _4555_/X _4554_/X _2587_/Q _2586_/Q
+ VPWR VGND sg13cmos5l_mux4_1
XFILLER_486_91 VPWR VGND sg13cmos5l_decap_8
XFILLER_156_140 VPWR VGND sg13cmos5l_decap_8
X_1722_ _1722_/Q Tile_X0Y3_FrameData[15] VGND VPWR Tile_X0Y9_FrameStrobe[1] latch
XFILLER_171_110 VPWR VGND sg13cmos5l_decap_8
X_4441_ _4441_/X Tile_X0Y9_W1END[1] Tile_X0Y9_WW4END[1] Tile_X0Y9_W6END[9] _4917_/X
+ _0900_/Q _0899_/Q VPWR VGND sg13cmos5l_mux4_1
X_1653_ _1653_/Q Tile_X0Y2_FrameData[28] VGND VPWR Tile_X0Y9_FrameStrobe[7] latch
XFILLER_305_126 VPWR VGND sg13cmos5l_decap_8
XFILLER_710_112 VPWR VGND sg13cmos5l_decap_8
XFILLER_208_34 VPWR VGND sg13cmos5l_decap_8
X_0604_ _0604_/Q Tile_X0Y8_FrameData[3] VGND VPWR Tile_X0Y9_FrameStrobe[5] latch
X_4372_ _4372_/X Tile_X0Y5_W2MID[7] AXI_M_SOC_RVALID _4467_/X _4428_/X _2359_/Q _2358_/Q
+ VPWR VGND sg13cmos5l_mux4_1
X_1584_ _1584_/Q Tile_X0Y2_FrameData[1] VGND VPWR Tile_X0Y9_FrameStrobe[4] latch
XFILLER_572_49 VPWR VGND sg13cmos5l_decap_8
XFILLER_355_84 VPWR VGND sg13cmos5l_decap_8
XFILLER_320_107 VPWR VGND sg13cmos5l_fill_1
XFILLER_505_21 VPWR VGND sg13cmos5l_decap_8
XFILLER_171_187 VPWR VGND sg13cmos5l_decap_8
X_3323_ Tile_X0Y4_EE4BEG[11] _4283_/X VPWR VGND sg13cmos5l_buf_1
XFILLER_291_28 VPWR VGND sg13cmos5l_decap_8
X_0535_ _0535_/Q Tile_X0Y8_FrameData[8] VGND VPWR Tile_X0Y9_FrameStrobe[3] latch
XFILLER_459_163 VPWR VGND sg13cmos5l_fill_1
XFILLER_459_185 VPWR VGND sg13cmos5l_decap_8
XFILLER_608_127 VPWR VGND sg13cmos5l_fill_2
XFILLER_85_105 VPWR VGND sg13cmos5l_decap_8
X_3254_ Tile_X0Y0_FrameData_O[22] Tile_X0Y0_FrameData[22] VPWR VGND sg13cmos5l_buf_1
XFILLER_608_138 VPWR VGND sg13cmos5l_fill_1
X_0466_ _0466_/Q Tile_X0Y8_FrameData[13] VGND VPWR Tile_X0Y9_FrameStrobe[1] latch
XFILLER_21_0 VPWR VGND sg13cmos5l_decap_8
XFILLER_224_55 VPWR VGND sg13cmos5l_fill_1
X_2205_ _2205_/Q Tile_X0Y5_FrameData[8] VGND VPWR Tile_X0Y9_FrameStrobe[0] latch
X_3185_ Tile_X0Y0_N4BEG[9] _3185_/A VPWR VGND sg13cmos5l_buf_1
XFILLER_623_119 VPWR VGND sg13cmos5l_fill_2
XFILLER_224_88 VPWR VGND sg13cmos5l_fill_1
X_0397_ _0397_/Q Tile_X0Y7_FrameData[18] VGND VPWR Tile_X0Y9_FrameStrobe[7] latch
XFILLER_474_199 VPWR VGND sg13cmos5l_decap_8
XFILLER_415_211 VPWR VGND sg13cmos5l_fill_1
XFILLER_521_42 VPWR VGND sg13cmos5l_decap_8
X_2136_ _2136_/Q Tile_X0Y4_FrameData[13] VGND VPWR Tile_X0Y9_FrameStrobe[6] latch
XFILLER_240_21 VPWR VGND sg13cmos5l_decap_8
X_2067_ _2067_/Q Tile_X0Y4_FrameData[18] VGND VPWR Tile_X0Y9_FrameStrobe[4] latch
XFILLER_597_35 VPWR VGND sg13cmos5l_decap_8
XFILLER_241_136 VPWR VGND sg13cmos5l_decap_8
XFILLER_240_76 VPWR VGND sg13cmos5l_fill_2
XFILLER_597_46 VPWR VGND sg13cmos5l_fill_2
XFILLER_387_129 VPWR VGND sg13cmos5l_decap_8
X_1018_ _1018_/Q Tile_X0Y0_FrameData[17] VGND VPWR Tile_X0Y9_FrameStrobe[2] latch
XFILLER_529_112 VPWR VGND sg13cmos5l_decap_8
XFILLER_529_156 VPWR VGND sg13cmos5l_decap_8
XFILLER_395_151 VPWR VGND sg13cmos5l_decap_8
XFILLER_544_104 VPWR VGND sg13cmos5l_fill_1
XFILLER_466_28 VPWR VGND sg13cmos5l_decap_8
X_2969_ Tile_X0Y8_FrameData_O[9] Tile_X0Y8_FrameData[9] VPWR VGND sg13cmos5l_buf_1
XFILLER_249_96 VPWR VGND sg13cmos5l_decap_8
XFILLER_147_140 VPWR VGND sg13cmos5l_fill_2
X_4708_ _4708_/X Tile_X0Y6_W1END[0] Tile_X0Y6_W2MID[3] Tile_X0Y6_W2END[3] _4558_/X
+ _2643_/Q _2642_/Q VPWR VGND sg13cmos5l_mux4_1
XFILLER_698_130 VPWR VGND sg13cmos5l_decap_8
XFILLER_147_173 VPWR VGND sg13cmos5l_fill_1
X_4639_ _4639_/X Tile_X0Y7_WW4END[4] AXI_M_SOC_RDATA20 _4688_/X _4674_/X _0281_/Q
+ _0280_/Q VPWR VGND sg13cmos5l_mux4_1
XFILLER_701_112 VPWR VGND sg13cmos5l_decap_8
XFILLER_118_56 VPWR VGND sg13cmos5l_decap_8
XFILLER_482_49 VPWR VGND sg13cmos5l_decap_8
XFILLER_701_167 VPWR VGND sg13cmos5l_decap_8
XFILLER_500_207 VPWR VGND sg13cmos5l_fill_2
XFILLER_415_21 VPWR VGND sg13cmos5l_decap_8
XFILLER_654_200 VPWR VGND sg13cmos5l_decap_8
XFILLER_399_7 VPWR VGND sg13cmos5l_decap_8
XANTENNA__3590__X Tile_X0Y9_FrameData_O[20] VPWR VGND sg13cmos5l_antennanp
XFILLER_76_105 VPWR VGND sg13cmos5l_decap_8
XFILLER_465_133 VPWR VGND sg13cmos5l_decap_8
XFILLER_415_98 VPWR VGND sg13cmos5l_fill_2
XFILLER_264_217 VPWR VGND sg13cmos5l_fill_1
XFILLER_134_77 VPWR VGND sg13cmos5l_decap_8
XFILLER_712_63 VPWR VGND sg13cmos5l_decap_8
XFILLER_69_190 VPWR VGND sg13cmos5l_decap_8
XFILLER_566_7 VPWR VGND sg13cmos5l_decap_8
XFILLER_217_111 VPWR VGND sg13cmos5l_decap_8
XFILLER_480_136 VPWR VGND sg13cmos5l_fill_1
XFILLER_431_42 VPWR VGND sg13cmos5l_decap_8
XFILLER_607_193 VPWR VGND sg13cmos5l_decap_4
XFILLER_27_42 VPWR VGND sg13cmos5l_decap_8
XFILLER_150_21 VPWR VGND sg13cmos5l_decap_8
XANTENNA__2934__X Tile_X0Y8_E6BEG[2] VPWR VGND sg13cmos5l_antennanp
XFILLER_43_41 VPWR VGND sg13cmos5l_decap_8
XFILLER_657_49 VPWR VGND sg13cmos5l_decap_8
XFILLER_240_191 VPWR VGND sg13cmos5l_fill_1
XFILLER_590_210 VPWR VGND sg13cmos5l_fill_1
XFILLER_223_0 VPWR VGND sg13cmos5l_decap_8
XFILLER_159_96 VPWR VGND sg13cmos5l_decap_4
XFILLER_138_140 VPWR VGND sg13cmos5l_decap_8
XFILLER_138_162 VPWR VGND sg13cmos5l_decap_8
XFILLER_550_129 VPWR VGND sg13cmos5l_fill_1
XFILLER_488_203 VPWR VGND sg13cmos5l_fill_2
XFILLER_543_181 VPWR VGND sg13cmos5l_fill_1
XFILLER_153_143 VPWR VGND sg13cmos5l_decap_8
XFILLER_99_208 VPWR VGND sg13cmos5l_fill_1
XFILLER_606_42 VPWR VGND sg13cmos5l_decap_8
XFILLER_392_49 VPWR VGND sg13cmos5l_decap_8
XFILLER_606_64 VPWR VGND sg13cmos5l_fill_1
XFILLER_592_0 VPWR VGND sg13cmos5l_decap_8
XFILLER_325_21 VPWR VGND sg13cmos5l_decap_8
XFILLER_175_95 VPWR VGND sg13cmos5l_decap_8
XFILLER_606_86 VPWR VGND sg13cmos5l_decap_4
XFILLER_4_35 VPWR VGND sg13cmos5l_decap_8
XFILLER_302_129 VPWR VGND sg13cmos5l_decap_4
XFILLER_153_198 VPWR VGND sg13cmos5l_decap_8
X_0320_ _0320_/Q Tile_X0Y7_FrameData[31] VGND VPWR Tile_X0Y9_FrameStrobe[5] latch
XFILLER_68_71 VPWR VGND sg13cmos5l_decap_8
XFILLER_456_133 VPWR VGND sg13cmos5l_decap_8
XFILLER_325_98 VPWR VGND sg13cmos5l_decap_8
XFILLER_310_162 VPWR VGND sg13cmos5l_decap_8
XFILLER_255_217 VPWR VGND sg13cmos5l_fill_1
X_0251_ _0251_/Q Tile_X0Y7_FrameData[4] VGND VPWR Tile_X0Y9_FrameStrobe[2] latch
XFILLER_622_63 VPWR VGND sg13cmos5l_decap_8
XFILLER_456_188 VPWR VGND sg13cmos5l_decap_8
XFILLER_208_111 VPWR VGND sg13cmos5l_decap_8
XANTENNA__3005__X Tile_X0Y5_E2BEGb[0] VPWR VGND sg13cmos5l_antennanp
XFILLER_341_42 VPWR VGND sg13cmos5l_decap_8
XFILLER_471_147 VPWR VGND sg13cmos5l_decap_8
X_0182_ _0182_/Q Tile_X0Y7_FrameData[9] VGND VPWR Tile_X0Y9_FrameStrobe[0] latch
XFILLER_613_130 VPWR VGND sg13cmos5l_decap_4
XFILLER_75_182 VPWR VGND sg13cmos5l_fill_1
XFILLER_613_141 VPWR VGND sg13cmos5l_decap_8
XFILLER_84_70 VPWR VGND sg13cmos5l_fill_1
XFILLER_698_56 VPWR VGND sg13cmos5l_decap_8
XANTENNA__2844__X Tile_X0Y6_E2BEGb[1] VPWR VGND sg13cmos5l_antennanp
XFILLER_90_141 VPWR VGND sg13cmos5l_decap_8
XFILLER_613_196 VPWR VGND sg13cmos5l_fill_2
XFILLER_210_13 VPWR VGND sg13cmos5l_decap_8
X_3941_ _3941_/X Tile_X0Y1_W2END[6] AXI_M_SOC_ARREADY _3991_/X _3990_/X _1327_/Q _1326_/Q
+ VPWR VGND sg13cmos5l_mux4_1
XFILLER_90_196 VPWR VGND sg13cmos5l_decap_8
X_3872_ _3872_/X _3849_/X _0086_/X Tile_X0Y0_S1END[1] Tile_X0Y0_S4END[1] _0977_/Q
+ _0976_/Q VPWR VGND sg13cmos5l_mux4_1
XFILLER_567_49 VPWR VGND sg13cmos5l_decap_8
X_2823_ Tile_X0Y4_E2BEG[1] _4257_/X VPWR VGND sg13cmos5l_buf_1
XFILLER_581_210 VPWR VGND sg13cmos5l_decap_8
XFILLER_286_28 VPWR VGND sg13cmos5l_decap_8
XFILLER_526_148 VPWR VGND sg13cmos5l_decap_8
X_2754_ Tile_X0Y3_FrameData_O[12] Tile_X0Y3_FrameData[12] VPWR VGND sg13cmos5l_buf_1
XFILLER_219_55 VPWR VGND sg13cmos5l_decap_4
XFILLER_69_0 VPWR VGND sg13cmos5l_fill_2
X_1705_ _1705_/Q Tile_X0Y3_FrameData[0] VGND VPWR Tile_X0Y9_FrameStrobe[0] latch
XFILLER_333_210 VPWR VGND sg13cmos5l_fill_2
X_2685_ _2685_/Q Tile_X0Y6_FrameData[10] VGND VPWR Tile_X0Y9_FrameStrobe[7] latch
XFILLER_534_181 VPWR VGND sg13cmos5l_decap_4
XFILLER_219_88 VPWR VGND sg13cmos5l_decap_4
X_4424_ _4424_/X Tile_X0Y6_W1END[2] Tile_X0Y6_W6END[6] _4582_/X _4542_/X _2691_/Q
+ _2690_/Q VPWR VGND sg13cmos5l_mux4_1
XFILLER_516_42 VPWR VGND sg13cmos5l_decap_8
X_1636_ _1636_/Q Tile_X0Y2_FrameData[13] VGND VPWR Tile_X0Y9_FrameStrobe[6] latch
XFILLER_144_176 VPWR VGND sg13cmos5l_decap_8
XFILLER_663_70 VPWR VGND sg13cmos5l_decap_8
XFILLER_235_21 VPWR VGND sg13cmos5l_decap_4
X_4355_ _4355_/X Tile_X0Y6_W2MID[6] Tile_X0Y6_W2END[6] Tile_X0Y6_W6END[6] _4555_/X
+ _2685_/Q _2684_/Q VPWR VGND sg13cmos5l_mux4_1
X_1567_ _1567_/Q Tile_X0Y2_FrameData[18] VGND VPWR Tile_X0Y9_FrameStrobe[4] latch
XFILLER_235_54 VPWR VGND sg13cmos5l_decap_8
X_3306_ Tile_X0Y0_E2BEG[6] _3810_/X VPWR VGND sg13cmos5l_buf_1
X_0518_ _0518_/Q Tile_X0Y8_FrameData[25] VGND VPWR Tile_X0Y9_FrameStrobe[3] latch
XFILLER_301_151 VPWR VGND sg13cmos5l_decap_4
X_4286_ _4286_/X Tile_X0Y4_WW4END[1] AXI_M_SOC_BRESP1 _4337_/X _4315_/X _2041_/Q _2040_/Q
+ VPWR VGND sg13cmos5l_mux4_1
X_1498_ _1498_/Q Tile_X0Y2_FrameData[23] VGND VPWR Tile_X0Y9_FrameStrobe[2] latch
XFILLER_246_206 VPWR VGND sg13cmos5l_decap_4
XFILLER_246_217 VPWR VGND sg13cmos5l_fill_1
X_3237_ Tile_X0Y0_FrameData_O[5] Tile_X0Y0_FrameData[5] VPWR VGND sg13cmos5l_buf_1
XFILLER_651_203 VPWR VGND sg13cmos5l_decap_8
XFILLER_532_63 VPWR VGND sg13cmos5l_decap_8
X_0449_ _0449_/Q Tile_X0Y8_FrameData[30] VGND VPWR Tile_X0Y9_FrameStrobe[1] latch
XFILLER_251_20 VPWR VGND sg13cmos5l_decap_8
XFILLER_251_31 VPWR VGND sg13cmos5l_fill_2
XFILLER_104_47 VPWR VGND sg13cmos5l_decap_8
X_3168_ Tile_X0Y4_E6BEG[5] _4293_/X VPWR VGND sg13cmos5l_buf_1
XFILLER_462_158 VPWR VGND sg13cmos5l_decap_8
XFILLER_66_182 VPWR VGND sg13cmos5l_decap_8
XANTENNA__2754__X Tile_X0Y3_FrameData_O[12] VPWR VGND sg13cmos5l_antennanp
X_2119_ _2119_/Q Tile_X0Y4_FrameData[30] VGND VPWR Tile_X0Y9_FrameStrobe[6] latch
XFILLER_604_152 VPWR VGND sg13cmos5l_decap_8
X_3099_ Tile_X0Y7_E2BEGb[5] _4625_/X VPWR VGND sg13cmos5l_buf_1
XFILLER_81_163 VPWR VGND sg13cmos5l_decap_8
XFILLER_401_56 VPWR VGND sg13cmos5l_decap_4
XFILLER_120_13 VPWR VGND sg13cmos5l_decap_8
XFILLER_477_49 VPWR VGND sg13cmos5l_decap_4
XFILLER_147_7 VPWR VGND sg13cmos5l_decap_8
XFILLER_368_184 VPWR VGND sg13cmos5l_decap_8
XANTENNA__3585__X Tile_X0Y9_FrameData_O[15] VPWR VGND sg13cmos5l_antennanp
XFILLER_314_7 VPWR VGND sg13cmos5l_decap_8
XFILLER_13_77 VPWR VGND sg13cmos5l_decap_8
XFILLER_532_107 VPWR VGND sg13cmos5l_decap_8
XFILLER_383_187 VPWR VGND sg13cmos5l_fill_2
XFILLER_707_63 VPWR VGND sg13cmos5l_decap_8
XFILLER_135_154 VPWR VGND sg13cmos5l_decap_4
XFILLER_426_42 VPWR VGND sg13cmos5l_decap_8
XFILLER_573_70 VPWR VGND sg13cmos5l_decap_8
XFILLER_145_21 VPWR VGND sg13cmos5l_decap_8
XFILLER_485_206 VPWR VGND sg13cmos5l_fill_2
XFILLER_683_7 VPWR VGND sg13cmos5l_decap_8
XFILLER_150_146 VPWR VGND sg13cmos5l_decap_8
XANTENNA__2929__X Tile_X0Y8_E2BEGb[5] VPWR VGND sg13cmos5l_antennanp
XFILLER_289_180 VPWR VGND sg13cmos5l_decap_8
XFILLER_1_167 VPWR VGND sg13cmos5l_decap_4
XFILLER_442_63 VPWR VGND sg13cmos5l_decap_8
XFILLER_57_182 VPWR VGND sg13cmos5l_fill_2
XFILLER_311_67 VPWR VGND sg13cmos5l_decap_8
XFILLER_205_147 VPWR VGND sg13cmos5l_decap_8
XFILLER_72_174 VPWR VGND sg13cmos5l_decap_8
XFILLER_54_51 VPWR VGND sg13cmos5l_decap_8
XFILLER_311_89 VPWR VGND sg13cmos5l_decap_8
XFILLER_340_0 VPWR VGND sg13cmos5l_decap_8
XFILLER_438_0 VPWR VGND sg13cmos5l_decap_8
XFILLER_359_140 VPWR VGND sg13cmos5l_decap_4
XFILLER_684_14 VPWR VGND sg13cmos5l_decap_8
XFILLER_374_132 VPWR VGND sg13cmos5l_decap_8
XANTENNA__3495__X Tile_X0Y1_E6BEG[5] VPWR VGND sg13cmos5l_antennanp
XFILLER_605_0 VPWR VGND sg13cmos5l_decap_8
XFILLER_173_216 VPWR VGND sg13cmos5l_fill_2
XFILLER_617_63 VPWR VGND sg13cmos5l_decap_8
XFILLER_126_143 VPWR VGND sg13cmos5l_decap_8
XFILLER_126_154 VPWR VGND sg13cmos5l_fill_1
XFILLER_55_6 VPWR VGND sg13cmos5l_decap_8
XFILLER_336_42 VPWR VGND sg13cmos5l_decap_8
X_2470_ _2470_/Q Tile_X0Y6_FrameData[1] VGND VPWR Tile_X0Y9_FrameStrobe[0] latch
XFILLER_126_176 VPWR VGND sg13cmos5l_decap_4
XFILLER_677_144 VPWR VGND sg13cmos5l_decap_8
XFILLER_677_155 VPWR VGND sg13cmos5l_decap_4
XFILLER_336_75 VPWR VGND sg13cmos5l_decap_4
XFILLER_476_206 VPWR VGND sg13cmos5l_decap_4
XFILLER_336_86 VPWR VGND sg13cmos5l_decap_8
X_1421_ _1421_/Q Tile_X0Y1_FrameData[12] VGND VPWR Tile_X0Y9_FrameStrobe[7] latch
XANTENNA__2839__X Tile_X0Y6_E2BEG[4] VPWR VGND sg13cmos5l_antennanp
XFILLER_677_177 VPWR VGND sg13cmos5l_fill_1
XFILLER_692_125 VPWR VGND sg13cmos5l_fill_1
X_4140_ _4140_/X Tile_X0Y1_W1END[2] Tile_X0Y1_W2MID[1] Tile_X0Y1_W2END[1] _3990_/X
+ _1369_/Q _1368_/Q VPWR VGND sg13cmos5l_mux4_1
X_1352_ _1352_/Q Tile_X0Y1_FrameData[17] VGND VPWR Tile_X0Y9_FrameStrobe[5] latch
XFILLER_692_147 VPWR VGND sg13cmos5l_fill_2
XFILLER_633_84 VPWR VGND sg13cmos5l_decap_8
XFILLER_205_35 VPWR VGND sg13cmos5l_decap_8
XFILLER_295_161 VPWR VGND sg13cmos5l_decap_4
X_0303_ _0303_/Q Tile_X0Y7_FrameData[16] VGND VPWR Tile_X0Y9_FrameStrobe[4] latch
X_4071_ _4071_/X Tile_X0Y2_WW4END[0] AXI_M_SOC_AWREADY _4116_/X _4097_/X _1531_/Q
+ _1530_/Q VPWR VGND sg13cmos5l_mux4_1
XFILLER_352_63 VPWR VGND sg13cmos5l_decap_8
X_1283_ _1283_/Q Tile_X0Y1_FrameData[22] VGND VPWR Tile_X0Y9_FrameStrobe[3] latch
XFILLER_444_136 VPWR VGND sg13cmos5l_fill_2
X_3022_ Tile_X0Y5_E6BEG[9] _4413_/X VPWR VGND sg13cmos5l_buf_1
XFILLER_95_91 VPWR VGND sg13cmos5l_decap_8
X_0234_ _0234_/Q Tile_X0Y7_FrameData[21] VGND VPWR Tile_X0Y9_FrameStrobe[2] latch
XFILLER_48_160 VPWR VGND sg13cmos5l_decap_8
XFILLER_48_182 VPWR VGND sg13cmos5l_decap_8
XFILLER_48_193 VPWR VGND sg13cmos5l_fill_2
XFILLER_63_130 VPWR VGND sg13cmos5l_decap_8
XFILLER_502_77 VPWR VGND sg13cmos5l_decap_8
X_0165_ _0165_/Q Tile_X0Y7_FrameData[26] VGND VPWR Tile_X0Y9_FrameStrobe[0] latch
X_0096_ _0096_/X _4000_/X _4001_/X _2410_/Q VPWR VGND sg13cmos5l_mux2_1
XFILLER_601_144 VPWR VGND sg13cmos5l_decap_8
XFILLER_400_206 VPWR VGND sg13cmos5l_fill_2
XFILLER_400_217 VPWR VGND sg13cmos5l_fill_1
X_3924_ _3924_/X Tile_X0Y3_W1END[1] Tile_X0Y3_WW4END[1] Tile_X0Y3_W6END[9] _4223_/X
+ _1898_/Q _1897_/Q VPWR VGND sg13cmos5l_mux4_1
XFILLER_297_49 VPWR VGND sg13cmos5l_decap_8
XFILLER_365_110 VPWR VGND sg13cmos5l_decap_8
XFILLER_594_14 VPWR VGND sg13cmos5l_decap_8
X_3855_ _3855_/X _3891_/X _3890_/X Tile_X0Y0_S2MID[1] Tile_X0Y0_S2END[1] _0961_/Q
+ _0960_/Q VPWR VGND sg13cmos5l_mux4_1
XFILLER_377_60 VPWR VGND sg13cmos5l_fill_1
X_2806_ Tile_X0Y3_E2BEGb[4] _4160_/X VPWR VGND sg13cmos5l_buf_1
XFILLER_594_58 VPWR VGND sg13cmos5l_fill_1
X_3786_ _3786_/X Tile_X0Y0_W2MID[5] Tile_X0Y0_W2END[5] Tile_X0Y0_W6END[5] _3857_/X
+ _1165_/Q _1164_/Q VPWR VGND sg13cmos5l_mux4_1
X_0998_ _0998_/Q Tile_X0Y0_FrameData[5] VGND VPWR Tile_X0Y9_FrameStrobe[1] latch
XFILLER_507_170 VPWR VGND sg13cmos5l_fill_1
X_2737_ Tile_X0Y4_E1BEG[0] _4252_/X VPWR VGND sg13cmos5l_buf_1
XFILLER_674_91 VPWR VGND sg13cmos5l_decap_4
XFILLER_117_154 VPWR VGND sg13cmos5l_decap_8
XFILLER_522_140 VPWR VGND sg13cmos5l_decap_8
XFILLER_246_42 VPWR VGND sg13cmos5l_decap_8
XFILLER_246_53 VPWR VGND sg13cmos5l_fill_1
X_2668_ _2668_/Q Tile_X0Y6_FrameData[27] VGND VPWR Tile_X0Y9_FrameStrobe[7] latch
XFILLER_668_144 VPWR VGND sg13cmos5l_fill_2
XFILLER_393_81 VPWR VGND sg13cmos5l_fill_2
XFILLER_467_217 VPWR VGND sg13cmos5l_fill_1
XANTENNA__2749__X Tile_X0Y3_FrameData_O[7] VPWR VGND sg13cmos5l_antennanp
X_1619_ _1619_/Q Tile_X0Y2_FrameData[30] VGND VPWR Tile_X0Y9_FrameStrobe[6] latch
X_4407_ _4407_/X _0097_/X _0156_/X _4459_/X _4463_/X _2289_/Q _2288_/Q VPWR VGND sg13cmos5l_mux4_1
XFILLER_668_177 VPWR VGND sg13cmos5l_decap_8
XFILLER_278_139 VPWR VGND sg13cmos5l_decap_8
X_2599_ _2599_/Q Tile_X0Y6_FrameData[0] VGND VPWR Tile_X0Y9_FrameStrobe[4] latch
X_4338_ _4338_/X _4308_/X _0160_/X _4307_/X _0110_/X _1977_/Q _1976_/Q VPWR VGND sg13cmos5l_mux4_1
XFILLER_690_90 VPWR VGND sg13cmos5l_fill_2
XFILLER_115_35 VPWR VGND sg13cmos5l_decap_8
XFILLER_219_217 VPWR VGND sg13cmos5l_fill_1
XFILLER_262_63 VPWR VGND sg13cmos5l_fill_1
X_4269_ _4269_/X Tile_X0Y4_W2END[2] AXI_M_SOC_BRESP0 _4317_/X _4316_/X _2075_/Q _2074_/Q
+ VPWR VGND sg13cmos5l_mux4_1
XFILLER_286_183 VPWR VGND sg13cmos5l_decap_8
XFILLER_115_79 VPWR VGND sg13cmos5l_fill_1
XFILLER_262_85 VPWR VGND sg13cmos5l_decap_4
XFILLER_46_119 VPWR VGND sg13cmos5l_decap_8
XFILLER_39_160 VPWR VGND sg13cmos5l_decap_4
XFILLER_412_77 VPWR VGND sg13cmos5l_decap_8
XFILLER_264_7 VPWR VGND sg13cmos5l_decap_8
XFILLER_131_34 VPWR VGND sg13cmos5l_decap_8
XFILLER_54_174 VPWR VGND sg13cmos5l_decap_4
XFILLER_431_7 VPWR VGND sg13cmos5l_decap_8
XFILLER_24_21 VPWR VGND sg13cmos5l_decap_8
XFILLER_529_7 VPWR VGND sg13cmos5l_decap_8
XFILLER_568_70 VPWR VGND sg13cmos5l_decap_8
XFILLER_356_154 VPWR VGND sg13cmos5l_decap_8
XFILLER_210_172 VPWR VGND sg13cmos5l_decap_8
XFILLER_6_215 VPWR VGND sg13cmos5l_fill_2
XFILLER_560_202 VPWR VGND sg13cmos5l_fill_2
XFILLER_505_118 VPWR VGND sg13cmos5l_decap_8
XFILLER_108_110 VPWR VGND sg13cmos5l_fill_2
XFILLER_505_129 VPWR VGND sg13cmos5l_fill_1
XFILLER_654_28 VPWR VGND sg13cmos5l_decap_8
XFILLER_437_63 VPWR VGND sg13cmos5l_decap_8
XFILLER_584_91 VPWR VGND sg13cmos5l_decap_4
XFILLER_659_144 VPWR VGND sg13cmos5l_decap_8
XFILLER_659_166 VPWR VGND sg13cmos5l_decap_4
XFILLER_156_86 VPWR VGND sg13cmos5l_decap_4
XFILLER_269_128 VPWR VGND sg13cmos5l_decap_8
XFILLER_156_97 VPWR VGND sg13cmos5l_fill_2
XFILLER_306_56 VPWR VGND sg13cmos5l_decap_8
XFILLER_453_62 VPWR VGND sg13cmos5l_decap_8
XFILLER_670_49 VPWR VGND sg13cmos5l_decap_8
XFILLER_277_150 VPWR VGND sg13cmos5l_decap_8
XFILLER_603_21 VPWR VGND sg13cmos5l_decap_8
XFILLER_290_0 VPWR VGND sg13cmos5l_decap_8
XFILLER_388_0 VPWR VGND sg13cmos5l_decap_8
XFILLER_1_14 VPWR VGND sg13cmos5l_decap_8
XFILLER_603_76 VPWR VGND sg13cmos5l_decap_8
XFILLER_426_147 VPWR VGND sg13cmos5l_decap_8
XFILLER_679_14 VPWR VGND sg13cmos5l_decap_8
XFILLER_225_209 VPWR VGND sg13cmos5l_decap_8
XFILLER_630_206 VPWR VGND sg13cmos5l_fill_1
XFILLER_555_0 VPWR VGND sg13cmos5l_decap_8
XFILLER_322_77 VPWR VGND sg13cmos5l_fill_2
XFILLER_65_61 VPWR VGND sg13cmos5l_decap_8
XFILLER_630_217 VPWR VGND sg13cmos5l_fill_1
XFILLER_60_133 VPWR VGND sg13cmos5l_decap_8
X_1970_ _1970_/Q Tile_X0Y4_FrameData[19] VGND VPWR Tile_X0Y9_FrameStrobe[1] latch
XFILLER_695_35 VPWR VGND sg13cmos5l_decap_8
X_0921_ _0921_/Q Tile_X0Y9_FrameData[6] VGND VPWR Tile_X0Y9_FrameStrobe[7] latch
XFILLER_201_161 VPWR VGND sg13cmos5l_decap_8
X_3640_ AXI_M_SOC_AWADDR1 Tile_X0Y5_WW4END[1] Tile_X0Y5_WW4END[9] Tile_X0Y5_W6END[1]
+ _4452_/X _2269_/Q _2268_/Q VPWR VGND sg13cmos5l_mux4_1
XFILLER_347_165 VPWR VGND sg13cmos5l_decap_8
X_0852_ _0852_/Q Tile_X0Y9_FrameData[11] VGND VPWR Tile_X0Y9_FrameStrobe[5] latch
XFILLER_628_84 VPWR VGND sg13cmos5l_decap_8
XFILLER_697_217 VPWR VGND sg13cmos5l_fill_1
XFILLER_362_135 VPWR VGND sg13cmos5l_decap_8
X_3571_ Tile_X0Y9_FrameData_O[1] Tile_X0Y9_FrameData[1] VPWR VGND sg13cmos5l_buf_1
XFILLER_564_28 VPWR VGND sg13cmos5l_decap_8
XFILLER_347_63 VPWR VGND sg13cmos5l_decap_8
X_0783_ _0783_/Q Tile_X0Y9_FrameData[16] VGND VPWR Tile_X0Y9_FrameStrobe[3] latch
XFILLER_494_91 VPWR VGND sg13cmos5l_decap_8
X_2522_ _2522_/Q Tile_X0Y6_FrameData[13] VGND VPWR Tile_X0Y9_FrameStrobe[2] latch
XFILLER_504_140 VPWR VGND sg13cmos5l_decap_8
XFILLER_449_217 VPWR VGND sg13cmos5l_fill_1
X_2453_ _2453_/Q Tile_X0Y6_FrameData[18] VGND VPWR Tile_X0Y9_FrameStrobe[0] latch
XFILLER_46_2 VPWR VGND sg13cmos5l_fill_1
XFILLER_665_114 VPWR VGND sg13cmos5l_decap_4
XFILLER_216_56 VPWR VGND sg13cmos5l_decap_8
XFILLER_114_168 VPWR VGND sg13cmos5l_decap_8
X_1404_ _1404_/Q Tile_X0Y1_FrameData[29] VGND VPWR Tile_X0Y9_FrameStrobe[7] latch
X_2384_ _2384_/Q Tile_X0Y5_FrameData[21] VGND VPWR Tile_X0Y9_FrameStrobe[6] latch
XFILLER_580_49 VPWR VGND sg13cmos5l_decap_8
XFILLER_513_21 VPWR VGND sg13cmos5l_decap_8
X_4123_ _4123_/X _4095_/X _0094_/X _4094_/X Tile_X0Y0_S4END[11] _1467_/Q _1466_/Q
+ VPWR VGND sg13cmos5l_mux4_1
X_1335_ _1335_/Q Tile_X0Y1_FrameData[2] VGND VPWR Tile_X0Y9_FrameStrobe[4] latch
XFILLER_122_190 VPWR VGND sg13cmos5l_fill_2
X_4054_ _4054_/X Tile_X0Y2_W2END[1] AXI_M_SOC_AWREADY _4099_/X _4098_/X _1565_/Q _1564_/Q
+ VPWR VGND sg13cmos5l_mux4_1
X_1266_ _1266_/Q Tile_X0Y1_FrameData[7] VGND VPWR Tile_X0Y9_FrameStrobe[2] latch
XFILLER_589_14 VPWR VGND sg13cmos5l_decap_8
XFILLER_232_55 VPWR VGND sg13cmos5l_decap_8
X_3005_ Tile_X0Y5_E2BEGb[0] _4380_/X VPWR VGND sg13cmos5l_buf_1
X_0217_ _0217_/Q Tile_X0Y7_FrameData[6] VGND VPWR Tile_X0Y9_FrameStrobe[1] latch
XFILLER_36_141 VPWR VGND sg13cmos5l_decap_4
X_1197_ _1197_/Q Tile_X0Y1_FrameData[12] VGND VPWR Tile_X0Y9_FrameStrobe[0] latch
XFILLER_36_152 VPWR VGND sg13cmos5l_fill_2
X_0148_ AXI_M_SOC_ARCACHE2 _0929_/Q _3776_/X VPWR VGND sg13cmos5l_nor2b_1
X_0079_ _0079_/X _4105_/X _4106_/X _2669_/Q VPWR VGND sg13cmos5l_mux2_1
XFILLER_101_59 VPWR VGND sg13cmos5l_decap_8
XFILLER_388_81 VPWR VGND sg13cmos5l_fill_2
XFILLER_338_110 VPWR VGND sg13cmos5l_decap_8
X_3907_ _3907_/X _4014_/X _4018_/X _3999_/X _3993_/X _1395_/Q _1394_/Q VPWR VGND sg13cmos5l_mux4_1
XFILLER_338_121 VPWR VGND sg13cmos5l_fill_1
X_4887_ _4887_/X AXI_M_SOC_RDATA3 _4920_/X _4924_/X _4907_/X _0769_/Q _0768_/Q VPWR
+ VGND sg13cmos5l_mux4_1
XFILLER_137_205 VPWR VGND sg13cmos5l_fill_2
X_3838_ _3838_/X _0085_/X Tile_X0Y0_S4END[2] _3872_/X _3871_/X _1029_/Q _1028_/Q VPWR
+ VGND sg13cmos5l_mux4_1
XFILLER_474_28 VPWR VGND sg13cmos5l_decap_8
X_3769_ _3769_/X Tile_X0Y1_WW4END[2] Tile_X0Y1_WW4END[10] Tile_X0Y1_W6END[10] _4018_/X
+ _1237_/Q _1236_/Q VPWR VGND sg13cmos5l_mux4_1
XFILLER_257_74 VPWR VGND sg13cmos5l_decap_8
XFILLER_353_179 VPWR VGND sg13cmos5l_decap_4
XFILLER_10_56 VPWR VGND sg13cmos5l_decap_8
XFILLER_656_136 VPWR VGND sg13cmos5l_decap_8
XFILLER_704_42 VPWR VGND sg13cmos5l_decap_8
XFILLER_490_49 VPWR VGND sg13cmos5l_decap_8
XFILLER_273_84 VPWR VGND sg13cmos5l_decap_8
XFILLER_423_21 VPWR VGND sg13cmos5l_decap_8
XFILLER_19_21 VPWR VGND sg13cmos5l_decap_8
XFILLER_381_7 VPWR VGND sg13cmos5l_decap_8
XFILLER_259_183 VPWR VGND sg13cmos5l_fill_1
XFILLER_259_194 VPWR VGND sg13cmos5l_fill_2
XFILLER_479_7 VPWR VGND sg13cmos5l_decap_8
XFILLER_19_108 VPWR VGND sg13cmos5l_decap_8
XFILLER_19_119 VPWR VGND sg13cmos5l_fill_2
XFILLER_423_98 VPWR VGND sg13cmos5l_decap_8
XFILLER_499_14 VPWR VGND sg13cmos5l_decap_8
XFILLER_19_87 VPWR VGND sg13cmos5l_fill_1
XFILLER_612_217 VPWR VGND sg13cmos5l_fill_1
XFILLER_646_7 VPWR VGND sg13cmos5l_decap_8
XFILLER_423_139 VPWR VGND sg13cmos5l_decap_4
XANTENNA__3103__X Tile_X0Y7_E6BEG[1] VPWR VGND sg13cmos5l_antennanp
XFILLER_42_100 VPWR VGND sg13cmos5l_decap_4
XFILLER_649_28 VPWR VGND sg13cmos5l_decap_8
XFILLER_35_42 VPWR VGND sg13cmos5l_decap_8
XFILLER_579_91 VPWR VGND sg13cmos5l_decap_8
XFILLER_577_154 VPWR VGND sg13cmos5l_decap_8
XANTENNA__2942__X Tile_X0Y8_E6BEG[10] VPWR VGND sg13cmos5l_antennanp
XFILLER_35_86 VPWR VGND sg13cmos5l_fill_1
XFILLER_298_70 VPWR VGND sg13cmos5l_decap_8
XFILLER_592_113 VPWR VGND sg13cmos5l_decap_4
XFILLER_592_146 VPWR VGND sg13cmos5l_decap_8
XFILLER_51_41 VPWR VGND sg13cmos5l_decap_8
XFILLER_136_0 VPWR VGND sg13cmos5l_decap_8
XFILLER_329_165 VPWR VGND sg13cmos5l_decap_4
XFILLER_195_160 VPWR VGND sg13cmos5l_fill_1
XFILLER_448_73 VPWR VGND sg13cmos5l_decap_8
XFILLER_329_176 VPWR VGND sg13cmos5l_decap_8
XFILLER_665_49 VPWR VGND sg13cmos5l_decap_8
XFILLER_384_28 VPWR VGND sg13cmos5l_decap_4
XFILLER_384_39 VPWR VGND sg13cmos5l_decap_4
XFILLER_303_0 VPWR VGND sg13cmos5l_decap_8
XFILLER_498_161 VPWR VGND sg13cmos5l_decap_8
XFILLER_317_88 VPWR VGND sg13cmos5l_decap_8
XFILLER_183_40 VPWR VGND sg13cmos5l_decap_8
XFILLER_317_99 VPWR VGND sg13cmos5l_fill_1
XFILLER_183_51 VPWR VGND sg13cmos5l_fill_1
XFILLER_647_147 VPWR VGND sg13cmos5l_decap_8
XFILLER_614_42 VPWR VGND sg13cmos5l_decap_8
XFILLER_501_154 VPWR VGND sg13cmos5l_decap_8
XFILLER_111_116 VPWR VGND sg13cmos5l_decap_8
XFILLER_333_21 VPWR VGND sg13cmos5l_decap_8
XFILLER_672_0 VPWR VGND sg13cmos5l_decap_8
XFILLER_25_7 VPWR VGND sg13cmos5l_decap_8
X_1120_ _1120_/Q Tile_X0Y0_FrameData[11] VGND VPWR Tile_X0Y9_FrameStrobe[5] latch
XFILLER_655_191 VPWR VGND sg13cmos5l_decap_8
XFILLER_280_112 VPWR VGND sg13cmos5l_decap_8
X_1051_ _1051_/Q Tile_X0Y0_FrameData[16] VGND VPWR Tile_X0Y9_FrameStrobe[3] latch
XFILLER_630_63 VPWR VGND sg13cmos5l_decap_8
XFILLER_202_14 VPWR VGND sg13cmos5l_decap_8
XFILLER_18_141 VPWR VGND sg13cmos5l_decap_8
XFILLER_407_180 VPWR VGND sg13cmos5l_decap_8
XANTENNA__3013__X Tile_X0Y5_E6BEG[0] VPWR VGND sg13cmos5l_antennanp
XFILLER_80_217 VPWR VGND sg13cmos5l_fill_1
XFILLER_18_163 VPWR VGND sg13cmos5l_fill_1
XFILLER_559_28 VPWR VGND sg13cmos5l_decap_8
XFILLER_568_154 VPWR VGND sg13cmos5l_decap_8
XFILLER_489_91 VPWR VGND sg13cmos5l_decap_8
X_4810_ _4810_/X _4781_/X Tile_X0Y9_N4END[6] _4780_/X _0075_/X _0451_/Q _0450_/Q VPWR
+ VGND sg13cmos5l_mux4_1
XANTENNA__2852__X Tile_X0Y6_E6BEG[1] VPWR VGND sg13cmos5l_antennanp
XFILLER_178_138 VPWR VGND sg13cmos5l_decap_8
X_4741_ _4741_/X Tile_X0Y8_W2END[2] AXI_M_SOC_RDATA10 _4789_/X _4788_/X _0565_/Q _0564_/Q
+ VPWR VGND sg13cmos5l_mux4_1
X_1953_ _1953_/Q Tile_X0Y4_FrameData[4] VGND VPWR Tile_X0Y9_FrameStrobe[0] latch
XFILLER_583_168 VPWR VGND sg13cmos5l_decap_8
X_0904_ _0904_/Q Tile_X0Y9_FrameData[23] VGND VPWR Tile_X0Y9_FrameStrobe[7] latch
XFILLER_186_171 VPWR VGND sg13cmos5l_decap_8
X_1884_ _1884_/Q Tile_X0Y3_FrameData[13] VGND VPWR Tile_X0Y9_FrameStrobe[6] latch
X_4672_ _4672_/X _4595_/X _4711_/X _4710_/X _4594_/X _0173_/Q _0172_/Q VPWR VGND sg13cmos5l_mux4_1
XFILLER_575_49 VPWR VGND sg13cmos5l_decap_8
XFILLER_358_84 VPWR VGND sg13cmos5l_decap_8
XFILLER_508_21 VPWR VGND sg13cmos5l_decap_8
X_0835_ _0835_/Q Tile_X0Y9_FrameData[28] VGND VPWR Tile_X0Y9_FrameStrobe[5] latch
X_3623_ Tile_X0Y9_S4BEG[1] _3623_/A VPWR VGND sg13cmos5l_buf_1
XFILLER_294_28 VPWR VGND sg13cmos5l_decap_8
XFILLER_350_105 VPWR VGND sg13cmos5l_decap_8
XFILLER_335_179 VPWR VGND sg13cmos5l_fill_1
X_0766_ _0766_/Q Tile_X0Y9_FrameData[1] VGND VPWR Tile_X0Y9_FrameStrobe[2] latch
X_3554_ Tile_X0Y9_EE4BEG[0] _4864_/X VPWR VGND sg13cmos5l_buf_1
X_2505_ _2505_/Q Tile_X0Y6_FrameData[30] VGND VPWR Tile_X0Y9_FrameStrobe[2] latch
XFILLER_227_77 VPWR VGND sg13cmos5l_decap_8
X_3485_ Tile_X0Y1_EE4BEG[11] _3959_/X VPWR VGND sg13cmos5l_buf_1
X_0697_ _0697_/Q Tile_X0Y9_FrameData[6] VGND VPWR Tile_X0Y9_FrameStrobe[0] latch
X_2436_ _2436_/Q Tile_X0Y5_FrameData[1] VGND VPWR Tile_X0Y9_FrameStrobe[7] latch
XFILLER_102_127 VPWR VGND sg13cmos5l_decap_8
XFILLER_671_70 VPWR VGND sg13cmos5l_decap_8
XFILLER_638_169 VPWR VGND sg13cmos5l_decap_8
XFILLER_243_21 VPWR VGND sg13cmos5l_decap_8
X_2367_ _2367_/Q Tile_X0Y5_FrameData[6] VGND VPWR Tile_X0Y9_FrameStrobe[5] latch
XFILLER_256_142 VPWR VGND sg13cmos5l_fill_2
X_1318_ _1318_/Q Tile_X0Y1_FrameData[19] VGND VPWR Tile_X0Y9_FrameStrobe[4] latch
X_4106_ _4106_/X _4572_/X _4576_/X _4580_/X _4553_/X _2671_/Q _2670_/Q VPWR VGND sg13cmos5l_mux4_1
X_2298_ _2298_/Q Tile_X0Y5_FrameData[11] VGND VPWR Tile_X0Y9_FrameStrobe[3] latch
XFILLER_271_112 VPWR VGND sg13cmos5l_fill_2
X_4037_ _4037_/X _4091_/X Tile_X0Y2_WW4END[5] _4090_/X AXI_M_SOC_AWREADY _1599_/Q
+ _1598_/Q VPWR VGND sg13cmos5l_mux4_1
X_1249_ _1249_/Q Tile_X0Y1_FrameData[24] VGND VPWR Tile_X0Y9_FrameStrobe[2] latch
XFILLER_112_14 VPWR VGND sg13cmos5l_decap_8
XFILLER_71_217 VPWR VGND sg13cmos5l_fill_1
XFILLER_540_96 VPWR VGND sg13cmos5l_decap_8
XFILLER_24_100 VPWR VGND sg13cmos5l_decap_8
XFILLER_469_28 VPWR VGND sg13cmos5l_decap_8
XFILLER_559_143 VPWR VGND sg13cmos5l_fill_1
XFILLER_399_91 VPWR VGND sg13cmos5l_decap_8
XANTENNA__2762__X Tile_X0Y3_FrameData_O[20] VPWR VGND sg13cmos5l_antennanp
XFILLER_413_183 VPWR VGND sg13cmos5l_decap_8
XFILLER_559_176 VPWR VGND sg13cmos5l_fill_2
XFILLER_559_198 VPWR VGND sg13cmos5l_fill_1
X_4939_ _4939_/X Tile_X0Y8_W1END[3] Tile_X0Y8_W2MID[0] Tile_X0Y8_W2END[0] _4784_/X
+ _0613_/Q _0612_/Q VPWR VGND sg13cmos5l_mux4_1
XFILLER_574_157 VPWR VGND sg13cmos5l_decap_8
XANTENNA_40 Tile_X0Y0_S2MID[3] VPWR VGND sg13cmos5l_antennanp
XFILLER_716_140 VPWR VGND sg13cmos5l_fill_1
XFILLER_485_49 VPWR VGND sg13cmos5l_decap_8
XANTENNA_51 Tile_X0Y0_S2MID[7] VPWR VGND sg13cmos5l_antennanp
XFILLER_268_84 VPWR VGND sg13cmos5l_decap_4
XANTENNA_62 Tile_X0Y9_FrameStrobe[13] VPWR VGND sg13cmos5l_antennanp
XFILLER_418_21 VPWR VGND sg13cmos5l_decap_8
XANTENNA_73 Tile_X0Y9_N2MID[1] VPWR VGND sg13cmos5l_antennanp
XANTENNA_84 _4427_/X VPWR VGND sg13cmos5l_antennanp
XFILLER_582_190 VPWR VGND sg13cmos5l_fill_1
XANTENNA__3593__X Tile_X0Y9_FrameData_O[23] VPWR VGND sg13cmos5l_antennanp
XFILLER_192_163 VPWR VGND sg13cmos5l_decap_8
XFILLER_192_174 VPWR VGND sg13cmos5l_fill_1
XFILLER_530_205 VPWR VGND sg13cmos5l_fill_2
XFILLER_341_105 VPWR VGND sg13cmos5l_decap_4
XFILLER_418_98 VPWR VGND sg13cmos5l_decap_8
XFILLER_715_41 VPWR VGND sg13cmos5l_decap_8
XFILLER_137_77 VPWR VGND sg13cmos5l_decap_8
XFILLER_596_7 VPWR VGND sg13cmos5l_decap_8
XFILLER_629_136 VPWR VGND sg13cmos5l_fill_1
XFILLER_434_42 VPWR VGND sg13cmos5l_decap_8
XFILLER_239_109 VPWR VGND sg13cmos5l_decap_4
XFILLER_294_215 VPWR VGND sg13cmos5l_fill_2
XFILLER_153_21 VPWR VGND sg13cmos5l_decap_8
XFILLER_495_175 VPWR VGND sg13cmos5l_decap_8
XANTENNA__2937__X Tile_X0Y8_E6BEG[5] VPWR VGND sg13cmos5l_antennanp
XFILLER_153_54 VPWR VGND sg13cmos5l_decap_8
XFILLER_247_153 VPWR VGND sg13cmos5l_decap_8
XFILLER_101_171 VPWR VGND sg13cmos5l_decap_8
XFILLER_652_161 VPWR VGND sg13cmos5l_decap_8
XFILLER_597_205 VPWR VGND sg13cmos5l_decap_4
XFILLER_450_63 VPWR VGND sg13cmos5l_decap_4
XFILLER_597_216 VPWR VGND sg13cmos5l_fill_2
XFILLER_450_74 VPWR VGND sg13cmos5l_decap_8
XFILLER_450_85 VPWR VGND sg13cmos5l_fill_1
XFILLER_411_109 VPWR VGND sg13cmos5l_fill_2
XFILLER_379_28 VPWR VGND sg13cmos5l_decap_8
XFILLER_404_161 VPWR VGND sg13cmos5l_decap_8
XFILLER_253_0 VPWR VGND sg13cmos5l_decap_8
XFILLER_15_133 VPWR VGND sg13cmos5l_fill_2
XFILLER_600_77 VPWR VGND sg13cmos5l_decap_8
XFILLER_349_216 VPWR VGND sg13cmos5l_fill_2
XFILLER_62_40 VPWR VGND sg13cmos5l_decap_8
XFILLER_30_114 VPWR VGND sg13cmos5l_fill_1
XFILLER_420_0 VPWR VGND sg13cmos5l_decap_8
XFILLER_565_157 VPWR VGND sg13cmos5l_decap_8
XFILLER_518_0 VPWR VGND sg13cmos5l_decap_8
XFILLER_707_140 VPWR VGND sg13cmos5l_decap_8
XFILLER_609_42 VPWR VGND sg13cmos5l_decap_8
XFILLER_395_49 VPWR VGND sg13cmos5l_decap_8
XFILLER_168_193 VPWR VGND sg13cmos5l_decap_8
XFILLER_7_35 VPWR VGND sg13cmos5l_decap_8
XFILLER_328_21 VPWR VGND sg13cmos5l_decap_8
XFILLER_317_135 VPWR VGND sg13cmos5l_decap_8
XFILLER_692_14 VPWR VGND sg13cmos5l_decap_8
X_0620_ _0620_/Q Tile_X0Y8_FrameData[19] VGND VPWR Tile_X0Y9_FrameStrobe[6] latch
XFILLER_328_87 VPWR VGND sg13cmos5l_fill_2
XFILLER_521_216 VPWR VGND sg13cmos5l_fill_2
X_0551_ _0551_/Q Tile_X0Y8_FrameData[24] VGND VPWR Tile_X0Y9_FrameStrobe[4] latch
XFILLER_625_63 VPWR VGND sg13cmos5l_decap_8
XANTENNA__3008__X Tile_X0Y5_E2BEGb[3] VPWR VGND sg13cmos5l_antennanp
XFILLER_344_42 VPWR VGND sg13cmos5l_decap_8
X_3270_ Tile_X0Y0_EE4BEG[6] _3826_/X VPWR VGND sg13cmos5l_buf_1
X_0482_ _0482_/Q Tile_X0Y8_FrameData[29] VGND VPWR Tile_X0Y9_FrameStrobe[2] latch
XFILLER_340_171 VPWR VGND sg13cmos5l_decap_8
XFILLER_491_70 VPWR VGND sg13cmos5l_decap_8
XFILLER_486_164 VPWR VGND sg13cmos5l_decap_4
XFILLER_97_147 VPWR VGND sg13cmos5l_decap_8
XFILLER_97_158 VPWR VGND sg13cmos5l_fill_1
X_2221_ _2221_/Q Tile_X0Y5_FrameData[24] VGND VPWR Tile_X0Y9_FrameStrobe[1] latch
XANTENNA__2847__X Tile_X0Y6_E2BEGb[4] VPWR VGND sg13cmos5l_antennanp
XFILLER_87_81 VPWR VGND sg13cmos5l_decap_8
X_2152_ _2152_/Q Tile_X0Y4_FrameData[29] VGND VPWR Tile_X0Y9_FrameStrobe[7] latch
XFILLER_641_84 VPWR VGND sg13cmos5l_decap_8
XFILLER_213_35 VPWR VGND sg13cmos5l_decap_8
XFILLER_442_201 VPWR VGND sg13cmos5l_decap_8
X_1103_ _1103_/Q Tile_X0Y0_FrameData[28] VGND VPWR Tile_X0Y9_FrameStrobe[5] latch
XFILLER_643_161 VPWR VGND sg13cmos5l_decap_8
XFILLER_588_205 VPWR VGND sg13cmos5l_fill_1
XFILLER_360_63 VPWR VGND sg13cmos5l_decap_8
X_2083_ _2083_/Q Tile_X0Y4_FrameData[2] VGND VPWR Tile_X0Y9_FrameStrobe[4] latch
XFILLER_53_217 VPWR VGND sg13cmos5l_fill_1
X_1034_ _1034_/Q Tile_X0Y0_FrameData[1] VGND VPWR Tile_X0Y9_FrameStrobe[2] latch
XFILLER_289_28 VPWR VGND sg13cmos5l_decap_8
XFILLER_510_77 VPWR VGND sg13cmos5l_decap_8
XFILLER_99_0 VPWR VGND sg13cmos5l_fill_2
XFILLER_410_142 VPWR VGND sg13cmos5l_decap_8
XFILLER_410_153 VPWR VGND sg13cmos5l_fill_2
X_2985_ Tile_X0Y8_FrameData_O[25] Tile_X0Y8_FrameData[25] VPWR VGND sg13cmos5l_buf_1
XFILLER_519_42 VPWR VGND sg13cmos5l_decap_8
X_4724_ _4724_/X _4777_/X _4776_/X AXI_M_SOC_RDATA11 AXI_M_SOC_RDATA15 _0599_/Q _0598_/Q
+ VPWR VGND sg13cmos5l_mux4_1
XFILLER_571_105 VPWR VGND sg13cmos5l_decap_8
X_1936_ _1936_/Q Tile_X0Y4_FrameData[21] VGND VPWR Tile_X0Y9_FrameStrobe[0] latch
XFILLER_666_70 VPWR VGND sg13cmos5l_decap_8
X_4655_ _4655_/X AXI_M_SOC_RDATA23 _4684_/X _4688_/X _4668_/X _0249_/Q _0248_/Q VPWR
+ VGND sg13cmos5l_mux4_1
X_1867_ _1867_/Q Tile_X0Y3_FrameData[30] VGND VPWR Tile_X0Y9_FrameStrobe[6] latch
XFILLER_713_154 VPWR VGND sg13cmos5l_decap_8
X_3606_ Tile_X0Y9_S2BEG[0] _4828_/X VPWR VGND sg13cmos5l_buf_1
X_0818_ _0818_/Q Tile_X0Y9_FrameData[13] VGND VPWR Tile_X0Y9_FrameStrobe[4] latch
X_1798_ _1798_/Q Tile_X0Y3_FrameData[3] VGND VPWR Tile_X0Y9_FrameStrobe[3] latch
X_4586_ _4586_/X Tile_X0Y5_W2MID[6] Tile_X0Y5_W2END[6] Tile_X0Y5_W6END[9] _4430_/X
+ _2393_/Q _2392_/Q VPWR VGND sg13cmos5l_mux4_1
XFILLER_323_138 VPWR VGND sg13cmos5l_fill_2
XFILLER_316_190 VPWR VGND sg13cmos5l_decap_8
X_3537_ Tile_X0Y9_E2BEGb[3] _4859_/X VPWR VGND sg13cmos5l_buf_1
X_0749_ _0749_/Q Tile_X0Y9_FrameData[18] VGND VPWR Tile_X0Y9_FrameStrobe[2] latch
XFILLER_88_103 VPWR VGND sg13cmos5l_decap_8
XFILLER_254_53 VPWR VGND sg13cmos5l_decap_4
XFILLER_130_211 VPWR VGND sg13cmos5l_fill_1
XFILLER_254_64 VPWR VGND sg13cmos5l_fill_1
X_3468_ Tile_X0Y1_FrameData_O[26] Tile_X0Y1_FrameData[26] VPWR VGND sg13cmos5l_buf_1
XFILLER_107_69 VPWR VGND sg13cmos5l_decap_8
XFILLER_477_186 VPWR VGND sg13cmos5l_fill_2
XFILLER_331_193 VPWR VGND sg13cmos5l_decap_8
XFILLER_254_86 VPWR VGND sg13cmos5l_decap_8
XFILLER_492_112 VPWR VGND sg13cmos5l_decap_8
XANTENNA__2757__X Tile_X0Y3_FrameData_O[15] VPWR VGND sg13cmos5l_antennanp
X_2419_ _2419_/Q Tile_X0Y5_FrameData[18] VGND VPWR Tile_X0Y9_FrameStrobe[7] latch
X_3399_ Tile_X0Y2_E2BEG[2] _4042_/X VPWR VGND sg13cmos5l_buf_1
XFILLER_404_56 VPWR VGND sg13cmos5l_decap_8
XFILLER_291_207 VPWR VGND sg13cmos5l_fill_2
XFILLER_123_35 VPWR VGND sg13cmos5l_fill_1
XFILLER_701_21 VPWR VGND sg13cmos5l_decap_8
XFILLER_244_112 VPWR VGND sg13cmos5l_decap_8
XFILLER_270_63 VPWR VGND sg13cmos5l_decap_8
XFILLER_83_28 VPWR VGND sg13cmos5l_fill_1
XFILLER_177_7 VPWR VGND sg13cmos5l_decap_8
XFILLER_199_28 VPWR VGND sg13cmos5l_decap_8
XFILLER_701_98 VPWR VGND sg13cmos5l_decap_8
XANTENNA__3588__X Tile_X0Y9_FrameData_O[18] VPWR VGND sg13cmos5l_antennanp
XFILLER_420_77 VPWR VGND sg13cmos5l_decap_8
XFILLER_344_7 VPWR VGND sg13cmos5l_decap_8
XFILLER_279_83 VPWR VGND sg13cmos5l_decap_8
XFILLER_562_105 VPWR VGND sg13cmos5l_decap_8
XFILLER_511_7 VPWR VGND sg13cmos5l_decap_8
XFILLER_429_42 VPWR VGND sg13cmos5l_decap_8
XFILLER_609_7 VPWR VGND sg13cmos5l_decap_8
XFILLER_576_70 VPWR VGND sg13cmos5l_decap_8
XFILLER_148_21 VPWR VGND sg13cmos5l_decap_8
XFILLER_165_141 VPWR VGND sg13cmos5l_decap_4
XFILLER_20_191 VPWR VGND sg13cmos5l_decap_8
XFILLER_180_100 VPWR VGND sg13cmos5l_decap_8
XFILLER_165_185 VPWR VGND sg13cmos5l_fill_1
XFILLER_148_87 VPWR VGND sg13cmos5l_decap_8
XFILLER_570_182 VPWR VGND sg13cmos5l_decap_8
XFILLER_662_28 VPWR VGND sg13cmos5l_decap_8
XFILLER_468_120 VPWR VGND sg13cmos5l_fill_2
XFILLER_180_166 VPWR VGND sg13cmos5l_decap_4
XFILLER_180_199 VPWR VGND sg13cmos5l_decap_8
XFILLER_314_56 VPWR VGND sg13cmos5l_decap_4
XFILLER_87_180 VPWR VGND sg13cmos5l_fill_2
XFILLER_625_150 VPWR VGND sg13cmos5l_fill_2
XFILLER_370_0 VPWR VGND sg13cmos5l_decap_8
XFILLER_611_21 VPWR VGND sg13cmos5l_decap_8
XFILLER_468_0 VPWR VGND sg13cmos5l_decap_8
XFILLER_57_95 VPWR VGND sg13cmos5l_decap_8
XFILLER_235_134 VPWR VGND sg13cmos5l_decap_8
XFILLER_180_74 VPWR VGND sg13cmos5l_fill_2
XFILLER_35_217 VPWR VGND sg13cmos5l_fill_1
XFILLER_687_14 VPWR VGND sg13cmos5l_decap_8
XFILLER_640_175 VPWR VGND sg13cmos5l_decap_8
XFILLER_635_0 VPWR VGND sg13cmos5l_decap_8
XANTENNA__3498__X Tile_X0Y1_E6BEG[8] VPWR VGND sg13cmos5l_antennanp
XFILLER_92_7 VPWR VGND sg13cmos5l_decap_8
XFILLER_553_105 VPWR VGND sg13cmos5l_decap_8
XFILLER_339_42 VPWR VGND sg13cmos5l_decap_8
X_2770_ Tile_X0Y3_FrameData_O[28] Tile_X0Y3_FrameData[28] VPWR VGND sg13cmos5l_buf_1
XFILLER_486_70 VPWR VGND sg13cmos5l_decap_8
X_1721_ _1721_/Q Tile_X0Y3_FrameData[16] VGND VPWR Tile_X0Y9_FrameStrobe[1] latch
X_1652_ _1652_/Q Tile_X0Y2_FrameData[29] VGND VPWR Tile_X0Y9_FrameStrobe[7] latch
X_4440_ _4440_/X _4013_/X _4017_/X _4002_/X _3992_/X _1362_/Q _1361_/Q VPWR VGND sg13cmos5l_mux4_1
XFILLER_305_116 VPWR VGND sg13cmos5l_fill_2
XFILLER_208_13 VPWR VGND sg13cmos5l_decap_8
XFILLER_636_84 VPWR VGND sg13cmos5l_decap_8
XFILLER_171_133 VPWR VGND sg13cmos5l_decap_8
X_0603_ _0603_/Q Tile_X0Y8_FrameData[4] VGND VPWR Tile_X0Y9_FrameStrobe[5] latch
XFILLER_572_28 VPWR VGND sg13cmos5l_decap_8
XFILLER_355_63 VPWR VGND sg13cmos5l_decap_8
X_1583_ _1583_/Q Tile_X0Y2_FrameData[2] VGND VPWR Tile_X0Y9_FrameStrobe[4] latch
X_4371_ _4371_/X _4427_/X _4426_/X AXI_M_SOC_RVALID _4425_/X _2361_/Q _2360_/Q VPWR
+ VGND sg13cmos5l_mux4_1
XFILLER_710_168 VPWR VGND sg13cmos5l_decap_8
XFILLER_320_119 VPWR VGND sg13cmos5l_fill_2
X_0534_ _0534_/Q Tile_X0Y8_FrameData[9] VGND VPWR Tile_X0Y9_FrameStrobe[3] latch
X_3322_ Tile_X0Y4_EE4BEG[10] _4282_/X VPWR VGND sg13cmos5l_buf_1
XFILLER_98_91 VPWR VGND sg13cmos5l_decap_8
XFILLER_608_106 VPWR VGND sg13cmos5l_decap_8
XFILLER_505_77 VPWR VGND sg13cmos5l_decap_8
X_0465_ _0465_/Q Tile_X0Y8_FrameData[14] VGND VPWR Tile_X0Y9_FrameStrobe[1] latch
X_3253_ Tile_X0Y0_FrameData_O[21] Tile_X0Y0_FrameData[21] VPWR VGND sg13cmos5l_buf_1
XFILLER_371_51 VPWR VGND sg13cmos5l_fill_1
X_2204_ _2204_/Q Tile_X0Y5_FrameData[9] VGND VPWR Tile_X0Y9_FrameStrobe[0] latch
X_3184_ Tile_X0Y0_N4BEG[8] _3184_/A VPWR VGND sg13cmos5l_buf_1
XFILLER_474_178 VPWR VGND sg13cmos5l_decap_4
X_0396_ _0396_/Q Tile_X0Y7_FrameData[19] VGND VPWR Tile_X0Y9_FrameStrobe[7] latch
XFILLER_521_21 VPWR VGND sg13cmos5l_decap_8
XFILLER_14_0 VPWR VGND sg13cmos5l_decap_8
X_2135_ _2135_/Q Tile_X0Y4_FrameData[14] VGND VPWR Tile_X0Y9_FrameStrobe[6] latch
XFILLER_93_150 VPWR VGND sg13cmos5l_decap_4
XFILLER_26_217 VPWR VGND sg13cmos5l_fill_1
XFILLER_226_167 VPWR VGND sg13cmos5l_fill_2
X_2066_ _2066_/Q Tile_X0Y4_FrameData[19] VGND VPWR Tile_X0Y9_FrameStrobe[4] latch
XFILLER_631_153 VPWR VGND sg13cmos5l_fill_2
XFILLER_597_14 VPWR VGND sg13cmos5l_decap_8
XFILLER_241_115 VPWR VGND sg13cmos5l_decap_8
XFILLER_387_108 VPWR VGND sg13cmos5l_decap_8
X_1017_ _1017_/Q Tile_X0Y0_FrameData[18] VGND VPWR Tile_X0Y9_FrameStrobe[2] latch
XFILLER_179_211 VPWR VGND sg13cmos5l_fill_1
XANTENNA__3201__X Tile_X0Y0_N2BEG[1] VPWR VGND sg13cmos5l_antennanp
XFILLER_395_130 VPWR VGND sg13cmos5l_decap_8
XFILLER_139_119 VPWR VGND sg13cmos5l_decap_8
XFILLER_677_91 VPWR VGND sg13cmos5l_decap_8
XFILLER_529_179 VPWR VGND sg13cmos5l_decap_4
XFILLER_249_42 VPWR VGND sg13cmos5l_decap_4
XFILLER_249_53 VPWR VGND sg13cmos5l_decap_4
X_2968_ Tile_X0Y8_FrameData_O[8] Tile_X0Y8_FrameData[8] VPWR VGND sg13cmos5l_buf_1
X_4707_ _4707_/X Tile_X0Y9_W2MID[4] Tile_X0Y9_W2END[4] Tile_X0Y9_W6END[4] _4907_/X
+ _0913_/Q _0912_/Q VPWR VGND sg13cmos5l_mux4_1
XFILLER_537_190 VPWR VGND sg13cmos5l_decap_4
X_1919_ _1919_/Q Tile_X0Y3_FrameData[10] VGND VPWR Tile_X0Y9_FrameStrobe[7] latch
X_2899_ Tile_X0Y6_FrameData_O[20] Tile_X0Y6_FrameData[20] VPWR VGND sg13cmos5l_buf_1
X_4638_ _4638_/X Tile_X0Y7_WW4END[5] AXI_M_SOC_RDATA21 _4689_/X _4672_/X _0283_/Q
+ _0282_/Q VPWR VGND sg13cmos5l_mux4_1
XFILLER_546_84 VPWR VGND sg13cmos5l_decap_8
XFILLER_552_182 VPWR VGND sg13cmos5l_decap_8
XFILLER_118_35 VPWR VGND sg13cmos5l_decap_8
XFILLER_552_193 VPWR VGND sg13cmos5l_fill_2
XFILLER_482_28 VPWR VGND sg13cmos5l_decap_8
X_4569_ _4569_/X _4547_/X Tile_X0Y9_N4END[13] _4546_/X _0153_/X _2493_/Q _2492_/Q
+ VPWR VGND sg13cmos5l_mux4_1
XFILLER_78_28 VPWR VGND sg13cmos5l_decap_8
XFILLER_304_171 VPWR VGND sg13cmos5l_decap_8
XFILLER_415_77 VPWR VGND sg13cmos5l_decap_8
XFILLER_294_7 VPWR VGND sg13cmos5l_decap_8
XFILLER_134_56 VPWR VGND sg13cmos5l_decap_8
XFILLER_712_42 VPWR VGND sg13cmos5l_decap_8
XFILLER_69_180 VPWR VGND sg13cmos5l_fill_2
XFILLER_614_109 VPWR VGND sg13cmos5l_fill_1
XFILLER_281_84 VPWR VGND sg13cmos5l_decap_8
XFILLER_607_150 VPWR VGND sg13cmos5l_decap_8
XFILLER_465_189 VPWR VGND sg13cmos5l_decap_4
XFILLER_431_21 VPWR VGND sg13cmos5l_decap_8
XFILLER_91_109 VPWR VGND sg13cmos5l_fill_2
XFILLER_607_172 VPWR VGND sg13cmos5l_decap_8
XFILLER_406_212 VPWR VGND sg13cmos5l_decap_4
XFILLER_461_7 VPWR VGND sg13cmos5l_decap_8
XFILLER_27_21 VPWR VGND sg13cmos5l_decap_8
XFILLER_559_7 VPWR VGND sg13cmos5l_decap_8
XFILLER_217_167 VPWR VGND sg13cmos5l_decap_8
XFILLER_431_98 VPWR VGND sg13cmos5l_decap_8
XFILLER_421_204 VPWR VGND sg13cmos5l_fill_1
XFILLER_300_14 VPWR VGND sg13cmos5l_decap_8
XANTENNA__3111__X Tile_X0Y7_E6BEG[9] VPWR VGND sg13cmos5l_antennanp
XFILLER_43_20 VPWR VGND sg13cmos5l_decap_8
XFILLER_657_28 VPWR VGND sg13cmos5l_decap_8
XFILLER_159_20 VPWR VGND sg13cmos5l_fill_2
XANTENNA__2950__X Tile_X0Y8_EE4BEG[6] VPWR VGND sg13cmos5l_antennanp
XFILLER_43_86 VPWR VGND sg13cmos5l_decap_8
XFILLER_159_75 VPWR VGND sg13cmos5l_decap_8
XFILLER_689_131 VPWR VGND sg13cmos5l_fill_2
XFILLER_216_0 VPWR VGND sg13cmos5l_decap_8
XFILLER_543_160 VPWR VGND sg13cmos5l_decap_8
XFILLER_342_211 VPWR VGND sg13cmos5l_fill_1
XFILLER_673_49 VPWR VGND sg13cmos5l_decap_8
XFILLER_606_21 VPWR VGND sg13cmos5l_decap_8
XFILLER_4_132 VPWR VGND sg13cmos5l_decap_8
XFILLER_392_28 VPWR VGND sg13cmos5l_decap_8
XFILLER_4_143 VPWR VGND sg13cmos5l_fill_1
XFILLER_175_63 VPWR VGND sg13cmos5l_decap_8
XFILLER_4_14 VPWR VGND sg13cmos5l_decap_8
XFILLER_302_108 VPWR VGND sg13cmos5l_decap_8
XFILLER_153_177 VPWR VGND sg13cmos5l_decap_8
XFILLER_4_176 VPWR VGND sg13cmos5l_fill_1
XFILLER_4_198 VPWR VGND sg13cmos5l_fill_2
XFILLER_68_50 VPWR VGND sg13cmos5l_decap_8
XFILLER_585_0 VPWR VGND sg13cmos5l_decap_8
XFILLER_325_77 VPWR VGND sg13cmos5l_decap_8
XFILLER_622_42 VPWR VGND sg13cmos5l_decap_8
XFILLER_255_207 VPWR VGND sg13cmos5l_decap_4
XFILLER_191_62 VPWR VGND sg13cmos5l_decap_8
X_0250_ _0250_/Q Tile_X0Y7_FrameData[5] VGND VPWR Tile_X0Y9_FrameStrobe[2] latch
XFILLER_456_167 VPWR VGND sg13cmos5l_decap_8
XFILLER_341_21 VPWR VGND sg13cmos5l_decap_8
XFILLER_82_109 VPWR VGND sg13cmos5l_decap_8
X_0181_ _0181_/Q Tile_X0Y7_FrameData[10] VGND VPWR Tile_X0Y9_FrameStrobe[0] latch
XFILLER_208_145 VPWR VGND sg13cmos5l_decap_8
XFILLER_698_35 VPWR VGND sg13cmos5l_decap_8
XFILLER_341_98 VPWR VGND sg13cmos5l_decap_8
XFILLER_223_115 VPWR VGND sg13cmos5l_fill_1
XFILLER_84_93 VPWR VGND sg13cmos5l_fill_1
XFILLER_412_215 VPWR VGND sg13cmos5l_fill_2
XFILLER_223_137 VPWR VGND sg13cmos5l_decap_8
X_3940_ _3940_/X Tile_X0Y1_W2END[7] AXI_M_SOC_ARREADY _3989_/X _3988_/X _1329_/Q _1328_/Q
+ VPWR VGND sg13cmos5l_mux4_1
XFILLER_90_175 VPWR VGND sg13cmos5l_decap_8
XANTENNA__3021__X Tile_X0Y5_E6BEG[8] VPWR VGND sg13cmos5l_antennanp
XFILLER_567_28 VPWR VGND sg13cmos5l_decap_8
X_3871_ _3871_/X _3849_/X _0086_/X Tile_X0Y0_S1END[1] Tile_X0Y0_S4END[1] _0969_/Q
+ _0968_/Q VPWR VGND sg13cmos5l_mux4_1
XFILLER_210_69 VPWR VGND sg13cmos5l_decap_8
XFILLER_176_203 VPWR VGND sg13cmos5l_fill_1
XFILLER_497_91 VPWR VGND sg13cmos5l_decap_8
XFILLER_231_181 VPWR VGND sg13cmos5l_decap_8
XANTENNA__2860__X Tile_X0Y6_E6BEG[9] VPWR VGND sg13cmos5l_antennanp
X_2822_ Tile_X0Y4_E2BEG[0] _4256_/X VPWR VGND sg13cmos5l_buf_1
XFILLER_715_216 VPWR VGND sg13cmos5l_fill_2
XFILLER_129_130 VPWR VGND sg13cmos5l_decap_8
XFILLER_392_155 VPWR VGND sg13cmos5l_fill_1
X_2753_ Tile_X0Y3_FrameData_O[11] Tile_X0Y3_FrameData[11] VPWR VGND sg13cmos5l_buf_1
XFILLER_219_34 VPWR VGND sg13cmos5l_decap_8
XFILLER_191_206 VPWR VGND sg13cmos5l_fill_2
XFILLER_392_177 VPWR VGND sg13cmos5l_fill_1
X_1704_ _1704_/Q Tile_X0Y3_FrameData[1] VGND VPWR Tile_X0Y9_FrameStrobe[0] latch
XFILLER_392_199 VPWR VGND sg13cmos5l_decap_8
XFILLER_583_49 VPWR VGND sg13cmos5l_decap_8
X_2684_ _2684_/Q Tile_X0Y6_FrameData[11] VGND VPWR Tile_X0Y9_FrameStrobe[7] latch
XFILLER_479_215 VPWR VGND sg13cmos5l_fill_2
XFILLER_516_21 VPWR VGND sg13cmos5l_decap_8
X_4423_ _4423_/X Tile_X0Y4_W1END[2] Tile_X0Y4_W6END[10] _4350_/X _4306_/X _2141_/Q
+ _2140_/Q VPWR VGND sg13cmos5l_mux4_1
XFILLER_695_112 VPWR VGND sg13cmos5l_fill_1
X_1635_ _1635_/Q Tile_X0Y2_FrameData[14] VGND VPWR Tile_X0Y9_FrameStrobe[6] latch
XFILLER_695_123 VPWR VGND sg13cmos5l_fill_2
XFILLER_695_134 VPWR VGND sg13cmos5l_fill_1
XANTENNA__3691__X AXI_M_SOC_WDATA1 VPWR VGND sg13cmos5l_antennanp
X_4354_ _4354_/X Tile_X0Y3_W2MID[6] Tile_X0Y3_W2END[6] Tile_X0Y3_W6END[9] _4207_/X
+ _1879_/Q _1878_/Q VPWR VGND sg13cmos5l_mux4_1
X_1566_ _1566_/Q Tile_X0Y2_FrameData[19] VGND VPWR Tile_X0Y9_FrameStrobe[4] latch
XFILLER_447_112 VPWR VGND sg13cmos5l_decap_8
X_3305_ Tile_X0Y0_E2BEG[5] _3809_/X VPWR VGND sg13cmos5l_buf_1
X_0517_ _0517_/Q Tile_X0Y8_FrameData[26] VGND VPWR Tile_X0Y9_FrameStrobe[3] latch
X_1497_ _1497_/Q Tile_X0Y2_FrameData[24] VGND VPWR Tile_X0Y9_FrameStrobe[2] latch
X_4285_ _4285_/X Tile_X0Y4_WW4END[2] AXI_M_SOC_BRESP0 _4338_/X _4317_/X _2043_/Q _2042_/Q
+ VPWR VGND sg13cmos5l_mux4_1
XFILLER_100_203 VPWR VGND sg13cmos5l_decap_8
XFILLER_58_117 VPWR VGND sg13cmos5l_decap_8
X_0448_ _0448_/Q Tile_X0Y8_FrameData[31] VGND VPWR Tile_X0Y9_FrameStrobe[1] latch
X_3236_ Tile_X0Y0_FrameData_O[4] Tile_X0Y0_FrameData[4] VPWR VGND sg13cmos5l_buf_1
XFILLER_73_109 VPWR VGND sg13cmos5l_decap_4
X_0379_ _0379_/Q Tile_X0Y7_FrameData[4] VGND VPWR Tile_X0Y9_FrameStrobe[6] latch
X_3167_ Tile_X0Y4_E6BEG[4] _4292_/X VPWR VGND sg13cmos5l_buf_1
XFILLER_66_161 VPWR VGND sg13cmos5l_decap_8
XFILLER_81_120 VPWR VGND sg13cmos5l_fill_1
X_2118_ _2118_/Q Tile_X0Y4_FrameData[31] VGND VPWR Tile_X0Y9_FrameStrobe[6] latch
X_3098_ Tile_X0Y7_E2BEGb[4] _4624_/X VPWR VGND sg13cmos5l_buf_1
XFILLER_81_142 VPWR VGND sg13cmos5l_decap_8
XFILLER_401_35 VPWR VGND sg13cmos5l_decap_8
XFILLER_470_170 VPWR VGND sg13cmos5l_fill_2
X_2049_ _2049_/Q Tile_X0Y4_FrameData[4] VGND VPWR Tile_X0Y9_FrameStrobe[3] latch
XFILLER_214_148 VPWR VGND sg13cmos5l_decap_4
XFILLER_477_28 VPWR VGND sg13cmos5l_decap_8
XFILLER_368_163 VPWR VGND sg13cmos5l_decap_8
XANTENNA__2770__X Tile_X0Y3_FrameData_O[28] VPWR VGND sg13cmos5l_antennanp
XFILLER_200_91 VPWR VGND sg13cmos5l_decap_8
XFILLER_13_56 VPWR VGND sg13cmos5l_decap_8
XFILLER_707_42 VPWR VGND sg13cmos5l_decap_8
XFILLER_307_7 VPWR VGND sg13cmos5l_decap_8
XFILLER_493_49 VPWR VGND sg13cmos5l_decap_8
XFILLER_276_84 VPWR VGND sg13cmos5l_decap_8
XFILLER_426_21 VPWR VGND sg13cmos5l_decap_8
XFILLER_135_133 VPWR VGND sg13cmos5l_decap_8
XFILLER_135_166 VPWR VGND sg13cmos5l_decap_8
XFILLER_540_152 VPWR VGND sg13cmos5l_fill_2
XFILLER_1_102 VPWR VGND sg13cmos5l_decap_4
XFILLER_150_114 VPWR VGND sg13cmos5l_decap_4
XFILLER_135_199 VPWR VGND sg13cmos5l_fill_1
XFILLER_426_98 VPWR VGND sg13cmos5l_decap_8
XFILLER_145_44 VPWR VGND sg13cmos5l_fill_1
XFILLER_438_112 VPWR VGND sg13cmos5l_fill_2
XFILLER_150_169 VPWR VGND sg13cmos5l_decap_8
XFILLER_145_77 VPWR VGND sg13cmos5l_fill_1
XFILLER_676_7 VPWR VGND sg13cmos5l_decap_8
XFILLER_1_179 VPWR VGND sg13cmos5l_decap_4
XFILLER_145_99 VPWR VGND sg13cmos5l_decap_8
XANTENNA__3106__X Tile_X0Y7_E6BEG[4] VPWR VGND sg13cmos5l_antennanp
XFILLER_438_156 VPWR VGND sg13cmos5l_fill_1
XFILLER_442_42 VPWR VGND sg13cmos5l_decap_8
XFILLER_453_115 VPWR VGND sg13cmos5l_decap_4
XFILLER_161_21 VPWR VGND sg13cmos5l_decap_8
XFILLER_599_108 VPWR VGND sg13cmos5l_decap_8
XFILLER_453_126 VPWR VGND sg13cmos5l_decap_8
XFILLER_180_2 VPWR VGND sg13cmos5l_fill_1
XANTENNA__2945__X Tile_X0Y8_EE4BEG[1] VPWR VGND sg13cmos5l_antennanp
XFILLER_161_87 VPWR VGND sg13cmos5l_decap_8
XFILLER_311_35 VPWR VGND sg13cmos5l_decap_8
XFILLER_205_126 VPWR VGND sg13cmos5l_decap_8
XFILLER_72_153 VPWR VGND sg13cmos5l_decap_8
XFILLER_610_112 VPWR VGND sg13cmos5l_decap_8
XFILLER_54_30 VPWR VGND sg13cmos5l_decap_8
XFILLER_166_0 VPWR VGND sg13cmos5l_decap_8
XFILLER_610_167 VPWR VGND sg13cmos5l_decap_4
XFILLER_387_28 VPWR VGND sg13cmos5l_decap_8
XFILLER_333_0 VPWR VGND sg13cmos5l_decap_8
XFILLER_359_174 VPWR VGND sg13cmos5l_decap_4
XFILLER_508_116 VPWR VGND sg13cmos5l_decap_8
XFILLER_508_149 VPWR VGND sg13cmos5l_decap_8
XFILLER_500_0 VPWR VGND sg13cmos5l_decap_8
XFILLER_70_84 VPWR VGND sg13cmos5l_decap_4
XFILLER_617_42 VPWR VGND sg13cmos5l_decap_8
XFILLER_523_119 VPWR VGND sg13cmos5l_fill_2
XFILLER_315_211 VPWR VGND sg13cmos5l_fill_1
XFILLER_126_122 VPWR VGND sg13cmos5l_decap_8
XFILLER_336_21 VPWR VGND sg13cmos5l_decap_8
XFILLER_531_152 VPWR VGND sg13cmos5l_decap_8
XFILLER_141_103 VPWR VGND sg13cmos5l_decap_8
X_1420_ _1420_/Q Tile_X0Y1_FrameData[13] VGND VPWR Tile_X0Y9_FrameStrobe[7] latch
XFILLER_79_82 VPWR VGND sg13cmos5l_fill_2
XFILLER_429_112 VPWR VGND sg13cmos5l_decap_8
X_1351_ _1351_/Q Tile_X0Y1_FrameData[18] VGND VPWR Tile_X0Y9_FrameStrobe[5] latch
XFILLER_633_63 VPWR VGND sg13cmos5l_decap_8
XFILLER_205_14 VPWR VGND sg13cmos5l_decap_8
XFILLER_95_212 VPWR VGND sg13cmos5l_decap_4
XANTENNA__3016__X Tile_X0Y5_E6BEG[3] VPWR VGND sg13cmos5l_antennanp
X_0302_ _0302_/Q Tile_X0Y7_FrameData[17] VGND VPWR Tile_X0Y9_FrameStrobe[4] latch
XFILLER_352_42 VPWR VGND sg13cmos5l_decap_8
X_1282_ _1282_/Q Tile_X0Y1_FrameData[23] VGND VPWR Tile_X0Y9_FrameStrobe[3] latch
X_4070_ _4070_/X Tile_X0Y2_WW4END[1] AXI_M_SOC_AWREADY _4117_/X _4099_/X _1533_/Q
+ _1532_/Q VPWR VGND sg13cmos5l_mux4_1
X_0233_ _0233_/Q Tile_X0Y7_FrameData[22] VGND VPWR Tile_X0Y9_FrameStrobe[2] latch
X_3021_ Tile_X0Y5_E6BEG[8] _4412_/X VPWR VGND sg13cmos5l_buf_1
XFILLER_55_109 VPWR VGND sg13cmos5l_decap_8
XANTENNA__2855__X Tile_X0Y6_E6BEG[4] VPWR VGND sg13cmos5l_antennanp
XFILLER_502_56 VPWR VGND sg13cmos5l_decap_8
X_0164_ _0164_/Q Tile_X0Y7_FrameData[27] VGND VPWR Tile_X0Y9_FrameStrobe[0] latch
XFILLER_221_35 VPWR VGND sg13cmos5l_decap_8
X_0095_ _0095_/X _4003_/X _4004_/X _2407_/Q VPWR VGND sg13cmos5l_mux2_1
XFILLER_601_134 VPWR VGND sg13cmos5l_fill_2
XFILLER_63_186 VPWR VGND sg13cmos5l_decap_8
XFILLER_598_196 VPWR VGND sg13cmos5l_decap_4
XFILLER_578_49 VPWR VGND sg13cmos5l_decap_8
XFILLER_63_197 VPWR VGND sg13cmos5l_decap_8
X_3923_ _3923_/X _4228_/X _4232_/X _4215_/X _4209_/X _1895_/Q _1894_/Q VPWR VGND sg13cmos5l_mux4_1
XFILLER_297_28 VPWR VGND sg13cmos5l_decap_8
XFILLER_365_100 VPWR VGND sg13cmos5l_fill_2
XFILLER_658_82 VPWR VGND sg13cmos5l_decap_8
X_3854_ _3854_/X _3901_/X _3900_/X Tile_X0Y0_S2MID[6] Tile_X0Y0_S2END[6] _0951_/Q
+ _0950_/Q VPWR VGND sg13cmos5l_mux4_1
XFILLER_81_0 VPWR VGND sg13cmos5l_fill_2
X_2805_ Tile_X0Y3_E2BEGb[3] _4159_/X VPWR VGND sg13cmos5l_buf_1
XFILLER_365_166 VPWR VGND sg13cmos5l_decap_8
X_3785_ _3785_/X Tile_X0Y0_W2MID[6] Tile_X0Y0_W2END[6] Tile_X0Y0_W6END[6] _3855_/X
+ _1167_/Q _1166_/Q VPWR VGND sg13cmos5l_mux4_1
XFILLER_164_217 VPWR VGND sg13cmos5l_fill_1
X_0997_ _0997_/Q Tile_X0Y0_FrameData[6] VGND VPWR Tile_X0Y9_FrameStrobe[1] latch
XFILLER_527_42 VPWR VGND sg13cmos5l_decap_8
X_2736_ _3979_/A3 VPWR VGND sg13cmos5l_tielo
XFILLER_380_136 VPWR VGND sg13cmos5l_decap_8
XFILLER_674_70 VPWR VGND sg13cmos5l_decap_8
XFILLER_117_133 VPWR VGND sg13cmos5l_decap_8
XFILLER_246_21 VPWR VGND sg13cmos5l_decap_8
XFILLER_380_158 VPWR VGND sg13cmos5l_decap_8
X_2667_ _2667_/Q Tile_X0Y6_FrameData[28] VGND VPWR Tile_X0Y9_FrameStrobe[7] latch
XFILLER_522_163 VPWR VGND sg13cmos5l_decap_8
XFILLER_321_203 VPWR VGND sg13cmos5l_decap_8
XFILLER_246_65 VPWR VGND sg13cmos5l_fill_2
X_4406_ _4406_/X _0100_/X _0140_/X _4460_/X _4464_/X _2291_/Q _2290_/Q VPWR VGND sg13cmos5l_mux4_1
X_1618_ _1618_/Q Tile_X0Y2_FrameData[31] VGND VPWR Tile_X0Y9_FrameStrobe[6] latch
X_2598_ _2598_/Q Tile_X0Y6_FrameData[1] VGND VPWR Tile_X0Y9_FrameStrobe[4] latch
XFILLER_609_201 VPWR VGND sg13cmos5l_fill_1
X_4337_ _4337_/X _4305_/X _0158_/X _4304_/X _0111_/X _1979_/Q _1978_/Q VPWR VGND sg13cmos5l_mux4_1
XFILLER_543_63 VPWR VGND sg13cmos5l_decap_4
XFILLER_115_14 VPWR VGND sg13cmos5l_decap_8
X_1549_ _1549_/Q Tile_X0Y2_FrameData[4] VGND VPWR Tile_X0Y9_FrameStrobe[3] latch
XFILLER_543_85 VPWR VGND sg13cmos5l_decap_8
XFILLER_262_42 VPWR VGND sg13cmos5l_decap_8
XFILLER_219_207 VPWR VGND sg13cmos5l_decap_4
XFILLER_286_162 VPWR VGND sg13cmos5l_decap_8
X_4268_ _4268_/X Tile_X0Y4_W2END[3] AXI_M_SOC_BRESP1 _4319_/X _4318_/X _2077_/Q _2076_/Q
+ VPWR VGND sg13cmos5l_mux4_1
XFILLER_435_126 VPWR VGND sg13cmos5l_decap_8
XFILLER_435_137 VPWR VGND sg13cmos5l_fill_1
XANTENNA__2765__X Tile_X0Y3_FrameData_O[23] VPWR VGND sg13cmos5l_antennanp
X_3219_ Tile_X0Y0_FrameStrobe_O[7] Tile_X0Y9_FrameStrobe[7] VPWR VGND sg13cmos5l_buf_1
X_4199_ _4199_/X Tile_X0Y2_W1END[2] Tile_X0Y2_W6END[10] _4107_/X _4086_/X _1633_/Q
+ _1632_/Q VPWR VGND sg13cmos5l_mux4_1
XFILLER_435_159 VPWR VGND sg13cmos5l_decap_8
XFILLER_412_56 VPWR VGND sg13cmos5l_decap_8
XFILLER_39_183 VPWR VGND sg13cmos5l_decap_8
XFILLER_450_107 VPWR VGND sg13cmos5l_decap_8
XFILLER_131_13 VPWR VGND sg13cmos5l_decap_8
XFILLER_39_194 VPWR VGND sg13cmos5l_fill_2
XFILLER_54_153 VPWR VGND sg13cmos5l_decap_8
XFILLER_91_28 VPWR VGND sg13cmos5l_decap_8
XFILLER_488_49 VPWR VGND sg13cmos5l_decap_8
XFILLER_257_7 VPWR VGND sg13cmos5l_decap_8
XFILLER_91_39 VPWR VGND sg13cmos5l_decap_8
XANTENNA__3596__X Tile_X0Y9_FrameData_O[26] VPWR VGND sg13cmos5l_antennanp
XFILLER_424_7 VPWR VGND sg13cmos5l_decap_8
XFILLER_356_133 VPWR VGND sg13cmos5l_decap_8
XFILLER_155_206 VPWR VGND sg13cmos5l_decap_4
XFILLER_210_184 VPWR VGND sg13cmos5l_decap_8
XFILLER_437_42 VPWR VGND sg13cmos5l_decap_8
XFILLER_40_43 VPWR VGND sg13cmos5l_decap_4
XFILLER_584_70 VPWR VGND sg13cmos5l_decap_8
XFILLER_371_147 VPWR VGND sg13cmos5l_decap_4
XFILLER_156_21 VPWR VGND sg13cmos5l_decap_8
XFILLER_371_158 VPWR VGND sg13cmos5l_fill_2
XFILLER_40_76 VPWR VGND sg13cmos5l_decap_8
XFILLER_156_65 VPWR VGND sg13cmos5l_decap_8
XFILLER_306_35 VPWR VGND sg13cmos5l_decap_8
XFILLER_123_169 VPWR VGND sg13cmos5l_decap_8
XFILLER_670_28 VPWR VGND sg13cmos5l_decap_8
XFILLER_77_201 VPWR VGND sg13cmos5l_fill_2
XFILLER_172_42 VPWR VGND sg13cmos5l_decap_8
XFILLER_426_126 VPWR VGND sg13cmos5l_decap_8
XFILLER_283_0 VPWR VGND sg13cmos5l_decap_8
XFILLER_37_109 VPWR VGND sg13cmos5l_fill_1
XFILLER_92_215 VPWR VGND sg13cmos5l_fill_2
XFILLER_322_56 VPWR VGND sg13cmos5l_decap_8
XFILLER_292_165 VPWR VGND sg13cmos5l_decap_8
XFILLER_65_40 VPWR VGND sg13cmos5l_decap_8
XFILLER_450_0 VPWR VGND sg13cmos5l_decap_8
XFILLER_548_0 VPWR VGND sg13cmos5l_decap_8
XFILLER_60_112 VPWR VGND sg13cmos5l_decap_8
XFILLER_695_14 VPWR VGND sg13cmos5l_decap_8
XFILLER_394_206 VPWR VGND sg13cmos5l_fill_2
XFILLER_394_217 VPWR VGND sg13cmos5l_fill_1
XFILLER_81_72 VPWR VGND sg13cmos5l_decap_8
X_0920_ _0920_/Q Tile_X0Y9_FrameData[7] VGND VPWR Tile_X0Y9_FrameStrobe[7] latch
XFILLER_60_189 VPWR VGND sg13cmos5l_decap_8
XFILLER_201_140 VPWR VGND sg13cmos5l_decap_8
XFILLER_347_155 VPWR VGND sg13cmos5l_fill_2
X_0851_ _0851_/Q Tile_X0Y9_FrameData[12] VGND VPWR Tile_X0Y9_FrameStrobe[5] latch
XFILLER_628_63 VPWR VGND sg13cmos5l_decap_8
XFILLER_146_217 VPWR VGND sg13cmos5l_fill_1
XFILLER_362_114 VPWR VGND sg13cmos5l_decap_8
XFILLER_347_42 VPWR VGND sg13cmos5l_decap_8
XFILLER_697_207 VPWR VGND sg13cmos5l_fill_2
X_3570_ Tile_X0Y9_FrameData_O[0] Tile_X0Y9_FrameData[0] VPWR VGND sg13cmos5l_buf_1
X_0782_ _0782_/Q Tile_X0Y9_FrameData[17] VGND VPWR Tile_X0Y9_FrameStrobe[3] latch
XFILLER_494_70 VPWR VGND sg13cmos5l_decap_8
X_2521_ _2521_/Q Tile_X0Y6_FrameData[14] VGND VPWR Tile_X0Y9_FrameStrobe[2] latch
XFILLER_303_214 VPWR VGND sg13cmos5l_decap_4
X_2452_ _2452_/Q Tile_X0Y6_FrameData[19] VGND VPWR Tile_X0Y9_FrameStrobe[0] latch
XFILLER_644_84 VPWR VGND sg13cmos5l_decap_8
XFILLER_504_196 VPWR VGND sg13cmos5l_decap_8
XFILLER_114_147 VPWR VGND sg13cmos5l_decap_8
XFILLER_363_41 VPWR VGND sg13cmos5l_decap_8
XFILLER_216_35 VPWR VGND sg13cmos5l_decap_8
X_1403_ _1403_/Q Tile_X0Y1_FrameData[30] VGND VPWR Tile_X0Y9_FrameStrobe[7] latch
XFILLER_580_28 VPWR VGND sg13cmos5l_decap_8
X_2383_ _2383_/Q Tile_X0Y5_FrameData[22] VGND VPWR Tile_X0Y9_FrameStrobe[6] latch
X_4122_ _4122_/X _4093_/X _0057_/X _4092_/X Tile_X0Y0_S4END[10] _1469_/Q _1468_/Q
+ VPWR VGND sg13cmos5l_mux4_1
X_1334_ _1334_/Q Tile_X0Y1_FrameData[3] VGND VPWR Tile_X0Y9_FrameStrobe[4] latch
XFILLER_268_173 VPWR VGND sg13cmos5l_decap_4
XFILLER_417_126 VPWR VGND sg13cmos5l_decap_8
XFILLER_513_77 VPWR VGND sg13cmos5l_fill_2
X_1265_ _1265_/Q Tile_X0Y1_FrameData[8] VGND VPWR Tile_X0Y9_FrameStrobe[2] latch
X_4053_ _4053_/X Tile_X0Y2_W2END[2] AXI_M_SOC_AWREADY _4101_/X _4100_/X _1567_/Q _1566_/Q
+ VPWR VGND sg13cmos5l_mux4_1
XFILLER_232_34 VPWR VGND sg13cmos5l_decap_8
XFILLER_283_154 VPWR VGND sg13cmos5l_decap_8
X_3004_ Tile_X0Y5_E2BEG[7] _4379_/X VPWR VGND sg13cmos5l_buf_1
X_0216_ _0216_/Q Tile_X0Y7_FrameData[7] VGND VPWR Tile_X0Y9_FrameStrobe[1] latch
X_1196_ _1196_/Q Tile_X0Y1_FrameData[13] VGND VPWR Tile_X0Y9_FrameStrobe[0] latch
X_0147_ _3184_/A _3910_/X _3911_/X _1399_/Q VPWR VGND sg13cmos5l_mux2_1
XFILLER_36_175 VPWR VGND sg13cmos5l_decap_8
XFILLER_669_92 VPWR VGND sg13cmos5l_decap_8
XFILLER_101_38 VPWR VGND sg13cmos5l_decap_8
X_0078_ _0078_/X _3877_/X _3878_/X _2146_/Q VPWR VGND sg13cmos5l_mux2_1
XFILLER_385_217 VPWR VGND sg13cmos5l_fill_1
X_3906_ _3906_/X Tile_X0Y1_W1END[2] Tile_X0Y1_WW4END[2] Tile_X0Y1_W6END[10] _4010_/X
+ _1395_/Q _1394_/Q VPWR VGND sg13cmos5l_mux4_1
XFILLER_189_180 VPWR VGND sg13cmos5l_decap_8
X_4886_ _4886_/X AXI_M_SOC_RDATA2 _4921_/X _4925_/X _4905_/X _0771_/Q _0770_/Q VPWR
+ VGND sg13cmos5l_mux4_1
XFILLER_338_133 VPWR VGND sg13cmos5l_decap_4
X_3837_ _3837_/X _0086_/X Tile_X0Y0_S4END[1] _3868_/X _3867_/X _1031_/Q _1030_/Q VPWR
+ VGND sg13cmos5l_mux4_1
XFILLER_338_166 VPWR VGND sg13cmos5l_decap_8
X_3768_ _3768_/X Tile_X0Y1_WW4END[1] Tile_X0Y1_WW4END[9] Tile_X0Y1_W6END[9] _4017_/X
+ _1239_/Q _1238_/Q VPWR VGND sg13cmos5l_mux4_1
XFILLER_353_147 VPWR VGND sg13cmos5l_decap_4
XFILLER_353_158 VPWR VGND sg13cmos5l_decap_8
XFILLER_152_209 VPWR VGND sg13cmos5l_decap_8
X_2719_ _4656_/A3 VPWR VGND sg13cmos5l_tielo
X_3699_ AXI_M_SOC_WDATA9 Tile_X0Y7_WW4END[1] Tile_X0Y7_WW4END[9] Tile_X0Y7_W6END[9]
+ _4693_/X _0229_/Q _0228_/Q VPWR VGND sg13cmos5l_mux4_1
XFILLER_10_35 VPWR VGND sg13cmos5l_decap_8
XFILLER_554_84 VPWR VGND sg13cmos5l_decap_8
XFILLER_407_89 VPWR VGND sg13cmos5l_decap_8
XFILLER_126_35 VPWR VGND sg13cmos5l_fill_2
XFILLER_105_158 VPWR VGND sg13cmos5l_decap_8
XFILLER_704_21 VPWR VGND sg13cmos5l_decap_8
XFILLER_105_169 VPWR VGND sg13cmos5l_fill_2
XFILLER_510_144 VPWR VGND sg13cmos5l_fill_1
XFILLER_490_28 VPWR VGND sg13cmos5l_decap_8
XFILLER_273_63 VPWR VGND sg13cmos5l_decap_8
XFILLER_59_201 VPWR VGND sg13cmos5l_fill_1
XFILLER_120_117 VPWR VGND sg13cmos5l_decap_8
XFILLER_86_28 VPWR VGND sg13cmos5l_fill_2
XFILLER_120_128 VPWR VGND sg13cmos5l_fill_1
XFILLER_510_188 VPWR VGND sg13cmos5l_fill_2
XFILLER_408_104 VPWR VGND sg13cmos5l_fill_2
XFILLER_704_98 VPWR VGND sg13cmos5l_decap_8
XFILLER_664_170 VPWR VGND sg13cmos5l_fill_1
XFILLER_206_90 VPWR VGND sg13cmos5l_decap_8
XFILLER_423_77 VPWR VGND sg13cmos5l_decap_8
XFILLER_74_215 VPWR VGND sg13cmos5l_fill_2
XFILLER_374_7 VPWR VGND sg13cmos5l_decap_8
XFILLER_274_154 VPWR VGND sg13cmos5l_decap_4
XFILLER_19_99 VPWR VGND sg13cmos5l_fill_2
XFILLER_541_7 VPWR VGND sg13cmos5l_decap_8
XFILLER_35_21 VPWR VGND sg13cmos5l_decap_8
XFILLER_639_7 VPWR VGND sg13cmos5l_decap_8
XFILLER_579_70 VPWR VGND sg13cmos5l_decap_8
XFILLER_577_133 VPWR VGND sg13cmos5l_decap_8
XFILLER_42_134 VPWR VGND sg13cmos5l_fill_2
XFILLER_376_217 VPWR VGND sg13cmos5l_fill_1
XFILLER_577_199 VPWR VGND sg13cmos5l_fill_1
XFILLER_665_28 VPWR VGND sg13cmos5l_decap_8
XFILLER_592_169 VPWR VGND sg13cmos5l_fill_2
XFILLER_128_217 VPWR VGND sg13cmos5l_fill_1
XFILLER_533_214 VPWR VGND sg13cmos5l_decap_4
XFILLER_129_0 VPWR VGND sg13cmos5l_decap_8
XFILLER_51_97 VPWR VGND sg13cmos5l_decap_8
XFILLER_344_136 VPWR VGND sg13cmos5l_decap_8
XFILLER_143_209 VPWR VGND sg13cmos5l_fill_1
XFILLER_498_140 VPWR VGND sg13cmos5l_decap_8
XFILLER_297_202 VPWR VGND sg13cmos5l_decap_8
XFILLER_681_49 VPWR VGND sg13cmos5l_decap_8
XFILLER_352_191 VPWR VGND sg13cmos5l_fill_2
XFILLER_614_21 VPWR VGND sg13cmos5l_decap_8
XFILLER_501_133 VPWR VGND sg13cmos5l_decap_8
XFILLER_647_126 VPWR VGND sg13cmos5l_decap_8
XFILLER_498_0 VPWR VGND sg13cmos5l_decap_8
XFILLER_300_217 VPWR VGND sg13cmos5l_fill_1
XFILLER_662_118 VPWR VGND sg13cmos5l_fill_2
XFILLER_614_98 VPWR VGND sg13cmos5l_fill_2
XFILLER_265_121 VPWR VGND sg13cmos5l_decap_4
XFILLER_116_90 VPWR VGND sg13cmos5l_decap_8
XFILLER_665_0 VPWR VGND sg13cmos5l_decap_8
XFILLER_65_215 VPWR VGND sg13cmos5l_fill_2
XFILLER_18_7 VPWR VGND sg13cmos5l_decap_8
XFILLER_630_42 VPWR VGND sg13cmos5l_decap_8
XFILLER_265_176 VPWR VGND sg13cmos5l_fill_1
X_1050_ _1050_/Q Tile_X0Y0_FrameData[17] VGND VPWR Tile_X0Y9_FrameStrobe[3] latch
XFILLER_18_131 VPWR VGND sg13cmos5l_fill_2
XFILLER_670_195 VPWR VGND sg13cmos5l_decap_4
XFILLER_280_168 VPWR VGND sg13cmos5l_decap_8
XFILLER_489_70 VPWR VGND sg13cmos5l_decap_8
XFILLER_280_179 VPWR VGND sg13cmos5l_fill_2
XFILLER_568_133 VPWR VGND sg13cmos5l_decap_8
XFILLER_33_156 VPWR VGND sg13cmos5l_fill_2
XFILLER_178_117 VPWR VGND sg13cmos5l_decap_8
XFILLER_717_119 VPWR VGND sg13cmos5l_decap_8
X_4740_ _4740_/X Tile_X0Y8_W2END[3] AXI_M_SOC_RDATA11 _4791_/X _4790_/X _0567_/Q _0566_/Q
+ VPWR VGND sg13cmos5l_mux4_1
X_1952_ _1952_/Q Tile_X0Y4_FrameData[5] VGND VPWR Tile_X0Y9_FrameStrobe[0] latch
XFILLER_639_84 VPWR VGND sg13cmos5l_decap_8
XFILLER_583_147 VPWR VGND sg13cmos5l_decap_8
XFILLER_186_150 VPWR VGND sg13cmos5l_decap_8
X_0903_ _0903_/Q Tile_X0Y9_FrameData[24] VGND VPWR Tile_X0Y9_FrameStrobe[7] latch
XFILLER_575_28 VPWR VGND sg13cmos5l_decap_8
XFILLER_119_206 VPWR VGND sg13cmos5l_decap_4
X_4671_ _4671_/X _4587_/X _4703_/X _4702_/X _4586_/X _0181_/Q _0180_/Q VPWR VGND sg13cmos5l_mux4_1
XFILLER_358_63 VPWR VGND sg13cmos5l_decap_8
XFILLER_119_217 VPWR VGND sg13cmos5l_fill_1
X_1883_ _1883_/Q Tile_X0Y3_FrameData[14] VGND VPWR Tile_X0Y9_FrameStrobe[6] latch
X_3622_ Tile_X0Y9_S4BEG[0] _3622_/A VPWR VGND sg13cmos5l_buf_1
X_0834_ _0834_/Q Tile_X0Y9_FrameData[29] VGND VPWR Tile_X0Y9_FrameStrobe[5] latch
X_3553_ Tile_X0Y9_E6BEG[11] _4891_/X VPWR VGND sg13cmos5l_buf_1
XFILLER_508_77 VPWR VGND sg13cmos5l_decap_8
X_0765_ _0765_/Q Tile_X0Y9_FrameData[2] VGND VPWR Tile_X0Y9_FrameStrobe[2] latch
XFILLER_227_34 VPWR VGND sg13cmos5l_decap_8
XFILLER_350_128 VPWR VGND sg13cmos5l_fill_1
XFILLER_227_56 VPWR VGND sg13cmos5l_decap_8
X_2504_ _2504_/Q Tile_X0Y6_FrameData[31] VGND VPWR Tile_X0Y9_FrameStrobe[2] latch
X_3484_ Tile_X0Y1_EE4BEG[10] _3958_/X VPWR VGND sg13cmos5l_buf_1
XFILLER_591_49 VPWR VGND sg13cmos5l_decap_8
XFILLER_343_191 VPWR VGND sg13cmos5l_decap_8
X_0696_ _0696_/Q Tile_X0Y9_FrameData[7] VGND VPWR Tile_X0Y9_FrameStrobe[0] latch
XFILLER_524_21 VPWR VGND sg13cmos5l_decap_8
XFILLER_44_0 VPWR VGND sg13cmos5l_fill_1
XFILLER_638_126 VPWR VGND sg13cmos5l_decap_8
XFILLER_102_106 VPWR VGND sg13cmos5l_decap_8
X_2435_ _2435_/Q Tile_X0Y5_FrameData[2] VGND VPWR Tile_X0Y9_FrameStrobe[7] latch
X_2366_ _2366_/Q Tile_X0Y5_FrameData[7] VGND VPWR Tile_X0Y9_FrameStrobe[5] latch
XFILLER_256_110 VPWR VGND sg13cmos5l_decap_4
XFILLER_256_121 VPWR VGND sg13cmos5l_decap_8
X_4105_ _4105_/X Tile_X0Y6_W1END[0] Tile_X0Y6_WW4END[0] Tile_X0Y6_W6END[8] _4568_/X
+ _2671_/Q _2670_/Q VPWR VGND sg13cmos5l_mux4_1
XFILLER_390_72 VPWR VGND sg13cmos5l_fill_1
X_1317_ _1317_/Q Tile_X0Y1_FrameData[20] VGND VPWR Tile_X0Y9_FrameStrobe[4] latch
X_2297_ _2297_/Q Tile_X0Y5_FrameData[12] VGND VPWR Tile_X0Y9_FrameStrobe[3] latch
XFILLER_256_165 VPWR VGND sg13cmos5l_fill_2
XANTENNA__3204__X Tile_X0Y0_N2BEG[4] VPWR VGND sg13cmos5l_antennanp
XFILLER_110_183 VPWR VGND sg13cmos5l_fill_1
XFILLER_540_42 VPWR VGND sg13cmos5l_decap_8
X_4036_ _4036_/X _4089_/X Tile_X0Y2_WW4END[4] _4088_/X AXI_M_SOC_AWREADY _1601_/Q
+ _1600_/Q VPWR VGND sg13cmos5l_mux4_1
XFILLER_540_53 VPWR VGND sg13cmos5l_fill_1
X_1248_ _1248_/Q Tile_X0Y1_FrameData[25] VGND VPWR Tile_X0Y9_FrameStrobe[2] latch
XFILLER_256_198 VPWR VGND sg13cmos5l_decap_8
XFILLER_540_75 VPWR VGND sg13cmos5l_decap_8
X_1179_ _1179_/Q Tile_X0Y1_FrameData[30] VGND VPWR Tile_X0Y9_FrameStrobe[0] latch
XFILLER_399_70 VPWR VGND sg13cmos5l_decap_8
XFILLER_212_213 VPWR VGND sg13cmos5l_fill_1
XFILLER_358_217 VPWR VGND sg13cmos5l_fill_1
XFILLER_708_119 VPWR VGND sg13cmos5l_decap_8
X_4938_ _4938_/X Tile_X0Y8_W1END[2] Tile_X0Y8_W2MID[1] Tile_X0Y8_W2END[1] _4786_/X
+ _0615_/Q _0614_/Q VPWR VGND sg13cmos5l_mux4_1
XFILLER_574_136 VPWR VGND sg13cmos5l_decap_8
XFILLER_549_84 VPWR VGND sg13cmos5l_decap_8
XANTENNA_30 AXI_M_SOC_WREADY VPWR VGND sg13cmos5l_antennanp
XFILLER_485_28 VPWR VGND sg13cmos5l_decap_8
XFILLER_268_63 VPWR VGND sg13cmos5l_decap_8
XANTENNA_41 Tile_X0Y0_S2MID[3] VPWR VGND sg13cmos5l_antennanp
X_4869_ _4869_/X Tile_X0Y9_WW4END[10] AXI_M_SOC_RDATA5 _4926_/X _4905_/X _0805_/Q
+ _0804_/Q VPWR VGND sg13cmos5l_mux4_1
XANTENNA_52 _0040_/X VPWR VGND sg13cmos5l_antennanp
XFILLER_716_152 VPWR VGND sg13cmos5l_decap_8
XANTENNA_63 Tile_X0Y9_FrameStrobe[14] VPWR VGND sg13cmos5l_antennanp
XFILLER_268_96 VPWR VGND sg13cmos5l_fill_2
XANTENNA_74 Tile_X0Y9_N2MID[2] VPWR VGND sg13cmos5l_antennanp
XFILLER_122_7 VPWR VGND sg13cmos5l_decap_8
XFILLER_326_158 VPWR VGND sg13cmos5l_decap_8
XFILLER_418_77 VPWR VGND sg13cmos5l_decap_8
XFILLER_715_20 VPWR VGND sg13cmos5l_decap_8
XFILLER_137_56 VPWR VGND sg13cmos5l_decap_8
XFILLER_284_84 VPWR VGND sg13cmos5l_decap_8
XFILLER_434_21 VPWR VGND sg13cmos5l_decap_8
XFILLER_715_97 VPWR VGND sg13cmos5l_decap_8
XFILLER_491_7 VPWR VGND sg13cmos5l_decap_8
XFILLER_589_7 VPWR VGND sg13cmos5l_decap_8
XFILLER_581_60 VPWR VGND sg13cmos5l_fill_1
XFILLER_495_154 VPWR VGND sg13cmos5l_decap_8
XFILLER_581_71 VPWR VGND sg13cmos5l_decap_8
XFILLER_434_98 VPWR VGND sg13cmos5l_decap_8
XFILLER_495_198 VPWR VGND sg13cmos5l_decap_4
XFILLER_637_170 VPWR VGND sg13cmos5l_fill_1
XFILLER_303_14 VPWR VGND sg13cmos5l_decap_8
XFILLER_153_99 VPWR VGND sg13cmos5l_fill_1
XFILLER_652_140 VPWR VGND sg13cmos5l_decap_8
XANTENNA__3114__X Tile_X0Y7_EE4BEG[0] VPWR VGND sg13cmos5l_antennanp
XFILLER_451_202 VPWR VGND sg13cmos5l_decap_8
XFILLER_450_42 VPWR VGND sg13cmos5l_decap_8
XFILLER_247_176 VPWR VGND sg13cmos5l_decap_4
XFILLER_262_124 VPWR VGND sg13cmos5l_fill_2
XFILLER_62_207 VPWR VGND sg13cmos5l_fill_1
XFILLER_46_53 VPWR VGND sg13cmos5l_decap_8
XANTENNA__2953__X Tile_X0Y8_EE4BEG[9] VPWR VGND sg13cmos5l_antennanp
XFILLER_15_101 VPWR VGND sg13cmos5l_decap_4
XFILLER_600_56 VPWR VGND sg13cmos5l_decap_8
XFILLER_203_202 VPWR VGND sg13cmos5l_fill_2
XFILLER_15_156 VPWR VGND sg13cmos5l_decap_8
XFILLER_102_70 VPWR VGND sg13cmos5l_decap_8
XFILLER_246_0 VPWR VGND sg13cmos5l_decap_8
XFILLER_676_49 VPWR VGND sg13cmos5l_decap_8
XFILLER_459_73 VPWR VGND sg13cmos5l_decap_8
XFILLER_565_147 VPWR VGND sg13cmos5l_fill_2
XFILLER_178_30 VPWR VGND sg13cmos5l_fill_2
XFILLER_609_21 VPWR VGND sg13cmos5l_decap_8
XFILLER_175_109 VPWR VGND sg13cmos5l_decap_8
XFILLER_30_148 VPWR VGND sg13cmos5l_decap_4
XFILLER_395_28 VPWR VGND sg13cmos5l_decap_8
XFILLER_168_172 VPWR VGND sg13cmos5l_decap_8
XFILLER_7_14 VPWR VGND sg13cmos5l_decap_8
XFILLER_413_0 VPWR VGND sg13cmos5l_decap_8
XFILLER_707_174 VPWR VGND sg13cmos5l_fill_2
XFILLER_178_96 VPWR VGND sg13cmos5l_decap_8
XFILLER_609_87 VPWR VGND sg13cmos5l_decap_8
XFILLER_328_44 VPWR VGND sg13cmos5l_fill_1
XFILLER_328_66 VPWR VGND sg13cmos5l_decap_8
XFILLER_475_83 VPWR VGND sg13cmos5l_fill_1
XFILLER_183_186 VPWR VGND sg13cmos5l_decap_8
XFILLER_332_128 VPWR VGND sg13cmos5l_decap_4
XFILLER_625_42 VPWR VGND sg13cmos5l_decap_8
X_0550_ _0550_/Q Tile_X0Y8_FrameData[25] VGND VPWR Tile_X0Y9_FrameStrobe[4] latch
XFILLER_194_84 VPWR VGND sg13cmos5l_decap_8
XFILLER_486_121 VPWR VGND sg13cmos5l_fill_1
XFILLER_344_21 VPWR VGND sg13cmos5l_decap_8
XFILLER_340_150 VPWR VGND sg13cmos5l_decap_8
XFILLER_486_143 VPWR VGND sg13cmos5l_decap_8
X_0481_ _0481_/Q Tile_X0Y8_FrameData[30] VGND VPWR Tile_X0Y9_FrameStrobe[2] latch
XFILLER_285_205 VPWR VGND sg13cmos5l_decap_8
XFILLER_285_216 VPWR VGND sg13cmos5l_fill_2
XFILLER_87_60 VPWR VGND sg13cmos5l_decap_8
X_2220_ _2220_/Q Tile_X0Y5_FrameData[25] VGND VPWR Tile_X0Y9_FrameStrobe[1] latch
XFILLER_486_187 VPWR VGND sg13cmos5l_decap_8
XFILLER_344_98 VPWR VGND sg13cmos5l_decap_4
XFILLER_238_132 VPWR VGND sg13cmos5l_decap_8
X_2151_ _2151_/Q Tile_X0Y4_FrameData[30] VGND VPWR Tile_X0Y9_FrameStrobe[7] latch
XFILLER_641_63 VPWR VGND sg13cmos5l_decap_8
XFILLER_38_215 VPWR VGND sg13cmos5l_fill_2
XFILLER_213_14 VPWR VGND sg13cmos5l_decap_8
XFILLER_643_140 VPWR VGND sg13cmos5l_decap_8
XANTENNA__3024__X Tile_X0Y5_E6BEG[11] VPWR VGND sg13cmos5l_antennanp
XFILLER_360_42 VPWR VGND sg13cmos5l_decap_8
X_1102_ _1102_/Q Tile_X0Y0_FrameData[29] VGND VPWR Tile_X0Y9_FrameStrobe[5] latch
XFILLER_253_113 VPWR VGND sg13cmos5l_decap_8
XFILLER_238_187 VPWR VGND sg13cmos5l_fill_2
X_2082_ _2082_/Q Tile_X0Y4_FrameData[3] VGND VPWR Tile_X0Y9_FrameStrobe[4] latch
XFILLER_588_217 VPWR VGND sg13cmos5l_fill_1
X_1033_ _1033_/Q Tile_X0Y0_FrameData[2] VGND VPWR Tile_X0Y9_FrameStrobe[2] latch
XANTENNA__2863__X Tile_X0Y6_EE4BEG[0] VPWR VGND sg13cmos5l_antennanp
XFILLER_510_56 VPWR VGND sg13cmos5l_decap_8
X_2984_ Tile_X0Y8_FrameData_O[24] Tile_X0Y8_FrameData[24] VPWR VGND sg13cmos5l_buf_1
XFILLER_586_49 VPWR VGND sg13cmos5l_decap_8
XFILLER_519_21 VPWR VGND sg13cmos5l_decap_8
X_4723_ _4723_/X _4807_/X _4811_/X _4815_/X _4784_/X _0602_/Q _0601_/Q VPWR VGND sg13cmos5l_mux4_1
X_1935_ _1935_/Q Tile_X0Y4_FrameData[22] VGND VPWR Tile_X0Y9_FrameStrobe[0] latch
XANTENNA__3694__X AXI_M_SOC_WDATA4 VPWR VGND sg13cmos5l_antennanp
X_4654_ _4654_/X AXI_M_SOC_RDATA22 _4685_/X _4689_/X _4670_/X _0251_/Q _0250_/Q VPWR
+ VGND sg13cmos5l_mux4_1
X_1866_ _1866_/Q Tile_X0Y3_FrameData[31] VGND VPWR Tile_X0Y9_FrameStrobe[6] latch
XFILLER_564_191 VPWR VGND sg13cmos5l_decap_4
XFILLER_713_133 VPWR VGND sg13cmos5l_decap_8
XFILLER_238_66 VPWR VGND sg13cmos5l_decap_8
X_3605_ Tile_X0Y9_S1BEG[3] _4827_/X VPWR VGND sg13cmos5l_buf_1
X_0817_ _0817_/Q Tile_X0Y9_FrameData[14] VGND VPWR Tile_X0Y9_FrameStrobe[4] latch
X_4585_ _4585_/X Tile_X0Y8_W2MID[7] Tile_X0Y8_W2END[7] Tile_X0Y8_W6END[7] _4785_/X
+ _0663_/Q _0662_/Q VPWR VGND sg13cmos5l_mux4_1
XFILLER_174_186 VPWR VGND sg13cmos5l_fill_1
X_1797_ _1797_/Q Tile_X0Y3_FrameData[4] VGND VPWR Tile_X0Y9_FrameStrobe[3] latch
XFILLER_323_128 VPWR VGND sg13cmos5l_fill_2
XFILLER_535_42 VPWR VGND sg13cmos5l_decap_8
X_3536_ Tile_X0Y9_E2BEGb[2] _4858_/X VPWR VGND sg13cmos5l_buf_1
XFILLER_535_53 VPWR VGND sg13cmos5l_fill_1
X_0748_ _0748_/Q Tile_X0Y9_FrameData[19] VGND VPWR Tile_X0Y9_FrameStrobe[2] latch
XFILLER_682_70 VPWR VGND sg13cmos5l_decap_4
XFILLER_254_21 VPWR VGND sg13cmos5l_decap_8
XFILLER_682_81 VPWR VGND sg13cmos5l_decap_8
XFILLER_535_86 VPWR VGND sg13cmos5l_decap_8
XFILLER_107_48 VPWR VGND sg13cmos5l_decap_8
X_3467_ Tile_X0Y1_FrameData_O[25] Tile_X0Y1_FrameData[25] VPWR VGND sg13cmos5l_buf_1
X_0679_ _0679_/Q Tile_X0Y9_FrameData[24] VGND VPWR Tile_X0Y9_FrameStrobe[0] latch
XFILLER_477_165 VPWR VGND sg13cmos5l_decap_8
XFILLER_276_216 VPWR VGND sg13cmos5l_fill_2
X_2418_ _2418_/Q Tile_X0Y5_FrameData[19] VGND VPWR Tile_X0Y9_FrameStrobe[7] latch
X_3398_ Tile_X0Y2_E2BEG[1] _4041_/X VPWR VGND sg13cmos5l_buf_1
XFILLER_404_35 VPWR VGND sg13cmos5l_decap_8
X_2349_ _2349_/Q Tile_X0Y5_FrameData[24] VGND VPWR Tile_X0Y9_FrameStrobe[5] latch
XFILLER_123_14 VPWR VGND sg13cmos5l_decap_8
XFILLER_551_85 VPWR VGND sg13cmos5l_decap_8
XFILLER_492_179 VPWR VGND sg13cmos5l_decap_8
XFILLER_96_192 VPWR VGND sg13cmos5l_decap_8
XFILLER_270_42 VPWR VGND sg13cmos5l_decap_8
XFILLER_579_217 VPWR VGND sg13cmos5l_fill_1
XANTENNA__2773__X Tile_X0Y3_FrameData_O[31] VPWR VGND sg13cmos5l_antennanp
X_4019_ _4019_/X _3987_/X _0084_/X _3986_/X Tile_X0Y0_S4END[7] _1211_/Q _1210_/Q VPWR
+ VGND sg13cmos5l_mux4_1
XFILLER_701_77 VPWR VGND sg13cmos5l_decap_8
XFILLER_420_56 VPWR VGND sg13cmos5l_decap_8
XFILLER_203_91 VPWR VGND sg13cmos5l_decap_8
XFILLER_16_56 VPWR VGND sg13cmos5l_fill_2
XFILLER_398_183 VPWR VGND sg13cmos5l_decap_8
XFILLER_547_125 VPWR VGND sg13cmos5l_decap_4
XFILLER_279_62 VPWR VGND sg13cmos5l_decap_8
XFILLER_496_49 VPWR VGND sg13cmos5l_decap_8
XFILLER_401_154 VPWR VGND sg13cmos5l_decap_8
XFILLER_337_7 VPWR VGND sg13cmos5l_decap_8
XFILLER_429_21 VPWR VGND sg13cmos5l_decap_8
XFILLER_232_6 VPWR VGND sg13cmos5l_decap_8
XFILLER_562_128 VPWR VGND sg13cmos5l_decap_8
XFILLER_32_55 VPWR VGND sg13cmos5l_decap_4
XFILLER_504_7 VPWR VGND sg13cmos5l_decap_8
XFILLER_429_98 VPWR VGND sg13cmos5l_decap_8
XFILLER_704_133 VPWR VGND sg13cmos5l_decap_8
XFILLER_32_99 VPWR VGND sg13cmos5l_decap_4
XFILLER_148_66 VPWR VGND sg13cmos5l_decap_8
XFILLER_570_161 VPWR VGND sg13cmos5l_decap_8
XFILLER_314_117 VPWR VGND sg13cmos5l_decap_8
XFILLER_503_217 VPWR VGND sg13cmos5l_fill_1
XFILLER_704_177 VPWR VGND sg13cmos5l_fill_1
XANTENNA__3109__X Tile_X0Y7_E6BEG[7] VPWR VGND sg13cmos5l_antennanp
XFILLER_445_42 VPWR VGND sg13cmos5l_fill_1
XFILLER_704_199 VPWR VGND sg13cmos5l_fill_2
XFILLER_164_21 VPWR VGND sg13cmos5l_decap_8
XFILLER_164_54 VPWR VGND sg13cmos5l_decap_8
XANTENNA__2948__X Tile_X0Y8_EE4BEG[4] VPWR VGND sg13cmos5l_antennanp
XFILLER_322_172 VPWR VGND sg13cmos5l_decap_8
XFILLER_468_165 VPWR VGND sg13cmos5l_decap_8
XFILLER_267_216 VPWR VGND sg13cmos5l_fill_2
XFILLER_468_176 VPWR VGND sg13cmos5l_fill_2
XFILLER_164_87 VPWR VGND sg13cmos5l_decap_4
XFILLER_164_98 VPWR VGND sg13cmos5l_decap_8
XFILLER_314_35 VPWR VGND sg13cmos5l_decap_8
XFILLER_196_0 VPWR VGND sg13cmos5l_fill_2
XFILLER_314_68 VPWR VGND sg13cmos5l_fill_1
XFILLER_180_20 VPWR VGND sg13cmos5l_decap_8
XFILLER_57_74 VPWR VGND sg13cmos5l_decap_8
XFILLER_235_102 VPWR VGND sg13cmos5l_fill_2
XFILLER_363_0 VPWR VGND sg13cmos5l_fill_2
XANTENNA__3779__X AXI_M_SOC_RREADY VPWR VGND sg13cmos5l_antennanp
XFILLER_640_154 VPWR VGND sg13cmos5l_decap_8
XFILLER_330_56 VPWR VGND sg13cmos5l_decap_8
XFILLER_640_198 VPWR VGND sg13cmos5l_fill_2
XFILLER_389_161 VPWR VGND sg13cmos5l_decap_8
XFILLER_73_73 VPWR VGND sg13cmos5l_decap_8
XFILLER_530_0 VPWR VGND sg13cmos5l_decap_8
XFILLER_628_0 VPWR VGND sg13cmos5l_fill_2
XFILLER_189_84 VPWR VGND sg13cmos5l_decap_8
XFILLER_339_21 VPWR VGND sg13cmos5l_decap_8
XFILLER_85_7 VPWR VGND sg13cmos5l_decap_8
X_1720_ _1720_/Q Tile_X0Y3_FrameData[17] VGND VPWR Tile_X0Y9_FrameStrobe[1] latch
XFILLER_11_170 VPWR VGND sg13cmos5l_decap_8
XFILLER_7_130 VPWR VGND sg13cmos5l_decap_4
XFILLER_171_101 VPWR VGND sg13cmos5l_fill_2
X_1651_ _1651_/Q Tile_X0Y2_FrameData[30] VGND VPWR Tile_X0Y9_FrameStrobe[7] latch
XFILLER_636_63 VPWR VGND sg13cmos5l_decap_8
XFILLER_561_172 VPWR VGND sg13cmos5l_decap_4
XANTENNA__3019__X Tile_X0Y5_E6BEG[6] VPWR VGND sg13cmos5l_antennanp
XFILLER_355_42 VPWR VGND sg13cmos5l_decap_8
X_0602_ _0602_/Q Tile_X0Y8_FrameData[5] VGND VPWR Tile_X0Y9_FrameStrobe[5] latch
X_4370_ _4370_/X _4424_/X _4423_/X AXI_M_SOC_RLAST _4422_/X _2363_/Q _2362_/Q VPWR
+ VGND sg13cmos5l_mux4_1
X_1582_ _1582_/Q Tile_X0Y2_FrameData[3] VGND VPWR Tile_X0Y9_FrameStrobe[4] latch
XFILLER_710_147 VPWR VGND sg13cmos5l_decap_8
XFILLER_648_210 VPWR VGND sg13cmos5l_decap_8
XFILLER_208_69 VPWR VGND sg13cmos5l_decap_8
XFILLER_98_70 VPWR VGND sg13cmos5l_decap_8
X_3321_ Tile_X0Y4_EE4BEG[9] _4281_/X VPWR VGND sg13cmos5l_buf_1
XFILLER_112_201 VPWR VGND sg13cmos5l_decap_8
X_0533_ _0533_/Q Tile_X0Y8_FrameData[10] VGND VPWR Tile_X0Y9_FrameStrobe[3] latch
XFILLER_459_143 VPWR VGND sg13cmos5l_decap_4
XANTENNA__2858__X Tile_X0Y6_E6BEG[7] VPWR VGND sg13cmos5l_antennanp
XFILLER_505_56 VPWR VGND sg13cmos5l_decap_8
XFILLER_313_194 VPWR VGND sg13cmos5l_fill_1
X_3252_ Tile_X0Y0_FrameData_O[20] Tile_X0Y0_FrameData[20] VPWR VGND sg13cmos5l_buf_1
X_0464_ _0464_/Q Tile_X0Y8_FrameData[15] VGND VPWR Tile_X0Y9_FrameStrobe[1] latch
XFILLER_652_84 VPWR VGND sg13cmos5l_decap_8
XFILLER_224_35 VPWR VGND sg13cmos5l_decap_8
X_2203_ _2203_/Q Tile_X0Y5_FrameData[10] VGND VPWR Tile_X0Y9_FrameStrobe[0] latch
XFILLER_85_129 VPWR VGND sg13cmos5l_decap_8
X_3183_ Tile_X0Y0_N4BEG[7] _3183_/A VPWR VGND sg13cmos5l_buf_1
X_0395_ _0395_/Q Tile_X0Y7_FrameData[20] VGND VPWR Tile_X0Y9_FrameStrobe[7] latch
XFILLER_415_202 VPWR VGND sg13cmos5l_decap_4
X_2134_ _2134_/Q Tile_X0Y4_FrameData[15] VGND VPWR Tile_X0Y9_FrameStrobe[6] latch
XFILLER_304_90 VPWR VGND sg13cmos5l_fill_2
XFILLER_226_146 VPWR VGND sg13cmos5l_decap_8
XANTENNA__3689__X AXI_M_SOC_AWVALID VPWR VGND sg13cmos5l_antennanp
X_2065_ _2065_/Q Tile_X0Y4_FrameData[20] VGND VPWR Tile_X0Y9_FrameStrobe[4] latch
XFILLER_240_56 VPWR VGND sg13cmos5l_decap_4
XFILLER_631_176 VPWR VGND sg13cmos5l_decap_8
X_1016_ _1016_/Q Tile_X0Y0_FrameData[19] VGND VPWR Tile_X0Y9_FrameStrobe[2] latch
XFILLER_240_78 VPWR VGND sg13cmos5l_fill_1
XFILLER_179_201 VPWR VGND sg13cmos5l_decap_4
XFILLER_677_70 VPWR VGND sg13cmos5l_decap_8
XFILLER_249_21 VPWR VGND sg13cmos5l_decap_8
XFILLER_194_215 VPWR VGND sg13cmos5l_fill_2
X_2967_ Tile_X0Y8_FrameData_O[7] Tile_X0Y8_FrameData[7] VPWR VGND sg13cmos5l_buf_1
XFILLER_395_197 VPWR VGND sg13cmos5l_decap_8
XFILLER_249_76 VPWR VGND sg13cmos5l_decap_8
X_1918_ _1918_/Q Tile_X0Y3_FrameData[11] VGND VPWR Tile_X0Y9_FrameStrobe[7] latch
X_4706_ _4706_/X Tile_X0Y6_W2MID[4] Tile_X0Y6_W2END[4] Tile_X0Y6_W6END[11] _4559_/X
+ _2645_/Q _2644_/Q VPWR VGND sg13cmos5l_mux4_1
XFILLER_249_87 VPWR VGND sg13cmos5l_fill_2
XFILLER_147_142 VPWR VGND sg13cmos5l_fill_1
X_2898_ Tile_X0Y6_FrameData_O[19] Tile_X0Y6_FrameData[19] VPWR VGND sg13cmos5l_buf_1
XFILLER_147_164 VPWR VGND sg13cmos5l_decap_8
X_4637_ _4637_/X Tile_X0Y7_WW4END[6] AXI_M_SOC_RDATA22 _4690_/X _4670_/X _0285_/Q
+ _0284_/Q VPWR VGND sg13cmos5l_mux4_1
XFILLER_546_63 VPWR VGND sg13cmos5l_decap_8
X_1849_ _1849_/Q Tile_X0Y3_FrameData[16] VGND VPWR Tile_X0Y9_FrameStrobe[5] latch
XFILLER_162_112 VPWR VGND sg13cmos5l_decap_8
XFILLER_118_14 VPWR VGND sg13cmos5l_decap_8
XFILLER_693_91 VPWR VGND sg13cmos5l_decap_8
XFILLER_497_216 VPWR VGND sg13cmos5l_fill_2
XFILLER_265_42 VPWR VGND sg13cmos5l_decap_8
X_4568_ _4568_/X _4545_/X Tile_X0Y9_N4END[12] _4544_/X _0152_/X _2495_/Q _2494_/Q
+ VPWR VGND sg13cmos5l_mux4_1
XFILLER_639_210 VPWR VGND sg13cmos5l_fill_2
XFILLER_162_189 VPWR VGND sg13cmos5l_decap_8
XANTENNA__2768__X Tile_X0Y3_FrameData_O[26] VPWR VGND sg13cmos5l_antennanp
X_3519_ Tile_X0Y1_E1BEG[1] _3929_/X VPWR VGND sg13cmos5l_buf_1
X_4499_ _4499_/X Tile_X0Y6_W2MID[4] AXI_M_SOC_RDATA27 _4559_/X _4558_/X _2609_/Q _2608_/Q
+ VPWR VGND sg13cmos5l_mux4_1
XFILLER_249_205 VPWR VGND sg13cmos5l_fill_1
XFILLER_415_56 VPWR VGND sg13cmos5l_decap_8
XFILLER_465_113 VPWR VGND sg13cmos5l_fill_2
XFILLER_562_84 VPWR VGND sg13cmos5l_decap_8
XFILLER_134_35 VPWR VGND sg13cmos5l_decap_8
XFILLER_712_21 VPWR VGND sg13cmos5l_decap_8
XFILLER_281_63 VPWR VGND sg13cmos5l_decap_8
XFILLER_264_208 VPWR VGND sg13cmos5l_decap_8
XFILLER_465_168 VPWR VGND sg13cmos5l_decap_8
XFILLER_94_28 VPWR VGND sg13cmos5l_decap_8
XFILLER_287_7 VPWR VGND sg13cmos5l_decap_8
XFILLER_480_116 VPWR VGND sg13cmos5l_decap_4
XFILLER_182_6 VPWR VGND sg13cmos5l_decap_8
XFILLER_712_98 VPWR VGND sg13cmos5l_decap_8
XFILLER_480_149 VPWR VGND sg13cmos5l_fill_1
XFILLER_217_146 VPWR VGND sg13cmos5l_decap_8
XANTENNA__3599__X Tile_X0Y9_FrameData_O[29] VPWR VGND sg13cmos5l_antennanp
XFILLER_431_77 VPWR VGND sg13cmos5l_decap_8
XFILLER_454_7 VPWR VGND sg13cmos5l_decap_8
XFILLER_232_127 VPWR VGND sg13cmos5l_fill_2
XFILLER_621_7 VPWR VGND sg13cmos5l_decap_8
XFILLER_386_142 VPWR VGND sg13cmos5l_decap_8
XFILLER_300_59 VPWR VGND sg13cmos5l_decap_8
XFILLER_386_164 VPWR VGND sg13cmos5l_decap_4
XFILLER_159_43 VPWR VGND sg13cmos5l_decap_4
XFILLER_159_54 VPWR VGND sg13cmos5l_decap_8
XFILLER_535_117 VPWR VGND sg13cmos5l_decap_8
XFILLER_309_35 VPWR VGND sg13cmos5l_fill_1
XFILLER_673_28 VPWR VGND sg13cmos5l_decap_8
XFILLER_309_57 VPWR VGND sg13cmos5l_decap_4
XFILLER_456_63 VPWR VGND sg13cmos5l_decap_8
XFILLER_689_154 VPWR VGND sg13cmos5l_decap_8
XFILLER_111_0 VPWR VGND sg13cmos5l_decap_8
XFILLER_4_111 VPWR VGND sg13cmos5l_fill_2
XFILLER_488_216 VPWR VGND sg13cmos5l_fill_2
XFILLER_209_0 VPWR VGND sg13cmos5l_decap_8
XFILLER_175_42 VPWR VGND sg13cmos5l_decap_8
XFILLER_472_51 VPWR VGND sg13cmos5l_fill_1
XFILLER_325_56 VPWR VGND sg13cmos5l_decap_8
XFILLER_472_73 VPWR VGND sg13cmos5l_fill_1
XFILLER_310_131 VPWR VGND sg13cmos5l_fill_2
XFILLER_622_21 VPWR VGND sg13cmos5l_decap_8
XFILLER_480_0 VPWR VGND sg13cmos5l_decap_8
XFILLER_191_41 VPWR VGND sg13cmos5l_decap_8
XFILLER_67_129 VPWR VGND sg13cmos5l_decap_8
XFILLER_578_0 VPWR VGND sg13cmos5l_decap_8
XFILLER_191_85 VPWR VGND sg13cmos5l_decap_8
X_0180_ _0180_/Q Tile_X0Y7_FrameData[11] VGND VPWR Tile_X0Y9_FrameStrobe[0] latch
XFILLER_698_14 VPWR VGND sg13cmos5l_decap_8
XFILLER_622_98 VPWR VGND sg13cmos5l_decap_8
XFILLER_75_173 VPWR VGND sg13cmos5l_fill_2
XFILLER_341_77 VPWR VGND sg13cmos5l_decap_8
XFILLER_208_157 VPWR VGND sg13cmos5l_decap_8
XANTENNA__3302__X Tile_X0Y0_E2BEG[2] VPWR VGND sg13cmos5l_antennanp
XFILLER_90_165 VPWR VGND sg13cmos5l_fill_2
XFILLER_613_198 VPWR VGND sg13cmos5l_fill_1
XFILLER_210_48 VPWR VGND sg13cmos5l_decap_8
X_3870_ _3870_/X _4341_/X _4345_/X _4349_/X _4315_/X _2154_/Q _2153_/Q VPWR VGND sg13cmos5l_mux4_1
XFILLER_497_70 VPWR VGND sg13cmos5l_decap_8
XFILLER_377_153 VPWR VGND sg13cmos5l_decap_4
XFILLER_231_171 VPWR VGND sg13cmos5l_fill_2
X_2821_ Tile_X0Y3_E1BEG[3] _4147_/X VPWR VGND sg13cmos5l_buf_1
XFILLER_519_180 VPWR VGND sg13cmos5l_fill_2
X_2752_ Tile_X0Y3_FrameData_O[10] Tile_X0Y3_FrameData[10] VPWR VGND sg13cmos5l_buf_1
XFILLER_219_13 VPWR VGND sg13cmos5l_decap_8
XFILLER_647_84 VPWR VGND sg13cmos5l_decap_8
X_1703_ _1703_/Q Tile_X0Y3_FrameData[2] VGND VPWR Tile_X0Y9_FrameStrobe[0] latch
XFILLER_583_28 VPWR VGND sg13cmos5l_decap_8
XFILLER_366_63 VPWR VGND sg13cmos5l_decap_8
X_2683_ _2683_/Q Tile_X0Y6_FrameData[12] VGND VPWR Tile_X0Y9_FrameStrobe[7] latch
XFILLER_69_2 VPWR VGND sg13cmos5l_fill_1
X_4422_ _4422_/X _4424_/X Tile_X0Y5_W6END[2] _4423_/X _4422_/A3 _2185_/Q _2184_/Q
+ VPWR VGND sg13cmos5l_mux4_1
X_1634_ _1634_/Q Tile_X0Y2_FrameData[15] VGND VPWR Tile_X0Y9_FrameStrobe[6] latch
XFILLER_695_146 VPWR VGND sg13cmos5l_fill_2
X_4353_ _4353_/X Tile_X0Y6_W2MID[7] Tile_X0Y6_W2END[7] Tile_X0Y6_W6END[7] _4553_/X
+ _2687_/Q _2686_/Q VPWR VGND sg13cmos5l_mux4_1
XFILLER_494_208 VPWR VGND sg13cmos5l_fill_1
X_1565_ _1565_/Q Tile_X0Y2_FrameData[20] VGND VPWR Tile_X0Y9_FrameStrobe[4] latch
XFILLER_382_51 VPWR VGND sg13cmos5l_decap_8
X_3304_ Tile_X0Y0_E2BEG[4] _3808_/X VPWR VGND sg13cmos5l_buf_1
XFILLER_636_202 VPWR VGND sg13cmos5l_fill_1
XFILLER_382_62 VPWR VGND sg13cmos5l_fill_1
XFILLER_301_120 VPWR VGND sg13cmos5l_fill_2
X_0516_ _0516_/Q Tile_X0Y8_FrameData[27] VGND VPWR Tile_X0Y9_FrameStrobe[3] latch
X_4284_ _4284_/X Tile_X0Y4_WW4END[3] AXI_M_SOC_BRESP1 _4339_/X _4319_/X _2045_/Q _2044_/Q
+ VPWR VGND sg13cmos5l_mux4_1
XFILLER_382_84 VPWR VGND sg13cmos5l_decap_8
X_1496_ _1496_/Q Tile_X0Y2_FrameData[25] VGND VPWR Tile_X0Y9_FrameStrobe[2] latch
XFILLER_532_21 VPWR VGND sg13cmos5l_decap_8
XFILLER_100_215 VPWR VGND sg13cmos5l_fill_2
X_3235_ Tile_X0Y0_FrameData_O[3] Tile_X0Y0_FrameData[3] VPWR VGND sg13cmos5l_buf_1
X_0447_ _0447_/Q Tile_X0Y8_FrameData[0] VGND VPWR Tile_X0Y9_FrameStrobe[0] latch
XFILLER_447_179 VPWR VGND sg13cmos5l_decap_8
XFILLER_66_140 VPWR VGND sg13cmos5l_decap_8
XFILLER_462_127 VPWR VGND sg13cmos5l_fill_2
X_3166_ Tile_X0Y4_E6BEG[3] _4291_/X VPWR VGND sg13cmos5l_buf_1
X_0378_ _0378_/Q Tile_X0Y7_FrameData[5] VGND VPWR Tile_X0Y9_FrameStrobe[6] latch
XFILLER_251_77 VPWR VGND sg13cmos5l_decap_8
X_2117_ _2117_/Q Tile_X0Y4_FrameData[0] VGND VPWR Tile_X0Y9_FrameStrobe[5] latch
XFILLER_401_14 VPWR VGND sg13cmos5l_decap_8
X_3097_ Tile_X0Y7_E2BEGb[3] _4623_/X VPWR VGND sg13cmos5l_buf_1
XFILLER_214_105 VPWR VGND sg13cmos5l_decap_8
XANTENNA__3212__X Tile_X0Y0_FrameStrobe_O[0] VPWR VGND sg13cmos5l_antennanp
XFILLER_214_127 VPWR VGND sg13cmos5l_decap_8
XFILLER_604_187 VPWR VGND sg13cmos5l_decap_8
XFILLER_470_182 VPWR VGND sg13cmos5l_decap_4
X_2048_ _2048_/Q Tile_X0Y4_FrameData[5] VGND VPWR Tile_X0Y9_FrameStrobe[3] latch
XFILLER_81_198 VPWR VGND sg13cmos5l_decap_8
XFILLER_120_48 VPWR VGND sg13cmos5l_fill_2
XFILLER_222_182 VPWR VGND sg13cmos5l_decap_8
XFILLER_167_215 VPWR VGND sg13cmos5l_fill_2
XFILLER_200_70 VPWR VGND sg13cmos5l_decap_8
XFILLER_706_217 VPWR VGND sg13cmos5l_fill_1
X_3999_ _3999_/X _3985_/X _0095_/X _3984_/X Tile_X0Y0_S4END[6] _1205_/Q _1204_/Q VPWR
+ VGND sg13cmos5l_mux4_1
XFILLER_13_35 VPWR VGND sg13cmos5l_decap_8
XFILLER_557_84 VPWR VGND sg13cmos5l_decap_8
XFILLER_129_35 VPWR VGND sg13cmos5l_decap_4
XFILLER_707_21 VPWR VGND sg13cmos5l_decap_8
XFILLER_493_28 VPWR VGND sg13cmos5l_decap_8
XFILLER_276_63 VPWR VGND sg13cmos5l_decap_8
XFILLER_135_112 VPWR VGND sg13cmos5l_decap_8
XFILLER_129_68 VPWR VGND sg13cmos5l_decap_8
XFILLER_89_28 VPWR VGND sg13cmos5l_fill_2
XFILLER_686_102 VPWR VGND sg13cmos5l_decap_4
XFILLER_202_7 VPWR VGND sg13cmos5l_decap_8
XFILLER_540_131 VPWR VGND sg13cmos5l_decap_8
XFILLER_707_98 VPWR VGND sg13cmos5l_decap_8
XFILLER_426_77 VPWR VGND sg13cmos5l_decap_8
XFILLER_1_147 VPWR VGND sg13cmos5l_fill_1
XFILLER_292_84 VPWR VGND sg13cmos5l_decap_4
XFILLER_442_21 VPWR VGND sg13cmos5l_decap_8
XFILLER_571_7 VPWR VGND sg13cmos5l_decap_8
XFILLER_669_7 VPWR VGND sg13cmos5l_decap_8
XFILLER_442_98 VPWR VGND sg13cmos5l_decap_8
XFILLER_161_66 VPWR VGND sg13cmos5l_decap_8
XFILLER_311_14 VPWR VGND sg13cmos5l_decap_8
XFILLER_72_121 VPWR VGND sg13cmos5l_decap_4
XFILLER_205_105 VPWR VGND sg13cmos5l_decap_8
XFILLER_72_132 VPWR VGND sg13cmos5l_decap_8
XANTENNA__3122__X Tile_X0Y7_EE4BEG[8] VPWR VGND sg13cmos5l_antennanp
XFILLER_668_28 VPWR VGND sg13cmos5l_fill_2
XFILLER_159_0 VPWR VGND sg13cmos5l_fill_2
XFILLER_54_86 VPWR VGND sg13cmos5l_decap_8
XANTENNA__2961__X Tile_X0Y8_FrameData_O[1] VPWR VGND sg13cmos5l_antennanp
XFILLER_359_153 VPWR VGND sg13cmos5l_decap_8
XFILLER_158_215 VPWR VGND sg13cmos5l_fill_2
XFILLER_213_193 VPWR VGND sg13cmos5l_decap_4
XFILLER_326_0 VPWR VGND sg13cmos5l_decap_8
XFILLER_70_63 VPWR VGND sg13cmos5l_decap_8
XFILLER_684_49 VPWR VGND sg13cmos5l_decap_8
XFILLER_617_21 VPWR VGND sg13cmos5l_decap_8
XFILLER_126_101 VPWR VGND sg13cmos5l_decap_8
XFILLER_186_85 VPWR VGND sg13cmos5l_decap_8
XFILLER_617_98 VPWR VGND sg13cmos5l_decap_8
XFILLER_695_0 VPWR VGND sg13cmos5l_decap_8
XFILLER_79_61 VPWR VGND sg13cmos5l_decap_8
XFILLER_677_168 VPWR VGND sg13cmos5l_decap_8
XFILLER_531_186 VPWR VGND sg13cmos5l_decap_8
XFILLER_633_42 VPWR VGND sg13cmos5l_decap_8
X_1350_ _1350_/Q Tile_X0Y1_FrameData[19] VGND VPWR Tile_X0Y9_FrameStrobe[5] latch
XFILLER_692_149 VPWR VGND sg13cmos5l_fill_1
XFILLER_352_21 VPWR VGND sg13cmos5l_decap_8
X_0301_ _0301_/Q Tile_X0Y7_FrameData[18] VGND VPWR Tile_X0Y9_FrameStrobe[4] latch
X_1281_ _1281_/Q Tile_X0Y1_FrameData[24] VGND VPWR Tile_X0Y9_FrameStrobe[3] latch
XFILLER_295_174 VPWR VGND sg13cmos5l_decap_8
XFILLER_633_205 VPWR VGND sg13cmos5l_fill_2
X_3020_ Tile_X0Y5_E6BEG[7] _4411_/X VPWR VGND sg13cmos5l_buf_1
X_0232_ _0232_/Q Tile_X0Y7_FrameData[23] VGND VPWR Tile_X0Y9_FrameStrobe[2] latch
XFILLER_444_138 VPWR VGND sg13cmos5l_fill_1
XFILLER_352_98 VPWR VGND sg13cmos5l_decap_8
XFILLER_502_35 VPWR VGND sg13cmos5l_decap_8
X_0163_ _0163_/Q Tile_X0Y7_FrameData[28] VGND VPWR Tile_X0Y9_FrameStrobe[0] latch
XFILLER_48_195 VPWR VGND sg13cmos5l_fill_1
XFILLER_221_14 VPWR VGND sg13cmos5l_decap_8
XANTENNA__3032__X Tile_X0Y5_EE4BEG[7] VPWR VGND sg13cmos5l_antennanp
XFILLER_601_113 VPWR VGND sg13cmos5l_decap_8
XFILLER_397_215 VPWR VGND sg13cmos5l_fill_2
XFILLER_63_165 VPWR VGND sg13cmos5l_decap_8
XFILLER_578_28 VPWR VGND sg13cmos5l_decap_8
XFILLER_452_193 VPWR VGND sg13cmos5l_decap_8
X_0094_ _0094_/X _4114_/X _4115_/X _2660_/Q VPWR VGND sg13cmos5l_mux2_1
XANTENNA__2871__X Tile_X0Y6_EE4BEG[8] VPWR VGND sg13cmos5l_antennanp
X_3922_ _3922_/X Tile_X0Y3_W1END[2] Tile_X0Y3_WW4END[2] Tile_X0Y3_W6END[10] _4224_/X
+ _1895_/Q _1894_/Q VPWR VGND sg13cmos5l_mux4_1
XFILLER_211_119 VPWR VGND sg13cmos5l_decap_8
XFILLER_601_179 VPWR VGND sg13cmos5l_decap_4
XFILLER_204_182 VPWR VGND sg13cmos5l_fill_2
XFILLER_149_215 VPWR VGND sg13cmos5l_fill_2
X_3853_ _3853_/X _3889_/X _3888_/X Tile_X0Y0_S2MID[0] Tile_X0Y0_S2END[0] _0963_/Q
+ _0962_/Q VPWR VGND sg13cmos5l_mux4_1
X_2804_ Tile_X0Y3_E2BEGb[2] _4158_/X VPWR VGND sg13cmos5l_buf_1
XFILLER_365_145 VPWR VGND sg13cmos5l_decap_8
X_3784_ _3784_/X Tile_X0Y0_W2MID[7] Tile_X0Y0_W2END[7] Tile_X0Y0_W6END[7] _3853_/X
+ _1169_/Q _1168_/Q VPWR VGND sg13cmos5l_mux4_1
XFILLER_594_49 VPWR VGND sg13cmos5l_fill_2
X_0996_ _0996_/Q Tile_X0Y0_FrameData[7] VGND VPWR Tile_X0Y9_FrameStrobe[1] latch
XFILLER_74_0 VPWR VGND sg13cmos5l_decap_8
XFILLER_527_21 VPWR VGND sg13cmos5l_decap_8
X_2735_ _3978_/A3 VPWR VGND sg13cmos5l_tielo
XFILLER_117_112 VPWR VGND sg13cmos5l_decap_8
XFILLER_306_212 VPWR VGND sg13cmos5l_decap_4
X_2666_ _2666_/Q Tile_X0Y6_FrameData[29] VGND VPWR Tile_X0Y9_FrameStrobe[7] latch
X_4405_ _4405_/X _0159_/X _0145_/X _4461_/X _4465_/X _2293_/Q _2292_/Q VPWR VGND sg13cmos5l_mux4_1
XFILLER_668_146 VPWR VGND sg13cmos5l_fill_1
X_1617_ _1617_/Q Tile_X0Y2_FrameData[0] VGND VPWR Tile_X0Y9_FrameStrobe[5] latch
XFILLER_132_126 VPWR VGND sg13cmos5l_decap_8
XFILLER_668_168 VPWR VGND sg13cmos5l_fill_2
XFILLER_278_119 VPWR VGND sg13cmos5l_decap_8
X_2597_ _2597_/Q Tile_X0Y6_FrameData[2] VGND VPWR Tile_X0Y9_FrameStrobe[4] latch
XANTENNA__3207__X Tile_X0Y0_N2BEG[7] VPWR VGND sg13cmos5l_antennanp
XFILLER_543_42 VPWR VGND sg13cmos5l_decap_8
X_4336_ _4336_/X _4302_/X _0099_/X _4301_/X _0112_/X _1981_/Q _1980_/Q VPWR VGND sg13cmos5l_mux4_1
XFILLER_5_91 VPWR VGND sg13cmos5l_decap_4
X_1548_ _1548_/Q Tile_X0Y2_FrameData[5] VGND VPWR Tile_X0Y9_FrameStrobe[3] latch
XFILLER_262_21 VPWR VGND sg13cmos5l_decap_8
XFILLER_286_141 VPWR VGND sg13cmos5l_decap_8
X_4267_ _4267_/X Tile_X0Y4_W2END[4] AXI_M_SOC_BRESP0 _4319_/X _4318_/X _2079_/Q _2078_/Q
+ VPWR VGND sg13cmos5l_mux4_1
X_1479_ _1479_/Q Tile_X0Y2_FrameData[10] VGND VPWR Tile_X0Y9_FrameStrobe[1] latch
XFILLER_435_105 VPWR VGND sg13cmos5l_decap_8
XFILLER_140_192 VPWR VGND sg13cmos5l_decap_8
XFILLER_624_216 VPWR VGND sg13cmos5l_fill_2
XFILLER_490_211 VPWR VGND sg13cmos5l_fill_1
X_3218_ Tile_X0Y0_FrameStrobe_O[6] Tile_X0Y9_FrameStrobe[6] VPWR VGND sg13cmos5l_buf_1
XFILLER_39_140 VPWR VGND sg13cmos5l_decap_8
XFILLER_691_182 VPWR VGND sg13cmos5l_decap_8
XFILLER_39_151 VPWR VGND sg13cmos5l_fill_2
X_4198_ _4198_/X _4195_/X Tile_X0Y3_W6END[0] _4194_/X _4198_/A3 _1681_/Q _1680_/Q
+ VPWR VGND sg13cmos5l_mux4_1
XFILLER_412_35 VPWR VGND sg13cmos5l_decap_8
X_3149_ Tile_X0Y7_FrameData_O[19] Tile_X0Y7_FrameData[19] VPWR VGND sg13cmos5l_buf_1
XFILLER_242_211 VPWR VGND sg13cmos5l_fill_1
XFILLER_388_215 VPWR VGND sg13cmos5l_fill_2
XFILLER_488_28 VPWR VGND sg13cmos5l_decap_8
XANTENNA__2781__X Tile_X0Y3_EE4BEG[7] VPWR VGND sg13cmos5l_antennanp
XFILLER_199_159 VPWR VGND sg13cmos5l_decap_4
XFILLER_152_7 VPWR VGND sg13cmos5l_decap_8
XFILLER_211_91 VPWR VGND sg13cmos5l_decap_8
XFILLER_24_56 VPWR VGND sg13cmos5l_decap_8
XFILLER_356_112 VPWR VGND sg13cmos5l_decap_8
XFILLER_417_7 VPWR VGND sg13cmos5l_decap_8
XFILLER_287_84 VPWR VGND sg13cmos5l_decap_8
XFILLER_437_21 VPWR VGND sg13cmos5l_decap_8
XFILLER_6_217 VPWR VGND sg13cmos5l_fill_1
XFILLER_371_104 VPWR VGND sg13cmos5l_fill_1
XFILLER_356_189 VPWR VGND sg13cmos5l_decap_8
XFILLER_108_112 VPWR VGND sg13cmos5l_fill_1
XFILLER_108_134 VPWR VGND sg13cmos5l_decap_8
XFILLER_156_44 VPWR VGND sg13cmos5l_decap_8
XFILLER_312_204 VPWR VGND sg13cmos5l_decap_8
XFILLER_458_208 VPWR VGND sg13cmos5l_fill_1
XFILLER_306_14 VPWR VGND sg13cmos5l_decap_8
XFILLER_156_99 VPWR VGND sg13cmos5l_fill_1
XFILLER_513_197 VPWR VGND sg13cmos5l_decap_4
XFILLER_123_148 VPWR VGND sg13cmos5l_decap_8
XANTENNA__3117__X Tile_X0Y7_EE4BEG[3] VPWR VGND sg13cmos5l_antennanp
XFILLER_453_42 VPWR VGND sg13cmos5l_decap_8
XFILLER_453_53 VPWR VGND sg13cmos5l_fill_2
XFILLER_172_21 VPWR VGND sg13cmos5l_decap_8
XFILLER_49_64 VPWR VGND sg13cmos5l_decap_8
XANTENNA__2956__X Tile_X0Y8_EE4BEG[12] VPWR VGND sg13cmos5l_antennanp
XFILLER_426_105 VPWR VGND sg13cmos5l_decap_8
XFILLER_172_65 VPWR VGND sg13cmos5l_decap_4
XFILLER_603_56 VPWR VGND sg13cmos5l_decap_8
XFILLER_292_111 VPWR VGND sg13cmos5l_decap_4
XFILLER_172_76 VPWR VGND sg13cmos5l_decap_8
XFILLER_603_67 VPWR VGND sg13cmos5l_fill_2
XFILLER_292_144 VPWR VGND sg13cmos5l_decap_8
XFILLER_322_35 VPWR VGND sg13cmos5l_decap_8
XFILLER_1_49 VPWR VGND sg13cmos5l_decap_8
XFILLER_276_0 VPWR VGND sg13cmos5l_decap_8
XFILLER_105_92 VPWR VGND sg13cmos5l_decap_8
XFILLER_679_49 VPWR VGND sg13cmos5l_decap_8
XFILLER_434_160 VPWR VGND sg13cmos5l_decap_8
XFILLER_398_28 VPWR VGND sg13cmos5l_decap_8
XFILLER_379_215 VPWR VGND sg13cmos5l_fill_2
XFILLER_65_96 VPWR VGND sg13cmos5l_decap_8
XFILLER_434_193 VPWR VGND sg13cmos5l_decap_8
XFILLER_45_176 VPWR VGND sg13cmos5l_decap_4
XFILLER_443_0 VPWR VGND sg13cmos5l_decap_8
XFILLER_60_168 VPWR VGND sg13cmos5l_decap_8
XFILLER_478_72 VPWR VGND sg13cmos5l_fill_1
XFILLER_347_112 VPWR VGND sg13cmos5l_fill_1
XFILLER_610_0 VPWR VGND sg13cmos5l_decap_8
XFILLER_478_94 VPWR VGND sg13cmos5l_fill_2
XFILLER_708_0 VPWR VGND sg13cmos5l_decap_8
XFILLER_628_42 VPWR VGND sg13cmos5l_decap_8
X_0850_ _0850_/Q Tile_X0Y9_FrameData[13] VGND VPWR Tile_X0Y9_FrameStrobe[5] latch
XFILLER_146_207 VPWR VGND sg13cmos5l_decap_4
XFILLER_347_21 VPWR VGND sg13cmos5l_decap_8
XFILLER_347_178 VPWR VGND sg13cmos5l_decap_8
X_0781_ _0781_/Q Tile_X0Y9_FrameData[18] VGND VPWR Tile_X0Y9_FrameStrobe[3] latch
X_2520_ _2520_/Q Tile_X0Y6_FrameData[15] VGND VPWR Tile_X0Y9_FrameStrobe[2] latch
XFILLER_347_98 VPWR VGND sg13cmos5l_decap_8
XFILLER_114_104 VPWR VGND sg13cmos5l_decap_4
X_2451_ _2451_/Q Tile_X0Y6_FrameData[20] VGND VPWR Tile_X0Y9_FrameStrobe[0] latch
XFILLER_644_63 VPWR VGND sg13cmos5l_decap_8
XFILLER_504_175 VPWR VGND sg13cmos5l_decap_8
XFILLER_449_208 VPWR VGND sg13cmos5l_decap_8
XFILLER_363_20 VPWR VGND sg13cmos5l_decap_8
XFILLER_216_14 VPWR VGND sg13cmos5l_decap_8
XFILLER_665_105 VPWR VGND sg13cmos5l_fill_2
XANTENNA__3027__X Tile_X0Y5_EE4BEG[2] VPWR VGND sg13cmos5l_antennanp
X_1402_ _1402_/Q Tile_X0Y1_FrameData[31] VGND VPWR Tile_X0Y9_FrameStrobe[7] latch
XFILLER_665_127 VPWR VGND sg13cmos5l_fill_2
X_2382_ _2382_/Q Tile_X0Y5_FrameData[23] VGND VPWR Tile_X0Y9_FrameStrobe[6] latch
XFILLER_268_130 VPWR VGND sg13cmos5l_fill_1
XFILLER_363_86 VPWR VGND sg13cmos5l_decap_4
X_4121_ _4121_/X _4091_/X _0064_/X _4090_/X Tile_X0Y0_S4END[9] _1471_/Q _1470_/Q VPWR
+ VGND sg13cmos5l_mux4_1
X_1333_ _1333_/Q Tile_X0Y1_FrameData[4] VGND VPWR Tile_X0Y9_FrameStrobe[4] latch
XANTENNA__2866__X Tile_X0Y6_EE4BEG[3] VPWR VGND sg13cmos5l_antennanp
XFILLER_680_108 VPWR VGND sg13cmos5l_decap_4
XFILLER_680_119 VPWR VGND sg13cmos5l_decap_4
XFILLER_417_105 VPWR VGND sg13cmos5l_decap_8
XFILLER_606_216 VPWR VGND sg13cmos5l_fill_2
XFILLER_513_56 VPWR VGND sg13cmos5l_decap_8
X_4052_ _4052_/X Tile_X0Y2_W2END[3] AXI_M_SOC_AWREADY _4103_/X _4102_/X _1569_/Q _1568_/Q
+ VPWR VGND sg13cmos5l_mux4_1
XFILLER_283_133 VPWR VGND sg13cmos5l_decap_8
XFILLER_232_13 VPWR VGND sg13cmos5l_decap_8
X_1264_ _1264_/Q Tile_X0Y1_FrameData[9] VGND VPWR Tile_X0Y9_FrameStrobe[2] latch
XFILLER_660_84 VPWR VGND sg13cmos5l_decap_8
X_3003_ Tile_X0Y5_E2BEG[6] _4378_/X VPWR VGND sg13cmos5l_buf_1
X_0215_ _0215_/Q Tile_X0Y7_FrameData[8] VGND VPWR Tile_X0Y9_FrameStrobe[1] latch
X_1195_ _1195_/Q Tile_X0Y1_FrameData[14] VGND VPWR Tile_X0Y9_FrameStrobe[0] latch
XFILLER_589_49 VPWR VGND sg13cmos5l_decap_8
XFILLER_432_119 VPWR VGND sg13cmos5l_fill_2
XFILLER_283_199 VPWR VGND sg13cmos5l_fill_1
XFILLER_224_211 VPWR VGND sg13cmos5l_fill_1
XFILLER_425_182 VPWR VGND sg13cmos5l_fill_1
X_0146_ AXI_M_SOC_ARCACHE3 _0929_/Q _3777_/X VPWR VGND sg13cmos5l_nor2b_1
XANTENNA__3697__X AXI_M_SOC_WDATA7 VPWR VGND sg13cmos5l_antennanp
XFILLER_669_71 VPWR VGND sg13cmos5l_fill_2
XFILLER_586_134 VPWR VGND sg13cmos5l_decap_8
X_0077_ _0077_/X _4792_/X _4793_/X _2119_/Q VPWR VGND sg13cmos5l_mux2_1
X_3905_ _3905_/X _4015_/X _4019_/X _3996_/X _3995_/X _1392_/Q _1391_/Q VPWR VGND sg13cmos5l_mux4_1
XFILLER_388_83 VPWR VGND sg13cmos5l_fill_1
X_4885_ _4885_/X AXI_M_SOC_RDATA1 _4922_/X _4926_/X _4903_/X _0773_/Q _0772_/Q VPWR
+ VGND sg13cmos5l_mux4_1
XFILLER_538_42 VPWR VGND sg13cmos5l_decap_8
XFILLER_338_145 VPWR VGND sg13cmos5l_decap_8
XFILLER_538_53 VPWR VGND sg13cmos5l_fill_2
X_3836_ _3836_/X _0067_/X Tile_X0Y0_S4END[0] _3864_/X _3863_/X _1033_/Q _1032_/Q VPWR
+ VGND sg13cmos5l_mux4_1
XFILLER_685_70 VPWR VGND sg13cmos5l_fill_2
XFILLER_257_21 VPWR VGND sg13cmos5l_decap_8
XFILLER_542_215 VPWR VGND sg13cmos5l_fill_2
X_3767_ _3767_/X Tile_X0Y1_WW4END[0] Tile_X0Y1_WW4END[8] Tile_X0Y1_W6END[8] _4016_/X
+ _1241_/Q _1240_/Q VPWR VGND sg13cmos5l_mux4_1
XFILLER_499_119 VPWR VGND sg13cmos5l_decap_8
XFILLER_353_126 VPWR VGND sg13cmos5l_decap_8
X_0979_ _0979_/Q Tile_X0Y0_FrameData[24] VGND VPWR Tile_X0Y9_FrameStrobe[1] latch
X_2718_ _4774_/A3 VPWR VGND sg13cmos5l_tielo
X_3698_ AXI_M_SOC_WDATA8 Tile_X0Y7_WW4END[0] Tile_X0Y7_WW4END[8] Tile_X0Y7_W6END[8]
+ _4692_/X _0231_/Q _0230_/Q VPWR VGND sg13cmos5l_mux4_1
XFILLER_10_14 VPWR VGND sg13cmos5l_decap_8
XFILLER_407_35 VPWR VGND sg13cmos5l_decap_8
XFILLER_407_46 VPWR VGND sg13cmos5l_fill_1
XFILLER_554_63 VPWR VGND sg13cmos5l_decap_8
X_2649_ _2649_/Q Tile_X0Y6_FrameData[14] VGND VPWR Tile_X0Y9_FrameStrobe[6] latch
XFILLER_126_14 VPWR VGND sg13cmos5l_decap_8
XFILLER_105_137 VPWR VGND sg13cmos5l_decap_8
XFILLER_656_105 VPWR VGND sg13cmos5l_fill_2
XFILLER_510_123 VPWR VGND sg13cmos5l_decap_8
XFILLER_273_42 VPWR VGND sg13cmos5l_decap_8
XANTENNA__2776__X Tile_X0Y3_EE4BEG[2] VPWR VGND sg13cmos5l_antennanp
XFILLER_704_77 VPWR VGND sg13cmos5l_decap_8
X_4319_ _4319_/X _4243_/X _4359_/X _4358_/X _4242_/X _1943_/Q _1942_/Q VPWR VGND sg13cmos5l_mux4_1
XFILLER_113_181 VPWR VGND sg13cmos5l_decap_8
XFILLER_463_200 VPWR VGND sg13cmos5l_decap_8
XFILLER_423_56 VPWR VGND sg13cmos5l_decap_8
XFILLER_259_196 VPWR VGND sg13cmos5l_fill_1
XFILLER_274_133 VPWR VGND sg13cmos5l_decap_8
XFILLER_19_56 VPWR VGND sg13cmos5l_fill_1
XFILLER_570_84 VPWR VGND sg13cmos5l_decap_8
XFILLER_142_35 VPWR VGND sg13cmos5l_decap_8
XFILLER_27_110 VPWR VGND sg13cmos5l_decap_8
XFILLER_612_208 VPWR VGND sg13cmos5l_decap_4
XFILLER_367_7 VPWR VGND sg13cmos5l_decap_8
XFILLER_499_49 VPWR VGND sg13cmos5l_decap_8
XFILLER_577_112 VPWR VGND sg13cmos5l_decap_8
XFILLER_534_7 VPWR VGND sg13cmos5l_decap_8
XFILLER_35_77 VPWR VGND sg13cmos5l_decap_8
XFILLER_187_118 VPWR VGND sg13cmos5l_decap_8
XANTENNA__3400__X Tile_X0Y2_E2BEG[3] VPWR VGND sg13cmos5l_antennanp
XFILLER_431_196 VPWR VGND sg13cmos5l_decap_8
XFILLER_42_168 VPWR VGND sg13cmos5l_decap_8
XFILLER_42_179 VPWR VGND sg13cmos5l_fill_1
XFILLER_701_7 VPWR VGND sg13cmos5l_decap_8
XFILLER_448_42 VPWR VGND sg13cmos5l_decap_8
XFILLER_595_70 VPWR VGND sg13cmos5l_decap_8
XFILLER_167_21 VPWR VGND sg13cmos5l_decap_8
XFILLER_195_184 VPWR VGND sg13cmos5l_fill_2
XFILLER_51_76 VPWR VGND sg13cmos5l_decap_8
XFILLER_167_65 VPWR VGND sg13cmos5l_decap_8
XFILLER_317_35 VPWR VGND sg13cmos5l_decap_8
XFILLER_681_28 VPWR VGND sg13cmos5l_decap_8
XFILLER_464_63 VPWR VGND sg13cmos5l_fill_1
XFILLER_501_112 VPWR VGND sg13cmos5l_decap_8
XFILLER_647_105 VPWR VGND sg13cmos5l_decap_8
XFILLER_4_0 VPWR VGND sg13cmos5l_decap_8
XFILLER_498_196 VPWR VGND sg13cmos5l_decap_8
XFILLER_393_0 VPWR VGND sg13cmos5l_decap_8
XFILLER_501_189 VPWR VGND sg13cmos5l_decap_8
XFILLER_183_97 VPWR VGND sg13cmos5l_decap_8
XFILLER_614_77 VPWR VGND sg13cmos5l_decap_8
XFILLER_614_88 VPWR VGND sg13cmos5l_fill_2
XFILLER_104_192 VPWR VGND sg13cmos5l_decap_8
XFILLER_333_56 VPWR VGND sg13cmos5l_fill_2
XFILLER_480_73 VPWR VGND sg13cmos5l_decap_8
XFILLER_630_21 VPWR VGND sg13cmos5l_decap_8
XFILLER_560_0 VPWR VGND sg13cmos5l_decap_8
XFILLER_76_84 VPWR VGND sg13cmos5l_decap_8
XFILLER_670_141 VPWR VGND sg13cmos5l_fill_1
XFILLER_658_0 VPWR VGND sg13cmos5l_decap_8
XFILLER_670_163 VPWR VGND sg13cmos5l_decap_4
XFILLER_280_147 VPWR VGND sg13cmos5l_decap_8
XFILLER_630_98 VPWR VGND sg13cmos5l_decap_8
XFILLER_202_49 VPWR VGND sg13cmos5l_decap_8
XFILLER_568_112 VPWR VGND sg13cmos5l_decap_8
XANTENNA__3310__X Tile_X0Y0_E1BEG[2] VPWR VGND sg13cmos5l_antennanp
XFILLER_33_179 VPWR VGND sg13cmos5l_fill_2
X_1951_ _1951_/Q Tile_X0Y4_FrameData[6] VGND VPWR Tile_X0Y9_FrameStrobe[0] latch
XFILLER_639_63 VPWR VGND sg13cmos5l_decap_8
XFILLER_583_126 VPWR VGND sg13cmos5l_decap_8
XFILLER_509_212 VPWR VGND sg13cmos5l_decap_4
X_0902_ _0902_/Q Tile_X0Y9_FrameData[25] VGND VPWR Tile_X0Y9_FrameStrobe[7] latch
XFILLER_358_42 VPWR VGND sg13cmos5l_decap_8
X_4670_ _4670_/X _4597_/X _4713_/X _4712_/X _4596_/X _0171_/Q _0170_/Q VPWR VGND sg13cmos5l_mux4_1
XFILLER_41_190 VPWR VGND sg13cmos5l_decap_8
X_1882_ _1882_/Q Tile_X0Y3_FrameData[15] VGND VPWR Tile_X0Y9_FrameStrobe[6] latch
X_3621_ Tile_X0Y9_S2BEGb[7] _4939_/X VPWR VGND sg13cmos5l_buf_1
XFILLER_390_210 VPWR VGND sg13cmos5l_decap_8
X_0833_ _0833_/Q Tile_X0Y9_FrameData[30] VGND VPWR Tile_X0Y9_FrameStrobe[5] latch
XFILLER_335_126 VPWR VGND sg13cmos5l_fill_2
XFILLER_508_56 VPWR VGND sg13cmos5l_decap_8
X_3552_ Tile_X0Y9_E6BEG[10] _4890_/X VPWR VGND sg13cmos5l_buf_1
XFILLER_227_13 VPWR VGND sg13cmos5l_decap_8
X_0764_ _0764_/Q Tile_X0Y9_FrameData[3] VGND VPWR Tile_X0Y9_FrameStrobe[2] latch
XFILLER_655_84 VPWR VGND sg13cmos5l_decap_8
XFILLER_489_141 VPWR VGND sg13cmos5l_decap_8
X_2503_ _2503_/Q Tile_X0Y6_FrameData[0] VGND VPWR Tile_X0Y9_FrameStrobe[1] latch
XFILLER_591_28 VPWR VGND sg13cmos5l_decap_8
X_3483_ Tile_X0Y1_EE4BEG[9] _3957_/X VPWR VGND sg13cmos5l_buf_1
XFILLER_288_214 VPWR VGND sg13cmos5l_decap_4
X_0695_ _0695_/Q Tile_X0Y9_FrameData[8] VGND VPWR Tile_X0Y9_FrameStrobe[0] latch
XFILLER_638_105 VPWR VGND sg13cmos5l_decap_8
XFILLER_374_85 VPWR VGND sg13cmos5l_decap_8
X_2434_ _2434_/Q Tile_X0Y5_FrameData[3] VGND VPWR Tile_X0Y9_FrameStrobe[7] latch
X_2365_ _2365_/Q Tile_X0Y5_FrameData[8] VGND VPWR Tile_X0Y9_FrameStrobe[5] latch
XFILLER_653_119 VPWR VGND sg13cmos5l_decap_8
XFILLER_445_200 VPWR VGND sg13cmos5l_decap_8
XFILLER_243_56 VPWR VGND sg13cmos5l_decap_8
X_4104_ _4104_/X _4095_/X _0094_/X _4094_/X Tile_X0Y0_S4END[11] _1451_/Q _1450_/Q
+ VPWR VGND sg13cmos5l_mux4_1
X_1316_ _1316_/Q Tile_X0Y1_FrameData[21] VGND VPWR Tile_X0Y9_FrameStrobe[4] latch
XFILLER_646_182 VPWR VGND sg13cmos5l_decap_8
XFILLER_243_78 VPWR VGND sg13cmos5l_decap_8
X_2296_ _2296_/Q Tile_X0Y5_FrameData[13] VGND VPWR Tile_X0Y9_FrameStrobe[3] latch
XFILLER_56_216 VPWR VGND sg13cmos5l_fill_2
XFILLER_540_21 VPWR VGND sg13cmos5l_decap_8
XFILLER_110_173 VPWR VGND sg13cmos5l_fill_2
XFILLER_2_70 VPWR VGND sg13cmos5l_decap_8
X_4035_ _4035_/X Tile_X0Y3_W2MID[0] Tile_X0Y3_W2END[0] Tile_X0Y3_W6END[0] _4204_/X
+ _1903_/Q _1902_/Q VPWR VGND sg13cmos5l_mux4_1
XFILLER_256_177 VPWR VGND sg13cmos5l_decap_8
XFILLER_110_195 VPWR VGND sg13cmos5l_fill_2
X_1247_ _1247_/Q Tile_X0Y1_FrameData[26] VGND VPWR Tile_X0Y9_FrameStrobe[2] latch
XFILLER_271_114 VPWR VGND sg13cmos5l_fill_1
XFILLER_271_147 VPWR VGND sg13cmos5l_fill_1
X_1178_ _1178_/Q Tile_X0Y0_FrameData[31] VGND VPWR Tile_X0Y9_FrameStrobe[0] latch
XFILLER_112_49 VPWR VGND sg13cmos5l_decap_8
XFILLER_271_169 VPWR VGND sg13cmos5l_fill_2
XFILLER_559_134 VPWR VGND sg13cmos5l_decap_8
X_0129_ _3636_/A _4840_/X _4841_/X _0859_/Q VPWR VGND sg13cmos5l_mux2_1
XFILLER_24_135 VPWR VGND sg13cmos5l_decap_4
XANTENNA__3220__X Tile_X0Y0_FrameStrobe_O[8] VPWR VGND sg13cmos5l_antennanp
XFILLER_169_129 VPWR VGND sg13cmos5l_decap_8
XFILLER_574_115 VPWR VGND sg13cmos5l_decap_8
XFILLER_24_179 VPWR VGND sg13cmos5l_fill_2
X_4937_ _4937_/X Tile_X0Y8_W1END[1] Tile_X0Y8_W2MID[2] Tile_X0Y8_W2END[2] _4788_/X
+ _0617_/Q _0616_/Q VPWR VGND sg13cmos5l_mux4_1
XFILLER_549_63 VPWR VGND sg13cmos5l_decap_8
XFILLER_696_91 VPWR VGND sg13cmos5l_decap_8
XFILLER_268_42 VPWR VGND sg13cmos5l_decap_8
XANTENNA_20 AXI_M_SOC_WREADY VPWR VGND sg13cmos5l_antennanp
XANTENNA_31 AXI_M_SOC_WREADY VPWR VGND sg13cmos5l_antennanp
XFILLER_32_190 VPWR VGND sg13cmos5l_decap_8
X_4868_ _4868_/X Tile_X0Y9_WW4END[11] AXI_M_SOC_RDATA4 _4927_/X _4907_/X _0807_/Q
+ _0806_/Q VPWR VGND sg13cmos5l_mux4_1
XANTENNA_42 Tile_X0Y0_S2MID[4] VPWR VGND sg13cmos5l_antennanp
XANTENNA_53 _0040_/X VPWR VGND sg13cmos5l_antennanp
XFILLER_515_204 VPWR VGND sg13cmos5l_decap_8
XANTENNA_64 Tile_X0Y9_FrameStrobe[15] VPWR VGND sg13cmos5l_antennanp
XFILLER_515_215 VPWR VGND sg13cmos5l_fill_2
XFILLER_381_210 VPWR VGND sg13cmos5l_fill_1
XANTENNA_75 Tile_X0Y9_N2MID[2] VPWR VGND sg13cmos5l_antennanp
X_3819_ _3819_/X Tile_X0Y0_W2END[0] _3853_/X _3852_/X _3861_/X _1067_/Q _1066_/Q VPWR
+ VGND sg13cmos5l_mux4_1
X_4799_ _4799_/X _4343_/X _4347_/X _4351_/X _4312_/X _2112_/Q _2111_/Q VPWR VGND sg13cmos5l_mux4_1
XFILLER_418_56 VPWR VGND sg13cmos5l_decap_8
XFILLER_21_35 VPWR VGND sg13cmos5l_decap_8
XFILLER_115_7 VPWR VGND sg13cmos5l_decap_8
XFILLER_565_84 VPWR VGND sg13cmos5l_decap_8
XFILLER_341_118 VPWR VGND sg13cmos5l_decap_8
XFILLER_137_35 VPWR VGND sg13cmos5l_decap_8
XFILLER_284_63 VPWR VGND sg13cmos5l_decap_8
XFILLER_629_105 VPWR VGND sg13cmos5l_decap_4
XFILLER_334_192 VPWR VGND sg13cmos5l_decap_8
XFILLER_97_28 VPWR VGND sg13cmos5l_decap_8
XFILLER_715_76 VPWR VGND sg13cmos5l_decap_8
XFILLER_495_133 VPWR VGND sg13cmos5l_decap_8
XFILLER_217_90 VPWR VGND sg13cmos5l_decap_8
XFILLER_434_77 VPWR VGND sg13cmos5l_decap_8
XFILLER_294_217 VPWR VGND sg13cmos5l_fill_1
XFILLER_99_190 VPWR VGND sg13cmos5l_fill_2
XFILLER_644_119 VPWR VGND sg13cmos5l_decap_8
XFILLER_495_188 VPWR VGND sg13cmos5l_fill_2
XFILLER_484_7 VPWR VGND sg13cmos5l_decap_8
XFILLER_247_122 VPWR VGND sg13cmos5l_decap_8
XFILLER_247_144 VPWR VGND sg13cmos5l_fill_2
XFILLER_450_21 VPWR VGND sg13cmos5l_decap_8
XFILLER_651_7 VPWR VGND sg13cmos5l_decap_8
XFILLER_46_32 VPWR VGND sg13cmos5l_decap_8
XFILLER_652_196 VPWR VGND sg13cmos5l_decap_8
XFILLER_46_76 VPWR VGND sg13cmos5l_decap_8
XFILLER_600_35 VPWR VGND sg13cmos5l_decap_8
XANTENNA__3130__X Tile_X0Y7_FrameData_O[0] VPWR VGND sg13cmos5l_antennanp
XFILLER_404_196 VPWR VGND sg13cmos5l_fill_2
XFILLER_676_28 VPWR VGND sg13cmos5l_decap_8
XFILLER_565_126 VPWR VGND sg13cmos5l_decap_8
XFILLER_459_63 VPWR VGND sg13cmos5l_fill_2
XFILLER_141_0 VPWR VGND sg13cmos5l_fill_2
XFILLER_239_0 VPWR VGND sg13cmos5l_decap_8
XFILLER_62_86 VPWR VGND sg13cmos5l_decap_8
XFILLER_178_75 VPWR VGND sg13cmos5l_decap_8
XFILLER_707_164 VPWR VGND sg13cmos5l_fill_2
XFILLER_372_210 VPWR VGND sg13cmos5l_decap_8
XFILLER_609_77 VPWR VGND sg13cmos5l_fill_2
XFILLER_406_0 VPWR VGND sg13cmos5l_decap_8
XFILLER_183_165 VPWR VGND sg13cmos5l_decap_8
XFILLER_692_49 VPWR VGND sg13cmos5l_decap_8
XFILLER_328_89 VPWR VGND sg13cmos5l_fill_1
XFILLER_625_21 VPWR VGND sg13cmos5l_decap_8
XFILLER_194_63 VPWR VGND sg13cmos5l_decap_8
X_0480_ _0480_/Q Tile_X0Y8_FrameData[31] VGND VPWR Tile_X0Y9_FrameStrobe[2] latch
XFILLER_625_98 VPWR VGND sg13cmos5l_fill_2
XFILLER_30_7 VPWR VGND sg13cmos5l_decap_8
XFILLER_486_177 VPWR VGND sg13cmos5l_fill_2
XFILLER_344_77 VPWR VGND sg13cmos5l_decap_8
XFILLER_635_119 VPWR VGND sg13cmos5l_decap_4
XFILLER_238_111 VPWR VGND sg13cmos5l_decap_8
XANTENNA__3305__X Tile_X0Y0_E2BEG[5] VPWR VGND sg13cmos5l_antennanp
XFILLER_641_42 VPWR VGND sg13cmos5l_decap_8
X_2150_ _2150_/Q Tile_X0Y4_FrameData[31] VGND VPWR Tile_X0Y9_FrameStrobe[7] latch
XFILLER_38_205 VPWR VGND sg13cmos5l_decap_8
XFILLER_360_21 VPWR VGND sg13cmos5l_decap_8
X_1101_ _1101_/Q Tile_X0Y0_FrameData[30] VGND VPWR Tile_X0Y9_FrameStrobe[5] latch
X_2081_ _2081_/Q Tile_X0Y4_FrameData[4] VGND VPWR Tile_X0Y9_FrameStrobe[4] latch
XFILLER_53_208 VPWR VGND sg13cmos5l_fill_1
X_1032_ _1032_/Q Tile_X0Y0_FrameData[3] VGND VPWR Tile_X0Y9_FrameStrobe[2] latch
XFILLER_510_35 VPWR VGND sg13cmos5l_decap_8
XANTENNA__3040__X Tile_X0Y5_EE4BEG[15] VPWR VGND sg13cmos5l_antennanp
XFILLER_410_122 VPWR VGND sg13cmos5l_decap_4
XFILLER_586_28 VPWR VGND sg13cmos5l_decap_8
XFILLER_369_63 VPWR VGND sg13cmos5l_decap_8
XFILLER_99_2 VPWR VGND sg13cmos5l_fill_1
X_2983_ Tile_X0Y8_FrameData_O[23] Tile_X0Y8_FrameData[23] VPWR VGND sg13cmos5l_buf_1
XFILLER_556_126 VPWR VGND sg13cmos5l_decap_4
XFILLER_21_138 VPWR VGND sg13cmos5l_fill_1
XFILLER_369_96 VPWR VGND sg13cmos5l_decap_8
X_4722_ _4722_/X Tile_X0Y8_W1END[3] Tile_X0Y8_WW4END[15] Tile_X0Y8_W6END[7] _4803_/X
+ _0602_/Q _0601_/Q VPWR VGND sg13cmos5l_mux4_1
X_1934_ _1934_/Q Tile_X0Y4_FrameData[23] VGND VPWR Tile_X0Y9_FrameStrobe[0] latch
XFILLER_159_184 VPWR VGND sg13cmos5l_decap_8
XFILLER_308_126 VPWR VGND sg13cmos5l_decap_8
X_1865_ _1865_/Q Tile_X0Y3_FrameData[0] VGND VPWR Tile_X0Y9_FrameStrobe[5] latch
X_4653_ _4653_/X AXI_M_SOC_RDATA21 _4686_/X _4690_/X _4672_/X _0253_/Q _0252_/Q VPWR
+ VGND sg13cmos5l_mux4_1
XFILLER_238_34 VPWR VGND sg13cmos5l_decap_8
XFILLER_174_132 VPWR VGND sg13cmos5l_decap_8
XFILLER_713_112 VPWR VGND sg13cmos5l_decap_8
XFILLER_308_159 VPWR VGND sg13cmos5l_decap_8
X_0816_ _0816_/Q Tile_X0Y9_FrameData[15] VGND VPWR Tile_X0Y9_FrameStrobe[4] latch
X_3604_ Tile_X0Y9_S1BEG[2] _4826_/X VPWR VGND sg13cmos5l_buf_1
X_1796_ _1796_/Q Tile_X0Y3_FrameData[5] VGND VPWR Tile_X0Y9_FrameStrobe[3] latch
X_4584_ _4584_/X Tile_X0Y5_W2MID[7] Tile_X0Y5_W2END[7] Tile_X0Y5_W6END[8] _4467_/X
+ _2395_/Q _2394_/Q VPWR VGND sg13cmos5l_mux4_1
XFILLER_535_21 VPWR VGND sg13cmos5l_decap_8
XFILLER_713_189 VPWR VGND sg13cmos5l_decap_8
X_0747_ _0747_/Q Tile_X0Y9_FrameData[20] VGND VPWR Tile_X0Y9_FrameStrobe[2] latch
X_3535_ Tile_X0Y9_E2BEGb[1] _4857_/X VPWR VGND sg13cmos5l_buf_1
XFILLER_477_122 VPWR VGND sg13cmos5l_fill_1
XFILLER_331_140 VPWR VGND sg13cmos5l_decap_4
X_3466_ Tile_X0Y1_FrameData_O[24] Tile_X0Y1_FrameData[24] VPWR VGND sg13cmos5l_buf_1
XFILLER_331_151 VPWR VGND sg13cmos5l_decap_4
X_0678_ _0678_/Q Tile_X0Y9_FrameData[25] VGND VPWR Tile_X0Y9_FrameStrobe[0] latch
XFILLER_477_144 VPWR VGND sg13cmos5l_decap_8
XFILLER_88_149 VPWR VGND sg13cmos5l_decap_8
X_2417_ _2417_/Q Tile_X0Y5_FrameData[20] VGND VPWR Tile_X0Y9_FrameStrobe[7] latch
XFILLER_404_14 VPWR VGND sg13cmos5l_decap_8
XFILLER_229_100 VPWR VGND sg13cmos5l_fill_1
X_3397_ Tile_X0Y2_E2BEG[0] _4040_/X VPWR VGND sg13cmos5l_buf_1
XFILLER_626_119 VPWR VGND sg13cmos5l_fill_2
XFILLER_477_188 VPWR VGND sg13cmos5l_fill_1
XFILLER_619_160 VPWR VGND sg13cmos5l_decap_4
XANTENNA__3215__X Tile_X0Y0_FrameStrobe_O[3] VPWR VGND sg13cmos5l_antennanp
XFILLER_551_42 VPWR VGND sg13cmos5l_decap_8
XFILLER_551_53 VPWR VGND sg13cmos5l_fill_1
XFILLER_492_147 VPWR VGND sg13cmos5l_decap_4
X_2348_ _2348_/Q Tile_X0Y5_FrameData[25] VGND VPWR Tile_X0Y9_FrameStrobe[5] latch
XFILLER_551_64 VPWR VGND sg13cmos5l_decap_8
XFILLER_492_158 VPWR VGND sg13cmos5l_decap_8
XFILLER_270_21 VPWR VGND sg13cmos5l_decap_8
XFILLER_229_155 VPWR VGND sg13cmos5l_decap_4
X_2279_ _2279_/Q Tile_X0Y5_FrameData[30] VGND VPWR Tile_X0Y9_FrameStrobe[3] latch
XFILLER_579_207 VPWR VGND sg13cmos5l_fill_1
XFILLER_701_56 VPWR VGND sg13cmos5l_decap_8
X_4018_ _4018_/X _3985_/X _0095_/X _3984_/X Tile_X0Y0_S4END[6] _1213_/Q _1212_/Q VPWR
+ VGND sg13cmos5l_mux4_1
XFILLER_634_196 VPWR VGND sg13cmos5l_decap_8
XFILLER_244_147 VPWR VGND sg13cmos5l_decap_8
XFILLER_270_98 VPWR VGND sg13cmos5l_fill_2
XFILLER_420_35 VPWR VGND sg13cmos5l_decap_8
XFILLER_203_70 VPWR VGND sg13cmos5l_decap_8
XFILLER_16_35 VPWR VGND sg13cmos5l_decap_8
XFILLER_398_162 VPWR VGND sg13cmos5l_decap_8
XFILLER_197_213 VPWR VGND sg13cmos5l_decap_4
XFILLER_401_111 VPWR VGND sg13cmos5l_fill_1
XFILLER_279_41 VPWR VGND sg13cmos5l_decap_8
XFILLER_496_28 VPWR VGND sg13cmos5l_decap_8
XFILLER_12_105 VPWR VGND sg13cmos5l_decap_8
XFILLER_401_144 VPWR VGND sg13cmos5l_fill_2
XFILLER_32_34 VPWR VGND sg13cmos5l_decap_8
XFILLER_225_6 VPWR VGND sg13cmos5l_decap_8
XFILLER_429_77 VPWR VGND sg13cmos5l_decap_8
XFILLER_704_112 VPWR VGND sg13cmos5l_decap_8
XFILLER_32_89 VPWR VGND sg13cmos5l_fill_2
XFILLER_165_154 VPWR VGND sg13cmos5l_decap_8
XFILLER_148_56 VPWR VGND sg13cmos5l_fill_2
XFILLER_570_140 VPWR VGND sg13cmos5l_decap_8
XFILLER_295_84 VPWR VGND sg13cmos5l_decap_8
XFILLER_445_21 VPWR VGND sg13cmos5l_decap_8
XFILLER_180_135 VPWR VGND sg13cmos5l_decap_8
XFILLER_699_7 VPWR VGND sg13cmos5l_decap_8
XFILLER_468_122 VPWR VGND sg13cmos5l_fill_1
XFILLER_468_144 VPWR VGND sg13cmos5l_decap_8
XFILLER_79_127 VPWR VGND sg13cmos5l_decap_8
XFILLER_483_114 VPWR VGND sg13cmos5l_decap_8
XFILLER_314_14 VPWR VGND sg13cmos5l_decap_8
XANTENNA__3125__X Tile_X0Y7_EE4BEG[11] VPWR VGND sg13cmos5l_antennanp
XFILLER_461_42 VPWR VGND sg13cmos5l_fill_1
XFILLER_57_42 VPWR VGND sg13cmos5l_fill_1
XFILLER_625_152 VPWR VGND sg13cmos5l_fill_1
XFILLER_189_0 VPWR VGND sg13cmos5l_decap_8
XANTENNA__2964__X Tile_X0Y8_FrameData_O[4] VPWR VGND sg13cmos5l_antennanp
XFILLER_180_54 VPWR VGND sg13cmos5l_decap_4
XFILLER_625_174 VPWR VGND sg13cmos5l_fill_2
XFILLER_611_56 VPWR VGND sg13cmos5l_decap_8
XFILLER_180_87 VPWR VGND sg13cmos5l_fill_2
XFILLER_640_133 VPWR VGND sg13cmos5l_decap_8
XFILLER_611_78 VPWR VGND sg13cmos5l_decap_8
XFILLER_330_35 VPWR VGND sg13cmos5l_decap_8
XFILLER_235_169 VPWR VGND sg13cmos5l_decap_8
XFILLER_250_106 VPWR VGND sg13cmos5l_decap_8
XFILLER_113_81 VPWR VGND sg13cmos5l_decap_8
XFILLER_356_0 VPWR VGND sg13cmos5l_decap_8
XFILLER_687_49 VPWR VGND sg13cmos5l_decap_8
XFILLER_538_104 VPWR VGND sg13cmos5l_fill_1
XFILLER_189_63 VPWR VGND sg13cmos5l_decap_8
XFILLER_538_137 VPWR VGND sg13cmos5l_fill_1
XFILLER_523_0 VPWR VGND sg13cmos5l_decap_8
XFILLER_339_77 VPWR VGND sg13cmos5l_decap_8
XFILLER_78_7 VPWR VGND sg13cmos5l_decap_8
XFILLER_156_132 VPWR VGND sg13cmos5l_fill_1
XFILLER_156_154 VPWR VGND sg13cmos5l_decap_8
XFILLER_636_42 VPWR VGND sg13cmos5l_decap_8
X_1650_ _1650_/Q Tile_X0Y2_FrameData[31] VGND VPWR Tile_X0Y9_FrameStrobe[7] latch
XFILLER_561_162 VPWR VGND sg13cmos5l_fill_2
XFILLER_305_118 VPWR VGND sg13cmos5l_fill_1
XFILLER_156_187 VPWR VGND sg13cmos5l_decap_8
XFILLER_355_21 VPWR VGND sg13cmos5l_decap_8
XFILLER_171_124 VPWR VGND sg13cmos5l_fill_2
X_0601_ _0601_/Q Tile_X0Y8_FrameData[6] VGND VPWR Tile_X0Y9_FrameStrobe[5] latch
XFILLER_710_126 VPWR VGND sg13cmos5l_decap_8
X_1581_ _1581_/Q Tile_X0Y2_FrameData[4] VGND VPWR Tile_X0Y9_FrameStrobe[4] latch
XFILLER_208_48 VPWR VGND sg13cmos5l_decap_8
XFILLER_171_168 VPWR VGND sg13cmos5l_decap_8
X_3320_ Tile_X0Y4_EE4BEG[8] _4280_/X VPWR VGND sg13cmos5l_buf_1
XFILLER_459_122 VPWR VGND sg13cmos5l_decap_8
XFILLER_171_179 VPWR VGND sg13cmos5l_fill_1
X_0532_ _0532_/Q Tile_X0Y8_FrameData[11] VGND VPWR Tile_X0Y9_FrameStrobe[3] latch
XFILLER_355_98 VPWR VGND sg13cmos5l_decap_8
XFILLER_505_35 VPWR VGND sg13cmos5l_decap_8
XFILLER_313_173 VPWR VGND sg13cmos5l_decap_8
XFILLER_258_206 VPWR VGND sg13cmos5l_fill_1
XFILLER_258_217 VPWR VGND sg13cmos5l_fill_1
X_3251_ Tile_X0Y0_FrameData_O[19] Tile_X0Y0_FrameData[19] VPWR VGND sg13cmos5l_buf_1
XFILLER_652_63 VPWR VGND sg13cmos5l_decap_8
XFILLER_474_103 VPWR VGND sg13cmos5l_decap_8
X_0463_ _0463_/Q Tile_X0Y8_FrameData[16] VGND VPWR Tile_X0Y9_FrameStrobe[1] latch
XFILLER_224_14 VPWR VGND sg13cmos5l_decap_8
XFILLER_459_199 VPWR VGND sg13cmos5l_decap_8
XANTENNA__3035__X Tile_X0Y5_EE4BEG[10] VPWR VGND sg13cmos5l_antennanp
X_2202_ _2202_/Q Tile_X0Y5_FrameData[11] VGND VPWR Tile_X0Y9_FrameStrobe[0] latch
XFILLER_371_42 VPWR VGND sg13cmos5l_decap_8
X_3182_ Tile_X0Y0_N4BEG[6] _3182_/A VPWR VGND sg13cmos5l_buf_1
X_0394_ _0394_/Q Tile_X0Y7_FrameData[21] VGND VPWR Tile_X0Y9_FrameStrobe[7] latch
XFILLER_616_130 VPWR VGND sg13cmos5l_decap_4
X_2133_ _2133_/Q Tile_X0Y4_FrameData[16] VGND VPWR Tile_X0Y9_FrameStrobe[6] latch
XFILLER_371_97 VPWR VGND sg13cmos5l_decap_8
XANTENNA__2874__X Tile_X0Y6_EE4BEG[11] VPWR VGND sg13cmos5l_antennanp
XFILLER_93_163 VPWR VGND sg13cmos5l_decap_4
X_2064_ _2064_/Q Tile_X0Y4_FrameData[21] VGND VPWR Tile_X0Y9_FrameStrobe[4] latch
XFILLER_631_133 VPWR VGND sg13cmos5l_decap_4
XFILLER_240_35 VPWR VGND sg13cmos5l_decap_8
X_1015_ _1015_/Q Tile_X0Y0_FrameData[20] VGND VPWR Tile_X0Y9_FrameStrobe[2] latch
XFILLER_631_188 VPWR VGND sg13cmos5l_decap_8
XFILLER_529_104 VPWR VGND sg13cmos5l_fill_1
XFILLER_584_210 VPWR VGND sg13cmos5l_decap_8
XFILLER_529_126 VPWR VGND sg13cmos5l_fill_2
XFILLER_395_176 VPWR VGND sg13cmos5l_decap_8
X_2966_ Tile_X0Y8_FrameData_O[6] Tile_X0Y8_FrameData[6] VPWR VGND sg13cmos5l_buf_1
XFILLER_396_72 VPWR VGND sg13cmos5l_decap_8
X_4705_ _4705_/X Tile_X0Y9_W2MID[5] Tile_X0Y9_W2END[5] Tile_X0Y9_W6END[5] _4905_/X
+ _0915_/Q _0914_/Q VPWR VGND sg13cmos5l_mux4_1
X_1917_ _1917_/Q Tile_X0Y3_FrameData[12] VGND VPWR Tile_X0Y9_FrameStrobe[7] latch
XFILLER_396_94 VPWR VGND sg13cmos5l_decap_8
X_2897_ Tile_X0Y6_FrameData_O[18] Tile_X0Y6_FrameData[18] VPWR VGND sg13cmos5l_buf_1
XFILLER_546_42 VPWR VGND sg13cmos5l_decap_8
XFILLER_8_91 VPWR VGND sg13cmos5l_fill_1
X_4636_ _4636_/X Tile_X0Y7_WW4END[7] AXI_M_SOC_RDATA23 _4691_/X _4668_/X _0287_/Q
+ _0286_/Q VPWR VGND sg13cmos5l_mux4_1
X_1848_ _1848_/Q Tile_X0Y3_FrameData[17] VGND VPWR Tile_X0Y9_FrameStrobe[5] latch
XFILLER_698_144 VPWR VGND sg13cmos5l_decap_8
XFILLER_693_70 VPWR VGND sg13cmos5l_decap_8
XFILLER_265_21 VPWR VGND sg13cmos5l_decap_8
XFILLER_701_126 VPWR VGND sg13cmos5l_decap_4
X_1779_ _1779_/Q Tile_X0Y3_FrameData[22] VGND VPWR Tile_X0Y9_FrameStrobe[3] latch
X_4567_ _4567_/X _4123_/X _4127_/X _4104_/X _4096_/X _1604_/Q _1603_/Q VPWR VGND sg13cmos5l_mux4_1
XFILLER_701_137 VPWR VGND sg13cmos5l_decap_8
XFILLER_698_199 VPWR VGND sg13cmos5l_decap_4
X_3518_ Tile_X0Y1_E1BEG[0] _3928_/X VPWR VGND sg13cmos5l_buf_1
X_4498_ _4498_/X Tile_X0Y6_W2MID[5] AXI_M_SOC_RDATA26 _4557_/X _4556_/X _2611_/Q _2610_/Q
+ VPWR VGND sg13cmos5l_mux4_1
XFILLER_415_35 VPWR VGND sg13cmos5l_decap_8
XFILLER_562_63 VPWR VGND sg13cmos5l_decap_8
XFILLER_134_14 VPWR VGND sg13cmos5l_decap_8
X_3449_ Tile_X0Y1_FrameData_O[7] Tile_X0Y1_FrameData[7] VPWR VGND sg13cmos5l_buf_1
XFILLER_654_214 VPWR VGND sg13cmos5l_decap_4
XFILLER_465_125 VPWR VGND sg13cmos5l_fill_1
XFILLER_281_42 VPWR VGND sg13cmos5l_decap_8
XFILLER_465_147 VPWR VGND sg13cmos5l_fill_2
XFILLER_69_182 VPWR VGND sg13cmos5l_fill_1
XANTENNA__2784__X Tile_X0Y3_EE4BEG[10] VPWR VGND sg13cmos5l_antennanp
XFILLER_712_77 VPWR VGND sg13cmos5l_decap_8
XFILLER_217_125 VPWR VGND sg13cmos5l_decap_8
XFILLER_431_56 VPWR VGND sg13cmos5l_decap_8
XFILLER_214_91 VPWR VGND sg13cmos5l_decap_8
XFILLER_84_185 VPWR VGND sg13cmos5l_decap_8
XFILLER_27_56 VPWR VGND sg13cmos5l_decap_4
XFILLER_150_35 VPWR VGND sg13cmos5l_decap_8
XFILLER_447_7 VPWR VGND sg13cmos5l_decap_8
XFILLER_575_210 VPWR VGND sg13cmos5l_decap_8
XFILLER_43_55 VPWR VGND sg13cmos5l_decap_4
XFILLER_185_205 VPWR VGND sg13cmos5l_fill_2
XFILLER_614_7 VPWR VGND sg13cmos5l_decap_8
XFILLER_386_198 VPWR VGND sg13cmos5l_decap_8
XFILLER_309_14 VPWR VGND sg13cmos5l_decap_8
XFILLER_528_192 VPWR VGND sg13cmos5l_fill_1
XFILLER_138_154 VPWR VGND sg13cmos5l_fill_1
XFILLER_456_42 VPWR VGND sg13cmos5l_decap_8
XFILLER_138_176 VPWR VGND sg13cmos5l_decap_8
XFILLER_175_21 VPWR VGND sg13cmos5l_decap_8
XFILLER_299_117 VPWR VGND sg13cmos5l_decap_8
XFILLER_153_135 VPWR VGND sg13cmos5l_fill_1
XANTENNA__2959__X Tile_X0Y8_EE4BEG[15] VPWR VGND sg13cmos5l_antennanp
XFILLER_299_139 VPWR VGND sg13cmos5l_decap_8
XFILLER_153_157 VPWR VGND sg13cmos5l_decap_4
XFILLER_104_0 VPWR VGND sg13cmos5l_decap_8
XFILLER_606_56 VPWR VGND sg13cmos5l_fill_1
XFILLER_325_35 VPWR VGND sg13cmos5l_decap_8
XFILLER_4_49 VPWR VGND sg13cmos5l_decap_8
XFILLER_645_203 VPWR VGND sg13cmos5l_decap_8
XFILLER_456_114 VPWR VGND sg13cmos5l_decap_8
XFILLER_191_20 VPWR VGND sg13cmos5l_decap_8
XFILLER_456_125 VPWR VGND sg13cmos5l_fill_1
XFILLER_67_108 VPWR VGND sg13cmos5l_decap_8
XFILLER_68_85 VPWR VGND sg13cmos5l_decap_8
XFILLER_456_147 VPWR VGND sg13cmos5l_decap_4
XFILLER_310_176 VPWR VGND sg13cmos5l_decap_4
XFILLER_473_0 VPWR VGND sg13cmos5l_decap_8
XFILLER_405_90 VPWR VGND sg13cmos5l_decap_4
XFILLER_660_217 VPWR VGND sg13cmos5l_fill_1
XFILLER_622_77 VPWR VGND sg13cmos5l_decap_8
XFILLER_471_117 VPWR VGND sg13cmos5l_fill_2
XFILLER_208_125 VPWR VGND sg13cmos5l_decap_4
XFILLER_464_180 VPWR VGND sg13cmos5l_fill_2
XFILLER_341_56 VPWR VGND sg13cmos5l_decap_8
XFILLER_124_91 VPWR VGND sg13cmos5l_decap_8
XFILLER_90_100 VPWR VGND sg13cmos5l_decap_8
XFILLER_640_0 VPWR VGND sg13cmos5l_decap_8
XFILLER_613_155 VPWR VGND sg13cmos5l_decap_4
XFILLER_412_217 VPWR VGND sg13cmos5l_fill_1
XFILLER_210_27 VPWR VGND sg13cmos5l_decap_8
XFILLER_566_210 VPWR VGND sg13cmos5l_fill_1
XFILLER_377_132 VPWR VGND sg13cmos5l_decap_8
XFILLER_231_150 VPWR VGND sg13cmos5l_decap_8
X_2820_ Tile_X0Y3_E1BEG[2] _4146_/X VPWR VGND sg13cmos5l_buf_1
XFILLER_377_165 VPWR VGND sg13cmos5l_decap_8
XFILLER_392_102 VPWR VGND sg13cmos5l_decap_8
XFILLER_715_207 VPWR VGND sg13cmos5l_fill_2
XFILLER_581_202 VPWR VGND sg13cmos5l_fill_1
X_2751_ Tile_X0Y3_FrameData_O[9] Tile_X0Y3_FrameData[9] VPWR VGND sg13cmos5l_buf_1
XFILLER_647_63 VPWR VGND sg13cmos5l_decap_8
XFILLER_392_146 VPWR VGND sg13cmos5l_decap_8
XFILLER_366_42 VPWR VGND sg13cmos5l_decap_8
XFILLER_129_165 VPWR VGND sg13cmos5l_decap_4
X_1702_ _1702_/Q Tile_X0Y3_FrameData[3] VGND VPWR Tile_X0Y9_FrameStrobe[0] latch
X_2682_ _2682_/Q Tile_X0Y6_FrameData[13] VGND VPWR Tile_X0Y9_FrameStrobe[7] latch
XFILLER_534_151 VPWR VGND sg13cmos5l_decap_4
XFILLER_144_102 VPWR VGND sg13cmos5l_decap_4
XFILLER_144_135 VPWR VGND sg13cmos5l_decap_8
X_1633_ _1633_/Q Tile_X0Y2_FrameData[16] VGND VPWR Tile_X0Y9_FrameStrobe[6] latch
X_4421_ _4421_/X Tile_X0Y6_W1END[1] Tile_X0Y6_W6END[5] _4581_/X _4541_/X _2693_/Q
+ _2692_/Q VPWR VGND sg13cmos5l_mux4_1
XFILLER_479_217 VPWR VGND sg13cmos5l_fill_1
XANTENNA__2869__X Tile_X0Y6_EE4BEG[6] VPWR VGND sg13cmos5l_antennanp
XFILLER_144_157 VPWR VGND sg13cmos5l_decap_8
XFILLER_144_168 VPWR VGND sg13cmos5l_fill_1
XFILLER_516_56 VPWR VGND sg13cmos5l_decap_8
X_1564_ _1564_/Q Tile_X0Y2_FrameData[21] VGND VPWR Tile_X0Y9_FrameStrobe[4] latch
X_4352_ _4352_/X Tile_X0Y3_W2MID[7] Tile_X0Y3_W2END[7] Tile_X0Y3_W6END[8] _4205_/X
+ _1881_/Q _1880_/Q VPWR VGND sg13cmos5l_mux4_1
XFILLER_663_84 VPWR VGND sg13cmos5l_decap_8
X_0515_ _0515_/Q Tile_X0Y8_FrameData[28] VGND VPWR Tile_X0Y9_FrameStrobe[3] latch
X_3303_ Tile_X0Y0_E2BEG[3] _3807_/X VPWR VGND sg13cmos5l_buf_1
X_4283_ _4283_/X Tile_X0Y4_WW4END[4] AXI_M_SOC_BRESP0 _4340_/X _4318_/X _2047_/Q _2046_/Q
+ VPWR VGND sg13cmos5l_mux4_1
X_1495_ _1495_/Q Tile_X0Y2_FrameData[26] VGND VPWR Tile_X0Y9_FrameStrobe[2] latch
XFILLER_298_194 VPWR VGND sg13cmos5l_decap_8
XFILLER_235_79 VPWR VGND sg13cmos5l_fill_2
X_3234_ Tile_X0Y0_FrameData_O[2] Tile_X0Y0_FrameData[2] VPWR VGND sg13cmos5l_buf_1
X_0446_ _0446_/Q Tile_X0Y8_FrameData[1] VGND VPWR Tile_X0Y9_FrameStrobe[0] latch
XFILLER_447_158 VPWR VGND sg13cmos5l_decap_8
XFILLER_462_106 VPWR VGND sg13cmos5l_decap_8
X_3165_ Tile_X0Y4_E6BEG[2] _4290_/X VPWR VGND sg13cmos5l_buf_1
XFILLER_651_217 VPWR VGND sg13cmos5l_fill_1
X_0377_ _0377_/Q Tile_X0Y7_FrameData[6] VGND VPWR Tile_X0Y9_FrameStrobe[6] latch
XFILLER_604_111 VPWR VGND sg13cmos5l_decap_8
X_2116_ _2116_/Q Tile_X0Y4_FrameData[1] VGND VPWR Tile_X0Y9_FrameStrobe[5] latch
XFILLER_604_122 VPWR VGND sg13cmos5l_fill_2
X_3096_ Tile_X0Y7_E2BEGb[2] _4622_/X VPWR VGND sg13cmos5l_buf_1
XFILLER_604_166 VPWR VGND sg13cmos5l_decap_8
X_2047_ _2047_/Q Tile_X0Y4_FrameData[6] VGND VPWR Tile_X0Y9_FrameStrobe[3] latch
XFILLER_81_177 VPWR VGND sg13cmos5l_decap_8
XFILLER_120_27 VPWR VGND sg13cmos5l_decap_8
XFILLER_222_150 VPWR VGND sg13cmos5l_decap_4
XFILLER_383_102 VPWR VGND sg13cmos5l_decap_8
X_3998_ _3998_/X _4455_/X _4459_/X _4463_/X _4467_/X _2415_/Q _2414_/Q VPWR VGND sg13cmos5l_mux4_1
XFILLER_13_14 VPWR VGND sg13cmos5l_decap_8
XFILLER_309_210 VPWR VGND sg13cmos5l_decap_8
XFILLER_557_63 VPWR VGND sg13cmos5l_decap_8
X_2949_ Tile_X0Y8_EE4BEG[5] _4749_/X VPWR VGND sg13cmos5l_buf_1
XFILLER_129_14 VPWR VGND sg13cmos5l_decap_8
XFILLER_182_208 VPWR VGND sg13cmos5l_fill_1
XFILLER_276_42 VPWR VGND sg13cmos5l_decap_8
XFILLER_324_202 VPWR VGND sg13cmos5l_decap_8
XANTENNA__2779__X Tile_X0Y3_EE4BEG[5] VPWR VGND sg13cmos5l_antennanp
XFILLER_707_77 VPWR VGND sg13cmos5l_decap_8
X_4619_ _4619_/X Tile_X0Y7_W2MID[0] AXI_M_SOC_RDATA23 _4669_/X _4668_/X _0321_/Q _0320_/Q
+ VPWR VGND sg13cmos5l_mux4_1
XFILLER_426_56 VPWR VGND sg13cmos5l_decap_8
XFILLER_540_154 VPWR VGND sg13cmos5l_fill_1
XFILLER_209_91 VPWR VGND sg13cmos5l_decap_8
XFILLER_573_84 VPWR VGND sg13cmos5l_decap_8
XFILLER_540_176 VPWR VGND sg13cmos5l_decap_4
XFILLER_8_7 VPWR VGND sg13cmos5l_decap_8
XFILLER_145_35 VPWR VGND sg13cmos5l_decap_8
XFILLER_292_63 VPWR VGND sg13cmos5l_decap_8
XFILLER_438_114 VPWR VGND sg13cmos5l_fill_1
XFILLER_397_7 VPWR VGND sg13cmos5l_decap_8
XFILLER_289_194 VPWR VGND sg13cmos5l_decap_8
XFILLER_438_147 VPWR VGND sg13cmos5l_fill_2
XFILLER_38_22 VPWR VGND sg13cmos5l_fill_1
XFILLER_38_33 VPWR VGND sg13cmos5l_decap_8
XFILLER_57_130 VPWR VGND sg13cmos5l_fill_2
XFILLER_564_7 VPWR VGND sg13cmos5l_decap_8
XFILLER_161_45 VPWR VGND sg13cmos5l_decap_8
XANTENNA__3403__X Tile_X0Y2_E2BEG[6] VPWR VGND sg13cmos5l_antennanp
XFILLER_72_111 VPWR VGND sg13cmos5l_fill_2
XFILLER_598_70 VPWR VGND sg13cmos5l_decap_4
XFILLER_72_188 VPWR VGND sg13cmos5l_decap_8
XFILLER_54_65 VPWR VGND sg13cmos5l_decap_8
XFILLER_220_109 VPWR VGND sg13cmos5l_decap_8
XFILLER_213_161 VPWR VGND sg13cmos5l_decap_8
XFILLER_374_113 VPWR VGND sg13cmos5l_decap_8
XFILLER_374_124 VPWR VGND sg13cmos5l_fill_1
XFILLER_110_82 VPWR VGND sg13cmos5l_decap_8
XFILLER_70_42 VPWR VGND sg13cmos5l_decap_8
XFILLER_684_28 VPWR VGND sg13cmos5l_decap_8
XFILLER_467_63 VPWR VGND sg13cmos5l_decap_8
XFILLER_374_146 VPWR VGND sg13cmos5l_decap_8
XFILLER_221_0 VPWR VGND sg13cmos5l_decap_8
XFILLER_319_0 VPWR VGND sg13cmos5l_decap_8
XFILLER_516_151 VPWR VGND sg13cmos5l_fill_1
XFILLER_70_97 VPWR VGND sg13cmos5l_fill_1
XFILLER_516_173 VPWR VGND sg13cmos5l_decap_8
XFILLER_617_77 VPWR VGND sg13cmos5l_decap_8
XFILLER_382_190 VPWR VGND sg13cmos5l_decap_8
XFILLER_79_40 VPWR VGND sg13cmos5l_decap_8
XFILLER_336_56 VPWR VGND sg13cmos5l_decap_8
XFILLER_336_67 VPWR VGND sg13cmos5l_fill_1
XFILLER_330_216 VPWR VGND sg13cmos5l_fill_2
XFILLER_287_109 VPWR VGND sg13cmos5l_fill_1
XFILLER_633_21 VPWR VGND sg13cmos5l_decap_8
XFILLER_590_0 VPWR VGND sg13cmos5l_decap_8
XFILLER_141_138 VPWR VGND sg13cmos5l_decap_8
XFILLER_79_84 VPWR VGND sg13cmos5l_fill_1
XFILLER_688_0 VPWR VGND sg13cmos5l_decap_8
X_0300_ _0300_/Q Tile_X0Y7_FrameData[19] VGND VPWR Tile_X0Y9_FrameStrobe[4] latch
XFILLER_429_147 VPWR VGND sg13cmos5l_decap_8
X_1280_ _1280_/Q Tile_X0Y1_FrameData[25] VGND VPWR Tile_X0Y9_FrameStrobe[3] latch
XFILLER_633_98 VPWR VGND sg13cmos5l_decap_8
XFILLER_295_153 VPWR VGND sg13cmos5l_fill_1
XFILLER_205_49 VPWR VGND sg13cmos5l_decap_8
XFILLER_95_61 VPWR VGND sg13cmos5l_fill_2
X_0231_ _0231_/Q Tile_X0Y7_FrameData[24] VGND VPWR Tile_X0Y9_FrameStrobe[2] latch
XFILLER_633_217 VPWR VGND sg13cmos5l_fill_1
XFILLER_352_77 VPWR VGND sg13cmos5l_decap_8
XFILLER_0_192 VPWR VGND sg13cmos5l_decap_8
XFILLER_502_14 VPWR VGND sg13cmos5l_decap_8
XANTENNA__3313__X Tile_X0Y4_EE4BEG[1] VPWR VGND sg13cmos5l_antennanp
X_0162_ _0162_/Q Tile_X0Y7_FrameData[29] VGND VPWR Tile_X0Y9_FrameStrobe[0] latch
XFILLER_598_143 VPWR VGND sg13cmos5l_decap_8
XFILLER_63_144 VPWR VGND sg13cmos5l_decap_8
XFILLER_397_205 VPWR VGND sg13cmos5l_decap_4
X_0093_ _3622_/A _4484_/X _4485_/X _2633_/Q VPWR VGND sg13cmos5l_mux2_1
XFILLER_601_136 VPWR VGND sg13cmos5l_fill_1
X_3921_ _3921_/X _4229_/X _4233_/X _4212_/X _4211_/X _1892_/Q _1891_/Q VPWR VGND sg13cmos5l_mux4_1
XFILLER_601_158 VPWR VGND sg13cmos5l_decap_8
X_3852_ _3852_/X _3903_/X _3902_/X Tile_X0Y0_S2MID[7] Tile_X0Y0_S2END[7] _0949_/Q
+ _0948_/Q VPWR VGND sg13cmos5l_mux4_1
XFILLER_365_102 VPWR VGND sg13cmos5l_fill_1
XFILLER_554_202 VPWR VGND sg13cmos5l_decap_8
XFILLER_81_2 VPWR VGND sg13cmos5l_fill_1
XFILLER_365_124 VPWR VGND sg13cmos5l_decap_8
X_2803_ Tile_X0Y3_E2BEGb[1] _4157_/X VPWR VGND sg13cmos5l_buf_1
XFILLER_594_28 VPWR VGND sg13cmos5l_decap_8
X_0995_ _0995_/Q Tile_X0Y0_FrameData[8] VGND VPWR Tile_X0Y9_FrameStrobe[1] latch
X_3783_ _3783_/X Tile_X0Y0_W1END[3] Tile_X0Y0_W6END[7] _3863_/X _3880_/X _1171_/Q
+ _1170_/Q VPWR VGND sg13cmos5l_mux4_1
XFILLER_377_96 VPWR VGND sg13cmos5l_decap_8
X_2734_ _3977_/A3 VPWR VGND sg13cmos5l_tielo
XFILLER_67_0 VPWR VGND sg13cmos5l_fill_2
XFILLER_373_190 VPWR VGND sg13cmos5l_decap_8
X_2665_ _2665_/Q Tile_X0Y6_FrameData[30] VGND VPWR Tile_X0Y9_FrameStrobe[7] latch
XFILLER_117_168 VPWR VGND sg13cmos5l_decap_8
XFILLER_522_154 VPWR VGND sg13cmos5l_fill_2
XFILLER_132_105 VPWR VGND sg13cmos5l_decap_8
X_4404_ _4404_/X _0157_/X _0143_/X _4462_/X _4466_/X _2295_/Q _2294_/Q VPWR VGND sg13cmos5l_mux4_1
X_1616_ _1616_/Q Tile_X0Y2_FrameData[1] VGND VPWR Tile_X0Y9_FrameStrobe[5] latch
X_2596_ _2596_/Q Tile_X0Y6_FrameData[3] VGND VPWR Tile_X0Y9_FrameStrobe[4] latch
XFILLER_543_21 VPWR VGND sg13cmos5l_decap_8
XFILLER_5_70 VPWR VGND sg13cmos5l_decap_8
X_4335_ _4335_/X _4807_/X _4811_/X _4815_/X _4791_/X _0638_/Q _0637_/Q VPWR VGND sg13cmos5l_mux4_1
X_1547_ _1547_/Q Tile_X0Y2_FrameData[6] VGND VPWR Tile_X0Y9_FrameStrobe[3] latch
XFILLER_140_171 VPWR VGND sg13cmos5l_decap_8
X_1478_ _1478_/Q Tile_X0Y2_FrameData[11] VGND VPWR Tile_X0Y9_FrameStrobe[1] latch
X_4266_ _4266_/X Tile_X0Y4_W2END[5] AXI_M_SOC_BRESP1 _4317_/X _4316_/X _2081_/Q _2080_/Q
+ VPWR VGND sg13cmos5l_mux4_1
X_0429_ _0429_/Q Tile_X0Y8_FrameData[18] VGND VPWR Tile_X0Y9_FrameStrobe[0] latch
X_3217_ Tile_X0Y0_FrameStrobe_O[5] Tile_X0Y9_FrameStrobe[5] VPWR VGND sg13cmos5l_buf_1
XFILLER_286_197 VPWR VGND sg13cmos5l_decap_8
XFILLER_412_14 VPWR VGND sg13cmos5l_decap_8
X_4197_ _4197_/X Tile_X0Y4_W1END[1] Tile_X0Y4_W6END[5] _4349_/X _4303_/X _2179_/Q
+ _2178_/Q VPWR VGND sg13cmos5l_mux4_1
XANTENNA__3223__X Tile_X0Y0_FrameStrobe_O[11] VPWR VGND sg13cmos5l_antennanp
XFILLER_54_100 VPWR VGND sg13cmos5l_decap_8
X_3148_ Tile_X0Y7_FrameData_O[18] Tile_X0Y7_FrameData[18] VPWR VGND sg13cmos5l_buf_1
XFILLER_589_143 VPWR VGND sg13cmos5l_decap_8
XFILLER_242_201 VPWR VGND sg13cmos5l_fill_2
XFILLER_699_91 VPWR VGND sg13cmos5l_decap_8
XFILLER_443_172 VPWR VGND sg13cmos5l_decap_8
X_3079_ Tile_X0Y4_E2BEGb[5] _4269_/X VPWR VGND sg13cmos5l_buf_1
XFILLER_199_138 VPWR VGND sg13cmos5l_decap_8
XFILLER_54_199 VPWR VGND sg13cmos5l_decap_8
XFILLER_211_70 VPWR VGND sg13cmos5l_decap_8
XFILLER_24_35 VPWR VGND sg13cmos5l_decap_8
XFILLER_145_7 VPWR VGND sg13cmos5l_decap_8
XFILLER_568_84 VPWR VGND sg13cmos5l_decap_8
XFILLER_600_180 VPWR VGND sg13cmos5l_decap_8
XFILLER_600_191 VPWR VGND sg13cmos5l_fill_2
XFILLER_287_63 VPWR VGND sg13cmos5l_decap_8
XFILLER_210_153 VPWR VGND sg13cmos5l_fill_2
XFILLER_356_168 VPWR VGND sg13cmos5l_decap_8
XFILLER_356_179 VPWR VGND sg13cmos5l_fill_2
XFILLER_312_7 VPWR VGND sg13cmos5l_decap_8
XFILLER_40_23 VPWR VGND sg13cmos5l_fill_1
XFILLER_305_6 VPWR VGND sg13cmos5l_decap_8
XFILLER_437_77 VPWR VGND sg13cmos5l_decap_8
XFILLER_108_157 VPWR VGND sg13cmos5l_decap_8
XFILLER_513_143 VPWR VGND sg13cmos5l_decap_8
XFILLER_659_158 VPWR VGND sg13cmos5l_fill_1
XFILLER_453_21 VPWR VGND sg13cmos5l_decap_8
XFILLER_681_7 VPWR VGND sg13cmos5l_decap_8
XFILLER_49_43 VPWR VGND sg13cmos5l_decap_8
XFILLER_453_76 VPWR VGND sg13cmos5l_decap_8
XFILLER_603_35 VPWR VGND sg13cmos5l_decap_8
XFILLER_682_150 VPWR VGND sg13cmos5l_decap_4
XFILLER_682_161 VPWR VGND sg13cmos5l_fill_2
XFILLER_322_14 VPWR VGND sg13cmos5l_decap_8
XFILLER_1_28 VPWR VGND sg13cmos5l_decap_8
XFILLER_92_206 VPWR VGND sg13cmos5l_decap_4
XANTENNA__3133__X Tile_X0Y7_FrameData_O[3] VPWR VGND sg13cmos5l_antennanp
XFILLER_92_217 VPWR VGND sg13cmos5l_fill_1
XFILLER_679_28 VPWR VGND sg13cmos5l_decap_8
XFILLER_441_109 VPWR VGND sg13cmos5l_decap_4
XFILLER_171_0 VPWR VGND sg13cmos5l_decap_8
XFILLER_65_75 VPWR VGND sg13cmos5l_decap_8
XFILLER_269_0 VPWR VGND sg13cmos5l_decap_8
XANTENNA__2972__X Tile_X0Y8_FrameData_O[12] VPWR VGND sg13cmos5l_antennanp
XFILLER_121_70 VPWR VGND sg13cmos5l_decap_8
XFILLER_60_147 VPWR VGND sg13cmos5l_decap_8
XFILLER_436_0 VPWR VGND sg13cmos5l_fill_2
XFILLER_595_179 VPWR VGND sg13cmos5l_decap_4
XFILLER_695_49 VPWR VGND sg13cmos5l_decap_8
XFILLER_628_21 VPWR VGND sg13cmos5l_decap_8
XFILLER_197_63 VPWR VGND sg13cmos5l_decap_8
XFILLER_603_0 VPWR VGND sg13cmos5l_decap_8
XFILLER_347_157 VPWR VGND sg13cmos5l_fill_1
XFILLER_201_175 VPWR VGND sg13cmos5l_fill_1
XFILLER_551_205 VPWR VGND sg13cmos5l_fill_1
X_0780_ _0780_/Q Tile_X0Y9_FrameData[19] VGND VPWR Tile_X0Y9_FrameStrobe[3] latch
XFILLER_551_216 VPWR VGND sg13cmos5l_fill_2
XFILLER_628_98 VPWR VGND sg13cmos5l_decap_8
XFILLER_60_7 VPWR VGND sg13cmos5l_decap_8
XFILLER_362_149 VPWR VGND sg13cmos5l_decap_4
XFILLER_347_77 VPWR VGND sg13cmos5l_decap_8
XANTENNA__3308__X Tile_X0Y0_E1BEG[0] VPWR VGND sg13cmos5l_antennanp
XFILLER_644_42 VPWR VGND sg13cmos5l_decap_8
XFILLER_53_6 VPWR VGND sg13cmos5l_decap_8
XFILLER_504_154 VPWR VGND sg13cmos5l_decap_8
X_2450_ _2450_/Q Tile_X0Y6_FrameData[21] VGND VPWR Tile_X0Y9_FrameStrobe[0] latch
XFILLER_370_182 VPWR VGND sg13cmos5l_decap_8
X_1401_ _1401_/Q Tile_X0Y1_FrameData[0] VGND VPWR Tile_X0Y9_FrameStrobe[6] latch
X_2381_ _2381_/Q Tile_X0Y5_FrameData[24] VGND VPWR Tile_X0Y9_FrameStrobe[6] latch
XFILLER_658_191 VPWR VGND sg13cmos5l_decap_4
X_1332_ _1332_/Q Tile_X0Y1_FrameData[5] VGND VPWR Tile_X0Y9_FrameStrobe[4] latch
X_4120_ _4120_/X _4089_/X _0079_/X _4088_/X Tile_X0Y0_S4END[8] _1473_/Q _1472_/Q VPWR
+ VGND sg13cmos5l_mux4_1
XFILLER_68_214 VPWR VGND sg13cmos5l_decap_4
XFILLER_513_35 VPWR VGND sg13cmos5l_decap_8
XFILLER_472_201 VPWR VGND sg13cmos5l_decap_8
XFILLER_283_112 VPWR VGND sg13cmos5l_decap_8
X_1263_ _1263_/Q Tile_X0Y1_FrameData[10] VGND VPWR Tile_X0Y9_FrameStrobe[2] latch
X_4051_ _4051_/X Tile_X0Y2_W2END[4] AXI_M_SOC_AWREADY _4103_/X _4102_/X _1571_/Q _1570_/Q
+ VPWR VGND sg13cmos5l_mux4_1
XFILLER_660_63 VPWR VGND sg13cmos5l_decap_8
XFILLER_83_217 VPWR VGND sg13cmos5l_fill_1
XFILLER_513_79 VPWR VGND sg13cmos5l_fill_1
XANTENNA__3043__X Tile_X0Y5_FrameData_O[2] VPWR VGND sg13cmos5l_antennanp
X_0214_ _0214_/Q Tile_X0Y7_FrameData[9] VGND VPWR Tile_X0Y9_FrameStrobe[1] latch
X_3002_ Tile_X0Y5_E2BEG[5] _4377_/X VPWR VGND sg13cmos5l_buf_1
XFILLER_589_28 VPWR VGND sg13cmos5l_decap_8
X_1194_ _1194_/Q Tile_X0Y1_FrameData[15] VGND VPWR Tile_X0Y9_FrameStrobe[0] latch
XFILLER_232_69 VPWR VGND sg13cmos5l_decap_8
XFILLER_425_161 VPWR VGND sg13cmos5l_decap_8
X_0145_ _0145_/X _4439_/X _4440_/X _1360_/Q VPWR VGND sg13cmos5l_mux2_1
XANTENNA__2882__X Tile_X0Y6_FrameData_O[3] VPWR VGND sg13cmos5l_antennanp
XFILLER_425_194 VPWR VGND sg13cmos5l_decap_4
XFILLER_669_50 VPWR VGND sg13cmos5l_decap_8
XFILLER_586_113 VPWR VGND sg13cmos5l_decap_8
X_0076_ _0076_/X _4794_/X _4795_/X _2116_/Q VPWR VGND sg13cmos5l_mux2_1
X_3904_ _3904_/X Tile_X0Y1_W1END[3] Tile_X0Y1_WW4END[3] Tile_X0Y1_W6END[11] _4011_/X
+ _1392_/Q _1391_/Q VPWR VGND sg13cmos5l_mux4_1
XFILLER_51_169 VPWR VGND sg13cmos5l_decap_4
XFILLER_440_197 VPWR VGND sg13cmos5l_decap_8
X_4884_ _4884_/X AXI_M_SOC_RDATA0 _4923_/X _4927_/X _4901_/X _0775_/Q _0774_/Q VPWR
+ VGND sg13cmos5l_mux4_1
XFILLER_538_21 VPWR VGND sg13cmos5l_decap_8
X_3835_ _3835_/X Tile_X0Y0_WW4END[0] Tile_X0Y0_WW4END[9] _3881_/X _3853_/X _1035_/Q
+ _1034_/Q VPWR VGND sg13cmos5l_mux4_1
XFILLER_538_76 VPWR VGND sg13cmos5l_decap_8
XFILLER_353_105 VPWR VGND sg13cmos5l_decap_8
X_3766_ _3766_/X Tile_X0Y1_WW4END[7] Tile_X0Y1_WW4END[15] Tile_X0Y1_W6END[7] _4015_/X
+ _1243_/Q _1242_/Q VPWR VGND sg13cmos5l_mux4_1
X_0978_ _0978_/Q Tile_X0Y0_FrameData[25] VGND VPWR Tile_X0Y9_FrameStrobe[1] latch
X_2717_ _4773_/A3 VPWR VGND sg13cmos5l_tielo
XFILLER_407_14 VPWR VGND sg13cmos5l_decap_8
XFILLER_257_88 VPWR VGND sg13cmos5l_decap_8
X_3697_ AXI_M_SOC_WDATA7 Tile_X0Y7_WW4END[7] Tile_X0Y7_WW4END[15] Tile_X0Y7_W6END[7]
+ _4691_/X _0233_/Q _0232_/Q VPWR VGND sg13cmos5l_mux4_1
XANTENNA__3218__X Tile_X0Y0_FrameStrobe_O[6] VPWR VGND sg13cmos5l_antennanp
XFILLER_554_42 VPWR VGND sg13cmos5l_decap_8
XFILLER_105_116 VPWR VGND sg13cmos5l_decap_8
X_2648_ _2648_/Q Tile_X0Y6_FrameData[15] VGND VPWR Tile_X0Y9_FrameStrobe[6] latch
XFILLER_273_21 VPWR VGND sg13cmos5l_decap_8
XFILLER_126_37 VPWR VGND sg13cmos5l_fill_1
X_2579_ _2579_/Q Tile_X0Y6_FrameData[20] VGND VPWR Tile_X0Y9_FrameStrobe[4] latch
XFILLER_120_108 VPWR VGND sg13cmos5l_fill_2
XFILLER_704_56 VPWR VGND sg13cmos5l_decap_8
X_4318_ _4318_/X _4245_/X _4361_/X _4360_/X _4244_/X _1941_/Q _1940_/Q VPWR VGND sg13cmos5l_mux4_1
XFILLER_273_98 VPWR VGND sg13cmos5l_decap_8
XFILLER_423_35 VPWR VGND sg13cmos5l_decap_8
XFILLER_274_112 VPWR VGND sg13cmos5l_decap_8
XFILLER_19_35 VPWR VGND sg13cmos5l_decap_8
XFILLER_570_63 VPWR VGND sg13cmos5l_decap_8
XFILLER_142_14 VPWR VGND sg13cmos5l_decap_8
X_4249_ _4249_/X Tile_X0Y5_W2MID[1] Tile_X0Y5_W2END[1] Tile_X0Y5_W6END[1] _4429_/X
+ _2419_/Q _2418_/Q VPWR VGND sg13cmos5l_mux4_1
XFILLER_74_217 VPWR VGND sg13cmos5l_fill_1
XFILLER_499_28 VPWR VGND sg13cmos5l_decap_8
XANTENNA__2792__X Tile_X0Y3_E6BEG[2] VPWR VGND sg13cmos5l_antennanp
XFILLER_262_7 VPWR VGND sg13cmos5l_decap_8
XFILLER_431_120 VPWR VGND sg13cmos5l_decap_8
XFILLER_27_188 VPWR VGND sg13cmos5l_decap_8
XFILLER_431_142 VPWR VGND sg13cmos5l_decap_8
XFILLER_35_56 VPWR VGND sg13cmos5l_decap_8
XFILLER_431_175 VPWR VGND sg13cmos5l_decap_8
XFILLER_376_208 VPWR VGND sg13cmos5l_decap_8
XFILLER_230_215 VPWR VGND sg13cmos5l_fill_2
XFILLER_577_168 VPWR VGND sg13cmos5l_decap_8
XFILLER_527_7 VPWR VGND sg13cmos5l_decap_8
XFILLER_298_84 VPWR VGND sg13cmos5l_decap_8
XFILLER_518_213 VPWR VGND sg13cmos5l_decap_4
XFILLER_448_21 VPWR VGND sg13cmos5l_decap_8
XFILLER_195_130 VPWR VGND sg13cmos5l_fill_2
XFILLER_585_190 VPWR VGND sg13cmos5l_fill_1
XFILLER_50_180 VPWR VGND sg13cmos5l_decap_8
XFILLER_50_191 VPWR VGND sg13cmos5l_fill_1
XFILLER_51_55 VPWR VGND sg13cmos5l_decap_8
XFILLER_448_87 VPWR VGND sg13cmos5l_decap_8
XFILLER_344_116 VPWR VGND sg13cmos5l_decap_8
XFILLER_344_127 VPWR VGND sg13cmos5l_fill_2
XFILLER_337_190 VPWR VGND sg13cmos5l_decap_4
XFILLER_317_14 VPWR VGND sg13cmos5l_decap_8
XANTENNA__3128__X Tile_X0Y7_EE4BEG[14] VPWR VGND sg13cmos5l_antennanp
XFILLER_464_42 VPWR VGND sg13cmos5l_decap_8
XFILLER_297_215 VPWR VGND sg13cmos5l_fill_2
XFILLER_183_21 VPWR VGND sg13cmos5l_decap_8
XFILLER_498_175 VPWR VGND sg13cmos5l_decap_8
XFILLER_352_193 VPWR VGND sg13cmos5l_fill_1
XFILLER_183_32 VPWR VGND sg13cmos5l_fill_1
XANTENNA__2967__X Tile_X0Y8_FrameData_O[7] VPWR VGND sg13cmos5l_antennanp
XFILLER_614_56 VPWR VGND sg13cmos5l_decap_8
XFILLER_501_168 VPWR VGND sg13cmos5l_decap_8
XFILLER_104_171 VPWR VGND sg13cmos5l_decap_8
XFILLER_333_35 VPWR VGND sg13cmos5l_decap_8
XFILLER_386_0 VPWR VGND sg13cmos5l_decap_8
XFILLER_480_63 VPWR VGND sg13cmos5l_fill_2
XFILLER_454_212 VPWR VGND sg13cmos5l_decap_4
XFILLER_76_63 VPWR VGND sg13cmos5l_decap_8
XFILLER_65_217 VPWR VGND sg13cmos5l_fill_1
XFILLER_553_0 VPWR VGND sg13cmos5l_decap_8
XFILLER_280_126 VPWR VGND sg13cmos5l_decap_8
XFILLER_18_133 VPWR VGND sg13cmos5l_fill_1
XFILLER_630_77 VPWR VGND sg13cmos5l_decap_8
XFILLER_202_28 VPWR VGND sg13cmos5l_decap_8
XFILLER_407_194 VPWR VGND sg13cmos5l_fill_2
XFILLER_132_91 VPWR VGND sg13cmos5l_decap_8
XFILLER_18_188 VPWR VGND sg13cmos5l_decap_8
XFILLER_92_62 VPWR VGND sg13cmos5l_decap_4
XFILLER_92_73 VPWR VGND sg13cmos5l_decap_4
XFILLER_568_168 VPWR VGND sg13cmos5l_decap_8
XFILLER_639_42 VPWR VGND sg13cmos5l_decap_8
XFILLER_583_105 VPWR VGND sg13cmos5l_decap_4
X_1950_ _1950_/Q Tile_X0Y4_FrameData[7] VGND VPWR Tile_X0Y9_FrameStrobe[0] latch
XFILLER_358_21 VPWR VGND sg13cmos5l_decap_8
X_0901_ _0901_/Q Tile_X0Y9_FrameData[26] VGND VPWR Tile_X0Y9_FrameStrobe[7] latch
X_1881_ _1881_/Q Tile_X0Y3_FrameData[16] VGND VPWR Tile_X0Y9_FrameStrobe[6] latch
X_3620_ Tile_X0Y9_S2BEGb[6] _4938_/X VPWR VGND sg13cmos5l_buf_1
XFILLER_186_185 VPWR VGND sg13cmos5l_decap_8
X_0832_ _0832_/Q Tile_X0Y9_FrameData[31] VGND VPWR Tile_X0Y9_FrameStrobe[5] latch
XFILLER_524_216 VPWR VGND sg13cmos5l_fill_2
XFILLER_358_98 VPWR VGND sg13cmos5l_decap_8
XFILLER_508_35 VPWR VGND sg13cmos5l_decap_8
XFILLER_335_149 VPWR VGND sg13cmos5l_decap_8
X_3551_ Tile_X0Y9_E6BEG[9] _4889_/X VPWR VGND sg13cmos5l_buf_1
XFILLER_655_63 VPWR VGND sg13cmos5l_decap_8
X_0763_ _0763_/Q Tile_X0Y9_FrameData[4] VGND VPWR Tile_X0Y9_FrameStrobe[2] latch
XANTENNA__3038__X Tile_X0Y5_EE4BEG[13] VPWR VGND sg13cmos5l_antennanp
XFILLER_374_42 VPWR VGND sg13cmos5l_decap_8
XFILLER_350_119 VPWR VGND sg13cmos5l_decap_8
X_2502_ _2502_/Q Tile_X0Y6_FrameData[1] VGND VPWR Tile_X0Y9_FrameStrobe[1] latch
XFILLER_343_160 VPWR VGND sg13cmos5l_decap_4
X_0694_ _0694_/Q Tile_X0Y9_FrameData[9] VGND VPWR Tile_X0Y9_FrameStrobe[0] latch
X_3482_ Tile_X0Y1_EE4BEG[8] _3956_/X VPWR VGND sg13cmos5l_buf_1
X_2433_ _2433_/Q Tile_X0Y5_FrameData[4] VGND VPWR Tile_X0Y9_FrameStrobe[7] latch
XANTENNA__2877__X Tile_X0Y6_EE4BEG[14] VPWR VGND sg13cmos5l_antennanp
XFILLER_307_80 VPWR VGND sg13cmos5l_decap_8
XFILLER_307_91 VPWR VGND sg13cmos5l_fill_2
X_2364_ _2364_/Q Tile_X0Y5_FrameData[9] VGND VPWR Tile_X0Y9_FrameStrobe[5] latch
XFILLER_243_35 VPWR VGND sg13cmos5l_decap_8
XFILLER_646_161 VPWR VGND sg13cmos5l_decap_8
X_4103_ _4103_/X _4027_/X _4135_/X _4134_/X _4026_/X _1443_/Q _1442_/Q VPWR VGND sg13cmos5l_mux4_1
XFILLER_110_130 VPWR VGND sg13cmos5l_decap_8
X_1315_ _1315_/Q Tile_X0Y1_FrameData[22] VGND VPWR Tile_X0Y9_FrameStrobe[4] latch
XFILLER_390_63 VPWR VGND sg13cmos5l_decap_8
X_2295_ _2295_/Q Tile_X0Y5_FrameData[14] VGND VPWR Tile_X0Y9_FrameStrobe[3] latch
XFILLER_661_120 VPWR VGND sg13cmos5l_fill_1
X_1246_ _1246_/Q Tile_X0Y1_FrameData[27] VGND VPWR Tile_X0Y9_FrameStrobe[2] latch
X_4034_ _4034_/X Tile_X0Y0_W1END[3] Tile_X0Y0_W2MID[0] Tile_X0Y0_W2END[0] _3852_/X
+ _1119_/Q _1118_/Q VPWR VGND sg13cmos5l_mux4_1
XFILLER_405_109 VPWR VGND sg13cmos5l_decap_8
XFILLER_540_66 VPWR VGND sg13cmos5l_fill_2
XFILLER_112_28 VPWR VGND sg13cmos5l_decap_8
X_1177_ _1177_/Q Tile_X0Y0_FrameData[18] VGND VPWR Tile_X0Y9_FrameStrobe[7] latch
XANTENNA__3501__X Tile_X0Y1_E6BEG[11] VPWR VGND sg13cmos5l_antennanp
XFILLER_559_113 VPWR VGND sg13cmos5l_decap_8
XFILLER_413_142 VPWR VGND sg13cmos5l_decap_4
XFILLER_24_114 VPWR VGND sg13cmos5l_decap_8
X_0128_ _3637_/A _4842_/X _4843_/X _0856_/Q VPWR VGND sg13cmos5l_mux2_1
XFILLER_169_108 VPWR VGND sg13cmos5l_decap_8
XFILLER_24_147 VPWR VGND sg13cmos5l_decap_4
XFILLER_549_42 VPWR VGND sg13cmos5l_decap_8
X_0059_ _3178_/A _3922_/X _3923_/X _1893_/Q VPWR VGND sg13cmos5l_mux2_1
X_4936_ _4936_/X Tile_X0Y8_W1END[0] Tile_X0Y8_W2MID[3] Tile_X0Y8_W2END[3] _4790_/X
+ _0619_/Q _0618_/Q VPWR VGND sg13cmos5l_mux4_1
XFILLER_696_70 VPWR VGND sg13cmos5l_decap_8
XFILLER_268_21 VPWR VGND sg13cmos5l_decap_8
XANTENNA_10 AXI_M_SOC_WREADY VPWR VGND sg13cmos5l_antennanp
XFILLER_567_190 VPWR VGND sg13cmos5l_fill_2
XFILLER_177_141 VPWR VGND sg13cmos5l_decap_8
XANTENNA_21 AXI_M_SOC_WREADY VPWR VGND sg13cmos5l_antennanp
X_4867_ _4867_/X Tile_X0Y9_WW4END[12] AXI_M_SOC_RDATA3 _4928_/X _4906_/X _0809_/Q
+ _0808_/Q VPWR VGND sg13cmos5l_mux4_1
XANTENNA_32 AXI_M_SOC_WREADY VPWR VGND sg13cmos5l_antennanp
XANTENNA_43 Tile_X0Y0_S2MID[4] VPWR VGND sg13cmos5l_antennanp
XANTENNA_54 _0040_/X VPWR VGND sg13cmos5l_antennanp
X_3818_ _3818_/X Tile_X0Y0_W2END[1] Tile_X0Y0_W6END[8] _3855_/X _3854_/X _1069_/Q
+ _1068_/Q VPWR VGND sg13cmos5l_mux4_1
XANTENNA_65 Tile_X0Y9_FrameStrobe[16] VPWR VGND sg13cmos5l_antennanp
XFILLER_326_127 VPWR VGND sg13cmos5l_decap_8
XANTENNA_76 Tile_X0Y9_N2MID[3] VPWR VGND sg13cmos5l_antennanp
X_4798_ _4798_/X Tile_X0Y4_W1END[3] Tile_X0Y4_WW4END[15] Tile_X0Y4_W6END[7] _4339_/X
+ _2112_/Q _2111_/Q VPWR VGND sg13cmos5l_mux4_1
XFILLER_418_35 VPWR VGND sg13cmos5l_decap_8
XFILLER_21_14 VPWR VGND sg13cmos5l_decap_8
XFILLER_565_63 VPWR VGND sg13cmos5l_decap_8
X_3749_ AXI_M_SOC_ARADDR21 Tile_X0Y8_WW4END[5] Tile_X0Y8_WW4END[13] Tile_X0Y8_W6END[5]
+ _4805_/X _0493_/Q _0492_/Q VPWR VGND sg13cmos5l_mux4_1
XFILLER_137_14 VPWR VGND sg13cmos5l_decap_8
XFILLER_284_42 VPWR VGND sg13cmos5l_decap_8
XFILLER_133_200 VPWR VGND sg13cmos5l_fill_1
XFILLER_108_7 VPWR VGND sg13cmos5l_decap_8
XFILLER_715_55 VPWR VGND sg13cmos5l_decap_8
XFILLER_684_201 VPWR VGND sg13cmos5l_fill_1
XFILLER_495_112 VPWR VGND sg13cmos5l_decap_8
XANTENNA__2787__X Tile_X0Y3_EE4BEG[13] VPWR VGND sg13cmos5l_antennanp
XFILLER_434_56 VPWR VGND sg13cmos5l_decap_8
XFILLER_153_35 VPWR VGND sg13cmos5l_decap_8
XFILLER_153_46 VPWR VGND sg13cmos5l_fill_1
XFILLER_153_68 VPWR VGND sg13cmos5l_fill_2
XFILLER_477_7 VPWR VGND sg13cmos5l_decap_8
XFILLER_47_217 VPWR VGND sg13cmos5l_fill_1
XFILLER_101_185 VPWR VGND sg13cmos5l_decap_8
XFILLER_652_175 VPWR VGND sg13cmos5l_decap_8
XFILLER_262_126 VPWR VGND sg13cmos5l_fill_1
XFILLER_644_7 VPWR VGND sg13cmos5l_decap_8
XFILLER_600_14 VPWR VGND sg13cmos5l_decap_8
XFILLER_262_148 VPWR VGND sg13cmos5l_decap_8
XANTENNA__3411__X Tile_X0Y4_FrameData_O[2] VPWR VGND sg13cmos5l_antennanp
XFILLER_404_175 VPWR VGND sg13cmos5l_decap_8
XFILLER_270_181 VPWR VGND sg13cmos5l_fill_1
XFILLER_565_105 VPWR VGND sg13cmos5l_decap_8
XFILLER_459_42 VPWR VGND sg13cmos5l_decap_8
XFILLER_62_54 VPWR VGND sg13cmos5l_fill_1
XFILLER_62_65 VPWR VGND sg13cmos5l_decap_8
XFILLER_565_149 VPWR VGND sg13cmos5l_fill_1
XFILLER_23_191 VPWR VGND sg13cmos5l_decap_8
XFILLER_134_0 VPWR VGND sg13cmos5l_decap_8
XFILLER_609_56 VPWR VGND sg13cmos5l_decap_8
XFILLER_183_111 VPWR VGND sg13cmos5l_decap_8
XFILLER_707_187 VPWR VGND sg13cmos5l_fill_1
XFILLER_7_49 VPWR VGND sg13cmos5l_decap_8
XFILLER_573_182 VPWR VGND sg13cmos5l_decap_8
XFILLER_328_35 VPWR VGND sg13cmos5l_decap_8
XFILLER_317_149 VPWR VGND sg13cmos5l_fill_2
XFILLER_692_28 VPWR VGND sg13cmos5l_decap_8
XFILLER_301_0 VPWR VGND sg13cmos5l_decap_8
XFILLER_194_42 VPWR VGND sg13cmos5l_decap_8
XFILLER_325_193 VPWR VGND sg13cmos5l_decap_8
XFILLER_486_112 VPWR VGND sg13cmos5l_decap_8
XFILLER_625_77 VPWR VGND sg13cmos5l_decap_8
XFILLER_344_56 VPWR VGND sg13cmos5l_decap_8
XFILLER_340_185 VPWR VGND sg13cmos5l_decap_8
XFILLER_491_84 VPWR VGND sg13cmos5l_decap_8
XFILLER_670_0 VPWR VGND sg13cmos5l_decap_8
XFILLER_641_21 VPWR VGND sg13cmos5l_decap_8
XFILLER_87_95 VPWR VGND sg13cmos5l_decap_8
XFILLER_23_7 VPWR VGND sg13cmos5l_decap_8
XFILLER_38_217 VPWR VGND sg13cmos5l_fill_1
X_1100_ _1100_/Q Tile_X0Y0_FrameData[31] VGND VPWR Tile_X0Y9_FrameStrobe[5] latch
X_2080_ _2080_/Q Tile_X0Y4_FrameData[5] VGND VPWR Tile_X0Y9_FrameStrobe[4] latch
XFILLER_641_98 VPWR VGND sg13cmos5l_decap_8
XFILLER_238_189 VPWR VGND sg13cmos5l_fill_1
XFILLER_213_49 VPWR VGND sg13cmos5l_decap_8
XFILLER_442_215 VPWR VGND sg13cmos5l_fill_2
XFILLER_399_108 VPWR VGND sg13cmos5l_decap_8
XFILLER_643_175 VPWR VGND sg13cmos5l_decap_8
X_1031_ _1031_/Q Tile_X0Y0_FrameData[4] VGND VPWR Tile_X0Y9_FrameStrobe[2] latch
XFILLER_360_77 VPWR VGND sg13cmos5l_decap_8
XFILLER_510_14 VPWR VGND sg13cmos5l_decap_8
XANTENNA__3321__X Tile_X0Y4_EE4BEG[9] VPWR VGND sg13cmos5l_antennanp
XFILLER_556_105 VPWR VGND sg13cmos5l_decap_8
XFILLER_369_42 VPWR VGND sg13cmos5l_decap_8
XFILLER_21_106 VPWR VGND sg13cmos5l_decap_4
X_2982_ Tile_X0Y8_FrameData_O[22] Tile_X0Y8_FrameData[22] VPWR VGND sg13cmos5l_buf_1
X_4721_ _4721_/X _4806_/X _4810_/X _4814_/X _4786_/X _0605_/Q _0604_/Q VPWR VGND sg13cmos5l_mux4_1
XFILLER_159_141 VPWR VGND sg13cmos5l_fill_1
X_1933_ _1933_/Q Tile_X0Y4_FrameData[24] VGND VPWR Tile_X0Y9_FrameStrobe[0] latch
XFILLER_14_180 VPWR VGND sg13cmos5l_fill_2
XFILLER_519_56 VPWR VGND sg13cmos5l_decap_8
XFILLER_308_105 VPWR VGND sg13cmos5l_decap_8
XFILLER_571_119 VPWR VGND sg13cmos5l_decap_8
XFILLER_238_13 VPWR VGND sg13cmos5l_decap_8
X_4652_ _4652_/X AXI_M_SOC_RDATA20 _4687_/X _4691_/X _4674_/X _0255_/Q _0254_/Q VPWR
+ VGND sg13cmos5l_mux4_1
X_1864_ _1864_/Q Tile_X0Y3_FrameData[1] VGND VPWR Tile_X0Y9_FrameStrobe[5] latch
XFILLER_666_84 VPWR VGND sg13cmos5l_decap_4
X_3603_ Tile_X0Y9_S1BEG[1] _4825_/X VPWR VGND sg13cmos5l_buf_1
XFILLER_238_57 VPWR VGND sg13cmos5l_fill_2
X_0815_ _0815_/Q Tile_X0Y9_FrameData[16] VGND VPWR Tile_X0Y9_FrameStrobe[4] latch
X_4583_ _4583_/X _4551_/X Tile_X0Y9_N4END[15] _4550_/X _0150_/X _2465_/Q _2464_/Q
+ VPWR VGND sg13cmos5l_mux4_1
X_1795_ _1795_/Q Tile_X0Y3_FrameData[6] VGND VPWR Tile_X0Y9_FrameStrobe[3] latch
XFILLER_713_168 VPWR VGND sg13cmos5l_decap_8
XFILLER_323_119 VPWR VGND sg13cmos5l_fill_2
X_3534_ Tile_X0Y9_E2BEGb[0] _4856_/X VPWR VGND sg13cmos5l_buf_1
X_0746_ _0746_/Q Tile_X0Y9_FrameData[21] VGND VPWR Tile_X0Y9_FrameStrobe[2] latch
X_3465_ Tile_X0Y1_FrameData_O[23] Tile_X0Y1_FrameData[23] VPWR VGND sg13cmos5l_buf_1
XFILLER_88_117 VPWR VGND sg13cmos5l_decap_8
X_0677_ _0677_/Q Tile_X0Y9_FrameData[26] VGND VPWR Tile_X0Y9_FrameStrobe[0] latch
XFILLER_130_203 VPWR VGND sg13cmos5l_fill_1
X_2416_ _2416_/Q Tile_X0Y5_FrameData[21] VGND VPWR Tile_X0Y9_FrameStrobe[7] latch
XFILLER_331_185 VPWR VGND sg13cmos5l_decap_4
X_3396_ Tile_X0Y2_E2BEGb[7] _4055_/X VPWR VGND sg13cmos5l_buf_1
XFILLER_551_21 VPWR VGND sg13cmos5l_decap_8
XFILLER_492_126 VPWR VGND sg13cmos5l_decap_8
X_2347_ _2347_/Q Tile_X0Y5_FrameData[26] VGND VPWR Tile_X0Y9_FrameStrobe[5] latch
X_2278_ _2278_/Q Tile_X0Y5_FrameData[31] VGND VPWR Tile_X0Y9_FrameStrobe[3] latch
XFILLER_701_35 VPWR VGND sg13cmos5l_decap_8
XFILLER_433_215 VPWR VGND sg13cmos5l_fill_2
XFILLER_244_126 VPWR VGND sg13cmos5l_decap_8
XFILLER_270_77 VPWR VGND sg13cmos5l_decap_8
X_4017_ _4017_/X _3983_/X _0096_/X _3982_/X Tile_X0Y0_S4END[5] _1215_/Q _1214_/Q VPWR
+ VGND sg13cmos5l_mux4_1
X_1229_ _1229_/Q Tile_X0Y1_FrameData[12] VGND VPWR Tile_X0Y9_FrameStrobe[1] latch
XFILLER_420_14 VPWR VGND sg13cmos5l_decap_8
XANTENNA__3231__X Tile_X0Y0_FrameStrobe_O[19] VPWR VGND sg13cmos5l_antennanp
XFILLER_16_14 VPWR VGND sg13cmos5l_decap_8
XFILLER_398_141 VPWR VGND sg13cmos5l_decap_8
XFILLER_279_20 VPWR VGND sg13cmos5l_decap_8
XFILLER_16_58 VPWR VGND sg13cmos5l_fill_1
XFILLER_401_123 VPWR VGND sg13cmos5l_decap_8
XFILLER_252_192 VPWR VGND sg13cmos5l_decap_4
XFILLER_547_138 VPWR VGND sg13cmos5l_fill_1
XFILLER_500_91 VPWR VGND sg13cmos5l_decap_8
XFILLER_200_207 VPWR VGND sg13cmos5l_fill_1
X_4919_ _4919_/X Tile_X0Y9_N1END[3] Tile_X0Y9_N4END[3] _4899_/X _0080_/X _0721_/Q
+ _0720_/Q VPWR VGND sg13cmos5l_mux4_1
XFILLER_279_97 VPWR VGND sg13cmos5l_decap_8
XFILLER_32_13 VPWR VGND sg13cmos5l_decap_8
XFILLER_429_56 VPWR VGND sg13cmos5l_decap_8
XFILLER_555_160 VPWR VGND sg13cmos5l_decap_8
XFILLER_165_111 VPWR VGND sg13cmos5l_decap_8
XFILLER_576_84 VPWR VGND sg13cmos5l_decap_8
XFILLER_32_68 VPWR VGND sg13cmos5l_decap_8
XFILLER_148_35 VPWR VGND sg13cmos5l_decap_8
XFILLER_120_6 VPWR VGND sg13cmos5l_decap_8
XFILLER_295_63 VPWR VGND sg13cmos5l_decap_8
XFILLER_314_108 VPWR VGND sg13cmos5l_fill_2
XFILLER_180_114 VPWR VGND sg13cmos5l_decap_8
XFILLER_106_211 VPWR VGND sg13cmos5l_decap_8
XFILLER_468_101 VPWR VGND sg13cmos5l_fill_1
XFILLER_79_106 VPWR VGND sg13cmos5l_decap_8
XFILLER_594_7 VPWR VGND sg13cmos5l_decap_8
XANTENNA__3406__X Tile_X0Y2_E1BEG[1] VPWR VGND sg13cmos5l_antennanp
XFILLER_461_21 VPWR VGND sg13cmos5l_decap_8
XFILLER_57_21 VPWR VGND sg13cmos5l_decap_8
XFILLER_483_137 VPWR VGND sg13cmos5l_decap_4
XFILLER_57_32 VPWR VGND sg13cmos5l_decap_4
XFILLER_483_148 VPWR VGND sg13cmos5l_decap_4
XFILLER_196_2 VPWR VGND sg13cmos5l_fill_1
XFILLER_461_65 VPWR VGND sg13cmos5l_decap_8
XFILLER_57_54 VPWR VGND sg13cmos5l_fill_1
XFILLER_235_104 VPWR VGND sg13cmos5l_fill_1
XFILLER_235_115 VPWR VGND sg13cmos5l_decap_8
XFILLER_611_35 VPWR VGND sg13cmos5l_decap_8
XFILLER_290_210 VPWR VGND sg13cmos5l_decap_8
XFILLER_235_126 VPWR VGND sg13cmos5l_fill_1
XFILLER_640_112 VPWR VGND sg13cmos5l_decap_8
XFILLER_363_2 VPWR VGND sg13cmos5l_fill_1
XFILLER_330_14 VPWR VGND sg13cmos5l_decap_8
XFILLER_235_148 VPWR VGND sg13cmos5l_decap_8
XANTENNA__3141__X Tile_X0Y7_FrameData_O[11] VPWR VGND sg13cmos5l_antennanp
XFILLER_73_42 VPWR VGND sg13cmos5l_fill_2
XFILLER_687_28 VPWR VGND sg13cmos5l_decap_8
XFILLER_251_0 VPWR VGND sg13cmos5l_fill_2
XFILLER_188_203 VPWR VGND sg13cmos5l_decap_4
XFILLER_349_0 VPWR VGND sg13cmos5l_decap_8
XFILLER_189_42 VPWR VGND sg13cmos5l_decap_8
XANTENNA__2980__X Tile_X0Y8_FrameData_O[20] VPWR VGND sg13cmos5l_antennanp
XFILLER_628_2 VPWR VGND sg13cmos5l_fill_1
XFILLER_410_91 VPWR VGND sg13cmos5l_decap_4
XFILLER_538_149 VPWR VGND sg13cmos5l_decap_8
XFILLER_516_0 VPWR VGND sg13cmos5l_decap_8
XFILLER_339_56 VPWR VGND sg13cmos5l_decap_8
XFILLER_486_84 VPWR VGND sg13cmos5l_decap_8
XFILLER_11_161 VPWR VGND sg13cmos5l_fill_2
XFILLER_636_21 VPWR VGND sg13cmos5l_decap_8
XFILLER_546_182 VPWR VGND sg13cmos5l_decap_4
XFILLER_710_105 VPWR VGND sg13cmos5l_decap_8
X_0600_ _0600_/Q Tile_X0Y8_FrameData[7] VGND VPWR Tile_X0Y9_FrameStrobe[5] latch
XFILLER_208_27 VPWR VGND sg13cmos5l_decap_8
X_1580_ _1580_/Q Tile_X0Y2_FrameData[5] VGND VPWR Tile_X0Y9_FrameStrobe[4] latch
XFILLER_636_98 VPWR VGND sg13cmos5l_decap_8
XFILLER_355_77 VPWR VGND sg13cmos5l_decap_8
X_0531_ _0531_/Q Tile_X0Y8_FrameData[12] VGND VPWR Tile_X0Y9_FrameStrobe[3] latch
XFILLER_505_14 VPWR VGND sg13cmos5l_decap_8
XFILLER_313_152 VPWR VGND sg13cmos5l_decap_8
XANTENNA__3316__X Tile_X0Y4_EE4BEG[4] VPWR VGND sg13cmos5l_antennanp
XFILLER_652_42 VPWR VGND sg13cmos5l_decap_8
X_0462_ _0462_/Q Tile_X0Y8_FrameData[17] VGND VPWR Tile_X0Y9_FrameStrobe[1] latch
X_3250_ Tile_X0Y0_FrameData_O[18] Tile_X0Y0_FrameData[18] VPWR VGND sg13cmos5l_buf_1
XFILLER_459_178 VPWR VGND sg13cmos5l_decap_8
XFILLER_474_115 VPWR VGND sg13cmos5l_decap_8
XFILLER_371_21 VPWR VGND sg13cmos5l_decap_8
X_2201_ _2201_/Q Tile_X0Y5_FrameData[12] VGND VPWR Tile_X0Y9_FrameStrobe[0] latch
X_0393_ _0393_/Q Tile_X0Y7_FrameData[22] VGND VPWR Tile_X0Y9_FrameStrobe[7] latch
X_3181_ Tile_X0Y0_N4BEG[5] _3181_/A VPWR VGND sg13cmos5l_buf_1
XFILLER_78_172 VPWR VGND sg13cmos5l_decap_8
XFILLER_616_142 VPWR VGND sg13cmos5l_decap_4
X_2132_ _2132_/Q Tile_X0Y4_FrameData[17] VGND VPWR Tile_X0Y9_FrameStrobe[6] latch
XFILLER_521_35 VPWR VGND sg13cmos5l_decap_8
XFILLER_415_215 VPWR VGND sg13cmos5l_fill_2
XFILLER_281_210 VPWR VGND sg13cmos5l_fill_2
XFILLER_93_142 VPWR VGND sg13cmos5l_fill_1
XFILLER_631_112 VPWR VGND sg13cmos5l_decap_8
XFILLER_304_92 VPWR VGND sg13cmos5l_fill_1
XFILLER_240_14 VPWR VGND sg13cmos5l_decap_8
X_2063_ _2063_/Q Tile_X0Y4_FrameData[22] VGND VPWR Tile_X0Y9_FrameStrobe[4] latch
XANTENNA__3051__X Tile_X0Y5_FrameData_O[10] VPWR VGND sg13cmos5l_antennanp
X_1014_ _1014_/Q Tile_X0Y0_FrameData[21] VGND VPWR Tile_X0Y9_FrameStrobe[2] latch
XFILLER_597_28 VPWR VGND sg13cmos5l_decap_8
XFILLER_240_69 VPWR VGND sg13cmos5l_decap_8
XFILLER_241_129 VPWR VGND sg13cmos5l_decap_8
XFILLER_234_192 VPWR VGND sg13cmos5l_decap_8
XANTENNA__2890__X Tile_X0Y6_FrameData_O[11] VPWR VGND sg13cmos5l_antennanp
XFILLER_97_0 VPWR VGND sg13cmos5l_decap_8
XFILLER_395_144 VPWR VGND sg13cmos5l_decap_8
XFILLER_320_91 VPWR VGND sg13cmos5l_decap_8
XFILLER_529_149 VPWR VGND sg13cmos5l_decap_8
XFILLER_194_206 VPWR VGND sg13cmos5l_decap_4
X_2965_ Tile_X0Y8_FrameData_O[5] Tile_X0Y8_FrameData[5] VPWR VGND sg13cmos5l_buf_1
XFILLER_194_217 VPWR VGND sg13cmos5l_fill_1
X_4704_ _4704_/X Tile_X0Y6_W2MID[5] Tile_X0Y6_W2END[5] Tile_X0Y6_W6END[10] _4557_/X
+ _2647_/Q _2646_/Q VPWR VGND sg13cmos5l_mux4_1
X_1916_ _1916_/Q Tile_X0Y3_FrameData[13] VGND VPWR Tile_X0Y9_FrameStrobe[7] latch
X_2896_ Tile_X0Y6_FrameData_O[17] Tile_X0Y6_FrameData[17] VPWR VGND sg13cmos5l_buf_1
XFILLER_147_133 VPWR VGND sg13cmos5l_decap_8
XFILLER_546_21 VPWR VGND sg13cmos5l_decap_8
XFILLER_8_70 VPWR VGND sg13cmos5l_decap_8
XFILLER_698_112 VPWR VGND sg13cmos5l_decap_8
X_4635_ _4635_/X Tile_X0Y7_WW4END[8] AXI_M_SOC_RDATA23 _4692_/X _4669_/X _0289_/Q
+ _0288_/Q VPWR VGND sg13cmos5l_mux4_1
X_1847_ _1847_/Q Tile_X0Y3_FrameData[18] VGND VPWR Tile_X0Y9_FrameStrobe[5] latch
XFILLER_147_188 VPWR VGND sg13cmos5l_decap_4
XFILLER_497_207 VPWR VGND sg13cmos5l_fill_2
XFILLER_701_105 VPWR VGND sg13cmos5l_decap_8
X_4566_ _4566_/X Tile_X0Y2_W1END[3] Tile_X0Y2_WW4END[15] Tile_X0Y2_W6END[7] _4119_/X
+ _1604_/Q _1603_/Q VPWR VGND sg13cmos5l_mux4_1
XFILLER_546_98 VPWR VGND sg13cmos5l_decap_8
X_1778_ _1778_/Q Tile_X0Y3_FrameData[23] VGND VPWR Tile_X0Y9_FrameStrobe[3] latch
XFILLER_118_49 VPWR VGND sg13cmos5l_decap_8
X_3517_ Tile_X0Y1_E2BEG[7] _3939_/X VPWR VGND sg13cmos5l_buf_1
X_0729_ _0729_/Q Tile_X0Y9_FrameData[6] VGND VPWR Tile_X0Y9_FrameStrobe[1] latch
XFILLER_415_14 VPWR VGND sg13cmos5l_decap_8
XFILLER_265_88 VPWR VGND sg13cmos5l_decap_4
X_4497_ _4497_/X Tile_X0Y6_W2MID[6] AXI_M_SOC_RDATA25 _4555_/X _4554_/X _2613_/Q _2612_/Q
+ VPWR VGND sg13cmos5l_mux4_1
XFILLER_265_99 VPWR VGND sg13cmos5l_fill_1
XANTENNA__3226__X Tile_X0Y0_FrameStrobe_O[14] VPWR VGND sg13cmos5l_antennanp
XFILLER_562_42 VPWR VGND sg13cmos5l_decap_8
X_3448_ Tile_X0Y1_FrameData_O[6] Tile_X0Y1_FrameData[6] VPWR VGND sg13cmos5l_buf_1
XFILLER_281_21 VPWR VGND sg13cmos5l_decap_8
X_3379_ Tile_X0Y2_E6BEG[2] _4074_/X VPWR VGND sg13cmos5l_buf_1
XFILLER_712_56 VPWR VGND sg13cmos5l_decap_8
XFILLER_281_98 VPWR VGND sg13cmos5l_decap_8
XFILLER_217_104 VPWR VGND sg13cmos5l_decap_8
XFILLER_607_164 VPWR VGND sg13cmos5l_fill_1
XFILLER_431_35 VPWR VGND sg13cmos5l_decap_8
XFILLER_473_170 VPWR VGND sg13cmos5l_decap_4
XFILLER_214_70 VPWR VGND sg13cmos5l_decap_8
XFILLER_607_186 VPWR VGND sg13cmos5l_decap_8
XFILLER_622_112 VPWR VGND sg13cmos5l_decap_4
XFILLER_27_35 VPWR VGND sg13cmos5l_decap_8
XFILLER_607_197 VPWR VGND sg13cmos5l_fill_1
XFILLER_150_14 VPWR VGND sg13cmos5l_decap_8
XFILLER_175_7 VPWR VGND sg13cmos5l_decap_8
XFILLER_225_192 VPWR VGND sg13cmos5l_decap_8
XFILLER_342_7 VPWR VGND sg13cmos5l_decap_8
XFILLER_300_28 VPWR VGND sg13cmos5l_fill_2
XFILLER_709_216 VPWR VGND sg13cmos5l_fill_2
XFILLER_43_34 VPWR VGND sg13cmos5l_decap_8
XFILLER_590_203 VPWR VGND sg13cmos5l_decap_8
XFILLER_607_7 VPWR VGND sg13cmos5l_decap_8
XFILLER_159_89 VPWR VGND sg13cmos5l_decap_8
XFILLER_138_133 VPWR VGND sg13cmos5l_decap_8
XFILLER_689_101 VPWR VGND sg13cmos5l_decap_4
XFILLER_456_21 VPWR VGND sg13cmos5l_decap_8
XFILLER_4_102 VPWR VGND sg13cmos5l_fill_2
XFILLER_4_113 VPWR VGND sg13cmos5l_fill_1
XFILLER_606_35 VPWR VGND sg13cmos5l_decap_8
XFILLER_325_14 VPWR VGND sg13cmos5l_decap_8
XFILLER_175_88 VPWR VGND sg13cmos5l_decap_8
XFILLER_4_28 VPWR VGND sg13cmos5l_decap_8
XFILLER_108_60 VPWR VGND sg13cmos5l_fill_2
XANTENNA__3136__X Tile_X0Y7_FrameData_O[6] VPWR VGND sg13cmos5l_antennanp
XFILLER_472_42 VPWR VGND sg13cmos5l_decap_8
XFILLER_310_133 VPWR VGND sg13cmos5l_fill_1
XFILLER_68_64 VPWR VGND sg13cmos5l_decap_8
XFILLER_299_0 VPWR VGND sg13cmos5l_decap_8
XANTENNA__2975__X Tile_X0Y8_FrameData_O[15] VPWR VGND sg13cmos5l_antennanp
XFILLER_622_56 VPWR VGND sg13cmos5l_decap_8
XFILLER_191_76 VPWR VGND sg13cmos5l_fill_2
XFILLER_208_104 VPWR VGND sg13cmos5l_decap_8
XFILLER_191_98 VPWR VGND sg13cmos5l_fill_1
XFILLER_75_131 VPWR VGND sg13cmos5l_fill_1
XFILLER_341_35 VPWR VGND sg13cmos5l_decap_8
XFILLER_124_70 VPWR VGND sg13cmos5l_decap_8
XFILLER_466_0 VPWR VGND sg13cmos5l_decap_8
XFILLER_698_49 VPWR VGND sg13cmos5l_decap_8
XFILLER_90_134 VPWR VGND sg13cmos5l_decap_8
XFILLER_613_167 VPWR VGND sg13cmos5l_fill_1
XFILLER_90_167 VPWR VGND sg13cmos5l_fill_1
XFILLER_633_0 VPWR VGND sg13cmos5l_decap_8
XFILLER_377_111 VPWR VGND sg13cmos5l_decap_8
XFILLER_90_189 VPWR VGND sg13cmos5l_decap_8
XFILLER_140_91 VPWR VGND sg13cmos5l_decap_8
XFILLER_90_7 VPWR VGND sg13cmos5l_decap_8
XFILLER_231_173 VPWR VGND sg13cmos5l_fill_1
XFILLER_647_42 VPWR VGND sg13cmos5l_decap_8
X_2750_ Tile_X0Y3_FrameData_O[8] Tile_X0Y3_FrameData[8] VPWR VGND sg13cmos5l_buf_1
XFILLER_366_21 VPWR VGND sg13cmos5l_decap_8
X_1701_ _1701_/Q Tile_X0Y3_FrameData[4] VGND VPWR Tile_X0Y9_FrameStrobe[0] latch
XFILLER_534_130 VPWR VGND sg13cmos5l_decap_8
XFILLER_219_48 VPWR VGND sg13cmos5l_decap_8
X_2681_ _2681_/Q Tile_X0Y6_FrameData[14] VGND VPWR Tile_X0Y9_FrameStrobe[7] latch
XFILLER_219_59 VPWR VGND sg13cmos5l_fill_1
X_4420_ _4420_/X Tile_X0Y4_W1END[1] Tile_X0Y4_W6END[9] _4349_/X _4303_/X _2143_/Q
+ _2142_/Q VPWR VGND sg13cmos5l_mux4_1
XFILLER_534_174 VPWR VGND sg13cmos5l_decap_8
XFILLER_479_207 VPWR VGND sg13cmos5l_fill_2
XFILLER_129_199 VPWR VGND sg13cmos5l_fill_2
X_1632_ _1632_/Q Tile_X0Y2_FrameData[17] VGND VPWR Tile_X0Y9_FrameStrobe[6] latch
XFILLER_534_185 VPWR VGND sg13cmos5l_fill_2
XFILLER_516_35 VPWR VGND sg13cmos5l_decap_8
X_4351_ _4351_/X _4311_/X _0040_/X _4310_/X _0109_/X _1951_/Q _1950_/Q VPWR VGND sg13cmos5l_mux4_1
XFILLER_663_63 VPWR VGND sg13cmos5l_decap_8
X_1563_ _1563_/Q Tile_X0Y2_FrameData[22] VGND VPWR Tile_X0Y9_FrameStrobe[4] latch
XFILLER_235_14 VPWR VGND sg13cmos5l_decap_8
XFILLER_235_25 VPWR VGND sg13cmos5l_fill_1
XANTENNA__3046__X Tile_X0Y5_FrameData_O[5] VPWR VGND sg13cmos5l_antennanp
X_3302_ Tile_X0Y0_E2BEG[2] _3806_/X VPWR VGND sg13cmos5l_buf_1
X_0514_ _0514_/Q Tile_X0Y8_FrameData[29] VGND VPWR Tile_X0Y9_FrameStrobe[3] latch
X_4282_ _4282_/X Tile_X0Y4_WW4END[5] AXI_M_SOC_BRESP1 _4341_/X _4316_/X _2049_/Q _2048_/Q
+ VPWR VGND sg13cmos5l_mux4_1
XFILLER_301_122 VPWR VGND sg13cmos5l_fill_1
X_1494_ _1494_/Q Tile_X0Y2_FrameData[27] VGND VPWR Tile_X0Y9_FrameStrobe[2] latch
XFILLER_447_126 VPWR VGND sg13cmos5l_decap_4
X_3233_ Tile_X0Y0_FrameData_O[1] Tile_X0Y0_FrameData[1] VPWR VGND sg13cmos5l_buf_1
XANTENNA__2885__X Tile_X0Y6_FrameData_O[6] VPWR VGND sg13cmos5l_antennanp
X_0445_ _0445_/Q Tile_X0Y8_FrameData[2] VGND VPWR Tile_X0Y9_FrameStrobe[0] latch
XFILLER_100_217 VPWR VGND sg13cmos5l_fill_1
XFILLER_532_56 VPWR VGND sg13cmos5l_decap_8
XFILLER_251_13 VPWR VGND sg13cmos5l_decap_8
X_3164_ Tile_X0Y4_E6BEG[1] _4289_/X VPWR VGND sg13cmos5l_buf_1
X_0376_ _0376_/Q Tile_X0Y7_FrameData[7] VGND VPWR Tile_X0Y9_FrameStrobe[6] latch
XFILLER_462_129 VPWR VGND sg13cmos5l_fill_1
XFILLER_12_0 VPWR VGND sg13cmos5l_decap_8
X_2115_ _2115_/Q Tile_X0Y4_FrameData[2] VGND VPWR Tile_X0Y9_FrameStrobe[5] latch
XFILLER_251_68 VPWR VGND sg13cmos5l_fill_2
XFILLER_66_175 VPWR VGND sg13cmos5l_decap_8
X_3095_ Tile_X0Y7_E2BEGb[1] _4621_/X VPWR VGND sg13cmos5l_buf_1
XFILLER_66_197 VPWR VGND sg13cmos5l_fill_2
X_2046_ _2046_/Q Tile_X0Y4_FrameData[7] VGND VPWR Tile_X0Y9_FrameStrobe[3] latch
XFILLER_81_156 VPWR VGND sg13cmos5l_decap_8
XFILLER_401_49 VPWR VGND sg13cmos5l_decap_8
XFILLER_207_170 VPWR VGND sg13cmos5l_fill_1
XFILLER_688_71 VPWR VGND sg13cmos5l_fill_2
XFILLER_207_192 VPWR VGND sg13cmos5l_decap_4
XFILLER_167_217 VPWR VGND sg13cmos5l_fill_1
X_3997_ _3997_/X Tile_X0Y5_W1END[0] Tile_X0Y5_WW4END[0] Tile_X0Y5_W6END[8] _4451_/X
+ _2415_/Q _2414_/Q VPWR VGND sg13cmos5l_mux4_1
XFILLER_368_177 VPWR VGND sg13cmos5l_decap_8
XFILLER_706_208 VPWR VGND sg13cmos5l_fill_2
XFILLER_572_203 VPWR VGND sg13cmos5l_fill_2
XFILLER_557_42 VPWR VGND sg13cmos5l_decap_8
X_2948_ Tile_X0Y8_EE4BEG[4] _4748_/X VPWR VGND sg13cmos5l_buf_1
XFILLER_276_21 VPWR VGND sg13cmos5l_decap_8
X_2879_ Tile_X0Y6_FrameData_O[0] Tile_X0Y6_FrameData[0] VPWR VGND sg13cmos5l_buf_1
XFILLER_707_56 VPWR VGND sg13cmos5l_decap_8
X_4618_ _4618_/X Tile_X0Y7_W2MID[1] AXI_M_SOC_RDATA22 _4671_/X _4670_/X _0323_/Q _0322_/Q
+ VPWR VGND sg13cmos5l_mux4_1
XFILLER_276_98 VPWR VGND sg13cmos5l_decap_8
XFILLER_426_35 VPWR VGND sg13cmos5l_decap_8
XFILLER_135_147 VPWR VGND sg13cmos5l_decap_8
XFILLER_209_70 VPWR VGND sg13cmos5l_decap_8
XFILLER_135_158 VPWR VGND sg13cmos5l_fill_1
XFILLER_573_63 VPWR VGND sg13cmos5l_decap_8
X_4549_ _4549_/X Tile_X0Y7_W1END[2] Tile_X0Y7_W6END[6] _4698_/X _4658_/X _0411_/Q
+ _0410_/Q VPWR VGND sg13cmos5l_mux4_1
XFILLER_145_14 VPWR VGND sg13cmos5l_decap_8
XFILLER_292_42 VPWR VGND sg13cmos5l_decap_8
XFILLER_143_180 VPWR VGND sg13cmos5l_decap_8
XFILLER_289_173 VPWR VGND sg13cmos5l_decap_8
XANTENNA__2795__X Tile_X0Y3_E6BEG[5] VPWR VGND sg13cmos5l_antennanp
XFILLER_292_7 VPWR VGND sg13cmos5l_decap_8
XFILLER_442_56 VPWR VGND sg13cmos5l_decap_8
XFILLER_57_175 VPWR VGND sg13cmos5l_decap_8
XFILLER_557_7 VPWR VGND sg13cmos5l_decap_8
XFILLER_461_173 VPWR VGND sg13cmos5l_decap_8
XFILLER_72_167 VPWR VGND sg13cmos5l_decap_8
XFILLER_610_126 VPWR VGND sg13cmos5l_decap_4
XFILLER_54_44 VPWR VGND sg13cmos5l_decap_8
XFILLER_598_93 VPWR VGND sg13cmos5l_fill_1
XFILLER_359_133 VPWR VGND sg13cmos5l_decap_8
XFILLER_159_2 VPWR VGND sg13cmos5l_fill_1
XFILLER_359_144 VPWR VGND sg13cmos5l_fill_2
XFILLER_158_217 VPWR VGND sg13cmos5l_fill_1
XFILLER_70_21 VPWR VGND sg13cmos5l_decap_8
XFILLER_467_42 VPWR VGND sg13cmos5l_decap_8
XFILLER_186_21 VPWR VGND sg13cmos5l_decap_8
XFILLER_173_209 VPWR VGND sg13cmos5l_decap_8
XFILLER_214_0 VPWR VGND sg13cmos5l_decap_8
XFILLER_617_56 VPWR VGND sg13cmos5l_decap_8
XFILLER_126_136 VPWR VGND sg13cmos5l_decap_8
XFILLER_336_35 VPWR VGND sg13cmos5l_decap_8
XFILLER_119_81 VPWR VGND sg13cmos5l_decap_8
XFILLER_677_137 VPWR VGND sg13cmos5l_decap_8
XFILLER_483_63 VPWR VGND sg13cmos5l_decap_8
XFILLER_531_166 VPWR VGND sg13cmos5l_decap_4
XFILLER_141_117 VPWR VGND sg13cmos5l_decap_8
XFILLER_677_159 VPWR VGND sg13cmos5l_fill_2
XFILLER_134_180 VPWR VGND sg13cmos5l_decap_8
XFILLER_583_0 VPWR VGND sg13cmos5l_decap_8
XFILLER_429_126 VPWR VGND sg13cmos5l_decap_8
XFILLER_633_77 VPWR VGND sg13cmos5l_decap_8
XFILLER_205_28 VPWR VGND sg13cmos5l_decap_8
XFILLER_352_56 VPWR VGND sg13cmos5l_decap_8
XFILLER_295_165 VPWR VGND sg13cmos5l_fill_2
XFILLER_135_91 VPWR VGND sg13cmos5l_decap_8
X_0230_ _0230_/Q Tile_X0Y7_FrameData[25] VGND VPWR Tile_X0Y9_FrameStrobe[2] latch
XFILLER_444_129 VPWR VGND sg13cmos5l_decap_8
XFILLER_48_153 VPWR VGND sg13cmos5l_decap_8
X_0161_ _0161_/Q Tile_X0Y7_FrameData[30] VGND VPWR Tile_X0Y9_FrameStrobe[0] latch
XFILLER_48_175 VPWR VGND sg13cmos5l_decap_8
XFILLER_63_123 VPWR VGND sg13cmos5l_decap_8
X_0092_ _3623_/A _4486_/X _4487_/X _2630_/Q VPWR VGND sg13cmos5l_mux2_1
XFILLER_221_49 VPWR VGND sg13cmos5l_decap_8
XFILLER_452_184 VPWR VGND sg13cmos5l_decap_4
XFILLER_397_217 VPWR VGND sg13cmos5l_fill_1
X_3920_ _3920_/X Tile_X0Y3_W1END[3] Tile_X0Y3_WW4END[3] Tile_X0Y3_W6END[11] _4225_/X
+ _1892_/Q _1891_/Q VPWR VGND sg13cmos5l_mux4_1
X_3851_ _3851_/X Tile_X0Y1_W1END[3] Tile_X0Y1_W6END[7] _3996_/X _3979_/X _1419_/Q
+ _1418_/Q VPWR VGND sg13cmos5l_mux4_1
XFILLER_658_63 VPWR VGND sg13cmos5l_fill_2
XFILLER_149_217 VPWR VGND sg13cmos5l_fill_1
X_2802_ Tile_X0Y3_E2BEGb[0] _4156_/X VPWR VGND sg13cmos5l_buf_1
XFILLER_658_96 VPWR VGND sg13cmos5l_decap_8
XFILLER_377_42 VPWR VGND sg13cmos5l_decap_8
X_3782_ _3782_/X Tile_X0Y0_W1END[2] Tile_X0Y0_W6END[6] _3867_/X _3861_/X _1173_/Q
+ _1172_/Q VPWR VGND sg13cmos5l_mux4_1
X_0994_ _0994_/Q Tile_X0Y0_FrameData[9] VGND VPWR Tile_X0Y9_FrameStrobe[1] latch
X_2733_ _4892_/A3 VPWR VGND sg13cmos5l_tielo
XFILLER_527_56 VPWR VGND sg13cmos5l_fill_1
XFILLER_527_67 VPWR VGND sg13cmos5l_decap_8
XFILLER_522_111 VPWR VGND sg13cmos5l_fill_1
X_2664_ _2664_/Q Tile_X0Y6_FrameData[31] VGND VPWR Tile_X0Y9_FrameStrobe[7] latch
XFILLER_117_147 VPWR VGND sg13cmos5l_decap_8
XFILLER_246_35 VPWR VGND sg13cmos5l_decap_8
XFILLER_674_95 VPWR VGND sg13cmos5l_fill_1
XFILLER_522_133 VPWR VGND sg13cmos5l_decap_8
X_4403_ _4403_/X Tile_X0Y5_WW4END[0] AXI_M_SOC_RVALID _4451_/X _4467_/X _2297_/Q _2296_/Q
+ VPWR VGND sg13cmos5l_mux4_1
X_1615_ _1615_/Q Tile_X0Y2_FrameData[2] VGND VPWR Tile_X0Y9_FrameStrobe[5] latch
XFILLER_668_137 VPWR VGND sg13cmos5l_decap_8
XFILLER_393_74 VPWR VGND sg13cmos5l_decap_8
X_2595_ _2595_/Q Tile_X0Y6_FrameData[4] VGND VPWR Tile_X0Y9_FrameStrobe[4] latch
X_4334_ _4334_/X Tile_X0Y8_W1END[3] Tile_X0Y8_WW4END[3] Tile_X0Y8_W6END[11] _4803_/X
+ _0638_/Q _0637_/Q VPWR VGND sg13cmos5l_mux4_1
X_1546_ _1546_/Q Tile_X0Y2_FrameData[7] VGND VPWR Tile_X0Y9_FrameStrobe[3] latch
XFILLER_690_83 VPWR VGND sg13cmos5l_decap_8
XFILLER_115_28 VPWR VGND sg13cmos5l_decap_8
XFILLER_86_215 VPWR VGND sg13cmos5l_fill_2
X_4265_ _4265_/X Tile_X0Y4_W2END[6] AXI_M_SOC_BRESP0 _4315_/X _4314_/X _2083_/Q _2082_/Q
+ VPWR VGND sg13cmos5l_mux4_1
XFILLER_140_161 VPWR VGND sg13cmos5l_decap_4
X_1477_ _1477_/Q Tile_X0Y2_FrameData[12] VGND VPWR Tile_X0Y9_FrameStrobe[1] latch
XFILLER_543_99 VPWR VGND sg13cmos5l_decap_4
XFILLER_262_56 VPWR VGND sg13cmos5l_decap_8
XANTENNA__3504__X Tile_X0Y1_E2BEGb[2] VPWR VGND sg13cmos5l_antennanp
XFILLER_691_151 VPWR VGND sg13cmos5l_fill_2
XFILLER_286_176 VPWR VGND sg13cmos5l_decap_8
X_3216_ Tile_X0Y0_FrameStrobe_O[4] Tile_X0Y9_FrameStrobe[4] VPWR VGND sg13cmos5l_buf_1
XFILLER_624_207 VPWR VGND sg13cmos5l_fill_2
X_0428_ _0428_/Q Tile_X0Y8_FrameData[19] VGND VPWR Tile_X0Y9_FrameStrobe[0] latch
X_4196_ _4196_/X Tile_X0Y2_W1END[1] Tile_X0Y2_W6END[9] _4110_/X _4085_/X _1635_/Q
+ _1634_/Q VPWR VGND sg13cmos5l_mux4_1
XFILLER_227_210 VPWR VGND sg13cmos5l_fill_1
XFILLER_39_164 VPWR VGND sg13cmos5l_fill_2
X_3147_ Tile_X0Y7_FrameData_O[17] Tile_X0Y7_FrameData[17] VPWR VGND sg13cmos5l_buf_1
X_0359_ _0359_/Q Tile_X0Y7_FrameData[24] VGND VPWR Tile_X0Y9_FrameStrobe[6] latch
XFILLER_699_70 VPWR VGND sg13cmos5l_decap_8
XFILLER_443_151 VPWR VGND sg13cmos5l_decap_8
XFILLER_131_27 VPWR VGND sg13cmos5l_decap_8
XFILLER_54_134 VPWR VGND sg13cmos5l_fill_1
X_3078_ Tile_X0Y4_E2BEGb[4] _4268_/X VPWR VGND sg13cmos5l_buf_1
XFILLER_388_217 VPWR VGND sg13cmos5l_fill_1
XFILLER_199_128 VPWR VGND sg13cmos5l_fill_2
XFILLER_54_167 VPWR VGND sg13cmos5l_decap_8
XFILLER_589_188 VPWR VGND sg13cmos5l_decap_4
X_2029_ _2029_/Q Tile_X0Y4_FrameData[24] VGND VPWR Tile_X0Y9_FrameStrobe[3] latch
XFILLER_24_14 VPWR VGND sg13cmos5l_decap_8
XFILLER_568_63 VPWR VGND sg13cmos5l_decap_8
XFILLER_287_42 VPWR VGND sg13cmos5l_decap_8
XFILLER_210_132 VPWR VGND sg13cmos5l_decap_8
XFILLER_356_147 VPWR VGND sg13cmos5l_decap_8
XFILLER_210_165 VPWR VGND sg13cmos5l_decap_8
XFILLER_138_7 VPWR VGND sg13cmos5l_decap_8
XFILLER_6_208 VPWR VGND sg13cmos5l_decap_8
XFILLER_108_103 VPWR VGND sg13cmos5l_decap_8
XFILLER_437_56 VPWR VGND sg13cmos5l_decap_8
XFILLER_364_180 VPWR VGND sg13cmos5l_decap_8
XFILLER_584_84 VPWR VGND sg13cmos5l_decap_8
XFILLER_513_122 VPWR VGND sg13cmos5l_decap_8
XFILLER_156_35 VPWR VGND sg13cmos5l_fill_2
XFILLER_584_95 VPWR VGND sg13cmos5l_fill_1
XFILLER_156_79 VPWR VGND sg13cmos5l_decap_8
XFILLER_49_11 VPWR VGND sg13cmos5l_decap_4
XFILLER_49_22 VPWR VGND sg13cmos5l_decap_8
XFILLER_277_121 VPWR VGND sg13cmos5l_fill_1
XFILLER_236_90 VPWR VGND sg13cmos5l_decap_8
XFILLER_667_181 VPWR VGND sg13cmos5l_fill_2
XFILLER_674_7 VPWR VGND sg13cmos5l_decap_8
XFILLER_277_143 VPWR VGND sg13cmos5l_decap_8
XFILLER_603_14 VPWR VGND sg13cmos5l_decap_8
XFILLER_131_172 VPWR VGND sg13cmos5l_decap_4
XANTENNA__3414__X Tile_X0Y4_FrameData_O[5] VPWR VGND sg13cmos5l_antennanp
XFILLER_218_210 VPWR VGND sg13cmos5l_fill_1
XFILLER_292_179 VPWR VGND sg13cmos5l_decap_4
XFILLER_65_54 VPWR VGND sg13cmos5l_decap_8
XFILLER_45_156 VPWR VGND sg13cmos5l_decap_4
XFILLER_379_217 VPWR VGND sg13cmos5l_fill_1
XFILLER_595_103 VPWR VGND sg13cmos5l_decap_4
XFILLER_164_0 VPWR VGND sg13cmos5l_decap_8
XFILLER_60_126 VPWR VGND sg13cmos5l_decap_8
XFILLER_595_169 VPWR VGND sg13cmos5l_fill_2
XFILLER_695_28 VPWR VGND sg13cmos5l_decap_8
XFILLER_331_0 VPWR VGND sg13cmos5l_decap_8
XFILLER_198_183 VPWR VGND sg13cmos5l_fill_1
XFILLER_429_0 VPWR VGND sg13cmos5l_decap_8
XFILLER_197_42 VPWR VGND sg13cmos5l_decap_8
XFILLER_478_96 VPWR VGND sg13cmos5l_fill_1
XFILLER_201_154 VPWR VGND sg13cmos5l_decap_8
XFILLER_201_187 VPWR VGND sg13cmos5l_decap_4
XFILLER_628_77 VPWR VGND sg13cmos5l_decap_8
XFILLER_362_128 VPWR VGND sg13cmos5l_decap_8
XFILLER_347_56 VPWR VGND sg13cmos5l_decap_8
XFILLER_494_84 VPWR VGND sg13cmos5l_decap_8
XFILLER_504_133 VPWR VGND sg13cmos5l_decap_8
XFILLER_644_21 VPWR VGND sg13cmos5l_decap_8
XFILLER_114_117 VPWR VGND sg13cmos5l_fill_2
X_1400_ _1400_/Q Tile_X0Y1_FrameData[1] VGND VPWR Tile_X0Y9_FrameStrobe[6] latch
XFILLER_46_6 VPWR VGND sg13cmos5l_decap_8
X_2380_ _2380_/Q Tile_X0Y5_FrameData[25] VGND VPWR Tile_X0Y9_FrameStrobe[6] latch
XFILLER_665_118 VPWR VGND sg13cmos5l_fill_2
XFILLER_644_98 VPWR VGND sg13cmos5l_decap_8
XFILLER_363_55 VPWR VGND sg13cmos5l_fill_2
XFILLER_216_49 VPWR VGND sg13cmos5l_decap_8
XFILLER_68_204 VPWR VGND sg13cmos5l_decap_4
XFILLER_658_181 VPWR VGND sg13cmos5l_fill_2
X_1331_ _1331_/Q Tile_X0Y1_FrameData[6] VGND VPWR Tile_X0Y9_FrameStrobe[4] latch
XFILLER_513_14 VPWR VGND sg13cmos5l_decap_8
XANTENNA__3324__X Tile_X0Y4_EE4BEG[12] VPWR VGND sg13cmos5l_antennanp
XFILLER_660_42 VPWR VGND sg13cmos5l_decap_8
X_4050_ _4050_/X Tile_X0Y2_W2END[5] AXI_M_SOC_AWREADY _4101_/X _4100_/X _1573_/Q _1572_/Q
+ VPWR VGND sg13cmos5l_mux4_1
X_1262_ _1262_/Q Tile_X0Y1_FrameData[11] VGND VPWR Tile_X0Y9_FrameStrobe[2] latch
XFILLER_673_173 VPWR VGND sg13cmos5l_fill_1
X_3001_ Tile_X0Y5_E2BEG[4] _4376_/X VPWR VGND sg13cmos5l_buf_1
X_0213_ _0213_/Q Tile_X0Y7_FrameData[10] VGND VPWR Tile_X0Y9_FrameStrobe[1] latch
XFILLER_232_48 VPWR VGND sg13cmos5l_decap_8
XFILLER_36_101 VPWR VGND sg13cmos5l_decap_4
XFILLER_283_168 VPWR VGND sg13cmos5l_fill_2
X_1193_ _1193_/Q Tile_X0Y1_FrameData[16] VGND VPWR Tile_X0Y9_FrameStrobe[0] latch
XFILLER_425_140 VPWR VGND sg13cmos5l_decap_8
XFILLER_36_112 VPWR VGND sg13cmos5l_decap_8
XFILLER_36_134 VPWR VGND sg13cmos5l_decap_8
X_0144_ _3186_/A _3906_/X _3907_/X _1393_/Q VPWR VGND sg13cmos5l_mux2_1
XFILLER_51_104 VPWR VGND sg13cmos5l_fill_1
XFILLER_440_132 VPWR VGND sg13cmos5l_decap_8
X_0075_ _0075_/X _4796_/X _4797_/X _2113_/Q VPWR VGND sg13cmos5l_mux2_1
XFILLER_669_73 VPWR VGND sg13cmos5l_fill_1
XFILLER_385_209 VPWR VGND sg13cmos5l_fill_2
X_3903_ _3903_/X Tile_X0Y1_W2MID[0] Tile_X0Y1_W2END[0] Tile_X0Y1_W6END[0] _3988_/X
+ _1403_/Q _1402_/Q VPWR VGND sg13cmos5l_mux4_1
X_4883_ _4883_/X Tile_X0Y9_N4END[3] _0080_/X _4924_/X _4928_/X _0777_/Q _0776_/Q VPWR
+ VGND sg13cmos5l_mux4_1
XFILLER_388_74 VPWR VGND sg13cmos5l_decap_8
XFILLER_338_103 VPWR VGND sg13cmos5l_decap_8
XFILLER_527_214 VPWR VGND sg13cmos5l_decap_4
X_3834_ _3834_/X Tile_X0Y0_WW4END[1] Tile_X0Y0_WW4END[2] _3882_/X _3855_/X _1037_/Q
+ _1036_/Q VPWR VGND sg13cmos5l_mux4_1
XFILLER_538_66 VPWR VGND sg13cmos5l_fill_2
X_3765_ _3765_/X Tile_X0Y1_WW4END[6] Tile_X0Y1_WW4END[14] Tile_X0Y1_W6END[6] _4014_/X
+ _1245_/Q _1244_/Q VPWR VGND sg13cmos5l_mux4_1
X_0977_ _0977_/Q Tile_X0Y0_FrameData[26] VGND VPWR Tile_X0Y9_FrameStrobe[1] latch
XFILLER_542_217 VPWR VGND sg13cmos5l_fill_1
X_2716_ _4543_/A3 VPWR VGND sg13cmos5l_tielo
XFILLER_257_67 VPWR VGND sg13cmos5l_decap_8
X_3696_ AXI_M_SOC_WDATA6 Tile_X0Y7_WW4END[6] Tile_X0Y7_WW4END[14] Tile_X0Y7_W6END[6]
+ _4690_/X _0235_/Q _0234_/Q VPWR VGND sg13cmos5l_mux4_1
XFILLER_554_21 VPWR VGND sg13cmos5l_decap_8
XFILLER_361_150 VPWR VGND sg13cmos5l_decap_8
XFILLER_105_106 VPWR VGND sg13cmos5l_fill_2
X_2647_ _2647_/Q Tile_X0Y6_FrameData[16] VGND VPWR Tile_X0Y9_FrameStrobe[6] latch
XFILLER_510_103 VPWR VGND sg13cmos5l_decap_4
XFILLER_10_49 VPWR VGND sg13cmos5l_decap_8
XFILLER_656_107 VPWR VGND sg13cmos5l_fill_1
XFILLER_361_194 VPWR VGND sg13cmos5l_decap_4
XFILLER_554_98 VPWR VGND sg13cmos5l_decap_8
X_2578_ _2578_/Q Tile_X0Y6_FrameData[21] VGND VPWR Tile_X0Y9_FrameStrobe[4] latch
XFILLER_704_35 VPWR VGND sg13cmos5l_decap_8
X_4317_ _4317_/X _4241_/X _4357_/X _4356_/X _4240_/X _1945_/Q _1944_/Q VPWR VGND sg13cmos5l_mux4_1
XFILLER_273_77 VPWR VGND sg13cmos5l_decap_8
XFILLER_259_143 VPWR VGND sg13cmos5l_decap_4
X_1529_ _1529_/Q Tile_X0Y2_FrameData[24] VGND VPWR Tile_X0Y9_FrameStrobe[3] latch
XFILLER_423_14 VPWR VGND sg13cmos5l_decap_8
XANTENNA__3234__X Tile_X0Y0_FrameData_O[2] VPWR VGND sg13cmos5l_antennanp
XFILLER_664_151 VPWR VGND sg13cmos5l_decap_4
XFILLER_570_42 VPWR VGND sg13cmos5l_decap_8
XFILLER_259_176 VPWR VGND sg13cmos5l_decap_8
XFILLER_19_14 VPWR VGND sg13cmos5l_decap_8
XFILLER_259_187 VPWR VGND sg13cmos5l_decap_8
X_4248_ _4248_/X Tile_X0Y2_W1END[2] Tile_X0Y2_W2MID[1] Tile_X0Y2_W2END[1] _4098_/X
+ _1617_/Q _1616_/Q VPWR VGND sg13cmos5l_mux4_1
XFILLER_274_168 VPWR VGND sg13cmos5l_decap_8
X_4179_ _4179_/X Tile_X0Y3_WW4END[0] AXI_M_SOC_WREADY _4222_/X _4205_/X _1783_/Q _1782_/Q
+ VPWR VGND sg13cmos5l_mux4_1
XFILLER_503_91 VPWR VGND sg13cmos5l_decap_8
XFILLER_416_173 VPWR VGND sg13cmos5l_fill_2
XFILLER_620_210 VPWR VGND sg13cmos5l_fill_1
XFILLER_222_70 VPWR VGND sg13cmos5l_decap_8
XFILLER_42_104 VPWR VGND sg13cmos5l_fill_2
XFILLER_35_35 VPWR VGND sg13cmos5l_decap_8
XFILLER_255_7 VPWR VGND sg13cmos5l_decap_8
XFILLER_579_84 VPWR VGND sg13cmos5l_decap_8
XFILLER_577_147 VPWR VGND sg13cmos5l_decap_8
XFILLER_187_109 VPWR VGND sg13cmos5l_fill_2
XFILLER_592_117 VPWR VGND sg13cmos5l_fill_1
XFILLER_422_7 VPWR VGND sg13cmos5l_decap_8
XFILLER_51_34 VPWR VGND sg13cmos5l_decap_8
XFILLER_329_158 VPWR VGND sg13cmos5l_decap_8
XFILLER_448_66 VPWR VGND sg13cmos5l_decap_8
XFILLER_195_175 VPWR VGND sg13cmos5l_fill_2
XANTENNA__3409__X Tile_X0Y4_FrameData_O[0] VPWR VGND sg13cmos5l_antennanp
XFILLER_464_21 VPWR VGND sg13cmos5l_decap_8
XFILLER_498_154 VPWR VGND sg13cmos5l_decap_8
XFILLER_2_200 VPWR VGND sg13cmos5l_decap_8
XFILLER_614_35 VPWR VGND sg13cmos5l_decap_8
XFILLER_501_147 VPWR VGND sg13cmos5l_decap_8
XFILLER_439_210 VPWR VGND sg13cmos5l_decap_8
XFILLER_111_109 VPWR VGND sg13cmos5l_decap_8
XFILLER_333_14 VPWR VGND sg13cmos5l_decap_8
XANTENNA__3144__X Tile_X0Y7_FrameData_O[14] VPWR VGND sg13cmos5l_antennanp
XFILLER_480_42 VPWR VGND sg13cmos5l_decap_8
XFILLER_333_58 VPWR VGND sg13cmos5l_fill_1
XFILLER_76_42 VPWR VGND sg13cmos5l_decap_8
XFILLER_65_207 VPWR VGND sg13cmos5l_fill_2
XFILLER_281_0 VPWR VGND sg13cmos5l_decap_8
XFILLER_379_0 VPWR VGND sg13cmos5l_decap_8
XANTENNA__2983__X Tile_X0Y8_FrameData_O[23] VPWR VGND sg13cmos5l_antennanp
XFILLER_280_105 VPWR VGND sg13cmos5l_decap_8
XFILLER_18_112 VPWR VGND sg13cmos5l_decap_4
XFILLER_630_56 VPWR VGND sg13cmos5l_decap_8
XFILLER_413_91 VPWR VGND sg13cmos5l_decap_8
XFILLER_407_173 VPWR VGND sg13cmos5l_decap_8
XFILLER_18_156 VPWR VGND sg13cmos5l_decap_8
XFILLER_546_0 VPWR VGND sg13cmos5l_decap_8
XFILLER_18_178 VPWR VGND sg13cmos5l_fill_2
XFILLER_489_84 VPWR VGND sg13cmos5l_decap_8
XFILLER_568_147 VPWR VGND sg13cmos5l_decap_8
XFILLER_221_216 VPWR VGND sg13cmos5l_fill_2
XFILLER_639_21 VPWR VGND sg13cmos5l_decap_8
XFILLER_713_0 VPWR VGND sg13cmos5l_decap_8
X_0900_ _0900_/Q Tile_X0Y9_FrameData[27] VGND VPWR Tile_X0Y9_FrameStrobe[7] latch
XFILLER_186_120 VPWR VGND sg13cmos5l_fill_2
X_1880_ _1880_/Q Tile_X0Y3_FrameData[17] VGND VPWR Tile_X0Y9_FrameStrobe[6] latch
XFILLER_639_98 VPWR VGND sg13cmos5l_decap_8
XFILLER_186_164 VPWR VGND sg13cmos5l_decap_8
X_0831_ _0831_/Q Tile_X0Y9_FrameData[0] VGND VPWR Tile_X0Y9_FrameStrobe[4] latch
XFILLER_358_77 VPWR VGND sg13cmos5l_decap_8
XFILLER_508_14 VPWR VGND sg13cmos5l_decap_8
XANTENNA__3319__X Tile_X0Y4_EE4BEG[7] VPWR VGND sg13cmos5l_antennanp
XFILLER_655_42 VPWR VGND sg13cmos5l_decap_8
X_3550_ Tile_X0Y9_E6BEG[8] _4888_/X VPWR VGND sg13cmos5l_buf_1
X_0762_ _0762_/Q Tile_X0Y9_FrameData[5] VGND VPWR Tile_X0Y9_FrameStrobe[2] latch
XFILLER_374_21 VPWR VGND sg13cmos5l_decap_8
X_2501_ _2501_/Q Tile_X0Y6_FrameData[2] VGND VPWR Tile_X0Y9_FrameStrobe[1] latch
XFILLER_142_201 VPWR VGND sg13cmos5l_decap_8
X_3481_ Tile_X0Y1_EE4BEG[7] _3955_/X VPWR VGND sg13cmos5l_buf_1
XFILLER_227_48 VPWR VGND sg13cmos5l_fill_1
X_0693_ _0693_/Q Tile_X0Y9_FrameData[10] VGND VPWR Tile_X0Y9_FrameStrobe[0] latch
XFILLER_343_172 VPWR VGND sg13cmos5l_decap_8
X_2432_ _2432_/Q Tile_X0Y5_FrameData[5] VGND VPWR Tile_X0Y9_FrameStrobe[7] latch
XFILLER_489_198 VPWR VGND sg13cmos5l_decap_8
XFILLER_524_35 VPWR VGND sg13cmos5l_decap_8
XFILLER_671_63 VPWR VGND sg13cmos5l_decap_8
X_2363_ _2363_/Q Tile_X0Y5_FrameData[10] VGND VPWR Tile_X0Y9_FrameStrobe[5] latch
XFILLER_243_14 VPWR VGND sg13cmos5l_decap_8
XANTENNA__3054__X Tile_X0Y5_FrameData_O[13] VPWR VGND sg13cmos5l_antennanp
XFILLER_646_140 VPWR VGND sg13cmos5l_decap_8
X_4102_ _4102_/X _4029_/X _4137_/X _4136_/X _4028_/X _1441_/Q _1440_/Q VPWR VGND sg13cmos5l_mux4_1
XFILLER_390_42 VPWR VGND sg13cmos5l_decap_8
X_1314_ _1314_/Q Tile_X0Y1_FrameData[23] VGND VPWR Tile_X0Y9_FrameStrobe[4] latch
X_2294_ _2294_/Q Tile_X0Y5_FrameData[15] VGND VPWR Tile_X0Y9_FrameStrobe[3] latch
XFILLER_256_135 VPWR VGND sg13cmos5l_decap_8
XFILLER_243_69 VPWR VGND sg13cmos5l_fill_2
X_4033_ _4033_/X Tile_X0Y3_W2MID[1] Tile_X0Y3_W2END[1] Tile_X0Y3_W6END[1] _4206_/X
+ _1905_/Q _1904_/Q VPWR VGND sg13cmos5l_mux4_1
XANTENNA__2893__X Tile_X0Y6_FrameData_O[14] VPWR VGND sg13cmos5l_antennanp
X_1245_ _1245_/Q Tile_X0Y1_FrameData[28] VGND VPWR Tile_X0Y9_FrameStrobe[2] latch
XFILLER_271_105 VPWR VGND sg13cmos5l_decap_8
XFILLER_460_216 VPWR VGND sg13cmos5l_fill_2
X_1176_ _1176_/Q Tile_X0Y0_FrameData[19] VGND VPWR Tile_X0Y9_FrameStrobe[7] latch
XFILLER_540_89 VPWR VGND sg13cmos5l_decap_8
X_0127_ AXI_M_SOC_WLAST _4940_/X _0934_/Q VPWR VGND sg13cmos5l_or2_1
XFILLER_399_84 VPWR VGND sg13cmos5l_decap_8
XFILLER_549_21 VPWR VGND sg13cmos5l_decap_8
XFILLER_413_176 VPWR VGND sg13cmos5l_decap_8
X_0058_ _3179_/A _3920_/X _3921_/X _1890_/Q VPWR VGND sg13cmos5l_mux2_1
X_4935_ _4935_/X Tile_X0Y8_W2MID[4] Tile_X0Y8_W2END[4] Tile_X0Y8_W6END[11] _4791_/X
+ _0621_/Q _0620_/Q VPWR VGND sg13cmos5l_mux4_1
XFILLER_413_198 VPWR VGND sg13cmos5l_decap_8
XANTENNA_11 AXI_M_SOC_WREADY VPWR VGND sg13cmos5l_antennanp
XANTENNA_22 AXI_M_SOC_WREADY VPWR VGND sg13cmos5l_antennanp
X_4866_ _4866_/X Tile_X0Y9_WW4END[13] AXI_M_SOC_RDATA2 _4929_/X _4904_/X _0811_/Q
+ _0810_/Q VPWR VGND sg13cmos5l_mux4_1
XFILLER_549_98 VPWR VGND sg13cmos5l_decap_8
XANTENNA_33 AXI_M_SOC_WREADY VPWR VGND sg13cmos5l_antennanp
XANTENNA_44 Tile_X0Y0_S2MID[4] VPWR VGND sg13cmos5l_antennanp
XFILLER_268_77 VPWR VGND sg13cmos5l_decap_8
XFILLER_177_175 VPWR VGND sg13cmos5l_decap_8
XANTENNA_55 _0040_/X VPWR VGND sg13cmos5l_antennanp
X_3817_ _3817_/X Tile_X0Y0_W2END[2] Tile_X0Y0_W6END[0] _3857_/X _3856_/X _1071_/Q
+ _1070_/Q VPWR VGND sg13cmos5l_mux4_1
XFILLER_418_14 VPWR VGND sg13cmos5l_decap_8
XFILLER_268_88 VPWR VGND sg13cmos5l_fill_1
XFILLER_192_112 VPWR VGND sg13cmos5l_decap_8
XANTENNA_66 Tile_X0Y9_FrameStrobe[17] VPWR VGND sg13cmos5l_antennanp
XFILLER_716_166 VPWR VGND sg13cmos5l_fill_2
X_4797_ _4797_/X _4342_/X _4346_/X _4350_/X _4314_/X _2115_/Q _2114_/Q VPWR VGND sg13cmos5l_mux4_1
XFILLER_515_217 VPWR VGND sg13cmos5l_fill_1
XFILLER_192_123 VPWR VGND sg13cmos5l_fill_2
XANTENNA__3229__X Tile_X0Y0_FrameStrobe_O[17] VPWR VGND sg13cmos5l_antennanp
XANTENNA_77 Tile_X0Y9_N2MID[3] VPWR VGND sg13cmos5l_antennanp
XFILLER_565_42 VPWR VGND sg13cmos5l_decap_8
X_3748_ AXI_M_SOC_ARADDR20 Tile_X0Y8_WW4END[4] Tile_X0Y8_WW4END[12] Tile_X0Y8_W6END[4]
+ _4804_/X _0495_/Q _0494_/Q VPWR VGND sg13cmos5l_mux4_1
XFILLER_319_191 VPWR VGND sg13cmos5l_decap_8
XFILLER_284_21 VPWR VGND sg13cmos5l_decap_8
XFILLER_341_109 VPWR VGND sg13cmos5l_fill_2
XFILLER_192_189 VPWR VGND sg13cmos5l_decap_8
XFILLER_715_34 VPWR VGND sg13cmos5l_decap_8
X_3679_ _3679_/X Tile_X0Y2_WW4END[1] Tile_X0Y2_WW4END[9] Tile_X0Y2_W6END[9] _4125_/X
+ _1487_/Q _1486_/Q VPWR VGND sg13cmos5l_mux4_1
XFILLER_629_118 VPWR VGND sg13cmos5l_decap_8
XFILLER_284_98 VPWR VGND sg13cmos5l_decap_8
XFILLER_434_35 VPWR VGND sg13cmos5l_decap_8
XFILLER_294_208 VPWR VGND sg13cmos5l_decap_8
XFILLER_153_14 VPWR VGND sg13cmos5l_decap_8
XFILLER_495_168 VPWR VGND sg13cmos5l_decap_8
XFILLER_581_85 VPWR VGND sg13cmos5l_decap_8
XFILLER_247_113 VPWR VGND sg13cmos5l_fill_2
XFILLER_101_153 VPWR VGND sg13cmos5l_fill_1
XFILLER_372_7 VPWR VGND sg13cmos5l_decap_8
XFILLER_303_28 VPWR VGND sg13cmos5l_decap_4
XFILLER_652_154 VPWR VGND sg13cmos5l_decap_8
XFILLER_451_216 VPWR VGND sg13cmos5l_fill_2
XFILLER_450_56 VPWR VGND sg13cmos5l_decap_8
XFILLER_233_91 VPWR VGND sg13cmos5l_fill_1
XFILLER_46_67 VPWR VGND sg13cmos5l_fill_2
XFILLER_637_7 VPWR VGND sg13cmos5l_decap_8
XFILLER_404_154 VPWR VGND sg13cmos5l_decap_8
XFILLER_15_126 VPWR VGND sg13cmos5l_decap_8
XFILLER_459_21 VPWR VGND sg13cmos5l_decap_8
XFILLER_404_198 VPWR VGND sg13cmos5l_fill_1
XFILLER_62_33 VPWR VGND sg13cmos5l_decap_8
XFILLER_459_65 VPWR VGND sg13cmos5l_fill_1
XFILLER_30_107 VPWR VGND sg13cmos5l_decap_8
XFILLER_141_2 VPWR VGND sg13cmos5l_fill_1
XFILLER_707_133 VPWR VGND sg13cmos5l_decap_8
XFILLER_609_35 VPWR VGND sg13cmos5l_decap_8
XFILLER_707_166 VPWR VGND sg13cmos5l_fill_1
XFILLER_7_28 VPWR VGND sg13cmos5l_decap_8
XFILLER_573_161 VPWR VGND sg13cmos5l_decap_8
XFILLER_506_217 VPWR VGND sg13cmos5l_fill_1
XFILLER_328_14 VPWR VGND sg13cmos5l_decap_8
XFILLER_168_186 VPWR VGND sg13cmos5l_decap_8
XFILLER_609_79 VPWR VGND sg13cmos5l_fill_1
XFILLER_317_128 VPWR VGND sg13cmos5l_decap_8
XANTENNA__3139__X Tile_X0Y7_FrameData_O[9] VPWR VGND sg13cmos5l_antennanp
XFILLER_127_0 VPWR VGND sg13cmos5l_decap_8
XFILLER_475_42 VPWR VGND sg13cmos5l_decap_8
XFILLER_707_199 VPWR VGND sg13cmos5l_fill_2
XFILLER_194_21 VPWR VGND sg13cmos5l_decap_8
XFILLER_124_201 VPWR VGND sg13cmos5l_fill_1
XANTENNA__2978__X Tile_X0Y8_FrameData_O[18] VPWR VGND sg13cmos5l_antennanp
XFILLER_408_80 VPWR VGND sg13cmos5l_fill_2
XFILLER_625_56 VPWR VGND sg13cmos5l_decap_8
XFILLER_11_70 VPWR VGND sg13cmos5l_decap_8
XFILLER_194_98 VPWR VGND sg13cmos5l_decap_8
XFILLER_97_107 VPWR VGND sg13cmos5l_decap_4
XFILLER_344_35 VPWR VGND sg13cmos5l_decap_8
XFILLER_127_70 VPWR VGND sg13cmos5l_decap_8
XFILLER_496_0 VPWR VGND sg13cmos5l_decap_8
XFILLER_491_63 VPWR VGND sg13cmos5l_decap_8
XFILLER_486_157 VPWR VGND sg13cmos5l_decap_8
XFILLER_486_168 VPWR VGND sg13cmos5l_fill_2
XFILLER_486_179 VPWR VGND sg13cmos5l_fill_1
XFILLER_628_151 VPWR VGND sg13cmos5l_decap_4
XFILLER_87_74 VPWR VGND sg13cmos5l_decap_8
XFILLER_628_162 VPWR VGND sg13cmos5l_decap_4
XFILLER_663_0 VPWR VGND sg13cmos5l_decap_8
XFILLER_238_146 VPWR VGND sg13cmos5l_decap_4
XFILLER_641_77 VPWR VGND sg13cmos5l_decap_8
XFILLER_213_28 VPWR VGND sg13cmos5l_decap_8
XFILLER_16_7 VPWR VGND sg13cmos5l_decap_8
XFILLER_643_154 VPWR VGND sg13cmos5l_decap_8
XFILLER_360_56 VPWR VGND sg13cmos5l_decap_8
XANTENNA__3602__X Tile_X0Y9_S1BEG[0] VPWR VGND sg13cmos5l_antennanp
X_1030_ _1030_/Q Tile_X0Y0_FrameData[5] VGND VPWR Tile_X0Y9_FrameStrobe[2] latch
XFILLER_253_138 VPWR VGND sg13cmos5l_fill_2
XFILLER_369_21 VPWR VGND sg13cmos5l_decap_8
XFILLER_261_182 VPWR VGND sg13cmos5l_fill_1
X_2981_ Tile_X0Y8_FrameData_O[21] Tile_X0Y8_FrameData[21] VPWR VGND sg13cmos5l_buf_1
XFILLER_410_135 VPWR VGND sg13cmos5l_decap_8
X_1932_ _1932_/Q Tile_X0Y4_FrameData[25] VGND VPWR Tile_X0Y9_FrameStrobe[0] latch
X_4720_ _4720_/X Tile_X0Y8_W1END[2] Tile_X0Y8_WW4END[14] Tile_X0Y8_W6END[6] _4802_/X
+ _0605_/Q _0604_/Q VPWR VGND sg13cmos5l_mux4_1
XFILLER_519_35 VPWR VGND sg13cmos5l_decap_8
X_4651_ _4651_/X AXI_M_SOC_RDATA19 _4688_/X _4692_/X _4675_/X _0257_/Q _0256_/Q VPWR
+ VGND sg13cmos5l_mux4_1
XFILLER_666_63 VPWR VGND sg13cmos5l_decap_8
X_1863_ _1863_/Q Tile_X0Y3_FrameData[2] VGND VPWR Tile_X0Y9_FrameStrobe[5] latch
XANTENNA__3049__X Tile_X0Y5_FrameData_O[8] VPWR VGND sg13cmos5l_antennanp
X_3602_ Tile_X0Y9_S1BEG[0] _4824_/X VPWR VGND sg13cmos5l_buf_1
X_0814_ _0814_/Q Tile_X0Y9_FrameData[17] VGND VPWR Tile_X0Y9_FrameStrobe[4] latch
X_4582_ _4582_/X _4549_/X Tile_X0Y9_N4END[14] _4548_/X _0155_/X _2467_/Q _2466_/Q
+ VPWR VGND sg13cmos5l_mux4_1
XFILLER_713_147 VPWR VGND sg13cmos5l_decap_8
X_1794_ _1794_/Q Tile_X0Y3_FrameData[7] VGND VPWR Tile_X0Y9_FrameStrobe[3] latch
XFILLER_385_75 VPWR VGND sg13cmos5l_decap_4
XFILLER_174_178 VPWR VGND sg13cmos5l_fill_1
X_3533_ Tile_X0Y9_E2BEG[7] _4855_/X VPWR VGND sg13cmos5l_buf_1
XFILLER_115_201 VPWR VGND sg13cmos5l_decap_4
X_0745_ _0745_/Q Tile_X0Y9_FrameData[22] VGND VPWR Tile_X0Y9_FrameStrobe[2] latch
XANTENNA__2888__X Tile_X0Y6_FrameData_O[9] VPWR VGND sg13cmos5l_antennanp
XFILLER_318_80 VPWR VGND sg13cmos5l_fill_2
XFILLER_316_183 VPWR VGND sg13cmos5l_decap_8
XFILLER_331_120 VPWR VGND sg13cmos5l_decap_4
X_3464_ Tile_X0Y1_FrameData_O[22] Tile_X0Y1_FrameData[22] VPWR VGND sg13cmos5l_buf_1
X_0676_ _0676_/Q Tile_X0Y9_FrameData[27] VGND VPWR Tile_X0Y9_FrameStrobe[0] latch
XFILLER_682_95 VPWR VGND sg13cmos5l_decap_8
X_2415_ _2415_/Q Tile_X0Y5_FrameData[22] VGND VPWR Tile_X0Y9_FrameStrobe[7] latch
X_3395_ Tile_X0Y2_E2BEGb[6] _4054_/X VPWR VGND sg13cmos5l_buf_1
XFILLER_492_105 VPWR VGND sg13cmos5l_decap_8
XFILLER_477_179 VPWR VGND sg13cmos5l_decap_8
X_2346_ _2346_/Q Tile_X0Y5_FrameData[27] VGND VPWR Tile_X0Y9_FrameStrobe[5] latch
XFILLER_229_124 VPWR VGND sg13cmos5l_fill_2
XFILLER_404_49 VPWR VGND sg13cmos5l_decap_8
XFILLER_701_14 VPWR VGND sg13cmos5l_decap_8
XFILLER_123_28 VPWR VGND sg13cmos5l_decap_8
X_2277_ _2277_/Q Tile_X0Y5_FrameData[0] VGND VPWR Tile_X0Y9_FrameStrobe[2] latch
XFILLER_244_105 VPWR VGND sg13cmos5l_decap_8
XFILLER_551_99 VPWR VGND sg13cmos5l_fill_2
XANTENNA__3512__X Tile_X0Y1_E2BEG[2] VPWR VGND sg13cmos5l_antennanp
XFILLER_270_56 VPWR VGND sg13cmos5l_decap_8
X_4016_ _4016_/X _3981_/X _0073_/X _3980_/X Tile_X0Y0_S4END[4] _1217_/Q _1216_/Q VPWR
+ VGND sg13cmos5l_mux4_1
X_1228_ _1228_/Q Tile_X0Y1_FrameData[13] VGND VPWR Tile_X0Y9_FrameStrobe[1] latch
X_1159_ _1159_/Q Tile_X0Y0_FrameData[4] VGND VPWR Tile_X0Y9_FrameStrobe[6] latch
XFILLER_197_204 VPWR VGND sg13cmos5l_decap_4
XFILLER_500_70 VPWR VGND sg13cmos5l_decap_8
XFILLER_401_146 VPWR VGND sg13cmos5l_fill_1
XFILLER_398_197 VPWR VGND sg13cmos5l_decap_4
XFILLER_279_76 VPWR VGND sg13cmos5l_decap_8
X_4918_ _4918_/X Tile_X0Y9_N1END[2] Tile_X0Y9_N4END[2] _4898_/X _0081_/X _0723_/Q
+ _0722_/Q VPWR VGND sg13cmos5l_mux4_1
XFILLER_429_35 VPWR VGND sg13cmos5l_decap_8
XFILLER_576_63 VPWR VGND sg13cmos5l_decap_8
XFILLER_148_14 VPWR VGND sg13cmos5l_decap_8
X_4849_ _4849_/X Tile_X0Y9_W2MID[6] AXI_M_SOC_RDATA1 _4903_/X _4902_/X _0845_/Q _0844_/Q
+ VPWR VGND sg13cmos5l_mux4_1
XFILLER_295_42 VPWR VGND sg13cmos5l_decap_8
XFILLER_165_145 VPWR VGND sg13cmos5l_fill_2
XFILLER_148_58 VPWR VGND sg13cmos5l_fill_1
XFILLER_218_7 VPWR VGND sg13cmos5l_decap_8
XANTENNA__2798__X Tile_X0Y3_E6BEG[8] VPWR VGND sg13cmos5l_antennanp
XFILLER_570_175 VPWR VGND sg13cmos5l_decap_8
XFILLER_180_159 VPWR VGND sg13cmos5l_decap_8
XFILLER_468_113 VPWR VGND sg13cmos5l_decap_8
XFILLER_322_142 VPWR VGND sg13cmos5l_decap_8
XFILLER_164_35 VPWR VGND sg13cmos5l_decap_4
XFILLER_164_68 VPWR VGND sg13cmos5l_decap_4
XFILLER_587_7 VPWR VGND sg13cmos5l_decap_8
XFILLER_483_105 VPWR VGND sg13cmos5l_fill_2
XFILLER_322_197 VPWR VGND sg13cmos5l_decap_8
XFILLER_672_205 VPWR VGND sg13cmos5l_fill_2
XFILLER_314_49 VPWR VGND sg13cmos5l_decap_8
XFILLER_611_14 VPWR VGND sg13cmos5l_decap_8
XFILLER_180_45 VPWR VGND sg13cmos5l_fill_2
XANTENNA__3422__X Tile_X0Y4_FrameData_O[13] VPWR VGND sg13cmos5l_antennanp
XFILLER_57_88 VPWR VGND sg13cmos5l_decap_8
XFILLER_491_160 VPWR VGND sg13cmos5l_fill_1
XFILLER_424_216 VPWR VGND sg13cmos5l_fill_2
XFILLER_180_67 VPWR VGND sg13cmos5l_decap_8
XFILLER_491_182 VPWR VGND sg13cmos5l_decap_8
XFILLER_73_21 VPWR VGND sg13cmos5l_decap_8
XFILLER_640_168 VPWR VGND sg13cmos5l_decap_8
XFILLER_189_21 VPWR VGND sg13cmos5l_decap_8
XFILLER_188_215 VPWR VGND sg13cmos5l_fill_2
XFILLER_243_193 VPWR VGND sg13cmos5l_fill_1
XFILLER_410_70 VPWR VGND sg13cmos5l_decap_8
XFILLER_244_0 VPWR VGND sg13cmos5l_decap_8
XFILLER_189_98 VPWR VGND sg13cmos5l_decap_8
XFILLER_339_35 VPWR VGND sg13cmos5l_decap_8
XFILLER_546_150 VPWR VGND sg13cmos5l_decap_4
XFILLER_486_63 VPWR VGND sg13cmos5l_decap_8
XFILLER_7_100 VPWR VGND sg13cmos5l_fill_1
XFILLER_411_0 VPWR VGND sg13cmos5l_decap_8
XFILLER_509_0 VPWR VGND sg13cmos5l_decap_8
XFILLER_7_155 VPWR VGND sg13cmos5l_decap_4
XFILLER_305_109 VPWR VGND sg13cmos5l_decap_8
XFILLER_561_164 VPWR VGND sg13cmos5l_fill_1
XFILLER_636_77 VPWR VGND sg13cmos5l_decap_8
XFILLER_355_56 VPWR VGND sg13cmos5l_decap_8
XFILLER_138_91 VPWR VGND sg13cmos5l_decap_8
X_0530_ _0530_/Q Tile_X0Y8_FrameData[13] VGND VPWR Tile_X0Y9_FrameStrobe[3] latch
XFILLER_703_180 VPWR VGND sg13cmos5l_decap_8
XFILLER_313_131 VPWR VGND sg13cmos5l_decap_8
XFILLER_652_21 VPWR VGND sg13cmos5l_decap_8
XFILLER_98_84 VPWR VGND sg13cmos5l_decap_8
X_0461_ _0461_/Q Tile_X0Y8_FrameData[18] VGND VPWR Tile_X0Y9_FrameStrobe[1] latch
X_2200_ _2200_/Q Tile_X0Y5_FrameData[13] VGND VPWR Tile_X0Y9_FrameStrobe[0] latch
XFILLER_663_216 VPWR VGND sg13cmos5l_fill_2
X_3180_ Tile_X0Y0_N4BEG[4] _3180_/A VPWR VGND sg13cmos5l_buf_1
XFILLER_652_98 VPWR VGND sg13cmos5l_decap_8
XFILLER_78_151 VPWR VGND sg13cmos5l_decap_8
X_0392_ _0392_/Q Tile_X0Y7_FrameData[23] VGND VPWR Tile_X0Y9_FrameStrobe[7] latch
X_2131_ _2131_/Q Tile_X0Y4_FrameData[18] VGND VPWR Tile_X0Y9_FrameStrobe[6] latch
XFILLER_521_14 VPWR VGND sg13cmos5l_decap_8
XFILLER_281_200 VPWR VGND sg13cmos5l_decap_4
XANTENNA__3332__X Tile_X0Y2_FrameData_O[3] VPWR VGND sg13cmos5l_antennanp
XFILLER_93_154 VPWR VGND sg13cmos5l_fill_2
X_2062_ _2062_/Q Tile_X0Y4_FrameData[23] VGND VPWR Tile_X0Y9_FrameStrobe[4] latch
XFILLER_93_176 VPWR VGND sg13cmos5l_decap_4
X_1013_ _1013_/Q Tile_X0Y0_FrameData[22] VGND VPWR Tile_X0Y9_FrameStrobe[2] latch
XFILLER_631_146 VPWR VGND sg13cmos5l_decap_8
XFILLER_241_108 VPWR VGND sg13cmos5l_decap_8
XFILLER_234_171 VPWR VGND sg13cmos5l_decap_8
XFILLER_179_215 VPWR VGND sg13cmos5l_fill_2
XFILLER_395_123 VPWR VGND sg13cmos5l_decap_8
X_2964_ Tile_X0Y8_FrameData_O[4] Tile_X0Y8_FrameData[4] VPWR VGND sg13cmos5l_buf_1
XFILLER_677_84 VPWR VGND sg13cmos5l_fill_2
XFILLER_249_35 VPWR VGND sg13cmos5l_decap_8
XFILLER_544_109 VPWR VGND sg13cmos5l_fill_2
X_1915_ _1915_/Q Tile_X0Y3_FrameData[14] VGND VPWR Tile_X0Y9_FrameStrobe[7] latch
X_4703_ _4703_/X Tile_X0Y9_W2MID[6] Tile_X0Y9_W2END[6] Tile_X0Y9_W6END[6] _4903_/X
+ _0917_/Q _0916_/Q VPWR VGND sg13cmos5l_mux4_1
XFILLER_249_57 VPWR VGND sg13cmos5l_fill_2
X_2895_ Tile_X0Y6_FrameData_O[16] Tile_X0Y6_FrameData[16] VPWR VGND sg13cmos5l_buf_1
XFILLER_537_194 VPWR VGND sg13cmos5l_fill_1
X_1846_ _1846_/Q Tile_X0Y3_FrameData[19] VGND VPWR Tile_X0Y9_FrameStrobe[5] latch
X_4634_ _4634_/X Tile_X0Y7_WW4END[9] AXI_M_SOC_RDATA22 _4693_/X _4671_/X _0291_/Q
+ _0290_/Q VPWR VGND sg13cmos5l_mux4_1
XFILLER_546_77 VPWR VGND sg13cmos5l_decap_8
X_4565_ _4565_/X _4122_/X _4126_/X _4107_/X _4098_/X _1607_/Q _1606_/Q VPWR VGND sg13cmos5l_mux4_1
XFILLER_118_28 VPWR VGND sg13cmos5l_decap_8
X_1777_ _1777_/Q Tile_X0Y3_FrameData[24] VGND VPWR Tile_X0Y9_FrameStrobe[3] latch
XANTENNA__3507__X Tile_X0Y1_E2BEGb[5] VPWR VGND sg13cmos5l_antennanp
XFILLER_265_56 VPWR VGND sg13cmos5l_decap_4
X_0728_ _0728_/Q Tile_X0Y9_FrameData[7] VGND VPWR Tile_X0Y9_FrameStrobe[1] latch
X_3516_ Tile_X0Y1_E2BEG[6] _3938_/X VPWR VGND sg13cmos5l_buf_1
X_4496_ _4496_/X Tile_X0Y6_W2MID[7] AXI_M_SOC_RDATA24 _4553_/X _4552_/X _2615_/Q _2614_/Q
+ VPWR VGND sg13cmos5l_mux4_1
XFILLER_562_21 VPWR VGND sg13cmos5l_decap_8
XFILLER_103_204 VPWR VGND sg13cmos5l_fill_2
X_3447_ Tile_X0Y1_FrameData_O[5] Tile_X0Y1_FrameData[5] VPWR VGND sg13cmos5l_buf_1
X_0659_ _0659_/Q Tile_X0Y8_FrameData[12] VGND VPWR Tile_X0Y9_FrameStrobe[7] latch
XFILLER_170_192 VPWR VGND sg13cmos5l_decap_4
X_3378_ Tile_X0Y2_E6BEG[1] _4073_/X VPWR VGND sg13cmos5l_buf_1
XFILLER_562_98 VPWR VGND sg13cmos5l_decap_8
XFILLER_134_49 VPWR VGND sg13cmos5l_decap_8
XFILLER_712_35 VPWR VGND sg13cmos5l_decap_8
XFILLER_465_149 VPWR VGND sg13cmos5l_fill_1
XFILLER_69_173 VPWR VGND sg13cmos5l_decap_8
XFILLER_281_77 VPWR VGND sg13cmos5l_decap_8
X_2329_ _2329_/Q Tile_X0Y5_FrameData[12] VGND VPWR Tile_X0Y9_FrameStrobe[4] latch
XFILLER_607_143 VPWR VGND sg13cmos5l_decap_8
XFILLER_431_14 VPWR VGND sg13cmos5l_decap_8
XFILLER_406_205 VPWR VGND sg13cmos5l_decap_8
XANTENNA__3242__X Tile_X0Y0_FrameData_O[10] VPWR VGND sg13cmos5l_antennanp
XFILLER_406_216 VPWR VGND sg13cmos5l_fill_2
XFILLER_27_14 VPWR VGND sg13cmos5l_decap_8
XFILLER_168_7 VPWR VGND sg13cmos5l_decap_8
XFILLER_225_171 VPWR VGND sg13cmos5l_decap_8
XFILLER_43_13 VPWR VGND sg13cmos5l_decap_8
XFILLER_587_51 VPWR VGND sg13cmos5l_fill_1
XFILLER_240_152 VPWR VGND sg13cmos5l_decap_8
XFILLER_159_13 VPWR VGND sg13cmos5l_decap_8
XFILLER_587_73 VPWR VGND sg13cmos5l_decap_4
XFILLER_335_7 VPWR VGND sg13cmos5l_decap_8
XFILLER_386_156 VPWR VGND sg13cmos5l_fill_1
XFILLER_43_79 VPWR VGND sg13cmos5l_decap_8
XFILLER_590_215 VPWR VGND sg13cmos5l_fill_2
XFILLER_159_68 VPWR VGND sg13cmos5l_decap_8
XFILLER_138_112 VPWR VGND sg13cmos5l_decap_8
XFILLER_528_172 VPWR VGND sg13cmos5l_decap_4
XFILLER_502_7 VPWR VGND sg13cmos5l_decap_8
XFILLER_543_142 VPWR VGND sg13cmos5l_decap_4
XFILLER_543_153 VPWR VGND sg13cmos5l_decap_8
XFILLER_342_204 VPWR VGND sg13cmos5l_decap_8
XFILLER_342_215 VPWR VGND sg13cmos5l_fill_2
XFILLER_606_14 VPWR VGND sg13cmos5l_decap_8
XFILLER_4_125 VPWR VGND sg13cmos5l_decap_8
XFILLER_175_56 VPWR VGND sg13cmos5l_decap_8
XANTENNA__3417__X Tile_X0Y4_FrameData_O[8] VPWR VGND sg13cmos5l_antennanp
XFILLER_472_21 VPWR VGND sg13cmos5l_decap_8
XFILLER_68_43 VPWR VGND sg13cmos5l_decap_8
XFILLER_472_98 VPWR VGND sg13cmos5l_decap_8
XFILLER_622_35 VPWR VGND sg13cmos5l_decap_8
XFILLER_191_55 VPWR VGND sg13cmos5l_decap_8
XFILLER_194_0 VPWR VGND sg13cmos5l_decap_8
XFILLER_75_110 VPWR VGND sg13cmos5l_decap_8
XFILLER_341_14 VPWR VGND sg13cmos5l_decap_8
XFILLER_471_119 VPWR VGND sg13cmos5l_fill_1
XANTENNA__3152__X Tile_X0Y7_FrameData_O[22] VPWR VGND sg13cmos5l_antennanp
XFILLER_84_20 VPWR VGND sg13cmos5l_decap_8
XFILLER_208_138 VPWR VGND sg13cmos5l_decap_8
XFILLER_698_28 VPWR VGND sg13cmos5l_decap_8
XFILLER_361_0 VPWR VGND sg13cmos5l_decap_8
XFILLER_459_0 VPWR VGND sg13cmos5l_decap_8
XFILLER_223_108 VPWR VGND sg13cmos5l_decap_8
XANTENNA__2991__X Tile_X0Y8_FrameData_O[31] VPWR VGND sg13cmos5l_antennanp
XFILLER_421_91 VPWR VGND sg13cmos5l_decap_8
XFILLER_231_130 VPWR VGND sg13cmos5l_decap_8
XFILLER_140_70 VPWR VGND sg13cmos5l_decap_8
XFILLER_626_0 VPWR VGND sg13cmos5l_decap_8
XFILLER_231_141 VPWR VGND sg13cmos5l_fill_2
XFILLER_497_84 VPWR VGND sg13cmos5l_decap_8
XFILLER_647_21 VPWR VGND sg13cmos5l_decap_8
XFILLER_526_109 VPWR VGND sg13cmos5l_decap_4
XFILLER_519_150 VPWR VGND sg13cmos5l_decap_8
XFILLER_83_7 VPWR VGND sg13cmos5l_decap_8
XFILLER_129_123 VPWR VGND sg13cmos5l_decap_8
X_1700_ _1700_/Q Tile_X0Y3_FrameData[5] VGND VPWR Tile_X0Y9_FrameStrobe[0] latch
XFILLER_534_120 VPWR VGND sg13cmos5l_fill_2
XFILLER_219_27 VPWR VGND sg13cmos5l_decap_8
X_2680_ _2680_/Q Tile_X0Y6_FrameData[15] VGND VPWR Tile_X0Y9_FrameStrobe[7] latch
XFILLER_647_98 VPWR VGND sg13cmos5l_decap_8
XFILLER_534_164 VPWR VGND sg13cmos5l_fill_2
X_1631_ _1631_/Q Tile_X0Y2_FrameData[18] VGND VPWR Tile_X0Y9_FrameStrobe[6] latch
XFILLER_333_215 VPWR VGND sg13cmos5l_fill_2
XFILLER_516_14 VPWR VGND sg13cmos5l_decap_8
XFILLER_695_105 VPWR VGND sg13cmos5l_decap_8
XANTENNA__3327__X Tile_X0Y4_EE4BEG[15] VPWR VGND sg13cmos5l_antennanp
XFILLER_663_42 VPWR VGND sg13cmos5l_decap_8
X_4350_ _4350_/X _4308_/X _0160_/X _4307_/X _0110_/X _1953_/Q _1952_/Q VPWR VGND sg13cmos5l_mux4_1
X_1562_ _1562_/Q Tile_X0Y2_FrameData[23] VGND VPWR Tile_X0Y9_FrameStrobe[4] latch
XFILLER_98_202 VPWR VGND sg13cmos5l_decap_4
XFILLER_382_21 VPWR VGND sg13cmos5l_decap_8
X_3301_ Tile_X0Y0_E2BEG[1] _3805_/X VPWR VGND sg13cmos5l_buf_1
X_0513_ _0513_/Q Tile_X0Y8_FrameData[30] VGND VPWR Tile_X0Y9_FrameStrobe[3] latch
X_4281_ _4281_/X Tile_X0Y4_WW4END[6] AXI_M_SOC_BRESP0 _4342_/X _4314_/X _2051_/Q _2050_/Q
+ VPWR VGND sg13cmos5l_mux4_1
X_1493_ _1493_/Q Tile_X0Y2_FrameData[28] VGND VPWR Tile_X0Y9_FrameStrobe[2] latch
XFILLER_447_105 VPWR VGND sg13cmos5l_decap_8
X_3232_ Tile_X0Y0_FrameData_O[0] Tile_X0Y0_FrameData[0] VPWR VGND sg13cmos5l_buf_1
X_0444_ _0444_/Q Tile_X0Y8_FrameData[3] VGND VPWR Tile_X0Y9_FrameStrobe[0] latch
XFILLER_382_98 VPWR VGND sg13cmos5l_fill_2
XFILLER_532_35 VPWR VGND sg13cmos5l_decap_8
X_3163_ Tile_X0Y4_E6BEG[0] _4288_/X VPWR VGND sg13cmos5l_buf_1
X_0375_ _0375_/Q Tile_X0Y7_FrameData[8] VGND VPWR Tile_X0Y9_FrameStrobe[6] latch
XANTENNA__3062__X Tile_X0Y5_FrameData_O[21] VPWR VGND sg13cmos5l_antennanp
XFILLER_455_171 VPWR VGND sg13cmos5l_decap_4
X_2114_ _2114_/Q Tile_X0Y4_FrameData[3] VGND VPWR Tile_X0Y9_FrameStrobe[5] latch
XFILLER_66_154 VPWR VGND sg13cmos5l_decap_8
XFILLER_604_102 VPWR VGND sg13cmos5l_fill_2
X_3094_ Tile_X0Y7_E2BEGb[0] _4620_/X VPWR VGND sg13cmos5l_buf_1
X_2045_ _2045_/Q Tile_X0Y4_FrameData[8] VGND VPWR Tile_X0Y9_FrameStrobe[3] latch
XFILLER_401_28 VPWR VGND sg13cmos5l_decap_8
XFILLER_81_135 VPWR VGND sg13cmos5l_decap_8
XFILLER_214_119 VPWR VGND sg13cmos5l_decap_4
XFILLER_688_50 VPWR VGND sg13cmos5l_decap_8
XFILLER_368_123 VPWR VGND sg13cmos5l_decap_4
XFILLER_368_156 VPWR VGND sg13cmos5l_decap_8
X_3996_ _3996_/X _3987_/X _0084_/X _3986_/X Tile_X0Y0_S4END[7] _1203_/Q _1202_/Q VPWR
+ VGND sg13cmos5l_mux4_1
XFILLER_557_21 VPWR VGND sg13cmos5l_decap_8
XFILLER_517_109 VPWR VGND sg13cmos5l_decap_4
XFILLER_222_196 VPWR VGND sg13cmos5l_decap_8
X_2947_ Tile_X0Y8_EE4BEG[3] _4747_/X VPWR VGND sg13cmos5l_buf_1
XFILLER_200_84 VPWR VGND sg13cmos5l_decap_8
XFILLER_383_148 VPWR VGND sg13cmos5l_decap_8
XFILLER_13_49 VPWR VGND sg13cmos5l_decap_8
XFILLER_557_98 VPWR VGND sg13cmos5l_decap_8
XFILLER_707_35 VPWR VGND sg13cmos5l_decap_8
X_2878_ Tile_X0Y6_EE4BEG[15] _4527_/X VPWR VGND sg13cmos5l_buf_1
XFILLER_276_77 VPWR VGND sg13cmos5l_decap_8
X_4617_ _4617_/X Tile_X0Y7_W2MID[2] AXI_M_SOC_RDATA21 _4673_/X _4672_/X _0325_/Q _0324_/Q
+ VPWR VGND sg13cmos5l_mux4_1
XFILLER_135_126 VPWR VGND sg13cmos5l_decap_8
X_1829_ _1829_/Q Tile_X0Y3_FrameData[4] VGND VPWR Tile_X0Y9_FrameStrobe[4] latch
XFILLER_426_14 VPWR VGND sg13cmos5l_decap_8
XANTENNA__3237__X Tile_X0Y0_FrameData_O[5] VPWR VGND sg13cmos5l_antennanp
XFILLER_573_42 VPWR VGND sg13cmos5l_decap_8
XFILLER_540_145 VPWR VGND sg13cmos5l_decap_8
X_4548_ _4548_/X Tile_X0Y5_W1END[2] Tile_X0Y5_W6END[10] _4465_/X _4422_/X _2399_/Q
+ _2398_/Q VPWR VGND sg13cmos5l_mux4_1
XFILLER_686_149 VPWR VGND sg13cmos5l_decap_4
XFILLER_292_21 VPWR VGND sg13cmos5l_decap_8
XFILLER_679_190 VPWR VGND sg13cmos5l_fill_1
XFILLER_289_163 VPWR VGND sg13cmos5l_fill_2
X_4479_ _4479_/X Tile_X0Y7_W2MID[2] Tile_X0Y7_W2END[2] Tile_X0Y7_W6END[2] _4672_/X
+ _0397_/Q _0396_/Q VPWR VGND sg13cmos5l_mux4_1
XFILLER_438_105 VPWR VGND sg13cmos5l_decap_8
XFILLER_627_216 VPWR VGND sg13cmos5l_fill_2
XFILLER_442_35 VPWR VGND sg13cmos5l_decap_8
XFILLER_38_13 VPWR VGND sg13cmos5l_fill_2
XFILLER_453_108 VPWR VGND sg13cmos5l_decap_8
XFILLER_161_14 VPWR VGND sg13cmos5l_decap_8
XFILLER_285_7 VPWR VGND sg13cmos5l_decap_8
XFILLER_245_211 VPWR VGND sg13cmos5l_fill_1
XFILLER_180_6 VPWR VGND sg13cmos5l_decap_8
XFILLER_72_113 VPWR VGND sg13cmos5l_fill_1
XFILLER_461_152 VPWR VGND sg13cmos5l_decap_8
XFILLER_311_28 VPWR VGND sg13cmos5l_decap_8
XFILLER_452_7 VPWR VGND sg13cmos5l_decap_8
XFILLER_205_119 VPWR VGND sg13cmos5l_decap_8
XFILLER_72_146 VPWR VGND sg13cmos5l_decap_8
XFILLER_610_105 VPWR VGND sg13cmos5l_decap_8
XANTENNA__3700__X AXI_M_SOC_WDATA10 VPWR VGND sg13cmos5l_antennanp
XFILLER_598_83 VPWR VGND sg13cmos5l_fill_2
XFILLER_359_112 VPWR VGND sg13cmos5l_decap_8
XFILLER_359_167 VPWR VGND sg13cmos5l_decap_8
XFILLER_467_21 VPWR VGND sg13cmos5l_decap_8
XFILLER_516_131 VPWR VGND sg13cmos5l_decap_4
XFILLER_70_77 VPWR VGND sg13cmos5l_decap_8
XFILLER_70_88 VPWR VGND sg13cmos5l_fill_2
XFILLER_617_35 VPWR VGND sg13cmos5l_decap_8
XFILLER_126_115 VPWR VGND sg13cmos5l_decap_8
XFILLER_186_77 VPWR VGND sg13cmos5l_fill_1
XFILLER_336_14 VPWR VGND sg13cmos5l_decap_8
XFILLER_531_112 VPWR VGND sg13cmos5l_decap_4
XFILLER_186_99 VPWR VGND sg13cmos5l_decap_8
XANTENNA__3147__X Tile_X0Y7_FrameData_O[17] VPWR VGND sg13cmos5l_antennanp
XFILLER_79_20 VPWR VGND sg13cmos5l_decap_8
XFILLER_483_42 VPWR VGND sg13cmos5l_decap_8
XFILLER_207_0 VPWR VGND sg13cmos5l_fill_2
XFILLER_79_31 VPWR VGND sg13cmos5l_fill_2
XFILLER_531_145 VPWR VGND sg13cmos5l_decap_8
XFILLER_79_75 VPWR VGND sg13cmos5l_decap_8
XANTENNA__2986__X Tile_X0Y8_FrameData_O[26] VPWR VGND sg13cmos5l_antennanp
XFILLER_484_200 VPWR VGND sg13cmos5l_decap_8
XFILLER_429_105 VPWR VGND sg13cmos5l_decap_8
XFILLER_633_56 VPWR VGND sg13cmos5l_decap_8
XFILLER_416_91 VPWR VGND sg13cmos5l_decap_8
XFILLER_95_216 VPWR VGND sg13cmos5l_fill_2
XFILLER_352_35 VPWR VGND sg13cmos5l_decap_8
XFILLER_135_70 VPWR VGND sg13cmos5l_decap_8
XFILLER_576_0 VPWR VGND sg13cmos5l_decap_8
XFILLER_48_121 VPWR VGND sg13cmos5l_decap_8
XFILLER_295_188 VPWR VGND sg13cmos5l_fill_1
XFILLER_236_200 VPWR VGND sg13cmos5l_decap_8
X_0160_ _0160_/X _4330_/X _4331_/X _0639_/Q VPWR VGND sg13cmos5l_mux2_1
XFILLER_502_49 VPWR VGND sg13cmos5l_decap_8
XFILLER_63_102 VPWR VGND sg13cmos5l_decap_8
XFILLER_221_28 VPWR VGND sg13cmos5l_decap_8
X_0091_ _3624_/A _4488_/X _4489_/X _2627_/Q VPWR VGND sg13cmos5l_mux2_1
XFILLER_151_80 VPWR VGND sg13cmos5l_decap_8
XANTENNA__3610__X Tile_X0Y9_S2BEG[4] VPWR VGND sg13cmos5l_antennanp
XFILLER_601_127 VPWR VGND sg13cmos5l_decap_8
XFILLER_63_179 VPWR VGND sg13cmos5l_decap_8
XFILLER_598_189 VPWR VGND sg13cmos5l_decap_8
XFILLER_658_42 VPWR VGND sg13cmos5l_decap_8
X_3850_ _3850_/X Tile_X0Y1_W1END[2] Tile_X0Y1_W6END[6] _3999_/X _3978_/X _1421_/Q
+ _1420_/Q VPWR VGND sg13cmos5l_mux4_1
XFILLER_658_75 VPWR VGND sg13cmos5l_decap_8
XFILLER_377_21 VPWR VGND sg13cmos5l_decap_8
X_2801_ Tile_X0Y3_E6BEG[11] _4191_/X VPWR VGND sg13cmos5l_buf_1
XFILLER_554_215 VPWR VGND sg13cmos5l_fill_2
X_3781_ _3781_/X Tile_X0Y0_W1END[1] Tile_X0Y0_W6END[5] _3871_/X _3860_/X _1175_/Q
+ _1174_/Q VPWR VGND sg13cmos5l_mux4_1
X_0993_ _0993_/Q Tile_X0Y0_FrameData[10] VGND VPWR Tile_X0Y9_FrameStrobe[1] latch
XFILLER_365_159 VPWR VGND sg13cmos5l_decap_8
X_2732_ _3880_/A3 VPWR VGND sg13cmos5l_tielo
XFILLER_527_35 VPWR VGND sg13cmos5l_decap_8
XFILLER_380_129 VPWR VGND sg13cmos5l_decap_8
XFILLER_172_210 VPWR VGND sg13cmos5l_fill_2
XFILLER_117_126 VPWR VGND sg13cmos5l_decap_8
X_2663_ _2663_/Q Tile_X0Y6_FrameData[0] VGND VPWR Tile_X0Y9_FrameStrobe[6] latch
XFILLER_674_63 VPWR VGND sg13cmos5l_decap_8
XFILLER_246_14 VPWR VGND sg13cmos5l_decap_8
XANTENNA__3057__X Tile_X0Y5_FrameData_O[16] VPWR VGND sg13cmos5l_antennanp
X_1614_ _1614_/Q Tile_X0Y2_FrameData[3] VGND VPWR Tile_X0Y9_FrameStrobe[5] latch
X_4402_ _4402_/X Tile_X0Y5_WW4END[1] AXI_M_SOC_RLAST _4452_/X _4430_/X _2299_/Q _2298_/Q
+ VPWR VGND sg13cmos5l_mux4_1
X_2594_ _2594_/Q Tile_X0Y6_FrameData[5] VGND VPWR Tile_X0Y9_FrameStrobe[4] latch
X_1545_ _1545_/Q Tile_X0Y2_FrameData[8] VGND VPWR Tile_X0Y9_FrameStrobe[3] latch
X_4333_ _4333_/X _3879_/X _3864_/X _3863_/X _3852_/X _1108_/Q _1107_/Q VPWR VGND sg13cmos5l_mux4_1
XANTENNA__2896__X Tile_X0Y6_FrameData_O[17] VPWR VGND sg13cmos5l_antennanp
XFILLER_609_216 VPWR VGND sg13cmos5l_fill_2
XFILLER_543_56 VPWR VGND sg13cmos5l_decap_8
XFILLER_690_62 VPWR VGND sg13cmos5l_decap_8
XFILLER_543_67 VPWR VGND sg13cmos5l_fill_1
XFILLER_140_140 VPWR VGND sg13cmos5l_decap_8
X_4264_ _4264_/X Tile_X0Y4_W2END[7] AXI_M_SOC_BRESP1 _4313_/X _4312_/X _2085_/Q _2084_/Q
+ VPWR VGND sg13cmos5l_mux4_1
XFILLER_543_78 VPWR VGND sg13cmos5l_decap_8
X_1476_ _1476_/Q Tile_X0Y2_FrameData[13] VGND VPWR Tile_X0Y9_FrameStrobe[1] latch
XFILLER_286_155 VPWR VGND sg13cmos5l_decap_8
XFILLER_262_35 VPWR VGND sg13cmos5l_decap_8
X_3215_ Tile_X0Y0_FrameStrobe_O[3] Tile_X0Y9_FrameStrobe[3] VPWR VGND sg13cmos5l_buf_1
X_0427_ _0427_/Q Tile_X0Y8_FrameData[20] VGND VPWR Tile_X0Y9_FrameStrobe[0] latch
X_4195_ _4195_/X Tile_X0Y4_W1END[0] Tile_X0Y4_W6END[4] _4348_/X _4300_/X _2181_/Q
+ _2180_/Q VPWR VGND sg13cmos5l_mux4_1
XFILLER_435_119 VPWR VGND sg13cmos5l_decap_8
X_3146_ Tile_X0Y7_FrameData_O[16] Tile_X0Y7_FrameData[16] VPWR VGND sg13cmos5l_buf_1
X_0358_ _0358_/Q Tile_X0Y7_FrameData[25] VGND VPWR Tile_X0Y9_FrameStrobe[6] latch
XFILLER_412_49 VPWR VGND sg13cmos5l_decap_8
XFILLER_39_176 VPWR VGND sg13cmos5l_decap_8
X_3077_ Tile_X0Y4_E2BEGb[3] _4267_/X VPWR VGND sg13cmos5l_buf_1
X_0289_ _0289_/Q Tile_X0Y7_FrameData[30] VGND VPWR Tile_X0Y9_FrameStrobe[4] latch
XFILLER_54_146 VPWR VGND sg13cmos5l_decap_8
XFILLER_388_207 VPWR VGND sg13cmos5l_decap_4
XANTENNA__3520__X Tile_X0Y1_E1BEG[2] VPWR VGND sg13cmos5l_antennanp
X_2028_ _2028_/Q Tile_X0Y4_FrameData[25] VGND VPWR Tile_X0Y9_FrameStrobe[3] latch
XFILLER_568_42 VPWR VGND sg13cmos5l_decap_8
XFILLER_287_21 VPWR VGND sg13cmos5l_decap_8
XFILLER_210_111 VPWR VGND sg13cmos5l_decap_8
XFILLER_545_204 VPWR VGND sg13cmos5l_decap_4
XFILLER_545_215 VPWR VGND sg13cmos5l_fill_2
XFILLER_356_126 VPWR VGND sg13cmos5l_decap_8
X_3979_ _3979_/X _3987_/X Tile_X0Y1_W6END[3] _3986_/X _3979_/A3 _1179_/Q _1426_/Q
+ VPWR VGND sg13cmos5l_mux4_1
XFILLER_287_98 VPWR VGND sg13cmos5l_decap_8
XFILLER_437_35 VPWR VGND sg13cmos5l_decap_8
XFILLER_40_36 VPWR VGND sg13cmos5l_decap_8
XFILLER_584_63 VPWR VGND sg13cmos5l_decap_8
XFILLER_40_47 VPWR VGND sg13cmos5l_fill_1
XFILLER_156_14 VPWR VGND sg13cmos5l_decap_8
XFILLER_200_7 VPWR VGND sg13cmos5l_decap_8
XFILLER_156_58 VPWR VGND sg13cmos5l_decap_8
XFILLER_123_107 VPWR VGND sg13cmos5l_decap_4
XFILLER_306_28 VPWR VGND sg13cmos5l_decap_8
XFILLER_116_181 VPWR VGND sg13cmos5l_fill_2
XFILLER_172_35 VPWR VGND sg13cmos5l_decap_8
XFILLER_426_119 VPWR VGND sg13cmos5l_decap_8
XFILLER_667_7 VPWR VGND sg13cmos5l_decap_8
XFILLER_292_158 VPWR VGND sg13cmos5l_decap_8
XFILLER_65_33 VPWR VGND sg13cmos5l_decap_8
XFILLER_45_102 VPWR VGND sg13cmos5l_decap_8
XFILLER_322_49 VPWR VGND sg13cmos5l_decap_8
XFILLER_45_113 VPWR VGND sg13cmos5l_fill_1
XFILLER_434_174 VPWR VGND sg13cmos5l_decap_4
XFILLER_402_60 VPWR VGND sg13cmos5l_fill_2
XANTENNA__3430__X Tile_X0Y4_FrameData_O[21] VPWR VGND sg13cmos5l_antennanp
XFILLER_60_105 VPWR VGND sg13cmos5l_decap_8
XFILLER_595_115 VPWR VGND sg13cmos5l_decap_4
XFILLER_478_42 VPWR VGND sg13cmos5l_fill_2
XFILLER_157_0 VPWR VGND sg13cmos5l_decap_8
XFILLER_436_2 VPWR VGND sg13cmos5l_fill_1
XFILLER_201_100 VPWR VGND sg13cmos5l_fill_1
XFILLER_198_162 VPWR VGND sg13cmos5l_decap_8
XFILLER_201_122 VPWR VGND sg13cmos5l_decap_8
XFILLER_197_21 VPWR VGND sg13cmos5l_decap_8
XFILLER_536_204 VPWR VGND sg13cmos5l_decap_4
XFILLER_347_148 VPWR VGND sg13cmos5l_decap_8
XFILLER_324_0 VPWR VGND sg13cmos5l_decap_8
XFILLER_628_56 VPWR VGND sg13cmos5l_decap_8
XFILLER_362_107 VPWR VGND sg13cmos5l_decap_8
XFILLER_347_35 VPWR VGND sg13cmos5l_decap_8
XFILLER_201_199 VPWR VGND sg13cmos5l_decap_8
XFILLER_494_63 VPWR VGND sg13cmos5l_decap_8
XFILLER_355_170 VPWR VGND sg13cmos5l_fill_1
XFILLER_504_112 VPWR VGND sg13cmos5l_decap_8
XFILLER_355_181 VPWR VGND sg13cmos5l_decap_8
XFILLER_303_207 VPWR VGND sg13cmos5l_decap_8
XFILLER_693_0 VPWR VGND sg13cmos5l_decap_8
XFILLER_644_77 VPWR VGND sg13cmos5l_decap_8
XFILLER_504_189 VPWR VGND sg13cmos5l_decap_8
XFILLER_363_34 VPWR VGND sg13cmos5l_decap_8
XFILLER_216_28 VPWR VGND sg13cmos5l_decap_8
XFILLER_107_192 VPWR VGND sg13cmos5l_decap_4
XFILLER_146_80 VPWR VGND sg13cmos5l_decap_4
XANTENNA__3605__X Tile_X0Y9_S1BEG[3] VPWR VGND sg13cmos5l_antennanp
XFILLER_146_91 VPWR VGND sg13cmos5l_decap_8
X_1330_ _1330_/Q Tile_X0Y1_FrameData[7] VGND VPWR Tile_X0Y9_FrameStrobe[4] latch
XFILLER_122_151 VPWR VGND sg13cmos5l_decap_4
XFILLER_660_21 VPWR VGND sg13cmos5l_decap_8
X_1261_ _1261_/Q Tile_X0Y1_FrameData[12] VGND VPWR Tile_X0Y9_FrameStrobe[2] latch
XFILLER_417_119 VPWR VGND sg13cmos5l_decap_8
XFILLER_209_211 VPWR VGND sg13cmos5l_fill_1
X_3000_ Tile_X0Y5_E2BEG[3] _4375_/X VPWR VGND sg13cmos5l_buf_1
X_0212_ _0212_/Q Tile_X0Y7_FrameData[11] VGND VPWR Tile_X0Y9_FrameStrobe[1] latch
XFILLER_283_147 VPWR VGND sg13cmos5l_decap_8
XFILLER_232_27 VPWR VGND sg13cmos5l_decap_8
XFILLER_660_98 VPWR VGND sg13cmos5l_decap_8
X_1192_ _1192_/Q Tile_X0Y1_FrameData[17] VGND VPWR Tile_X0Y9_FrameStrobe[0] latch
X_0143_ _0143_/X _4435_/X _4436_/X _1363_/Q VPWR VGND sg13cmos5l_mux2_1
XANTENNA__3340__X Tile_X0Y2_FrameData_O[11] VPWR VGND sg13cmos5l_antennanp
X_0074_ _0074_/X _4798_/X _4799_/X _2110_/Q VPWR VGND sg13cmos5l_mux2_1
XFILLER_669_85 VPWR VGND sg13cmos5l_decap_8
XFILLER_586_148 VPWR VGND sg13cmos5l_fill_2
XFILLER_189_140 VPWR VGND sg13cmos5l_decap_4
X_3902_ _3902_/X Tile_X0Y2_W2MID[0] Tile_X0Y2_W2END[0] Tile_X0Y2_W6END[0] _4096_/X
+ _1651_/Q _1650_/Q VPWR VGND sg13cmos5l_mux4_1
X_4882_ _4882_/X Tile_X0Y9_N4END[2] _0081_/X _4925_/X _4929_/X _0779_/Q _0778_/Q VPWR
+ VGND sg13cmos5l_mux4_1
XFILLER_388_64 VPWR VGND sg13cmos5l_fill_2
X_3833_ _3833_/X Tile_X0Y0_WW4END[2] _3883_/X _3857_/X _3880_/X _1039_/Q _1038_/Q
+ VPWR VGND sg13cmos5l_mux4_1
XFILLER_338_126 VPWR VGND sg13cmos5l_decap_8
XFILLER_594_181 VPWR VGND sg13cmos5l_decap_8
XFILLER_338_137 VPWR VGND sg13cmos5l_fill_1
XFILLER_338_159 VPWR VGND sg13cmos5l_decap_8
X_0976_ _0976_/Q Tile_X0Y0_FrameData[27] VGND VPWR Tile_X0Y9_FrameStrobe[1] latch
X_3764_ _3764_/X Tile_X0Y1_WW4END[5] Tile_X0Y1_WW4END[13] Tile_X0Y1_W6END[5] _4013_/X
+ _1247_/Q _1246_/Q VPWR VGND sg13cmos5l_mux4_1
XFILLER_72_0 VPWR VGND sg13cmos5l_decap_8
XFILLER_542_207 VPWR VGND sg13cmos5l_fill_2
XFILLER_145_210 VPWR VGND sg13cmos5l_decap_8
X_2715_ _4416_/A3 VPWR VGND sg13cmos5l_tielo
X_3695_ AXI_M_SOC_WDATA5 Tile_X0Y7_WW4END[5] Tile_X0Y7_WW4END[13] Tile_X0Y7_W6END[5]
+ _4689_/X _0237_/Q _0236_/Q VPWR VGND sg13cmos5l_mux4_1
X_2646_ _2646_/Q Tile_X0Y6_FrameData[17] VGND VPWR Tile_X0Y9_FrameStrobe[6] latch
XFILLER_10_28 VPWR VGND sg13cmos5l_decap_8
XFILLER_337_90 VPWR VGND sg13cmos5l_decap_4
XFILLER_554_77 VPWR VGND sg13cmos5l_decap_8
XFILLER_126_28 VPWR VGND sg13cmos5l_decap_8
X_2577_ _2577_/Q Tile_X0Y6_FrameData[22] VGND VPWR Tile_X0Y9_FrameStrobe[4] latch
XFILLER_704_14 VPWR VGND sg13cmos5l_decap_8
XFILLER_510_137 VPWR VGND sg13cmos5l_decap_8
XFILLER_448_200 VPWR VGND sg13cmos5l_decap_8
XFILLER_273_56 VPWR VGND sg13cmos5l_decap_8
XANTENNA__3515__X Tile_X0Y1_E2BEG[5] VPWR VGND sg13cmos5l_antennanp
X_4316_ _4316_/X _4247_/X _4363_/X _4362_/X _4246_/X _1939_/Q _1938_/Q VPWR VGND sg13cmos5l_mux4_1
XFILLER_649_182 VPWR VGND sg13cmos5l_decap_8
XFILLER_259_133 VPWR VGND sg13cmos5l_fill_2
X_1528_ _1528_/Q Tile_X0Y2_FrameData[25] VGND VPWR Tile_X0Y9_FrameStrobe[3] latch
XFILLER_59_216 VPWR VGND sg13cmos5l_fill_2
XFILLER_570_21 VPWR VGND sg13cmos5l_decap_8
X_1459_ _1459_/Q Tile_X0Y2_FrameData[30] VGND VPWR Tile_X0Y9_FrameStrobe[1] latch
X_4247_ _4247_/X Tile_X0Y5_W2MID[2] Tile_X0Y5_W2END[2] Tile_X0Y5_W6END[2] _4431_/X
+ _2421_/Q _2420_/Q VPWR VGND sg13cmos5l_mux4_1
XFILLER_664_163 VPWR VGND sg13cmos5l_decap_8
XFILLER_206_83 VPWR VGND sg13cmos5l_decap_8
XFILLER_74_208 VPWR VGND sg13cmos5l_decap_8
XFILLER_274_147 VPWR VGND sg13cmos5l_decap_8
X_4178_ _4178_/X Tile_X0Y3_WW4END[1] AXI_M_SOC_BVALID _4223_/X _4207_/X _1785_/Q _1784_/Q
+ VPWR VGND sg13cmos5l_mux4_1
XFILLER_570_98 VPWR VGND sg13cmos5l_decap_8
XFILLER_142_49 VPWR VGND sg13cmos5l_fill_1
XFILLER_503_70 VPWR VGND sg13cmos5l_decap_8
XFILLER_416_141 VPWR VGND sg13cmos5l_decap_4
XFILLER_27_135 VPWR VGND sg13cmos5l_fill_1
X_3129_ Tile_X0Y7_EE4BEG[15] _4643_/X VPWR VGND sg13cmos5l_buf_1
XFILLER_215_214 VPWR VGND sg13cmos5l_decap_4
XANTENNA__3250__X Tile_X0Y0_FrameData_O[18] VPWR VGND sg13cmos5l_antennanp
XFILLER_35_14 VPWR VGND sg13cmos5l_decap_8
XFILLER_282_180 VPWR VGND sg13cmos5l_fill_2
XFILLER_27_157 VPWR VGND sg13cmos5l_fill_2
XFILLER_579_63 VPWR VGND sg13cmos5l_decap_8
XFILLER_577_126 VPWR VGND sg13cmos5l_decap_8
XFILLER_298_42 VPWR VGND sg13cmos5l_decap_8
XFILLER_230_217 VPWR VGND sg13cmos5l_fill_1
XFILLER_150_7 VPWR VGND sg13cmos5l_decap_8
XFILLER_248_7 VPWR VGND sg13cmos5l_decap_8
XFILLER_51_13 VPWR VGND sg13cmos5l_fill_2
XFILLER_195_132 VPWR VGND sg13cmos5l_fill_1
XFILLER_195_154 VPWR VGND sg13cmos5l_fill_1
XFILLER_415_7 VPWR VGND sg13cmos5l_decap_8
XFILLER_533_207 VPWR VGND sg13cmos5l_decap_8
XFILLER_595_95 VPWR VGND sg13cmos5l_fill_1
XFILLER_167_57 VPWR VGND sg13cmos5l_fill_1
XFILLER_167_79 VPWR VGND sg13cmos5l_fill_1
XFILLER_498_133 VPWR VGND sg13cmos5l_decap_8
XFILLER_151_202 VPWR VGND sg13cmos5l_decap_8
XFILLER_317_49 VPWR VGND sg13cmos5l_decap_4
XFILLER_352_173 VPWR VGND sg13cmos5l_decap_4
XFILLER_352_184 VPWR VGND sg13cmos5l_decap_8
XFILLER_297_217 VPWR VGND sg13cmos5l_fill_1
XFILLER_614_14 VPWR VGND sg13cmos5l_decap_8
XFILLER_501_126 VPWR VGND sg13cmos5l_decap_8
XFILLER_464_88 VPWR VGND sg13cmos5l_decap_8
XFILLER_647_119 VPWR VGND sg13cmos5l_decap_8
XANTENNA__3425__X Tile_X0Y4_FrameData_O[16] VPWR VGND sg13cmos5l_antennanp
XFILLER_480_21 VPWR VGND sg13cmos5l_decap_8
XFILLER_76_21 VPWR VGND sg13cmos5l_decap_8
XFILLER_116_83 VPWR VGND sg13cmos5l_decap_8
XFILLER_480_65 VPWR VGND sg13cmos5l_fill_1
XFILLER_265_125 VPWR VGND sg13cmos5l_fill_1
XFILLER_265_147 VPWR VGND sg13cmos5l_decap_4
XFILLER_630_35 VPWR VGND sg13cmos5l_decap_8
XFILLER_413_70 VPWR VGND sg13cmos5l_decap_8
XFILLER_407_141 VPWR VGND sg13cmos5l_decap_8
XFILLER_76_98 VPWR VGND sg13cmos5l_decap_8
XFILLER_274_0 VPWR VGND sg13cmos5l_decap_8
XFILLER_18_124 VPWR VGND sg13cmos5l_decap_8
XFILLER_670_188 VPWR VGND sg13cmos5l_decap_8
XFILLER_273_180 VPWR VGND sg13cmos5l_decap_8
XANTENNA__3160__X Tile_X0Y7_FrameData_O[30] VPWR VGND sg13cmos5l_antennanp
XFILLER_670_199 VPWR VGND sg13cmos5l_fill_2
XFILLER_273_191 VPWR VGND sg13cmos5l_fill_2
XFILLER_568_126 VPWR VGND sg13cmos5l_decap_8
XFILLER_489_63 VPWR VGND sg13cmos5l_decap_8
XFILLER_422_144 VPWR VGND sg13cmos5l_fill_2
XFILLER_441_0 VPWR VGND sg13cmos5l_decap_8
XFILLER_33_138 VPWR VGND sg13cmos5l_decap_4
XFILLER_539_0 VPWR VGND sg13cmos5l_decap_8
XFILLER_33_149 VPWR VGND sg13cmos5l_decap_8
XFILLER_639_77 VPWR VGND sg13cmos5l_decap_8
XFILLER_375_210 VPWR VGND sg13cmos5l_decap_8
XFILLER_25_91 VPWR VGND sg13cmos5l_decap_4
XFILLER_706_0 VPWR VGND sg13cmos5l_decap_8
XFILLER_358_56 VPWR VGND sg13cmos5l_decap_8
X_0830_ _0830_/Q Tile_X0Y9_FrameData[1] VGND VPWR Tile_X0Y9_FrameStrobe[4] latch
XFILLER_591_151 VPWR VGND sg13cmos5l_fill_2
XFILLER_655_21 VPWR VGND sg13cmos5l_decap_8
X_0761_ _0761_/Q Tile_X0Y9_FrameData[6] VGND VPWR Tile_X0Y9_FrameStrobe[2] latch
XFILLER_328_192 VPWR VGND sg13cmos5l_fill_2
X_2500_ _2500_/Q Tile_X0Y6_FrameData[3] VGND VPWR Tile_X0Y9_FrameStrobe[1] latch
XFILLER_489_122 VPWR VGND sg13cmos5l_decap_4
XFILLER_227_27 VPWR VGND sg13cmos5l_decap_8
X_3480_ Tile_X0Y1_EE4BEG[6] _3954_/X VPWR VGND sg13cmos5l_buf_1
X_0692_ _0692_/Q Tile_X0Y9_FrameData[11] VGND VPWR Tile_X0Y9_FrameStrobe[0] latch
XFILLER_655_98 VPWR VGND sg13cmos5l_decap_8
X_2431_ _2431_/Q Tile_X0Y5_FrameData[6] VGND VPWR Tile_X0Y9_FrameStrobe[7] latch
XFILLER_343_184 VPWR VGND sg13cmos5l_decap_8
XFILLER_489_177 VPWR VGND sg13cmos5l_decap_8
XFILLER_638_119 VPWR VGND sg13cmos5l_decap_8
XFILLER_524_14 VPWR VGND sg13cmos5l_decap_8
XFILLER_374_99 VPWR VGND sg13cmos5l_decap_8
XANTENNA__3335__X Tile_X0Y2_FrameData_O[6] VPWR VGND sg13cmos5l_antennanp
XFILLER_671_42 VPWR VGND sg13cmos5l_decap_8
X_2362_ _2362_/Q Tile_X0Y5_FrameData[11] VGND VPWR Tile_X0Y9_FrameStrobe[5] latch
XFILLER_390_21 VPWR VGND sg13cmos5l_decap_8
X_1313_ _1313_/Q Tile_X0Y1_FrameData[24] VGND VPWR Tile_X0Y9_FrameStrobe[4] latch
X_4101_ _4101_/X _4025_/X _4133_/X _4132_/X _4024_/X _1445_/Q _1444_/Q VPWR VGND sg13cmos5l_mux4_1
XFILLER_256_103 VPWR VGND sg13cmos5l_decap_8
X_2293_ _2293_/Q Tile_X0Y5_FrameData[16] VGND VPWR Tile_X0Y9_FrameStrobe[3] latch
XFILLER_445_214 VPWR VGND sg13cmos5l_decap_4
X_4032_ _4032_/X Tile_X0Y0_W1END[2] Tile_X0Y0_W2MID[1] Tile_X0Y0_W2END[1] _3854_/X
+ _1121_/Q _1120_/Q VPWR VGND sg13cmos5l_mux4_1
XFILLER_646_196 VPWR VGND sg13cmos5l_decap_8
XFILLER_604_91 VPWR VGND sg13cmos5l_decap_8
X_1244_ _1244_/Q Tile_X0Y1_FrameData[29] VGND VPWR Tile_X0Y9_FrameStrobe[2] latch
XFILLER_256_158 VPWR VGND sg13cmos5l_decap_8
XFILLER_540_35 VPWR VGND sg13cmos5l_decap_8
XFILLER_2_84 VPWR VGND sg13cmos5l_fill_2
XFILLER_540_57 VPWR VGND sg13cmos5l_fill_1
XFILLER_2_95 VPWR VGND sg13cmos5l_decap_8
X_1175_ _1175_/Q Tile_X0Y0_FrameData[20] VGND VPWR Tile_X0Y9_FrameStrobe[7] latch
XANTENNA__3070__X Tile_X0Y5_FrameData_O[29] VPWR VGND sg13cmos5l_antennanp
XFILLER_661_199 VPWR VGND sg13cmos5l_fill_2
XFILLER_264_191 VPWR VGND sg13cmos5l_fill_2
X_0126_ _3188_/A _3792_/X _3793_/X _1151_/Q VPWR VGND sg13cmos5l_mux2_1
XFILLER_212_217 VPWR VGND sg13cmos5l_fill_1
X_0057_ _0057_/X _4111_/X _4112_/X _2663_/Q VPWR VGND sg13cmos5l_mux2_1
X_4934_ _4934_/X Tile_X0Y8_W2MID[5] Tile_X0Y8_W2END[5] Tile_X0Y8_W6END[10] _4789_/X
+ _0623_/Q _0622_/Q VPWR VGND sg13cmos5l_mux4_1
XFILLER_574_129 VPWR VGND sg13cmos5l_decap_8
XFILLER_716_101 VPWR VGND sg13cmos5l_decap_4
XFILLER_567_170 VPWR VGND sg13cmos5l_decap_8
XFILLER_549_77 VPWR VGND sg13cmos5l_decap_8
X_4865_ _4865_/X Tile_X0Y9_WW4END[14] AXI_M_SOC_RDATA1 _4930_/X _4902_/X _0813_/Q
+ _0812_/Q VPWR VGND sg13cmos5l_mux4_1
XANTENNA_12 AXI_M_SOC_WREADY VPWR VGND sg13cmos5l_antennanp
XANTENNA_23 AXI_M_SOC_WREADY VPWR VGND sg13cmos5l_antennanp
XFILLER_268_56 VPWR VGND sg13cmos5l_decap_8
XANTENNA_34 AXI_M_SOC_WREADY VPWR VGND sg13cmos5l_antennanp
XFILLER_716_145 VPWR VGND sg13cmos5l_decap_8
X_3816_ _3816_/X Tile_X0Y0_W2END[3] Tile_X0Y0_WW4END[10] _3859_/X _3858_/X _1073_/Q
+ _1072_/Q VPWR VGND sg13cmos5l_mux4_1
XANTENNA_45 Tile_X0Y0_S2MID[4] VPWR VGND sg13cmos5l_antennanp
XFILLER_326_107 VPWR VGND sg13cmos5l_decap_4
XANTENNA_56 Tile_X0Y5_W2END[5] VPWR VGND sg13cmos5l_antennanp
X_4796_ _4796_/X Tile_X0Y4_W1END[2] Tile_X0Y4_WW4END[14] Tile_X0Y4_W6END[6] _4338_/X
+ _2115_/Q _2114_/Q VPWR VGND sg13cmos5l_mux4_1
XANTENNA_67 Tile_X0Y9_FrameStrobe[18] VPWR VGND sg13cmos5l_antennanp
XFILLER_565_21 VPWR VGND sg13cmos5l_decap_8
XANTENNA_78 Tile_X0Y9_N2MID[4] VPWR VGND sg13cmos5l_antennanp
XFILLER_319_170 VPWR VGND sg13cmos5l_decap_8
X_3747_ AXI_M_SOC_ARADDR19 Tile_X0Y8_WW4END[3] Tile_X0Y8_WW4END[11] Tile_X0Y8_W6END[3]
+ _4803_/X _0497_/Q _0496_/Q VPWR VGND sg13cmos5l_mux4_1
X_0959_ _0959_/Q Tile_X0Y0_FrameData[12] VGND VPWR Tile_X0Y9_FrameStrobe[0] latch
XFILLER_21_49 VPWR VGND sg13cmos5l_fill_2
XFILLER_715_13 VPWR VGND sg13cmos5l_decap_8
XFILLER_565_98 VPWR VGND sg13cmos5l_decap_8
X_3678_ _3678_/X Tile_X0Y2_WW4END[0] Tile_X0Y2_WW4END[8] Tile_X0Y2_W6END[8] _4124_/X
+ _1489_/Q _1488_/Q VPWR VGND sg13cmos5l_mux4_1
XFILLER_137_49 VPWR VGND sg13cmos5l_decap_8
XFILLER_284_77 VPWR VGND sg13cmos5l_decap_8
X_2629_ _2629_/Q Tile_X0Y6_FrameData[2] VGND VPWR Tile_X0Y9_FrameStrobe[5] latch
XFILLER_434_14 VPWR VGND sg13cmos5l_decap_8
XANTENNA__3245__X Tile_X0Y0_FrameData_O[13] VPWR VGND sg13cmos5l_antennanp
XFILLER_581_42 VPWR VGND sg13cmos5l_decap_8
XFILLER_495_147 VPWR VGND sg13cmos5l_decap_8
XFILLER_581_64 VPWR VGND sg13cmos5l_decap_8
XFILLER_99_171 VPWR VGND sg13cmos5l_fill_1
XFILLER_101_121 VPWR VGND sg13cmos5l_decap_4
XFILLER_198_7 VPWR VGND sg13cmos5l_decap_8
XFILLER_637_185 VPWR VGND sg13cmos5l_decap_4
XFILLER_652_133 VPWR VGND sg13cmos5l_decap_8
XFILLER_46_13 VPWR VGND sg13cmos5l_decap_4
XFILLER_450_35 VPWR VGND sg13cmos5l_decap_8
XFILLER_247_169 VPWR VGND sg13cmos5l_decap_8
XFILLER_262_117 VPWR VGND sg13cmos5l_decap_8
XFILLER_46_46 VPWR VGND sg13cmos5l_decap_8
XFILLER_365_7 VPWR VGND sg13cmos5l_decap_8
XFILLER_600_49 VPWR VGND sg13cmos5l_decap_8
XFILLER_270_150 VPWR VGND sg13cmos5l_decap_8
XFILLER_270_172 VPWR VGND sg13cmos5l_decap_8
XFILLER_532_7 VPWR VGND sg13cmos5l_decap_8
XFILLER_102_63 VPWR VGND sg13cmos5l_decap_8
XFILLER_357_210 VPWR VGND sg13cmos5l_decap_8
XFILLER_168_110 VPWR VGND sg13cmos5l_fill_2
XFILLER_558_170 VPWR VGND sg13cmos5l_decap_8
XFILLER_178_23 VPWR VGND sg13cmos5l_decap_8
XFILLER_707_112 VPWR VGND sg13cmos5l_decap_8
XFILLER_609_14 VPWR VGND sg13cmos5l_decap_8
XFILLER_168_132 VPWR VGND sg13cmos5l_decap_4
XFILLER_573_140 VPWR VGND sg13cmos5l_decap_8
XFILLER_168_165 VPWR VGND sg13cmos5l_decap_8
XFILLER_178_89 VPWR VGND sg13cmos5l_decap_8
XFILLER_475_21 VPWR VGND sg13cmos5l_decap_8
XFILLER_328_59 VPWR VGND sg13cmos5l_decap_8
XFILLER_183_179 VPWR VGND sg13cmos5l_decap_8
XFILLER_625_35 VPWR VGND sg13cmos5l_decap_8
XFILLER_194_77 VPWR VGND sg13cmos5l_decap_8
XFILLER_344_14 VPWR VGND sg13cmos5l_decap_8
XFILLER_340_143 VPWR VGND sg13cmos5l_decap_8
XFILLER_2_0 VPWR VGND sg13cmos5l_decap_8
XANTENNA__3155__X Tile_X0Y7_FrameData_O[25] VPWR VGND sg13cmos5l_antennanp
XFILLER_491_42 VPWR VGND sg13cmos5l_decap_8
XFILLER_486_136 VPWR VGND sg13cmos5l_decap_8
XFILLER_87_53 VPWR VGND sg13cmos5l_decap_8
XFILLER_391_0 VPWR VGND sg13cmos5l_decap_8
XFILLER_489_0 VPWR VGND sg13cmos5l_decap_8
XFILLER_690_217 VPWR VGND sg13cmos5l_fill_1
XANTENNA__2994__X Tile_X0Y5_E1BEG[1] VPWR VGND sg13cmos5l_antennanp
XFILLER_238_125 VPWR VGND sg13cmos5l_decap_8
XFILLER_641_56 VPWR VGND sg13cmos5l_decap_8
XFILLER_424_91 VPWR VGND sg13cmos5l_decap_8
XFILLER_643_133 VPWR VGND sg13cmos5l_decap_8
XFILLER_360_35 VPWR VGND sg13cmos5l_decap_8
XFILLER_143_70 VPWR VGND sg13cmos5l_decap_8
XFILLER_656_0 VPWR VGND sg13cmos5l_decap_8
XFILLER_253_106 VPWR VGND sg13cmos5l_decap_8
XFILLER_442_217 VPWR VGND sg13cmos5l_fill_1
XFILLER_643_199 VPWR VGND sg13cmos5l_fill_2
XFILLER_510_49 VPWR VGND sg13cmos5l_decap_8
XFILLER_261_161 VPWR VGND sg13cmos5l_decap_8
X_2980_ Tile_X0Y8_FrameData_O[20] Tile_X0Y8_FrameData[20] VPWR VGND sg13cmos5l_buf_1
XFILLER_261_194 VPWR VGND sg13cmos5l_fill_1
XFILLER_348_210 VPWR VGND sg13cmos5l_fill_2
XFILLER_159_110 VPWR VGND sg13cmos5l_fill_1
XFILLER_369_77 VPWR VGND sg13cmos5l_decap_4
X_1931_ _1931_/Q Tile_X0Y4_FrameData[26] VGND VPWR Tile_X0Y9_FrameStrobe[0] latch
XFILLER_519_14 VPWR VGND sg13cmos5l_decap_8
XFILLER_410_169 VPWR VGND sg13cmos5l_decap_4
XFILLER_666_42 VPWR VGND sg13cmos5l_decap_8
X_4650_ _4650_/X AXI_M_SOC_RDATA18 _4689_/X _4693_/X _4673_/X _0259_/Q _0258_/Q VPWR
+ VGND sg13cmos5l_mux4_1
X_1862_ _1862_/Q Tile_X0Y3_FrameData[3] VGND VPWR Tile_X0Y9_FrameStrobe[5] latch
XFILLER_385_21 VPWR VGND sg13cmos5l_decap_8
X_3601_ Tile_X0Y9_FrameData_O[31] Tile_X0Y9_FrameData[31] VPWR VGND sg13cmos5l_buf_1
X_0813_ _0813_/Q Tile_X0Y9_FrameData[18] VGND VPWR Tile_X0Y9_FrameStrobe[4] latch
XFILLER_174_146 VPWR VGND sg13cmos5l_decap_4
XFILLER_713_126 VPWR VGND sg13cmos5l_decap_8
X_1793_ _1793_/Q Tile_X0Y3_FrameData[8] VGND VPWR Tile_X0Y9_FrameStrobe[3] latch
X_4581_ _4581_/X _4547_/X Tile_X0Y9_N4END[13] _4546_/X _0153_/X _2469_/Q _2468_/Q
+ VPWR VGND sg13cmos5l_mux4_1
X_3532_ Tile_X0Y9_E2BEG[6] _4854_/X VPWR VGND sg13cmos5l_buf_1
X_0744_ _0744_/Q Tile_X0Y9_FrameData[23] VGND VPWR Tile_X0Y9_FrameStrobe[2] latch
XFILLER_535_35 VPWR VGND sg13cmos5l_decap_8
XFILLER_682_63 VPWR VGND sg13cmos5l_decap_8
XFILLER_254_14 VPWR VGND sg13cmos5l_decap_8
X_0675_ _0675_/Q Tile_X0Y9_FrameData[28] VGND VPWR Tile_X0Y9_FrameStrobe[0] latch
X_3463_ Tile_X0Y1_FrameData_O[21] Tile_X0Y1_FrameData[21] VPWR VGND sg13cmos5l_buf_1
XFILLER_666_214 VPWR VGND sg13cmos5l_decap_4
XANTENNA__3065__X Tile_X0Y5_FrameData_O[24] VPWR VGND sg13cmos5l_antennanp
X_2414_ _2414_/Q Tile_X0Y5_FrameData[23] VGND VPWR Tile_X0Y9_FrameStrobe[7] latch
XFILLER_477_158 VPWR VGND sg13cmos5l_decap_8
X_3394_ Tile_X0Y2_E2BEGb[5] _4053_/X VPWR VGND sg13cmos5l_buf_1
XFILLER_35_0 VPWR VGND sg13cmos5l_decap_8
XFILLER_404_28 VPWR VGND sg13cmos5l_decap_8
X_2345_ _2345_/Q Tile_X0Y5_FrameData[28] VGND VPWR Tile_X0Y9_FrameStrobe[5] latch
XFILLER_96_185 VPWR VGND sg13cmos5l_decap_8
X_2276_ _2276_/Q Tile_X0Y5_FrameData[1] VGND VPWR Tile_X0Y9_FrameStrobe[2] latch
XFILLER_634_133 VPWR VGND sg13cmos5l_fill_1
XFILLER_551_78 VPWR VGND sg13cmos5l_decap_8
XFILLER_270_35 VPWR VGND sg13cmos5l_decap_8
XFILLER_634_155 VPWR VGND sg13cmos5l_fill_1
X_1227_ _1227_/Q Tile_X0Y1_FrameData[14] VGND VPWR Tile_X0Y9_FrameStrobe[1] latch
X_4015_ _4015_/X _3987_/X _0084_/X _3986_/X Tile_X0Y0_S4END[7] _1219_/Q _1218_/Q VPWR
+ VGND sg13cmos5l_mux4_1
XFILLER_634_177 VPWR VGND sg13cmos5l_decap_4
XFILLER_433_217 VPWR VGND sg13cmos5l_fill_1
XFILLER_634_188 VPWR VGND sg13cmos5l_decap_4
XFILLER_237_191 VPWR VGND sg13cmos5l_decap_8
X_1158_ _1158_/Q Tile_X0Y0_FrameData[5] VGND VPWR Tile_X0Y9_FrameStrobe[6] latch
XFILLER_420_49 VPWR VGND sg13cmos5l_decap_8
XFILLER_203_84 VPWR VGND sg13cmos5l_decap_8
XFILLER_16_49 VPWR VGND sg13cmos5l_decap_8
X_0109_ _0109_/X _4332_/X _4333_/X _1106_/Q VPWR VGND sg13cmos5l_mux2_1
XFILLER_252_172 VPWR VGND sg13cmos5l_decap_4
X_1089_ _1089_/Q Tile_X0Y0_FrameData[10] VGND VPWR Tile_X0Y9_FrameStrobe[4] latch
XFILLER_398_176 VPWR VGND sg13cmos5l_decap_8
XFILLER_547_118 VPWR VGND sg13cmos5l_decap_8
XFILLER_279_55 VPWR VGND sg13cmos5l_decap_8
XFILLER_547_129 VPWR VGND sg13cmos5l_fill_2
X_4917_ _4917_/X Tile_X0Y9_N1END[1] Tile_X0Y9_N4END[1] _4897_/X _0082_/X _0725_/Q
+ _0724_/Q VPWR VGND sg13cmos5l_mux4_1
XFILLER_429_14 VPWR VGND sg13cmos5l_decap_8
XFILLER_576_42 VPWR VGND sg13cmos5l_decap_8
X_4848_ _4848_/X Tile_X0Y9_W2MID[7] AXI_M_SOC_RDATA0 _4901_/X _4900_/X _0847_/Q _0846_/Q
+ VPWR VGND sg13cmos5l_mux4_1
XFILLER_354_202 VPWR VGND sg13cmos5l_decap_4
XFILLER_32_48 VPWR VGND sg13cmos5l_decap_8
XFILLER_295_21 VPWR VGND sg13cmos5l_decap_8
XFILLER_32_59 VPWR VGND sg13cmos5l_fill_2
XFILLER_704_126 VPWR VGND sg13cmos5l_decap_8
X_4779_ _4779_/X Tile_X0Y9_W1END[1] Tile_X0Y9_W6END[5] _4929_/X _4893_/X _0925_/Q
+ _0924_/Q VPWR VGND sg13cmos5l_mux4_1
XFILLER_165_168 VPWR VGND sg13cmos5l_decap_4
XFILLER_570_154 VPWR VGND sg13cmos5l_decap_8
XFILLER_113_7 VPWR VGND sg13cmos5l_decap_8
XFILLER_295_98 VPWR VGND sg13cmos5l_decap_8
XFILLER_445_35 VPWR VGND sg13cmos5l_decap_8
XFILLER_180_149 VPWR VGND sg13cmos5l_fill_2
XFILLER_322_121 VPWR VGND sg13cmos5l_decap_8
XFILLER_228_92 VPWR VGND sg13cmos5l_decap_8
XFILLER_164_14 VPWR VGND sg13cmos5l_decap_8
XFILLER_712_192 VPWR VGND sg13cmos5l_fill_1
XFILLER_164_47 VPWR VGND sg13cmos5l_decap_8
XFILLER_322_165 VPWR VGND sg13cmos5l_decap_8
XFILLER_121_216 VPWR VGND sg13cmos5l_fill_2
XFILLER_87_130 VPWR VGND sg13cmos5l_fill_1
XFILLER_482_7 VPWR VGND sg13cmos5l_decap_8
XFILLER_314_28 VPWR VGND sg13cmos5l_decap_8
XFILLER_625_100 VPWR VGND sg13cmos5l_fill_1
XFILLER_87_152 VPWR VGND sg13cmos5l_decap_8
XFILLER_476_180 VPWR VGND sg13cmos5l_decap_8
XANTENNA__3703__X AXI_M_SOC_WDATA13 VPWR VGND sg13cmos5l_antennanp
XFILLER_180_13 VPWR VGND sg13cmos5l_decap_8
XFILLER_57_67 VPWR VGND sg13cmos5l_decap_8
XFILLER_424_206 VPWR VGND sg13cmos5l_fill_2
XFILLER_228_191 VPWR VGND sg13cmos5l_decap_8
XFILLER_640_147 VPWR VGND sg13cmos5l_decap_8
XFILLER_330_49 VPWR VGND sg13cmos5l_decap_8
XFILLER_260_90 VPWR VGND sg13cmos5l_decap_4
XFILLER_73_44 VPWR VGND sg13cmos5l_fill_1
XFILLER_113_95 VPWR VGND sg13cmos5l_decap_8
XFILLER_73_66 VPWR VGND sg13cmos5l_decap_8
XFILLER_251_2 VPWR VGND sg13cmos5l_fill_1
XFILLER_189_77 VPWR VGND sg13cmos5l_decap_8
XFILLER_339_14 VPWR VGND sg13cmos5l_decap_8
XFILLER_486_42 VPWR VGND sg13cmos5l_decap_8
XFILLER_237_0 VPWR VGND sg13cmos5l_decap_8
XFILLER_546_162 VPWR VGND sg13cmos5l_decap_4
XFILLER_561_121 VPWR VGND sg13cmos5l_fill_1
XANTENNA__2989__X Tile_X0Y8_FrameData_O[29] VPWR VGND sg13cmos5l_antennanp
XFILLER_561_132 VPWR VGND sg13cmos5l_fill_2
XFILLER_404_0 VPWR VGND sg13cmos5l_decap_8
XFILLER_156_168 VPWR VGND sg13cmos5l_decap_4
XFILLER_636_56 VPWR VGND sg13cmos5l_decap_8
XFILLER_419_91 VPWR VGND sg13cmos5l_decap_8
XFILLER_360_216 VPWR VGND sg13cmos5l_fill_2
XFILLER_561_176 VPWR VGND sg13cmos5l_fill_1
XFILLER_355_35 VPWR VGND sg13cmos5l_decap_8
XFILLER_138_70 VPWR VGND sg13cmos5l_decap_8
XFILLER_502_210 VPWR VGND sg13cmos5l_decap_8
XFILLER_313_110 VPWR VGND sg13cmos5l_decap_8
XFILLER_648_203 VPWR VGND sg13cmos5l_decap_8
XFILLER_98_63 VPWR VGND sg13cmos5l_decap_8
XFILLER_459_136 VPWR VGND sg13cmos5l_decap_8
XFILLER_459_147 VPWR VGND sg13cmos5l_fill_2
X_0460_ _0460_/Q Tile_X0Y8_FrameData[19] VGND VPWR Tile_X0Y9_FrameStrobe[1] latch
XFILLER_505_49 VPWR VGND sg13cmos5l_decap_8
XFILLER_313_187 VPWR VGND sg13cmos5l_decap_8
XFILLER_652_77 VPWR VGND sg13cmos5l_decap_8
XFILLER_224_28 VPWR VGND sg13cmos5l_decap_8
X_0391_ _0391_/Q Tile_X0Y7_FrameData[24] VGND VPWR Tile_X0Y9_FrameStrobe[7] latch
XANTENNA__3613__X Tile_X0Y9_S2BEG[7] VPWR VGND sg13cmos5l_antennanp
X_2130_ _2130_/Q Tile_X0Y4_FrameData[19] VGND VPWR Tile_X0Y9_FrameStrobe[6] latch
XFILLER_415_206 VPWR VGND sg13cmos5l_fill_1
XFILLER_226_106 VPWR VGND sg13cmos5l_decap_4
XFILLER_415_217 VPWR VGND sg13cmos5l_fill_1
XFILLER_226_117 VPWR VGND sg13cmos5l_fill_1
X_2061_ _2061_/Q Tile_X0Y4_FrameData[24] VGND VPWR Tile_X0Y9_FrameStrobe[4] latch
XFILLER_482_172 VPWR VGND sg13cmos5l_decap_8
XFILLER_482_183 VPWR VGND sg13cmos5l_fill_1
XFILLER_304_83 VPWR VGND sg13cmos5l_decap_8
XFILLER_482_194 VPWR VGND sg13cmos5l_fill_2
X_1012_ _1012_/Q Tile_X0Y0_FrameData[23] VGND VPWR Tile_X0Y9_FrameStrobe[2] latch
XFILLER_240_49 VPWR VGND sg13cmos5l_decap_8
XFILLER_170_90 VPWR VGND sg13cmos5l_decap_8
XFILLER_320_60 VPWR VGND sg13cmos5l_decap_8
XFILLER_677_63 VPWR VGND sg13cmos5l_decap_8
X_2963_ Tile_X0Y8_FrameData_O[3] Tile_X0Y8_FrameData[3] VPWR VGND sg13cmos5l_buf_1
XFILLER_249_14 VPWR VGND sg13cmos5l_decap_8
X_4702_ _4702_/X Tile_X0Y6_W2MID[6] Tile_X0Y6_W2END[6] Tile_X0Y6_W6END[9] _4555_/X
+ _2649_/Q _2648_/Q VPWR VGND sg13cmos5l_mux4_1
XFILLER_396_42 VPWR VGND sg13cmos5l_fill_2
X_1914_ _1914_/Q Tile_X0Y3_FrameData[15] VGND VPWR Tile_X0Y9_FrameStrobe[7] latch
X_2894_ Tile_X0Y6_FrameData_O[15] Tile_X0Y6_FrameData[15] VPWR VGND sg13cmos5l_buf_1
XFILLER_249_69 VPWR VGND sg13cmos5l_decap_8
XFILLER_396_86 VPWR VGND sg13cmos5l_fill_1
X_4633_ _4633_/X Tile_X0Y7_WW4END[10] AXI_M_SOC_RDATA21 _4694_/X _4673_/X _0293_/Q
+ _0292_/Q VPWR VGND sg13cmos5l_mux4_1
XANTENNA__2899__X Tile_X0Y6_FrameData_O[20] VPWR VGND sg13cmos5l_antennanp
X_1845_ _1845_/Q Tile_X0Y3_FrameData[20] VGND VPWR Tile_X0Y9_FrameStrobe[5] latch
XFILLER_546_56 VPWR VGND sg13cmos5l_decap_8
X_4564_ _4564_/X Tile_X0Y2_W1END[2] Tile_X0Y2_WW4END[14] Tile_X0Y2_W6END[6] _4118_/X
+ _1607_/Q _1606_/Q VPWR VGND sg13cmos5l_mux4_1
XFILLER_698_158 VPWR VGND sg13cmos5l_decap_4
XFILLER_693_84 VPWR VGND sg13cmos5l_decap_8
X_1776_ _1776_/Q Tile_X0Y3_FrameData[25] VGND VPWR Tile_X0Y9_FrameStrobe[3] latch
XFILLER_265_35 VPWR VGND sg13cmos5l_decap_8
X_3515_ Tile_X0Y1_E2BEG[5] _3937_/X VPWR VGND sg13cmos5l_buf_1
X_0727_ _0727_/Q Tile_X0Y9_FrameData[8] VGND VPWR Tile_X0Y9_FrameStrobe[1] latch
XFILLER_304_132 VPWR VGND sg13cmos5l_decap_8
X_4495_ _4495_/X _4551_/X _4550_/X AXI_M_SOC_RDATA24 AXI_M_SOC_RDATA28 _2617_/Q _2616_/Q
+ VPWR VGND sg13cmos5l_mux4_1
X_3446_ Tile_X0Y1_FrameData_O[4] Tile_X0Y1_FrameData[4] VPWR VGND sg13cmos5l_buf_1
XFILLER_170_171 VPWR VGND sg13cmos5l_decap_8
X_0658_ _0658_/Q Tile_X0Y8_FrameData[13] VGND VPWR Tile_X0Y9_FrameStrobe[7] latch
XFILLER_415_49 VPWR VGND sg13cmos5l_decap_8
XFILLER_465_106 VPWR VGND sg13cmos5l_decap_8
XFILLER_69_130 VPWR VGND sg13cmos5l_decap_8
XFILLER_562_77 VPWR VGND sg13cmos5l_decap_8
XFILLER_134_28 VPWR VGND sg13cmos5l_decap_8
XFILLER_712_14 VPWR VGND sg13cmos5l_decap_8
X_0589_ _0589_/Q Tile_X0Y8_FrameData[18] VGND VPWR Tile_X0Y9_FrameStrobe[5] latch
X_3377_ Tile_X0Y2_E6BEG[0] _4072_/X VPWR VGND sg13cmos5l_buf_1
XFILLER_458_180 VPWR VGND sg13cmos5l_decap_8
XFILLER_281_56 VPWR VGND sg13cmos5l_decap_8
XANTENNA__3523__X Tile_X0Y9_E1BEG[1] VPWR VGND sg13cmos5l_antennanp
X_2328_ _2328_/Q Tile_X0Y5_FrameData[13] VGND VPWR Tile_X0Y9_FrameStrobe[4] latch
XFILLER_84_122 VPWR VGND sg13cmos5l_decap_4
XFILLER_84_155 VPWR VGND sg13cmos5l_fill_2
X_2259_ _2259_/Q Tile_X0Y5_FrameData[18] VGND VPWR Tile_X0Y9_FrameStrobe[2] latch
XFILLER_217_139 VPWR VGND sg13cmos5l_decap_8
XFILLER_84_199 VPWR VGND sg13cmos5l_fill_2
XFILLER_150_49 VPWR VGND sg13cmos5l_decap_4
XFILLER_386_135 VPWR VGND sg13cmos5l_decap_8
XFILLER_386_168 VPWR VGND sg13cmos5l_fill_2
XFILLER_240_175 VPWR VGND sg13cmos5l_decap_4
XFILLER_230_7 VPWR VGND sg13cmos5l_decap_8
XFILLER_528_151 VPWR VGND sg13cmos5l_decap_8
XFILLER_328_7 VPWR VGND sg13cmos5l_decap_8
XANTENNA__0106__Y AXI_M_SOC_ARLEN3 VPWR VGND sg13cmos5l_antennanp
XFILLER_543_121 VPWR VGND sg13cmos5l_fill_1
XFILLER_309_28 VPWR VGND sg13cmos5l_decap_8
XFILLER_456_56 VPWR VGND sg13cmos5l_decap_8
XFILLER_239_91 VPWR VGND sg13cmos5l_decap_8
XFILLER_175_35 VPWR VGND sg13cmos5l_decap_8
XFILLER_697_7 VPWR VGND sg13cmos5l_decap_8
XFILLER_68_22 VPWR VGND sg13cmos5l_decap_8
XFILLER_161_171 VPWR VGND sg13cmos5l_fill_1
XFILLER_108_73 VPWR VGND sg13cmos5l_fill_2
XFILLER_325_49 VPWR VGND sg13cmos5l_decap_8
XFILLER_310_124 VPWR VGND sg13cmos5l_decap_8
XFILLER_161_193 VPWR VGND sg13cmos5l_decap_8
XFILLER_645_217 VPWR VGND sg13cmos5l_fill_1
XFILLER_622_14 VPWR VGND sg13cmos5l_decap_8
XFILLER_472_88 VPWR VGND sg13cmos5l_fill_2
XFILLER_191_34 VPWR VGND sg13cmos5l_decap_8
XANTENNA__3433__X Tile_X0Y4_FrameData_O[24] VPWR VGND sg13cmos5l_antennanp
XFILLER_68_99 VPWR VGND sg13cmos5l_decap_8
XFILLER_471_109 VPWR VGND sg13cmos5l_fill_1
XFILLER_187_0 VPWR VGND sg13cmos5l_decap_8
XFILLER_75_166 VPWR VGND sg13cmos5l_decap_8
XFILLER_90_114 VPWR VGND sg13cmos5l_decap_4
XFILLER_702_91 VPWR VGND sg13cmos5l_decap_8
XFILLER_16_211 VPWR VGND sg13cmos5l_fill_1
XFILLER_421_70 VPWR VGND sg13cmos5l_decap_8
XFILLER_354_0 VPWR VGND sg13cmos5l_decap_8
XFILLER_90_158 VPWR VGND sg13cmos5l_decap_8
XFILLER_17_81 VPWR VGND sg13cmos5l_decap_4
XFILLER_17_92 VPWR VGND sg13cmos5l_decap_8
XFILLER_31_203 VPWR VGND sg13cmos5l_decap_8
XFILLER_497_63 VPWR VGND sg13cmos5l_decap_8
XFILLER_377_146 VPWR VGND sg13cmos5l_decap_8
XFILLER_521_0 VPWR VGND sg13cmos5l_decap_8
XFILLER_377_157 VPWR VGND sg13cmos5l_fill_1
XFILLER_231_164 VPWR VGND sg13cmos5l_decap_8
XFILLER_619_0 VPWR VGND sg13cmos5l_decap_8
XFILLER_377_179 VPWR VGND sg13cmos5l_decap_8
XFILLER_392_116 VPWR VGND sg13cmos5l_fill_2
XFILLER_519_173 VPWR VGND sg13cmos5l_decap_8
XFILLER_76_7 VPWR VGND sg13cmos5l_decap_8
XFILLER_647_77 VPWR VGND sg13cmos5l_decap_8
XFILLER_33_91 VPWR VGND sg13cmos5l_decap_4
XFILLER_366_56 VPWR VGND sg13cmos5l_decap_8
XFILLER_149_91 VPWR VGND sg13cmos5l_fill_2
XANTENNA__3608__X Tile_X0Y9_S2BEG[2] VPWR VGND sg13cmos5l_antennanp
X_1630_ _1630_/Q Tile_X0Y2_FrameData[19] VGND VPWR Tile_X0Y9_FrameStrobe[6] latch
XFILLER_663_21 VPWR VGND sg13cmos5l_decap_8
XFILLER_144_149 VPWR VGND sg13cmos5l_fill_1
X_1561_ _1561_/Q Tile_X0Y2_FrameData[24] VGND VPWR Tile_X0Y9_FrameStrobe[4] latch
X_3300_ Tile_X0Y0_E2BEG[0] _3804_/X VPWR VGND sg13cmos5l_buf_1
X_0512_ _0512_/Q Tile_X0Y8_FrameData[31] VGND VPWR Tile_X0Y9_FrameStrobe[3] latch
X_1492_ _1492_/Q Tile_X0Y2_FrameData[29] VGND VPWR Tile_X0Y9_FrameStrobe[2] latch
X_4280_ _4280_/X Tile_X0Y4_WW4END[7] AXI_M_SOC_BRESP1 _4343_/X _4312_/X _2053_/Q _2052_/Q
+ VPWR VGND sg13cmos5l_mux4_1
XFILLER_382_44 VPWR VGND sg13cmos5l_decap_8
XFILLER_165_90 VPWR VGND sg13cmos5l_decap_8
XFILLER_382_77 VPWR VGND sg13cmos5l_decap_8
X_0443_ _0443_/Q Tile_X0Y8_FrameData[4] VGND VPWR Tile_X0Y9_FrameStrobe[0] latch
X_3231_ Tile_X0Y0_FrameStrobe_O[19] Tile_X0Y9_FrameStrobe[19] VPWR VGND sg13cmos5l_buf_1
XFILLER_532_14 VPWR VGND sg13cmos5l_decap_8
XANTENNA__3343__X Tile_X0Y2_FrameData_O[14] VPWR VGND sg13cmos5l_antennanp
X_0374_ _0374_/Q Tile_X0Y7_FrameData[9] VGND VPWR Tile_X0Y9_FrameStrobe[6] latch
X_3162_ Tile_X0Y7_UserCLKo Tile_X0Y7_UserCLK VPWR VGND sg13cmos5l_buf_1
XFILLER_66_133 VPWR VGND sg13cmos5l_decap_8
X_2113_ _2113_/Q Tile_X0Y4_FrameData[4] VGND VPWR Tile_X0Y9_FrameStrobe[5] latch
X_3093_ Tile_X0Y7_E2BEG[7] _4619_/X VPWR VGND sg13cmos5l_buf_1
XFILLER_612_91 VPWR VGND sg13cmos5l_decap_8
X_2044_ _2044_/Q Tile_X0Y4_FrameData[9] VGND VPWR Tile_X0Y9_FrameStrobe[3] latch
XFILLER_470_153 VPWR VGND sg13cmos5l_fill_2
XFILLER_331_92 VPWR VGND sg13cmos5l_decap_8
XFILLER_470_197 VPWR VGND sg13cmos5l_decap_4
XFILLER_612_180 VPWR VGND sg13cmos5l_decap_8
X_3995_ _3995_/X _3894_/X _4027_/X _4026_/X Tile_X0Y0_S2MID[3] _1195_/Q _1194_/Q VPWR
+ VGND sg13cmos5l_mux4_1
XFILLER_222_175 VPWR VGND sg13cmos5l_decap_8
XFILLER_167_208 VPWR VGND sg13cmos5l_decap_8
XFILLER_572_205 VPWR VGND sg13cmos5l_fill_1
XFILLER_200_63 VPWR VGND sg13cmos5l_decap_8
X_2946_ Tile_X0Y8_EE4BEG[2] _4746_/X VPWR VGND sg13cmos5l_buf_1
XFILLER_572_216 VPWR VGND sg13cmos5l_fill_2
XFILLER_383_116 VPWR VGND sg13cmos5l_decap_4
XFILLER_13_28 VPWR VGND sg13cmos5l_decap_8
XFILLER_557_77 VPWR VGND sg13cmos5l_decap_8
XFILLER_707_14 VPWR VGND sg13cmos5l_decap_8
XFILLER_129_28 VPWR VGND sg13cmos5l_decap_8
X_2877_ Tile_X0Y6_EE4BEG[14] _4526_/X VPWR VGND sg13cmos5l_buf_1
XFILLER_129_39 VPWR VGND sg13cmos5l_fill_1
XFILLER_276_56 VPWR VGND sg13cmos5l_decap_8
XANTENNA__3518__X Tile_X0Y1_E1BEG[0] VPWR VGND sg13cmos5l_antennanp
XFILLER_135_105 VPWR VGND sg13cmos5l_decap_8
X_4616_ _4616_/X Tile_X0Y7_W2MID[3] AXI_M_SOC_RDATA20 _4675_/X _4674_/X _0327_/Q _0326_/Q
+ VPWR VGND sg13cmos5l_mux4_1
X_1828_ _1828_/Q Tile_X0Y3_FrameData[5] VGND VPWR Tile_X0Y9_FrameStrobe[4] latch
XFILLER_391_171 VPWR VGND sg13cmos5l_decap_8
XFILLER_324_216 VPWR VGND sg13cmos5l_fill_2
XFILLER_573_21 VPWR VGND sg13cmos5l_decap_8
XFILLER_686_106 VPWR VGND sg13cmos5l_fill_1
X_4547_ _4547_/X Tile_X0Y7_W1END[1] Tile_X0Y7_W6END[5] _4697_/X _4657_/X _0413_/Q
+ _0412_/Q VPWR VGND sg13cmos5l_mux4_1
X_1759_ _1759_/Q Tile_X0Y3_FrameData[10] VGND VPWR Tile_X0Y9_FrameStrobe[2] latch
XFILLER_289_120 VPWR VGND sg13cmos5l_decap_8
XFILLER_289_142 VPWR VGND sg13cmos5l_decap_8
XFILLER_573_98 VPWR VGND sg13cmos5l_decap_8
XFILLER_1_118 VPWR VGND sg13cmos5l_fill_1
X_4478_ _4478_/X Tile_X0Y4_W1END[1] Tile_X0Y4_W2MID[2] Tile_X0Y4_W2END[2] _4316_/X
+ _2127_/Q _2126_/Q VPWR VGND sg13cmos5l_mux4_1
XFILLER_506_70 VPWR VGND sg13cmos5l_decap_8
XFILLER_292_77 VPWR VGND sg13cmos5l_decap_8
X_3429_ Tile_X0Y4_FrameData_O[20] Tile_X0Y4_FrameData[20] VPWR VGND sg13cmos5l_buf_1
XFILLER_442_14 VPWR VGND sg13cmos5l_decap_8
XFILLER_292_88 VPWR VGND sg13cmos5l_fill_2
XANTENNA__3253__X Tile_X0Y0_FrameData_O[21] VPWR VGND sg13cmos5l_antennanp
XFILLER_225_71 VPWR VGND sg13cmos5l_decap_8
XFILLER_161_59 VPWR VGND sg13cmos5l_decap_8
XFILLER_446_194 VPWR VGND sg13cmos5l_fill_2
XFILLER_278_7 VPWR VGND sg13cmos5l_decap_8
XFILLER_461_131 VPWR VGND sg13cmos5l_decap_8
XFILLER_173_6 VPWR VGND sg13cmos5l_decap_8
XFILLER_445_7 VPWR VGND sg13cmos5l_decap_8
XFILLER_54_79 VPWR VGND sg13cmos5l_decap_8
XFILLER_110_41 VPWR VGND sg13cmos5l_decap_4
XFILLER_213_186 VPWR VGND sg13cmos5l_decap_8
XANTENNA__0117__X AXI_M_SOC_ARCACHE0 VPWR VGND sg13cmos5l_antennanp
XFILLER_612_7 VPWR VGND sg13cmos5l_decap_8
XFILLER_70_56 VPWR VGND sg13cmos5l_decap_8
XFILLER_617_14 VPWR VGND sg13cmos5l_decap_8
XANTENNA__3428__X Tile_X0Y4_FrameData_O[19] VPWR VGND sg13cmos5l_antennanp
XFILLER_181_200 VPWR VGND sg13cmos5l_decap_8
XFILLER_181_211 VPWR VGND sg13cmos5l_fill_1
XFILLER_483_21 VPWR VGND sg13cmos5l_decap_8
XFILLER_382_182 VPWR VGND sg13cmos5l_fill_1
XFILLER_677_128 VPWR VGND sg13cmos5l_fill_2
XFILLER_102_0 VPWR VGND sg13cmos5l_decap_8
XFILLER_79_54 VPWR VGND sg13cmos5l_decap_8
XFILLER_531_179 VPWR VGND sg13cmos5l_decap_8
XFILLER_633_35 VPWR VGND sg13cmos5l_decap_8
XFILLER_416_70 VPWR VGND sg13cmos5l_decap_8
XFILLER_295_112 VPWR VGND sg13cmos5l_decap_8
XFILLER_352_14 VPWR VGND sg13cmos5l_decap_8
XFILLER_295_123 VPWR VGND sg13cmos5l_fill_2
XANTENNA__3163__X Tile_X0Y4_E6BEG[0] VPWR VGND sg13cmos5l_antennanp
XFILLER_95_42 VPWR VGND sg13cmos5l_decap_4
XFILLER_48_111 VPWR VGND sg13cmos5l_fill_2
XFILLER_444_109 VPWR VGND sg13cmos5l_decap_4
XFILLER_471_0 VPWR VGND sg13cmos5l_decap_8
XFILLER_569_0 VPWR VGND sg13cmos5l_decap_8
XFILLER_502_28 VPWR VGND sg13cmos5l_decap_8
XFILLER_432_91 VPWR VGND sg13cmos5l_decap_8
XFILLER_452_142 VPWR VGND sg13cmos5l_decap_8
X_0090_ _3625_/A _4490_/X _4491_/X _2624_/Q VPWR VGND sg13cmos5l_mux2_1
XFILLER_63_158 VPWR VGND sg13cmos5l_decap_8
XFILLER_658_21 VPWR VGND sg13cmos5l_decap_8
XFILLER_204_175 VPWR VGND sg13cmos5l_decap_8
X_2800_ Tile_X0Y3_E6BEG[10] _4190_/X VPWR VGND sg13cmos5l_buf_1
X_3780_ _3780_/X Tile_X0Y0_W1END[0] Tile_X0Y0_W6END[4] _3875_/X _3862_/X _1177_/Q
+ _1176_/Q VPWR VGND sg13cmos5l_mux4_1
X_0992_ _0992_/Q Tile_X0Y0_FrameData[11] VGND VPWR Tile_X0Y9_FrameStrobe[1] latch
XFILLER_365_138 VPWR VGND sg13cmos5l_decap_8
X_2731_ _3862_/A3 VPWR VGND sg13cmos5l_tielo
XFILLER_507_121 VPWR VGND sg13cmos5l_decap_8
XFILLER_527_14 VPWR VGND sg13cmos5l_decap_8
XANTENNA__3338__X Tile_X0Y2_FrameData_O[9] VPWR VGND sg13cmos5l_antennanp
XFILLER_674_42 VPWR VGND sg13cmos5l_decap_8
XFILLER_306_205 VPWR VGND sg13cmos5l_decap_8
XFILLER_117_105 VPWR VGND sg13cmos5l_decap_8
XFILLER_306_216 VPWR VGND sg13cmos5l_fill_2
X_2662_ _2662_/Q Tile_X0Y6_FrameData[1] VGND VPWR Tile_X0Y9_FrameStrobe[6] latch
XFILLER_522_102 VPWR VGND sg13cmos5l_decap_8
XFILLER_711_202 VPWR VGND sg13cmos5l_fill_1
XFILLER_393_21 VPWR VGND sg13cmos5l_decap_8
X_4401_ _4401_/X Tile_X0Y5_WW4END[2] AXI_M_SOC_RRESP0 _4453_/X _4432_/X _2301_/Q _2300_/Q
+ VPWR VGND sg13cmos5l_mux4_1
X_1613_ _1613_/Q Tile_X0Y2_FrameData[4] VGND VPWR Tile_X0Y9_FrameStrobe[5] latch
X_2593_ _2593_/Q Tile_X0Y6_FrameData[6] VGND VPWR Tile_X0Y9_FrameStrobe[4] latch
XFILLER_132_119 VPWR VGND sg13cmos5l_decap_8
X_4332_ _4332_/X Tile_X0Y0_W1END[3] Tile_X0Y0_WW4END[15] Tile_X0Y0_W6END[7] _3884_/X
+ _1108_/Q _1107_/Q VPWR VGND sg13cmos5l_mux4_1
X_1544_ _1544_/Q Tile_X0Y2_FrameData[9] VGND VPWR Tile_X0Y9_FrameStrobe[3] latch
XFILLER_543_35 VPWR VGND sg13cmos5l_decap_8
XFILLER_5_84 VPWR VGND sg13cmos5l_decap_8
XFILLER_5_95 VPWR VGND sg13cmos5l_fill_2
X_4263_ _4263_/X Tile_X0Y4_W2MID[0] AXI_M_SOC_BRESP1 _4313_/X _4312_/X _2087_/Q _2086_/Q
+ VPWR VGND sg13cmos5l_mux4_1
XFILLER_286_134 VPWR VGND sg13cmos5l_decap_8
XFILLER_262_14 VPWR VGND sg13cmos5l_decap_8
XFILLER_86_206 VPWR VGND sg13cmos5l_decap_4
X_1475_ _1475_/Q Tile_X0Y2_FrameData[14] VGND VPWR Tile_X0Y9_FrameStrobe[1] latch
XANTENNA__3073__X Tile_X0Y5_UserCLKo VPWR VGND sg13cmos5l_antennanp
XFILLER_86_217 VPWR VGND sg13cmos5l_fill_1
XFILLER_691_131 VPWR VGND sg13cmos5l_decap_4
X_3214_ Tile_X0Y0_FrameStrobe_O[2] Tile_X0Y9_FrameStrobe[2] VPWR VGND sg13cmos5l_buf_1
XFILLER_140_185 VPWR VGND sg13cmos5l_decap_8
X_0426_ _0426_/Q Tile_X0Y8_FrameData[21] VGND VPWR Tile_X0Y9_FrameStrobe[0] latch
XFILLER_691_153 VPWR VGND sg13cmos5l_fill_1
X_4194_ _4194_/X Tile_X0Y2_W1END[0] Tile_X0Y2_W6END[8] _4113_/X _4084_/X _1637_/Q
+ _1636_/Q VPWR VGND sg13cmos5l_mux4_1
XFILLER_691_175 VPWR VGND sg13cmos5l_decap_8
XFILLER_428_161 VPWR VGND sg13cmos5l_decap_8
X_3145_ Tile_X0Y7_FrameData_O[15] Tile_X0Y7_FrameData[15] VPWR VGND sg13cmos5l_buf_1
XFILLER_412_28 VPWR VGND sg13cmos5l_decap_8
X_0357_ _0357_/Q Tile_X0Y7_FrameData[26] VGND VPWR Tile_X0Y9_FrameStrobe[6] latch
XFILLER_54_114 VPWR VGND sg13cmos5l_decap_4
X_0288_ _0288_/Q Tile_X0Y7_FrameData[31] VGND VPWR Tile_X0Y9_FrameStrobe[4] latch
X_3076_ Tile_X0Y4_E2BEGb[2] _4266_/X VPWR VGND sg13cmos5l_buf_1
XFILLER_589_157 VPWR VGND sg13cmos5l_fill_2
XFILLER_242_215 VPWR VGND sg13cmos5l_fill_2
X_2027_ _2027_/Q Tile_X0Y4_FrameData[26] VGND VPWR Tile_X0Y9_FrameStrobe[3] latch
XFILLER_568_21 VPWR VGND sg13cmos5l_decap_8
XFILLER_211_84 VPWR VGND sg13cmos5l_decap_8
XFILLER_62_191 VPWR VGND sg13cmos5l_fill_1
XFILLER_24_49 VPWR VGND sg13cmos5l_decap_8
XFILLER_356_105 VPWR VGND sg13cmos5l_decap_8
XFILLER_568_98 VPWR VGND sg13cmos5l_decap_8
XFILLER_10_206 VPWR VGND sg13cmos5l_decap_4
X_3978_ _3978_/X _3985_/X Tile_X0Y1_W6END[2] _3984_/X _3978_/A3 _1181_/Q _1180_/Q
+ VPWR VGND sg13cmos5l_mux4_1
XFILLER_10_217 VPWR VGND sg13cmos5l_fill_1
XFILLER_287_77 VPWR VGND sg13cmos5l_decap_8
X_2929_ Tile_X0Y8_E2BEGb[5] _4741_/X VPWR VGND sg13cmos5l_buf_1
XFILLER_437_14 VPWR VGND sg13cmos5l_decap_8
XANTENNA__3248__X Tile_X0Y0_FrameData_O[16] VPWR VGND sg13cmos5l_antennanp
XFILLER_584_42 VPWR VGND sg13cmos5l_decap_8
XFILLER_108_127 VPWR VGND sg13cmos5l_decap_8
XFILLER_513_157 VPWR VGND sg13cmos5l_fill_2
XFILLER_6_7 VPWR VGND sg13cmos5l_decap_8
XFILLER_453_35 VPWR VGND sg13cmos5l_decap_8
XFILLER_277_112 VPWR VGND sg13cmos5l_decap_8
XFILLER_172_14 VPWR VGND sg13cmos5l_decap_8
XFILLER_49_57 VPWR VGND sg13cmos5l_decap_8
XFILLER_395_7 VPWR VGND sg13cmos5l_decap_8
XFILLER_77_217 VPWR VGND sg13cmos5l_fill_1
XFILLER_172_58 VPWR VGND sg13cmos5l_decap_8
XFILLER_603_49 VPWR VGND sg13cmos5l_decap_8
XFILLER_292_115 VPWR VGND sg13cmos5l_fill_1
XFILLER_105_41 VPWR VGND sg13cmos5l_decap_8
XFILLER_292_137 VPWR VGND sg13cmos5l_decap_8
XFILLER_65_12 VPWR VGND sg13cmos5l_decap_8
XFILLER_562_7 VPWR VGND sg13cmos5l_decap_8
XFILLER_322_28 VPWR VGND sg13cmos5l_decap_8
XANTENNA__3711__X AXI_M_SOC_WDATA21 VPWR VGND sg13cmos5l_antennanp
XFILLER_105_85 VPWR VGND sg13cmos5l_decap_8
XFILLER_434_142 VPWR VGND sg13cmos5l_decap_8
XFILLER_434_153 VPWR VGND sg13cmos5l_decap_8
XFILLER_379_208 VPWR VGND sg13cmos5l_fill_1
XFILLER_65_89 VPWR VGND sg13cmos5l_decap_8
XFILLER_434_186 VPWR VGND sg13cmos5l_decap_8
XFILLER_45_169 VPWR VGND sg13cmos5l_decap_8
XFILLER_402_83 VPWR VGND sg13cmos5l_decap_4
XFILLER_478_21 VPWR VGND sg13cmos5l_decap_8
XFILLER_198_141 VPWR VGND sg13cmos5l_decap_8
XFILLER_121_84 VPWR VGND sg13cmos5l_decap_8
XFILLER_347_105 VPWR VGND sg13cmos5l_decap_8
XFILLER_628_35 VPWR VGND sg13cmos5l_decap_8
XFILLER_197_77 VPWR VGND sg13cmos5l_decap_8
XFILLER_347_14 VPWR VGND sg13cmos5l_decap_8
XFILLER_14_82 VPWR VGND sg13cmos5l_decap_8
XANTENNA__3158__X Tile_X0Y7_FrameData_O[28] VPWR VGND sg13cmos5l_antennanp
XFILLER_317_0 VPWR VGND sg13cmos5l_decap_8
XFILLER_494_42 VPWR VGND sg13cmos5l_decap_8
XFILLER_5_210 VPWR VGND sg13cmos5l_decap_8
XANTENNA__2997__X Tile_X0Y5_E2BEG[0] VPWR VGND sg13cmos5l_antennanp
XFILLER_370_152 VPWR VGND sg13cmos5l_fill_1
XFILLER_114_108 VPWR VGND sg13cmos5l_fill_2
XFILLER_644_56 VPWR VGND sg13cmos5l_decap_8
XFILLER_504_168 VPWR VGND sg13cmos5l_decap_8
XFILLER_30_70 VPWR VGND sg13cmos5l_decap_8
XFILLER_427_91 VPWR VGND sg13cmos5l_decap_8
XFILLER_370_174 VPWR VGND sg13cmos5l_fill_1
XFILLER_363_13 VPWR VGND sg13cmos5l_decap_8
XFILLER_30_81 VPWR VGND sg13cmos5l_fill_1
XFILLER_107_171 VPWR VGND sg13cmos5l_decap_8
XFILLER_146_70 VPWR VGND sg13cmos5l_fill_2
XFILLER_686_0 VPWR VGND sg13cmos5l_decap_8
XFILLER_363_57 VPWR VGND sg13cmos5l_fill_1
XFILLER_122_130 VPWR VGND sg13cmos5l_fill_1
XFILLER_512_190 VPWR VGND sg13cmos5l_decap_8
XFILLER_658_183 VPWR VGND sg13cmos5l_fill_1
X_1260_ _1260_/Q Tile_X0Y1_FrameData[13] VGND VPWR Tile_X0Y9_FrameStrobe[2] latch
XFILLER_513_49 VPWR VGND sg13cmos5l_decap_8
XFILLER_283_126 VPWR VGND sg13cmos5l_decap_8
XFILLER_83_209 VPWR VGND sg13cmos5l_fill_1
X_0211_ _0211_/Q Tile_X0Y7_FrameData[12] VGND VPWR Tile_X0Y9_FrameStrobe[1] latch
XFILLER_660_77 VPWR VGND sg13cmos5l_decap_8
X_1191_ _1191_/Q Tile_X0Y1_FrameData[18] VGND VPWR Tile_X0Y9_FrameStrobe[0] latch
XANTENNA__3621__X Tile_X0Y9_S2BEGb[7] VPWR VGND sg13cmos5l_antennanp
X_0142_ _3187_/A _3904_/X _3905_/X _1390_/Q VPWR VGND sg13cmos5l_mux2_1
XFILLER_224_215 VPWR VGND sg13cmos5l_fill_2
XFILLER_425_175 VPWR VGND sg13cmos5l_decap_8
X_0073_ _0073_/X _3997_/X _3998_/X _2413_/Q VPWR VGND sg13cmos5l_mux2_1
XFILLER_440_123 VPWR VGND sg13cmos5l_fill_2
XFILLER_669_64 VPWR VGND sg13cmos5l_decap_8
XFILLER_586_127 VPWR VGND sg13cmos5l_decap_8
XFILLER_388_21 VPWR VGND sg13cmos5l_decap_8
X_3901_ _3901_/X Tile_X0Y1_W2MID[1] Tile_X0Y1_W2END[1] Tile_X0Y1_W6END[1] _3990_/X
+ _1405_/Q _1404_/Q VPWR VGND sg13cmos5l_mux4_1
X_4881_ _4881_/X Tile_X0Y9_N4END[1] _0082_/X _4926_/X _4930_/X _0781_/Q _0780_/Q VPWR
+ VGND sg13cmos5l_mux4_1
XFILLER_440_178 VPWR VGND sg13cmos5l_decap_4
XFILLER_393_200 VPWR VGND sg13cmos5l_decap_4
X_3832_ _3832_/X Tile_X0Y0_WW4END[3] _3884_/X _3859_/X _3861_/X _1041_/Q _1040_/Q
+ VPWR VGND sg13cmos5l_mux4_1
XFILLER_189_196 VPWR VGND sg13cmos5l_decap_8
XFILLER_538_35 VPWR VGND sg13cmos5l_decap_8
XFILLER_685_63 VPWR VGND sg13cmos5l_decap_8
X_3763_ _3763_/X Tile_X0Y1_WW4END[4] Tile_X0Y1_WW4END[12] Tile_X0Y1_W6END[4] _4012_/X
+ _1249_/Q _1248_/Q VPWR VGND sg13cmos5l_mux4_1
XFILLER_538_68 VPWR VGND sg13cmos5l_fill_1
XFILLER_257_14 VPWR VGND sg13cmos5l_decap_8
X_0975_ _0975_/Q Tile_X0Y0_FrameData[28] VGND VPWR Tile_X0Y9_FrameStrobe[1] latch
XANTENNA__3068__X Tile_X0Y5_FrameData_O[27] VPWR VGND sg13cmos5l_antennanp
XFILLER_353_119 VPWR VGND sg13cmos5l_decap_8
X_2714_ _4541_/A3 VPWR VGND sg13cmos5l_tielo
X_3694_ AXI_M_SOC_WDATA4 Tile_X0Y7_WW4END[4] Tile_X0Y7_WW4END[12] Tile_X0Y7_W6END[4]
+ _4688_/X _0239_/Q _0238_/Q VPWR VGND sg13cmos5l_mux4_1
XFILLER_346_182 VPWR VGND sg13cmos5l_decap_8
XFILLER_65_0 VPWR VGND sg13cmos5l_decap_8
X_2645_ _2645_/Q Tile_X0Y6_FrameData[18] VGND VPWR Tile_X0Y9_FrameStrobe[6] latch
XFILLER_407_28 VPWR VGND sg13cmos5l_decap_8
XFILLER_105_108 VPWR VGND sg13cmos5l_fill_1
XFILLER_160_203 VPWR VGND sg13cmos5l_fill_2
XFILLER_554_56 VPWR VGND sg13cmos5l_decap_8
XFILLER_510_116 VPWR VGND sg13cmos5l_decap_8
X_2576_ _2576_/Q Tile_X0Y6_FrameData[23] VGND VPWR Tile_X0Y9_FrameStrobe[4] latch
XFILLER_273_35 VPWR VGND sg13cmos5l_decap_8
XFILLER_649_161 VPWR VGND sg13cmos5l_decap_8
X_4315_ _4315_/X _4239_/X _4355_/X _4354_/X _4238_/X _1947_/Q _1946_/Q VPWR VGND sg13cmos5l_mux4_1
X_1527_ _1527_/Q Tile_X0Y2_FrameData[26] VGND VPWR Tile_X0Y9_FrameStrobe[3] latch
XFILLER_259_156 VPWR VGND sg13cmos5l_decap_4
XFILLER_206_62 VPWR VGND sg13cmos5l_decap_8
X_4246_ _4246_/X Tile_X0Y2_W1END[1] Tile_X0Y2_W2MID[2] Tile_X0Y2_W2END[2] _4100_/X
+ _1619_/Q _1618_/Q VPWR VGND sg13cmos5l_mux4_1
X_1458_ _1458_/Q Tile_X0Y2_FrameData[31] VGND VPWR Tile_X0Y9_FrameStrobe[1] latch
XFILLER_423_49 VPWR VGND sg13cmos5l_decap_8
XFILLER_463_215 VPWR VGND sg13cmos5l_fill_2
XFILLER_274_126 VPWR VGND sg13cmos5l_decap_8
XFILLER_570_77 VPWR VGND sg13cmos5l_decap_8
XFILLER_19_49 VPWR VGND sg13cmos5l_decap_8
X_0409_ _0409_/Q Tile_X0Y7_FrameData[6] VGND VPWR Tile_X0Y9_FrameStrobe[7] latch
XFILLER_142_28 VPWR VGND sg13cmos5l_decap_8
X_4177_ _4177_/X Tile_X0Y3_WW4END[2] AXI_M_SOC_WREADY _4224_/X _4209_/X _1787_/Q _1786_/Q
+ VPWR VGND sg13cmos5l_mux4_1
X_1389_ _1389_/Q Tile_X0Y1_FrameData[12] VGND VPWR Tile_X0Y9_FrameStrobe[6] latch
XFILLER_27_103 VPWR VGND sg13cmos5l_decap_8
XANTENNA__3531__X Tile_X0Y9_E2BEG[5] VPWR VGND sg13cmos5l_antennanp
X_3128_ Tile_X0Y7_EE4BEG[14] _4642_/X VPWR VGND sg13cmos5l_buf_1
XFILLER_416_164 VPWR VGND sg13cmos5l_fill_2
XFILLER_416_175 VPWR VGND sg13cmos5l_fill_1
XFILLER_579_42 VPWR VGND sg13cmos5l_decap_8
XFILLER_431_112 VPWR VGND sg13cmos5l_fill_1
XFILLER_577_105 VPWR VGND sg13cmos5l_decap_8
X_3059_ Tile_X0Y5_FrameData_O[18] Tile_X0Y5_FrameData[18] VPWR VGND sg13cmos5l_buf_1
XFILLER_298_21 VPWR VGND sg13cmos5l_decap_8
XFILLER_431_189 VPWR VGND sg13cmos5l_decap_8
XFILLER_384_200 VPWR VGND sg13cmos5l_decap_8
XFILLER_329_116 VPWR VGND sg13cmos5l_decap_8
XFILLER_298_98 VPWR VGND sg13cmos5l_decap_8
XFILLER_143_7 VPWR VGND sg13cmos5l_decap_8
XFILLER_448_35 VPWR VGND sg13cmos5l_decap_8
XFILLER_595_63 VPWR VGND sg13cmos5l_decap_8
XFILLER_167_14 VPWR VGND sg13cmos5l_decap_8
XFILLER_51_69 VPWR VGND sg13cmos5l_decap_8
XFILLER_310_7 VPWR VGND sg13cmos5l_decap_8
XFILLER_136_211 VPWR VGND sg13cmos5l_fill_1
XFILLER_408_7 VPWR VGND sg13cmos5l_decap_8
XFILLER_498_112 VPWR VGND sg13cmos5l_decap_8
XFILLER_352_130 VPWR VGND sg13cmos5l_fill_1
XANTENNA__0114__Y AXI_M_SOC_ARLOCK VPWR VGND sg13cmos5l_antennanp
XFILLER_317_28 VPWR VGND sg13cmos5l_decap_8
XFILLER_464_56 VPWR VGND sg13cmos5l_decap_8
XFILLER_247_91 VPWR VGND sg13cmos5l_decap_8
XANTENNA__3706__X AXI_M_SOC_WDATA16 VPWR VGND sg13cmos5l_antennanp
XFILLER_501_105 VPWR VGND sg13cmos5l_decap_8
XFILLER_498_189 VPWR VGND sg13cmos5l_decap_8
XFILLER_116_62 VPWR VGND sg13cmos5l_decap_8
XFILLER_104_185 VPWR VGND sg13cmos5l_decap_8
XFILLER_333_49 VPWR VGND sg13cmos5l_decap_8
XFILLER_630_14 VPWR VGND sg13cmos5l_decap_8
XFILLER_76_77 VPWR VGND sg13cmos5l_decap_8
XANTENNA__3441__X Tile_X0Y1_UserCLKo VPWR VGND sg13cmos5l_antennanp
XFILLER_206_204 VPWR VGND sg13cmos5l_decap_4
XFILLER_267_0 VPWR VGND sg13cmos5l_decap_8
XFILLER_568_105 VPWR VGND sg13cmos5l_decap_8
XFILLER_489_42 VPWR VGND sg13cmos5l_decap_8
XFILLER_710_91 VPWR VGND sg13cmos5l_decap_8
XFILLER_434_0 VPWR VGND sg13cmos5l_decap_8
XFILLER_639_56 VPWR VGND sg13cmos5l_decap_8
XFILLER_25_70 VPWR VGND sg13cmos5l_fill_1
XFILLER_509_216 VPWR VGND sg13cmos5l_fill_2
XFILLER_576_182 VPWR VGND sg13cmos5l_decap_8
XFILLER_358_35 VPWR VGND sg13cmos5l_decap_8
XFILLER_41_183 VPWR VGND sg13cmos5l_decap_8
XFILLER_601_0 VPWR VGND sg13cmos5l_decap_8
XFILLER_390_203 VPWR VGND sg13cmos5l_decap_8
XFILLER_186_199 VPWR VGND sg13cmos5l_decap_8
X_0760_ _0760_/Q Tile_X0Y9_FrameData[7] VGND VPWR Tile_X0Y9_FrameStrobe[2] latch
XFILLER_591_185 VPWR VGND sg13cmos5l_fill_1
XFILLER_508_49 VPWR VGND sg13cmos5l_decap_8
XFILLER_655_77 VPWR VGND sg13cmos5l_decap_8
XFILLER_489_134 VPWR VGND sg13cmos5l_decap_8
X_0691_ _0691_/Q Tile_X0Y9_FrameData[12] VGND VPWR Tile_X0Y9_FrameStrobe[0] latch
XFILLER_51_6 VPWR VGND sg13cmos5l_decap_8
XFILLER_374_56 VPWR VGND sg13cmos5l_fill_1
XANTENNA__3616__X Tile_X0Y9_S2BEGb[2] VPWR VGND sg13cmos5l_antennanp
X_2430_ _2430_/Q Tile_X0Y5_FrameData[7] VGND VPWR Tile_X0Y9_FrameStrobe[7] latch
XFILLER_374_78 VPWR VGND sg13cmos5l_decap_8
XFILLER_671_21 VPWR VGND sg13cmos5l_decap_8
XFILLER_307_61 VPWR VGND sg13cmos5l_decap_8
XFILLER_307_72 VPWR VGND sg13cmos5l_fill_1
X_2361_ _2361_/Q Tile_X0Y5_FrameData[12] VGND VPWR Tile_X0Y9_FrameStrobe[5] latch
X_4100_ _4100_/X _4031_/X _4139_/X _4138_/X _4030_/X _1439_/Q _1438_/Q VPWR VGND sg13cmos5l_mux4_1
X_1312_ _1312_/Q Tile_X0Y1_FrameData[25] VGND VPWR Tile_X0Y9_FrameStrobe[4] latch
X_2292_ _2292_/Q Tile_X0Y5_FrameData[17] VGND VPWR Tile_X0Y9_FrameStrobe[3] latch
XFILLER_243_49 VPWR VGND sg13cmos5l_decap_8
XFILLER_646_175 VPWR VGND sg13cmos5l_decap_8
XFILLER_604_70 VPWR VGND sg13cmos5l_decap_8
XFILLER_500_182 VPWR VGND sg13cmos5l_decap_8
XFILLER_661_101 VPWR VGND sg13cmos5l_decap_8
XFILLER_110_144 VPWR VGND sg13cmos5l_fill_1
X_4031_ _4031_/X Tile_X0Y3_W2MID[2] Tile_X0Y3_W2END[2] Tile_X0Y3_W6END[2] _4208_/X
+ _1907_/Q _1906_/Q VPWR VGND sg13cmos5l_mux4_1
X_1243_ _1243_/Q Tile_X0Y1_FrameData[30] VGND VPWR Tile_X0Y9_FrameStrobe[2] latch
XFILLER_540_14 VPWR VGND sg13cmos5l_decap_8
XFILLER_2_63 VPWR VGND sg13cmos5l_decap_8
XANTENNA__3351__X Tile_X0Y2_FrameData_O[22] VPWR VGND sg13cmos5l_antennanp
XFILLER_661_156 VPWR VGND sg13cmos5l_decap_4
XFILLER_661_167 VPWR VGND sg13cmos5l_decap_4
X_1174_ _1174_/Q Tile_X0Y0_FrameData[21] VGND VPWR Tile_X0Y9_FrameStrobe[7] latch
XFILLER_264_170 VPWR VGND sg13cmos5l_decap_8
XFILLER_413_112 VPWR VGND sg13cmos5l_decap_8
XFILLER_399_42 VPWR VGND sg13cmos5l_decap_8
X_0125_ _3189_/A _3794_/X _3795_/X _1148_/Q VPWR VGND sg13cmos5l_mux2_1
XFILLER_559_127 VPWR VGND sg13cmos5l_decap_8
XFILLER_620_91 VPWR VGND sg13cmos5l_decap_8
XFILLER_24_128 VPWR VGND sg13cmos5l_decap_8
XFILLER_24_139 VPWR VGND sg13cmos5l_fill_1
X_0056_ _0056_/X _4676_/X _4677_/X _1863_/Q VPWR VGND sg13cmos5l_mux2_1
X_4933_ _4933_/X Tile_X0Y8_W2MID[6] Tile_X0Y8_W2END[6] Tile_X0Y8_W6END[9] _4787_/X
+ _0625_/Q _0624_/Q VPWR VGND sg13cmos5l_mux4_1
XFILLER_17_180 VPWR VGND sg13cmos5l_fill_1
XFILLER_574_108 VPWR VGND sg13cmos5l_decap_8
XFILLER_549_56 VPWR VGND sg13cmos5l_decap_8
XFILLER_366_211 VPWR VGND sg13cmos5l_decap_8
X_4864_ _4864_/X Tile_X0Y9_WW4END[15] AXI_M_SOC_RDATA0 _4931_/X _4900_/X _0815_/Q
+ _0814_/Q VPWR VGND sg13cmos5l_mux4_1
XFILLER_696_84 VPWR VGND sg13cmos5l_decap_8
XFILLER_268_35 VPWR VGND sg13cmos5l_decap_8
XANTENNA_13 AXI_M_SOC_WREADY VPWR VGND sg13cmos5l_antennanp
XFILLER_32_183 VPWR VGND sg13cmos5l_decap_8
XANTENNA_24 AXI_M_SOC_WREADY VPWR VGND sg13cmos5l_antennanp
X_3815_ _3815_/X Tile_X0Y0_W2END[4] Tile_X0Y0_WW4END[3] _3859_/X _3858_/X _1075_/Q
+ _1074_/Q VPWR VGND sg13cmos5l_mux4_1
XFILLER_177_155 VPWR VGND sg13cmos5l_decap_4
XANTENNA_35 AXI_M_SOC_WREADY VPWR VGND sg13cmos5l_antennanp
XANTENNA_46 Tile_X0Y0_S2MID[6] VPWR VGND sg13cmos5l_antennanp
X_4795_ _4795_/X _4341_/X _4345_/X _4349_/X _4316_/X _2118_/Q _2117_/Q VPWR VGND sg13cmos5l_mux4_1
XANTENNA_57 Tile_X0Y5_W2END[5] VPWR VGND sg13cmos5l_antennanp
XANTENNA_68 Tile_X0Y9_FrameStrobe[19] VPWR VGND sg13cmos5l_antennanp
XANTENNA_79 Tile_X0Y9_N2MID[4] VPWR VGND sg13cmos5l_antennanp
X_3746_ AXI_M_SOC_ARADDR18 Tile_X0Y8_WW4END[2] Tile_X0Y8_WW4END[10] Tile_X0Y8_W6END[2]
+ _4802_/X _0499_/Q _0498_/Q VPWR VGND sg13cmos5l_mux4_1
X_0958_ _0958_/Q Tile_X0Y0_FrameData[13] VGND VPWR Tile_X0Y9_FrameStrobe[0] latch
XFILLER_418_49 VPWR VGND sg13cmos5l_decap_8
XFILLER_21_28 VPWR VGND sg13cmos5l_decap_8
XFILLER_565_77 VPWR VGND sg13cmos5l_decap_8
XFILLER_137_28 VPWR VGND sg13cmos5l_decap_8
X_3677_ _3677_/X Tile_X0Y2_WW4END[7] Tile_X0Y2_WW4END[15] Tile_X0Y2_W6END[7] _4123_/X
+ _1491_/Q _1490_/Q VPWR VGND sg13cmos5l_mux4_1
X_0889_ _0889_/Q Tile_X0Y9_FrameData[6] VGND VPWR Tile_X0Y9_FrameStrobe[6] latch
XANTENNA__3526__X Tile_X0Y9_E2BEG[0] VPWR VGND sg13cmos5l_antennanp
XFILLER_284_56 VPWR VGND sg13cmos5l_decap_8
X_2628_ _2628_/Q Tile_X0Y6_FrameData[3] VGND VPWR Tile_X0Y9_FrameStrobe[5] latch
XFILLER_334_185 VPWR VGND sg13cmos5l_decap_8
XFILLER_629_109 VPWR VGND sg13cmos5l_fill_2
XFILLER_715_69 VPWR VGND sg13cmos5l_decap_8
XFILLER_581_21 VPWR VGND sg13cmos5l_decap_8
XFILLER_495_126 VPWR VGND sg13cmos5l_decap_8
XFILLER_217_83 VPWR VGND sg13cmos5l_decap_8
X_2559_ _2559_/Q Tile_X0Y6_FrameData[8] VGND VPWR Tile_X0Y9_FrameStrobe[3] latch
XFILLER_99_183 VPWR VGND sg13cmos5l_decap_8
XFILLER_514_70 VPWR VGND sg13cmos5l_decap_4
XFILLER_652_112 VPWR VGND sg13cmos5l_decap_8
XFILLER_247_137 VPWR VGND sg13cmos5l_decap_8
X_4229_ _4229_/X _4203_/X _0046_/X _4202_/X Tile_X0Y0_S4END[15] _1715_/Q _1714_/Q
+ VPWR VGND sg13cmos5l_mux4_1
XFILLER_450_14 VPWR VGND sg13cmos5l_decap_8
XANTENNA__3261__X Tile_X0Y0_FrameData_O[29] VPWR VGND sg13cmos5l_antennanp
XFILLER_233_71 VPWR VGND sg13cmos5l_decap_4
XFILLER_46_25 VPWR VGND sg13cmos5l_decap_8
XFILLER_101_199 VPWR VGND sg13cmos5l_decap_8
XFILLER_652_189 VPWR VGND sg13cmos5l_decap_8
XFILLER_600_28 VPWR VGND sg13cmos5l_decap_8
XFILLER_260_7 VPWR VGND sg13cmos5l_decap_8
XFILLER_358_7 VPWR VGND sg13cmos5l_decap_8
XFILLER_102_42 VPWR VGND sg13cmos5l_decap_4
XFILLER_404_189 VPWR VGND sg13cmos5l_decap_8
XFILLER_565_119 VPWR VGND sg13cmos5l_decap_8
XFILLER_459_56 VPWR VGND sg13cmos5l_decap_8
XFILLER_558_160 VPWR VGND sg13cmos5l_fill_2
XFILLER_178_13 VPWR VGND sg13cmos5l_fill_2
XFILLER_525_7 VPWR VGND sg13cmos5l_decap_8
XFILLER_23_161 VPWR VGND sg13cmos5l_decap_8
XFILLER_62_79 VPWR VGND sg13cmos5l_decap_8
XFILLER_178_46 VPWR VGND sg13cmos5l_decap_4
XFILLER_178_68 VPWR VGND sg13cmos5l_decap_8
XFILLER_707_157 VPWR VGND sg13cmos5l_decap_8
XFILLER_109_211 VPWR VGND sg13cmos5l_fill_1
XFILLER_573_196 VPWR VGND sg13cmos5l_decap_8
XFILLER_183_147 VPWR VGND sg13cmos5l_decap_4
XFILLER_183_158 VPWR VGND sg13cmos5l_decap_8
XFILLER_325_141 VPWR VGND sg13cmos5l_decap_4
XFILLER_625_14 VPWR VGND sg13cmos5l_decap_8
XFILLER_194_56 VPWR VGND sg13cmos5l_decap_8
XANTENNA__3436__X Tile_X0Y4_FrameData_O[27] VPWR VGND sg13cmos5l_antennanp
XFILLER_340_100 VPWR VGND sg13cmos5l_fill_1
XFILLER_408_82 VPWR VGND sg13cmos5l_fill_1
XFILLER_340_122 VPWR VGND sg13cmos5l_decap_8
XFILLER_491_21 VPWR VGND sg13cmos5l_decap_8
XFILLER_675_215 VPWR VGND sg13cmos5l_fill_2
XFILLER_87_21 VPWR VGND sg13cmos5l_decap_4
XFILLER_628_120 VPWR VGND sg13cmos5l_decap_8
XFILLER_705_91 VPWR VGND sg13cmos5l_decap_8
XFILLER_340_199 VPWR VGND sg13cmos5l_decap_4
XFILLER_491_98 VPWR VGND sg13cmos5l_decap_8
XFILLER_238_104 VPWR VGND sg13cmos5l_decap_8
XFILLER_641_35 VPWR VGND sg13cmos5l_decap_8
XFILLER_424_70 VPWR VGND sg13cmos5l_decap_8
XFILLER_643_112 VPWR VGND sg13cmos5l_decap_8
XFILLER_384_0 VPWR VGND sg13cmos5l_decap_8
XFILLER_494_192 VPWR VGND sg13cmos5l_decap_8
XFILLER_360_14 VPWR VGND sg13cmos5l_decap_8
XANTENNA__3171__X Tile_X0Y4_E6BEG[8] VPWR VGND sg13cmos5l_antennanp
XFILLER_643_189 VPWR VGND sg13cmos5l_decap_4
XFILLER_551_0 VPWR VGND sg13cmos5l_decap_8
XFILLER_649_0 VPWR VGND sg13cmos5l_decap_8
XFILLER_510_28 VPWR VGND sg13cmos5l_decap_8
XFILLER_246_192 VPWR VGND sg13cmos5l_decap_8
XFILLER_440_80 VPWR VGND sg13cmos5l_fill_1
XFILLER_261_140 VPWR VGND sg13cmos5l_decap_8
XFILLER_410_115 VPWR VGND sg13cmos5l_decap_8
XFILLER_410_126 VPWR VGND sg13cmos5l_fill_2
XFILLER_159_100 VPWR VGND sg13cmos5l_fill_1
XFILLER_556_119 VPWR VGND sg13cmos5l_decap_8
XFILLER_369_56 VPWR VGND sg13cmos5l_decap_8
X_1930_ _1930_/Q Tile_X0Y4_FrameData[27] VGND VPWR Tile_X0Y9_FrameStrobe[0] latch
XFILLER_99_6 VPWR VGND sg13cmos5l_decap_8
XFILLER_369_89 VPWR VGND sg13cmos5l_decap_8
XFILLER_666_21 VPWR VGND sg13cmos5l_decap_8
X_1861_ _1861_/Q Tile_X0Y3_FrameData[4] VGND VPWR Tile_X0Y9_FrameStrobe[5] latch
XFILLER_564_152 VPWR VGND sg13cmos5l_decap_8
XFILLER_159_177 VPWR VGND sg13cmos5l_decap_8
XFILLER_308_119 VPWR VGND sg13cmos5l_decap_8
X_3600_ Tile_X0Y9_FrameData_O[30] Tile_X0Y9_FrameData[30] VPWR VGND sg13cmos5l_buf_1
XFILLER_174_125 VPWR VGND sg13cmos5l_decap_8
XFILLER_159_199 VPWR VGND sg13cmos5l_decap_8
XFILLER_713_105 VPWR VGND sg13cmos5l_decap_8
X_0812_ _0812_/Q Tile_X0Y9_FrameData[19] VGND VPWR Tile_X0Y9_FrameStrobe[4] latch
XFILLER_238_27 VPWR VGND sg13cmos5l_decap_8
X_4580_ _4580_/X _4545_/X Tile_X0Y9_N4END[12] _4544_/X _0152_/X _2471_/Q _2470_/Q
+ VPWR VGND sg13cmos5l_mux4_1
X_1792_ _1792_/Q Tile_X0Y3_FrameData[9] VGND VPWR Tile_X0Y9_FrameStrobe[3] latch
XFILLER_174_158 VPWR VGND sg13cmos5l_fill_2
X_3531_ Tile_X0Y9_E2BEG[5] _4853_/X VPWR VGND sg13cmos5l_buf_1
X_0743_ _0743_/Q Tile_X0Y9_FrameData[24] VGND VPWR Tile_X0Y9_FrameStrobe[2] latch
XFILLER_535_14 VPWR VGND sg13cmos5l_decap_8
XFILLER_316_163 VPWR VGND sg13cmos5l_decap_4
XANTENNA__3346__X Tile_X0Y2_FrameData_O[17] VPWR VGND sg13cmos5l_antennanp
XFILLER_682_42 VPWR VGND sg13cmos5l_decap_8
X_3462_ Tile_X0Y1_FrameData_O[20] Tile_X0Y1_FrameData[20] VPWR VGND sg13cmos5l_buf_1
X_0674_ _0674_/Q Tile_X0Y9_FrameData[29] VGND VPWR Tile_X0Y9_FrameStrobe[0] latch
XFILLER_331_133 VPWR VGND sg13cmos5l_decap_8
X_2413_ _2413_/Q Tile_X0Y5_FrameData[24] VGND VPWR Tile_X0Y9_FrameStrobe[7] latch
XFILLER_477_137 VPWR VGND sg13cmos5l_decap_8
XFILLER_331_155 VPWR VGND sg13cmos5l_fill_2
X_3393_ Tile_X0Y2_E2BEGb[4] _4052_/X VPWR VGND sg13cmos5l_buf_1
X_2344_ _2344_/Q Tile_X0Y5_FrameData[29] VGND VPWR Tile_X0Y9_FrameStrobe[5] latch
XFILLER_619_153 VPWR VGND sg13cmos5l_decap_8
XFILLER_418_204 VPWR VGND sg13cmos5l_fill_1
XFILLER_96_131 VPWR VGND sg13cmos5l_decap_4
XFILLER_619_164 VPWR VGND sg13cmos5l_fill_1
XFILLER_551_35 VPWR VGND sg13cmos5l_decap_8
XFILLER_229_115 VPWR VGND sg13cmos5l_fill_2
XFILLER_619_175 VPWR VGND sg13cmos5l_fill_2
XFILLER_229_126 VPWR VGND sg13cmos5l_fill_1
XFILLER_28_0 VPWR VGND sg13cmos5l_decap_8
XFILLER_634_112 VPWR VGND sg13cmos5l_decap_8
XFILLER_551_57 VPWR VGND sg13cmos5l_decap_8
XFILLER_270_14 VPWR VGND sg13cmos5l_decap_8
X_2275_ _2275_/Q Tile_X0Y5_FrameData[2] VGND VPWR Tile_X0Y9_FrameStrobe[2] latch
XANTENNA__3081__X Tile_X0Y4_E2BEGb[7] VPWR VGND sg13cmos5l_antennanp
X_4014_ _4014_/X _3985_/X _0095_/X _3984_/X Tile_X0Y0_S4END[6] _1221_/Q _1220_/Q VPWR
+ VGND sg13cmos5l_mux4_1
X_1226_ _1226_/Q Tile_X0Y1_FrameData[15] VGND VPWR Tile_X0Y9_FrameStrobe[1] latch
XFILLER_701_49 VPWR VGND sg13cmos5l_decap_8
XFILLER_420_28 VPWR VGND sg13cmos5l_decap_8
XFILLER_203_63 VPWR VGND sg13cmos5l_decap_8
X_1157_ _1157_/Q Tile_X0Y0_FrameData[6] VGND VPWR Tile_X0Y9_FrameStrobe[6] latch
XFILLER_398_122 VPWR VGND sg13cmos5l_decap_8
XFILLER_16_28 VPWR VGND sg13cmos5l_decap_8
XFILLER_398_133 VPWR VGND sg13cmos5l_fill_1
XFILLER_350_91 VPWR VGND sg13cmos5l_decap_8
X_0108_ AXI_M_SOC_ARBURST0 _3771_/X _0931_/Q VPWR VGND sg13cmos5l_or2_1
XFILLER_398_155 VPWR VGND sg13cmos5l_decap_8
XFILLER_401_104 VPWR VGND sg13cmos5l_decap_8
XFILLER_279_34 VPWR VGND sg13cmos5l_decap_8
X_1088_ _1088_/Q Tile_X0Y0_FrameData[11] VGND VPWR Tile_X0Y9_FrameStrobe[4] latch
XFILLER_197_217 VPWR VGND sg13cmos5l_fill_1
XFILLER_401_137 VPWR VGND sg13cmos5l_decap_8
X_4916_ _4916_/X Tile_X0Y9_N1END[0] Tile_X0Y9_N4END[0] _4896_/X _0083_/X _0727_/Q
+ _0726_/Q VPWR VGND sg13cmos5l_mux4_1
XFILLER_576_21 VPWR VGND sg13cmos5l_decap_8
XFILLER_555_130 VPWR VGND sg13cmos5l_fill_2
XFILLER_20_120 VPWR VGND sg13cmos5l_decap_8
XFILLER_32_27 VPWR VGND sg13cmos5l_decap_8
X_4847_ _4847_/X Tile_X0Y9_N1END[3] _4899_/X AXI_M_SOC_RDATA0 AXI_M_SOC_RDATA4 _0849_/Q
+ _0848_/Q VPWR VGND sg13cmos5l_mux4_1
XFILLER_20_142 VPWR VGND sg13cmos5l_decap_8
XFILLER_704_105 VPWR VGND sg13cmos5l_decap_8
XFILLER_555_174 VPWR VGND sg13cmos5l_decap_4
X_4778_ _4778_/X Tile_X0Y7_W1END[1] Tile_X0Y7_W6END[9] _4697_/X _4657_/X _0377_/Q
+ _0376_/Q VPWR VGND sg13cmos5l_mux4_1
XFILLER_576_98 VPWR VGND sg13cmos5l_decap_8
XFILLER_148_49 VPWR VGND sg13cmos5l_decap_8
XFILLER_509_70 VPWR VGND sg13cmos5l_fill_1
XFILLER_570_133 VPWR VGND sg13cmos5l_decap_8
XFILLER_295_77 VPWR VGND sg13cmos5l_decap_8
X_3729_ AXI_M_SOC_ARADDR1 Tile_X0Y9_WW4END[1] Tile_X0Y9_WW4END[9] Tile_X0Y9_W6END[1]
+ _4917_/X _0757_/Q _0756_/Q VPWR VGND sg13cmos5l_mux4_1
XFILLER_445_14 VPWR VGND sg13cmos5l_decap_8
XFILLER_228_60 VPWR VGND sg13cmos5l_decap_4
XFILLER_180_128 VPWR VGND sg13cmos5l_decap_8
XANTENNA__3256__X Tile_X0Y0_FrameData_O[24] VPWR VGND sg13cmos5l_antennanp
XFILLER_592_42 VPWR VGND sg13cmos5l_decap_8
XFILLER_228_71 VPWR VGND sg13cmos5l_decap_8
XFILLER_322_100 VPWR VGND sg13cmos5l_decap_8
XFILLER_570_199 VPWR VGND sg13cmos5l_decap_4
XFILLER_106_7 VPWR VGND sg13cmos5l_decap_8
XFILLER_712_182 VPWR VGND sg13cmos5l_fill_2
XFILLER_468_137 VPWR VGND sg13cmos5l_decap_8
XFILLER_672_207 VPWR VGND sg13cmos5l_fill_1
XFILLER_461_35 VPWR VGND sg13cmos5l_decap_8
XFILLER_244_70 VPWR VGND sg13cmos5l_decap_8
XFILLER_475_7 VPWR VGND sg13cmos5l_decap_8
XFILLER_491_140 VPWR VGND sg13cmos5l_fill_2
XFILLER_180_58 VPWR VGND sg13cmos5l_fill_2
XFILLER_611_49 VPWR VGND sg13cmos5l_decap_8
XFILLER_541_90 VPWR VGND sg13cmos5l_decap_4
XFILLER_640_126 VPWR VGND sg13cmos5l_decap_8
XFILLER_642_7 VPWR VGND sg13cmos5l_decap_8
XFILLER_330_28 VPWR VGND sg13cmos5l_decap_8
XFILLER_43_201 VPWR VGND sg13cmos5l_decap_4
XFILLER_113_74 VPWR VGND sg13cmos5l_decap_8
XFILLER_188_217 VPWR VGND sg13cmos5l_fill_1
XFILLER_389_177 VPWR VGND sg13cmos5l_decap_4
XFILLER_389_188 VPWR VGND sg13cmos5l_fill_1
XFILLER_189_56 VPWR VGND sg13cmos5l_decap_8
XFILLER_593_214 VPWR VGND sg13cmos5l_decap_4
XFILLER_486_21 VPWR VGND sg13cmos5l_decap_8
XFILLER_132_0 VPWR VGND sg13cmos5l_decap_8
XFILLER_11_142 VPWR VGND sg13cmos5l_decap_4
XFILLER_400_181 VPWR VGND sg13cmos5l_decap_8
XFILLER_486_98 VPWR VGND sg13cmos5l_decap_8
XFILLER_636_35 VPWR VGND sg13cmos5l_decap_8
XFILLER_419_70 VPWR VGND sg13cmos5l_decap_8
XFILLER_22_60 VPWR VGND sg13cmos5l_fill_1
XFILLER_360_206 VPWR VGND sg13cmos5l_fill_2
XFILLER_355_14 VPWR VGND sg13cmos5l_decap_8
XFILLER_7_179 VPWR VGND sg13cmos5l_fill_2
XFILLER_171_117 VPWR VGND sg13cmos5l_decap_8
XANTENNA__3166__X Tile_X0Y4_E6BEG[3] VPWR VGND sg13cmos5l_antennanp
XFILLER_710_119 VPWR VGND sg13cmos5l_decap_8
XFILLER_98_42 VPWR VGND sg13cmos5l_decap_8
XFILLER_459_115 VPWR VGND sg13cmos5l_decap_8
XFILLER_599_0 VPWR VGND sg13cmos5l_decap_8
XFILLER_505_28 VPWR VGND sg13cmos5l_decap_8
XFILLER_313_166 VPWR VGND sg13cmos5l_decap_8
XFILLER_652_56 VPWR VGND sg13cmos5l_decap_8
XFILLER_435_91 VPWR VGND sg13cmos5l_decap_8
XFILLER_313_199 VPWR VGND sg13cmos5l_decap_8
X_0390_ _0390_/Q Tile_X0Y7_FrameData[25] VGND VPWR Tile_X0Y9_FrameStrobe[7] latch
XFILLER_474_129 VPWR VGND sg13cmos5l_fill_2
XFILLER_371_35 VPWR VGND sg13cmos5l_decap_8
XFILLER_21_7 VPWR VGND sg13cmos5l_decap_8
XFILLER_616_134 VPWR VGND sg13cmos5l_fill_1
XFILLER_93_112 VPWR VGND sg13cmos5l_decap_8
XFILLER_304_62 VPWR VGND sg13cmos5l_decap_8
X_2060_ _2060_/Q Tile_X0Y4_FrameData[25] VGND VPWR Tile_X0Y9_FrameStrobe[4] latch
XFILLER_616_178 VPWR VGND sg13cmos5l_decap_4
XFILLER_521_49 VPWR VGND sg13cmos5l_decap_4
XFILLER_93_167 VPWR VGND sg13cmos5l_fill_2
XFILLER_631_126 VPWR VGND sg13cmos5l_decap_8
X_1011_ _1011_/Q Tile_X0Y0_FrameData[24] VGND VPWR Tile_X0Y9_FrameStrobe[2] latch
XFILLER_240_28 VPWR VGND sg13cmos5l_decap_8
XFILLER_631_137 VPWR VGND sg13cmos5l_fill_2
XFILLER_569_211 VPWR VGND sg13cmos5l_fill_1
XFILLER_179_217 VPWR VGND sg13cmos5l_fill_1
XFILLER_677_42 VPWR VGND sg13cmos5l_decap_8
XFILLER_529_119 VPWR VGND sg13cmos5l_decap_8
X_2962_ Tile_X0Y8_FrameData_O[2] Tile_X0Y8_FrameData[2] VPWR VGND sg13cmos5l_buf_1
XFILLER_396_21 VPWR VGND sg13cmos5l_decap_8
XFILLER_395_158 VPWR VGND sg13cmos5l_decap_4
XFILLER_677_86 VPWR VGND sg13cmos5l_fill_1
X_1913_ _1913_/Q Tile_X0Y3_FrameData[16] VGND VPWR Tile_X0Y9_FrameStrobe[7] latch
X_4701_ _4701_/X Tile_X0Y9_W2MID[7] Tile_X0Y9_W2END[7] Tile_X0Y9_W6END[7] _4901_/X
+ _0919_/Q _0918_/Q VPWR VGND sg13cmos5l_mux4_1
XFILLER_537_130 VPWR VGND sg13cmos5l_decap_8
XFILLER_395_169 VPWR VGND sg13cmos5l_decap_8
X_2893_ Tile_X0Y6_FrameData_O[14] Tile_X0Y6_FrameData[14] VPWR VGND sg13cmos5l_buf_1
X_4632_ _4632_/X Tile_X0Y7_WW4END[11] AXI_M_SOC_RDATA20 _4695_/X _4675_/X _0295_/Q
+ _0294_/Q VPWR VGND sg13cmos5l_mux4_1
X_1844_ _1844_/Q Tile_X0Y3_FrameData[21] VGND VPWR Tile_X0Y9_FrameStrobe[5] latch
XFILLER_537_185 VPWR VGND sg13cmos5l_fill_1
XFILLER_546_35 VPWR VGND sg13cmos5l_decap_8
XFILLER_8_84 VPWR VGND sg13cmos5l_decap_8
XFILLER_698_137 VPWR VGND sg13cmos5l_decap_8
XFILLER_329_92 VPWR VGND sg13cmos5l_decap_8
X_4563_ _4563_/X _4121_/X _4125_/X _4110_/X _4100_/X _1610_/Q _1609_/Q VPWR VGND sg13cmos5l_mux4_1
XFILLER_693_63 VPWR VGND sg13cmos5l_decap_8
XFILLER_265_14 VPWR VGND sg13cmos5l_decap_8
X_1775_ _1775_/Q Tile_X0Y3_FrameData[26] VGND VPWR Tile_X0Y9_FrameStrobe[3] latch
XFILLER_162_128 VPWR VGND sg13cmos5l_fill_1
XANTENNA__3076__X Tile_X0Y4_E2BEGb[2] VPWR VGND sg13cmos5l_antennanp
XFILLER_304_100 VPWR VGND sg13cmos5l_decap_8
X_3514_ Tile_X0Y1_E2BEG[4] _3936_/X VPWR VGND sg13cmos5l_buf_1
XFILLER_701_119 VPWR VGND sg13cmos5l_decap_8
X_0726_ _0726_/Q Tile_X0Y9_FrameData[9] VGND VPWR Tile_X0Y9_FrameStrobe[1] latch
X_4494_ _4494_/X _4549_/X _4548_/X AXI_M_SOC_RDATA25 AXI_M_SOC_RDATA29 _2619_/Q _2618_/Q
+ VPWR VGND sg13cmos5l_mux4_1
X_3445_ Tile_X0Y1_FrameData_O[3] Tile_X0Y1_FrameData[3] VPWR VGND sg13cmos5l_buf_1
XFILLER_415_28 VPWR VGND sg13cmos5l_decap_8
X_0657_ _0657_/Q Tile_X0Y8_FrameData[14] VGND VPWR Tile_X0Y9_FrameStrobe[7] latch
XFILLER_103_217 VPWR VGND sg13cmos5l_fill_1
XFILLER_562_56 VPWR VGND sg13cmos5l_decap_8
XFILLER_345_91 VPWR VGND sg13cmos5l_decap_8
XFILLER_654_207 VPWR VGND sg13cmos5l_decap_8
XFILLER_465_118 VPWR VGND sg13cmos5l_decap_8
X_3376_ Tile_X0Y2_EE4BEG[15] _4071_/X VPWR VGND sg13cmos5l_buf_1
XFILLER_281_35 VPWR VGND sg13cmos5l_decap_8
X_0588_ _0588_/Q Tile_X0Y8_FrameData[19] VGND VPWR Tile_X0Y9_FrameStrobe[5] latch
XFILLER_69_164 VPWR VGND sg13cmos5l_fill_2
X_2327_ _2327_/Q Tile_X0Y5_FrameData[14] VGND VPWR Tile_X0Y9_FrameStrobe[4] latch
XFILLER_217_118 VPWR VGND sg13cmos5l_decap_8
X_2258_ _2258_/Q Tile_X0Y5_FrameData[19] VGND VPWR Tile_X0Y9_FrameStrobe[2] latch
XFILLER_431_49 VPWR VGND sg13cmos5l_decap_8
XFILLER_361_90 VPWR VGND sg13cmos5l_decap_8
XFILLER_214_84 VPWR VGND sg13cmos5l_decap_8
XFILLER_27_49 VPWR VGND sg13cmos5l_decap_8
X_1209_ _1209_/Q Tile_X0Y1_FrameData[0] VGND VPWR Tile_X0Y9_FrameStrobe[0] latch
XFILLER_150_28 VPWR VGND sg13cmos5l_decap_8
X_2189_ _2189_/Q Tile_X0Y5_FrameData[24] VGND VPWR Tile_X0Y9_FrameStrobe[0] latch
XFILLER_575_203 VPWR VGND sg13cmos5l_decap_8
XFILLER_587_42 VPWR VGND sg13cmos5l_decap_8
XFILLER_43_48 VPWR VGND sg13cmos5l_decap_8
XFILLER_43_59 VPWR VGND sg13cmos5l_fill_2
XFILLER_528_130 VPWR VGND sg13cmos5l_decap_8
XFILLER_240_187 VPWR VGND sg13cmos5l_decap_4
XFILLER_590_217 VPWR VGND sg13cmos5l_fill_1
XFILLER_528_185 VPWR VGND sg13cmos5l_decap_8
XFILLER_223_7 VPWR VGND sg13cmos5l_decap_8
XFILLER_138_147 VPWR VGND sg13cmos5l_decap_8
XFILLER_456_35 VPWR VGND sg13cmos5l_decap_8
XFILLER_239_70 VPWR VGND sg13cmos5l_decap_8
XFILLER_138_169 VPWR VGND sg13cmos5l_decap_8
XFILLER_175_14 VPWR VGND sg13cmos5l_decap_8
XFILLER_153_117 VPWR VGND sg13cmos5l_decap_4
XFILLER_342_217 VPWR VGND sg13cmos5l_fill_1
XFILLER_153_128 VPWR VGND sg13cmos5l_decap_8
XFILLER_606_49 VPWR VGND sg13cmos5l_decap_8
XFILLER_325_28 VPWR VGND sg13cmos5l_decap_8
XFILLER_592_7 VPWR VGND sg13cmos5l_decap_8
XANTENNA__3714__X AXI_M_SOC_WDATA24 VPWR VGND sg13cmos5l_antennanp
XFILLER_456_107 VPWR VGND sg13cmos5l_decap_8
XFILLER_191_13 VPWR VGND sg13cmos5l_decap_8
XFILLER_248_210 VPWR VGND sg13cmos5l_fill_2
XFILLER_68_78 VPWR VGND sg13cmos5l_decap_8
XFILLER_405_61 VPWR VGND sg13cmos5l_fill_1
XFILLER_310_169 VPWR VGND sg13cmos5l_decap_8
XFILLER_405_83 VPWR VGND sg13cmos5l_decap_8
XFILLER_405_94 VPWR VGND sg13cmos5l_fill_1
XFILLER_208_118 VPWR VGND sg13cmos5l_decap_8
XFILLER_208_129 VPWR VGND sg13cmos5l_fill_2
XFILLER_341_49 VPWR VGND sg13cmos5l_decap_8
XFILLER_124_84 VPWR VGND sg13cmos5l_decap_8
XFILLER_702_70 VPWR VGND sg13cmos5l_decap_8
XFILLER_84_66 VPWR VGND sg13cmos5l_decap_4
XFILLER_216_140 VPWR VGND sg13cmos5l_decap_8
XFILLER_613_159 VPWR VGND sg13cmos5l_fill_1
XFILLER_90_148 VPWR VGND sg13cmos5l_fill_2
XFILLER_231_110 VPWR VGND sg13cmos5l_decap_4
XFILLER_377_103 VPWR VGND sg13cmos5l_fill_1
XFILLER_497_42 VPWR VGND sg13cmos5l_decap_8
XFILLER_377_125 VPWR VGND sg13cmos5l_decap_8
XFILLER_347_0 VPWR VGND sg13cmos5l_decap_8
XFILLER_231_198 VPWR VGND sg13cmos5l_decap_8
XFILLER_581_217 VPWR VGND sg13cmos5l_fill_1
XFILLER_514_0 VPWR VGND sg13cmos5l_decap_8
XFILLER_647_56 VPWR VGND sg13cmos5l_decap_8
XFILLER_392_139 VPWR VGND sg13cmos5l_decap_8
XFILLER_534_122 VPWR VGND sg13cmos5l_fill_1
XFILLER_366_35 VPWR VGND sg13cmos5l_decap_8
XFILLER_534_144 VPWR VGND sg13cmos5l_decap_8
XFILLER_129_169 VPWR VGND sg13cmos5l_fill_2
XFILLER_534_155 VPWR VGND sg13cmos5l_fill_2
XFILLER_144_106 VPWR VGND sg13cmos5l_fill_1
XFILLER_333_206 VPWR VGND sg13cmos5l_decap_4
XFILLER_534_166 VPWR VGND sg13cmos5l_fill_1
XFILLER_333_217 VPWR VGND sg13cmos5l_fill_1
XFILLER_144_128 VPWR VGND sg13cmos5l_decap_8
XFILLER_137_180 VPWR VGND sg13cmos5l_decap_8
X_1560_ _1560_/Q Tile_X0Y2_FrameData[25] VGND VPWR Tile_X0Y9_FrameStrobe[4] latch
XFILLER_516_49 VPWR VGND sg13cmos5l_decap_8
XFILLER_298_121 VPWR VGND sg13cmos5l_fill_2
X_0511_ _0511_/Q Tile_X0Y8_FrameData[0] VGND VPWR Tile_X0Y9_FrameStrobe[2] latch
XFILLER_663_77 VPWR VGND sg13cmos5l_decap_8
X_1491_ _1491_/Q Tile_X0Y2_FrameData[30] VGND VPWR Tile_X0Y9_FrameStrobe[2] latch
XANTENNA__3624__X Tile_X0Y9_S4BEG[2] VPWR VGND sg13cmos5l_antennanp
X_3230_ Tile_X0Y0_FrameStrobe_O[18] Tile_X0Y9_FrameStrobe[18] VPWR VGND sg13cmos5l_buf_1
XFILLER_636_207 VPWR VGND sg13cmos5l_fill_1
XFILLER_298_187 VPWR VGND sg13cmos5l_decap_8
X_0442_ _0442_/Q Tile_X0Y8_FrameData[5] VGND VPWR Tile_X0Y9_FrameStrobe[0] latch
XFILLER_301_169 VPWR VGND sg13cmos5l_decap_4
X_3161_ Tile_X0Y7_FrameData_O[31] Tile_X0Y7_FrameData[31] VPWR VGND sg13cmos5l_buf_1
X_0373_ _0373_/Q Tile_X0Y7_FrameData[10] VGND VPWR Tile_X0Y9_FrameStrobe[6] latch
XFILLER_66_112 VPWR VGND sg13cmos5l_decap_8
XFILLER_251_27 VPWR VGND sg13cmos5l_decap_4
X_2112_ _2112_/Q Tile_X0Y4_FrameData[5] VGND VPWR Tile_X0Y9_FrameStrobe[5] latch
X_3092_ Tile_X0Y7_E2BEG[6] _4618_/X VPWR VGND sg13cmos5l_buf_1
XFILLER_612_70 VPWR VGND sg13cmos5l_decap_8
XFILLER_470_121 VPWR VGND sg13cmos5l_decap_8
X_2043_ _2043_/Q Tile_X0Y4_FrameData[10] VGND VPWR Tile_X0Y9_FrameStrobe[3] latch
XFILLER_66_189 VPWR VGND sg13cmos5l_fill_1
XFILLER_604_159 VPWR VGND sg13cmos5l_decap_8
XFILLER_331_60 VPWR VGND sg13cmos5l_fill_2
XFILLER_22_204 VPWR VGND sg13cmos5l_decap_8
XFILLER_222_143 VPWR VGND sg13cmos5l_decap_8
X_3994_ _3994_/X _3896_/X _4029_/X _4028_/X Tile_X0Y0_S2MID[4] _1193_/Q _1192_/Q VPWR
+ VGND sg13cmos5l_mux4_1
XFILLER_95_0 VPWR VGND sg13cmos5l_decap_8
XFILLER_200_42 VPWR VGND sg13cmos5l_decap_8
X_2945_ Tile_X0Y8_EE4BEG[1] _4745_/X VPWR VGND sg13cmos5l_buf_1
XFILLER_309_203 VPWR VGND sg13cmos5l_decap_8
XFILLER_557_56 VPWR VGND sg13cmos5l_decap_8
XFILLER_714_200 VPWR VGND sg13cmos5l_fill_1
XFILLER_714_211 VPWR VGND sg13cmos5l_fill_1
X_2876_ Tile_X0Y6_EE4BEG[13] _4525_/X VPWR VGND sg13cmos5l_buf_1
XFILLER_376_191 VPWR VGND sg13cmos5l_decap_8
XFILLER_276_35 VPWR VGND sg13cmos5l_decap_8
X_1827_ _1827_/Q Tile_X0Y3_FrameData[6] VGND VPWR Tile_X0Y9_FrameStrobe[4] latch
X_4615_ _4615_/X Tile_X0Y7_W2MID[4] AXI_M_SOC_RDATA19 _4675_/X _4674_/X _0329_/Q _0328_/Q
+ VPWR VGND sg13cmos5l_mux4_1
XFILLER_391_150 VPWR VGND sg13cmos5l_decap_8
X_4546_ _4546_/X Tile_X0Y5_W1END[1] Tile_X0Y5_W6END[9] _4464_/X _4419_/X _2401_/Q
+ _2400_/Q VPWR VGND sg13cmos5l_mux4_1
X_1758_ _1758_/Q Tile_X0Y3_FrameData[11] VGND VPWR Tile_X0Y9_FrameStrobe[2] latch
XFILLER_426_49 VPWR VGND sg13cmos5l_decap_8
XFILLER_209_84 VPWR VGND sg13cmos5l_decap_8
XFILLER_679_181 VPWR VGND sg13cmos5l_decap_8
XFILLER_573_77 VPWR VGND sg13cmos5l_decap_8
X_0709_ _0709_/Q Tile_X0Y9_FrameData[26] VGND VPWR Tile_X0Y9_FrameStrobe[1] latch
XFILLER_145_28 VPWR VGND sg13cmos5l_decap_8
X_4477_ _4477_/X Tile_X0Y7_W2MID[3] Tile_X0Y7_W2END[3] Tile_X0Y7_W6END[3] _4674_/X
+ _0399_/Q _0398_/Q VPWR VGND sg13cmos5l_mux4_1
X_1689_ _1689_/Q Tile_X0Y3_FrameData[16] VGND VPWR Tile_X0Y9_FrameStrobe[0] latch
XFILLER_289_165 VPWR VGND sg13cmos5l_fill_1
XANTENNA__3534__X Tile_X0Y9_E2BEGb[0] VPWR VGND sg13cmos5l_antennanp
XFILLER_292_56 VPWR VGND sg13cmos5l_decap_8
XFILLER_143_194 VPWR VGND sg13cmos5l_decap_4
X_3428_ Tile_X0Y4_FrameData_O[19] Tile_X0Y4_FrameData[19] VPWR VGND sg13cmos5l_buf_1
XFILLER_289_187 VPWR VGND sg13cmos5l_decap_8
XFILLER_38_26 VPWR VGND sg13cmos5l_decap_8
X_3359_ Tile_X0Y2_FrameData_O[30] Tile_X0Y2_FrameData[30] VPWR VGND sg13cmos5l_buf_1
XFILLER_57_123 VPWR VGND sg13cmos5l_decap_8
XFILLER_446_162 VPWR VGND sg13cmos5l_decap_4
XFILLER_300_180 VPWR VGND sg13cmos5l_fill_2
XFILLER_161_38 VPWR VGND sg13cmos5l_decap_8
XFILLER_522_70 VPWR VGND sg13cmos5l_decap_4
XFILLER_650_210 VPWR VGND sg13cmos5l_decap_8
XFILLER_72_104 VPWR VGND sg13cmos5l_decap_8
XFILLER_241_71 VPWR VGND sg13cmos5l_fill_2
XFILLER_260_216 VPWR VGND sg13cmos5l_fill_2
XFILLER_598_63 VPWR VGND sg13cmos5l_decap_8
XFILLER_598_74 VPWR VGND sg13cmos5l_fill_2
XFILLER_54_58 VPWR VGND sg13cmos5l_decap_8
XFILLER_548_203 VPWR VGND sg13cmos5l_fill_2
XFILLER_603_181 VPWR VGND sg13cmos5l_fill_1
XFILLER_598_85 VPWR VGND sg13cmos5l_fill_1
XFILLER_340_7 VPWR VGND sg13cmos5l_decap_8
XFILLER_438_7 VPWR VGND sg13cmos5l_decap_8
XFILLER_213_154 VPWR VGND sg13cmos5l_decap_8
XFILLER_110_20 VPWR VGND sg13cmos5l_decap_8
XFILLER_374_106 VPWR VGND sg13cmos5l_decap_8
XFILLER_110_75 VPWR VGND sg13cmos5l_decap_8
XFILLER_70_35 VPWR VGND sg13cmos5l_decap_8
XANTENNA__3709__X AXI_M_SOC_WDATA19 VPWR VGND sg13cmos5l_antennanp
XFILLER_374_139 VPWR VGND sg13cmos5l_decap_8
XFILLER_110_97 VPWR VGND sg13cmos5l_decap_4
XFILLER_605_7 VPWR VGND sg13cmos5l_decap_8
XFILLER_186_35 VPWR VGND sg13cmos5l_decap_8
XFILLER_516_144 VPWR VGND sg13cmos5l_decap_8
XFILLER_382_150 VPWR VGND sg13cmos5l_decap_8
XFILLER_516_166 VPWR VGND sg13cmos5l_decap_8
XFILLER_207_2 VPWR VGND sg13cmos5l_fill_1
XFILLER_336_49 VPWR VGND sg13cmos5l_decap_8
XFILLER_119_95 VPWR VGND sg13cmos5l_decap_4
XFILLER_330_209 VPWR VGND sg13cmos5l_decap_8
XFILLER_633_14 VPWR VGND sg13cmos5l_decap_8
XANTENNA__3444__X Tile_X0Y1_FrameData_O[2] VPWR VGND sg13cmos5l_antennanp
XFILLER_685_184 VPWR VGND sg13cmos5l_decap_4
XFILLER_295_146 VPWR VGND sg13cmos5l_decap_8
XFILLER_95_21 VPWR VGND sg13cmos5l_decap_8
XFILLER_297_0 VPWR VGND sg13cmos5l_decap_8
XFILLER_0_185 VPWR VGND sg13cmos5l_decap_8
XFILLER_713_91 VPWR VGND sg13cmos5l_decap_8
XFILLER_95_54 VPWR VGND sg13cmos5l_decap_8
XFILLER_95_98 VPWR VGND sg13cmos5l_fill_2
XFILLER_48_167 VPWR VGND sg13cmos5l_fill_1
XFILLER_432_70 VPWR VGND sg13cmos5l_decap_8
XFILLER_464_0 VPWR VGND sg13cmos5l_decap_8
XFILLER_452_121 VPWR VGND sg13cmos5l_decap_8
XFILLER_598_136 VPWR VGND sg13cmos5l_decap_8
XFILLER_63_137 VPWR VGND sg13cmos5l_decap_8
XFILLER_251_216 VPWR VGND sg13cmos5l_fill_2
XFILLER_631_0 VPWR VGND sg13cmos5l_decap_8
XFILLER_539_203 VPWR VGND sg13cmos5l_decap_8
XFILLER_539_214 VPWR VGND sg13cmos5l_decap_4
XFILLER_204_187 VPWR VGND sg13cmos5l_decap_8
X_0991_ _0991_/Q Tile_X0Y0_FrameData[12] VGND VPWR Tile_X0Y9_FrameStrobe[1] latch
XFILLER_554_217 VPWR VGND sg13cmos5l_fill_1
XFILLER_365_117 VPWR VGND sg13cmos5l_decap_8
XANTENNA__3619__X Tile_X0Y9_S2BEGb[5] VPWR VGND sg13cmos5l_antennanp
XFILLER_81_6 VPWR VGND sg13cmos5l_decap_8
XFILLER_377_56 VPWR VGND sg13cmos5l_decap_4
X_2730_ _3860_/A3 VPWR VGND sg13cmos5l_tielo
XFILLER_377_89 VPWR VGND sg13cmos5l_decap_8
XFILLER_674_21 VPWR VGND sg13cmos5l_decap_8
X_2661_ _2661_/Q Tile_X0Y6_FrameData[2] VGND VPWR Tile_X0Y9_FrameStrobe[6] latch
X_4400_ _4400_/X Tile_X0Y5_WW4END[3] AXI_M_SOC_RRESP1 _4454_/X _4434_/X _2303_/Q _2302_/Q
+ VPWR VGND sg13cmos5l_mux4_1
XFILLER_373_183 VPWR VGND sg13cmos5l_decap_8
X_1612_ _1612_/Q Tile_X0Y2_FrameData[5] VGND VPWR Tile_X0Y9_FrameStrobe[5] latch
XFILLER_507_199 VPWR VGND sg13cmos5l_decap_8
X_2592_ _2592_/Q Tile_X0Y6_FrameData[7] VGND VPWR Tile_X0Y9_FrameStrobe[4] latch
XFILLER_246_49 VPWR VGND sg13cmos5l_decap_4
XFILLER_607_70 VPWR VGND sg13cmos5l_decap_8
XFILLER_522_147 VPWR VGND sg13cmos5l_decap_8
XFILLER_176_90 VPWR VGND sg13cmos5l_fill_2
X_4331_ _4331_/X _4806_/X _4810_/X _4814_/X _4789_/X _0641_/Q _0640_/Q VPWR VGND sg13cmos5l_mux4_1
X_1543_ _1543_/Q Tile_X0Y2_FrameData[10] VGND VPWR Tile_X0Y9_FrameStrobe[3] latch
XFILLER_543_14 VPWR VGND sg13cmos5l_decap_8
XFILLER_5_63 VPWR VGND sg13cmos5l_decap_8
XFILLER_125_172 VPWR VGND sg13cmos5l_fill_2
XANTENNA__3354__X Tile_X0Y2_FrameData_O[25] VPWR VGND sg13cmos5l_antennanp
XFILLER_690_42 VPWR VGND sg13cmos5l_fill_2
X_4262_ _4262_/X Tile_X0Y4_W2MID[1] AXI_M_SOC_BRESP0 _4315_/X _4314_/X _2089_/Q _2088_/Q
+ VPWR VGND sg13cmos5l_mux4_1
X_1474_ _1474_/Q Tile_X0Y2_FrameData[15] VGND VPWR Tile_X0Y9_FrameStrobe[1] latch
X_3213_ Tile_X0Y0_FrameStrobe_O[1] Tile_X0Y9_FrameStrobe[1] VPWR VGND sg13cmos5l_buf_1
X_0425_ _0425_/Q Tile_X0Y8_FrameData[22] VGND VPWR Tile_X0Y9_FrameStrobe[0] latch
XFILLER_39_101 VPWR VGND sg13cmos5l_decap_8
X_4193_ _4193_/X _4203_/X Tile_X0Y3_W6END[3] _4202_/X _4193_/A3 _1675_/Q _1926_/Q
+ VPWR VGND sg13cmos5l_mux4_1
XFILLER_428_140 VPWR VGND sg13cmos5l_decap_8
XFILLER_623_91 VPWR VGND sg13cmos5l_decap_8
X_3144_ Tile_X0Y7_FrameData_O[14] Tile_X0Y7_FrameData[14] VPWR VGND sg13cmos5l_buf_1
X_0356_ _0356_/Q Tile_X0Y7_FrameData[27] VGND VPWR Tile_X0Y9_FrameStrobe[6] latch
XFILLER_10_0 VPWR VGND sg13cmos5l_decap_8
XFILLER_691_198 VPWR VGND sg13cmos5l_decap_4
XFILLER_342_70 VPWR VGND sg13cmos5l_decap_8
X_3075_ Tile_X0Y4_E2BEGb[1] _4265_/X VPWR VGND sg13cmos5l_buf_1
XFILLER_589_136 VPWR VGND sg13cmos5l_decap_8
X_0287_ _0287_/Q Tile_X0Y7_FrameData[0] VGND VPWR Tile_X0Y9_FrameStrobe[3] latch
XFILLER_699_84 VPWR VGND sg13cmos5l_decap_8
XFILLER_443_165 VPWR VGND sg13cmos5l_decap_8
X_2026_ _2026_/Q Tile_X0Y4_FrameData[27] VGND VPWR Tile_X0Y9_FrameStrobe[3] latch
XFILLER_211_63 VPWR VGND sg13cmos5l_decap_8
XFILLER_62_170 VPWR VGND sg13cmos5l_decap_8
XFILLER_24_28 VPWR VGND sg13cmos5l_decap_8
XFILLER_568_77 VPWR VGND sg13cmos5l_decap_8
X_3977_ _3977_/X _3983_/X Tile_X0Y1_W6END[1] _3982_/X _3977_/A3 _1183_/Q _1182_/Q
+ VPWR VGND sg13cmos5l_mux4_1
XFILLER_545_217 VPWR VGND sg13cmos5l_fill_1
XFILLER_287_56 VPWR VGND sg13cmos5l_decap_8
XFILLER_210_146 VPWR VGND sg13cmos5l_decap_8
XANTENNA__3529__X Tile_X0Y9_E2BEG[3] VPWR VGND sg13cmos5l_antennanp
XFILLER_349_180 VPWR VGND sg13cmos5l_decap_8
X_2928_ Tile_X0Y8_E2BEGb[4] _4740_/X VPWR VGND sg13cmos5l_buf_1
XFILLER_210_179 VPWR VGND sg13cmos5l_fill_1
XFILLER_584_21 VPWR VGND sg13cmos5l_decap_8
XFILLER_40_16 VPWR VGND sg13cmos5l_decap_8
X_2859_ Tile_X0Y6_E6BEG[8] _4536_/X VPWR VGND sg13cmos5l_buf_1
XFILLER_364_194 VPWR VGND sg13cmos5l_decap_8
XFILLER_513_136 VPWR VGND sg13cmos5l_decap_8
XFILLER_517_70 VPWR VGND sg13cmos5l_decap_4
XFILLER_517_81 VPWR VGND sg13cmos5l_decap_8
X_4529_ _4529_/X Tile_X0Y9_N4END[13] _0153_/X _4578_/X _4582_/X _2549_/Q _2548_/Q
+ VPWR VGND sg13cmos5l_mux4_1
XFILLER_453_14 VPWR VGND sg13cmos5l_decap_8
XANTENNA__3264__X Tile_X0Y0_EE4BEG[0] VPWR VGND sg13cmos5l_antennanp
XFILLER_521_180 VPWR VGND sg13cmos5l_decap_8
XFILLER_49_36 VPWR VGND sg13cmos5l_decap_8
XFILLER_453_69 VPWR VGND sg13cmos5l_decap_8
XFILLER_131_142 VPWR VGND sg13cmos5l_decap_8
XFILLER_290_7 VPWR VGND sg13cmos5l_decap_8
XFILLER_277_157 VPWR VGND sg13cmos5l_decap_4
XFILLER_682_143 VPWR VGND sg13cmos5l_decap_8
XFILLER_603_28 VPWR VGND sg13cmos5l_decap_8
XFILLER_277_168 VPWR VGND sg13cmos5l_fill_2
XFILLER_388_7 VPWR VGND sg13cmos5l_decap_8
XFILLER_105_20 VPWR VGND sg13cmos5l_decap_8
XFILLER_481_205 VPWR VGND sg13cmos5l_fill_1
XFILLER_533_91 VPWR VGND sg13cmos5l_decap_8
XFILLER_434_121 VPWR VGND sg13cmos5l_decap_8
XFILLER_555_7 VPWR VGND sg13cmos5l_decap_8
XFILLER_65_68 VPWR VGND sg13cmos5l_decap_8
XFILLER_121_63 VPWR VGND sg13cmos5l_decap_8
XFILLER_715_6 VPWR VGND sg13cmos5l_decap_8
XFILLER_628_14 VPWR VGND sg13cmos5l_decap_8
XFILLER_197_56 VPWR VGND sg13cmos5l_decap_8
XANTENNA__3439__X Tile_X0Y4_FrameData_O[30] VPWR VGND sg13cmos5l_antennanp
XFILLER_201_168 VPWR VGND sg13cmos5l_decap_8
XFILLER_494_21 VPWR VGND sg13cmos5l_decap_8
XFILLER_355_161 VPWR VGND sg13cmos5l_decap_4
XFILLER_212_0 VPWR VGND sg13cmos5l_fill_2
XFILLER_708_91 VPWR VGND sg13cmos5l_decap_8
XFILLER_494_98 VPWR VGND sg13cmos5l_decap_8
XFILLER_504_147 VPWR VGND sg13cmos5l_decap_8
XFILLER_644_35 VPWR VGND sg13cmos5l_decap_8
XFILLER_427_70 VPWR VGND sg13cmos5l_decap_8
XFILLER_658_140 VPWR VGND sg13cmos5l_decap_8
XANTENNA__3174__X Tile_X0Y4_E6BEG[11] VPWR VGND sg13cmos5l_antennanp
XFILLER_658_151 VPWR VGND sg13cmos5l_fill_2
XFILLER_122_142 VPWR VGND sg13cmos5l_fill_2
XFILLER_581_0 VPWR VGND sg13cmos5l_decap_8
XFILLER_658_195 VPWR VGND sg13cmos5l_fill_1
XFILLER_679_0 VPWR VGND sg13cmos5l_decap_8
XFILLER_513_28 VPWR VGND sg13cmos5l_decap_8
XFILLER_283_105 VPWR VGND sg13cmos5l_decap_8
XFILLER_660_56 VPWR VGND sg13cmos5l_decap_8
XFILLER_209_202 VPWR VGND sg13cmos5l_fill_2
X_0210_ _0210_/Q Tile_X0Y7_FrameData[13] VGND VPWR Tile_X0Y9_FrameStrobe[1] latch
XFILLER_39_80 VPWR VGND sg13cmos5l_decap_8
X_1190_ _1190_/Q Tile_X0Y1_FrameData[19] VGND VPWR Tile_X0Y9_FrameStrobe[0] latch
X_0141_ AXI_M_SOC_ARLEN1 _0933_/Q _3761_/X VPWR VGND sg13cmos5l_nor2b_1
XFILLER_425_154 VPWR VGND sg13cmos5l_decap_8
XFILLER_669_21 VPWR VGND sg13cmos5l_decap_8
XFILLER_291_182 VPWR VGND sg13cmos5l_decap_4
X_0072_ AXI_M_SOC_AWCACHE3 _0936_/Q _3688_/X VPWR VGND sg13cmos5l_nor2b_1
XFILLER_669_43 VPWR VGND sg13cmos5l_decap_8
XFILLER_586_106 VPWR VGND sg13cmos5l_decap_8
XFILLER_440_146 VPWR VGND sg13cmos5l_decap_4
X_3900_ _3900_/X Tile_X0Y2_W2MID[1] Tile_X0Y2_W2END[1] Tile_X0Y2_W6END[1] _4098_/X
+ _1653_/Q _1652_/Q VPWR VGND sg13cmos5l_mux4_1
X_4880_ _4880_/X Tile_X0Y9_N4END[0] _0083_/X _4927_/X _4931_/X _0783_/Q _0782_/Q VPWR
+ VGND sg13cmos5l_mux4_1
XFILLER_388_66 VPWR VGND sg13cmos5l_fill_1
X_3831_ _3831_/X Tile_X0Y0_WW4END[4] Tile_X0Y0_WW4END[11] _3885_/X _3858_/X _1043_/Q
+ _1042_/Q VPWR VGND sg13cmos5l_mux4_1
XFILLER_538_14 VPWR VGND sg13cmos5l_decap_8
XFILLER_338_117 VPWR VGND sg13cmos5l_decap_4
XANTENNA__3349__X Tile_X0Y2_FrameData_O[20] VPWR VGND sg13cmos5l_antennanp
XFILLER_685_42 VPWR VGND sg13cmos5l_decap_8
X_3762_ _3762_/X Tile_X0Y1_WW4END[3] Tile_X0Y1_WW4END[11] Tile_X0Y1_W6END[3] _4011_/X
+ _1251_/Q _1250_/Q VPWR VGND sg13cmos5l_mux4_1
X_0974_ _0974_/Q Tile_X0Y0_FrameData[29] VGND VPWR Tile_X0Y9_FrameStrobe[1] latch
X_2713_ _4542_/A3 VPWR VGND sg13cmos5l_tielo
X_3693_ AXI_M_SOC_WDATA3 Tile_X0Y7_WW4END[3] Tile_X0Y7_WW4END[11] Tile_X0Y7_W6END[3]
+ _4687_/X _0241_/Q _0240_/Q VPWR VGND sg13cmos5l_mux4_1
XFILLER_618_91 VPWR VGND sg13cmos5l_decap_8
X_2644_ _2644_/Q Tile_X0Y6_FrameData[19] VGND VPWR Tile_X0Y9_FrameStrobe[6] latch
XFILLER_554_35 VPWR VGND sg13cmos5l_decap_8
XFILLER_337_70 VPWR VGND sg13cmos5l_decap_4
XFILLER_58_0 VPWR VGND sg13cmos5l_decap_4
XFILLER_361_164 VPWR VGND sg13cmos5l_fill_2
XFILLER_273_14 VPWR VGND sg13cmos5l_decap_8
X_2575_ _2575_/Q Tile_X0Y6_FrameData[24] VGND VPWR Tile_X0Y9_FrameStrobe[4] latch
XFILLER_649_140 VPWR VGND sg13cmos5l_decap_8
XANTENNA__3084__X Tile_X0Y7_E1BEG[2] VPWR VGND sg13cmos5l_antennanp
X_1526_ _1526_/Q Tile_X0Y2_FrameData[27] VGND VPWR Tile_X0Y9_FrameStrobe[3] latch
X_4314_ _4314_/X _4249_/X _4365_/X _4364_/X _4248_/X _1937_/Q _1936_/Q VPWR VGND sg13cmos5l_mux4_1
XFILLER_704_49 VPWR VGND sg13cmos5l_decap_8
XFILLER_259_135 VPWR VGND sg13cmos5l_fill_1
XFILLER_206_41 VPWR VGND sg13cmos5l_decap_8
X_4245_ _4245_/X Tile_X0Y5_W2MID[3] Tile_X0Y5_W2END[3] Tile_X0Y5_W6END[3] _4433_/X
+ _2423_/Q _2422_/Q VPWR VGND sg13cmos5l_mux4_1
XFILLER_423_28 VPWR VGND sg13cmos5l_decap_8
X_1457_ _1457_/Q Tile_X0Y2_FrameData[0] VGND VPWR Tile_X0Y9_FrameStrobe[0] latch
XFILLER_274_105 VPWR VGND sg13cmos5l_decap_8
XFILLER_570_56 VPWR VGND sg13cmos5l_decap_8
XFILLER_19_28 VPWR VGND sg13cmos5l_decap_8
XFILLER_353_91 VPWR VGND sg13cmos5l_decap_8
X_0408_ _0408_/Q Tile_X0Y7_FrameData[7] VGND VPWR Tile_X0Y9_FrameStrobe[7] latch
X_4176_ _4176_/X Tile_X0Y3_WW4END[3] AXI_M_SOC_BVALID _4225_/X _4211_/X _1789_/Q _1788_/Q
+ VPWR VGND sg13cmos5l_mux4_1
X_1388_ _1388_/Q Tile_X0Y1_FrameData[13] VGND VPWR Tile_X0Y9_FrameStrobe[6] latch
X_3127_ Tile_X0Y7_EE4BEG[13] _4641_/X VPWR VGND sg13cmos5l_buf_1
X_0339_ _0339_/Q Tile_X0Y7_FrameData[12] VGND VPWR Tile_X0Y9_FrameStrobe[5] latch
XFILLER_416_154 VPWR VGND sg13cmos5l_decap_8
XFILLER_579_21 VPWR VGND sg13cmos5l_decap_8
XFILLER_27_159 VPWR VGND sg13cmos5l_fill_1
X_3058_ Tile_X0Y5_FrameData_O[17] Tile_X0Y5_FrameData[17] VPWR VGND sg13cmos5l_buf_1
XFILLER_222_84 VPWR VGND sg13cmos5l_fill_2
XFILLER_431_135 VPWR VGND sg13cmos5l_decap_8
XFILLER_35_49 VPWR VGND sg13cmos5l_decap_8
X_2009_ _2009_/Q Tile_X0Y4_FrameData[12] VGND VPWR Tile_X0Y9_FrameStrobe[2] latch
XFILLER_230_208 VPWR VGND sg13cmos5l_decap_8
XFILLER_579_98 VPWR VGND sg13cmos5l_decap_8
XFILLER_518_206 VPWR VGND sg13cmos5l_decap_8
XFILLER_329_106 VPWR VGND sg13cmos5l_fill_2
XFILLER_448_14 VPWR VGND sg13cmos5l_decap_8
XFILLER_518_217 VPWR VGND sg13cmos5l_fill_1
XFILLER_195_123 VPWR VGND sg13cmos5l_decap_8
XANTENNA__3259__X Tile_X0Y0_FrameData_O[27] VPWR VGND sg13cmos5l_antennanp
XFILLER_595_42 VPWR VGND sg13cmos5l_decap_8
XFILLER_50_173 VPWR VGND sg13cmos5l_decap_8
XFILLER_136_7 VPWR VGND sg13cmos5l_decap_8
XFILLER_51_48 VPWR VGND sg13cmos5l_decap_8
XFILLER_344_109 VPWR VGND sg13cmos5l_decap_8
XFILLER_337_194 VPWR VGND sg13cmos5l_fill_2
XFILLER_303_7 VPWR VGND sg13cmos5l_decap_8
XFILLER_464_35 VPWR VGND sg13cmos5l_decap_8
XFILLER_247_70 VPWR VGND sg13cmos5l_decap_8
XFILLER_498_168 VPWR VGND sg13cmos5l_decap_8
XFILLER_2_214 VPWR VGND sg13cmos5l_decap_4
XFILLER_183_14 VPWR VGND sg13cmos5l_decap_8
XFILLER_183_47 VPWR VGND sg13cmos5l_decap_4
XFILLER_614_49 VPWR VGND sg13cmos5l_decap_8
XFILLER_116_41 VPWR VGND sg13cmos5l_decap_8
XANTENNA__0130__Y AXI_M_SOC_AWSIZE0 VPWR VGND sg13cmos5l_antennanp
XFILLER_672_7 VPWR VGND sg13cmos5l_decap_8
XFILLER_333_28 VPWR VGND sg13cmos5l_decap_8
XFILLER_480_56 VPWR VGND sg13cmos5l_decap_8
XFILLER_454_205 VPWR VGND sg13cmos5l_fill_2
XFILLER_454_216 VPWR VGND sg13cmos5l_fill_2
XFILLER_76_56 VPWR VGND sg13cmos5l_decap_8
XFILLER_655_198 VPWR VGND sg13cmos5l_decap_8
XFILLER_407_110 VPWR VGND sg13cmos5l_decap_8
XFILLER_407_121 VPWR VGND sg13cmos5l_fill_2
XFILLER_280_119 VPWR VGND sg13cmos5l_decap_8
XFILLER_489_21 VPWR VGND sg13cmos5l_decap_8
XFILLER_18_148 VPWR VGND sg13cmos5l_fill_1
XFILLER_407_187 VPWR VGND sg13cmos5l_decap_8
XFILLER_132_84 VPWR VGND sg13cmos5l_decap_8
XFILLER_710_70 VPWR VGND sg13cmos5l_decap_8
XFILLER_422_135 VPWR VGND sg13cmos5l_fill_2
XFILLER_162_0 VPWR VGND sg13cmos5l_decap_8
XFILLER_92_55 VPWR VGND sg13cmos5l_decap_8
XFILLER_489_98 VPWR VGND sg13cmos5l_decap_8
XFILLER_639_35 VPWR VGND sg13cmos5l_decap_8
XFILLER_576_161 VPWR VGND sg13cmos5l_decap_8
XFILLER_358_14 VPWR VGND sg13cmos5l_decap_8
XFILLER_25_82 VPWR VGND sg13cmos5l_fill_2
XANTENNA__3169__X Tile_X0Y4_E6BEG[6] VPWR VGND sg13cmos5l_antennanp
XFILLER_427_0 VPWR VGND sg13cmos5l_decap_8
XFILLER_591_153 VPWR VGND sg13cmos5l_fill_1
XFILLER_524_209 VPWR VGND sg13cmos5l_decap_8
XFILLER_186_178 VPWR VGND sg13cmos5l_decap_8
XFILLER_328_150 VPWR VGND sg13cmos5l_fill_1
XFILLER_591_175 VPWR VGND sg13cmos5l_fill_2
XFILLER_508_28 VPWR VGND sg13cmos5l_decap_8
XFILLER_328_183 VPWR VGND sg13cmos5l_fill_1
XFILLER_655_56 VPWR VGND sg13cmos5l_decap_8
XFILLER_438_91 VPWR VGND sg13cmos5l_decap_8
XANTENNA__2801__X Tile_X0Y3_E6BEG[11] VPWR VGND sg13cmos5l_antennanp
X_0690_ _0690_/Q Tile_X0Y9_FrameData[13] VGND VPWR Tile_X0Y9_FrameStrobe[0] latch
XFILLER_374_35 VPWR VGND sg13cmos5l_decap_8
XFILLER_343_153 VPWR VGND sg13cmos5l_decap_8
XFILLER_343_164 VPWR VGND sg13cmos5l_fill_1
XFILLER_142_215 VPWR VGND sg13cmos5l_fill_2
XFILLER_693_216 VPWR VGND sg13cmos5l_fill_2
X_2360_ _2360_/Q Tile_X0Y5_FrameData[13] VGND VPWR Tile_X0Y9_FrameStrobe[5] latch
X_1311_ _1311_/Q Tile_X0Y1_FrameData[26] VGND VPWR Tile_X0Y9_FrameStrobe[4] latch
XFILLER_243_28 VPWR VGND sg13cmos5l_decap_8
XFILLER_110_101 VPWR VGND sg13cmos5l_fill_1
X_2291_ _2291_/Q Tile_X0Y5_FrameData[18] VGND VPWR Tile_X0Y9_FrameStrobe[3] latch
XFILLER_500_161 VPWR VGND sg13cmos5l_decap_8
XFILLER_646_154 VPWR VGND sg13cmos5l_decap_8
XFILLER_110_123 VPWR VGND sg13cmos5l_decap_8
XANTENNA__3632__X Tile_X0Y9_S4BEG[10] VPWR VGND sg13cmos5l_antennanp
XFILLER_390_56 VPWR VGND sg13cmos5l_decap_8
X_4030_ _4030_/X Tile_X0Y0_W1END[1] Tile_X0Y0_W2MID[2] Tile_X0Y0_W2END[2] _3856_/X
+ _1123_/Q _1122_/Q VPWR VGND sg13cmos5l_mux4_1
X_1242_ _1242_/Q Tile_X0Y1_FrameData[31] VGND VPWR Tile_X0Y9_FrameStrobe[2] latch
XFILLER_2_42 VPWR VGND sg13cmos5l_decap_8
XFILLER_249_190 VPWR VGND sg13cmos5l_fill_1
XFILLER_2_86 VPWR VGND sg13cmos5l_fill_1
X_1173_ _1173_/Q Tile_X0Y0_FrameData[22] VGND VPWR Tile_X0Y9_FrameStrobe[7] latch
XFILLER_399_21 VPWR VGND sg13cmos5l_decap_8
X_0124_ AXI_M_SOC_ARSIZE1 _0932_/Q _3769_/X VPWR VGND sg13cmos5l_or2_1
XFILLER_559_106 VPWR VGND sg13cmos5l_decap_8
XFILLER_264_193 VPWR VGND sg13cmos5l_fill_1
XFILLER_620_70 VPWR VGND sg13cmos5l_decap_8
XFILLER_413_135 VPWR VGND sg13cmos5l_decap_8
XFILLER_24_107 VPWR VGND sg13cmos5l_decap_8
XFILLER_413_146 VPWR VGND sg13cmos5l_fill_2
X_0055_ _0055_/X _4678_/X _4679_/X _1860_/Q VPWR VGND sg13cmos5l_mux2_1
X_4932_ _4932_/X Tile_X0Y8_W2MID[7] Tile_X0Y8_W2END[7] Tile_X0Y8_W6END[8] _4785_/X
+ _0627_/Q _0626_/Q VPWR VGND sg13cmos5l_mux4_1
XFILLER_399_98 VPWR VGND sg13cmos5l_fill_2
XFILLER_549_35 VPWR VGND sg13cmos5l_decap_8
XFILLER_696_63 VPWR VGND sg13cmos5l_decap_8
X_4863_ _4863_/X Tile_X0Y9_W2END[0] AXI_M_SOC_RDATA0 _4901_/X _4900_/X _0817_/Q _0816_/Q
+ VPWR VGND sg13cmos5l_mux4_1
XFILLER_567_161 VPWR VGND sg13cmos5l_fill_1
XFILLER_268_14 VPWR VGND sg13cmos5l_decap_8
XFILLER_177_123 VPWR VGND sg13cmos5l_decap_4
XANTENNA__3079__X Tile_X0Y4_E2BEGb[5] VPWR VGND sg13cmos5l_antennanp
XFILLER_716_114 VPWR VGND sg13cmos5l_decap_8
XFILLER_177_134 VPWR VGND sg13cmos5l_decap_8
XANTENNA_14 AXI_M_SOC_WREADY VPWR VGND sg13cmos5l_antennanp
XANTENNA_25 AXI_M_SOC_WREADY VPWR VGND sg13cmos5l_antennanp
XFILLER_716_125 VPWR VGND sg13cmos5l_fill_2
X_3814_ _3814_/X Tile_X0Y0_W2END[3] Tile_X0Y0_W2END[5] _3857_/X _3856_/X _1077_/Q
+ _1076_/Q VPWR VGND sg13cmos5l_mux4_1
XFILLER_716_136 VPWR VGND sg13cmos5l_decap_4
XANTENNA_36 Tile_X0Y0_S2MID[0] VPWR VGND sg13cmos5l_antennanp
X_4794_ _4794_/X Tile_X0Y4_W1END[1] Tile_X0Y4_WW4END[13] Tile_X0Y4_W6END[5] _4337_/X
+ _2118_/Q _2117_/Q VPWR VGND sg13cmos5l_mux4_1
XANTENNA_47 Tile_X0Y0_S2MID[6] VPWR VGND sg13cmos5l_antennanp
XANTENNA_58 Tile_X0Y5_W2END[5] VPWR VGND sg13cmos5l_antennanp
XANTENNA_69 Tile_X0Y9_FrameStrobe[9] VPWR VGND sg13cmos5l_antennanp
X_0957_ _0957_/Q Tile_X0Y0_FrameData[14] VGND VPWR Tile_X0Y9_FrameStrobe[0] latch
X_3745_ AXI_M_SOC_ARADDR17 Tile_X0Y8_WW4END[1] Tile_X0Y8_WW4END[9] Tile_X0Y8_W6END[1]
+ _4801_/X _0501_/Q _0500_/Q VPWR VGND sg13cmos5l_mux4_1
XFILLER_418_28 VPWR VGND sg13cmos5l_decap_8
XFILLER_582_186 VPWR VGND sg13cmos5l_decap_4
XFILLER_565_56 VPWR VGND sg13cmos5l_decap_8
XFILLER_348_91 VPWR VGND sg13cmos5l_decap_8
X_0888_ _0888_/Q Tile_X0Y9_FrameData[7] VGND VPWR Tile_X0Y9_FrameStrobe[6] latch
X_3676_ _3676_/X Tile_X0Y2_WW4END[6] Tile_X0Y2_WW4END[14] Tile_X0Y2_W6END[6] _4122_/X
+ _1493_/Q _1492_/Q VPWR VGND sg13cmos5l_mux4_1
XFILLER_284_35 VPWR VGND sg13cmos5l_decap_8
XFILLER_715_48 VPWR VGND sg13cmos5l_decap_8
X_2627_ _2627_/Q Tile_X0Y6_FrameData[4] VGND VPWR Tile_X0Y9_FrameStrobe[5] latch
XFILLER_495_105 VPWR VGND sg13cmos5l_decap_8
XFILLER_684_216 VPWR VGND sg13cmos5l_fill_2
XFILLER_217_62 VPWR VGND sg13cmos5l_decap_8
X_2558_ _2558_/Q Tile_X0Y6_FrameData[9] VGND VPWR Tile_X0Y9_FrameStrobe[3] latch
XFILLER_434_49 VPWR VGND sg13cmos5l_decap_8
X_1509_ _1509_/Q Tile_X0Y2_FrameData[12] VGND VPWR Tile_X0Y9_FrameStrobe[2] latch
XFILLER_153_28 VPWR VGND sg13cmos5l_decap_8
XFILLER_101_101 VPWR VGND sg13cmos5l_decap_8
XFILLER_101_112 VPWR VGND sg13cmos5l_fill_2
X_2489_ _2489_/Q Tile_X0Y6_FrameData[14] VGND VPWR Tile_X0Y9_FrameStrobe[1] latch
XANTENNA__3542__X Tile_X0Y9_E6BEG[0] VPWR VGND sg13cmos5l_antennanp
XFILLER_514_82 VPWR VGND sg13cmos5l_decap_8
X_4228_ _4228_/X _4200_/X _0087_/X _4199_/X Tile_X0Y0_S4END[14] _1717_/Q _1716_/Q
+ VPWR VGND sg13cmos5l_mux4_1
XFILLER_637_198 VPWR VGND sg13cmos5l_decap_4
XFILLER_101_178 VPWR VGND sg13cmos5l_decap_8
X_4159_ _4159_/X Tile_X0Y3_W2END[4] AXI_M_SOC_WREADY _4211_/X _4210_/X _1823_/Q _1822_/Q
+ VPWR VGND sg13cmos5l_mux4_1
XFILLER_652_168 VPWR VGND sg13cmos5l_decap_8
XFILLER_530_70 VPWR VGND sg13cmos5l_decap_8
XFILLER_102_21 VPWR VGND sg13cmos5l_decap_8
XFILLER_70_213 VPWR VGND sg13cmos5l_decap_4
XFILLER_404_168 VPWR VGND sg13cmos5l_decap_8
XFILLER_253_7 VPWR VGND sg13cmos5l_decap_8
XFILLER_203_208 VPWR VGND sg13cmos5l_fill_1
XFILLER_459_35 VPWR VGND sg13cmos5l_decap_8
XFILLER_62_47 VPWR VGND sg13cmos5l_decap_8
XFILLER_62_58 VPWR VGND sg13cmos5l_decap_8
XFILLER_168_123 VPWR VGND sg13cmos5l_fill_2
XFILLER_420_7 VPWR VGND sg13cmos5l_decap_8
XFILLER_23_184 VPWR VGND sg13cmos5l_decap_8
XFILLER_518_7 VPWR VGND sg13cmos5l_decap_8
XFILLER_707_147 VPWR VGND sg13cmos5l_fill_2
XFILLER_609_49 VPWR VGND sg13cmos5l_decap_8
XFILLER_183_104 VPWR VGND sg13cmos5l_decap_8
XFILLER_573_175 VPWR VGND sg13cmos5l_decap_8
XFILLER_328_28 VPWR VGND sg13cmos5l_decap_8
XANTENNA__3717__X AXI_M_SOC_WDATA27 VPWR VGND sg13cmos5l_antennanp
XFILLER_325_131 VPWR VGND sg13cmos5l_fill_2
XFILLER_194_35 VPWR VGND sg13cmos5l_decap_8
XFILLER_325_186 VPWR VGND sg13cmos5l_decap_8
XFILLER_486_105 VPWR VGND sg13cmos5l_decap_8
XFILLER_344_49 VPWR VGND sg13cmos5l_decap_8
XFILLER_127_84 VPWR VGND sg13cmos5l_decap_4
XFILLER_705_70 VPWR VGND sg13cmos5l_decap_8
XFILLER_340_178 VPWR VGND sg13cmos5l_decap_8
XFILLER_491_77 VPWR VGND sg13cmos5l_decap_8
XFILLER_641_14 VPWR VGND sg13cmos5l_decap_8
XANTENNA__3452__X Tile_X0Y1_FrameData_O[10] VPWR VGND sg13cmos5l_antennanp
XFILLER_87_88 VPWR VGND sg13cmos5l_decap_8
XFILLER_427_216 VPWR VGND sg13cmos5l_fill_2
XFILLER_377_0 VPWR VGND sg13cmos5l_decap_8
XFILLER_442_208 VPWR VGND sg13cmos5l_decap_8
XFILLER_643_168 VPWR VGND sg13cmos5l_decap_8
XFILLER_544_0 VPWR VGND sg13cmos5l_decap_8
XFILLER_369_35 VPWR VGND sg13cmos5l_decap_8
XFILLER_711_0 VPWR VGND sg13cmos5l_decap_8
XFILLER_410_149 VPWR VGND sg13cmos5l_decap_4
XFILLER_14_173 VPWR VGND sg13cmos5l_decap_8
X_1860_ _1860_/Q Tile_X0Y3_FrameData[5] VGND VPWR Tile_X0Y9_FrameStrobe[5] latch
XFILLER_519_49 VPWR VGND sg13cmos5l_decap_8
X_0811_ _0811_/Q Tile_X0Y9_FrameData[20] VGND VPWR Tile_X0Y9_FrameStrobe[4] latch
XFILLER_666_77 VPWR VGND sg13cmos5l_decap_8
X_1791_ _1791_/Q Tile_X0Y3_FrameData[10] VGND VPWR Tile_X0Y9_FrameStrobe[3] latch
XFILLER_666_88 VPWR VGND sg13cmos5l_fill_2
XANTENNA__3627__X Tile_X0Y9_S4BEG[5] VPWR VGND sg13cmos5l_antennanp
XFILLER_316_120 VPWR VGND sg13cmos5l_fill_1
XFILLER_706_180 VPWR VGND sg13cmos5l_decap_8
X_0742_ _0742_/Q Tile_X0Y9_FrameData[25] VGND VPWR Tile_X0Y9_FrameStrobe[2] latch
X_3530_ Tile_X0Y9_E2BEG[4] _4852_/X VPWR VGND sg13cmos5l_buf_1
XFILLER_682_21 VPWR VGND sg13cmos5l_decap_8
XFILLER_318_61 VPWR VGND sg13cmos5l_fill_1
X_3461_ Tile_X0Y1_FrameData_O[19] Tile_X0Y1_FrameData[19] VPWR VGND sg13cmos5l_buf_1
X_0673_ _0673_/Q Tile_X0Y9_FrameData[30] VGND VPWR Tile_X0Y9_FrameStrobe[0] latch
XFILLER_520_212 VPWR VGND sg13cmos5l_decap_4
XFILLER_477_105 VPWR VGND sg13cmos5l_fill_2
XFILLER_316_197 VPWR VGND sg13cmos5l_decap_8
X_2412_ _2412_/Q Tile_X0Y5_FrameData[25] VGND VPWR Tile_X0Y9_FrameStrobe[7] latch
X_3392_ Tile_X0Y2_E2BEGb[3] _4051_/X VPWR VGND sg13cmos5l_buf_1
XFILLER_615_70 VPWR VGND sg13cmos5l_decap_8
XFILLER_331_178 VPWR VGND sg13cmos5l_fill_2
XFILLER_96_110 VPWR VGND sg13cmos5l_decap_8
X_2343_ _2343_/Q Tile_X0Y5_FrameData[30] VGND VPWR Tile_X0Y9_FrameStrobe[5] latch
XFILLER_331_189 VPWR VGND sg13cmos5l_fill_1
XFILLER_551_14 VPWR VGND sg13cmos5l_decap_8
XFILLER_492_119 VPWR VGND sg13cmos5l_decap_8
XANTENNA__3362__X Tile_X0Y2_EE4BEG[1] VPWR VGND sg13cmos5l_antennanp
XFILLER_284_211 VPWR VGND sg13cmos5l_fill_1
X_2274_ _2274_/Q Tile_X0Y5_FrameData[3] VGND VPWR Tile_X0Y9_FrameStrobe[2] latch
X_4013_ _4013_/X _3983_/X _0096_/X _3982_/X Tile_X0Y0_S4END[5] _1223_/Q _1222_/Q VPWR
+ VGND sg13cmos5l_mux4_1
X_1225_ _1225_/Q Tile_X0Y1_FrameData[16] VGND VPWR Tile_X0Y9_FrameStrobe[1] latch
XFILLER_701_28 VPWR VGND sg13cmos5l_decap_8
XFILLER_244_119 VPWR VGND sg13cmos5l_decap_8
XFILLER_631_91 VPWR VGND sg13cmos5l_decap_8
XFILLER_203_42 VPWR VGND sg13cmos5l_decap_8
X_1156_ _1156_/Q Tile_X0Y0_FrameData[7] VGND VPWR Tile_X0Y9_FrameStrobe[6] latch
XFILLER_350_70 VPWR VGND sg13cmos5l_decap_8
X_0107_ AXI_M_SOC_ARLEN2 _0933_/Q _3762_/X VPWR VGND sg13cmos5l_nor2b_1
XFILLER_279_13 VPWR VGND sg13cmos5l_decap_8
X_1087_ _1087_/Q Tile_X0Y0_FrameData[12] VGND VPWR Tile_X0Y9_FrameStrobe[4] latch
XFILLER_252_185 VPWR VGND sg13cmos5l_decap_8
XFILLER_401_116 VPWR VGND sg13cmos5l_decap_8
X_4915_ _4915_/X _4458_/X _4462_/X _4466_/X _4428_/X _2370_/Q _2369_/Q VPWR VGND sg13cmos5l_mux4_1
XFILLER_500_84 VPWR VGND sg13cmos5l_decap_8
X_4846_ _4846_/X Tile_X0Y9_N1END[2] _4898_/X AXI_M_SOC_RDATA1 AXI_M_SOC_RDATA5 _0851_/Q
+ _0850_/Q VPWR VGND sg13cmos5l_mux4_1
XFILLER_429_49 VPWR VGND sg13cmos5l_decap_8
XFILLER_555_153 VPWR VGND sg13cmos5l_decap_8
XFILLER_165_104 VPWR VGND sg13cmos5l_decap_8
XFILLER_576_77 VPWR VGND sg13cmos5l_decap_8
XFILLER_148_28 VPWR VGND sg13cmos5l_decap_8
X_4777_ _4777_/X Tile_X0Y9_W1END[0] Tile_X0Y9_W6END[4] _4928_/X _4892_/X _0927_/Q
+ _0926_/Q VPWR VGND sg13cmos5l_mux4_1
XFILLER_570_112 VPWR VGND sg13cmos5l_decap_8
X_1989_ _1989_/Q Tile_X0Y4_FrameData[0] VGND VPWR Tile_X0Y9_FrameStrobe[1] latch
XFILLER_295_56 VPWR VGND sg13cmos5l_decap_8
XANTENNA__3537__X Tile_X0Y9_E2BEGb[3] VPWR VGND sg13cmos5l_antennanp
XFILLER_20_198 VPWR VGND sg13cmos5l_fill_1
X_3728_ AXI_M_SOC_ARADDR0 Tile_X0Y9_WW4END[0] Tile_X0Y9_WW4END[8] Tile_X0Y9_W6END[0]
+ _4916_/X _0759_/Q _0758_/Q VPWR VGND sg13cmos5l_mux4_1
XFILLER_180_107 VPWR VGND sg13cmos5l_decap_8
XFILLER_592_21 VPWR VGND sg13cmos5l_decap_8
XFILLER_570_189 VPWR VGND sg13cmos5l_decap_8
XFILLER_712_161 VPWR VGND sg13cmos5l_decap_8
XFILLER_173_181 VPWR VGND sg13cmos5l_decap_8
X_3659_ AXI_M_SOC_AWADDR20 Tile_X0Y4_WW4END[4] Tile_X0Y4_WW4END[12] Tile_X0Y4_W6END[4]
+ _4340_/X _2005_/Q _2004_/Q VPWR VGND sg13cmos5l_mux4_1
XFILLER_657_216 VPWR VGND sg13cmos5l_fill_2
XFILLER_525_92 VPWR VGND sg13cmos5l_decap_8
XFILLER_461_14 VPWR VGND sg13cmos5l_decap_8
XFILLER_57_14 VPWR VGND sg13cmos5l_decap_8
XANTENNA__3272__X Tile_X0Y0_EE4BEG[8] VPWR VGND sg13cmos5l_antennanp
XFILLER_196_6 VPWR VGND sg13cmos5l_decap_8
XFILLER_611_28 VPWR VGND sg13cmos5l_decap_8
XFILLER_370_7 VPWR VGND sg13cmos5l_decap_8
XFILLER_290_203 VPWR VGND sg13cmos5l_decap_8
XFILLER_640_105 VPWR VGND sg13cmos5l_decap_8
XFILLER_468_7 VPWR VGND sg13cmos5l_decap_8
XFILLER_491_196 VPWR VGND sg13cmos5l_fill_2
XFILLER_363_6 VPWR VGND sg13cmos5l_decap_8
XFILLER_73_35 VPWR VGND sg13cmos5l_decap_8
XFILLER_389_134 VPWR VGND sg13cmos5l_decap_4
XFILLER_635_7 VPWR VGND sg13cmos5l_decap_8
XFILLER_189_35 VPWR VGND sg13cmos5l_decap_8
XFILLER_188_207 VPWR VGND sg13cmos5l_fill_2
XFILLER_410_84 VPWR VGND sg13cmos5l_decap_8
XFILLER_410_95 VPWR VGND sg13cmos5l_fill_2
XFILLER_339_49 VPWR VGND sg13cmos5l_decap_8
XFILLER_486_77 VPWR VGND sg13cmos5l_decap_8
XFILLER_11_154 VPWR VGND sg13cmos5l_decap_8
XFILLER_546_175 VPWR VGND sg13cmos5l_decap_8
XFILLER_636_14 VPWR VGND sg13cmos5l_decap_8
XFILLER_561_112 VPWR VGND sg13cmos5l_decap_8
XFILLER_546_186 VPWR VGND sg13cmos5l_fill_1
XFILLER_11_187 VPWR VGND sg13cmos5l_fill_2
XANTENNA__3447__X Tile_X0Y1_FrameData_O[5] VPWR VGND sg13cmos5l_antennanp
XFILLER_125_0 VPWR VGND sg13cmos5l_decap_8
XFILLER_98_21 VPWR VGND sg13cmos5l_decap_8
XFILLER_716_80 VPWR VGND sg13cmos5l_fill_1
XFILLER_703_194 VPWR VGND sg13cmos5l_decap_8
XFILLER_313_145 VPWR VGND sg13cmos5l_decap_8
XFILLER_652_35 VPWR VGND sg13cmos5l_decap_8
XFILLER_435_70 VPWR VGND sg13cmos5l_decap_8
XFILLER_98_98 VPWR VGND sg13cmos5l_decap_8
XFILLER_494_0 VPWR VGND sg13cmos5l_decap_8
XFILLER_371_14 VPWR VGND sg13cmos5l_decap_8
XANTENNA__3182__X Tile_X0Y0_N4BEG[6] VPWR VGND sg13cmos5l_antennanp
XFILLER_266_211 VPWR VGND sg13cmos5l_fill_1
XFILLER_78_165 VPWR VGND sg13cmos5l_decap_8
XFILLER_467_193 VPWR VGND sg13cmos5l_fill_2
XFILLER_661_0 VPWR VGND sg13cmos5l_decap_8
XFILLER_521_28 VPWR VGND sg13cmos5l_decap_8
XFILLER_19_210 VPWR VGND sg13cmos5l_fill_1
XFILLER_14_7 VPWR VGND sg13cmos5l_decap_8
XFILLER_93_135 VPWR VGND sg13cmos5l_decap_8
XFILLER_631_105 VPWR VGND sg13cmos5l_decap_8
XFILLER_219_160 VPWR VGND sg13cmos5l_decap_4
X_1010_ _1010_/Q Tile_X0Y0_FrameData[25] VGND VPWR Tile_X0Y9_FrameStrobe[2] latch
XFILLER_569_201 VPWR VGND sg13cmos5l_decap_4
XFILLER_219_193 VPWR VGND sg13cmos5l_decap_8
XFILLER_34_202 VPWR VGND sg13cmos5l_decap_8
XFILLER_601_83 VPWR VGND sg13cmos5l_fill_2
XFILLER_234_185 VPWR VGND sg13cmos5l_decap_8
XFILLER_677_21 VPWR VGND sg13cmos5l_decap_8
X_2961_ Tile_X0Y8_FrameData_O[1] Tile_X0Y8_FrameData[1] VPWR VGND sg13cmos5l_buf_1
XFILLER_395_137 VPWR VGND sg13cmos5l_decap_8
X_4700_ _4700_/X Tile_X0Y6_W2MID[7] Tile_X0Y6_W2END[7] Tile_X0Y6_W6END[8] _4553_/X
+ _2651_/Q _2650_/Q VPWR VGND sg13cmos5l_mux4_1
X_1912_ _1912_/Q Tile_X0Y3_FrameData[17] VGND VPWR Tile_X0Y9_FrameStrobe[7] latch
XFILLER_677_98 VPWR VGND sg13cmos5l_fill_2
X_2892_ Tile_X0Y6_FrameData_O[13] Tile_X0Y6_FrameData[13] VPWR VGND sg13cmos5l_buf_1
X_4631_ _4631_/X Tile_X0Y7_WW4END[12] AXI_M_SOC_RDATA19 _4696_/X _4674_/X _0297_/Q
+ _0296_/Q VPWR VGND sg13cmos5l_mux4_1
XFILLER_147_126 VPWR VGND sg13cmos5l_decap_8
X_1843_ _1843_/Q Tile_X0Y3_FrameData[22] VGND VPWR Tile_X0Y9_FrameStrobe[5] latch
XFILLER_546_14 VPWR VGND sg13cmos5l_decap_8
XFILLER_8_63 VPWR VGND sg13cmos5l_decap_8
XFILLER_698_105 VPWR VGND sg13cmos5l_decap_8
XANTENNA__3357__X Tile_X0Y2_FrameData_O[28] VPWR VGND sg13cmos5l_antennanp
XFILLER_693_42 VPWR VGND sg13cmos5l_decap_8
X_1774_ _1774_/Q Tile_X0Y3_FrameData[27] VGND VPWR Tile_X0Y9_FrameStrobe[3] latch
X_4562_ _4562_/X Tile_X0Y2_W1END[1] Tile_X0Y2_WW4END[13] Tile_X0Y2_W6END[5] _4117_/X
+ _1610_/Q _1609_/Q VPWR VGND sg13cmos5l_mux4_1
X_0725_ _0725_/Q Tile_X0Y9_FrameData[10] VGND VPWR Tile_X0Y9_FrameStrobe[1] latch
X_3513_ Tile_X0Y1_E2BEG[3] _3935_/X VPWR VGND sg13cmos5l_buf_1
XFILLER_552_189 VPWR VGND sg13cmos5l_decap_4
X_4493_ _4493_/X _4547_/X _4546_/X AXI_M_SOC_RDATA26 AXI_M_SOC_RDATA30 _2621_/Q _2620_/Q
+ VPWR VGND sg13cmos5l_mux4_1
XFILLER_626_91 VPWR VGND sg13cmos5l_decap_8
X_0656_ _0656_/Q Tile_X0Y8_FrameData[15] VGND VPWR Tile_X0Y9_FrameStrobe[7] latch
X_3444_ Tile_X0Y1_FrameData_O[2] Tile_X0Y1_FrameData[2] VPWR VGND sg13cmos5l_buf_1
XFILLER_562_35 VPWR VGND sg13cmos5l_decap_8
XFILLER_345_70 VPWR VGND sg13cmos5l_decap_8
XFILLER_304_178 VPWR VGND sg13cmos5l_fill_2
X_3375_ Tile_X0Y2_EE4BEG[14] _4070_/X VPWR VGND sg13cmos5l_buf_1
XFILLER_281_14 VPWR VGND sg13cmos5l_decap_8
X_0587_ _0587_/Q Tile_X0Y8_FrameData[20] VGND VPWR Tile_X0Y9_FrameStrobe[5] latch
XANTENNA__3092__X Tile_X0Y7_E2BEG[6] VPWR VGND sg13cmos5l_antennanp
XFILLER_607_102 VPWR VGND sg13cmos5l_decap_4
X_2326_ _2326_/Q Tile_X0Y5_FrameData[15] VGND VPWR Tile_X0Y9_FrameStrobe[4] latch
XFILLER_712_49 VPWR VGND sg13cmos5l_decap_8
XFILLER_473_141 VPWR VGND sg13cmos5l_decap_8
XFILLER_607_157 VPWR VGND sg13cmos5l_decap_8
XFILLER_431_28 VPWR VGND sg13cmos5l_decap_8
X_2257_ _2257_/Q Tile_X0Y5_FrameData[20] VGND VPWR Tile_X0Y9_FrameStrobe[2] latch
XFILLER_473_163 VPWR VGND sg13cmos5l_decap_8
XFILLER_272_203 VPWR VGND sg13cmos5l_decap_4
XFILLER_214_63 VPWR VGND sg13cmos5l_decap_8
XFILLER_473_174 VPWR VGND sg13cmos5l_fill_2
XFILLER_622_105 VPWR VGND sg13cmos5l_decap_8
XFILLER_607_179 VPWR VGND sg13cmos5l_decap_8
XFILLER_27_28 VPWR VGND sg13cmos5l_decap_8
XFILLER_622_116 VPWR VGND sg13cmos5l_fill_1
X_1208_ _1208_/Q Tile_X0Y1_FrameData[1] VGND VPWR Tile_X0Y9_FrameStrobe[0] latch
X_2188_ _2188_/Q Tile_X0Y5_FrameData[25] VGND VPWR Tile_X0Y9_FrameStrobe[0] latch
XFILLER_615_190 VPWR VGND sg13cmos5l_fill_2
X_1139_ _1139_/Q Tile_X0Y0_FrameData[24] VGND VPWR Tile_X0Y9_FrameStrobe[6] latch
XFILLER_240_100 VPWR VGND sg13cmos5l_decap_4
XFILLER_230_51 VPWR VGND sg13cmos5l_decap_8
XFILLER_225_185 VPWR VGND sg13cmos5l_decap_8
XFILLER_587_21 VPWR VGND sg13cmos5l_decap_8
XFILLER_43_27 VPWR VGND sg13cmos5l_decap_8
XFILLER_240_166 VPWR VGND sg13cmos5l_fill_2
XFILLER_240_199 VPWR VGND sg13cmos5l_decap_8
XFILLER_138_126 VPWR VGND sg13cmos5l_decap_8
X_4829_ _4829_/X Tile_X0Y9_W2MID[6] Tile_X0Y9_W2END[6] Tile_X0Y9_W6END[9] _4903_/X
+ _0881_/Q _0880_/Q VPWR VGND sg13cmos5l_mux4_1
XFILLER_456_14 VPWR VGND sg13cmos5l_decap_8
XFILLER_543_112 VPWR VGND sg13cmos5l_decap_8
XFILLER_689_105 VPWR VGND sg13cmos5l_fill_1
XANTENNA__3267__X Tile_X0Y0_EE4BEG[3] VPWR VGND sg13cmos5l_antennanp
XFILLER_689_127 VPWR VGND sg13cmos5l_decap_4
XFILLER_216_7 VPWR VGND sg13cmos5l_decap_8
XFILLER_543_167 VPWR VGND sg13cmos5l_decap_8
XFILLER_606_28 VPWR VGND sg13cmos5l_decap_8
XFILLER_4_139 VPWR VGND sg13cmos5l_decap_4
XFILLER_496_200 VPWR VGND sg13cmos5l_fill_2
XFILLER_697_171 VPWR VGND sg13cmos5l_decap_8
XFILLER_161_140 VPWR VGND sg13cmos5l_fill_1
XFILLER_108_42 VPWR VGND sg13cmos5l_decap_8
XFILLER_472_35 VPWR VGND sg13cmos5l_decap_8
XFILLER_161_162 VPWR VGND sg13cmos5l_decap_8
XFILLER_255_81 VPWR VGND sg13cmos5l_fill_1
XFILLER_68_57 VPWR VGND sg13cmos5l_decap_8
XFILLER_585_7 VPWR VGND sg13cmos5l_decap_8
XFILLER_622_49 VPWR VGND sg13cmos5l_decap_8
XFILLER_191_69 VPWR VGND sg13cmos5l_decap_8
XFILLER_75_124 VPWR VGND sg13cmos5l_decap_8
XFILLER_341_28 VPWR VGND sg13cmos5l_decap_8
XFILLER_124_63 VPWR VGND sg13cmos5l_decap_8
XFILLER_613_105 VPWR VGND sg13cmos5l_decap_4
XANTENNA__3730__X AXI_M_SOC_ARADDR2 VPWR VGND sg13cmos5l_antennanp
XFILLER_84_34 VPWR VGND sg13cmos5l_decap_4
XFILLER_271_91 VPWR VGND sg13cmos5l_decap_8
XFILLER_84_78 VPWR VGND sg13cmos5l_fill_2
XFILLER_90_127 VPWR VGND sg13cmos5l_decap_8
XFILLER_497_21 VPWR VGND sg13cmos5l_decap_8
XFILLER_621_171 VPWR VGND sg13cmos5l_decap_8
XFILLER_140_84 VPWR VGND sg13cmos5l_decap_8
XFILLER_242_0 VPWR VGND sg13cmos5l_fill_2
XFILLER_231_188 VPWR VGND sg13cmos5l_fill_2
XFILLER_497_98 VPWR VGND sg13cmos5l_decap_8
XFILLER_647_35 VPWR VGND sg13cmos5l_decap_8
XFILLER_519_164 VPWR VGND sg13cmos5l_fill_2
XFILLER_534_101 VPWR VGND sg13cmos5l_decap_4
XFILLER_385_181 VPWR VGND sg13cmos5l_decap_8
XFILLER_366_14 VPWR VGND sg13cmos5l_decap_8
XANTENNA__3177__X Tile_X0Y0_N4BEG[1] VPWR VGND sg13cmos5l_antennanp
XFILLER_507_0 VPWR VGND sg13cmos5l_decap_8
XFILLER_516_28 VPWR VGND sg13cmos5l_decap_8
XFILLER_663_56 VPWR VGND sg13cmos5l_decap_8
X_0510_ _0510_/Q Tile_X0Y8_FrameData[1] VGND VPWR Tile_X0Y9_FrameStrobe[2] latch
X_1490_ _1490_/Q Tile_X0Y2_FrameData[31] VGND VPWR Tile_X0Y9_FrameStrobe[2] latch
XFILLER_382_35 VPWR VGND sg13cmos5l_fill_2
X_0441_ _0441_/Q Tile_X0Y8_FrameData[6] VGND VPWR Tile_X0Y9_FrameStrobe[0] latch
X_3160_ Tile_X0Y7_FrameData_O[30] Tile_X0Y7_FrameData[30] VPWR VGND sg13cmos5l_buf_1
X_0372_ _0372_/Q Tile_X0Y7_FrameData[11] VGND VPWR Tile_X0Y9_FrameStrobe[6] latch
XFILLER_315_73 VPWR VGND sg13cmos5l_decap_4
XFILLER_532_49 VPWR VGND sg13cmos5l_decap_8
X_2111_ _2111_/Q Tile_X0Y4_FrameData[6] VGND VPWR Tile_X0Y9_FrameStrobe[5] latch
X_3091_ Tile_X0Y7_E2BEG[5] _4617_/X VPWR VGND sg13cmos5l_buf_1
XANTENNA__3640__X AXI_M_SOC_AWADDR1 VPWR VGND sg13cmos5l_antennanp
XFILLER_66_168 VPWR VGND sg13cmos5l_decap_8
X_2042_ _2042_/Q Tile_X0Y4_FrameData[11] VGND VPWR Tile_X0Y9_FrameStrobe[3] latch
XFILLER_470_155 VPWR VGND sg13cmos5l_fill_1
XFILLER_470_166 VPWR VGND sg13cmos5l_decap_4
XFILLER_81_149 VPWR VGND sg13cmos5l_decap_8
XFILLER_688_64 VPWR VGND sg13cmos5l_decap_8
XFILLER_411_200 VPWR VGND sg13cmos5l_fill_1
XFILLER_222_111 VPWR VGND sg13cmos5l_decap_8
XFILLER_207_185 VPWR VGND sg13cmos5l_decap_8
XFILLER_207_196 VPWR VGND sg13cmos5l_fill_1
X_3993_ _3993_/X _3892_/X _4025_/X _4024_/X Tile_X0Y0_S2MID[2] _1197_/Q _1196_/Q VPWR
+ VGND sg13cmos5l_mux4_1
XFILLER_200_21 VPWR VGND sg13cmos5l_decap_8
X_2944_ Tile_X0Y8_EE4BEG[0] _4744_/X VPWR VGND sg13cmos5l_buf_1
XFILLER_557_35 VPWR VGND sg13cmos5l_decap_8
XFILLER_88_0 VPWR VGND sg13cmos5l_decap_8
XFILLER_276_14 VPWR VGND sg13cmos5l_decap_8
XFILLER_200_98 VPWR VGND sg13cmos5l_decap_8
X_2875_ Tile_X0Y6_EE4BEG[12] _4524_/X VPWR VGND sg13cmos5l_buf_1
XANTENNA__3087__X Tile_X0Y7_E2BEG[1] VPWR VGND sg13cmos5l_antennanp
X_4614_ _4614_/X Tile_X0Y7_W2MID[5] AXI_M_SOC_RDATA18 _4673_/X _4672_/X _0331_/Q _0330_/Q
+ VPWR VGND sg13cmos5l_mux4_1
XFILLER_525_145 VPWR VGND sg13cmos5l_decap_4
X_1826_ _1826_/Q Tile_X0Y3_FrameData[7] VGND VPWR Tile_X0Y9_FrameStrobe[4] latch
XFILLER_707_49 VPWR VGND sg13cmos5l_decap_8
XFILLER_525_178 VPWR VGND sg13cmos5l_decap_8
X_4545_ _4545_/X Tile_X0Y7_W1END[0] Tile_X0Y7_W6END[4] _4696_/X _4656_/X _0415_/Q
+ _0414_/Q VPWR VGND sg13cmos5l_mux4_1
XFILLER_426_28 VPWR VGND sg13cmos5l_decap_8
XFILLER_391_195 VPWR VGND sg13cmos5l_decap_8
XFILLER_209_63 VPWR VGND sg13cmos5l_decap_8
XFILLER_128_181 VPWR VGND sg13cmos5l_decap_4
X_1757_ _1757_/Q Tile_X0Y3_FrameData[12] VGND VPWR Tile_X0Y9_FrameStrobe[2] latch
XFILLER_478_211 VPWR VGND sg13cmos5l_fill_1
XFILLER_573_56 VPWR VGND sg13cmos5l_decap_8
XFILLER_356_91 VPWR VGND sg13cmos5l_decap_8
X_0708_ _0708_/Q Tile_X0Y9_FrameData[27] VGND VPWR Tile_X0Y9_FrameStrobe[1] latch
XFILLER_89_216 VPWR VGND sg13cmos5l_fill_2
X_4476_ _4476_/X Tile_X0Y4_W1END[0] Tile_X0Y4_W2MID[3] Tile_X0Y4_W2END[3] _4318_/X
+ _2129_/Q _2128_/Q VPWR VGND sg13cmos5l_mux4_1
XFILLER_292_35 VPWR VGND sg13cmos5l_decap_8
X_1688_ _1688_/Q Tile_X0Y3_FrameData[17] VGND VPWR Tile_X0Y9_FrameStrobe[0] latch
XFILLER_143_173 VPWR VGND sg13cmos5l_decap_8
X_3427_ Tile_X0Y4_FrameData_O[18] Tile_X0Y4_FrameData[18] VPWR VGND sg13cmos5l_buf_1
XFILLER_627_208 VPWR VGND sg13cmos5l_fill_1
X_0639_ _0639_/Q Tile_X0Y8_FrameData[0] VGND VPWR Tile_X0Y9_FrameStrobe[6] latch
XFILLER_694_174 VPWR VGND sg13cmos5l_decap_8
X_3358_ Tile_X0Y2_FrameData_O[29] Tile_X0Y2_FrameData[29] VPWR VGND sg13cmos5l_buf_1
XFILLER_57_102 VPWR VGND sg13cmos5l_decap_8
XFILLER_442_49 VPWR VGND sg13cmos5l_decap_8
XFILLER_161_28 VPWR VGND sg13cmos5l_fill_2
X_2309_ _2309_/Q Tile_X0Y5_FrameData[0] VGND VPWR Tile_X0Y9_FrameStrobe[3] latch
X_3289_ Tile_X0Y0_E6BEG[9] _3845_/X VPWR VGND sg13cmos5l_buf_1
XFILLER_57_157 VPWR VGND sg13cmos5l_decap_8
XANTENNA__3550__X Tile_X0Y9_E6BEG[8] VPWR VGND sg13cmos5l_antennanp
XFILLER_57_168 VPWR VGND sg13cmos5l_decap_8
XFILLER_446_196 VPWR VGND sg13cmos5l_fill_1
XFILLER_598_42 VPWR VGND sg13cmos5l_decap_8
XFILLER_461_166 VPWR VGND sg13cmos5l_decap_8
XFILLER_54_37 VPWR VGND sg13cmos5l_decap_8
XFILLER_166_7 VPWR VGND sg13cmos5l_decap_8
XFILLER_610_119 VPWR VGND sg13cmos5l_decap_8
XFILLER_402_200 VPWR VGND sg13cmos5l_decap_8
XFILLER_359_126 VPWR VGND sg13cmos5l_decap_8
XFILLER_159_6 VPWR VGND sg13cmos5l_decap_8
XFILLER_13_216 VPWR VGND sg13cmos5l_fill_2
XFILLER_333_7 VPWR VGND sg13cmos5l_decap_8
XFILLER_70_14 VPWR VGND sg13cmos5l_decap_8
XFILLER_467_35 VPWR VGND sg13cmos5l_decap_8
XFILLER_705_201 VPWR VGND sg13cmos5l_fill_1
XFILLER_186_14 VPWR VGND sg13cmos5l_decap_8
XFILLER_500_7 VPWR VGND sg13cmos5l_decap_8
XFILLER_617_49 VPWR VGND sg13cmos5l_decap_8
XFILLER_119_52 VPWR VGND sg13cmos5l_decap_8
XANTENNA__0133__Y AXI_M_SOC_AWSIZE2 VPWR VGND sg13cmos5l_antennanp
XFILLER_336_28 VPWR VGND sg13cmos5l_decap_8
XFILLER_119_192 VPWR VGND sg13cmos5l_decap_8
XFILLER_119_74 VPWR VGND sg13cmos5l_decap_8
XFILLER_483_56 VPWR VGND sg13cmos5l_decap_8
XFILLER_531_159 VPWR VGND sg13cmos5l_decap_8
XFILLER_134_173 VPWR VGND sg13cmos5l_decap_8
XFILLER_134_195 VPWR VGND sg13cmos5l_decap_4
XFILLER_429_119 VPWR VGND sg13cmos5l_decap_8
XFILLER_352_49 VPWR VGND sg13cmos5l_decap_8
XFILLER_713_70 VPWR VGND sg13cmos5l_decap_8
XFILLER_48_102 VPWR VGND sg13cmos5l_fill_2
XFILLER_135_84 VPWR VGND sg13cmos5l_decap_8
XFILLER_48_113 VPWR VGND sg13cmos5l_fill_1
XFILLER_437_141 VPWR VGND sg13cmos5l_decap_8
XFILLER_192_0 VPWR VGND sg13cmos5l_decap_8
XFILLER_48_135 VPWR VGND sg13cmos5l_decap_4
XFILLER_48_146 VPWR VGND sg13cmos5l_decap_8
XANTENNA__3460__X Tile_X0Y1_FrameData_O[18] VPWR VGND sg13cmos5l_antennanp
XFILLER_28_71 VPWR VGND sg13cmos5l_decap_4
XFILLER_63_116 VPWR VGND sg13cmos5l_decap_8
XFILLER_251_206 VPWR VGND sg13cmos5l_fill_2
XFILLER_457_0 VPWR VGND sg13cmos5l_decap_8
XFILLER_452_177 VPWR VGND sg13cmos5l_decap_8
XFILLER_452_188 VPWR VGND sg13cmos5l_fill_2
XFILLER_151_94 VPWR VGND sg13cmos5l_decap_8
XFILLER_301_42 VPWR VGND sg13cmos5l_decap_8
XFILLER_624_0 VPWR VGND sg13cmos5l_decap_8
XFILLER_658_56 VPWR VGND sg13cmos5l_decap_8
XANTENNA__2804__X Tile_X0Y3_E2BEGb[2] VPWR VGND sg13cmos5l_antennanp
XFILLER_44_81 VPWR VGND sg13cmos5l_decap_8
X_0990_ _0990_/Q Tile_X0Y0_FrameData[13] VGND VPWR Tile_X0Y9_FrameStrobe[1] latch
XFILLER_658_89 VPWR VGND sg13cmos5l_decap_8
XFILLER_377_35 VPWR VGND sg13cmos5l_decap_8
X_2660_ _2660_/Q Tile_X0Y6_FrameData[3] VGND VPWR Tile_X0Y9_FrameStrobe[6] latch
XFILLER_527_49 VPWR VGND sg13cmos5l_decap_8
X_1611_ _1611_/Q Tile_X0Y2_FrameData[6] VGND VPWR Tile_X0Y9_FrameStrobe[5] latch
XFILLER_674_77 VPWR VGND sg13cmos5l_decap_8
XFILLER_60_91 VPWR VGND sg13cmos5l_decap_8
XFILLER_246_28 VPWR VGND sg13cmos5l_decap_8
X_2591_ _2591_/Q Tile_X0Y6_FrameData[8] VGND VPWR Tile_X0Y9_FrameStrobe[4] latch
XFILLER_176_80 VPWR VGND sg13cmos5l_fill_2
XANTENNA__3635__X Tile_X0Y9_S4BEG[13] VPWR VGND sg13cmos5l_antennanp
XFILLER_393_67 VPWR VGND sg13cmos5l_decap_8
X_4330_ _4330_/X Tile_X0Y8_W1END[2] Tile_X0Y8_WW4END[2] Tile_X0Y8_W6END[10] _4802_/X
+ _0641_/Q _0640_/Q VPWR VGND sg13cmos5l_mux4_1
XFILLER_125_151 VPWR VGND sg13cmos5l_decap_8
X_1542_ _1542_/Q Tile_X0Y2_FrameData[11] VGND VPWR Tile_X0Y9_FrameStrobe[3] latch
XFILLER_5_42 VPWR VGND sg13cmos5l_decap_8
XFILLER_690_21 VPWR VGND sg13cmos5l_decap_8
X_1473_ _1473_/Q Tile_X0Y2_FrameData[16] VGND VPWR Tile_X0Y9_FrameStrobe[1] latch
X_4261_ _4261_/X Tile_X0Y4_W2MID[2] AXI_M_SOC_BRESP1 _4317_/X _4316_/X _2091_/Q _2090_/Q
+ VPWR VGND sg13cmos5l_mux4_1
XFILLER_475_203 VPWR VGND sg13cmos5l_decap_4
XFILLER_690_76 VPWR VGND sg13cmos5l_decap_8
XFILLER_140_154 VPWR VGND sg13cmos5l_decap_8
X_0424_ _0424_/Q Tile_X0Y8_FrameData[23] VGND VPWR Tile_X0Y9_FrameStrobe[0] latch
X_3212_ Tile_X0Y0_FrameStrobe_O[0] Tile_X0Y9_FrameStrobe[0] VPWR VGND sg13cmos5l_buf_1
XFILLER_140_165 VPWR VGND sg13cmos5l_fill_2
X_4192_ _4192_/X _4200_/X Tile_X0Y3_W6END[2] _4199_/X _4192_/A3 _1677_/Q _1676_/Q
+ VPWR VGND sg13cmos5l_mux4_1
XFILLER_691_144 VPWR VGND sg13cmos5l_decap_8
XFILLER_286_169 VPWR VGND sg13cmos5l_decap_8
XFILLER_262_49 VPWR VGND sg13cmos5l_decap_8
XFILLER_623_70 VPWR VGND sg13cmos5l_decap_8
X_0355_ _0355_/Q Tile_X0Y7_FrameData[28] VGND VPWR Tile_X0Y9_FrameStrobe[6] latch
X_3143_ Tile_X0Y7_FrameData_O[13] Tile_X0Y7_FrameData[13] VPWR VGND sg13cmos5l_buf_1
XANTENNA__3370__X Tile_X0Y2_EE4BEG[9] VPWR VGND sg13cmos5l_antennanp
XFILLER_294_180 VPWR VGND sg13cmos5l_decap_8
X_3074_ Tile_X0Y4_E2BEGb[0] _4264_/X VPWR VGND sg13cmos5l_buf_1
XFILLER_699_63 VPWR VGND sg13cmos5l_decap_8
X_0286_ _0286_/Q Tile_X0Y7_FrameData[1] VGND VPWR Tile_X0Y9_FrameStrobe[3] latch
XFILLER_443_144 VPWR VGND sg13cmos5l_decap_8
XFILLER_54_127 VPWR VGND sg13cmos5l_decap_8
X_2025_ _2025_/Q Tile_X0Y4_FrameData[28] VGND VPWR Tile_X0Y9_FrameStrobe[3] latch
XFILLER_589_159 VPWR VGND sg13cmos5l_fill_1
XFILLER_242_217 VPWR VGND sg13cmos5l_fill_1
XFILLER_396_210 VPWR VGND sg13cmos5l_decap_8
XFILLER_211_42 VPWR VGND sg13cmos5l_decap_8
XFILLER_568_56 VPWR VGND sg13cmos5l_decap_8
X_3976_ _3976_/X _3981_/X Tile_X0Y1_W6END[0] _3980_/X _3976_/A3 _1185_/Q _1184_/Q
+ VPWR VGND sg13cmos5l_mux4_1
XFILLER_287_35 VPWR VGND sg13cmos5l_decap_8
XFILLER_210_125 VPWR VGND sg13cmos5l_decap_8
X_2927_ Tile_X0Y8_E2BEGb[3] _4739_/X VPWR VGND sg13cmos5l_buf_1
XFILLER_210_158 VPWR VGND sg13cmos5l_decap_8
X_2858_ Tile_X0Y6_E6BEG[7] _4535_/X VPWR VGND sg13cmos5l_buf_1
XFILLER_437_49 VPWR VGND sg13cmos5l_decap_8
XFILLER_364_173 VPWR VGND sg13cmos5l_decap_8
XFILLER_584_77 VPWR VGND sg13cmos5l_decap_8
X_1809_ _1809_/Q Tile_X0Y3_FrameData[24] VGND VPWR Tile_X0Y9_FrameStrobe[4] latch
XFILLER_156_28 VPWR VGND sg13cmos5l_decap_8
XFILLER_659_119 VPWR VGND sg13cmos5l_decap_4
X_2789_ Tile_X0Y3_EE4BEG[15] _4179_/X VPWR VGND sg13cmos5l_buf_1
XANTENNA__3545__X Tile_X0Y9_E6BEG[3] VPWR VGND sg13cmos5l_antennanp
X_4528_ _4528_/X Tile_X0Y9_N4END[12] _0152_/X _4579_/X _4583_/X _2551_/Q _2550_/Q
+ VPWR VGND sg13cmos5l_mux4_1
XFILLER_49_15 VPWR VGND sg13cmos5l_fill_2
XFILLER_236_83 VPWR VGND sg13cmos5l_decap_8
X_4459_ _4459_/X _4418_/X _0157_/X _4417_/X _0143_/X _2221_/Q _2220_/Q VPWR VGND sg13cmos5l_mux4_1
XFILLER_277_136 VPWR VGND sg13cmos5l_decap_8
XFILLER_131_165 VPWR VGND sg13cmos5l_decap_8
XFILLER_172_49 VPWR VGND sg13cmos5l_fill_2
XFILLER_131_176 VPWR VGND sg13cmos5l_fill_1
XFILLER_533_81 VPWR VGND sg13cmos5l_fill_2
XFILLER_131_198 VPWR VGND sg13cmos5l_decap_4
XFILLER_283_7 VPWR VGND sg13cmos5l_decap_8
XANTENNA__3280__X Tile_X0Y0_E6BEG[0] VPWR VGND sg13cmos5l_antennanp
XFILLER_285_191 VPWR VGND sg13cmos5l_decap_8
XFILLER_65_47 VPWR VGND sg13cmos5l_decap_8
XFILLER_233_217 VPWR VGND sg13cmos5l_fill_1
XFILLER_450_7 VPWR VGND sg13cmos5l_decap_8
XFILLER_595_107 VPWR VGND sg13cmos5l_fill_1
XFILLER_548_7 VPWR VGND sg13cmos5l_decap_8
XFILLER_121_42 VPWR VGND sg13cmos5l_decap_8
XFILLER_60_119 VPWR VGND sg13cmos5l_decap_8
XFILLER_387_210 VPWR VGND sg13cmos5l_fill_2
XFILLER_81_13 VPWR VGND sg13cmos5l_decap_4
XFILLER_53_193 VPWR VGND sg13cmos5l_decap_8
XFILLER_198_176 VPWR VGND sg13cmos5l_decap_8
XFILLER_197_35 VPWR VGND sg13cmos5l_decap_8
XFILLER_81_79 VPWR VGND sg13cmos5l_decap_8
XFILLER_201_147 VPWR VGND sg13cmos5l_decap_8
XFILLER_355_140 VPWR VGND sg13cmos5l_decap_8
XFILLER_347_49 VPWR VGND sg13cmos5l_decap_8
XFILLER_708_70 VPWR VGND sg13cmos5l_decap_8
XFILLER_494_77 VPWR VGND sg13cmos5l_decap_8
XFILLER_370_121 VPWR VGND sg13cmos5l_fill_2
XFILLER_355_195 VPWR VGND sg13cmos5l_decap_8
XFILLER_644_14 VPWR VGND sg13cmos5l_decap_8
XFILLER_504_126 VPWR VGND sg13cmos5l_decap_8
XANTENNA__3455__X Tile_X0Y1_FrameData_O[13] VPWR VGND sg13cmos5l_antennanp
XFILLER_205_0 VPWR VGND sg13cmos5l_decap_8
XFILLER_370_198 VPWR VGND sg13cmos5l_decap_4
XFILLER_146_72 VPWR VGND sg13cmos5l_fill_1
XFILLER_363_48 VPWR VGND sg13cmos5l_decap_8
XFILLER_122_121 VPWR VGND sg13cmos5l_decap_8
XFILLER_457_214 VPWR VGND sg13cmos5l_decap_4
XFILLER_68_208 VPWR VGND sg13cmos5l_fill_2
XFILLER_673_122 VPWR VGND sg13cmos5l_fill_2
XFILLER_660_35 VPWR VGND sg13cmos5l_decap_8
XFILLER_574_0 VPWR VGND sg13cmos5l_decap_8
XANTENNA__3190__X Tile_X0Y0_N4BEG[14] VPWR VGND sg13cmos5l_antennanp
XFILLER_614_211 VPWR VGND sg13cmos5l_fill_1
X_0140_ _0140_/X _4443_/X _4444_/X _1357_/Q VPWR VGND sg13cmos5l_mux2_1
XFILLER_425_133 VPWR VGND sg13cmos5l_decap_8
XFILLER_36_127 VPWR VGND sg13cmos5l_decap_8
XFILLER_224_217 VPWR VGND sg13cmos5l_fill_1
X_0071_ AXI_M_SOC_WSTRB0 _0935_/Q _3722_/X VPWR VGND sg13cmos5l_or2_1
XFILLER_312_63 VPWR VGND sg13cmos5l_decap_4
XFILLER_669_99 VPWR VGND sg13cmos5l_fill_2
X_3830_ _3830_/X Tile_X0Y0_WW4END[5] Tile_X0Y0_WW4END[10] _3886_/X _3856_/X _1045_/Q
+ _1044_/Q VPWR VGND sg13cmos5l_mux4_1
XFILLER_594_151 VPWR VGND sg13cmos5l_decap_8
XFILLER_189_187 VPWR VGND sg13cmos5l_fill_2
XFILLER_685_21 VPWR VGND sg13cmos5l_decap_8
X_3761_ _3761_/X Tile_X0Y1_WW4END[2] Tile_X0Y1_WW4END[10] Tile_X0Y1_W6END[2] _4010_/X
+ _1253_/Q _1252_/Q VPWR VGND sg13cmos5l_mux4_1
XFILLER_594_195 VPWR VGND sg13cmos5l_decap_8
X_0973_ _0973_/Q Tile_X0Y0_FrameData[30] VGND VPWR Tile_X0Y9_FrameStrobe[1] latch
XFILLER_538_59 VPWR VGND sg13cmos5l_decap_8
XFILLER_71_90 VPWR VGND sg13cmos5l_decap_8
X_2712_ _4425_/A3 VPWR VGND sg13cmos5l_tielo
X_3692_ AXI_M_SOC_WDATA2 Tile_X0Y7_WW4END[2] Tile_X0Y7_WW4END[10] Tile_X0Y7_W6END[2]
+ _4686_/X _0243_/Q _0242_/Q VPWR VGND sg13cmos5l_mux4_1
XFILLER_618_70 VPWR VGND sg13cmos5l_decap_8
X_2643_ _2643_/Q Tile_X0Y6_FrameData[20] VGND VPWR Tile_X0Y9_FrameStrobe[6] latch
XFILLER_554_14 VPWR VGND sg13cmos5l_decap_8
XFILLER_361_143 VPWR VGND sg13cmos5l_decap_8
XANTENNA__3365__X Tile_X0Y2_EE4BEG[4] VPWR VGND sg13cmos5l_antennanp
XFILLER_160_205 VPWR VGND sg13cmos5l_fill_1
X_2574_ _2574_/Q Tile_X0Y6_FrameData[25] VGND VPWR Tile_X0Y9_FrameStrobe[4] latch
XFILLER_510_107 VPWR VGND sg13cmos5l_fill_2
X_4313_ _4313_/X _4237_/X _4353_/X _4352_/X _4236_/X _1949_/Q _1948_/Q VPWR VGND sg13cmos5l_mux4_1
X_1525_ _1525_/Q Tile_X0Y2_FrameData[28] VGND VPWR Tile_X0Y9_FrameStrobe[3] latch
XFILLER_704_28 VPWR VGND sg13cmos5l_decap_8
XFILLER_448_214 VPWR VGND sg13cmos5l_decap_4
XFILLER_206_20 VPWR VGND sg13cmos5l_decap_8
XFILLER_113_132 VPWR VGND sg13cmos5l_decap_8
XFILLER_634_91 VPWR VGND sg13cmos5l_decap_8
XFILLER_649_196 VPWR VGND sg13cmos5l_decap_8
XFILLER_259_147 VPWR VGND sg13cmos5l_fill_2
X_4244_ _4244_/X Tile_X0Y2_W1END[0] Tile_X0Y2_W2MID[3] Tile_X0Y2_W2END[3] _4102_/X
+ _1621_/Q _1620_/Q VPWR VGND sg13cmos5l_mux4_1
X_1456_ _1456_/Q Tile_X0Y2_FrameData[1] VGND VPWR Tile_X0Y9_FrameStrobe[0] latch
XFILLER_570_35 VPWR VGND sg13cmos5l_decap_8
XFILLER_259_169 VPWR VGND sg13cmos5l_decap_8
XFILLER_353_70 VPWR VGND sg13cmos5l_decap_8
XFILLER_664_155 VPWR VGND sg13cmos5l_fill_1
XFILLER_463_217 VPWR VGND sg13cmos5l_fill_1
X_0407_ _0407_/Q Tile_X0Y7_FrameData[8] VGND VPWR Tile_X0Y9_FrameStrobe[7] latch
XFILLER_206_97 VPWR VGND sg13cmos5l_decap_8
X_1387_ _1387_/Q Tile_X0Y1_FrameData[14] VGND VPWR Tile_X0Y9_FrameStrobe[6] latch
X_4175_ _4175_/X Tile_X0Y3_WW4END[4] AXI_M_SOC_WREADY _4226_/X _4210_/X _1791_/Q _1790_/Q
+ VPWR VGND sg13cmos5l_mux4_1
X_3126_ Tile_X0Y7_EE4BEG[12] _4640_/X VPWR VGND sg13cmos5l_buf_1
X_0338_ _0338_/Q Tile_X0Y7_FrameData[13] VGND VPWR Tile_X0Y9_FrameStrobe[5] latch
XFILLER_503_84 VPWR VGND sg13cmos5l_decap_8
XFILLER_282_161 VPWR VGND sg13cmos5l_decap_4
XFILLER_620_203 VPWR VGND sg13cmos5l_decap_8
XFILLER_222_63 VPWR VGND sg13cmos5l_decap_8
X_0269_ _0269_/Q Tile_X0Y7_FrameData[18] VGND VPWR Tile_X0Y9_FrameStrobe[3] latch
X_3057_ Tile_X0Y5_FrameData_O[16] Tile_X0Y5_FrameData[16] VPWR VGND sg13cmos5l_buf_1
XFILLER_35_28 VPWR VGND sg13cmos5l_decap_8
X_2008_ _2008_/Q Tile_X0Y4_FrameData[13] VGND VPWR Tile_X0Y9_FrameStrobe[2] latch
XFILLER_579_77 VPWR VGND sg13cmos5l_decap_8
XFILLER_298_56 VPWR VGND sg13cmos5l_decap_8
XFILLER_585_151 VPWR VGND sg13cmos5l_decap_4
XFILLER_595_21 VPWR VGND sg13cmos5l_decap_8
XFILLER_50_152 VPWR VGND sg13cmos5l_decap_8
XFILLER_51_27 VPWR VGND sg13cmos5l_decap_8
X_3959_ _3959_/X Tile_X0Y1_WW4END[4] AXI_M_SOC_ARREADY _4012_/X _3994_/X _1291_/Q
+ _1290_/Q VPWR VGND sg13cmos5l_mux4_1
XFILLER_448_59 VPWR VGND sg13cmos5l_decap_8
XFILLER_195_168 VPWR VGND sg13cmos5l_decap_8
XFILLER_129_7 VPWR VGND sg13cmos5l_decap_8
XFILLER_528_81 VPWR VGND sg13cmos5l_decap_8
XFILLER_337_184 VPWR VGND sg13cmos5l_fill_2
XFILLER_464_14 VPWR VGND sg13cmos5l_decap_8
XANTENNA__3275__X Tile_X0Y0_EE4BEG[11] VPWR VGND sg13cmos5l_antennanp
XFILLER_498_147 VPWR VGND sg13cmos5l_decap_8
XFILLER_151_216 VPWR VGND sg13cmos5l_fill_2
XFILLER_297_209 VPWR VGND sg13cmos5l_fill_2
XFILLER_104_110 VPWR VGND sg13cmos5l_fill_1
XFILLER_614_28 VPWR VGND sg13cmos5l_decap_8
XFILLER_183_59 VPWR VGND sg13cmos5l_fill_2
XFILLER_104_132 VPWR VGND sg13cmos5l_decap_8
XFILLER_498_7 VPWR VGND sg13cmos5l_decap_8
XFILLER_116_20 VPWR VGND sg13cmos5l_decap_8
XFILLER_480_35 VPWR VGND sg13cmos5l_decap_8
XFILLER_76_35 VPWR VGND sg13cmos5l_decap_8
XFILLER_116_97 VPWR VGND sg13cmos5l_decap_8
XFILLER_665_7 VPWR VGND sg13cmos5l_decap_8
XFILLER_18_116 VPWR VGND sg13cmos5l_fill_1
XFILLER_630_49 VPWR VGND sg13cmos5l_decap_8
XFILLER_413_84 VPWR VGND sg13cmos5l_decap_8
XFILLER_407_166 VPWR VGND sg13cmos5l_decap_8
XFILLER_132_63 VPWR VGND sg13cmos5l_decap_8
XFILLER_92_23 VPWR VGND sg13cmos5l_fill_2
XFILLER_489_77 VPWR VGND sg13cmos5l_decap_8
XFILLER_639_14 VPWR VGND sg13cmos5l_decap_8
XFILLER_155_0 VPWR VGND sg13cmos5l_decap_8
XFILLER_576_140 VPWR VGND sg13cmos5l_decap_8
XFILLER_41_130 VPWR VGND sg13cmos5l_fill_2
XFILLER_186_113 VPWR VGND sg13cmos5l_decap_8
XFILLER_591_132 VPWR VGND sg13cmos5l_decap_4
XFILLER_322_0 VPWR VGND sg13cmos5l_decap_8
XFILLER_186_157 VPWR VGND sg13cmos5l_decap_8
XFILLER_655_35 VPWR VGND sg13cmos5l_decap_8
XFILLER_438_70 VPWR VGND sg13cmos5l_decap_8
XFILLER_343_121 VPWR VGND sg13cmos5l_decap_8
XFILLER_374_14 VPWR VGND sg13cmos5l_decap_8
XANTENNA__3185__X Tile_X0Y0_N4BEG[9] VPWR VGND sg13cmos5l_antennanp
XFILLER_157_82 VPWR VGND sg13cmos5l_decap_8
XFILLER_288_209 VPWR VGND sg13cmos5l_fill_1
XFILLER_489_169 VPWR VGND sg13cmos5l_fill_1
XFILLER_691_0 VPWR VGND sg13cmos5l_decap_8
XFILLER_343_198 VPWR VGND sg13cmos5l_decap_8
XFILLER_524_28 VPWR VGND sg13cmos5l_decap_8
XFILLER_671_56 VPWR VGND sg13cmos5l_decap_8
X_1310_ _1310_/Q Tile_X0Y1_FrameData[27] VGND VPWR Tile_X0Y9_FrameStrobe[4] latch
XFILLER_500_140 VPWR VGND sg13cmos5l_decap_8
X_2290_ _2290_/Q Tile_X0Y5_FrameData[19] VGND VPWR Tile_X0Y9_FrameStrobe[3] latch
XFILLER_646_133 VPWR VGND sg13cmos5l_decap_8
XFILLER_390_35 VPWR VGND sg13cmos5l_decap_8
XFILLER_2_21 VPWR VGND sg13cmos5l_decap_8
X_1241_ _1241_/Q Tile_X0Y1_FrameData[0] VGND VPWR Tile_X0Y9_FrameStrobe[1] latch
XFILLER_256_128 VPWR VGND sg13cmos5l_decap_8
XFILLER_323_51 VPWR VGND sg13cmos5l_decap_8
XFILLER_599_210 VPWR VGND sg13cmos5l_decap_8
XFILLER_110_179 VPWR VGND sg13cmos5l_decap_4
X_1172_ _1172_/Q Tile_X0Y0_FrameData[23] VGND VPWR Tile_X0Y9_FrameStrobe[7] latch
XFILLER_540_49 VPWR VGND sg13cmos5l_decap_4
XFILLER_323_84 VPWR VGND sg13cmos5l_decap_8
X_0123_ AXI_M_SOC_ARSIZE2 _0932_/Q _3770_/X VPWR VGND sg13cmos5l_nor2b_1
XANTENNA__0049__X AXI_M_SOC_AWCACHE0 VPWR VGND sg13cmos5l_antennanp
X_0054_ _0054_/X _4680_/X _4681_/X _1857_/Q VPWR VGND sg13cmos5l_mux2_1
X_4931_ _4931_/X Tile_X0Y9_N1END[3] Tile_X0Y9_N4END[3] _4899_/X _0080_/X _0697_/Q
+ _0696_/Q VPWR VGND sg13cmos5l_mux4_1
XFILLER_399_77 VPWR VGND sg13cmos5l_decap_8
XFILLER_549_14 VPWR VGND sg13cmos5l_decap_8
XFILLER_212_209 VPWR VGND sg13cmos5l_fill_1
XFILLER_17_171 VPWR VGND sg13cmos5l_decap_8
XFILLER_413_169 VPWR VGND sg13cmos5l_decap_8
XFILLER_696_42 VPWR VGND sg13cmos5l_decap_8
XFILLER_567_140 VPWR VGND sg13cmos5l_decap_8
X_4862_ _4862_/X Tile_X0Y9_W2END[1] AXI_M_SOC_RDATA1 _4903_/X _4902_/X _0819_/Q _0818_/Q
+ VPWR VGND sg13cmos5l_mux4_1
XFILLER_177_102 VPWR VGND sg13cmos5l_decap_8
X_3813_ _3813_/X Tile_X0Y0_W2MID[4] Tile_X0Y0_W2END[6] _3855_/X _3854_/X _1079_/Q
+ _1078_/Q VPWR VGND sg13cmos5l_mux4_1
XFILLER_567_184 VPWR VGND sg13cmos5l_fill_2
XANTENNA_15 AXI_M_SOC_WREADY VPWR VGND sg13cmos5l_antennanp
XANTENNA_26 AXI_M_SOC_WREADY VPWR VGND sg13cmos5l_antennanp
X_4793_ _4793_/X _4340_/X _4344_/X _4348_/X _4318_/X _2121_/Q _2120_/Q VPWR VGND sg13cmos5l_mux4_1
XANTENNA_37 Tile_X0Y0_S2MID[0] VPWR VGND sg13cmos5l_antennanp
XFILLER_177_168 VPWR VGND sg13cmos5l_decap_8
XANTENNA_48 Tile_X0Y0_S2MID[6] VPWR VGND sg13cmos5l_antennanp
XFILLER_629_91 VPWR VGND sg13cmos5l_decap_8
XFILLER_716_159 VPWR VGND sg13cmos5l_decap_8
XFILLER_192_105 VPWR VGND sg13cmos5l_decap_8
XANTENNA_59 Tile_X0Y9_FrameStrobe[10] VPWR VGND sg13cmos5l_antennanp
X_3744_ AXI_M_SOC_ARADDR16 Tile_X0Y8_WW4END[0] Tile_X0Y8_WW4END[8] Tile_X0Y8_W6END[0]
+ _4800_/X _0503_/Q _0502_/Q VPWR VGND sg13cmos5l_mux4_1
XFILLER_70_0 VPWR VGND sg13cmos5l_decap_8
X_0956_ _0956_/Q Tile_X0Y0_FrameData[15] VGND VPWR Tile_X0Y9_FrameStrobe[0] latch
XFILLER_565_35 VPWR VGND sg13cmos5l_decap_8
XFILLER_348_70 VPWR VGND sg13cmos5l_decap_8
XFILLER_319_184 VPWR VGND sg13cmos5l_decap_8
XFILLER_523_210 VPWR VGND sg13cmos5l_fill_1
XFILLER_284_14 VPWR VGND sg13cmos5l_decap_8
X_3675_ _3675_/X Tile_X0Y2_WW4END[5] Tile_X0Y2_WW4END[13] Tile_X0Y2_W6END[5] _4121_/X
+ _1495_/Q _1494_/Q VPWR VGND sg13cmos5l_mux4_1
XFILLER_669_214 VPWR VGND sg13cmos5l_decap_4
X_0887_ _0887_/Q Tile_X0Y9_FrameData[8] VGND VPWR Tile_X0Y9_FrameStrobe[6] latch
XFILLER_334_143 VPWR VGND sg13cmos5l_decap_8
XANTENNA__3095__X Tile_X0Y7_E2BEGb[1] VPWR VGND sg13cmos5l_antennanp
XFILLER_715_27 VPWR VGND sg13cmos5l_decap_8
X_2626_ _2626_/Q Tile_X0Y6_FrameData[5] VGND VPWR Tile_X0Y9_FrameStrobe[5] latch
XFILLER_133_216 VPWR VGND sg13cmos5l_fill_2
XFILLER_217_41 VPWR VGND sg13cmos5l_decap_8
XFILLER_434_28 VPWR VGND sg13cmos5l_decap_8
X_2557_ _2557_/Q Tile_X0Y6_FrameData[10] VGND VPWR Tile_X0Y9_FrameStrobe[3] latch
XFILLER_581_56 VPWR VGND sg13cmos5l_decap_4
X_1508_ _1508_/Q Tile_X0Y2_FrameData[13] VGND VPWR Tile_X0Y9_FrameStrobe[2] latch
XFILLER_581_78 VPWR VGND sg13cmos5l_decap_8
X_2488_ _2488_/Q Tile_X0Y6_FrameData[15] VGND VPWR Tile_X0Y9_FrameStrobe[1] latch
XFILLER_637_166 VPWR VGND sg13cmos5l_decap_4
X_4227_ _4227_/X _4197_/X _0088_/X _4196_/X Tile_X0Y0_S4END[13] _1719_/Q _1718_/Q
+ VPWR VGND sg13cmos5l_mux4_1
XFILLER_101_146 VPWR VGND sg13cmos5l_decap_8
X_1439_ _1439_/Q Tile_X0Y2_FrameData[18] VGND VPWR Tile_X0Y9_FrameStrobe[0] latch
XFILLER_233_51 VPWR VGND sg13cmos5l_fill_1
XFILLER_652_147 VPWR VGND sg13cmos5l_decap_8
X_4158_ _4158_/X Tile_X0Y3_W2END[5] AXI_M_SOC_BVALID _4209_/X _4208_/X _1825_/Q _1824_/Q
+ VPWR VGND sg13cmos5l_mux4_1
XFILLER_450_49 VPWR VGND sg13cmos5l_decap_8
XFILLER_451_209 VPWR VGND sg13cmos5l_decap_8
X_3109_ Tile_X0Y7_E6BEG[7] _4651_/X VPWR VGND sg13cmos5l_buf_1
XFILLER_404_114 VPWR VGND sg13cmos5l_decap_4
X_4089_ _4089_/X Tile_X0Y3_W1END[0] Tile_X0Y3_W6END[4] _4234_/X _4198_/X _1925_/Q
+ _1924_/Q VPWR VGND sg13cmos5l_mux4_1
XFILLER_15_119 VPWR VGND sg13cmos5l_decap_8
XFILLER_404_147 VPWR VGND sg13cmos5l_decap_8
XFILLER_270_142 VPWR VGND sg13cmos5l_fill_1
XFILLER_459_14 VPWR VGND sg13cmos5l_decap_8
XFILLER_62_26 VPWR VGND sg13cmos5l_decap_8
XFILLER_102_77 VPWR VGND sg13cmos5l_fill_1
XFILLER_246_7 VPWR VGND sg13cmos5l_decap_8
XFILLER_102_99 VPWR VGND sg13cmos5l_decap_8
XFILLER_558_162 VPWR VGND sg13cmos5l_fill_1
XFILLER_178_15 VPWR VGND sg13cmos5l_fill_1
XFILLER_141_6 VPWR VGND sg13cmos5l_decap_8
XFILLER_558_184 VPWR VGND sg13cmos5l_decap_8
XFILLER_707_126 VPWR VGND sg13cmos5l_decap_8
XFILLER_558_195 VPWR VGND sg13cmos5l_decap_8
XFILLER_609_28 VPWR VGND sg13cmos5l_decap_8
XFILLER_539_80 VPWR VGND sg13cmos5l_fill_2
XFILLER_573_154 VPWR VGND sg13cmos5l_decap_8
XFILLER_168_179 VPWR VGND sg13cmos5l_decap_8
XFILLER_413_7 VPWR VGND sg13cmos5l_decap_8
XFILLER_109_202 VPWR VGND sg13cmos5l_decap_4
XANTENNA__2902__X Tile_X0Y6_FrameData_O[23] VPWR VGND sg13cmos5l_antennanp
XFILLER_475_35 VPWR VGND sg13cmos5l_decap_8
XFILLER_194_14 VPWR VGND sg13cmos5l_decap_8
XFILLER_176_190 VPWR VGND sg13cmos5l_fill_2
XFILLER_715_181 VPWR VGND sg13cmos5l_fill_1
XFILLER_124_216 VPWR VGND sg13cmos5l_fill_2
XFILLER_408_73 VPWR VGND sg13cmos5l_decap_8
XFILLER_625_49 VPWR VGND sg13cmos5l_decap_8
XFILLER_11_63 VPWR VGND sg13cmos5l_decap_8
XANTENNA__0141__Y AXI_M_SOC_ARLEN1 VPWR VGND sg13cmos5l_antennanp
XFILLER_675_217 VPWR VGND sg13cmos5l_fill_1
XFILLER_344_28 VPWR VGND sg13cmos5l_decap_8
XFILLER_127_63 VPWR VGND sg13cmos5l_decap_8
XFILLER_340_157 VPWR VGND sg13cmos5l_decap_8
XFILLER_491_56 VPWR VGND sg13cmos5l_decap_8
XFILLER_274_91 VPWR VGND sg13cmos5l_decap_8
XANTENNA__3733__X AXI_M_SOC_ARADDR5 VPWR VGND sg13cmos5l_antennanp
XFILLER_87_67 VPWR VGND sg13cmos5l_decap_8
XFILLER_628_144 VPWR VGND sg13cmos5l_decap_8
XFILLER_628_166 VPWR VGND sg13cmos5l_fill_1
XFILLER_494_161 VPWR VGND sg13cmos5l_decap_8
XFILLER_238_139 VPWR VGND sg13cmos5l_decap_8
XFILLER_643_147 VPWR VGND sg13cmos5l_decap_8
XFILLER_360_49 VPWR VGND sg13cmos5l_decap_8
XFILLER_143_84 VPWR VGND sg13cmos5l_decap_4
XFILLER_272_0 VPWR VGND sg13cmos5l_decap_8
XFILLER_596_202 VPWR VGND sg13cmos5l_decap_8
XFILLER_369_14 VPWR VGND sg13cmos5l_decap_8
XFILLER_261_175 VPWR VGND sg13cmos5l_decap_8
XFILLER_537_0 VPWR VGND sg13cmos5l_decap_8
XFILLER_14_152 VPWR VGND sg13cmos5l_decap_8
XFILLER_519_28 VPWR VGND sg13cmos5l_decap_8
XFILLER_14_196 VPWR VGND sg13cmos5l_decap_8
XFILLER_704_0 VPWR VGND sg13cmos5l_decap_8
XFILLER_666_56 VPWR VGND sg13cmos5l_decap_8
XANTENNA__2812__X Tile_X0Y3_E2BEG[2] VPWR VGND sg13cmos5l_antennanp
X_0810_ _0810_/Q Tile_X0Y9_FrameData[21] VGND VPWR Tile_X0Y9_FrameStrobe[4] latch
X_1790_ _1790_/Q Tile_X0Y3_FrameData[11] VGND VPWR Tile_X0Y9_FrameStrobe[3] latch
XFILLER_385_35 VPWR VGND sg13cmos5l_fill_2
X_0741_ _0741_/Q Tile_X0Y9_FrameData[26] VGND VPWR Tile_X0Y9_FrameStrobe[2] latch
XFILLER_385_68 VPWR VGND sg13cmos5l_decap_8
XFILLER_318_40 VPWR VGND sg13cmos5l_decap_8
XFILLER_115_205 VPWR VGND sg13cmos5l_fill_2
X_3460_ Tile_X0Y1_FrameData_O[18] Tile_X0Y1_FrameData[18] VPWR VGND sg13cmos5l_buf_1
XFILLER_318_73 VPWR VGND sg13cmos5l_decap_8
XFILLER_316_176 VPWR VGND sg13cmos5l_decap_8
X_0672_ _0672_/Q Tile_X0Y8_FrameData[31] VGND VPWR Tile_X0Y9_FrameStrobe[0] latch
XFILLER_535_49 VPWR VGND sg13cmos5l_decap_4
XFILLER_331_113 VPWR VGND sg13cmos5l_decap_8
XFILLER_331_124 VPWR VGND sg13cmos5l_fill_2
XANTENNA__0051__Y AXI_M_SOC_AWBURST1 VPWR VGND sg13cmos5l_antennanp
X_2411_ _2411_/Q Tile_X0Y5_FrameData[26] VGND VPWR Tile_X0Y9_FrameStrobe[7] latch
XFILLER_254_28 VPWR VGND sg13cmos5l_decap_4
X_3391_ Tile_X0Y2_E2BEGb[2] _4050_/X VPWR VGND sg13cmos5l_buf_1
XFILLER_254_39 VPWR VGND sg13cmos5l_decap_8
XANTENNA__3643__X AXI_M_SOC_AWADDR4 VPWR VGND sg13cmos5l_antennanp
X_2342_ _2342_/Q Tile_X0Y5_FrameData[31] VGND VPWR Tile_X0Y9_FrameStrobe[5] latch
XFILLER_485_161 VPWR VGND sg13cmos5l_decap_8
XFILLER_284_201 VPWR VGND sg13cmos5l_decap_4
XFILLER_619_177 VPWR VGND sg13cmos5l_fill_1
X_2273_ _2273_/Q Tile_X0Y5_FrameData[4] VGND VPWR Tile_X0Y9_FrameStrobe[2] latch
XFILLER_619_199 VPWR VGND sg13cmos5l_decap_4
X_4012_ _4012_/X _3981_/X _0073_/X _3980_/X Tile_X0Y0_S4END[4] _1225_/Q _1224_/Q VPWR
+ VGND sg13cmos5l_mux4_1
XFILLER_96_199 VPWR VGND sg13cmos5l_decap_8
X_1224_ _1224_/Q Tile_X0Y1_FrameData[17] VGND VPWR Tile_X0Y9_FrameStrobe[1] latch
XFILLER_433_209 VPWR VGND sg13cmos5l_fill_2
XFILLER_270_49 VPWR VGND sg13cmos5l_decap_8
XFILLER_631_70 VPWR VGND sg13cmos5l_decap_8
XFILLER_237_161 VPWR VGND sg13cmos5l_decap_8
XFILLER_203_21 VPWR VGND sg13cmos5l_decap_8
X_1155_ _1155_/Q Tile_X0Y0_FrameData[8] VGND VPWR Tile_X0Y9_FrameStrobe[6] latch
XFILLER_252_142 VPWR VGND sg13cmos5l_decap_8
X_0106_ AXI_M_SOC_ARLEN3 _0933_/Q _3763_/X VPWR VGND sg13cmos5l_nor2b_1
X_1086_ _1086_/Q Tile_X0Y0_FrameData[13] VGND VPWR Tile_X0Y9_FrameStrobe[4] latch
XFILLER_203_98 VPWR VGND sg13cmos5l_decap_8
XFILLER_197_208 VPWR VGND sg13cmos5l_fill_1
X_4914_ _4914_/X Tile_X0Y5_W1END[3] Tile_X0Y5_WW4END[15] Tile_X0Y5_W6END[7] _4454_/X
+ _2370_/Q _2369_/Q VPWR VGND sg13cmos5l_mux4_1
XFILLER_500_63 VPWR VGND sg13cmos5l_decap_8
XFILLER_279_69 VPWR VGND sg13cmos5l_decap_8
X_4845_ _4845_/X Tile_X0Y9_N1END[1] _4897_/X AXI_M_SOC_RDATA2 AXI_M_SOC_RDATA6 _0853_/Q
+ _0852_/Q VPWR VGND sg13cmos5l_mux4_1
XFILLER_429_28 VPWR VGND sg13cmos5l_decap_8
XFILLER_576_56 VPWR VGND sg13cmos5l_decap_8
XFILLER_359_91 VPWR VGND sg13cmos5l_decap_8
X_4776_ _4776_/X Tile_X0Y7_W1END[0] Tile_X0Y7_W6END[8] _4696_/X _4656_/X _0379_/Q
+ _0378_/Q VPWR VGND sg13cmos5l_mux4_1
XFILLER_295_35 VPWR VGND sg13cmos5l_decap_8
X_1988_ _1988_/Q Tile_X0Y4_FrameData[1] VGND VPWR Tile_X0Y9_FrameStrobe[1] latch
XFILLER_20_177 VPWR VGND sg13cmos5l_decap_8
X_3727_ AXI_M_SOC_BREADY Tile_X0Y3_W1END[1] Tile_X0Y3_WW4END[5] Tile_X0Y3_WW4END[13]
+ _4235_/X _1731_/Q _1730_/Q VPWR VGND sg13cmos5l_mux4_1
XFILLER_307_121 VPWR VGND sg13cmos5l_decap_4
X_0939_ _0939_/Q Tile_X0Y9_FrameData[30] VGND VPWR Tile_X0Y9_FrameStrobe[8] latch
XFILLER_570_168 VPWR VGND sg13cmos5l_decap_8
XFILLER_173_160 VPWR VGND sg13cmos5l_decap_8
XFILLER_712_140 VPWR VGND sg13cmos5l_decap_8
X_3658_ AXI_M_SOC_AWADDR19 Tile_X0Y4_WW4END[3] Tile_X0Y4_WW4END[11] Tile_X0Y4_W6END[3]
+ _4339_/X _2007_/Q _2006_/Q VPWR VGND sg13cmos5l_mux4_1
XFILLER_468_106 VPWR VGND sg13cmos5l_decap_8
XFILLER_322_135 VPWR VGND sg13cmos5l_decap_8
X_2609_ _2609_/Q Tile_X0Y6_FrameData[22] VGND VPWR Tile_X0Y9_FrameStrobe[5] latch
XFILLER_164_28 VPWR VGND sg13cmos5l_decap_8
XFILLER_164_39 VPWR VGND sg13cmos5l_fill_1
X_3589_ Tile_X0Y9_FrameData_O[19] Tile_X0Y9_FrameData[19] VPWR VGND sg13cmos5l_buf_1
XFILLER_121_208 VPWR VGND sg13cmos5l_fill_1
XANTENNA__3553__X Tile_X0Y9_E6BEG[11] VPWR VGND sg13cmos5l_antennanp
XFILLER_322_179 VPWR VGND sg13cmos5l_decap_4
XFILLER_87_166 VPWR VGND sg13cmos5l_decap_8
XFILLER_57_48 VPWR VGND sg13cmos5l_fill_2
XFILLER_180_27 VPWR VGND sg13cmos5l_decap_4
XFILLER_180_38 VPWR VGND sg13cmos5l_decap_8
XFILLER_228_150 VPWR VGND sg13cmos5l_decap_4
XFILLER_491_175 VPWR VGND sg13cmos5l_decap_8
XFILLER_113_21 VPWR VGND sg13cmos5l_decap_8
XFILLER_73_14 VPWR VGND sg13cmos5l_decap_8
XFILLER_243_164 VPWR VGND sg13cmos5l_decap_4
XFILLER_189_14 VPWR VGND sg13cmos5l_decap_8
XFILLER_243_175 VPWR VGND sg13cmos5l_decap_8
XFILLER_389_168 VPWR VGND sg13cmos5l_fill_2
XFILLER_530_7 VPWR VGND sg13cmos5l_decap_8
XFILLER_410_63 VPWR VGND sg13cmos5l_decap_8
XFILLER_628_7 VPWR VGND sg13cmos5l_decap_8
XANTENNA__0136__Y AXI_M_SOC_AWLEN3 VPWR VGND sg13cmos5l_antennanp
XFILLER_339_28 VPWR VGND sg13cmos5l_decap_8
XFILLER_546_143 VPWR VGND sg13cmos5l_decap_8
XFILLER_486_56 VPWR VGND sg13cmos5l_decap_8
XFILLER_11_133 VPWR VGND sg13cmos5l_fill_2
XANTENNA__3728__X AXI_M_SOC_ARADDR0 VPWR VGND sg13cmos5l_antennanp
XFILLER_546_154 VPWR VGND sg13cmos5l_fill_1
XFILLER_269_91 VPWR VGND sg13cmos5l_decap_8
XFILLER_11_177 VPWR VGND sg13cmos5l_fill_2
XFILLER_7_159 VPWR VGND sg13cmos5l_fill_1
XFILLER_360_208 VPWR VGND sg13cmos5l_fill_1
XFILLER_118_0 VPWR VGND sg13cmos5l_decap_8
XFILLER_355_49 VPWR VGND sg13cmos5l_decap_8
XFILLER_164_182 VPWR VGND sg13cmos5l_decap_8
XFILLER_138_84 VPWR VGND sg13cmos5l_decap_8
XFILLER_313_124 VPWR VGND sg13cmos5l_decap_8
XFILLER_716_92 VPWR VGND sg13cmos5l_decap_4
XFILLER_648_217 VPWR VGND sg13cmos5l_fill_1
XFILLER_652_14 VPWR VGND sg13cmos5l_decap_8
XFILLER_98_77 VPWR VGND sg13cmos5l_decap_8
XFILLER_0_0 VPWR VGND sg13cmos5l_fill_2
XANTENNA__3463__X Tile_X0Y1_FrameData_O[21] VPWR VGND sg13cmos5l_antennanp
XFILLER_154_50 VPWR VGND sg13cmos5l_fill_2
XFILLER_467_150 VPWR VGND sg13cmos5l_fill_1
XFILLER_78_144 VPWR VGND sg13cmos5l_decap_8
XFILLER_487_0 VPWR VGND sg13cmos5l_decap_8
XFILLER_304_53 VPWR VGND sg13cmos5l_fill_2
XFILLER_281_204 VPWR VGND sg13cmos5l_fill_2
XFILLER_451_70 VPWR VGND sg13cmos5l_decap_8
XFILLER_281_215 VPWR VGND sg13cmos5l_fill_2
XFILLER_654_0 VPWR VGND sg13cmos5l_decap_8
XFILLER_219_172 VPWR VGND sg13cmos5l_decap_8
XANTENNA__2807__X Tile_X0Y3_E2BEGb[5] VPWR VGND sg13cmos5l_antennanp
XFILLER_47_81 VPWR VGND sg13cmos5l_decap_8
XFILLER_234_131 VPWR VGND sg13cmos5l_decap_8
X_2960_ Tile_X0Y8_FrameData_O[0] Tile_X0Y8_FrameData[0] VPWR VGND sg13cmos5l_buf_1
XFILLER_395_116 VPWR VGND sg13cmos5l_decap_8
XFILLER_537_110 VPWR VGND sg13cmos5l_decap_8
X_1911_ _1911_/Q Tile_X0Y3_FrameData[18] VGND VPWR Tile_X0Y9_FrameStrobe[7] latch
XFILLER_677_77 VPWR VGND sg13cmos5l_decap_8
XFILLER_537_121 VPWR VGND sg13cmos5l_fill_2
XFILLER_249_28 VPWR VGND sg13cmos5l_decap_8
X_2891_ Tile_X0Y6_FrameData_O[12] Tile_X0Y6_FrameData[12] VPWR VGND sg13cmos5l_buf_1
XANTENNA__3638__X Tile_X0Y9_UserCLKo VPWR VGND sg13cmos5l_antennanp
X_4630_ _4630_/X Tile_X0Y7_WW4END[13] AXI_M_SOC_RDATA18 _4697_/X _4672_/X _0299_/Q
+ _0298_/Q VPWR VGND sg13cmos5l_mux4_1
XFILLER_8_42 VPWR VGND sg13cmos5l_decap_8
X_1842_ _1842_/Q Tile_X0Y3_FrameData[23] VGND VPWR Tile_X0Y9_FrameStrobe[5] latch
XFILLER_336_216 VPWR VGND sg13cmos5l_fill_2
XFILLER_693_21 VPWR VGND sg13cmos5l_decap_8
XFILLER_552_124 VPWR VGND sg13cmos5l_decap_4
X_4561_ _4561_/X _4120_/X _4124_/X _4113_/X _4102_/X _1613_/Q _1612_/Q VPWR VGND sg13cmos5l_mux4_1
X_1773_ _1773_/Q Tile_X0Y3_FrameData[28] VGND VPWR Tile_X0Y9_FrameStrobe[3] latch
XFILLER_162_119 VPWR VGND sg13cmos5l_fill_2
X_3512_ Tile_X0Y1_E2BEG[2] _3934_/X VPWR VGND sg13cmos5l_buf_1
X_0724_ _0724_/Q Tile_X0Y9_FrameData[11] VGND VPWR Tile_X0Y9_FrameStrobe[1] latch
XFILLER_693_98 VPWR VGND sg13cmos5l_decap_8
X_4492_ _4492_/X _4545_/X _4544_/X AXI_M_SOC_RDATA27 AXI_M_SOC_RDATA31 _2623_/Q _2622_/Q
+ VPWR VGND sg13cmos5l_mux4_1
XFILLER_265_49 VPWR VGND sg13cmos5l_decap_8
XFILLER_626_70 VPWR VGND sg13cmos5l_decap_8
X_3443_ Tile_X0Y1_FrameData_O[1] Tile_X0Y1_FrameData[1] VPWR VGND sg13cmos5l_buf_1
XFILLER_562_14 VPWR VGND sg13cmos5l_decap_8
XFILLER_560_190 VPWR VGND sg13cmos5l_decap_4
XFILLER_304_146 VPWR VGND sg13cmos5l_decap_4
X_0655_ _0655_/Q Tile_X0Y8_FrameData[16] VGND VPWR Tile_X0Y9_FrameStrobe[7] latch
XFILLER_170_152 VPWR VGND sg13cmos5l_decap_4
XANTENNA__3373__X Tile_X0Y2_EE4BEG[12] VPWR VGND sg13cmos5l_antennanp
XFILLER_170_185 VPWR VGND sg13cmos5l_decap_8
X_3374_ Tile_X0Y2_EE4BEG[13] _4069_/X VPWR VGND sg13cmos5l_buf_1
X_0586_ _0586_/Q Tile_X0Y8_FrameData[21] VGND VPWR Tile_X0Y9_FrameStrobe[5] latch
XFILLER_33_0 VPWR VGND sg13cmos5l_decap_8
XFILLER_69_144 VPWR VGND sg13cmos5l_decap_4
XFILLER_712_28 VPWR VGND sg13cmos5l_decap_8
X_2325_ _2325_/Q Tile_X0Y5_FrameData[16] VGND VPWR Tile_X0Y9_FrameStrobe[4] latch
XFILLER_312_190 VPWR VGND sg13cmos5l_decap_8
XFILLER_458_194 VPWR VGND sg13cmos5l_fill_2
XFILLER_642_91 VPWR VGND sg13cmos5l_decap_8
XFILLER_607_136 VPWR VGND sg13cmos5l_decap_8
XFILLER_473_131 VPWR VGND sg13cmos5l_decap_8
XFILLER_214_42 VPWR VGND sg13cmos5l_decap_8
X_2256_ _2256_/Q Tile_X0Y5_FrameData[21] VGND VPWR Tile_X0Y9_FrameStrobe[2] latch
XFILLER_361_70 VPWR VGND sg13cmos5l_decap_4
X_1207_ _1207_/Q Tile_X0Y1_FrameData[2] VGND VPWR Tile_X0Y9_FrameStrobe[0] latch
X_2187_ _2187_/Q Tile_X0Y5_FrameData[26] VGND VPWR Tile_X0Y9_FrameStrobe[0] latch
XFILLER_225_142 VPWR VGND sg13cmos5l_decap_8
X_1138_ _1138_/Q Tile_X0Y0_FrameData[25] VGND VPWR Tile_X0Y9_FrameStrobe[6] latch
XFILLER_225_164 VPWR VGND sg13cmos5l_decap_8
XFILLER_92_191 VPWR VGND sg13cmos5l_fill_1
XFILLER_386_105 VPWR VGND sg13cmos5l_fill_2
X_1069_ _1069_/Q Tile_X0Y0_FrameData[30] VGND VPWR Tile_X0Y9_FrameStrobe[4] latch
XFILLER_230_85 VPWR VGND sg13cmos5l_decap_8
XFILLER_587_66 VPWR VGND sg13cmos5l_decap_8
XFILLER_386_149 VPWR VGND sg13cmos5l_decap_8
XANTENNA__3548__X Tile_X0Y9_E6BEG[6] VPWR VGND sg13cmos5l_antennanp
XFILLER_138_105 VPWR VGND sg13cmos5l_decap_8
X_4828_ _4828_/X Tile_X0Y9_W2MID[7] Tile_X0Y9_W2END[7] Tile_X0Y9_W6END[8] _4901_/X
+ _0883_/Q _0882_/Q VPWR VGND sg13cmos5l_mux4_1
XFILLER_528_165 VPWR VGND sg13cmos5l_decap_8
XFILLER_327_216 VPWR VGND sg13cmos5l_fill_2
XFILLER_528_176 VPWR VGND sg13cmos5l_fill_2
X_4759_ _4759_/X Tile_X0Y8_WW4END[0] AXI_M_SOC_RDATA8 _4800_/X _4785_/X _0529_/Q _0528_/Q
+ VPWR VGND sg13cmos5l_mux4_1
XFILLER_4_118 VPWR VGND sg13cmos5l_decap_8
XFILLER_111_7 VPWR VGND sg13cmos5l_decap_8
XFILLER_209_7 VPWR VGND sg13cmos5l_decap_8
XFILLER_175_49 VPWR VGND sg13cmos5l_decap_8
XFILLER_146_193 VPWR VGND sg13cmos5l_decap_8
XFILLER_108_21 VPWR VGND sg13cmos5l_decap_8
XFILLER_472_14 VPWR VGND sg13cmos5l_decap_8
XANTENNA__3283__X Tile_X0Y0_E6BEG[3] VPWR VGND sg13cmos5l_antennanp
XFILLER_700_143 VPWR VGND sg13cmos5l_fill_1
XFILLER_68_36 VPWR VGND sg13cmos5l_decap_8
XFILLER_480_7 VPWR VGND sg13cmos5l_decap_8
XFILLER_191_48 VPWR VGND sg13cmos5l_decap_8
XFILLER_622_28 VPWR VGND sg13cmos5l_decap_8
XFILLER_449_183 VPWR VGND sg13cmos5l_decap_4
XFILLER_578_7 VPWR VGND sg13cmos5l_decap_8
XFILLER_75_103 VPWR VGND sg13cmos5l_decap_8
XFILLER_552_91 VPWR VGND sg13cmos5l_decap_4
XFILLER_124_42 VPWR VGND sg13cmos5l_decap_8
XFILLER_84_13 VPWR VGND sg13cmos5l_decap_8
XFILLER_464_164 VPWR VGND sg13cmos5l_fill_2
XFILLER_271_70 VPWR VGND sg13cmos5l_decap_8
XFILLER_421_84 VPWR VGND sg13cmos5l_decap_8
XFILLER_231_123 VPWR VGND sg13cmos5l_decap_8
XFILLER_140_63 VPWR VGND sg13cmos5l_decap_8
XFILLER_31_217 VPWR VGND sg13cmos5l_fill_1
XFILLER_519_121 VPWR VGND sg13cmos5l_fill_1
XFILLER_497_77 VPWR VGND sg13cmos5l_decap_8
XFILLER_647_14 VPWR VGND sg13cmos5l_decap_8
XFILLER_519_143 VPWR VGND sg13cmos5l_decap_8
XFILLER_235_0 VPWR VGND sg13cmos5l_decap_8
XANTENNA__3458__X Tile_X0Y1_FrameData_O[16] VPWR VGND sg13cmos5l_antennanp
XFILLER_534_113 VPWR VGND sg13cmos5l_decap_8
XFILLER_402_0 VPWR VGND sg13cmos5l_decap_8
XFILLER_663_35 VPWR VGND sg13cmos5l_decap_8
XFILLER_688_150 VPWR VGND sg13cmos5l_fill_1
XFILLER_298_112 VPWR VGND sg13cmos5l_fill_2
XFILLER_298_123 VPWR VGND sg13cmos5l_fill_1
XFILLER_152_130 VPWR VGND sg13cmos5l_decap_8
XFILLER_382_14 VPWR VGND sg13cmos5l_decap_8
XFILLER_98_206 VPWR VGND sg13cmos5l_fill_1
XFILLER_165_60 VPWR VGND sg13cmos5l_fill_2
XANTENNA__3193__X Tile_X0Y0_N2BEGb[1] VPWR VGND sg13cmos5l_antennanp
X_0440_ _0440_/Q Tile_X0Y8_FrameData[7] VGND VPWR Tile_X0Y9_FrameStrobe[0] latch
XFILLER_382_58 VPWR VGND sg13cmos5l_decap_4
XFILLER_152_185 VPWR VGND sg13cmos5l_fill_2
XFILLER_315_30 VPWR VGND sg13cmos5l_fill_1
XFILLER_532_28 VPWR VGND sg13cmos5l_decap_8
X_0371_ _0371_/Q Tile_X0Y7_FrameData[12] VGND VPWR Tile_X0Y9_FrameStrobe[6] latch
X_2110_ _2110_/Q Tile_X0Y4_FrameData[7] VGND VPWR Tile_X0Y9_FrameStrobe[5] latch
X_3090_ Tile_X0Y7_E2BEG[4] _4616_/X VPWR VGND sg13cmos5l_buf_1
XFILLER_254_204 VPWR VGND sg13cmos5l_decap_8
XFILLER_455_164 VPWR VGND sg13cmos5l_decap_8
XFILLER_66_147 VPWR VGND sg13cmos5l_decap_8
X_2041_ _2041_/Q Tile_X0Y4_FrameData[12] VGND VPWR Tile_X0Y9_FrameStrobe[3] latch
XFILLER_688_21 VPWR VGND sg13cmos5l_decap_8
XFILLER_688_43 VPWR VGND sg13cmos5l_decap_8
XFILLER_331_84 VPWR VGND sg13cmos5l_fill_1
XFILLER_557_205 VPWR VGND sg13cmos5l_fill_2
XFILLER_557_216 VPWR VGND sg13cmos5l_fill_2
X_3992_ _3992_/X _3898_/X _4031_/X _4030_/X Tile_X0Y0_S2MID[5] _1191_/Q _1190_/Q VPWR
+ VGND sg13cmos5l_mux4_1
XFILLER_612_194 VPWR VGND sg13cmos5l_decap_8
XFILLER_368_127 VPWR VGND sg13cmos5l_fill_1
X_2943_ Tile_X0Y8_E6BEG[11] _4771_/X VPWR VGND sg13cmos5l_buf_1
XFILLER_557_14 VPWR VGND sg13cmos5l_decap_8
XFILLER_222_189 VPWR VGND sg13cmos5l_decap_8
XANTENNA__3368__X Tile_X0Y2_EE4BEG[7] VPWR VGND sg13cmos5l_antennanp
XFILLER_200_77 VPWR VGND sg13cmos5l_decap_8
XFILLER_175_200 VPWR VGND sg13cmos5l_decap_8
X_2874_ Tile_X0Y6_EE4BEG[11] _4523_/X VPWR VGND sg13cmos5l_buf_1
X_4613_ _4613_/X Tile_X0Y7_W2MID[6] AXI_M_SOC_RDATA17 _4671_/X _4670_/X _0333_/Q _0332_/Q
+ VPWR VGND sg13cmos5l_mux4_1
XFILLER_707_28 VPWR VGND sg13cmos5l_decap_8
X_1825_ _1825_/Q Tile_X0Y3_FrameData[8] VGND VPWR Tile_X0Y9_FrameStrobe[4] latch
XFILLER_135_119 VPWR VGND sg13cmos5l_decap_8
XFILLER_637_91 VPWR VGND sg13cmos5l_decap_8
XFILLER_209_42 VPWR VGND sg13cmos5l_decap_8
X_4544_ _4544_/X Tile_X0Y5_W1END[0] Tile_X0Y5_W6END[8] _4463_/X _4416_/X _2403_/Q
+ _2402_/Q VPWR VGND sg13cmos5l_mux4_1
XFILLER_391_185 VPWR VGND sg13cmos5l_fill_2
X_1756_ _1756_/Q Tile_X0Y3_FrameData[13] VGND VPWR Tile_X0Y9_FrameStrobe[2] latch
XFILLER_573_35 VPWR VGND sg13cmos5l_decap_8
XFILLER_356_70 VPWR VGND sg13cmos5l_decap_8
XFILLER_540_138 VPWR VGND sg13cmos5l_decap_8
X_0707_ _0707_/Q Tile_X0Y9_FrameData[28] VGND VPWR Tile_X0Y9_FrameStrobe[1] latch
XFILLER_292_14 VPWR VGND sg13cmos5l_decap_8
X_4475_ _4475_/X Tile_X0Y7_W2MID[4] Tile_X0Y7_W2END[4] Tile_X0Y7_W6END[4] _4675_/X
+ _0401_/Q _0400_/Q VPWR VGND sg13cmos5l_mux4_1
XFILLER_289_134 VPWR VGND sg13cmos5l_fill_1
X_1687_ _1687_/Q Tile_X0Y3_FrameData[18] VGND VPWR Tile_X0Y9_FrameStrobe[0] latch
XFILLER_289_156 VPWR VGND sg13cmos5l_decap_8
X_3426_ Tile_X0Y4_FrameData_O[17] Tile_X0Y4_FrameData[17] VPWR VGND sg13cmos5l_buf_1
X_0638_ _0638_/Q Tile_X0Y8_FrameData[1] VGND VPWR Tile_X0Y9_FrameStrobe[6] latch
XFILLER_506_84 VPWR VGND sg13cmos5l_fill_2
XFILLER_442_28 VPWR VGND sg13cmos5l_decap_8
X_3357_ Tile_X0Y2_FrameData_O[28] Tile_X0Y2_FrameData[28] VPWR VGND sg13cmos5l_buf_1
X_0569_ _0569_/Q Tile_X0Y8_FrameData[6] VGND VPWR Tile_X0Y9_FrameStrobe[4] latch
X_2308_ _2308_/Q Tile_X0Y5_FrameData[1] VGND VPWR Tile_X0Y9_FrameStrobe[3] latch
XFILLER_245_204 VPWR VGND sg13cmos5l_decap_8
X_3288_ Tile_X0Y0_E6BEG[8] _3844_/X VPWR VGND sg13cmos5l_buf_1
XFILLER_245_215 VPWR VGND sg13cmos5l_fill_2
XFILLER_461_101 VPWR VGND sg13cmos5l_decap_8
XFILLER_446_175 VPWR VGND sg13cmos5l_decap_4
X_2239_ _2239_/Q Tile_X0Y5_FrameData[6] VGND VPWR Tile_X0Y9_FrameStrobe[1] latch
XFILLER_461_145 VPWR VGND sg13cmos5l_decap_8
XFILLER_598_21 VPWR VGND sg13cmos5l_decap_8
XFILLER_72_139 VPWR VGND sg13cmos5l_decap_8
XFILLER_54_16 VPWR VGND sg13cmos5l_decap_8
XFILLER_65_180 VPWR VGND sg13cmos5l_decap_8
XFILLER_65_191 VPWR VGND sg13cmos5l_decap_8
XFILLER_359_105 VPWR VGND sg13cmos5l_decap_8
XFILLER_110_11 VPWR VGND sg13cmos5l_fill_2
XFILLER_80_172 VPWR VGND sg13cmos5l_decap_8
XFILLER_467_14 VPWR VGND sg13cmos5l_decap_8
XANTENNA__3278__X Tile_X0Y0_EE4BEG[14] VPWR VGND sg13cmos5l_antennanp
XFILLER_326_7 VPWR VGND sg13cmos5l_decap_8
XFILLER_516_124 VPWR VGND sg13cmos5l_decap_8
XFILLER_516_135 VPWR VGND sg13cmos5l_fill_2
XFILLER_617_28 VPWR VGND sg13cmos5l_decap_8
XFILLER_126_108 VPWR VGND sg13cmos5l_decap_8
XFILLER_531_105 VPWR VGND sg13cmos5l_decap_8
XFILLER_119_42 VPWR VGND sg13cmos5l_fill_2
XANTENNA__2910__X Tile_X0Y6_FrameData_O[31] VPWR VGND sg13cmos5l_antennanp
XFILLER_531_116 VPWR VGND sg13cmos5l_fill_1
XFILLER_79_13 VPWR VGND sg13cmos5l_decap_8
XFILLER_483_35 VPWR VGND sg13cmos5l_decap_8
XFILLER_266_70 VPWR VGND sg13cmos5l_decap_8
XFILLER_266_92 VPWR VGND sg13cmos5l_decap_8
XFILLER_695_7 VPWR VGND sg13cmos5l_decap_8
XFILLER_79_68 VPWR VGND sg13cmos5l_decap_8
XFILLER_633_49 VPWR VGND sg13cmos5l_decap_8
XFILLER_416_84 VPWR VGND sg13cmos5l_decap_8
XFILLER_484_215 VPWR VGND sg13cmos5l_fill_2
XFILLER_352_28 VPWR VGND sg13cmos5l_decap_8
XFILLER_0_132 VPWR VGND sg13cmos5l_fill_2
XFILLER_135_63 VPWR VGND sg13cmos5l_decap_8
XFILLER_437_120 VPWR VGND sg13cmos5l_decap_8
XANTENNA__3741__X AXI_M_SOC_ARADDR13 VPWR VGND sg13cmos5l_antennanp
XFILLER_282_91 VPWR VGND sg13cmos5l_decap_8
XFILLER_641_201 VPWR VGND sg13cmos5l_fill_2
XFILLER_185_0 VPWR VGND sg13cmos5l_decap_8
XFILLER_151_73 VPWR VGND sg13cmos5l_decap_8
XFILLER_301_21 VPWR VGND sg13cmos5l_decap_8
XFILLER_352_0 VPWR VGND sg13cmos5l_decap_8
XFILLER_204_112 VPWR VGND sg13cmos5l_decap_4
XFILLER_204_145 VPWR VGND sg13cmos5l_fill_2
XFILLER_658_35 VPWR VGND sg13cmos5l_decap_8
XFILLER_71_183 VPWR VGND sg13cmos5l_decap_4
XFILLER_44_71 VPWR VGND sg13cmos5l_fill_2
XFILLER_658_68 VPWR VGND sg13cmos5l_decap_8
XFILLER_377_14 VPWR VGND sg13cmos5l_decap_8
XANTENNA__3188__X Tile_X0Y0_N4BEG[12] VPWR VGND sg13cmos5l_antennanp
XFILLER_617_0 VPWR VGND sg13cmos5l_decap_8
XFILLER_358_182 VPWR VGND sg13cmos5l_decap_8
XFILLER_507_135 VPWR VGND sg13cmos5l_decap_8
XFILLER_74_7 VPWR VGND sg13cmos5l_decap_8
XFILLER_527_28 VPWR VGND sg13cmos5l_decap_8
XFILLER_674_56 VPWR VGND sg13cmos5l_decap_8
XFILLER_60_70 VPWR VGND sg13cmos5l_decap_8
XFILLER_117_119 VPWR VGND sg13cmos5l_decap_8
XANTENNA__2820__X Tile_X0Y3_E1BEG[2] VPWR VGND sg13cmos5l_antennanp
X_1610_ _1610_/Q Tile_X0Y2_FrameData[7] VGND VPWR Tile_X0Y9_FrameStrobe[5] latch
X_2590_ _2590_/Q Tile_X0Y6_FrameData[9] VGND VPWR Tile_X0Y9_FrameStrobe[4] latch
XFILLER_393_35 VPWR VGND sg13cmos5l_decap_4
XFILLER_5_21 VPWR VGND sg13cmos5l_decap_8
X_1541_ _1541_/Q Tile_X0Y2_FrameData[12] VGND VPWR Tile_X0Y9_FrameStrobe[3] latch
XFILLER_676_131 VPWR VGND sg13cmos5l_fill_2
XFILLER_125_174 VPWR VGND sg13cmos5l_fill_1
X_4260_ _4260_/X Tile_X0Y4_W2MID[3] AXI_M_SOC_BRESP0 _4319_/X _4318_/X _2093_/Q _2092_/Q
+ VPWR VGND sg13cmos5l_mux4_1
XFILLER_125_185 VPWR VGND sg13cmos5l_fill_1
X_1472_ _1472_/Q Tile_X0Y2_FrameData[17] VGND VPWR Tile_X0Y9_FrameStrobe[1] latch
XFILLER_543_49 VPWR VGND sg13cmos5l_decap_8
XFILLER_690_55 VPWR VGND sg13cmos5l_decap_8
XFILLER_140_133 VPWR VGND sg13cmos5l_decap_8
X_3211_ Tile_X0Y0_N1BEG[3] _3783_/X VPWR VGND sg13cmos5l_buf_1
X_0423_ _0423_/Q Tile_X0Y8_FrameData[24] VGND VPWR Tile_X0Y9_FrameStrobe[0] latch
XFILLER_286_148 VPWR VGND sg13cmos5l_decap_8
XFILLER_262_28 VPWR VGND sg13cmos5l_decap_8
X_4191_ _4191_/X AXI_M_SOC_BVALID _4222_/X _4226_/X _4204_/X _1759_/Q _1758_/Q VPWR
+ VGND sg13cmos5l_mux4_1
XANTENNA__3651__X AXI_M_SOC_AWADDR12 VPWR VGND sg13cmos5l_antennanp
XFILLER_192_91 VPWR VGND sg13cmos5l_decap_8
XFILLER_140_199 VPWR VGND sg13cmos5l_decap_8
X_3142_ Tile_X0Y7_FrameData_O[12] Tile_X0Y7_FrameData[12] VPWR VGND sg13cmos5l_buf_1
X_0354_ _0354_/Q Tile_X0Y7_FrameData[29] VGND VPWR Tile_X0Y9_FrameStrobe[6] latch
XFILLER_691_189 VPWR VGND sg13cmos5l_fill_2
XFILLER_428_175 VPWR VGND sg13cmos5l_decap_4
XFILLER_39_147 VPWR VGND sg13cmos5l_decap_4
XFILLER_699_42 VPWR VGND sg13cmos5l_decap_8
X_3073_ Tile_X0Y5_UserCLKo Tile_X0Y5_UserCLK VPWR VGND sg13cmos5l_buf_1
X_0285_ _0285_/Q Tile_X0Y7_FrameData[2] VGND VPWR Tile_X0Y9_FrameStrobe[3] latch
X_2024_ _2024_/Q Tile_X0Y4_FrameData[29] VGND VPWR Tile_X0Y9_FrameStrobe[3] latch
XFILLER_54_139 VPWR VGND sg13cmos5l_decap_8
XFILLER_211_21 VPWR VGND sg13cmos5l_decap_8
XFILLER_597_171 VPWR VGND sg13cmos5l_fill_1
XFILLER_568_35 VPWR VGND sg13cmos5l_decap_8
XFILLER_287_14 VPWR VGND sg13cmos5l_decap_8
XFILLER_211_98 VPWR VGND sg13cmos5l_decap_8
XFILLER_210_104 VPWR VGND sg13cmos5l_decap_8
X_3975_ _3975_/X AXI_M_SOC_ARREADY _4008_/X _4012_/X _3988_/X _1259_/Q _1258_/Q VPWR
+ VGND sg13cmos5l_mux4_1
XANTENNA__3098__X Tile_X0Y7_E2BEGb[4] VPWR VGND sg13cmos5l_antennanp
XFILLER_545_208 VPWR VGND sg13cmos5l_fill_1
XFILLER_356_119 VPWR VGND sg13cmos5l_decap_8
X_2926_ Tile_X0Y8_E2BEGb[2] _4738_/X VPWR VGND sg13cmos5l_buf_1
XFILLER_437_28 VPWR VGND sg13cmos5l_decap_8
X_2857_ Tile_X0Y6_E6BEG[6] _4534_/X VPWR VGND sg13cmos5l_buf_1
XFILLER_584_56 VPWR VGND sg13cmos5l_decap_8
XFILLER_367_91 VPWR VGND sg13cmos5l_fill_1
X_1808_ _1808_/Q Tile_X0Y3_FrameData[25] VGND VPWR Tile_X0Y9_FrameStrobe[4] latch
X_2788_ Tile_X0Y3_EE4BEG[14] _4178_/X VPWR VGND sg13cmos5l_buf_1
X_4527_ _4527_/X Tile_X0Y6_WW4END[0] AXI_M_SOC_RDATA24 _4568_/X _4553_/X _2553_/Q
+ _2552_/Q VPWR VGND sg13cmos5l_mux4_1
X_1739_ _1739_/Q Tile_X0Y3_FrameData[30] VGND VPWR Tile_X0Y9_FrameStrobe[2] latch
XFILLER_320_200 VPWR VGND sg13cmos5l_decap_4
XFILLER_236_62 VPWR VGND sg13cmos5l_decap_8
X_4458_ _4458_/X _4427_/X _0097_/X _4426_/X _0156_/X _2223_/Q _2222_/Q VPWR VGND sg13cmos5l_mux4_1
XFILLER_131_122 VPWR VGND sg13cmos5l_decap_8
XFILLER_453_49 VPWR VGND sg13cmos5l_decap_4
XFILLER_466_215 VPWR VGND sg13cmos5l_fill_2
XFILLER_131_133 VPWR VGND sg13cmos5l_fill_2
X_3409_ Tile_X0Y4_FrameData_O[0] Tile_X0Y4_FrameData[0] VPWR VGND sg13cmos5l_buf_1
XFILLER_172_28 VPWR VGND sg13cmos5l_decap_8
X_4389_ _4389_/X Tile_X0Y5_WW4END[14] AXI_M_SOC_RLAST _4465_/X _4429_/X _2325_/Q _2324_/Q
+ VPWR VGND sg13cmos5l_mux4_1
XANTENNA__3561__X Tile_X0Y9_EE4BEG[7] VPWR VGND sg13cmos5l_antennanp
XFILLER_218_215 VPWR VGND sg13cmos5l_fill_2
XFILLER_105_55 VPWR VGND sg13cmos5l_fill_2
XFILLER_434_112 VPWR VGND sg13cmos5l_fill_2
XFILLER_65_26 VPWR VGND sg13cmos5l_decap_8
XFILLER_252_72 VPWR VGND sg13cmos5l_decap_8
XFILLER_276_7 VPWR VGND sg13cmos5l_decap_8
XFILLER_105_99 VPWR VGND sg13cmos5l_decap_8
XFILLER_434_167 VPWR VGND sg13cmos5l_decap_8
XFILLER_402_42 VPWR VGND sg13cmos5l_decap_8
XFILLER_434_178 VPWR VGND sg13cmos5l_fill_1
XFILLER_121_21 VPWR VGND sg13cmos5l_decap_8
XFILLER_595_119 VPWR VGND sg13cmos5l_fill_1
XFILLER_443_7 VPWR VGND sg13cmos5l_decap_8
XANTENNA__2905__X Tile_X0Y6_FrameData_O[26] VPWR VGND sg13cmos5l_antennanp
XFILLER_588_171 VPWR VGND sg13cmos5l_fill_1
XFILLER_478_35 VPWR VGND sg13cmos5l_decap_8
XFILLER_588_193 VPWR VGND sg13cmos5l_decap_4
XFILLER_436_6 VPWR VGND sg13cmos5l_decap_8
XFILLER_198_155 VPWR VGND sg13cmos5l_decap_8
XFILLER_81_47 VPWR VGND sg13cmos5l_decap_4
XFILLER_197_14 VPWR VGND sg13cmos5l_decap_8
XFILLER_121_98 VPWR VGND sg13cmos5l_decap_4
XFILLER_201_115 VPWR VGND sg13cmos5l_decap_8
XFILLER_610_7 VPWR VGND sg13cmos5l_decap_8
XFILLER_139_200 VPWR VGND sg13cmos5l_fill_2
XFILLER_708_7 VPWR VGND sg13cmos5l_decap_8
XFILLER_628_49 VPWR VGND sg13cmos5l_decap_8
XFILLER_14_63 VPWR VGND sg13cmos5l_decap_4
XFILLER_347_28 VPWR VGND sg13cmos5l_decap_8
XFILLER_14_96 VPWR VGND sg13cmos5l_decap_8
XANTENNA__3736__X AXI_M_SOC_ARADDR8 VPWR VGND sg13cmos5l_antennanp
XFILLER_494_56 VPWR VGND sg13cmos5l_decap_8
XFILLER_355_174 VPWR VGND sg13cmos5l_decap_8
XFILLER_277_91 VPWR VGND sg13cmos5l_decap_8
XFILLER_504_105 VPWR VGND sg13cmos5l_decap_8
XFILLER_370_100 VPWR VGND sg13cmos5l_decap_8
XFILLER_212_2 VPWR VGND sg13cmos5l_fill_1
XFILLER_100_0 VPWR VGND sg13cmos5l_fill_2
XFILLER_363_27 VPWR VGND sg13cmos5l_decap_8
XFILLER_122_100 VPWR VGND sg13cmos5l_decap_8
XFILLER_107_185 VPWR VGND sg13cmos5l_decap_8
XFILLER_268_126 VPWR VGND sg13cmos5l_decap_4
XFILLER_660_14 VPWR VGND sg13cmos5l_decap_8
XANTENNA__3471__X Tile_X0Y1_FrameData_O[29] VPWR VGND sg13cmos5l_antennanp
XFILLER_39_60 VPWR VGND sg13cmos5l_decap_4
XFILLER_122_199 VPWR VGND sg13cmos5l_decap_8
XFILLER_614_201 VPWR VGND sg13cmos5l_fill_1
XFILLER_567_0 VPWR VGND sg13cmos5l_decap_8
XFILLER_425_112 VPWR VGND sg13cmos5l_decap_8
XFILLER_312_42 VPWR VGND sg13cmos5l_decap_8
X_0070_ AXI_M_SOC_WSTRB1 _0935_/Q _3723_/X VPWR VGND sg13cmos5l_or2_1
XANTENNA__2815__X Tile_X0Y3_E2BEG[5] VPWR VGND sg13cmos5l_antennanp
XFILLER_55_81 VPWR VGND sg13cmos5l_decap_8
XFILLER_669_78 VPWR VGND sg13cmos5l_decap_8
XFILLER_44_161 VPWR VGND sg13cmos5l_fill_1
XFILLER_388_35 VPWR VGND sg13cmos5l_fill_1
XFILLER_189_133 VPWR VGND sg13cmos5l_decap_8
XFILLER_579_193 VPWR VGND sg13cmos5l_decap_8
XFILLER_189_144 VPWR VGND sg13cmos5l_fill_1
XFILLER_594_130 VPWR VGND sg13cmos5l_decap_8
XFILLER_594_174 VPWR VGND sg13cmos5l_decap_8
X_3760_ _3760_/X Tile_X0Y1_WW4END[1] Tile_X0Y1_WW4END[9] Tile_X0Y1_W6END[1] _4009_/X
+ _1255_/Q _1254_/Q VPWR VGND sg13cmos5l_mux4_1
X_0972_ _0972_/Q Tile_X0Y0_FrameData[31] VGND VPWR Tile_X0Y9_FrameStrobe[1] latch
XFILLER_538_49 VPWR VGND sg13cmos5l_decap_4
X_2711_ _4300_/A3 VPWR VGND sg13cmos5l_tielo
XFILLER_257_28 VPWR VGND sg13cmos5l_decap_4
X_3691_ AXI_M_SOC_WDATA1 Tile_X0Y7_WW4END[1] Tile_X0Y7_WW4END[9] Tile_X0Y7_W6END[1]
+ _4685_/X _0245_/Q _0244_/Q VPWR VGND sg13cmos5l_mux4_1
XANTENNA__3646__X AXI_M_SOC_AWADDR7 VPWR VGND sg13cmos5l_antennanp
XFILLER_200_192 VPWR VGND sg13cmos5l_fill_2
X_2642_ _2642_/Q Tile_X0Y6_FrameData[21] VGND VPWR Tile_X0Y9_FrameStrobe[6] latch
XFILLER_361_111 VPWR VGND sg13cmos5l_decap_8
XFILLER_696_204 VPWR VGND sg13cmos5l_fill_2
X_2573_ _2573_/Q Tile_X0Y6_FrameData[26] VGND VPWR Tile_X0Y9_FrameStrobe[4] latch
XFILLER_337_83 VPWR VGND sg13cmos5l_decap_8
XFILLER_160_217 VPWR VGND sg13cmos5l_fill_1
XANTENNA__0070__X AXI_M_SOC_WSTRB1 VPWR VGND sg13cmos5l_antennanp
X_4312_ _4312_/X _4251_/X _4367_/X _4366_/X _4250_/X _1935_/Q _1934_/Q VPWR VGND sg13cmos5l_mux4_1
X_1524_ _1524_/Q Tile_X0Y2_FrameData[29] VGND VPWR Tile_X0Y9_FrameStrobe[3] latch
XFILLER_302_211 VPWR VGND sg13cmos5l_decap_8
XFILLER_273_49 VPWR VGND sg13cmos5l_decap_8
XFILLER_634_70 VPWR VGND sg13cmos5l_decap_8
XFILLER_503_182 VPWR VGND sg13cmos5l_decap_8
XFILLER_649_175 VPWR VGND sg13cmos5l_decap_8
XFILLER_259_126 VPWR VGND sg13cmos5l_decap_8
X_4243_ _4243_/X Tile_X0Y5_W2MID[4] Tile_X0Y5_W2END[4] Tile_X0Y5_W6END[4] _4434_/X
+ _2425_/Q _2424_/Q VPWR VGND sg13cmos5l_mux4_1
X_1455_ _1455_/Q Tile_X0Y2_FrameData[2] VGND VPWR Tile_X0Y9_FrameStrobe[0] latch
XFILLER_570_14 VPWR VGND sg13cmos5l_decap_8
XANTENNA__3381__X Tile_X0Y2_E6BEG[4] VPWR VGND sg13cmos5l_antennanp
XFILLER_113_188 VPWR VGND sg13cmos5l_decap_8
XFILLER_206_76 VPWR VGND sg13cmos5l_decap_8
X_0406_ _0406_/Q Tile_X0Y7_FrameData[9] VGND VPWR Tile_X0Y9_FrameStrobe[7] latch
XFILLER_463_207 VPWR VGND sg13cmos5l_fill_2
X_4174_ _4174_/X Tile_X0Y3_WW4END[5] AXI_M_SOC_BVALID _4227_/X _4208_/X _1793_/Q _1792_/Q
+ VPWR VGND sg13cmos5l_mux4_1
X_1386_ _1386_/Q Tile_X0Y1_FrameData[15] VGND VPWR Tile_X0Y9_FrameStrobe[6] latch
XFILLER_664_178 VPWR VGND sg13cmos5l_decap_8
XFILLER_605_201 VPWR VGND sg13cmos5l_decap_8
X_3125_ Tile_X0Y7_EE4BEG[11] _4639_/X VPWR VGND sg13cmos5l_buf_1
XFILLER_267_192 VPWR VGND sg13cmos5l_decap_8
X_0337_ _0337_/Q Tile_X0Y7_FrameData[14] VGND VPWR Tile_X0Y9_FrameStrobe[5] latch
XFILLER_503_63 VPWR VGND sg13cmos5l_decap_8
XFILLER_27_117 VPWR VGND sg13cmos5l_decap_4
XFILLER_416_145 VPWR VGND sg13cmos5l_fill_2
XFILLER_282_140 VPWR VGND sg13cmos5l_decap_8
XFILLER_650_91 VPWR VGND sg13cmos5l_decap_8
XFILLER_27_128 VPWR VGND sg13cmos5l_decap_8
XFILLER_222_42 VPWR VGND sg13cmos5l_decap_8
X_3056_ Tile_X0Y5_FrameData_O[15] Tile_X0Y5_FrameData[15] VPWR VGND sg13cmos5l_buf_1
XFILLER_282_173 VPWR VGND sg13cmos5l_decap_8
X_0268_ _0268_/Q Tile_X0Y7_FrameData[19] VGND VPWR Tile_X0Y9_FrameStrobe[3] latch
XFILLER_620_215 VPWR VGND sg13cmos5l_fill_2
XFILLER_579_56 VPWR VGND sg13cmos5l_decap_8
XFILLER_222_86 VPWR VGND sg13cmos5l_fill_1
X_2007_ _2007_/Q Tile_X0Y4_FrameData[14] VGND VPWR Tile_X0Y9_FrameStrobe[2] latch
XFILLER_577_119 VPWR VGND sg13cmos5l_decap_8
X_0199_ _0199_/Q Tile_X0Y7_FrameData[24] VGND VPWR Tile_X0Y9_FrameStrobe[1] latch
XFILLER_298_35 VPWR VGND sg13cmos5l_decap_8
XFILLER_35_194 VPWR VGND sg13cmos5l_fill_2
XFILLER_329_108 VPWR VGND sg13cmos5l_fill_1
XFILLER_585_174 VPWR VGND sg13cmos5l_decap_4
XFILLER_384_214 VPWR VGND sg13cmos5l_decap_4
X_3958_ _3958_/X Tile_X0Y1_WW4END[5] AXI_M_SOC_ARREADY _4013_/X _3992_/X _1293_/Q
+ _1292_/Q VPWR VGND sg13cmos5l_mux4_1
XFILLER_448_49 VPWR VGND sg13cmos5l_decap_8
XFILLER_195_158 VPWR VGND sg13cmos5l_fill_2
XFILLER_595_77 VPWR VGND sg13cmos5l_decap_4
XFILLER_167_28 VPWR VGND sg13cmos5l_fill_1
X_2909_ Tile_X0Y6_FrameData_O[30] Tile_X0Y6_FrameData[30] VPWR VGND sg13cmos5l_buf_1
XFILLER_595_88 VPWR VGND sg13cmos5l_decap_8
X_3889_ _3889_/X Tile_X0Y1_W2MID[7] Tile_X0Y1_W2END[7] Tile_X0Y1_W6END[7] _3989_/X
+ _1417_/Q _1416_/Q VPWR VGND sg13cmos5l_mux4_1
XANTENNA__3556__X Tile_X0Y9_EE4BEG[2] VPWR VGND sg13cmos5l_antennanp
XFILLER_541_211 VPWR VGND sg13cmos5l_fill_1
XFILLER_498_126 VPWR VGND sg13cmos5l_decap_8
XFILLER_352_166 VPWR VGND sg13cmos5l_decap_8
XFILLER_501_119 VPWR VGND sg13cmos5l_decap_8
XFILLER_4_7 VPWR VGND sg13cmos5l_decap_8
XFILLER_655_112 VPWR VGND sg13cmos5l_fill_2
XFILLER_480_14 VPWR VGND sg13cmos5l_decap_8
XFILLER_393_7 VPWR VGND sg13cmos5l_decap_8
XANTENNA__3291__X Tile_X0Y0_E6BEG[11] VPWR VGND sg13cmos5l_antennanp
XFILLER_76_14 VPWR VGND sg13cmos5l_decap_8
XFILLER_263_71 VPWR VGND sg13cmos5l_decap_4
XFILLER_116_76 VPWR VGND sg13cmos5l_decap_8
XFILLER_655_156 VPWR VGND sg13cmos5l_decap_8
XFILLER_454_207 VPWR VGND sg13cmos5l_fill_1
XFILLER_263_82 VPWR VGND sg13cmos5l_decap_8
XFILLER_104_199 VPWR VGND sg13cmos5l_decap_8
XFILLER_630_28 VPWR VGND sg13cmos5l_decap_8
XFILLER_560_7 VPWR VGND sg13cmos5l_decap_8
XFILLER_413_63 VPWR VGND sg13cmos5l_decap_8
XFILLER_658_7 VPWR VGND sg13cmos5l_decap_8
XFILLER_407_134 VPWR VGND sg13cmos5l_decap_8
XFILLER_560_91 VPWR VGND sg13cmos5l_decap_8
XFILLER_132_42 VPWR VGND sg13cmos5l_decap_8
XFILLER_273_173 VPWR VGND sg13cmos5l_decap_8
XANTENNA__0139__Y AXI_M_SOC_ARLEN0 VPWR VGND sg13cmos5l_antennanp
XFILLER_568_119 VPWR VGND sg13cmos5l_decap_8
XFILLER_489_56 VPWR VGND sg13cmos5l_decap_8
XFILLER_26_161 VPWR VGND sg13cmos5l_decap_8
XFILLER_25_51 VPWR VGND sg13cmos5l_fill_1
XFILLER_375_203 VPWR VGND sg13cmos5l_decap_8
XFILLER_148_0 VPWR VGND sg13cmos5l_decap_8
XFILLER_576_196 VPWR VGND sg13cmos5l_decap_8
XFILLER_358_49 VPWR VGND sg13cmos5l_decap_8
XFILLER_591_144 VPWR VGND sg13cmos5l_decap_8
XFILLER_655_14 VPWR VGND sg13cmos5l_decap_8
XFILLER_591_177 VPWR VGND sg13cmos5l_fill_1
XFILLER_390_217 VPWR VGND sg13cmos5l_fill_1
XANTENNA__3466__X Tile_X0Y1_FrameData_O[24] VPWR VGND sg13cmos5l_antennanp
XFILLER_315_0 VPWR VGND sg13cmos5l_decap_8
XFILLER_489_115 VPWR VGND sg13cmos5l_decap_8
XFILLER_489_126 VPWR VGND sg13cmos5l_fill_1
XFILLER_142_217 VPWR VGND sg13cmos5l_fill_1
XFILLER_671_35 VPWR VGND sg13cmos5l_decap_8
XFILLER_296_210 VPWR VGND sg13cmos5l_fill_1
XFILLER_684_0 VPWR VGND sg13cmos5l_decap_8
XFILLER_646_112 VPWR VGND sg13cmos5l_decap_8
XFILLER_390_14 VPWR VGND sg13cmos5l_decap_8
XFILLER_445_207 VPWR VGND sg13cmos5l_decap_8
X_1240_ _1240_/Q Tile_X0Y1_FrameData[1] VGND VPWR Tile_X0Y9_FrameStrobe[1] latch
XFILLER_604_84 VPWR VGND sg13cmos5l_decap_8
XFILLER_500_196 VPWR VGND sg13cmos5l_decap_8
XFILLER_646_189 VPWR VGND sg13cmos5l_decap_8
XFILLER_540_28 VPWR VGND sg13cmos5l_decap_8
X_1171_ _1171_/Q Tile_X0Y0_FrameData[24] VGND VPWR Tile_X0Y9_FrameStrobe[7] latch
XFILLER_2_77 VPWR VGND sg13cmos5l_decap_8
X_0122_ _3180_/A _3918_/X _3919_/X _1647_/Q VPWR VGND sg13cmos5l_mux2_1
XFILLER_66_91 VPWR VGND sg13cmos5l_decap_8
XFILLER_264_184 VPWR VGND sg13cmos5l_decap_8
XFILLER_413_126 VPWR VGND sg13cmos5l_fill_2
XFILLER_399_56 VPWR VGND sg13cmos5l_decap_8
X_0053_ _0053_/X _4682_/X _4683_/X _1854_/Q VPWR VGND sg13cmos5l_mux2_1
X_4930_ _4930_/X Tile_X0Y9_N1END[2] Tile_X0Y9_N4END[2] _4898_/X _0081_/X _0699_/Q
+ _0698_/Q VPWR VGND sg13cmos5l_mux4_1
XFILLER_696_21 VPWR VGND sg13cmos5l_decap_8
X_4861_ _4861_/X Tile_X0Y9_W2END[2] AXI_M_SOC_RDATA2 _4905_/X _4904_/X _0821_/Q _0820_/Q
+ VPWR VGND sg13cmos5l_mux4_1
XFILLER_421_170 VPWR VGND sg13cmos5l_decap_8
XFILLER_32_142 VPWR VGND sg13cmos5l_decap_4
XFILLER_716_105 VPWR VGND sg13cmos5l_fill_1
X_3812_ _3812_/X Tile_X0Y0_W2MID[1] Tile_X0Y0_W2END[7] _3853_/X _3852_/X _1081_/Q
+ _1080_/Q VPWR VGND sg13cmos5l_mux4_1
XANTENNA_16 AXI_M_SOC_WREADY VPWR VGND sg13cmos5l_antennanp
X_4792_ _4792_/X Tile_X0Y4_W1END[0] Tile_X0Y4_WW4END[12] Tile_X0Y4_W6END[4] _4336_/X
+ _2121_/Q _2120_/Q VPWR VGND sg13cmos5l_mux4_1
XFILLER_696_98 VPWR VGND sg13cmos5l_decap_8
XFILLER_268_49 VPWR VGND sg13cmos5l_decap_8
XFILLER_716_127 VPWR VGND sg13cmos5l_fill_1
XANTENNA_27 AXI_M_SOC_WREADY VPWR VGND sg13cmos5l_antennanp
XFILLER_629_70 VPWR VGND sg13cmos5l_decap_8
XFILLER_582_133 VPWR VGND sg13cmos5l_decap_4
XFILLER_32_197 VPWR VGND sg13cmos5l_fill_2
XANTENNA_38 Tile_X0Y0_S2MID[0] VPWR VGND sg13cmos5l_antennanp
XANTENNA_49 Tile_X0Y0_S2MID[6] VPWR VGND sg13cmos5l_antennanp
X_3743_ AXI_M_SOC_ARADDR15 Tile_X0Y9_W1END[3] Tile_X0Y9_WW4END[7] Tile_X0Y9_WW4END[15]
+ _4931_/X _0729_/Q _0728_/Q VPWR VGND sg13cmos5l_mux4_1
X_0955_ _0955_/Q Tile_X0Y0_FrameData[16] VGND VPWR Tile_X0Y9_FrameStrobe[0] latch
XFILLER_565_14 VPWR VGND sg13cmos5l_decap_8
XFILLER_319_163 VPWR VGND sg13cmos5l_decap_8
XANTENNA__3376__X Tile_X0Y2_EE4BEG[15] VPWR VGND sg13cmos5l_antennanp
XFILLER_334_111 VPWR VGND sg13cmos5l_fill_1
X_3674_ _3674_/X Tile_X0Y2_WW4END[4] Tile_X0Y2_WW4END[12] Tile_X0Y2_W6END[4] _4120_/X
+ _1497_/Q _1496_/Q VPWR VGND sg13cmos5l_mux4_1
X_0886_ _0886_/Q Tile_X0Y9_FrameData[9] VGND VPWR Tile_X0Y9_FrameStrobe[6] latch
XFILLER_63_0 VPWR VGND sg13cmos5l_decap_8
X_2625_ _2625_/Q Tile_X0Y6_FrameData[6] VGND VPWR Tile_X0Y9_FrameStrobe[5] latch
XFILLER_217_20 VPWR VGND sg13cmos5l_decap_8
XFILLER_645_91 VPWR VGND sg13cmos5l_decap_8
XFILLER_334_199 VPWR VGND sg13cmos5l_decap_8
X_2556_ _2556_/Q Tile_X0Y6_FrameData[11] VGND VPWR Tile_X0Y9_FrameStrobe[3] latch
XFILLER_581_35 VPWR VGND sg13cmos5l_decap_8
XFILLER_637_112 VPWR VGND sg13cmos5l_decap_8
X_1507_ _1507_/Q Tile_X0Y2_FrameData[14] VGND VPWR Tile_X0Y9_FrameStrobe[2] latch
XFILLER_217_97 VPWR VGND sg13cmos5l_decap_8
X_2487_ _2487_/Q Tile_X0Y6_FrameData[16] VGND VPWR Tile_X0Y9_FrameStrobe[1] latch
X_4226_ _4226_/X _4195_/X _0089_/X _4194_/X Tile_X0Y0_S4END[12] _1721_/Q _1720_/Q
+ VPWR VGND sg13cmos5l_mux4_1
X_1438_ _1438_/Q Tile_X0Y2_FrameData[19] VGND VPWR Tile_X0Y9_FrameStrobe[0] latch
XFILLER_637_178 VPWR VGND sg13cmos5l_decap_8
XFILLER_247_129 VPWR VGND sg13cmos5l_fill_1
XFILLER_637_189 VPWR VGND sg13cmos5l_fill_2
XFILLER_652_126 VPWR VGND sg13cmos5l_decap_8
XFILLER_450_28 VPWR VGND sg13cmos5l_decap_8
X_4157_ _4157_/X Tile_X0Y3_W2END[6] AXI_M_SOC_WREADY _4207_/X _4206_/X _1827_/Q _1826_/Q
+ VPWR VGND sg13cmos5l_mux4_1
X_1369_ _1369_/Q Tile_X0Y1_FrameData[0] VGND VPWR Tile_X0Y9_FrameStrobe[5] latch
XFILLER_46_17 VPWR VGND sg13cmos5l_fill_1
XFILLER_46_39 VPWR VGND sg13cmos5l_decap_8
X_3108_ Tile_X0Y7_E6BEG[6] _4650_/X VPWR VGND sg13cmos5l_buf_1
X_4088_ _4088_/X Tile_X0Y1_W1END[0] Tile_X0Y1_W6END[8] _4005_/X _3976_/X _1389_/Q
+ _1388_/Q VPWR VGND sg13cmos5l_mux4_1
X_3039_ Tile_X0Y5_EE4BEG[14] _4402_/X VPWR VGND sg13cmos5l_buf_1
XFILLER_270_165 VPWR VGND sg13cmos5l_decap_8
XFILLER_357_203 VPWR VGND sg13cmos5l_decap_8
XFILLER_168_103 VPWR VGND sg13cmos5l_decap_8
XFILLER_707_105 VPWR VGND sg13cmos5l_decap_8
XFILLER_168_136 VPWR VGND sg13cmos5l_fill_1
XFILLER_239_7 VPWR VGND sg13cmos5l_decap_8
XFILLER_573_133 VPWR VGND sg13cmos5l_decap_8
XFILLER_707_149 VPWR VGND sg13cmos5l_fill_1
XFILLER_475_14 VPWR VGND sg13cmos5l_decap_8
XFILLER_372_217 VPWR VGND sg13cmos5l_fill_1
XANTENNA__3286__X Tile_X0Y0_E6BEG[6] VPWR VGND sg13cmos5l_antennanp
XFILLER_715_160 VPWR VGND sg13cmos5l_decap_8
XFILLER_406_7 VPWR VGND sg13cmos5l_decap_8
XFILLER_325_133 VPWR VGND sg13cmos5l_fill_1
XFILLER_625_28 VPWR VGND sg13cmos5l_decap_8
XFILLER_408_63 VPWR VGND sg13cmos5l_fill_2
XFILLER_11_42 VPWR VGND sg13cmos5l_decap_8
XFILLER_555_91 VPWR VGND sg13cmos5l_decap_8
XFILLER_191_183 VPWR VGND sg13cmos5l_fill_2
XFILLER_127_42 VPWR VGND sg13cmos5l_decap_8
XFILLER_340_136 VPWR VGND sg13cmos5l_decap_8
XFILLER_491_35 VPWR VGND sg13cmos5l_decap_8
XFILLER_486_129 VPWR VGND sg13cmos5l_decap_8
XFILLER_479_170 VPWR VGND sg13cmos5l_decap_4
XFILLER_274_70 VPWR VGND sg13cmos5l_decap_8
XFILLER_87_46 VPWR VGND sg13cmos5l_decap_8
XFILLER_127_97 VPWR VGND sg13cmos5l_decap_8
XFILLER_628_134 VPWR VGND sg13cmos5l_fill_2
XFILLER_494_140 VPWR VGND sg13cmos5l_decap_8
XFILLER_238_118 VPWR VGND sg13cmos5l_decap_8
XFILLER_641_49 VPWR VGND sg13cmos5l_decap_8
XFILLER_424_84 VPWR VGND sg13cmos5l_decap_8
XFILLER_643_126 VPWR VGND sg13cmos5l_decap_8
XFILLER_360_28 VPWR VGND sg13cmos5l_decap_8
XFILLER_143_63 VPWR VGND sg13cmos5l_decap_8
XFILLER_290_91 VPWR VGND sg13cmos5l_decap_8
XFILLER_246_162 VPWR VGND sg13cmos5l_decap_8
XFILLER_143_96 VPWR VGND sg13cmos5l_decap_8
XFILLER_265_0 VPWR VGND sg13cmos5l_decap_8
XFILLER_61_215 VPWR VGND sg13cmos5l_fill_2
XFILLER_261_154 VPWR VGND sg13cmos5l_decap_8
XFILLER_36_94 VPWR VGND sg13cmos5l_decap_8
XFILLER_261_187 VPWR VGND sg13cmos5l_decap_8
XFILLER_14_142 VPWR VGND sg13cmos5l_fill_2
XFILLER_432_0 VPWR VGND sg13cmos5l_fill_2
XFILLER_666_35 VPWR VGND sg13cmos5l_decap_8
XFILLER_564_133 VPWR VGND sg13cmos5l_decap_4
XFILLER_449_81 VPWR VGND sg13cmos5l_fill_2
XFILLER_385_14 VPWR VGND sg13cmos5l_decap_8
XFILLER_52_93 VPWR VGND sg13cmos5l_decap_8
XFILLER_363_217 VPWR VGND sg13cmos5l_fill_1
XANTENNA__3196__X Tile_X0Y0_N2BEGb[4] VPWR VGND sg13cmos5l_antennanp
XFILLER_713_119 VPWR VGND sg13cmos5l_decap_8
XFILLER_174_139 VPWR VGND sg13cmos5l_decap_8
XFILLER_168_82 VPWR VGND sg13cmos5l_decap_8
XFILLER_167_180 VPWR VGND sg13cmos5l_decap_8
X_0740_ _0740_/Q Tile_X0Y9_FrameData[27] VGND VPWR Tile_X0Y9_FrameStrobe[2] latch
XFILLER_505_211 VPWR VGND sg13cmos5l_decap_8
XFILLER_316_111 VPWR VGND sg13cmos5l_decap_8
XFILLER_535_28 VPWR VGND sg13cmos5l_decap_8
X_0671_ _0671_/Q Tile_X0Y8_FrameData[0] VGND VPWR Tile_X0Y9_FrameStrobe[7] latch
XFILLER_115_217 VPWR VGND sg13cmos5l_fill_1
XFILLER_682_56 VPWR VGND sg13cmos5l_decap_8
X_2410_ _2410_/Q Tile_X0Y5_FrameData[27] VGND VPWR Tile_X0Y9_FrameStrobe[7] latch
XFILLER_477_118 VPWR VGND sg13cmos5l_decap_4
X_3390_ Tile_X0Y2_E2BEGb[1] _4049_/X VPWR VGND sg13cmos5l_buf_1
X_2341_ _2341_/Q Tile_X0Y5_FrameData[0] VGND VPWR Tile_X0Y9_FrameStrobe[4] latch
X_2272_ _2272_/Q Tile_X0Y5_FrameData[5] VGND VPWR Tile_X0Y9_FrameStrobe[2] latch
XFILLER_551_49 VPWR VGND sg13cmos5l_decap_4
X_4011_ _4011_/X _3987_/X _0084_/X _3986_/X Tile_X0Y0_S4END[7] _1227_/Q _1226_/Q VPWR
+ VGND sg13cmos5l_mux4_1
X_1223_ _1223_/Q Tile_X0Y1_FrameData[18] VGND VPWR Tile_X0Y9_FrameStrobe[1] latch
XFILLER_270_28 VPWR VGND sg13cmos5l_decap_8
XFILLER_37_201 VPWR VGND sg13cmos5l_fill_2
XFILLER_237_140 VPWR VGND sg13cmos5l_decap_8
X_1154_ _1154_/Q Tile_X0Y0_FrameData[9] VGND VPWR Tile_X0Y9_FrameStrobe[6] latch
XFILLER_237_184 VPWR VGND sg13cmos5l_decap_8
XFILLER_398_103 VPWR VGND sg13cmos5l_fill_1
X_0105_ AXI_M_SOC_ARLEN4 _0933_/Q _3764_/X VPWR VGND sg13cmos5l_nor2b_1
XFILLER_203_77 VPWR VGND sg13cmos5l_decap_8
X_1085_ _1085_/Q Tile_X0Y0_FrameData[14] VGND VPWR Tile_X0Y9_FrameStrobe[4] latch
XFILLER_252_165 VPWR VGND sg13cmos5l_decap_8
XFILLER_252_176 VPWR VGND sg13cmos5l_fill_2
XFILLER_500_42 VPWR VGND sg13cmos5l_decap_8
XFILLER_398_169 VPWR VGND sg13cmos5l_decap_8
X_4913_ _4913_/X _4457_/X _4461_/X _4465_/X _4429_/X _2373_/Q _2372_/Q VPWR VGND sg13cmos5l_mux4_1
XFILLER_279_48 VPWR VGND sg13cmos5l_decap_8
X_4844_ _4844_/X Tile_X0Y9_N1END[0] _4896_/X AXI_M_SOC_RDATA3 AXI_M_SOC_RDATA7 _0855_/Q
+ _0854_/Q VPWR VGND sg13cmos5l_mux4_1
XFILLER_576_35 VPWR VGND sg13cmos5l_decap_8
XFILLER_359_70 VPWR VGND sg13cmos5l_decap_8
XFILLER_295_14 VPWR VGND sg13cmos5l_decap_8
X_1987_ _1987_/Q Tile_X0Y4_FrameData[2] VGND VPWR Tile_X0Y9_FrameStrobe[1] latch
X_4775_ _4775_/X _4783_/X Tile_X0Y8_W6END[3] _4782_/X _4775_/A3 _0417_/Q _0672_/Q
+ VPWR VGND sg13cmos5l_mux4_1
XFILLER_354_217 VPWR VGND sg13cmos5l_fill_1
XFILLER_704_119 VPWR VGND sg13cmos5l_decap_8
X_0938_ _0938_/Q Tile_X0Y9_FrameData[29] VGND VPWR Tile_X0Y9_FrameStrobe[8] latch
X_3726_ AXI_M_SOC_WVALID Tile_X0Y3_W1END[0] Tile_X0Y3_WW4END[4] Tile_X0Y3_WW4END[12]
+ _4234_/X _1733_/Q _1732_/Q VPWR VGND sg13cmos5l_mux4_1
XFILLER_570_147 VPWR VGND sg13cmos5l_decap_8
XFILLER_307_155 VPWR VGND sg13cmos5l_decap_4
XFILLER_445_28 VPWR VGND sg13cmos5l_decap_8
X_0869_ _0869_/Q Tile_X0Y9_FrameData[26] VGND VPWR Tile_X0Y9_FrameStrobe[6] latch
X_3657_ AXI_M_SOC_AWADDR18 Tile_X0Y4_WW4END[2] Tile_X0Y4_WW4END[10] Tile_X0Y4_W6END[2]
+ _4338_/X _2009_/Q _2008_/Q VPWR VGND sg13cmos5l_mux4_1
XFILLER_592_56 VPWR VGND sg13cmos5l_fill_1
XFILLER_228_85 VPWR VGND sg13cmos5l_decap_8
XFILLER_322_114 VPWR VGND sg13cmos5l_decap_8
X_2608_ _2608_/Q Tile_X0Y6_FrameData[23] VGND VPWR Tile_X0Y9_FrameStrobe[5] latch
XFILLER_712_196 VPWR VGND sg13cmos5l_decap_8
X_3588_ Tile_X0Y9_FrameData_O[18] Tile_X0Y9_FrameData[18] VPWR VGND sg13cmos5l_buf_1
XFILLER_322_158 VPWR VGND sg13cmos5l_decap_8
X_2539_ _2539_/Q Tile_X0Y6_FrameData[28] VGND VPWR Tile_X0Y9_FrameStrobe[3] latch
XFILLER_87_123 VPWR VGND sg13cmos5l_decap_8
XFILLER_476_151 VPWR VGND sg13cmos5l_fill_1
XFILLER_476_173 VPWR VGND sg13cmos5l_decap_8
X_4209_ _4209_/X _4133_/X _4241_/X _4240_/X _4132_/X _1693_/Q _1692_/Q VPWR VGND sg13cmos5l_mux4_1
XFILLER_189_7 VPWR VGND sg13cmos5l_decap_8
XFILLER_228_184 VPWR VGND sg13cmos5l_decap_8
XFILLER_633_192 VPWR VGND sg13cmos5l_fill_2
XFILLER_260_83 VPWR VGND sg13cmos5l_decap_8
XFILLER_356_7 VPWR VGND sg13cmos5l_decap_8
XFILLER_260_94 VPWR VGND sg13cmos5l_fill_1
XFILLER_113_88 VPWR VGND sg13cmos5l_decap_8
XFILLER_410_42 VPWR VGND sg13cmos5l_decap_8
XFILLER_251_6 VPWR VGND sg13cmos5l_decap_8
XFILLER_523_7 VPWR VGND sg13cmos5l_decap_8
XANTENNA__2913__X Tile_X0Y8_E1BEG[1] VPWR VGND sg13cmos5l_antennanp
XFILLER_400_140 VPWR VGND sg13cmos5l_decap_8
XFILLER_486_35 VPWR VGND sg13cmos5l_decap_8
XFILLER_269_70 VPWR VGND sg13cmos5l_decap_8
XFILLER_546_166 VPWR VGND sg13cmos5l_fill_2
XFILLER_400_195 VPWR VGND sg13cmos5l_decap_8
XFILLER_156_128 VPWR VGND sg13cmos5l_decap_4
XFILLER_149_180 VPWR VGND sg13cmos5l_decap_4
XFILLER_636_49 VPWR VGND sg13cmos5l_decap_8
XFILLER_499_210 VPWR VGND sg13cmos5l_fill_2
XFILLER_419_84 VPWR VGND sg13cmos5l_decap_8
XFILLER_355_28 VPWR VGND sg13cmos5l_decap_8
XFILLER_138_63 VPWR VGND sg13cmos5l_decap_8
XFILLER_502_203 VPWR VGND sg13cmos5l_decap_8
XFILLER_313_103 VPWR VGND sg13cmos5l_decap_8
XANTENNA__3744__X AXI_M_SOC_ARADDR16 VPWR VGND sg13cmos5l_antennanp
XFILLER_285_91 VPWR VGND sg13cmos5l_decap_8
XFILLER_716_71 VPWR VGND sg13cmos5l_decap_8
XFILLER_98_56 VPWR VGND sg13cmos5l_decap_8
XFILLER_459_129 VPWR VGND sg13cmos5l_decap_8
XFILLER_321_180 VPWR VGND sg13cmos5l_decap_8
XFILLER_371_49 VPWR VGND sg13cmos5l_fill_2
XFILLER_154_84 VPWR VGND sg13cmos5l_decap_4
XFILLER_382_0 VPWR VGND sg13cmos5l_decap_8
XFILLER_304_21 VPWR VGND sg13cmos5l_decap_8
XFILLER_482_143 VPWR VGND sg13cmos5l_fill_1
XFILLER_93_126 VPWR VGND sg13cmos5l_fill_2
XFILLER_482_165 VPWR VGND sg13cmos5l_decap_8
XFILLER_219_151 VPWR VGND sg13cmos5l_fill_2
XFILLER_304_76 VPWR VGND sg13cmos5l_decap_8
XFILLER_482_187 VPWR VGND sg13cmos5l_decap_8
XFILLER_423_210 VPWR VGND sg13cmos5l_fill_2
XFILLER_624_170 VPWR VGND sg13cmos5l_decap_8
XFILLER_647_0 VPWR VGND sg13cmos5l_decap_8
XFILLER_170_83 VPWR VGND sg13cmos5l_decap_8
XFILLER_320_42 VPWR VGND sg13cmos5l_decap_4
XFILLER_179_209 VPWR VGND sg13cmos5l_fill_2
XFILLER_320_53 VPWR VGND sg13cmos5l_decap_8
XFILLER_395_106 VPWR VGND sg13cmos5l_fill_2
XFILLER_584_217 VPWR VGND sg13cmos5l_fill_1
XFILLER_677_56 VPWR VGND sg13cmos5l_decap_8
X_1910_ _1910_/Q Tile_X0Y3_FrameData[19] VGND VPWR Tile_X0Y9_FrameStrobe[7] latch
XANTENNA__2823__X Tile_X0Y4_E2BEG[1] VPWR VGND sg13cmos5l_antennanp
XFILLER_63_81 VPWR VGND sg13cmos5l_decap_8
XFILLER_388_180 VPWR VGND sg13cmos5l_decap_8
X_2890_ Tile_X0Y6_FrameData_O[11] Tile_X0Y6_FrameData[11] VPWR VGND sg13cmos5l_buf_1
XFILLER_396_35 VPWR VGND sg13cmos5l_decap_8
XFILLER_8_21 VPWR VGND sg13cmos5l_decap_8
X_1841_ _1841_/Q Tile_X0Y3_FrameData[24] VGND VPWR Tile_X0Y9_FrameStrobe[5] latch
XFILLER_336_206 VPWR VGND sg13cmos5l_fill_2
XFILLER_396_79 VPWR VGND sg13cmos5l_decap_8
X_4560_ _4560_/X Tile_X0Y2_W1END[0] Tile_X0Y2_WW4END[12] Tile_X0Y2_W6END[4] _4116_/X
+ _1613_/Q _1612_/Q VPWR VGND sg13cmos5l_mux4_1
X_1772_ _1772_/Q Tile_X0Y3_FrameData[29] VGND VPWR Tile_X0Y9_FrameStrobe[3] latch
XFILLER_546_49 VPWR VGND sg13cmos5l_decap_8
XFILLER_329_84 VPWR VGND sg13cmos5l_fill_1
X_0723_ _0723_/Q Tile_X0Y9_FrameData[12] VGND VPWR Tile_X0Y9_FrameStrobe[1] latch
X_3511_ Tile_X0Y1_E2BEG[1] _3933_/X VPWR VGND sg13cmos5l_buf_1
XFILLER_693_77 VPWR VGND sg13cmos5l_decap_8
XFILLER_265_28 VPWR VGND sg13cmos5l_decap_8
X_4491_ _4491_/X _4575_/X _4579_/X _4583_/X _4552_/X _2626_/Q _2625_/Q VPWR VGND sg13cmos5l_mux4_1
XANTENNA__3654__X AXI_M_SOC_AWADDR15 VPWR VGND sg13cmos5l_antennanp
X_3442_ Tile_X0Y1_FrameData_O[0] Tile_X0Y1_FrameData[0] VPWR VGND sg13cmos5l_buf_1
X_0654_ _0654_/Q Tile_X0Y8_FrameData[17] VGND VPWR Tile_X0Y9_FrameStrobe[7] latch
XFILLER_6_193 VPWR VGND sg13cmos5l_fill_1
XFILLER_170_164 VPWR VGND sg13cmos5l_decap_8
X_3373_ Tile_X0Y2_EE4BEG[12] _4068_/X VPWR VGND sg13cmos5l_buf_1
X_0585_ _0585_/Q Tile_X0Y8_FrameData[22] VGND VPWR Tile_X0Y9_FrameStrobe[5] latch
XFILLER_69_123 VPWR VGND sg13cmos5l_decap_8
X_2324_ _2324_/Q Tile_X0Y5_FrameData[17] VGND VPWR Tile_X0Y9_FrameStrobe[4] latch
XFILLER_458_173 VPWR VGND sg13cmos5l_decap_8
XFILLER_281_49 VPWR VGND sg13cmos5l_decap_8
XFILLER_642_70 VPWR VGND sg13cmos5l_decap_8
XFILLER_607_115 VPWR VGND sg13cmos5l_decap_4
XFILLER_26_0 VPWR VGND sg13cmos5l_decap_8
XFILLER_214_21 VPWR VGND sg13cmos5l_decap_8
X_2255_ _2255_/Q Tile_X0Y5_FrameData[22] VGND VPWR Tile_X0Y9_FrameStrobe[2] latch
XFILLER_84_126 VPWR VGND sg13cmos5l_fill_1
X_1206_ _1206_/Q Tile_X0Y1_FrameData[3] VGND VPWR Tile_X0Y9_FrameStrobe[0] latch
X_2186_ _2186_/Q Tile_X0Y5_FrameData[27] VGND VPWR Tile_X0Y9_FrameStrobe[0] latch
XFILLER_214_98 VPWR VGND sg13cmos5l_decap_8
XFILLER_225_121 VPWR VGND sg13cmos5l_decap_8
X_1137_ _1137_/Q Tile_X0Y0_FrameData[26] VGND VPWR Tile_X0Y9_FrameStrobe[6] latch
XFILLER_615_192 VPWR VGND sg13cmos5l_fill_1
XFILLER_511_63 VPWR VGND sg13cmos5l_decap_8
XFILLER_230_42 VPWR VGND sg13cmos5l_fill_2
XFILLER_630_151 VPWR VGND sg13cmos5l_decap_4
X_1068_ _1068_/Q Tile_X0Y0_FrameData[31] VGND VPWR Tile_X0Y9_FrameStrobe[4] latch
XFILLER_575_217 VPWR VGND sg13cmos5l_fill_1
XFILLER_230_75 VPWR VGND sg13cmos5l_fill_2
XFILLER_379_180 VPWR VGND sg13cmos5l_decap_8
XFILLER_240_179 VPWR VGND sg13cmos5l_fill_1
XFILLER_528_144 VPWR VGND sg13cmos5l_decap_8
X_4827_ _4827_/X Tile_X0Y9_W1END[3] Tile_X0Y9_W6END[11] _4931_/X _4895_/X _0885_/Q
+ _0884_/Q VPWR VGND sg13cmos5l_mux4_1
XFILLER_327_206 VPWR VGND sg13cmos5l_fill_2
XFILLER_543_103 VPWR VGND sg13cmos5l_fill_2
X_4758_ _4758_/X Tile_X0Y8_WW4END[1] AXI_M_SOC_RDATA9 _4801_/X _4787_/X _0531_/Q _0530_/Q
+ VPWR VGND sg13cmos5l_mux4_1
XFILLER_456_49 VPWR VGND sg13cmos5l_decap_8
XFILLER_239_84 VPWR VGND sg13cmos5l_decap_8
X_3709_ AXI_M_SOC_WDATA19 Tile_X0Y6_WW4END[3] Tile_X0Y6_WW4END[11] Tile_X0Y6_W6END[3]
+ _4571_/X _2521_/Q _2520_/Q VPWR VGND sg13cmos5l_mux4_1
XFILLER_175_28 VPWR VGND sg13cmos5l_decap_8
XFILLER_146_172 VPWR VGND sg13cmos5l_decap_8
X_4689_ _4689_/X _4663_/X Tile_X0Y9_N4END[9] _4662_/X _0055_/X _0205_/Q _0204_/Q VPWR
+ VGND sg13cmos5l_mux4_1
XANTENNA__3564__X Tile_X0Y9_EE4BEG[10] VPWR VGND sg13cmos5l_antennanp
XFILLER_536_82 VPWR VGND sg13cmos5l_decap_4
XFILLER_104_7 VPWR VGND sg13cmos5l_decap_4
XFILLER_68_15 VPWR VGND sg13cmos5l_decap_8
XFILLER_255_72 VPWR VGND sg13cmos5l_decap_8
XFILLER_310_117 VPWR VGND sg13cmos5l_decap_8
XFILLER_161_186 VPWR VGND sg13cmos5l_decap_8
XFILLER_191_27 VPWR VGND sg13cmos5l_decap_8
XFILLER_405_42 VPWR VGND sg13cmos5l_decap_4
XFILLER_552_70 VPWR VGND sg13cmos5l_decap_8
XFILLER_124_21 VPWR VGND sg13cmos5l_decap_8
XFILLER_473_7 VPWR VGND sg13cmos5l_decap_8
XANTENNA__2908__X Tile_X0Y6_FrameData_O[29] VPWR VGND sg13cmos5l_antennanp
XFILLER_464_176 VPWR VGND sg13cmos5l_decap_4
XFILLER_124_98 VPWR VGND sg13cmos5l_decap_8
XFILLER_702_84 VPWR VGND sg13cmos5l_decap_8
XFILLER_90_107 VPWR VGND sg13cmos5l_decap_4
XFILLER_90_118 VPWR VGND sg13cmos5l_fill_2
XFILLER_606_181 VPWR VGND sg13cmos5l_fill_2
XFILLER_640_7 VPWR VGND sg13cmos5l_decap_8
XFILLER_421_63 VPWR VGND sg13cmos5l_decap_8
XFILLER_16_215 VPWR VGND sg13cmos5l_fill_2
XFILLER_83_181 VPWR VGND sg13cmos5l_decap_8
XFILLER_17_63 VPWR VGND sg13cmos5l_decap_8
XFILLER_216_176 VPWR VGND sg13cmos5l_fill_2
XFILLER_140_42 VPWR VGND sg13cmos5l_decap_8
XFILLER_497_56 VPWR VGND sg13cmos5l_decap_8
XFILLER_377_139 VPWR VGND sg13cmos5l_decap_8
XANTENNA__3739__X AXI_M_SOC_ARADDR11 VPWR VGND sg13cmos5l_antennanp
XFILLER_242_2 VPWR VGND sg13cmos5l_fill_1
XFILLER_231_157 VPWR VGND sg13cmos5l_decap_8
XFILLER_392_109 VPWR VGND sg13cmos5l_decap_8
XFILLER_33_51 VPWR VGND sg13cmos5l_fill_1
XFILLER_184_201 VPWR VGND sg13cmos5l_decap_4
XFILLER_130_0 VPWR VGND sg13cmos5l_decap_8
XFILLER_33_95 VPWR VGND sg13cmos5l_fill_1
XFILLER_228_0 VPWR VGND sg13cmos5l_decap_8
XFILLER_149_62 VPWR VGND sg13cmos5l_decap_8
XFILLER_366_49 VPWR VGND sg13cmos5l_decap_8
XFILLER_149_84 VPWR VGND sg13cmos5l_decap_8
XFILLER_663_14 VPWR VGND sg13cmos5l_decap_8
XANTENNA__3474__X Tile_X0Y1_EE4BEG[0] VPWR VGND sg13cmos5l_antennanp
XFILLER_137_194 VPWR VGND sg13cmos5l_decap_8
XFILLER_597_0 VPWR VGND sg13cmos5l_decap_8
XFILLER_165_83 VPWR VGND sg13cmos5l_decap_8
XFILLER_3_196 VPWR VGND sg13cmos5l_decap_8
X_0370_ _0370_/Q Tile_X0Y7_FrameData[13] VGND VPWR Tile_X0Y9_FrameStrobe[6] latch
XFILLER_462_70 VPWR VGND sg13cmos5l_decap_8
XFILLER_315_86 VPWR VGND sg13cmos5l_decap_8
XANTENNA__2818__X Tile_X0Y3_E1BEG[0] VPWR VGND sg13cmos5l_antennanp
XFILLER_66_126 VPWR VGND sg13cmos5l_decap_8
XFILLER_181_71 VPWR VGND sg13cmos5l_decap_8
X_2040_ _2040_/Q Tile_X0Y4_FrameData[13] VGND VPWR Tile_X0Y9_FrameStrobe[3] latch
XFILLER_604_118 VPWR VGND sg13cmos5l_decap_4
XFILLER_612_84 VPWR VGND sg13cmos5l_decap_8
XFILLER_81_107 VPWR VGND sg13cmos5l_fill_2
XFILLER_470_146 VPWR VGND sg13cmos5l_decap_8
XFILLER_207_143 VPWR VGND sg13cmos5l_fill_2
XFILLER_612_173 VPWR VGND sg13cmos5l_decap_8
X_3991_ _3991_/X _3890_/X _4023_/X _4022_/X Tile_X0Y0_S2MID[1] _1199_/Q _1198_/Q VPWR
+ VGND sg13cmos5l_mux4_1
XANTENNA__3649__X AXI_M_SOC_AWADDR10 VPWR VGND sg13cmos5l_antennanp
X_2942_ Tile_X0Y8_E6BEG[10] _4770_/X VPWR VGND sg13cmos5l_buf_1
XFILLER_200_56 VPWR VGND sg13cmos5l_decap_8
XFILLER_383_109 VPWR VGND sg13cmos5l_decap_8
XFILLER_376_161 VPWR VGND sg13cmos5l_fill_2
XFILLER_309_217 VPWR VGND sg13cmos5l_fill_1
X_2873_ Tile_X0Y6_EE4BEG[10] _4522_/X VPWR VGND sg13cmos5l_buf_1
XFILLER_230_190 VPWR VGND sg13cmos5l_decap_8
X_4612_ _4612_/X Tile_X0Y7_W2MID[7] AXI_M_SOC_RDATA16 _4669_/X _4668_/X _0335_/Q _0334_/Q
+ VPWR VGND sg13cmos5l_mux4_1
X_1824_ _1824_/Q Tile_X0Y3_FrameData[9] VGND VPWR Tile_X0Y9_FrameStrobe[4] latch
XFILLER_276_49 VPWR VGND sg13cmos5l_decap_8
XFILLER_637_70 VPWR VGND sg13cmos5l_decap_8
XFILLER_209_21 VPWR VGND sg13cmos5l_decap_8
XFILLER_324_209 VPWR VGND sg13cmos5l_decap_8
XFILLER_391_164 VPWR VGND sg13cmos5l_decap_8
XFILLER_190_215 VPWR VGND sg13cmos5l_fill_2
X_1755_ _1755_/Q Tile_X0Y3_FrameData[14] VGND VPWR Tile_X0Y9_FrameStrobe[2] latch
X_4543_ _4543_/X _4551_/X Tile_X0Y6_W6END[3] _4550_/X _4543_/A3 _2441_/Q _2696_/Q
+ VPWR VGND sg13cmos5l_mux4_1
XFILLER_573_14 VPWR VGND sg13cmos5l_decap_8
XANTENNA__3384__X Tile_X0Y2_E6BEG[7] VPWR VGND sg13cmos5l_antennanp
X_0706_ _0706_/Q Tile_X0Y9_FrameData[29] VGND VPWR Tile_X0Y9_FrameStrobe[1] latch
X_1686_ _1686_/Q Tile_X0Y3_FrameData[19] VGND VPWR Tile_X0Y9_FrameStrobe[0] latch
X_4474_ _4474_/X Tile_X0Y4_W2MID[4] Tile_X0Y4_W2END[4] Tile_X0Y4_W6END[11] _4319_/X
+ _2131_/Q _2130_/Q VPWR VGND sg13cmos5l_mux4_1
XFILLER_209_98 VPWR VGND sg13cmos5l_decap_8
X_0637_ _0637_/Q Tile_X0Y8_FrameData[2] VGND VPWR Tile_X0Y9_FrameStrobe[6] latch
X_3425_ Tile_X0Y4_FrameData_O[16] Tile_X0Y4_FrameData[16] VPWR VGND sg13cmos5l_buf_1
XFILLER_506_63 VPWR VGND sg13cmos5l_decap_8
XFILLER_225_20 VPWR VGND sg13cmos5l_decap_8
XFILLER_493_205 VPWR VGND sg13cmos5l_fill_1
XFILLER_653_91 VPWR VGND sg13cmos5l_decap_8
XFILLER_493_216 VPWR VGND sg13cmos5l_fill_2
X_3356_ Tile_X0Y2_FrameData_O[27] Tile_X0Y2_FrameData[27] VPWR VGND sg13cmos5l_buf_1
X_0568_ _0568_/Q Tile_X0Y8_FrameData[7] VGND VPWR Tile_X0Y9_FrameStrobe[4] latch
XFILLER_225_64 VPWR VGND sg13cmos5l_decap_8
XFILLER_635_210 VPWR VGND sg13cmos5l_fill_2
X_2307_ _2307_/Q Tile_X0Y5_FrameData[2] VGND VPWR Tile_X0Y9_FrameStrobe[3] latch
XFILLER_446_143 VPWR VGND sg13cmos5l_decap_4
XFILLER_300_161 VPWR VGND sg13cmos5l_decap_4
X_3287_ Tile_X0Y0_E6BEG[7] _3843_/X VPWR VGND sg13cmos5l_buf_1
X_0499_ _0499_/Q Tile_X0Y8_FrameData[12] VGND VPWR Tile_X0Y9_FrameStrobe[2] latch
X_2238_ _2238_/Q Tile_X0Y5_FrameData[7] VGND VPWR Tile_X0Y9_FrameStrobe[1] latch
XFILLER_446_187 VPWR VGND sg13cmos5l_decap_8
XFILLER_461_124 VPWR VGND sg13cmos5l_decap_8
X_2169_ _2169_/Q Tile_X0Y4_FrameData[12] VGND VPWR Tile_X0Y9_FrameStrobe[7] latch
XFILLER_603_140 VPWR VGND sg13cmos5l_fill_1
XANTENNA__3559__X Tile_X0Y9_EE4BEG[5] VPWR VGND sg13cmos5l_antennanp
XFILLER_213_168 VPWR VGND sg13cmos5l_decap_4
XFILLER_110_34 VPWR VGND sg13cmos5l_decap_8
XFILLER_213_179 VPWR VGND sg13cmos5l_decap_8
XFILLER_110_45 VPWR VGND sg13cmos5l_fill_2
XFILLER_110_89 VPWR VGND sg13cmos5l_fill_1
XFILLER_70_49 VPWR VGND sg13cmos5l_decap_8
XFILLER_221_7 VPWR VGND sg13cmos5l_decap_8
XFILLER_319_7 VPWR VGND sg13cmos5l_decap_8
XFILLER_547_70 VPWR VGND sg13cmos5l_decap_8
XFILLER_119_21 VPWR VGND sg13cmos5l_decap_8
XFILLER_382_164 VPWR VGND sg13cmos5l_decap_8
XFILLER_483_14 VPWR VGND sg13cmos5l_decap_8
XANTENNA__3294__X Tile_X0Y0_E2BEGb[2] VPWR VGND sg13cmos5l_antennanp
XFILLER_382_197 VPWR VGND sg13cmos5l_fill_2
XFILLER_79_47 VPWR VGND sg13cmos5l_decap_8
XFILLER_633_28 VPWR VGND sg13cmos5l_decap_8
XFILLER_590_7 VPWR VGND sg13cmos5l_decap_8
XFILLER_416_63 VPWR VGND sg13cmos5l_decap_8
XFILLER_688_7 VPWR VGND sg13cmos5l_decap_8
XFILLER_295_105 VPWR VGND sg13cmos5l_decap_8
XFILLER_563_91 VPWR VGND sg13cmos5l_decap_8
XFILLER_135_42 VPWR VGND sg13cmos5l_decap_8
XFILLER_282_70 VPWR VGND sg13cmos5l_decap_8
XFILLER_95_35 VPWR VGND sg13cmos5l_decap_8
XFILLER_95_46 VPWR VGND sg13cmos5l_fill_1
XFILLER_0_199 VPWR VGND sg13cmos5l_decap_8
XFILLER_437_176 VPWR VGND sg13cmos5l_decap_8
XFILLER_432_84 VPWR VGND sg13cmos5l_decap_8
XFILLER_452_135 VPWR VGND sg13cmos5l_decap_8
XFILLER_178_0 VPWR VGND sg13cmos5l_fill_2
XFILLER_251_208 VPWR VGND sg13cmos5l_fill_1
XFILLER_658_14 VPWR VGND sg13cmos5l_decap_8
XFILLER_460_190 VPWR VGND sg13cmos5l_fill_1
XFILLER_44_50 VPWR VGND sg13cmos5l_decap_8
XFILLER_345_0 VPWR VGND sg13cmos5l_decap_8
XANTENNA__3469__X Tile_X0Y1_FrameData_O[27] VPWR VGND sg13cmos5l_antennanp
XFILLER_301_88 VPWR VGND sg13cmos5l_decap_4
XFILLER_358_161 VPWR VGND sg13cmos5l_decap_8
XFILLER_512_0 VPWR VGND sg13cmos5l_decap_8
XFILLER_507_114 VPWR VGND sg13cmos5l_decap_8
XFILLER_674_35 VPWR VGND sg13cmos5l_decap_8
XFILLER_373_153 VPWR VGND sg13cmos5l_fill_2
XFILLER_457_81 VPWR VGND sg13cmos5l_decap_8
XFILLER_172_215 VPWR VGND sg13cmos5l_fill_2
XFILLER_393_14 VPWR VGND sg13cmos5l_decap_8
XFILLER_711_217 VPWR VGND sg13cmos5l_fill_1
XFILLER_373_197 VPWR VGND sg13cmos5l_decap_8
X_1540_ _1540_/Q Tile_X0Y2_FrameData[13] VGND VPWR Tile_X0Y9_FrameStrobe[3] latch
XFILLER_176_82 VPWR VGND sg13cmos5l_fill_1
XFILLER_607_84 VPWR VGND sg13cmos5l_decap_4
XFILLER_607_95 VPWR VGND sg13cmos5l_decap_8
XFILLER_543_28 VPWR VGND sg13cmos5l_decap_8
X_1471_ _1471_/Q Tile_X0Y2_FrameData[18] VGND VPWR Tile_X0Y9_FrameStrobe[1] latch
XFILLER_5_77 VPWR VGND sg13cmos5l_decap_8
XFILLER_140_112 VPWR VGND sg13cmos5l_decap_8
XFILLER_676_154 VPWR VGND sg13cmos5l_decap_4
X_3210_ Tile_X0Y0_N1BEG[2] _3782_/X VPWR VGND sg13cmos5l_buf_1
X_0422_ _0422_/Q Tile_X0Y8_FrameData[25] VGND VPWR Tile_X0Y9_FrameStrobe[0] latch
XFILLER_530_194 VPWR VGND sg13cmos5l_decap_8
XFILLER_286_127 VPWR VGND sg13cmos5l_decap_8
X_4190_ _4190_/X AXI_M_SOC_WREADY _4223_/X _4227_/X _4206_/X _1761_/Q _1760_/Q VPWR
+ VGND sg13cmos5l_mux4_1
XFILLER_691_113 VPWR VGND sg13cmos5l_decap_4
XFILLER_192_70 VPWR VGND sg13cmos5l_decap_8
XFILLER_691_135 VPWR VGND sg13cmos5l_fill_2
XFILLER_140_178 VPWR VGND sg13cmos5l_decap_8
X_3141_ Tile_X0Y7_FrameData_O[11] Tile_X0Y7_FrameData[11] VPWR VGND sg13cmos5l_buf_1
X_0353_ _0353_/Q Tile_X0Y7_FrameData[30] VGND VPWR Tile_X0Y9_FrameStrobe[6] latch
XFILLER_428_154 VPWR VGND sg13cmos5l_decap_8
XFILLER_699_21 VPWR VGND sg13cmos5l_decap_8
X_3072_ Tile_X0Y5_FrameData_O[31] Tile_X0Y5_FrameData[31] VPWR VGND sg13cmos5l_buf_1
XFILLER_589_106 VPWR VGND sg13cmos5l_fill_2
X_0284_ _0284_/Q Tile_X0Y7_FrameData[3] VGND VPWR Tile_X0Y9_FrameStrobe[3] latch
XFILLER_342_84 VPWR VGND sg13cmos5l_fill_2
XFILLER_54_107 VPWR VGND sg13cmos5l_decap_8
XFILLER_54_118 VPWR VGND sg13cmos5l_fill_2
XANTENNA__0068__X AXI_M_SOC_WSTRB3 VPWR VGND sg13cmos5l_antennanp
X_2023_ _2023_/Q Tile_X0Y4_FrameData[30] VGND VPWR Tile_X0Y9_FrameStrobe[3] latch
XFILLER_699_98 VPWR VGND sg13cmos5l_decap_8
XFILLER_443_179 VPWR VGND sg13cmos5l_fill_2
XFILLER_568_14 VPWR VGND sg13cmos5l_decap_8
XANTENNA__3379__X Tile_X0Y2_E6BEG[2] VPWR VGND sg13cmos5l_antennanp
XFILLER_597_183 VPWR VGND sg13cmos5l_fill_1
XFILLER_211_77 VPWR VGND sg13cmos5l_decap_8
XFILLER_62_184 VPWR VGND sg13cmos5l_decap_8
X_3974_ _3974_/X AXI_M_SOC_ARREADY _4009_/X _4013_/X _3990_/X _1261_/Q _1260_/Q VPWR
+ VGND sg13cmos5l_mux4_1
XFILLER_93_0 VPWR VGND sg13cmos5l_decap_8
XFILLER_600_187 VPWR VGND sg13cmos5l_decap_4
X_2925_ Tile_X0Y8_E2BEGb[1] _4737_/X VPWR VGND sg13cmos5l_buf_1
XFILLER_648_91 VPWR VGND sg13cmos5l_decap_8
XFILLER_349_194 VPWR VGND sg13cmos5l_fill_1
XFILLER_364_131 VPWR VGND sg13cmos5l_decap_8
X_2856_ Tile_X0Y6_E6BEG[5] _4533_/X VPWR VGND sg13cmos5l_buf_1
XFILLER_584_35 VPWR VGND sg13cmos5l_decap_8
X_1807_ _1807_/Q Tile_X0Y3_FrameData[26] VGND VPWR Tile_X0Y9_FrameStrobe[4] latch
X_2787_ Tile_X0Y3_EE4BEG[13] _4177_/X VPWR VGND sg13cmos5l_buf_1
XFILLER_702_217 VPWR VGND sg13cmos5l_fill_1
X_4526_ _4526_/X Tile_X0Y6_WW4END[1] AXI_M_SOC_RDATA25 _4569_/X _4555_/X _2555_/Q
+ _2554_/Q VPWR VGND sg13cmos5l_mux4_1
X_1738_ _1738_/Q Tile_X0Y3_FrameData[31] VGND VPWR Tile_X0Y9_FrameStrobe[2] latch
XFILLER_506_191 VPWR VGND sg13cmos5l_fill_1
XFILLER_517_95 VPWR VGND sg13cmos5l_decap_8
XFILLER_131_101 VPWR VGND sg13cmos5l_decap_8
XFILLER_453_28 VPWR VGND sg13cmos5l_decap_8
X_4457_ _4457_/X _4424_/X _0100_/X _4423_/X _0140_/X _2225_/Q _2224_/Q VPWR VGND sg13cmos5l_mux4_1
X_1669_ _1669_/Q Tile_X0Y2_FrameData[12] VGND VPWR Tile_X0Y9_FrameStrobe[7] latch
XFILLER_277_105 VPWR VGND sg13cmos5l_decap_8
XFILLER_682_102 VPWR VGND sg13cmos5l_fill_2
X_3408_ Tile_X0Y2_E1BEG[3] _4039_/X VPWR VGND sg13cmos5l_buf_1
X_4388_ _4388_/X Tile_X0Y5_WW4END[15] AXI_M_SOC_RVALID _4466_/X _4428_/X _2327_/Q
+ _2326_/Q VPWR VGND sg13cmos5l_mux4_1
XFILLER_608_210 VPWR VGND sg13cmos5l_fill_2
X_3339_ Tile_X0Y2_FrameData_O[10] Tile_X0Y2_FrameData[10] VPWR VGND sg13cmos5l_buf_1
XFILLER_533_83 VPWR VGND sg13cmos5l_fill_1
XFILLER_105_34 VPWR VGND sg13cmos5l_decap_8
XFILLER_419_165 VPWR VGND sg13cmos5l_fill_2
XFILLER_105_78 VPWR VGND sg13cmos5l_decap_8
XFILLER_434_135 VPWR VGND sg13cmos5l_decap_8
XFILLER_402_21 VPWR VGND sg13cmos5l_decap_8
XFILLER_171_7 VPWR VGND sg13cmos5l_decap_8
XFILLER_38_181 VPWR VGND sg13cmos5l_fill_2
XFILLER_269_7 VPWR VGND sg13cmos5l_decap_8
XFILLER_402_76 VPWR VGND sg13cmos5l_decap_8
XFILLER_588_150 VPWR VGND sg13cmos5l_decap_8
XFILLER_402_87 VPWR VGND sg13cmos5l_fill_2
XFILLER_478_14 VPWR VGND sg13cmos5l_decap_8
XANTENNA__3289__X Tile_X0Y0_E6BEG[9] VPWR VGND sg13cmos5l_antennanp
XFILLER_198_134 VPWR VGND sg13cmos5l_decap_8
XFILLER_121_77 VPWR VGND sg13cmos5l_decap_8
XFILLER_628_28 VPWR VGND sg13cmos5l_decap_8
XFILLER_14_42 VPWR VGND sg13cmos5l_decap_8
XFILLER_14_75 VPWR VGND sg13cmos5l_decap_8
XFILLER_603_7 VPWR VGND sg13cmos5l_decap_8
XANTENNA__2921__X Tile_X0Y8_E2BEG[5] VPWR VGND sg13cmos5l_antennanp
XFILLER_494_35 VPWR VGND sg13cmos5l_decap_8
XFILLER_277_70 VPWR VGND sg13cmos5l_decap_8
XFILLER_370_123 VPWR VGND sg13cmos5l_fill_1
XFILLER_658_110 VPWR VGND sg13cmos5l_fill_2
XFILLER_644_49 VPWR VGND sg13cmos5l_decap_8
XFILLER_427_84 VPWR VGND sg13cmos5l_decap_8
XFILLER_370_167 VPWR VGND sg13cmos5l_decap_8
XFILLER_30_63 VPWR VGND sg13cmos5l_decap_8
XFILLER_107_164 VPWR VGND sg13cmos5l_decap_8
XFILLER_370_189 VPWR VGND sg13cmos5l_fill_2
XFILLER_146_63 VPWR VGND sg13cmos5l_decap_8
XFILLER_512_183 VPWR VGND sg13cmos5l_decap_8
XANTENNA__3752__X AXI_M_SOC_ARADDR24 VPWR VGND sg13cmos5l_antennanp
XFILLER_673_124 VPWR VGND sg13cmos5l_fill_1
XFILLER_295_0 VPWR VGND sg13cmos5l_decap_8
XFILLER_472_208 VPWR VGND sg13cmos5l_fill_1
XFILLER_283_119 VPWR VGND sg13cmos5l_decap_8
XFILLER_39_94 VPWR VGND sg13cmos5l_decap_8
XFILLER_162_73 VPWR VGND sg13cmos5l_decap_8
XFILLER_462_0 VPWR VGND sg13cmos5l_decap_8
XFILLER_312_21 VPWR VGND sg13cmos5l_decap_8
XFILLER_91_213 VPWR VGND sg13cmos5l_decap_4
XFILLER_681_190 VPWR VGND sg13cmos5l_fill_1
XFILLER_312_32 VPWR VGND sg13cmos5l_fill_1
XFILLER_425_168 VPWR VGND sg13cmos5l_decap_8
XFILLER_29_181 VPWR VGND sg13cmos5l_fill_2
XFILLER_55_60 VPWR VGND sg13cmos5l_decap_8
XFILLER_669_57 VPWR VGND sg13cmos5l_decap_8
XFILLER_388_14 VPWR VGND sg13cmos5l_decap_8
XFILLER_189_112 VPWR VGND sg13cmos5l_decap_8
XANTENNA__3199__X Tile_X0Y0_N2BEGb[7] VPWR VGND sg13cmos5l_antennanp
X_0971_ _0971_/Q Tile_X0Y0_FrameData[0] VGND VPWR Tile_X0Y9_FrameStrobe[0] latch
XFILLER_538_28 VPWR VGND sg13cmos5l_decap_8
XFILLER_468_80 VPWR VGND sg13cmos5l_decap_8
XFILLER_685_56 VPWR VGND sg13cmos5l_decap_8
XANTENNA__2831__X Tile_X0Y6_E1BEG[0] VPWR VGND sg13cmos5l_antennanp
X_2710_ _4419_/A3 VPWR VGND sg13cmos5l_tielo
X_3690_ AXI_M_SOC_WDATA0 Tile_X0Y7_WW4END[0] Tile_X0Y7_WW4END[8] Tile_X0Y7_W6END[0]
+ _4684_/X _0247_/Q _0246_/Q VPWR VGND sg13cmos5l_mux4_1
XFILLER_187_81 VPWR VGND sg13cmos5l_decap_8
X_2641_ _2641_/Q Tile_X0Y6_FrameData[22] VGND VPWR Tile_X0Y9_FrameStrobe[6] latch
XFILLER_550_201 VPWR VGND sg13cmos5l_decap_8
XFILLER_696_216 VPWR VGND sg13cmos5l_fill_2
X_2572_ _2572_/Q Tile_X0Y6_FrameData[27] VGND VPWR Tile_X0Y9_FrameStrobe[4] latch
XFILLER_554_49 VPWR VGND sg13cmos5l_decap_8
X_4311_ _4311_/X Tile_X0Y5_W1END[3] Tile_X0Y5_W6END[7] _4466_/X _4425_/X _2433_/Q
+ _2432_/Q VPWR VGND sg13cmos5l_mux4_1
XFILLER_273_28 VPWR VGND sg13cmos5l_decap_8
X_1523_ _1523_/Q Tile_X0Y2_FrameData[30] VGND VPWR Tile_X0Y9_FrameStrobe[3] latch
XFILLER_503_161 VPWR VGND sg13cmos5l_decap_8
XFILLER_649_154 VPWR VGND sg13cmos5l_decap_8
XFILLER_259_105 VPWR VGND sg13cmos5l_decap_8
XFILLER_113_123 VPWR VGND sg13cmos5l_decap_4
XANTENNA__3662__X AXI_M_SOC_AWADDR23 VPWR VGND sg13cmos5l_antennanp
X_1454_ _1454_/Q Tile_X0Y2_FrameData[3] VGND VPWR Tile_X0Y9_FrameStrobe[0] latch
X_4242_ _4242_/X Tile_X0Y2_W2MID[4] Tile_X0Y2_W2END[4] Tile_X0Y2_W6END[11] _4103_/X
+ _1623_/Q _1622_/Q VPWR VGND sg13cmos5l_mux4_1
XFILLER_664_124 VPWR VGND sg13cmos5l_decap_4
XFILLER_206_55 VPWR VGND sg13cmos5l_decap_8
X_0405_ _0405_/Q Tile_X0Y7_FrameData[10] VGND VPWR Tile_X0Y9_FrameStrobe[7] latch
X_4173_ _4173_/X Tile_X0Y3_WW4END[6] AXI_M_SOC_WREADY _4228_/X _4206_/X _1795_/Q _1794_/Q
+ VPWR VGND sg13cmos5l_mux4_1
X_1385_ _1385_/Q Tile_X0Y1_FrameData[16] VGND VPWR Tile_X0Y9_FrameStrobe[6] latch
XFILLER_274_119 VPWR VGND sg13cmos5l_decap_8
XFILLER_267_171 VPWR VGND sg13cmos5l_decap_8
XFILLER_503_42 VPWR VGND sg13cmos5l_decap_8
X_0336_ _0336_/Q Tile_X0Y7_FrameData[15] VGND VPWR Tile_X0Y9_FrameStrobe[5] latch
X_3124_ Tile_X0Y7_EE4BEG[10] _4638_/X VPWR VGND sg13cmos5l_buf_1
XFILLER_650_70 VPWR VGND sg13cmos5l_decap_8
XFILLER_222_21 VPWR VGND sg13cmos5l_decap_8
X_3055_ Tile_X0Y5_FrameData_O[14] Tile_X0Y5_FrameData[14] VPWR VGND sg13cmos5l_buf_1
X_0267_ _0267_/Q Tile_X0Y7_FrameData[20] VGND VPWR Tile_X0Y9_FrameStrobe[3] latch
XFILLER_431_105 VPWR VGND sg13cmos5l_decap_8
XFILLER_579_35 VPWR VGND sg13cmos5l_decap_8
X_2006_ _2006_/Q Tile_X0Y4_FrameData[15] VGND VPWR Tile_X0Y9_FrameStrobe[2] latch
XFILLER_431_127 VPWR VGND sg13cmos5l_fill_1
XFILLER_282_196 VPWR VGND sg13cmos5l_decap_8
XFILLER_369_201 VPWR VGND sg13cmos5l_decap_8
XFILLER_35_151 VPWR VGND sg13cmos5l_fill_1
XFILLER_298_14 VPWR VGND sg13cmos5l_decap_8
X_0198_ _0198_/Q Tile_X0Y7_FrameData[25] VGND VPWR Tile_X0Y9_FrameStrobe[1] latch
XFILLER_431_149 VPWR VGND sg13cmos5l_fill_2
XFILLER_35_173 VPWR VGND sg13cmos5l_decap_8
XFILLER_50_121 VPWR VGND sg13cmos5l_fill_2
XFILLER_448_28 VPWR VGND sg13cmos5l_decap_8
X_3957_ _3957_/X Tile_X0Y1_WW4END[6] AXI_M_SOC_ARREADY _4014_/X _3990_/X _1295_/Q
+ _1294_/Q VPWR VGND sg13cmos5l_mux4_1
XFILLER_595_56 VPWR VGND sg13cmos5l_decap_8
XFILLER_50_187 VPWR VGND sg13cmos5l_decap_4
XANTENNA__2741__X Tile_X0Y3_UserCLKo VPWR VGND sg13cmos5l_antennanp
X_2908_ Tile_X0Y6_FrameData_O[29] Tile_X0Y6_FrameData[29] VPWR VGND sg13cmos5l_buf_1
X_3888_ _3888_/X Tile_X0Y2_W2MID[7] Tile_X0Y2_W2END[7] Tile_X0Y2_W6END[7] _4097_/X
+ _1665_/Q _1664_/Q VPWR VGND sg13cmos5l_mux4_1
X_2839_ Tile_X0Y6_E2BEG[4] _4500_/X VPWR VGND sg13cmos5l_buf_1
XFILLER_352_112 VPWR VGND sg13cmos5l_decap_8
XFILLER_337_186 VPWR VGND sg13cmos5l_fill_1
XFILLER_498_105 VPWR VGND sg13cmos5l_decap_8
XFILLER_687_216 VPWR VGND sg13cmos5l_fill_2
XFILLER_464_49 VPWR VGND sg13cmos5l_decap_8
XFILLER_247_84 VPWR VGND sg13cmos5l_decap_8
X_4509_ _4509_/X Tile_X0Y6_W2END[2] AXI_M_SOC_RDATA26 _4557_/X _4556_/X _2589_/Q _2588_/Q
+ VPWR VGND sg13cmos5l_mux4_1
XFILLER_183_28 VPWR VGND sg13cmos5l_decap_4
XFILLER_544_60 VPWR VGND sg13cmos5l_fill_2
XANTENNA__3572__X Tile_X0Y9_FrameData_O[2] VPWR VGND sg13cmos5l_antennanp
XFILLER_544_71 VPWR VGND sg13cmos5l_fill_1
XFILLER_116_55 VPWR VGND sg13cmos5l_decap_8
XFILLER_104_178 VPWR VGND sg13cmos5l_decap_8
XFILLER_58_210 VPWR VGND sg13cmos5l_fill_2
XFILLER_386_7 VPWR VGND sg13cmos5l_decap_8
XFILLER_670_116 VPWR VGND sg13cmos5l_decap_4
XFILLER_413_42 VPWR VGND sg13cmos5l_decap_8
XFILLER_560_70 VPWR VGND sg13cmos5l_decap_8
XFILLER_132_21 VPWR VGND sg13cmos5l_decap_8
XFILLER_553_7 VPWR VGND sg13cmos5l_decap_8
XANTENNA__2916__X Tile_X0Y8_E2BEG[0] VPWR VGND sg13cmos5l_antennanp
XFILLER_422_105 VPWR VGND sg13cmos5l_fill_2
XFILLER_92_14 VPWR VGND sg13cmos5l_fill_2
XFILLER_489_35 VPWR VGND sg13cmos5l_decap_8
XFILLER_92_25 VPWR VGND sg13cmos5l_fill_1
XFILLER_92_47 VPWR VGND sg13cmos5l_fill_1
XFILLER_132_98 VPWR VGND sg13cmos5l_decap_8
XFILLER_710_84 VPWR VGND sg13cmos5l_decap_8
XFILLER_415_190 VPWR VGND sg13cmos5l_decap_4
XFILLER_41_110 VPWR VGND sg13cmos5l_decap_8
XFILLER_41_121 VPWR VGND sg13cmos5l_fill_2
XFILLER_639_49 VPWR VGND sg13cmos5l_decap_8
XFILLER_41_132 VPWR VGND sg13cmos5l_fill_1
XFILLER_430_171 VPWR VGND sg13cmos5l_decap_8
XFILLER_41_154 VPWR VGND sg13cmos5l_fill_1
XFILLER_576_175 VPWR VGND sg13cmos5l_decap_8
XFILLER_430_182 VPWR VGND sg13cmos5l_fill_1
XFILLER_358_28 VPWR VGND sg13cmos5l_decap_8
XANTENNA__3747__X AXI_M_SOC_ARADDR19 VPWR VGND sg13cmos5l_antennanp
XFILLER_288_91 VPWR VGND sg13cmos5l_decap_8
XFILLER_41_62 VPWR VGND sg13cmos5l_decap_8
XFILLER_489_105 VPWR VGND sg13cmos5l_fill_2
XFILLER_210_0 VPWR VGND sg13cmos5l_fill_2
XFILLER_41_84 VPWR VGND sg13cmos5l_decap_4
XFILLER_308_0 VPWR VGND sg13cmos5l_fill_2
XFILLER_157_62 VPWR VGND sg13cmos5l_decap_8
XFILLER_157_73 VPWR VGND sg13cmos5l_fill_2
XFILLER_374_49 VPWR VGND sg13cmos5l_decap_8
XFILLER_307_21 VPWR VGND sg13cmos5l_decap_8
XFILLER_307_32 VPWR VGND sg13cmos5l_fill_1
XFILLER_671_14 VPWR VGND sg13cmos5l_decap_8
XANTENNA__3482__X Tile_X0Y1_EE4BEG[8] VPWR VGND sg13cmos5l_antennanp
XFILLER_454_71 VPWR VGND sg13cmos5l_fill_1
XFILLER_497_182 VPWR VGND sg13cmos5l_decap_8
XFILLER_307_87 VPWR VGND sg13cmos5l_decap_4
XFILLER_677_0 VPWR VGND sg13cmos5l_decap_8
XFILLER_173_72 VPWR VGND sg13cmos5l_decap_4
XFILLER_604_63 VPWR VGND sg13cmos5l_decap_8
XFILLER_500_175 VPWR VGND sg13cmos5l_decap_8
XFILLER_646_168 VPWR VGND sg13cmos5l_decap_8
XFILLER_110_137 VPWR VGND sg13cmos5l_decap_8
XFILLER_661_116 VPWR VGND sg13cmos5l_decap_4
XFILLER_323_42 VPWR VGND sg13cmos5l_fill_2
XFILLER_2_56 VPWR VGND sg13cmos5l_decap_8
X_1170_ _1170_/Q Tile_X0Y0_FrameData[25] VGND VPWR Tile_X0Y9_FrameStrobe[7] latch
XFILLER_470_70 VPWR VGND sg13cmos5l_decap_8
XFILLER_661_149 VPWR VGND sg13cmos5l_decap_8
XFILLER_64_202 VPWR VGND sg13cmos5l_fill_2
XFILLER_264_130 VPWR VGND sg13cmos5l_decap_8
X_0121_ _3181_/A _3916_/X _3917_/X _1644_/Q VPWR VGND sg13cmos5l_mux2_1
XFILLER_66_70 VPWR VGND sg13cmos5l_decap_8
XANTENNA__2826__X Tile_X0Y4_E2BEG[4] VPWR VGND sg13cmos5l_antennanp
XFILLER_413_105 VPWR VGND sg13cmos5l_decap_8
XFILLER_399_35 VPWR VGND sg13cmos5l_decap_8
X_0052_ AXI_M_SOC_AWBURST0 _0938_/Q _3682_/X VPWR VGND sg13cmos5l_or2_1
XFILLER_620_84 VPWR VGND sg13cmos5l_decap_8
X_4860_ _4860_/X Tile_X0Y9_W2END[3] AXI_M_SOC_RDATA3 _4907_/X _4906_/X _0823_/Q _0822_/Q
+ VPWR VGND sg13cmos5l_mux4_1
XFILLER_17_195 VPWR VGND sg13cmos5l_decap_8
XFILLER_549_49 VPWR VGND sg13cmos5l_decap_8
XFILLER_82_80 VPWR VGND sg13cmos5l_fill_1
XFILLER_366_204 VPWR VGND sg13cmos5l_decap_8
X_3811_ _3811_/X Tile_X0Y0_W2MID[0] _3853_/X _3852_/X _3860_/X _1083_/Q _1082_/Q VPWR
+ VGND sg13cmos5l_mux4_1
XFILLER_696_77 VPWR VGND sg13cmos5l_decap_8
XFILLER_268_28 VPWR VGND sg13cmos5l_decap_8
X_4791_ _4791_/X _4707_/X Tile_X0Y9_N2MID[3] _4819_/X _4706_/X _0433_/Q _0432_/Q VPWR
+ VGND sg13cmos5l_mux4_1
XFILLER_582_112 VPWR VGND sg13cmos5l_decap_8
XFILLER_32_176 VPWR VGND sg13cmos5l_decap_8
XANTENNA_17 AXI_M_SOC_WREADY VPWR VGND sg13cmos5l_antennanp
XFILLER_177_148 VPWR VGND sg13cmos5l_decap_8
XANTENNA__3657__X AXI_M_SOC_AWADDR18 VPWR VGND sg13cmos5l_antennanp
XANTENNA_28 AXI_M_SOC_WREADY VPWR VGND sg13cmos5l_antennanp
XFILLER_198_91 VPWR VGND sg13cmos5l_decap_8
XFILLER_177_159 VPWR VGND sg13cmos5l_fill_2
XANTENNA_39 Tile_X0Y0_S2MID[0] VPWR VGND sg13cmos5l_antennanp
X_3742_ AXI_M_SOC_ARADDR14 Tile_X0Y9_W1END[2] Tile_X0Y9_WW4END[6] Tile_X0Y9_WW4END[14]
+ _4930_/X _0731_/Q _0730_/Q VPWR VGND sg13cmos5l_mux4_1
X_0954_ _0954_/Q Tile_X0Y0_FrameData[17] VGND VPWR Tile_X0Y9_FrameStrobe[0] latch
XFILLER_523_201 VPWR VGND sg13cmos5l_decap_8
X_3673_ _3673_/X Tile_X0Y2_WW4END[3] Tile_X0Y2_WW4END[11] Tile_X0Y2_W6END[3] _4119_/X
+ _1499_/Q _1498_/Q VPWR VGND sg13cmos5l_mux4_1
X_0885_ _0885_/Q Tile_X0Y9_FrameData[10] VGND VPWR Tile_X0Y9_FrameStrobe[6] latch
X_2624_ _2624_/Q Tile_X0Y6_FrameData[7] VGND VPWR Tile_X0Y9_FrameStrobe[5] latch
XFILLER_284_49 VPWR VGND sg13cmos5l_decap_8
XFILLER_645_70 VPWR VGND sg13cmos5l_decap_8
XFILLER_334_178 VPWR VGND sg13cmos5l_decap_8
XFILLER_581_14 VPWR VGND sg13cmos5l_decap_8
X_2555_ _2555_/Q Tile_X0Y6_FrameData[12] VGND VPWR Tile_X0Y9_FrameStrobe[3] latch
XFILLER_495_119 VPWR VGND sg13cmos5l_decap_8
XFILLER_364_60 VPWR VGND sg13cmos5l_fill_1
XANTENNA__3392__X Tile_X0Y2_E2BEGb[3] VPWR VGND sg13cmos5l_antennanp
XFILLER_488_171 VPWR VGND sg13cmos5l_decap_8
XFILLER_217_76 VPWR VGND sg13cmos5l_decap_8
X_1506_ _1506_/Q Tile_X0Y2_FrameData[15] VGND VPWR Tile_X0Y9_FrameStrobe[2] latch
XFILLER_488_193 VPWR VGND sg13cmos5l_fill_2
XFILLER_99_176 VPWR VGND sg13cmos5l_decap_8
X_2486_ _2486_/Q Tile_X0Y6_FrameData[17] VGND VPWR Tile_X0Y9_FrameStrobe[1] latch
X_4225_ _4225_/X _4203_/X _0046_/X _4202_/X Tile_X0Y0_S4END[15] _1723_/Q _1722_/Q
+ VPWR VGND sg13cmos5l_mux4_1
XFILLER_637_157 VPWR VGND sg13cmos5l_fill_2
XFILLER_514_63 VPWR VGND sg13cmos5l_decap_8
X_1437_ _1437_/Q Tile_X0Y2_FrameData[20] VGND VPWR Tile_X0Y9_FrameStrobe[0] latch
XFILLER_652_105 VPWR VGND sg13cmos5l_decap_8
XFILLER_514_74 VPWR VGND sg13cmos5l_fill_1
XFILLER_661_91 VPWR VGND sg13cmos5l_fill_2
XFILLER_514_96 VPWR VGND sg13cmos5l_decap_8
XFILLER_233_42 VPWR VGND sg13cmos5l_decap_8
X_1368_ _1368_/Q Tile_X0Y1_FrameData[1] VGND VPWR Tile_X0Y9_FrameStrobe[5] latch
X_4156_ _4156_/X Tile_X0Y3_W2END[7] AXI_M_SOC_BVALID _4205_/X _4204_/X _1829_/Q _1828_/Q
+ VPWR VGND sg13cmos5l_mux4_1
XFILLER_55_202 VPWR VGND sg13cmos5l_fill_2
XFILLER_233_75 VPWR VGND sg13cmos5l_fill_2
XFILLER_255_152 VPWR VGND sg13cmos5l_fill_1
X_0319_ _0319_/Q Tile_X0Y7_FrameData[0] VGND VPWR Tile_X0Y9_FrameStrobe[4] latch
X_3107_ Tile_X0Y7_E6BEG[5] _4649_/X VPWR VGND sg13cmos5l_buf_1
X_1299_ _1299_/Q Tile_X0Y1_FrameData[6] VGND VPWR Tile_X0Y9_FrameStrobe[3] latch
X_4087_ _4087_/X _4095_/X Tile_X0Y2_W6END[3] _4094_/X _4087_/A3 _1427_/Q _1674_/Q
+ VPWR VGND sg13cmos5l_mux4_1
XFILLER_270_100 VPWR VGND sg13cmos5l_fill_1
XFILLER_255_174 VPWR VGND sg13cmos5l_fill_1
XFILLER_270_122 VPWR VGND sg13cmos5l_decap_8
X_3038_ Tile_X0Y5_EE4BEG[13] _4401_/X VPWR VGND sg13cmos5l_buf_1
XFILLER_102_35 VPWR VGND sg13cmos5l_decap_8
XFILLER_62_17 VPWR VGND sg13cmos5l_decap_4
XFILLER_558_131 VPWR VGND sg13cmos5l_fill_1
XFILLER_459_49 VPWR VGND sg13cmos5l_decap_8
XFILLER_23_154 VPWR VGND sg13cmos5l_decap_8
XFILLER_573_112 VPWR VGND sg13cmos5l_decap_8
XFILLER_178_39 VPWR VGND sg13cmos5l_decap_8
XANTENNA__3567__X Tile_X0Y9_EE4BEG[13] VPWR VGND sg13cmos5l_antennanp
XFILLER_134_7 VPWR VGND sg13cmos5l_decap_8
XFILLER_183_118 VPWR VGND sg13cmos5l_decap_4
XFILLER_258_72 VPWR VGND sg13cmos5l_fill_1
XFILLER_109_215 VPWR VGND sg13cmos5l_fill_2
XFILLER_573_189 VPWR VGND sg13cmos5l_decap_8
XFILLER_258_94 VPWR VGND sg13cmos5l_decap_8
XFILLER_301_7 VPWR VGND sg13cmos5l_decap_8
XFILLER_11_21 VPWR VGND sg13cmos5l_decap_8
XFILLER_408_42 VPWR VGND sg13cmos5l_decap_8
XFILLER_325_145 VPWR VGND sg13cmos5l_fill_2
XFILLER_194_49 VPWR VGND sg13cmos5l_decap_8
XFILLER_555_70 VPWR VGND sg13cmos5l_decap_8
XFILLER_127_21 VPWR VGND sg13cmos5l_decap_8
XFILLER_491_14 VPWR VGND sg13cmos5l_decap_8
XFILLER_340_115 VPWR VGND sg13cmos5l_decap_8
XFILLER_486_119 VPWR VGND sg13cmos5l_fill_2
XFILLER_87_14 VPWR VGND sg13cmos5l_decap_8
XFILLER_479_193 VPWR VGND sg13cmos5l_decap_8
XFILLER_705_84 VPWR VGND sg13cmos5l_decap_8
XFILLER_670_7 VPWR VGND sg13cmos5l_decap_8
XFILLER_641_28 VPWR VGND sg13cmos5l_decap_8
XFILLER_424_63 VPWR VGND sg13cmos5l_decap_8
XFILLER_293_214 VPWR VGND sg13cmos5l_decap_4
XFILLER_643_105 VPWR VGND sg13cmos5l_decap_8
XFILLER_571_91 VPWR VGND sg13cmos5l_decap_8
XFILLER_494_185 VPWR VGND sg13cmos5l_decap_4
XFILLER_143_42 VPWR VGND sg13cmos5l_decap_8
XFILLER_290_70 VPWR VGND sg13cmos5l_decap_8
XFILLER_636_190 VPWR VGND sg13cmos5l_fill_1
XFILLER_246_141 VPWR VGND sg13cmos5l_decap_8
XFILLER_246_185 VPWR VGND sg13cmos5l_decap_8
XFILLER_651_182 VPWR VGND sg13cmos5l_decap_8
XFILLER_596_215 VPWR VGND sg13cmos5l_fill_2
XFILLER_261_133 VPWR VGND sg13cmos5l_decap_8
XFILLER_160_0 VPWR VGND sg13cmos5l_fill_2
XFILLER_258_0 VPWR VGND sg13cmos5l_decap_8
XFILLER_14_110 VPWR VGND sg13cmos5l_decap_8
XFILLER_410_108 VPWR VGND sg13cmos5l_decap_8
XFILLER_369_49 VPWR VGND sg13cmos5l_decap_8
XFILLER_14_132 VPWR VGND sg13cmos5l_decap_4
XFILLER_666_14 VPWR VGND sg13cmos5l_decap_8
XFILLER_403_193 VPWR VGND sg13cmos5l_decap_8
XFILLER_564_112 VPWR VGND sg13cmos5l_decap_8
XFILLER_425_0 VPWR VGND sg13cmos5l_decap_8
XANTENNA__3477__X Tile_X0Y1_EE4BEG[3] VPWR VGND sg13cmos5l_antennanp
XFILLER_564_145 VPWR VGND sg13cmos5l_decap_8
XFILLER_52_72 VPWR VGND sg13cmos5l_decap_8
XFILLER_168_61 VPWR VGND sg13cmos5l_decap_8
X_0670_ _0670_/Q Tile_X0Y8_FrameData[1] VGND VPWR Tile_X0Y9_FrameStrobe[7] latch
XFILLER_316_156 VPWR VGND sg13cmos5l_decap_8
XFILLER_182_151 VPWR VGND sg13cmos5l_decap_4
XFILLER_682_35 VPWR VGND sg13cmos5l_decap_8
XFILLER_316_167 VPWR VGND sg13cmos5l_fill_2
XFILLER_465_81 VPWR VGND sg13cmos5l_decap_4
X_2340_ _2340_/Q Tile_X0Y5_FrameData[1] VGND VPWR Tile_X0Y9_FrameStrobe[4] latch
XFILLER_184_93 VPWR VGND sg13cmos5l_decap_4
XFILLER_615_84 VPWR VGND sg13cmos5l_decap_4
XFILLER_619_146 VPWR VGND sg13cmos5l_decap_8
XFILLER_96_124 VPWR VGND sg13cmos5l_decap_8
XFILLER_229_108 VPWR VGND sg13cmos5l_decap_8
XFILLER_96_135 VPWR VGND sg13cmos5l_fill_1
X_2271_ _2271_/Q Tile_X0Y5_FrameData[6] VGND VPWR Tile_X0Y9_FrameStrobe[2] latch
XFILLER_551_28 VPWR VGND sg13cmos5l_decap_8
XFILLER_334_63 VPWR VGND sg13cmos5l_fill_2
XFILLER_634_105 VPWR VGND sg13cmos5l_decap_8
XFILLER_96_157 VPWR VGND sg13cmos5l_decap_8
XFILLER_77_80 VPWR VGND sg13cmos5l_decap_8
X_1222_ _1222_/Q Tile_X0Y1_FrameData[19] VGND VPWR Tile_X0Y9_FrameStrobe[1] latch
X_4010_ _4010_/X _3985_/X _0095_/X _3984_/X Tile_X0Y0_S4END[6] _1229_/Q _1228_/Q VPWR
+ VGND sg13cmos5l_mux4_1
X_1153_ _1153_/Q Tile_X0Y0_FrameData[10] VGND VPWR Tile_X0Y9_FrameStrobe[6] latch
XFILLER_441_211 VPWR VGND sg13cmos5l_decap_8
XFILLER_203_56 VPWR VGND sg13cmos5l_decap_8
X_0104_ _3190_/A _3796_/X _3797_/X _1145_/Q VPWR VGND sg13cmos5l_mux2_1
XFILLER_642_182 VPWR VGND sg13cmos5l_decap_8
XFILLER_398_115 VPWR VGND sg13cmos5l_decap_8
X_1084_ _1084_/Q Tile_X0Y0_FrameData[15] VGND VPWR Tile_X0Y9_FrameStrobe[4] latch
XFILLER_350_84 VPWR VGND sg13cmos5l_decap_8
XFILLER_500_21 VPWR VGND sg13cmos5l_decap_8
XFILLER_398_148 VPWR VGND sg13cmos5l_decap_8
X_4912_ _4912_/X Tile_X0Y5_W1END[2] Tile_X0Y5_WW4END[14] Tile_X0Y5_W6END[6] _4453_/X
+ _2373_/Q _2372_/Q VPWR VGND sg13cmos5l_mux4_1
XFILLER_279_27 VPWR VGND sg13cmos5l_decap_8
XFILLER_339_204 VPWR VGND sg13cmos5l_decap_4
X_4843_ _4843_/X _4923_/X _4927_/X _4931_/X _4900_/X _0858_/Q _0857_/Q VPWR VGND sg13cmos5l_mux4_1
XFILLER_576_14 VPWR VGND sg13cmos5l_decap_8
XFILLER_500_98 VPWR VGND sg13cmos5l_decap_8
XFILLER_20_113 VPWR VGND sg13cmos5l_decap_8
XANTENNA__3387__X Tile_X0Y2_E6BEG[10] VPWR VGND sg13cmos5l_antennanp
XFILLER_20_135 VPWR VGND sg13cmos5l_decap_8
X_4774_ _4774_/X _4781_/X Tile_X0Y8_W6END[2] _4780_/X _4774_/A3 _0419_/Q _0418_/Q
+ VPWR VGND sg13cmos5l_mux4_1
X_1986_ _1986_/Q Tile_X0Y4_FrameData[3] VGND VPWR Tile_X0Y9_FrameStrobe[1] latch
XFILLER_165_118 VPWR VGND sg13cmos5l_fill_2
X_3725_ _3725_/X Tile_X0Y3_WW4END[2] Tile_X0Y3_WW4END[10] Tile_X0Y3_W6END[10] _4232_/X
+ _1737_/Q _1736_/Q VPWR VGND sg13cmos5l_mux4_1
X_0937_ _0937_/Q Tile_X0Y9_FrameData[28] VGND VPWR Tile_X0Y9_FrameStrobe[8] latch
XFILLER_570_126 VPWR VGND sg13cmos5l_decap_8
XFILLER_509_63 VPWR VGND sg13cmos5l_decap_8
XFILLER_656_91 VPWR VGND sg13cmos5l_decap_8
X_3656_ AXI_M_SOC_AWADDR17 Tile_X0Y4_WW4END[1] Tile_X0Y4_WW4END[9] Tile_X0Y4_W6END[1]
+ _4337_/X _2011_/Q _2010_/Q VPWR VGND sg13cmos5l_mux4_1
X_0868_ _0868_/Q Tile_X0Y9_FrameData[27] VGND VPWR Tile_X0Y9_FrameStrobe[6] latch
XFILLER_592_35 VPWR VGND sg13cmos5l_decap_8
X_2607_ _2607_/Q Tile_X0Y6_FrameData[24] VGND VPWR Tile_X0Y9_FrameStrobe[5] latch
XFILLER_511_215 VPWR VGND sg13cmos5l_fill_2
XFILLER_173_195 VPWR VGND sg13cmos5l_decap_8
XFILLER_712_175 VPWR VGND sg13cmos5l_decap_8
X_3587_ Tile_X0Y9_FrameData_O[17] Tile_X0Y9_FrameData[17] VPWR VGND sg13cmos5l_buf_1
X_0799_ _0799_/Q Tile_X0Y9_FrameData[0] VGND VPWR Tile_X0Y9_FrameStrobe[3] latch
X_2538_ _2538_/Q Tile_X0Y6_FrameData[29] VGND VPWR Tile_X0Y9_FrameStrobe[3] latch
XFILLER_87_102 VPWR VGND sg13cmos5l_decap_8
XFILLER_461_28 VPWR VGND sg13cmos5l_decap_8
XFILLER_275_203 VPWR VGND sg13cmos5l_fill_1
XFILLER_244_63 VPWR VGND sg13cmos5l_decap_8
X_2469_ _2469_/Q Tile_X0Y6_FrameData[2] VGND VPWR Tile_X0Y9_FrameStrobe[0] latch
XFILLER_57_28 VPWR VGND sg13cmos5l_fill_1
X_4208_ _4208_/X _4139_/X _4247_/X _4246_/X _4138_/X _1687_/Q _1686_/Q VPWR VGND sg13cmos5l_mux4_1
XFILLER_491_133 VPWR VGND sg13cmos5l_decap_8
XFILLER_290_217 VPWR VGND sg13cmos5l_fill_1
XFILLER_228_163 VPWR VGND sg13cmos5l_decap_8
X_4139_ _4139_/X Tile_X0Y4_W2MID[2] Tile_X0Y4_W2END[2] Tile_X0Y4_W6END[2] _4316_/X
+ _2163_/Q _2162_/Q VPWR VGND sg13cmos5l_mux4_1
XFILLER_541_83 VPWR VGND sg13cmos5l_decap_8
XFILLER_640_119 VPWR VGND sg13cmos5l_decap_8
XFILLER_541_94 VPWR VGND sg13cmos5l_fill_2
XFILLER_113_67 VPWR VGND sg13cmos5l_decap_8
XFILLER_43_205 VPWR VGND sg13cmos5l_fill_1
XFILLER_410_21 VPWR VGND sg13cmos5l_decap_8
XFILLER_189_49 VPWR VGND sg13cmos5l_decap_8
XFILLER_349_7 VPWR VGND sg13cmos5l_decap_8
XFILLER_196_210 VPWR VGND sg13cmos5l_fill_1
XFILLER_546_112 VPWR VGND sg13cmos5l_fill_2
XFILLER_486_14 VPWR VGND sg13cmos5l_decap_8
XANTENNA__3297__X Tile_X0Y0_E2BEGb[5] VPWR VGND sg13cmos5l_antennanp
XFILLER_516_7 VPWR VGND sg13cmos5l_decap_8
XFILLER_11_146 VPWR VGND sg13cmos5l_fill_1
XFILLER_400_174 VPWR VGND sg13cmos5l_decap_8
XFILLER_11_179 VPWR VGND sg13cmos5l_fill_1
XFILLER_636_28 VPWR VGND sg13cmos5l_decap_8
XFILLER_419_63 VPWR VGND sg13cmos5l_decap_8
XFILLER_22_42 VPWR VGND sg13cmos5l_decap_8
XFILLER_566_91 VPWR VGND sg13cmos5l_decap_8
XFILLER_138_42 VPWR VGND sg13cmos5l_decap_8
XFILLER_285_70 VPWR VGND sg13cmos5l_decap_8
XFILLER_716_50 VPWR VGND sg13cmos5l_decap_8
XFILLER_98_35 VPWR VGND sg13cmos5l_decap_8
XFILLER_703_164 VPWR VGND sg13cmos5l_decap_4
XFILLER_459_108 VPWR VGND sg13cmos5l_decap_8
XFILLER_313_159 VPWR VGND sg13cmos5l_decap_8
XFILLER_0_2 VPWR VGND sg13cmos5l_fill_1
XFILLER_652_49 VPWR VGND sg13cmos5l_decap_8
XFILLER_467_130 VPWR VGND sg13cmos5l_decap_8
XFILLER_435_84 VPWR VGND sg13cmos5l_decap_8
XFILLER_467_141 VPWR VGND sg13cmos5l_fill_2
XFILLER_371_28 VPWR VGND sg13cmos5l_decap_8
XFILLER_482_100 VPWR VGND sg13cmos5l_decap_8
XFILLER_616_116 VPWR VGND sg13cmos5l_decap_8
XFILLER_482_111 VPWR VGND sg13cmos5l_fill_2
XFILLER_78_179 VPWR VGND sg13cmos5l_decap_4
XFILLER_93_105 VPWR VGND sg13cmos5l_decap_8
XFILLER_375_0 VPWR VGND sg13cmos5l_decap_8
XFILLER_281_217 VPWR VGND sg13cmos5l_fill_1
XFILLER_86_190 VPWR VGND sg13cmos5l_fill_2
XFILLER_631_119 VPWR VGND sg13cmos5l_decap_8
XFILLER_601_42 VPWR VGND sg13cmos5l_decap_8
XFILLER_601_53 VPWR VGND sg13cmos5l_fill_2
XFILLER_320_21 VPWR VGND sg13cmos5l_decap_8
XFILLER_542_0 VPWR VGND sg13cmos5l_decap_8
XFILLER_234_199 VPWR VGND sg13cmos5l_decap_8
XFILLER_677_35 VPWR VGND sg13cmos5l_decap_8
XFILLER_63_60 VPWR VGND sg13cmos5l_decap_8
XFILLER_396_14 VPWR VGND sg13cmos5l_decap_8
XFILLER_320_98 VPWR VGND sg13cmos5l_decap_8
XFILLER_97_7 VPWR VGND sg13cmos5l_decap_8
XFILLER_537_145 VPWR VGND sg13cmos5l_fill_2
X_1840_ _1840_/Q Tile_X0Y3_FrameData[25] VGND VPWR Tile_X0Y9_FrameStrobe[5] latch
XFILLER_179_93 VPWR VGND sg13cmos5l_decap_4
XANTENNA__3000__X Tile_X0Y5_E2BEG[3] VPWR VGND sg13cmos5l_antennanp
XFILLER_537_178 VPWR VGND sg13cmos5l_decap_8
XFILLER_546_28 VPWR VGND sg13cmos5l_decap_8
XFILLER_8_77 VPWR VGND sg13cmos5l_decap_8
X_1771_ _1771_/Q Tile_X0Y3_FrameData[30] VGND VPWR Tile_X0Y9_FrameStrobe[3] latch
XFILLER_698_119 VPWR VGND sg13cmos5l_decap_4
XFILLER_8_99 VPWR VGND sg13cmos5l_fill_2
XFILLER_693_56 VPWR VGND sg13cmos5l_decap_8
X_3510_ Tile_X0Y1_E2BEG[0] _3932_/X VPWR VGND sg13cmos5l_buf_1
X_0722_ _0722_/Q Tile_X0Y9_FrameData[13] VGND VPWR Tile_X0Y9_FrameStrobe[1] latch
X_4490_ _4490_/X Tile_X0Y6_W1END[3] Tile_X0Y6_WW4END[15] Tile_X0Y6_W6END[7] _4571_/X
+ _2626_/Q _2625_/Q VPWR VGND sg13cmos5l_mux4_1
XFILLER_155_162 VPWR VGND sg13cmos5l_decap_8
XFILLER_195_70 VPWR VGND sg13cmos5l_decap_8
X_3441_ Tile_X0Y1_UserCLKo Tile_X0Y1_UserCLK VPWR VGND sg13cmos5l_buf_1
X_0653_ _0653_/Q Tile_X0Y8_FrameData[18] VGND VPWR Tile_X0Y9_FrameStrobe[7] latch
X_0584_ _0584_/Q Tile_X0Y8_FrameData[23] VGND VPWR Tile_X0Y9_FrameStrobe[5] latch
X_3372_ Tile_X0Y2_EE4BEG[11] _4067_/X VPWR VGND sg13cmos5l_buf_1
XFILLER_562_49 VPWR VGND sg13cmos5l_decap_8
XFILLER_69_102 VPWR VGND sg13cmos5l_decap_8
XFILLER_345_84 VPWR VGND sg13cmos5l_decap_8
XFILLER_458_152 VPWR VGND sg13cmos5l_decap_8
X_2323_ _2323_/Q Tile_X0Y5_FrameData[18] VGND VPWR Tile_X0Y9_FrameStrobe[4] latch
XFILLER_281_28 VPWR VGND sg13cmos5l_decap_8
XANTENNA__3670__X AXI_M_SOC_AWADDR31 VPWR VGND sg13cmos5l_antennanp
XFILLER_69_157 VPWR VGND sg13cmos5l_decap_8
XFILLER_458_196 VPWR VGND sg13cmos5l_fill_1
X_2254_ _2254_/Q Tile_X0Y5_FrameData[23] VGND VPWR Tile_X0Y9_FrameStrobe[2] latch
XFILLER_19_0 VPWR VGND sg13cmos5l_decap_8
X_1205_ _1205_/Q Tile_X0Y1_FrameData[4] VGND VPWR Tile_X0Y9_FrameStrobe[0] latch
XFILLER_361_83 VPWR VGND sg13cmos5l_decap_8
XFILLER_214_77 VPWR VGND sg13cmos5l_decap_8
X_2185_ _2185_/Q Tile_X0Y5_FrameData[28] VGND VPWR Tile_X0Y9_FrameStrobe[0] latch
XFILLER_511_42 VPWR VGND sg13cmos5l_decap_8
XFILLER_25_205 VPWR VGND sg13cmos5l_decap_4
X_1136_ _1136_/Q Tile_X0Y0_FrameData[27] VGND VPWR Tile_X0Y9_FrameStrobe[6] latch
XFILLER_92_182 VPWR VGND sg13cmos5l_decap_8
XFILLER_230_21 VPWR VGND sg13cmos5l_decap_8
X_1067_ _1067_/Q Tile_X0Y0_FrameData[0] VGND VPWR Tile_X0Y9_FrameStrobe[3] latch
XFILLER_225_199 VPWR VGND sg13cmos5l_fill_2
XFILLER_587_35 VPWR VGND sg13cmos5l_decap_8
XFILLER_528_123 VPWR VGND sg13cmos5l_decap_8
X_4826_ _4826_/X Tile_X0Y9_W1END[2] Tile_X0Y9_W6END[10] _4930_/X _4894_/X _0887_/Q
+ _0886_/Q VPWR VGND sg13cmos5l_mux4_1
XFILLER_394_162 VPWR VGND sg13cmos5l_decap_8
XFILLER_394_173 VPWR VGND sg13cmos5l_fill_1
XFILLER_456_28 VPWR VGND sg13cmos5l_decap_8
X_4757_ _4757_/X Tile_X0Y8_WW4END[2] AXI_M_SOC_RDATA10 _4802_/X _4789_/X _0533_/Q
+ _0532_/Q VPWR VGND sg13cmos5l_mux4_1
XFILLER_239_63 VPWR VGND sg13cmos5l_decap_8
X_1969_ _1969_/Q Tile_X0Y4_FrameData[20] VGND VPWR Tile_X0Y9_FrameStrobe[1] latch
X_3708_ AXI_M_SOC_WDATA18 Tile_X0Y6_WW4END[2] Tile_X0Y6_WW4END[10] Tile_X0Y6_W6END[2]
+ _4570_/X _2523_/Q _2522_/Q VPWR VGND sg13cmos5l_mux4_1
XFILLER_146_151 VPWR VGND sg13cmos5l_decap_8
X_4688_ _4688_/X _4661_/X Tile_X0Y9_N4END[8] _4660_/X _0056_/X _0207_/Q _0206_/Q VPWR
+ VGND sg13cmos5l_mux4_1
X_3639_ AXI_M_SOC_AWADDR0 Tile_X0Y5_WW4END[0] Tile_X0Y5_WW4END[8] Tile_X0Y5_W6END[0]
+ _4451_/X _2271_/Q _2270_/Q VPWR VGND sg13cmos5l_mux4_1
XFILLER_697_185 VPWR VGND sg13cmos5l_fill_1
XFILLER_108_56 VPWR VGND sg13cmos5l_decap_4
XFILLER_472_49 VPWR VGND sg13cmos5l_fill_2
XFILLER_405_21 VPWR VGND sg13cmos5l_decap_8
XFILLER_405_54 VPWR VGND sg13cmos5l_decap_8
XANTENNA__3580__X Tile_X0Y9_FrameData_O[10] VPWR VGND sg13cmos5l_antennanp
XFILLER_299_7 VPWR VGND sg13cmos5l_decap_8
XFILLER_405_76 VPWR VGND sg13cmos5l_decap_8
XFILLER_263_217 VPWR VGND sg13cmos5l_fill_1
XFILLER_124_77 VPWR VGND sg13cmos5l_decap_8
XFILLER_702_63 VPWR VGND sg13cmos5l_decap_8
XFILLER_68_190 VPWR VGND sg13cmos5l_decap_8
XFILLER_466_7 VPWR VGND sg13cmos5l_decap_8
XFILLER_421_42 VPWR VGND sg13cmos5l_decap_8
XFILLER_216_133 VPWR VGND sg13cmos5l_decap_8
XFILLER_17_42 VPWR VGND sg13cmos5l_decap_8
XFILLER_140_21 VPWR VGND sg13cmos5l_decap_8
XFILLER_621_141 VPWR VGND sg13cmos5l_fill_1
XFILLER_231_103 VPWR VGND sg13cmos5l_decap_8
XFILLER_633_7 VPWR VGND sg13cmos5l_decap_8
XANTENNA__2924__X Tile_X0Y8_E2BEGb[0] VPWR VGND sg13cmos5l_antennanp
XFILLER_621_163 VPWR VGND sg13cmos5l_fill_1
XFILLER_231_114 VPWR VGND sg13cmos5l_fill_2
XFILLER_497_35 VPWR VGND sg13cmos5l_decap_8
XFILLER_377_118 VPWR VGND sg13cmos5l_decap_8
XFILLER_140_98 VPWR VGND sg13cmos5l_decap_8
XFILLER_647_49 VPWR VGND sg13cmos5l_decap_8
XFILLER_149_41 VPWR VGND sg13cmos5l_decap_8
XFILLER_385_195 VPWR VGND sg13cmos5l_decap_8
XFILLER_366_28 VPWR VGND sg13cmos5l_decap_8
XFILLER_534_137 VPWR VGND sg13cmos5l_decap_8
XFILLER_123_0 VPWR VGND sg13cmos5l_decap_8
XANTENNA__3755__X AXI_M_SOC_ARADDR27 VPWR VGND sg13cmos5l_antennanp
XFILLER_137_173 VPWR VGND sg13cmos5l_decap_8
XFILLER_446_72 VPWR VGND sg13cmos5l_decap_8
XFILLER_341_210 VPWR VGND sg13cmos5l_fill_2
XFILLER_3_142 VPWR VGND sg13cmos5l_decap_8
XFILLER_3_175 VPWR VGND sg13cmos5l_fill_2
XFILLER_152_187 VPWR VGND sg13cmos5l_fill_1
XFILLER_492_0 VPWR VGND sg13cmos5l_decap_8
XFILLER_315_21 VPWR VGND sg13cmos5l_decap_8
XANTENNA__3490__X Tile_X0Y1_E6BEG[0] VPWR VGND sg13cmos5l_antennanp
XFILLER_66_105 VPWR VGND sg13cmos5l_decap_8
XFILLER_455_133 VPWR VGND sg13cmos5l_fill_2
XFILLER_181_50 VPWR VGND sg13cmos5l_decap_8
XFILLER_58_82 VPWR VGND sg13cmos5l_decap_8
XFILLER_12_7 VPWR VGND sg13cmos5l_decap_8
XFILLER_612_63 VPWR VGND sg13cmos5l_decap_8
XFILLER_470_114 VPWR VGND sg13cmos5l_decap_8
XFILLER_207_111 VPWR VGND sg13cmos5l_decap_4
XFILLER_331_42 VPWR VGND sg13cmos5l_decap_8
XFILLER_207_166 VPWR VGND sg13cmos5l_decap_4
XFILLER_74_193 VPWR VGND sg13cmos5l_fill_1
XANTENNA__2834__X Tile_X0Y6_E1BEG[3] VPWR VGND sg13cmos5l_antennanp
X_3990_ _3990_/X _3900_/X _4033_/X _4032_/X Tile_X0Y0_S2MID[6] _1189_/Q _1188_/Q VPWR
+ VGND sg13cmos5l_mux4_1
XFILLER_557_207 VPWR VGND sg13cmos5l_fill_1
X_2941_ Tile_X0Y8_E6BEG[9] _4769_/X VPWR VGND sg13cmos5l_buf_1
XFILLER_200_35 VPWR VGND sg13cmos5l_decap_8
X_2872_ Tile_X0Y6_EE4BEG[9] _4521_/X VPWR VGND sg13cmos5l_buf_1
XFILLER_557_49 VPWR VGND sg13cmos5l_decap_8
XFILLER_175_213 VPWR VGND sg13cmos5l_decap_4
X_4611_ _4611_/X _4667_/X _4666_/X AXI_M_SOC_RDATA16 AXI_M_SOC_RDATA20 _0337_/Q _0336_/Q
+ VPWR VGND sg13cmos5l_mux4_1
XFILLER_376_184 VPWR VGND sg13cmos5l_decap_8
X_1823_ _1823_/Q Tile_X0Y3_FrameData[10] VGND VPWR Tile_X0Y9_FrameStrobe[4] latch
XFILLER_276_28 VPWR VGND sg13cmos5l_decap_8
XANTENNA__3665__X AXI_M_SOC_AWADDR26 VPWR VGND sg13cmos5l_antennanp
XFILLER_391_143 VPWR VGND sg13cmos5l_decap_8
X_4542_ _4542_/X _4549_/X Tile_X0Y6_W6END[2] _4548_/X _4542_/A3 _2443_/Q _2442_/Q
+ VPWR VGND sg13cmos5l_mux4_1
X_1754_ _1754_/Q Tile_X0Y3_FrameData[15] VGND VPWR Tile_X0Y9_FrameStrobe[2] latch
XFILLER_128_162 VPWR VGND sg13cmos5l_decap_8
XFILLER_391_187 VPWR VGND sg13cmos5l_fill_1
XFILLER_143_110 VPWR VGND sg13cmos5l_decap_8
X_0705_ _0705_/Q Tile_X0Y9_FrameData[30] VGND VPWR Tile_X0Y9_FrameStrobe[1] latch
XFILLER_209_77 VPWR VGND sg13cmos5l_decap_8
X_4473_ _4473_/X Tile_X0Y7_W2MID[5] Tile_X0Y7_W2END[5] Tile_X0Y7_W6END[5] _4673_/X
+ _0403_/Q _0402_/Q VPWR VGND sg13cmos5l_mux4_1
X_1685_ _1685_/Q Tile_X0Y3_FrameData[20] VGND VPWR Tile_X0Y9_FrameStrobe[0] latch
XFILLER_506_42 VPWR VGND sg13cmos5l_decap_8
X_3424_ Tile_X0Y4_FrameData_O[15] Tile_X0Y4_FrameData[15] VPWR VGND sg13cmos5l_buf_1
X_0636_ _0636_/Q Tile_X0Y8_FrameData[3] VGND VPWR Tile_X0Y9_FrameStrobe[6] latch
XFILLER_292_49 VPWR VGND sg13cmos5l_decap_8
XFILLER_653_70 VPWR VGND sg13cmos5l_decap_8
XFILLER_143_187 VPWR VGND sg13cmos5l_decap_8
XFILLER_143_198 VPWR VGND sg13cmos5l_fill_2
XFILLER_506_86 VPWR VGND sg13cmos5l_fill_1
X_3355_ Tile_X0Y2_FrameData_O[26] Tile_X0Y2_FrameData[26] VPWR VGND sg13cmos5l_buf_1
X_0567_ _0567_/Q Tile_X0Y8_FrameData[8] VGND VPWR Tile_X0Y9_FrameStrobe[4] latch
X_2306_ _2306_/Q Tile_X0Y5_FrameData[3] VGND VPWR Tile_X0Y9_FrameStrobe[3] latch
XFILLER_57_116 VPWR VGND sg13cmos5l_decap_8
X_3286_ Tile_X0Y0_E6BEG[6] _3842_/X VPWR VGND sg13cmos5l_buf_1
X_0498_ _0498_/Q Tile_X0Y8_FrameData[13] VGND VPWR Tile_X0Y9_FrameStrobe[2] latch
XFILLER_446_155 VPWR VGND sg13cmos5l_decap_8
XFILLER_300_173 VPWR VGND sg13cmos5l_decap_8
XFILLER_446_166 VPWR VGND sg13cmos5l_fill_2
XFILLER_245_217 VPWR VGND sg13cmos5l_fill_1
X_2237_ _2237_/Q Tile_X0Y5_FrameData[8] VGND VPWR Tile_X0Y9_FrameStrobe[1] latch
XFILLER_650_203 VPWR VGND sg13cmos5l_decap_8
XFILLER_522_63 VPWR VGND sg13cmos5l_decap_8
XFILLER_241_42 VPWR VGND sg13cmos5l_decap_8
X_2168_ _2168_/Q Tile_X0Y4_FrameData[13] VGND VPWR Tile_X0Y9_FrameStrobe[7] latch
XFILLER_241_64 VPWR VGND sg13cmos5l_decap_8
XFILLER_598_56 VPWR VGND sg13cmos5l_decap_8
XANTENNA__2744__X Tile_X0Y3_FrameData_O[2] VPWR VGND sg13cmos5l_antennanp
X_1119_ _1119_/Q Tile_X0Y0_FrameData[12] VGND VPWR Tile_X0Y9_FrameStrobe[5] latch
X_2099_ _2099_/Q Tile_X0Y4_FrameData[18] VGND VPWR Tile_X0Y9_FrameStrobe[5] latch
XFILLER_213_147 VPWR VGND sg13cmos5l_decap_8
XFILLER_110_68 VPWR VGND sg13cmos5l_decap_8
XFILLER_70_28 VPWR VGND sg13cmos5l_decap_8
XFILLER_467_49 VPWR VGND sg13cmos5l_decap_8
X_4809_ _4809_/X _4779_/X Tile_X0Y9_N4END[5] _4778_/X _0076_/X _0453_/Q _0452_/Q VPWR
+ VGND sg13cmos5l_mux4_1
XFILLER_367_195 VPWR VGND sg13cmos5l_decap_8
XFILLER_186_28 VPWR VGND sg13cmos5l_decap_8
XFILLER_382_143 VPWR VGND sg13cmos5l_decap_8
XANTENNA__3575__X Tile_X0Y9_FrameData_O[5] VPWR VGND sg13cmos5l_antennanp
XFILLER_516_159 VPWR VGND sg13cmos5l_decap_8
XFILLER_214_7 VPWR VGND sg13cmos5l_decap_8
XFILLER_119_44 VPWR VGND sg13cmos5l_fill_1
XFILLER_469_203 VPWR VGND sg13cmos5l_decap_4
XFILLER_207_6 VPWR VGND sg13cmos5l_decap_8
XFILLER_685_100 VPWR VGND sg13cmos5l_decap_4
XFILLER_119_88 VPWR VGND sg13cmos5l_decap_8
XFILLER_119_99 VPWR VGND sg13cmos5l_fill_2
XFILLER_416_42 VPWR VGND sg13cmos5l_decap_8
XFILLER_134_187 VPWR VGND sg13cmos5l_fill_1
XFILLER_563_70 VPWR VGND sg13cmos5l_decap_8
XFILLER_135_21 VPWR VGND sg13cmos5l_decap_8
XFILLER_484_217 VPWR VGND sg13cmos5l_fill_1
XFILLER_583_7 VPWR VGND sg13cmos5l_decap_8
XANTENNA__2919__X Tile_X0Y8_E2BEG[3] VPWR VGND sg13cmos5l_antennanp
XFILLER_685_188 VPWR VGND sg13cmos5l_fill_1
XFILLER_95_14 VPWR VGND sg13cmos5l_decap_8
XFILLER_626_200 VPWR VGND sg13cmos5l_fill_2
XFILLER_135_98 VPWR VGND sg13cmos5l_decap_8
XFILLER_0_178 VPWR VGND sg13cmos5l_decap_8
XFILLER_713_84 VPWR VGND sg13cmos5l_decap_8
XFILLER_437_155 VPWR VGND sg13cmos5l_decap_8
XFILLER_236_217 VPWR VGND sg13cmos5l_fill_1
XFILLER_432_63 VPWR VGND sg13cmos5l_decap_8
XFILLER_28_63 VPWR VGND sg13cmos5l_fill_1
XFILLER_151_42 VPWR VGND sg13cmos5l_fill_2
XFILLER_56_171 VPWR VGND sg13cmos5l_decap_4
XFILLER_301_56 VPWR VGND sg13cmos5l_decap_4
XFILLER_44_73 VPWR VGND sg13cmos5l_fill_1
XFILLER_240_0 VPWR VGND sg13cmos5l_decap_8
XFILLER_338_0 VPWR VGND sg13cmos5l_decap_8
XFILLER_44_95 VPWR VGND sg13cmos5l_fill_1
XFILLER_358_140 VPWR VGND sg13cmos5l_decap_8
XFILLER_377_49 VPWR VGND sg13cmos5l_decap_8
XFILLER_8_212 VPWR VGND sg13cmos5l_decap_4
XFILLER_674_14 VPWR VGND sg13cmos5l_decap_8
XFILLER_505_0 VPWR VGND sg13cmos5l_decap_8
XANTENNA__3485__X Tile_X0Y1_EE4BEG[11] VPWR VGND sg13cmos5l_antennanp
XFILLER_373_176 VPWR VGND sg13cmos5l_decap_8
XFILLER_314_210 VPWR VGND sg13cmos5l_fill_2
XFILLER_607_63 VPWR VGND sg13cmos5l_decap_8
XFILLER_515_192 VPWR VGND sg13cmos5l_decap_4
XFILLER_125_165 VPWR VGND sg13cmos5l_decap_8
XFILLER_5_56 VPWR VGND sg13cmos5l_decap_8
X_1470_ _1470_/Q Tile_X0Y2_FrameData[19] VGND VPWR Tile_X0Y9_FrameStrobe[1] latch
XFILLER_690_35 VPWR VGND sg13cmos5l_decap_8
X_0421_ _0421_/Q Tile_X0Y8_FrameData[26] VGND VPWR Tile_X0Y9_FrameStrobe[0] latch
XANTENNA__2829__X Tile_X0Y4_E2BEG[7] VPWR VGND sg13cmos5l_antennanp
XFILLER_69_81 VPWR VGND sg13cmos5l_decap_8
XFILLER_279_180 VPWR VGND sg13cmos5l_fill_2
X_3140_ Tile_X0Y7_FrameData_O[10] Tile_X0Y7_FrameData[10] VPWR VGND sg13cmos5l_buf_1
XFILLER_428_133 VPWR VGND sg13cmos5l_decap_8
X_0352_ _0352_/Q Tile_X0Y7_FrameData[31] VGND VPWR Tile_X0Y9_FrameStrobe[6] latch
XFILLER_94_211 VPWR VGND sg13cmos5l_decap_8
XFILLER_623_84 VPWR VGND sg13cmos5l_decap_8
XFILLER_227_206 VPWR VGND sg13cmos5l_decap_4
XFILLER_342_63 VPWR VGND sg13cmos5l_decap_8
X_0283_ _0283_/Q Tile_X0Y7_FrameData[4] VGND VPWR Tile_X0Y9_FrameStrobe[3] latch
X_3071_ Tile_X0Y5_FrameData_O[30] Tile_X0Y5_FrameData[30] VPWR VGND sg13cmos5l_buf_1
XFILLER_294_194 VPWR VGND sg13cmos5l_decap_8
X_2022_ _2022_/Q Tile_X0Y4_FrameData[31] VGND VPWR Tile_X0Y9_FrameStrobe[3] latch
XFILLER_589_129 VPWR VGND sg13cmos5l_decap_8
XFILLER_85_91 VPWR VGND sg13cmos5l_decap_8
XFILLER_699_77 VPWR VGND sg13cmos5l_decap_8
XFILLER_443_158 VPWR VGND sg13cmos5l_decap_8
XFILLER_62_163 VPWR VGND sg13cmos5l_decap_8
XFILLER_211_56 VPWR VGND sg13cmos5l_decap_8
XFILLER_600_122 VPWR VGND sg13cmos5l_fill_2
X_3973_ _3973_/X AXI_M_SOC_ARREADY _4010_/X _4014_/X _3992_/X _1263_/Q _1262_/Q VPWR
+ VGND sg13cmos5l_mux4_1
XFILLER_62_196 VPWR VGND sg13cmos5l_fill_1
X_2924_ Tile_X0Y8_E2BEGb[0] _4736_/X VPWR VGND sg13cmos5l_buf_1
XFILLER_287_49 VPWR VGND sg13cmos5l_decap_8
XFILLER_210_139 VPWR VGND sg13cmos5l_decap_8
XFILLER_148_213 VPWR VGND sg13cmos5l_decap_4
XFILLER_86_0 VPWR VGND sg13cmos5l_decap_8
XFILLER_648_70 VPWR VGND sg13cmos5l_decap_8
XFILLER_349_173 VPWR VGND sg13cmos5l_decap_8
XFILLER_203_191 VPWR VGND sg13cmos5l_decap_8
XFILLER_364_110 VPWR VGND sg13cmos5l_decap_8
X_2855_ Tile_X0Y6_E6BEG[4] _4532_/X VPWR VGND sg13cmos5l_buf_1
XFILLER_584_14 VPWR VGND sg13cmos5l_decap_8
XANTENNA__3395__X Tile_X0Y2_E2BEGb[6] VPWR VGND sg13cmos5l_antennanp
X_1806_ _1806_/Q Tile_X0Y3_FrameData[27] VGND VPWR Tile_X0Y9_FrameStrobe[4] latch
XFILLER_163_216 VPWR VGND sg13cmos5l_fill_2
X_2786_ Tile_X0Y3_EE4BEG[12] _4176_/X VPWR VGND sg13cmos5l_buf_1
XFILLER_364_187 VPWR VGND sg13cmos5l_decap_8
XFILLER_513_129 VPWR VGND sg13cmos5l_decap_8
X_4525_ _4525_/X Tile_X0Y6_WW4END[2] AXI_M_SOC_RDATA26 _4570_/X _4557_/X _2557_/Q
+ _2556_/Q VPWR VGND sg13cmos5l_mux4_1
X_1737_ _1737_/Q Tile_X0Y3_FrameData[0] VGND VPWR Tile_X0Y9_FrameStrobe[1] latch
XFILLER_517_63 VPWR VGND sg13cmos5l_decap_8
XFILLER_236_42 VPWR VGND sg13cmos5l_decap_4
X_4456_ _4456_/X _4421_/X _0159_/X _4420_/X _0145_/X _2227_/Q _2226_/Q VPWR VGND sg13cmos5l_mux4_1
XFILLER_667_133 VPWR VGND sg13cmos5l_fill_2
X_1668_ _1668_/Q Tile_X0Y2_FrameData[13] VGND VPWR Tile_X0Y9_FrameStrobe[7] latch
XFILLER_521_173 VPWR VGND sg13cmos5l_decap_8
XFILLER_49_29 VPWR VGND sg13cmos5l_decap_8
XFILLER_466_206 VPWR VGND sg13cmos5l_fill_2
X_3407_ Tile_X0Y2_E1BEG[2] _4038_/X VPWR VGND sg13cmos5l_buf_1
XFILLER_466_217 VPWR VGND sg13cmos5l_fill_1
XFILLER_236_97 VPWR VGND sg13cmos5l_decap_8
XANTENNA__2739__X Tile_X0Y4_E1BEG[2] VPWR VGND sg13cmos5l_antennanp
X_0619_ _0619_/Q Tile_X0Y8_FrameData[20] VGND VPWR Tile_X0Y9_FrameStrobe[6] latch
X_4387_ _4387_/X Tile_X0Y5_W2END[0] AXI_M_SOC_RVALID _4467_/X _4428_/X _2329_/Q _2328_/Q
+ VPWR VGND sg13cmos5l_mux4_1
X_1599_ _1599_/Q Tile_X0Y2_FrameData[18] VGND VPWR Tile_X0Y9_FrameStrobe[5] latch
XFILLER_419_133 VPWR VGND sg13cmos5l_decap_4
XFILLER_105_13 VPWR VGND sg13cmos5l_decap_8
X_3338_ Tile_X0Y2_FrameData_O[9] Tile_X0Y2_FrameData[9] VPWR VGND sg13cmos5l_buf_1
XFILLER_218_217 VPWR VGND sg13cmos5l_fill_1
X_3269_ Tile_X0Y0_EE4BEG[5] _3825_/X VPWR VGND sg13cmos5l_buf_1
XFILLER_164_7 VPWR VGND sg13cmos5l_decap_8
XFILLER_442_180 VPWR VGND sg13cmos5l_decap_8
XFILLER_121_56 VPWR VGND sg13cmos5l_decap_8
XFILLER_53_174 VPWR VGND sg13cmos5l_decap_4
XFILLER_331_7 VPWR VGND sg13cmos5l_decap_8
XFILLER_14_21 VPWR VGND sg13cmos5l_decap_8
XFILLER_429_7 VPWR VGND sg13cmos5l_decap_8
XFILLER_197_49 VPWR VGND sg13cmos5l_decap_8
XFILLER_558_92 VPWR VGND sg13cmos5l_decap_8
XFILLER_494_14 VPWR VGND sg13cmos5l_decap_8
XFILLER_355_154 VPWR VGND sg13cmos5l_decap_8
XFILLER_355_165 VPWR VGND sg13cmos5l_fill_1
XFILLER_154_216 VPWR VGND sg13cmos5l_fill_2
XFILLER_708_84 VPWR VGND sg13cmos5l_decap_8
XFILLER_644_28 VPWR VGND sg13cmos5l_decap_8
XFILLER_427_63 VPWR VGND sg13cmos5l_decap_8
XFILLER_30_42 VPWR VGND sg13cmos5l_decap_8
XFILLER_107_132 VPWR VGND sg13cmos5l_fill_1
XFILLER_574_80 VPWR VGND sg13cmos5l_decap_8
XFILLER_107_154 VPWR VGND sg13cmos5l_fill_2
XFILLER_146_42 VPWR VGND sg13cmos5l_decap_8
XFILLER_100_2 VPWR VGND sg13cmos5l_fill_1
XFILLER_512_162 VPWR VGND sg13cmos5l_decap_8
XFILLER_311_213 VPWR VGND sg13cmos5l_decap_4
XFILLER_293_70 VPWR VGND sg13cmos5l_decap_8
XFILLER_293_81 VPWR VGND sg13cmos5l_fill_1
XFILLER_76_200 VPWR VGND sg13cmos5l_decap_8
XFILLER_673_158 VPWR VGND sg13cmos5l_decap_4
XFILLER_660_49 VPWR VGND sg13cmos5l_decap_8
XFILLER_673_169 VPWR VGND sg13cmos5l_decap_4
XFILLER_276_150 VPWR VGND sg13cmos5l_fill_1
XFILLER_39_73 VPWR VGND sg13cmos5l_decap_8
XFILLER_190_0 VPWR VGND sg13cmos5l_decap_8
XFILLER_276_172 VPWR VGND sg13cmos5l_decap_8
XFILLER_288_0 VPWR VGND sg13cmos5l_fill_2
XFILLER_36_119 VPWR VGND sg13cmos5l_fill_1
XFILLER_425_147 VPWR VGND sg13cmos5l_decap_8
XFILLER_29_160 VPWR VGND sg13cmos5l_decap_8
XFILLER_291_153 VPWR VGND sg13cmos5l_fill_1
XFILLER_224_209 VPWR VGND sg13cmos5l_fill_2
XFILLER_669_14 VPWR VGND sg13cmos5l_decap_8
XFILLER_291_175 VPWR VGND sg13cmos5l_decap_8
XFILLER_669_36 VPWR VGND sg13cmos5l_decap_8
XFILLER_455_0 VPWR VGND sg13cmos5l_decap_8
XFILLER_579_151 VPWR VGND sg13cmos5l_fill_1
XFILLER_440_139 VPWR VGND sg13cmos5l_decap_8
XFILLER_312_99 VPWR VGND sg13cmos5l_decap_4
XFILLER_433_180 VPWR VGND sg13cmos5l_fill_1
XFILLER_44_185 VPWR VGND sg13cmos5l_decap_8
XFILLER_622_0 VPWR VGND sg13cmos5l_decap_8
X_0970_ _0970_/Q Tile_X0Y0_FrameData[1] VGND VPWR Tile_X0Y9_FrameStrobe[0] latch
XFILLER_685_35 VPWR VGND sg13cmos5l_decap_8
XFILLER_197_190 VPWR VGND sg13cmos5l_decap_8
XFILLER_200_172 VPWR VGND sg13cmos5l_decap_8
X_2640_ _2640_/Q Tile_X0Y6_FrameData[23] VGND VPWR Tile_X0Y9_FrameStrobe[6] latch
XFILLER_200_183 VPWR VGND sg13cmos5l_fill_1
XFILLER_346_176 VPWR VGND sg13cmos5l_fill_2
XFILLER_618_84 VPWR VGND sg13cmos5l_decap_8
XFILLER_554_28 VPWR VGND sg13cmos5l_decap_8
X_2571_ _2571_/Q Tile_X0Y6_FrameData[28] VGND VPWR Tile_X0Y9_FrameStrobe[4] latch
XFILLER_337_63 VPWR VGND sg13cmos5l_decap_8
XFILLER_361_157 VPWR VGND sg13cmos5l_decap_8
XFILLER_337_74 VPWR VGND sg13cmos5l_fill_2
XFILLER_58_4 VPWR VGND sg13cmos5l_fill_1
X_4310_ _4310_/X Tile_X0Y3_W1END[3] Tile_X0Y3_W6END[11] _4212_/X _4193_/X _1883_/Q
+ _1882_/Q VPWR VGND sg13cmos5l_mux4_1
X_1522_ _1522_/Q Tile_X0Y2_FrameData[31] VGND VPWR Tile_X0Y9_FrameStrobe[3] latch
XFILLER_649_133 VPWR VGND sg13cmos5l_decap_8
XFILLER_503_140 VPWR VGND sg13cmos5l_decap_8
XFILLER_113_102 VPWR VGND sg13cmos5l_decap_8
X_4241_ _4241_/X Tile_X0Y5_W2MID[5] Tile_X0Y5_W2END[5] Tile_X0Y5_W6END[5] _4432_/X
+ _2427_/Q _2426_/Q VPWR VGND sg13cmos5l_mux4_1
X_1453_ _1453_/Q Tile_X0Y2_FrameData[4] VGND VPWR Tile_X0Y9_FrameStrobe[0] latch
XFILLER_206_34 VPWR VGND sg13cmos5l_decap_8
X_0404_ _0404_/Q Tile_X0Y7_FrameData[11] VGND VPWR Tile_X0Y9_FrameStrobe[7] latch
X_4172_ _4172_/X Tile_X0Y3_WW4END[7] AXI_M_SOC_BVALID _4229_/X _4204_/X _1797_/Q _1796_/Q
+ VPWR VGND sg13cmos5l_mux4_1
XFILLER_570_49 VPWR VGND sg13cmos5l_decap_8
X_1384_ _1384_/Q Tile_X0Y1_FrameData[17] VGND VPWR Tile_X0Y9_FrameStrobe[6] latch
XFILLER_353_84 VPWR VGND sg13cmos5l_decap_8
XFILLER_503_21 VPWR VGND sg13cmos5l_decap_8
X_3123_ Tile_X0Y7_EE4BEG[9] _4637_/X VPWR VGND sg13cmos5l_buf_1
X_0335_ _0335_/Q Tile_X0Y7_FrameData[16] VGND VPWR Tile_X0Y9_FrameStrobe[5] latch
X_3054_ Tile_X0Y5_FrameData_O[13] Tile_X0Y5_FrameData[13] VPWR VGND sg13cmos5l_buf_1
X_0266_ _0266_/Q Tile_X0Y7_FrameData[21] VGND VPWR Tile_X0Y9_FrameStrobe[3] latch
XFILLER_579_14 VPWR VGND sg13cmos5l_decap_8
XFILLER_503_98 VPWR VGND sg13cmos5l_decap_8
XFILLER_215_209 VPWR VGND sg13cmos5l_fill_2
X_2005_ _2005_/Q Tile_X0Y4_FrameData[16] VGND VPWR Tile_X0Y9_FrameStrobe[2] latch
XFILLER_620_217 VPWR VGND sg13cmos5l_fill_1
XFILLER_222_77 VPWR VGND sg13cmos5l_decap_8
X_0197_ _0197_/Q Tile_X0Y7_FrameData[26] VGND VPWR Tile_X0Y9_FrameStrobe[1] latch
XFILLER_35_196 VPWR VGND sg13cmos5l_fill_1
XFILLER_195_116 VPWR VGND sg13cmos5l_decap_8
X_3956_ _3956_/X Tile_X0Y1_WW4END[7] AXI_M_SOC_ARREADY _4015_/X _3988_/X _1297_/Q
+ _1296_/Q VPWR VGND sg13cmos5l_mux4_1
XFILLER_595_35 VPWR VGND sg13cmos5l_decap_8
XFILLER_50_166 VPWR VGND sg13cmos5l_decap_8
XFILLER_378_70 VPWR VGND sg13cmos5l_decap_8
X_2907_ Tile_X0Y6_FrameData_O[28] Tile_X0Y6_FrameData[28] VPWR VGND sg13cmos5l_buf_1
XFILLER_50_199 VPWR VGND sg13cmos5l_decap_8
X_3887_ _3887_/X _3850_/X _0085_/X Tile_X0Y0_S1END[2] Tile_X0Y0_S4END[2] _0983_/Q
+ _0982_/Q VPWR VGND sg13cmos5l_mux4_1
X_2838_ Tile_X0Y6_E2BEG[3] _4499_/X VPWR VGND sg13cmos5l_buf_1
XFILLER_528_95 VPWR VGND sg13cmos5l_decap_8
XFILLER_464_28 VPWR VGND sg13cmos5l_decap_8
XFILLER_247_63 VPWR VGND sg13cmos5l_decap_8
X_2769_ Tile_X0Y3_FrameData_O[27] Tile_X0Y3_FrameData[27] VPWR VGND sg13cmos5l_buf_1
XFILLER_394_80 VPWR VGND sg13cmos5l_decap_8
X_4508_ _4508_/X Tile_X0Y6_W2END[3] AXI_M_SOC_RDATA27 _4559_/X _4558_/X _2591_/Q _2590_/Q
+ VPWR VGND sg13cmos5l_mux4_1
XFILLER_2_207 VPWR VGND sg13cmos5l_decap_8
XFILLER_439_217 VPWR VGND sg13cmos5l_fill_1
X_4439_ _4439_/X Tile_X0Y1_W1END[1] Tile_X0Y1_WW4END[13] Tile_X0Y1_W6END[5] _4009_/X
+ _1362_/Q _1361_/Q VPWR VGND sg13cmos5l_mux4_1
XFILLER_116_34 VPWR VGND sg13cmos5l_decap_8
XFILLER_480_49 VPWR VGND sg13cmos5l_decap_8
XFILLER_413_21 VPWR VGND sg13cmos5l_decap_8
XFILLER_76_49 VPWR VGND sg13cmos5l_decap_8
XFILLER_670_106 VPWR VGND sg13cmos5l_fill_2
XFILLER_407_103 VPWR VGND sg13cmos5l_decap_8
XFILLER_281_7 VPWR VGND sg13cmos5l_decap_8
XFILLER_379_7 VPWR VGND sg13cmos5l_decap_8
XFILLER_489_14 VPWR VGND sg13cmos5l_decap_8
XFILLER_413_98 VPWR VGND sg13cmos5l_decap_8
XFILLER_132_77 VPWR VGND sg13cmos5l_decap_8
XFILLER_710_63 VPWR VGND sg13cmos5l_decap_8
XFILLER_26_130 VPWR VGND sg13cmos5l_fill_1
XFILLER_546_7 VPWR VGND sg13cmos5l_decap_8
XFILLER_639_28 VPWR VGND sg13cmos5l_decap_8
XFILLER_25_42 VPWR VGND sg13cmos5l_decap_8
XFILLER_569_91 VPWR VGND sg13cmos5l_decap_8
XFILLER_713_7 VPWR VGND sg13cmos5l_decap_8
XFILLER_576_154 VPWR VGND sg13cmos5l_decap_8
XANTENNA__2932__X Tile_X0Y8_E6BEG[0] VPWR VGND sg13cmos5l_antennanp
XFILLER_591_102 VPWR VGND sg13cmos5l_decap_8
XFILLER_288_70 VPWR VGND sg13cmos5l_decap_8
XFILLER_328_132 VPWR VGND sg13cmos5l_decap_8
XFILLER_41_41 VPWR VGND sg13cmos5l_decap_8
XFILLER_655_49 VPWR VGND sg13cmos5l_decap_8
XFILLER_438_84 VPWR VGND sg13cmos5l_decap_8
XFILLER_328_198 VPWR VGND sg13cmos5l_decap_8
XFILLER_343_135 VPWR VGND sg13cmos5l_decap_4
XFILLER_678_217 VPWR VGND sg13cmos5l_fill_1
XFILLER_41_96 VPWR VGND sg13cmos5l_decap_8
XFILLER_374_28 VPWR VGND sg13cmos5l_decap_8
XFILLER_343_146 VPWR VGND sg13cmos5l_decap_8
XFILLER_203_0 VPWR VGND sg13cmos5l_decap_8
XFILLER_142_208 VPWR VGND sg13cmos5l_decap_8
XFILLER_343_179 VPWR VGND sg13cmos5l_fill_1
XFILLER_157_96 VPWR VGND sg13cmos5l_decap_8
XFILLER_497_161 VPWR VGND sg13cmos5l_decap_8
XFILLER_296_201 VPWR VGND sg13cmos5l_fill_2
XFILLER_37_9 VPWR VGND sg13cmos5l_fill_1
XFILLER_173_51 VPWR VGND sg13cmos5l_decap_8
XFILLER_604_42 VPWR VGND sg13cmos5l_decap_8
XFILLER_500_154 VPWR VGND sg13cmos5l_decap_8
XFILLER_646_147 VPWR VGND sg13cmos5l_decap_8
XFILLER_110_116 VPWR VGND sg13cmos5l_decap_8
XFILLER_390_49 VPWR VGND sg13cmos5l_decap_8
XFILLER_572_0 VPWR VGND sg13cmos5l_decap_8
XFILLER_323_21 VPWR VGND sg13cmos5l_decap_8
XFILLER_2_35 VPWR VGND sg13cmos5l_decap_8
XFILLER_323_65 VPWR VGND sg13cmos5l_decap_4
X_0120_ _3182_/A _3914_/X _3915_/X _1641_/Q VPWR VGND sg13cmos5l_mux2_1
XFILLER_399_14 VPWR VGND sg13cmos5l_decap_8
XFILLER_602_206 VPWR VGND sg13cmos5l_fill_1
X_0051_ AXI_M_SOC_AWBURST1 _0938_/Q _3683_/X VPWR VGND sg13cmos5l_nor2b_1
XFILLER_620_63 VPWR VGND sg13cmos5l_decap_8
XANTENNA__3003__X Tile_X0Y5_E2BEG[6] VPWR VGND sg13cmos5l_antennanp
XFILLER_406_191 VPWR VGND sg13cmos5l_decap_8
XFILLER_549_28 VPWR VGND sg13cmos5l_decap_8
XFILLER_220_201 VPWR VGND sg13cmos5l_decap_4
XFILLER_696_56 VPWR VGND sg13cmos5l_decap_8
X_3810_ _3810_/X Tile_X0Y0_W2MID[1] Tile_X0Y0_W6END[7] _3855_/X _3854_/X _1085_/Q
+ _1084_/Q VPWR VGND sg13cmos5l_mux4_1
XFILLER_567_154 VPWR VGND sg13cmos5l_decap_8
XFILLER_220_212 VPWR VGND sg13cmos5l_decap_4
XANTENNA__2842__X Tile_X0Y6_E2BEG[7] VPWR VGND sg13cmos5l_antennanp
XFILLER_177_116 VPWR VGND sg13cmos5l_decap_8
X_4790_ _4790_/X _4709_/X Tile_X0Y9_N2MID[4] _4820_/X _4708_/X _0431_/Q _0430_/Q VPWR
+ VGND sg13cmos5l_mux4_1
XFILLER_421_194 VPWR VGND sg13cmos5l_fill_2
XFILLER_198_70 VPWR VGND sg13cmos5l_decap_8
XANTENNA_18 AXI_M_SOC_WREADY VPWR VGND sg13cmos5l_antennanp
XANTENNA_29 AXI_M_SOC_WREADY VPWR VGND sg13cmos5l_antennanp
X_3741_ AXI_M_SOC_ARADDR13 Tile_X0Y9_W1END[1] Tile_X0Y9_WW4END[5] Tile_X0Y9_WW4END[13]
+ _4929_/X _0733_/Q _0732_/Q VPWR VGND sg13cmos5l_mux4_1
X_0953_ _0953_/Q Tile_X0Y0_FrameData[18] VGND VPWR Tile_X0Y9_FrameStrobe[0] latch
XFILLER_192_119 VPWR VGND sg13cmos5l_decap_4
X_3672_ _3672_/X Tile_X0Y2_WW4END[2] Tile_X0Y2_WW4END[10] Tile_X0Y2_W6END[2] _4118_/X
+ _1501_/Q _1500_/Q VPWR VGND sg13cmos5l_mux4_1
X_0884_ _0884_/Q Tile_X0Y9_FrameData[11] VGND VPWR Tile_X0Y9_FrameStrobe[6] latch
XFILLER_565_49 VPWR VGND sg13cmos5l_decap_8
XFILLER_348_84 VPWR VGND sg13cmos5l_decap_8
XFILLER_319_198 VPWR VGND sg13cmos5l_decap_8
X_2623_ _2623_/Q Tile_X0Y6_FrameData[8] VGND VPWR Tile_X0Y9_FrameStrobe[5] latch
XFILLER_334_135 VPWR VGND sg13cmos5l_fill_1
XFILLER_284_28 VPWR VGND sg13cmos5l_decap_8
X_2554_ _2554_/Q Tile_X0Y6_FrameData[13] VGND VPWR Tile_X0Y9_FrameStrobe[3] latch
XFILLER_217_55 VPWR VGND sg13cmos5l_decap_8
X_1505_ _1505_/Q Tile_X0Y2_FrameData[16] VGND VPWR Tile_X0Y9_FrameStrobe[2] latch
XFILLER_342_190 VPWR VGND sg13cmos5l_fill_2
X_2485_ _2485_/Q Tile_X0Y6_FrameData[18] VGND VPWR Tile_X0Y9_FrameStrobe[1] latch
X_4224_ _4224_/X _4200_/X _0087_/X _4199_/X Tile_X0Y0_S4END[14] _1725_/Q _1724_/Q
+ VPWR VGND sg13cmos5l_mux4_1
XFILLER_514_42 VPWR VGND sg13cmos5l_decap_8
XFILLER_99_199 VPWR VGND sg13cmos5l_decap_8
X_1436_ _1436_/Q Tile_X0Y2_FrameData[21] VGND VPWR Tile_X0Y9_FrameStrobe[0] latch
XFILLER_247_109 VPWR VGND sg13cmos5l_decap_4
XFILLER_661_70 VPWR VGND sg13cmos5l_decap_8
XFILLER_233_21 VPWR VGND sg13cmos5l_decap_8
X_4155_ _4155_/X Tile_X0Y3_W2MID[0] AXI_M_SOC_BVALID _4205_/X _4204_/X _1831_/Q _1830_/Q
+ VPWR VGND sg13cmos5l_mux4_1
X_1367_ _1367_/Q Tile_X0Y1_FrameData[2] VGND VPWR Tile_X0Y9_FrameStrobe[5] latch
X_3106_ Tile_X0Y7_E6BEG[4] _4648_/X VPWR VGND sg13cmos5l_buf_1
XFILLER_255_142 VPWR VGND sg13cmos5l_fill_2
XFILLER_233_87 VPWR VGND sg13cmos5l_decap_4
X_0318_ _0318_/Q Tile_X0Y7_FrameData[1] VGND VPWR Tile_X0Y9_FrameStrobe[4] latch
X_4086_ _4086_/X _4093_/X Tile_X0Y2_W6END[2] _4092_/X _4086_/A3 _1429_/Q _1428_/Q
+ VPWR VGND sg13cmos5l_mux4_1
X_1298_ _1298_/Q Tile_X0Y1_FrameData[7] VGND VPWR Tile_X0Y9_FrameStrobe[3] latch
XFILLER_404_106 VPWR VGND sg13cmos5l_fill_1
X_3037_ Tile_X0Y5_EE4BEG[12] _4400_/X VPWR VGND sg13cmos5l_buf_1
XFILLER_102_14 VPWR VGND sg13cmos5l_decap_8
X_0249_ _0249_/Q Tile_X0Y7_FrameData[6] VGND VPWR Tile_X0Y9_FrameStrobe[2] latch
XFILLER_70_206 VPWR VGND sg13cmos5l_decap_8
XFILLER_70_217 VPWR VGND sg13cmos5l_fill_1
XFILLER_459_28 VPWR VGND sg13cmos5l_decap_8
XFILLER_412_150 VPWR VGND sg13cmos5l_decap_8
XFILLER_389_91 VPWR VGND sg13cmos5l_fill_1
XANTENNA__2752__X Tile_X0Y3_FrameData_O[10] VPWR VGND sg13cmos5l_antennanp
XFILLER_23_177 VPWR VGND sg13cmos5l_decap_8
X_3939_ _3939_/X Tile_X0Y1_W2MID[0] AXI_M_SOC_ARREADY _3989_/X _3988_/X _1331_/Q _1330_/Q
+ VPWR VGND sg13cmos5l_mux4_1
XFILLER_573_168 VPWR VGND sg13cmos5l_decap_8
XFILLER_475_49 VPWR VGND sg13cmos5l_decap_4
XFILLER_127_7 VPWR VGND sg13cmos5l_decap_8
XFILLER_408_21 VPWR VGND sg13cmos5l_decap_8
XFILLER_325_124 VPWR VGND sg13cmos5l_decap_8
XFILLER_194_28 VPWR VGND sg13cmos5l_decap_8
XANTENNA__3583__X Tile_X0Y9_FrameData_O[13] VPWR VGND sg13cmos5l_antennanp
XFILLER_408_65 VPWR VGND sg13cmos5l_fill_1
XFILLER_325_179 VPWR VGND sg13cmos5l_decap_8
XFILLER_11_77 VPWR VGND sg13cmos5l_decap_8
XFILLER_705_63 VPWR VGND sg13cmos5l_decap_8
XFILLER_127_77 VPWR VGND sg13cmos5l_decap_8
XFILLER_496_7 VPWR VGND sg13cmos5l_decap_8
XFILLER_127_88 VPWR VGND sg13cmos5l_fill_2
XFILLER_628_136 VPWR VGND sg13cmos5l_fill_1
XFILLER_424_42 VPWR VGND sg13cmos5l_decap_8
XFILLER_571_70 VPWR VGND sg13cmos5l_decap_8
XFILLER_143_21 VPWR VGND sg13cmos5l_decap_8
XFILLER_494_175 VPWR VGND sg13cmos5l_decap_4
XANTENNA__2927__X Tile_X0Y8_E2BEGb[3] VPWR VGND sg13cmos5l_antennanp
XFILLER_663_7 VPWR VGND sg13cmos5l_decap_8
XFILLER_46_203 VPWR VGND sg13cmos5l_fill_2
XFILLER_100_171 VPWR VGND sg13cmos5l_decap_4
XFILLER_450_201 VPWR VGND sg13cmos5l_fill_1
XFILLER_651_161 VPWR VGND sg13cmos5l_decap_8
XFILLER_261_112 VPWR VGND sg13cmos5l_decap_8
XFILLER_440_63 VPWR VGND sg13cmos5l_fill_1
XFILLER_61_217 VPWR VGND sg13cmos5l_fill_1
XFILLER_369_28 VPWR VGND sg13cmos5l_decap_8
XANTENNA__3758__X AXI_M_SOC_ARADDR30 VPWR VGND sg13cmos5l_antennanp
XFILLER_153_0 VPWR VGND sg13cmos5l_decap_8
XFILLER_432_2 VPWR VGND sg13cmos5l_fill_1
XFILLER_14_144 VPWR VGND sg13cmos5l_fill_1
XFILLER_14_166 VPWR VGND sg13cmos5l_decap_8
XFILLER_52_51 VPWR VGND sg13cmos5l_decap_8
XFILLER_320_0 VPWR VGND sg13cmos5l_decap_8
XFILLER_418_0 VPWR VGND sg13cmos5l_decap_8
XFILLER_363_208 VPWR VGND sg13cmos5l_fill_2
XFILLER_706_140 VPWR VGND sg13cmos5l_decap_8
XFILLER_706_151 VPWR VGND sg13cmos5l_fill_1
XFILLER_505_202 VPWR VGND sg13cmos5l_fill_2
XFILLER_706_173 VPWR VGND sg13cmos5l_decap_8
XFILLER_318_21 VPWR VGND sg13cmos5l_decap_8
XFILLER_318_32 VPWR VGND sg13cmos5l_fill_1
XFILLER_682_14 VPWR VGND sg13cmos5l_decap_8
XFILLER_318_54 VPWR VGND sg13cmos5l_decap_8
XANTENNA__3493__X Tile_X0Y1_E6BEG[3] VPWR VGND sg13cmos5l_antennanp
XFILLER_520_205 VPWR VGND sg13cmos5l_decap_8
XFILLER_520_216 VPWR VGND sg13cmos5l_fill_2
XFILLER_184_72 VPWR VGND sg13cmos5l_decap_8
XFILLER_619_114 VPWR VGND sg13cmos5l_decap_4
XFILLER_615_63 VPWR VGND sg13cmos5l_decap_8
XFILLER_96_103 VPWR VGND sg13cmos5l_decap_8
XFILLER_615_96 VPWR VGND sg13cmos5l_decap_8
XFILLER_334_42 VPWR VGND sg13cmos5l_decap_8
X_2270_ _2270_/Q Tile_X0Y5_FrameData[7] VGND VPWR Tile_X0Y9_FrameStrobe[2] latch
XFILLER_481_70 VPWR VGND sg13cmos5l_decap_4
XFILLER_485_175 VPWR VGND sg13cmos5l_decap_4
X_1221_ _1221_/Q Tile_X0Y1_FrameData[20] VGND VPWR Tile_X0Y9_FrameStrobe[1] latch
XANTENNA__2837__X Tile_X0Y6_E2BEG[2] VPWR VGND sg13cmos5l_antennanp
X_1152_ _1152_/Q Tile_X0Y0_FrameData[11] VGND VPWR Tile_X0Y9_FrameStrobe[6] latch
XFILLER_631_84 VPWR VGND sg13cmos5l_decap_8
XFILLER_252_101 VPWR VGND sg13cmos5l_decap_4
XFILLER_203_35 VPWR VGND sg13cmos5l_decap_8
XFILLER_642_161 VPWR VGND sg13cmos5l_decap_8
XFILLER_441_201 VPWR VGND sg13cmos5l_fill_2
X_0103_ _3191_/A _3798_/X _3799_/X _1142_/Q VPWR VGND sg13cmos5l_mux2_1
XFILLER_350_63 VPWR VGND sg13cmos5l_decap_8
X_1083_ _1083_/Q Tile_X0Y0_FrameData[16] VGND VPWR Tile_X0Y9_FrameStrobe[4] latch
XFILLER_52_217 VPWR VGND sg13cmos5l_fill_1
XFILLER_93_91 VPWR VGND sg13cmos5l_decap_8
X_4911_ _4911_/X _4456_/X _4460_/X _4464_/X _4431_/X _2376_/Q _2375_/Q VPWR VGND sg13cmos5l_mux4_1
XANTENNA__3668__X AXI_M_SOC_AWADDR29 VPWR VGND sg13cmos5l_antennanp
XFILLER_500_77 VPWR VGND sg13cmos5l_decap_8
XFILLER_339_216 VPWR VGND sg13cmos5l_fill_2
X_4842_ _4842_/X Tile_X0Y9_W1END[3] Tile_X0Y9_WW4END[15] Tile_X0Y9_W6END[7] _4919_/X
+ _0858_/Q _0857_/Q VPWR VGND sg13cmos5l_mux4_1
X_4773_ _4773_/X _4779_/X Tile_X0Y8_W6END[1] _4778_/X _4773_/A3 _0421_/Q _0420_/Q
+ VPWR VGND sg13cmos5l_mux4_1
X_1985_ _1985_/Q Tile_X0Y4_FrameData[4] VGND VPWR Tile_X0Y9_FrameStrobe[1] latch
X_3724_ _3724_/X Tile_X0Y3_WW4END[1] Tile_X0Y3_WW4END[9] Tile_X0Y3_W6END[9] _4231_/X
+ _1739_/Q _1738_/Q VPWR VGND sg13cmos5l_mux4_1
XFILLER_570_105 VPWR VGND sg13cmos5l_decap_8
XFILLER_509_42 VPWR VGND sg13cmos5l_decap_8
X_0936_ _0936_/Q Tile_X0Y9_FrameData[27] VGND VPWR Tile_X0Y9_FrameStrobe[8] latch
XFILLER_158_171 VPWR VGND sg13cmos5l_decap_8
XFILLER_295_49 VPWR VGND sg13cmos5l_decap_8
XFILLER_158_182 VPWR VGND sg13cmos5l_fill_1
XFILLER_656_70 VPWR VGND sg13cmos5l_decap_8
XFILLER_228_21 VPWR VGND sg13cmos5l_decap_8
X_3655_ AXI_M_SOC_AWADDR16 Tile_X0Y4_WW4END[0] Tile_X0Y4_WW4END[8] Tile_X0Y4_W6END[0]
+ _4336_/X _2013_/Q _2012_/Q VPWR VGND sg13cmos5l_mux4_1
XFILLER_592_14 VPWR VGND sg13cmos5l_decap_8
X_0867_ _0867_/Q Tile_X0Y9_FrameData[28] VGND VPWR Tile_X0Y9_FrameStrobe[6] latch
XFILLER_173_174 VPWR VGND sg13cmos5l_decap_8
XFILLER_712_154 VPWR VGND sg13cmos5l_decap_8
X_2606_ _2606_/Q Tile_X0Y6_FrameData[25] VGND VPWR Tile_X0Y9_FrameStrobe[5] latch
XFILLER_375_93 VPWR VGND sg13cmos5l_decap_8
X_3586_ Tile_X0Y9_FrameData_O[16] Tile_X0Y9_FrameData[16] VPWR VGND sg13cmos5l_buf_1
X_0798_ _0798_/Q Tile_X0Y9_FrameData[1] VGND VPWR Tile_X0Y9_FrameStrobe[3] latch
XFILLER_322_149 VPWR VGND sg13cmos5l_fill_2
X_2537_ _2537_/Q Tile_X0Y6_FrameData[30] VGND VPWR Tile_X0Y9_FrameStrobe[3] latch
XFILLER_525_63 VPWR VGND sg13cmos5l_fill_1
XFILLER_672_91 VPWR VGND sg13cmos5l_fill_2
XFILLER_476_131 VPWR VGND sg13cmos5l_decap_4
XFILLER_244_42 VPWR VGND sg13cmos5l_decap_8
X_2468_ _2468_/Q Tile_X0Y6_FrameData[3] VGND VPWR Tile_X0Y9_FrameStrobe[0] latch
X_4207_ _4207_/X _4131_/X _4239_/X _4238_/X _4130_/X _1695_/Q _1694_/Q VPWR VGND sg13cmos5l_mux4_1
XFILLER_491_112 VPWR VGND sg13cmos5l_decap_8
XANTENNA__2747__X Tile_X0Y3_FrameData_O[5] VPWR VGND sg13cmos5l_antennanp
X_1419_ _1419_/Q Tile_X0Y1_FrameData[14] VGND VPWR Tile_X0Y9_FrameStrobe[7] latch
X_2399_ _2399_/Q Tile_X0Y5_FrameData[6] VGND VPWR Tile_X0Y9_FrameStrobe[6] latch
XFILLER_491_156 VPWR VGND sg13cmos5l_decap_4
X_4138_ _4138_/X Tile_X0Y1_W1END[1] Tile_X0Y1_W2MID[2] Tile_X0Y1_W2END[2] _3992_/X
+ _1371_/Q _1370_/Q VPWR VGND sg13cmos5l_mux4_1
XFILLER_113_35 VPWR VGND sg13cmos5l_decap_4
XFILLER_491_189 VPWR VGND sg13cmos5l_decap_8
X_4069_ _4069_/X Tile_X0Y2_WW4END[2] AXI_M_SOC_AWREADY _4118_/X _4101_/X _1535_/Q
+ _1534_/Q VPWR VGND sg13cmos5l_mux4_1
XFILLER_578_216 VPWR VGND sg13cmos5l_fill_2
XFILLER_73_28 VPWR VGND sg13cmos5l_decap_8
XFILLER_389_138 VPWR VGND sg13cmos5l_fill_2
XFILLER_189_28 VPWR VGND sg13cmos5l_decap_8
XFILLER_243_189 VPWR VGND sg13cmos5l_decap_4
XANTENNA__3578__X Tile_X0Y9_FrameData_O[8] VPWR VGND sg13cmos5l_antennanp
XFILLER_410_77 VPWR VGND sg13cmos5l_decap_8
XFILLER_397_171 VPWR VGND sg13cmos5l_fill_1
XFILLER_244_7 VPWR VGND sg13cmos5l_decap_8
XFILLER_397_193 VPWR VGND sg13cmos5l_decap_4
XFILLER_345_208 VPWR VGND sg13cmos5l_fill_1
XFILLER_561_105 VPWR VGND sg13cmos5l_decap_8
XFILLER_419_42 VPWR VGND sg13cmos5l_decap_8
XFILLER_411_7 VPWR VGND sg13cmos5l_decap_8
XFILLER_22_21 VPWR VGND sg13cmos5l_decap_8
XFILLER_509_7 VPWR VGND sg13cmos5l_decap_8
XFILLER_566_70 VPWR VGND sg13cmos5l_decap_8
XFILLER_149_193 VPWR VGND sg13cmos5l_decap_8
XFILLER_499_201 VPWR VGND sg13cmos5l_fill_1
XFILLER_138_21 VPWR VGND sg13cmos5l_decap_8
XFILLER_164_130 VPWR VGND sg13cmos5l_fill_1
XFILLER_164_152 VPWR VGND sg13cmos5l_fill_2
XFILLER_98_14 VPWR VGND sg13cmos5l_decap_8
XFILLER_164_196 VPWR VGND sg13cmos5l_decap_8
XFILLER_138_98 VPWR VGND sg13cmos5l_decap_8
XFILLER_703_187 VPWR VGND sg13cmos5l_decap_8
XFILLER_313_138 VPWR VGND sg13cmos5l_decap_8
XFILLER_652_28 VPWR VGND sg13cmos5l_decap_8
XFILLER_435_63 VPWR VGND sg13cmos5l_decap_8
XFILLER_154_20 VPWR VGND sg13cmos5l_decap_8
XFILLER_78_103 VPWR VGND sg13cmos5l_decap_4
XFILLER_582_91 VPWR VGND sg13cmos5l_decap_8
XFILLER_266_204 VPWR VGND sg13cmos5l_decap_8
XFILLER_266_215 VPWR VGND sg13cmos5l_fill_2
XFILLER_78_158 VPWR VGND sg13cmos5l_decap_8
XFILLER_467_186 VPWR VGND sg13cmos5l_decap_8
XFILLER_154_97 VPWR VGND sg13cmos5l_decap_8
XFILLER_219_120 VPWR VGND sg13cmos5l_fill_2
XFILLER_482_134 VPWR VGND sg13cmos5l_fill_2
XFILLER_609_180 VPWR VGND sg13cmos5l_decap_8
XFILLER_219_164 VPWR VGND sg13cmos5l_fill_1
XFILLER_601_21 VPWR VGND sg13cmos5l_decap_8
XFILLER_270_0 VPWR VGND sg13cmos5l_decap_8
XFILLER_170_41 VPWR VGND sg13cmos5l_decap_8
XFILLER_219_186 VPWR VGND sg13cmos5l_decap_8
XFILLER_569_205 VPWR VGND sg13cmos5l_fill_2
XFILLER_368_0 VPWR VGND sg13cmos5l_decap_8
XFILLER_624_194 VPWR VGND sg13cmos5l_decap_4
XFILLER_234_145 VPWR VGND sg13cmos5l_decap_4
XFILLER_234_178 VPWR VGND sg13cmos5l_decap_8
XFILLER_677_14 VPWR VGND sg13cmos5l_decap_8
XFILLER_395_108 VPWR VGND sg13cmos5l_fill_1
XANTENNA__3488__X Tile_X0Y1_EE4BEG[14] VPWR VGND sg13cmos5l_antennanp
XFILLER_535_0 VPWR VGND sg13cmos5l_decap_8
XFILLER_179_50 VPWR VGND sg13cmos5l_decap_8
XFILLER_702_0 VPWR VGND sg13cmos5l_decap_8
XFILLER_336_208 VPWR VGND sg13cmos5l_fill_1
XFILLER_8_56 VPWR VGND sg13cmos5l_decap_8
X_1770_ _1770_/Q Tile_X0Y3_FrameData[31] VGND VPWR Tile_X0Y9_FrameStrobe[3] latch
XFILLER_693_35 VPWR VGND sg13cmos5l_decap_8
XFILLER_155_130 VPWR VGND sg13cmos5l_decap_8
X_0721_ _0721_/Q Tile_X0Y9_FrameData[14] VGND VPWR Tile_X0Y9_FrameStrobe[1] latch
XFILLER_476_92 VPWR VGND sg13cmos5l_decap_4
X_3440_ Tile_X0Y4_FrameData_O[31] Tile_X0Y4_FrameData[31] VPWR VGND sg13cmos5l_buf_1
X_0652_ _0652_/Q Tile_X0Y8_FrameData[19] VGND VPWR Tile_X0Y9_FrameStrobe[7] latch
XFILLER_626_84 VPWR VGND sg13cmos5l_decap_8
XFILLER_562_28 VPWR VGND sg13cmos5l_decap_8
X_3371_ Tile_X0Y2_EE4BEG[10] _4066_/X VPWR VGND sg13cmos5l_buf_1
XFILLER_345_63 VPWR VGND sg13cmos5l_decap_8
X_0583_ _0583_/Q Tile_X0Y8_FrameData[24] VGND VPWR Tile_X0Y9_FrameStrobe[5] latch
XFILLER_458_120 VPWR VGND sg13cmos5l_decap_4
XFILLER_492_91 VPWR VGND sg13cmos5l_decap_8
X_2322_ _2322_/Q Tile_X0Y5_FrameData[19] VGND VPWR Tile_X0Y9_FrameStrobe[4] latch
XFILLER_607_106 VPWR VGND sg13cmos5l_fill_2
X_2253_ _2253_/Q Tile_X0Y5_FrameData[24] VGND VPWR Tile_X0Y9_FrameStrobe[2] latch
XFILLER_214_56 VPWR VGND sg13cmos5l_decap_8
X_1204_ _1204_/Q Tile_X0Y1_FrameData[5] VGND VPWR Tile_X0Y9_FrameStrobe[0] latch
XFILLER_473_156 VPWR VGND sg13cmos5l_decap_8
XFILLER_272_207 VPWR VGND sg13cmos5l_fill_1
X_2184_ _2184_/Q Tile_X0Y5_FrameData[29] VGND VPWR Tile_X0Y9_FrameStrobe[0] latch
XFILLER_511_21 VPWR VGND sg13cmos5l_decap_8
XFILLER_615_161 VPWR VGND sg13cmos5l_decap_8
X_1135_ _1135_/Q Tile_X0Y0_FrameData[28] VGND VPWR Tile_X0Y9_FrameStrobe[6] latch
XFILLER_615_183 VPWR VGND sg13cmos5l_decap_8
X_1066_ _1066_/Q Tile_X0Y0_FrameData[1] VGND VPWR Tile_X0Y9_FrameStrobe[3] latch
XFILLER_587_14 VPWR VGND sg13cmos5l_decap_8
XFILLER_511_98 VPWR VGND sg13cmos5l_fill_2
XFILLER_240_104 VPWR VGND sg13cmos5l_fill_2
XFILLER_225_178 VPWR VGND sg13cmos5l_decap_8
XFILLER_230_66 VPWR VGND sg13cmos5l_fill_2
XANTENNA__3398__X Tile_X0Y2_E2BEG[1] VPWR VGND sg13cmos5l_antennanp
XFILLER_230_77 VPWR VGND sg13cmos5l_fill_1
XFILLER_528_102 VPWR VGND sg13cmos5l_decap_8
XFILLER_240_159 VPWR VGND sg13cmos5l_decap_8
XFILLER_230_99 VPWR VGND sg13cmos5l_decap_8
XFILLER_394_130 VPWR VGND sg13cmos5l_decap_8
X_4825_ _4825_/X Tile_X0Y9_W1END[1] Tile_X0Y9_W6END[9] _4929_/X _4893_/X _0889_/Q
+ _0888_/Q VPWR VGND sg13cmos5l_mux4_1
XFILLER_327_208 VPWR VGND sg13cmos5l_fill_1
XFILLER_138_119 VPWR VGND sg13cmos5l_decap_8
X_1968_ _1968_/Q Tile_X0Y4_FrameData[21] VGND VPWR Tile_X0Y9_FrameStrobe[1] latch
X_4756_ _4756_/X Tile_X0Y8_WW4END[3] AXI_M_SOC_RDATA11 _4803_/X _4791_/X _0535_/Q
+ _0534_/Q VPWR VGND sg13cmos5l_mux4_1
XFILLER_146_130 VPWR VGND sg13cmos5l_decap_8
XFILLER_386_92 VPWR VGND sg13cmos5l_decap_4
X_0919_ _0919_/Q Tile_X0Y9_FrameData[8] VGND VPWR Tile_X0Y9_FrameStrobe[7] latch
X_3707_ AXI_M_SOC_WDATA17 Tile_X0Y6_WW4END[1] Tile_X0Y6_WW4END[9] Tile_X0Y6_W6END[1]
+ _4569_/X _2525_/Q _2524_/Q VPWR VGND sg13cmos5l_mux4_1
XFILLER_536_190 VPWR VGND sg13cmos5l_decap_8
X_4687_ _4687_/X _4667_/X Tile_X0Y9_N4END[11] _4666_/X _0053_/X _0209_/Q _0208_/Q
+ VPWR VGND sg13cmos5l_mux4_1
X_1899_ _1899_/Q Tile_X0Y3_FrameData[30] VGND VPWR Tile_X0Y9_FrameStrobe[7] latch
XFILLER_697_142 VPWR VGND sg13cmos5l_fill_1
X_3638_ Tile_X0Y9_UserCLKo Tile_X0Y9_UserCLK VPWR VGND sg13cmos5l_buf_1
XFILLER_161_122 VPWR VGND sg13cmos5l_decap_8
XFILLER_700_113 VPWR VGND sg13cmos5l_decap_4
XFILLER_108_35 VPWR VGND sg13cmos5l_decap_8
XFILLER_472_28 VPWR VGND sg13cmos5l_decap_8
XFILLER_161_155 VPWR VGND sg13cmos5l_decap_8
X_3569_ Tile_X0Y9_EE4BEG[15] _4879_/X VPWR VGND sg13cmos5l_buf_1
XFILLER_255_96 VPWR VGND sg13cmos5l_decap_8
XFILLER_102_200 VPWR VGND sg13cmos5l_decap_8
XFILLER_102_211 VPWR VGND sg13cmos5l_fill_1
XFILLER_248_215 VPWR VGND sg13cmos5l_fill_2
XFILLER_303_193 VPWR VGND sg13cmos5l_decap_8
XFILLER_194_7 VPWR VGND sg13cmos5l_decap_8
XFILLER_75_117 VPWR VGND sg13cmos5l_decap_8
XFILLER_124_56 VPWR VGND sg13cmos5l_decap_8
XFILLER_702_42 VPWR VGND sg13cmos5l_decap_8
XFILLER_75_139 VPWR VGND sg13cmos5l_fill_2
XFILLER_84_27 VPWR VGND sg13cmos5l_decap_8
XFILLER_271_84 VPWR VGND sg13cmos5l_decap_8
XFILLER_421_21 VPWR VGND sg13cmos5l_decap_8
XFILLER_606_161 VPWR VGND sg13cmos5l_decap_4
XFILLER_216_112 VPWR VGND sg13cmos5l_decap_8
XFILLER_361_7 VPWR VGND sg13cmos5l_decap_8
XFILLER_17_21 VPWR VGND sg13cmos5l_decap_8
XFILLER_606_183 VPWR VGND sg13cmos5l_fill_1
XFILLER_459_7 VPWR VGND sg13cmos5l_decap_8
XFILLER_16_217 VPWR VGND sg13cmos5l_fill_1
XFILLER_497_14 VPWR VGND sg13cmos5l_decap_8
XFILLER_421_98 VPWR VGND sg13cmos5l_decap_8
XFILLER_231_137 VPWR VGND sg13cmos5l_decap_4
XFILLER_140_77 VPWR VGND sg13cmos5l_decap_8
XFILLER_626_7 VPWR VGND sg13cmos5l_decap_8
XANTENNA__3101__X Tile_X0Y7_E2BEGb[7] VPWR VGND sg13cmos5l_antennanp
XFILLER_647_28 VPWR VGND sg13cmos5l_decap_8
XFILLER_33_42 VPWR VGND sg13cmos5l_decap_8
XFILLER_519_157 VPWR VGND sg13cmos5l_decap_8
XFILLER_149_20 VPWR VGND sg13cmos5l_decap_8
XFILLER_577_91 VPWR VGND sg13cmos5l_decap_8
XFILLER_534_105 VPWR VGND sg13cmos5l_fill_1
XFILLER_385_174 VPWR VGND sg13cmos5l_decap_8
XANTENNA__2940__X Tile_X0Y8_E6BEG[8] VPWR VGND sg13cmos5l_antennanp
XFILLER_296_70 VPWR VGND sg13cmos5l_decap_8
XFILLER_296_92 VPWR VGND sg13cmos5l_fill_2
XFILLER_137_130 VPWR VGND sg13cmos5l_fill_2
XFILLER_116_0 VPWR VGND sg13cmos5l_fill_2
XFILLER_663_49 VPWR VGND sg13cmos5l_decap_8
XFILLER_542_182 VPWR VGND sg13cmos5l_decap_8
XFILLER_446_95 VPWR VGND sg13cmos5l_decap_4
XFILLER_3_121 VPWR VGND sg13cmos5l_decap_8
XFILLER_152_144 VPWR VGND sg13cmos5l_decap_4
XFILLER_382_28 VPWR VGND sg13cmos5l_decap_8
XFILLER_3_187 VPWR VGND sg13cmos5l_fill_2
XFILLER_485_0 VPWR VGND sg13cmos5l_decap_8
XFILLER_455_112 VPWR VGND sg13cmos5l_decap_8
XFILLER_315_66 VPWR VGND sg13cmos5l_decap_8
XFILLER_58_50 VPWR VGND sg13cmos5l_fill_1
XFILLER_315_77 VPWR VGND sg13cmos5l_fill_2
XFILLER_58_61 VPWR VGND sg13cmos5l_decap_8
XFILLER_612_42 VPWR VGND sg13cmos5l_decap_8
XFILLER_652_0 VPWR VGND sg13cmos5l_decap_8
XFILLER_331_21 VPWR VGND sg13cmos5l_decap_8
XFILLER_688_35 VPWR VGND sg13cmos5l_decap_4
XFILLER_470_159 VPWR VGND sg13cmos5l_decap_8
XFILLER_331_76 VPWR VGND sg13cmos5l_fill_1
XFILLER_688_57 VPWR VGND sg13cmos5l_decap_8
XFILLER_222_104 VPWR VGND sg13cmos5l_decap_8
XFILLER_207_178 VPWR VGND sg13cmos5l_decap_8
XFILLER_74_93 VPWR VGND sg13cmos5l_fill_1
X_2940_ Tile_X0Y8_E6BEG[8] _4768_/X VPWR VGND sg13cmos5l_buf_1
XFILLER_200_14 VPWR VGND sg13cmos5l_decap_8
XANTENNA__3011__X Tile_X0Y5_E2BEGb[6] VPWR VGND sg13cmos5l_antennanp
X_2871_ Tile_X0Y6_EE4BEG[8] _4520_/X VPWR VGND sg13cmos5l_buf_1
XFILLER_557_28 VPWR VGND sg13cmos5l_decap_8
XFILLER_376_141 VPWR VGND sg13cmos5l_decap_4
XFILLER_487_91 VPWR VGND sg13cmos5l_decap_8
XFILLER_714_205 VPWR VGND sg13cmos5l_fill_2
X_1822_ _1822_/Q Tile_X0Y3_FrameData[11] VGND VPWR Tile_X0Y9_FrameStrobe[4] latch
X_4610_ _4610_/X _4665_/X _4664_/X AXI_M_SOC_RDATA17 AXI_M_SOC_RDATA21 _0339_/Q _0338_/Q
+ VPWR VGND sg13cmos5l_mux4_1
XFILLER_391_100 VPWR VGND sg13cmos5l_decap_8
XANTENNA__2850__X Tile_X0Y6_E2BEGb[7] VPWR VGND sg13cmos5l_antennanp
XFILLER_580_211 VPWR VGND sg13cmos5l_decap_8
XFILLER_391_111 VPWR VGND sg13cmos5l_fill_1
XFILLER_525_138 VPWR VGND sg13cmos5l_decap_8
XFILLER_525_149 VPWR VGND sg13cmos5l_fill_1
X_4541_ _4541_/X _4547_/X Tile_X0Y6_W6END[1] _4546_/X _4541_/A3 _2445_/Q _2444_/Q
+ VPWR VGND sg13cmos5l_mux4_1
XFILLER_128_141 VPWR VGND sg13cmos5l_decap_8
X_1753_ _1753_/Q Tile_X0Y3_FrameData[16] VGND VPWR Tile_X0Y9_FrameStrobe[2] latch
XFILLER_190_217 VPWR VGND sg13cmos5l_fill_1
XFILLER_209_56 VPWR VGND sg13cmos5l_decap_8
X_0704_ _0704_/Q Tile_X0Y9_FrameData[31] VGND VPWR Tile_X0Y9_FrameStrobe[1] latch
XFILLER_679_142 VPWR VGND sg13cmos5l_decap_8
XFILLER_128_185 VPWR VGND sg13cmos5l_fill_1
X_4472_ _4472_/X Tile_X0Y4_W2MID[5] Tile_X0Y4_W2END[5] Tile_X0Y4_W6END[10] _4317_/X
+ _2133_/Q _2132_/Q VPWR VGND sg13cmos5l_mux4_1
X_1684_ _1684_/Q Tile_X0Y3_FrameData[21] VGND VPWR Tile_X0Y9_FrameStrobe[0] latch
XFILLER_679_164 VPWR VGND sg13cmos5l_fill_2
XFILLER_573_49 VPWR VGND sg13cmos5l_decap_8
XFILLER_356_84 VPWR VGND sg13cmos5l_decap_8
XFILLER_478_215 VPWR VGND sg13cmos5l_fill_2
XFILLER_533_193 VPWR VGND sg13cmos5l_decap_8
XFILLER_506_21 VPWR VGND sg13cmos5l_decap_8
XFILLER_89_209 VPWR VGND sg13cmos5l_decap_8
X_3423_ Tile_X0Y4_FrameData_O[14] Tile_X0Y4_FrameData[14] VPWR VGND sg13cmos5l_buf_1
XFILLER_292_28 VPWR VGND sg13cmos5l_decap_8
X_0635_ _0635_/Q Tile_X0Y8_FrameData[4] VGND VPWR Tile_X0Y9_FrameStrobe[6] latch
XFILLER_143_166 VPWR VGND sg13cmos5l_decap_8
XFILLER_694_134 VPWR VGND sg13cmos5l_decap_4
XFILLER_694_156 VPWR VGND sg13cmos5l_decap_4
X_3354_ Tile_X0Y2_FrameData_O[25] Tile_X0Y2_FrameData[25] VPWR VGND sg13cmos5l_buf_1
XFILLER_694_167 VPWR VGND sg13cmos5l_decap_8
X_0566_ _0566_/Q Tile_X0Y8_FrameData[9] VGND VPWR Tile_X0Y9_FrameStrobe[4] latch
XFILLER_31_0 VPWR VGND sg13cmos5l_fill_2
XFILLER_297_170 VPWR VGND sg13cmos5l_decap_8
X_2305_ _2305_/Q Tile_X0Y5_FrameData[4] VGND VPWR Tile_X0Y9_FrameStrobe[3] latch
X_3285_ Tile_X0Y0_E6BEG[5] _3841_/X VPWR VGND sg13cmos5l_buf_1
X_0497_ _0497_/Q Tile_X0Y8_FrameData[14] VGND VPWR Tile_X0Y9_FrameStrobe[2] latch
XFILLER_225_99 VPWR VGND sg13cmos5l_decap_8
XFILLER_522_42 VPWR VGND sg13cmos5l_decap_8
X_2236_ _2236_/Q Tile_X0Y5_FrameData[9] VGND VPWR Tile_X0Y9_FrameStrobe[1] latch
XFILLER_57_139 VPWR VGND sg13cmos5l_decap_8
XFILLER_300_196 VPWR VGND sg13cmos5l_decap_8
XFILLER_461_115 VPWR VGND sg13cmos5l_fill_2
XFILLER_241_21 VPWR VGND sg13cmos5l_decap_8
X_2167_ _2167_/Q Tile_X0Y4_FrameData[14] VGND VPWR Tile_X0Y9_FrameStrobe[7] latch
XFILLER_461_159 VPWR VGND sg13cmos5l_decap_8
XFILLER_598_35 VPWR VGND sg13cmos5l_decap_8
X_1118_ _1118_/Q Tile_X0Y0_FrameData[13] VGND VPWR Tile_X0Y9_FrameStrobe[5] latch
X_2098_ _2098_/Q Tile_X0Y4_FrameData[19] VGND VPWR Tile_X0Y9_FrameStrobe[5] latch
XFILLER_359_119 VPWR VGND sg13cmos5l_decap_8
X_1049_ _1049_/Q Tile_X0Y0_FrameData[18] VGND VPWR Tile_X0Y9_FrameStrobe[3] latch
XFILLER_467_28 VPWR VGND sg13cmos5l_decap_8
XFILLER_367_141 VPWR VGND sg13cmos5l_decap_4
XFILLER_221_170 VPWR VGND sg13cmos5l_decap_4
XFILLER_397_91 VPWR VGND sg13cmos5l_fill_1
XANTENNA__2760__X Tile_X0Y3_FrameData_O[18] VPWR VGND sg13cmos5l_antennanp
XFILLER_382_100 VPWR VGND sg13cmos5l_fill_1
X_4808_ _4808_/X _4777_/X Tile_X0Y9_N4END[4] _4776_/X _0077_/X _0455_/Q _0454_/Q VPWR
+ VGND sg13cmos5l_mux4_1
XFILLER_705_216 VPWR VGND sg13cmos5l_fill_2
XFILLER_382_122 VPWR VGND sg13cmos5l_decap_8
X_4739_ _4739_/X Tile_X0Y8_W2END[4] AXI_M_SOC_RDATA12 _4791_/X _4790_/X _0569_/Q _0568_/Q
+ VPWR VGND sg13cmos5l_mux4_1
XFILLER_119_67 VPWR VGND sg13cmos5l_decap_8
XFILLER_79_27 VPWR VGND sg13cmos5l_decap_4
XFILLER_483_49 VPWR VGND sg13cmos5l_decap_8
XFILLER_524_182 VPWR VGND sg13cmos5l_decap_8
XFILLER_469_215 VPWR VGND sg13cmos5l_fill_2
XFILLER_134_133 VPWR VGND sg13cmos5l_decap_4
XFILLER_416_21 VPWR VGND sg13cmos5l_decap_8
XFILLER_134_166 VPWR VGND sg13cmos5l_decap_8
XFILLER_685_134 VPWR VGND sg13cmos5l_decap_4
XANTENNA__3591__X Tile_X0Y9_FrameData_O[21] VPWR VGND sg13cmos5l_antennanp
XFILLER_685_145 VPWR VGND sg13cmos5l_decap_4
XFILLER_134_199 VPWR VGND sg13cmos5l_fill_1
XFILLER_484_207 VPWR VGND sg13cmos5l_fill_2
XFILLER_416_98 VPWR VGND sg13cmos5l_decap_8
XFILLER_135_77 VPWR VGND sg13cmos5l_decap_8
XFILLER_713_63 VPWR VGND sg13cmos5l_decap_8
XFILLER_437_134 VPWR VGND sg13cmos5l_decap_8
XFILLER_576_7 VPWR VGND sg13cmos5l_decap_8
XFILLER_48_128 VPWR VGND sg13cmos5l_decap_8
XFILLER_432_42 VPWR VGND sg13cmos5l_decap_8
XFILLER_236_207 VPWR VGND sg13cmos5l_fill_2
XFILLER_28_42 VPWR VGND sg13cmos5l_decap_8
XFILLER_151_21 VPWR VGND sg13cmos5l_decap_8
XFILLER_63_109 VPWR VGND sg13cmos5l_decap_8
XFILLER_28_75 VPWR VGND sg13cmos5l_fill_1
XANTENNA__2935__X Tile_X0Y8_E6BEG[3] VPWR VGND sg13cmos5l_antennanp
XFILLER_178_2 VPWR VGND sg13cmos5l_fill_1
XFILLER_151_87 VPWR VGND sg13cmos5l_decap_8
XFILLER_301_35 VPWR VGND sg13cmos5l_decap_8
XFILLER_658_49 VPWR VGND sg13cmos5l_decap_8
XFILLER_377_28 VPWR VGND sg13cmos5l_decap_8
XFILLER_233_0 VPWR VGND sg13cmos5l_decap_8
XFILLER_212_181 VPWR VGND sg13cmos5l_decap_8
XFILLER_157_214 VPWR VGND sg13cmos5l_decap_4
XFILLER_507_105 VPWR VGND sg13cmos5l_fill_2
XFILLER_358_196 VPWR VGND sg13cmos5l_decap_8
XFILLER_172_206 VPWR VGND sg13cmos5l_decap_4
XFILLER_400_0 VPWR VGND sg13cmos5l_decap_8
XFILLER_172_217 VPWR VGND sg13cmos5l_fill_1
XFILLER_60_84 VPWR VGND sg13cmos5l_decap_8
XFILLER_607_42 VPWR VGND sg13cmos5l_decap_8
XFILLER_176_73 VPWR VGND sg13cmos5l_decap_8
XFILLER_676_101 VPWR VGND sg13cmos5l_decap_4
XFILLER_326_21 VPWR VGND sg13cmos5l_decap_8
XFILLER_5_35 VPWR VGND sg13cmos5l_decap_8
XFILLER_690_14 VPWR VGND sg13cmos5l_decap_8
XFILLER_530_141 VPWR VGND sg13cmos5l_decap_4
X_0420_ _0420_/Q Tile_X0Y8_FrameData[27] VGND VPWR Tile_X0Y9_FrameStrobe[0] latch
XFILLER_69_60 VPWR VGND sg13cmos5l_decap_8
XFILLER_690_69 VPWR VGND sg13cmos5l_decap_8
XFILLER_140_147 VPWR VGND sg13cmos5l_decap_8
XFILLER_617_201 VPWR VGND sg13cmos5l_decap_8
XFILLER_428_112 VPWR VGND sg13cmos5l_decap_8
X_0351_ _0351_/Q Tile_X0Y7_FrameData[0] VGND VPWR Tile_X0Y9_FrameStrobe[5] latch
XFILLER_623_63 VPWR VGND sg13cmos5l_decap_8
XANTENNA__3006__X Tile_X0Y5_E2BEGb[1] VPWR VGND sg13cmos5l_antennanp
XFILLER_342_42 VPWR VGND sg13cmos5l_decap_8
X_3070_ Tile_X0Y5_FrameData_O[29] Tile_X0Y5_FrameData[29] VPWR VGND sg13cmos5l_buf_1
XFILLER_294_173 VPWR VGND sg13cmos5l_decap_8
X_0282_ _0282_/Q Tile_X0Y7_FrameData[5] VGND VPWR Tile_X0Y9_FrameStrobe[3] latch
XFILLER_342_86 VPWR VGND sg13cmos5l_fill_1
XFILLER_85_70 VPWR VGND sg13cmos5l_decap_8
X_2021_ _2021_/Q Tile_X0Y4_FrameData[0] VGND VPWR Tile_X0Y9_FrameStrobe[2] latch
XFILLER_699_56 VPWR VGND sg13cmos5l_decap_8
XFILLER_443_137 VPWR VGND sg13cmos5l_decap_8
XANTENNA__2845__X Tile_X0Y6_E2BEGb[2] VPWR VGND sg13cmos5l_antennanp
XFILLER_62_142 VPWR VGND sg13cmos5l_decap_4
XFILLER_211_35 VPWR VGND sg13cmos5l_decap_8
XFILLER_451_181 VPWR VGND sg13cmos5l_decap_8
X_3972_ _3972_/X AXI_M_SOC_ARREADY _4011_/X _4015_/X _3994_/X _1265_/Q _1264_/Q VPWR
+ VGND sg13cmos5l_mux4_1
XFILLER_568_49 VPWR VGND sg13cmos5l_decap_8
XFILLER_210_118 VPWR VGND sg13cmos5l_decap_8
X_2923_ Tile_X0Y8_E2BEG[7] _4735_/X VPWR VGND sg13cmos5l_buf_1
XFILLER_349_141 VPWR VGND sg13cmos5l_decap_4
XFILLER_287_28 VPWR VGND sg13cmos5l_decap_8
XFILLER_203_170 VPWR VGND sg13cmos5l_decap_8
X_2854_ Tile_X0Y6_E6BEG[3] _4531_/X VPWR VGND sg13cmos5l_buf_1
XFILLER_79_0 VPWR VGND sg13cmos5l_fill_2
X_1805_ _1805_/Q Tile_X0Y3_FrameData[28] VGND VPWR Tile_X0Y9_FrameStrobe[4] latch
X_2785_ Tile_X0Y3_EE4BEG[11] _4175_/X VPWR VGND sg13cmos5l_buf_1
XFILLER_513_108 VPWR VGND sg13cmos5l_decap_8
XFILLER_702_208 VPWR VGND sg13cmos5l_fill_1
XFILLER_517_42 VPWR VGND sg13cmos5l_decap_8
XFILLER_506_160 VPWR VGND sg13cmos5l_fill_1
XFILLER_305_200 VPWR VGND sg13cmos5l_decap_8
XFILLER_116_111 VPWR VGND sg13cmos5l_decap_8
X_1736_ _1736_/Q Tile_X0Y3_FrameData[1] VGND VPWR Tile_X0Y9_FrameStrobe[1] latch
X_4524_ _4524_/X Tile_X0Y6_WW4END[3] AXI_M_SOC_RDATA27 _4571_/X _4559_/X _2559_/Q
+ _2558_/Q VPWR VGND sg13cmos5l_mux4_1
XFILLER_664_70 VPWR VGND sg13cmos5l_decap_8
XFILLER_506_182 VPWR VGND sg13cmos5l_decap_8
XFILLER_236_21 VPWR VGND sg13cmos5l_decap_8
XFILLER_521_130 VPWR VGND sg13cmos5l_fill_1
X_1667_ _1667_/Q Tile_X0Y2_FrameData[14] VGND VPWR Tile_X0Y9_FrameStrobe[7] latch
X_4455_ _4455_/X _4418_/X _0157_/X _4417_/X _0143_/X _2229_/Q _2228_/Q VPWR VGND sg13cmos5l_mux4_1
XFILLER_521_152 VPWR VGND sg13cmos5l_decap_8
XFILLER_116_177 VPWR VGND sg13cmos5l_decap_4
XFILLER_383_71 VPWR VGND sg13cmos5l_decap_8
XFILLER_236_76 VPWR VGND sg13cmos5l_decap_8
X_0618_ _0618_/Q Tile_X0Y8_FrameData[21] VGND VPWR Tile_X0Y9_FrameStrobe[6] latch
X_3406_ Tile_X0Y2_E1BEG[1] _4037_/X VPWR VGND sg13cmos5l_buf_1
X_4386_ _4386_/X Tile_X0Y5_W2END[1] AXI_M_SOC_RLAST _4430_/X _4429_/X _2331_/Q _2330_/Q
+ VPWR VGND sg13cmos5l_mux4_1
XFILLER_682_104 VPWR VGND sg13cmos5l_fill_1
XFILLER_277_129 VPWR VGND sg13cmos5l_decap_8
X_1598_ _1598_/Q Tile_X0Y2_FrameData[19] VGND VPWR Tile_X0Y9_FrameStrobe[5] latch
XFILLER_131_158 VPWR VGND sg13cmos5l_decap_8
X_3337_ Tile_X0Y2_FrameData_O[8] Tile_X0Y2_FrameData[8] VPWR VGND sg13cmos5l_buf_1
XFILLER_533_63 VPWR VGND sg13cmos5l_decap_4
X_0549_ _0549_/Q Tile_X0Y8_FrameData[26] VGND VPWR Tile_X0Y9_FrameStrobe[4] latch
XFILLER_533_74 VPWR VGND sg13cmos5l_decap_8
XFILLER_680_91 VPWR VGND sg13cmos5l_decap_8
X_3268_ Tile_X0Y0_EE4BEG[4] _3824_/X VPWR VGND sg13cmos5l_buf_1
XFILLER_419_178 VPWR VGND sg13cmos5l_decap_4
XFILLER_623_204 VPWR VGND sg13cmos5l_fill_1
XFILLER_285_184 VPWR VGND sg13cmos5l_decap_8
XFILLER_690_170 VPWR VGND sg13cmos5l_decap_4
XANTENNA__2755__X Tile_X0Y3_FrameData_O[13] VPWR VGND sg13cmos5l_antennanp
X_2219_ _2219_/Q Tile_X0Y5_FrameData[26] VGND VPWR Tile_X0Y9_FrameStrobe[1] latch
XFILLER_45_109 VPWR VGND sg13cmos5l_decap_4
X_3199_ Tile_X0Y0_N2BEGb[7] _3903_/X VPWR VGND sg13cmos5l_buf_1
XFILLER_402_56 VPWR VGND sg13cmos5l_decap_4
XFILLER_38_183 VPWR VGND sg13cmos5l_fill_1
XFILLER_121_35 VPWR VGND sg13cmos5l_decap_8
XFILLER_81_17 VPWR VGND sg13cmos5l_fill_2
XFILLER_157_7 VPWR VGND sg13cmos5l_decap_8
XFILLER_198_169 VPWR VGND sg13cmos5l_decap_8
XFILLER_197_28 VPWR VGND sg13cmos5l_decap_8
XFILLER_201_129 VPWR VGND sg13cmos5l_decap_4
XANTENNA__3586__X Tile_X0Y9_FrameData_O[16] VPWR VGND sg13cmos5l_antennanp
XFILLER_558_71 VPWR VGND sg13cmos5l_decap_8
XFILLER_324_7 VPWR VGND sg13cmos5l_decap_8
XFILLER_355_133 VPWR VGND sg13cmos5l_decap_8
XFILLER_708_63 VPWR VGND sg13cmos5l_decap_8
XFILLER_355_188 VPWR VGND sg13cmos5l_decap_8
XFILLER_504_119 VPWR VGND sg13cmos5l_decap_8
XFILLER_427_42 VPWR VGND sg13cmos5l_decap_8
XFILLER_370_114 VPWR VGND sg13cmos5l_decap_8
XFILLER_30_21 VPWR VGND sg13cmos5l_decap_8
XFILLER_107_111 VPWR VGND sg13cmos5l_decap_8
XFILLER_146_21 VPWR VGND sg13cmos5l_decap_8
XFILLER_693_7 VPWR VGND sg13cmos5l_decap_8
XFILLER_122_114 VPWR VGND sg13cmos5l_decap_8
XFILLER_457_207 VPWR VGND sg13cmos5l_decap_8
XFILLER_146_98 VPWR VGND sg13cmos5l_decap_8
XFILLER_660_28 VPWR VGND sg13cmos5l_decap_8
XFILLER_443_63 VPWR VGND sg13cmos5l_decap_8
XFILLER_590_80 VPWR VGND sg13cmos5l_decap_4
XFILLER_425_126 VPWR VGND sg13cmos5l_decap_8
XFILLER_183_0 VPWR VGND sg13cmos5l_decap_8
XFILLER_291_132 VPWR VGND sg13cmos5l_decap_8
XFILLER_312_56 VPWR VGND sg13cmos5l_decap_8
XFILLER_312_67 VPWR VGND sg13cmos5l_fill_1
XFILLER_350_0 VPWR VGND sg13cmos5l_decap_8
XFILLER_232_210 VPWR VGND sg13cmos5l_fill_1
XFILLER_579_174 VPWR VGND sg13cmos5l_decap_4
XFILLER_448_0 VPWR VGND sg13cmos5l_decap_8
XFILLER_378_214 VPWR VGND sg13cmos5l_decap_4
XFILLER_55_95 VPWR VGND sg13cmos5l_decap_8
XFILLER_685_14 VPWR VGND sg13cmos5l_decap_8
XFILLER_615_0 VPWR VGND sg13cmos5l_decap_8
XANTENNA__3496__X Tile_X0Y1_E6BEG[6] VPWR VGND sg13cmos5l_antennanp
XFILLER_594_188 VPWR VGND sg13cmos5l_decap_8
XFILLER_535_211 VPWR VGND sg13cmos5l_fill_1
XFILLER_71_83 VPWR VGND sg13cmos5l_decap_8
XFILLER_72_7 VPWR VGND sg13cmos5l_decap_8
XFILLER_618_63 VPWR VGND sg13cmos5l_decap_8
XFILLER_145_217 VPWR VGND sg13cmos5l_fill_1
XFILLER_361_125 VPWR VGND sg13cmos5l_decap_4
XFILLER_337_42 VPWR VGND sg13cmos5l_decap_8
X_2570_ _2570_/Q Tile_X0Y6_FrameData[29] VGND VPWR Tile_X0Y9_FrameStrobe[4] latch
XFILLER_361_136 VPWR VGND sg13cmos5l_decap_8
XFILLER_484_70 VPWR VGND sg13cmos5l_decap_8
X_1521_ _1521_/Q Tile_X0Y2_FrameData[0] VGND VPWR Tile_X0Y9_FrameStrobe[2] latch
XFILLER_649_112 VPWR VGND sg13cmos5l_decap_8
X_4240_ _4240_/X Tile_X0Y2_W2MID[5] Tile_X0Y2_W2END[5] Tile_X0Y2_W6END[10] _4101_/X
+ _1625_/Q _1624_/Q VPWR VGND sg13cmos5l_mux4_1
XFILLER_448_207 VPWR VGND sg13cmos5l_decap_8
X_1452_ _1452_/Q Tile_X0Y2_FrameData[5] VGND VPWR Tile_X0Y9_FrameStrobe[0] latch
XFILLER_206_13 VPWR VGND sg13cmos5l_decap_8
XFILLER_634_84 VPWR VGND sg13cmos5l_decap_8
XFILLER_503_196 VPWR VGND sg13cmos5l_decap_8
XFILLER_649_189 VPWR VGND sg13cmos5l_decap_8
X_0403_ _0403_/Q Tile_X0Y7_FrameData[12] VGND VPWR Tile_X0Y9_FrameStrobe[7] latch
X_4171_ _4171_/X Tile_X0Y3_WW4END[8] AXI_M_SOC_BVALID _4230_/X _4205_/X _1799_/Q _1798_/Q
+ VPWR VGND sg13cmos5l_mux4_1
XFILLER_570_28 VPWR VGND sg13cmos5l_decap_8
XFILLER_353_63 VPWR VGND sg13cmos5l_decap_8
X_1383_ _1383_/Q Tile_X0Y1_FrameData[18] VGND VPWR Tile_X0Y9_FrameStrobe[6] latch
XFILLER_96_80 VPWR VGND sg13cmos5l_decap_8
X_3122_ Tile_X0Y7_EE4BEG[8] _4636_/X VPWR VGND sg13cmos5l_buf_1
X_0334_ _0334_/Q Tile_X0Y7_FrameData[17] VGND VPWR Tile_X0Y9_FrameStrobe[5] latch
XFILLER_605_215 VPWR VGND sg13cmos5l_fill_2
X_3053_ Tile_X0Y5_FrameData_O[12] Tile_X0Y5_FrameData[12] VPWR VGND sg13cmos5l_buf_1
XFILLER_503_77 VPWR VGND sg13cmos5l_decap_8
X_0265_ _0265_/Q Tile_X0Y7_FrameData[22] VGND VPWR Tile_X0Y9_FrameStrobe[3] latch
XFILLER_282_154 VPWR VGND sg13cmos5l_decap_8
XFILLER_282_165 VPWR VGND sg13cmos5l_fill_1
XFILLER_222_56 VPWR VGND sg13cmos5l_decap_8
X_2004_ _2004_/Q Tile_X0Y4_FrameData[17] VGND VPWR Tile_X0Y9_FrameStrobe[2] latch
X_0196_ _0196_/Q Tile_X0Y7_FrameData[27] VGND VPWR Tile_X0Y9_FrameStrobe[1] latch
XFILLER_298_49 VPWR VGND sg13cmos5l_decap_8
XFILLER_659_70 VPWR VGND sg13cmos5l_decap_8
XFILLER_50_123 VPWR VGND sg13cmos5l_fill_1
XFILLER_595_14 VPWR VGND sg13cmos5l_decap_8
XFILLER_585_155 VPWR VGND sg13cmos5l_fill_2
XFILLER_50_145 VPWR VGND sg13cmos5l_decap_8
X_3955_ _3955_/X Tile_X0Y1_WW4END[8] AXI_M_SOC_ARREADY _4016_/X _3989_/X _1299_/Q
+ _1298_/Q VPWR VGND sg13cmos5l_mux4_1
XFILLER_585_188 VPWR VGND sg13cmos5l_fill_2
XFILLER_188_180 VPWR VGND sg13cmos5l_fill_1
X_2906_ Tile_X0Y6_FrameData_O[27] Tile_X0Y6_FrameData[27] VPWR VGND sg13cmos5l_buf_1
XFILLER_526_211 VPWR VGND sg13cmos5l_fill_1
XFILLER_337_122 VPWR VGND sg13cmos5l_decap_4
X_3886_ _3886_/X _3849_/X _0086_/X Tile_X0Y0_S1END[1] Tile_X0Y0_S4END[1] _0985_/Q
+ _0984_/Q VPWR VGND sg13cmos5l_mux4_1
X_2837_ Tile_X0Y6_E2BEG[2] _4498_/X VPWR VGND sg13cmos5l_buf_1
XFILLER_528_74 VPWR VGND sg13cmos5l_decap_8
XFILLER_337_177 VPWR VGND sg13cmos5l_fill_2
XFILLER_247_42 VPWR VGND sg13cmos5l_decap_8
X_2768_ Tile_X0Y3_FrameData_O[26] Tile_X0Y3_FrameData[26] VPWR VGND sg13cmos5l_buf_1
XFILLER_151_209 VPWR VGND sg13cmos5l_decap_8
X_4507_ _4507_/X Tile_X0Y6_W2END[4] AXI_M_SOC_RDATA28 _4559_/X _4558_/X _2593_/Q _2592_/Q
+ VPWR VGND sg13cmos5l_mux4_1
X_1719_ _1719_/Q Tile_X0Y3_FrameData[18] VGND VPWR Tile_X0Y9_FrameStrobe[1] latch
X_2699_ _4085_/A3 VPWR VGND sg13cmos5l_tielo
XFILLER_104_103 VPWR VGND sg13cmos5l_decap_8
XFILLER_116_13 VPWR VGND sg13cmos5l_decap_8
X_4438_ _4438_/X _4920_/X _4924_/X _4928_/X _4901_/X _0903_/Q _0902_/Q VPWR VGND sg13cmos5l_mux4_1
XFILLER_104_147 VPWR VGND sg13cmos5l_fill_2
XFILLER_480_28 VPWR VGND sg13cmos5l_decap_8
XFILLER_76_28 VPWR VGND sg13cmos5l_decap_8
X_4369_ _4369_/X _4421_/X _4420_/X AXI_M_SOC_RRESP0 _4419_/X _2365_/Q _2364_/Q VPWR
+ VGND sg13cmos5l_mux4_1
XFILLER_263_96 VPWR VGND sg13cmos5l_decap_4
XFILLER_663_181 VPWR VGND sg13cmos5l_decap_8
XFILLER_413_77 VPWR VGND sg13cmos5l_decap_8
XFILLER_407_148 VPWR VGND sg13cmos5l_decap_8
XFILLER_274_7 VPWR VGND sg13cmos5l_decap_8
XFILLER_407_159 VPWR VGND sg13cmos5l_decap_8
XFILLER_710_42 VPWR VGND sg13cmos5l_decap_8
XFILLER_132_56 VPWR VGND sg13cmos5l_decap_8
XFILLER_273_187 VPWR VGND sg13cmos5l_decap_4
XFILLER_214_210 VPWR VGND sg13cmos5l_fill_1
XFILLER_25_21 VPWR VGND sg13cmos5l_decap_8
XFILLER_441_7 VPWR VGND sg13cmos5l_decap_8
XFILLER_539_7 VPWR VGND sg13cmos5l_decap_8
XFILLER_430_140 VPWR VGND sg13cmos5l_decap_8
XFILLER_576_133 VPWR VGND sg13cmos5l_decap_8
XFILLER_569_70 VPWR VGND sg13cmos5l_decap_8
XFILLER_186_106 VPWR VGND sg13cmos5l_decap_8
XFILLER_375_217 VPWR VGND sg13cmos5l_fill_1
XFILLER_328_111 VPWR VGND sg13cmos5l_decap_8
XFILLER_706_7 VPWR VGND sg13cmos5l_decap_8
XFILLER_591_136 VPWR VGND sg13cmos5l_fill_1
XFILLER_41_20 VPWR VGND sg13cmos5l_decap_8
XFILLER_655_28 VPWR VGND sg13cmos5l_decap_8
XFILLER_438_63 VPWR VGND sg13cmos5l_decap_8
XFILLER_328_188 VPWR VGND sg13cmos5l_decap_4
XFILLER_489_107 VPWR VGND sg13cmos5l_fill_1
XFILLER_343_114 VPWR VGND sg13cmos5l_decap_8
XFILLER_210_2 VPWR VGND sg13cmos5l_fill_1
XFILLER_194_194 VPWR VGND sg13cmos5l_decap_4
XFILLER_308_2 VPWR VGND sg13cmos5l_fill_1
XFILLER_497_140 VPWR VGND sg13cmos5l_decap_8
XFILLER_9_0 VPWR VGND sg13cmos5l_decap_8
XFILLER_351_180 VPWR VGND sg13cmos5l_decap_8
XFILLER_671_49 VPWR VGND sg13cmos5l_decap_8
XFILLER_500_133 VPWR VGND sg13cmos5l_decap_8
XFILLER_646_126 VPWR VGND sg13cmos5l_decap_8
XFILLER_604_21 VPWR VGND sg13cmos5l_decap_8
XFILLER_398_0 VPWR VGND sg13cmos5l_decap_8
XFILLER_390_28 VPWR VGND sg13cmos5l_decap_8
XFILLER_2_14 VPWR VGND sg13cmos5l_decap_8
XFILLER_604_98 VPWR VGND sg13cmos5l_decap_4
XFILLER_249_195 VPWR VGND sg13cmos5l_fill_2
XFILLER_565_0 VPWR VGND sg13cmos5l_decap_8
XFILLER_323_77 VPWR VGND sg13cmos5l_decap_8
XFILLER_620_42 VPWR VGND sg13cmos5l_decap_8
X_0050_ AXI_M_SOC_AWLOCK _0937_/Q _3684_/X VPWR VGND sg13cmos5l_nor2b_1
XFILLER_17_142 VPWR VGND sg13cmos5l_fill_1
XFILLER_696_35 VPWR VGND sg13cmos5l_decap_8
XFILLER_567_133 VPWR VGND sg13cmos5l_decap_8
XFILLER_479_70 VPWR VGND sg13cmos5l_fill_2
XFILLER_567_166 VPWR VGND sg13cmos5l_fill_1
XFILLER_567_177 VPWR VGND sg13cmos5l_decap_8
XANTENNA_19 AXI_M_SOC_WREADY VPWR VGND sg13cmos5l_antennanp
XFILLER_567_199 VPWR VGND sg13cmos5l_decap_4
X_0952_ _0952_/Q Tile_X0Y0_FrameData[19] VGND VPWR Tile_X0Y9_FrameStrobe[0] latch
X_3740_ AXI_M_SOC_ARADDR12 Tile_X0Y9_W1END[0] Tile_X0Y9_WW4END[4] Tile_X0Y9_WW4END[12]
+ _4928_/X _0735_/Q _0734_/Q VPWR VGND sg13cmos5l_mux4_1
XFILLER_709_182 VPWR VGND sg13cmos5l_decap_8
XFILLER_629_84 VPWR VGND sg13cmos5l_decap_8
XFILLER_565_28 VPWR VGND sg13cmos5l_decap_8
XFILLER_348_63 VPWR VGND sg13cmos5l_decap_8
X_0883_ _0883_/Q Tile_X0Y9_FrameData[12] VGND VPWR Tile_X0Y9_FrameStrobe[6] latch
X_3671_ _3671_/X Tile_X0Y2_WW4END[1] Tile_X0Y2_WW4END[9] Tile_X0Y2_W6END[1] _4117_/X
+ _1503_/Q _1502_/Q VPWR VGND sg13cmos5l_mux4_1
XFILLER_118_217 VPWR VGND sg13cmos5l_fill_1
XFILLER_334_103 VPWR VGND sg13cmos5l_fill_1
XFILLER_495_91 VPWR VGND sg13cmos5l_decap_8
X_2622_ _2622_/Q Tile_X0Y6_FrameData[9] VGND VPWR Tile_X0Y9_FrameStrobe[5] latch
X_2553_ _2553_/Q Tile_X0Y6_FrameData[14] VGND VPWR Tile_X0Y9_FrameStrobe[3] latch
XFILLER_217_34 VPWR VGND sg13cmos5l_decap_8
X_1504_ _1504_/Q Tile_X0Y2_FrameData[17] VGND VPWR Tile_X0Y9_FrameStrobe[2] latch
XFILLER_287_213 VPWR VGND sg13cmos5l_decap_4
XFILLER_99_145 VPWR VGND sg13cmos5l_decap_4
X_2484_ _2484_/Q Tile_X0Y6_FrameData[19] VGND VPWR Tile_X0Y9_FrameStrobe[1] latch
XFILLER_581_49 VPWR VGND sg13cmos5l_decap_8
XFILLER_637_126 VPWR VGND sg13cmos5l_fill_2
XFILLER_514_21 VPWR VGND sg13cmos5l_decap_8
XFILLER_488_195 VPWR VGND sg13cmos5l_fill_1
X_1435_ _1435_/Q Tile_X0Y2_FrameData[22] VGND VPWR Tile_X0Y9_FrameStrobe[0] latch
X_4223_ _4223_/X _4197_/X _0088_/X _4196_/X Tile_X0Y0_S4END[13] _1727_/Q _1726_/Q
+ VPWR VGND sg13cmos5l_mux4_1
X_4154_ _4154_/X Tile_X0Y3_W2MID[1] AXI_M_SOC_WREADY _4207_/X _4206_/X _1833_/Q _1832_/Q
+ VPWR VGND sg13cmos5l_mux4_1
X_1366_ _1366_/Q Tile_X0Y1_FrameData[3] VGND VPWR Tile_X0Y9_FrameStrobe[5] latch
XFILLER_661_93 VPWR VGND sg13cmos5l_fill_1
XFILLER_255_110 VPWR VGND sg13cmos5l_decap_4
X_3105_ Tile_X0Y7_E6BEG[3] _4647_/X VPWR VGND sg13cmos5l_buf_1
XFILLER_233_66 VPWR VGND sg13cmos5l_fill_1
X_0317_ _0317_/Q Tile_X0Y7_FrameData[2] VGND VPWR Tile_X0Y9_FrameStrobe[4] latch
X_4085_ _4085_/X _4091_/X Tile_X0Y2_W6END[1] _4090_/X _4085_/A3 _1431_/Q _1430_/Q
+ VPWR VGND sg13cmos5l_mux4_1
XFILLER_380_94 VPWR VGND sg13cmos5l_decap_8
X_1297_ _1297_/Q Tile_X0Y1_FrameData[8] VGND VPWR Tile_X0Y9_FrameStrobe[3] latch
XFILLER_233_99 VPWR VGND sg13cmos5l_decap_8
XFILLER_530_42 VPWR VGND sg13cmos5l_decap_8
X_3036_ Tile_X0Y5_EE4BEG[11] _4399_/X VPWR VGND sg13cmos5l_buf_1
XFILLER_660_162 VPWR VGND sg13cmos5l_fill_1
XFILLER_404_118 VPWR VGND sg13cmos5l_fill_1
X_0248_ _0248_/Q Tile_X0Y7_FrameData[7] VGND VPWR Tile_X0Y9_FrameStrobe[2] latch
XFILLER_660_184 VPWR VGND sg13cmos5l_fill_1
XFILLER_270_157 VPWR VGND sg13cmos5l_fill_1
X_0179_ _0179_/Q Tile_X0Y7_FrameData[12] VGND VPWR Tile_X0Y9_FrameStrobe[0] latch
XFILLER_412_140 VPWR VGND sg13cmos5l_fill_2
XFILLER_389_70 VPWR VGND sg13cmos5l_decap_8
XFILLER_270_179 VPWR VGND sg13cmos5l_fill_2
XFILLER_357_217 VPWR VGND sg13cmos5l_fill_1
XFILLER_558_177 VPWR VGND sg13cmos5l_decap_8
XFILLER_707_119 VPWR VGND sg13cmos5l_decap_8
X_3938_ _3938_/X Tile_X0Y1_W2MID[1] AXI_M_SOC_ARREADY _3991_/X _3990_/X _1333_/Q _1332_/Q
+ VPWR VGND sg13cmos5l_mux4_1
XFILLER_573_147 VPWR VGND sg13cmos5l_decap_8
XFILLER_475_28 VPWR VGND sg13cmos5l_decap_8
XFILLER_258_63 VPWR VGND sg13cmos5l_fill_2
XFILLER_109_206 VPWR VGND sg13cmos5l_fill_1
XFILLER_109_217 VPWR VGND sg13cmos5l_fill_1
X_3869_ _3869_/X Tile_X0Y4_W1END[1] Tile_X0Y4_WW4END[1] Tile_X0Y4_W6END[9] _4337_/X
+ _2154_/Q _2153_/Q VPWR VGND sg13cmos5l_mux4_1
XFILLER_176_183 VPWR VGND sg13cmos5l_decap_8
XFILLER_715_174 VPWR VGND sg13cmos5l_decap_8
XFILLER_715_185 VPWR VGND sg13cmos5l_decap_4
XFILLER_191_153 VPWR VGND sg13cmos5l_decap_4
XFILLER_11_56 VPWR VGND sg13cmos5l_decap_8
XFILLER_127_56 VPWR VGND sg13cmos5l_decap_8
XFILLER_705_42 VPWR VGND sg13cmos5l_decap_8
XFILLER_491_49 VPWR VGND sg13cmos5l_decap_8
XFILLER_2_7 VPWR VGND sg13cmos5l_decap_8
XFILLER_274_84 VPWR VGND sg13cmos5l_decap_8
XFILLER_424_21 VPWR VGND sg13cmos5l_decap_8
XFILLER_391_7 VPWR VGND sg13cmos5l_decap_8
XFILLER_494_154 VPWR VGND sg13cmos5l_decap_8
XFILLER_489_7 VPWR VGND sg13cmos5l_decap_8
XFILLER_435_210 VPWR VGND sg13cmos5l_decap_8
XFILLER_424_98 VPWR VGND sg13cmos5l_decap_8
XFILLER_143_77 VPWR VGND sg13cmos5l_decap_8
XFILLER_100_150 VPWR VGND sg13cmos5l_decap_8
XFILLER_143_88 VPWR VGND sg13cmos5l_fill_1
XFILLER_656_7 VPWR VGND sg13cmos5l_decap_8
XFILLER_651_140 VPWR VGND sg13cmos5l_decap_8
XANTENNA__3104__X Tile_X0Y7_E6BEG[2] VPWR VGND sg13cmos5l_antennanp
XFILLER_440_42 VPWR VGND sg13cmos5l_decap_8
XFILLER_36_42 VPWR VGND sg13cmos5l_decap_4
XFILLER_596_217 VPWR VGND sg13cmos5l_fill_1
XFILLER_36_75 VPWR VGND sg13cmos5l_decap_4
XFILLER_160_2 VPWR VGND sg13cmos5l_fill_1
XANTENNA__2943__X Tile_X0Y8_E6BEG[11] VPWR VGND sg13cmos5l_antennanp
XFILLER_261_168 VPWR VGND sg13cmos5l_decap_8
XFILLER_403_151 VPWR VGND sg13cmos5l_decap_8
XFILLER_52_30 VPWR VGND sg13cmos5l_decap_8
XFILLER_159_139 VPWR VGND sg13cmos5l_fill_2
XFILLER_146_0 VPWR VGND sg13cmos5l_decap_8
XFILLER_14_189 VPWR VGND sg13cmos5l_decap_8
XFILLER_666_49 VPWR VGND sg13cmos5l_decap_8
XFILLER_385_28 VPWR VGND sg13cmos5l_decap_8
XFILLER_313_0 VPWR VGND sg13cmos5l_decap_8
XFILLER_168_96 VPWR VGND sg13cmos5l_decap_8
XFILLER_167_194 VPWR VGND sg13cmos5l_decap_8
XFILLER_318_66 VPWR VGND sg13cmos5l_decap_8
XFILLER_331_106 VPWR VGND sg13cmos5l_decap_8
XFILLER_318_99 VPWR VGND sg13cmos5l_decap_8
XFILLER_184_51 VPWR VGND sg13cmos5l_decap_8
XFILLER_615_42 VPWR VGND sg13cmos5l_decap_8
XFILLER_619_104 VPWR VGND sg13cmos5l_fill_2
XFILLER_674_210 VPWR VGND sg13cmos5l_fill_1
XFILLER_334_21 VPWR VGND sg13cmos5l_decap_8
XFILLER_682_0 VPWR VGND sg13cmos5l_decap_8
XFILLER_35_7 VPWR VGND sg13cmos5l_decap_8
XFILLER_334_65 VPWR VGND sg13cmos5l_fill_1
XFILLER_284_205 VPWR VGND sg13cmos5l_fill_2
X_1220_ _1220_/Q Tile_X0Y1_FrameData[21] VGND VPWR Tile_X0Y9_FrameStrobe[1] latch
XFILLER_334_87 VPWR VGND sg13cmos5l_fill_2
XFILLER_237_110 VPWR VGND sg13cmos5l_fill_2
X_1151_ _1151_/Q Tile_X0Y0_FrameData[12] VGND VPWR Tile_X0Y9_FrameStrobe[6] latch
XFILLER_631_63 VPWR VGND sg13cmos5l_decap_8
XFILLER_237_154 VPWR VGND sg13cmos5l_decap_8
XFILLER_203_14 VPWR VGND sg13cmos5l_decap_8
XANTENNA__3014__X Tile_X0Y5_E6BEG[1] VPWR VGND sg13cmos5l_antennanp
XFILLER_642_140 VPWR VGND sg13cmos5l_decap_8
X_0102_ AXI_M_SOC_ARLEN5 _0933_/Q _3765_/X VPWR VGND sg13cmos5l_nor2b_1
XFILLER_350_42 VPWR VGND sg13cmos5l_decap_8
XFILLER_252_113 VPWR VGND sg13cmos5l_fill_1
X_1082_ _1082_/Q Tile_X0Y0_FrameData[17] VGND VPWR Tile_X0Y9_FrameStrobe[4] latch
XFILLER_237_198 VPWR VGND sg13cmos5l_decap_8
XFILLER_587_217 VPWR VGND sg13cmos5l_fill_1
XFILLER_252_135 VPWR VGND sg13cmos5l_decap_8
XFILLER_93_70 VPWR VGND sg13cmos5l_decap_8
X_4910_ _4910_/X Tile_X0Y5_W1END[1] Tile_X0Y5_WW4END[13] Tile_X0Y5_W6END[5] _4452_/X
+ _2376_/Q _2375_/Q VPWR VGND sg13cmos5l_mux4_1
XANTENNA__2853__X Tile_X0Y6_E6BEG[2] VPWR VGND sg13cmos5l_antennanp
XFILLER_500_56 VPWR VGND sg13cmos5l_decap_8
X_4841_ _4841_/X _4922_/X _4926_/X _4930_/X _4902_/X _0861_/Q _0860_/Q VPWR VGND sg13cmos5l_mux4_1
X_4772_ _4772_/X _4777_/X Tile_X0Y8_W6END[0] _4776_/X _4772_/A3 _0423_/Q _0422_/Q
+ VPWR VGND sg13cmos5l_mux4_1
XFILLER_576_49 VPWR VGND sg13cmos5l_decap_8
X_1984_ _1984_/Q Tile_X0Y4_FrameData[5] VGND VPWR Tile_X0Y9_FrameStrobe[1] latch
XFILLER_359_84 VPWR VGND sg13cmos5l_decap_8
XFILLER_509_21 VPWR VGND sg13cmos5l_decap_8
XFILLER_158_150 VPWR VGND sg13cmos5l_decap_8
X_3723_ _3723_/X Tile_X0Y3_WW4END[0] Tile_X0Y3_WW4END[8] Tile_X0Y3_W6END[8] _4230_/X
+ _1741_/Q _1740_/Q VPWR VGND sg13cmos5l_mux4_1
XFILLER_295_28 VPWR VGND sg13cmos5l_decap_8
X_0935_ _0935_/Q Tile_X0Y9_FrameData[26] VGND VPWR Tile_X0Y9_FrameStrobe[8] latch
XFILLER_9_160 VPWR VGND sg13cmos5l_fill_1
XFILLER_307_114 VPWR VGND sg13cmos5l_decap_8
XFILLER_307_125 VPWR VGND sg13cmos5l_fill_2
X_0866_ _0866_/Q Tile_X0Y9_FrameData[29] VGND VPWR Tile_X0Y9_FrameStrobe[6] latch
X_3654_ AXI_M_SOC_AWADDR15 Tile_X0Y5_W1END[3] Tile_X0Y5_WW4END[7] Tile_X0Y5_WW4END[15]
+ _4466_/X _2241_/Q _2240_/Q VPWR VGND sg13cmos5l_mux4_1
XFILLER_61_0 VPWR VGND sg13cmos5l_fill_1
XFILLER_712_133 VPWR VGND sg13cmos5l_decap_8
XFILLER_173_153 VPWR VGND sg13cmos5l_decap_8
X_2605_ _2605_/Q Tile_X0Y6_FrameData[26] VGND VPWR Tile_X0Y9_FrameStrobe[5] latch
X_0797_ _0797_/Q Tile_X0Y9_FrameData[2] VGND VPWR Tile_X0Y9_FrameStrobe[3] latch
X_3585_ Tile_X0Y9_FrameData_O[15] Tile_X0Y9_FrameData[15] VPWR VGND sg13cmos5l_buf_1
XFILLER_511_217 VPWR VGND sg13cmos5l_fill_1
XFILLER_228_99 VPWR VGND sg13cmos5l_decap_8
XFILLER_322_128 VPWR VGND sg13cmos5l_decap_8
XFILLER_712_188 VPWR VGND sg13cmos5l_decap_4
XFILLER_525_42 VPWR VGND sg13cmos5l_decap_4
X_2536_ _2536_/Q Tile_X0Y6_FrameData[31] VGND VPWR Tile_X0Y9_FrameStrobe[3] latch
XFILLER_525_53 VPWR VGND sg13cmos5l_fill_2
XFILLER_672_70 VPWR VGND sg13cmos5l_decap_8
XFILLER_476_110 VPWR VGND sg13cmos5l_decap_8
XFILLER_244_21 VPWR VGND sg13cmos5l_decap_8
XFILLER_330_150 VPWR VGND sg13cmos5l_fill_1
X_2467_ _2467_/Q Tile_X0Y6_FrameData[4] VGND VPWR Tile_X0Y9_FrameStrobe[0] latch
XFILLER_87_159 VPWR VGND sg13cmos5l_decap_8
X_4206_ _4206_/X _4141_/X _4249_/X _4248_/X _4140_/X _1685_/Q _1684_/Q VPWR VGND sg13cmos5l_mux4_1
XFILLER_680_202 VPWR VGND sg13cmos5l_fill_1
XFILLER_476_187 VPWR VGND sg13cmos5l_fill_2
XFILLER_391_93 VPWR VGND sg13cmos5l_decap_8
X_1418_ _1418_/Q Tile_X0Y1_FrameData[15] VGND VPWR Tile_X0Y9_FrameStrobe[7] latch
XFILLER_244_98 VPWR VGND sg13cmos5l_decap_8
X_2398_ _2398_/Q Tile_X0Y5_FrameData[7] VGND VPWR Tile_X0Y9_FrameStrobe[6] latch
XFILLER_618_170 VPWR VGND sg13cmos5l_decap_4
XFILLER_618_181 VPWR VGND sg13cmos5l_decap_4
X_1349_ _1349_/Q Tile_X0Y1_FrameData[20] VGND VPWR Tile_X0Y9_FrameStrobe[5] latch
X_4137_ _4137_/X Tile_X0Y4_W2MID[3] Tile_X0Y4_W2END[3] Tile_X0Y4_W6END[3] _4318_/X
+ _2165_/Q _2164_/Q VPWR VGND sg13cmos5l_mux4_1
XFILLER_228_154 VPWR VGND sg13cmos5l_fill_2
XFILLER_113_14 VPWR VGND sg13cmos5l_decap_8
XFILLER_491_168 VPWR VGND sg13cmos5l_decap_8
XFILLER_260_42 VPWR VGND sg13cmos5l_decap_8
XFILLER_260_53 VPWR VGND sg13cmos5l_fill_2
XFILLER_228_198 VPWR VGND sg13cmos5l_decap_8
X_4068_ _4068_/X Tile_X0Y2_WW4END[3] AXI_M_SOC_AWREADY _4119_/X _4103_/X _1537_/Q
+ _1536_/Q VPWR VGND sg13cmos5l_mux4_1
XFILLER_243_146 VPWR VGND sg13cmos5l_fill_1
XFILLER_243_157 VPWR VGND sg13cmos5l_decap_8
XANTENNA__2763__X Tile_X0Y3_FrameData_O[21] VPWR VGND sg13cmos5l_antennanp
X_3019_ Tile_X0Y5_E6BEG[6] _4410_/X VPWR VGND sg13cmos5l_buf_1
XFILLER_410_56 VPWR VGND sg13cmos5l_decap_8
XFILLER_196_201 VPWR VGND sg13cmos5l_decap_8
XFILLER_546_114 VPWR VGND sg13cmos5l_fill_1
XFILLER_400_154 VPWR VGND sg13cmos5l_decap_4
XFILLER_237_7 VPWR VGND sg13cmos5l_decap_8
XFILLER_11_126 VPWR VGND sg13cmos5l_decap_8
XFILLER_486_49 VPWR VGND sg13cmos5l_decap_8
XFILLER_269_84 VPWR VGND sg13cmos5l_decap_8
XFILLER_419_21 VPWR VGND sg13cmos5l_decap_8
XFILLER_7_108 VPWR VGND sg13cmos5l_fill_1
XANTENNA__3594__X Tile_X0Y9_FrameData_O[24] VPWR VGND sg13cmos5l_antennanp
XFILLER_404_7 VPWR VGND sg13cmos5l_decap_8
XFILLER_419_98 VPWR VGND sg13cmos5l_decap_8
XFILLER_716_30 VPWR VGND sg13cmos5l_decap_8
XFILLER_138_77 VPWR VGND sg13cmos5l_decap_8
XFILLER_502_217 VPWR VGND sg13cmos5l_fill_1
XFILLER_313_117 VPWR VGND sg13cmos5l_decap_8
XFILLER_716_85 VPWR VGND sg13cmos5l_decap_8
XFILLER_716_96 VPWR VGND sg13cmos5l_fill_1
XFILLER_435_42 VPWR VGND sg13cmos5l_decap_8
XFILLER_582_70 VPWR VGND sg13cmos5l_decap_8
XFILLER_321_161 VPWR VGND sg13cmos5l_fill_1
XANTENNA__2938__X Tile_X0Y8_E6BEG[6] VPWR VGND sg13cmos5l_antennanp
XFILLER_78_137 VPWR VGND sg13cmos5l_decap_8
XFILLER_321_194 VPWR VGND sg13cmos5l_decap_4
XFILLER_408_210 VPWR VGND sg13cmos5l_fill_2
XFILLER_609_170 VPWR VGND sg13cmos5l_decap_4
XFILLER_304_35 VPWR VGND sg13cmos5l_decap_8
XFILLER_47_41 VPWR VGND sg13cmos5l_decap_8
XFILLER_451_63 VPWR VGND sg13cmos5l_decap_8
XFILLER_19_215 VPWR VGND sg13cmos5l_fill_2
XFILLER_47_52 VPWR VGND sg13cmos5l_fill_1
XFILLER_482_179 VPWR VGND sg13cmos5l_decap_4
XFILLER_234_124 VPWR VGND sg13cmos5l_decap_8
XFILLER_624_184 VPWR VGND sg13cmos5l_fill_2
XFILLER_263_0 VPWR VGND sg13cmos5l_decap_8
XFILLER_170_97 VPWR VGND sg13cmos5l_decap_8
XFILLER_320_67 VPWR VGND sg13cmos5l_fill_2
XFILLER_103_91 VPWR VGND sg13cmos5l_decap_8
XFILLER_430_0 VPWR VGND sg13cmos5l_decap_8
XFILLER_537_103 VPWR VGND sg13cmos5l_decap_8
XFILLER_242_190 VPWR VGND sg13cmos5l_decap_8
XFILLER_528_0 VPWR VGND sg13cmos5l_decap_8
XFILLER_63_95 VPWR VGND sg13cmos5l_decap_8
XFILLER_388_194 VPWR VGND sg13cmos5l_decap_4
XFILLER_8_35 VPWR VGND sg13cmos5l_decap_8
XFILLER_329_21 VPWR VGND sg13cmos5l_decap_8
XFILLER_693_14 VPWR VGND sg13cmos5l_decap_8
XFILLER_552_128 VPWR VGND sg13cmos5l_fill_2
X_0720_ _0720_/Q Tile_X0Y9_FrameData[15] VGND VPWR Tile_X0Y9_FrameStrobe[1] latch
XFILLER_10_192 VPWR VGND sg13cmos5l_decap_8
X_0651_ _0651_/Q Tile_X0Y8_FrameData[20] VGND VPWR Tile_X0Y9_FrameStrobe[7] latch
XFILLER_626_63 VPWR VGND sg13cmos5l_decap_8
XANTENNA__3009__X Tile_X0Y5_E2BEGb[4] VPWR VGND sg13cmos5l_antennanp
XFILLER_345_42 VPWR VGND sg13cmos5l_decap_8
XFILLER_304_139 VPWR VGND sg13cmos5l_decap_8
X_3370_ Tile_X0Y2_EE4BEG[9] _4065_/X VPWR VGND sg13cmos5l_buf_1
XFILLER_560_194 VPWR VGND sg13cmos5l_fill_1
XFILLER_170_145 VPWR VGND sg13cmos5l_decap_8
X_0582_ _0582_/Q Tile_X0Y8_FrameData[25] VGND VPWR Tile_X0Y9_FrameStrobe[5] latch
XFILLER_170_156 VPWR VGND sg13cmos5l_fill_1
XFILLER_647_210 VPWR VGND sg13cmos5l_decap_8
XFILLER_492_70 VPWR VGND sg13cmos5l_decap_8
XFILLER_170_178 VPWR VGND sg13cmos5l_decap_8
X_2321_ _2321_/Q Tile_X0Y5_FrameData[20] VGND VPWR Tile_X0Y9_FrameStrobe[4] latch
XANTENNA__2848__X Tile_X0Y6_E2BEGb[5] VPWR VGND sg13cmos5l_antennanp
XFILLER_312_161 VPWR VGND sg13cmos5l_fill_1
XFILLER_69_137 VPWR VGND sg13cmos5l_decap_8
XFILLER_69_148 VPWR VGND sg13cmos5l_fill_2
XFILLER_473_102 VPWR VGND sg13cmos5l_fill_1
X_2252_ _2252_/Q Tile_X0Y5_FrameData[25] VGND VPWR Tile_X0Y9_FrameStrobe[2] latch
XFILLER_458_187 VPWR VGND sg13cmos5l_decap_8
XFILLER_642_84 VPWR VGND sg13cmos5l_decap_8
XFILLER_214_35 VPWR VGND sg13cmos5l_decap_8
X_1203_ _1203_/Q Tile_X0Y1_FrameData[6] VGND VPWR Tile_X0Y9_FrameStrobe[0] latch
XFILLER_361_63 VPWR VGND sg13cmos5l_decap_8
X_2183_ _2183_/Q Tile_X0Y5_FrameData[30] VGND VPWR Tile_X0Y9_FrameStrobe[0] latch
XFILLER_361_74 VPWR VGND sg13cmos5l_fill_2
XFILLER_615_140 VPWR VGND sg13cmos5l_decap_8
XFILLER_414_202 VPWR VGND sg13cmos5l_fill_2
X_1134_ _1134_/Q Tile_X0Y0_FrameData[29] VGND VPWR Tile_X0Y9_FrameStrobe[6] latch
XFILLER_225_113 VPWR VGND sg13cmos5l_decap_4
XFILLER_225_135 VPWR VGND sg13cmos5l_decap_8
XFILLER_92_173 VPWR VGND sg13cmos5l_fill_2
XFILLER_225_157 VPWR VGND sg13cmos5l_decap_8
X_1065_ _1065_/Q Tile_X0Y0_FrameData[2] VGND VPWR Tile_X0Y9_FrameStrobe[3] latch
XFILLER_630_176 VPWR VGND sg13cmos5l_fill_2
XFILLER_379_150 VPWR VGND sg13cmos5l_decap_8
XFILLER_240_127 VPWR VGND sg13cmos5l_decap_4
XFILLER_379_161 VPWR VGND sg13cmos5l_fill_1
XFILLER_587_59 VPWR VGND sg13cmos5l_decap_8
XFILLER_379_194 VPWR VGND sg13cmos5l_fill_2
X_4824_ _4824_/X Tile_X0Y9_W1END[0] Tile_X0Y9_W6END[8] _4928_/X _4892_/X _0891_/Q
+ _0890_/Q VPWR VGND sg13cmos5l_mux4_1
XFILLER_667_70 VPWR VGND sg13cmos5l_fill_1
XFILLER_528_158 VPWR VGND sg13cmos5l_decap_8
XFILLER_239_21 VPWR VGND sg13cmos5l_decap_8
XFILLER_667_81 VPWR VGND sg13cmos5l_decap_8
X_4755_ _4755_/X Tile_X0Y8_WW4END[4] AXI_M_SOC_RDATA12 _4804_/X _4790_/X _0537_/Q
+ _0536_/Q VPWR VGND sg13cmos5l_mux4_1
X_1967_ _1967_/Q Tile_X0Y4_FrameData[22] VGND VPWR Tile_X0Y9_FrameStrobe[1] latch
XFILLER_386_71 VPWR VGND sg13cmos5l_decap_8
X_3706_ AXI_M_SOC_WDATA16 Tile_X0Y6_WW4END[0] Tile_X0Y6_WW4END[8] Tile_X0Y6_W6END[0]
+ _4568_/X _2527_/Q _2526_/Q VPWR VGND sg13cmos5l_mux4_1
X_0918_ _0918_/Q Tile_X0Y9_FrameData[9] VGND VPWR Tile_X0Y9_FrameStrobe[7] latch
XFILLER_239_98 VPWR VGND sg13cmos5l_decap_4
X_4686_ _4686_/X _4665_/X Tile_X0Y9_N4END[10] _4664_/X _0054_/X _0211_/Q _0210_/Q
+ VPWR VGND sg13cmos5l_mux4_1
X_1898_ _1898_/Q Tile_X0Y3_FrameData[31] VGND VPWR Tile_X0Y9_FrameStrobe[7] latch
XFILLER_161_101 VPWR VGND sg13cmos5l_decap_8
X_3637_ Tile_X0Y9_S4BEG[15] _3637_/A VPWR VGND sg13cmos5l_buf_1
XFILLER_146_186 VPWR VGND sg13cmos5l_decap_8
XFILLER_108_14 VPWR VGND sg13cmos5l_decap_8
X_0849_ _0849_/Q Tile_X0Y9_FrameData[14] VGND VPWR Tile_X0Y9_FrameStrobe[5] latch
XFILLER_536_74 VPWR VGND sg13cmos5l_fill_1
XFILLER_496_216 VPWR VGND sg13cmos5l_fill_2
X_3568_ Tile_X0Y9_EE4BEG[14] _4878_/X VPWR VGND sg13cmos5l_buf_1
XFILLER_638_210 VPWR VGND sg13cmos5l_fill_1
XFILLER_108_69 VPWR VGND sg13cmos5l_decap_4
XFILLER_68_29 VPWR VGND sg13cmos5l_decap_8
XANTENNA__2758__X Tile_X0Y3_FrameData_O[16] VPWR VGND sg13cmos5l_antennanp
X_2519_ _2519_/Q Tile_X0Y6_FrameData[16] VGND VPWR Tile_X0Y9_FrameStrobe[2] latch
XFILLER_303_172 VPWR VGND sg13cmos5l_decap_8
X_3499_ Tile_X0Y1_E6BEG[9] _3973_/X VPWR VGND sg13cmos5l_buf_1
XFILLER_464_102 VPWR VGND sg13cmos5l_decap_8
XFILLER_449_176 VPWR VGND sg13cmos5l_decap_8
XFILLER_653_202 VPWR VGND sg13cmos5l_decap_8
XFILLER_552_84 VPWR VGND sg13cmos5l_decap_8
XFILLER_702_21 VPWR VGND sg13cmos5l_decap_8
XFILLER_552_95 VPWR VGND sg13cmos5l_fill_1
XFILLER_124_35 VPWR VGND sg13cmos5l_decap_8
XFILLER_271_63 VPWR VGND sg13cmos5l_decap_8
XFILLER_187_7 VPWR VGND sg13cmos5l_decap_8
XFILLER_606_151 VPWR VGND sg13cmos5l_decap_4
XFILLER_702_98 VPWR VGND sg13cmos5l_decap_8
XANTENNA__3589__X Tile_X0Y9_FrameData_O[19] VPWR VGND sg13cmos5l_antennanp
XFILLER_621_132 VPWR VGND sg13cmos5l_fill_2
XFILLER_421_77 VPWR VGND sg13cmos5l_decap_8
XFILLER_83_195 VPWR VGND sg13cmos5l_decap_8
XFILLER_354_7 VPWR VGND sg13cmos5l_decap_8
XFILLER_140_56 VPWR VGND sg13cmos5l_decap_8
XFILLER_17_99 VPWR VGND sg13cmos5l_decap_8
XFILLER_521_7 VPWR VGND sg13cmos5l_decap_8
XFILLER_33_21 VPWR VGND sg13cmos5l_decap_8
XFILLER_385_131 VPWR VGND sg13cmos5l_decap_8
XFILLER_619_7 VPWR VGND sg13cmos5l_decap_8
XFILLER_577_70 VPWR VGND sg13cmos5l_decap_8
XFILLER_318_209 VPWR VGND sg13cmos5l_fill_2
XFILLER_149_76 VPWR VGND sg13cmos5l_fill_1
XFILLER_663_28 VPWR VGND sg13cmos5l_decap_8
XFILLER_298_105 VPWR VGND sg13cmos5l_decap_8
XFILLER_152_123 VPWR VGND sg13cmos5l_decap_8
XFILLER_487_216 VPWR VGND sg13cmos5l_fill_2
XFILLER_109_0 VPWR VGND sg13cmos5l_decap_8
XFILLER_688_187 VPWR VGND sg13cmos5l_decap_4
XFILLER_688_198 VPWR VGND sg13cmos5l_decap_4
XFILLER_152_178 VPWR VGND sg13cmos5l_decap_8
XFILLER_165_97 VPWR VGND sg13cmos5l_decap_8
XFILLER_455_135 VPWR VGND sg13cmos5l_fill_1
XFILLER_612_21 VPWR VGND sg13cmos5l_decap_8
XFILLER_380_0 VPWR VGND sg13cmos5l_decap_8
XFILLER_478_0 VPWR VGND sg13cmos5l_decap_8
XFILLER_181_85 VPWR VGND sg13cmos5l_decap_4
XFILLER_59_192 VPWR VGND sg13cmos5l_decap_8
XFILLER_181_96 VPWR VGND sg13cmos5l_decap_8
XFILLER_74_140 VPWR VGND sg13cmos5l_fill_1
XFILLER_688_14 VPWR VGND sg13cmos5l_decap_8
XFILLER_612_98 VPWR VGND sg13cmos5l_decap_8
XFILLER_74_162 VPWR VGND sg13cmos5l_decap_8
XANTENNA__3499__X Tile_X0Y1_E6BEG[9] VPWR VGND sg13cmos5l_antennanp
XFILLER_645_0 VPWR VGND sg13cmos5l_decap_8
XFILLER_74_72 VPWR VGND sg13cmos5l_decap_8
XFILLER_331_99 VPWR VGND sg13cmos5l_decap_8
XFILLER_612_187 VPWR VGND sg13cmos5l_decap_8
XFILLER_30_210 VPWR VGND sg13cmos5l_fill_1
X_2870_ Tile_X0Y6_EE4BEG[7] _4519_/X VPWR VGND sg13cmos5l_buf_1
XFILLER_487_70 VPWR VGND sg13cmos5l_decap_8
X_1821_ _1821_/Q Tile_X0Y3_FrameData[12] VGND VPWR Tile_X0Y9_FrameStrobe[4] latch
XFILLER_525_106 VPWR VGND sg13cmos5l_decap_4
XFILLER_90_93 VPWR VGND sg13cmos5l_decap_8
XFILLER_128_120 VPWR VGND sg13cmos5l_decap_8
X_4540_ _4540_/X _4545_/X Tile_X0Y6_W6END[0] _4544_/X _4540_/A3 _2447_/Q _2446_/Q
+ VPWR VGND sg13cmos5l_mux4_1
X_1752_ _1752_/Q Tile_X0Y3_FrameData[17] VGND VPWR Tile_X0Y9_FrameStrobe[2] latch
XFILLER_637_84 VPWR VGND sg13cmos5l_decap_8
XFILLER_209_35 VPWR VGND sg13cmos5l_decap_8
XFILLER_679_132 VPWR VGND sg13cmos5l_fill_2
XFILLER_391_178 VPWR VGND sg13cmos5l_decap_8
X_0703_ _0703_/Q Tile_X0Y9_FrameData[0] VGND VPWR Tile_X0Y9_FrameStrobe[0] latch
XFILLER_573_28 VPWR VGND sg13cmos5l_decap_8
XFILLER_356_63 VPWR VGND sg13cmos5l_decap_8
X_4471_ _4471_/X Tile_X0Y7_W2MID[6] Tile_X0Y7_W2END[6] Tile_X0Y7_W6END[6] _4671_/X
+ _0405_/Q _0404_/Q VPWR VGND sg13cmos5l_mux4_1
X_1683_ _1683_/Q Tile_X0Y3_FrameData[22] VGND VPWR Tile_X0Y9_FrameStrobe[0] latch
XFILLER_533_172 VPWR VGND sg13cmos5l_decap_8
XFILLER_289_127 VPWR VGND sg13cmos5l_decap_8
XFILLER_99_80 VPWR VGND sg13cmos5l_decap_8
X_3422_ Tile_X0Y4_FrameData_O[13] Tile_X0Y4_FrameData[13] VPWR VGND sg13cmos5l_buf_1
X_0634_ _0634_/Q Tile_X0Y8_FrameData[5] VGND VPWR Tile_X0Y9_FrameStrobe[6] latch
XFILLER_679_198 VPWR VGND sg13cmos5l_decap_8
XFILLER_289_149 VPWR VGND sg13cmos5l_decap_8
XFILLER_506_77 VPWR VGND sg13cmos5l_decap_8
X_0565_ _0565_/Q Tile_X0Y8_FrameData[10] VGND VPWR Tile_X0Y9_FrameStrobe[4] latch
X_3353_ Tile_X0Y2_FrameData_O[24] Tile_X0Y2_FrameData[24] VPWR VGND sg13cmos5l_buf_1
XFILLER_225_34 VPWR VGND sg13cmos5l_fill_2
X_2304_ _2304_/Q Tile_X0Y5_FrameData[5] VGND VPWR Tile_X0Y9_FrameStrobe[3] latch
XFILLER_635_202 VPWR VGND sg13cmos5l_fill_1
X_0496_ _0496_/Q Tile_X0Y8_FrameData[15] VGND VPWR Tile_X0Y9_FrameStrobe[2] latch
X_3284_ Tile_X0Y0_E6BEG[4] _3840_/X VPWR VGND sg13cmos5l_buf_1
XFILLER_522_21 VPWR VGND sg13cmos5l_decap_8
XFILLER_24_0 VPWR VGND sg13cmos5l_decap_8
X_2235_ _2235_/Q Tile_X0Y5_FrameData[10] VGND VPWR Tile_X0Y9_FrameStrobe[1] latch
XFILLER_446_179 VPWR VGND sg13cmos5l_fill_1
X_2166_ _2166_/Q Tile_X0Y4_FrameData[15] VGND VPWR Tile_X0Y9_FrameStrobe[7] latch
XFILLER_461_138 VPWR VGND sg13cmos5l_decap_8
XFILLER_399_201 VPWR VGND sg13cmos5l_fill_1
XFILLER_598_14 VPWR VGND sg13cmos5l_decap_8
XFILLER_65_173 VPWR VGND sg13cmos5l_decap_8
X_1117_ _1117_/Q Tile_X0Y0_FrameData[14] VGND VPWR Tile_X0Y9_FrameStrobe[5] latch
X_2097_ _2097_/Q Tile_X0Y4_FrameData[20] VGND VPWR Tile_X0Y9_FrameStrobe[5] latch
XFILLER_213_105 VPWR VGND sg13cmos5l_decap_8
XANTENNA__3202__X Tile_X0Y0_N2BEG[2] VPWR VGND sg13cmos5l_antennanp
X_1048_ _1048_/Q Tile_X0Y0_FrameData[19] VGND VPWR Tile_X0Y9_FrameStrobe[3] latch
XFILLER_367_120 VPWR VGND sg13cmos5l_decap_8
XFILLER_21_210 VPWR VGND sg13cmos5l_fill_1
XFILLER_397_70 VPWR VGND sg13cmos5l_decap_8
X_4807_ _4807_/X _4783_/X Tile_X0Y9_N4END[7] _4782_/X _0074_/X _0457_/Q _0456_/Q VPWR
+ VGND sg13cmos5l_mux4_1
XFILLER_516_117 VPWR VGND sg13cmos5l_decap_8
X_2999_ Tile_X0Y5_E2BEG[2] _4374_/X VPWR VGND sg13cmos5l_buf_1
X_4738_ _4738_/X Tile_X0Y8_W2END[5] AXI_M_SOC_RDATA13 _4789_/X _4788_/X _0571_/Q _0570_/Q
+ VPWR VGND sg13cmos5l_mux4_1
XFILLER_547_84 VPWR VGND sg13cmos5l_decap_4
XFILLER_119_35 VPWR VGND sg13cmos5l_decap_8
XFILLER_382_178 VPWR VGND sg13cmos5l_decap_4
XFILLER_119_164 VPWR VGND sg13cmos5l_decap_8
XFILLER_524_150 VPWR VGND sg13cmos5l_decap_8
XFILLER_483_28 VPWR VGND sg13cmos5l_decap_8
XFILLER_266_63 VPWR VGND sg13cmos5l_decap_8
XFILLER_134_112 VPWR VGND sg13cmos5l_decap_8
X_4669_ _4669_/X _4585_/X _4701_/X _4700_/X _4584_/X _0183_/Q _0182_/Q VPWR VGND sg13cmos5l_mux4_1
XFILLER_266_85 VPWR VGND sg13cmos5l_decap_8
XFILLER_102_7 VPWR VGND sg13cmos5l_decap_8
XFILLER_416_77 VPWR VGND sg13cmos5l_decap_8
XFILLER_295_119 VPWR VGND sg13cmos5l_decap_4
XFILLER_288_160 VPWR VGND sg13cmos5l_decap_8
XFILLER_135_56 VPWR VGND sg13cmos5l_decap_8
XFILLER_713_42 VPWR VGND sg13cmos5l_decap_8
XFILLER_626_202 VPWR VGND sg13cmos5l_fill_1
XFILLER_437_113 VPWR VGND sg13cmos5l_decap_8
XFILLER_282_84 VPWR VGND sg13cmos5l_decap_8
XFILLER_432_21 VPWR VGND sg13cmos5l_decap_8
XFILLER_693_190 VPWR VGND sg13cmos5l_decap_4
XFILLER_471_7 VPWR VGND sg13cmos5l_decap_8
XFILLER_28_21 VPWR VGND sg13cmos5l_decap_8
XFILLER_569_7 VPWR VGND sg13cmos5l_decap_8
XFILLER_641_216 VPWR VGND sg13cmos5l_fill_2
XFILLER_432_98 VPWR VGND sg13cmos5l_decap_8
XFILLER_151_44 VPWR VGND sg13cmos5l_fill_1
XFILLER_452_149 VPWR VGND sg13cmos5l_decap_8
XFILLER_301_14 VPWR VGND sg13cmos5l_decap_8
XFILLER_204_105 VPWR VGND sg13cmos5l_decap_8
XANTENNA__3112__X Tile_X0Y7_E6BEG[10] VPWR VGND sg13cmos5l_antennanp
XFILLER_71_132 VPWR VGND sg13cmos5l_decap_8
XFILLER_204_116 VPWR VGND sg13cmos5l_fill_1
XFILLER_460_171 VPWR VGND sg13cmos5l_fill_2
XFILLER_44_20 VPWR VGND sg13cmos5l_decap_8
XFILLER_658_28 VPWR VGND sg13cmos5l_decap_8
XFILLER_71_176 VPWR VGND sg13cmos5l_decap_8
XFILLER_44_64 VPWR VGND sg13cmos5l_decap_8
XFILLER_71_187 VPWR VGND sg13cmos5l_fill_2
XANTENNA__2951__X Tile_X0Y8_EE4BEG[7] VPWR VGND sg13cmos5l_antennanp
XFILLER_212_160 VPWR VGND sg13cmos5l_decap_8
XFILLER_8_203 VPWR VGND sg13cmos5l_fill_2
XFILLER_358_175 VPWR VGND sg13cmos5l_decap_8
XFILLER_373_112 VPWR VGND sg13cmos5l_decap_4
XFILLER_507_128 VPWR VGND sg13cmos5l_decap_8
XFILLER_100_81 VPWR VGND sg13cmos5l_fill_1
XFILLER_226_0 VPWR VGND sg13cmos5l_fill_2
XFILLER_674_49 VPWR VGND sg13cmos5l_decap_8
XFILLER_60_63 VPWR VGND sg13cmos5l_decap_8
XFILLER_607_21 VPWR VGND sg13cmos5l_decap_8
XFILLER_457_95 VPWR VGND sg13cmos5l_decap_8
XFILLER_522_109 VPWR VGND sg13cmos5l_fill_2
XFILLER_393_28 VPWR VGND sg13cmos5l_decap_8
XFILLER_125_112 VPWR VGND sg13cmos5l_decap_4
XFILLER_5_14 VPWR VGND sg13cmos5l_decap_8
XFILLER_530_131 VPWR VGND sg13cmos5l_fill_2
XFILLER_473_61 VPWR VGND sg13cmos5l_decap_8
XFILLER_595_0 VPWR VGND sg13cmos5l_decap_8
XFILLER_690_48 VPWR VGND sg13cmos5l_decap_8
XFILLER_530_175 VPWR VGND sg13cmos5l_decap_4
XFILLER_140_126 VPWR VGND sg13cmos5l_decap_8
XFILLER_691_105 VPWR VGND sg13cmos5l_fill_1
XFILLER_676_179 VPWR VGND sg13cmos5l_decap_4
XFILLER_623_42 VPWR VGND sg13cmos5l_decap_8
X_0350_ _0350_/Q Tile_X0Y7_FrameData[1] VGND VPWR Tile_X0Y9_FrameStrobe[5] latch
XFILLER_192_84 VPWR VGND sg13cmos5l_decap_8
XFILLER_94_202 VPWR VGND sg13cmos5l_fill_2
XFILLER_342_21 VPWR VGND sg13cmos5l_decap_8
XFILLER_294_152 VPWR VGND sg13cmos5l_decap_8
X_0281_ _0281_/Q Tile_X0Y7_FrameData[6] VGND VPWR Tile_X0Y9_FrameStrobe[3] latch
XFILLER_428_168 VPWR VGND sg13cmos5l_decap_8
XFILLER_428_179 VPWR VGND sg13cmos5l_fill_2
XFILLER_699_35 VPWR VGND sg13cmos5l_decap_8
X_2020_ _2020_/Q Tile_X0Y4_FrameData[1] VGND VPWR Tile_X0Y9_FrameStrobe[2] latch
XFILLER_632_216 VPWR VGND sg13cmos5l_fill_2
XFILLER_47_184 VPWR VGND sg13cmos5l_fill_1
XFILLER_211_14 VPWR VGND sg13cmos5l_decap_8
XFILLER_62_121 VPWR VGND sg13cmos5l_decap_8
XANTENNA__3022__X Tile_X0Y5_E6BEG[9] VPWR VGND sg13cmos5l_antennanp
XFILLER_250_211 VPWR VGND sg13cmos5l_fill_1
XFILLER_597_164 VPWR VGND sg13cmos5l_decap_8
XFILLER_568_28 VPWR VGND sg13cmos5l_decap_8
X_3971_ _3971_/X AXI_M_SOC_ARREADY _4012_/X _4016_/X _3995_/X _1267_/Q _1266_/Q VPWR
+ VGND sg13cmos5l_mux4_1
XFILLER_498_91 VPWR VGND sg13cmos5l_decap_8
XANTENNA__2861__X Tile_X0Y6_E6BEG[10] VPWR VGND sg13cmos5l_antennanp
X_2922_ Tile_X0Y8_E2BEG[6] _4734_/X VPWR VGND sg13cmos5l_buf_1
XFILLER_148_204 VPWR VGND sg13cmos5l_decap_4
X_2853_ Tile_X0Y6_E6BEG[2] _4530_/X VPWR VGND sg13cmos5l_buf_1
XFILLER_699_205 VPWR VGND sg13cmos5l_fill_1
XFILLER_699_216 VPWR VGND sg13cmos5l_fill_2
X_1804_ _1804_/Q Tile_X0Y3_FrameData[29] VGND VPWR Tile_X0Y9_FrameStrobe[4] latch
XFILLER_364_145 VPWR VGND sg13cmos5l_decap_8
XFILLER_584_49 VPWR VGND sg13cmos5l_decap_8
X_2784_ Tile_X0Y3_EE4BEG[10] _4174_/X VPWR VGND sg13cmos5l_buf_1
XFILLER_517_21 VPWR VGND sg13cmos5l_decap_8
X_4523_ _4523_/X Tile_X0Y6_WW4END[4] AXI_M_SOC_RDATA28 _4572_/X _4558_/X _2561_/Q
+ _2560_/Q VPWR VGND sg13cmos5l_mux4_1
X_1735_ _1735_/Q Tile_X0Y3_FrameData[2] VGND VPWR Tile_X0Y9_FrameStrobe[1] latch
XANTENNA__3692__X AXI_M_SOC_WDATA2 VPWR VGND sg13cmos5l_antennanp
X_4454_ _4454_/X _4427_/X _0097_/X _4426_/X _0156_/X _2231_/Q _2230_/Q VPWR VGND sg13cmos5l_mux4_1
X_1666_ _1666_/Q Tile_X0Y2_FrameData[15] VGND VPWR Tile_X0Y9_FrameStrobe[7] latch
XFILLER_667_135 VPWR VGND sg13cmos5l_fill_1
XFILLER_236_55 VPWR VGND sg13cmos5l_decap_8
XFILLER_320_204 VPWR VGND sg13cmos5l_fill_2
X_3405_ Tile_X0Y2_E1BEG[0] _4036_/X VPWR VGND sg13cmos5l_buf_1
XFILLER_667_157 VPWR VGND sg13cmos5l_fill_2
XFILLER_131_115 VPWR VGND sg13cmos5l_decap_8
X_0617_ _0617_/Q Tile_X0Y8_FrameData[22] VGND VPWR Tile_X0Y9_FrameStrobe[6] latch
XFILLER_466_208 VPWR VGND sg13cmos5l_fill_1
X_4385_ _4385_/X Tile_X0Y5_W2END[2] AXI_M_SOC_RRESP0 _4432_/X _4431_/X _2333_/Q _2332_/Q
+ VPWR VGND sg13cmos5l_mux4_1
XFILLER_277_119 VPWR VGND sg13cmos5l_fill_2
X_1597_ _1597_/Q Tile_X0Y2_FrameData[20] VGND VPWR Tile_X0Y9_FrameStrobe[5] latch
XFILLER_521_197 VPWR VGND sg13cmos5l_decap_8
XFILLER_533_42 VPWR VGND sg13cmos5l_decap_8
X_3336_ Tile_X0Y2_FrameData_O[7] Tile_X0Y2_FrameData[7] VPWR VGND sg13cmos5l_buf_1
X_0548_ _0548_/Q Tile_X0Y8_FrameData[27] VGND VPWR Tile_X0Y9_FrameStrobe[4] latch
XFILLER_680_70 VPWR VGND sg13cmos5l_decap_8
XFILLER_252_21 VPWR VGND sg13cmos5l_decap_8
XFILLER_285_152 VPWR VGND sg13cmos5l_fill_1
XFILLER_105_48 VPWR VGND sg13cmos5l_decap_8
X_3267_ Tile_X0Y0_EE4BEG[3] _3823_/X VPWR VGND sg13cmos5l_buf_1
X_0479_ _0479_/Q Tile_X0Y8_FrameData[0] VGND VPWR Tile_X0Y9_FrameStrobe[1] latch
XFILLER_434_105 VPWR VGND sg13cmos5l_decap_8
XFILLER_252_65 VPWR VGND sg13cmos5l_decap_8
XFILLER_65_19 VPWR VGND sg13cmos5l_decap_8
XFILLER_623_216 VPWR VGND sg13cmos5l_fill_2
X_2218_ _2218_/Q Tile_X0Y5_FrameData[27] VGND VPWR Tile_X0Y9_FrameStrobe[1] latch
X_3198_ Tile_X0Y0_N2BEGb[6] _3901_/X VPWR VGND sg13cmos5l_buf_1
XFILLER_402_35 VPWR VGND sg13cmos5l_decap_8
XFILLER_38_162 VPWR VGND sg13cmos5l_decap_4
XFILLER_121_14 VPWR VGND sg13cmos5l_decap_8
X_2149_ _2149_/Q Tile_X0Y4_FrameData[0] VGND VPWR Tile_X0Y9_FrameStrobe[6] latch
XFILLER_588_164 VPWR VGND sg13cmos5l_decap_8
XFILLER_387_215 VPWR VGND sg13cmos5l_fill_2
XFILLER_478_28 VPWR VGND sg13cmos5l_decap_8
XFILLER_588_186 VPWR VGND sg13cmos5l_decap_8
XFILLER_588_197 VPWR VGND sg13cmos5l_fill_1
XFILLER_53_187 VPWR VGND sg13cmos5l_fill_2
XFILLER_198_148 VPWR VGND sg13cmos5l_decap_8
XANTENNA__2771__X Tile_X0Y3_FrameData_O[29] VPWR VGND sg13cmos5l_antennanp
XFILLER_201_108 VPWR VGND sg13cmos5l_decap_8
XFILLER_201_91 VPWR VGND sg13cmos5l_decap_8
XFILLER_14_56 VPWR VGND sg13cmos5l_decap_8
XFILLER_355_112 VPWR VGND sg13cmos5l_decap_8
XFILLER_14_67 VPWR VGND sg13cmos5l_fill_1
XFILLER_14_89 VPWR VGND sg13cmos5l_decap_8
XFILLER_708_42 VPWR VGND sg13cmos5l_decap_8
XFILLER_317_7 VPWR VGND sg13cmos5l_decap_8
XFILLER_494_49 VPWR VGND sg13cmos5l_decap_8
XFILLER_277_84 VPWR VGND sg13cmos5l_decap_8
XFILLER_427_21 VPWR VGND sg13cmos5l_decap_8
XFILLER_212_6 VPWR VGND sg13cmos5l_decap_8
XFILLER_5_217 VPWR VGND sg13cmos5l_fill_1
XFILLER_512_131 VPWR VGND sg13cmos5l_decap_8
XFILLER_107_156 VPWR VGND sg13cmos5l_fill_1
XFILLER_427_98 VPWR VGND sg13cmos5l_decap_8
XFILLER_30_77 VPWR VGND sg13cmos5l_decap_4
XFILLER_107_178 VPWR VGND sg13cmos5l_decap_8
XFILLER_512_153 VPWR VGND sg13cmos5l_fill_2
XFILLER_686_7 VPWR VGND sg13cmos5l_decap_8
XFILLER_512_197 VPWR VGND sg13cmos5l_decap_8
XANTENNA__3107__X Tile_X0Y7_E6BEG[5] VPWR VGND sg13cmos5l_antennanp
XFILLER_443_42 VPWR VGND sg13cmos5l_decap_8
XFILLER_39_53 VPWR VGND sg13cmos5l_decap_8
XFILLER_162_21 VPWR VGND sg13cmos5l_fill_2
XFILLER_39_64 VPWR VGND sg13cmos5l_fill_2
XANTENNA__2946__X Tile_X0Y8_EE4BEG[2] VPWR VGND sg13cmos5l_antennanp
XFILLER_130_181 VPWR VGND sg13cmos5l_decap_4
XFILLER_425_105 VPWR VGND sg13cmos5l_decap_8
XFILLER_288_2 VPWR VGND sg13cmos5l_fill_1
XFILLER_681_182 VPWR VGND sg13cmos5l_fill_1
XFILLER_162_87 VPWR VGND sg13cmos5l_decap_4
XFILLER_176_0 VPWR VGND sg13cmos5l_decap_8
XFILLER_579_120 VPWR VGND sg13cmos5l_fill_1
XFILLER_55_41 VPWR VGND sg13cmos5l_fill_2
XFILLER_440_119 VPWR VGND sg13cmos5l_decap_4
XFILLER_55_74 VPWR VGND sg13cmos5l_decap_8
XFILLER_388_28 VPWR VGND sg13cmos5l_decap_8
XFILLER_189_126 VPWR VGND sg13cmos5l_decap_8
XFILLER_579_186 VPWR VGND sg13cmos5l_decap_8
XFILLER_343_0 VPWR VGND sg13cmos5l_decap_8
XFILLER_594_167 VPWR VGND sg13cmos5l_decap_8
XFILLER_71_62 VPWR VGND sg13cmos5l_decap_8
XFILLER_346_112 VPWR VGND sg13cmos5l_decap_8
XFILLER_510_0 VPWR VGND sg13cmos5l_decap_8
XFILLER_468_94 VPWR VGND sg13cmos5l_decap_8
XFILLER_608_0 VPWR VGND sg13cmos5l_decap_8
XFILLER_618_42 VPWR VGND sg13cmos5l_decap_8
XFILLER_361_104 VPWR VGND sg13cmos5l_decap_8
XFILLER_337_21 VPWR VGND sg13cmos5l_decap_8
XFILLER_187_95 VPWR VGND sg13cmos5l_decap_8
XFILLER_346_189 VPWR VGND sg13cmos5l_fill_2
X_1520_ _1520_/Q Tile_X0Y2_FrameData[1] VGND VPWR Tile_X0Y9_FrameStrobe[2] latch
XFILLER_503_175 VPWR VGND sg13cmos5l_decap_8
X_1451_ _1451_/Q Tile_X0Y2_FrameData[6] VGND VPWR Tile_X0Y9_FrameStrobe[0] latch
XFILLER_649_168 VPWR VGND sg13cmos5l_decap_8
XFILLER_634_63 VPWR VGND sg13cmos5l_decap_8
XFILLER_259_119 VPWR VGND sg13cmos5l_decap_8
XANTENNA__3017__X Tile_X0Y5_E6BEG[4] VPWR VGND sg13cmos5l_antennanp
XFILLER_353_42 VPWR VGND sg13cmos5l_decap_8
X_0402_ _0402_/Q Tile_X0Y7_FrameData[13] VGND VPWR Tile_X0Y9_FrameStrobe[7] latch
X_1382_ _1382_/Q Tile_X0Y1_FrameData[19] VGND VPWR Tile_X0Y9_FrameStrobe[6] latch
X_4170_ _4170_/X Tile_X0Y3_WW4END[9] AXI_M_SOC_WREADY _4231_/X _4207_/X _1801_/Q _1800_/Q
+ VPWR VGND sg13cmos5l_mux4_1
XFILLER_67_202 VPWR VGND sg13cmos5l_decap_8
XFILLER_206_69 VPWR VGND sg13cmos5l_decap_8
X_3121_ Tile_X0Y7_EE4BEG[7] _4635_/X VPWR VGND sg13cmos5l_buf_1
X_0333_ _0333_/Q Tile_X0Y7_FrameData[18] VGND VPWR Tile_X0Y9_FrameStrobe[5] latch
XFILLER_267_163 VPWR VGND sg13cmos5l_fill_1
XANTENNA__2856__X Tile_X0Y6_E6BEG[5] VPWR VGND sg13cmos5l_antennanp
XFILLER_416_105 VPWR VGND sg13cmos5l_decap_4
XFILLER_471_200 VPWR VGND sg13cmos5l_decap_4
XFILLER_416_116 VPWR VGND sg13cmos5l_decap_4
XFILLER_267_185 VPWR VGND sg13cmos5l_decap_8
XFILLER_503_56 VPWR VGND sg13cmos5l_decap_8
X_0264_ _0264_/Q Tile_X0Y7_FrameData[23] VGND VPWR Tile_X0Y9_FrameStrobe[3] latch
X_3052_ Tile_X0Y5_FrameData_O[11] Tile_X0Y5_FrameData[11] VPWR VGND sg13cmos5l_buf_1
XFILLER_672_182 VPWR VGND sg13cmos5l_decap_8
XFILLER_282_133 VPWR VGND sg13cmos5l_decap_8
XFILLER_82_216 VPWR VGND sg13cmos5l_fill_2
XFILLER_650_84 VPWR VGND sg13cmos5l_decap_8
XFILLER_222_35 VPWR VGND sg13cmos5l_decap_8
X_2003_ _2003_/Q Tile_X0Y4_FrameData[18] VGND VPWR Tile_X0Y9_FrameStrobe[2] latch
X_0195_ _0195_/Q Tile_X0Y7_FrameData[28] VGND VPWR Tile_X0Y9_FrameStrobe[1] latch
XFILLER_579_49 VPWR VGND sg13cmos5l_decap_8
XFILLER_369_215 VPWR VGND sg13cmos5l_fill_2
XFILLER_298_28 VPWR VGND sg13cmos5l_decap_8
XFILLER_35_187 VPWR VGND sg13cmos5l_decap_8
X_3954_ _3954_/X Tile_X0Y1_WW4END[9] AXI_M_SOC_ARREADY _4017_/X _3991_/X _1301_/Q
+ _1300_/Q VPWR VGND sg13cmos5l_mux4_1
XFILLER_91_0 VPWR VGND sg13cmos5l_decap_8
XFILLER_384_207 VPWR VGND sg13cmos5l_fill_2
XFILLER_378_61 VPWR VGND sg13cmos5l_fill_2
X_2905_ Tile_X0Y6_FrameData_O[26] Tile_X0Y6_FrameData[26] VPWR VGND sg13cmos5l_buf_1
X_3885_ _3885_/X _3848_/X _0067_/X Tile_X0Y0_S1END[0] Tile_X0Y0_S4END[0] _0987_/Q
+ _0986_/Q VPWR VGND sg13cmos5l_mux4_1
XFILLER_188_192 VPWR VGND sg13cmos5l_decap_4
XFILLER_528_42 VPWR VGND sg13cmos5l_decap_4
X_2836_ Tile_X0Y6_E2BEG[1] _4497_/X VPWR VGND sg13cmos5l_buf_1
XFILLER_675_70 VPWR VGND sg13cmos5l_decap_8
XFILLER_247_21 VPWR VGND sg13cmos5l_decap_8
XFILLER_541_215 VPWR VGND sg13cmos5l_fill_2
XFILLER_352_126 VPWR VGND sg13cmos5l_decap_4
X_2767_ Tile_X0Y3_FrameData_O[25] Tile_X0Y3_FrameData[25] VPWR VGND sg13cmos5l_buf_1
XFILLER_498_119 VPWR VGND sg13cmos5l_decap_8
X_4506_ _4506_/X Tile_X0Y6_W2END[5] AXI_M_SOC_RDATA29 _4557_/X _4556_/X _2595_/Q _2594_/Q
+ VPWR VGND sg13cmos5l_mux4_1
XFILLER_352_159 VPWR VGND sg13cmos5l_decap_8
X_1718_ _1718_/Q Tile_X0Y3_FrameData[19] VGND VPWR Tile_X0Y9_FrameStrobe[1] latch
XFILLER_247_98 VPWR VGND sg13cmos5l_fill_1
X_2698_ _4086_/A3 VPWR VGND sg13cmos5l_tielo
X_4437_ _4437_/X Tile_X0Y9_W1END[0] Tile_X0Y9_WW4END[0] Tile_X0Y9_W6END[8] _4916_/X
+ _0903_/Q _0902_/Q VPWR VGND sg13cmos5l_mux4_1
X_1649_ _1649_/Q Tile_X0Y2_FrameData[0] VGND VPWR Tile_X0Y9_FrameStrobe[6] latch
XFILLER_655_105 VPWR VGND sg13cmos5l_decap_8
XFILLER_360_192 VPWR VGND sg13cmos5l_decap_8
XFILLER_691_91 VPWR VGND sg13cmos5l_decap_8
XFILLER_263_42 VPWR VGND sg13cmos5l_decap_8
X_4368_ _4368_/X _4418_/X _4417_/X AXI_M_SOC_RRESP1 _4416_/X _2367_/Q _2366_/Q VPWR
+ VGND sg13cmos5l_mux4_1
XFILLER_263_64 VPWR VGND sg13cmos5l_decap_8
XFILLER_655_149 VPWR VGND sg13cmos5l_decap_8
XFILLER_116_69 VPWR VGND sg13cmos5l_decap_8
XANTENNA__2766__X Tile_X0Y3_FrameData_O[24] VPWR VGND sg13cmos5l_antennanp
X_3319_ Tile_X0Y4_EE4BEG[7] _4279_/X VPWR VGND sg13cmos5l_buf_1
XFILLER_670_108 VPWR VGND sg13cmos5l_fill_1
X_4299_ _4299_/X AXI_M_SOC_BRESP1 _4336_/X _4340_/X _4312_/X _2015_/Q _2014_/Q VPWR
+ VGND sg13cmos5l_mux4_1
XFILLER_462_200 VPWR VGND sg13cmos5l_decap_8
XFILLER_413_56 VPWR VGND sg13cmos5l_decap_8
XFILLER_407_127 VPWR VGND sg13cmos5l_decap_8
XFILLER_560_84 VPWR VGND sg13cmos5l_decap_8
XFILLER_73_216 VPWR VGND sg13cmos5l_fill_2
XFILLER_132_35 VPWR VGND sg13cmos5l_decap_8
XFILLER_710_21 VPWR VGND sg13cmos5l_decap_8
XFILLER_26_121 VPWR VGND sg13cmos5l_decap_8
XFILLER_489_49 VPWR VGND sg13cmos5l_decap_8
XFILLER_267_7 VPWR VGND sg13cmos5l_decap_8
XFILLER_214_200 VPWR VGND sg13cmos5l_decap_4
XFILLER_26_154 VPWR VGND sg13cmos5l_decap_8
XFILLER_710_98 VPWR VGND sg13cmos5l_decap_8
XFILLER_576_112 VPWR VGND sg13cmos5l_decap_8
XFILLER_212_90 VPWR VGND sg13cmos5l_decap_8
XANTENNA__3597__X Tile_X0Y9_FrameData_O[27] VPWR VGND sg13cmos5l_antennanp
XFILLER_434_7 VPWR VGND sg13cmos5l_decap_8
XFILLER_25_66 VPWR VGND sg13cmos5l_decap_4
XFILLER_576_189 VPWR VGND sg13cmos5l_decap_8
XFILLER_601_7 VPWR VGND sg13cmos5l_decap_8
XFILLER_438_42 VPWR VGND sg13cmos5l_decap_8
XFILLER_585_81 VPWR VGND sg13cmos5l_decap_8
XFILLER_194_184 VPWR VGND sg13cmos5l_fill_2
XFILLER_41_76 VPWR VGND sg13cmos5l_fill_1
XFILLER_157_54 VPWR VGND sg13cmos5l_fill_1
XFILLER_671_28 VPWR VGND sg13cmos5l_decap_8
XFILLER_500_112 VPWR VGND sg13cmos5l_decap_8
XFILLER_307_68 VPWR VGND sg13cmos5l_decap_4
XFILLER_173_20 VPWR VGND sg13cmos5l_decap_8
XFILLER_646_105 VPWR VGND sg13cmos5l_decap_8
XFILLER_497_196 VPWR VGND sg13cmos5l_decap_8
XFILLER_293_0 VPWR VGND sg13cmos5l_decap_8
XFILLER_604_77 VPWR VGND sg13cmos5l_decap_8
XFILLER_500_189 VPWR VGND sg13cmos5l_decap_8
XFILLER_249_163 VPWR VGND sg13cmos5l_decap_4
XFILLER_173_97 VPWR VGND sg13cmos5l_decap_8
XFILLER_661_108 VPWR VGND sg13cmos5l_fill_1
XFILLER_103_181 VPWR VGND sg13cmos5l_fill_2
XFILLER_654_182 VPWR VGND sg13cmos5l_decap_8
XFILLER_620_21 VPWR VGND sg13cmos5l_decap_8
XFILLER_460_0 VPWR VGND sg13cmos5l_decap_8
XFILLER_66_84 VPWR VGND sg13cmos5l_decap_8
XFILLER_558_0 VPWR VGND sg13cmos5l_decap_8
XFILLER_264_177 VPWR VGND sg13cmos5l_decap_8
XFILLER_413_119 VPWR VGND sg13cmos5l_decap_8
XFILLER_399_49 VPWR VGND sg13cmos5l_decap_8
XFILLER_406_182 VPWR VGND sg13cmos5l_fill_2
XFILLER_620_98 VPWR VGND sg13cmos5l_decap_8
XFILLER_696_14 VPWR VGND sg13cmos5l_decap_8
XFILLER_567_112 VPWR VGND sg13cmos5l_decap_8
XFILLER_32_124 VPWR VGND sg13cmos5l_decap_4
XFILLER_421_163 VPWR VGND sg13cmos5l_decap_8
XFILLER_32_146 VPWR VGND sg13cmos5l_fill_2
XANTENNA__3300__X Tile_X0Y0_E2BEG[0] VPWR VGND sg13cmos5l_antennanp
XFILLER_421_196 VPWR VGND sg13cmos5l_fill_1
XFILLER_709_161 VPWR VGND sg13cmos5l_decap_8
X_0951_ _0951_/Q Tile_X0Y0_FrameData[20] VGND VPWR Tile_X0Y9_FrameStrobe[0] latch
XFILLER_629_63 VPWR VGND sg13cmos5l_decap_8
XFILLER_582_126 VPWR VGND sg13cmos5l_decap_8
XFILLER_348_42 VPWR VGND sg13cmos5l_decap_8
X_3670_ AXI_M_SOC_AWADDR31 Tile_X0Y4_W1END[3] Tile_X0Y4_WW4END[7] Tile_X0Y4_WW4END[15]
+ _4351_/X _1983_/Q _1982_/Q VPWR VGND sg13cmos5l_mux4_1
XFILLER_319_156 VPWR VGND sg13cmos5l_decap_8
X_0882_ _0882_/Q Tile_X0Y9_FrameData[13] VGND VPWR Tile_X0Y9_FrameStrobe[6] latch
XFILLER_495_70 VPWR VGND sg13cmos5l_decap_8
X_2621_ _2621_/Q Tile_X0Y6_FrameData[10] VGND VPWR Tile_X0Y9_FrameStrobe[5] latch
XFILLER_523_215 VPWR VGND sg13cmos5l_fill_2
XFILLER_217_13 VPWR VGND sg13cmos5l_decap_8
X_2552_ _2552_/Q Tile_X0Y6_FrameData[15] VGND VPWR Tile_X0Y9_FrameStrobe[3] latch
XFILLER_645_84 VPWR VGND sg13cmos5l_decap_8
X_1503_ _1503_/Q Tile_X0Y2_FrameData[18] VGND VPWR Tile_X0Y9_FrameStrobe[2] latch
XFILLER_581_28 VPWR VGND sg13cmos5l_decap_8
X_2483_ _2483_/Q Tile_X0Y6_FrameData[20] VGND VPWR Tile_X0Y9_FrameStrobe[1] latch
XFILLER_637_105 VPWR VGND sg13cmos5l_decap_8
XFILLER_342_192 VPWR VGND sg13cmos5l_fill_1
XFILLER_364_96 VPWR VGND sg13cmos5l_decap_8
X_4222_ _4222_/X _4195_/X _0089_/X _4194_/X Tile_X0Y0_S4END[12] _1729_/Q _1728_/Q
+ VPWR VGND sg13cmos5l_mux4_1
X_1434_ _1434_/Q Tile_X0Y2_FrameData[23] VGND VPWR Tile_X0Y9_FrameStrobe[0] latch
X_4153_ _4153_/X Tile_X0Y3_W2MID[2] AXI_M_SOC_BVALID _4209_/X _4208_/X _1835_/Q _1834_/Q
+ VPWR VGND sg13cmos5l_mux4_1
X_1365_ _1365_/Q Tile_X0Y1_FrameData[4] VGND VPWR Tile_X0Y9_FrameStrobe[5] latch
XFILLER_652_119 VPWR VGND sg13cmos5l_decap_8
XFILLER_380_62 VPWR VGND sg13cmos5l_decap_8
X_3104_ Tile_X0Y7_E6BEG[2] _4646_/X VPWR VGND sg13cmos5l_buf_1
X_0316_ _0316_/Q Tile_X0Y7_FrameData[3] VGND VPWR Tile_X0Y9_FrameStrobe[4] latch
XFILLER_645_182 VPWR VGND sg13cmos5l_decap_8
X_4084_ _4084_/X _4089_/X Tile_X0Y2_W6END[0] _4088_/X _4084_/A3 _1433_/Q _1432_/Q
+ VPWR VGND sg13cmos5l_mux4_1
XFILLER_255_144 VPWR VGND sg13cmos5l_fill_1
X_1296_ _1296_/Q Tile_X0Y1_FrameData[9] VGND VPWR Tile_X0Y9_FrameStrobe[3] latch
XFILLER_530_21 VPWR VGND sg13cmos5l_decap_8
X_3035_ Tile_X0Y5_EE4BEG[10] _4398_/X VPWR VGND sg13cmos5l_buf_1
X_0247_ _0247_/Q Tile_X0Y7_FrameData[8] VGND VPWR Tile_X0Y9_FrameStrobe[2] latch
X_0178_ _0178_/Q Tile_X0Y7_FrameData[13] VGND VPWR Tile_X0Y9_FrameStrobe[0] latch
XANTENNA__3210__X Tile_X0Y0_N1BEG[2] VPWR VGND sg13cmos5l_antennanp
XFILLER_23_168 VPWR VGND sg13cmos5l_fill_2
X_3937_ _3937_/X Tile_X0Y1_W2MID[2] AXI_M_SOC_ARREADY _3993_/X _3992_/X _1335_/Q _1334_/Q
+ VPWR VGND sg13cmos5l_mux4_1
XFILLER_573_126 VPWR VGND sg13cmos5l_decap_8
XFILLER_258_42 VPWR VGND sg13cmos5l_decap_8
X_3868_ _3868_/X _3850_/X _0085_/X Tile_X0Y0_S1END[2] Tile_X0Y0_S4END[2] _0975_/Q
+ _0974_/Q VPWR VGND sg13cmos5l_mux4_1
XFILLER_715_153 VPWR VGND sg13cmos5l_decap_8
XFILLER_514_215 VPWR VGND sg13cmos5l_fill_2
XFILLER_325_115 VPWR VGND sg13cmos5l_fill_2
X_2819_ Tile_X0Y3_E1BEG[1] _4145_/X VPWR VGND sg13cmos5l_buf_1
XFILLER_581_181 VPWR VGND sg13cmos5l_decap_8
XFILLER_715_197 VPWR VGND sg13cmos5l_decap_4
X_3799_ _3799_/X _3879_/X _3864_/X _3863_/X _3859_/X _1144_/Q _1143_/Q VPWR VGND sg13cmos5l_mux4_1
XFILLER_11_35 VPWR VGND sg13cmos5l_decap_8
XFILLER_408_56 VPWR VGND sg13cmos5l_decap_8
XFILLER_555_84 VPWR VGND sg13cmos5l_decap_8
XFILLER_127_35 VPWR VGND sg13cmos5l_decap_8
XFILLER_705_21 VPWR VGND sg13cmos5l_decap_8
XFILLER_340_129 VPWR VGND sg13cmos5l_decap_8
XFILLER_491_28 VPWR VGND sg13cmos5l_decap_8
XFILLER_278_203 VPWR VGND sg13cmos5l_fill_1
XFILLER_274_63 VPWR VGND sg13cmos5l_decap_8
XFILLER_628_105 VPWR VGND sg13cmos5l_decap_4
XFILLER_479_174 VPWR VGND sg13cmos5l_fill_2
XFILLER_628_127 VPWR VGND sg13cmos5l_decap_8
XFILLER_494_133 VPWR VGND sg13cmos5l_decap_8
XFILLER_705_98 VPWR VGND sg13cmos5l_decap_8
XFILLER_207_90 VPWR VGND sg13cmos5l_decap_8
XFILLER_424_77 VPWR VGND sg13cmos5l_decap_8
XFILLER_384_7 VPWR VGND sg13cmos5l_decap_8
XFILLER_643_119 VPWR VGND sg13cmos5l_decap_8
XFILLER_636_160 VPWR VGND sg13cmos5l_fill_2
XFILLER_494_199 VPWR VGND sg13cmos5l_decap_4
XFILLER_143_56 VPWR VGND sg13cmos5l_decap_8
XFILLER_290_84 VPWR VGND sg13cmos5l_decap_8
XFILLER_46_216 VPWR VGND sg13cmos5l_fill_2
XFILLER_246_155 VPWR VGND sg13cmos5l_decap_8
XFILLER_440_21 VPWR VGND sg13cmos5l_decap_8
XFILLER_551_7 VPWR VGND sg13cmos5l_decap_8
XFILLER_36_21 VPWR VGND sg13cmos5l_decap_8
XFILLER_649_7 VPWR VGND sg13cmos5l_decap_8
XFILLER_246_199 VPWR VGND sg13cmos5l_decap_8
XFILLER_61_208 VPWR VGND sg13cmos5l_fill_1
XFILLER_651_196 VPWR VGND sg13cmos5l_decap_8
XFILLER_261_147 VPWR VGND sg13cmos5l_decap_8
XFILLER_403_130 VPWR VGND sg13cmos5l_fill_2
XFILLER_36_87 VPWR VGND sg13cmos5l_decap_8
XFILLER_14_124 VPWR VGND sg13cmos5l_fill_1
XANTENNA__3120__X Tile_X0Y7_EE4BEG[6] VPWR VGND sg13cmos5l_antennanp
XFILLER_666_28 VPWR VGND sg13cmos5l_decap_8
XFILLER_564_126 VPWR VGND sg13cmos5l_decap_8
XFILLER_564_137 VPWR VGND sg13cmos5l_fill_1
XFILLER_564_159 VPWR VGND sg13cmos5l_decap_4
XFILLER_139_0 VPWR VGND sg13cmos5l_decap_8
XFILLER_52_86 VPWR VGND sg13cmos5l_decap_8
XFILLER_22_190 VPWR VGND sg13cmos5l_decap_8
XFILLER_167_151 VPWR VGND sg13cmos5l_fill_1
XFILLER_316_104 VPWR VGND sg13cmos5l_decap_8
XFILLER_168_75 VPWR VGND sg13cmos5l_decap_8
XFILLER_167_173 VPWR VGND sg13cmos5l_decap_8
XFILLER_706_197 VPWR VGND sg13cmos5l_decap_8
XFILLER_306_0 VPWR VGND sg13cmos5l_decap_8
XFILLER_682_49 VPWR VGND sg13cmos5l_decap_8
XFILLER_615_21 VPWR VGND sg13cmos5l_decap_8
XFILLER_324_181 VPWR VGND sg13cmos5l_decap_8
XFILLER_674_200 VPWR VGND sg13cmos5l_fill_2
XFILLER_675_0 VPWR VGND sg13cmos5l_decap_8
XFILLER_28_7 VPWR VGND sg13cmos5l_decap_8
XFILLER_634_119 VPWR VGND sg13cmos5l_decap_8
XFILLER_77_94 VPWR VGND sg13cmos5l_decap_8
XFILLER_631_42 VPWR VGND sg13cmos5l_decap_8
X_1150_ _1150_/Q Tile_X0Y0_FrameData[13] VGND VPWR Tile_X0Y9_FrameStrobe[6] latch
XFILLER_350_21 VPWR VGND sg13cmos5l_decap_8
X_0101_ AXI_M_SOC_ARLEN6 _0933_/Q _3766_/X VPWR VGND sg13cmos5l_nor2b_1
XFILLER_237_177 VPWR VGND sg13cmos5l_decap_8
X_1081_ _1081_/Q Tile_X0Y0_FrameData[18] VGND VPWR Tile_X0Y9_FrameStrobe[4] latch
XFILLER_441_203 VPWR VGND sg13cmos5l_fill_1
XFILLER_587_207 VPWR VGND sg13cmos5l_fill_2
XFILLER_52_208 VPWR VGND sg13cmos5l_fill_2
XFILLER_642_196 VPWR VGND sg13cmos5l_fill_1
XFILLER_398_129 VPWR VGND sg13cmos5l_decap_4
XFILLER_350_98 VPWR VGND sg13cmos5l_decap_8
XFILLER_252_158 VPWR VGND sg13cmos5l_decap_8
XFILLER_500_35 VPWR VGND sg13cmos5l_decap_8
X_4840_ _4840_/X Tile_X0Y9_W1END[2] Tile_X0Y9_WW4END[14] Tile_X0Y9_W6END[6] _4918_/X
+ _0861_/Q _0860_/Q VPWR VGND sg13cmos5l_mux4_1
XANTENNA__3030__X Tile_X0Y5_EE4BEG[5] VPWR VGND sg13cmos5l_antennanp
XFILLER_576_28 VPWR VGND sg13cmos5l_decap_8
X_4771_ _4771_/X AXI_M_SOC_RDATA15 _4800_/X _4804_/X _4784_/X _0505_/Q _0504_/Q VPWR
+ VGND sg13cmos5l_mux4_1
XFILLER_555_126 VPWR VGND sg13cmos5l_decap_4
XFILLER_359_63 VPWR VGND sg13cmos5l_decap_8
X_1983_ _1983_/Q Tile_X0Y4_FrameData[6] VGND VPWR Tile_X0Y9_FrameStrobe[1] latch
XFILLER_20_127 VPWR VGND sg13cmos5l_fill_1
X_3722_ _3722_/X Tile_X0Y3_WW4END[7] Tile_X0Y3_WW4END[15] Tile_X0Y3_W6END[7] _4229_/X
+ _1743_/Q _1742_/Q VPWR VGND sg13cmos5l_mux4_1
XFILLER_20_149 VPWR VGND sg13cmos5l_decap_8
X_0934_ _0934_/Q Tile_X0Y9_FrameData[25] VGND VPWR Tile_X0Y9_FrameStrobe[8] latch
X_3653_ AXI_M_SOC_AWADDR14 Tile_X0Y5_W1END[2] Tile_X0Y5_WW4END[6] Tile_X0Y5_WW4END[14]
+ _4465_/X _2243_/Q _2242_/Q VPWR VGND sg13cmos5l_mux4_1
XFILLER_712_112 VPWR VGND sg13cmos5l_decap_8
X_0865_ _0865_/Q Tile_X0Y9_FrameData[30] VGND VPWR Tile_X0Y9_FrameStrobe[6] latch
XFILLER_509_99 VPWR VGND sg13cmos5l_fill_1
XFILLER_307_159 VPWR VGND sg13cmos5l_fill_1
X_2604_ _2604_/Q Tile_X0Y6_FrameData[27] VGND VPWR Tile_X0Y9_FrameStrobe[5] latch
X_3584_ Tile_X0Y9_FrameData_O[14] Tile_X0Y9_FrameData[14] VPWR VGND sg13cmos5l_buf_1
XFILLER_592_49 VPWR VGND sg13cmos5l_decap_8
XFILLER_322_107 VPWR VGND sg13cmos5l_decap_8
XFILLER_228_78 VPWR VGND sg13cmos5l_decap_8
X_0796_ _0796_/Q Tile_X0Y9_FrameData[3] VGND VPWR Tile_X0Y9_FrameStrobe[3] latch
XFILLER_525_21 VPWR VGND sg13cmos5l_decap_8
X_2535_ _2535_/Q Tile_X0Y6_FrameData[0] VGND VPWR Tile_X0Y9_FrameStrobe[2] latch
XFILLER_87_116 VPWR VGND sg13cmos5l_decap_8
X_2466_ _2466_/Q Tile_X0Y6_FrameData[5] VGND VPWR Tile_X0Y9_FrameStrobe[0] latch
XFILLER_476_144 VPWR VGND sg13cmos5l_decap_8
X_4205_ _4205_/X _4129_/X _4237_/X _4236_/X _4128_/X _1697_/Q _1696_/Q VPWR VGND sg13cmos5l_mux4_1
XFILLER_275_217 VPWR VGND sg13cmos5l_fill_1
X_1417_ _1417_/Q Tile_X0Y1_FrameData[16] VGND VPWR Tile_X0Y9_FrameStrobe[7] latch
X_2397_ _2397_/Q Tile_X0Y5_FrameData[8] VGND VPWR Tile_X0Y9_FrameStrobe[6] latch
XFILLER_476_199 VPWR VGND sg13cmos5l_decap_8
XANTENNA__3205__X Tile_X0Y0_N2BEG[5] VPWR VGND sg13cmos5l_antennanp
XFILLER_541_42 VPWR VGND sg13cmos5l_decap_4
X_4136_ _4136_/X Tile_X0Y1_W1END[0] Tile_X0Y1_W2MID[3] Tile_X0Y1_W2END[3] _3994_/X
+ _1373_/Q _1372_/Q VPWR VGND sg13cmos5l_mux4_1
XFILLER_3_91 VPWR VGND sg13cmos5l_decap_8
X_1348_ _1348_/Q Tile_X0Y1_FrameData[21] VGND VPWR Tile_X0Y9_FrameStrobe[5] latch
XFILLER_95_171 VPWR VGND sg13cmos5l_fill_1
XFILLER_260_21 VPWR VGND sg13cmos5l_decap_8
XFILLER_228_177 VPWR VGND sg13cmos5l_decap_8
X_4067_ _4067_/X Tile_X0Y2_WW4END[4] AXI_M_SOC_AWREADY _4120_/X _4102_/X _1539_/Q
+ _1538_/Q VPWR VGND sg13cmos5l_mux4_1
X_1279_ _1279_/Q Tile_X0Y1_FrameData[26] VGND VPWR Tile_X0Y9_FrameStrobe[3] latch
XFILLER_633_185 VPWR VGND sg13cmos5l_decap_8
XFILLER_243_136 VPWR VGND sg13cmos5l_fill_2
X_3018_ Tile_X0Y5_E6BEG[5] _4409_/X VPWR VGND sg13cmos5l_buf_1
XFILLER_410_35 VPWR VGND sg13cmos5l_decap_8
XFILLER_397_162 VPWR VGND sg13cmos5l_decap_8
XFILLER_486_28 VPWR VGND sg13cmos5l_decap_8
XFILLER_400_133 VPWR VGND sg13cmos5l_decap_8
XFILLER_269_63 VPWR VGND sg13cmos5l_decap_8
XFILLER_132_7 VPWR VGND sg13cmos5l_decap_8
XFILLER_400_188 VPWR VGND sg13cmos5l_decap_8
XFILLER_149_184 VPWR VGND sg13cmos5l_fill_2
XFILLER_353_210 VPWR VGND sg13cmos5l_fill_2
XFILLER_419_77 VPWR VGND sg13cmos5l_decap_8
XFILLER_22_56 VPWR VGND sg13cmos5l_decap_4
XFILLER_164_121 VPWR VGND sg13cmos5l_decap_8
XFILLER_703_112 VPWR VGND sg13cmos5l_decap_8
XFILLER_22_89 VPWR VGND sg13cmos5l_fill_2
XFILLER_138_56 VPWR VGND sg13cmos5l_decap_8
XFILLER_285_84 VPWR VGND sg13cmos5l_decap_8
XFILLER_716_64 VPWR VGND sg13cmos5l_decap_8
XFILLER_435_21 VPWR VGND sg13cmos5l_decap_8
XFILLER_105_210 VPWR VGND sg13cmos5l_fill_1
XFILLER_599_7 VPWR VGND sg13cmos5l_decap_8
XFILLER_306_192 VPWR VGND sg13cmos5l_decap_4
XFILLER_321_140 VPWR VGND sg13cmos5l_decap_8
XFILLER_435_98 VPWR VGND sg13cmos5l_decap_8
XFILLER_321_173 VPWR VGND sg13cmos5l_decap_8
XFILLER_266_217 VPWR VGND sg13cmos5l_fill_1
XFILLER_154_77 VPWR VGND sg13cmos5l_decap_8
XFILLER_304_14 VPWR VGND sg13cmos5l_decap_8
XFILLER_154_88 VPWR VGND sg13cmos5l_fill_2
XANTENNA__3115__X Tile_X0Y7_EE4BEG[1] VPWR VGND sg13cmos5l_antennanp
XFILLER_47_20 VPWR VGND sg13cmos5l_decap_8
XFILLER_451_42 VPWR VGND sg13cmos5l_decap_8
XFILLER_93_119 VPWR VGND sg13cmos5l_decap_8
XFILLER_219_144 VPWR VGND sg13cmos5l_decap_8
XFILLER_304_69 VPWR VGND sg13cmos5l_decap_8
XFILLER_423_203 VPWR VGND sg13cmos5l_fill_2
XANTENNA__2954__X Tile_X0Y8_EE4BEG[10] VPWR VGND sg13cmos5l_antennanp
XFILLER_170_76 VPWR VGND sg13cmos5l_decap_8
XFILLER_320_35 VPWR VGND sg13cmos5l_decap_8
XFILLER_103_70 VPWR VGND sg13cmos5l_decap_8
XFILLER_256_0 VPWR VGND sg13cmos5l_decap_8
XFILLER_677_49 VPWR VGND sg13cmos5l_decap_8
XFILLER_388_162 VPWR VGND sg13cmos5l_decap_8
XFILLER_63_74 VPWR VGND sg13cmos5l_decap_8
XFILLER_388_173 VPWR VGND sg13cmos5l_decap_8
XFILLER_396_28 VPWR VGND sg13cmos5l_decap_8
XFILLER_8_14 VPWR VGND sg13cmos5l_decap_8
XFILLER_537_137 VPWR VGND sg13cmos5l_fill_1
XFILLER_423_0 VPWR VGND sg13cmos5l_decap_8
XFILLER_626_42 VPWR VGND sg13cmos5l_decap_8
X_0650_ _0650_/Q Tile_X0Y8_FrameData[21] VGND VPWR Tile_X0Y9_FrameStrobe[7] latch
XFILLER_560_151 VPWR VGND sg13cmos5l_fill_1
XFILLER_304_107 VPWR VGND sg13cmos5l_decap_4
XFILLER_345_21 VPWR VGND sg13cmos5l_decap_8
X_0581_ _0581_/Q Tile_X0Y8_FrameData[26] VGND VPWR Tile_X0Y9_FrameStrobe[5] latch
X_2320_ _2320_/Q Tile_X0Y5_FrameData[21] VGND VPWR Tile_X0Y9_FrameStrobe[4] latch
XFILLER_88_82 VPWR VGND sg13cmos5l_decap_8
XFILLER_69_116 VPWR VGND sg13cmos5l_decap_8
XFILLER_345_98 VPWR VGND sg13cmos5l_decap_8
XFILLER_458_166 VPWR VGND sg13cmos5l_decap_8
XFILLER_257_206 VPWR VGND sg13cmos5l_fill_2
X_2251_ _2251_/Q Tile_X0Y5_FrameData[26] VGND VPWR Tile_X0Y9_FrameStrobe[2] latch
XFILLER_642_63 VPWR VGND sg13cmos5l_decap_8
XFILLER_214_14 VPWR VGND sg13cmos5l_decap_8
XFILLER_607_119 VPWR VGND sg13cmos5l_fill_2
XANTENNA__3025__X Tile_X0Y5_EE4BEG[0] VPWR VGND sg13cmos5l_antennanp
XFILLER_361_42 VPWR VGND sg13cmos5l_decap_8
X_1202_ _1202_/Q Tile_X0Y1_FrameData[7] VGND VPWR Tile_X0Y9_FrameStrobe[0] latch
X_2182_ _2182_/Q Tile_X0Y4_FrameData[31] VGND VPWR Tile_X0Y9_FrameStrobe[0] latch
XFILLER_361_97 VPWR VGND sg13cmos5l_decap_8
X_1133_ _1133_/Q Tile_X0Y0_FrameData[30] VGND VPWR Tile_X0Y9_FrameStrobe[6] latch
XANTENNA__2864__X Tile_X0Y6_EE4BEG[1] VPWR VGND sg13cmos5l_antennanp
XFILLER_92_141 VPWR VGND sg13cmos5l_decap_4
XFILLER_511_56 VPWR VGND sg13cmos5l_decap_8
X_1064_ _1064_/Q Tile_X0Y0_FrameData[3] VGND VPWR Tile_X0Y9_FrameStrobe[3] latch
XFILLER_230_35 VPWR VGND sg13cmos5l_decap_8
XFILLER_587_49 VPWR VGND sg13cmos5l_fill_2
XFILLER_233_180 VPWR VGND sg13cmos5l_fill_2
XFILLER_717_215 VPWR VGND sg13cmos5l_fill_2
X_4823_ _4823_/X Tile_X0Y7_W1END[3] Tile_X0Y7_W2MID[0] Tile_X0Y7_W2END[0] _4668_/X
+ _0357_/Q _0356_/Q VPWR VGND sg13cmos5l_mux4_1
XFILLER_583_210 VPWR VGND sg13cmos5l_decap_8
XANTENNA__3695__X AXI_M_SOC_WDATA5 VPWR VGND sg13cmos5l_antennanp
X_4754_ _4754_/X Tile_X0Y8_WW4END[5] AXI_M_SOC_RDATA13 _4805_/X _4788_/X _0539_/Q
+ _0538_/Q VPWR VGND sg13cmos5l_mux4_1
X_1966_ _1966_/Q Tile_X0Y4_FrameData[23] VGND VPWR Tile_X0Y9_FrameStrobe[1] latch
X_3705_ AXI_M_SOC_WDATA15 Tile_X0Y7_W1END[3] Tile_X0Y7_WW4END[7] Tile_X0Y7_WW4END[15]
+ _4699_/X _0217_/Q _0216_/Q VPWR VGND sg13cmos5l_mux4_1
XFILLER_543_129 VPWR VGND sg13cmos5l_fill_2
X_0917_ _0917_/Q Tile_X0Y9_FrameData[10] VGND VPWR Tile_X0Y9_FrameStrobe[7] latch
XFILLER_239_77 VPWR VGND sg13cmos5l_decap_8
X_4685_ _4685_/X _4663_/X Tile_X0Y9_N4END[9] _4662_/X _0055_/X _0213_/Q _0212_/Q VPWR
+ VGND sg13cmos5l_mux4_1
X_1897_ _1897_/Q Tile_X0Y3_FrameData[0] VGND VPWR Tile_X0Y9_FrameStrobe[6] latch
XFILLER_536_42 VPWR VGND sg13cmos5l_decap_8
XFILLER_146_165 VPWR VGND sg13cmos5l_decap_8
X_3636_ Tile_X0Y9_S4BEG[14] _3636_/A VPWR VGND sg13cmos5l_buf_1
X_0848_ _0848_/Q Tile_X0Y9_FrameData[15] VGND VPWR Tile_X0Y9_FrameStrobe[5] latch
XFILLER_551_162 VPWR VGND sg13cmos5l_decap_4
XFILLER_255_21 VPWR VGND sg13cmos5l_decap_8
X_3567_ Tile_X0Y9_EE4BEG[13] _4877_/X VPWR VGND sg13cmos5l_buf_1
X_0779_ _0779_/Q Tile_X0Y9_FrameData[20] VGND VPWR Tile_X0Y9_FrameStrobe[3] latch
XFILLER_255_65 VPWR VGND sg13cmos5l_decap_8
XFILLER_449_111 VPWR VGND sg13cmos5l_decap_8
XFILLER_161_179 VPWR VGND sg13cmos5l_decap_8
X_2518_ _2518_/Q Tile_X0Y6_FrameData[17] VGND VPWR Tile_X0Y9_FrameStrobe[2] latch
XFILLER_303_151 VPWR VGND sg13cmos5l_decap_8
XFILLER_449_144 VPWR VGND sg13cmos5l_decap_4
X_3498_ Tile_X0Y1_E6BEG[8] _3972_/X VPWR VGND sg13cmos5l_buf_1
XFILLER_405_35 VPWR VGND sg13cmos5l_decap_8
XFILLER_248_206 VPWR VGND sg13cmos5l_decap_4
XFILLER_405_46 VPWR VGND sg13cmos5l_fill_1
XFILLER_248_217 VPWR VGND sg13cmos5l_fill_1
XFILLER_552_63 VPWR VGND sg13cmos5l_decap_8
X_2449_ _2449_/Q Tile_X0Y6_FrameData[22] VGND VPWR Tile_X0Y9_FrameStrobe[0] latch
XFILLER_124_14 VPWR VGND sg13cmos5l_decap_8
XFILLER_653_214 VPWR VGND sg13cmos5l_decap_4
XFILLER_271_42 VPWR VGND sg13cmos5l_decap_8
XANTENNA__2774__X Tile_X0Y3_EE4BEG[0] VPWR VGND sg13cmos5l_antennanp
X_4119_ _4119_/X _4095_/X _0094_/X _4094_/X Tile_X0Y0_S4END[11] _1475_/Q _1474_/Q
+ VPWR VGND sg13cmos5l_mux4_1
XFILLER_702_77 VPWR VGND sg13cmos5l_decap_8
XFILLER_606_174 VPWR VGND sg13cmos5l_decap_8
XFILLER_421_56 VPWR VGND sg13cmos5l_decap_8
XFILLER_216_147 VPWR VGND sg13cmos5l_fill_1
XFILLER_204_91 VPWR VGND sg13cmos5l_decap_8
XFILLER_17_56 VPWR VGND sg13cmos5l_decap_8
XFILLER_140_35 VPWR VGND sg13cmos5l_decap_8
XFILLER_420_217 VPWR VGND sg13cmos5l_fill_1
XFILLER_497_49 VPWR VGND sg13cmos5l_decap_8
XFILLER_347_7 VPWR VGND sg13cmos5l_decap_8
XFILLER_169_213 VPWR VGND sg13cmos5l_decap_4
XFILLER_242_6 VPWR VGND sg13cmos5l_decap_8
XFILLER_385_121 VPWR VGND sg13cmos5l_fill_2
XFILLER_184_205 VPWR VGND sg13cmos5l_fill_1
XFILLER_514_7 VPWR VGND sg13cmos5l_decap_8
XFILLER_184_216 VPWR VGND sg13cmos5l_fill_2
XFILLER_149_55 VPWR VGND sg13cmos5l_decap_8
XFILLER_527_181 VPWR VGND sg13cmos5l_decap_4
XFILLER_296_94 VPWR VGND sg13cmos5l_fill_1
XFILLER_446_42 VPWR VGND sg13cmos5l_decap_8
XFILLER_152_102 VPWR VGND sg13cmos5l_decap_8
XFILLER_116_2 VPWR VGND sg13cmos5l_fill_1
XFILLER_137_187 VPWR VGND sg13cmos5l_decap_8
XFILLER_446_86 VPWR VGND sg13cmos5l_fill_2
XANTENNA__2949__X Tile_X0Y8_EE4BEG[5] VPWR VGND sg13cmos5l_antennanp
XFILLER_644_203 VPWR VGND sg13cmos5l_decap_4
XFILLER_58_41 VPWR VGND sg13cmos5l_decap_8
XFILLER_66_119 VPWR VGND sg13cmos5l_decap_8
XFILLER_181_64 VPWR VGND sg13cmos5l_decap_8
XFILLER_58_96 VPWR VGND sg13cmos5l_decap_8
XFILLER_373_0 VPWR VGND sg13cmos5l_decap_8
XFILLER_612_77 VPWR VGND sg13cmos5l_decap_8
XFILLER_470_128 VPWR VGND sg13cmos5l_decap_4
XFILLER_470_139 VPWR VGND sg13cmos5l_decap_8
XFILLER_331_56 VPWR VGND sg13cmos5l_decap_4
XFILLER_612_133 VPWR VGND sg13cmos5l_decap_4
XFILLER_540_0 VPWR VGND sg13cmos5l_decap_8
XFILLER_638_0 VPWR VGND sg13cmos5l_decap_8
XFILLER_612_166 VPWR VGND sg13cmos5l_decap_8
XFILLER_376_121 VPWR VGND sg13cmos5l_fill_2
XFILLER_95_7 VPWR VGND sg13cmos5l_decap_8
XFILLER_200_49 VPWR VGND sg13cmos5l_decap_8
XFILLER_376_154 VPWR VGND sg13cmos5l_decap_8
X_1820_ _1820_/Q Tile_X0Y3_FrameData[13] VGND VPWR Tile_X0Y9_FrameStrobe[4] latch
XFILLER_230_183 VPWR VGND sg13cmos5l_decap_8
XFILLER_376_198 VPWR VGND sg13cmos5l_fill_2
X_1751_ _1751_/Q Tile_X0Y3_FrameData[18] VGND VPWR Tile_X0Y9_FrameStrobe[2] latch
XFILLER_637_63 VPWR VGND sg13cmos5l_decap_8
XFILLER_209_14 VPWR VGND sg13cmos5l_decap_8
XFILLER_190_208 VPWR VGND sg13cmos5l_fill_1
X_0702_ _0702_/Q Tile_X0Y9_FrameData[1] VGND VPWR Tile_X0Y9_FrameStrobe[0] latch
XFILLER_356_42 VPWR VGND sg13cmos5l_decap_8
X_4470_ _4470_/X Tile_X0Y4_W2MID[6] Tile_X0Y4_W2END[6] Tile_X0Y4_W6END[9] _4315_/X
+ _2135_/Q _2134_/Q VPWR VGND sg13cmos5l_mux4_1
XFILLER_533_151 VPWR VGND sg13cmos5l_decap_8
XFILLER_128_176 VPWR VGND sg13cmos5l_fill_2
X_1682_ _1682_/Q Tile_X0Y3_FrameData[23] VGND VPWR Tile_X0Y9_FrameStrobe[0] latch
XFILLER_143_124 VPWR VGND sg13cmos5l_decap_8
X_3421_ Tile_X0Y4_FrameData_O[12] Tile_X0Y4_FrameData[12] VPWR VGND sg13cmos5l_buf_1
XFILLER_679_166 VPWR VGND sg13cmos5l_fill_1
XFILLER_478_217 VPWR VGND sg13cmos5l_fill_1
X_0633_ _0633_/Q Tile_X0Y8_FrameData[6] VGND VPWR Tile_X0Y9_FrameStrobe[6] latch
XANTENNA__2859__X Tile_X0Y6_E6BEG[8] VPWR VGND sg13cmos5l_antennanp
XFILLER_679_188 VPWR VGND sg13cmos5l_fill_2
XFILLER_506_56 VPWR VGND sg13cmos5l_decap_8
XFILLER_225_13 VPWR VGND sg13cmos5l_decap_8
X_3352_ Tile_X0Y2_FrameData_O[23] Tile_X0Y2_FrameData[23] VPWR VGND sg13cmos5l_buf_1
X_0564_ _0564_/Q Tile_X0Y8_FrameData[11] VGND VPWR Tile_X0Y9_FrameStrobe[4] latch
XFILLER_653_84 VPWR VGND sg13cmos5l_decap_8
X_2303_ _2303_/Q Tile_X0Y5_FrameData[6] VGND VPWR Tile_X0Y9_FrameStrobe[3] latch
XFILLER_31_2 VPWR VGND sg13cmos5l_fill_1
X_3283_ Tile_X0Y0_E6BEG[3] _3839_/X VPWR VGND sg13cmos5l_buf_1
X_0495_ _0495_/Q Tile_X0Y8_FrameData[16] VGND VPWR Tile_X0Y9_FrameStrobe[2] latch
XFILLER_446_136 VPWR VGND sg13cmos5l_decap_8
XFILLER_446_147 VPWR VGND sg13cmos5l_fill_1
XFILLER_300_154 VPWR VGND sg13cmos5l_decap_8
X_2234_ _2234_/Q Tile_X0Y5_FrameData[11] VGND VPWR Tile_X0Y9_FrameStrobe[1] latch
XFILLER_300_165 VPWR VGND sg13cmos5l_fill_1
XFILLER_17_0 VPWR VGND sg13cmos5l_decap_8
XFILLER_650_217 VPWR VGND sg13cmos5l_fill_1
X_2165_ _2165_/Q Tile_X0Y4_FrameData[16] VGND VPWR Tile_X0Y9_FrameStrobe[7] latch
XFILLER_65_152 VPWR VGND sg13cmos5l_decap_8
XFILLER_603_122 VPWR VGND sg13cmos5l_decap_8
XFILLER_454_191 VPWR VGND sg13cmos5l_decap_8
X_1116_ _1116_/Q Tile_X0Y0_FrameData[15] VGND VPWR Tile_X0Y9_FrameStrobe[5] latch
XFILLER_80_111 VPWR VGND sg13cmos5l_decap_8
X_2096_ _2096_/Q Tile_X0Y4_FrameData[21] VGND VPWR Tile_X0Y9_FrameStrobe[5] latch
XFILLER_603_155 VPWR VGND sg13cmos5l_fill_1
XFILLER_0_70 VPWR VGND sg13cmos5l_decap_8
XFILLER_603_177 VPWR VGND sg13cmos5l_decap_4
XFILLER_0_81 VPWR VGND sg13cmos5l_fill_2
X_1047_ _1047_/Q Tile_X0Y0_FrameData[20] VGND VPWR Tile_X0Y9_FrameStrobe[3] latch
XFILLER_678_70 VPWR VGND sg13cmos5l_fill_2
XFILLER_110_27 VPWR VGND sg13cmos5l_decap_8
XFILLER_367_154 VPWR VGND sg13cmos5l_decap_4
X_4806_ _4806_/X _4781_/X Tile_X0Y9_N4END[6] _4780_/X _0075_/X _0459_/Q _0458_/Q VPWR
+ VGND sg13cmos5l_mux4_1
XFILLER_166_216 VPWR VGND sg13cmos5l_fill_2
X_2998_ Tile_X0Y5_E2BEG[1] _4373_/X VPWR VGND sg13cmos5l_buf_1
XFILLER_571_202 VPWR VGND sg13cmos5l_decap_4
XFILLER_547_63 VPWR VGND sg13cmos5l_decap_8
X_1949_ _1949_/Q Tile_X0Y4_FrameData[8] VGND VPWR Tile_X0Y9_FrameStrobe[0] latch
X_4737_ _4737_/X Tile_X0Y8_W2END[6] AXI_M_SOC_RDATA14 _4787_/X _4786_/X _0573_/Q _0572_/Q
+ VPWR VGND sg13cmos5l_mux4_1
XFILLER_119_14 VPWR VGND sg13cmos5l_decap_8
XFILLER_382_157 VPWR VGND sg13cmos5l_decap_8
XFILLER_694_91 VPWR VGND sg13cmos5l_decap_8
XFILLER_266_42 VPWR VGND sg13cmos5l_decap_8
X_4668_ _4668_/X _4599_/X _4715_/X _4714_/X _4598_/X _0169_/Q _0168_/Q VPWR VGND sg13cmos5l_mux4_1
XFILLER_469_217 VPWR VGND sg13cmos5l_fill_1
XANTENNA__2769__X Tile_X0Y3_FrameData_O[27] VPWR VGND sg13cmos5l_antennanp
X_3619_ Tile_X0Y9_S2BEGb[5] _4937_/X VPWR VGND sg13cmos5l_buf_1
X_4599_ _4599_/X Tile_X0Y8_W2MID[0] Tile_X0Y8_W2END[0] Tile_X0Y8_W6END[0] _4784_/X
+ _0649_/Q _0648_/Q VPWR VGND sg13cmos5l_mux4_1
XFILLER_416_56 VPWR VGND sg13cmos5l_decap_8
XFILLER_563_84 VPWR VGND sg13cmos5l_decap_8
XFILLER_135_35 VPWR VGND sg13cmos5l_decap_8
XFILLER_0_115 VPWR VGND sg13cmos5l_fill_2
XFILLER_713_21 VPWR VGND sg13cmos5l_decap_8
XFILLER_282_63 VPWR VGND sg13cmos5l_decap_8
XFILLER_95_28 VPWR VGND sg13cmos5l_decap_8
XFILLER_297_7 VPWR VGND sg13cmos5l_decap_8
XFILLER_236_209 VPWR VGND sg13cmos5l_fill_1
XFILLER_713_98 VPWR VGND sg13cmos5l_decap_8
XFILLER_437_169 VPWR VGND sg13cmos5l_decap_8
XFILLER_432_77 VPWR VGND sg13cmos5l_decap_8
XFILLER_464_7 VPWR VGND sg13cmos5l_decap_8
XFILLER_452_128 VPWR VGND sg13cmos5l_decap_8
XFILLER_71_111 VPWR VGND sg13cmos5l_decap_8
XFILLER_631_7 VPWR VGND sg13cmos5l_decap_8
XFILLER_460_183 VPWR VGND sg13cmos5l_decap_8
XFILLER_44_43 VPWR VGND sg13cmos5l_decap_8
XFILLER_588_81 VPWR VGND sg13cmos5l_decap_8
XFILLER_358_154 VPWR VGND sg13cmos5l_decap_8
XFILLER_674_28 VPWR VGND sg13cmos5l_decap_8
XFILLER_60_42 VPWR VGND sg13cmos5l_decap_8
XFILLER_457_63 VPWR VGND sg13cmos5l_decap_4
XFILLER_457_74 VPWR VGND sg13cmos5l_decap_8
XFILLER_121_0 VPWR VGND sg13cmos5l_decap_8
XFILLER_219_0 VPWR VGND sg13cmos5l_fill_2
XFILLER_607_77 VPWR VGND sg13cmos5l_decap_8
XFILLER_140_105 VPWR VGND sg13cmos5l_decap_8
XFILLER_623_21 VPWR VGND sg13cmos5l_decap_8
XFILLER_530_187 VPWR VGND sg13cmos5l_decap_8
XFILLER_490_0 VPWR VGND sg13cmos5l_decap_8
XFILLER_326_89 VPWR VGND sg13cmos5l_decap_4
XFILLER_588_0 VPWR VGND sg13cmos5l_decap_8
XFILLER_192_63 VPWR VGND sg13cmos5l_decap_8
XFILLER_69_95 VPWR VGND sg13cmos5l_decap_8
XFILLER_39_108 VPWR VGND sg13cmos5l_decap_4
XFILLER_428_147 VPWR VGND sg13cmos5l_decap_8
X_0280_ _0280_/Q Tile_X0Y7_FrameData[7] VGND VPWR Tile_X0Y9_FrameStrobe[3] latch
XFILLER_699_14 VPWR VGND sg13cmos5l_decap_8
XFILLER_632_206 VPWR VGND sg13cmos5l_fill_2
XFILLER_342_77 VPWR VGND sg13cmos5l_decap_8
XFILLER_10_7 VPWR VGND sg13cmos5l_decap_8
XANTENNA__3303__X Tile_X0Y0_E2BEG[3] VPWR VGND sg13cmos5l_antennanp
XFILLER_436_191 VPWR VGND sg13cmos5l_fill_2
XFILLER_62_100 VPWR VGND sg13cmos5l_decap_8
X_3970_ _3970_/X AXI_M_SOC_ARREADY _4013_/X _4017_/X _3993_/X _1269_/Q _1268_/Q VPWR
+ VGND sg13cmos5l_mux4_1
XFILLER_62_177 VPWR VGND sg13cmos5l_decap_8
XFILLER_498_70 VPWR VGND sg13cmos5l_decap_8
X_2921_ Tile_X0Y8_E2BEG[5] _4733_/X VPWR VGND sg13cmos5l_buf_1
XFILLER_203_161 VPWR VGND sg13cmos5l_fill_2
X_2852_ Tile_X0Y6_E6BEG[1] _4529_/X VPWR VGND sg13cmos5l_buf_1
XFILLER_203_183 VPWR VGND sg13cmos5l_decap_4
XFILLER_648_84 VPWR VGND sg13cmos5l_decap_8
XFILLER_349_187 VPWR VGND sg13cmos5l_decap_8
XFILLER_364_124 VPWR VGND sg13cmos5l_decap_8
X_1803_ _1803_/Q Tile_X0Y3_FrameData[30] VGND VPWR Tile_X0Y9_FrameStrobe[4] latch
XFILLER_584_28 VPWR VGND sg13cmos5l_decap_8
XFILLER_79_2 VPWR VGND sg13cmos5l_fill_1
X_2783_ Tile_X0Y3_EE4BEG[9] _4173_/X VPWR VGND sg13cmos5l_buf_1
X_4522_ _4522_/X Tile_X0Y6_WW4END[5] AXI_M_SOC_RDATA29 _4573_/X _4556_/X _2563_/Q
+ _2562_/Q VPWR VGND sg13cmos5l_mux4_1
X_1734_ _1734_/Q Tile_X0Y3_FrameData[3] VGND VPWR Tile_X0Y9_FrameStrobe[1] latch
XFILLER_506_151 VPWR VGND sg13cmos5l_decap_8
XFILLER_710_210 VPWR VGND sg13cmos5l_fill_2
X_4453_ _4453_/X _4424_/X _0100_/X _4423_/X _0140_/X _2233_/Q _2232_/Q VPWR VGND sg13cmos5l_mux4_1
X_1665_ _1665_/Q Tile_X0Y2_FrameData[16] VGND VPWR Tile_X0Y9_FrameStrobe[7] latch
XFILLER_517_88 VPWR VGND sg13cmos5l_decap_8
X_3404_ Tile_X0Y2_E2BEG[7] _4047_/X VPWR VGND sg13cmos5l_buf_1
X_0616_ _0616_/Q Tile_X0Y8_FrameData[23] VGND VPWR Tile_X0Y9_FrameStrobe[6] latch
X_4384_ _4384_/X Tile_X0Y5_W2END[3] AXI_M_SOC_RRESP1 _4434_/X _4433_/X _2335_/Q _2334_/Q
+ VPWR VGND sg13cmos5l_mux4_1
X_1596_ _1596_/Q Tile_X0Y2_FrameData[21] VGND VPWR Tile_X0Y9_FrameStrobe[5] latch
XFILLER_383_95 VPWR VGND sg13cmos5l_decap_8
XFILLER_533_21 VPWR VGND sg13cmos5l_decap_8
XFILLER_521_187 VPWR VGND sg13cmos5l_fill_2
XFILLER_131_149 VPWR VGND sg13cmos5l_fill_2
X_3335_ Tile_X0Y2_FrameData_O[6] Tile_X0Y2_FrameData[6] VPWR VGND sg13cmos5l_buf_1
X_0547_ _0547_/Q Tile_X0Y8_FrameData[28] VGND VPWR Tile_X0Y9_FrameStrobe[4] latch
XFILLER_285_131 VPWR VGND sg13cmos5l_decap_8
XFILLER_105_27 VPWR VGND sg13cmos5l_decap_8
X_3266_ Tile_X0Y0_EE4BEG[2] _3822_/X VPWR VGND sg13cmos5l_buf_1
X_0478_ _0478_/Q Tile_X0Y8_FrameData[1] VGND VPWR Tile_X0Y9_FrameStrobe[1] latch
X_2217_ _2217_/Q Tile_X0Y5_FrameData[28] VGND VPWR Tile_X0Y9_FrameStrobe[1] latch
XFILLER_434_128 VPWR VGND sg13cmos5l_decap_8
XFILLER_402_14 VPWR VGND sg13cmos5l_decap_8
X_3197_ Tile_X0Y0_N2BEGb[5] _3899_/X VPWR VGND sg13cmos5l_buf_1
XANTENNA__3213__X Tile_X0Y0_FrameStrobe_O[1] VPWR VGND sg13cmos5l_antennanp
XFILLER_38_174 VPWR VGND sg13cmos5l_decap_8
X_2148_ _2148_/Q Tile_X0Y4_FrameData[1] VGND VPWR Tile_X0Y9_FrameStrobe[6] latch
XFILLER_402_69 VPWR VGND sg13cmos5l_decap_8
X_2079_ _2079_/Q Tile_X0Y4_FrameData[6] VGND VPWR Tile_X0Y9_FrameStrobe[4] latch
XFILLER_198_127 VPWR VGND sg13cmos5l_decap_8
XFILLER_442_194 VPWR VGND sg13cmos5l_decap_8
XFILLER_201_70 VPWR VGND sg13cmos5l_decap_8
XFILLER_14_35 VPWR VGND sg13cmos5l_decap_8
XFILLER_708_21 VPWR VGND sg13cmos5l_decap_8
XFILLER_494_28 VPWR VGND sg13cmos5l_decap_8
XFILLER_277_63 VPWR VGND sg13cmos5l_decap_8
XFILLER_708_98 VPWR VGND sg13cmos5l_decap_8
XFILLER_658_103 VPWR VGND sg13cmos5l_decap_8
XFILLER_427_77 VPWR VGND sg13cmos5l_decap_8
XFILLER_30_56 VPWR VGND sg13cmos5l_decap_8
XFILLER_574_94 VPWR VGND sg13cmos5l_decap_8
XFILLER_30_89 VPWR VGND sg13cmos5l_decap_4
XFILLER_146_56 VPWR VGND sg13cmos5l_decap_8
XFILLER_658_147 VPWR VGND sg13cmos5l_decap_4
XFILLER_512_176 VPWR VGND sg13cmos5l_decap_8
XFILLER_443_21 VPWR VGND sg13cmos5l_decap_8
XFILLER_122_138 VPWR VGND sg13cmos5l_decap_4
XFILLER_673_128 VPWR VGND sg13cmos5l_fill_2
XFILLER_581_7 VPWR VGND sg13cmos5l_decap_8
XFILLER_39_32 VPWR VGND sg13cmos5l_decap_8
XFILLER_679_7 VPWR VGND sg13cmos5l_decap_8
XFILLER_443_98 VPWR VGND sg13cmos5l_decap_4
XFILLER_39_87 VPWR VGND sg13cmos5l_decap_8
XFILLER_614_206 VPWR VGND sg13cmos5l_fill_1
XFILLER_480_201 VPWR VGND sg13cmos5l_fill_2
XFILLER_681_172 VPWR VGND sg13cmos5l_fill_2
XFILLER_312_14 VPWR VGND sg13cmos5l_decap_8
XFILLER_276_197 VPWR VGND sg13cmos5l_fill_2
XFILLER_418_180 VPWR VGND sg13cmos5l_fill_1
XANTENNA__3123__X Tile_X0Y7_EE4BEG[9] VPWR VGND sg13cmos5l_antennanp
XFILLER_91_217 VPWR VGND sg13cmos5l_fill_1
XFILLER_55_20 VPWR VGND sg13cmos5l_decap_8
XFILLER_312_36 VPWR VGND sg13cmos5l_fill_2
XFILLER_669_28 VPWR VGND sg13cmos5l_decap_4
XFILLER_55_53 VPWR VGND sg13cmos5l_decap_8
XFILLER_189_105 VPWR VGND sg13cmos5l_decap_8
XFILLER_169_0 VPWR VGND sg13cmos5l_decap_8
XANTENNA__2962__X Tile_X0Y8_FrameData_O[2] VPWR VGND sg13cmos5l_antennanp
XFILLER_44_199 VPWR VGND sg13cmos5l_decap_4
XFILLER_336_0 VPWR VGND sg13cmos5l_decap_8
XFILLER_71_41 VPWR VGND sg13cmos5l_decap_8
XFILLER_468_73 VPWR VGND sg13cmos5l_decap_8
XFILLER_685_49 VPWR VGND sg13cmos5l_decap_8
XFILLER_618_21 VPWR VGND sg13cmos5l_decap_8
XFILLER_346_135 VPWR VGND sg13cmos5l_decap_4
XFILLER_187_74 VPWR VGND sg13cmos5l_decap_8
XFILLER_503_0 VPWR VGND sg13cmos5l_decap_8
XFILLER_618_98 VPWR VGND sg13cmos5l_decap_4
XFILLER_649_147 VPWR VGND sg13cmos5l_decap_8
XFILLER_634_42 VPWR VGND sg13cmos5l_decap_8
XFILLER_503_154 VPWR VGND sg13cmos5l_decap_8
X_1450_ _1450_/Q Tile_X0Y2_FrameData[7] VGND VPWR Tile_X0Y9_FrameStrobe[0] latch
XFILLER_113_116 VPWR VGND sg13cmos5l_decap_8
XFILLER_113_127 VPWR VGND sg13cmos5l_fill_1
XFILLER_353_21 VPWR VGND sg13cmos5l_decap_8
X_0401_ _0401_/Q Tile_X0Y7_FrameData[14] VGND VPWR Tile_X0Y9_FrameStrobe[7] latch
XFILLER_206_48 VPWR VGND sg13cmos5l_decap_8
X_1381_ _1381_/Q Tile_X0Y1_FrameData[20] VGND VPWR Tile_X0Y9_FrameStrobe[6] latch
XFILLER_664_128 VPWR VGND sg13cmos5l_fill_2
X_3120_ Tile_X0Y7_EE4BEG[6] _4634_/X VPWR VGND sg13cmos5l_buf_1
X_0332_ _0332_/Q Tile_X0Y7_FrameData[19] VGND VPWR Tile_X0Y9_FrameStrobe[5] latch
XFILLER_353_98 VPWR VGND sg13cmos5l_decap_8
XFILLER_503_35 VPWR VGND sg13cmos5l_decap_8
XFILLER_121_182 VPWR VGND sg13cmos5l_decap_4
XFILLER_282_112 VPWR VGND sg13cmos5l_decap_8
X_3051_ Tile_X0Y5_FrameData_O[10] Tile_X0Y5_FrameData[10] VPWR VGND sg13cmos5l_buf_1
XFILLER_650_63 VPWR VGND sg13cmos5l_decap_8
XFILLER_605_217 VPWR VGND sg13cmos5l_fill_1
X_0263_ _0263_/Q Tile_X0Y7_FrameData[24] VGND VPWR Tile_X0Y9_FrameStrobe[3] latch
XFILLER_222_14 VPWR VGND sg13cmos5l_decap_8
XANTENNA__3033__X Tile_X0Y5_EE4BEG[8] VPWR VGND sg13cmos5l_antennanp
X_2002_ _2002_/Q Tile_X0Y4_FrameData[19] VGND VPWR Tile_X0Y9_FrameStrobe[2] latch
XFILLER_579_28 VPWR VGND sg13cmos5l_decap_8
X_0194_ _0194_/Q Tile_X0Y7_FrameData[29] VGND VPWR Tile_X0Y9_FrameStrobe[1] latch
XFILLER_424_161 VPWR VGND sg13cmos5l_fill_1
XFILLER_35_144 VPWR VGND sg13cmos5l_decap_8
XANTENNA__2872__X Tile_X0Y6_EE4BEG[9] VPWR VGND sg13cmos5l_antennanp
XFILLER_585_102 VPWR VGND sg13cmos5l_fill_1
XFILLER_585_124 VPWR VGND sg13cmos5l_decap_4
XFILLER_50_114 VPWR VGND sg13cmos5l_decap_8
X_3953_ _3953_/X Tile_X0Y1_WW4END[10] AXI_M_SOC_ARREADY _4018_/X _3993_/X _1303_/Q
+ _1302_/Q VPWR VGND sg13cmos5l_mux4_1
X_2904_ Tile_X0Y6_FrameData_O[25] Tile_X0Y6_FrameData[25] VPWR VGND sg13cmos5l_buf_1
XFILLER_188_171 VPWR VGND sg13cmos5l_fill_2
X_3884_ _3884_/X _3851_/X _0078_/X Tile_X0Y0_S1END[3] Tile_X0Y0_S4END[3] _0989_/Q
+ _0988_/Q VPWR VGND sg13cmos5l_mux4_1
XFILLER_595_49 VPWR VGND sg13cmos5l_decap_8
XFILLER_84_0 VPWR VGND sg13cmos5l_fill_2
XFILLER_528_21 VPWR VGND sg13cmos5l_decap_8
XFILLER_337_135 VPWR VGND sg13cmos5l_fill_2
X_2835_ Tile_X0Y6_E2BEG[0] _4496_/X VPWR VGND sg13cmos5l_buf_1
XFILLER_352_105 VPWR VGND sg13cmos5l_decap_8
XFILLER_337_179 VPWR VGND sg13cmos5l_fill_1
X_2766_ Tile_X0Y3_FrameData_O[24] Tile_X0Y3_FrameData[24] VPWR VGND sg13cmos5l_buf_1
XFILLER_394_72 VPWR VGND sg13cmos5l_fill_1
X_1717_ _1717_/Q Tile_X0Y3_FrameData[20] VGND VPWR Tile_X0Y9_FrameStrobe[1] latch
X_4505_ _4505_/X Tile_X0Y6_W2END[6] AXI_M_SOC_RDATA30 _4555_/X _4554_/X _2597_/Q _2596_/Q
+ VPWR VGND sg13cmos5l_mux4_1
XFILLER_247_77 VPWR VGND sg13cmos5l_decap_8
X_2697_ _4087_/A3 VPWR VGND sg13cmos5l_tielo
XFILLER_394_94 VPWR VGND sg13cmos5l_decap_8
XANTENNA__3208__X Tile_X0Y0_N1BEG[0] VPWR VGND sg13cmos5l_antennanp
XFILLER_544_42 VPWR VGND sg13cmos5l_decap_8
X_4436_ _4436_/X _4012_/X _4016_/X _4005_/X _3994_/X _1365_/Q _1364_/Q VPWR VGND sg13cmos5l_mux4_1
XFILLER_6_91 VPWR VGND sg13cmos5l_decap_8
X_1648_ _1648_/Q Tile_X0Y2_FrameData[1] VGND VPWR Tile_X0Y9_FrameStrobe[6] latch
XFILLER_691_70 VPWR VGND sg13cmos5l_decap_8
XFILLER_263_21 VPWR VGND sg13cmos5l_decap_8
XFILLER_104_149 VPWR VGND sg13cmos5l_fill_1
X_4367_ _4367_/X Tile_X0Y6_W2MID[0] Tile_X0Y6_W2END[0] Tile_X0Y6_W6END[0] _4552_/X
+ _2673_/Q _2672_/Q VPWR VGND sg13cmos5l_mux4_1
XFILLER_116_48 VPWR VGND sg13cmos5l_decap_8
X_1579_ _1579_/Q Tile_X0Y2_FrameData[6] VGND VPWR Tile_X0Y9_FrameStrobe[4] latch
XFILLER_258_142 VPWR VGND sg13cmos5l_decap_4
X_3318_ Tile_X0Y4_EE4BEG[6] _4278_/X VPWR VGND sg13cmos5l_buf_1
X_4298_ _4298_/X AXI_M_SOC_BRESP0 _4337_/X _4341_/X _4314_/X _2017_/Q _2016_/Q VPWR
+ VGND sg13cmos5l_mux4_1
XFILLER_413_35 VPWR VGND sg13cmos5l_decap_8
XFILLER_258_175 VPWR VGND sg13cmos5l_decap_4
XFILLER_407_117 VPWR VGND sg13cmos5l_decap_4
XFILLER_273_112 VPWR VGND sg13cmos5l_decap_8
XFILLER_560_63 VPWR VGND sg13cmos5l_decap_8
X_3249_ Tile_X0Y0_FrameData_O[17] Tile_X0Y0_FrameData[17] VPWR VGND sg13cmos5l_buf_1
XFILLER_132_14 VPWR VGND sg13cmos5l_decap_8
XFILLER_489_28 VPWR VGND sg13cmos5l_decap_8
XANTENNA__2782__X Tile_X0Y3_EE4BEG[8] VPWR VGND sg13cmos5l_antennanp
XFILLER_710_77 VPWR VGND sg13cmos5l_decap_8
XFILLER_415_183 VPWR VGND sg13cmos5l_decap_8
XFILLER_162_7 VPWR VGND sg13cmos5l_decap_8
XFILLER_415_194 VPWR VGND sg13cmos5l_fill_1
XFILLER_430_164 VPWR VGND sg13cmos5l_decap_8
XFILLER_25_78 VPWR VGND sg13cmos5l_decap_4
XFILLER_576_168 VPWR VGND sg13cmos5l_decap_8
XFILLER_427_7 VPWR VGND sg13cmos5l_decap_8
XFILLER_288_84 VPWR VGND sg13cmos5l_decap_8
XFILLER_179_182 VPWR VGND sg13cmos5l_decap_4
XFILLER_438_21 VPWR VGND sg13cmos5l_decap_8
XFILLER_328_146 VPWR VGND sg13cmos5l_decap_4
XFILLER_194_141 VPWR VGND sg13cmos5l_decap_4
XFILLER_41_55 VPWR VGND sg13cmos5l_decap_8
XFILLER_438_98 VPWR VGND sg13cmos5l_decap_8
XFILLER_41_88 VPWR VGND sg13cmos5l_fill_1
XFILLER_307_14 VPWR VGND sg13cmos5l_decap_8
XANTENNA__3118__X Tile_X0Y7_EE4BEG[4] VPWR VGND sg13cmos5l_antennanp
XFILLER_454_42 VPWR VGND sg13cmos5l_decap_8
XFILLER_296_215 VPWR VGND sg13cmos5l_fill_2
XFILLER_497_175 VPWR VGND sg13cmos5l_decap_8
XANTENNA__2957__X Tile_X0Y8_EE4BEG[13] VPWR VGND sg13cmos5l_antennanp
XFILLER_173_65 VPWR VGND sg13cmos5l_decap_8
XFILLER_604_56 VPWR VGND sg13cmos5l_decap_8
XFILLER_500_168 VPWR VGND sg13cmos5l_decap_8
XFILLER_249_142 VPWR VGND sg13cmos5l_decap_8
XFILLER_323_35 VPWR VGND sg13cmos5l_decap_8
XFILLER_2_49 VPWR VGND sg13cmos5l_decap_8
XFILLER_286_0 VPWR VGND sg13cmos5l_decap_8
XFILLER_470_63 VPWR VGND sg13cmos5l_decap_8
XFILLER_249_197 VPWR VGND sg13cmos5l_fill_1
XFILLER_66_63 VPWR VGND sg13cmos5l_decap_8
XFILLER_264_156 VPWR VGND sg13cmos5l_decap_8
XFILLER_399_28 VPWR VGND sg13cmos5l_decap_8
XFILLER_453_0 VPWR VGND sg13cmos5l_decap_8
XFILLER_620_77 VPWR VGND sg13cmos5l_decap_8
XFILLER_421_142 VPWR VGND sg13cmos5l_decap_8
XFILLER_17_188 VPWR VGND sg13cmos5l_decap_8
XFILLER_82_62 VPWR VGND sg13cmos5l_decap_8
XFILLER_620_0 VPWR VGND sg13cmos5l_decap_8
XFILLER_709_140 VPWR VGND sg13cmos5l_decap_8
XFILLER_82_95 VPWR VGND sg13cmos5l_decap_8
XFILLER_629_42 VPWR VGND sg13cmos5l_decap_8
XFILLER_582_105 VPWR VGND sg13cmos5l_decap_8
XFILLER_32_169 VPWR VGND sg13cmos5l_decap_8
X_0950_ _0950_/Q Tile_X0Y0_FrameData[21] VGND VPWR Tile_X0Y9_FrameStrobe[0] latch
XFILLER_198_84 VPWR VGND sg13cmos5l_decap_8
XFILLER_508_213 VPWR VGND sg13cmos5l_decap_4
XFILLER_348_21 VPWR VGND sg13cmos5l_decap_8
X_0881_ _0881_/Q Tile_X0Y9_FrameData[14] VGND VPWR Tile_X0Y9_FrameStrobe[6] latch
X_2620_ _2620_/Q Tile_X0Y6_FrameData[11] VGND VPWR Tile_X0Y9_FrameStrobe[5] latch
XFILLER_348_98 VPWR VGND sg13cmos5l_decap_8
XFILLER_590_193 VPWR VGND sg13cmos5l_fill_2
X_2551_ _2551_/Q Tile_X0Y6_FrameData[16] VGND VPWR Tile_X0Y9_FrameStrobe[3] latch
XFILLER_645_63 VPWR VGND sg13cmos5l_decap_8
XANTENNA__3028__X Tile_X0Y5_EE4BEG[3] VPWR VGND sg13cmos5l_antennanp
XFILLER_99_114 VPWR VGND sg13cmos5l_fill_2
X_1502_ _1502_/Q Tile_X0Y2_FrameData[19] VGND VPWR Tile_X0Y9_FrameStrobe[2] latch
XFILLER_488_142 VPWR VGND sg13cmos5l_fill_1
XFILLER_364_42 VPWR VGND sg13cmos5l_decap_8
XFILLER_141_211 VPWR VGND sg13cmos5l_decap_8
X_2482_ _2482_/Q Tile_X0Y6_FrameData[21] VGND VPWR Tile_X0Y9_FrameStrobe[1] latch
XFILLER_488_164 VPWR VGND sg13cmos5l_decap_8
XFILLER_217_69 VPWR VGND sg13cmos5l_decap_8
X_4221_ _4221_/X _4691_/X _4695_/X _4699_/X _4675_/X _0382_/Q _0381_/Q VPWR VGND sg13cmos5l_mux4_1
X_1433_ _1433_/Q Tile_X0Y2_FrameData[24] VGND VPWR Tile_X0Y9_FrameStrobe[0] latch
XANTENNA__2867__X Tile_X0Y6_EE4BEG[4] VPWR VGND sg13cmos5l_antennanp
XFILLER_637_128 VPWR VGND sg13cmos5l_fill_1
XFILLER_101_108 VPWR VGND sg13cmos5l_decap_4
XFILLER_514_56 VPWR VGND sg13cmos5l_decap_8
X_4152_ _4152_/X Tile_X0Y3_W2MID[3] AXI_M_SOC_WREADY _4211_/X _4210_/X _1837_/Q _1836_/Q
+ VPWR VGND sg13cmos5l_mux4_1
X_1364_ _1364_/Q Tile_X0Y1_FrameData[5] VGND VPWR Tile_X0Y9_FrameStrobe[5] latch
XFILLER_661_84 VPWR VGND sg13cmos5l_decap_8
XFILLER_233_35 VPWR VGND sg13cmos5l_decap_8
X_3103_ Tile_X0Y7_E6BEG[1] _4645_/X VPWR VGND sg13cmos5l_buf_1
XFILLER_645_161 VPWR VGND sg13cmos5l_decap_8
XFILLER_444_212 VPWR VGND sg13cmos5l_decap_4
X_0315_ _0315_/Q Tile_X0Y7_FrameData[4] VGND VPWR Tile_X0Y9_FrameStrobe[4] latch
X_4083_ _4083_/X AXI_M_SOC_AWREADY _4116_/X _4120_/X _4096_/X _1507_/Q _1506_/Q VPWR
+ VGND sg13cmos5l_mux4_1
X_1295_ _1295_/Q Tile_X0Y1_FrameData[10] VGND VPWR Tile_X0Y9_FrameStrobe[3] latch
XFILLER_380_85 VPWR VGND sg13cmos5l_fill_2
X_3034_ Tile_X0Y5_EE4BEG[9] _4397_/X VPWR VGND sg13cmos5l_buf_1
X_0246_ _0246_/Q Tile_X0Y7_FrameData[9] VGND VPWR Tile_X0Y9_FrameStrobe[2] latch
XFILLER_270_115 VPWR VGND sg13cmos5l_decap_8
XANTENNA__3698__X AXI_M_SOC_WDATA8 VPWR VGND sg13cmos5l_antennanp
XFILLER_530_77 VPWR VGND sg13cmos5l_decap_4
XFILLER_102_28 VPWR VGND sg13cmos5l_decap_8
XFILLER_530_88 VPWR VGND sg13cmos5l_decap_8
X_0177_ _0177_/Q Tile_X0Y7_FrameData[14] VGND VPWR Tile_X0Y9_FrameStrobe[0] latch
XFILLER_412_142 VPWR VGND sg13cmos5l_fill_1
XFILLER_23_114 VPWR VGND sg13cmos5l_fill_1
XFILLER_23_125 VPWR VGND sg13cmos5l_fill_1
XFILLER_168_119 VPWR VGND sg13cmos5l_decap_4
XFILLER_539_42 VPWR VGND sg13cmos5l_decap_8
XFILLER_412_186 VPWR VGND sg13cmos5l_fill_2
XFILLER_573_105 VPWR VGND sg13cmos5l_decap_8
X_3936_ _3936_/X Tile_X0Y1_W2MID[3] AXI_M_SOC_ARREADY _3995_/X _3994_/X _1337_/Q _1336_/Q
+ VPWR VGND sg13cmos5l_mux4_1
XFILLER_686_70 VPWR VGND sg13cmos5l_decap_4
XFILLER_258_21 VPWR VGND sg13cmos5l_decap_8
XFILLER_715_132 VPWR VGND sg13cmos5l_decap_8
X_3867_ _3867_/X _3850_/X _0085_/X Tile_X0Y0_S1END[2] Tile_X0Y0_S4END[2] _0967_/Q
+ _0966_/Q VPWR VGND sg13cmos5l_mux4_1
X_2818_ Tile_X0Y3_E1BEG[0] _4144_/X VPWR VGND sg13cmos5l_buf_1
XFILLER_11_14 VPWR VGND sg13cmos5l_decap_8
X_3798_ _3798_/X Tile_X0Y0_W1END[3] Tile_X0Y0_WW4END[3] Tile_X0Y0_W6END[11] _3884_/X
+ _1144_/Q _1143_/Q VPWR VGND sg13cmos5l_mux4_1
XFILLER_408_35 VPWR VGND sg13cmos5l_decap_8
XFILLER_555_63 VPWR VGND sg13cmos5l_decap_8
XFILLER_127_14 VPWR VGND sg13cmos5l_decap_8
X_2749_ Tile_X0Y3_FrameData_O[7] Tile_X0Y3_FrameData[7] VPWR VGND sg13cmos5l_buf_1
XFILLER_340_108 VPWR VGND sg13cmos5l_decap_8
XFILLER_274_42 VPWR VGND sg13cmos5l_decap_8
XFILLER_479_142 VPWR VGND sg13cmos5l_decap_8
XFILLER_494_112 VPWR VGND sg13cmos5l_decap_8
XANTENNA__2777__X Tile_X0Y3_EE4BEG[3] VPWR VGND sg13cmos5l_antennanp
XFILLER_705_77 VPWR VGND sg13cmos5l_decap_8
X_4419_ _4419_/X _4421_/X Tile_X0Y5_W6END[1] _4420_/X _4419_/A3 _2187_/Q _2186_/Q
+ VPWR VGND sg13cmos5l_mux4_1
XFILLER_424_56 VPWR VGND sg13cmos5l_decap_8
XFILLER_571_84 VPWR VGND sg13cmos5l_decap_8
XFILLER_143_35 VPWR VGND sg13cmos5l_decap_8
XFILLER_435_201 VPWR VGND sg13cmos5l_fill_2
XFILLER_290_63 VPWR VGND sg13cmos5l_decap_8
XFILLER_636_183 VPWR VGND sg13cmos5l_fill_2
XFILLER_377_7 VPWR VGND sg13cmos5l_decap_8
XFILLER_246_134 VPWR VGND sg13cmos5l_decap_8
XFILLER_246_178 VPWR VGND sg13cmos5l_decap_8
XFILLER_450_215 VPWR VGND sg13cmos5l_fill_2
XFILLER_651_175 VPWR VGND sg13cmos5l_decap_8
XFILLER_261_126 VPWR VGND sg13cmos5l_decap_8
XFILLER_199_200 VPWR VGND sg13cmos5l_decap_8
XFILLER_544_7 VPWR VGND sg13cmos5l_decap_8
XFILLER_549_113 VPWR VGND sg13cmos5l_decap_4
XANTENNA__3401__X Tile_X0Y2_E2BEG[4] VPWR VGND sg13cmos5l_antennanp
XFILLER_14_103 VPWR VGND sg13cmos5l_decap_8
XFILLER_14_136 VPWR VGND sg13cmos5l_fill_2
XFILLER_202_215 VPWR VGND sg13cmos5l_fill_2
XFILLER_159_108 VPWR VGND sg13cmos5l_fill_2
XFILLER_403_186 VPWR VGND sg13cmos5l_decap_8
XFILLER_711_7 VPWR VGND sg13cmos5l_decap_8
XFILLER_564_105 VPWR VGND sg13cmos5l_decap_8
XFILLER_449_42 VPWR VGND sg13cmos5l_decap_4
XFILLER_168_21 VPWR VGND sg13cmos5l_decap_4
XFILLER_52_65 VPWR VGND sg13cmos5l_decap_8
XFILLER_168_54 VPWR VGND sg13cmos5l_decap_8
XFILLER_706_187 VPWR VGND sg13cmos5l_fill_2
XFILLER_572_182 VPWR VGND sg13cmos5l_decap_8
XFILLER_316_149 VPWR VGND sg13cmos5l_decap_8
XFILLER_682_28 VPWR VGND sg13cmos5l_decap_8
XFILLER_201_0 VPWR VGND sg13cmos5l_decap_8
XFILLER_324_160 VPWR VGND sg13cmos5l_decap_8
XFILLER_269_215 VPWR VGND sg13cmos5l_fill_2
XFILLER_619_106 VPWR VGND sg13cmos5l_fill_1
XFILLER_184_86 VPWR VGND sg13cmos5l_decap_8
XFILLER_184_97 VPWR VGND sg13cmos5l_fill_2
XFILLER_615_77 VPWR VGND sg13cmos5l_decap_8
XFILLER_619_139 VPWR VGND sg13cmos5l_decap_8
XFILLER_615_88 VPWR VGND sg13cmos5l_fill_1
XFILLER_485_134 VPWR VGND sg13cmos5l_decap_4
XFILLER_96_117 VPWR VGND sg13cmos5l_decap_8
XFILLER_334_56 VPWR VGND sg13cmos5l_decap_8
XFILLER_117_91 VPWR VGND sg13cmos5l_decap_8
XFILLER_77_73 VPWR VGND sg13cmos5l_decap_8
XFILLER_570_0 VPWR VGND sg13cmos5l_decap_8
XFILLER_631_21 VPWR VGND sg13cmos5l_decap_8
XFILLER_668_0 VPWR VGND sg13cmos5l_decap_8
XFILLER_627_172 VPWR VGND sg13cmos5l_decap_4
XFILLER_37_217 VPWR VGND sg13cmos5l_fill_1
X_0100_ _0100_/X _4445_/X _4446_/X _0895_/Q VPWR VGND sg13cmos5l_mux2_1
X_1080_ _1080_/Q Tile_X0Y0_FrameData[19] VGND VPWR Tile_X0Y9_FrameStrobe[4] latch
XFILLER_631_98 VPWR VGND sg13cmos5l_decap_8
XFILLER_203_49 VPWR VGND sg13cmos5l_decap_8
XFILLER_642_175 VPWR VGND sg13cmos5l_decap_8
XFILLER_398_108 VPWR VGND sg13cmos5l_decap_8
XFILLER_350_77 VPWR VGND sg13cmos5l_decap_8
XFILLER_500_14 VPWR VGND sg13cmos5l_decap_8
XANTENNA__3311__X Tile_X0Y0_E1BEG[3] VPWR VGND sg13cmos5l_antennanp
XFILLER_339_208 VPWR VGND sg13cmos5l_fill_1
XFILLER_359_42 VPWR VGND sg13cmos5l_decap_8
X_1982_ _1982_/Q Tile_X0Y4_FrameData[7] VGND VPWR Tile_X0Y9_FrameStrobe[1] latch
X_4770_ _4770_/X AXI_M_SOC_RDATA14 _4801_/X _4805_/X _4786_/X _0507_/Q _0506_/Q VPWR
+ VGND sg13cmos5l_mux4_1
XFILLER_20_106 VPWR VGND sg13cmos5l_decap_8
X_0933_ _0933_/Q Tile_X0Y9_FrameData[24] VGND VPWR Tile_X0Y9_FrameStrobe[8] latch
X_3721_ AXI_M_SOC_WDATA31 Tile_X0Y6_W1END[3] Tile_X0Y6_WW4END[7] Tile_X0Y6_WW4END[15]
+ _4583_/X _2497_/Q _2496_/Q VPWR VGND sg13cmos5l_mux4_1
XFILLER_13_180 VPWR VGND sg13cmos5l_decap_4
XFILLER_9_151 VPWR VGND sg13cmos5l_decap_8
XFILLER_570_119 VPWR VGND sg13cmos5l_decap_8
XFILLER_509_56 VPWR VGND sg13cmos5l_decap_8
XFILLER_173_111 VPWR VGND sg13cmos5l_decap_4
X_0864_ _0864_/Q Tile_X0Y9_FrameData[31] VGND VPWR Tile_X0Y9_FrameStrobe[6] latch
X_3652_ AXI_M_SOC_AWADDR13 Tile_X0Y5_W1END[1] Tile_X0Y5_WW4END[5] Tile_X0Y5_WW4END[13]
+ _4464_/X _2245_/Q _2244_/Q VPWR VGND sg13cmos5l_mux4_1
XFILLER_563_171 VPWR VGND sg13cmos5l_fill_2
XFILLER_656_84 VPWR VGND sg13cmos5l_decap_8
X_2603_ _2603_/Q Tile_X0Y6_FrameData[28] VGND VPWR Tile_X0Y9_FrameStrobe[5] latch
XFILLER_592_28 VPWR VGND sg13cmos5l_decap_8
XFILLER_375_63 VPWR VGND sg13cmos5l_decap_4
X_3583_ Tile_X0Y9_FrameData_O[13] Tile_X0Y9_FrameData[13] VPWR VGND sg13cmos5l_buf_1
X_0795_ _0795_/Q Tile_X0Y9_FrameData[4] VGND VPWR Tile_X0Y9_FrameStrobe[3] latch
XFILLER_173_188 VPWR VGND sg13cmos5l_decap_8
XFILLER_712_168 VPWR VGND sg13cmos5l_decap_8
X_2534_ _2534_/Q Tile_X0Y6_FrameData[1] VGND VPWR Tile_X0Y9_FrameStrobe[2] latch
XFILLER_315_160 VPWR VGND sg13cmos5l_decap_4
XFILLER_525_55 VPWR VGND sg13cmos5l_fill_1
XFILLER_315_193 VPWR VGND sg13cmos5l_decap_4
XFILLER_47_0 VPWR VGND sg13cmos5l_fill_2
X_2465_ _2465_/Q Tile_X0Y6_FrameData[6] VGND VPWR Tile_X0Y9_FrameStrobe[0] latch
XFILLER_525_99 VPWR VGND sg13cmos5l_decap_8
XFILLER_244_56 VPWR VGND sg13cmos5l_decap_8
X_1416_ _1416_/Q Tile_X0Y1_FrameData[17] VGND VPWR Tile_X0Y9_FrameStrobe[7] latch
X_4204_ _4204_/X _4143_/X _4251_/X _4250_/X _4142_/X _1683_/Q _1682_/Q VPWR VGND sg13cmos5l_mux4_1
X_2396_ _2396_/Q Tile_X0Y5_FrameData[9] VGND VPWR Tile_X0Y9_FrameStrobe[6] latch
XFILLER_541_21 VPWR VGND sg13cmos5l_decap_8
XFILLER_491_126 VPWR VGND sg13cmos5l_decap_8
XFILLER_3_70 VPWR VGND sg13cmos5l_decap_8
X_4135_ _4135_/X Tile_X0Y4_W2MID[4] Tile_X0Y4_W2END[4] Tile_X0Y4_W6END[4] _4319_/X
+ _2167_/Q _2166_/Q VPWR VGND sg13cmos5l_mux4_1
X_1347_ _1347_/Q Tile_X0Y1_FrameData[22] VGND VPWR Tile_X0Y9_FrameStrobe[5] latch
XFILLER_95_161 VPWR VGND sg13cmos5l_fill_2
XFILLER_28_217 VPWR VGND sg13cmos5l_fill_1
XFILLER_541_76 VPWR VGND sg13cmos5l_decap_8
XFILLER_95_183 VPWR VGND sg13cmos5l_fill_1
XFILLER_633_142 VPWR VGND sg13cmos5l_fill_1
X_4066_ _4066_/X Tile_X0Y2_WW4END[5] AXI_M_SOC_AWREADY _4121_/X _4100_/X _1541_/Q
+ _1540_/Q VPWR VGND sg13cmos5l_mux4_1
X_1278_ _1278_/Q Tile_X0Y1_FrameData[27] VGND VPWR Tile_X0Y9_FrameStrobe[3] latch
XFILLER_633_164 VPWR VGND sg13cmos5l_decap_4
X_3017_ Tile_X0Y5_E6BEG[4] _4408_/X VPWR VGND sg13cmos5l_buf_1
X_0229_ _0229_/Q Tile_X0Y7_FrameData[26] VGND VPWR Tile_X0Y9_FrameStrobe[2] latch
XFILLER_410_14 VPWR VGND sg13cmos5l_decap_8
XANTENNA__3221__X Tile_X0Y0_FrameStrobe_O[9] VPWR VGND sg13cmos5l_antennanp
XFILLER_397_141 VPWR VGND sg13cmos5l_decap_8
XFILLER_697_91 VPWR VGND sg13cmos5l_decap_8
XFILLER_400_112 VPWR VGND sg13cmos5l_decap_8
XFILLER_269_42 VPWR VGND sg13cmos5l_decap_8
XFILLER_400_167 VPWR VGND sg13cmos5l_decap_8
X_3919_ _3919_/X _4120_/X _4124_/X _4113_/X _4097_/X _1649_/Q _1648_/Q VPWR VGND sg13cmos5l_mux4_1
XFILLER_149_152 VPWR VGND sg13cmos5l_decap_8
X_4899_ _4899_/X Tile_X0Y8_W1END[3] Tile_X0Y8_W6END[11] _4815_/X _4775_/X _0629_/Q
+ _0628_/Q VPWR VGND sg13cmos5l_mux4_1
XFILLER_561_119 VPWR VGND sg13cmos5l_fill_2
XFILLER_419_56 VPWR VGND sg13cmos5l_decap_8
XFILLER_22_35 VPWR VGND sg13cmos5l_decap_8
XFILLER_125_7 VPWR VGND sg13cmos5l_decap_8
XFILLER_566_84 VPWR VGND sg13cmos5l_decap_8
XFILLER_138_35 VPWR VGND sg13cmos5l_decap_8
XFILLER_716_21 VPWR VGND sg13cmos5l_decap_4
XFILLER_554_193 VPWR VGND sg13cmos5l_fill_2
XFILLER_285_63 VPWR VGND sg13cmos5l_decap_8
XFILLER_98_28 VPWR VGND sg13cmos5l_decap_8
XFILLER_703_168 VPWR VGND sg13cmos5l_fill_2
XFILLER_435_77 VPWR VGND sg13cmos5l_decap_8
XFILLER_467_123 VPWR VGND sg13cmos5l_decap_8
XFILLER_154_34 VPWR VGND sg13cmos5l_decap_4
XFILLER_494_7 VPWR VGND sg13cmos5l_decap_8
XFILLER_451_21 VPWR VGND sg13cmos5l_decap_8
XFILLER_671_215 VPWR VGND sg13cmos5l_fill_2
XFILLER_661_7 VPWR VGND sg13cmos5l_decap_8
XFILLER_609_194 VPWR VGND sg13cmos5l_decap_8
XFILLER_19_217 VPWR VGND sg13cmos5l_fill_1
XFILLER_170_11 VPWR VGND sg13cmos5l_fill_2
XFILLER_86_183 VPWR VGND sg13cmos5l_decap_8
XFILLER_451_98 VPWR VGND sg13cmos5l_fill_2
XFILLER_601_35 VPWR VGND sg13cmos5l_decap_8
XFILLER_624_186 VPWR VGND sg13cmos5l_fill_1
XFILLER_34_209 VPWR VGND sg13cmos5l_fill_2
XFILLER_320_14 VPWR VGND sg13cmos5l_decap_8
XANTENNA__3131__X Tile_X0Y7_FrameData_O[1] VPWR VGND sg13cmos5l_antennanp
XFILLER_388_130 VPWR VGND sg13cmos5l_decap_8
XFILLER_677_28 VPWR VGND sg13cmos5l_decap_8
XFILLER_63_53 VPWR VGND sg13cmos5l_fill_2
XFILLER_320_69 VPWR VGND sg13cmos5l_fill_1
XFILLER_151_0 VPWR VGND sg13cmos5l_decap_8
XFILLER_249_0 VPWR VGND sg13cmos5l_decap_8
XANTENNA__2970__X Tile_X0Y8_FrameData_O[10] VPWR VGND sg13cmos5l_antennanp
XFILLER_592_211 VPWR VGND sg13cmos5l_decap_8
XFILLER_179_64 VPWR VGND sg13cmos5l_fill_1
XFILLER_179_86 VPWR VGND sg13cmos5l_decap_8
XFILLER_416_0 VPWR VGND sg13cmos5l_decap_8
XFILLER_476_62 VPWR VGND sg13cmos5l_decap_8
XFILLER_693_49 VPWR VGND sg13cmos5l_decap_8
XFILLER_626_21 VPWR VGND sg13cmos5l_decap_8
XFILLER_155_144 VPWR VGND sg13cmos5l_decap_4
XFILLER_155_155 VPWR VGND sg13cmos5l_decap_8
XFILLER_195_63 VPWR VGND sg13cmos5l_decap_8
XFILLER_155_199 VPWR VGND sg13cmos5l_decap_8
X_0580_ _0580_/Q Tile_X0Y8_FrameData[27] VGND VPWR Tile_X0Y9_FrameStrobe[5] latch
XFILLER_626_98 VPWR VGND sg13cmos5l_decap_8
XFILLER_458_112 VPWR VGND sg13cmos5l_fill_1
XFILLER_88_61 VPWR VGND sg13cmos5l_decap_8
XFILLER_345_77 VPWR VGND sg13cmos5l_decap_8
XFILLER_458_145 VPWR VGND sg13cmos5l_decap_8
XFILLER_312_152 VPWR VGND sg13cmos5l_decap_8
XANTENNA__3306__X Tile_X0Y0_E2BEG[6] VPWR VGND sg13cmos5l_antennanp
XFILLER_642_42 VPWR VGND sg13cmos5l_decap_8
X_2250_ _2250_/Q Tile_X0Y5_FrameData[27] VGND VPWR Tile_X0Y9_FrameStrobe[2] latch
XFILLER_662_215 VPWR VGND sg13cmos5l_fill_2
XFILLER_361_21 VPWR VGND sg13cmos5l_decap_8
X_1201_ _1201_/Q Tile_X0Y1_FrameData[8] VGND VPWR Tile_X0Y9_FrameStrobe[0] latch
X_2181_ _2181_/Q Tile_X0Y4_FrameData[0] VGND VPWR Tile_X0Y9_FrameStrobe[7] latch
XFILLER_473_148 VPWR VGND sg13cmos5l_decap_4
XFILLER_77_183 VPWR VGND sg13cmos5l_decap_8
X_1132_ _1132_/Q Tile_X0Y0_FrameData[31] VGND VPWR Tile_X0Y9_FrameStrobe[6] latch
XFILLER_92_120 VPWR VGND sg13cmos5l_decap_8
XFILLER_511_35 VPWR VGND sg13cmos5l_decap_8
XFILLER_615_175 VPWR VGND sg13cmos5l_fill_1
XFILLER_630_112 VPWR VGND sg13cmos5l_decap_8
XFILLER_25_209 VPWR VGND sg13cmos5l_fill_2
X_1063_ _1063_/Q Tile_X0Y0_FrameData[4] VGND VPWR Tile_X0Y9_FrameStrobe[3] latch
XFILLER_230_14 VPWR VGND sg13cmos5l_decap_8
XANTENNA__3041__X Tile_X0Y5_FrameData_O[0] VPWR VGND sg13cmos5l_antennanp
XFILLER_587_28 VPWR VGND sg13cmos5l_decap_8
XFILLER_230_58 VPWR VGND sg13cmos5l_fill_1
XANTENNA__2880__X Tile_X0Y6_FrameData_O[1] VPWR VGND sg13cmos5l_antennanp
X_4822_ _4822_/X Tile_X0Y7_W1END[2] Tile_X0Y7_W2MID[1] Tile_X0Y7_W2END[1] _4670_/X
+ _0359_/Q _0358_/Q VPWR VGND sg13cmos5l_mux4_1
XFILLER_528_116 VPWR VGND sg13cmos5l_decap_8
XFILLER_394_122 VPWR VGND sg13cmos5l_fill_1
XFILLER_379_196 VPWR VGND sg13cmos5l_fill_1
XFILLER_394_155 VPWR VGND sg13cmos5l_decap_8
X_4753_ _4753_/X Tile_X0Y8_WW4END[6] AXI_M_SOC_RDATA14 _4806_/X _4786_/X _0541_/Q
+ _0540_/Q VPWR VGND sg13cmos5l_mux4_1
X_1965_ _1965_/Q Tile_X0Y4_FrameData[24] VGND VPWR Tile_X0Y9_FrameStrobe[1] latch
XFILLER_193_217 VPWR VGND sg13cmos5l_fill_1
XFILLER_543_119 VPWR VGND sg13cmos5l_fill_2
XFILLER_239_56 VPWR VGND sg13cmos5l_decap_8
X_3704_ AXI_M_SOC_WDATA14 Tile_X0Y7_W1END[2] Tile_X0Y7_WW4END[6] Tile_X0Y7_WW4END[14]
+ _4698_/X _0219_/Q _0218_/Q VPWR VGND sg13cmos5l_mux4_1
X_0916_ _0916_/Q Tile_X0Y9_FrameData[11] VGND VPWR Tile_X0Y9_FrameStrobe[7] latch
X_1896_ _1896_/Q Tile_X0Y3_FrameData[1] VGND VPWR Tile_X0Y9_FrameStrobe[6] latch
X_4684_ _4684_/X _4661_/X Tile_X0Y9_N4END[8] _4660_/X _0056_/X _0215_/Q _0214_/Q VPWR
+ VGND sg13cmos5l_mux4_1
XFILLER_536_21 VPWR VGND sg13cmos5l_decap_8
XFILLER_146_144 VPWR VGND sg13cmos5l_decap_8
X_0847_ _0847_/Q Tile_X0Y9_FrameData[16] VGND VPWR Tile_X0Y9_FrameStrobe[5] latch
X_3635_ Tile_X0Y9_S4BEG[13] _3635_/A VPWR VGND sg13cmos5l_buf_1
XFILLER_697_134 VPWR VGND sg13cmos5l_fill_1
XFILLER_700_105 VPWR VGND sg13cmos5l_fill_1
XFILLER_161_136 VPWR VGND sg13cmos5l_decap_4
X_0778_ _0778_/Q Tile_X0Y9_FrameData[21] VGND VPWR Tile_X0Y9_FrameStrobe[3] latch
X_3566_ Tile_X0Y9_EE4BEG[12] _4876_/X VPWR VGND sg13cmos5l_buf_1
XFILLER_697_178 VPWR VGND sg13cmos5l_decap_8
XFILLER_108_49 VPWR VGND sg13cmos5l_decap_8
XFILLER_303_130 VPWR VGND sg13cmos5l_decap_8
XFILLER_161_169 VPWR VGND sg13cmos5l_fill_2
X_2517_ _2517_/Q Tile_X0Y6_FrameData[18] VGND VPWR Tile_X0Y9_FrameStrobe[2] latch
XFILLER_405_14 VPWR VGND sg13cmos5l_decap_8
X_3497_ Tile_X0Y1_E6BEG[7] _3971_/X VPWR VGND sg13cmos5l_buf_1
XANTENNA__3216__X Tile_X0Y0_FrameStrobe_O[4] VPWR VGND sg13cmos5l_antennanp
XFILLER_552_42 VPWR VGND sg13cmos5l_decap_8
X_2448_ _2448_/Q Tile_X0Y6_FrameData[23] VGND VPWR Tile_X0Y9_FrameStrobe[0] latch
XFILLER_405_69 VPWR VGND sg13cmos5l_decap_8
XFILLER_271_21 VPWR VGND sg13cmos5l_decap_8
X_2379_ _2379_/Q Tile_X0Y5_FrameData[26] VGND VPWR Tile_X0Y9_FrameStrobe[6] latch
XFILLER_702_56 VPWR VGND sg13cmos5l_decap_8
XFILLER_68_183 VPWR VGND sg13cmos5l_decap_8
X_4118_ _4118_/X _4093_/X _0057_/X _4092_/X Tile_X0Y0_S4END[10] _1477_/Q _1476_/Q
+ VPWR VGND sg13cmos5l_mux4_1
XFILLER_271_98 VPWR VGND sg13cmos5l_decap_8
XFILLER_83_131 VPWR VGND sg13cmos5l_decap_8
XFILLER_421_35 VPWR VGND sg13cmos5l_decap_8
XFILLER_204_70 VPWR VGND sg13cmos5l_decap_8
XFILLER_216_126 VPWR VGND sg13cmos5l_decap_8
XFILLER_17_35 VPWR VGND sg13cmos5l_decap_8
XFILLER_140_14 VPWR VGND sg13cmos5l_decap_8
X_4049_ _4049_/X Tile_X0Y2_W2END[6] AXI_M_SOC_AWREADY _4099_/X _4098_/X _1575_/Q _1574_/Q
+ VPWR VGND sg13cmos5l_mux4_1
XFILLER_621_156 VPWR VGND sg13cmos5l_decap_8
XFILLER_497_28 VPWR VGND sg13cmos5l_decap_8
XFILLER_621_178 VPWR VGND sg13cmos5l_decap_4
XFILLER_621_189 VPWR VGND sg13cmos5l_fill_1
XANTENNA__2790__X Tile_X0Y3_E6BEG[0] VPWR VGND sg13cmos5l_antennanp
XFILLER_708_216 VPWR VGND sg13cmos5l_fill_2
XFILLER_149_34 VPWR VGND sg13cmos5l_decap_8
XFILLER_507_7 VPWR VGND sg13cmos5l_decap_8
XFILLER_296_84 VPWR VGND sg13cmos5l_fill_1
XFILLER_446_21 VPWR VGND sg13cmos5l_decap_8
XFILLER_137_166 VPWR VGND sg13cmos5l_decap_8
XFILLER_341_203 VPWR VGND sg13cmos5l_decap_8
XFILLER_3_135 VPWR VGND sg13cmos5l_decap_8
XFILLER_315_14 VPWR VGND sg13cmos5l_decap_8
XANTENNA__3126__X Tile_X0Y7_EE4BEG[12] VPWR VGND sg13cmos5l_antennanp
XFILLER_462_42 VPWR VGND sg13cmos5l_decap_8
XFILLER_239_207 VPWR VGND sg13cmos5l_decap_4
XFILLER_455_126 VPWR VGND sg13cmos5l_decap_8
XFILLER_58_75 VPWR VGND sg13cmos5l_decap_8
XFILLER_199_0 VPWR VGND sg13cmos5l_decap_8
XFILLER_181_43 VPWR VGND sg13cmos5l_decap_8
XANTENNA__2965__X Tile_X0Y8_FrameData_O[5] VPWR VGND sg13cmos5l_antennanp
XFILLER_612_56 VPWR VGND sg13cmos5l_decap_8
XFILLER_59_183 VPWR VGND sg13cmos5l_decap_4
XFILLER_470_107 VPWR VGND sg13cmos5l_decap_8
XFILLER_207_104 VPWR VGND sg13cmos5l_decap_8
XFILLER_331_35 VPWR VGND sg13cmos5l_decap_8
XFILLER_612_112 VPWR VGND sg13cmos5l_decap_8
XFILLER_366_0 VPWR VGND sg13cmos5l_decap_8
XFILLER_463_192 VPWR VGND sg13cmos5l_fill_1
XFILLER_74_186 VPWR VGND sg13cmos5l_decap_8
XFILLER_222_118 VPWR VGND sg13cmos5l_decap_4
XFILLER_533_0 VPWR VGND sg13cmos5l_decap_8
XFILLER_200_28 VPWR VGND sg13cmos5l_decap_8
XFILLER_130_91 VPWR VGND sg13cmos5l_decap_8
XFILLER_230_162 VPWR VGND sg13cmos5l_decap_8
XFILLER_88_7 VPWR VGND sg13cmos5l_decap_8
XFILLER_700_0 VPWR VGND sg13cmos5l_decap_8
XFILLER_175_217 VPWR VGND sg13cmos5l_fill_1
XFILLER_128_100 VPWR VGND sg13cmos5l_fill_2
XFILLER_637_42 VPWR VGND sg13cmos5l_decap_8
XFILLER_518_160 VPWR VGND sg13cmos5l_decap_8
X_1750_ _1750_/Q Tile_X0Y3_FrameData[19] VGND VPWR Tile_X0Y9_FrameStrobe[2] latch
XFILLER_518_171 VPWR VGND sg13cmos5l_fill_1
XFILLER_391_136 VPWR VGND sg13cmos5l_decap_8
XFILLER_518_193 VPWR VGND sg13cmos5l_decap_4
XFILLER_356_21 VPWR VGND sg13cmos5l_decap_8
X_0701_ _0701_/Q Tile_X0Y9_FrameData[2] VGND VPWR Tile_X0Y9_FrameStrobe[0] latch
XFILLER_679_123 VPWR VGND sg13cmos5l_fill_2
X_1681_ _1681_/Q Tile_X0Y3_FrameData[24] VGND VPWR Tile_X0Y9_FrameStrobe[0] latch
XFILLER_679_134 VPWR VGND sg13cmos5l_fill_1
XFILLER_332_203 VPWR VGND sg13cmos5l_fill_2
XFILLER_143_103 VPWR VGND sg13cmos5l_decap_8
XFILLER_478_207 VPWR VGND sg13cmos5l_decap_4
X_0632_ _0632_/Q Tile_X0Y8_FrameData[7] VGND VPWR Tile_X0Y9_FrameStrobe[6] latch
X_3420_ Tile_X0Y4_FrameData_O[11] Tile_X0Y4_FrameData[11] VPWR VGND sg13cmos5l_buf_1
XFILLER_356_98 VPWR VGND sg13cmos5l_decap_8
XFILLER_506_35 VPWR VGND sg13cmos5l_decap_8
X_3351_ Tile_X0Y2_FrameData_O[22] Tile_X0Y2_FrameData[22] VPWR VGND sg13cmos5l_buf_1
X_0563_ _0563_/Q Tile_X0Y8_FrameData[12] VGND VPWR Tile_X0Y9_FrameStrobe[4] latch
XFILLER_653_63 VPWR VGND sg13cmos5l_decap_8
XANTENNA__3036__X Tile_X0Y5_EE4BEG[11] VPWR VGND sg13cmos5l_antennanp
X_2302_ _2302_/Q Tile_X0Y5_FrameData[7] VGND VPWR Tile_X0Y9_FrameStrobe[3] latch
XFILLER_372_42 VPWR VGND sg13cmos5l_decap_8
X_3282_ Tile_X0Y0_E6BEG[2] _3838_/X VPWR VGND sg13cmos5l_buf_1
X_0494_ _0494_/Q Tile_X0Y8_FrameData[17] VGND VPWR Tile_X0Y9_FrameStrobe[2] latch
XFILLER_300_122 VPWR VGND sg13cmos5l_decap_8
XFILLER_297_184 VPWR VGND sg13cmos5l_decap_4
XFILLER_297_195 VPWR VGND sg13cmos5l_decap_8
X_2233_ _2233_/Q Tile_X0Y5_FrameData[12] VGND VPWR Tile_X0Y9_FrameStrobe[1] latch
XFILLER_57_109 VPWR VGND sg13cmos5l_decap_8
XANTENNA__2875__X Tile_X0Y6_EE4BEG[12] VPWR VGND sg13cmos5l_antennanp
XFILLER_305_80 VPWR VGND sg13cmos5l_fill_1
XFILLER_522_56 VPWR VGND sg13cmos5l_decap_8
X_2164_ _2164_/Q Tile_X0Y4_FrameData[17] VGND VPWR Tile_X0Y9_FrameStrobe[7] latch
XFILLER_65_131 VPWR VGND sg13cmos5l_decap_8
XFILLER_241_35 VPWR VGND sg13cmos5l_decap_8
X_1115_ _1115_/Q Tile_X0Y0_FrameData[16] VGND VPWR Tile_X0Y9_FrameStrobe[5] latch
XFILLER_241_57 VPWR VGND sg13cmos5l_decap_8
X_2095_ _2095_/Q Tile_X0Y4_FrameData[22] VGND VPWR Tile_X0Y9_FrameStrobe[5] latch
XFILLER_598_49 VPWR VGND sg13cmos5l_decap_8
XFILLER_402_207 VPWR VGND sg13cmos5l_fill_2
X_1046_ _1046_/Q Tile_X0Y0_FrameData[21] VGND VPWR Tile_X0Y9_FrameStrobe[3] latch
XFILLER_206_170 VPWR VGND sg13cmos5l_decap_4
X_4805_ _4805_/X _4779_/X Tile_X0Y9_N4END[5] _4778_/X _0076_/X _0461_/Q _0460_/Q VPWR
+ VGND sg13cmos5l_mux4_1
X_2997_ Tile_X0Y5_E2BEG[0] _4372_/X VPWR VGND sg13cmos5l_buf_1
XFILLER_367_188 VPWR VGND sg13cmos5l_decap_8
XFILLER_547_42 VPWR VGND sg13cmos5l_decap_8
X_4736_ _4736_/X Tile_X0Y8_W2END[7] AXI_M_SOC_RDATA15 _4785_/X _4784_/X _0575_/Q _0574_/Q
+ VPWR VGND sg13cmos5l_mux4_1
XFILLER_382_136 VPWR VGND sg13cmos5l_decap_8
X_1948_ _1948_/Q Tile_X0Y4_FrameData[9] VGND VPWR Tile_X0Y9_FrameStrobe[0] latch
XFILLER_694_70 VPWR VGND sg13cmos5l_decap_8
XFILLER_119_133 VPWR VGND sg13cmos5l_fill_2
XFILLER_266_21 VPWR VGND sg13cmos5l_decap_8
X_4667_ _4667_/X Tile_X0Y8_W1END[3] Tile_X0Y8_W6END[7] _4815_/X _4775_/X _0665_/Q
+ _0664_/Q VPWR VGND sg13cmos5l_mux4_1
XFILLER_119_59 VPWR VGND sg13cmos5l_fill_1
X_1879_ _1879_/Q Tile_X0Y3_FrameData[18] VGND VPWR Tile_X0Y9_FrameStrobe[6] latch
XFILLER_119_199 VPWR VGND sg13cmos5l_decap_8
XFILLER_469_207 VPWR VGND sg13cmos5l_fill_2
X_3618_ Tile_X0Y9_S2BEGb[4] _4936_/X VPWR VGND sg13cmos5l_buf_1
XFILLER_685_104 VPWR VGND sg13cmos5l_fill_2
XFILLER_524_196 VPWR VGND sg13cmos5l_decap_4
X_4598_ _4598_/X Tile_X0Y5_W1END[3] Tile_X0Y5_W2MID[0] Tile_X0Y5_W2END[0] _4428_/X
+ _2381_/Q _2380_/Q VPWR VGND sg13cmos5l_mux4_1
XFILLER_416_35 VPWR VGND sg13cmos5l_decap_8
XFILLER_563_63 VPWR VGND sg13cmos5l_decap_8
XFILLER_135_14 VPWR VGND sg13cmos5l_decap_8
X_3549_ Tile_X0Y9_E6BEG[7] _4887_/X VPWR VGND sg13cmos5l_buf_1
XFILLER_282_42 VPWR VGND sg13cmos5l_decap_8
XANTENNA__2785__X Tile_X0Y3_EE4BEG[11] VPWR VGND sg13cmos5l_antennanp
XFILLER_713_77 VPWR VGND sg13cmos5l_decap_8
XFILLER_437_148 VPWR VGND sg13cmos5l_decap_8
XFILLER_192_7 VPWR VGND sg13cmos5l_decap_8
XFILLER_432_56 VPWR VGND sg13cmos5l_decap_8
XFILLER_215_91 VPWR VGND sg13cmos5l_decap_8
XFILLER_641_207 VPWR VGND sg13cmos5l_fill_1
XFILLER_28_56 VPWR VGND sg13cmos5l_decap_8
XFILLER_151_35 VPWR VGND sg13cmos5l_decap_8
XFILLER_56_175 VPWR VGND sg13cmos5l_fill_2
XFILLER_457_7 VPWR VGND sg13cmos5l_decap_8
XFILLER_301_49 VPWR VGND sg13cmos5l_decap_8
XFILLER_624_7 VPWR VGND sg13cmos5l_decap_8
XFILLER_358_133 VPWR VGND sg13cmos5l_decap_8
XFILLER_562_203 VPWR VGND sg13cmos5l_fill_1
XFILLER_212_195 VPWR VGND sg13cmos5l_fill_2
XFILLER_8_216 VPWR VGND sg13cmos5l_fill_2
XFILLER_60_21 VPWR VGND sg13cmos5l_decap_8
XFILLER_457_42 VPWR VGND sg13cmos5l_decap_8
XFILLER_373_125 VPWR VGND sg13cmos5l_decap_8
XFILLER_226_2 VPWR VGND sg13cmos5l_fill_1
XFILLER_176_21 VPWR VGND sg13cmos5l_decap_8
XFILLER_60_98 VPWR VGND sg13cmos5l_decap_8
XFILLER_114_0 VPWR VGND sg13cmos5l_fill_2
XFILLER_607_56 VPWR VGND sg13cmos5l_decap_8
XFILLER_515_185 VPWR VGND sg13cmos5l_decap_8
XFILLER_515_196 VPWR VGND sg13cmos5l_fill_1
XFILLER_5_49 VPWR VGND sg13cmos5l_decap_8
XFILLER_530_133 VPWR VGND sg13cmos5l_fill_1
XFILLER_326_46 VPWR VGND sg13cmos5l_decap_4
XFILLER_125_158 VPWR VGND sg13cmos5l_decap_8
XFILLER_690_28 VPWR VGND sg13cmos5l_decap_8
XFILLER_326_57 VPWR VGND sg13cmos5l_decap_4
XFILLER_69_74 VPWR VGND sg13cmos5l_decap_8
XFILLER_192_42 VPWR VGND sg13cmos5l_decap_8
XFILLER_483_0 VPWR VGND sg13cmos5l_decap_8
XFILLER_428_126 VPWR VGND sg13cmos5l_decap_8
XFILLER_623_77 VPWR VGND sg13cmos5l_decap_8
XFILLER_342_56 VPWR VGND sg13cmos5l_decap_8
XFILLER_125_91 VPWR VGND sg13cmos5l_decap_8
XFILLER_294_187 VPWR VGND sg13cmos5l_decap_8
XFILLER_650_0 VPWR VGND sg13cmos5l_decap_8
XFILLER_85_84 VPWR VGND sg13cmos5l_decap_8
XFILLER_250_202 VPWR VGND sg13cmos5l_decap_8
XFILLER_211_49 VPWR VGND sg13cmos5l_decap_8
XFILLER_62_156 VPWR VGND sg13cmos5l_decap_8
XFILLER_396_217 VPWR VGND sg13cmos5l_fill_1
XFILLER_451_195 VPWR VGND sg13cmos5l_decap_8
X_2920_ Tile_X0Y8_E2BEG[4] _4732_/X VPWR VGND sg13cmos5l_buf_1
XFILLER_203_140 VPWR VGND sg13cmos5l_decap_8
X_2851_ Tile_X0Y6_E6BEG[0] _4528_/X VPWR VGND sg13cmos5l_buf_1
XFILLER_648_63 VPWR VGND sg13cmos5l_decap_8
XFILLER_349_166 VPWR VGND sg13cmos5l_decap_8
XFILLER_148_217 VPWR VGND sg13cmos5l_fill_1
XFILLER_364_103 VPWR VGND sg13cmos5l_decap_8
XFILLER_367_42 VPWR VGND sg13cmos5l_decap_8
X_1802_ _1802_/Q Tile_X0Y3_FrameData[31] VGND VPWR Tile_X0Y9_FrameStrobe[4] latch
XFILLER_349_199 VPWR VGND sg13cmos5l_decap_8
X_2782_ Tile_X0Y3_EE4BEG[8] _4172_/X VPWR VGND sg13cmos5l_buf_1
X_4521_ _4521_/X Tile_X0Y6_WW4END[6] AXI_M_SOC_RDATA30 _4574_/X _4554_/X _2565_/Q
+ _2564_/Q VPWR VGND sg13cmos5l_mux4_1
X_1733_ _1733_/Q Tile_X0Y3_FrameData[4] VGND VPWR Tile_X0Y9_FrameStrobe[1] latch
XFILLER_517_56 VPWR VGND sg13cmos5l_decap_8
XFILLER_305_214 VPWR VGND sg13cmos5l_decap_4
XFILLER_116_125 VPWR VGND sg13cmos5l_fill_1
X_4452_ _4452_/X _4421_/X _0159_/X _4420_/X _0145_/X _2235_/Q _2234_/Q VPWR VGND sg13cmos5l_mux4_1
X_1664_ _1664_/Q Tile_X0Y2_FrameData[17] VGND VPWR Tile_X0Y9_FrameStrobe[7] latch
XFILLER_664_84 VPWR VGND sg13cmos5l_decap_4
XFILLER_116_147 VPWR VGND sg13cmos5l_fill_2
XFILLER_236_35 VPWR VGND sg13cmos5l_decap_8
XFILLER_236_46 VPWR VGND sg13cmos5l_fill_2
X_3403_ Tile_X0Y2_E2BEG[6] _4046_/X VPWR VGND sg13cmos5l_buf_1
X_0615_ _0615_/Q Tile_X0Y8_FrameData[24] VGND VPWR Tile_X0Y9_FrameStrobe[6] latch
X_1595_ _1595_/Q Tile_X0Y2_FrameData[22] VGND VPWR Tile_X0Y9_FrameStrobe[5] latch
X_4383_ _4383_/X Tile_X0Y5_W2END[4] AXI_M_SOC_RVALID _4434_/X _4433_/X _2337_/Q _2336_/Q
+ VPWR VGND sg13cmos5l_mux4_1
XFILLER_521_166 VPWR VGND sg13cmos5l_decap_8
XFILLER_320_217 VPWR VGND sg13cmos5l_fill_1
XFILLER_667_159 VPWR VGND sg13cmos5l_fill_1
XFILLER_383_85 VPWR VGND sg13cmos5l_fill_2
X_0546_ _0546_/Q Tile_X0Y8_FrameData[29] VGND VPWR Tile_X0Y9_FrameStrobe[4] latch
X_3334_ Tile_X0Y2_FrameData_O[5] Tile_X0Y2_FrameData[5] VPWR VGND sg13cmos5l_buf_1
XFILLER_608_215 VPWR VGND sg13cmos5l_fill_2
XFILLER_316_90 VPWR VGND sg13cmos5l_decap_8
X_0477_ _0477_/Q Tile_X0Y8_FrameData[2] VGND VPWR Tile_X0Y9_FrameStrobe[1] latch
X_3265_ Tile_X0Y0_EE4BEG[1] _3821_/X VPWR VGND sg13cmos5l_buf_1
XFILLER_690_140 VPWR VGND sg13cmos5l_fill_2
X_2216_ _2216_/Q Tile_X0Y5_FrameData[29] VGND VPWR Tile_X0Y9_FrameStrobe[1] latch
X_3196_ Tile_X0Y0_N2BEGb[4] _3897_/X VPWR VGND sg13cmos5l_buf_1
XFILLER_285_198 VPWR VGND sg13cmos5l_decap_8
XFILLER_226_210 VPWR VGND sg13cmos5l_decap_8
X_2147_ _2147_/Q Tile_X0Y4_FrameData[2] VGND VPWR Tile_X0Y9_FrameStrobe[6] latch
XFILLER_53_101 VPWR VGND sg13cmos5l_decap_8
XFILLER_689_70 VPWR VGND sg13cmos5l_fill_1
X_2078_ _2078_/Q Tile_X0Y4_FrameData[7] VGND VPWR Tile_X0Y9_FrameStrobe[4] latch
XFILLER_442_173 VPWR VGND sg13cmos5l_decap_8
XFILLER_387_206 VPWR VGND sg13cmos5l_decap_4
XFILLER_121_49 VPWR VGND sg13cmos5l_decap_8
XFILLER_387_217 VPWR VGND sg13cmos5l_fill_1
XFILLER_53_178 VPWR VGND sg13cmos5l_fill_2
X_1029_ _1029_/Q Tile_X0Y0_FrameData[6] VGND VPWR Tile_X0Y9_FrameStrobe[2] latch
XFILLER_14_14 VPWR VGND sg13cmos5l_decap_8
XFILLER_139_217 VPWR VGND sg13cmos5l_fill_1
XFILLER_558_85 VPWR VGND sg13cmos5l_decap_8
XFILLER_277_42 VPWR VGND sg13cmos5l_decap_8
XFILLER_355_147 VPWR VGND sg13cmos5l_decap_8
XFILLER_154_209 VPWR VGND sg13cmos5l_decap_8
XFILLER_708_77 VPWR VGND sg13cmos5l_decap_8
X_4719_ _4719_/X _4805_/X _4809_/X _4813_/X _4788_/X _0608_/Q _0607_/Q VPWR VGND sg13cmos5l_mux4_1
XFILLER_427_56 VPWR VGND sg13cmos5l_decap_8
XFILLER_30_35 VPWR VGND sg13cmos5l_decap_8
XFILLER_107_125 VPWR VGND sg13cmos5l_decap_8
XFILLER_574_73 VPWR VGND sg13cmos5l_decap_8
XFILLER_205_7 VPWR VGND sg13cmos5l_decap_8
XFILLER_146_35 VPWR VGND sg13cmos5l_decap_8
XFILLER_100_6 VPWR VGND sg13cmos5l_decap_8
XFILLER_311_206 VPWR VGND sg13cmos5l_decap_8
XFILLER_293_63 VPWR VGND sg13cmos5l_decap_8
XFILLER_311_217 VPWR VGND sg13cmos5l_fill_1
XFILLER_122_128 VPWR VGND sg13cmos5l_fill_2
XFILLER_276_121 VPWR VGND sg13cmos5l_fill_1
XFILLER_162_23 VPWR VGND sg13cmos5l_fill_1
XFILLER_666_192 VPWR VGND sg13cmos5l_fill_1
XFILLER_276_143 VPWR VGND sg13cmos5l_decap_8
XFILLER_574_7 VPWR VGND sg13cmos5l_decap_8
XFILLER_130_161 VPWR VGND sg13cmos5l_decap_8
XFILLER_162_45 VPWR VGND sg13cmos5l_decap_8
XANTENNA__3404__X Tile_X0Y2_E2BEG[7] VPWR VGND sg13cmos5l_antennanp
XFILLER_276_187 VPWR VGND sg13cmos5l_fill_2
XFILLER_29_131 VPWR VGND sg13cmos5l_fill_1
XFILLER_29_153 VPWR VGND sg13cmos5l_decap_8
XFILLER_291_146 VPWR VGND sg13cmos5l_decap_8
XFILLER_418_192 VPWR VGND sg13cmos5l_fill_1
XFILLER_44_134 VPWR VGND sg13cmos5l_fill_2
XFILLER_433_173 VPWR VGND sg13cmos5l_decap_8
XFILLER_579_166 VPWR VGND sg13cmos5l_fill_1
XFILLER_71_20 VPWR VGND sg13cmos5l_decap_8
XFILLER_594_158 VPWR VGND sg13cmos5l_fill_2
XFILLER_111_82 VPWR VGND sg13cmos5l_decap_8
XFILLER_685_28 VPWR VGND sg13cmos5l_decap_8
XFILLER_468_63 VPWR VGND sg13cmos5l_fill_2
XFILLER_111_93 VPWR VGND sg13cmos5l_fill_2
XFILLER_231_0 VPWR VGND sg13cmos5l_decap_8
XFILLER_200_121 VPWR VGND sg13cmos5l_fill_1
XFILLER_197_183 VPWR VGND sg13cmos5l_decap_8
XFILLER_329_0 VPWR VGND sg13cmos5l_decap_8
XFILLER_187_42 VPWR VGND sg13cmos5l_decap_8
XFILLER_200_143 VPWR VGND sg13cmos5l_fill_1
XFILLER_71_97 VPWR VGND sg13cmos5l_decap_8
XFILLER_346_169 VPWR VGND sg13cmos5l_decap_8
XFILLER_618_77 VPWR VGND sg13cmos5l_decap_8
XFILLER_337_56 VPWR VGND sg13cmos5l_decap_8
XFILLER_58_8 VPWR VGND sg13cmos5l_decap_8
XFILLER_484_84 VPWR VGND sg13cmos5l_decap_4
XFILLER_634_21 VPWR VGND sg13cmos5l_decap_8
XFILLER_503_133 VPWR VGND sg13cmos5l_decap_8
XFILLER_649_126 VPWR VGND sg13cmos5l_decap_8
XFILLER_698_0 VPWR VGND sg13cmos5l_decap_8
X_0400_ _0400_/Q Tile_X0Y7_FrameData[15] VGND VPWR Tile_X0Y9_FrameStrobe[7] latch
XFILLER_113_139 VPWR VGND sg13cmos5l_decap_4
XFILLER_206_27 VPWR VGND sg13cmos5l_decap_8
X_1380_ _1380_/Q Tile_X0Y1_FrameData[21] VGND VPWR Tile_X0Y9_FrameStrobe[6] latch
XFILLER_634_98 VPWR VGND sg13cmos5l_decap_8
X_0331_ _0331_/Q Tile_X0Y7_FrameData[20] VGND VPWR Tile_X0Y9_FrameStrobe[5] latch
XFILLER_353_77 VPWR VGND sg13cmos5l_decap_8
XFILLER_503_14 VPWR VGND sg13cmos5l_decap_8
XANTENNA__3314__X Tile_X0Y4_EE4BEG[2] VPWR VGND sg13cmos5l_antennanp
XFILLER_650_42 VPWR VGND sg13cmos5l_decap_8
X_3050_ Tile_X0Y5_FrameData_O[9] Tile_X0Y5_FrameData[9] VPWR VGND sg13cmos5l_buf_1
X_0262_ _0262_/Q Tile_X0Y7_FrameData[25] VGND VPWR Tile_X0Y9_FrameStrobe[3] latch
X_2001_ _2001_/Q Tile_X0Y4_FrameData[20] VGND VPWR Tile_X0Y9_FrameStrobe[2] latch
X_0193_ _0193_/Q Tile_X0Y7_FrameData[30] VGND VPWR Tile_X0Y9_FrameStrobe[1] latch
XFILLER_424_140 VPWR VGND sg13cmos5l_decap_8
XFILLER_369_217 VPWR VGND sg13cmos5l_fill_1
XFILLER_290_190 VPWR VGND sg13cmos5l_decap_4
X_3952_ _3952_/X Tile_X0Y1_WW4END[11] AXI_M_SOC_ARREADY _4019_/X _3995_/X _1305_/Q
+ _1304_/Q VPWR VGND sg13cmos5l_mux4_1
XFILLER_659_84 VPWR VGND sg13cmos5l_decap_8
XFILLER_384_209 VPWR VGND sg13cmos5l_fill_1
XFILLER_195_109 VPWR VGND sg13cmos5l_decap_8
X_2903_ Tile_X0Y6_FrameData_O[24] Tile_X0Y6_FrameData[24] VPWR VGND sg13cmos5l_buf_1
XFILLER_595_28 VPWR VGND sg13cmos5l_decap_8
XFILLER_50_159 VPWR VGND sg13cmos5l_decap_8
X_3883_ _3883_/X _3850_/X _0085_/X Tile_X0Y0_S1END[2] Tile_X0Y0_S4END[2] _0991_/Q
+ _0990_/Q VPWR VGND sg13cmos5l_mux4_1
XFILLER_526_203 VPWR VGND sg13cmos5l_fill_1
X_2834_ Tile_X0Y6_E1BEG[3] _4495_/X VPWR VGND sg13cmos5l_buf_1
XFILLER_528_55 VPWR VGND sg13cmos5l_fill_1
XFILLER_77_0 VPWR VGND sg13cmos5l_fill_2
XFILLER_528_66 VPWR VGND sg13cmos5l_fill_1
X_2765_ Tile_X0Y3_FrameData_O[23] Tile_X0Y3_FrameData[23] VPWR VGND sg13cmos5l_buf_1
XFILLER_528_88 VPWR VGND sg13cmos5l_decap_8
XFILLER_541_217 VPWR VGND sg13cmos5l_fill_1
XFILLER_247_56 VPWR VGND sg13cmos5l_decap_8
X_4504_ _4504_/X Tile_X0Y6_W2END[7] AXI_M_SOC_RDATA31 _4553_/X _4552_/X _2599_/Q _2598_/Q
+ VPWR VGND sg13cmos5l_mux4_1
XFILLER_345_180 VPWR VGND sg13cmos5l_decap_4
X_1716_ _1716_/Q Tile_X0Y3_FrameData[21] VGND VPWR Tile_X0Y9_FrameStrobe[1] latch
X_2696_ _2696_/Q Tile_X0Y6_FrameData[31] VGND VPWR Tile_X0Y9_FrameStrobe[0] latch
XFILLER_544_21 VPWR VGND sg13cmos5l_decap_8
XFILLER_6_70 VPWR VGND sg13cmos5l_decap_8
X_4435_ _4435_/X Tile_X0Y1_W1END[0] Tile_X0Y1_WW4END[12] Tile_X0Y1_W6END[4] _4008_/X
+ _1365_/Q _1364_/Q VPWR VGND sg13cmos5l_mux4_1
X_1647_ _1647_/Q Tile_X0Y2_FrameData[2] VGND VPWR Tile_X0Y9_FrameStrobe[6] latch
XFILLER_360_183 VPWR VGND sg13cmos5l_fill_2
XFILLER_104_139 VPWR VGND sg13cmos5l_fill_1
XFILLER_116_27 VPWR VGND sg13cmos5l_decap_8
X_4366_ _4366_/X Tile_X0Y3_W1END[3] Tile_X0Y3_W2MID[0] Tile_X0Y3_W2END[0] _4204_/X
+ _1867_/Q _1866_/Q VPWR VGND sg13cmos5l_mux4_1
X_1578_ _1578_/Q Tile_X0Y2_FrameData[7] VGND VPWR Tile_X0Y9_FrameStrobe[4] latch
XFILLER_58_204 VPWR VGND sg13cmos5l_fill_2
X_3317_ Tile_X0Y4_EE4BEG[5] _4277_/X VPWR VGND sg13cmos5l_buf_1
X_0529_ _0529_/Q Tile_X0Y8_FrameData[14] VGND VPWR Tile_X0Y9_FrameStrobe[3] latch
XFILLER_413_14 VPWR VGND sg13cmos5l_decap_8
X_4297_ _4297_/X AXI_M_SOC_BRESP1 _4338_/X _4342_/X _4316_/X _2019_/Q _2018_/Q VPWR
+ VGND sg13cmos5l_mux4_1
XANTENNA__3224__X Tile_X0Y0_FrameStrobe_O[12] VPWR VGND sg13cmos5l_antennanp
XFILLER_560_42 VPWR VGND sg13cmos5l_decap_8
XFILLER_112_194 VPWR VGND sg13cmos5l_decap_8
X_3248_ Tile_X0Y0_FrameData_O[16] Tile_X0Y0_FrameData[16] VPWR VGND sg13cmos5l_buf_1
XFILLER_663_195 VPWR VGND sg13cmos5l_decap_8
X_3179_ Tile_X0Y0_N4BEG[3] _3179_/A VPWR VGND sg13cmos5l_buf_1
XFILLER_710_56 VPWR VGND sg13cmos5l_decap_8
XFILLER_26_145 VPWR VGND sg13cmos5l_fill_2
XFILLER_25_35 VPWR VGND sg13cmos5l_decap_8
XFILLER_155_7 VPWR VGND sg13cmos5l_decap_8
XFILLER_576_147 VPWR VGND sg13cmos5l_decap_8
XFILLER_569_84 VPWR VGND sg13cmos5l_decap_8
XFILLER_288_63 VPWR VGND sg13cmos5l_decap_8
XFILLER_179_161 VPWR VGND sg13cmos5l_decap_8
XFILLER_328_125 VPWR VGND sg13cmos5l_decap_8
XFILLER_179_194 VPWR VGND sg13cmos5l_decap_8
XFILLER_322_7 VPWR VGND sg13cmos5l_decap_8
XFILLER_41_34 VPWR VGND sg13cmos5l_decap_8
XFILLER_194_153 VPWR VGND sg13cmos5l_fill_2
XFILLER_438_77 VPWR VGND sg13cmos5l_decap_8
XFILLER_194_186 VPWR VGND sg13cmos5l_fill_1
XFILLER_532_217 VPWR VGND sg13cmos5l_fill_1
XFILLER_343_128 VPWR VGND sg13cmos5l_decap_8
XFILLER_157_89 VPWR VGND sg13cmos5l_decap_8
XFILLER_454_21 VPWR VGND sg13cmos5l_decap_8
XFILLER_691_7 VPWR VGND sg13cmos5l_decap_8
XFILLER_150_212 VPWR VGND sg13cmos5l_decap_4
XFILLER_497_154 VPWR VGND sg13cmos5l_decap_8
XFILLER_351_194 VPWR VGND sg13cmos5l_decap_8
XFILLER_249_110 VPWR VGND sg13cmos5l_decap_8
XFILLER_173_44 VPWR VGND sg13cmos5l_decap_8
XFILLER_500_147 VPWR VGND sg13cmos5l_decap_8
XFILLER_604_35 VPWR VGND sg13cmos5l_decap_8
XFILLER_249_121 VPWR VGND sg13cmos5l_fill_1
XFILLER_110_109 VPWR VGND sg13cmos5l_decap_8
XFILLER_249_132 VPWR VGND sg13cmos5l_fill_2
XFILLER_323_14 VPWR VGND sg13cmos5l_decap_8
XFILLER_2_28 VPWR VGND sg13cmos5l_decap_8
XANTENNA__3134__X Tile_X0Y7_FrameData_O[4] VPWR VGND sg13cmos5l_antennanp
XFILLER_470_42 VPWR VGND sg13cmos5l_decap_8
XFILLER_66_42 VPWR VGND sg13cmos5l_decap_8
XFILLER_323_69 VPWR VGND sg13cmos5l_fill_1
XFILLER_599_217 VPWR VGND sg13cmos5l_fill_1
XFILLER_181_0 VPWR VGND sg13cmos5l_decap_8
XFILLER_279_0 VPWR VGND sg13cmos5l_fill_2
XANTENNA__2973__X Tile_X0Y8_FrameData_O[13] VPWR VGND sg13cmos5l_antennanp
XFILLER_620_56 VPWR VGND sg13cmos5l_decap_8
XFILLER_205_202 VPWR VGND sg13cmos5l_fill_1
XFILLER_610_210 VPWR VGND sg13cmos5l_fill_1
XFILLER_446_0 VPWR VGND sg13cmos5l_decap_8
XFILLER_82_41 VPWR VGND sg13cmos5l_decap_8
XFILLER_17_178 VPWR VGND sg13cmos5l_fill_2
XFILLER_696_49 VPWR VGND sg13cmos5l_decap_8
XFILLER_567_147 VPWR VGND sg13cmos5l_decap_8
XFILLER_629_21 VPWR VGND sg13cmos5l_decap_8
XFILLER_220_216 VPWR VGND sg13cmos5l_fill_2
XFILLER_177_109 VPWR VGND sg13cmos5l_decap_8
XFILLER_421_187 VPWR VGND sg13cmos5l_fill_2
XFILLER_198_63 VPWR VGND sg13cmos5l_decap_8
XFILLER_613_0 VPWR VGND sg13cmos5l_decap_8
XFILLER_319_125 VPWR VGND sg13cmos5l_fill_2
XFILLER_709_196 VPWR VGND sg13cmos5l_decap_4
X_0880_ _0880_/Q Tile_X0Y9_FrameData[15] VGND VPWR Tile_X0Y9_FrameStrobe[6] latch
XFILLER_629_98 VPWR VGND sg13cmos5l_decap_8
XFILLER_70_7 VPWR VGND sg13cmos5l_decap_8
XFILLER_348_77 VPWR VGND sg13cmos5l_decap_8
XFILLER_523_217 VPWR VGND sg13cmos5l_fill_1
XFILLER_590_172 VPWR VGND sg13cmos5l_decap_8
XFILLER_334_128 VPWR VGND sg13cmos5l_decap_8
XANTENNA__3309__X Tile_X0Y0_E1BEG[1] VPWR VGND sg13cmos5l_antennanp
XFILLER_645_42 VPWR VGND sg13cmos5l_decap_8
XFILLER_327_180 VPWR VGND sg13cmos5l_decap_8
X_2550_ _2550_/Q Tile_X0Y6_FrameData[17] VGND VPWR Tile_X0Y9_FrameStrobe[3] latch
XFILLER_364_21 VPWR VGND sg13cmos5l_decap_8
X_1501_ _1501_/Q Tile_X0Y2_FrameData[20] VGND VPWR Tile_X0Y9_FrameStrobe[2] latch
XFILLER_217_48 VPWR VGND sg13cmos5l_decap_8
X_2481_ _2481_/Q Tile_X0Y6_FrameData[22] VGND VPWR Tile_X0Y9_FrameStrobe[1] latch
XFILLER_342_183 VPWR VGND sg13cmos5l_decap_8
X_4220_ _4220_/X Tile_X0Y7_W1END[3] Tile_X0Y7_WW4END[3] Tile_X0Y7_W6END[11] _4687_/X
+ _0382_/Q _0381_/Q VPWR VGND sg13cmos5l_mux4_1
X_1432_ _1432_/Q Tile_X0Y2_FrameData[25] VGND VPWR Tile_X0Y9_FrameStrobe[0] latch
XFILLER_488_187 VPWR VGND sg13cmos5l_fill_2
XFILLER_514_35 VPWR VGND sg13cmos5l_decap_8
X_1363_ _1363_/Q Tile_X0Y1_FrameData[6] VGND VPWR Tile_X0Y9_FrameStrobe[5] latch
X_4151_ _4151_/X Tile_X0Y3_W2MID[4] AXI_M_SOC_BVALID _4211_/X _4210_/X _1839_/Q _1838_/Q
+ VPWR VGND sg13cmos5l_mux4_1
XFILLER_661_63 VPWR VGND sg13cmos5l_decap_8
XFILLER_233_14 VPWR VGND sg13cmos5l_decap_8
XFILLER_645_140 VPWR VGND sg13cmos5l_decap_8
XANTENNA__3044__X Tile_X0Y5_FrameData_O[3] VPWR VGND sg13cmos5l_antennanp
XFILLER_380_42 VPWR VGND sg13cmos5l_decap_8
X_0314_ _0314_/Q Tile_X0Y7_FrameData[5] VGND VPWR Tile_X0Y9_FrameStrobe[4] latch
X_3102_ Tile_X0Y7_E6BEG[0] _4644_/X VPWR VGND sg13cmos5l_buf_1
XFILLER_380_53 VPWR VGND sg13cmos5l_fill_2
X_1294_ _1294_/Q Tile_X0Y1_FrameData[11] VGND VPWR Tile_X0Y9_FrameStrobe[3] latch
X_4082_ _4082_/X AXI_M_SOC_AWREADY _4117_/X _4121_/X _4098_/X _1509_/Q _1508_/Q VPWR
+ VGND sg13cmos5l_mux4_1
XFILLER_255_135 VPWR VGND sg13cmos5l_decap_8
X_0245_ _0245_/Q Tile_X0Y7_FrameData[10] VGND VPWR Tile_X0Y9_FrameStrobe[2] latch
X_3033_ Tile_X0Y5_EE4BEG[8] _4396_/X VPWR VGND sg13cmos5l_buf_1
XANTENNA__2883__X Tile_X0Y6_FrameData_O[4] VPWR VGND sg13cmos5l_antennanp
X_0176_ _0176_/Q Tile_X0Y7_FrameData[15] VGND VPWR Tile_X0Y9_FrameStrobe[0] latch
XFILLER_270_138 VPWR VGND sg13cmos5l_decap_4
XFILLER_389_84 VPWR VGND sg13cmos5l_decap_8
XFILLER_539_21 VPWR VGND sg13cmos5l_decap_8
X_3935_ _3935_/X Tile_X0Y1_W2MID[4] AXI_M_SOC_ARREADY _3995_/X _3994_/X _1339_/Q _1338_/Q
+ VPWR VGND sg13cmos5l_mux4_1
XFILLER_715_111 VPWR VGND sg13cmos5l_decap_8
X_3866_ _3866_/X _4340_/X _4344_/X _4348_/X _4313_/X _2157_/Q _2156_/Q VPWR VGND sg13cmos5l_mux4_1
X_2817_ Tile_X0Y3_E2BEG[7] _4155_/X VPWR VGND sg13cmos5l_buf_1
XFILLER_408_14 VPWR VGND sg13cmos5l_decap_8
X_3797_ _3797_/X _3887_/X _3868_/X _3867_/X _3857_/X _1147_/Q _1146_/Q VPWR VGND sg13cmos5l_mux4_1
XFILLER_514_217 VPWR VGND sg13cmos5l_fill_1
XANTENNA__3219__X Tile_X0Y0_FrameStrobe_O[7] VPWR VGND sg13cmos5l_antennanp
XFILLER_555_42 VPWR VGND sg13cmos5l_decap_8
XFILLER_318_180 VPWR VGND sg13cmos5l_decap_8
X_2748_ Tile_X0Y3_FrameData_O[6] Tile_X0Y3_FrameData[6] VPWR VGND sg13cmos5l_buf_1
XFILLER_274_21 VPWR VGND sg13cmos5l_decap_8
X_2679_ _2679_/Q Tile_X0Y6_FrameData[16] VGND VPWR Tile_X0Y9_FrameStrobe[7] latch
XFILLER_705_56 VPWR VGND sg13cmos5l_decap_8
X_4418_ _4418_/X Tile_X0Y6_W1END[0] Tile_X0Y6_W6END[4] _4580_/X _4540_/X _2695_/Q
+ _2694_/Q VPWR VGND sg13cmos5l_mux4_1
XFILLER_274_98 VPWR VGND sg13cmos5l_decap_8
XFILLER_424_35 VPWR VGND sg13cmos5l_decap_8
XFILLER_571_63 VPWR VGND sg13cmos5l_decap_8
X_4349_ _4349_/X _4305_/X _0158_/X _4304_/X _0111_/X _1955_/Q _1954_/Q VPWR VGND sg13cmos5l_mux4_1
XFILLER_494_168 VPWR VGND sg13cmos5l_decap_8
XFILLER_143_14 VPWR VGND sg13cmos5l_decap_8
XFILLER_636_140 VPWR VGND sg13cmos5l_fill_2
XFILLER_494_179 VPWR VGND sg13cmos5l_fill_2
XFILLER_290_42 VPWR VGND sg13cmos5l_decap_8
XFILLER_100_131 VPWR VGND sg13cmos5l_decap_4
XFILLER_636_195 VPWR VGND sg13cmos5l_fill_2
XFILLER_100_164 VPWR VGND sg13cmos5l_decap_8
XANTENNA__2793__X Tile_X0Y3_E6BEG[3] VPWR VGND sg13cmos5l_antennanp
XFILLER_272_7 VPWR VGND sg13cmos5l_decap_8
XFILLER_651_154 VPWR VGND sg13cmos5l_decap_8
XFILLER_261_105 VPWR VGND sg13cmos5l_decap_8
XFILLER_440_56 VPWR VGND sg13cmos5l_decap_8
XFILLER_223_80 VPWR VGND sg13cmos5l_decap_8
XFILLER_596_209 VPWR VGND sg13cmos5l_fill_2
XFILLER_440_78 VPWR VGND sg13cmos5l_fill_2
XFILLER_403_132 VPWR VGND sg13cmos5l_fill_1
XFILLER_299_62 VPWR VGND sg13cmos5l_decap_4
XFILLER_537_7 VPWR VGND sg13cmos5l_decap_8
XFILLER_449_21 VPWR VGND sg13cmos5l_decap_8
XFILLER_299_95 VPWR VGND sg13cmos5l_fill_1
XFILLER_14_159 VPWR VGND sg13cmos5l_decap_8
XFILLER_52_44 VPWR VGND sg13cmos5l_decap_8
XFILLER_704_7 VPWR VGND sg13cmos5l_decap_8
XFILLER_168_33 VPWR VGND sg13cmos5l_decap_8
XFILLER_706_133 VPWR VGND sg13cmos5l_decap_8
XFILLER_706_166 VPWR VGND sg13cmos5l_decap_8
XFILLER_572_161 VPWR VGND sg13cmos5l_decap_8
XFILLER_318_14 VPWR VGND sg13cmos5l_decap_8
XANTENNA__3129__X Tile_X0Y7_EE4BEG[15] VPWR VGND sg13cmos5l_antennanp
XFILLER_465_42 VPWR VGND sg13cmos5l_decap_8
XANTENNA__2968__X Tile_X0Y8_FrameData_O[8] VPWR VGND sg13cmos5l_antennanp
XFILLER_269_205 VPWR VGND sg13cmos5l_decap_8
XFILLER_184_65 VPWR VGND sg13cmos5l_decap_8
XFILLER_7_0 VPWR VGND sg13cmos5l_decap_8
XFILLER_615_56 VPWR VGND sg13cmos5l_decap_8
XFILLER_674_202 VPWR VGND sg13cmos5l_fill_1
XFILLER_334_35 VPWR VGND sg13cmos5l_decap_8
XFILLER_117_70 VPWR VGND sg13cmos5l_decap_8
XFILLER_77_41 VPWR VGND sg13cmos5l_decap_8
XFILLER_481_63 VPWR VGND sg13cmos5l_decap_8
XFILLER_396_0 VPWR VGND sg13cmos5l_decap_8
XFILLER_485_168 VPWR VGND sg13cmos5l_decap_8
XFILLER_481_74 VPWR VGND sg13cmos5l_fill_1
XFILLER_485_179 VPWR VGND sg13cmos5l_fill_2
XFILLER_627_184 VPWR VGND sg13cmos5l_decap_8
XFILLER_563_0 VPWR VGND sg13cmos5l_decap_8
XFILLER_631_77 VPWR VGND sg13cmos5l_decap_8
XFILLER_237_168 VPWR VGND sg13cmos5l_fill_2
XFILLER_203_28 VPWR VGND sg13cmos5l_decap_8
XFILLER_642_154 VPWR VGND sg13cmos5l_decap_8
XFILLER_252_105 VPWR VGND sg13cmos5l_fill_1
XFILLER_350_56 VPWR VGND sg13cmos5l_decap_8
XFILLER_587_209 VPWR VGND sg13cmos5l_fill_1
XFILLER_252_149 VPWR VGND sg13cmos5l_fill_2
XFILLER_245_190 VPWR VGND sg13cmos5l_decap_8
XFILLER_93_84 VPWR VGND sg13cmos5l_decap_8
XFILLER_359_21 VPWR VGND sg13cmos5l_decap_8
X_1981_ _1981_/Q Tile_X0Y4_FrameData[8] VGND VPWR Tile_X0Y9_FrameStrobe[1] latch
X_3720_ AXI_M_SOC_WDATA30 Tile_X0Y6_W1END[2] Tile_X0Y6_WW4END[6] Tile_X0Y6_WW4END[14]
+ _4582_/X _2499_/Q _2498_/Q VPWR VGND sg13cmos5l_mux4_1
X_0932_ _0932_/Q Tile_X0Y9_FrameData[23] VGND VPWR Tile_X0Y9_FrameStrobe[8] latch
XFILLER_359_98 VPWR VGND sg13cmos5l_decap_8
XFILLER_509_35 VPWR VGND sg13cmos5l_decap_8
XFILLER_158_164 VPWR VGND sg13cmos5l_decap_8
X_3651_ AXI_M_SOC_AWADDR12 Tile_X0Y5_W1END[0] Tile_X0Y5_WW4END[4] Tile_X0Y5_WW4END[12]
+ _4463_/X _2247_/Q _2246_/Q VPWR VGND sg13cmos5l_mux4_1
XFILLER_656_63 VPWR VGND sg13cmos5l_decap_8
X_0863_ _0863_/Q Tile_X0Y9_FrameData[0] VGND VPWR Tile_X0Y9_FrameStrobe[5] latch
XFILLER_228_14 VPWR VGND sg13cmos5l_decap_8
XFILLER_173_123 VPWR VGND sg13cmos5l_fill_2
XANTENNA__3039__X Tile_X0Y5_EE4BEG[14] VPWR VGND sg13cmos5l_antennanp
XFILLER_375_42 VPWR VGND sg13cmos5l_decap_4
X_2602_ _2602_/Q Tile_X0Y6_FrameData[29] VGND VPWR Tile_X0Y9_FrameStrobe[5] latch
XFILLER_375_53 VPWR VGND sg13cmos5l_fill_2
X_3582_ Tile_X0Y9_FrameData_O[12] Tile_X0Y9_FrameData[12] VPWR VGND sg13cmos5l_buf_1
XFILLER_712_147 VPWR VGND sg13cmos5l_decap_8
X_0794_ _0794_/Q Tile_X0Y9_FrameData[5] VGND VPWR Tile_X0Y9_FrameStrobe[3] latch
XFILLER_173_167 VPWR VGND sg13cmos5l_decap_8
XFILLER_375_86 VPWR VGND sg13cmos5l_decap_8
X_2533_ _2533_/Q Tile_X0Y6_FrameData[2] VGND VPWR Tile_X0Y9_FrameStrobe[2] latch
XANTENNA__2878__X Tile_X0Y6_EE4BEG[15] VPWR VGND sg13cmos5l_antennanp
XFILLER_308_91 VPWR VGND sg13cmos5l_decap_8
X_2464_ _2464_/Q Tile_X0Y6_FrameData[7] VGND VPWR Tile_X0Y9_FrameStrobe[0] latch
XFILLER_672_84 VPWR VGND sg13cmos5l_decap_8
XFILLER_476_124 VPWR VGND sg13cmos5l_decap_8
XFILLER_476_135 VPWR VGND sg13cmos5l_fill_2
XFILLER_244_35 VPWR VGND sg13cmos5l_decap_8
X_4203_ _4203_/X Tile_X0Y4_W1END[3] Tile_X0Y4_W6END[7] _4351_/X _4309_/X _2175_/Q
+ _2174_/Q VPWR VGND sg13cmos5l_mux4_1
X_1415_ _1415_/Q Tile_X0Y1_FrameData[18] VGND VPWR Tile_X0Y9_FrameStrobe[7] latch
X_2395_ _2395_/Q Tile_X0Y5_FrameData[10] VGND VPWR Tile_X0Y9_FrameStrobe[6] latch
XFILLER_491_105 VPWR VGND sg13cmos5l_decap_8
XFILLER_417_202 VPWR VGND sg13cmos5l_fill_1
X_4134_ _4134_/X Tile_X0Y1_W2MID[4] Tile_X0Y1_W2END[4] Tile_X0Y1_W6END[11] _3995_/X
+ _1375_/Q _1374_/Q VPWR VGND sg13cmos5l_mux4_1
X_1346_ _1346_/Q Tile_X0Y1_FrameData[23] VGND VPWR Tile_X0Y9_FrameStrobe[5] latch
XFILLER_491_149 VPWR VGND sg13cmos5l_decap_8
XFILLER_28_207 VPWR VGND sg13cmos5l_fill_2
XFILLER_484_190 VPWR VGND sg13cmos5l_fill_2
XFILLER_113_28 VPWR VGND sg13cmos5l_decap_8
X_4065_ _4065_/X Tile_X0Y2_WW4END[6] AXI_M_SOC_AWREADY _4122_/X _4098_/X _1543_/Q
+ _1542_/Q VPWR VGND sg13cmos5l_mux4_1
X_1277_ _1277_/Q Tile_X0Y1_FrameData[28] VGND VPWR Tile_X0Y9_FrameStrobe[3] latch
XANTENNA__3502__X Tile_X0Y1_E2BEGb[0] VPWR VGND sg13cmos5l_antennanp
XFILLER_432_216 VPWR VGND sg13cmos5l_fill_2
X_3016_ Tile_X0Y5_E6BEG[3] _4407_/X VPWR VGND sg13cmos5l_buf_1
X_0228_ _0228_/Q Tile_X0Y7_FrameData[27] VGND VPWR Tile_X0Y9_FrameStrobe[2] latch
XFILLER_243_138 VPWR VGND sg13cmos5l_fill_1
XFILLER_397_120 VPWR VGND sg13cmos5l_decap_8
X_0159_ _0159_/X _4441_/X _4442_/X _0898_/Q VPWR VGND sg13cmos5l_mux2_1
XFILLER_697_70 VPWR VGND sg13cmos5l_decap_8
XFILLER_269_21 VPWR VGND sg13cmos5l_decap_8
XFILLER_251_171 VPWR VGND sg13cmos5l_decap_8
XFILLER_397_186 VPWR VGND sg13cmos5l_decap_8
XFILLER_397_197 VPWR VGND sg13cmos5l_fill_1
X_3918_ _3918_/X Tile_X0Y2_W1END[0] Tile_X0Y2_WW4END[0] Tile_X0Y2_W6END[8] _4116_/X
+ _1649_/Q _1648_/Q VPWR VGND sg13cmos5l_mux4_1
XFILLER_269_98 VPWR VGND sg13cmos5l_decap_8
XFILLER_149_142 VPWR VGND sg13cmos5l_fill_2
X_4898_ _4898_/X Tile_X0Y8_W1END[2] Tile_X0Y8_W6END[10] _4814_/X _4774_/X _0631_/Q
+ _0630_/Q VPWR VGND sg13cmos5l_mux4_1
XFILLER_419_35 VPWR VGND sg13cmos5l_decap_8
XFILLER_22_14 VPWR VGND sg13cmos5l_decap_8
XFILLER_566_63 VPWR VGND sg13cmos5l_decap_8
X_3849_ _3849_/X Tile_X0Y1_W1END[1] Tile_X0Y1_W6END[5] _4002_/X _3977_/X _1423_/Q
+ _1422_/Q VPWR VGND sg13cmos5l_mux4_1
XFILLER_164_112 VPWR VGND sg13cmos5l_fill_2
XFILLER_138_14 VPWR VGND sg13cmos5l_decap_8
XFILLER_285_42 VPWR VGND sg13cmos5l_decap_8
XFILLER_164_145 VPWR VGND sg13cmos5l_decap_8
XFILLER_118_7 VPWR VGND sg13cmos5l_decap_8
XFILLER_164_189 VPWR VGND sg13cmos5l_decap_8
XANTENNA__2788__X Tile_X0Y3_EE4BEG[14] VPWR VGND sg13cmos5l_antennanp
XFILLER_306_161 VPWR VGND sg13cmos5l_fill_1
XFILLER_105_201 VPWR VGND sg13cmos5l_fill_2
XFILLER_467_102 VPWR VGND sg13cmos5l_decap_8
XFILLER_435_56 VPWR VGND sg13cmos5l_decap_8
XFILLER_154_13 VPWR VGND sg13cmos5l_decap_8
XFILLER_0_7 VPWR VGND sg13cmos5l_decap_8
XFILLER_78_107 VPWR VGND sg13cmos5l_fill_2
XFILLER_582_84 VPWR VGND sg13cmos5l_decap_8
XFILLER_154_46 VPWR VGND sg13cmos5l_decap_4
XFILLER_120_204 VPWR VGND sg13cmos5l_fill_2
XFILLER_487_7 VPWR VGND sg13cmos5l_decap_8
XFILLER_467_179 VPWR VGND sg13cmos5l_decap_8
XFILLER_219_113 VPWR VGND sg13cmos5l_decap_8
XFILLER_86_140 VPWR VGND sg13cmos5l_decap_8
XFILLER_304_49 VPWR VGND sg13cmos5l_decap_4
XFILLER_654_7 VPWR VGND sg13cmos5l_decap_8
XFILLER_601_14 VPWR VGND sg13cmos5l_decap_8
XFILLER_234_105 VPWR VGND sg13cmos5l_decap_4
XFILLER_219_179 VPWR VGND sg13cmos5l_decap_8
XFILLER_423_205 VPWR VGND sg13cmos5l_fill_1
XANTENNA__3412__X Tile_X0Y4_FrameData_O[3] VPWR VGND sg13cmos5l_antennanp
XFILLER_234_138 VPWR VGND sg13cmos5l_decap_8
XFILLER_624_198 VPWR VGND sg13cmos5l_fill_2
XFILLER_234_149 VPWR VGND sg13cmos5l_fill_1
XFILLER_63_21 VPWR VGND sg13cmos5l_decap_8
XFILLER_179_21 VPWR VGND sg13cmos5l_fill_1
XFILLER_179_43 VPWR VGND sg13cmos5l_decap_8
XFILLER_537_117 VPWR VGND sg13cmos5l_decap_4
XFILLER_400_81 VPWR VGND sg13cmos5l_fill_2
XFILLER_144_0 VPWR VGND sg13cmos5l_fill_2
XFILLER_8_49 VPWR VGND sg13cmos5l_decap_8
XFILLER_693_28 VPWR VGND sg13cmos5l_decap_8
XFILLER_545_150 VPWR VGND sg13cmos5l_decap_8
XFILLER_311_0 VPWR VGND sg13cmos5l_decap_8
XFILLER_155_123 VPWR VGND sg13cmos5l_decap_8
XFILLER_476_85 VPWR VGND sg13cmos5l_decap_8
XFILLER_409_0 VPWR VGND sg13cmos5l_decap_8
XFILLER_195_42 VPWR VGND sg13cmos5l_decap_8
XFILLER_195_86 VPWR VGND sg13cmos5l_fill_2
XFILLER_170_104 VPWR VGND sg13cmos5l_decap_4
XFILLER_626_77 VPWR VGND sg13cmos5l_decap_8
XFILLER_12_91 VPWR VGND sg13cmos5l_decap_8
XFILLER_88_40 VPWR VGND sg13cmos5l_decap_8
XFILLER_345_56 VPWR VGND sg13cmos5l_decap_8
XFILLER_492_84 VPWR VGND sg13cmos5l_decap_8
XFILLER_680_0 VPWR VGND sg13cmos5l_decap_8
XFILLER_642_21 VPWR VGND sg13cmos5l_decap_8
XFILLER_33_7 VPWR VGND sg13cmos5l_decap_8
XFILLER_257_208 VPWR VGND sg13cmos5l_fill_1
XFILLER_312_197 VPWR VGND sg13cmos5l_decap_8
X_1200_ _1200_/Q Tile_X0Y1_FrameData[9] VGND VPWR Tile_X0Y9_FrameStrobe[0] latch
XFILLER_77_140 VPWR VGND sg13cmos5l_decap_8
X_2180_ _2180_/Q Tile_X0Y4_FrameData[1] VGND VPWR Tile_X0Y9_FrameStrobe[7] latch
XFILLER_642_98 VPWR VGND sg13cmos5l_decap_8
XFILLER_214_49 VPWR VGND sg13cmos5l_decap_8
XFILLER_615_110 VPWR VGND sg13cmos5l_decap_8
X_1131_ _1131_/Q Tile_X0Y0_FrameData[0] VGND VPWR Tile_X0Y9_FrameStrobe[5] latch
XFILLER_511_14 VPWR VGND sg13cmos5l_decap_8
XFILLER_615_154 VPWR VGND sg13cmos5l_decap_8
XANTENNA__3322__X Tile_X0Y4_EE4BEG[10] VPWR VGND sg13cmos5l_antennanp
X_1062_ _1062_/Q Tile_X0Y0_FrameData[5] VGND VPWR Tile_X0Y9_FrameStrobe[3] latch
XFILLER_225_149 VPWR VGND sg13cmos5l_fill_1
XFILLER_33_210 VPWR VGND sg13cmos5l_fill_1
X_4821_ _4821_/X Tile_X0Y7_W1END[1] Tile_X0Y7_W2MID[2] Tile_X0Y7_W2END[2] _4672_/X
+ _0361_/Q _0360_/Q VPWR VGND sg13cmos5l_mux4_1
XFILLER_717_206 VPWR VGND sg13cmos5l_fill_2
XFILLER_394_101 VPWR VGND sg13cmos5l_decap_8
XFILLER_717_217 VPWR VGND sg13cmos5l_fill_1
X_4752_ _4752_/X Tile_X0Y8_WW4END[7] AXI_M_SOC_RDATA15 _4807_/X _4784_/X _0543_/Q
+ _0542_/Q VPWR VGND sg13cmos5l_mux4_1
X_1964_ _1964_/Q Tile_X0Y4_FrameData[25] VGND VPWR Tile_X0Y9_FrameStrobe[1] latch
XFILLER_193_207 VPWR VGND sg13cmos5l_fill_2
XFILLER_667_95 VPWR VGND sg13cmos5l_decap_8
X_3703_ AXI_M_SOC_WDATA13 Tile_X0Y7_W1END[1] Tile_X0Y7_WW4END[5] Tile_X0Y7_WW4END[13]
+ _4697_/X _0221_/Q _0220_/Q VPWR VGND sg13cmos5l_mux4_1
X_0915_ _0915_/Q Tile_X0Y9_FrameData[12] VGND VPWR Tile_X0Y9_FrameStrobe[7] latch
XFILLER_386_63 VPWR VGND sg13cmos5l_fill_1
XFILLER_146_112 VPWR VGND sg13cmos5l_decap_4
X_4683_ _4683_/X _4229_/X _4233_/X _4212_/X _4204_/X _1856_/Q _1855_/Q VPWR VGND sg13cmos5l_mux4_1
X_1895_ _1895_/Q Tile_X0Y3_FrameData[2] VGND VPWR Tile_X0Y9_FrameStrobe[6] latch
XFILLER_386_85 VPWR VGND sg13cmos5l_decap_8
XFILLER_146_123 VPWR VGND sg13cmos5l_decap_8
XFILLER_536_183 VPWR VGND sg13cmos5l_decap_8
XFILLER_386_96 VPWR VGND sg13cmos5l_fill_2
X_3634_ Tile_X0Y9_S4BEG[12] _3634_/A VPWR VGND sg13cmos5l_buf_1
X_0846_ _0846_/Q Tile_X0Y9_FrameData[17] VGND VPWR Tile_X0Y9_FrameStrobe[5] latch
XFILLER_551_153 VPWR VGND sg13cmos5l_fill_2
XFILLER_536_66 VPWR VGND sg13cmos5l_fill_1
XFILLER_161_115 VPWR VGND sg13cmos5l_decap_8
XFILLER_551_175 VPWR VGND sg13cmos5l_fill_2
XFILLER_108_28 VPWR VGND sg13cmos5l_decap_8
X_3565_ Tile_X0Y9_EE4BEG[11] _4875_/X VPWR VGND sg13cmos5l_buf_1
X_0777_ _0777_/Q Tile_X0Y9_FrameData[22] VGND VPWR Tile_X0Y9_FrameStrobe[3] latch
XFILLER_700_117 VPWR VGND sg13cmos5l_fill_1
XFILLER_161_148 VPWR VGND sg13cmos5l_decap_8
XFILLER_700_139 VPWR VGND sg13cmos5l_decap_4
X_2516_ _2516_/Q Tile_X0Y6_FrameData[19] VGND VPWR Tile_X0Y9_FrameStrobe[2] latch
X_3496_ Tile_X0Y1_E6BEG[6] _3970_/X VPWR VGND sg13cmos5l_buf_1
XFILLER_255_89 VPWR VGND sg13cmos5l_decap_8
XFILLER_552_21 VPWR VGND sg13cmos5l_decap_8
XFILLER_102_215 VPWR VGND sg13cmos5l_fill_2
X_2447_ _2447_/Q Tile_X0Y6_FrameData[24] VGND VPWR Tile_X0Y9_FrameStrobe[0] latch
XFILLER_303_186 VPWR VGND sg13cmos5l_decap_8
XFILLER_464_116 VPWR VGND sg13cmos5l_fill_2
X_2378_ _2378_/Q Tile_X0Y5_FrameData[27] VGND VPWR Tile_X0Y9_FrameStrobe[6] latch
XFILLER_702_35 VPWR VGND sg13cmos5l_decap_8
XFILLER_124_49 VPWR VGND sg13cmos5l_decap_8
XFILLER_68_162 VPWR VGND sg13cmos5l_decap_8
XFILLER_271_77 VPWR VGND sg13cmos5l_decap_8
X_4117_ _4117_/X _4091_/X _0064_/X _4090_/X Tile_X0Y0_S4END[9] _1479_/Q _1478_/Q VPWR
+ VGND sg13cmos5l_mux4_1
X_1329_ _1329_/Q Tile_X0Y1_FrameData[8] VGND VPWR Tile_X0Y9_FrameStrobe[4] latch
XFILLER_421_14 VPWR VGND sg13cmos5l_decap_8
XFILLER_271_200 VPWR VGND sg13cmos5l_decap_4
XFILLER_606_165 VPWR VGND sg13cmos5l_fill_2
XFILLER_17_14 VPWR VGND sg13cmos5l_decap_8
XANTENNA__3232__X Tile_X0Y0_FrameData_O[0] VPWR VGND sg13cmos5l_antennanp
XFILLER_405_216 VPWR VGND sg13cmos5l_fill_2
X_4048_ _4048_/X Tile_X0Y2_W2END[7] AXI_M_SOC_AWREADY _4097_/X _4096_/X _1577_/Q _1576_/Q
+ VPWR VGND sg13cmos5l_mux4_1
XFILLER_472_193 VPWR VGND sg13cmos5l_fill_1
XFILLER_24_210 VPWR VGND sg13cmos5l_fill_1
XFILLER_501_91 VPWR VGND sg13cmos5l_decap_8
XFILLER_385_123 VPWR VGND sg13cmos5l_fill_1
XFILLER_220_70 VPWR VGND sg13cmos5l_decap_4
XFILLER_220_81 VPWR VGND sg13cmos5l_decap_8
XFILLER_33_35 VPWR VGND sg13cmos5l_decap_8
XFILLER_149_13 VPWR VGND sg13cmos5l_decap_8
XFILLER_235_7 VPWR VGND sg13cmos5l_decap_8
XFILLER_577_84 VPWR VGND sg13cmos5l_decap_8
XFILLER_385_167 VPWR VGND sg13cmos5l_decap_8
XFILLER_296_63 VPWR VGND sg13cmos5l_decap_8
XFILLER_137_112 VPWR VGND sg13cmos5l_decap_8
XFILLER_402_7 VPWR VGND sg13cmos5l_decap_8
XFILLER_593_72 VPWR VGND sg13cmos5l_decap_8
XFILLER_341_215 VPWR VGND sg13cmos5l_fill_2
XFILLER_593_83 VPWR VGND sg13cmos5l_fill_2
XFILLER_542_175 VPWR VGND sg13cmos5l_decap_8
XFILLER_3_114 VPWR VGND sg13cmos5l_decap_8
XFILLER_152_137 VPWR VGND sg13cmos5l_decap_8
XFILLER_688_179 VPWR VGND sg13cmos5l_fill_1
XFILLER_446_99 VPWR VGND sg13cmos5l_fill_2
XFILLER_152_148 VPWR VGND sg13cmos5l_fill_2
XANTENNA__3407__X Tile_X0Y2_E1BEG[2] VPWR VGND sg13cmos5l_antennanp
XFILLER_165_56 VPWR VGND sg13cmos5l_decap_4
XFILLER_462_21 VPWR VGND sg13cmos5l_decap_8
XFILLER_160_181 VPWR VGND sg13cmos5l_fill_1
XFILLER_315_59 VPWR VGND sg13cmos5l_decap_8
XFILLER_455_105 VPWR VGND sg13cmos5l_decap_8
XFILLER_58_54 VPWR VGND sg13cmos5l_decap_8
XFILLER_59_151 VPWR VGND sg13cmos5l_fill_1
XFILLER_612_35 VPWR VGND sg13cmos5l_decap_8
XFILLER_59_162 VPWR VGND sg13cmos5l_decap_8
XFILLER_331_14 VPWR VGND sg13cmos5l_decap_8
XANTENNA__3142__X Tile_X0Y7_FrameData_O[12] VPWR VGND sg13cmos5l_antennanp
XFILLER_688_28 VPWR VGND sg13cmos5l_decap_8
XFILLER_114_93 VPWR VGND sg13cmos5l_decap_4
XFILLER_331_69 VPWR VGND sg13cmos5l_decap_8
XFILLER_261_0 VPWR VGND sg13cmos5l_decap_8
XFILLER_359_0 VPWR VGND sg13cmos5l_decap_8
XFILLER_74_86 VPWR VGND sg13cmos5l_decap_8
XFILLER_411_208 VPWR VGND sg13cmos5l_fill_2
XANTENNA__2981__X Tile_X0Y8_FrameData_O[21] VPWR VGND sg13cmos5l_antennanp
XFILLER_130_70 VPWR VGND sg13cmos5l_decap_8
XFILLER_230_141 VPWR VGND sg13cmos5l_decap_8
XFILLER_526_0 VPWR VGND sg13cmos5l_decap_8
XFILLER_376_134 VPWR VGND sg13cmos5l_decap_8
XFILLER_376_145 VPWR VGND sg13cmos5l_fill_2
XFILLER_487_84 VPWR VGND sg13cmos5l_decap_8
XFILLER_175_207 VPWR VGND sg13cmos5l_fill_2
XFILLER_90_74 VPWR VGND sg13cmos5l_decap_4
XFILLER_637_21 VPWR VGND sg13cmos5l_decap_8
XFILLER_391_126 VPWR VGND sg13cmos5l_fill_2
XFILLER_128_112 VPWR VGND sg13cmos5l_fill_1
XFILLER_128_134 VPWR VGND sg13cmos5l_decap_8
X_0700_ _0700_/Q Tile_X0Y9_FrameData[3] VGND VPWR Tile_X0Y9_FrameStrobe[0] latch
X_1680_ _1680_/Q Tile_X0Y3_FrameData[25] VGND VPWR Tile_X0Y9_FrameStrobe[0] latch
XFILLER_637_98 VPWR VGND sg13cmos5l_decap_8
XFILLER_209_49 VPWR VGND sg13cmos5l_decap_8
XFILLER_356_77 VPWR VGND sg13cmos5l_decap_8
X_0631_ _0631_/Q Tile_X0Y8_FrameData[8] VGND VPWR Tile_X0Y9_FrameStrobe[6] latch
XFILLER_679_157 VPWR VGND sg13cmos5l_decap_8
XFILLER_533_186 VPWR VGND sg13cmos5l_decap_8
XFILLER_506_14 VPWR VGND sg13cmos5l_decap_8
XFILLER_694_105 VPWR VGND sg13cmos5l_fill_1
XANTENNA__3317__X Tile_X0Y4_EE4BEG[5] VPWR VGND sg13cmos5l_antennanp
XFILLER_99_94 VPWR VGND sg13cmos5l_decap_4
XFILLER_653_42 VPWR VGND sg13cmos5l_decap_8
XFILLER_143_159 VPWR VGND sg13cmos5l_decap_8
X_3350_ Tile_X0Y2_FrameData_O[21] Tile_X0Y2_FrameData[21] VPWR VGND sg13cmos5l_buf_1
X_0562_ _0562_/Q Tile_X0Y8_FrameData[13] VGND VPWR Tile_X0Y9_FrameStrobe[4] latch
XFILLER_694_138 VPWR VGND sg13cmos5l_fill_1
XFILLER_372_21 VPWR VGND sg13cmos5l_decap_8
X_2301_ _2301_/Q Tile_X0Y5_FrameData[8] VGND VPWR Tile_X0Y9_FrameStrobe[3] latch
XFILLER_297_163 VPWR VGND sg13cmos5l_decap_8
X_3281_ Tile_X0Y0_E6BEG[1] _3837_/X VPWR VGND sg13cmos5l_buf_1
XFILLER_151_181 VPWR VGND sg13cmos5l_decap_8
X_0493_ _0493_/Q Tile_X0Y8_FrameData[18] VGND VPWR Tile_X0Y9_FrameStrobe[2] latch
X_2232_ _2232_/Q Tile_X0Y5_FrameData[13] VGND VPWR Tile_X0Y9_FrameStrobe[1] latch
XFILLER_522_35 VPWR VGND sg13cmos5l_decap_8
XFILLER_300_189 VPWR VGND sg13cmos5l_decap_8
XFILLER_65_110 VPWR VGND sg13cmos5l_decap_8
X_2163_ _2163_/Q Tile_X0Y4_FrameData[18] VGND VPWR Tile_X0Y9_FrameStrobe[7] latch
XFILLER_461_108 VPWR VGND sg13cmos5l_decap_8
XFILLER_241_14 VPWR VGND sg13cmos5l_decap_8
XANTENNA__3052__X Tile_X0Y5_FrameData_O[11] VPWR VGND sg13cmos5l_antennanp
X_1114_ _1114_/Q Tile_X0Y0_FrameData[17] VGND VPWR Tile_X0Y9_FrameStrobe[5] latch
XFILLER_598_28 VPWR VGND sg13cmos5l_decap_8
X_2094_ _2094_/Q Tile_X0Y4_FrameData[23] VGND VPWR Tile_X0Y9_FrameStrobe[5] latch
XFILLER_65_198 VPWR VGND sg13cmos5l_decap_4
XANTENNA__2891__X Tile_X0Y6_FrameData_O[12] VPWR VGND sg13cmos5l_antennanp
X_1045_ _1045_/Q Tile_X0Y0_FrameData[22] VGND VPWR Tile_X0Y9_FrameStrobe[3] latch
XFILLER_80_179 VPWR VGND sg13cmos5l_fill_1
XFILLER_556_201 VPWR VGND sg13cmos5l_fill_1
XFILLER_367_134 VPWR VGND sg13cmos5l_decap_8
X_4804_ _4804_/X _4777_/X Tile_X0Y9_N4END[4] _4776_/X _0077_/X _0463_/Q _0462_/Q VPWR
+ VGND sg13cmos5l_mux4_1
XFILLER_367_145 VPWR VGND sg13cmos5l_fill_2
XFILLER_397_84 VPWR VGND sg13cmos5l_decap_8
X_2996_ Tile_X0Y5_E1BEG[3] _4371_/X VPWR VGND sg13cmos5l_buf_1
XFILLER_547_21 VPWR VGND sg13cmos5l_decap_8
XFILLER_9_70 VPWR VGND sg13cmos5l_decap_8
X_4735_ _4735_/X Tile_X0Y8_W2MID[0] AXI_M_SOC_RDATA15 _4785_/X _4784_/X _0577_/Q _0576_/Q
+ VPWR VGND sg13cmos5l_mux4_1
XFILLER_119_112 VPWR VGND sg13cmos5l_decap_8
X_1947_ _1947_/Q Tile_X0Y4_FrameData[10] VGND VPWR Tile_X0Y9_FrameStrobe[0] latch
XFILLER_308_212 VPWR VGND sg13cmos5l_decap_4
X_4666_ _4666_/X Tile_X0Y6_W1END[3] Tile_X0Y6_W6END[11] _4583_/X _4543_/X _2653_/Q
+ _2652_/Q VPWR VGND sg13cmos5l_mux4_1
X_1878_ _1878_/Q Tile_X0Y3_FrameData[19] VGND VPWR Tile_X0Y9_FrameStrobe[6] latch
XFILLER_524_164 VPWR VGND sg13cmos5l_decap_4
X_3617_ Tile_X0Y9_S2BEGb[3] _4935_/X VPWR VGND sg13cmos5l_buf_1
XFILLER_524_175 VPWR VGND sg13cmos5l_decap_8
XFILLER_266_77 VPWR VGND sg13cmos5l_fill_1
XFILLER_134_126 VPWR VGND sg13cmos5l_decap_8
X_0829_ _0829_/Q Tile_X0Y9_FrameData[2] VGND VPWR Tile_X0Y9_FrameStrobe[4] latch
XFILLER_416_14 VPWR VGND sg13cmos5l_decap_8
XFILLER_134_137 VPWR VGND sg13cmos5l_fill_1
X_4597_ _4597_/X Tile_X0Y8_W2MID[1] Tile_X0Y8_W2END[1] Tile_X0Y8_W6END[1] _4786_/X
+ _0651_/Q _0650_/Q VPWR VGND sg13cmos5l_mux4_1
XFILLER_266_99 VPWR VGND sg13cmos5l_fill_1
XANTENNA__3227__X Tile_X0Y0_FrameStrobe_O[15] VPWR VGND sg13cmos5l_antennanp
XFILLER_563_42 VPWR VGND sg13cmos5l_decap_8
X_3548_ Tile_X0Y9_E6BEG[6] _4886_/X VPWR VGND sg13cmos5l_buf_1
XFILLER_282_21 VPWR VGND sg13cmos5l_decap_8
XFILLER_678_190 VPWR VGND sg13cmos5l_fill_2
XFILLER_288_141 VPWR VGND sg13cmos5l_decap_4
X_3479_ Tile_X0Y1_EE4BEG[5] _3953_/X VPWR VGND sg13cmos5l_buf_1
XFILLER_288_174 VPWR VGND sg13cmos5l_decap_8
XFILLER_693_160 VPWR VGND sg13cmos5l_decap_8
XFILLER_713_56 VPWR VGND sg13cmos5l_decap_8
XFILLER_437_127 VPWR VGND sg13cmos5l_decap_8
XFILLER_282_98 VPWR VGND sg13cmos5l_decap_8
XFILLER_432_35 VPWR VGND sg13cmos5l_decap_8
XFILLER_215_70 VPWR VGND sg13cmos5l_decap_8
XFILLER_28_35 VPWR VGND sg13cmos5l_decap_8
XFILLER_151_14 VPWR VGND sg13cmos5l_decap_8
XFILLER_185_7 VPWR VGND sg13cmos5l_decap_8
XFILLER_445_193 VPWR VGND sg13cmos5l_decap_8
XFILLER_178_6 VPWR VGND sg13cmos5l_decap_8
XFILLER_460_130 VPWR VGND sg13cmos5l_decap_8
XFILLER_352_7 VPWR VGND sg13cmos5l_decap_8
XFILLER_301_28 VPWR VGND sg13cmos5l_decap_8
XFILLER_71_146 VPWR VGND sg13cmos5l_fill_2
XFILLER_231_80 VPWR VGND sg13cmos5l_fill_2
XFILLER_44_34 VPWR VGND sg13cmos5l_fill_2
XFILLER_547_201 VPWR VGND sg13cmos5l_decap_4
XFILLER_358_112 VPWR VGND sg13cmos5l_decap_8
XFILLER_12_202 VPWR VGND sg13cmos5l_decap_8
XFILLER_617_7 VPWR VGND sg13cmos5l_decap_8
XFILLER_212_174 VPWR VGND sg13cmos5l_decap_8
XFILLER_157_207 VPWR VGND sg13cmos5l_decap_8
XFILLER_457_21 VPWR VGND sg13cmos5l_decap_8
XFILLER_100_62 VPWR VGND sg13cmos5l_decap_8
XFILLER_358_189 VPWR VGND sg13cmos5l_decap_8
XFILLER_60_77 VPWR VGND sg13cmos5l_decap_8
XFILLER_515_131 VPWR VGND sg13cmos5l_decap_8
XFILLER_219_2 VPWR VGND sg13cmos5l_fill_1
XFILLER_607_35 VPWR VGND sg13cmos5l_decap_8
XFILLER_176_66 VPWR VGND sg13cmos5l_decap_8
XFILLER_314_215 VPWR VGND sg13cmos5l_fill_2
XFILLER_326_14 VPWR VGND sg13cmos5l_decap_8
XFILLER_5_28 VPWR VGND sg13cmos5l_decap_8
XFILLER_176_99 VPWR VGND sg13cmos5l_decap_4
XFILLER_676_105 VPWR VGND sg13cmos5l_fill_1
XFILLER_530_123 VPWR VGND sg13cmos5l_fill_1
XANTENNA__3137__X Tile_X0Y7_FrameData_O[7] VPWR VGND sg13cmos5l_antennanp
XFILLER_473_42 VPWR VGND sg13cmos5l_decap_8
XFILLER_107_0 VPWR VGND sg13cmos5l_decap_8
XFILLER_676_127 VPWR VGND sg13cmos5l_decap_4
XFILLER_109_82 VPWR VGND sg13cmos5l_decap_8
XFILLER_530_145 VPWR VGND sg13cmos5l_fill_2
XFILLER_473_53 VPWR VGND sg13cmos5l_fill_1
XFILLER_69_53 VPWR VGND sg13cmos5l_decap_8
XFILLER_192_21 VPWR VGND sg13cmos5l_decap_8
XANTENNA__2976__X Tile_X0Y8_FrameData_O[16] VPWR VGND sg13cmos5l_antennanp
XFILLER_428_105 VPWR VGND sg13cmos5l_decap_8
XFILLER_279_174 VPWR VGND sg13cmos5l_fill_2
XFILLER_623_56 VPWR VGND sg13cmos5l_decap_8
XFILLER_483_211 VPWR VGND sg13cmos5l_fill_1
XFILLER_279_196 VPWR VGND sg13cmos5l_decap_4
XFILLER_192_98 VPWR VGND sg13cmos5l_decap_8
XFILLER_342_35 VPWR VGND sg13cmos5l_decap_8
XFILLER_125_70 VPWR VGND sg13cmos5l_decap_8
XFILLER_476_0 VPWR VGND sg13cmos5l_decap_8
XFILLER_294_166 VPWR VGND sg13cmos5l_decap_8
XFILLER_85_63 VPWR VGND sg13cmos5l_decap_8
XFILLER_699_49 VPWR VGND sg13cmos5l_decap_8
XFILLER_597_101 VPWR VGND sg13cmos5l_fill_1
XFILLER_643_0 VPWR VGND sg13cmos5l_decap_8
XFILLER_211_28 VPWR VGND sg13cmos5l_decap_8
XFILLER_62_135 VPWR VGND sg13cmos5l_decap_8
XFILLER_451_174 VPWR VGND sg13cmos5l_decap_8
XANTENNA__3600__X Tile_X0Y9_FrameData_O[30] VPWR VGND sg13cmos5l_antennanp
XFILLER_349_112 VPWR VGND sg13cmos5l_fill_1
XFILLER_648_42 VPWR VGND sg13cmos5l_decap_8
X_2850_ Tile_X0Y6_E2BEGb[7] _4511_/X VPWR VGND sg13cmos5l_buf_1
XFILLER_367_21 VPWR VGND sg13cmos5l_decap_8
X_1801_ _1801_/Q Tile_X0Y3_FrameData[0] VGND VPWR Tile_X0Y9_FrameStrobe[3] latch
X_2781_ Tile_X0Y3_EE4BEG[7] _4171_/X VPWR VGND sg13cmos5l_buf_1
X_4520_ _4520_/X Tile_X0Y6_WW4END[7] AXI_M_SOC_RDATA31 _4575_/X _4552_/X _2567_/Q
+ _2566_/Q VPWR VGND sg13cmos5l_mux4_1
X_1732_ _1732_/Q Tile_X0Y3_FrameData[5] VGND VPWR Tile_X0Y9_FrameStrobe[1] latch
XFILLER_517_35 VPWR VGND sg13cmos5l_decap_8
XFILLER_116_104 VPWR VGND sg13cmos5l_decap_8
X_4451_ _4451_/X _4418_/X _0157_/X _4417_/X _0143_/X _2237_/Q _2236_/Q VPWR VGND sg13cmos5l_mux4_1
XFILLER_664_63 VPWR VGND sg13cmos5l_decap_8
XFILLER_506_175 VPWR VGND sg13cmos5l_decap_8
X_1663_ _1663_/Q Tile_X0Y2_FrameData[18] VGND VPWR Tile_X0Y9_FrameStrobe[7] latch
XFILLER_521_112 VPWR VGND sg13cmos5l_decap_8
XFILLER_236_14 VPWR VGND sg13cmos5l_decap_8
XANTENNA__3047__X Tile_X0Y5_FrameData_O[6] VPWR VGND sg13cmos5l_antennanp
X_3402_ Tile_X0Y2_E2BEG[5] _4045_/X VPWR VGND sg13cmos5l_buf_1
X_0614_ _0614_/Q Tile_X0Y8_FrameData[25] VGND VPWR Tile_X0Y9_FrameStrobe[6] latch
X_4382_ _4382_/X Tile_X0Y5_W2END[5] AXI_M_SOC_RLAST _4432_/X _4431_/X _2339_/Q _2338_/Q
+ VPWR VGND sg13cmos5l_mux4_1
X_1594_ _1594_/Q Tile_X0Y2_FrameData[23] VGND VPWR Tile_X0Y9_FrameStrobe[5] latch
XFILLER_236_69 VPWR VGND sg13cmos5l_decap_8
XFILLER_131_129 VPWR VGND sg13cmos5l_decap_4
X_3333_ Tile_X0Y2_FrameData_O[4] Tile_X0Y2_FrameData[4] VPWR VGND sg13cmos5l_buf_1
XFILLER_521_189 VPWR VGND sg13cmos5l_fill_1
XANTENNA__2886__X Tile_X0Y6_FrameData_O[7] VPWR VGND sg13cmos5l_antennanp
X_0545_ _0545_/Q Tile_X0Y8_FrameData[30] VGND VPWR Tile_X0Y9_FrameStrobe[4] latch
XFILLER_419_105 VPWR VGND sg13cmos5l_decap_8
XFILLER_675_160 VPWR VGND sg13cmos5l_decap_8
XFILLER_533_56 VPWR VGND sg13cmos5l_decap_8
X_3264_ Tile_X0Y0_EE4BEG[0] _3820_/X VPWR VGND sg13cmos5l_buf_1
XFILLER_680_84 VPWR VGND sg13cmos5l_decap_8
XFILLER_85_216 VPWR VGND sg13cmos5l_fill_2
X_0476_ _0476_/Q Tile_X0Y8_FrameData[3] VGND VPWR Tile_X0Y9_FrameStrobe[1] latch
XFILLER_22_0 VPWR VGND sg13cmos5l_decap_8
X_2215_ _2215_/Q Tile_X0Y5_FrameData[30] VGND VPWR Tile_X0Y9_FrameStrobe[1] latch
X_3195_ Tile_X0Y0_N2BEGb[3] _3895_/X VPWR VGND sg13cmos5l_buf_1
XFILLER_252_79 VPWR VGND sg13cmos5l_fill_1
XFILLER_427_182 VPWR VGND sg13cmos5l_decap_8
X_2146_ _2146_/Q Tile_X0Y4_FrameData[3] VGND VPWR Tile_X0Y9_FrameStrobe[6] latch
XFILLER_402_49 VPWR VGND sg13cmos5l_decap_8
XFILLER_588_123 VPWR VGND sg13cmos5l_decap_4
XFILLER_442_152 VPWR VGND sg13cmos5l_decap_8
XFILLER_121_28 VPWR VGND sg13cmos5l_decap_8
X_2077_ _2077_/Q Tile_X0Y4_FrameData[8] VGND VPWR Tile_X0Y9_FrameStrobe[4] latch
XANTENNA__3510__X Tile_X0Y1_E2BEG[0] VPWR VGND sg13cmos5l_antennanp
X_1028_ _1028_/Q Tile_X0Y0_FrameData[7] VGND VPWR Tile_X0Y9_FrameStrobe[2] latch
XFILLER_558_42 VPWR VGND sg13cmos5l_decap_8
XFILLER_277_21 VPWR VGND sg13cmos5l_decap_8
XFILLER_544_215 VPWR VGND sg13cmos5l_fill_2
XFILLER_355_126 VPWR VGND sg13cmos5l_decap_8
X_2979_ Tile_X0Y8_FrameData_O[19] Tile_X0Y8_FrameData[19] VPWR VGND sg13cmos5l_buf_1
XFILLER_708_56 VPWR VGND sg13cmos5l_decap_8
X_4718_ _4718_/X Tile_X0Y8_W1END[1] Tile_X0Y8_WW4END[13] Tile_X0Y8_W6END[5] _4801_/X
+ _0608_/Q _0607_/Q VPWR VGND sg13cmos5l_mux4_1
XFILLER_277_98 VPWR VGND sg13cmos5l_decap_8
XFILLER_370_107 VPWR VGND sg13cmos5l_decap_8
XFILLER_30_14 VPWR VGND sg13cmos5l_decap_8
XFILLER_427_35 VPWR VGND sg13cmos5l_decap_8
XFILLER_107_104 VPWR VGND sg13cmos5l_decap_8
XFILLER_162_210 VPWR VGND sg13cmos5l_decap_8
X_4649_ _4649_/X AXI_M_SOC_RDATA17 _4690_/X _4694_/X _4671_/X _0261_/Q _0260_/Q VPWR
+ VGND sg13cmos5l_mux4_1
XFILLER_701_201 VPWR VGND sg13cmos5l_fill_1
XFILLER_574_63 VPWR VGND sg13cmos5l_decap_4
XFILLER_146_14 VPWR VGND sg13cmos5l_decap_8
XFILLER_512_112 VPWR VGND sg13cmos5l_decap_8
XFILLER_512_123 VPWR VGND sg13cmos5l_fill_1
XFILLER_293_42 VPWR VGND sg13cmos5l_decap_8
XFILLER_122_107 VPWR VGND sg13cmos5l_decap_8
XANTENNA__2796__X Tile_X0Y3_E6BEG[6] VPWR VGND sg13cmos5l_antennanp
XFILLER_115_192 VPWR VGND sg13cmos5l_fill_2
XFILLER_443_56 VPWR VGND sg13cmos5l_decap_8
XFILLER_130_140 VPWR VGND sg13cmos5l_decap_8
XFILLER_590_84 VPWR VGND sg13cmos5l_fill_1
XFILLER_567_7 VPWR VGND sg13cmos5l_decap_8
XFILLER_425_119 VPWR VGND sg13cmos5l_decap_8
XFILLER_681_174 VPWR VGND sg13cmos5l_fill_1
XFILLER_291_125 VPWR VGND sg13cmos5l_decap_8
XFILLER_418_171 VPWR VGND sg13cmos5l_decap_8
XFILLER_579_112 VPWR VGND sg13cmos5l_fill_1
XFILLER_312_49 VPWR VGND sg13cmos5l_decap_8
XANTENNA__3420__X Tile_X0Y4_FrameData_O[11] VPWR VGND sg13cmos5l_antennanp
XFILLER_55_88 VPWR VGND sg13cmos5l_decap_8
XFILLER_44_157 VPWR VGND sg13cmos5l_decap_4
XFILLER_579_178 VPWR VGND sg13cmos5l_fill_1
XFILLER_594_137 VPWR VGND sg13cmos5l_decap_4
XFILLER_111_61 VPWR VGND sg13cmos5l_decap_8
XFILLER_468_42 VPWR VGND sg13cmos5l_decap_8
XFILLER_197_140 VPWR VGND sg13cmos5l_fill_1
XFILLER_187_21 VPWR VGND sg13cmos5l_decap_8
XFILLER_71_76 VPWR VGND sg13cmos5l_decap_8
XFILLER_535_215 VPWR VGND sg13cmos5l_fill_2
XFILLER_346_126 VPWR VGND sg13cmos5l_fill_2
XFILLER_224_0 VPWR VGND sg13cmos5l_decap_8
XFILLER_618_56 VPWR VGND sg13cmos5l_decap_8
XFILLER_361_118 VPWR VGND sg13cmos5l_decap_8
XFILLER_337_35 VPWR VGND sg13cmos5l_decap_8
XFILLER_484_63 VPWR VGND sg13cmos5l_decap_8
XFILLER_503_112 VPWR VGND sg13cmos5l_decap_8
XFILLER_649_105 VPWR VGND sg13cmos5l_decap_8
XFILLER_484_96 VPWR VGND sg13cmos5l_fill_1
XFILLER_593_0 VPWR VGND sg13cmos5l_decap_8
XFILLER_503_189 VPWR VGND sg13cmos5l_decap_8
XFILLER_634_77 VPWR VGND sg13cmos5l_decap_8
XFILLER_106_181 VPWR VGND sg13cmos5l_decap_8
XFILLER_353_56 VPWR VGND sg13cmos5l_decap_8
XFILLER_136_91 VPWR VGND sg13cmos5l_decap_8
X_0330_ _0330_/Q Tile_X0Y7_FrameData[21] VGND VPWR Tile_X0Y9_FrameStrobe[5] latch
XFILLER_96_73 VPWR VGND sg13cmos5l_decap_8
XFILLER_650_21 VPWR VGND sg13cmos5l_decap_8
XFILLER_672_130 VPWR VGND sg13cmos5l_decap_8
X_0261_ _0261_/Q Tile_X0Y7_FrameData[26] VGND VPWR Tile_X0Y9_FrameStrobe[3] latch
XFILLER_605_208 VPWR VGND sg13cmos5l_fill_1
XFILLER_267_199 VPWR VGND sg13cmos5l_decap_8
XFILLER_409_171 VPWR VGND sg13cmos5l_decap_8
X_2000_ _2000_/Q Tile_X0Y4_FrameData[21] VGND VPWR Tile_X0Y9_FrameStrobe[2] latch
XFILLER_282_147 VPWR VGND sg13cmos5l_decap_8
X_0192_ _0192_/Q Tile_X0Y7_FrameData[31] VGND VPWR Tile_X0Y9_FrameStrobe[1] latch
XFILLER_650_98 VPWR VGND sg13cmos5l_decap_8
XFILLER_222_49 VPWR VGND sg13cmos5l_decap_8
XANTENNA__3330__X Tile_X0Y2_FrameData_O[1] VPWR VGND sg13cmos5l_antennanp
XFILLER_302_71 VPWR VGND sg13cmos5l_decap_8
X_3951_ _3951_/X Tile_X0Y1_WW4END[12] AXI_M_SOC_ARREADY _4005_/X _3994_/X _1307_/Q
+ _1306_/Q VPWR VGND sg13cmos5l_mux4_1
XFILLER_659_63 VPWR VGND sg13cmos5l_decap_8
X_2902_ Tile_X0Y6_FrameData_O[23] Tile_X0Y6_FrameData[23] VPWR VGND sg13cmos5l_buf_1
XFILLER_378_42 VPWR VGND sg13cmos5l_decap_8
X_3882_ _3882_/X _3849_/X _0086_/X Tile_X0Y0_S1END[1] Tile_X0Y0_S4END[1] _0993_/Q
+ _0992_/Q VPWR VGND sg13cmos5l_mux4_1
XFILLER_392_210 VPWR VGND sg13cmos5l_fill_2
XFILLER_84_2 VPWR VGND sg13cmos5l_fill_1
X_2833_ Tile_X0Y6_E1BEG[2] _4494_/X VPWR VGND sg13cmos5l_buf_1
XFILLER_526_215 VPWR VGND sg13cmos5l_fill_2
XFILLER_337_126 VPWR VGND sg13cmos5l_fill_2
XFILLER_593_181 VPWR VGND sg13cmos5l_decap_4
XFILLER_337_137 VPWR VGND sg13cmos5l_fill_1
XFILLER_337_148 VPWR VGND sg13cmos5l_fill_1
X_2764_ Tile_X0Y3_FrameData_O[22] Tile_X0Y3_FrameData[22] VPWR VGND sg13cmos5l_buf_1
XFILLER_675_84 VPWR VGND sg13cmos5l_decap_4
XFILLER_541_207 VPWR VGND sg13cmos5l_decap_4
XFILLER_247_35 VPWR VGND sg13cmos5l_decap_8
X_4503_ _4503_/X Tile_X0Y6_W2MID[0] AXI_M_SOC_RDATA31 _4553_/X _4552_/X _2601_/Q _2600_/Q
+ VPWR VGND sg13cmos5l_mux4_1
X_1715_ _1715_/Q Tile_X0Y3_FrameData[22] VGND VPWR Tile_X0Y9_FrameStrobe[1] latch
X_2695_ _2695_/Q Tile_X0Y6_FrameData[0] VGND VPWR Tile_X0Y9_FrameStrobe[7] latch
X_4434_ _4434_/X _4359_/X _4475_/X _4474_/X _4358_/X _2199_/Q _2198_/Q VPWR VGND sg13cmos5l_mux4_1
X_1646_ _1646_/Q Tile_X0Y2_FrameData[3] VGND VPWR Tile_X0Y9_FrameStrobe[6] latch
XFILLER_360_162 VPWR VGND sg13cmos5l_decap_8
X_4365_ _4365_/X Tile_X0Y6_W2MID[1] Tile_X0Y6_W2END[1] Tile_X0Y6_W6END[1] _4554_/X
+ _2675_/Q _2674_/Q VPWR VGND sg13cmos5l_mux4_1
X_1577_ _1577_/Q Tile_X0Y2_FrameData[8] VGND VPWR Tile_X0Y9_FrameStrobe[4] latch
XFILLER_263_56 VPWR VGND sg13cmos5l_fill_1
XANTENNA__3505__X Tile_X0Y1_E2BEGb[3] VPWR VGND sg13cmos5l_antennanp
XFILLER_258_122 VPWR VGND sg13cmos5l_decap_8
X_3316_ Tile_X0Y4_EE4BEG[4] _4276_/X VPWR VGND sg13cmos5l_buf_1
XFILLER_648_182 VPWR VGND sg13cmos5l_decap_8
X_0528_ _0528_/Q Tile_X0Y8_FrameData[15] VGND VPWR Tile_X0Y9_FrameStrobe[3] latch
XFILLER_112_151 VPWR VGND sg13cmos5l_fill_1
X_4296_ _4296_/X AXI_M_SOC_BRESP0 _4339_/X _4343_/X _4318_/X _2021_/Q _2020_/Q VPWR
+ VGND sg13cmos5l_mux4_1
XFILLER_263_89 VPWR VGND sg13cmos5l_decap_8
XFILLER_560_21 VPWR VGND sg13cmos5l_decap_8
X_3247_ Tile_X0Y0_FrameData_O[15] Tile_X0Y0_FrameData[15] VPWR VGND sg13cmos5l_buf_1
X_0459_ _0459_/Q Tile_X0Y8_FrameData[20] VGND VPWR Tile_X0Y9_FrameStrobe[1] latch
XFILLER_560_98 VPWR VGND sg13cmos5l_decap_8
X_3178_ Tile_X0Y0_N4BEG[2] _3178_/A VPWR VGND sg13cmos5l_buf_1
XFILLER_132_49 VPWR VGND sg13cmos5l_decap_8
XFILLER_710_35 VPWR VGND sg13cmos5l_decap_8
X_2129_ _2129_/Q Tile_X0Y4_FrameData[20] VGND VPWR Tile_X0Y9_FrameStrobe[6] latch
XFILLER_415_163 VPWR VGND sg13cmos5l_decap_4
XANTENNA__3240__X Tile_X0Y0_FrameData_O[8] VPWR VGND sg13cmos5l_antennanp
XFILLER_25_14 VPWR VGND sg13cmos5l_decap_8
XFILLER_26_168 VPWR VGND sg13cmos5l_decap_4
XFILLER_430_133 VPWR VGND sg13cmos5l_decap_8
XFILLER_576_126 VPWR VGND sg13cmos5l_decap_8
XFILLER_569_63 VPWR VGND sg13cmos5l_decap_8
XFILLER_288_42 VPWR VGND sg13cmos5l_decap_8
XFILLER_148_7 VPWR VGND sg13cmos5l_decap_8
XFILLER_517_204 VPWR VGND sg13cmos5l_fill_2
XFILLER_383_210 VPWR VGND sg13cmos5l_fill_1
XFILLER_194_132 VPWR VGND sg13cmos5l_fill_2
XFILLER_584_192 VPWR VGND sg13cmos5l_decap_8
XFILLER_438_56 VPWR VGND sg13cmos5l_decap_8
XFILLER_315_7 VPWR VGND sg13cmos5l_decap_8
XFILLER_585_95 VPWR VGND sg13cmos5l_decap_8
XFILLER_210_6 VPWR VGND sg13cmos5l_decap_8
XFILLER_194_198 VPWR VGND sg13cmos5l_fill_1
XFILLER_336_170 VPWR VGND sg13cmos5l_fill_1
XFILLER_308_6 VPWR VGND sg13cmos5l_decap_8
XFILLER_351_140 VPWR VGND sg13cmos5l_decap_8
XFILLER_497_133 VPWR VGND sg13cmos5l_decap_8
XFILLER_351_173 VPWR VGND sg13cmos5l_decap_8
XFILLER_296_217 VPWR VGND sg13cmos5l_fill_1
XFILLER_500_126 VPWR VGND sg13cmos5l_decap_8
XFILLER_684_7 VPWR VGND sg13cmos5l_decap_8
XFILLER_646_119 VPWR VGND sg13cmos5l_decap_8
XFILLER_604_14 VPWR VGND sg13cmos5l_decap_8
XANTENNA__3415__X Tile_X0Y4_FrameData_O[6] VPWR VGND sg13cmos5l_antennanp
XFILLER_639_182 VPWR VGND sg13cmos5l_decap_8
XFILLER_49_216 VPWR VGND sg13cmos5l_fill_2
XFILLER_470_21 VPWR VGND sg13cmos5l_decap_8
XFILLER_106_50 VPWR VGND sg13cmos5l_fill_1
XFILLER_66_10 VPWR VGND sg13cmos5l_decap_4
XFILLER_106_72 VPWR VGND sg13cmos5l_decap_8
XFILLER_66_21 VPWR VGND sg13cmos5l_decap_8
XFILLER_249_188 VPWR VGND sg13cmos5l_fill_2
XFILLER_654_174 VPWR VGND sg13cmos5l_fill_1
XFILLER_264_147 VPWR VGND sg13cmos5l_fill_2
XFILLER_620_35 VPWR VGND sg13cmos5l_decap_8
XFILLER_66_98 VPWR VGND sg13cmos5l_decap_8
XFILLER_17_113 VPWR VGND sg13cmos5l_decap_4
XFILLER_174_0 VPWR VGND sg13cmos5l_decap_8
XANTENNA__3150__X Tile_X0Y7_FrameData_O[20] VPWR VGND sg13cmos5l_antennanp
XFILLER_82_20 VPWR VGND sg13cmos5l_decap_8
XFILLER_696_28 VPWR VGND sg13cmos5l_decap_8
XFILLER_567_126 VPWR VGND sg13cmos5l_decap_8
XFILLER_122_93 VPWR VGND sg13cmos5l_decap_8
XFILLER_341_0 VPWR VGND sg13cmos5l_decap_8
XFILLER_439_0 VPWR VGND sg13cmos5l_decap_8
XFILLER_421_177 VPWR VGND sg13cmos5l_fill_2
XFILLER_198_42 VPWR VGND sg13cmos5l_decap_8
XFILLER_319_104 VPWR VGND sg13cmos5l_decap_8
XFILLER_709_175 VPWR VGND sg13cmos5l_decap_8
XFILLER_629_77 VPWR VGND sg13cmos5l_decap_8
XFILLER_40_171 VPWR VGND sg13cmos5l_fill_1
XFILLER_606_0 VPWR VGND sg13cmos5l_decap_8
XFILLER_348_56 VPWR VGND sg13cmos5l_decap_8
XFILLER_495_84 VPWR VGND sg13cmos5l_decap_8
XFILLER_645_21 VPWR VGND sg13cmos5l_decap_8
XFILLER_63_7 VPWR VGND sg13cmos5l_decap_8
XFILLER_590_195 VPWR VGND sg13cmos5l_fill_1
XFILLER_677_200 VPWR VGND sg13cmos5l_decap_4
X_1500_ _1500_/Q Tile_X0Y2_FrameData[21] VGND VPWR Tile_X0Y9_FrameStrobe[2] latch
XFILLER_217_27 VPWR VGND sg13cmos5l_decap_8
XFILLER_56_6 VPWR VGND sg13cmos5l_decap_8
XFILLER_99_116 VPWR VGND sg13cmos5l_fill_1
X_2480_ _2480_/Q Tile_X0Y6_FrameData[23] VGND VPWR Tile_X0Y9_FrameStrobe[1] latch
XFILLER_645_98 VPWR VGND sg13cmos5l_decap_8
XFILLER_342_162 VPWR VGND sg13cmos5l_decap_8
XFILLER_287_206 VPWR VGND sg13cmos5l_decap_8
XFILLER_287_217 VPWR VGND sg13cmos5l_fill_1
XFILLER_99_149 VPWR VGND sg13cmos5l_fill_1
X_1431_ _1431_/Q Tile_X0Y2_FrameData[26] VGND VPWR Tile_X0Y9_FrameStrobe[0] latch
XFILLER_514_14 VPWR VGND sg13cmos5l_decap_8
XFILLER_637_119 VPWR VGND sg13cmos5l_decap_8
XFILLER_429_211 VPWR VGND sg13cmos5l_decap_8
XANTENNA__3325__X Tile_X0Y4_EE4BEG[13] VPWR VGND sg13cmos5l_antennanp
XFILLER_661_42 VPWR VGND sg13cmos5l_decap_8
X_4150_ _4150_/X Tile_X0Y3_W2MID[5] AXI_M_SOC_WREADY _4209_/X _4208_/X _1841_/Q _1840_/Q
+ VPWR VGND sg13cmos5l_mux4_1
X_1362_ _1362_/Q Tile_X0Y1_FrameData[7] VGND VPWR Tile_X0Y9_FrameStrobe[5] latch
XFILLER_380_21 VPWR VGND sg13cmos5l_decap_8
X_3101_ Tile_X0Y7_E2BEGb[7] _4627_/X VPWR VGND sg13cmos5l_buf_1
X_0313_ _0313_/Q Tile_X0Y7_FrameData[6] VGND VPWR Tile_X0Y9_FrameStrobe[4] latch
XFILLER_255_103 VPWR VGND sg13cmos5l_decap_8
X_4081_ _4081_/X AXI_M_SOC_AWREADY _4118_/X _4122_/X _4100_/X _1511_/Q _1510_/Q VPWR
+ VGND sg13cmos5l_mux4_1
X_1293_ _1293_/Q Tile_X0Y1_FrameData[12] VGND VPWR Tile_X0Y9_FrameStrobe[3] latch
XFILLER_233_59 VPWR VGND sg13cmos5l_decap_8
XFILLER_380_76 VPWR VGND sg13cmos5l_fill_2
X_3032_ Tile_X0Y5_EE4BEG[7] _4395_/X VPWR VGND sg13cmos5l_buf_1
XFILLER_645_196 VPWR VGND sg13cmos5l_decap_8
X_0244_ _0244_/Q Tile_X0Y7_FrameData[11] VGND VPWR Tile_X0Y9_FrameStrobe[2] latch
XFILLER_530_35 VPWR VGND sg13cmos5l_decap_8
X_0175_ _0175_/Q Tile_X0Y7_FrameData[16] VGND VPWR Tile_X0Y9_FrameStrobe[0] latch
XANTENNA__3060__X Tile_X0Y5_FrameData_O[19] VPWR VGND sg13cmos5l_antennanp
XFILLER_601_211 VPWR VGND sg13cmos5l_decap_8
XFILLER_412_133 VPWR VGND sg13cmos5l_decap_8
XFILLER_389_63 VPWR VGND sg13cmos5l_decap_8
X_3934_ _3934_/X Tile_X0Y1_W2MID[5] AXI_M_SOC_ARREADY _3993_/X _3992_/X _1341_/Q _1340_/Q
+ VPWR VGND sg13cmos5l_mux4_1
X_3865_ _3865_/X Tile_X0Y4_W1END[0] Tile_X0Y4_WW4END[0] Tile_X0Y4_W6END[8] _4336_/X
+ _2157_/Q _2156_/Q VPWR VGND sg13cmos5l_mux4_1
XFILLER_258_56 VPWR VGND sg13cmos5l_decap_8
X_2816_ Tile_X0Y3_E2BEG[6] _4154_/X VPWR VGND sg13cmos5l_buf_1
X_3796_ _3796_/X Tile_X0Y0_W1END[2] Tile_X0Y0_WW4END[2] Tile_X0Y0_W6END[10] _3883_/X
+ _1147_/Q _1146_/Q VPWR VGND sg13cmos5l_mux4_1
XFILLER_715_167 VPWR VGND sg13cmos5l_decap_8
XFILLER_581_162 VPWR VGND sg13cmos5l_decap_8
XFILLER_555_21 VPWR VGND sg13cmos5l_decap_8
XFILLER_380_213 VPWR VGND sg13cmos5l_decap_4
XFILLER_191_113 VPWR VGND sg13cmos5l_decap_4
XFILLER_581_173 VPWR VGND sg13cmos5l_fill_1
XFILLER_715_189 VPWR VGND sg13cmos5l_fill_1
X_2747_ Tile_X0Y3_FrameData_O[5] Tile_X0Y3_FrameData[5] VPWR VGND sg13cmos5l_buf_1
XFILLER_581_195 VPWR VGND sg13cmos5l_decap_8
XFILLER_191_146 VPWR VGND sg13cmos5l_decap_8
XFILLER_479_100 VPWR VGND sg13cmos5l_fill_2
XFILLER_191_157 VPWR VGND sg13cmos5l_fill_1
XFILLER_11_49 VPWR VGND sg13cmos5l_decap_8
X_2678_ _2678_/Q Tile_X0Y6_FrameData[17] VGND VPWR Tile_X0Y9_FrameStrobe[7] latch
XFILLER_333_162 VPWR VGND sg13cmos5l_decap_4
XFILLER_127_49 VPWR VGND sg13cmos5l_decap_8
XFILLER_705_35 VPWR VGND sg13cmos5l_decap_8
XFILLER_333_173 VPWR VGND sg13cmos5l_fill_1
X_4417_ _4417_/X Tile_X0Y4_W1END[0] Tile_X0Y4_W6END[8] _4348_/X _4300_/X _2145_/Q
+ _2144_/Q VPWR VGND sg13cmos5l_mux4_1
XFILLER_274_77 VPWR VGND sg13cmos5l_decap_8
X_1629_ _1629_/Q Tile_X0Y2_FrameData[20] VGND VPWR Tile_X0Y9_FrameStrobe[6] latch
XFILLER_424_14 VPWR VGND sg13cmos5l_decap_8
XANTENNA__3235__X Tile_X0Y0_FrameData_O[3] VPWR VGND sg13cmos5l_antennanp
XFILLER_571_42 VPWR VGND sg13cmos5l_decap_8
XFILLER_494_147 VPWR VGND sg13cmos5l_decap_8
X_4348_ _4348_/X _4302_/X _0099_/X _4301_/X _0112_/X _1957_/Q _1956_/Q VPWR VGND sg13cmos5l_mux4_1
XFILLER_293_209 VPWR VGND sg13cmos5l_fill_1
XFILLER_290_21 VPWR VGND sg13cmos5l_decap_8
XFILLER_100_110 VPWR VGND sg13cmos5l_decap_8
X_4279_ _4279_/X Tile_X0Y4_WW4END[8] AXI_M_SOC_BRESP1 _4344_/X _4313_/X _2055_/Q _2054_/Q
+ VPWR VGND sg13cmos5l_mux4_1
XFILLER_100_143 VPWR VGND sg13cmos5l_decap_8
XFILLER_636_185 VPWR VGND sg13cmos5l_fill_1
XFILLER_504_91 VPWR VGND sg13cmos5l_decap_8
XFILLER_651_133 VPWR VGND sg13cmos5l_decap_8
XFILLER_290_98 VPWR VGND sg13cmos5l_decap_8
XFILLER_246_169 VPWR VGND sg13cmos5l_fill_2
XFILLER_440_35 VPWR VGND sg13cmos5l_decap_8
XFILLER_223_70 VPWR VGND sg13cmos5l_fill_2
XFILLER_36_35 VPWR VGND sg13cmos5l_decap_8
XFILLER_450_217 VPWR VGND sg13cmos5l_fill_1
XFILLER_36_46 VPWR VGND sg13cmos5l_fill_1
XFILLER_265_7 VPWR VGND sg13cmos5l_decap_8
XFILLER_36_79 VPWR VGND sg13cmos5l_fill_1
XFILLER_160_6 VPWR VGND sg13cmos5l_decap_8
XFILLER_403_144 VPWR VGND sg13cmos5l_decap_8
XFILLER_202_217 VPWR VGND sg13cmos5l_fill_1
XFILLER_432_7 VPWR VGND sg13cmos5l_decap_8
XFILLER_52_23 VPWR VGND sg13cmos5l_decap_8
XFILLER_356_210 VPWR VGND sg13cmos5l_decap_8
XFILLER_596_83 VPWR VGND sg13cmos5l_fill_2
XFILLER_449_77 VPWR VGND sg13cmos5l_decap_4
XFILLER_706_112 VPWR VGND sg13cmos5l_decap_8
XFILLER_572_140 VPWR VGND sg13cmos5l_decap_8
XFILLER_465_21 VPWR VGND sg13cmos5l_decap_8
XFILLER_371_213 VPWR VGND sg13cmos5l_decap_4
XFILLER_316_118 VPWR VGND sg13cmos5l_fill_2
XFILLER_168_89 VPWR VGND sg13cmos5l_decap_8
XFILLER_167_187 VPWR VGND sg13cmos5l_decap_8
XFILLER_706_189 VPWR VGND sg13cmos5l_fill_1
XFILLER_184_44 VPWR VGND sg13cmos5l_decap_8
XFILLER_123_202 VPWR VGND sg13cmos5l_fill_2
XFILLER_615_35 VPWR VGND sg13cmos5l_decap_8
XFILLER_269_217 VPWR VGND sg13cmos5l_fill_1
XFILLER_324_195 VPWR VGND sg13cmos5l_decap_8
XFILLER_334_14 VPWR VGND sg13cmos5l_decap_8
XANTENNA__3145__X Tile_X0Y7_FrameData_O[15] VPWR VGND sg13cmos5l_antennanp
XFILLER_77_20 VPWR VGND sg13cmos5l_decap_8
XFILLER_481_42 VPWR VGND sg13cmos5l_decap_8
XFILLER_291_0 VPWR VGND sg13cmos5l_decap_8
XFILLER_426_203 VPWR VGND sg13cmos5l_fill_2
XFILLER_389_0 VPWR VGND sg13cmos5l_decap_8
XANTENNA__2984__X Tile_X0Y8_FrameData_O[24] VPWR VGND sg13cmos5l_antennanp
XFILLER_631_56 VPWR VGND sg13cmos5l_decap_8
XFILLER_237_147 VPWR VGND sg13cmos5l_decap_8
XFILLER_642_133 VPWR VGND sg13cmos5l_decap_8
XFILLER_350_35 VPWR VGND sg13cmos5l_decap_8
XFILLER_556_0 VPWR VGND sg13cmos5l_decap_8
XFILLER_93_63 VPWR VGND sg13cmos5l_decap_8
XFILLER_500_49 VPWR VGND sg13cmos5l_decap_8
X_1980_ _1980_/Q Tile_X0Y4_FrameData[9] VGND VPWR Tile_X0Y9_FrameStrobe[1] latch
X_0931_ _0931_/Q Tile_X0Y9_FrameData[22] VGND VPWR Tile_X0Y9_FrameStrobe[8] latch
XFILLER_359_77 VPWR VGND sg13cmos5l_decap_8
XFILLER_509_14 VPWR VGND sg13cmos5l_decap_8
XFILLER_158_143 VPWR VGND sg13cmos5l_decap_8
XFILLER_656_42 VPWR VGND sg13cmos5l_decap_8
X_3650_ AXI_M_SOC_AWADDR11 Tile_X0Y5_WW4END[3] Tile_X0Y5_WW4END[11] Tile_X0Y5_W6END[11]
+ _4462_/X _2249_/Q _2248_/Q VPWR VGND sg13cmos5l_mux4_1
X_0862_ _0862_/Q Tile_X0Y9_FrameData[1] VGND VPWR Tile_X0Y9_FrameStrobe[5] latch
XFILLER_375_21 VPWR VGND sg13cmos5l_decap_8
X_2601_ _2601_/Q Tile_X0Y6_FrameData[30] VGND VPWR Tile_X0Y9_FrameStrobe[5] latch
XFILLER_712_126 VPWR VGND sg13cmos5l_decap_8
X_3581_ Tile_X0Y9_FrameData_O[11] Tile_X0Y9_FrameData[11] VPWR VGND sg13cmos5l_buf_1
X_0793_ _0793_/Q Tile_X0Y9_FrameData[6] VGND VPWR Tile_X0Y9_FrameStrobe[3] latch
X_2532_ _2532_/Q Tile_X0Y6_FrameData[3] VGND VPWR Tile_X0Y9_FrameStrobe[2] latch
XFILLER_525_35 VPWR VGND sg13cmos5l_decap_8
XFILLER_672_63 VPWR VGND sg13cmos5l_decap_8
XFILLER_476_103 VPWR VGND sg13cmos5l_decap_8
X_2463_ _2463_/Q Tile_X0Y6_FrameData[8] VGND VPWR Tile_X0Y9_FrameStrobe[0] latch
XFILLER_47_2 VPWR VGND sg13cmos5l_fill_1
XFILLER_244_14 VPWR VGND sg13cmos5l_decap_8
XFILLER_330_132 VPWR VGND sg13cmos5l_decap_8
XANTENNA__3055__X Tile_X0Y5_FrameData_O[14] VPWR VGND sg13cmos5l_antennanp
X_4202_ _4202_/X Tile_X0Y2_W1END[3] Tile_X0Y2_W6END[11] _4104_/X _4087_/X _1631_/Q
+ _1630_/Q VPWR VGND sg13cmos5l_mux4_1
XFILLER_391_42 VPWR VGND sg13cmos5l_fill_2
X_1414_ _1414_/Q Tile_X0Y1_FrameData[19] VGND VPWR Tile_X0Y9_FrameStrobe[7] latch
X_2394_ _2394_/Q Tile_X0Y5_FrameData[11] VGND VPWR Tile_X0Y9_FrameStrobe[6] latch
XFILLER_391_86 VPWR VGND sg13cmos5l_decap_8
X_4133_ _4133_/X Tile_X0Y4_W2MID[5] Tile_X0Y4_W2END[5] Tile_X0Y4_W6END[5] _4317_/X
+ _2169_/Q _2168_/Q VPWR VGND sg13cmos5l_mux4_1
XANTENNA__2894__X Tile_X0Y6_FrameData_O[15] VPWR VGND sg13cmos5l_antennanp
X_1345_ _1345_/Q Tile_X0Y1_FrameData[24] VGND VPWR Tile_X0Y9_FrameStrobe[5] latch
XFILLER_618_163 VPWR VGND sg13cmos5l_decap_8
XFILLER_618_185 VPWR VGND sg13cmos5l_fill_1
XFILLER_228_136 VPWR VGND sg13cmos5l_decap_8
XFILLER_95_163 VPWR VGND sg13cmos5l_fill_1
X_4064_ _4064_/X Tile_X0Y2_WW4END[7] AXI_M_SOC_AWREADY _4123_/X _4096_/X _1545_/Q
+ _1544_/Q VPWR VGND sg13cmos5l_mux4_1
XFILLER_633_133 VPWR VGND sg13cmos5l_fill_2
X_1276_ _1276_/Q Tile_X0Y1_FrameData[29] VGND VPWR Tile_X0Y9_FrameStrobe[3] latch
XFILLER_260_35 VPWR VGND sg13cmos5l_decap_8
XFILLER_432_206 VPWR VGND sg13cmos5l_fill_2
X_3015_ Tile_X0Y5_E6BEG[2] _4406_/X VPWR VGND sg13cmos5l_buf_1
X_0227_ _0227_/Q Tile_X0Y7_FrameData[28] VGND VPWR Tile_X0Y9_FrameStrobe[2] latch
XFILLER_236_191 VPWR VGND sg13cmos5l_fill_2
XFILLER_586_210 VPWR VGND sg13cmos5l_fill_2
X_0158_ _0158_/X _4326_/X _4327_/X _0642_/Q VPWR VGND sg13cmos5l_mux2_1
XFILLER_410_49 VPWR VGND sg13cmos5l_decap_8
X_0089_ _0089_/X _4213_/X _4214_/X _0389_/Q VPWR VGND sg13cmos5l_mux2_1
XFILLER_11_119 VPWR VGND sg13cmos5l_decap_8
XFILLER_400_147 VPWR VGND sg13cmos5l_decap_8
XFILLER_269_77 VPWR VGND sg13cmos5l_decap_8
XFILLER_149_121 VPWR VGND sg13cmos5l_decap_8
X_3917_ _3917_/X _4121_/X _4125_/X _4110_/X _4099_/X _1646_/Q _1645_/Q VPWR VGND sg13cmos5l_mux4_1
XFILLER_400_158 VPWR VGND sg13cmos5l_fill_2
XFILLER_419_14 VPWR VGND sg13cmos5l_decap_8
X_4897_ _4897_/X Tile_X0Y8_W1END[1] Tile_X0Y8_W6END[9] _4813_/X _4773_/X _0633_/Q
+ _0632_/Q VPWR VGND sg13cmos5l_mux4_1
XFILLER_566_42 VPWR VGND sg13cmos5l_decap_8
X_3848_ _3848_/X Tile_X0Y1_W1END[0] Tile_X0Y1_W6END[4] _4005_/X _3976_/X _1425_/Q
+ _1424_/Q VPWR VGND sg13cmos5l_mux4_1
XFILLER_285_21 VPWR VGND sg13cmos5l_decap_8
XFILLER_703_126 VPWR VGND sg13cmos5l_fill_2
X_3779_ AXI_M_SOC_RREADY Tile_X0Y5_W2MID[0] Tile_X0Y5_W2END[0] Tile_X0Y5_W6END[0]
+ _4467_/X _2239_/Q _2238_/Q VPWR VGND sg13cmos5l_mux4_1
XFILLER_716_45 VPWR VGND sg13cmos5l_fill_1
XFILLER_285_98 VPWR VGND sg13cmos5l_decap_8
XFILLER_716_78 VPWR VGND sg13cmos5l_fill_2
XFILLER_435_35 VPWR VGND sg13cmos5l_decap_8
XFILLER_218_70 VPWR VGND sg13cmos5l_decap_8
XFILLER_582_63 VPWR VGND sg13cmos5l_decap_8
XFILLER_321_154 VPWR VGND sg13cmos5l_decap_8
XFILLER_321_187 VPWR VGND sg13cmos5l_decap_8
XFILLER_609_141 VPWR VGND sg13cmos5l_decap_8
XFILLER_321_198 VPWR VGND sg13cmos5l_fill_1
XANTENNA__0101__Y AXI_M_SOC_ARLEN6 VPWR VGND sg13cmos5l_antennanp
XFILLER_671_217 VPWR VGND sg13cmos5l_fill_1
XFILLER_609_163 VPWR VGND sg13cmos5l_decap_8
XFILLER_382_7 VPWR VGND sg13cmos5l_decap_8
XFILLER_304_28 VPWR VGND sg13cmos5l_decap_8
XFILLER_609_174 VPWR VGND sg13cmos5l_fill_2
XFILLER_47_34 VPWR VGND sg13cmos5l_decap_8
XFILLER_451_56 VPWR VGND sg13cmos5l_decap_8
XFILLER_219_136 VPWR VGND sg13cmos5l_fill_1
XFILLER_234_117 VPWR VGND sg13cmos5l_decap_8
XFILLER_624_177 VPWR VGND sg13cmos5l_decap_8
XFILLER_647_7 VPWR VGND sg13cmos5l_decap_8
XFILLER_103_84 VPWR VGND sg13cmos5l_decap_8
XFILLER_242_183 VPWR VGND sg13cmos5l_decap_8
XFILLER_187_216 VPWR VGND sg13cmos5l_fill_2
XFILLER_63_88 VPWR VGND sg13cmos5l_decap_8
XFILLER_388_187 VPWR VGND sg13cmos5l_decap_8
XFILLER_388_198 VPWR VGND sg13cmos5l_fill_2
XFILLER_8_28 VPWR VGND sg13cmos5l_decap_8
XFILLER_329_14 VPWR VGND sg13cmos5l_decap_8
XFILLER_137_0 VPWR VGND sg13cmos5l_decap_8
XFILLER_476_42 VPWR VGND sg13cmos5l_decap_4
XFILLER_344_202 VPWR VGND sg13cmos5l_fill_1
XFILLER_195_21 VPWR VGND sg13cmos5l_decap_8
XFILLER_155_113 VPWR VGND sg13cmos5l_fill_2
XFILLER_6_112 VPWR VGND sg13cmos5l_decap_8
XFILLER_545_195 VPWR VGND sg13cmos5l_fill_2
XANTENNA__2979__X Tile_X0Y8_FrameData_O[19] VPWR VGND sg13cmos5l_antennanp
XFILLER_10_185 VPWR VGND sg13cmos5l_decap_8
XFILLER_304_0 VPWR VGND sg13cmos5l_decap_8
XFILLER_626_56 VPWR VGND sg13cmos5l_decap_8
XFILLER_409_91 VPWR VGND sg13cmos5l_fill_1
XFILLER_12_70 VPWR VGND sg13cmos5l_decap_8
XFILLER_345_35 VPWR VGND sg13cmos5l_decap_8
XFILLER_170_138 VPWR VGND sg13cmos5l_decap_8
XFILLER_128_70 VPWR VGND sg13cmos5l_decap_4
XFILLER_647_203 VPWR VGND sg13cmos5l_decap_8
XFILLER_501_210 VPWR VGND sg13cmos5l_decap_8
XFILLER_492_63 VPWR VGND sg13cmos5l_decap_8
XFILLER_40_9 VPWR VGND sg13cmos5l_decap_8
XFILLER_88_96 VPWR VGND sg13cmos5l_decap_8
XFILLER_111_216 VPWR VGND sg13cmos5l_fill_2
XFILLER_673_0 VPWR VGND sg13cmos5l_decap_8
XFILLER_662_217 VPWR VGND sg13cmos5l_fill_1
XFILLER_642_77 VPWR VGND sg13cmos5l_decap_8
XFILLER_214_28 VPWR VGND sg13cmos5l_decap_8
XFILLER_26_7 VPWR VGND sg13cmos5l_decap_8
XFILLER_361_56 VPWR VGND sg13cmos5l_decap_8
XANTENNA__3603__X Tile_X0Y9_S1BEG[1] VPWR VGND sg13cmos5l_antennanp
X_1130_ _1130_/Q Tile_X0Y0_FrameData[1] VGND VPWR Tile_X0Y9_FrameStrobe[5] latch
XFILLER_615_133 VPWR VGND sg13cmos5l_decap_8
XFILLER_225_106 VPWR VGND sg13cmos5l_decap_8
XFILLER_225_117 VPWR VGND sg13cmos5l_fill_1
XFILLER_481_172 VPWR VGND sg13cmos5l_decap_4
X_1061_ _1061_/Q Tile_X0Y0_FrameData[6] VGND VPWR Tile_X0Y9_FrameStrobe[3] latch
XFILLER_225_128 VPWR VGND sg13cmos5l_decap_8
XFILLER_92_166 VPWR VGND sg13cmos5l_decap_8
XFILLER_92_199 VPWR VGND sg13cmos5l_decap_8
XFILLER_379_143 VPWR VGND sg13cmos5l_decap_8
XFILLER_178_205 VPWR VGND sg13cmos5l_fill_1
X_4820_ _4820_/X Tile_X0Y7_W1END[0] Tile_X0Y7_W2MID[3] Tile_X0Y7_W2END[3] _4674_/X
+ _0363_/Q _0362_/Q VPWR VGND sg13cmos5l_mux4_1
XFILLER_379_187 VPWR VGND sg13cmos5l_decap_8
XFILLER_310_71 VPWR VGND sg13cmos5l_decap_8
XFILLER_667_52 VPWR VGND sg13cmos5l_decap_8
X_1963_ _1963_/Q Tile_X0Y4_FrameData[26] VGND VPWR Tile_X0Y9_FrameStrobe[1] latch
X_4751_ _4751_/X Tile_X0Y8_WW4END[8] AXI_M_SOC_RDATA15 _4808_/X _4785_/X _0545_/Q
+ _0544_/Q VPWR VGND sg13cmos5l_mux4_1
XFILLER_239_14 VPWR VGND sg13cmos5l_decap_8
XFILLER_667_74 VPWR VGND sg13cmos5l_decap_8
XFILLER_386_42 VPWR VGND sg13cmos5l_decap_8
X_0914_ _0914_/Q Tile_X0Y9_FrameData[13] VGND VPWR Tile_X0Y9_FrameStrobe[7] latch
X_3702_ AXI_M_SOC_WDATA12 Tile_X0Y7_W1END[0] Tile_X0Y7_WW4END[4] Tile_X0Y7_WW4END[12]
+ _4696_/X _0223_/Q _0222_/Q VPWR VGND sg13cmos5l_mux4_1
X_4682_ _4682_/X Tile_X0Y3_W1END[3] Tile_X0Y3_WW4END[15] Tile_X0Y3_W6END[7] _4225_/X
+ _1856_/Q _1855_/Q VPWR VGND sg13cmos5l_mux4_1
XFILLER_335_202 VPWR VGND sg13cmos5l_decap_8
X_1894_ _1894_/Q Tile_X0Y3_FrameData[3] VGND VPWR Tile_X0Y9_FrameStrobe[6] latch
X_3633_ Tile_X0Y9_S4BEG[11] _3633_/A VPWR VGND sg13cmos5l_buf_1
X_0845_ _0845_/Q Tile_X0Y9_FrameData[18] VGND VPWR Tile_X0Y9_FrameStrobe[5] latch
XANTENNA__2889__X Tile_X0Y6_FrameData_O[10] VPWR VGND sg13cmos5l_antennanp
XFILLER_146_179 VPWR VGND sg13cmos5l_decap_8
XFILLER_350_205 VPWR VGND sg13cmos5l_fill_1
X_3564_ Tile_X0Y9_EE4BEG[10] _4874_/X VPWR VGND sg13cmos5l_buf_1
XFILLER_350_216 VPWR VGND sg13cmos5l_fill_2
X_0776_ _0776_/Q Tile_X0Y9_FrameData[23] VGND VPWR Tile_X0Y9_FrameStrobe[3] latch
XFILLER_255_35 VPWR VGND sg13cmos5l_fill_2
X_2515_ _2515_/Q Tile_X0Y6_FrameData[20] VGND VPWR Tile_X0Y9_FrameStrobe[2] latch
X_3495_ Tile_X0Y1_E6BEG[5] _3969_/X VPWR VGND sg13cmos5l_buf_1
XFILLER_255_79 VPWR VGND sg13cmos5l_fill_2
XFILLER_449_125 VPWR VGND sg13cmos5l_fill_2
XFILLER_303_165 VPWR VGND sg13cmos5l_decap_8
X_2446_ _2446_/Q Tile_X0Y6_FrameData[25] VGND VPWR Tile_X0Y9_FrameStrobe[0] latch
XFILLER_552_77 VPWR VGND sg13cmos5l_decap_8
XFILLER_124_28 VPWR VGND sg13cmos5l_decap_8
X_2377_ _2377_/Q Tile_X0Y5_FrameData[28] VGND VPWR Tile_X0Y9_FrameStrobe[6] latch
XFILLER_702_14 VPWR VGND sg13cmos5l_decap_8
XFILLER_68_141 VPWR VGND sg13cmos5l_decap_8
XANTENNA__3513__X Tile_X0Y1_E2BEG[3] VPWR VGND sg13cmos5l_antennanp
XFILLER_271_56 VPWR VGND sg13cmos5l_decap_8
X_4116_ _4116_/X _4089_/X _0079_/X _4088_/X Tile_X0Y0_S4END[8] _1481_/Q _1480_/Q VPWR
+ VGND sg13cmos5l_mux4_1
X_1328_ _1328_/Q Tile_X0Y1_FrameData[9] VGND VPWR Tile_X0Y9_FrameStrobe[4] latch
XFILLER_606_155 VPWR VGND sg13cmos5l_fill_2
XFILLER_472_161 VPWR VGND sg13cmos5l_decap_8
X_4047_ _4047_/X Tile_X0Y2_W2MID[0] AXI_M_SOC_AWREADY _4097_/X _4096_/X _1579_/Q _1578_/Q
+ VPWR VGND sg13cmos5l_mux4_1
X_1259_ _1259_/Q Tile_X0Y1_FrameData[14] VGND VPWR Tile_X0Y9_FrameStrobe[2] latch
XFILLER_621_125 VPWR VGND sg13cmos5l_decap_8
XFILLER_83_188 VPWR VGND sg13cmos5l_decap_8
XFILLER_140_49 VPWR VGND sg13cmos5l_decap_8
XFILLER_501_70 VPWR VGND sg13cmos5l_decap_8
XFILLER_574_213 VPWR VGND sg13cmos5l_decap_4
XFILLER_33_14 VPWR VGND sg13cmos5l_decap_8
XFILLER_577_63 VPWR VGND sg13cmos5l_decap_8
XFILLER_296_42 VPWR VGND sg13cmos5l_decap_8
XFILLER_130_7 VPWR VGND sg13cmos5l_decap_8
XFILLER_527_151 VPWR VGND sg13cmos5l_fill_2
XFILLER_228_7 VPWR VGND sg13cmos5l_decap_8
XFILLER_149_69 VPWR VGND sg13cmos5l_decap_8
XANTENNA__2799__X Tile_X0Y3_E6BEG[9] VPWR VGND sg13cmos5l_antennanp
XFILLER_152_116 VPWR VGND sg13cmos5l_decap_8
XFILLER_597_7 VPWR VGND sg13cmos5l_decap_8
XFILLER_58_22 VPWR VGND sg13cmos5l_decap_8
XFILLER_462_77 VPWR VGND sg13cmos5l_fill_1
XFILLER_612_14 VPWR VGND sg13cmos5l_decap_8
XFILLER_462_99 VPWR VGND sg13cmos5l_decap_8
XANTENNA__3423__X Tile_X0Y4_FrameData_O[14] VPWR VGND sg13cmos5l_antennanp
XFILLER_181_78 VPWR VGND sg13cmos5l_decap_8
XFILLER_74_122 VPWR VGND sg13cmos5l_decap_8
XFILLER_74_21 VPWR VGND sg13cmos5l_decap_8
XFILLER_114_72 VPWR VGND sg13cmos5l_decap_8
XFILLER_74_54 VPWR VGND sg13cmos5l_decap_4
XFILLER_74_65 VPWR VGND sg13cmos5l_decap_8
XFILLER_411_70 VPWR VGND sg13cmos5l_decap_8
XFILLER_254_0 VPWR VGND sg13cmos5l_decap_8
XFILLER_215_183 VPWR VGND sg13cmos5l_fill_2
XFILLER_565_202 VPWR VGND sg13cmos5l_fill_2
XFILLER_230_120 VPWR VGND sg13cmos5l_decap_8
XFILLER_90_42 VPWR VGND sg13cmos5l_decap_8
XFILLER_487_63 VPWR VGND sg13cmos5l_decap_8
XFILLER_421_0 VPWR VGND sg13cmos5l_decap_8
XFILLER_519_0 VPWR VGND sg13cmos5l_decap_8
XFILLER_90_86 VPWR VGND sg13cmos5l_decap_8
XFILLER_230_197 VPWR VGND sg13cmos5l_decap_4
XFILLER_637_77 VPWR VGND sg13cmos5l_decap_8
XFILLER_209_28 VPWR VGND sg13cmos5l_decap_8
XFILLER_356_56 VPWR VGND sg13cmos5l_decap_8
XFILLER_139_91 VPWR VGND sg13cmos5l_decap_8
X_0630_ _0630_/Q Tile_X0Y8_FrameData[9] VGND VPWR Tile_X0Y9_FrameStrobe[6] latch
XFILLER_533_165 VPWR VGND sg13cmos5l_decap_8
XFILLER_332_216 VPWR VGND sg13cmos5l_fill_2
XFILLER_99_73 VPWR VGND sg13cmos5l_decap_8
XFILLER_653_21 VPWR VGND sg13cmos5l_decap_8
X_0561_ _0561_/Q Tile_X0Y8_FrameData[14] VGND VPWR Tile_X0Y9_FrameStrobe[4] latch
X_2300_ _2300_/Q Tile_X0Y5_FrameData[9] VGND VPWR Tile_X0Y9_FrameStrobe[3] latch
XFILLER_297_142 VPWR VGND sg13cmos5l_decap_8
XFILLER_225_27 VPWR VGND sg13cmos5l_decap_8
X_3280_ Tile_X0Y0_E6BEG[0] _3836_/X VPWR VGND sg13cmos5l_buf_1
XFILLER_653_98 VPWR VGND sg13cmos5l_decap_8
X_0492_ _0492_/Q Tile_X0Y8_FrameData[19] VGND VPWR Tile_X0Y9_FrameStrobe[2] latch
X_2231_ _2231_/Q Tile_X0Y5_FrameData[14] VGND VPWR Tile_X0Y9_FrameStrobe[1] latch
XFILLER_522_14 VPWR VGND sg13cmos5l_decap_8
XANTENNA__3333__X Tile_X0Y2_FrameData_O[4] VPWR VGND sg13cmos5l_antennanp
X_2162_ _2162_/Q Tile_X0Y4_FrameData[19] VGND VPWR Tile_X0Y9_FrameStrobe[7] latch
X_1113_ _1113_/Q Tile_X0Y0_FrameData[18] VGND VPWR Tile_X0Y9_FrameStrobe[5] latch
X_2093_ _2093_/Q Tile_X0Y4_FrameData[24] VGND VPWR Tile_X0Y9_FrameStrobe[5] latch
XFILLER_603_114 VPWR VGND sg13cmos5l_fill_1
XFILLER_65_166 VPWR VGND sg13cmos5l_decap_8
XFILLER_603_136 VPWR VGND sg13cmos5l_decap_4
X_1044_ _1044_/Q Tile_X0Y0_FrameData[23] VGND VPWR Tile_X0Y9_FrameStrobe[3] latch
XFILLER_80_125 VPWR VGND sg13cmos5l_fill_2
XFILLER_80_158 VPWR VGND sg13cmos5l_decap_8
XFILLER_0_95 VPWR VGND sg13cmos5l_fill_2
XFILLER_221_142 VPWR VGND sg13cmos5l_decap_8
X_4803_ _4803_/X _4783_/X Tile_X0Y9_N4END[7] _4782_/X _0074_/X _0465_/Q _0464_/Q VPWR
+ VGND sg13cmos5l_mux4_1
XFILLER_397_63 VPWR VGND sg13cmos5l_decap_8
X_2995_ Tile_X0Y5_E1BEG[2] _4370_/X VPWR VGND sg13cmos5l_buf_1
X_4734_ _4734_/X Tile_X0Y8_W2MID[1] AXI_M_SOC_RDATA14 _4787_/X _4786_/X _0579_/Q _0578_/Q
+ VPWR VGND sg13cmos5l_mux4_1
X_1946_ _1946_/Q Tile_X0Y4_FrameData[11] VGND VPWR Tile_X0Y9_FrameStrobe[0] latch
XFILLER_119_135 VPWR VGND sg13cmos5l_fill_1
XFILLER_547_77 VPWR VGND sg13cmos5l_decap_8
XFILLER_119_28 VPWR VGND sg13cmos5l_decap_8
X_1877_ _1877_/Q Tile_X0Y3_FrameData[20] VGND VPWR Tile_X0Y9_FrameStrobe[6] latch
X_4665_ _4665_/X Tile_X0Y8_W1END[2] Tile_X0Y8_W6END[6] _4814_/X _4774_/X _0667_/Q
+ _0666_/Q VPWR VGND sg13cmos5l_mux4_1
XFILLER_547_88 VPWR VGND sg13cmos5l_fill_2
XFILLER_524_143 VPWR VGND sg13cmos5l_decap_8
XFILLER_266_56 VPWR VGND sg13cmos5l_decap_8
XFILLER_134_105 VPWR VGND sg13cmos5l_decap_8
XANTENNA__3508__X Tile_X0Y1_E2BEGb[6] VPWR VGND sg13cmos5l_antennanp
X_0828_ _0828_/Q Tile_X0Y9_FrameData[3] VGND VPWR Tile_X0Y9_FrameStrobe[4] latch
X_3616_ Tile_X0Y9_S2BEGb[2] _4934_/X VPWR VGND sg13cmos5l_buf_1
XFILLER_390_160 VPWR VGND sg13cmos5l_fill_1
X_4596_ _4596_/X Tile_X0Y5_W1END[2] Tile_X0Y5_W2MID[1] Tile_X0Y5_W2END[1] _4429_/X
+ _2383_/Q _2382_/Q VPWR VGND sg13cmos5l_mux4_1
XFILLER_563_21 VPWR VGND sg13cmos5l_decap_8
XFILLER_390_182 VPWR VGND sg13cmos5l_decap_8
X_0759_ _0759_/Q Tile_X0Y9_FrameData[8] VGND VPWR Tile_X0Y9_FrameStrobe[2] latch
X_3547_ Tile_X0Y9_E6BEG[5] _4885_/X VPWR VGND sg13cmos5l_buf_1
XFILLER_288_153 VPWR VGND sg13cmos5l_decap_8
X_3478_ Tile_X0Y1_EE4BEG[4] _3952_/X VPWR VGND sg13cmos5l_buf_1
XFILLER_563_98 VPWR VGND sg13cmos5l_decap_8
XFILLER_135_49 VPWR VGND sg13cmos5l_decap_8
XFILLER_713_35 VPWR VGND sg13cmos5l_decap_8
XFILLER_626_217 VPWR VGND sg13cmos5l_fill_1
XFILLER_282_77 VPWR VGND sg13cmos5l_decap_8
X_2429_ _2429_/Q Tile_X0Y5_FrameData[8] VGND VPWR Tile_X0Y9_FrameStrobe[7] latch
XFILLER_693_183 VPWR VGND sg13cmos5l_decap_8
XFILLER_432_14 VPWR VGND sg13cmos5l_decap_8
XANTENNA__3243__X Tile_X0Y0_FrameData_O[11] VPWR VGND sg13cmos5l_antennanp
XFILLER_693_194 VPWR VGND sg13cmos5l_fill_2
XFILLER_28_14 VPWR VGND sg13cmos5l_decap_8
XFILLER_445_150 VPWR VGND sg13cmos5l_decap_8
XFILLER_56_144 VPWR VGND sg13cmos5l_decap_4
XFILLER_445_172 VPWR VGND sg13cmos5l_decap_8
XFILLER_512_91 VPWR VGND sg13cmos5l_decap_8
XFILLER_71_125 VPWR VGND sg13cmos5l_decap_8
XFILLER_44_13 VPWR VGND sg13cmos5l_decap_8
XFILLER_71_169 VPWR VGND sg13cmos5l_decap_8
XFILLER_345_7 VPWR VGND sg13cmos5l_decap_8
XFILLER_44_57 VPWR VGND sg13cmos5l_decap_8
XFILLER_602_191 VPWR VGND sg13cmos5l_decap_8
XFILLER_588_95 VPWR VGND sg13cmos5l_fill_1
XFILLER_12_214 VPWR VGND sg13cmos5l_decap_4
XFILLER_212_153 VPWR VGND sg13cmos5l_decap_8
XFILLER_100_41 VPWR VGND sg13cmos5l_decap_8
XFILLER_358_168 VPWR VGND sg13cmos5l_decap_8
XFILLER_512_7 VPWR VGND sg13cmos5l_decap_8
XFILLER_373_116 VPWR VGND sg13cmos5l_fill_2
XFILLER_60_56 VPWR VGND sg13cmos5l_decap_8
XFILLER_366_190 VPWR VGND sg13cmos5l_decap_8
XFILLER_607_14 VPWR VGND sg13cmos5l_decap_8
XFILLER_457_88 VPWR VGND sg13cmos5l_decap_8
XANTENNA__3418__X Tile_X0Y4_FrameData_O[9] VPWR VGND sg13cmos5l_antennanp
XFILLER_125_105 VPWR VGND sg13cmos5l_decap_8
XFILLER_114_2 VPWR VGND sg13cmos5l_fill_1
XFILLER_381_171 VPWR VGND sg13cmos5l_decap_8
XFILLER_473_21 VPWR VGND sg13cmos5l_decap_8
XFILLER_109_61 VPWR VGND sg13cmos5l_decap_8
XFILLER_69_32 VPWR VGND sg13cmos5l_decap_8
XFILLER_140_119 VPWR VGND sg13cmos5l_decap_8
XFILLER_530_179 VPWR VGND sg13cmos5l_fill_1
XFILLER_279_153 VPWR VGND sg13cmos5l_decap_4
XFILLER_623_35 VPWR VGND sg13cmos5l_decap_8
XFILLER_192_77 VPWR VGND sg13cmos5l_decap_8
XFILLER_342_14 VPWR VGND sg13cmos5l_decap_8
XFILLER_294_145 VPWR VGND sg13cmos5l_decap_8
XANTENNA__3153__X Tile_X0Y7_FrameData_O[23] VPWR VGND sg13cmos5l_antennanp
XFILLER_85_42 VPWR VGND sg13cmos5l_decap_8
XFILLER_699_28 VPWR VGND sg13cmos5l_decap_8
XFILLER_371_0 VPWR VGND sg13cmos5l_decap_8
XFILLER_469_0 VPWR VGND sg13cmos5l_decap_8
XANTENNA__2992__X Tile_X0Y8_UserCLKo VPWR VGND sg13cmos5l_antennanp
XFILLER_47_177 VPWR VGND sg13cmos5l_decap_8
XFILLER_422_91 VPWR VGND sg13cmos5l_decap_8
XFILLER_62_114 VPWR VGND sg13cmos5l_decap_8
XFILLER_597_157 VPWR VGND sg13cmos5l_decap_8
XFILLER_250_215 VPWR VGND sg13cmos5l_fill_2
XFILLER_636_0 VPWR VGND sg13cmos5l_decap_8
XFILLER_141_81 VPWR VGND sg13cmos5l_decap_8
XFILLER_597_179 VPWR VGND sg13cmos5l_decap_4
XFILLER_498_84 VPWR VGND sg13cmos5l_decap_8
XFILLER_648_21 VPWR VGND sg13cmos5l_decap_8
XFILLER_93_7 VPWR VGND sg13cmos5l_decap_8
XFILLER_148_208 VPWR VGND sg13cmos5l_fill_1
X_1800_ _1800_/Q Tile_X0Y3_FrameData[1] VGND VPWR Tile_X0Y9_FrameStrobe[3] latch
X_2780_ Tile_X0Y3_EE4BEG[6] _4170_/X VPWR VGND sg13cmos5l_buf_1
XFILLER_648_98 VPWR VGND sg13cmos5l_decap_8
XFILLER_364_138 VPWR VGND sg13cmos5l_decap_8
X_1731_ _1731_/Q Tile_X0Y3_FrameData[6] VGND VPWR Tile_X0Y9_FrameStrobe[1] latch
XFILLER_517_14 VPWR VGND sg13cmos5l_decap_8
XFILLER_367_99 VPWR VGND sg13cmos5l_decap_8
XANTENNA__3328__X Tile_X0Y2_UserCLKo VPWR VGND sg13cmos5l_antennanp
XFILLER_664_42 VPWR VGND sg13cmos5l_decap_8
X_1662_ _1662_/Q Tile_X0Y2_FrameData[19] VGND VPWR Tile_X0Y9_FrameStrobe[7] latch
X_4450_ _4450_/X _4923_/X _4927_/X _4931_/X _4907_/X _0894_/Q _0893_/Q VPWR VGND sg13cmos5l_mux4_1
XFILLER_383_21 VPWR VGND sg13cmos5l_decap_8
X_0613_ _0613_/Q Tile_X0Y8_FrameData[26] VGND VPWR Tile_X0Y9_FrameStrobe[6] latch
X_3401_ Tile_X0Y2_E2BEG[4] _4044_/X VPWR VGND sg13cmos5l_buf_1
X_4381_ _4381_/X Tile_X0Y5_W2END[6] AXI_M_SOC_RRESP0 _4430_/X _4429_/X _2341_/Q _2340_/Q
+ VPWR VGND sg13cmos5l_mux4_1
X_1593_ _1593_/Q Tile_X0Y2_FrameData[24] VGND VPWR Tile_X0Y9_FrameStrobe[5] latch
XFILLER_131_108 VPWR VGND sg13cmos5l_decap_8
X_3332_ Tile_X0Y2_FrameData_O[3] Tile_X0Y2_FrameData[3] VPWR VGND sg13cmos5l_buf_1
XFILLER_383_87 VPWR VGND sg13cmos5l_fill_1
X_0544_ _0544_/Q Tile_X0Y8_FrameData[31] VGND VPWR Tile_X0Y9_FrameStrobe[4] latch
XFILLER_675_150 VPWR VGND sg13cmos5l_fill_2
XFILLER_533_35 VPWR VGND sg13cmos5l_decap_8
XFILLER_285_112 VPWR VGND sg13cmos5l_decap_4
XFILLER_608_217 VPWR VGND sg13cmos5l_fill_1
X_3263_ Tile_X0Y0_FrameData_O[31] Tile_X0Y0_FrameData[31] VPWR VGND sg13cmos5l_buf_1
XFILLER_680_63 VPWR VGND sg13cmos5l_decap_8
XFILLER_252_14 VPWR VGND sg13cmos5l_decap_8
X_0475_ _0475_/Q Tile_X0Y8_FrameData[4] VGND VPWR Tile_X0Y9_FrameStrobe[1] latch
XFILLER_675_183 VPWR VGND sg13cmos5l_fill_1
XFILLER_285_145 VPWR VGND sg13cmos5l_decap_8
XANTENNA__3063__X Tile_X0Y5_FrameData_O[22] VPWR VGND sg13cmos5l_antennanp
X_2214_ _2214_/Q Tile_X0Y5_FrameData[31] VGND VPWR Tile_X0Y9_FrameStrobe[1] latch
XFILLER_252_58 VPWR VGND sg13cmos5l_decap_8
X_3194_ Tile_X0Y0_N2BEGb[2] _3893_/X VPWR VGND sg13cmos5l_buf_1
XFILLER_15_0 VPWR VGND sg13cmos5l_decap_8
XFILLER_427_161 VPWR VGND sg13cmos5l_decap_8
X_2145_ _2145_/Q Tile_X0Y4_FrameData[4] VGND VPWR Tile_X0Y9_FrameStrobe[6] latch
XFILLER_402_28 VPWR VGND sg13cmos5l_decap_8
XFILLER_38_166 VPWR VGND sg13cmos5l_fill_1
X_2076_ _2076_/Q Tile_X0Y4_FrameData[9] VGND VPWR Tile_X0Y9_FrameStrobe[4] latch
XFILLER_241_204 VPWR VGND sg13cmos5l_fill_1
X_1027_ _1027_/Q Tile_X0Y0_FrameData[8] VGND VPWR Tile_X0Y9_FrameStrobe[2] latch
XFILLER_558_21 VPWR VGND sg13cmos5l_decap_8
XFILLER_201_84 VPWR VGND sg13cmos5l_decap_8
XFILLER_14_49 VPWR VGND sg13cmos5l_decap_8
XFILLER_355_105 VPWR VGND sg13cmos5l_decap_8
XFILLER_708_35 VPWR VGND sg13cmos5l_decap_8
X_2978_ Tile_X0Y8_FrameData_O[18] Tile_X0Y8_FrameData[18] VPWR VGND sg13cmos5l_buf_1
XFILLER_348_190 VPWR VGND sg13cmos5l_fill_1
XFILLER_277_77 VPWR VGND sg13cmos5l_decap_8
X_4717_ _4717_/X _4804_/X _4808_/X _4812_/X _4790_/X _0611_/Q _0610_/Q VPWR VGND sg13cmos5l_mux4_1
X_1929_ _1929_/Q Tile_X0Y4_FrameData[28] VGND VPWR Tile_X0Y9_FrameStrobe[0] latch
XFILLER_427_14 VPWR VGND sg13cmos5l_decap_8
XANTENNA__3238__X Tile_X0Y0_FrameData_O[6] VPWR VGND sg13cmos5l_antennanp
XFILLER_574_42 VPWR VGND sg13cmos5l_decap_8
X_4648_ _4648_/X AXI_M_SOC_RDATA16 _4691_/X _4695_/X _4669_/X _0263_/Q _0262_/Q VPWR
+ VGND sg13cmos5l_mux4_1
XFILLER_293_21 VPWR VGND sg13cmos5l_decap_8
XFILLER_512_146 VPWR VGND sg13cmos5l_decap_8
X_4579_ _4579_/X _4551_/X Tile_X0Y9_N4END[15] _4550_/X _0150_/X _2473_/Q _2472_/Q
+ VPWR VGND sg13cmos5l_mux4_1
XFILLER_507_91 VPWR VGND sg13cmos5l_decap_8
XFILLER_443_35 VPWR VGND sg13cmos5l_decap_8
XFILLER_276_112 VPWR VGND sg13cmos5l_fill_2
XFILLER_162_14 VPWR VGND sg13cmos5l_decap_8
XFILLER_39_46 VPWR VGND sg13cmos5l_decap_8
XFILLER_295_7 VPWR VGND sg13cmos5l_decap_8
XFILLER_130_196 VPWR VGND sg13cmos5l_decap_8
XFILLER_29_122 VPWR VGND sg13cmos5l_decap_8
XFILLER_276_189 VPWR VGND sg13cmos5l_fill_1
XFILLER_312_28 VPWR VGND sg13cmos5l_decap_4
XFILLER_462_7 VPWR VGND sg13cmos5l_decap_8
XFILLER_55_34 VPWR VGND sg13cmos5l_decap_8
XANTENNA__3701__X AXI_M_SOC_WDATA11 VPWR VGND sg13cmos5l_antennanp
XFILLER_433_142 VPWR VGND sg13cmos5l_fill_2
XFILLER_55_67 VPWR VGND sg13cmos5l_decap_8
XFILLER_599_94 VPWR VGND sg13cmos5l_decap_8
XFILLER_378_208 VPWR VGND sg13cmos5l_fill_2
XFILLER_232_215 VPWR VGND sg13cmos5l_fill_2
XFILLER_189_119 VPWR VGND sg13cmos5l_decap_8
XFILLER_44_169 VPWR VGND sg13cmos5l_fill_2
XFILLER_111_40 VPWR VGND sg13cmos5l_decap_8
XFILLER_468_21 VPWR VGND sg13cmos5l_decap_8
XFILLER_468_65 VPWR VGND sg13cmos5l_fill_1
XFILLER_200_112 VPWR VGND sg13cmos5l_decap_8
XFILLER_71_55 VPWR VGND sg13cmos5l_decap_8
XFILLER_346_105 VPWR VGND sg13cmos5l_decap_8
XFILLER_535_205 VPWR VGND sg13cmos5l_fill_2
XFILLER_468_87 VPWR VGND sg13cmos5l_decap_8
XFILLER_618_35 VPWR VGND sg13cmos5l_decap_8
XFILLER_339_190 VPWR VGND sg13cmos5l_decap_8
XFILLER_337_14 VPWR VGND sg13cmos5l_decap_8
XFILLER_187_88 VPWR VGND sg13cmos5l_decap_8
XANTENNA__3148__X Tile_X0Y7_FrameData_O[18] VPWR VGND sg13cmos5l_antennanp
XFILLER_484_42 VPWR VGND sg13cmos5l_decap_8
XFILLER_217_0 VPWR VGND sg13cmos5l_fill_2
XANTENNA__2987__X Tile_X0Y8_FrameData_O[27] VPWR VGND sg13cmos5l_antennanp
XFILLER_634_56 VPWR VGND sg13cmos5l_decap_8
XFILLER_503_168 VPWR VGND sg13cmos5l_decap_8
XFILLER_417_91 VPWR VGND sg13cmos5l_decap_8
XFILLER_20_92 VPWR VGND sg13cmos5l_decap_8
XFILLER_353_35 VPWR VGND sg13cmos5l_decap_8
XFILLER_136_70 VPWR VGND sg13cmos5l_decap_8
XFILLER_96_30 VPWR VGND sg13cmos5l_fill_1
XFILLER_586_0 VPWR VGND sg13cmos5l_decap_8
XFILLER_96_52 VPWR VGND sg13cmos5l_decap_8
XFILLER_121_141 VPWR VGND sg13cmos5l_decap_8
XFILLER_267_134 VPWR VGND sg13cmos5l_decap_4
XFILLER_267_145 VPWR VGND sg13cmos5l_decap_4
XFILLER_267_156 VPWR VGND sg13cmos5l_decap_8
XFILLER_96_96 VPWR VGND sg13cmos5l_decap_8
X_0260_ _0260_/Q Tile_X0Y7_FrameData[27] VGND VPWR Tile_X0Y9_FrameStrobe[3] latch
XFILLER_267_178 VPWR VGND sg13cmos5l_decap_8
XFILLER_503_49 VPWR VGND sg13cmos5l_decap_8
XFILLER_409_150 VPWR VGND sg13cmos5l_decap_8
XFILLER_672_175 VPWR VGND sg13cmos5l_decap_8
XFILLER_282_126 VPWR VGND sg13cmos5l_decap_8
XFILLER_650_77 VPWR VGND sg13cmos5l_decap_8
XFILLER_222_28 VPWR VGND sg13cmos5l_decap_8
X_0191_ _0191_/Q Tile_X0Y7_FrameData[0] VGND VPWR Tile_X0Y9_FrameStrobe[0] latch
XANTENNA__3611__X Tile_X0Y9_S2BEG[5] VPWR VGND sg13cmos5l_antennanp
XFILLER_369_208 VPWR VGND sg13cmos5l_decap_8
XFILLER_659_42 VPWR VGND sg13cmos5l_decap_8
X_3950_ _3950_/X Tile_X0Y1_WW4END[13] AXI_M_SOC_ARREADY _4002_/X _3992_/X _1309_/Q
+ _1308_/Q VPWR VGND sg13cmos5l_mux4_1
XFILLER_302_94 VPWR VGND sg13cmos5l_decap_8
XFILLER_378_21 VPWR VGND sg13cmos5l_decap_8
X_2901_ Tile_X0Y6_FrameData_O[22] Tile_X0Y6_FrameData[22] VPWR VGND sg13cmos5l_buf_1
XFILLER_188_141 VPWR VGND sg13cmos5l_fill_2
X_3881_ _3881_/X _3848_/X _0067_/X Tile_X0Y0_S1END[0] Tile_X0Y0_S4END[0] _0995_/Q
+ _0994_/Q VPWR VGND sg13cmos5l_mux4_1
X_2832_ Tile_X0Y6_E1BEG[1] _4493_/X VPWR VGND sg13cmos5l_buf_1
XFILLER_528_35 VPWR VGND sg13cmos5l_decap_8
XFILLER_528_46 VPWR VGND sg13cmos5l_fill_2
XFILLER_77_2 VPWR VGND sg13cmos5l_fill_1
XFILLER_675_63 VPWR VGND sg13cmos5l_decap_8
XFILLER_247_14 VPWR VGND sg13cmos5l_decap_8
X_2763_ Tile_X0Y3_FrameData_O[21] Tile_X0Y3_FrameData[21] VPWR VGND sg13cmos5l_buf_1
XANTENNA__3058__X Tile_X0Y5_FrameData_O[17] VPWR VGND sg13cmos5l_antennanp
XFILLER_394_42 VPWR VGND sg13cmos5l_decap_8
XFILLER_352_119 VPWR VGND sg13cmos5l_decap_8
X_4502_ _4502_/X Tile_X0Y6_W2MID[1] AXI_M_SOC_RDATA30 _4555_/X _4554_/X _2603_/Q _2602_/Q
+ VPWR VGND sg13cmos5l_mux4_1
X_1714_ _1714_/Q Tile_X0Y3_FrameData[23] VGND VPWR Tile_X0Y9_FrameStrobe[1] latch
XFILLER_394_53 VPWR VGND sg13cmos5l_fill_1
XFILLER_144_211 VPWR VGND sg13cmos5l_decap_8
X_2694_ _2694_/Q Tile_X0Y6_FrameData[1] VGND VPWR Tile_X0Y9_FrameStrobe[7] latch
X_1645_ _1645_/Q Tile_X0Y2_FrameData[4] VGND VPWR Tile_X0Y9_FrameStrobe[6] latch
X_4433_ _4433_/X _4361_/X _4477_/X _4476_/X _4360_/X _2197_/Q _2196_/Q VPWR VGND sg13cmos5l_mux4_1
XANTENNA__2897__X Tile_X0Y6_FrameData_O[18] VPWR VGND sg13cmos5l_antennanp
XFILLER_544_56 VPWR VGND sg13cmos5l_decap_4
XFILLER_327_91 VPWR VGND sg13cmos5l_decap_8
X_1576_ _1576_/Q Tile_X0Y2_FrameData[9] VGND VPWR Tile_X0Y9_FrameStrobe[4] latch
X_4364_ _4364_/X Tile_X0Y3_W1END[2] Tile_X0Y3_W2MID[1] Tile_X0Y3_W2END[1] _4206_/X
+ _1869_/Q _1868_/Q VPWR VGND sg13cmos5l_mux4_1
XFILLER_691_84 VPWR VGND sg13cmos5l_decap_8
XFILLER_263_35 VPWR VGND sg13cmos5l_decap_8
XFILLER_258_101 VPWR VGND sg13cmos5l_decap_8
XFILLER_648_161 VPWR VGND sg13cmos5l_decap_8
X_0527_ _0527_/Q Tile_X0Y8_FrameData[16] VGND VPWR Tile_X0Y9_FrameStrobe[3] latch
X_3315_ Tile_X0Y4_EE4BEG[3] _4275_/X VPWR VGND sg13cmos5l_buf_1
X_4295_ _4295_/X AXI_M_SOC_BRESP1 _4340_/X _4344_/X _4319_/X _2023_/Q _2022_/Q VPWR
+ VGND sg13cmos5l_mux4_1
X_3246_ Tile_X0Y0_FrameData_O[14] Tile_X0Y0_FrameData[14] VPWR VGND sg13cmos5l_buf_1
X_0458_ _0458_/Q Tile_X0Y8_FrameData[21] VGND VPWR Tile_X0Y9_FrameStrobe[1] latch
XFILLER_413_49 VPWR VGND sg13cmos5l_decap_8
XFILLER_560_77 VPWR VGND sg13cmos5l_decap_8
XFILLER_73_209 VPWR VGND sg13cmos5l_decap_8
XFILLER_132_28 VPWR VGND sg13cmos5l_decap_8
XFILLER_710_14 VPWR VGND sg13cmos5l_decap_8
X_3177_ Tile_X0Y0_N4BEG[1] _3177_/A VPWR VGND sg13cmos5l_buf_1
X_0389_ _0389_/Q Tile_X0Y7_FrameData[26] VGND VPWR Tile_X0Y9_FrameStrobe[7] latch
XANTENNA__3521__X Tile_X0Y1_E1BEG[3] VPWR VGND sg13cmos5l_antennanp
XFILLER_415_142 VPWR VGND sg13cmos5l_decap_8
X_2128_ _2128_/Q Tile_X0Y4_FrameData[21] VGND VPWR Tile_X0Y9_FrameStrobe[6] latch
XFILLER_214_204 VPWR VGND sg13cmos5l_fill_1
XFILLER_214_215 VPWR VGND sg13cmos5l_fill_2
XFILLER_430_112 VPWR VGND sg13cmos5l_decap_8
XFILLER_576_105 VPWR VGND sg13cmos5l_decap_8
XFILLER_569_42 VPWR VGND sg13cmos5l_decap_8
X_2059_ _2059_/Q Tile_X0Y4_FrameData[26] VGND VPWR Tile_X0Y9_FrameStrobe[4] latch
XFILLER_212_83 VPWR VGND sg13cmos5l_decap_8
XFILLER_41_117 VPWR VGND sg13cmos5l_decap_4
XFILLER_288_21 VPWR VGND sg13cmos5l_decap_8
XFILLER_430_178 VPWR VGND sg13cmos5l_decap_4
XFILLER_288_98 VPWR VGND sg13cmos5l_decap_4
XFILLER_438_35 VPWR VGND sg13cmos5l_decap_8
XFILLER_41_14 VPWR VGND sg13cmos5l_fill_1
XFILLER_585_63 VPWR VGND sg13cmos5l_decap_4
XFILLER_194_155 VPWR VGND sg13cmos5l_fill_1
XFILLER_585_74 VPWR VGND sg13cmos5l_decap_8
XFILLER_157_14 VPWR VGND sg13cmos5l_decap_4
XFILLER_41_69 VPWR VGND sg13cmos5l_decap_8
XFILLER_157_47 VPWR VGND sg13cmos5l_decap_8
XFILLER_157_69 VPWR VGND sg13cmos5l_decap_4
XFILLER_497_112 VPWR VGND sg13cmos5l_decap_8
XFILLER_307_28 VPWR VGND sg13cmos5l_decap_4
XFILLER_351_152 VPWR VGND sg13cmos5l_decap_8
XFILLER_1_202 VPWR VGND sg13cmos5l_decap_8
XFILLER_500_105 VPWR VGND sg13cmos5l_decap_8
XFILLER_173_13 VPWR VGND sg13cmos5l_decap_8
XFILLER_497_189 VPWR VGND sg13cmos5l_decap_8
XFILLER_639_161 VPWR VGND sg13cmos5l_decap_8
XFILLER_249_134 VPWR VGND sg13cmos5l_fill_1
XFILLER_677_7 VPWR VGND sg13cmos5l_decap_8
XFILLER_654_131 VPWR VGND sg13cmos5l_fill_1
XFILLER_249_156 VPWR VGND sg13cmos5l_decap_8
XFILLER_453_215 VPWR VGND sg13cmos5l_fill_2
XFILLER_470_77 VPWR VGND sg13cmos5l_fill_2
XFILLER_264_137 VPWR VGND sg13cmos5l_fill_2
XFILLER_620_14 VPWR VGND sg13cmos5l_decap_8
XFILLER_66_77 VPWR VGND sg13cmos5l_decap_8
XFILLER_406_120 VPWR VGND sg13cmos5l_decap_4
XFILLER_279_2 VPWR VGND sg13cmos5l_fill_1
XFILLER_406_131 VPWR VGND sg13cmos5l_decap_4
XANTENNA__3431__X Tile_X0Y4_FrameData_O[22] VPWR VGND sg13cmos5l_antennanp
XFILLER_567_105 VPWR VGND sg13cmos5l_decap_8
XFILLER_479_42 VPWR VGND sg13cmos5l_decap_8
XFILLER_421_112 VPWR VGND sg13cmos5l_decap_8
XFILLER_167_0 VPWR VGND sg13cmos5l_decap_8
XFILLER_122_72 VPWR VGND sg13cmos5l_decap_8
XFILLER_32_117 VPWR VGND sg13cmos5l_decap_8
XFILLER_700_91 VPWR VGND sg13cmos5l_decap_8
XFILLER_421_156 VPWR VGND sg13cmos5l_decap_8
XFILLER_198_21 VPWR VGND sg13cmos5l_decap_8
XFILLER_82_76 VPWR VGND sg13cmos5l_decap_4
XFILLER_421_189 VPWR VGND sg13cmos5l_fill_1
XFILLER_334_0 VPWR VGND sg13cmos5l_decap_8
XFILLER_709_154 VPWR VGND sg13cmos5l_decap_8
XFILLER_629_56 VPWR VGND sg13cmos5l_decap_8
XFILLER_582_119 VPWR VGND sg13cmos5l_decap_8
XFILLER_508_205 VPWR VGND sg13cmos5l_fill_1
XFILLER_40_150 VPWR VGND sg13cmos5l_decap_8
XFILLER_319_127 VPWR VGND sg13cmos5l_fill_1
XFILLER_198_98 VPWR VGND sg13cmos5l_fill_1
XFILLER_575_182 VPWR VGND sg13cmos5l_decap_8
XFILLER_348_35 VPWR VGND sg13cmos5l_decap_8
XFILLER_185_133 VPWR VGND sg13cmos5l_decap_8
XFILLER_319_149 VPWR VGND sg13cmos5l_decap_8
XFILLER_495_63 VPWR VGND sg13cmos5l_decap_8
XFILLER_501_0 VPWR VGND sg13cmos5l_decap_8
XFILLER_523_208 VPWR VGND sg13cmos5l_fill_2
XFILLER_590_163 VPWR VGND sg13cmos5l_fill_2
XFILLER_334_119 VPWR VGND sg13cmos5l_fill_2
XFILLER_488_112 VPWR VGND sg13cmos5l_fill_2
XFILLER_645_77 VPWR VGND sg13cmos5l_decap_8
XANTENNA__3606__X Tile_X0Y9_S2BEG[0] VPWR VGND sg13cmos5l_antennanp
XFILLER_364_56 VPWR VGND sg13cmos5l_decap_4
X_1430_ _1430_/Q Tile_X0Y2_FrameData[27] VGND VPWR Tile_X0Y9_FrameStrobe[0] latch
XFILLER_49_6 VPWR VGND sg13cmos5l_fill_2
XFILLER_488_178 VPWR VGND sg13cmos5l_fill_2
XFILLER_661_21 VPWR VGND sg13cmos5l_decap_8
X_1361_ _1361_/Q Tile_X0Y1_FrameData[8] VGND VPWR Tile_X0Y9_FrameStrobe[5] latch
X_3100_ Tile_X0Y7_E2BEGb[6] _4626_/X VPWR VGND sg13cmos5l_buf_1
X_0312_ _0312_/Q Tile_X0Y7_FrameData[7] VGND VPWR Tile_X0Y9_FrameStrobe[4] latch
X_4080_ _4080_/X AXI_M_SOC_AWREADY _4119_/X _4123_/X _4102_/X _1513_/Q _1512_/Q VPWR
+ VGND sg13cmos5l_mux4_1
X_1292_ _1292_/Q Tile_X0Y1_FrameData[13] VGND VPWR Tile_X0Y9_FrameStrobe[3] latch
XFILLER_233_49 VPWR VGND sg13cmos5l_fill_2
XFILLER_645_175 VPWR VGND sg13cmos5l_decap_8
X_3031_ Tile_X0Y5_EE4BEG[6] _4394_/X VPWR VGND sg13cmos5l_buf_1
X_0243_ _0243_/Q Tile_X0Y7_FrameData[12] VGND VPWR Tile_X0Y9_FrameStrobe[2] latch
XFILLER_530_14 VPWR VGND sg13cmos5l_decap_8
XANTENNA__3341__X Tile_X0Y2_FrameData_O[12] VPWR VGND sg13cmos5l_antennanp
XFILLER_313_82 VPWR VGND sg13cmos5l_decap_8
X_0174_ _0174_/Q Tile_X0Y7_FrameData[17] VGND VPWR Tile_X0Y9_FrameStrobe[0] latch
XFILLER_270_129 VPWR VGND sg13cmos5l_fill_2
XFILLER_412_112 VPWR VGND sg13cmos5l_decap_8
XFILLER_389_42 VPWR VGND sg13cmos5l_decap_8
XFILLER_263_192 VPWR VGND sg13cmos5l_decap_8
XFILLER_558_127 VPWR VGND sg13cmos5l_decap_4
XFILLER_211_207 VPWR VGND sg13cmos5l_fill_1
X_3933_ _3933_/X Tile_X0Y1_W2MID[6] AXI_M_SOC_ARREADY _3991_/X _3990_/X _1343_/Q _1342_/Q
+ VPWR VGND sg13cmos5l_mux4_1
XFILLER_573_119 VPWR VGND sg13cmos5l_decap_8
X_3864_ _3864_/X _3851_/X _0078_/X Tile_X0Y0_S1END[3] Tile_X0Y0_S4END[3] _0973_/Q
+ _0972_/Q VPWR VGND sg13cmos5l_mux4_1
XFILLER_82_0 VPWR VGND sg13cmos5l_fill_2
XFILLER_31_172 VPWR VGND sg13cmos5l_fill_2
XFILLER_258_35 VPWR VGND sg13cmos5l_decap_8
X_2815_ Tile_X0Y3_E2BEG[5] _4153_/X VPWR VGND sg13cmos5l_buf_1
XFILLER_715_146 VPWR VGND sg13cmos5l_decap_8
XFILLER_581_141 VPWR VGND sg13cmos5l_decap_8
X_3795_ _3795_/X _3886_/X _3872_/X _3871_/X _3855_/X _1150_/Q _1149_/Q VPWR VGND sg13cmos5l_mux4_1
XFILLER_191_125 VPWR VGND sg13cmos5l_decap_8
XFILLER_176_199 VPWR VGND sg13cmos5l_decap_4
X_2746_ Tile_X0Y3_FrameData_O[4] Tile_X0Y3_FrameData[4] VPWR VGND sg13cmos5l_buf_1
XFILLER_408_49 VPWR VGND sg13cmos5l_decap_8
XFILLER_11_28 VPWR VGND sg13cmos5l_decap_8
XFILLER_668_201 VPWR VGND sg13cmos5l_decap_4
XFILLER_555_77 VPWR VGND sg13cmos5l_decap_8
XFILLER_127_28 VPWR VGND sg13cmos5l_decap_8
XFILLER_705_14 VPWR VGND sg13cmos5l_decap_8
X_2677_ _2677_/Q Tile_X0Y6_FrameData[18] VGND VPWR Tile_X0Y9_FrameStrobe[7] latch
XFILLER_274_56 VPWR VGND sg13cmos5l_decap_8
XANTENNA__3516__X Tile_X0Y1_E2BEG[6] VPWR VGND sg13cmos5l_antennanp
XFILLER_479_156 VPWR VGND sg13cmos5l_decap_8
X_4416_ _4416_/X _4418_/X Tile_X0Y5_W6END[0] _4417_/X _4416_/A3 _2189_/Q _2188_/Q
+ VPWR VGND sg13cmos5l_mux4_1
X_1628_ _1628_/Q Tile_X0Y2_FrameData[21] VGND VPWR Tile_X0Y9_FrameStrobe[6] latch
XFILLER_628_109 VPWR VGND sg13cmos5l_fill_1
XFILLER_571_21 VPWR VGND sg13cmos5l_decap_8
XFILLER_494_126 VPWR VGND sg13cmos5l_decap_8
X_4347_ _4347_/X _4311_/X _0040_/X _4310_/X _0109_/X _1959_/Q _1958_/Q VPWR VGND sg13cmos5l_mux4_1
XFILLER_207_83 VPWR VGND sg13cmos5l_decap_8
XFILLER_98_161 VPWR VGND sg13cmos5l_fill_1
X_1559_ _1559_/Q Tile_X0Y2_FrameData[26] VGND VPWR Tile_X0Y9_FrameStrobe[4] latch
XFILLER_571_98 VPWR VGND sg13cmos5l_decap_8
XFILLER_143_49 VPWR VGND sg13cmos5l_decap_8
X_4278_ _4278_/X Tile_X0Y4_WW4END[9] AXI_M_SOC_BRESP0 _4345_/X _4315_/X _2057_/Q _2056_/Q
+ VPWR VGND sg13cmos5l_mux4_1
XFILLER_504_70 VPWR VGND sg13cmos5l_decap_8
XFILLER_290_77 VPWR VGND sg13cmos5l_decap_8
XFILLER_651_112 VPWR VGND sg13cmos5l_decap_8
X_3229_ Tile_X0Y0_FrameStrobe_O[17] Tile_X0Y9_FrameStrobe[17] VPWR VGND sg13cmos5l_buf_1
XFILLER_636_197 VPWR VGND sg13cmos5l_fill_1
XFILLER_440_14 VPWR VGND sg13cmos5l_decap_8
XFILLER_246_148 VPWR VGND sg13cmos5l_decap_8
XANTENNA__3251__X Tile_X0Y0_FrameData_O[19] VPWR VGND sg13cmos5l_antennanp
XFILLER_36_14 VPWR VGND sg13cmos5l_decap_8
XFILLER_651_189 VPWR VGND sg13cmos5l_decap_8
XFILLER_549_105 VPWR VGND sg13cmos5l_fill_1
XFILLER_403_123 VPWR VGND sg13cmos5l_decap_8
XFILLER_299_42 VPWR VGND sg13cmos5l_decap_4
XFILLER_254_192 VPWR VGND sg13cmos5l_decap_4
XFILLER_258_7 VPWR VGND sg13cmos5l_decap_8
XFILLER_14_117 VPWR VGND sg13cmos5l_decap_8
XFILLER_520_91 VPWR VGND sg13cmos5l_decap_8
XFILLER_564_119 VPWR VGND sg13cmos5l_decap_8
XFILLER_425_7 VPWR VGND sg13cmos5l_decap_8
XFILLER_557_182 VPWR VGND sg13cmos5l_fill_2
XFILLER_52_79 VPWR VGND sg13cmos5l_decap_8
XFILLER_167_144 VPWR VGND sg13cmos5l_decap_8
XFILLER_168_68 VPWR VGND sg13cmos5l_decap_8
XFILLER_167_166 VPWR VGND sg13cmos5l_decap_8
XFILLER_572_196 VPWR VGND sg13cmos5l_decap_8
XFILLER_309_182 VPWR VGND sg13cmos5l_decap_8
XFILLER_615_14 VPWR VGND sg13cmos5l_decap_8
XANTENNA__3426__X Tile_X0Y4_FrameData_O[17] VPWR VGND sg13cmos5l_antennanp
XFILLER_324_174 VPWR VGND sg13cmos5l_decap_8
XFILLER_481_21 VPWR VGND sg13cmos5l_decap_8
XFILLER_627_131 VPWR VGND sg13cmos5l_fill_1
XFILLER_77_87 VPWR VGND sg13cmos5l_decap_8
XFILLER_631_35 VPWR VGND sg13cmos5l_decap_8
XFILLER_426_215 VPWR VGND sg13cmos5l_fill_2
XFILLER_414_70 VPWR VGND sg13cmos5l_decap_8
XFILLER_284_0 VPWR VGND sg13cmos5l_decap_8
XFILLER_642_112 VPWR VGND sg13cmos5l_decap_8
XFILLER_493_192 VPWR VGND sg13cmos5l_fill_2
XFILLER_350_14 VPWR VGND sg13cmos5l_decap_8
XANTENNA__3161__X Tile_X0Y7_FrameData_O[31] VPWR VGND sg13cmos5l_antennanp
XFILLER_93_42 VPWR VGND sg13cmos5l_decap_8
XFILLER_133_93 VPWR VGND sg13cmos5l_decap_8
XFILLER_642_189 VPWR VGND sg13cmos5l_decap_8
XFILLER_451_0 VPWR VGND sg13cmos5l_decap_8
XFILLER_549_0 VPWR VGND sg13cmos5l_decap_8
XFILLER_500_28 VPWR VGND sg13cmos5l_decap_8
XFILLER_430_91 VPWR VGND sg13cmos5l_decap_8
XFILLER_716_0 VPWR VGND sg13cmos5l_fill_1
XFILLER_359_56 VPWR VGND sg13cmos5l_decap_8
XFILLER_548_160 VPWR VGND sg13cmos5l_decap_8
X_0930_ _0930_/Q Tile_X0Y9_FrameData[21] VGND VPWR Tile_X0Y9_FrameStrobe[8] latch
XFILLER_158_122 VPWR VGND sg13cmos5l_decap_8
XFILLER_656_21 VPWR VGND sg13cmos5l_decap_8
X_0861_ _0861_/Q Tile_X0Y9_FrameData[2] VGND VPWR Tile_X0Y9_FrameStrobe[5] latch
XFILLER_712_105 VPWR VGND sg13cmos5l_decap_8
X_2600_ _2600_/Q Tile_X0Y6_FrameData[31] VGND VPWR Tile_X0Y9_FrameStrobe[5] latch
X_0792_ _0792_/Q Tile_X0Y9_FrameData[7] VGND VPWR Tile_X0Y9_FrameStrobe[3] latch
X_3580_ Tile_X0Y9_FrameData_O[10] Tile_X0Y9_FrameData[10] VPWR VGND sg13cmos5l_buf_1
XFILLER_656_98 VPWR VGND sg13cmos5l_decap_8
XFILLER_375_55 VPWR VGND sg13cmos5l_fill_1
X_2531_ _2531_/Q Tile_X0Y6_FrameData[4] VGND VPWR Tile_X0Y9_FrameStrobe[2] latch
XFILLER_525_14 VPWR VGND sg13cmos5l_decap_8
XANTENNA__3336__X Tile_X0Y2_FrameData_O[7] VPWR VGND sg13cmos5l_antennanp
XFILLER_672_42 VPWR VGND sg13cmos5l_decap_8
X_2462_ _2462_/Q Tile_X0Y6_FrameData[9] VGND VPWR Tile_X0Y9_FrameStrobe[0] latch
XFILLER_665_204 VPWR VGND sg13cmos5l_fill_2
XFILLER_391_21 VPWR VGND sg13cmos5l_decap_8
XFILLER_87_109 VPWR VGND sg13cmos5l_decap_8
X_4201_ _4201_/X _4197_/X Tile_X0Y3_W6END[1] _4196_/X _4201_/A3 _1679_/Q _1678_/Q
+ VPWR VGND sg13cmos5l_mux4_1
X_1413_ _1413_/Q Tile_X0Y1_FrameData[20] VGND VPWR Tile_X0Y9_FrameStrobe[7] latch
X_2393_ _2393_/Q Tile_X0Y5_FrameData[12] VGND VPWR Tile_X0Y9_FrameStrobe[6] latch
X_1344_ _1344_/Q Tile_X0Y1_FrameData[25] VGND VPWR Tile_X0Y9_FrameStrobe[5] latch
X_4132_ _4132_/X Tile_X0Y1_W2MID[5] Tile_X0Y1_W2END[5] Tile_X0Y1_W6END[10] _3993_/X
+ _1377_/Q _1376_/Q VPWR VGND sg13cmos5l_mux4_1
XFILLER_541_35 VPWR VGND sg13cmos5l_decap_8
XFILLER_541_46 VPWR VGND sg13cmos5l_fill_2
XFILLER_3_84 VPWR VGND sg13cmos5l_decap_8
XFILLER_633_112 VPWR VGND sg13cmos5l_decap_8
XFILLER_28_209 VPWR VGND sg13cmos5l_fill_1
XFILLER_484_192 VPWR VGND sg13cmos5l_fill_1
XFILLER_260_14 VPWR VGND sg13cmos5l_decap_8
X_1275_ _1275_/Q Tile_X0Y1_FrameData[30] VGND VPWR Tile_X0Y9_FrameStrobe[3] latch
X_4063_ _4063_/X Tile_X0Y2_WW4END[8] AXI_M_SOC_AWREADY _4124_/X _4097_/X _1547_/Q
+ _1546_/Q VPWR VGND sg13cmos5l_mux4_1
XANTENNA__3071__X Tile_X0Y5_FrameData_O[30] VPWR VGND sg13cmos5l_antennanp
XFILLER_243_107 VPWR VGND sg13cmos5l_fill_1
X_0226_ _0226_/Q Tile_X0Y7_FrameData[29] VGND VPWR Tile_X0Y9_FrameStrobe[2] latch
X_3014_ Tile_X0Y5_E6BEG[1] _4405_/X VPWR VGND sg13cmos5l_buf_1
XFILLER_633_178 VPWR VGND sg13cmos5l_decap_8
XFILLER_236_170 VPWR VGND sg13cmos5l_decap_8
XFILLER_410_28 VPWR VGND sg13cmos5l_decap_8
X_0157_ _0157_/X _4437_/X _4438_/X _0901_/Q VPWR VGND sg13cmos5l_mux2_1
XFILLER_397_155 VPWR VGND sg13cmos5l_decap_8
X_0088_ _0088_/X _4216_/X _4217_/X _0386_/Q VPWR VGND sg13cmos5l_mux2_1
XFILLER_400_126 VPWR VGND sg13cmos5l_decap_8
XFILLER_269_56 VPWR VGND sg13cmos5l_decap_8
X_3916_ _3916_/X Tile_X0Y2_W1END[1] Tile_X0Y2_WW4END[1] Tile_X0Y2_W6END[9] _4117_/X
+ _1646_/Q _1645_/Q VPWR VGND sg13cmos5l_mux4_1
X_4896_ _4896_/X Tile_X0Y8_W1END[0] Tile_X0Y8_W6END[8] _4812_/X _4772_/X _0635_/Q
+ _0634_/Q VPWR VGND sg13cmos5l_mux4_1
XFILLER_539_182 VPWR VGND sg13cmos5l_decap_8
XFILLER_566_21 VPWR VGND sg13cmos5l_decap_8
XFILLER_149_144 VPWR VGND sg13cmos5l_fill_1
X_3847_ _3847_/X Tile_X0Y0_W2MID[7] _3881_/X _3885_/X _3852_/X _1011_/Q _1010_/Q VPWR
+ VGND sg13cmos5l_mux4_1
XFILLER_22_49 VPWR VGND sg13cmos5l_decap_8
XFILLER_703_105 VPWR VGND sg13cmos5l_decap_8
XFILLER_566_98 VPWR VGND sg13cmos5l_decap_8
X_3778_ AXI_M_SOC_ARVALID Tile_X0Y1_WW4END[0] Tile_X0Y1_WW4END[8] Tile_X0Y1_W6END[0]
+ _4008_/X _1257_/Q _1256_/Q VPWR VGND sg13cmos5l_mux4_1
XFILLER_138_49 VPWR VGND sg13cmos5l_decap_8
XFILLER_716_57 VPWR VGND sg13cmos5l_decap_8
XFILLER_285_77 VPWR VGND sg13cmos5l_decap_8
X_2729_ _3861_/A3 VPWR VGND sg13cmos5l_tielo
XFILLER_435_14 VPWR VGND sg13cmos5l_decap_8
XANTENNA__3246__X Tile_X0Y0_FrameData_O[14] VPWR VGND sg13cmos5l_antennanp
XFILLER_582_42 VPWR VGND sg13cmos5l_decap_8
XFILLER_306_185 VPWR VGND sg13cmos5l_decap_8
XFILLER_510_211 VPWR VGND sg13cmos5l_decap_8
XFILLER_306_196 VPWR VGND sg13cmos5l_fill_2
XFILLER_711_182 VPWR VGND sg13cmos5l_decap_8
XFILLER_656_215 VPWR VGND sg13cmos5l_fill_2
XFILLER_321_133 VPWR VGND sg13cmos5l_decap_8
XFILLER_467_137 VPWR VGND sg13cmos5l_decap_4
XFILLER_321_166 VPWR VGND sg13cmos5l_decap_8
XFILLER_120_206 VPWR VGND sg13cmos5l_fill_1
XFILLER_120_217 VPWR VGND sg13cmos5l_fill_1
XFILLER_482_107 VPWR VGND sg13cmos5l_decap_4
XFILLER_47_13 VPWR VGND sg13cmos5l_decap_8
XFILLER_451_35 VPWR VGND sg13cmos5l_decap_8
XFILLER_408_215 VPWR VGND sg13cmos5l_fill_2
XFILLER_375_7 VPWR VGND sg13cmos5l_decap_8
XFILLER_490_162 VPWR VGND sg13cmos5l_decap_8
XFILLER_601_49 VPWR VGND sg13cmos5l_decap_4
XFILLER_490_173 VPWR VGND sg13cmos5l_fill_1
XFILLER_227_192 VPWR VGND sg13cmos5l_decap_8
XFILLER_542_7 VPWR VGND sg13cmos5l_decap_8
XFILLER_320_28 VPWR VGND sg13cmos5l_decap_8
XFILLER_103_63 VPWR VGND sg13cmos5l_decap_8
XFILLER_63_45 VPWR VGND sg13cmos5l_fill_2
XFILLER_242_162 VPWR VGND sg13cmos5l_decap_8
XFILLER_63_67 VPWR VGND sg13cmos5l_decap_8
XFILLER_592_203 VPWR VGND sg13cmos5l_fill_1
XFILLER_400_83 VPWR VGND sg13cmos5l_fill_1
XFILLER_144_2 VPWR VGND sg13cmos5l_fill_1
XFILLER_476_21 VPWR VGND sg13cmos5l_decap_8
XFILLER_545_130 VPWR VGND sg13cmos5l_decap_8
XFILLER_10_142 VPWR VGND sg13cmos5l_decap_8
XFILLER_626_35 VPWR VGND sg13cmos5l_decap_8
XFILLER_409_70 VPWR VGND sg13cmos5l_decap_8
XFILLER_155_169 VPWR VGND sg13cmos5l_fill_2
XFILLER_195_77 VPWR VGND sg13cmos5l_fill_2
XFILLER_345_14 VPWR VGND sg13cmos5l_decap_8
XFILLER_560_166 VPWR VGND sg13cmos5l_fill_2
XANTENNA__3156__X Tile_X0Y7_FrameData_O[26] VPWR VGND sg13cmos5l_antennanp
XFILLER_492_42 VPWR VGND sg13cmos5l_decap_8
XFILLER_128_82 VPWR VGND sg13cmos5l_decap_8
XFILLER_88_75 VPWR VGND sg13cmos5l_decap_8
XFILLER_69_109 VPWR VGND sg13cmos5l_decap_8
XFILLER_499_0 VPWR VGND sg13cmos5l_decap_8
XANTENNA__2995__X Tile_X0Y5_E1BEG[2] VPWR VGND sg13cmos5l_antennanp
XFILLER_458_159 VPWR VGND sg13cmos5l_decap_8
XFILLER_642_56 VPWR VGND sg13cmos5l_decap_8
XFILLER_425_91 VPWR VGND sg13cmos5l_decap_8
XFILLER_361_35 VPWR VGND sg13cmos5l_decap_8
XFILLER_666_0 VPWR VGND sg13cmos5l_decap_8
XFILLER_19_7 VPWR VGND sg13cmos5l_decap_8
XFILLER_77_197 VPWR VGND sg13cmos5l_decap_4
XFILLER_92_134 VPWR VGND sg13cmos5l_decap_8
X_1060_ _1060_/Q Tile_X0Y0_FrameData[7] VGND VPWR Tile_X0Y9_FrameStrobe[3] latch
XFILLER_511_49 VPWR VGND sg13cmos5l_decap_8
XFILLER_630_126 VPWR VGND sg13cmos5l_decap_4
XFILLER_230_28 VPWR VGND sg13cmos5l_decap_8
XFILLER_92_189 VPWR VGND sg13cmos5l_fill_2
XFILLER_568_211 VPWR VGND sg13cmos5l_fill_1
XFILLER_233_162 VPWR VGND sg13cmos5l_decap_8
XFILLER_583_203 VPWR VGND sg13cmos5l_decap_8
XFILLER_717_208 VPWR VGND sg13cmos5l_fill_1
X_4750_ _4750_/X Tile_X0Y8_WW4END[9] AXI_M_SOC_RDATA14 _4809_/X _4787_/X _0547_/Q
+ _0546_/Q VPWR VGND sg13cmos5l_mux4_1
X_1962_ _1962_/Q Tile_X0Y4_FrameData[27] VGND VPWR Tile_X0Y9_FrameStrobe[1] latch
XFILLER_386_21 VPWR VGND sg13cmos5l_decap_8
X_3701_ AXI_M_SOC_WDATA11 Tile_X0Y7_WW4END[3] Tile_X0Y7_WW4END[11] Tile_X0Y7_W6END[11]
+ _4695_/X _0225_/Q _0224_/Q VPWR VGND sg13cmos5l_mux4_1
X_0913_ _0913_/Q Tile_X0Y9_FrameData[14] VGND VPWR Tile_X0Y9_FrameStrobe[7] latch
X_4681_ _4681_/X _4228_/X _4232_/X _4215_/X _4206_/X _1859_/Q _1858_/Q VPWR VGND sg13cmos5l_mux4_1
X_1893_ _1893_/Q Tile_X0Y3_FrameData[4] VGND VPWR Tile_X0Y9_FrameStrobe[6] latch
X_3632_ Tile_X0Y9_S4BEG[10] _3632_/A VPWR VGND sg13cmos5l_buf_1
X_0844_ _0844_/Q Tile_X0Y9_FrameData[19] VGND VPWR Tile_X0Y9_FrameStrobe[5] latch
XFILLER_536_35 VPWR VGND sg13cmos5l_decap_8
XFILLER_551_133 VPWR VGND sg13cmos5l_decap_4
XFILLER_146_158 VPWR VGND sg13cmos5l_decap_8
XFILLER_683_63 VPWR VGND sg13cmos5l_fill_2
X_3563_ Tile_X0Y9_EE4BEG[9] _4873_/X VPWR VGND sg13cmos5l_buf_1
XFILLER_551_166 VPWR VGND sg13cmos5l_fill_2
XFILLER_255_14 VPWR VGND sg13cmos5l_decap_8
X_0775_ _0775_/Q Tile_X0Y9_FrameData[24] VGND VPWR Tile_X0Y9_FrameStrobe[3] latch
XANTENNA__3066__X Tile_X0Y5_FrameData_O[25] VPWR VGND sg13cmos5l_antennanp
X_2514_ _2514_/Q Tile_X0Y6_FrameData[21] VGND VPWR Tile_X0Y9_FrameStrobe[2] latch
XFILLER_255_58 VPWR VGND sg13cmos5l_decap_8
XFILLER_154_180 VPWR VGND sg13cmos5l_decap_8
X_3494_ Tile_X0Y1_E6BEG[4] _3968_/X VPWR VGND sg13cmos5l_buf_1
XFILLER_45_0 VPWR VGND sg13cmos5l_fill_2
XFILLER_303_144 VPWR VGND sg13cmos5l_decap_8
X_2445_ _2445_/Q Tile_X0Y6_FrameData[26] VGND VPWR Tile_X0Y9_FrameStrobe[0] latch
XFILLER_405_28 VPWR VGND sg13cmos5l_decap_8
XFILLER_102_217 VPWR VGND sg13cmos5l_fill_1
XFILLER_552_56 VPWR VGND sg13cmos5l_decap_8
XFILLER_68_120 VPWR VGND sg13cmos5l_decap_8
XFILLER_464_118 VPWR VGND sg13cmos5l_fill_1
X_2376_ _2376_/Q Tile_X0Y5_FrameData[29] VGND VPWR Tile_X0Y9_FrameStrobe[6] latch
XFILLER_464_129 VPWR VGND sg13cmos5l_decap_8
XFILLER_271_35 VPWR VGND sg13cmos5l_decap_8
X_4115_ _4115_/X _4575_/X _4579_/X _4583_/X _4559_/X _2662_/Q _2661_/Q VPWR VGND sg13cmos5l_mux4_1
X_1327_ _1327_/Q Tile_X0Y1_FrameData[10] VGND VPWR Tile_X0Y9_FrameStrobe[4] latch
XFILLER_68_197 VPWR VGND sg13cmos5l_decap_8
XFILLER_83_145 VPWR VGND sg13cmos5l_fill_1
X_1258_ _1258_/Q Tile_X0Y1_FrameData[15] VGND VPWR Tile_X0Y9_FrameStrobe[2] latch
X_4046_ _4046_/X Tile_X0Y2_W2MID[1] AXI_M_SOC_AWREADY _4099_/X _4098_/X _1581_/Q _1580_/Q
+ VPWR VGND sg13cmos5l_mux4_1
XFILLER_421_49 VPWR VGND sg13cmos5l_decap_8
XFILLER_204_84 VPWR VGND sg13cmos5l_decap_8
XFILLER_83_167 VPWR VGND sg13cmos5l_decap_8
XFILLER_17_49 VPWR VGND sg13cmos5l_decap_8
XFILLER_140_28 VPWR VGND sg13cmos5l_decap_8
X_0209_ _0209_/Q Tile_X0Y7_FrameData[14] VGND VPWR Tile_X0Y9_FrameStrobe[1] latch
X_1189_ _1189_/Q Tile_X0Y1_FrameData[20] VGND VPWR Tile_X0Y9_FrameStrobe[0] latch
XFILLER_169_206 VPWR VGND sg13cmos5l_decap_8
XFILLER_169_217 VPWR VGND sg13cmos5l_fill_1
XFILLER_385_114 VPWR VGND sg13cmos5l_decap_8
XFILLER_577_42 VPWR VGND sg13cmos5l_decap_8
XFILLER_519_119 VPWR VGND sg13cmos5l_fill_2
XFILLER_33_59 VPWR VGND sg13cmos5l_decap_4
XFILLER_296_21 VPWR VGND sg13cmos5l_decap_8
XFILLER_149_48 VPWR VGND sg13cmos5l_decap_8
X_4879_ _4879_/X Tile_X0Y9_WW4END[0] AXI_M_SOC_RDATA0 _4916_/X _4901_/X _0785_/Q _0784_/Q
+ VPWR VGND sg13cmos5l_mux4_1
XFILLER_326_214 VPWR VGND sg13cmos5l_decap_4
XFILLER_527_185 VPWR VGND sg13cmos5l_fill_1
XFILLER_137_136 VPWR VGND sg13cmos5l_fill_2
XFILLER_123_7 VPWR VGND sg13cmos5l_decap_8
XFILLER_446_35 VPWR VGND sg13cmos5l_decap_8
XFILLER_593_63 VPWR VGND sg13cmos5l_fill_2
XFILLER_116_6 VPWR VGND sg13cmos5l_decap_8
XFILLER_165_14 VPWR VGND sg13cmos5l_decap_8
XFILLER_446_79 VPWR VGND sg13cmos5l_decap_8
XFILLER_3_105 VPWR VGND sg13cmos5l_decap_4
XFILLER_341_217 VPWR VGND sg13cmos5l_fill_1
XFILLER_629_204 VPWR VGND sg13cmos5l_fill_2
XFILLER_3_149 VPWR VGND sg13cmos5l_fill_2
XFILLER_526_90 VPWR VGND sg13cmos5l_fill_2
XFILLER_696_192 VPWR VGND sg13cmos5l_decap_4
XFILLER_492_7 VPWR VGND sg13cmos5l_decap_8
XFILLER_315_28 VPWR VGND sg13cmos5l_fill_2
XFILLER_160_172 VPWR VGND sg13cmos5l_fill_2
XANTENNA__3704__X AXI_M_SOC_WDATA14 VPWR VGND sg13cmos5l_antennanp
XFILLER_58_34 VPWR VGND sg13cmos5l_decap_8
XFILLER_245_91 VPWR VGND sg13cmos5l_decap_8
XFILLER_644_207 VPWR VGND sg13cmos5l_fill_2
XFILLER_59_131 VPWR VGND sg13cmos5l_decap_8
XFILLER_59_142 VPWR VGND sg13cmos5l_fill_2
XFILLER_58_89 VPWR VGND sg13cmos5l_decap_8
XFILLER_181_57 VPWR VGND sg13cmos5l_decap_8
XFILLER_74_101 VPWR VGND sg13cmos5l_decap_8
XFILLER_114_62 VPWR VGND sg13cmos5l_fill_2
XFILLER_331_49 VPWR VGND sg13cmos5l_decap_8
XFILLER_612_126 VPWR VGND sg13cmos5l_decap_8
XFILLER_612_137 VPWR VGND sg13cmos5l_fill_1
XFILLER_15_201 VPWR VGND sg13cmos5l_fill_1
XFILLER_612_159 VPWR VGND sg13cmos5l_decap_8
XFILLER_90_21 VPWR VGND sg13cmos5l_decap_8
XFILLER_487_42 VPWR VGND sg13cmos5l_decap_8
XFILLER_247_0 VPWR VGND sg13cmos5l_decap_8
XFILLER_230_176 VPWR VGND sg13cmos5l_decap_8
XFILLER_414_0 VPWR VGND sg13cmos5l_decap_8
XFILLER_637_56 VPWR VGND sg13cmos5l_decap_8
XFILLER_391_128 VPWR VGND sg13cmos5l_fill_1
XFILLER_23_92 VPWR VGND sg13cmos5l_fill_1
XFILLER_356_35 VPWR VGND sg13cmos5l_decap_8
XFILLER_139_70 VPWR VGND sg13cmos5l_decap_8
XFILLER_128_169 VPWR VGND sg13cmos5l_decap_8
XFILLER_143_117 VPWR VGND sg13cmos5l_decap_8
X_0560_ _0560_/Q Tile_X0Y8_FrameData[15] VGND VPWR Tile_X0Y9_FrameStrobe[4] latch
XFILLER_506_49 VPWR VGND sg13cmos5l_decap_8
XFILLER_436_90 VPWR VGND sg13cmos5l_decap_8
XFILLER_151_150 VPWR VGND sg13cmos5l_decap_8
XFILLER_97_215 VPWR VGND sg13cmos5l_fill_2
XFILLER_653_77 VPWR VGND sg13cmos5l_decap_8
X_0491_ _0491_/Q Tile_X0Y8_FrameData[20] VGND VPWR Tile_X0Y9_FrameStrobe[2] latch
XFILLER_31_6 VPWR VGND sg13cmos5l_decap_8
XFILLER_2_171 VPWR VGND sg13cmos5l_fill_1
XANTENNA__3614__X Tile_X0Y9_S2BEGb[0] VPWR VGND sg13cmos5l_antennanp
X_2230_ _2230_/Q Tile_X0Y5_FrameData[15] VGND VPWR Tile_X0Y9_FrameStrobe[1] latch
XFILLER_372_78 VPWR VGND sg13cmos5l_decap_4
XFILLER_300_136 VPWR VGND sg13cmos5l_decap_4
XFILLER_2_193 VPWR VGND sg13cmos5l_decap_8
XFILLER_300_147 VPWR VGND sg13cmos5l_decap_8
X_2161_ _2161_/Q Tile_X0Y4_FrameData[20] VGND VPWR Tile_X0Y9_FrameStrobe[7] latch
X_1112_ _1112_/Q Tile_X0Y0_FrameData[19] VGND VPWR Tile_X0Y9_FrameStrobe[5] latch
XFILLER_253_202 VPWR VGND sg13cmos5l_decap_8
X_2092_ _2092_/Q Tile_X0Y4_FrameData[25] VGND VPWR Tile_X0Y9_FrameStrobe[5] latch
XFILLER_65_145 VPWR VGND sg13cmos5l_decap_8
XFILLER_241_49 VPWR VGND sg13cmos5l_fill_1
XFILLER_454_184 VPWR VGND sg13cmos5l_decap_8
XFILLER_171_90 VPWR VGND sg13cmos5l_decap_8
XFILLER_80_104 VPWR VGND sg13cmos5l_decap_8
X_1043_ _1043_/Q Tile_X0Y0_FrameData[24] VGND VPWR Tile_X0Y9_FrameStrobe[3] latch
XFILLER_603_148 VPWR VGND sg13cmos5l_decap_8
XFILLER_0_63 VPWR VGND sg13cmos5l_decap_8
XFILLER_321_82 VPWR VGND sg13cmos5l_decap_8
XFILLER_678_63 VPWR VGND sg13cmos5l_decap_8
XFILLER_221_121 VPWR VGND sg13cmos5l_decap_8
X_4802_ _4802_/X _4781_/X Tile_X0Y9_N4END[6] _4780_/X _0075_/X _0467_/Q _0466_/Q VPWR
+ VGND sg13cmos5l_mux4_1
XFILLER_397_42 VPWR VGND sg13cmos5l_decap_8
XFILLER_21_215 VPWR VGND sg13cmos5l_fill_2
X_2994_ Tile_X0Y5_E1BEG[1] _4369_/X VPWR VGND sg13cmos5l_buf_1
XFILLER_367_158 VPWR VGND sg13cmos5l_fill_2
X_4733_ _4733_/X Tile_X0Y8_W2MID[2] AXI_M_SOC_RDATA13 _4789_/X _4788_/X _0581_/Q _0580_/Q
+ VPWR VGND sg13cmos5l_mux4_1
X_1945_ _1945_/Q Tile_X0Y4_FrameData[12] VGND VPWR Tile_X0Y9_FrameStrobe[0] latch
XFILLER_571_206 VPWR VGND sg13cmos5l_fill_2
XFILLER_547_56 VPWR VGND sg13cmos5l_decap_8
XFILLER_713_200 VPWR VGND sg13cmos5l_fill_2
XFILLER_509_185 VPWR VGND sg13cmos5l_decap_4
X_4664_ _4664_/X Tile_X0Y6_W1END[2] Tile_X0Y6_W6END[10] _4582_/X _4542_/X _2655_/Q
+ _2654_/Q VPWR VGND sg13cmos5l_mux4_1
X_1876_ _1876_/Q Tile_X0Y3_FrameData[21] VGND VPWR Tile_X0Y9_FrameStrobe[6] latch
XFILLER_694_84 VPWR VGND sg13cmos5l_decap_8
XFILLER_266_35 VPWR VGND sg13cmos5l_decap_8
X_3615_ Tile_X0Y9_S2BEGb[1] _4933_/X VPWR VGND sg13cmos5l_buf_1
X_0827_ _0827_/Q Tile_X0Y9_FrameData[4] VGND VPWR Tile_X0Y9_FrameStrobe[4] latch
X_4595_ _4595_/X Tile_X0Y8_W2MID[2] Tile_X0Y8_W2END[2] Tile_X0Y8_W6END[2] _4788_/X
+ _0653_/Q _0652_/Q VPWR VGND sg13cmos5l_mux4_1
X_3546_ Tile_X0Y9_E6BEG[4] _4884_/X VPWR VGND sg13cmos5l_buf_1
XFILLER_127_191 VPWR VGND sg13cmos5l_fill_1
X_0758_ _0758_/Q Tile_X0Y9_FrameData[9] VGND VPWR Tile_X0Y9_FrameStrobe[2] latch
XFILLER_477_210 VPWR VGND sg13cmos5l_decap_8
XFILLER_416_49 VPWR VGND sg13cmos5l_decap_8
XFILLER_563_77 VPWR VGND sg13cmos5l_decap_8
XFILLER_142_150 VPWR VGND sg13cmos5l_decap_8
XFILLER_135_28 VPWR VGND sg13cmos5l_decap_8
XFILLER_713_14 VPWR VGND sg13cmos5l_decap_8
XFILLER_88_215 VPWR VGND sg13cmos5l_fill_2
X_3477_ Tile_X0Y1_EE4BEG[3] _3951_/X VPWR VGND sg13cmos5l_buf_1
X_0689_ _0689_/Q Tile_X0Y9_FrameData[14] VGND VPWR Tile_X0Y9_FrameStrobe[0] latch
XFILLER_282_56 VPWR VGND sg13cmos5l_decap_8
XANTENNA__3524__X Tile_X0Y9_E1BEG[2] VPWR VGND sg13cmos5l_antennanp
XFILLER_142_194 VPWR VGND sg13cmos5l_decap_8
X_2428_ _2428_/Q Tile_X0Y5_FrameData[9] VGND VPWR Tile_X0Y9_FrameStrobe[7] latch
XFILLER_229_210 VPWR VGND sg13cmos5l_fill_1
X_2359_ _2359_/Q Tile_X0Y5_FrameData[14] VGND VPWR Tile_X0Y9_FrameStrobe[5] latch
XFILLER_512_70 VPWR VGND sg13cmos5l_decap_8
XFILLER_71_104 VPWR VGND sg13cmos5l_decap_8
X_4029_ _4029_/X Tile_X0Y3_W2MID[3] Tile_X0Y3_W2END[3] Tile_X0Y3_W6END[3] _4210_/X
+ _1909_/Q _1908_/Q VPWR VGND sg13cmos5l_mux4_1
XFILLER_44_36 VPWR VGND sg13cmos5l_fill_1
XFILLER_460_198 VPWR VGND sg13cmos5l_decap_8
XFILLER_401_210 VPWR VGND sg13cmos5l_fill_1
XFILLER_212_132 VPWR VGND sg13cmos5l_decap_8
XFILLER_240_7 VPWR VGND sg13cmos5l_decap_8
XFILLER_100_20 VPWR VGND sg13cmos5l_decap_8
XFILLER_358_147 VPWR VGND sg13cmos5l_decap_8
XFILLER_338_7 VPWR VGND sg13cmos5l_decap_8
XANTENNA__0107__Y AXI_M_SOC_ARLEN2 VPWR VGND sg13cmos5l_antennanp
XFILLER_60_35 VPWR VGND sg13cmos5l_decap_8
XFILLER_505_7 VPWR VGND sg13cmos5l_decap_8
XFILLER_176_35 VPWR VGND sg13cmos5l_fill_2
XFILLER_314_206 VPWR VGND sg13cmos5l_decap_4
XFILLER_314_217 VPWR VGND sg13cmos5l_fill_1
XFILLER_109_51 VPWR VGND sg13cmos5l_decap_4
XFILLER_669_170 VPWR VGND sg13cmos5l_decap_8
XFILLER_279_132 VPWR VGND sg13cmos5l_decap_8
XFILLER_79_215 VPWR VGND sg13cmos5l_fill_2
XFILLER_133_161 VPWR VGND sg13cmos5l_decap_8
XFILLER_623_14 VPWR VGND sg13cmos5l_decap_8
XANTENNA__3434__X Tile_X0Y4_FrameData_O[25] VPWR VGND sg13cmos5l_antennanp
XFILLER_69_88 VPWR VGND sg13cmos5l_decap_8
XFILLER_192_56 VPWR VGND sg13cmos5l_decap_8
XFILLER_684_162 VPWR VGND sg13cmos5l_decap_8
XFILLER_684_173 VPWR VGND sg13cmos5l_fill_1
XFILLER_197_0 VPWR VGND sg13cmos5l_decap_8
XFILLER_47_112 VPWR VGND sg13cmos5l_decap_8
XFILLER_436_151 VPWR VGND sg13cmos5l_fill_1
XFILLER_703_91 VPWR VGND sg13cmos5l_decap_8
XFILLER_235_213 VPWR VGND sg13cmos5l_decap_4
XFILLER_422_70 VPWR VGND sg13cmos5l_decap_8
XFILLER_85_98 VPWR VGND sg13cmos5l_decap_8
XFILLER_451_121 VPWR VGND sg13cmos5l_fill_1
XFILLER_364_0 VPWR VGND sg13cmos5l_decap_8
XFILLER_451_143 VPWR VGND sg13cmos5l_decap_4
XFILLER_498_63 VPWR VGND sg13cmos5l_decap_8
XFILLER_531_0 VPWR VGND sg13cmos5l_decap_8
XFILLER_629_0 VPWR VGND sg13cmos5l_decap_8
XFILLER_203_154 VPWR VGND sg13cmos5l_decap_8
XFILLER_70_192 VPWR VGND sg13cmos5l_decap_8
XFILLER_648_77 VPWR VGND sg13cmos5l_decap_8
XFILLER_203_198 VPWR VGND sg13cmos5l_decap_4
XFILLER_86_7 VPWR VGND sg13cmos5l_decap_8
XFILLER_364_117 VPWR VGND sg13cmos5l_decap_8
XFILLER_553_217 VPWR VGND sg13cmos5l_fill_1
XFILLER_367_56 VPWR VGND sg13cmos5l_fill_2
XANTENNA__3609__X Tile_X0Y9_S2BEG[3] VPWR VGND sg13cmos5l_antennanp
XFILLER_79_6 VPWR VGND sg13cmos5l_decap_8
X_1730_ _1730_/Q Tile_X0Y3_FrameData[7] VGND VPWR Tile_X0Y9_FrameStrobe[1] latch
XFILLER_367_89 VPWR VGND sg13cmos5l_fill_2
XFILLER_664_21 VPWR VGND sg13cmos5l_decap_8
XFILLER_506_144 VPWR VGND sg13cmos5l_decap_8
XFILLER_171_201 VPWR VGND sg13cmos5l_decap_8
X_1661_ _1661_/Q Tile_X0Y2_FrameData[20] VGND VPWR Tile_X0Y9_FrameStrobe[7] latch
XFILLER_521_103 VPWR VGND sg13cmos5l_fill_2
X_3400_ Tile_X0Y2_E2BEG[3] _4043_/X VPWR VGND sg13cmos5l_buf_1
X_0612_ _0612_/Q Tile_X0Y8_FrameData[27] VGND VPWR Tile_X0Y9_FrameStrobe[6] latch
X_4380_ _4380_/X Tile_X0Y5_W2END[7] AXI_M_SOC_RRESP1 _4467_/X _4428_/X _2343_/Q _2342_/Q
+ VPWR VGND sg13cmos5l_mux4_1
X_1592_ _1592_/Q Tile_X0Y2_FrameData[25] VGND VPWR Tile_X0Y9_FrameStrobe[5] latch
XFILLER_459_210 VPWR VGND sg13cmos5l_fill_2
X_3331_ Tile_X0Y2_FrameData_O[2] Tile_X0Y2_FrameData[2] VPWR VGND sg13cmos5l_buf_1
X_0543_ _0543_/Q Tile_X0Y8_FrameData[0] VGND VPWR Tile_X0Y9_FrameStrobe[3] latch
XFILLER_533_14 VPWR VGND sg13cmos5l_decap_8
XFILLER_124_172 VPWR VGND sg13cmos5l_decap_8
XANTENNA__3344__X Tile_X0Y2_FrameData_O[15] VPWR VGND sg13cmos5l_antennanp
XFILLER_680_42 VPWR VGND sg13cmos5l_decap_8
XFILLER_124_194 VPWR VGND sg13cmos5l_decap_8
X_3262_ Tile_X0Y0_FrameData_O[30] Tile_X0Y0_FrameData[30] VPWR VGND sg13cmos5l_buf_1
XFILLER_285_124 VPWR VGND sg13cmos5l_decap_8
X_0474_ _0474_/Q Tile_X0Y8_FrameData[5] VGND VPWR Tile_X0Y9_FrameStrobe[1] latch
X_2213_ _2213_/Q Tile_X0Y5_FrameData[0] VGND VPWR Tile_X0Y9_FrameStrobe[0] latch
X_3193_ Tile_X0Y0_N2BEGb[1] _3891_/X VPWR VGND sg13cmos5l_buf_1
XFILLER_427_140 VPWR VGND sg13cmos5l_decap_8
XFILLER_38_112 VPWR VGND sg13cmos5l_decap_8
XFILLER_613_91 VPWR VGND sg13cmos5l_decap_8
X_2144_ _2144_/Q Tile_X0Y4_FrameData[5] VGND VPWR Tile_X0Y9_FrameStrobe[6] latch
XFILLER_588_103 VPWR VGND sg13cmos5l_decap_4
XFILLER_53_115 VPWR VGND sg13cmos5l_fill_2
X_2075_ _2075_/Q Tile_X0Y4_FrameData[10] VGND VPWR Tile_X0Y9_FrameStrobe[4] latch
XFILLER_241_216 VPWR VGND sg13cmos5l_fill_2
X_1026_ _1026_/Q Tile_X0Y0_FrameData[9] VGND VPWR Tile_X0Y9_FrameStrobe[2] latch
XFILLER_442_187 VPWR VGND sg13cmos5l_decap_8
XFILLER_201_63 VPWR VGND sg13cmos5l_decap_8
XFILLER_14_28 VPWR VGND sg13cmos5l_decap_8
XFILLER_558_66 VPWR VGND sg13cmos5l_fill_1
XFILLER_544_206 VPWR VGND sg13cmos5l_fill_2
XFILLER_708_14 VPWR VGND sg13cmos5l_decap_8
X_2977_ Tile_X0Y8_FrameData_O[17] Tile_X0Y8_FrameData[17] VPWR VGND sg13cmos5l_buf_1
XFILLER_544_217 VPWR VGND sg13cmos5l_fill_1
XFILLER_558_99 VPWR VGND sg13cmos5l_decap_8
XANTENNA__3519__X Tile_X0Y1_E1BEG[1] VPWR VGND sg13cmos5l_antennanp
XFILLER_277_56 VPWR VGND sg13cmos5l_decap_8
X_4716_ _4716_/X Tile_X0Y8_W1END[0] Tile_X0Y8_WW4END[12] Tile_X0Y8_W6END[4] _4800_/X
+ _0611_/Q _0610_/Q VPWR VGND sg13cmos5l_mux4_1
X_1928_ _1928_/Q Tile_X0Y4_FrameData[29] VGND VPWR Tile_X0Y9_FrameStrobe[0] latch
XFILLER_574_21 VPWR VGND sg13cmos5l_decap_8
X_4647_ _4647_/X Tile_X0Y9_N4END[11] _0053_/X _4692_/X _4696_/X _0265_/Q _0264_/Q
+ VPWR VGND sg13cmos5l_mux4_1
XFILLER_363_161 VPWR VGND sg13cmos5l_decap_4
X_1859_ _1859_/Q Tile_X0Y3_FrameData[6] VGND VPWR Tile_X0Y9_FrameStrobe[5] latch
XFILLER_363_172 VPWR VGND sg13cmos5l_fill_1
XFILLER_30_49 VPWR VGND sg13cmos5l_decap_8
XFILLER_574_87 VPWR VGND sg13cmos5l_decap_8
X_4578_ _4578_/X _4549_/X Tile_X0Y9_N4END[14] _4548_/X _0155_/X _2475_/Q _2474_/Q
+ VPWR VGND sg13cmos5l_mux4_1
XFILLER_146_49 VPWR VGND sg13cmos5l_decap_8
XFILLER_507_70 VPWR VGND sg13cmos5l_decap_8
XFILLER_293_77 VPWR VGND sg13cmos5l_decap_4
XFILLER_115_150 VPWR VGND sg13cmos5l_decap_8
X_3529_ Tile_X0Y9_E2BEG[3] _4851_/X VPWR VGND sg13cmos5l_buf_1
XFILLER_443_14 VPWR VGND sg13cmos5l_decap_8
XANTENNA__3254__X Tile_X0Y0_FrameData_O[22] VPWR VGND sg13cmos5l_antennanp
XFILLER_590_42 VPWR VGND sg13cmos5l_decap_8
XFILLER_465_202 VPWR VGND sg13cmos5l_decap_8
XFILLER_520_191 VPWR VGND sg13cmos5l_decap_8
XFILLER_76_207 VPWR VGND sg13cmos5l_decap_4
XFILLER_190_7 VPWR VGND sg13cmos5l_decap_8
XFILLER_130_175 VPWR VGND sg13cmos5l_fill_2
XFILLER_288_7 VPWR VGND sg13cmos5l_decap_8
XFILLER_276_179 VPWR VGND sg13cmos5l_decap_4
XFILLER_55_13 VPWR VGND sg13cmos5l_decap_8
XFILLER_29_167 VPWR VGND sg13cmos5l_decap_8
XFILLER_55_46 VPWR VGND sg13cmos5l_decap_8
XFILLER_455_7 VPWR VGND sg13cmos5l_decap_8
XFILLER_622_7 VPWR VGND sg13cmos5l_decap_8
XFILLER_71_34 VPWR VGND sg13cmos5l_decap_8
XFILLER_618_14 VPWR VGND sg13cmos5l_decap_8
XFILLER_535_217 VPWR VGND sg13cmos5l_fill_1
XFILLER_197_197 VPWR VGND sg13cmos5l_decap_8
XANTENNA__3429__X Tile_X0Y4_FrameData_O[20] VPWR VGND sg13cmos5l_antennanp
XFILLER_346_139 VPWR VGND sg13cmos5l_fill_2
XFILLER_187_56 VPWR VGND sg13cmos5l_decap_4
XFILLER_187_67 VPWR VGND sg13cmos5l_decap_8
XFILLER_200_179 VPWR VGND sg13cmos5l_decap_4
XFILLER_484_21 VPWR VGND sg13cmos5l_decap_8
XFILLER_354_161 VPWR VGND sg13cmos5l_decap_8
XFILLER_112_0 VPWR VGND sg13cmos5l_decap_8
XFILLER_634_35 VPWR VGND sg13cmos5l_decap_8
XFILLER_503_147 VPWR VGND sg13cmos5l_decap_8
XFILLER_417_70 VPWR VGND sg13cmos5l_decap_8
XFILLER_113_109 VPWR VGND sg13cmos5l_decap_8
XFILLER_353_14 VPWR VGND sg13cmos5l_decap_8
XANTENNA__3164__X Tile_X0Y4_E6BEG[1] VPWR VGND sg13cmos5l_antennanp
XFILLER_456_202 VPWR VGND sg13cmos5l_decap_8
XFILLER_481_0 VPWR VGND sg13cmos5l_decap_8
XFILLER_579_0 VPWR VGND sg13cmos5l_decap_8
XFILLER_503_28 VPWR VGND sg13cmos5l_decap_8
XFILLER_121_175 VPWR VGND sg13cmos5l_decap_8
XFILLER_121_186 VPWR VGND sg13cmos5l_fill_1
XFILLER_282_105 VPWR VGND sg13cmos5l_decap_8
XFILLER_650_56 VPWR VGND sg13cmos5l_decap_8
XFILLER_433_91 VPWR VGND sg13cmos5l_decap_8
X_0190_ _0190_/Q Tile_X0Y7_FrameData[1] VGND VPWR Tile_X0Y9_FrameStrobe[0] latch
XFILLER_672_198 VPWR VGND sg13cmos5l_decap_8
XFILLER_152_81 VPWR VGND sg13cmos5l_decap_8
XFILLER_35_115 VPWR VGND sg13cmos5l_fill_1
XFILLER_424_154 VPWR VGND sg13cmos5l_decap_8
XFILLER_223_205 VPWR VGND sg13cmos5l_decap_4
XFILLER_659_21 VPWR VGND sg13cmos5l_decap_8
XFILLER_424_176 VPWR VGND sg13cmos5l_fill_2
XFILLER_585_128 VPWR VGND sg13cmos5l_fill_2
X_2900_ Tile_X0Y6_FrameData_O[21] Tile_X0Y6_FrameData[21] VPWR VGND sg13cmos5l_buf_1
XFILLER_188_120 VPWR VGND sg13cmos5l_decap_8
X_3880_ _3880_/X _3851_/X Tile_X0Y0_W6END[3] Tile_X0Y0_S1END[3] _3880_/A3 _0941_/Q
+ _1178_/Q VPWR VGND sg13cmos5l_mux4_1
XFILLER_188_153 VPWR VGND sg13cmos5l_decap_8
X_2831_ Tile_X0Y6_E1BEG[0] _4492_/X VPWR VGND sg13cmos5l_buf_1
XFILLER_378_77 VPWR VGND sg13cmos5l_fill_1
XFILLER_528_14 VPWR VGND sg13cmos5l_decap_8
XFILLER_526_217 VPWR VGND sg13cmos5l_fill_1
XANTENNA__3339__X Tile_X0Y2_FrameData_O[10] VPWR VGND sg13cmos5l_antennanp
XFILLER_675_42 VPWR VGND sg13cmos5l_decap_8
X_2762_ Tile_X0Y3_FrameData_O[20] Tile_X0Y3_FrameData[20] VPWR VGND sg13cmos5l_buf_1
XFILLER_394_21 VPWR VGND sg13cmos5l_decap_8
X_4501_ _4501_/X Tile_X0Y6_W2MID[2] AXI_M_SOC_RDATA29 _4557_/X _4556_/X _2605_/Q _2604_/Q
+ VPWR VGND sg13cmos5l_mux4_1
X_1713_ _1713_/Q Tile_X0Y3_FrameData[24] VGND VPWR Tile_X0Y9_FrameStrobe[1] latch
XFILLER_675_97 VPWR VGND sg13cmos5l_decap_8
X_2693_ _2693_/Q Tile_X0Y6_FrameData[2] VGND VPWR Tile_X0Y9_FrameStrobe[7] latch
XFILLER_394_65 VPWR VGND sg13cmos5l_decap_8
XFILLER_345_172 VPWR VGND sg13cmos5l_fill_1
XFILLER_345_194 VPWR VGND sg13cmos5l_decap_8
X_4432_ _4432_/X _4357_/X _4473_/X _4472_/X _4356_/X _2201_/Q _2200_/Q VPWR VGND sg13cmos5l_mux4_1
XFILLER_394_87 VPWR VGND sg13cmos5l_decap_8
X_1644_ _1644_/Q Tile_X0Y2_FrameData[5] VGND VPWR Tile_X0Y9_FrameStrobe[6] latch
XFILLER_544_35 VPWR VGND sg13cmos5l_decap_8
XFILLER_6_84 VPWR VGND sg13cmos5l_decap_8
XFILLER_691_63 VPWR VGND sg13cmos5l_decap_8
X_4363_ _4363_/X Tile_X0Y6_W2MID[2] Tile_X0Y6_W2END[2] Tile_X0Y6_W6END[2] _4556_/X
+ _2677_/Q _2676_/Q VPWR VGND sg13cmos5l_mux4_1
XFILLER_263_14 VPWR VGND sg13cmos5l_decap_8
X_1575_ _1575_/Q Tile_X0Y2_FrameData[10] VGND VPWR Tile_X0Y9_FrameStrobe[4] latch
XANTENNA__3074__X Tile_X0Y4_E2BEGb[0] VPWR VGND sg13cmos5l_antennanp
XFILLER_648_140 VPWR VGND sg13cmos5l_decap_8
X_3314_ Tile_X0Y4_EE4BEG[2] _4274_/X VPWR VGND sg13cmos5l_buf_1
X_0526_ _0526_/Q Tile_X0Y8_FrameData[17] VGND VPWR Tile_X0Y9_FrameStrobe[3] latch
X_4294_ _4294_/X AXI_M_SOC_BRESP0 _4341_/X _4345_/X _4317_/X _2025_/Q _2024_/Q VPWR
+ VGND sg13cmos5l_mux4_1
XFILLER_258_135 VPWR VGND sg13cmos5l_decap_8
XFILLER_112_142 VPWR VGND sg13cmos5l_decap_8
XFILLER_258_146 VPWR VGND sg13cmos5l_fill_1
X_3245_ Tile_X0Y0_FrameData_O[13] Tile_X0Y0_FrameData[13] VPWR VGND sg13cmos5l_buf_1
XFILLER_413_28 VPWR VGND sg13cmos5l_decap_8
X_0457_ _0457_/Q Tile_X0Y8_FrameData[22] VGND VPWR Tile_X0Y9_FrameStrobe[1] latch
XFILLER_273_105 VPWR VGND sg13cmos5l_decap_8
XFILLER_258_179 VPWR VGND sg13cmos5l_fill_2
XFILLER_560_56 VPWR VGND sg13cmos5l_decap_8
X_3176_ Tile_X0Y0_N4BEG[0] _3176_/A VPWR VGND sg13cmos5l_buf_1
X_0388_ _0388_/Q Tile_X0Y7_FrameData[27] VGND VPWR Tile_X0Y9_FrameStrobe[7] latch
XFILLER_604_210 VPWR VGND sg13cmos5l_fill_1
XFILLER_415_121 VPWR VGND sg13cmos5l_decap_8
XFILLER_266_190 VPWR VGND sg13cmos5l_decap_8
X_2127_ _2127_/Q Tile_X0Y4_FrameData[22] VGND VPWR Tile_X0Y9_FrameStrobe[6] latch
XFILLER_569_21 VPWR VGND sg13cmos5l_decap_8
XFILLER_415_176 VPWR VGND sg13cmos5l_decap_8
XFILLER_212_62 VPWR VGND sg13cmos5l_decap_8
XFILLER_281_182 VPWR VGND sg13cmos5l_decap_8
X_2058_ _2058_/Q Tile_X0Y4_FrameData[27] VGND VPWR Tile_X0Y9_FrameStrobe[4] latch
XFILLER_25_49 VPWR VGND sg13cmos5l_fill_2
X_1009_ _1009_/Q Tile_X0Y0_FrameData[26] VGND VPWR Tile_X0Y9_FrameStrobe[2] latch
XFILLER_430_157 VPWR VGND sg13cmos5l_decap_8
XFILLER_569_98 VPWR VGND sg13cmos5l_decap_8
XFILLER_34_181 VPWR VGND sg13cmos5l_decap_8
XFILLER_591_109 VPWR VGND sg13cmos5l_fill_2
XFILLER_288_77 VPWR VGND sg13cmos5l_decap_8
XFILLER_179_175 VPWR VGND sg13cmos5l_decap_8
XFILLER_517_206 VPWR VGND sg13cmos5l_fill_1
XFILLER_438_14 VPWR VGND sg13cmos5l_decap_8
XFILLER_194_112 VPWR VGND sg13cmos5l_decap_8
XFILLER_179_186 VPWR VGND sg13cmos5l_fill_1
XFILLER_194_123 VPWR VGND sg13cmos5l_fill_2
XANTENNA__3249__X Tile_X0Y0_FrameData_O[17] VPWR VGND sg13cmos5l_antennanp
XFILLER_585_42 VPWR VGND sg13cmos5l_decap_8
XFILLER_584_183 VPWR VGND sg13cmos5l_fill_2
XFILLER_194_145 VPWR VGND sg13cmos5l_fill_1
XFILLER_41_48 VPWR VGND sg13cmos5l_decap_8
XFILLER_203_7 VPWR VGND sg13cmos5l_decap_8
XFILLER_454_35 VPWR VGND sg13cmos5l_decap_8
XFILLER_497_168 VPWR VGND sg13cmos5l_decap_8
XFILLER_639_140 VPWR VGND sg13cmos5l_decap_8
XFILLER_438_202 VPWR VGND sg13cmos5l_decap_4
XFILLER_173_58 VPWR VGND sg13cmos5l_decap_8
XFILLER_103_131 VPWR VGND sg13cmos5l_decap_8
XFILLER_604_49 VPWR VGND sg13cmos5l_decap_8
XFILLER_639_195 VPWR VGND sg13cmos5l_decap_8
XFILLER_572_7 VPWR VGND sg13cmos5l_decap_8
XFILLER_323_28 VPWR VGND sg13cmos5l_decap_8
XFILLER_264_105 VPWR VGND sg13cmos5l_decap_8
XFILLER_470_56 VPWR VGND sg13cmos5l_decap_8
XANTENNA__3712__X AXI_M_SOC_WDATA22 VPWR VGND sg13cmos5l_antennanp
XFILLER_66_56 VPWR VGND sg13cmos5l_decap_8
XFILLER_257_190 VPWR VGND sg13cmos5l_fill_2
XFILLER_406_143 VPWR VGND sg13cmos5l_fill_2
XFILLER_479_21 VPWR VGND sg13cmos5l_decap_8
XFILLER_406_198 VPWR VGND sg13cmos5l_decap_8
XFILLER_700_70 VPWR VGND sg13cmos5l_decap_8
XFILLER_82_55 VPWR VGND sg13cmos5l_decap_8
XFILLER_709_133 VPWR VGND sg13cmos5l_decap_8
XFILLER_82_88 VPWR VGND sg13cmos5l_decap_8
XFILLER_629_35 VPWR VGND sg13cmos5l_decap_8
XFILLER_421_179 VPWR VGND sg13cmos5l_fill_1
XFILLER_25_192 VPWR VGND sg13cmos5l_decap_4
XFILLER_198_77 VPWR VGND sg13cmos5l_decap_8
XFILLER_575_161 VPWR VGND sg13cmos5l_decap_8
XFILLER_508_217 VPWR VGND sg13cmos5l_fill_1
XFILLER_348_14 VPWR VGND sg13cmos5l_decap_8
XFILLER_185_112 VPWR VGND sg13cmos5l_decap_8
XFILLER_15_93 VPWR VGND sg13cmos5l_fill_1
XANTENNA__3159__X Tile_X0Y7_FrameData_O[29] VPWR VGND sg13cmos5l_antennanp
XFILLER_327_0 VPWR VGND sg13cmos5l_decap_8
XFILLER_495_42 VPWR VGND sg13cmos5l_decap_8
XFILLER_590_120 VPWR VGND sg13cmos5l_decap_8
XANTENNA__2998__X Tile_X0Y5_E2BEG[1] VPWR VGND sg13cmos5l_antennanp
XFILLER_327_172 VPWR VGND sg13cmos5l_fill_1
XFILLER_645_56 VPWR VGND sg13cmos5l_decap_8
XFILLER_428_91 VPWR VGND sg13cmos5l_decap_8
XFILLER_99_107 VPWR VGND sg13cmos5l_decap_8
XFILLER_488_135 VPWR VGND sg13cmos5l_decap_8
XFILLER_364_35 VPWR VGND sg13cmos5l_decap_8
XFILLER_141_204 VPWR VGND sg13cmos5l_decap_8
XFILLER_696_0 VPWR VGND sg13cmos5l_decap_8
XFILLER_342_197 VPWR VGND sg13cmos5l_decap_8
XFILLER_692_216 VPWR VGND sg13cmos5l_fill_2
X_1360_ _1360_/Q Tile_X0Y1_FrameData[9] VGND VPWR Tile_X0Y9_FrameStrobe[5] latch
XFILLER_514_49 VPWR VGND sg13cmos5l_decap_8
X_0311_ _0311_/Q Tile_X0Y7_FrameData[8] VGND VPWR Tile_X0Y9_FrameStrobe[4] latch
XFILLER_661_77 VPWR VGND sg13cmos5l_decap_8
XFILLER_233_28 VPWR VGND sg13cmos5l_decap_8
X_1291_ _1291_/Q Tile_X0Y1_FrameData[14] VGND VPWR Tile_X0Y9_FrameStrobe[3] latch
XFILLER_645_154 VPWR VGND sg13cmos5l_decap_8
XFILLER_444_205 VPWR VGND sg13cmos5l_decap_8
XANTENNA__3622__X Tile_X0Y9_S4BEG[0] VPWR VGND sg13cmos5l_antennanp
XFILLER_444_216 VPWR VGND sg13cmos5l_fill_2
X_3030_ Tile_X0Y5_EE4BEG[5] _4393_/X VPWR VGND sg13cmos5l_buf_1
X_0242_ _0242_/Q Tile_X0Y7_FrameData[13] VGND VPWR Tile_X0Y9_FrameStrobe[2] latch
XFILLER_313_61 VPWR VGND sg13cmos5l_decap_8
X_0173_ _0173_/Q Tile_X0Y7_FrameData[18] VGND VPWR Tile_X0Y9_FrameStrobe[0] latch
XFILLER_270_108 VPWR VGND sg13cmos5l_decap_8
XFILLER_389_21 VPWR VGND sg13cmos5l_decap_8
XFILLER_610_70 VPWR VGND sg13cmos5l_decap_8
XFILLER_412_157 VPWR VGND sg13cmos5l_fill_1
X_3932_ _3932_/X Tile_X0Y1_W2MID[7] AXI_M_SOC_ARREADY _3989_/X _3988_/X _1345_/Q _1344_/Q
+ VPWR VGND sg13cmos5l_mux4_1
XFILLER_539_35 VPWR VGND sg13cmos5l_decap_8
X_3863_ _3863_/X _3851_/X _0078_/X Tile_X0Y0_S1END[3] Tile_X0Y0_S4END[3] _0965_/Q
+ _0964_/Q VPWR VGND sg13cmos5l_mux4_1
XFILLER_686_63 VPWR VGND sg13cmos5l_decap_8
XFILLER_566_161 VPWR VGND sg13cmos5l_decap_8
XFILLER_258_14 VPWR VGND sg13cmos5l_decap_8
XFILLER_176_112 VPWR VGND sg13cmos5l_fill_2
XFILLER_31_162 VPWR VGND sg13cmos5l_fill_2
XANTENNA__3069__X Tile_X0Y5_FrameData_O[28] VPWR VGND sg13cmos5l_antennanp
XFILLER_715_125 VPWR VGND sg13cmos5l_decap_8
X_2814_ Tile_X0Y3_E2BEG[4] _4152_/X VPWR VGND sg13cmos5l_buf_1
X_3794_ _3794_/X Tile_X0Y0_W1END[1] Tile_X0Y0_WW4END[1] Tile_X0Y0_W6END[9] _3882_/X
+ _1150_/Q _1149_/Q VPWR VGND sg13cmos5l_mux4_1
XFILLER_75_0 VPWR VGND sg13cmos5l_fill_2
X_2745_ Tile_X0Y3_FrameData_O[3] Tile_X0Y3_FrameData[3] VPWR VGND sg13cmos5l_buf_1
XFILLER_408_28 VPWR VGND sg13cmos5l_decap_8
XFILLER_555_56 VPWR VGND sg13cmos5l_decap_8
XFILLER_479_102 VPWR VGND sg13cmos5l_fill_1
X_2676_ _2676_/Q Tile_X0Y6_FrameData[19] VGND VPWR Tile_X0Y9_FrameStrobe[7] latch
XFILLER_274_35 VPWR VGND sg13cmos5l_decap_8
XFILLER_479_135 VPWR VGND sg13cmos5l_decap_8
X_4415_ _4415_/X AXI_M_SOC_RRESP1 _4451_/X _4455_/X _4428_/X _2273_/Q _2272_/Q VPWR
+ VGND sg13cmos5l_mux4_1
X_1627_ _1627_/Q Tile_X0Y2_FrameData[22] VGND VPWR Tile_X0Y9_FrameStrobe[6] latch
XFILLER_278_208 VPWR VGND sg13cmos5l_fill_1
XFILLER_494_105 VPWR VGND sg13cmos5l_decap_8
XFILLER_207_62 VPWR VGND sg13cmos5l_decap_8
X_4346_ _4346_/X _4308_/X _0160_/X _4307_/X _0110_/X _1961_/Q _1960_/Q VPWR VGND sg13cmos5l_mux4_1
X_1558_ _1558_/Q Tile_X0Y2_FrameData[27] VGND VPWR Tile_X0Y9_FrameStrobe[4] latch
XFILLER_424_49 VPWR VGND sg13cmos5l_decap_8
XFILLER_98_173 VPWR VGND sg13cmos5l_fill_1
XFILLER_571_77 VPWR VGND sg13cmos5l_decap_8
X_0509_ _0509_/Q Tile_X0Y8_FrameData[2] VGND VPWR Tile_X0Y9_FrameStrobe[2] latch
XFILLER_143_28 VPWR VGND sg13cmos5l_decap_8
X_4277_ _4277_/X Tile_X0Y4_WW4END[10] AXI_M_SOC_BRESP1 _4346_/X _4317_/X _2059_/Q
+ _2058_/Q VPWR VGND sg13cmos5l_mux4_1
X_1489_ _1489_/Q Tile_X0Y2_FrameData[0] VGND VPWR Tile_X0Y9_FrameStrobe[1] latch
XANTENNA__3532__X Tile_X0Y9_E2BEG[6] VPWR VGND sg13cmos5l_antennanp
XFILLER_290_56 VPWR VGND sg13cmos5l_decap_8
XFILLER_246_127 VPWR VGND sg13cmos5l_decap_8
X_3228_ Tile_X0Y0_FrameStrobe_O[16] Tile_X0Y9_FrameStrobe[16] VPWR VGND sg13cmos5l_buf_1
XFILLER_223_72 VPWR VGND sg13cmos5l_fill_1
X_3159_ Tile_X0Y7_FrameData_O[29] Tile_X0Y7_FrameData[29] VPWR VGND sg13cmos5l_buf_1
XFILLER_651_168 VPWR VGND sg13cmos5l_decap_8
XFILLER_261_119 VPWR VGND sg13cmos5l_decap_8
XFILLER_223_94 VPWR VGND sg13cmos5l_decap_8
XFILLER_299_21 VPWR VGND sg13cmos5l_decap_8
XFILLER_254_171 VPWR VGND sg13cmos5l_decap_8
XFILLER_403_102 VPWR VGND sg13cmos5l_decap_8
XFILLER_549_117 VPWR VGND sg13cmos5l_fill_1
XFILLER_549_139 VPWR VGND sg13cmos5l_decap_4
XFILLER_153_7 VPWR VGND sg13cmos5l_decap_8
XFILLER_449_35 VPWR VGND sg13cmos5l_decap_8
XFILLER_22_140 VPWR VGND sg13cmos5l_fill_2
XFILLER_167_101 VPWR VGND sg13cmos5l_decap_8
XFILLER_596_63 VPWR VGND sg13cmos5l_fill_2
XFILLER_168_14 VPWR VGND sg13cmos5l_decap_8
XFILLER_52_58 VPWR VGND sg13cmos5l_decap_8
XFILLER_168_25 VPWR VGND sg13cmos5l_fill_1
XFILLER_320_7 VPWR VGND sg13cmos5l_decap_8
XFILLER_168_47 VPWR VGND sg13cmos5l_decap_8
XFILLER_418_7 VPWR VGND sg13cmos5l_decap_8
XFILLER_706_147 VPWR VGND sg13cmos5l_decap_4
XFILLER_309_150 VPWR VGND sg13cmos5l_decap_4
XANTENNA__0115__Y AXI_M_SOC_ARSIZE0 VPWR VGND sg13cmos5l_antennanp
XFILLER_572_175 VPWR VGND sg13cmos5l_decap_8
XFILLER_318_28 VPWR VGND sg13cmos5l_decap_4
XANTENNA__3707__X AXI_M_SOC_WDATA17 VPWR VGND sg13cmos5l_antennanp
XFILLER_324_153 VPWR VGND sg13cmos5l_decap_8
XFILLER_123_204 VPWR VGND sg13cmos5l_fill_1
XFILLER_184_79 VPWR VGND sg13cmos5l_decap_8
XFILLER_485_105 VPWR VGND sg13cmos5l_fill_1
XANTENNA__0131__X AXI_M_SOC_AWSIZE1 VPWR VGND sg13cmos5l_antennanp
XFILLER_89_151 VPWR VGND sg13cmos5l_decap_4
XFILLER_485_138 VPWR VGND sg13cmos5l_fill_2
XFILLER_334_49 VPWR VGND sg13cmos5l_decap_8
XFILLER_117_84 VPWR VGND sg13cmos5l_decap_8
XFILLER_77_55 VPWR VGND sg13cmos5l_decap_4
XFILLER_77_66 VPWR VGND sg13cmos5l_decap_8
XFILLER_631_14 VPWR VGND sg13cmos5l_decap_8
XFILLER_627_143 VPWR VGND sg13cmos5l_fill_1
XFILLER_426_205 VPWR VGND sg13cmos5l_fill_1
XANTENNA__3442__X Tile_X0Y1_FrameData_O[0] VPWR VGND sg13cmos5l_antennanp
XFILLER_627_176 VPWR VGND sg13cmos5l_fill_1
XFILLER_493_182 VPWR VGND sg13cmos5l_decap_4
XFILLER_627_198 VPWR VGND sg13cmos5l_fill_1
XFILLER_133_72 VPWR VGND sg13cmos5l_decap_8
XFILLER_93_21 VPWR VGND sg13cmos5l_decap_8
XFILLER_277_0 VPWR VGND sg13cmos5l_decap_8
XFILLER_642_168 VPWR VGND sg13cmos5l_decap_8
XFILLER_711_91 VPWR VGND sg13cmos5l_decap_8
XFILLER_430_70 VPWR VGND sg13cmos5l_decap_8
XFILLER_93_98 VPWR VGND sg13cmos5l_decap_8
XFILLER_444_0 VPWR VGND sg13cmos5l_decap_8
XFILLER_26_70 VPWR VGND sg13cmos5l_fill_2
XFILLER_260_152 VPWR VGND sg13cmos5l_fill_1
XFILLER_359_35 VPWR VGND sg13cmos5l_decap_8
XFILLER_158_101 VPWR VGND sg13cmos5l_decap_8
XFILLER_13_151 VPWR VGND sg13cmos5l_fill_1
XFILLER_9_111 VPWR VGND sg13cmos5l_decap_4
XFILLER_611_0 VPWR VGND sg13cmos5l_decap_8
XFILLER_402_190 VPWR VGND sg13cmos5l_fill_2
XFILLER_709_0 VPWR VGND sg13cmos5l_decap_8
XFILLER_13_184 VPWR VGND sg13cmos5l_fill_1
X_0860_ _0860_/Q Tile_X0Y9_FrameData[3] VGND VPWR Tile_X0Y9_FrameStrobe[5] latch
XFILLER_509_49 VPWR VGND sg13cmos5l_decap_8
XFILLER_173_104 VPWR VGND sg13cmos5l_decap_8
XFILLER_158_178 VPWR VGND sg13cmos5l_decap_4
XFILLER_173_115 VPWR VGND sg13cmos5l_fill_1
XFILLER_656_77 VPWR VGND sg13cmos5l_decap_8
XFILLER_228_28 VPWR VGND sg13cmos5l_decap_4
X_0791_ _0791_/Q Tile_X0Y9_FrameData[8] VGND VPWR Tile_X0Y9_FrameStrobe[3] latch
XANTENNA__3617__X Tile_X0Y9_S2BEGb[3] VPWR VGND sg13cmos5l_antennanp
X_2530_ _2530_/Q Tile_X0Y6_FrameData[5] VGND VPWR Tile_X0Y9_FrameStrobe[2] latch
XFILLER_375_67 VPWR VGND sg13cmos5l_fill_1
XFILLER_672_21 VPWR VGND sg13cmos5l_decap_8
XFILLER_315_153 VPWR VGND sg13cmos5l_decap_8
XFILLER_308_50 VPWR VGND sg13cmos5l_decap_8
XFILLER_315_164 VPWR VGND sg13cmos5l_fill_1
XFILLER_308_61 VPWR VGND sg13cmos5l_fill_2
X_2461_ _2461_/Q Tile_X0Y6_FrameData[10] VGND VPWR Tile_X0Y9_FrameStrobe[0] latch
XFILLER_181_181 VPWR VGND sg13cmos5l_decap_8
XFILLER_315_197 VPWR VGND sg13cmos5l_fill_2
XFILLER_181_192 VPWR VGND sg13cmos5l_fill_1
X_4200_ _4200_/X Tile_X0Y4_W1END[2] Tile_X0Y4_W6END[6] _4350_/X _4306_/X _2177_/Q
+ _2176_/Q VPWR VGND sg13cmos5l_mux4_1
X_1412_ _1412_/Q Tile_X0Y1_FrameData[21] VGND VPWR Tile_X0Y9_FrameStrobe[7] latch
X_2392_ _2392_/Q Tile_X0Y5_FrameData[13] VGND VPWR Tile_X0Y9_FrameStrobe[6] latch
XFILLER_244_49 VPWR VGND sg13cmos5l_decap_8
X_4131_ _4131_/X Tile_X0Y4_W2MID[6] Tile_X0Y4_W2END[6] Tile_X0Y4_W6END[6] _4315_/X
+ _2171_/Q _2170_/Q VPWR VGND sg13cmos5l_mux4_1
XFILLER_618_132 VPWR VGND sg13cmos5l_fill_2
XFILLER_605_92 VPWR VGND sg13cmos5l_fill_1
X_1343_ _1343_/Q Tile_X0Y1_FrameData[26] VGND VPWR Tile_X0Y9_FrameStrobe[5] latch
XFILLER_541_14 VPWR VGND sg13cmos5l_decap_8
XFILLER_95_121 VPWR VGND sg13cmos5l_decap_8
XFILLER_491_119 VPWR VGND sg13cmos5l_decap_8
XFILLER_3_63 VPWR VGND sg13cmos5l_decap_8
XFILLER_324_60 VPWR VGND sg13cmos5l_fill_2
XANTENNA__3352__X Tile_X0Y2_FrameData_O[23] VPWR VGND sg13cmos5l_antennanp
XFILLER_417_216 VPWR VGND sg13cmos5l_fill_2
XFILLER_283_211 VPWR VGND sg13cmos5l_fill_1
XFILLER_95_154 VPWR VGND sg13cmos5l_decap_8
X_4062_ _4062_/X Tile_X0Y2_WW4END[9] AXI_M_SOC_AWREADY _4125_/X _4099_/X _1549_/Q
+ _1548_/Q VPWR VGND sg13cmos5l_mux4_1
X_1274_ _1274_/Q Tile_X0Y1_FrameData[31] VGND VPWR Tile_X0Y9_FrameStrobe[3] latch
X_3013_ Tile_X0Y5_E6BEG[0] _4404_/X VPWR VGND sg13cmos5l_buf_1
X_0225_ _0225_/Q Tile_X0Y7_FrameData[30] VGND VPWR Tile_X0Y9_FrameStrobe[2] latch
XFILLER_432_208 VPWR VGND sg13cmos5l_fill_1
XFILLER_621_91 VPWR VGND sg13cmos5l_decap_4
X_0156_ _0156_/X _4447_/X _4448_/X _1354_/Q VPWR VGND sg13cmos5l_mux2_1
XFILLER_340_70 VPWR VGND sg13cmos5l_decap_8
XFILLER_397_134 VPWR VGND sg13cmos5l_decap_8
XFILLER_251_163 VPWR VGND sg13cmos5l_fill_1
X_0087_ _0087_/X _4218_/X _4219_/X _0383_/Q VPWR VGND sg13cmos5l_mux2_1
XFILLER_697_84 VPWR VGND sg13cmos5l_decap_8
XFILLER_269_35 VPWR VGND sg13cmos5l_decap_8
X_3915_ _3915_/X _4122_/X _4126_/X _4107_/X _4101_/X _1643_/Q _1642_/Q VPWR VGND sg13cmos5l_mux4_1
X_4895_ _4895_/X Tile_X0Y9_N1END[3] Tile_X0Y9_W6END[3] _4899_/X _4895_/A3 _0673_/Q
+ _0928_/Q VPWR VGND sg13cmos5l_mux4_1
X_3846_ _3846_/X Tile_X0Y0_W2MID[6] _3882_/X _3886_/X _3854_/X _1013_/Q _1012_/Q VPWR
+ VGND sg13cmos5l_mux4_1
XFILLER_419_49 VPWR VGND sg13cmos5l_decap_8
XFILLER_22_28 VPWR VGND sg13cmos5l_decap_8
XFILLER_353_204 VPWR VGND sg13cmos5l_fill_2
XFILLER_566_77 VPWR VGND sg13cmos5l_decap_8
XFILLER_138_28 VPWR VGND sg13cmos5l_decap_8
X_3777_ _3777_/X Tile_X0Y0_WW4END[6] Tile_X0Y0_WW4END[14] Tile_X0Y0_W6END[6] _3887_/X
+ _0997_/Q _0996_/Q VPWR VGND sg13cmos5l_mux4_1
XFILLER_554_186 VPWR VGND sg13cmos5l_decap_8
XFILLER_716_25 VPWR VGND sg13cmos5l_fill_1
X_0989_ _0989_/Q Tile_X0Y0_FrameData[14] VGND VPWR Tile_X0Y9_FrameStrobe[1] latch
XANTENNA__3527__X Tile_X0Y9_E2BEG[1] VPWR VGND sg13cmos5l_antennanp
XFILLER_703_128 VPWR VGND sg13cmos5l_fill_1
XFILLER_285_56 VPWR VGND sg13cmos5l_decap_8
X_2728_ _4893_/A3 VPWR VGND sg13cmos5l_tielo
XFILLER_582_21 VPWR VGND sg13cmos5l_decap_8
XFILLER_306_153 VPWR VGND sg13cmos5l_fill_1
XFILLER_711_161 VPWR VGND sg13cmos5l_decap_8
X_2659_ _2659_/Q Tile_X0Y6_FrameData[4] VGND VPWR Tile_X0Y9_FrameStrobe[6] latch
XFILLER_172_192 VPWR VGND sg13cmos5l_fill_2
XFILLER_467_116 VPWR VGND sg13cmos5l_decap_8
XFILLER_154_27 VPWR VGND sg13cmos5l_decap_8
XFILLER_154_38 VPWR VGND sg13cmos5l_fill_1
XFILLER_582_98 VPWR VGND sg13cmos5l_decap_8
XFILLER_515_70 VPWR VGND sg13cmos5l_decap_8
X_4329_ _4329_/X _3887_/X _3868_/X _3867_/X _3854_/X _1111_/Q _1110_/Q VPWR VGND sg13cmos5l_mux4_1
XFILLER_451_14 VPWR VGND sg13cmos5l_decap_8
XANTENNA__3262__X Tile_X0Y0_FrameData_O[30] VPWR VGND sg13cmos5l_antennanp
XFILLER_624_102 VPWR VGND sg13cmos5l_decap_4
XFILLER_609_187 VPWR VGND sg13cmos5l_decap_8
XFILLER_86_176 VPWR VGND sg13cmos5l_decap_8
XFILLER_601_28 VPWR VGND sg13cmos5l_decap_8
XFILLER_270_7 VPWR VGND sg13cmos5l_decap_8
XFILLER_170_48 VPWR VGND sg13cmos5l_decap_8
XFILLER_368_7 VPWR VGND sg13cmos5l_decap_8
XFILLER_103_42 VPWR VGND sg13cmos5l_decap_8
XFILLER_388_112 VPWR VGND sg13cmos5l_decap_8
XFILLER_250_70 VPWR VGND sg13cmos5l_decap_8
XFILLER_242_141 VPWR VGND sg13cmos5l_decap_8
XFILLER_63_35 VPWR VGND sg13cmos5l_decap_4
XFILLER_250_92 VPWR VGND sg13cmos5l_decap_8
XFILLER_535_7 VPWR VGND sg13cmos5l_decap_8
XFILLER_187_207 VPWR VGND sg13cmos5l_fill_1
XFILLER_400_62 VPWR VGND sg13cmos5l_decap_8
XFILLER_179_57 VPWR VGND sg13cmos5l_decap_8
XFILLER_400_73 VPWR VGND sg13cmos5l_fill_1
XFILLER_329_212 VPWR VGND sg13cmos5l_decap_4
XFILLER_702_7 VPWR VGND sg13cmos5l_decap_8
XFILLER_10_110 VPWR VGND sg13cmos5l_fill_1
XFILLER_476_55 VPWR VGND sg13cmos5l_decap_8
XFILLER_155_115 VPWR VGND sg13cmos5l_fill_1
XFILLER_626_14 VPWR VGND sg13cmos5l_decap_8
XFILLER_155_137 VPWR VGND sg13cmos5l_decap_8
XFILLER_6_136 VPWR VGND sg13cmos5l_fill_1
XFILLER_195_56 VPWR VGND sg13cmos5l_decap_8
XANTENNA__3437__X Tile_X0Y4_FrameData_O[28] VPWR VGND sg13cmos5l_antennanp
XFILLER_492_21 VPWR VGND sg13cmos5l_decap_8
XFILLER_163_170 VPWR VGND sg13cmos5l_decap_8
XFILLER_88_32 VPWR VGND sg13cmos5l_fill_1
XFILLER_458_105 VPWR VGND sg13cmos5l_decap_8
XFILLER_706_91 VPWR VGND sg13cmos5l_decap_8
XFILLER_88_54 VPWR VGND sg13cmos5l_decap_8
XFILLER_5_0 VPWR VGND sg13cmos5l_decap_8
XFILLER_492_98 VPWR VGND sg13cmos5l_decap_8
XFILLER_642_35 VPWR VGND sg13cmos5l_decap_8
XFILLER_111_207 VPWR VGND sg13cmos5l_fill_2
XFILLER_425_70 VPWR VGND sg13cmos5l_decap_8
XFILLER_394_0 VPWR VGND sg13cmos5l_decap_8
XFILLER_361_14 VPWR VGND sg13cmos5l_decap_8
XANTENNA__3172__X Tile_X0Y4_E6BEG[9] VPWR VGND sg13cmos5l_antennanp
XFILLER_77_154 VPWR VGND sg13cmos5l_fill_1
XFILLER_77_176 VPWR VGND sg13cmos5l_decap_8
XFILLER_561_0 VPWR VGND sg13cmos5l_decap_8
XFILLER_92_113 VPWR VGND sg13cmos5l_decap_8
XFILLER_659_0 VPWR VGND sg13cmos5l_decap_8
XFILLER_481_152 VPWR VGND sg13cmos5l_decap_4
XFILLER_511_28 VPWR VGND sg13cmos5l_decap_8
XFILLER_630_105 VPWR VGND sg13cmos5l_decap_8
XFILLER_568_201 VPWR VGND sg13cmos5l_fill_2
XFILLER_37_91 VPWR VGND sg13cmos5l_fill_1
XFILLER_379_134 VPWR VGND sg13cmos5l_fill_2
XFILLER_233_141 VPWR VGND sg13cmos5l_decap_8
XFILLER_667_21 VPWR VGND sg13cmos5l_decap_8
XFILLER_667_32 VPWR VGND sg13cmos5l_fill_2
XFILLER_528_109 VPWR VGND sg13cmos5l_decap_8
XFILLER_394_115 VPWR VGND sg13cmos5l_decap_8
X_1961_ _1961_/Q Tile_X0Y4_FrameData[28] VGND VPWR Tile_X0Y9_FrameStrobe[1] latch
XFILLER_394_137 VPWR VGND sg13cmos5l_decap_4
XFILLER_394_148 VPWR VGND sg13cmos5l_decap_8
X_3700_ AXI_M_SOC_WDATA10 Tile_X0Y7_WW4END[2] Tile_X0Y7_WW4END[10] Tile_X0Y7_W6END[10]
+ _4694_/X _0227_/Q _0226_/Q VPWR VGND sg13cmos5l_mux4_1
X_0912_ _0912_/Q Tile_X0Y9_FrameData[15] VGND VPWR Tile_X0Y9_FrameStrobe[7] latch
X_4680_ _4680_/X Tile_X0Y3_W1END[2] Tile_X0Y3_WW4END[14] Tile_X0Y3_W6END[6] _4224_/X
+ _1859_/Q _1858_/Q VPWR VGND sg13cmos5l_mux4_1
X_1892_ _1892_/Q Tile_X0Y3_FrameData[5] VGND VPWR Tile_X0Y9_FrameStrobe[6] latch
X_3631_ Tile_X0Y9_S4BEG[9] _3631_/A VPWR VGND sg13cmos5l_buf_1
X_0843_ _0843_/Q Tile_X0Y9_FrameData[20] VGND VPWR Tile_X0Y9_FrameStrobe[5] latch
XFILLER_551_101 VPWR VGND sg13cmos5l_fill_1
XFILLER_536_14 VPWR VGND sg13cmos5l_decap_8
XFILLER_146_137 VPWR VGND sg13cmos5l_decap_8
XFILLER_697_105 VPWR VGND sg13cmos5l_fill_1
XFILLER_536_197 VPWR VGND sg13cmos5l_decap_8
XANTENNA__3347__X Tile_X0Y2_FrameData_O[18] VPWR VGND sg13cmos5l_antennanp
XFILLER_683_42 VPWR VGND sg13cmos5l_decap_8
X_3562_ Tile_X0Y9_EE4BEG[8] _4872_/X VPWR VGND sg13cmos5l_buf_1
X_0774_ _0774_/Q Tile_X0Y9_FrameData[25] VGND VPWR Tile_X0Y9_FrameStrobe[3] latch
XFILLER_161_129 VPWR VGND sg13cmos5l_decap_8
X_2513_ _2513_/Q Tile_X0Y6_FrameData[22] VGND VPWR Tile_X0Y9_FrameStrobe[2] latch
X_3493_ Tile_X0Y1_E6BEG[3] _3967_/X VPWR VGND sg13cmos5l_buf_1
XFILLER_638_205 VPWR VGND sg13cmos5l_fill_1
XFILLER_616_91 VPWR VGND sg13cmos5l_decap_4
X_2444_ _2444_/Q Tile_X0Y6_FrameData[27] VGND VPWR Tile_X0Y9_FrameStrobe[0] latch
XFILLER_102_207 VPWR VGND sg13cmos5l_decap_4
XFILLER_552_35 VPWR VGND sg13cmos5l_decap_8
XFILLER_271_14 VPWR VGND sg13cmos5l_decap_8
X_2375_ _2375_/Q Tile_X0Y5_FrameData[30] VGND VPWR Tile_X0Y9_FrameStrobe[6] latch
XANTENNA__3082__X Tile_X0Y7_E1BEG[0] VPWR VGND sg13cmos5l_antennanp
X_4114_ _4114_/X Tile_X0Y6_W1END[3] Tile_X0Y6_WW4END[3] Tile_X0Y6_W6END[11] _4571_/X
+ _2662_/Q _2661_/Q VPWR VGND sg13cmos5l_mux4_1
X_1326_ _1326_/Q Tile_X0Y1_FrameData[11] VGND VPWR Tile_X0Y9_FrameStrobe[4] latch
XFILLER_702_49 VPWR VGND sg13cmos5l_decap_8
XFILLER_68_176 VPWR VGND sg13cmos5l_decap_8
XFILLER_83_124 VPWR VGND sg13cmos5l_decap_8
X_4045_ _4045_/X Tile_X0Y2_W2MID[2] AXI_M_SOC_AWREADY _4101_/X _4100_/X _1583_/Q _1582_/Q
+ VPWR VGND sg13cmos5l_mux4_1
XFILLER_421_28 VPWR VGND sg13cmos5l_decap_8
XFILLER_204_63 VPWR VGND sg13cmos5l_decap_8
X_1257_ _1257_/Q Tile_X0Y1_FrameData[16] VGND VPWR Tile_X0Y9_FrameStrobe[2] latch
XFILLER_216_119 VPWR VGND sg13cmos5l_decap_8
XFILLER_17_28 VPWR VGND sg13cmos5l_decap_8
XFILLER_351_91 VPWR VGND sg13cmos5l_decap_8
X_0208_ _0208_/Q Tile_X0Y7_FrameData[15] VGND VPWR Tile_X0Y9_FrameStrobe[1] latch
XFILLER_209_193 VPWR VGND sg13cmos5l_fill_2
X_1188_ _1188_/Q Tile_X0Y1_FrameData[21] VGND VPWR Tile_X0Y9_FrameStrobe[0] latch
XFILLER_621_149 VPWR VGND sg13cmos5l_decap_8
XFILLER_614_190 VPWR VGND sg13cmos5l_decap_8
X_0139_ AXI_M_SOC_ARLEN0 _0933_/Q _3760_/X VPWR VGND sg13cmos5l_nor2b_1
XFILLER_577_21 VPWR VGND sg13cmos5l_decap_8
XFILLER_220_95 VPWR VGND sg13cmos5l_decap_8
XFILLER_33_49 VPWR VGND sg13cmos5l_fill_2
XFILLER_149_27 VPWR VGND sg13cmos5l_decap_8
XFILLER_577_98 VPWR VGND sg13cmos5l_decap_8
X_4878_ _4878_/X Tile_X0Y9_WW4END[1] AXI_M_SOC_RDATA1 _4917_/X _4903_/X _0787_/Q _0786_/Q
+ VPWR VGND sg13cmos5l_mux4_1
XFILLER_296_77 VPWR VGND sg13cmos5l_decap_8
XFILLER_137_126 VPWR VGND sg13cmos5l_decap_4
X_3829_ _3829_/X Tile_X0Y0_WW4END[6] Tile_X0Y0_WW4END[7] _3887_/X _3854_/X _1047_/Q
+ _1046_/Q VPWR VGND sg13cmos5l_mux4_1
XFILLER_446_14 VPWR VGND sg13cmos5l_decap_8
XFILLER_393_181 VPWR VGND sg13cmos5l_decap_8
XFILLER_393_192 VPWR VGND sg13cmos5l_fill_1
XANTENNA__3257__X Tile_X0Y0_FrameData_O[25] VPWR VGND sg13cmos5l_antennanp
XFILLER_593_42 VPWR VGND sg13cmos5l_decap_8
XFILLER_542_189 VPWR VGND sg13cmos5l_decap_4
XFILLER_3_128 VPWR VGND sg13cmos5l_decap_8
XFILLER_629_216 VPWR VGND sg13cmos5l_fill_2
XFILLER_160_140 VPWR VGND sg13cmos5l_decap_8
XFILLER_462_35 VPWR VGND sg13cmos5l_decap_8
XFILLER_245_70 VPWR VGND sg13cmos5l_decap_4
XFILLER_181_14 VPWR VGND sg13cmos5l_fill_1
XFILLER_485_7 VPWR VGND sg13cmos5l_decap_8
XFILLER_455_119 VPWR VGND sg13cmos5l_decap_8
XFILLER_58_68 VPWR VGND sg13cmos5l_decap_8
XFILLER_448_193 VPWR VGND sg13cmos5l_decap_8
XFILLER_612_49 VPWR VGND sg13cmos5l_decap_8
XFILLER_59_176 VPWR VGND sg13cmos5l_decap_8
XFILLER_59_187 VPWR VGND sg13cmos5l_fill_1
XFILLER_114_41 VPWR VGND sg13cmos5l_decap_8
XFILLER_331_28 VPWR VGND sg13cmos5l_decap_8
XFILLER_652_7 VPWR VGND sg13cmos5l_decap_8
XFILLER_612_105 VPWR VGND sg13cmos5l_decap_8
XFILLER_463_185 VPWR VGND sg13cmos5l_decap_8
XANTENNA__3720__X AXI_M_SOC_WDATA30 VPWR VGND sg13cmos5l_antennanp
XFILLER_261_91 VPWR VGND sg13cmos5l_decap_8
XFILLER_215_152 VPWR VGND sg13cmos5l_decap_8
XFILLER_215_163 VPWR VGND sg13cmos5l_fill_2
XFILLER_487_21 VPWR VGND sg13cmos5l_decap_8
XFILLER_130_84 VPWR VGND sg13cmos5l_decap_8
XFILLER_230_155 VPWR VGND sg13cmos5l_decap_8
XFILLER_142_0 VPWR VGND sg13cmos5l_decap_8
XFILLER_487_98 VPWR VGND sg13cmos5l_decap_4
XFILLER_391_107 VPWR VGND sg13cmos5l_decap_4
XFILLER_637_35 VPWR VGND sg13cmos5l_decap_8
XFILLER_317_215 VPWR VGND sg13cmos5l_fill_2
XFILLER_518_186 VPWR VGND sg13cmos5l_decap_8
XFILLER_356_14 VPWR VGND sg13cmos5l_decap_8
XFILLER_23_82 VPWR VGND sg13cmos5l_fill_2
XFILLER_518_197 VPWR VGND sg13cmos5l_fill_2
XFILLER_128_148 VPWR VGND sg13cmos5l_decap_8
XANTENNA__3167__X Tile_X0Y4_E6BEG[4] VPWR VGND sg13cmos5l_antennanp
XFILLER_407_0 VPWR VGND sg13cmos5l_decap_8
XFILLER_679_149 VPWR VGND sg13cmos5l_fill_1
XFILLER_506_28 VPWR VGND sg13cmos5l_decap_8
XFILLER_297_111 VPWR VGND sg13cmos5l_decap_8
XFILLER_653_56 VPWR VGND sg13cmos5l_decap_8
XFILLER_97_205 VPWR VGND sg13cmos5l_fill_2
XFILLER_297_133 VPWR VGND sg13cmos5l_fill_2
X_0490_ _0490_/Q Tile_X0Y8_FrameData[21] VGND VPWR Tile_X0Y9_FrameStrobe[2] latch
XFILLER_372_35 VPWR VGND sg13cmos5l_decap_8
XFILLER_300_115 VPWR VGND sg13cmos5l_decap_8
XFILLER_297_177 VPWR VGND sg13cmos5l_decap_8
XFILLER_155_92 VPWR VGND sg13cmos5l_decap_8
XFILLER_151_195 VPWR VGND sg13cmos5l_decap_8
XFILLER_238_211 VPWR VGND sg13cmos5l_decap_8
X_2160_ _2160_/Q Tile_X0Y4_FrameData[21] VGND VPWR Tile_X0Y9_FrameStrobe[7] latch
XFILLER_522_49 VPWR VGND sg13cmos5l_decap_8
XFILLER_454_130 VPWR VGND sg13cmos5l_decap_8
XFILLER_305_95 VPWR VGND sg13cmos5l_decap_8
X_1111_ _1111_/Q Tile_X0Y0_FrameData[20] VGND VPWR Tile_X0Y9_FrameStrobe[5] latch
XFILLER_65_124 VPWR VGND sg13cmos5l_decap_8
XFILLER_241_28 VPWR VGND sg13cmos5l_decap_8
X_2091_ _2091_/Q Tile_X0Y4_FrameData[26] VGND VPWR Tile_X0Y9_FrameStrobe[5] latch
XANTENNA__3630__X Tile_X0Y9_S4BEG[8] VPWR VGND sg13cmos5l_antennanp
X_1042_ _1042_/Q Tile_X0Y0_FrameData[25] VGND VPWR Tile_X0Y9_FrameStrobe[3] latch
XFILLER_0_42 VPWR VGND sg13cmos5l_decap_8
XFILLER_80_127 VPWR VGND sg13cmos5l_fill_1
XFILLER_678_42 VPWR VGND sg13cmos5l_decap_8
XFILLER_80_149 VPWR VGND sg13cmos5l_fill_2
XFILLER_206_163 VPWR VGND sg13cmos5l_decap_8
XFILLER_206_174 VPWR VGND sg13cmos5l_fill_2
XFILLER_397_21 VPWR VGND sg13cmos5l_decap_8
X_4801_ _4801_/X _4779_/X Tile_X0Y9_N4END[5] _4778_/X _0076_/X _0469_/Q _0468_/Q VPWR
+ VGND sg13cmos5l_mux4_1
X_2993_ Tile_X0Y5_E1BEG[0] _4368_/X VPWR VGND sg13cmos5l_buf_1
X_1944_ _1944_/Q Tile_X0Y4_FrameData[13] VGND VPWR Tile_X0Y9_FrameStrobe[0] latch
X_4732_ _4732_/X Tile_X0Y8_W2MID[3] AXI_M_SOC_RDATA12 _4791_/X _4790_/X _0583_/Q _0582_/Q
+ VPWR VGND sg13cmos5l_mux4_1
XFILLER_547_35 VPWR VGND sg13cmos5l_decap_8
XFILLER_9_84 VPWR VGND sg13cmos5l_decap_4
XFILLER_509_175 VPWR VGND sg13cmos5l_fill_2
XFILLER_382_129 VPWR VGND sg13cmos5l_decap_8
XFILLER_119_126 VPWR VGND sg13cmos5l_decap_8
X_4663_ _4663_/X Tile_X0Y8_W1END[1] Tile_X0Y8_W6END[5] _4813_/X _4773_/X _0669_/Q
+ _0668_/Q VPWR VGND sg13cmos5l_mux4_1
XFILLER_694_63 VPWR VGND sg13cmos5l_decap_8
XFILLER_266_14 VPWR VGND sg13cmos5l_decap_8
X_1875_ _1875_/Q Tile_X0Y3_FrameData[22] VGND VPWR Tile_X0Y9_FrameStrobe[6] latch
XFILLER_524_112 VPWR VGND sg13cmos5l_decap_8
XANTENNA__3077__X Tile_X0Y4_E2BEGb[3] VPWR VGND sg13cmos5l_antennanp
X_3614_ Tile_X0Y9_S2BEGb[0] _4932_/X VPWR VGND sg13cmos5l_buf_1
X_0826_ _0826_/Q Tile_X0Y9_FrameData[5] VGND VPWR Tile_X0Y9_FrameStrobe[4] latch
X_4594_ _4594_/X Tile_X0Y5_W1END[1] Tile_X0Y5_W2MID[2] Tile_X0Y5_W2END[2] _4431_/X
+ _2385_/Q _2384_/Q VPWR VGND sg13cmos5l_mux4_1
XFILLER_323_207 VPWR VGND sg13cmos5l_decap_4
XFILLER_524_189 VPWR VGND sg13cmos5l_decap_8
X_3545_ Tile_X0Y9_E6BEG[3] _4883_/X VPWR VGND sg13cmos5l_buf_1
XFILLER_416_28 VPWR VGND sg13cmos5l_decap_8
X_0757_ _0757_/Q Tile_X0Y9_FrameData[10] VGND VPWR Tile_X0Y9_FrameStrobe[2] latch
XFILLER_563_56 VPWR VGND sg13cmos5l_decap_8
XFILLER_346_91 VPWR VGND sg13cmos5l_decap_8
XFILLER_88_205 VPWR VGND sg13cmos5l_decap_4
X_3476_ Tile_X0Y1_EE4BEG[2] _3950_/X VPWR VGND sg13cmos5l_buf_1
X_0688_ _0688_/Q Tile_X0Y9_FrameData[15] VGND VPWR Tile_X0Y9_FrameStrobe[0] latch
XFILLER_282_35 VPWR VGND sg13cmos5l_decap_8
X_2427_ _2427_/Q Tile_X0Y5_FrameData[10] VGND VPWR Tile_X0Y9_FrameStrobe[7] latch
X_2358_ _2358_/Q Tile_X0Y5_FrameData[15] VGND VPWR Tile_X0Y9_FrameStrobe[5] latch
XFILLER_432_49 VPWR VGND sg13cmos5l_decap_8
XFILLER_56_102 VPWR VGND sg13cmos5l_decap_8
XFILLER_215_84 VPWR VGND sg13cmos5l_decap_8
XFILLER_28_49 VPWR VGND sg13cmos5l_decap_8
X_1309_ _1309_/Q Tile_X0Y1_FrameData[28] VGND VPWR Tile_X0Y9_FrameStrobe[4] latch
XFILLER_151_28 VPWR VGND sg13cmos5l_decap_8
X_2289_ _2289_/Q Tile_X0Y5_FrameData[20] VGND VPWR Tile_X0Y9_FrameStrobe[3] latch
XANTENNA__3540__X Tile_X0Y9_E2BEGb[6] VPWR VGND sg13cmos5l_antennanp
X_4028_ _4028_/X Tile_X0Y0_W1END[0] Tile_X0Y0_W2MID[3] Tile_X0Y0_W2END[3] _3858_/X
+ _1125_/Q _1124_/Q VPWR VGND sg13cmos5l_mux4_1
XFILLER_588_42 VPWR VGND sg13cmos5l_decap_4
XFILLER_212_111 VPWR VGND sg13cmos5l_decap_8
XFILLER_358_126 VPWR VGND sg13cmos5l_decap_8
XFILLER_233_7 VPWR VGND sg13cmos5l_decap_8
XFILLER_212_188 VPWR VGND sg13cmos5l_decap_8
XFILLER_60_14 VPWR VGND sg13cmos5l_decap_8
XFILLER_457_35 VPWR VGND sg13cmos5l_decap_8
XFILLER_226_6 VPWR VGND sg13cmos5l_decap_8
XFILLER_176_14 VPWR VGND sg13cmos5l_decap_8
XFILLER_400_7 VPWR VGND sg13cmos5l_decap_8
XFILLER_515_156 VPWR VGND sg13cmos5l_fill_1
XFILLER_607_49 VPWR VGND sg13cmos5l_decap_8
XFILLER_515_178 VPWR VGND sg13cmos5l_decap_8
XFILLER_118_170 VPWR VGND sg13cmos5l_decap_8
XANTENNA__0123__Y AXI_M_SOC_ARSIZE2 VPWR VGND sg13cmos5l_antennanp
XFILLER_326_28 VPWR VGND sg13cmos5l_decap_4
XFILLER_326_39 VPWR VGND sg13cmos5l_decap_8
XFILLER_669_160 VPWR VGND sg13cmos5l_fill_2
XFILLER_279_111 VPWR VGND sg13cmos5l_decap_8
XANTENNA__3715__X AXI_M_SOC_WDATA25 VPWR VGND sg13cmos5l_antennanp
XFILLER_256_91 VPWR VGND sg13cmos5l_decap_4
XFILLER_133_140 VPWR VGND sg13cmos5l_decap_8
XFILLER_109_96 VPWR VGND sg13cmos5l_decap_8
XFILLER_79_205 VPWR VGND sg13cmos5l_fill_2
XFILLER_69_67 VPWR VGND sg13cmos5l_decap_8
XFILLER_192_35 VPWR VGND sg13cmos5l_decap_8
XFILLER_428_119 VPWR VGND sg13cmos5l_decap_8
XFILLER_294_114 VPWR VGND sg13cmos5l_fill_2
XFILLER_342_49 VPWR VGND sg13cmos5l_decap_8
XFILLER_125_84 VPWR VGND sg13cmos5l_decap_8
XFILLER_703_70 VPWR VGND sg13cmos5l_decap_8
XFILLER_85_77 VPWR VGND sg13cmos5l_decap_8
XANTENNA__3450__X Tile_X0Y1_FrameData_O[8] VPWR VGND sg13cmos5l_antennanp
XFILLER_498_42 VPWR VGND sg13cmos5l_decap_8
XFILLER_451_166 VPWR VGND sg13cmos5l_fill_1
XFILLER_357_0 VPWR VGND sg13cmos5l_decap_8
XFILLER_250_217 VPWR VGND sg13cmos5l_fill_1
XFILLER_451_188 VPWR VGND sg13cmos5l_decap_8
XFILLER_203_133 VPWR VGND sg13cmos5l_decap_8
XFILLER_70_171 VPWR VGND sg13cmos5l_decap_8
XFILLER_524_0 VPWR VGND sg13cmos5l_decap_8
XFILLER_648_56 VPWR VGND sg13cmos5l_decap_8
XFILLER_203_177 VPWR VGND sg13cmos5l_fill_2
XFILLER_367_35 VPWR VGND sg13cmos5l_decap_8
XFILLER_34_92 VPWR VGND sg13cmos5l_decap_4
XFILLER_156_210 VPWR VGND sg13cmos5l_fill_1
X_1660_ _1660_/Q Tile_X0Y2_FrameData[21] VGND VPWR Tile_X0Y9_FrameStrobe[7] latch
XFILLER_517_49 VPWR VGND sg13cmos5l_decap_8
XFILLER_305_207 VPWR VGND sg13cmos5l_decap_8
XFILLER_50_80 VPWR VGND sg13cmos5l_decap_4
X_0611_ _0611_/Q Tile_X0Y8_FrameData[28] VGND VPWR Tile_X0Y9_FrameStrobe[6] latch
XFILLER_664_77 VPWR VGND sg13cmos5l_decap_8
XFILLER_506_189 VPWR VGND sg13cmos5l_fill_2
XFILLER_664_88 VPWR VGND sg13cmos5l_fill_1
XFILLER_236_28 VPWR VGND sg13cmos5l_decap_8
X_1591_ _1591_/Q Tile_X0Y2_FrameData[26] VGND VPWR Tile_X0Y9_FrameStrobe[5] latch
XANTENNA__3625__X Tile_X0Y9_S4BEG[3] VPWR VGND sg13cmos5l_antennanp
XFILLER_166_91 VPWR VGND sg13cmos5l_decap_4
X_3330_ Tile_X0Y2_FrameData_O[1] Tile_X0Y2_FrameData[1] VPWR VGND sg13cmos5l_buf_1
XFILLER_521_159 VPWR VGND sg13cmos5l_decap_8
XFILLER_124_140 VPWR VGND sg13cmos5l_decap_4
X_0542_ _0542_/Q Tile_X0Y8_FrameData[1] VGND VPWR Tile_X0Y9_FrameStrobe[3] latch
XFILLER_383_78 VPWR VGND sg13cmos5l_decap_8
XFILLER_680_21 VPWR VGND sg13cmos5l_decap_8
XFILLER_316_61 VPWR VGND sg13cmos5l_decap_8
X_3261_ Tile_X0Y0_FrameData_O[29] Tile_X0Y0_FrameData[29] VPWR VGND sg13cmos5l_buf_1
XFILLER_675_152 VPWR VGND sg13cmos5l_fill_1
X_0473_ _0473_/Q Tile_X0Y8_FrameData[6] VGND VPWR Tile_X0Y9_FrameStrobe[1] latch
XFILLER_316_83 VPWR VGND sg13cmos5l_decap_8
X_2212_ _2212_/Q Tile_X0Y5_FrameData[1] VGND VPWR Tile_X0Y9_FrameStrobe[0] latch
XFILLER_680_98 VPWR VGND sg13cmos5l_fill_2
X_3192_ Tile_X0Y0_N2BEGb[0] _3889_/X VPWR VGND sg13cmos5l_buf_1
XFILLER_613_70 VPWR VGND sg13cmos5l_decap_8
X_2143_ _2143_/Q Tile_X0Y4_FrameData[6] VGND VPWR Tile_X0Y9_FrameStrobe[6] latch
XANTENNA__3360__X Tile_X0Y2_FrameData_O[31] VPWR VGND sg13cmos5l_antennanp
XFILLER_588_115 VPWR VGND sg13cmos5l_fill_1
XFILLER_442_133 VPWR VGND sg13cmos5l_decap_4
X_2074_ _2074_/Q Tile_X0Y4_FrameData[11] VGND VPWR Tile_X0Y9_FrameStrobe[4] latch
XFILLER_689_63 VPWR VGND sg13cmos5l_decap_4
XFILLER_442_166 VPWR VGND sg13cmos5l_decap_8
X_1025_ _1025_/Q Tile_X0Y0_FrameData[10] VGND VPWR Tile_X0Y9_FrameStrobe[2] latch
XFILLER_201_42 VPWR VGND sg13cmos5l_decap_8
XFILLER_529_215 VPWR VGND sg13cmos5l_fill_2
XFILLER_558_56 VPWR VGND sg13cmos5l_decap_8
XFILLER_61_193 VPWR VGND sg13cmos5l_decap_8
X_2976_ Tile_X0Y8_FrameData_O[16] Tile_X0Y8_FrameData[16] VPWR VGND sg13cmos5l_buf_1
XFILLER_558_78 VPWR VGND sg13cmos5l_decap_8
XFILLER_277_35 VPWR VGND sg13cmos5l_decap_8
X_4715_ _4715_/X Tile_X0Y9_W2MID[0] Tile_X0Y9_W2END[0] Tile_X0Y9_W6END[0] _4900_/X
+ _0905_/Q _0904_/Q VPWR VGND sg13cmos5l_mux4_1
X_1927_ _1927_/Q Tile_X0Y4_FrameData[30] VGND VPWR Tile_X0Y9_FrameStrobe[0] latch
X_1858_ _1858_/Q Tile_X0Y3_FrameData[7] VGND VPWR Tile_X0Y9_FrameStrobe[5] latch
X_4646_ _4646_/X Tile_X0Y9_N4END[10] _0054_/X _4693_/X _4697_/X _0267_/Q _0266_/Q
+ VPWR VGND sg13cmos5l_mux4_1
XFILLER_30_28 VPWR VGND sg13cmos5l_decap_8
XFILLER_427_49 VPWR VGND sg13cmos5l_decap_8
XFILLER_107_118 VPWR VGND sg13cmos5l_decap_8
X_0809_ _0809_/Q Tile_X0Y9_FrameData[22] VGND VPWR Tile_X0Y9_FrameStrobe[4] latch
XFILLER_146_28 VPWR VGND sg13cmos5l_decap_8
X_4577_ _4577_/X _4547_/X Tile_X0Y9_N4END[13] _4546_/X _0153_/X _2477_/Q _2476_/Q
+ VPWR VGND sg13cmos5l_mux4_1
X_1789_ _1789_/Q Tile_X0Y3_FrameData[12] VGND VPWR Tile_X0Y9_FrameStrobe[3] latch
XFILLER_293_56 VPWR VGND sg13cmos5l_decap_8
XANTENNA__3535__X Tile_X0Y9_E2BEGb[1] VPWR VGND sg13cmos5l_antennanp
X_3528_ Tile_X0Y9_E2BEG[2] _4850_/X VPWR VGND sg13cmos5l_buf_1
XFILLER_590_21 VPWR VGND sg13cmos5l_decap_8
XFILLER_293_89 VPWR VGND sg13cmos5l_decap_4
XFILLER_666_141 VPWR VGND sg13cmos5l_fill_1
X_3459_ Tile_X0Y1_FrameData_O[17] Tile_X0Y1_FrameData[17] VPWR VGND sg13cmos5l_buf_1
XFILLER_666_163 VPWR VGND sg13cmos5l_decap_4
XFILLER_666_174 VPWR VGND sg13cmos5l_decap_4
XFILLER_590_65 VPWR VGND sg13cmos5l_decap_4
XFILLER_666_185 VPWR VGND sg13cmos5l_decap_8
XFILLER_130_154 VPWR VGND sg13cmos5l_decap_8
XFILLER_681_133 VPWR VGND sg13cmos5l_decap_4
XFILLER_217_214 VPWR VGND sg13cmos5l_decap_4
XFILLER_183_7 VPWR VGND sg13cmos5l_decap_8
XFILLER_291_139 VPWR VGND sg13cmos5l_decap_8
XANTENNA__3270__X Tile_X0Y0_EE4BEG[6] VPWR VGND sg13cmos5l_antennanp
XFILLER_284_180 VPWR VGND sg13cmos5l_decap_8
XFILLER_242_82 VPWR VGND sg13cmos5l_decap_8
XFILLER_433_144 VPWR VGND sg13cmos5l_fill_1
XFILLER_232_206 VPWR VGND sg13cmos5l_decap_4
XFILLER_579_159 VPWR VGND sg13cmos5l_decap_8
XFILLER_350_7 VPWR VGND sg13cmos5l_decap_8
XFILLER_232_217 VPWR VGND sg13cmos5l_fill_1
XFILLER_448_7 VPWR VGND sg13cmos5l_decap_8
XANTENNA__0118__Y AXI_M_SOC_ARBURST1 VPWR VGND sg13cmos5l_antennanp
XFILLER_71_13 VPWR VGND sg13cmos5l_decap_8
XFILLER_587_181 VPWR VGND sg13cmos5l_decap_4
XFILLER_111_75 VPWR VGND sg13cmos5l_decap_8
XFILLER_468_56 VPWR VGND sg13cmos5l_decap_8
XFILLER_615_7 VPWR VGND sg13cmos5l_decap_8
XFILLER_197_176 VPWR VGND sg13cmos5l_decap_8
XFILLER_187_35 VPWR VGND sg13cmos5l_decap_8
XFILLER_354_140 VPWR VGND sg13cmos5l_decap_8
XFILLER_217_2 VPWR VGND sg13cmos5l_fill_1
XFILLER_337_49 VPWR VGND sg13cmos5l_decap_8
XFILLER_354_173 VPWR VGND sg13cmos5l_fill_1
XFILLER_354_184 VPWR VGND sg13cmos5l_decap_8
XFILLER_484_77 VPWR VGND sg13cmos5l_decap_8
XFILLER_299_217 VPWR VGND sg13cmos5l_fill_1
XFILLER_634_14 VPWR VGND sg13cmos5l_decap_8
XFILLER_503_126 VPWR VGND sg13cmos5l_decap_8
XFILLER_484_88 VPWR VGND sg13cmos5l_fill_1
XFILLER_354_195 VPWR VGND sg13cmos5l_decap_8
XFILLER_649_119 VPWR VGND sg13cmos5l_decap_8
XFILLER_105_0 VPWR VGND sg13cmos5l_fill_2
XANTENNA__3445__X Tile_X0Y1_FrameData_O[3] VPWR VGND sg13cmos5l_antennanp
XFILLER_96_21 VPWR VGND sg13cmos5l_decap_8
XFILLER_657_163 VPWR VGND sg13cmos5l_fill_2
XFILLER_672_100 VPWR VGND sg13cmos5l_decap_8
XFILLER_714_91 VPWR VGND sg13cmos5l_decap_8
XFILLER_96_87 VPWR VGND sg13cmos5l_fill_2
XFILLER_650_35 VPWR VGND sg13cmos5l_decap_8
XFILLER_433_70 VPWR VGND sg13cmos5l_decap_8
XFILLER_474_0 VPWR VGND sg13cmos5l_decap_8
XFILLER_672_166 VPWR VGND sg13cmos5l_fill_2
XFILLER_409_185 VPWR VGND sg13cmos5l_decap_4
XFILLER_275_180 VPWR VGND sg13cmos5l_decap_4
XANTENNA__3180__X Tile_X0Y0_N4BEG[4] VPWR VGND sg13cmos5l_antennanp
XFILLER_424_133 VPWR VGND sg13cmos5l_decap_8
XFILLER_641_0 VPWR VGND sg13cmos5l_decap_8
XFILLER_290_194 VPWR VGND sg13cmos5l_fill_2
XFILLER_659_77 VPWR VGND sg13cmos5l_decap_8
X_2830_ Tile_X0Y4_UserCLKo Tile_X0Y4_UserCLK VPWR VGND sg13cmos5l_buf_1
XFILLER_675_21 VPWR VGND sg13cmos5l_decap_8
XFILLER_129_210 VPWR VGND sg13cmos5l_fill_2
X_2761_ Tile_X0Y3_FrameData_O[19] Tile_X0Y3_FrameData[19] VPWR VGND sg13cmos5l_buf_1
X_1712_ _1712_/Q Tile_X0Y3_FrameData[25] VGND VPWR Tile_X0Y9_FrameStrobe[1] latch
X_4500_ _4500_/X Tile_X0Y6_W2MID[3] AXI_M_SOC_RDATA28 _4559_/X _4558_/X _2607_/Q _2606_/Q
+ VPWR VGND sg13cmos5l_mux4_1
X_2692_ _2692_/Q Tile_X0Y6_FrameData[3] VGND VPWR Tile_X0Y9_FrameStrobe[7] latch
XFILLER_345_162 VPWR VGND sg13cmos5l_decap_4
XFILLER_247_49 VPWR VGND sg13cmos5l_decap_8
XANTENNA_1 _3761_/X VPWR VGND sg13cmos5l_antennanp
X_4431_ _4431_/X _4363_/X _4479_/X _4478_/X _4362_/X _2195_/Q _2194_/Q VPWR VGND sg13cmos5l_mux4_1
X_1643_ _1643_/Q Tile_X0Y2_FrameData[6] VGND VPWR Tile_X0Y9_FrameStrobe[6] latch
XFILLER_544_14 VPWR VGND sg13cmos5l_decap_8
XFILLER_360_132 VPWR VGND sg13cmos5l_fill_2
XFILLER_6_63 VPWR VGND sg13cmos5l_decap_8
XANTENNA__3355__X Tile_X0Y2_FrameData_O[26] VPWR VGND sg13cmos5l_antennanp
XFILLER_691_42 VPWR VGND sg13cmos5l_decap_8
XFILLER_327_71 VPWR VGND sg13cmos5l_decap_4
X_4362_ _4362_/X Tile_X0Y3_W1END[1] Tile_X0Y3_W2MID[2] Tile_X0Y3_W2END[2] _4208_/X
+ _1871_/Q _1870_/Q VPWR VGND sg13cmos5l_mux4_1
X_1574_ _1574_/Q Tile_X0Y2_FrameData[11] VGND VPWR Tile_X0Y9_FrameStrobe[4] latch
XFILLER_360_176 VPWR VGND sg13cmos5l_decap_8
XFILLER_544_69 VPWR VGND sg13cmos5l_fill_2
X_3313_ Tile_X0Y4_EE4BEG[1] _4273_/X VPWR VGND sg13cmos5l_buf_1
X_0525_ _0525_/Q Tile_X0Y8_FrameData[18] VGND VPWR Tile_X0Y9_FrameStrobe[3] latch
X_4293_ _4293_/X AXI_M_SOC_BRESP1 _4342_/X _4346_/X _4315_/X _2027_/Q _2026_/Q VPWR
+ VGND sg13cmos5l_mux4_1
XFILLER_648_196 VPWR VGND sg13cmos5l_decap_8
XFILLER_624_91 VPWR VGND sg13cmos5l_decap_4
X_3244_ Tile_X0Y0_FrameData_O[12] Tile_X0Y0_FrameData[12] VPWR VGND sg13cmos5l_buf_1
X_0456_ _0456_/Q Tile_X0Y8_FrameData[23] VGND VPWR Tile_X0Y9_FrameStrobe[1] latch
XFILLER_560_35 VPWR VGND sg13cmos5l_decap_8
XFILLER_343_70 VPWR VGND sg13cmos5l_decap_8
XFILLER_20_0 VPWR VGND sg13cmos5l_decap_8
XFILLER_112_187 VPWR VGND sg13cmos5l_decap_8
XFILLER_462_217 VPWR VGND sg13cmos5l_fill_1
X_3175_ Tile_X0Y0_UserCLKo Tile_X0Y0_UserCLK VPWR VGND sg13cmos5l_buf_1
X_0387_ _0387_/Q Tile_X0Y7_FrameData[28] VGND VPWR Tile_X0Y9_FrameStrobe[7] latch
XFILLER_663_188 VPWR VGND sg13cmos5l_decap_8
XANTENNA__3090__X Tile_X0Y7_E2BEG[4] VPWR VGND sg13cmos5l_antennanp
X_2126_ _2126_/Q Tile_X0Y4_FrameData[23] VGND VPWR Tile_X0Y9_FrameStrobe[6] latch
XFILLER_710_49 VPWR VGND sg13cmos5l_decap_8
XFILLER_212_41 VPWR VGND sg13cmos5l_decap_8
XFILLER_281_161 VPWR VGND sg13cmos5l_decap_8
XFILLER_26_138 VPWR VGND sg13cmos5l_decap_8
XFILLER_214_217 VPWR VGND sg13cmos5l_fill_1
X_2057_ _2057_/Q Tile_X0Y4_FrameData[28] VGND VPWR Tile_X0Y9_FrameStrobe[4] latch
XFILLER_25_28 VPWR VGND sg13cmos5l_decap_8
X_1008_ _1008_/Q Tile_X0Y0_FrameData[27] VGND VPWR Tile_X0Y9_FrameStrobe[2] latch
XFILLER_569_77 VPWR VGND sg13cmos5l_decap_8
XFILLER_179_132 VPWR VGND sg13cmos5l_fill_1
XFILLER_288_56 VPWR VGND sg13cmos5l_decap_8
XFILLER_328_118 VPWR VGND sg13cmos5l_decap_8
XFILLER_585_21 VPWR VGND sg13cmos5l_decap_8
XFILLER_41_27 VPWR VGND sg13cmos5l_decap_8
X_2959_ Tile_X0Y8_EE4BEG[15] _4759_/X VPWR VGND sg13cmos5l_buf_1
XFILLER_518_70 VPWR VGND sg13cmos5l_decap_8
XFILLER_518_81 VPWR VGND sg13cmos5l_fill_1
X_4629_ _4629_/X Tile_X0Y7_WW4END[14] AXI_M_SOC_RDATA17 _4698_/X _4670_/X _0301_/Q
+ _0300_/Q VPWR VGND sg13cmos5l_mux4_1
XFILLER_686_203 VPWR VGND sg13cmos5l_decap_4
XFILLER_454_14 VPWR VGND sg13cmos5l_decap_8
XANTENNA__3265__X Tile_X0Y0_EE4BEG[1] VPWR VGND sg13cmos5l_antennanp
XFILLER_497_147 VPWR VGND sg13cmos5l_decap_8
XFILLER_150_216 VPWR VGND sg13cmos5l_fill_2
XFILLER_9_7 VPWR VGND sg13cmos5l_decap_8
XFILLER_173_37 VPWR VGND sg13cmos5l_decap_8
XFILLER_249_103 VPWR VGND sg13cmos5l_decap_8
XFILLER_604_28 VPWR VGND sg13cmos5l_decap_8
XFILLER_398_7 VPWR VGND sg13cmos5l_decap_8
XFILLER_249_125 VPWR VGND sg13cmos5l_decap_8
XFILLER_470_35 VPWR VGND sg13cmos5l_decap_8
XFILLER_253_81 VPWR VGND sg13cmos5l_decap_8
XFILLER_106_86 VPWR VGND sg13cmos5l_decap_8
XFILLER_66_35 VPWR VGND sg13cmos5l_decap_8
XFILLER_453_217 VPWR VGND sg13cmos5l_fill_1
XFILLER_565_7 VPWR VGND sg13cmos5l_decap_8
XFILLER_264_139 VPWR VGND sg13cmos5l_fill_1
XFILLER_403_73 VPWR VGND sg13cmos5l_decap_4
XFILLER_620_49 VPWR VGND sg13cmos5l_decap_8
XFILLER_403_84 VPWR VGND sg13cmos5l_decap_4
XFILLER_550_90 VPWR VGND sg13cmos5l_decap_4
XFILLER_403_95 VPWR VGND sg13cmos5l_decap_8
XFILLER_17_138 VPWR VGND sg13cmos5l_decap_4
XFILLER_205_217 VPWR VGND sg13cmos5l_fill_1
XFILLER_82_34 VPWR VGND sg13cmos5l_decap_8
XFILLER_479_66 VPWR VGND sg13cmos5l_decap_4
XFILLER_709_112 VPWR VGND sg13cmos5l_decap_8
XFILLER_25_171 VPWR VGND sg13cmos5l_decap_8
XFILLER_629_14 VPWR VGND sg13cmos5l_decap_8
XFILLER_198_56 VPWR VGND sg13cmos5l_decap_8
XFILLER_575_140 VPWR VGND sg13cmos5l_decap_8
XFILLER_40_141 VPWR VGND sg13cmos5l_fill_2
XFILLER_319_118 VPWR VGND sg13cmos5l_decap_8
XFILLER_495_21 VPWR VGND sg13cmos5l_decap_8
XFILLER_709_189 VPWR VGND sg13cmos5l_decap_8
XFILLER_222_0 VPWR VGND sg13cmos5l_decap_8
XFILLER_709_91 VPWR VGND sg13cmos5l_decap_8
XFILLER_495_98 VPWR VGND sg13cmos5l_decap_8
XFILLER_645_35 VPWR VGND sg13cmos5l_decap_8
XFILLER_428_70 VPWR VGND sg13cmos5l_decap_8
XFILLER_364_14 VPWR VGND sg13cmos5l_decap_8
XFILLER_31_93 VPWR VGND sg13cmos5l_decap_4
XANTENNA__3175__X Tile_X0Y0_UserCLKo VPWR VGND sg13cmos5l_antennanp
XFILLER_147_93 VPWR VGND sg13cmos5l_decap_4
XFILLER_342_176 VPWR VGND sg13cmos5l_decap_8
XFILLER_591_0 VPWR VGND sg13cmos5l_decap_8
XFILLER_692_206 VPWR VGND sg13cmos5l_fill_2
XFILLER_689_0 VPWR VGND sg13cmos5l_decap_8
XFILLER_514_28 VPWR VGND sg13cmos5l_decap_8
XFILLER_661_56 VPWR VGND sg13cmos5l_decap_8
X_0310_ _0310_/Q Tile_X0Y7_FrameData[9] VGND VPWR Tile_X0Y9_FrameStrobe[4] latch
XFILLER_645_133 VPWR VGND sg13cmos5l_decap_8
X_1290_ _1290_/Q Tile_X0Y1_FrameData[15] VGND VPWR Tile_X0Y9_FrameStrobe[3] latch
XFILLER_380_35 VPWR VGND sg13cmos5l_decap_8
XFILLER_163_81 VPWR VGND sg13cmos5l_decap_8
X_0241_ _0241_/Q Tile_X0Y7_FrameData[14] VGND VPWR Tile_X0Y9_FrameStrobe[2] latch
X_0172_ _0172_/Q Tile_X0Y7_FrameData[19] VGND VPWR Tile_X0Y9_FrameStrobe[0] latch
XFILLER_389_77 VPWR VGND sg13cmos5l_decap_8
XFILLER_16_160 VPWR VGND sg13cmos5l_fill_1
X_3931_ _3931_/X _3987_/X Tile_X0Y1_WW4END[7] _3986_/X AXI_M_SOC_ARREADY _1347_/Q
+ _1346_/Q VPWR VGND sg13cmos5l_mux4_1
XFILLER_539_14 VPWR VGND sg13cmos5l_decap_8
XFILLER_389_99 VPWR VGND sg13cmos5l_decap_8
XFILLER_686_42 VPWR VGND sg13cmos5l_decap_8
XFILLER_566_140 VPWR VGND sg13cmos5l_decap_8
X_3862_ _3862_/X _3848_/X Tile_X0Y0_W6END[0] Tile_X0Y0_S1END[0] _3862_/A3 _0947_/Q
+ _0946_/Q VPWR VGND sg13cmos5l_mux4_1
XFILLER_715_104 VPWR VGND sg13cmos5l_decap_8
XFILLER_82_2 VPWR VGND sg13cmos5l_fill_1
XFILLER_31_174 VPWR VGND sg13cmos5l_fill_1
XFILLER_176_135 VPWR VGND sg13cmos5l_decap_4
X_2813_ Tile_X0Y3_E2BEG[3] _4151_/X VPWR VGND sg13cmos5l_buf_1
X_3793_ _3793_/X _3885_/X _3876_/X _3875_/X _3853_/X _1153_/Q _1152_/Q VPWR VGND sg13cmos5l_mux4_1
XFILLER_619_91 VPWR VGND sg13cmos5l_decap_4
X_2744_ Tile_X0Y3_FrameData_O[2] Tile_X0Y3_FrameData[2] VPWR VGND sg13cmos5l_buf_1
XFILLER_555_35 VPWR VGND sg13cmos5l_decap_8
XFILLER_318_173 VPWR VGND sg13cmos5l_decap_8
XFILLER_68_0 VPWR VGND sg13cmos5l_fill_2
X_2675_ _2675_/Q Tile_X0Y6_FrameData[20] VGND VPWR Tile_X0Y9_FrameStrobe[7] latch
XFILLER_274_14 VPWR VGND sg13cmos5l_decap_8
XANTENNA__3085__X Tile_X0Y7_E1BEG[3] VPWR VGND sg13cmos5l_antennanp
XFILLER_132_205 VPWR VGND sg13cmos5l_fill_1
X_1626_ _1626_/Q Tile_X0Y2_FrameData[23] VGND VPWR Tile_X0Y9_FrameStrobe[6] latch
X_4414_ _4414_/X AXI_M_SOC_RRESP0 _4452_/X _4456_/X _4429_/X _2275_/Q _2274_/Q VPWR
+ VGND sg13cmos5l_mux4_1
XFILLER_132_216 VPWR VGND sg13cmos5l_fill_2
XFILLER_705_49 VPWR VGND sg13cmos5l_decap_8
XFILLER_207_41 VPWR VGND sg13cmos5l_decap_8
XFILLER_424_28 VPWR VGND sg13cmos5l_decap_8
X_1557_ _1557_/Q Tile_X0Y2_FrameData[28] VGND VPWR Tile_X0Y9_FrameStrobe[4] latch
X_4345_ _4345_/X _4305_/X _0158_/X _4304_/X _0111_/X _1963_/Q _1962_/Q VPWR VGND sg13cmos5l_mux4_1
XFILLER_571_56 VPWR VGND sg13cmos5l_decap_8
XFILLER_354_91 VPWR VGND sg13cmos5l_decap_8
X_0508_ _0508_/Q Tile_X0Y8_FrameData[3] VGND VPWR Tile_X0Y9_FrameStrobe[2] latch
X_4276_ _4276_/X Tile_X0Y4_WW4END[11] AXI_M_SOC_BRESP0 _4347_/X _4319_/X _2061_/Q
+ _2060_/Q VPWR VGND sg13cmos5l_mux4_1
XFILLER_636_133 VPWR VGND sg13cmos5l_decap_8
X_1488_ _1488_/Q Tile_X0Y2_FrameData[1] VGND VPWR Tile_X0Y9_FrameStrobe[1] latch
XFILLER_290_35 VPWR VGND sg13cmos5l_decap_8
XFILLER_100_124 VPWR VGND sg13cmos5l_decap_8
X_3227_ Tile_X0Y0_FrameStrobe_O[15] Tile_X0Y9_FrameStrobe[15] VPWR VGND sg13cmos5l_buf_1
XFILLER_435_217 VPWR VGND sg13cmos5l_fill_1
XFILLER_100_135 VPWR VGND sg13cmos5l_fill_1
X_0439_ _0439_/Q Tile_X0Y8_FrameData[8] VGND VPWR Tile_X0Y9_FrameStrobe[0] latch
XFILLER_100_157 VPWR VGND sg13cmos5l_decap_8
XFILLER_239_191 VPWR VGND sg13cmos5l_decap_8
X_3158_ Tile_X0Y7_FrameData_O[28] Tile_X0Y7_FrameData[28] VPWR VGND sg13cmos5l_buf_1
XFILLER_651_147 VPWR VGND sg13cmos5l_decap_8
XFILLER_450_209 VPWR VGND sg13cmos5l_fill_2
XFILLER_440_49 VPWR VGND sg13cmos5l_decap_8
X_2109_ _2109_/Q Tile_X0Y4_FrameData[8] VGND VPWR Tile_X0Y9_FrameStrobe[5] latch
X_3089_ Tile_X0Y7_E2BEG[3] _4615_/X VPWR VGND sg13cmos5l_buf_1
XFILLER_299_55 VPWR VGND sg13cmos5l_decap_8
XFILLER_299_66 VPWR VGND sg13cmos5l_fill_1
XFILLER_449_14 VPWR VGND sg13cmos5l_decap_8
XFILLER_299_88 VPWR VGND sg13cmos5l_decap_8
XFILLER_596_42 VPWR VGND sg13cmos5l_decap_8
XFILLER_52_37 VPWR VGND sg13cmos5l_decap_8
XFILLER_146_7 VPWR VGND sg13cmos5l_decap_8
XFILLER_706_126 VPWR VGND sg13cmos5l_decap_8
XFILLER_572_154 VPWR VGND sg13cmos5l_decap_8
XFILLER_706_159 VPWR VGND sg13cmos5l_decap_8
XFILLER_313_7 VPWR VGND sg13cmos5l_decap_8
XFILLER_465_35 VPWR VGND sg13cmos5l_decap_8
XFILLER_248_70 VPWR VGND sg13cmos5l_fill_2
XFILLER_184_14 VPWR VGND sg13cmos5l_fill_2
XFILLER_184_58 VPWR VGND sg13cmos5l_decap_8
XFILLER_615_49 VPWR VGND sg13cmos5l_decap_8
XFILLER_682_7 VPWR VGND sg13cmos5l_decap_8
XFILLER_334_28 VPWR VGND sg13cmos5l_decap_8
XFILLER_117_63 VPWR VGND sg13cmos5l_decap_8
XFILLER_77_34 VPWR VGND sg13cmos5l_decap_8
XFILLER_481_56 VPWR VGND sg13cmos5l_decap_8
XFILLER_264_91 VPWR VGND sg13cmos5l_decap_8
XFILLER_237_106 VPWR VGND sg13cmos5l_decap_4
XFILLER_493_161 VPWR VGND sg13cmos5l_decap_8
XFILLER_426_217 VPWR VGND sg13cmos5l_fill_1
XFILLER_493_194 VPWR VGND sg13cmos5l_fill_1
XFILLER_642_147 VPWR VGND sg13cmos5l_decap_8
XFILLER_350_49 VPWR VGND sg13cmos5l_decap_8
XFILLER_711_70 VPWR VGND sg13cmos5l_decap_8
XFILLER_172_0 VPWR VGND sg13cmos5l_decap_8
XFILLER_245_183 VPWR VGND sg13cmos5l_decap_8
XFILLER_93_77 VPWR VGND sg13cmos5l_decap_8
XFILLER_595_213 VPWR VGND sg13cmos5l_decap_4
XFILLER_359_14 VPWR VGND sg13cmos5l_decap_8
XFILLER_26_93 VPWR VGND sg13cmos5l_decap_8
XFILLER_437_0 VPWR VGND sg13cmos5l_decap_8
XFILLER_548_195 VPWR VGND sg13cmos5l_fill_1
XFILLER_509_28 VPWR VGND sg13cmos5l_decap_8
XFILLER_158_157 VPWR VGND sg13cmos5l_decap_8
XFILLER_604_0 VPWR VGND sg13cmos5l_decap_8
XFILLER_656_56 VPWR VGND sg13cmos5l_decap_8
XFILLER_362_205 VPWR VGND sg13cmos5l_decap_4
XANTENNA__2802__X Tile_X0Y3_E2BEGb[0] VPWR VGND sg13cmos5l_antennanp
X_0790_ _0790_/Q Tile_X0Y9_FrameData[9] VGND VPWR Tile_X0Y9_FrameStrobe[3] latch
XFILLER_375_35 VPWR VGND sg13cmos5l_decap_8
XFILLER_504_210 VPWR VGND sg13cmos5l_decap_8
XFILLER_315_121 VPWR VGND sg13cmos5l_decap_8
XFILLER_375_79 VPWR VGND sg13cmos5l_decap_8
XFILLER_114_205 VPWR VGND sg13cmos5l_fill_1
X_2460_ _2460_/Q Tile_X0Y6_FrameData[11] VGND VPWR Tile_X0Y9_FrameStrobe[0] latch
XFILLER_308_84 VPWR VGND sg13cmos5l_decap_8
X_1411_ _1411_/Q Tile_X0Y1_FrameData[22] VGND VPWR Tile_X0Y9_FrameStrobe[7] latch
XFILLER_672_77 VPWR VGND sg13cmos5l_decap_8
XFILLER_665_206 VPWR VGND sg13cmos5l_fill_1
XFILLER_476_117 VPWR VGND sg13cmos5l_decap_8
XFILLER_244_28 VPWR VGND sg13cmos5l_decap_8
X_2391_ _2391_/Q Tile_X0Y5_FrameData[14] VGND VPWR Tile_X0Y9_FrameStrobe[6] latch
XFILLER_330_146 VPWR VGND sg13cmos5l_decap_4
XANTENNA__3633__X Tile_X0Y9_S4BEG[11] VPWR VGND sg13cmos5l_antennanp
X_4130_ _4130_/X Tile_X0Y1_W2MID[6] Tile_X0Y1_W2END[6] Tile_X0Y1_W6END[9] _3991_/X
+ _1379_/Q _1378_/Q VPWR VGND sg13cmos5l_mux4_1
X_1342_ _1342_/Q Tile_X0Y1_FrameData[27] VGND VPWR Tile_X0Y9_FrameStrobe[5] latch
XFILLER_3_42 VPWR VGND sg13cmos5l_decap_8
XFILLER_330_179 VPWR VGND sg13cmos5l_fill_2
XFILLER_228_106 VPWR VGND sg13cmos5l_fill_2
X_4061_ _4061_/X Tile_X0Y2_WW4END[10] AXI_M_SOC_AWREADY _4126_/X _4101_/X _1551_/Q
+ _1550_/Q VPWR VGND sg13cmos5l_mux4_1
X_1273_ _1273_/Q Tile_X0Y1_FrameData[0] VGND VPWR Tile_X0Y9_FrameStrobe[2] latch
XFILLER_484_183 VPWR VGND sg13cmos5l_decap_8
XFILLER_324_83 VPWR VGND sg13cmos5l_fill_1
X_3012_ Tile_X0Y5_E2BEGb[7] _4387_/X VPWR VGND sg13cmos5l_buf_1
X_0224_ _0224_/Q Tile_X0Y7_FrameData[31] VGND VPWR Tile_X0Y9_FrameStrobe[2] latch
XFILLER_260_49 VPWR VGND sg13cmos5l_decap_4
XFILLER_621_70 VPWR VGND sg13cmos5l_decap_8
X_0155_ _0155_/X _4564_/X _4565_/X _1605_/Q VPWR VGND sg13cmos5l_mux2_1
XFILLER_397_113 VPWR VGND sg13cmos5l_decap_8
XFILLER_251_142 VPWR VGND sg13cmos5l_decap_8
XFILLER_697_63 VPWR VGND sg13cmos5l_decap_8
XFILLER_340_93 VPWR VGND sg13cmos5l_decap_8
X_0086_ _0086_/X _3869_/X _3870_/X _2152_/Q VPWR VGND sg13cmos5l_mux2_1
XFILLER_269_14 VPWR VGND sg13cmos5l_decap_8
XFILLER_196_208 VPWR VGND sg13cmos5l_fill_2
XFILLER_397_179 VPWR VGND sg13cmos5l_decap_8
X_3914_ _3914_/X Tile_X0Y2_W1END[2] Tile_X0Y2_WW4END[2] Tile_X0Y2_W6END[10] _4118_/X
+ _1643_/Q _1642_/Q VPWR VGND sg13cmos5l_mux4_1
X_4894_ _4894_/X Tile_X0Y9_N1END[2] Tile_X0Y9_W6END[2] _4898_/X _4894_/A3 _0675_/Q
+ _0674_/Q VPWR VGND sg13cmos5l_mux4_1
XFILLER_149_135 VPWR VGND sg13cmos5l_decap_8
X_3845_ _3845_/X Tile_X0Y0_W2MID[5] _3883_/X _3887_/X _3856_/X _1015_/Q _1014_/Q VPWR
+ VGND sg13cmos5l_mux4_1
XFILLER_419_28 VPWR VGND sg13cmos5l_decap_8
XFILLER_566_56 VPWR VGND sg13cmos5l_decap_8
XFILLER_349_91 VPWR VGND sg13cmos5l_decap_8
XFILLER_164_105 VPWR VGND sg13cmos5l_decap_8
X_0988_ _0988_/Q Tile_X0Y0_FrameData[15] VGND VPWR Tile_X0Y9_FrameStrobe[1] latch
X_3776_ _3776_/X Tile_X0Y0_WW4END[5] Tile_X0Y0_WW4END[13] Tile_X0Y0_W6END[5] _3886_/X
+ _0999_/Q _0998_/Q VPWR VGND sg13cmos5l_mux4_1
XFILLER_285_35 VPWR VGND sg13cmos5l_decap_8
XFILLER_164_138 VPWR VGND sg13cmos5l_decap_8
XFILLER_716_37 VPWR VGND sg13cmos5l_decap_4
X_2727_ _4894_/A3 VPWR VGND sg13cmos5l_tielo
XFILLER_711_140 VPWR VGND sg13cmos5l_decap_8
X_2658_ _2658_/Q Tile_X0Y6_FrameData[5] VGND VPWR Tile_X0Y9_FrameStrobe[6] latch
XFILLER_435_49 VPWR VGND sg13cmos5l_decap_8
XFILLER_218_95 VPWR VGND sg13cmos5l_fill_2
XFILLER_656_217 VPWR VGND sg13cmos5l_fill_1
XFILLER_582_77 VPWR VGND sg13cmos5l_decap_8
XFILLER_711_195 VPWR VGND sg13cmos5l_decap_8
X_1609_ _1609_/Q Tile_X0Y2_FrameData[8] VGND VPWR Tile_X0Y9_FrameStrobe[5] latch
X_2589_ _2589_/Q Tile_X0Y6_FrameData[10] VGND VPWR Tile_X0Y9_FrameStrobe[4] latch
XANTENNA__3543__X Tile_X0Y9_E6BEG[1] VPWR VGND sg13cmos5l_antennanp
X_4328_ _4328_/X Tile_X0Y0_W1END[2] Tile_X0Y0_WW4END[14] Tile_X0Y0_W6END[6] _3883_/X
+ _1111_/Q _1110_/Q VPWR VGND sg13cmos5l_mux4_1
XFILLER_234_50 VPWR VGND sg13cmos5l_decap_8
XFILLER_408_206 VPWR VGND sg13cmos5l_decap_4
XFILLER_86_133 VPWR VGND sg13cmos5l_decap_8
XFILLER_408_217 VPWR VGND sg13cmos5l_fill_1
XFILLER_234_83 VPWR VGND sg13cmos5l_fill_1
X_4259_ _4259_/X Tile_X0Y4_W2MID[4] AXI_M_SOC_BRESP1 _4319_/X _4318_/X _2095_/Q _2094_/Q
+ VPWR VGND sg13cmos5l_mux4_1
XFILLER_47_48 VPWR VGND sg13cmos5l_decap_4
XFILLER_86_199 VPWR VGND sg13cmos5l_decap_8
XFILLER_234_109 VPWR VGND sg13cmos5l_fill_1
XFILLER_531_70 VPWR VGND sg13cmos5l_decap_8
XFILLER_103_21 VPWR VGND sg13cmos5l_decap_8
XFILLER_531_81 VPWR VGND sg13cmos5l_fill_1
XFILLER_263_7 VPWR VGND sg13cmos5l_decap_8
XFILLER_242_120 VPWR VGND sg13cmos5l_decap_8
XFILLER_63_14 VPWR VGND sg13cmos5l_decap_8
XFILLER_63_47 VPWR VGND sg13cmos5l_fill_1
XFILLER_179_14 VPWR VGND sg13cmos5l_decap_8
XFILLER_103_98 VPWR VGND sg13cmos5l_decap_4
XFILLER_430_7 VPWR VGND sg13cmos5l_decap_8
XFILLER_242_197 VPWR VGND sg13cmos5l_decap_4
XFILLER_528_7 VPWR VGND sg13cmos5l_decap_8
XANTENNA__3718__X AXI_M_SOC_WDATA28 VPWR VGND sg13cmos5l_antennanp
XFILLER_259_91 VPWR VGND sg13cmos5l_decap_8
XFILLER_476_78 VPWR VGND sg13cmos5l_decap_8
XFILLER_195_35 VPWR VGND sg13cmos5l_decap_8
XFILLER_560_135 VPWR VGND sg13cmos5l_decap_4
XFILLER_170_108 VPWR VGND sg13cmos5l_fill_2
XFILLER_560_168 VPWR VGND sg13cmos5l_fill_1
XFILLER_12_84 VPWR VGND sg13cmos5l_decap_8
XFILLER_345_49 VPWR VGND sg13cmos5l_decap_8
XFILLER_706_70 VPWR VGND sg13cmos5l_decap_8
XFILLER_647_217 VPWR VGND sg13cmos5l_fill_1
XFILLER_492_77 VPWR VGND sg13cmos5l_decap_8
XFILLER_642_14 VPWR VGND sg13cmos5l_decap_8
XANTENNA__3453__X Tile_X0Y1_FrameData_O[11] VPWR VGND sg13cmos5l_antennanp
XFILLER_77_122 VPWR VGND sg13cmos5l_decap_4
XFILLER_77_133 VPWR VGND sg13cmos5l_decap_8
XFILLER_387_0 VPWR VGND sg13cmos5l_decap_8
XFILLER_615_147 VPWR VGND sg13cmos5l_decap_8
XFILLER_280_204 VPWR VGND sg13cmos5l_decap_4
XFILLER_441_70 VPWR VGND sg13cmos5l_decap_8
XFILLER_554_0 VPWR VGND sg13cmos5l_decap_8
XFILLER_280_215 VPWR VGND sg13cmos5l_fill_2
XFILLER_37_81 VPWR VGND sg13cmos5l_fill_2
XFILLER_379_102 VPWR VGND sg13cmos5l_decap_8
XFILLER_233_120 VPWR VGND sg13cmos5l_decap_8
XFILLER_160_71 VPWR VGND sg13cmos5l_decap_8
XFILLER_160_82 VPWR VGND sg13cmos5l_fill_2
XFILLER_379_157 VPWR VGND sg13cmos5l_decap_4
XFILLER_310_30 VPWR VGND sg13cmos5l_fill_1
XFILLER_310_52 VPWR VGND sg13cmos5l_decap_4
X_1960_ _1960_/Q Tile_X0Y4_FrameData[29] VGND VPWR Tile_X0Y9_FrameStrobe[1] latch
XFILLER_310_85 VPWR VGND sg13cmos5l_decap_4
XFILLER_667_66 VPWR VGND sg13cmos5l_decap_4
XFILLER_53_80 VPWR VGND sg13cmos5l_decap_8
X_0911_ _0911_/Q Tile_X0Y9_FrameData[16] VGND VPWR Tile_X0Y9_FrameStrobe[7] latch
X_1891_ _1891_/Q Tile_X0Y3_FrameData[6] VGND VPWR Tile_X0Y9_FrameStrobe[6] latch
XFILLER_667_88 VPWR VGND sg13cmos5l_decap_8
XFILLER_386_56 VPWR VGND sg13cmos5l_decap_8
XANTENNA__3628__X Tile_X0Y9_S4BEG[6] VPWR VGND sg13cmos5l_antennanp
XFILLER_146_105 VPWR VGND sg13cmos5l_decap_8
X_0842_ _0842_/Q Tile_X0Y9_FrameData[21] VGND VPWR Tile_X0Y9_FrameStrobe[5] latch
X_3630_ Tile_X0Y9_S4BEG[8] _3630_/A VPWR VGND sg13cmos5l_buf_1
XFILLER_335_216 VPWR VGND sg13cmos5l_fill_2
XFILLER_536_176 VPWR VGND sg13cmos5l_decap_8
XFILLER_386_78 VPWR VGND sg13cmos5l_decap_8
XFILLER_683_21 VPWR VGND sg13cmos5l_decap_8
XFILLER_551_124 VPWR VGND sg13cmos5l_fill_2
X_0773_ _0773_/Q Tile_X0Y9_FrameData[26] VGND VPWR Tile_X0Y9_FrameStrobe[3] latch
X_3561_ Tile_X0Y9_EE4BEG[7] _4871_/X VPWR VGND sg13cmos5l_buf_1
XFILLER_536_59 VPWR VGND sg13cmos5l_decap_8
XFILLER_161_108 VPWR VGND sg13cmos5l_decap_8
XANTENNA__0052__X AXI_M_SOC_AWBURST0 VPWR VGND sg13cmos5l_antennanp
X_2512_ _2512_/Q Tile_X0Y6_FrameData[23] VGND VPWR Tile_X0Y9_FrameStrobe[2] latch
X_3492_ Tile_X0Y1_E6BEG[2] _3966_/X VPWR VGND sg13cmos5l_buf_1
XFILLER_303_102 VPWR VGND sg13cmos5l_decap_8
XFILLER_185_90 VPWR VGND sg13cmos5l_fill_1
XFILLER_616_70 VPWR VGND sg13cmos5l_decap_8
X_2443_ _2443_/Q Tile_X0Y6_FrameData[28] VGND VPWR Tile_X0Y9_FrameStrobe[0] latch
XFILLER_45_2 VPWR VGND sg13cmos5l_fill_1
XFILLER_552_14 VPWR VGND sg13cmos5l_decap_8
XANTENNA__3363__X Tile_X0Y2_EE4BEG[2] VPWR VGND sg13cmos5l_antennanp
XFILLER_303_179 VPWR VGND sg13cmos5l_decap_8
X_2374_ _2374_/Q Tile_X0Y5_FrameData[31] VGND VPWR Tile_X0Y9_FrameStrobe[6] latch
XFILLER_653_209 VPWR VGND sg13cmos5l_fill_2
XFILLER_457_150 VPWR VGND sg13cmos5l_decap_4
X_1325_ _1325_/Q Tile_X0Y1_FrameData[12] VGND VPWR Tile_X0Y9_FrameStrobe[4] latch
X_4113_ _4113_/X _4089_/X _0079_/X _4088_/X Tile_X0Y0_S4END[8] _1457_/Q _1456_/Q VPWR
+ VGND sg13cmos5l_mux4_1
XFILLER_702_28 VPWR VGND sg13cmos5l_decap_8
XFILLER_68_155 VPWR VGND sg13cmos5l_decap_8
XFILLER_606_125 VPWR VGND sg13cmos5l_decap_4
XFILLER_472_120 VPWR VGND sg13cmos5l_fill_2
XFILLER_632_91 VPWR VGND sg13cmos5l_decap_8
XFILLER_204_42 VPWR VGND sg13cmos5l_decap_8
X_1256_ _1256_/Q Tile_X0Y1_FrameData[17] VGND VPWR Tile_X0Y9_FrameStrobe[2] latch
X_4044_ _4044_/X Tile_X0Y2_W2MID[3] AXI_M_SOC_AWREADY _4103_/X _4102_/X _1585_/Q _1584_/Q
+ VPWR VGND sg13cmos5l_mux4_1
XFILLER_405_209 VPWR VGND sg13cmos5l_decap_8
XFILLER_351_70 VPWR VGND sg13cmos5l_decap_8
XFILLER_472_175 VPWR VGND sg13cmos5l_decap_4
X_0207_ _0207_/Q Tile_X0Y7_FrameData[16] VGND VPWR Tile_X0Y9_FrameStrobe[1] latch
XFILLER_472_186 VPWR VGND sg13cmos5l_decap_8
X_1187_ _1187_/Q Tile_X0Y1_FrameData[22] VGND VPWR Tile_X0Y9_FrameStrobe[0] latch
X_0138_ AXI_M_SOC_AWLEN0 _0940_/Q _3671_/X VPWR VGND sg13cmos5l_nor2b_1
XFILLER_501_84 VPWR VGND sg13cmos5l_decap_8
XFILLER_220_63 VPWR VGND sg13cmos5l_decap_8
X_0069_ AXI_M_SOC_WSTRB2 _0935_/Q _3724_/X VPWR VGND sg13cmos5l_or2_1
XFILLER_33_28 VPWR VGND sg13cmos5l_decap_8
XFILLER_385_138 VPWR VGND sg13cmos5l_fill_1
XFILLER_577_77 VPWR VGND sg13cmos5l_decap_8
X_4877_ _4877_/X Tile_X0Y9_WW4END[2] AXI_M_SOC_RDATA2 _4918_/X _4905_/X _0789_/Q _0788_/Q
+ VPWR VGND sg13cmos5l_mux4_1
XFILLER_296_56 VPWR VGND sg13cmos5l_decap_8
XANTENNA__3538__X Tile_X0Y9_E2BEGb[4] VPWR VGND sg13cmos5l_antennanp
XFILLER_137_105 VPWR VGND sg13cmos5l_decap_8
X_3828_ _3828_/X Tile_X0Y0_WW4END[7] Tile_X0Y0_WW4END[9] _3879_/X _3852_/X _1049_/Q
+ _1048_/Q VPWR VGND sg13cmos5l_mux4_1
XFILLER_593_21 VPWR VGND sg13cmos5l_decap_8
X_3759_ AXI_M_SOC_ARADDR31 Tile_X0Y8_W1END[3] Tile_X0Y8_WW4END[7] Tile_X0Y8_WW4END[15]
+ _4815_/X _0473_/Q _0472_/Q VPWR VGND sg13cmos5l_mux4_1
XFILLER_165_49 VPWR VGND sg13cmos5l_decap_8
XFILLER_109_7 VPWR VGND sg13cmos5l_decap_8
XFILLER_526_70 VPWR VGND sg13cmos5l_decap_8
XFILLER_526_81 VPWR VGND sg13cmos5l_fill_2
XFILLER_462_14 VPWR VGND sg13cmos5l_decap_8
XANTENNA__3273__X Tile_X0Y0_EE4BEG[9] VPWR VGND sg13cmos5l_antennanp
XFILLER_448_172 VPWR VGND sg13cmos5l_decap_8
XFILLER_612_28 VPWR VGND sg13cmos5l_decap_8
XFILLER_380_7 VPWR VGND sg13cmos5l_decap_8
XFILLER_114_20 VPWR VGND sg13cmos5l_decap_8
XFILLER_478_7 VPWR VGND sg13cmos5l_decap_8
XFILLER_463_131 VPWR VGND sg13cmos5l_decap_8
XFILLER_59_199 VPWR VGND sg13cmos5l_fill_2
XFILLER_114_64 VPWR VGND sg13cmos5l_fill_1
XFILLER_74_136 VPWR VGND sg13cmos5l_decap_4
XFILLER_261_70 VPWR VGND sg13cmos5l_decap_8
XFILLER_463_175 VPWR VGND sg13cmos5l_fill_2
XFILLER_74_35 VPWR VGND sg13cmos5l_decap_4
XFILLER_114_86 VPWR VGND sg13cmos5l_decap_8
XFILLER_74_169 VPWR VGND sg13cmos5l_decap_8
XFILLER_645_7 VPWR VGND sg13cmos5l_decap_8
XFILLER_74_79 VPWR VGND sg13cmos5l_decap_8
XFILLER_620_150 VPWR VGND sg13cmos5l_fill_1
XFILLER_130_63 VPWR VGND sg13cmos5l_decap_8
XFILLER_230_134 VPWR VGND sg13cmos5l_decap_8
XFILLER_376_127 VPWR VGND sg13cmos5l_decap_8
XFILLER_30_206 VPWR VGND sg13cmos5l_decap_4
XFILLER_518_110 VPWR VGND sg13cmos5l_decap_8
XFILLER_90_56 VPWR VGND sg13cmos5l_decap_4
XFILLER_487_77 VPWR VGND sg13cmos5l_decap_8
XFILLER_90_67 VPWR VGND sg13cmos5l_decap_8
XFILLER_90_78 VPWR VGND sg13cmos5l_fill_1
XFILLER_637_14 VPWR VGND sg13cmos5l_decap_8
XANTENNA__3448__X Tile_X0Y1_FrameData_O[6] VPWR VGND sg13cmos5l_antennanp
XFILLER_135_0 VPWR VGND sg13cmos5l_decap_8
XFILLER_128_105 VPWR VGND sg13cmos5l_decap_8
XFILLER_391_119 VPWR VGND sg13cmos5l_decap_8
XFILLER_317_205 VPWR VGND sg13cmos5l_decap_4
XFILLER_183_200 VPWR VGND sg13cmos5l_decap_8
XFILLER_183_211 VPWR VGND sg13cmos5l_fill_1
XFILLER_128_127 VPWR VGND sg13cmos5l_decap_8
XFILLER_384_193 VPWR VGND sg13cmos5l_decap_8
XFILLER_302_0 VPWR VGND sg13cmos5l_decap_8
XFILLER_717_80 VPWR VGND sg13cmos5l_decap_4
XFILLER_533_179 VPWR VGND sg13cmos5l_decap_8
XFILLER_99_87 VPWR VGND sg13cmos5l_decap_8
XFILLER_653_35 VPWR VGND sg13cmos5l_decap_8
XFILLER_99_98 VPWR VGND sg13cmos5l_fill_2
XFILLER_687_161 VPWR VGND sg13cmos5l_decap_4
XFILLER_687_172 VPWR VGND sg13cmos5l_fill_1
XFILLER_372_14 VPWR VGND sg13cmos5l_decap_8
XANTENNA__3183__X Tile_X0Y0_N4BEG[7] VPWR VGND sg13cmos5l_antennanp
XFILLER_97_217 VPWR VGND sg13cmos5l_fill_1
XFILLER_300_105 VPWR VGND sg13cmos5l_fill_2
XFILLER_297_156 VPWR VGND sg13cmos5l_decap_8
XFILLER_151_174 VPWR VGND sg13cmos5l_decap_8
XFILLER_671_0 VPWR VGND sg13cmos5l_decap_8
XFILLER_522_28 VPWR VGND sg13cmos5l_decap_8
XFILLER_24_7 VPWR VGND sg13cmos5l_decap_8
XFILLER_452_80 VPWR VGND sg13cmos5l_decap_8
XFILLER_65_103 VPWR VGND sg13cmos5l_decap_8
X_1110_ _1110_/Q Tile_X0Y0_FrameData[21] VGND VPWR Tile_X0Y9_FrameStrobe[5] latch
XFILLER_48_80 VPWR VGND sg13cmos5l_fill_1
X_2090_ _2090_/Q Tile_X0Y4_FrameData[27] VGND VPWR Tile_X0Y9_FrameStrobe[5] latch
XFILLER_171_70 VPWR VGND sg13cmos5l_decap_8
XFILLER_171_81 VPWR VGND sg13cmos5l_fill_2
XFILLER_0_21 VPWR VGND sg13cmos5l_decap_8
X_1041_ _1041_/Q Tile_X0Y0_FrameData[26] VGND VPWR Tile_X0Y9_FrameStrobe[3] latch
XFILLER_678_21 VPWR VGND sg13cmos5l_decap_8
XFILLER_410_201 VPWR VGND sg13cmos5l_decap_8
XFILLER_221_112 VPWR VGND sg13cmos5l_fill_2
X_4800_ _4800_/X _4777_/X Tile_X0Y9_N4END[4] _4776_/X _0077_/X _0471_/Q _0470_/Q VPWR
+ VGND sg13cmos5l_mux4_1
XFILLER_206_197 VPWR VGND sg13cmos5l_decap_8
XFILLER_367_127 VPWR VGND sg13cmos5l_decap_8
X_2992_ Tile_X0Y8_UserCLKo Tile_X0Y8_UserCLK VPWR VGND sg13cmos5l_buf_1
XFILLER_21_217 VPWR VGND sg13cmos5l_fill_1
XFILLER_221_156 VPWR VGND sg13cmos5l_decap_8
X_4731_ _4731_/X Tile_X0Y8_W2MID[4] AXI_M_SOC_RDATA11 _4791_/X _4790_/X _0585_/Q _0584_/Q
+ VPWR VGND sg13cmos5l_mux4_1
XFILLER_509_121 VPWR VGND sg13cmos5l_decap_4
XFILLER_397_77 VPWR VGND sg13cmos5l_decap_8
X_1943_ _1943_/Q Tile_X0Y4_FrameData[14] VGND VPWR Tile_X0Y9_FrameStrobe[0] latch
XFILLER_547_14 VPWR VGND sg13cmos5l_decap_8
XFILLER_9_63 VPWR VGND sg13cmos5l_decap_8
XFILLER_397_99 VPWR VGND sg13cmos5l_decap_8
XANTENNA__3358__X Tile_X0Y2_FrameData_O[29] VPWR VGND sg13cmos5l_antennanp
XFILLER_694_42 VPWR VGND sg13cmos5l_decap_8
XFILLER_509_154 VPWR VGND sg13cmos5l_decap_8
XFILLER_308_205 VPWR VGND sg13cmos5l_decap_8
XFILLER_308_216 VPWR VGND sg13cmos5l_fill_2
X_4662_ _4662_/X Tile_X0Y6_W1END[1] Tile_X0Y6_W6END[9] _4581_/X _4541_/X _2657_/Q
+ _2656_/Q VPWR VGND sg13cmos5l_mux4_1
X_1874_ _1874_/Q Tile_X0Y3_FrameData[23] VGND VPWR Tile_X0Y9_FrameStrobe[6] latch
XFILLER_375_182 VPWR VGND sg13cmos5l_decap_8
X_3613_ Tile_X0Y9_S2BEG[7] _4835_/X VPWR VGND sg13cmos5l_buf_1
X_0825_ _0825_/Q Tile_X0Y9_FrameData[6] VGND VPWR Tile_X0Y9_FrameStrobe[4] latch
X_4593_ _4593_/X Tile_X0Y8_W2MID[3] Tile_X0Y8_W2END[3] Tile_X0Y8_W6END[3] _4790_/X
+ _0655_/Q _0654_/Q VPWR VGND sg13cmos5l_mux4_1
XFILLER_524_157 VPWR VGND sg13cmos5l_decap_8
XFILLER_627_91 VPWR VGND sg13cmos5l_decap_8
XFILLER_134_119 VPWR VGND sg13cmos5l_decap_8
X_3544_ Tile_X0Y9_E6BEG[2] _4882_/X VPWR VGND sg13cmos5l_buf_1
X_0756_ _0756_/Q Tile_X0Y9_FrameData[11] VGND VPWR Tile_X0Y9_FrameStrobe[2] latch
XFILLER_563_35 VPWR VGND sg13cmos5l_decap_8
XFILLER_390_196 VPWR VGND sg13cmos5l_decap_8
XFILLER_346_70 VPWR VGND sg13cmos5l_decap_8
XFILLER_678_161 VPWR VGND sg13cmos5l_decap_4
XFILLER_288_134 VPWR VGND sg13cmos5l_decap_8
XFILLER_282_14 VPWR VGND sg13cmos5l_decap_8
X_0687_ _0687_/Q Tile_X0Y9_FrameData[16] VGND VPWR Tile_X0Y9_FrameStrobe[0] latch
X_3475_ Tile_X0Y1_EE4BEG[1] _3949_/X VPWR VGND sg13cmos5l_buf_1
XANTENNA__3093__X Tile_X0Y7_E2BEG[7] VPWR VGND sg13cmos5l_antennanp
XFILLER_88_217 VPWR VGND sg13cmos5l_fill_1
XFILLER_288_145 VPWR VGND sg13cmos5l_fill_1
XFILLER_288_167 VPWR VGND sg13cmos5l_decap_8
X_2426_ _2426_/Q Tile_X0Y5_FrameData[11] VGND VPWR Tile_X0Y9_FrameStrobe[7] latch
XFILLER_693_153 VPWR VGND sg13cmos5l_decap_8
XFILLER_713_49 VPWR VGND sg13cmos5l_decap_8
XFILLER_432_28 VPWR VGND sg13cmos5l_decap_8
XFILLER_215_63 VPWR VGND sg13cmos5l_decap_8
X_2357_ _2357_/Q Tile_X0Y5_FrameData[16] VGND VPWR Tile_X0Y9_FrameStrobe[5] latch
XFILLER_28_28 VPWR VGND sg13cmos5l_decap_8
X_1308_ _1308_/Q Tile_X0Y1_FrameData[29] VGND VPWR Tile_X0Y9_FrameStrobe[4] latch
X_2288_ _2288_/Q Tile_X0Y5_FrameData[21] VGND VPWR Tile_X0Y9_FrameStrobe[3] latch
XFILLER_445_186 VPWR VGND sg13cmos5l_decap_8
X_1239_ _1239_/Q Tile_X0Y1_FrameData[2] VGND VPWR Tile_X0Y9_FrameStrobe[1] latch
X_4027_ _4027_/X Tile_X0Y3_W2MID[4] Tile_X0Y3_W2END[4] Tile_X0Y3_W6END[4] _4211_/X
+ _1911_/Q _1910_/Q VPWR VGND sg13cmos5l_mux4_1
XFILLER_588_21 VPWR VGND sg13cmos5l_decap_8
XFILLER_71_139 VPWR VGND sg13cmos5l_decap_8
XFILLER_460_167 VPWR VGND sg13cmos5l_decap_4
XFILLER_44_27 VPWR VGND sg13cmos5l_decap_8
XFILLER_358_105 VPWR VGND sg13cmos5l_decap_8
XFILLER_547_205 VPWR VGND sg13cmos5l_fill_1
XFILLER_547_216 VPWR VGND sg13cmos5l_fill_2
XFILLER_212_167 VPWR VGND sg13cmos5l_decap_8
X_4929_ _4929_/X Tile_X0Y9_N1END[1] Tile_X0Y9_N4END[1] _4897_/X _0082_/X _0701_/Q
+ _0700_/Q VPWR VGND sg13cmos5l_mux4_1
XFILLER_457_14 VPWR VGND sg13cmos5l_decap_8
XFILLER_100_55 VPWR VGND sg13cmos5l_decap_8
XANTENNA__3268__X Tile_X0Y0_EE4BEG[4] VPWR VGND sg13cmos5l_antennanp
XFILLER_165_200 VPWR VGND sg13cmos5l_fill_1
XFILLER_100_77 VPWR VGND sg13cmos5l_decap_4
XFILLER_515_124 VPWR VGND sg13cmos5l_decap_8
XFILLER_381_130 VPWR VGND sg13cmos5l_fill_1
XFILLER_176_37 VPWR VGND sg13cmos5l_fill_1
XFILLER_607_28 VPWR VGND sg13cmos5l_decap_8
XFILLER_219_6 VPWR VGND sg13cmos5l_decap_8
XFILLER_176_59 VPWR VGND sg13cmos5l_decap_8
XANTENNA__2900__X Tile_X0Y6_FrameData_O[21] VPWR VGND sg13cmos5l_antennanp
XFILLER_530_116 VPWR VGND sg13cmos5l_decap_8
XFILLER_381_185 VPWR VGND sg13cmos5l_decap_4
XFILLER_473_35 VPWR VGND sg13cmos5l_decap_8
XFILLER_109_75 VPWR VGND sg13cmos5l_decap_8
XFILLER_69_46 VPWR VGND sg13cmos5l_decap_8
XFILLER_473_68 VPWR VGND sg13cmos5l_decap_4
XFILLER_192_14 VPWR VGND sg13cmos5l_decap_8
XFILLER_595_7 VPWR VGND sg13cmos5l_decap_8
XFILLER_473_79 VPWR VGND sg13cmos5l_fill_2
XFILLER_79_217 VPWR VGND sg13cmos5l_fill_1
XFILLER_406_51 VPWR VGND sg13cmos5l_fill_1
XFILLER_623_49 VPWR VGND sg13cmos5l_decap_8
XFILLER_483_204 VPWR VGND sg13cmos5l_fill_2
XFILLER_406_73 VPWR VGND sg13cmos5l_decap_4
XFILLER_279_189 VPWR VGND sg13cmos5l_decap_8
XFILLER_342_28 VPWR VGND sg13cmos5l_decap_8
XFILLER_125_63 VPWR VGND sg13cmos5l_decap_8
XFILLER_436_120 VPWR VGND sg13cmos5l_fill_1
XFILLER_294_159 VPWR VGND sg13cmos5l_decap_8
XANTENNA__3731__X AXI_M_SOC_ARADDR3 VPWR VGND sg13cmos5l_antennanp
XFILLER_272_91 VPWR VGND sg13cmos5l_decap_8
XFILLER_85_56 VPWR VGND sg13cmos5l_decap_8
XFILLER_498_21 VPWR VGND sg13cmos5l_decap_8
XFILLER_62_128 VPWR VGND sg13cmos5l_decap_8
XFILLER_141_62 VPWR VGND sg13cmos5l_decap_4
XFILLER_252_0 VPWR VGND sg13cmos5l_decap_8
XFILLER_141_95 VPWR VGND sg13cmos5l_fill_1
XFILLER_203_112 VPWR VGND sg13cmos5l_decap_8
XFILLER_349_105 VPWR VGND sg13cmos5l_decap_8
XFILLER_70_150 VPWR VGND sg13cmos5l_decap_8
XFILLER_498_98 VPWR VGND sg13cmos5l_decap_8
XFILLER_648_35 VPWR VGND sg13cmos5l_decap_8
XFILLER_367_14 VPWR VGND sg13cmos5l_decap_8
XANTENNA__3178__X Tile_X0Y0_N4BEG[2] VPWR VGND sg13cmos5l_antennanp
XFILLER_517_0 VPWR VGND sg13cmos5l_decap_8
XFILLER_7_210 VPWR VGND sg13cmos5l_decap_8
XFILLER_357_182 VPWR VGND sg13cmos5l_decap_8
XFILLER_517_28 VPWR VGND sg13cmos5l_decap_8
XFILLER_664_56 VPWR VGND sg13cmos5l_decap_8
XFILLER_506_168 VPWR VGND sg13cmos5l_decap_8
XFILLER_171_214 VPWR VGND sg13cmos5l_decap_4
XFILLER_109_160 VPWR VGND sg13cmos5l_fill_1
XANTENNA__2810__X Tile_X0Y3_E2BEG[0] VPWR VGND sg13cmos5l_antennanp
X_0610_ _0610_/Q Tile_X0Y8_FrameData[29] VGND VPWR Tile_X0Y9_FrameStrobe[6] latch
X_1590_ _1590_/Q Tile_X0Y2_FrameData[27] VGND VPWR Tile_X0Y9_FrameStrobe[5] latch
XFILLER_383_35 VPWR VGND sg13cmos5l_decap_8
XFILLER_166_70 VPWR VGND sg13cmos5l_decap_8
X_0541_ _0541_/Q Tile_X0Y8_FrameData[2] VGND VPWR Tile_X0Y9_FrameStrobe[3] latch
XFILLER_675_142 VPWR VGND sg13cmos5l_fill_1
X_0472_ _0472_/Q Tile_X0Y8_FrameData[7] VGND VPWR Tile_X0Y9_FrameStrobe[1] latch
X_3260_ Tile_X0Y0_FrameData_O[28] Tile_X0Y0_FrameData[28] VPWR VGND sg13cmos5l_buf_1
XFILLER_533_49 VPWR VGND sg13cmos5l_decap_8
X_2211_ _2211_/Q Tile_X0Y5_FrameData[2] VGND VPWR Tile_X0Y9_FrameStrobe[0] latch
XFILLER_680_77 VPWR VGND sg13cmos5l_decap_8
XFILLER_252_28 VPWR VGND sg13cmos5l_fill_2
X_3191_ Tile_X0Y0_N4BEG[15] _3191_/A VPWR VGND sg13cmos5l_buf_1
XANTENNA__3641__X AXI_M_SOC_AWADDR2 VPWR VGND sg13cmos5l_antennanp
X_2142_ _2142_/Q Tile_X0Y4_FrameData[7] VGND VPWR Tile_X0Y9_FrameStrobe[6] latch
XFILLER_690_156 VPWR VGND sg13cmos5l_decap_8
XFILLER_427_175 VPWR VGND sg13cmos5l_decap_8
XFILLER_689_42 VPWR VGND sg13cmos5l_decap_8
XFILLER_442_112 VPWR VGND sg13cmos5l_fill_2
X_2073_ _2073_/Q Tile_X0Y4_FrameData[12] VGND VPWR Tile_X0Y9_FrameStrobe[4] latch
XFILLER_588_127 VPWR VGND sg13cmos5l_fill_2
XFILLER_53_117 VPWR VGND sg13cmos5l_fill_1
XFILLER_442_145 VPWR VGND sg13cmos5l_decap_8
XFILLER_689_75 VPWR VGND sg13cmos5l_decap_4
X_1024_ _1024_/Q Tile_X0Y0_FrameData[11] VGND VPWR Tile_X0Y9_FrameStrobe[2] latch
XFILLER_201_21 VPWR VGND sg13cmos5l_decap_8
XFILLER_61_172 VPWR VGND sg13cmos5l_decap_8
XFILLER_558_35 VPWR VGND sg13cmos5l_decap_8
XFILLER_98_0 VPWR VGND sg13cmos5l_decap_8
XFILLER_277_14 VPWR VGND sg13cmos5l_decap_8
XFILLER_201_98 VPWR VGND sg13cmos5l_fill_2
X_2975_ Tile_X0Y8_FrameData_O[15] Tile_X0Y8_FrameData[15] VPWR VGND sg13cmos5l_buf_1
XFILLER_544_208 VPWR VGND sg13cmos5l_fill_1
XANTENNA__3088__X Tile_X0Y7_E2BEG[2] VPWR VGND sg13cmos5l_antennanp
XFILLER_355_119 VPWR VGND sg13cmos5l_decap_8
X_4714_ _4714_/X Tile_X0Y6_W1END[3] Tile_X0Y6_W2MID[0] Tile_X0Y6_W2END[0] _4552_/X
+ _2637_/Q _2636_/Q VPWR VGND sg13cmos5l_mux4_1
X_1926_ _1926_/Q Tile_X0Y3_FrameData[31] VGND VPWR Tile_X0Y9_FrameStrobe[0] latch
XFILLER_708_49 VPWR VGND sg13cmos5l_decap_8
X_4645_ _4645_/X Tile_X0Y9_N4END[9] _0055_/X _4694_/X _4698_/X _0269_/Q _0268_/Q VPWR
+ VGND sg13cmos5l_mux4_1
XFILLER_427_28 VPWR VGND sg13cmos5l_decap_8
X_1857_ _1857_/Q Tile_X0Y3_FrameData[8] VGND VPWR Tile_X0Y9_FrameStrobe[5] latch
XFILLER_574_56 VPWR VGND sg13cmos5l_decap_8
XFILLER_357_91 VPWR VGND sg13cmos5l_decap_8
XFILLER_574_67 VPWR VGND sg13cmos5l_fill_2
XFILLER_512_105 VPWR VGND sg13cmos5l_decap_8
X_0808_ _0808_/Q Tile_X0Y9_FrameData[23] VGND VPWR Tile_X0Y9_FrameStrobe[4] latch
X_4576_ _4576_/X _4545_/X Tile_X0Y9_N4END[12] _4544_/X _0152_/X _2479_/Q _2478_/Q
+ VPWR VGND sg13cmos5l_mux4_1
XFILLER_293_35 VPWR VGND sg13cmos5l_decap_8
X_1788_ _1788_/Q Tile_X0Y3_FrameData[13] VGND VPWR Tile_X0Y9_FrameStrobe[3] latch
XFILLER_512_138 VPWR VGND sg13cmos5l_fill_1
X_3527_ Tile_X0Y9_E2BEG[1] _4849_/X VPWR VGND sg13cmos5l_buf_1
X_0739_ _0739_/Q Tile_X0Y9_FrameData[28] VGND VPWR Tile_X0Y9_FrameStrobe[2] latch
XFILLER_226_62 VPWR VGND sg13cmos5l_decap_4
XFILLER_115_185 VPWR VGND sg13cmos5l_decap_8
X_3458_ Tile_X0Y1_FrameData_O[16] Tile_X0Y1_FrameData[16] VPWR VGND sg13cmos5l_buf_1
XFILLER_443_49 VPWR VGND sg13cmos5l_decap_8
XFILLER_130_133 VPWR VGND sg13cmos5l_decap_8
XFILLER_681_112 VPWR VGND sg13cmos5l_decap_8
X_2409_ _2409_/Q Tile_X0Y5_FrameData[28] VGND VPWR Tile_X0Y9_FrameStrobe[7] latch
X_3389_ Tile_X0Y2_E2BEGb[0] _4048_/X VPWR VGND sg13cmos5l_buf_1
XFILLER_130_177 VPWR VGND sg13cmos5l_fill_1
XANTENNA__3551__X Tile_X0Y9_E6BEG[9] VPWR VGND sg13cmos5l_antennanp
XFILLER_523_82 VPWR VGND sg13cmos5l_decap_8
XFILLER_418_142 VPWR VGND sg13cmos5l_decap_4
XFILLER_291_107 VPWR VGND sg13cmos5l_decap_4
XFILLER_480_207 VPWR VGND sg13cmos5l_fill_2
XFILLER_418_153 VPWR VGND sg13cmos5l_decap_4
XFILLER_291_118 VPWR VGND sg13cmos5l_decap_8
XFILLER_523_93 VPWR VGND sg13cmos5l_fill_1
XFILLER_418_164 VPWR VGND sg13cmos5l_decap_8
XFILLER_242_61 VPWR VGND sg13cmos5l_decap_8
XFILLER_599_42 VPWR VGND sg13cmos5l_decap_8
XFILLER_433_112 VPWR VGND sg13cmos5l_decap_4
XFILLER_579_105 VPWR VGND sg13cmos5l_decap_8
XFILLER_176_7 VPWR VGND sg13cmos5l_decap_8
XFILLER_579_149 VPWR VGND sg13cmos5l_fill_2
XFILLER_111_21 VPWR VGND sg13cmos5l_decap_4
XFILLER_594_119 VPWR VGND sg13cmos5l_decap_4
XFILLER_587_160 VPWR VGND sg13cmos5l_decap_8
XFILLER_343_7 VPWR VGND sg13cmos5l_decap_8
XFILLER_111_54 VPWR VGND sg13cmos5l_decap_8
XFILLER_197_122 VPWR VGND sg13cmos5l_decap_8
XFILLER_52_172 VPWR VGND sg13cmos5l_decap_8
XFILLER_468_35 VPWR VGND sg13cmos5l_decap_8
XFILLER_187_14 VPWR VGND sg13cmos5l_decap_8
XFILLER_71_69 VPWR VGND sg13cmos5l_decap_8
XFILLER_346_119 VPWR VGND sg13cmos5l_decap_8
XFILLER_510_7 VPWR VGND sg13cmos5l_decap_8
XFILLER_608_7 VPWR VGND sg13cmos5l_decap_8
XFILLER_618_49 VPWR VGND sg13cmos5l_decap_8
XANTENNA__0134__Y AXI_M_SOC_AWLEN4 VPWR VGND sg13cmos5l_antennanp
XFILLER_337_28 VPWR VGND sg13cmos5l_decap_8
XFILLER_484_56 VPWR VGND sg13cmos5l_decap_8
XFILLER_267_91 VPWR VGND sg13cmos5l_decap_8
XANTENNA__3726__X AXI_M_SOC_WVALID VPWR VGND sg13cmos5l_antennanp
XFILLER_503_105 VPWR VGND sg13cmos5l_decap_8
XFILLER_353_49 VPWR VGND sg13cmos5l_decap_8
XFILLER_136_84 VPWR VGND sg13cmos5l_decap_8
XFILLER_714_70 VPWR VGND sg13cmos5l_decap_8
XFILLER_267_126 VPWR VGND sg13cmos5l_fill_1
XFILLER_511_193 VPWR VGND sg13cmos5l_fill_1
XFILLER_96_66 VPWR VGND sg13cmos5l_decap_8
XFILLER_650_14 VPWR VGND sg13cmos5l_decap_8
XFILLER_121_166 VPWR VGND sg13cmos5l_fill_2
XFILLER_409_120 VPWR VGND sg13cmos5l_decap_8
XANTENNA__3461__X Tile_X0Y1_FrameData_O[19] VPWR VGND sg13cmos5l_antennanp
XFILLER_409_164 VPWR VGND sg13cmos5l_decap_8
XFILLER_672_189 VPWR VGND sg13cmos5l_fill_2
XFILLER_467_0 VPWR VGND sg13cmos5l_decap_8
XFILLER_409_197 VPWR VGND sg13cmos5l_decap_8
XFILLER_302_42 VPWR VGND sg13cmos5l_decap_8
XFILLER_290_162 VPWR VGND sg13cmos5l_decap_8
XFILLER_302_64 VPWR VGND sg13cmos5l_decap_8
XFILLER_634_0 VPWR VGND sg13cmos5l_decap_8
XFILLER_659_56 VPWR VGND sg13cmos5l_decap_8
XFILLER_377_200 VPWR VGND sg13cmos5l_decap_8
XANTENNA__2805__X Tile_X0Y3_E2BEGb[3] VPWR VGND sg13cmos5l_antennanp
XFILLER_378_35 VPWR VGND sg13cmos5l_decap_8
XFILLER_91_7 VPWR VGND sg13cmos5l_decap_8
XFILLER_43_194 VPWR VGND sg13cmos5l_decap_8
XFILLER_378_57 VPWR VGND sg13cmos5l_decap_4
XFILLER_593_141 VPWR VGND sg13cmos5l_decap_4
XFILLER_84_6 VPWR VGND sg13cmos5l_decap_8
X_2760_ Tile_X0Y3_FrameData_O[18] Tile_X0Y3_FrameData[18] VPWR VGND sg13cmos5l_buf_1
XFILLER_593_185 VPWR VGND sg13cmos5l_fill_1
X_1711_ _1711_/Q Tile_X0Y3_FrameData[26] VGND VPWR Tile_X0Y9_FrameStrobe[1] latch
XFILLER_675_77 VPWR VGND sg13cmos5l_decap_8
XFILLER_247_28 VPWR VGND sg13cmos5l_decap_8
XFILLER_675_88 VPWR VGND sg13cmos5l_fill_2
XFILLER_345_141 VPWR VGND sg13cmos5l_decap_8
X_2691_ _2691_/Q Tile_X0Y6_FrameData[4] VGND VPWR Tile_X0Y9_FrameStrobe[7] latch
XANTENNA__3636__X Tile_X0Y9_S4BEG[14] VPWR VGND sg13cmos5l_antennanp
X_4430_ _4430_/X _4355_/X _4471_/X _4470_/X _4354_/X _2203_/Q _2202_/Q VPWR VGND sg13cmos5l_mux4_1
XANTENNA_2 _3763_/X VPWR VGND sg13cmos5l_antennanp
X_1642_ _1642_/Q Tile_X0Y2_FrameData[7] VGND VPWR Tile_X0Y9_FrameStrobe[6] latch
XFILLER_6_42 VPWR VGND sg13cmos5l_decap_8
XFILLER_691_21 VPWR VGND sg13cmos5l_decap_8
XFILLER_360_155 VPWR VGND sg13cmos5l_decap_8
X_4361_ _4361_/X Tile_X0Y6_W2MID[3] Tile_X0Y6_W2END[3] Tile_X0Y6_W6END[3] _4558_/X
+ _2679_/Q _2678_/Q VPWR VGND sg13cmos5l_mux4_1
X_1573_ _1573_/Q Tile_X0Y2_FrameData[12] VGND VPWR Tile_X0Y9_FrameStrobe[4] latch
X_3312_ Tile_X0Y4_EE4BEG[0] _4272_/X VPWR VGND sg13cmos5l_buf_1
XFILLER_360_199 VPWR VGND sg13cmos5l_decap_8
X_0524_ _0524_/Q Tile_X0Y8_FrameData[19] VGND VPWR Tile_X0Y9_FrameStrobe[3] latch
XFILLER_691_98 VPWR VGND sg13cmos5l_decap_8
XFILLER_301_211 VPWR VGND sg13cmos5l_decap_8
XFILLER_112_122 VPWR VGND sg13cmos5l_decap_8
X_4292_ _4292_/X AXI_M_SOC_BRESP0 _4343_/X _4347_/X _4313_/X _2029_/Q _2028_/Q VPWR
+ VGND sg13cmos5l_mux4_1
XFILLER_263_49 VPWR VGND sg13cmos5l_decap_8
XFILLER_258_115 VPWR VGND sg13cmos5l_decap_8
XFILLER_648_175 VPWR VGND sg13cmos5l_decap_8
XFILLER_624_70 VPWR VGND sg13cmos5l_decap_8
XFILLER_502_182 VPWR VGND sg13cmos5l_decap_8
XFILLER_112_133 VPWR VGND sg13cmos5l_fill_2
XFILLER_663_112 VPWR VGND sg13cmos5l_decap_4
X_0455_ _0455_/Q Tile_X0Y8_FrameData[24] VGND VPWR Tile_X0Y9_FrameStrobe[1] latch
X_3243_ Tile_X0Y0_FrameData_O[11] Tile_X0Y0_FrameData[11] VPWR VGND sg13cmos5l_buf_1
XFILLER_560_14 VPWR VGND sg13cmos5l_decap_8
XANTENNA__3371__X Tile_X0Y2_EE4BEG[10] VPWR VGND sg13cmos5l_antennanp
X_0386_ _0386_/Q Tile_X0Y7_FrameData[29] VGND VPWR Tile_X0Y9_FrameStrobe[7] latch
X_3174_ Tile_X0Y4_E6BEG[11] _4299_/X VPWR VGND sg13cmos5l_buf_1
XFILLER_13_0 VPWR VGND sg13cmos5l_decap_8
XFILLER_604_201 VPWR VGND sg13cmos5l_decap_8
XFILLER_710_28 VPWR VGND sg13cmos5l_decap_8
X_2125_ _2125_/Q Tile_X0Y4_FrameData[24] VGND VPWR Tile_X0Y9_FrameStrobe[6] latch
XFILLER_212_20 VPWR VGND sg13cmos5l_decap_8
XFILLER_281_140 VPWR VGND sg13cmos5l_decap_8
XFILLER_640_91 VPWR VGND sg13cmos5l_decap_8
XFILLER_415_156 VPWR VGND sg13cmos5l_decap_8
XFILLER_26_128 VPWR VGND sg13cmos5l_fill_2
X_2056_ _2056_/Q Tile_X0Y4_FrameData[29] VGND VPWR Tile_X0Y9_FrameStrobe[4] latch
XFILLER_415_167 VPWR VGND sg13cmos5l_fill_2
XFILLER_19_180 VPWR VGND sg13cmos5l_decap_8
XFILLER_430_126 VPWR VGND sg13cmos5l_decap_8
XFILLER_576_119 VPWR VGND sg13cmos5l_decap_8
XFILLER_569_56 VPWR VGND sg13cmos5l_decap_8
X_1007_ _1007_/Q Tile_X0Y0_FrameData[28] VGND VPWR Tile_X0Y9_FrameStrobe[2] latch
XFILLER_212_97 VPWR VGND sg13cmos5l_decap_8
XFILLER_569_182 VPWR VGND sg13cmos5l_decap_8
XFILLER_288_35 VPWR VGND sg13cmos5l_decap_8
X_2958_ Tile_X0Y8_EE4BEG[14] _4758_/X VPWR VGND sg13cmos5l_buf_1
XFILLER_438_49 VPWR VGND sg13cmos5l_decap_8
X_1909_ _1909_/Q Tile_X0Y3_FrameData[20] VGND VPWR Tile_X0Y9_FrameStrobe[7] latch
XFILLER_585_88 VPWR VGND sg13cmos5l_decap_8
X_2889_ Tile_X0Y6_FrameData_O[10] Tile_X0Y6_FrameData[10] VPWR VGND sg13cmos5l_buf_1
XFILLER_336_163 VPWR VGND sg13cmos5l_decap_8
XANTENNA__3546__X Tile_X0Y9_E6BEG[4] VPWR VGND sg13cmos5l_antennanp
X_4628_ _4628_/X Tile_X0Y7_WW4END[15] AXI_M_SOC_RDATA16 _4699_/X _4668_/X _0303_/Q
+ _0302_/Q VPWR VGND sg13cmos5l_mux4_1
XFILLER_351_133 VPWR VGND sg13cmos5l_decap_8
XFILLER_497_126 VPWR VGND sg13cmos5l_decap_8
X_4559_ _4559_/X _4475_/X _4591_/X _4590_/X _4474_/X _2457_/Q _2456_/Q VPWR VGND sg13cmos5l_mux4_1
XFILLER_351_166 VPWR VGND sg13cmos5l_decap_8
XFILLER_1_216 VPWR VGND sg13cmos5l_fill_2
XFILLER_500_119 VPWR VGND sg13cmos5l_decap_8
XFILLER_173_27 VPWR VGND sg13cmos5l_fill_2
XFILLER_103_111 VPWR VGND sg13cmos5l_decap_8
XFILLER_103_122 VPWR VGND sg13cmos5l_fill_2
XFILLER_438_215 VPWR VGND sg13cmos5l_fill_2
XFILLER_106_21 VPWR VGND sg13cmos5l_decap_8
XFILLER_654_112 VPWR VGND sg13cmos5l_decap_8
XFILLER_534_92 VPWR VGND sg13cmos5l_fill_2
XFILLER_470_14 VPWR VGND sg13cmos5l_decap_8
XFILLER_106_43 VPWR VGND sg13cmos5l_decap_8
XFILLER_293_7 VPWR VGND sg13cmos5l_decap_8
XFILLER_253_60 VPWR VGND sg13cmos5l_decap_8
XFILLER_103_177 VPWR VGND sg13cmos5l_decap_4
XANTENNA__3281__X Tile_X0Y0_E6BEG[1] VPWR VGND sg13cmos5l_antennanp
XFILLER_106_65 VPWR VGND sg13cmos5l_decap_8
XFILLER_654_167 VPWR VGND sg13cmos5l_decap_8
XFILLER_654_189 VPWR VGND sg13cmos5l_decap_4
XFILLER_620_28 VPWR VGND sg13cmos5l_decap_8
XFILLER_460_7 VPWR VGND sg13cmos5l_decap_8
XFILLER_17_106 VPWR VGND sg13cmos5l_decap_8
XFILLER_558_7 VPWR VGND sg13cmos5l_decap_8
XFILLER_406_145 VPWR VGND sg13cmos5l_fill_1
XFILLER_122_42 VPWR VGND sg13cmos5l_decap_8
XFILLER_406_167 VPWR VGND sg13cmos5l_decap_4
XFILLER_406_178 VPWR VGND sg13cmos5l_decap_4
XFILLER_82_13 VPWR VGND sg13cmos5l_decap_8
XFILLER_479_56 VPWR VGND sg13cmos5l_fill_2
XFILLER_122_86 VPWR VGND sg13cmos5l_decap_8
XFILLER_567_119 VPWR VGND sg13cmos5l_decap_8
XFILLER_198_35 VPWR VGND sg13cmos5l_decap_8
XFILLER_709_168 VPWR VGND sg13cmos5l_decap_8
XFILLER_40_164 VPWR VGND sg13cmos5l_decap_8
XFILLER_575_196 VPWR VGND sg13cmos5l_decap_8
XFILLER_348_49 VPWR VGND sg13cmos5l_decap_8
XFILLER_185_147 VPWR VGND sg13cmos5l_fill_2
XFILLER_709_70 VPWR VGND sg13cmos5l_decap_8
XFILLER_495_77 VPWR VGND sg13cmos5l_decap_8
XFILLER_645_14 VPWR VGND sg13cmos5l_decap_8
XFILLER_126_203 VPWR VGND sg13cmos5l_fill_2
XFILLER_215_0 VPWR VGND sg13cmos5l_decap_8
XANTENNA__3456__X Tile_X0Y1_FrameData_O[14] VPWR VGND sg13cmos5l_antennanp
XFILLER_531_200 VPWR VGND sg13cmos5l_fill_1
XFILLER_342_155 VPWR VGND sg13cmos5l_fill_2
XFILLER_429_204 VPWR VGND sg13cmos5l_decap_8
XFILLER_661_35 VPWR VGND sg13cmos5l_decap_8
XFILLER_295_210 VPWR VGND sg13cmos5l_decap_8
XFILLER_645_112 VPWR VGND sg13cmos5l_decap_8
XFILLER_584_0 VPWR VGND sg13cmos5l_decap_8
XFILLER_380_14 VPWR VGND sg13cmos5l_decap_8
XANTENNA__3191__X Tile_X0Y0_N4BEG[15] VPWR VGND sg13cmos5l_antennanp
X_0240_ _0240_/Q Tile_X0Y7_FrameData[15] VGND VPWR Tile_X0Y9_FrameStrobe[2] latch
XFILLER_380_69 VPWR VGND sg13cmos5l_decap_8
XFILLER_660_115 VPWR VGND sg13cmos5l_fill_1
XFILLER_645_189 VPWR VGND sg13cmos5l_decap_8
XFILLER_248_192 VPWR VGND sg13cmos5l_decap_8
X_0171_ _0171_/Q Tile_X0Y7_FrameData[20] VGND VPWR Tile_X0Y9_FrameStrobe[0] latch
XFILLER_660_137 VPWR VGND sg13cmos5l_decap_4
XFILLER_530_28 VPWR VGND sg13cmos5l_decap_8
XFILLER_313_96 VPWR VGND sg13cmos5l_decap_8
XFILLER_601_204 VPWR VGND sg13cmos5l_decap_8
XFILLER_412_126 VPWR VGND sg13cmos5l_decap_8
XFILLER_389_56 VPWR VGND sg13cmos5l_decap_8
X_3930_ _3930_/X _3985_/X Tile_X0Y1_WW4END[6] _3984_/X AXI_M_SOC_ARREADY _1349_/Q
+ _1348_/Q VPWR VGND sg13cmos5l_mux4_1
XFILLER_686_21 VPWR VGND sg13cmos5l_decap_8
X_3861_ _3861_/X _3850_/X Tile_X0Y0_W6END[2] Tile_X0Y0_S1END[2] _3861_/A3 _0943_/Q
+ _0942_/Q VPWR VGND sg13cmos5l_mux4_1
XFILLER_176_103 VPWR VGND sg13cmos5l_fill_2
XFILLER_72_90 VPWR VGND sg13cmos5l_decap_8
X_2812_ Tile_X0Y3_E2BEG[2] _4150_/X VPWR VGND sg13cmos5l_buf_1
XFILLER_31_164 VPWR VGND sg13cmos5l_fill_1
X_3792_ _3792_/X Tile_X0Y0_W1END[0] Tile_X0Y0_WW4END[0] Tile_X0Y0_W6END[8] _3881_/X
+ _1153_/Q _1152_/Q VPWR VGND sg13cmos5l_mux4_1
XFILLER_258_49 VPWR VGND sg13cmos5l_decap_8
XFILLER_619_70 VPWR VGND sg13cmos5l_decap_8
XFILLER_188_90 VPWR VGND sg13cmos5l_decap_8
XFILLER_176_169 VPWR VGND sg13cmos5l_decap_8
XFILLER_75_2 VPWR VGND sg13cmos5l_fill_1
X_2743_ Tile_X0Y3_FrameData_O[1] Tile_X0Y3_FrameData[1] VPWR VGND sg13cmos5l_buf_1
XFILLER_581_155 VPWR VGND sg13cmos5l_decap_8
XFILLER_555_14 VPWR VGND sg13cmos5l_decap_8
XFILLER_380_206 VPWR VGND sg13cmos5l_decap_8
XFILLER_191_106 VPWR VGND sg13cmos5l_decap_8
XFILLER_380_217 VPWR VGND sg13cmos5l_fill_1
XFILLER_318_152 VPWR VGND sg13cmos5l_decap_8
XFILLER_191_117 VPWR VGND sg13cmos5l_fill_1
XANTENNA__3366__X Tile_X0Y2_EE4BEG[5] VPWR VGND sg13cmos5l_antennanp
XFILLER_191_139 VPWR VGND sg13cmos5l_decap_8
XFILLER_184_191 VPWR VGND sg13cmos5l_fill_2
X_2674_ _2674_/Q Tile_X0Y6_FrameData[21] VGND VPWR Tile_X0Y9_FrameStrobe[7] latch
XFILLER_333_122 VPWR VGND sg13cmos5l_decap_4
X_4413_ _4413_/X AXI_M_SOC_RLAST _4453_/X _4457_/X _4431_/X _2277_/Q _2276_/Q VPWR
+ VGND sg13cmos5l_mux4_1
XFILLER_333_155 VPWR VGND sg13cmos5l_decap_8
XFILLER_705_28 VPWR VGND sg13cmos5l_decap_8
X_1625_ _1625_/Q Tile_X0Y2_FrameData[24] VGND VPWR Tile_X0Y9_FrameStrobe[6] latch
XFILLER_207_20 VPWR VGND sg13cmos5l_decap_8
XFILLER_635_91 VPWR VGND sg13cmos5l_decap_8
X_4344_ _4344_/X _4302_/X _0099_/X _4301_/X _0112_/X _1965_/Q _1964_/Q VPWR VGND sg13cmos5l_mux4_1
X_1556_ _1556_/Q Tile_X0Y2_FrameData[29] VGND VPWR Tile_X0Y9_FrameStrobe[4] latch
XFILLER_571_35 VPWR VGND sg13cmos5l_decap_8
XFILLER_354_70 VPWR VGND sg13cmos5l_decap_8
XFILLER_98_153 VPWR VGND sg13cmos5l_fill_2
XFILLER_636_112 VPWR VGND sg13cmos5l_decap_8
X_0507_ _0507_/Q Tile_X0Y8_FrameData[4] VGND VPWR Tile_X0Y9_FrameStrobe[2] latch
XFILLER_290_14 VPWR VGND sg13cmos5l_decap_8
XFILLER_207_97 VPWR VGND sg13cmos5l_decap_8
X_4275_ _4275_/X Tile_X0Y4_WW4END[12] AXI_M_SOC_BRESP1 _4348_/X _4318_/X _2063_/Q
+ _2062_/Q VPWR VGND sg13cmos5l_mux4_1
X_1487_ _1487_/Q Tile_X0Y2_FrameData[2] VGND VPWR Tile_X0Y9_FrameStrobe[1] latch
XFILLER_636_156 VPWR VGND sg13cmos5l_decap_4
X_3226_ Tile_X0Y0_FrameStrobe_O[14] Tile_X0Y9_FrameStrobe[14] VPWR VGND sg13cmos5l_buf_1
X_0438_ _0438_/Q Tile_X0Y8_FrameData[9] VGND VPWR Tile_X0Y9_FrameStrobe[0] latch
XFILLER_504_84 VPWR VGND sg13cmos5l_decap_8
XFILLER_651_126 VPWR VGND sg13cmos5l_decap_8
XFILLER_440_28 VPWR VGND sg13cmos5l_decap_8
XFILLER_223_63 VPWR VGND sg13cmos5l_decap_8
X_3157_ Tile_X0Y7_FrameData_O[27] Tile_X0Y7_FrameData[27] VPWR VGND sg13cmos5l_buf_1
X_0369_ _0369_/Q Tile_X0Y7_FrameData[14] VGND VPWR Tile_X0Y9_FrameStrobe[6] latch
XFILLER_36_28 VPWR VGND sg13cmos5l_decap_8
XFILLER_254_151 VPWR VGND sg13cmos5l_decap_8
XFILLER_254_162 VPWR VGND sg13cmos5l_fill_2
X_2108_ _2108_/Q Tile_X0Y4_FrameData[9] VGND VPWR Tile_X0Y9_FrameStrobe[5] latch
X_3088_ Tile_X0Y7_E2BEG[2] _4614_/X VPWR VGND sg13cmos5l_buf_1
X_2039_ _2039_/Q Tile_X0Y4_FrameData[14] VGND VPWR Tile_X0Y9_FrameStrobe[3] latch
XFILLER_596_21 VPWR VGND sg13cmos5l_decap_8
XFILLER_52_16 VPWR VGND sg13cmos5l_decap_8
XFILLER_356_203 VPWR VGND sg13cmos5l_decap_8
XFILLER_411_181 VPWR VGND sg13cmos5l_fill_1
XFILLER_706_105 VPWR VGND sg13cmos5l_decap_8
XFILLER_22_164 VPWR VGND sg13cmos5l_decap_4
XFILLER_596_98 VPWR VGND sg13cmos5l_decap_8
XFILLER_139_7 VPWR VGND sg13cmos5l_decap_8
XFILLER_529_70 VPWR VGND sg13cmos5l_fill_2
XFILLER_572_133 VPWR VGND sg13cmos5l_decap_8
XFILLER_22_197 VPWR VGND sg13cmos5l_decap_8
XFILLER_465_14 VPWR VGND sg13cmos5l_decap_8
XFILLER_371_206 VPWR VGND sg13cmos5l_decap_8
XFILLER_182_117 VPWR VGND sg13cmos5l_decap_8
XFILLER_371_217 VPWR VGND sg13cmos5l_fill_1
XFILLER_182_128 VPWR VGND sg13cmos5l_fill_2
XANTENNA__3276__X Tile_X0Y0_EE4BEG[12] VPWR VGND sg13cmos5l_antennanp
XFILLER_309_196 VPWR VGND sg13cmos5l_decap_8
XFILLER_306_7 VPWR VGND sg13cmos5l_decap_8
XFILLER_714_182 VPWR VGND sg13cmos5l_decap_8
XFILLER_615_28 VPWR VGND sg13cmos5l_decap_8
XFILLER_324_188 VPWR VGND sg13cmos5l_decap_8
XFILLER_545_91 VPWR VGND sg13cmos5l_decap_4
XFILLER_89_131 VPWR VGND sg13cmos5l_decap_4
XFILLER_77_13 VPWR VGND sg13cmos5l_decap_8
XFILLER_481_35 VPWR VGND sg13cmos5l_decap_8
XFILLER_277_210 VPWR VGND sg13cmos5l_fill_2
XFILLER_264_70 VPWR VGND sg13cmos5l_decap_8
XFILLER_675_7 VPWR VGND sg13cmos5l_decap_8
XFILLER_493_140 VPWR VGND sg13cmos5l_decap_8
XFILLER_292_213 VPWR VGND sg13cmos5l_decap_4
XFILLER_631_49 VPWR VGND sg13cmos5l_decap_8
XFILLER_642_126 VPWR VGND sg13cmos5l_decap_8
XFILLER_350_28 VPWR VGND sg13cmos5l_decap_8
XFILLER_280_91 VPWR VGND sg13cmos5l_decap_8
XFILLER_93_56 VPWR VGND sg13cmos5l_decap_8
XFILLER_245_162 VPWR VGND sg13cmos5l_decap_8
XFILLER_165_0 VPWR VGND sg13cmos5l_decap_8
XFILLER_60_215 VPWR VGND sg13cmos5l_fill_2
XFILLER_332_0 VPWR VGND sg13cmos5l_decap_8
XFILLER_13_142 VPWR VGND sg13cmos5l_decap_8
XFILLER_548_174 VPWR VGND sg13cmos5l_decap_8
XFILLER_402_192 VPWR VGND sg13cmos5l_fill_1
XFILLER_158_136 VPWR VGND sg13cmos5l_decap_8
XFILLER_656_35 VPWR VGND sg13cmos5l_decap_8
XFILLER_439_70 VPWR VGND sg13cmos5l_decap_8
XFILLER_9_168 VPWR VGND sg13cmos5l_decap_4
XFILLER_375_14 VPWR VGND sg13cmos5l_decap_8
XFILLER_362_217 VPWR VGND sg13cmos5l_fill_1
XANTENNA__3186__X Tile_X0Y0_N4BEG[10] VPWR VGND sg13cmos5l_antennanp
XFILLER_712_119 VPWR VGND sg13cmos5l_decap_8
XFILLER_308_41 VPWR VGND sg13cmos5l_fill_2
XFILLER_525_28 VPWR VGND sg13cmos5l_decap_8
XFILLER_114_217 VPWR VGND sg13cmos5l_fill_1
XFILLER_672_56 VPWR VGND sg13cmos5l_decap_8
XFILLER_455_91 VPWR VGND sg13cmos5l_decap_8
X_1410_ _1410_/Q Tile_X0Y1_FrameData[23] VGND VPWR Tile_X0Y9_FrameStrobe[7] latch
XFILLER_47_6 VPWR VGND sg13cmos5l_decap_8
XFILLER_330_125 VPWR VGND sg13cmos5l_decap_8
X_2390_ _2390_/Q Tile_X0Y5_FrameData[15] VGND VPWR Tile_X0Y9_FrameStrobe[6] latch
XFILLER_391_35 VPWR VGND sg13cmos5l_decap_8
XFILLER_3_21 VPWR VGND sg13cmos5l_decap_8
X_1341_ _1341_/Q Tile_X0Y1_FrameData[28] VGND VPWR Tile_X0Y9_FrameStrobe[5] latch
XFILLER_618_134 VPWR VGND sg13cmos5l_fill_1
XFILLER_391_79 VPWR VGND sg13cmos5l_decap_8
X_4060_ _4060_/X Tile_X0Y2_WW4END[11] AXI_M_SOC_AWREADY _4127_/X _4103_/X _1553_/Q
+ _1552_/Q VPWR VGND sg13cmos5l_mux4_1
X_1272_ _1272_/Q Tile_X0Y1_FrameData[1] VGND VPWR Tile_X0Y9_FrameStrobe[2] latch
XFILLER_228_129 VPWR VGND sg13cmos5l_decap_8
XFILLER_3_98 VPWR VGND sg13cmos5l_decap_8
XFILLER_95_167 VPWR VGND sg13cmos5l_decap_4
XFILLER_633_126 VPWR VGND sg13cmos5l_decap_8
X_3011_ Tile_X0Y5_E2BEGb[6] _4386_/X VPWR VGND sg13cmos5l_buf_1
XFILLER_260_28 VPWR VGND sg13cmos5l_decap_8
X_0223_ _0223_/Q Tile_X0Y7_FrameData[0] VGND VPWR Tile_X0Y9_FrameStrobe[1] latch
X_0154_ _3183_/A _3912_/X _3913_/X _1638_/Q VPWR VGND sg13cmos5l_mux2_1
XFILLER_236_184 VPWR VGND sg13cmos5l_decap_8
XFILLER_251_121 VPWR VGND sg13cmos5l_decap_8
XFILLER_697_42 VPWR VGND sg13cmos5l_decap_8
X_0085_ _0085_/X _3873_/X _3874_/X _2149_/Q VPWR VGND sg13cmos5l_mux2_1
X_3913_ _3913_/X _4123_/X _4127_/X _4104_/X _4103_/X _1640_/Q _1639_/Q VPWR VGND sg13cmos5l_mux4_1
XFILLER_539_130 VPWR VGND sg13cmos5l_fill_1
XFILLER_397_169 VPWR VGND sg13cmos5l_fill_2
X_4893_ _4893_/X Tile_X0Y9_N1END[1] Tile_X0Y9_W6END[1] _4897_/X _4893_/A3 _0677_/Q
+ _0676_/Q VPWR VGND sg13cmos5l_mux4_1
XFILLER_149_114 VPWR VGND sg13cmos5l_decap_8
X_3844_ _3844_/X Tile_X0Y0_W2MID[2] _3884_/X _3879_/X _3858_/X _1017_/Q _1016_/Q VPWR
+ VGND sg13cmos5l_mux4_1
XFILLER_80_0 VPWR VGND sg13cmos5l_fill_2
XFILLER_539_196 VPWR VGND sg13cmos5l_decap_8
XFILLER_566_35 VPWR VGND sg13cmos5l_decap_8
XFILLER_349_70 VPWR VGND sg13cmos5l_decap_8
XFILLER_285_14 VPWR VGND sg13cmos5l_decap_8
X_3775_ _3775_/X Tile_X0Y0_WW4END[4] Tile_X0Y0_WW4END[12] Tile_X0Y0_W6END[4] _3885_/X
+ _1001_/Q _1000_/Q VPWR VGND sg13cmos5l_mux4_1
X_0987_ _0987_/Q Tile_X0Y0_FrameData[16] VGND VPWR Tile_X0Y9_FrameStrobe[1] latch
XFILLER_164_128 VPWR VGND sg13cmos5l_fill_2
XANTENNA__3096__X Tile_X0Y7_E2BEGb[2] VPWR VGND sg13cmos5l_antennanp
XFILLER_703_119 VPWR VGND sg13cmos5l_decap_8
X_2726_ _4895_/A3 VPWR VGND sg13cmos5l_tielo
XFILLER_435_28 VPWR VGND sg13cmos5l_decap_8
XFILLER_218_63 VPWR VGND sg13cmos5l_decap_8
X_2657_ _2657_/Q Tile_X0Y6_FrameData[6] VGND VPWR Tile_X0Y9_FrameStrobe[6] latch
XFILLER_582_56 VPWR VGND sg13cmos5l_decap_8
XFILLER_218_85 VPWR VGND sg13cmos5l_fill_2
X_1608_ _1608_/Q Tile_X0Y2_FrameData[9] VGND VPWR Tile_X0Y9_FrameStrobe[5] latch
X_2588_ _2588_/Q Tile_X0Y6_FrameData[11] VGND VPWR Tile_X0Y9_FrameStrobe[4] latch
XFILLER_321_147 VPWR VGND sg13cmos5l_decap_8
X_4327_ _4327_/X _4805_/X _4809_/X _4813_/X _4787_/X _0644_/Q _0643_/Q VPWR VGND sg13cmos5l_mux4_1
X_1539_ _1539_/Q Tile_X0Y2_FrameData[14] VGND VPWR Tile_X0Y9_FrameStrobe[3] latch
XFILLER_609_134 VPWR VGND sg13cmos5l_decap_8
XFILLER_475_140 VPWR VGND sg13cmos5l_decap_8
XFILLER_475_151 VPWR VGND sg13cmos5l_fill_1
XFILLER_609_156 VPWR VGND sg13cmos5l_decap_8
XFILLER_475_162 VPWR VGND sg13cmos5l_decap_8
X_4258_ _4258_/X Tile_X0Y4_W2MID[5] AXI_M_SOC_BRESP0 _4317_/X _4316_/X _2097_/Q _2096_/Q
+ VPWR VGND sg13cmos5l_mux4_1
XFILLER_47_27 VPWR VGND sg13cmos5l_decap_8
XFILLER_475_173 VPWR VGND sg13cmos5l_fill_2
XFILLER_451_49 VPWR VGND sg13cmos5l_decap_8
XFILLER_219_129 VPWR VGND sg13cmos5l_decap_8
X_3209_ Tile_X0Y0_N1BEG[1] _3781_/X VPWR VGND sg13cmos5l_buf_1
X_4189_ _4189_/X AXI_M_SOC_BVALID _4224_/X _4228_/X _4208_/X _1763_/Q _1762_/Q VPWR
+ VGND sg13cmos5l_mux4_1
XFILLER_227_140 VPWR VGND sg13cmos5l_fill_2
XFILLER_431_210 VPWR VGND sg13cmos5l_decap_8
XFILLER_103_77 VPWR VGND sg13cmos5l_decap_8
XFILLER_256_7 VPWR VGND sg13cmos5l_decap_8
XFILLER_400_42 VPWR VGND sg13cmos5l_decap_8
XFILLER_242_176 VPWR VGND sg13cmos5l_decap_8
XFILLER_400_53 VPWR VGND sg13cmos5l_fill_2
XFILLER_423_7 VPWR VGND sg13cmos5l_decap_8
XANTENNA__2903__X Tile_X0Y6_FrameData_O[24] VPWR VGND sg13cmos5l_antennanp
XFILLER_476_35 VPWR VGND sg13cmos5l_decap_8
XFILLER_259_70 VPWR VGND sg13cmos5l_decap_4
XFILLER_476_46 VPWR VGND sg13cmos5l_fill_2
XFILLER_545_144 VPWR VGND sg13cmos5l_fill_2
XFILLER_259_81 VPWR VGND sg13cmos5l_fill_2
XFILLER_195_14 VPWR VGND sg13cmos5l_decap_8
XFILLER_155_106 VPWR VGND sg13cmos5l_decap_8
XFILLER_6_105 VPWR VGND sg13cmos5l_decap_4
XFILLER_545_188 VPWR VGND sg13cmos5l_decap_8
XFILLER_10_178 VPWR VGND sg13cmos5l_decap_8
XFILLER_626_49 VPWR VGND sg13cmos5l_decap_8
XFILLER_409_84 VPWR VGND sg13cmos5l_decap_8
XFILLER_12_63 VPWR VGND sg13cmos5l_decap_8
XFILLER_560_147 VPWR VGND sg13cmos5l_decap_4
XFILLER_702_130 VPWR VGND sg13cmos5l_fill_1
XFILLER_345_28 VPWR VGND sg13cmos5l_decap_8
XFILLER_128_63 VPWR VGND sg13cmos5l_decap_8
XFILLER_312_103 VPWR VGND sg13cmos5l_fill_1
XFILLER_128_74 VPWR VGND sg13cmos5l_fill_1
XFILLER_501_203 VPWR VGND sg13cmos5l_decap_8
XFILLER_492_56 VPWR VGND sg13cmos5l_decap_8
XANTENNA__3734__X AXI_M_SOC_ARADDR6 VPWR VGND sg13cmos5l_antennanp
XFILLER_275_91 VPWR VGND sg13cmos5l_decap_8
XFILLER_128_96 VPWR VGND sg13cmos5l_decap_4
XFILLER_312_125 VPWR VGND sg13cmos5l_decap_4
XFILLER_88_89 VPWR VGND sg13cmos5l_decap_8
XFILLER_77_101 VPWR VGND sg13cmos5l_decap_8
XFILLER_361_49 VPWR VGND sg13cmos5l_decap_8
XFILLER_481_110 VPWR VGND sg13cmos5l_fill_1
XFILLER_615_126 VPWR VGND sg13cmos5l_decap_8
XFILLER_282_0 VPWR VGND sg13cmos5l_decap_8
XFILLER_481_132 VPWR VGND sg13cmos5l_fill_2
XFILLER_481_165 VPWR VGND sg13cmos5l_decap_8
XFILLER_481_176 VPWR VGND sg13cmos5l_fill_1
XFILLER_547_0 VPWR VGND sg13cmos5l_decap_8
XFILLER_233_176 VPWR VGND sg13cmos5l_decap_4
XFILLER_379_169 VPWR VGND sg13cmos5l_decap_4
XFILLER_310_64 VPWR VGND sg13cmos5l_decap_8
XFILLER_583_217 VPWR VGND sg13cmos5l_fill_1
XFILLER_714_0 VPWR VGND sg13cmos5l_decap_8
XFILLER_667_45 VPWR VGND sg13cmos5l_decap_8
XANTENNA__2813__X Tile_X0Y3_E2BEG[3] VPWR VGND sg13cmos5l_antennanp
X_0910_ _0910_/Q Tile_X0Y9_FrameData[17] VGND VPWR Tile_X0Y9_FrameStrobe[7] latch
X_1890_ _1890_/Q Tile_X0Y3_FrameData[7] VGND VPWR Tile_X0Y9_FrameStrobe[6] latch
XFILLER_386_35 VPWR VGND sg13cmos5l_decap_8
XFILLER_536_144 VPWR VGND sg13cmos5l_decap_4
X_0841_ _0841_/Q Tile_X0Y9_FrameData[22] VGND VPWR Tile_X0Y9_FrameStrobe[5] latch
X_3560_ Tile_X0Y9_EE4BEG[6] _4870_/X VPWR VGND sg13cmos5l_buf_1
X_0772_ _0772_/Q Tile_X0Y9_FrameData[27] VGND VPWR Tile_X0Y9_FrameStrobe[3] latch
XFILLER_536_49 VPWR VGND sg13cmos5l_decap_8
XFILLER_319_95 VPWR VGND sg13cmos5l_fill_2
X_2511_ _2511_/Q Tile_X0Y6_FrameData[24] VGND VPWR Tile_X0Y9_FrameStrobe[2] latch
XFILLER_154_150 VPWR VGND sg13cmos5l_fill_2
XFILLER_255_28 VPWR VGND sg13cmos5l_decap_8
X_3491_ Tile_X0Y1_E6BEG[1] _3965_/X VPWR VGND sg13cmos5l_buf_1
XANTENNA__3644__X AXI_M_SOC_AWADDR5 VPWR VGND sg13cmos5l_antennanp
X_2442_ _2442_/Q Tile_X0Y6_FrameData[29] VGND VPWR Tile_X0Y9_FrameStrobe[0] latch
XFILLER_303_158 VPWR VGND sg13cmos5l_decap_8
X_2373_ _2373_/Q Tile_X0Y5_FrameData[0] VGND VPWR Tile_X0Y9_FrameStrobe[5] latch
X_4112_ _4112_/X _4574_/X _4578_/X _4582_/X _4557_/X _2665_/Q _2664_/Q VPWR VGND sg13cmos5l_mux4_1
XFILLER_68_134 VPWR VGND sg13cmos5l_decap_8
X_1324_ _1324_/Q Tile_X0Y1_FrameData[13] VGND VPWR Tile_X0Y9_FrameStrobe[4] latch
XFILLER_271_49 VPWR VGND sg13cmos5l_decap_8
XFILLER_632_70 VPWR VGND sg13cmos5l_decap_8
XFILLER_204_21 VPWR VGND sg13cmos5l_decap_8
X_4043_ _4043_/X Tile_X0Y2_W2MID[4] AXI_M_SOC_AWREADY _4103_/X _4102_/X _1587_/Q _1586_/Q
+ VPWR VGND sg13cmos5l_mux4_1
X_1255_ _1255_/Q Tile_X0Y1_FrameData[18] VGND VPWR Tile_X0Y9_FrameStrobe[2] latch
XFILLER_472_143 VPWR VGND sg13cmos5l_decap_4
XFILLER_209_140 VPWR VGND sg13cmos5l_decap_8
XFILLER_472_154 VPWR VGND sg13cmos5l_decap_8
X_0206_ _0206_/Q Tile_X0Y7_FrameData[17] VGND VPWR Tile_X0Y9_FrameStrobe[1] latch
XFILLER_209_184 VPWR VGND sg13cmos5l_fill_1
XFILLER_204_98 VPWR VGND sg13cmos5l_decap_8
X_1186_ _1186_/Q Tile_X0Y1_FrameData[23] VGND VPWR Tile_X0Y9_FrameStrobe[0] latch
XFILLER_559_203 VPWR VGND sg13cmos5l_fill_2
XFILLER_501_63 VPWR VGND sg13cmos5l_decap_8
X_0137_ AXI_M_SOC_AWLEN6 _0940_/Q _3677_/X VPWR VGND sg13cmos5l_nor2b_1
XFILLER_24_215 VPWR VGND sg13cmos5l_fill_2
XFILLER_220_42 VPWR VGND sg13cmos5l_decap_8
X_0068_ AXI_M_SOC_WSTRB3 _0935_/Q _3725_/X VPWR VGND sg13cmos5l_or2_1
XFILLER_574_206 VPWR VGND sg13cmos5l_decap_8
XFILLER_574_217 VPWR VGND sg13cmos5l_fill_1
XFILLER_577_56 VPWR VGND sg13cmos5l_decap_8
XFILLER_716_211 VPWR VGND sg13cmos5l_fill_1
X_4876_ _4876_/X Tile_X0Y9_WW4END[3] AXI_M_SOC_RDATA3 _4919_/X _4907_/X _0791_/Q _0790_/Q
+ VPWR VGND sg13cmos5l_mux4_1
XFILLER_296_35 VPWR VGND sg13cmos5l_decap_8
X_3827_ _3827_/X Tile_X0Y0_WW4END[8] _3876_/X _3853_/X _3860_/X _1051_/Q _1050_/Q
+ VPWR VGND sg13cmos5l_mux4_1
X_3758_ AXI_M_SOC_ARADDR30 Tile_X0Y8_W1END[2] Tile_X0Y8_WW4END[6] Tile_X0Y8_WW4END[14]
+ _4814_/X _0475_/Q _0474_/Q VPWR VGND sg13cmos5l_mux4_1
XFILLER_446_49 VPWR VGND sg13cmos5l_fill_2
XFILLER_152_109 VPWR VGND sg13cmos5l_decap_8
X_2709_ _4422_/A3 VPWR VGND sg13cmos5l_tielo
X_3689_ AXI_M_SOC_AWVALID Tile_X0Y2_WW4END[0] Tile_X0Y2_WW4END[8] Tile_X0Y2_W6END[0]
+ _4116_/X _1505_/Q _1504_/Q VPWR VGND sg13cmos5l_mux4_1
XANTENNA__3554__X Tile_X0Y9_EE4BEG[0] VPWR VGND sg13cmos5l_antennanp
XFILLER_495_202 VPWR VGND sg13cmos5l_fill_2
XFILLER_550_180 VPWR VGND sg13cmos5l_decap_8
XFILLER_58_15 VPWR VGND sg13cmos5l_decap_4
XFILLER_59_112 VPWR VGND sg13cmos5l_decap_8
XFILLER_58_48 VPWR VGND sg13cmos5l_fill_2
XFILLER_652_210 VPWR VGND sg13cmos5l_decap_8
XFILLER_74_115 VPWR VGND sg13cmos5l_decap_8
XFILLER_373_7 VPWR VGND sg13cmos5l_decap_8
XFILLER_74_14 VPWR VGND sg13cmos5l_decap_8
XFILLER_262_205 VPWR VGND sg13cmos5l_decap_4
XFILLER_74_148 VPWR VGND sg13cmos5l_decap_8
XFILLER_74_47 VPWR VGND sg13cmos5l_decap_8
XFILLER_605_192 VPWR VGND sg13cmos5l_fill_2
XFILLER_540_7 VPWR VGND sg13cmos5l_decap_8
XFILLER_411_63 VPWR VGND sg13cmos5l_decap_8
XFILLER_638_7 VPWR VGND sg13cmos5l_decap_8
XFILLER_82_181 VPWR VGND sg13cmos5l_fill_2
XFILLER_130_42 VPWR VGND sg13cmos5l_decap_8
XFILLER_230_113 VPWR VGND sg13cmos5l_decap_8
XANTENNA__0137__Y AXI_M_SOC_AWLEN6 VPWR VGND sg13cmos5l_antennanp
XFILLER_90_35 VPWR VGND sg13cmos5l_decap_8
XANTENNA__3729__X AXI_M_SOC_ARADDR1 VPWR VGND sg13cmos5l_antennanp
XFILLER_487_56 VPWR VGND sg13cmos5l_decap_8
XFILLER_384_172 VPWR VGND sg13cmos5l_decap_8
XFILLER_317_217 VPWR VGND sg13cmos5l_fill_1
XFILLER_23_84 VPWR VGND sg13cmos5l_fill_1
XFILLER_128_0 VPWR VGND sg13cmos5l_decap_8
XFILLER_356_49 VPWR VGND sg13cmos5l_decap_8
XFILLER_139_84 VPWR VGND sg13cmos5l_decap_8
XFILLER_533_158 VPWR VGND sg13cmos5l_decap_8
XFILLER_99_66 VPWR VGND sg13cmos5l_decap_8
XFILLER_653_14 VPWR VGND sg13cmos5l_decap_8
XFILLER_136_161 VPWR VGND sg13cmos5l_decap_8
XANTENNA__3464__X Tile_X0Y1_FrameData_O[22] VPWR VGND sg13cmos5l_antennanp
XFILLER_297_102 VPWR VGND sg13cmos5l_fill_2
XFILLER_2_130 VPWR VGND sg13cmos5l_decap_8
XFILLER_155_50 VPWR VGND sg13cmos5l_decap_4
XFILLER_97_207 VPWR VGND sg13cmos5l_fill_1
XFILLER_155_61 VPWR VGND sg13cmos5l_fill_2
XFILLER_151_164 VPWR VGND sg13cmos5l_fill_2
XFILLER_497_0 VPWR VGND sg13cmos5l_decap_8
XFILLER_2_152 VPWR VGND sg13cmos5l_decap_8
XFILLER_305_20 VPWR VGND sg13cmos5l_decap_4
XFILLER_439_184 VPWR VGND sg13cmos5l_fill_2
XFILLER_664_0 VPWR VGND sg13cmos5l_decap_8
XANTENNA__2808__X Tile_X0Y3_E2BEGb[6] VPWR VGND sg13cmos5l_antennanp
XFILLER_17_7 VPWR VGND sg13cmos5l_decap_8
XFILLER_253_216 VPWR VGND sg13cmos5l_fill_2
X_1040_ _1040_/Q Tile_X0Y0_FrameData[27] VGND VPWR Tile_X0Y9_FrameStrobe[3] latch
XFILLER_65_159 VPWR VGND sg13cmos5l_decap_8
XFILLER_454_198 VPWR VGND sg13cmos5l_decap_8
XFILLER_603_129 VPWR VGND sg13cmos5l_decap_8
XFILLER_80_118 VPWR VGND sg13cmos5l_decap_8
XFILLER_206_132 VPWR VGND sg13cmos5l_decap_8
XFILLER_0_77 VPWR VGND sg13cmos5l_decap_4
XANTENNA__0047__Y AXI_M_SOC_AWCACHE2 VPWR VGND sg13cmos5l_antennanp
XFILLER_367_106 VPWR VGND sg13cmos5l_decap_8
X_2991_ Tile_X0Y8_FrameData_O[31] Tile_X0Y8_FrameData[31] VPWR VGND sg13cmos5l_buf_1
XANTENNA__3639__X AXI_M_SOC_AWADDR0 VPWR VGND sg13cmos5l_antennanp
XFILLER_397_56 VPWR VGND sg13cmos5l_decap_8
X_4730_ _4730_/X Tile_X0Y8_W2MID[5] AXI_M_SOC_RDATA10 _4789_/X _4788_/X _0587_/Q _0586_/Q
+ VPWR VGND sg13cmos5l_mux4_1
XFILLER_9_42 VPWR VGND sg13cmos5l_decap_8
X_1942_ _1942_/Q Tile_X0Y4_FrameData[15] VGND VPWR Tile_X0Y9_FrameStrobe[0] latch
XFILLER_694_21 VPWR VGND sg13cmos5l_decap_8
X_4661_ _4661_/X Tile_X0Y8_W1END[0] Tile_X0Y8_W6END[4] _4812_/X _4772_/X _0671_/Q
+ _0670_/Q VPWR VGND sg13cmos5l_mux4_1
X_1873_ _1873_/Q Tile_X0Y3_FrameData[24] VGND VPWR Tile_X0Y9_FrameStrobe[6] latch
XFILLER_509_177 VPWR VGND sg13cmos5l_fill_1
X_3612_ Tile_X0Y9_S2BEG[6] _4834_/X VPWR VGND sg13cmos5l_buf_1
X_0824_ _0824_/Q Tile_X0Y9_FrameData[7] VGND VPWR Tile_X0Y9_FrameStrobe[4] latch
XFILLER_390_131 VPWR VGND sg13cmos5l_decap_4
X_4592_ _4592_/X Tile_X0Y5_W1END[0] Tile_X0Y5_W2MID[3] Tile_X0Y5_W2END[3] _4433_/X
+ _2387_/Q _2386_/Q VPWR VGND sg13cmos5l_mux4_1
XFILLER_694_98 VPWR VGND sg13cmos5l_decap_8
XFILLER_524_136 VPWR VGND sg13cmos5l_decap_8
XFILLER_266_49 VPWR VGND sg13cmos5l_decap_8
XFILLER_627_70 VPWR VGND sg13cmos5l_decap_8
XFILLER_390_142 VPWR VGND sg13cmos5l_decap_8
XFILLER_196_90 VPWR VGND sg13cmos5l_decap_4
X_3543_ Tile_X0Y9_E6BEG[1] _4881_/X VPWR VGND sg13cmos5l_buf_1
XFILLER_563_14 VPWR VGND sg13cmos5l_decap_8
XFILLER_127_161 VPWR VGND sg13cmos5l_decap_8
X_0755_ _0755_/Q Tile_X0Y9_FrameData[12] VGND VPWR Tile_X0Y9_FrameStrobe[2] latch
XANTENNA__3374__X Tile_X0Y2_EE4BEG[13] VPWR VGND sg13cmos5l_antennanp
XFILLER_288_102 VPWR VGND sg13cmos5l_fill_1
X_3474_ Tile_X0Y1_EE4BEG[0] _3948_/X VPWR VGND sg13cmos5l_buf_1
X_0686_ _0686_/Q Tile_X0Y9_FrameData[17] VGND VPWR Tile_X0Y9_FrameStrobe[0] latch
XFILLER_142_164 VPWR VGND sg13cmos5l_fill_2
XFILLER_713_28 VPWR VGND sg13cmos5l_decap_8
X_2425_ _2425_/Q Tile_X0Y5_FrameData[12] VGND VPWR Tile_X0Y9_FrameStrobe[7] latch
XFILLER_643_91 VPWR VGND sg13cmos5l_decap_8
XFILLER_215_42 VPWR VGND sg13cmos5l_decap_8
XFILLER_693_176 VPWR VGND sg13cmos5l_decap_8
X_2356_ _2356_/Q Tile_X0Y5_FrameData[17] VGND VPWR Tile_X0Y9_FrameStrobe[5] latch
X_1307_ _1307_/Q Tile_X0Y1_FrameData[30] VGND VPWR Tile_X0Y9_FrameStrobe[4] latch
X_2287_ _2287_/Q Tile_X0Y5_FrameData[22] VGND VPWR Tile_X0Y9_FrameStrobe[3] latch
XFILLER_445_165 VPWR VGND sg13cmos5l_decap_8
XFILLER_244_216 VPWR VGND sg13cmos5l_fill_2
XFILLER_56_148 VPWR VGND sg13cmos5l_fill_2
X_4026_ _4026_/X Tile_X0Y0_W2MID[4] Tile_X0Y0_W2END[4] Tile_X0Y0_W6END[11] _3859_/X
+ _1127_/Q _1126_/Q VPWR VGND sg13cmos5l_mux4_1
X_1238_ _1238_/Q Tile_X0Y1_FrameData[3] VGND VPWR Tile_X0Y9_FrameStrobe[1] latch
XFILLER_512_84 VPWR VGND sg13cmos5l_decap_8
XFILLER_71_118 VPWR VGND sg13cmos5l_decap_8
X_1169_ _1169_/Q Tile_X0Y0_FrameData[26] VGND VPWR Tile_X0Y9_FrameStrobe[7] latch
XFILLER_64_181 VPWR VGND sg13cmos5l_decap_8
XFILLER_602_173 VPWR VGND sg13cmos5l_decap_4
XFILLER_588_88 VPWR VGND sg13cmos5l_decap_8
XFILLER_602_184 VPWR VGND sg13cmos5l_decap_8
XFILLER_212_146 VPWR VGND sg13cmos5l_decap_8
XANTENNA__3549__X Tile_X0Y9_E6BEG[7] VPWR VGND sg13cmos5l_antennanp
XFILLER_100_34 VPWR VGND sg13cmos5l_decap_8
X_4928_ _4928_/X Tile_X0Y9_N1END[0] Tile_X0Y9_N4END[0] _4896_/X _0083_/X _0703_/Q
+ _0702_/Q VPWR VGND sg13cmos5l_mux4_1
X_4859_ _4859_/X Tile_X0Y9_W2END[4] AXI_M_SOC_RDATA4 _4907_/X _4906_/X _0825_/Q _0824_/Q
+ VPWR VGND sg13cmos5l_mux4_1
XFILLER_60_49 VPWR VGND sg13cmos5l_decap_8
XFILLER_366_183 VPWR VGND sg13cmos5l_decap_8
XFILLER_121_7 VPWR VGND sg13cmos5l_decap_8
XFILLER_381_142 VPWR VGND sg13cmos5l_fill_1
XFILLER_537_81 VPWR VGND sg13cmos5l_fill_1
XFILLER_381_164 VPWR VGND sg13cmos5l_decap_8
XFILLER_114_6 VPWR VGND sg13cmos5l_decap_8
XFILLER_473_14 VPWR VGND sg13cmos5l_decap_8
XFILLER_109_43 VPWR VGND sg13cmos5l_fill_1
XANTENNA__3284__X Tile_X0Y0_E6BEG[4] VPWR VGND sg13cmos5l_antennanp
XFILLER_69_25 VPWR VGND sg13cmos5l_decap_8
XFILLER_669_162 VPWR VGND sg13cmos5l_fill_1
XFILLER_523_180 VPWR VGND sg13cmos5l_decap_8
XFILLER_79_207 VPWR VGND sg13cmos5l_fill_1
XFILLER_279_146 VPWR VGND sg13cmos5l_decap_8
XFILLER_490_7 VPWR VGND sg13cmos5l_decap_8
XFILLER_623_28 VPWR VGND sg13cmos5l_decap_8
XFILLER_588_7 VPWR VGND sg13cmos5l_decap_8
XFILLER_553_91 VPWR VGND sg13cmos5l_decap_8
XFILLER_294_116 VPWR VGND sg13cmos5l_fill_1
XFILLER_125_42 VPWR VGND sg13cmos5l_decap_8
XFILLER_272_70 VPWR VGND sg13cmos5l_decap_8
XFILLER_85_35 VPWR VGND sg13cmos5l_decap_8
XFILLER_436_187 VPWR VGND sg13cmos5l_decap_4
XFILLER_422_84 VPWR VGND sg13cmos5l_decap_8
XFILLER_62_107 VPWR VGND sg13cmos5l_decap_8
XFILLER_141_41 VPWR VGND sg13cmos5l_decap_8
XFILLER_141_74 VPWR VGND sg13cmos5l_decap_8
XFILLER_55_181 VPWR VGND sg13cmos5l_decap_8
XFILLER_498_77 VPWR VGND sg13cmos5l_decap_8
XFILLER_648_14 VPWR VGND sg13cmos5l_decap_8
XFILLER_538_206 VPWR VGND sg13cmos5l_fill_2
XFILLER_245_0 VPWR VGND sg13cmos5l_fill_2
XANTENNA__3459__X Tile_X0Y1_FrameData_O[17] VPWR VGND sg13cmos5l_antennanp
XFILLER_156_201 VPWR VGND sg13cmos5l_decap_8
XFILLER_357_161 VPWR VGND sg13cmos5l_decap_8
XFILLER_412_0 VPWR VGND sg13cmos5l_decap_8
XFILLER_211_190 VPWR VGND sg13cmos5l_fill_1
XFILLER_506_136 VPWR VGND sg13cmos5l_fill_1
XFILLER_372_131 VPWR VGND sg13cmos5l_decap_8
XFILLER_664_35 VPWR VGND sg13cmos5l_decap_8
XFILLER_506_158 VPWR VGND sg13cmos5l_fill_2
XFILLER_383_14 VPWR VGND sg13cmos5l_decap_8
XFILLER_109_172 VPWR VGND sg13cmos5l_fill_2
XANTENNA__3194__X Tile_X0Y0_N2BEGb[2] VPWR VGND sg13cmos5l_antennanp
X_0540_ _0540_/Q Tile_X0Y8_FrameData[3] VGND VPWR Tile_X0Y9_FrameStrobe[3] latch
XFILLER_533_28 VPWR VGND sg13cmos5l_decap_8
X_0471_ _0471_/Q Tile_X0Y8_FrameData[8] VGND VPWR Tile_X0Y9_FrameStrobe[1] latch
XFILLER_285_105 VPWR VGND sg13cmos5l_decap_8
XFILLER_680_56 VPWR VGND sg13cmos5l_decap_8
XFILLER_285_116 VPWR VGND sg13cmos5l_fill_1
X_2210_ _2210_/Q Tile_X0Y5_FrameData[3] VGND VPWR Tile_X0Y9_FrameStrobe[0] latch
XFILLER_675_176 VPWR VGND sg13cmos5l_decap_8
XFILLER_285_138 VPWR VGND sg13cmos5l_decap_8
X_3190_ Tile_X0Y0_N4BEG[14] _3190_/A VPWR VGND sg13cmos5l_buf_1
XFILLER_616_210 VPWR VGND sg13cmos5l_fill_2
XFILLER_182_92 VPWR VGND sg13cmos5l_decap_4
XFILLER_93_210 VPWR VGND sg13cmos5l_fill_1
X_2141_ _2141_/Q Tile_X0Y4_FrameData[8] VGND VPWR Tile_X0Y9_FrameStrobe[6] latch
XFILLER_427_154 VPWR VGND sg13cmos5l_decap_8
XFILLER_38_126 VPWR VGND sg13cmos5l_decap_4
XFILLER_38_137 VPWR VGND sg13cmos5l_decap_4
XFILLER_689_21 VPWR VGND sg13cmos5l_decap_8
XFILLER_631_202 VPWR VGND sg13cmos5l_decap_8
X_2072_ _2072_/Q Tile_X0Y4_FrameData[13] VGND VPWR Tile_X0Y9_FrameStrobe[4] latch
XFILLER_427_198 VPWR VGND sg13cmos5l_decap_8
X_1023_ _1023_/Q Tile_X0Y0_FrameData[12] VGND VPWR Tile_X0Y9_FrameStrobe[2] latch
XFILLER_61_151 VPWR VGND sg13cmos5l_decap_8
XFILLER_558_14 VPWR VGND sg13cmos5l_decap_8
XFILLER_529_217 VPWR VGND sg13cmos5l_fill_1
XANTENNA__3369__X Tile_X0Y2_EE4BEG[8] VPWR VGND sg13cmos5l_antennanp
XFILLER_201_77 VPWR VGND sg13cmos5l_decap_8
X_2974_ Tile_X0Y8_FrameData_O[14] Tile_X0Y8_FrameData[14] VPWR VGND sg13cmos5l_buf_1
X_1925_ _1925_/Q Tile_X0Y3_FrameData[4] VGND VPWR Tile_X0Y9_FrameStrobe[7] latch
X_4713_ _4713_/X Tile_X0Y9_W2MID[1] Tile_X0Y9_W2END[1] Tile_X0Y9_W6END[1] _4902_/X
+ _0907_/Q _0906_/Q VPWR VGND sg13cmos5l_mux4_1
XFILLER_147_201 VPWR VGND sg13cmos5l_decap_8
XFILLER_708_28 VPWR VGND sg13cmos5l_decap_8
XFILLER_638_91 VPWR VGND sg13cmos5l_decap_8
X_4644_ _4644_/X Tile_X0Y9_N4END[8] _0056_/X _4695_/X _4699_/X _0271_/Q _0270_/Q VPWR
+ VGND sg13cmos5l_mux4_1
X_1856_ _1856_/Q Tile_X0Y3_FrameData[9] VGND VPWR Tile_X0Y9_FrameStrobe[5] latch
XFILLER_574_35 VPWR VGND sg13cmos5l_decap_8
XFILLER_357_70 VPWR VGND sg13cmos5l_decap_8
X_0807_ _0807_/Q Tile_X0Y9_FrameData[24] VGND VPWR Tile_X0Y9_FrameStrobe[4] latch
XFILLER_293_14 VPWR VGND sg13cmos5l_decap_8
X_4575_ _4575_/X _4551_/X Tile_X0Y9_N4END[15] _4550_/X _0150_/X _2481_/Q _2480_/Q
+ VPWR VGND sg13cmos5l_mux4_1
X_1787_ _1787_/Q Tile_X0Y3_FrameData[14] VGND VPWR Tile_X0Y9_FrameStrobe[3] latch
X_3526_ Tile_X0Y9_E2BEG[0] _4848_/X VPWR VGND sg13cmos5l_buf_1
X_0738_ _0738_/Q Tile_X0Y9_FrameData[29] VGND VPWR Tile_X0Y9_FrameStrobe[2] latch
XFILLER_505_191 VPWR VGND sg13cmos5l_decap_8
XFILLER_507_84 VPWR VGND sg13cmos5l_decap_8
XFILLER_115_164 VPWR VGND sg13cmos5l_decap_4
XFILLER_443_28 VPWR VGND sg13cmos5l_decap_8
XFILLER_115_175 VPWR VGND sg13cmos5l_fill_2
X_3457_ Tile_X0Y1_FrameData_O[15] Tile_X0Y1_FrameData[15] VPWR VGND sg13cmos5l_buf_1
XFILLER_130_112 VPWR VGND sg13cmos5l_decap_8
X_0669_ _0669_/Q Tile_X0Y8_FrameData[2] VGND VPWR Tile_X0Y9_FrameStrobe[7] latch
XFILLER_276_105 VPWR VGND sg13cmos5l_decap_8
XFILLER_590_56 VPWR VGND sg13cmos5l_fill_2
XFILLER_39_39 VPWR VGND sg13cmos5l_decap_8
X_2408_ _2408_/Q Tile_X0Y5_FrameData[29] VGND VPWR Tile_X0Y9_FrameStrobe[7] latch
X_3388_ Tile_X0Y2_E6BEG[11] _4083_/X VPWR VGND sg13cmos5l_buf_1
XFILLER_29_115 VPWR VGND sg13cmos5l_decap_8
XFILLER_130_189 VPWR VGND sg13cmos5l_decap_8
X_2339_ _2339_/Q Tile_X0Y5_FrameData[2] VGND VPWR Tile_X0Y9_FrameStrobe[4] latch
XFILLER_599_21 VPWR VGND sg13cmos5l_decap_8
XFILLER_55_27 VPWR VGND sg13cmos5l_decap_8
XFILLER_599_65 VPWR VGND sg13cmos5l_fill_1
X_4009_ _4009_/X _3983_/X _0096_/X _3982_/X Tile_X0Y0_S4END[5] _1231_/Q _1230_/Q VPWR
+ VGND sg13cmos5l_mux4_1
XFILLER_599_87 VPWR VGND sg13cmos5l_decap_8
XFILLER_169_7 VPWR VGND sg13cmos5l_decap_8
XFILLER_111_33 VPWR VGND sg13cmos5l_decap_8
XFILLER_52_151 VPWR VGND sg13cmos5l_decap_8
XFILLER_468_14 VPWR VGND sg13cmos5l_decap_8
XANTENNA__3279__X Tile_X0Y0_EE4BEG[15] VPWR VGND sg13cmos5l_antennanp
XFILLER_336_7 VPWR VGND sg13cmos5l_decap_8
XFILLER_71_48 VPWR VGND sg13cmos5l_decap_8
XFILLER_200_105 VPWR VGND sg13cmos5l_decap_8
XFILLER_618_28 VPWR VGND sg13cmos5l_decap_8
XFILLER_548_91 VPWR VGND sg13cmos5l_decap_8
XFILLER_503_7 VPWR VGND sg13cmos5l_decap_8
XANTENNA__2911__X Tile_X0Y6_UserCLKo VPWR VGND sg13cmos5l_antennanp
XFILLER_484_35 VPWR VGND sg13cmos5l_decap_8
XFILLER_267_70 VPWR VGND sg13cmos5l_decap_8
XFILLER_153_215 VPWR VGND sg13cmos5l_fill_2
XFILLER_4_214 VPWR VGND sg13cmos5l_decap_4
XFILLER_105_2 VPWR VGND sg13cmos5l_fill_1
XFILLER_634_49 VPWR VGND sg13cmos5l_decap_8
XFILLER_417_84 VPWR VGND sg13cmos5l_decap_8
XFILLER_106_153 VPWR VGND sg13cmos5l_decap_8
XFILLER_657_132 VPWR VGND sg13cmos5l_fill_2
XFILLER_511_150 VPWR VGND sg13cmos5l_decap_8
XFILLER_353_28 VPWR VGND sg13cmos5l_decap_8
XFILLER_136_63 VPWR VGND sg13cmos5l_decap_8
XANTENNA__3742__X AXI_M_SOC_ARADDR14 VPWR VGND sg13cmos5l_antennanp
XFILLER_657_165 VPWR VGND sg13cmos5l_fill_1
XFILLER_456_216 VPWR VGND sg13cmos5l_fill_2
XFILLER_283_91 VPWR VGND sg13cmos5l_decap_8
XFILLER_267_116 VPWR VGND sg13cmos5l_fill_2
XFILLER_96_45 VPWR VGND sg13cmos5l_decap_8
XFILLER_657_187 VPWR VGND sg13cmos5l_decap_4
XFILLER_195_0 VPWR VGND sg13cmos5l_fill_2
XFILLER_409_143 VPWR VGND sg13cmos5l_decap_8
XFILLER_471_208 VPWR VGND sg13cmos5l_fill_1
XFILLER_282_119 VPWR VGND sg13cmos5l_decap_8
XFILLER_29_83 VPWR VGND sg13cmos5l_fill_1
XFILLER_208_216 VPWR VGND sg13cmos5l_fill_2
XFILLER_152_95 VPWR VGND sg13cmos5l_decap_8
XFILLER_362_0 VPWR VGND sg13cmos5l_decap_8
XFILLER_302_21 VPWR VGND sg13cmos5l_decap_8
XFILLER_659_35 VPWR VGND sg13cmos5l_decap_8
XFILLER_302_87 VPWR VGND sg13cmos5l_decap_8
XFILLER_578_161 VPWR VGND sg13cmos5l_decap_4
XFILLER_378_14 VPWR VGND sg13cmos5l_decap_8
XANTENNA__3189__X Tile_X0Y0_N4BEG[13] VPWR VGND sg13cmos5l_antennanp
XFILLER_627_0 VPWR VGND sg13cmos5l_decap_8
XFILLER_593_120 VPWR VGND sg13cmos5l_decap_8
XFILLER_188_167 VPWR VGND sg13cmos5l_decap_4
XFILLER_593_153 VPWR VGND sg13cmos5l_decap_8
XFILLER_392_215 VPWR VGND sg13cmos5l_fill_2
XFILLER_129_201 VPWR VGND sg13cmos5l_fill_1
XFILLER_528_28 VPWR VGND sg13cmos5l_decap_8
XFILLER_675_56 VPWR VGND sg13cmos5l_decap_8
XANTENNA__2821__X Tile_X0Y3_E1BEG[3] VPWR VGND sg13cmos5l_antennanp
X_1710_ _1710_/Q Tile_X0Y3_FrameData[27] VGND VPWR Tile_X0Y9_FrameStrobe[1] latch
XFILLER_61_81 VPWR VGND sg13cmos5l_decap_8
XFILLER_77_6 VPWR VGND sg13cmos5l_decap_8
X_2690_ _2690_/Q Tile_X0Y6_FrameData[5] VGND VPWR Tile_X0Y9_FrameStrobe[7] latch
XFILLER_394_35 VPWR VGND sg13cmos5l_decap_8
XFILLER_144_204 VPWR VGND sg13cmos5l_decap_8
XFILLER_6_21 VPWR VGND sg13cmos5l_decap_8
X_1641_ _1641_/Q Tile_X0Y2_FrameData[8] VGND VPWR Tile_X0Y9_FrameStrobe[6] latch
XANTENNA_3 _3769_/X VPWR VGND sg13cmos5l_antennanp
X_4360_ _4360_/X Tile_X0Y3_W1END[0] Tile_X0Y3_W2MID[3] Tile_X0Y3_W2END[3] _4210_/X
+ _1873_/Q _1872_/Q VPWR VGND sg13cmos5l_mux4_1
X_1572_ _1572_/Q Tile_X0Y2_FrameData[13] VGND VPWR Tile_X0Y9_FrameStrobe[4] latch
XFILLER_544_49 VPWR VGND sg13cmos5l_decap_8
XFILLER_6_98 VPWR VGND sg13cmos5l_decap_8
XFILLER_327_84 VPWR VGND sg13cmos5l_decap_8
X_3311_ Tile_X0Y0_E1BEG[3] _3803_/X VPWR VGND sg13cmos5l_buf_1
XFILLER_691_77 VPWR VGND sg13cmos5l_decap_8
X_0523_ _0523_/Q Tile_X0Y8_FrameData[20] VGND VPWR Tile_X0Y9_FrameStrobe[3] latch
XFILLER_301_201 VPWR VGND sg13cmos5l_fill_2
XFILLER_263_28 VPWR VGND sg13cmos5l_decap_8
X_4291_ _4291_/X _0040_/X _0109_/X _4344_/X _4348_/X _2031_/Q _2030_/Q VPWR VGND sg13cmos5l_mux4_1
XFILLER_502_161 VPWR VGND sg13cmos5l_decap_8
XFILLER_648_154 VPWR VGND sg13cmos5l_decap_8
XANTENNA__3652__X AXI_M_SOC_AWADDR13 VPWR VGND sg13cmos5l_antennanp
XFILLER_447_216 VPWR VGND sg13cmos5l_fill_2
X_3242_ Tile_X0Y0_FrameData_O[10] Tile_X0Y0_FrameData[10] VPWR VGND sg13cmos5l_buf_1
X_0454_ _0454_/Q Tile_X0Y8_FrameData[25] VGND VPWR Tile_X0Y9_FrameStrobe[1] latch
XFILLER_663_146 VPWR VGND sg13cmos5l_decap_8
X_3173_ Tile_X0Y4_E6BEG[10] _4298_/X VPWR VGND sg13cmos5l_buf_1
X_0385_ _0385_/Q Tile_X0Y7_FrameData[30] VGND VPWR Tile_X0Y9_FrameStrobe[7] latch
XFILLER_273_119 VPWR VGND sg13cmos5l_fill_1
XFILLER_266_171 VPWR VGND sg13cmos5l_decap_4
X_2124_ _2124_/Q Tile_X0Y4_FrameData[25] VGND VPWR Tile_X0Y9_FrameStrobe[6] latch
XFILLER_640_70 VPWR VGND sg13cmos5l_decap_8
XFILLER_415_135 VPWR VGND sg13cmos5l_decap_8
XFILLER_214_208 VPWR VGND sg13cmos5l_fill_2
X_2055_ _2055_/Q Tile_X0Y4_FrameData[30] VGND VPWR Tile_X0Y9_FrameStrobe[4] latch
XFILLER_569_35 VPWR VGND sg13cmos5l_decap_8
XFILLER_430_105 VPWR VGND sg13cmos5l_decap_8
XFILLER_212_76 VPWR VGND sg13cmos5l_decap_8
X_1006_ _1006_/Q Tile_X0Y0_FrameData[29] VGND VPWR Tile_X0Y9_FrameStrobe[2] latch
XFILLER_569_161 VPWR VGND sg13cmos5l_decap_8
XFILLER_368_212 VPWR VGND sg13cmos5l_decap_4
XFILLER_34_151 VPWR VGND sg13cmos5l_fill_2
XFILLER_288_14 VPWR VGND sg13cmos5l_decap_8
XANTENNA__3099__X Tile_X0Y7_E2BEGb[5] VPWR VGND sg13cmos5l_antennanp
XFILLER_569_194 VPWR VGND sg13cmos5l_decap_8
XFILLER_34_195 VPWR VGND sg13cmos5l_decap_8
X_2957_ Tile_X0Y8_EE4BEG[13] _4757_/X VPWR VGND sg13cmos5l_buf_1
XFILLER_438_28 VPWR VGND sg13cmos5l_decap_8
XFILLER_585_56 VPWR VGND sg13cmos5l_decap_8
X_1908_ _1908_/Q Tile_X0Y3_FrameData[21] VGND VPWR Tile_X0Y9_FrameStrobe[7] latch
XFILLER_157_18 VPWR VGND sg13cmos5l_fill_1
XFILLER_336_142 VPWR VGND sg13cmos5l_decap_8
X_2888_ Tile_X0Y6_FrameData_O[9] Tile_X0Y6_FrameData[9] VPWR VGND sg13cmos5l_buf_1
XFILLER_135_204 VPWR VGND sg13cmos5l_fill_2
X_1839_ _1839_/Q Tile_X0Y3_FrameData[26] VGND VPWR Tile_X0Y9_FrameStrobe[5] latch
X_4627_ _4627_/X Tile_X0Y7_W2END[0] AXI_M_SOC_RDATA16 _4669_/X _4668_/X _0305_/Q _0304_/Q
+ VPWR VGND sg13cmos5l_mux4_1
XFILLER_497_105 VPWR VGND sg13cmos5l_decap_8
XFILLER_351_112 VPWR VGND sg13cmos5l_decap_8
X_4558_ _4558_/X _4477_/X _4593_/X _4592_/X _4476_/X _2455_/Q _2454_/Q VPWR VGND sg13cmos5l_mux4_1
XFILLER_454_49 VPWR VGND sg13cmos5l_fill_1
X_3509_ Tile_X0Y1_E2BEGb[7] _3947_/X VPWR VGND sg13cmos5l_buf_1
X_4489_ _4489_/X _4574_/X _4578_/X _4582_/X _4554_/X _2629_/Q _2628_/Q VPWR VGND sg13cmos5l_mux4_1
XFILLER_639_154 VPWR VGND sg13cmos5l_decap_8
XANTENNA__3562__X Tile_X0Y9_EE4BEG[8] VPWR VGND sg13cmos5l_antennanp
XFILLER_103_145 VPWR VGND sg13cmos5l_decap_4
XFILLER_654_124 VPWR VGND sg13cmos5l_decap_8
XFILLER_249_149 VPWR VGND sg13cmos5l_decap_8
XFILLER_286_7 VPWR VGND sg13cmos5l_decap_8
XFILLER_264_119 VPWR VGND sg13cmos5l_decap_4
XFILLER_403_42 VPWR VGND sg13cmos5l_fill_2
XFILLER_279_6 VPWR VGND sg13cmos5l_decap_8
XFILLER_72_202 VPWR VGND sg13cmos5l_decap_8
XFILLER_406_135 VPWR VGND sg13cmos5l_fill_1
XFILLER_122_21 VPWR VGND sg13cmos5l_decap_8
XFILLER_453_7 VPWR VGND sg13cmos5l_decap_8
XANTENNA__2906__X Tile_X0Y6_FrameData_O[27] VPWR VGND sg13cmos5l_antennanp
XFILLER_479_35 VPWR VGND sg13cmos5l_decap_8
XFILLER_421_105 VPWR VGND sg13cmos5l_decap_8
XFILLER_122_65 VPWR VGND sg13cmos5l_decap_8
XFILLER_25_151 VPWR VGND sg13cmos5l_decap_8
XFILLER_198_14 VPWR VGND sg13cmos5l_decap_8
XFILLER_700_84 VPWR VGND sg13cmos5l_decap_8
XFILLER_421_149 VPWR VGND sg13cmos5l_decap_8
XFILLER_25_162 VPWR VGND sg13cmos5l_fill_2
XFILLER_82_69 VPWR VGND sg13cmos5l_decap_8
XFILLER_620_7 VPWR VGND sg13cmos5l_decap_8
XFILLER_709_147 VPWR VGND sg13cmos5l_decap_8
XFILLER_629_49 VPWR VGND sg13cmos5l_decap_8
XFILLER_15_63 VPWR VGND sg13cmos5l_fill_2
XFILLER_575_175 VPWR VGND sg13cmos5l_decap_8
XFILLER_348_28 VPWR VGND sg13cmos5l_decap_8
XFILLER_185_126 VPWR VGND sg13cmos5l_decap_8
XANTENNA__3737__X AXI_M_SOC_ARADDR9 VPWR VGND sg13cmos5l_antennanp
XFILLER_495_56 VPWR VGND sg13cmos5l_decap_8
XFILLER_278_91 VPWR VGND sg13cmos5l_decap_8
XFILLER_590_134 VPWR VGND sg13cmos5l_decap_4
XFILLER_590_145 VPWR VGND sg13cmos5l_decap_4
XFILLER_590_156 VPWR VGND sg13cmos5l_decap_8
XFILLER_31_62 VPWR VGND sg13cmos5l_fill_2
XFILLER_193_181 VPWR VGND sg13cmos5l_decap_4
XFILLER_110_0 VPWR VGND sg13cmos5l_decap_8
XFILLER_488_105 VPWR VGND sg13cmos5l_decap_8
XFILLER_208_0 VPWR VGND sg13cmos5l_fill_2
XFILLER_364_49 VPWR VGND sg13cmos5l_decap_8
XFILLER_661_14 VPWR VGND sg13cmos5l_decap_8
XANTENNA__3472__X Tile_X0Y1_FrameData_O[30] VPWR VGND sg13cmos5l_antennanp
XFILLER_496_182 VPWR VGND sg13cmos5l_decap_8
XFILLER_444_93 VPWR VGND sg13cmos5l_decap_8
XFILLER_577_0 VPWR VGND sg13cmos5l_decap_8
XFILLER_645_168 VPWR VGND sg13cmos5l_decap_8
XFILLER_660_105 VPWR VGND sg13cmos5l_fill_2
XFILLER_248_171 VPWR VGND sg13cmos5l_decap_8
X_0170_ _0170_/Q Tile_X0Y7_FrameData[21] VGND VPWR Tile_X0Y9_FrameStrobe[0] latch
XFILLER_263_130 VPWR VGND sg13cmos5l_fill_2
XFILLER_313_75 VPWR VGND sg13cmos5l_decap_8
XANTENNA__2816__X Tile_X0Y3_E2BEG[6] VPWR VGND sg13cmos5l_antennanp
XFILLER_56_81 VPWR VGND sg13cmos5l_decap_8
XFILLER_412_105 VPWR VGND sg13cmos5l_decap_8
XFILLER_389_35 VPWR VGND sg13cmos5l_decap_8
XFILLER_263_185 VPWR VGND sg13cmos5l_decap_8
XFILLER_610_95 VPWR VGND sg13cmos5l_fill_2
XFILLER_16_184 VPWR VGND sg13cmos5l_decap_4
X_3860_ _3860_/X _3849_/X Tile_X0Y0_W6END[1] Tile_X0Y0_S1END[1] _3860_/A3 _0945_/Q
+ _0944_/Q VPWR VGND sg13cmos5l_mux4_1
XFILLER_469_90 VPWR VGND sg13cmos5l_decap_4
XFILLER_31_143 VPWR VGND sg13cmos5l_decap_4
X_2811_ Tile_X0Y3_E2BEG[1] _4149_/X VPWR VGND sg13cmos5l_buf_1
XFILLER_566_175 VPWR VGND sg13cmos5l_fill_2
XFILLER_258_28 VPWR VGND sg13cmos5l_decap_8
X_3791_ _3791_/X Tile_X0Y0_W2MID[0] Tile_X0Y0_W2END[0] Tile_X0Y0_W6END[0] _3852_/X
+ _1155_/Q _1154_/Q VPWR VGND sg13cmos5l_mux4_1
XANTENNA__3647__X AXI_M_SOC_AWADDR8 VPWR VGND sg13cmos5l_antennanp
XFILLER_715_139 VPWR VGND sg13cmos5l_decap_8
XFILLER_581_134 VPWR VGND sg13cmos5l_decap_8
XFILLER_318_120 VPWR VGND sg13cmos5l_decap_4
X_2742_ Tile_X0Y3_FrameData_O[0] Tile_X0Y3_FrameData[0] VPWR VGND sg13cmos5l_buf_1
XFILLER_117_215 VPWR VGND sg13cmos5l_fill_2
XFILLER_522_201 VPWR VGND sg13cmos5l_decap_8
X_2673_ _2673_/Q Tile_X0Y6_FrameData[22] VGND VPWR Tile_X0Y9_FrameStrobe[7] latch
XFILLER_68_2 VPWR VGND sg13cmos5l_fill_1
XFILLER_668_205 VPWR VGND sg13cmos5l_fill_1
XANTENNA__0071__X AXI_M_SOC_WSTRB0 VPWR VGND sg13cmos5l_antennanp
X_4412_ _4412_/X AXI_M_SOC_RVALID _4454_/X _4458_/X _4433_/X _2279_/Q _2278_/Q VPWR
+ VGND sg13cmos5l_mux4_1
XFILLER_668_216 VPWR VGND sg13cmos5l_fill_2
X_1624_ _1624_/Q Tile_X0Y2_FrameData[25] VGND VPWR Tile_X0Y9_FrameStrobe[6] latch
XFILLER_274_49 VPWR VGND sg13cmos5l_decap_8
XFILLER_479_149 VPWR VGND sg13cmos5l_decap_8
XFILLER_635_70 VPWR VGND sg13cmos5l_decap_8
X_4343_ _4343_/X _4311_/X _0040_/X _4310_/X _0109_/X _1967_/Q _1966_/Q VPWR VGND sg13cmos5l_mux4_1
X_1555_ _1555_/Q Tile_X0Y2_FrameData[30] VGND VPWR Tile_X0Y9_FrameStrobe[4] latch
XFILLER_683_208 VPWR VGND sg13cmos5l_fill_1
XFILLER_571_14 VPWR VGND sg13cmos5l_decap_8
XFILLER_494_119 VPWR VGND sg13cmos5l_decap_8
XANTENNA__3382__X Tile_X0Y2_E6BEG[5] VPWR VGND sg13cmos5l_antennanp
XFILLER_286_211 VPWR VGND sg13cmos5l_decap_8
XFILLER_98_143 VPWR VGND sg13cmos5l_fill_2
XFILLER_207_76 VPWR VGND sg13cmos5l_decap_8
X_0506_ _0506_/Q Tile_X0Y8_FrameData[5] VGND VPWR Tile_X0Y9_FrameStrobe[2] latch
XFILLER_487_182 VPWR VGND sg13cmos5l_fill_2
X_4274_ _4274_/X Tile_X0Y4_WW4END[13] AXI_M_SOC_BRESP0 _4349_/X _4316_/X _2065_/Q
+ _2064_/Q VPWR VGND sg13cmos5l_mux4_1
X_1486_ _1486_/Q Tile_X0Y2_FrameData[3] VGND VPWR Tile_X0Y9_FrameStrobe[1] latch
X_3225_ Tile_X0Y0_FrameStrobe_O[13] Tile_X0Y9_FrameStrobe[13] VPWR VGND sg13cmos5l_buf_1
X_0437_ _0437_/Q Tile_X0Y8_FrameData[10] VGND VPWR Tile_X0Y9_FrameStrobe[0] latch
XFILLER_504_63 VPWR VGND sg13cmos5l_decap_8
XFILLER_651_105 VPWR VGND sg13cmos5l_decap_8
XFILLER_651_91 VPWR VGND sg13cmos5l_decap_8
XFILLER_223_42 VPWR VGND sg13cmos5l_decap_8
X_3156_ Tile_X0Y7_FrameData_O[26] Tile_X0Y7_FrameData[26] VPWR VGND sg13cmos5l_buf_1
X_0368_ _0368_/Q Tile_X0Y7_FrameData[15] VGND VPWR Tile_X0Y9_FrameStrobe[6] latch
X_2107_ _2107_/Q Tile_X0Y4_FrameData[10] VGND VPWR Tile_X0Y9_FrameStrobe[5] latch
X_3087_ Tile_X0Y7_E2BEG[1] _4613_/X VPWR VGND sg13cmos5l_buf_1
XFILLER_199_207 VPWR VGND sg13cmos5l_fill_2
X_0299_ _0299_/Q Tile_X0Y7_FrameData[20] VGND VPWR Tile_X0Y9_FrameStrobe[4] latch
XFILLER_299_35 VPWR VGND sg13cmos5l_decap_8
XFILLER_254_185 VPWR VGND sg13cmos5l_decap_8
XFILLER_403_116 VPWR VGND sg13cmos5l_decap_8
XFILLER_299_46 VPWR VGND sg13cmos5l_fill_2
XFILLER_254_196 VPWR VGND sg13cmos5l_fill_1
X_2038_ _2038_/Q Tile_X0Y4_FrameData[15] VGND VPWR Tile_X0Y9_FrameStrobe[3] latch
XFILLER_520_84 VPWR VGND sg13cmos5l_decap_8
XFILLER_210_211 VPWR VGND sg13cmos5l_fill_1
XFILLER_167_115 VPWR VGND sg13cmos5l_fill_1
XFILLER_572_112 VPWR VGND sg13cmos5l_decap_8
XFILLER_167_137 VPWR VGND sg13cmos5l_decap_8
X_3989_ _3989_/X _3888_/X _4021_/X _4020_/X Tile_X0Y0_S2MID[0] _1201_/Q _1200_/Q VPWR
+ VGND sg13cmos5l_mux4_1
XANTENNA__3557__X Tile_X0Y9_EE4BEG[3] VPWR VGND sg13cmos5l_antennanp
XFILLER_167_159 VPWR VGND sg13cmos5l_decap_8
XFILLER_529_93 VPWR VGND sg13cmos5l_decap_8
XFILLER_572_189 VPWR VGND sg13cmos5l_decap_8
XFILLER_714_161 VPWR VGND sg13cmos5l_decap_8
XFILLER_513_201 VPWR VGND sg13cmos5l_fill_1
XFILLER_324_112 VPWR VGND sg13cmos5l_decap_8
XFILLER_324_123 VPWR VGND sg13cmos5l_fill_2
XFILLER_659_216 VPWR VGND sg13cmos5l_fill_2
XFILLER_201_7 VPWR VGND sg13cmos5l_decap_8
XFILLER_545_70 VPWR VGND sg13cmos5l_decap_8
XFILLER_324_167 VPWR VGND sg13cmos5l_decap_8
XFILLER_117_21 VPWR VGND sg13cmos5l_decap_8
XFILLER_481_14 VPWR VGND sg13cmos5l_decap_8
XANTENNA__3292__X Tile_X0Y0_E2BEGb[0] VPWR VGND sg13cmos5l_antennanp
XFILLER_627_124 VPWR VGND sg13cmos5l_decap_8
XFILLER_117_98 VPWR VGND sg13cmos5l_decap_8
XFILLER_631_28 VPWR VGND sg13cmos5l_decap_8
XFILLER_570_7 VPWR VGND sg13cmos5l_decap_8
XFILLER_414_63 VPWR VGND sg13cmos5l_decap_8
XFILLER_668_7 VPWR VGND sg13cmos5l_decap_8
XFILLER_642_105 VPWR VGND sg13cmos5l_decap_8
XFILLER_561_91 VPWR VGND sg13cmos5l_decap_8
XFILLER_133_42 VPWR VGND sg13cmos5l_decap_8
XFILLER_45_202 VPWR VGND sg13cmos5l_decap_4
XFILLER_280_70 VPWR VGND sg13cmos5l_decap_8
XFILLER_93_35 VPWR VGND sg13cmos5l_decap_8
XFILLER_133_86 VPWR VGND sg13cmos5l_decap_8
XFILLER_650_182 VPWR VGND sg13cmos5l_decap_8
XFILLER_430_84 VPWR VGND sg13cmos5l_decap_8
XFILLER_158_0 VPWR VGND sg13cmos5l_decap_8
XFILLER_359_49 VPWR VGND sg13cmos5l_decap_8
XFILLER_548_153 VPWR VGND sg13cmos5l_decap_8
XFILLER_201_211 VPWR VGND sg13cmos5l_fill_1
XFILLER_158_115 VPWR VGND sg13cmos5l_decap_8
XFILLER_656_14 VPWR VGND sg13cmos5l_decap_8
XFILLER_563_112 VPWR VGND sg13cmos5l_decap_8
XFILLER_563_123 VPWR VGND sg13cmos5l_fill_2
XANTENNA__3467__X Tile_X0Y1_FrameData_O[25] VPWR VGND sg13cmos5l_antennanp
XFILLER_325_0 VPWR VGND sg13cmos5l_decap_8
XFILLER_9_158 VPWR VGND sg13cmos5l_fill_2
XFILLER_563_167 VPWR VGND sg13cmos5l_decap_4
XFILLER_158_50 VPWR VGND sg13cmos5l_decap_8
XFILLER_308_20 VPWR VGND sg13cmos5l_decap_8
XFILLER_672_35 VPWR VGND sg13cmos5l_decap_8
XFILLER_694_0 VPWR VGND sg13cmos5l_decap_8
XFILLER_181_173 VPWR VGND sg13cmos5l_decap_4
XFILLER_391_14 VPWR VGND sg13cmos5l_decap_8
XFILLER_618_102 VPWR VGND sg13cmos5l_fill_2
X_1340_ _1340_/Q Tile_X0Y1_FrameData[29] VGND VPWR Tile_X0Y9_FrameStrobe[5] latch
XFILLER_469_182 VPWR VGND sg13cmos5l_decap_8
XFILLER_174_93 VPWR VGND sg13cmos5l_decap_4
XFILLER_484_130 VPWR VGND sg13cmos5l_decap_4
XFILLER_484_141 VPWR VGND sg13cmos5l_decap_4
XFILLER_541_28 VPWR VGND sg13cmos5l_decap_8
XFILLER_484_152 VPWR VGND sg13cmos5l_fill_2
X_1271_ _1271_/Q Tile_X0Y1_FrameData[2] VGND VPWR Tile_X0Y9_FrameStrobe[2] latch
XFILLER_3_77 VPWR VGND sg13cmos5l_decap_8
XFILLER_95_146 VPWR VGND sg13cmos5l_fill_1
XFILLER_633_105 VPWR VGND sg13cmos5l_decap_8
X_3010_ Tile_X0Y5_E2BEGb[5] _4385_/X VPWR VGND sg13cmos5l_buf_1
X_0222_ _0222_/Q Tile_X0Y7_FrameData[1] VGND VPWR Tile_X0Y9_FrameStrobe[1] latch
XFILLER_67_80 VPWR VGND sg13cmos5l_decap_8
XFILLER_95_179 VPWR VGND sg13cmos5l_decap_4
XFILLER_190_70 VPWR VGND sg13cmos5l_decap_8
X_0153_ _0153_/X _4562_/X _4563_/X _1608_/Q VPWR VGND sg13cmos5l_mux2_1
XFILLER_697_21 VPWR VGND sg13cmos5l_decap_8
XFILLER_440_211 VPWR VGND sg13cmos5l_decap_8
XFILLER_586_215 VPWR VGND sg13cmos5l_fill_2
X_0084_ _0084_/X _4006_/X _4007_/X _2404_/Q VPWR VGND sg13cmos5l_mux2_1
XFILLER_340_84 VPWR VGND sg13cmos5l_fill_2
XFILLER_397_148 VPWR VGND sg13cmos5l_decap_8
X_3912_ _3912_/X Tile_X0Y2_W1END[3] Tile_X0Y2_WW4END[3] Tile_X0Y2_W6END[11] _4119_/X
+ _1640_/Q _1639_/Q VPWR VGND sg13cmos5l_mux4_1
XFILLER_697_98 VPWR VGND sg13cmos5l_decap_8
XFILLER_400_119 VPWR VGND sg13cmos5l_decap_8
X_4892_ _4892_/X Tile_X0Y9_N1END[0] Tile_X0Y9_W6END[0] _4896_/X _4892_/A3 _0679_/Q
+ _0678_/Q VPWR VGND sg13cmos5l_mux4_1
XFILLER_269_49 VPWR VGND sg13cmos5l_decap_8
XFILLER_539_175 VPWR VGND sg13cmos5l_decap_8
X_3843_ _3843_/X _3885_/X _3876_/X _3859_/X _3880_/X _1019_/Q _1018_/Q VPWR VGND sg13cmos5l_mux4_1
XFILLER_566_14 VPWR VGND sg13cmos5l_decap_8
XANTENNA__3377__X Tile_X0Y2_E6BEG[0] VPWR VGND sg13cmos5l_antennanp
X_3774_ _3774_/X Tile_X0Y0_WW4END[3] Tile_X0Y0_WW4END[11] Tile_X0Y0_W6END[3] _3884_/X
+ _1003_/Q _1002_/Q VPWR VGND sg13cmos5l_mux4_1
X_0986_ _0986_/Q Tile_X0Y0_FrameData[17] VGND VPWR Tile_X0Y9_FrameStrobe[1] latch
XFILLER_73_0 VPWR VGND sg13cmos5l_decap_8
XFILLER_306_101 VPWR VGND sg13cmos5l_decap_4
X_2725_ _4772_/A3 VPWR VGND sg13cmos5l_tielo
XFILLER_306_112 VPWR VGND sg13cmos5l_decap_4
XFILLER_157_192 VPWR VGND sg13cmos5l_decap_8
XFILLER_646_91 VPWR VGND sg13cmos5l_decap_8
XFILLER_218_42 VPWR VGND sg13cmos5l_decap_8
X_2656_ _2656_/Q Tile_X0Y6_FrameData[7] VGND VPWR Tile_X0Y9_FrameStrobe[6] latch
XFILLER_582_35 VPWR VGND sg13cmos5l_decap_8
XFILLER_172_162 VPWR VGND sg13cmos5l_fill_2
XFILLER_365_70 VPWR VGND sg13cmos5l_decap_8
XFILLER_306_178 VPWR VGND sg13cmos5l_decap_8
X_1607_ _1607_/Q Tile_X0Y2_FrameData[10] VGND VPWR Tile_X0Y9_FrameStrobe[5] latch
XFILLER_711_175 VPWR VGND sg13cmos5l_decap_8
XFILLER_321_126 VPWR VGND sg13cmos5l_decap_8
XFILLER_218_97 VPWR VGND sg13cmos5l_fill_1
X_2587_ _2587_/Q Tile_X0Y6_FrameData[12] VGND VPWR Tile_X0Y9_FrameStrobe[4] latch
X_1538_ _1538_/Q Tile_X0Y2_FrameData[15] VGND VPWR Tile_X0Y9_FrameStrobe[3] latch
X_4326_ _4326_/X Tile_X0Y8_W1END[1] Tile_X0Y8_WW4END[1] Tile_X0Y8_W6END[9] _4801_/X
+ _0644_/Q _0643_/Q VPWR VGND sg13cmos5l_mux4_1
XFILLER_451_28 VPWR VGND sg13cmos5l_decap_8
X_4257_ _4257_/X Tile_X0Y4_W2MID[6] AXI_M_SOC_BRESP1 _4315_/X _4314_/X _2099_/Q _2098_/Q
+ VPWR VGND sg13cmos5l_mux4_1
XFILLER_274_203 VPWR VGND sg13cmos5l_decap_8
X_1469_ _1469_/Q Tile_X0Y2_FrameData[20] VGND VPWR Tile_X0Y9_FrameStrobe[1] latch
X_3208_ Tile_X0Y0_N1BEG[0] _3780_/X VPWR VGND sg13cmos5l_buf_1
XFILLER_490_133 VPWR VGND sg13cmos5l_fill_1
X_4188_ _4188_/X AXI_M_SOC_WREADY _4225_/X _4229_/X _4210_/X _1765_/Q _1764_/Q VPWR
+ VGND sg13cmos5l_mux4_1
XFILLER_27_202 VPWR VGND sg13cmos5l_decap_8
X_3139_ Tile_X0Y7_FrameData_O[9] Tile_X0Y7_FrameData[9] VPWR VGND sg13cmos5l_buf_1
XFILLER_227_185 VPWR VGND sg13cmos5l_decap_8
XFILLER_490_199 VPWR VGND sg13cmos5l_decap_4
XFILLER_103_56 VPWR VGND sg13cmos5l_decap_8
XFILLER_577_215 VPWR VGND sg13cmos5l_fill_2
XFILLER_42_216 VPWR VGND sg13cmos5l_fill_2
XFILLER_400_21 VPWR VGND sg13cmos5l_decap_8
XFILLER_388_137 VPWR VGND sg13cmos5l_decap_4
XFILLER_242_155 VPWR VGND sg13cmos5l_decap_8
XFILLER_151_7 VPWR VGND sg13cmos5l_decap_8
XFILLER_249_7 VPWR VGND sg13cmos5l_decap_8
XFILLER_144_6 VPWR VGND sg13cmos5l_decap_8
XFILLER_476_14 VPWR VGND sg13cmos5l_decap_8
XFILLER_396_181 VPWR VGND sg13cmos5l_fill_1
XFILLER_545_123 VPWR VGND sg13cmos5l_decap_8
XANTENNA__3287__X Tile_X0Y0_E6BEG[7] VPWR VGND sg13cmos5l_antennanp
XFILLER_416_7 VPWR VGND sg13cmos5l_decap_8
XFILLER_10_135 VPWR VGND sg13cmos5l_decap_8
XFILLER_476_69 VPWR VGND sg13cmos5l_fill_2
XFILLER_344_207 VPWR VGND sg13cmos5l_fill_1
XFILLER_6_128 VPWR VGND sg13cmos5l_fill_1
XFILLER_626_28 VPWR VGND sg13cmos5l_decap_8
XFILLER_409_63 VPWR VGND sg13cmos5l_decap_8
XFILLER_148_181 VPWR VGND sg13cmos5l_fill_2
XFILLER_12_42 VPWR VGND sg13cmos5l_decap_8
XFILLER_556_91 VPWR VGND sg13cmos5l_decap_8
XFILLER_498_211 VPWR VGND sg13cmos5l_fill_1
XFILLER_560_159 VPWR VGND sg13cmos5l_decap_8
XFILLER_128_42 VPWR VGND sg13cmos5l_decap_8
XFILLER_492_35 VPWR VGND sg13cmos5l_decap_8
XFILLER_275_70 VPWR VGND sg13cmos5l_decap_8
XFILLER_88_68 VPWR VGND sg13cmos5l_decap_8
XFILLER_312_159 VPWR VGND sg13cmos5l_fill_2
XFILLER_642_49 VPWR VGND sg13cmos5l_decap_8
XFILLER_425_84 VPWR VGND sg13cmos5l_decap_8
XFILLER_144_41 VPWR VGND sg13cmos5l_decap_8
XFILLER_361_28 VPWR VGND sg13cmos5l_decap_8
XFILLER_466_174 VPWR VGND sg13cmos5l_decap_4
XANTENNA__3750__X AXI_M_SOC_ARADDR22 VPWR VGND sg13cmos5l_antennanp
XFILLER_92_105 VPWR VGND sg13cmos5l_fill_1
XFILLER_92_127 VPWR VGND sg13cmos5l_decap_8
XFILLER_275_0 VPWR VGND sg13cmos5l_decap_8
XFILLER_280_217 VPWR VGND sg13cmos5l_fill_1
XFILLER_630_119 VPWR VGND sg13cmos5l_decap_8
XFILLER_37_72 VPWR VGND sg13cmos5l_fill_2
XFILLER_37_83 VPWR VGND sg13cmos5l_fill_1
XFILLER_442_0 VPWR VGND sg13cmos5l_decap_8
XFILLER_310_21 VPWR VGND sg13cmos5l_decap_8
XFILLER_233_155 VPWR VGND sg13cmos5l_decap_8
XFILLER_386_14 VPWR VGND sg13cmos5l_decap_8
XFILLER_387_192 VPWR VGND sg13cmos5l_decap_8
XANTENNA__3197__X Tile_X0Y0_N2BEGb[5] VPWR VGND sg13cmos5l_antennanp
XFILLER_707_0 VPWR VGND sg13cmos5l_decap_8
X_0840_ _0840_/Q Tile_X0Y9_FrameData[23] VGND VPWR Tile_X0Y9_FrameStrobe[5] latch
XFILLER_536_28 VPWR VGND sg13cmos5l_decap_8
X_0771_ _0771_/Q Tile_X0Y9_FrameData[28] VGND VPWR Tile_X0Y9_FrameStrobe[3] latch
XFILLER_551_137 VPWR VGND sg13cmos5l_fill_2
XFILLER_683_56 VPWR VGND sg13cmos5l_decap_8
X_2510_ _2510_/Q Tile_X0Y6_FrameData[25] VGND VPWR Tile_X0Y9_FrameStrobe[2] latch
X_3490_ Tile_X0Y1_E6BEG[0] _3964_/X VPWR VGND sg13cmos5l_buf_1
XFILLER_185_70 VPWR VGND sg13cmos5l_decap_8
XFILLER_5_161 VPWR VGND sg13cmos5l_decap_4
XFILLER_154_173 VPWR VGND sg13cmos5l_decap_8
X_2441_ _2441_/Q Tile_X0Y6_FrameData[30] VGND VPWR Tile_X0Y9_FrameStrobe[0] latch
XFILLER_154_195 VPWR VGND sg13cmos5l_decap_8
XFILLER_303_137 VPWR VGND sg13cmos5l_decap_8
X_2372_ _2372_/Q Tile_X0Y5_FrameData[1] VGND VPWR Tile_X0Y9_FrameStrobe[5] latch
XFILLER_552_49 VPWR VGND sg13cmos5l_decap_8
XFILLER_68_113 VPWR VGND sg13cmos5l_decap_8
X_4111_ _4111_/X Tile_X0Y6_W1END[2] Tile_X0Y6_WW4END[2] Tile_X0Y6_W6END[10] _4570_/X
+ _2665_/Q _2664_/Q VPWR VGND sg13cmos5l_mux4_1
X_1323_ _1323_/Q Tile_X0Y1_FrameData[14] VGND VPWR Tile_X0Y9_FrameStrobe[4] latch
XFILLER_271_28 VPWR VGND sg13cmos5l_decap_8
XFILLER_311_192 VPWR VGND sg13cmos5l_decap_8
XANTENNA__3660__X AXI_M_SOC_AWADDR21 VPWR VGND sg13cmos5l_antennanp
X_4042_ _4042_/X Tile_X0Y2_W2MID[5] AXI_M_SOC_AWREADY _4101_/X _4100_/X _1589_/Q _1588_/Q
+ VPWR VGND sg13cmos5l_mux4_1
X_1254_ _1254_/Q Tile_X0Y1_FrameData[19] VGND VPWR Tile_X0Y9_FrameStrobe[2] latch
XFILLER_83_138 VPWR VGND sg13cmos5l_decap_8
X_0205_ _0205_/Q Tile_X0Y7_FrameData[18] VGND VPWR Tile_X0Y9_FrameStrobe[1] latch
XFILLER_204_77 VPWR VGND sg13cmos5l_decap_8
X_1185_ _1185_/Q Tile_X0Y1_FrameData[24] VGND VPWR Tile_X0Y9_FrameStrobe[0] latch
XFILLER_501_42 VPWR VGND sg13cmos5l_decap_8
X_0136_ AXI_M_SOC_AWLEN3 _0940_/Q _3674_/X VPWR VGND sg13cmos5l_nor2b_1
XFILLER_614_182 VPWR VGND sg13cmos5l_fill_1
XFILLER_91_171 VPWR VGND sg13cmos5l_decap_8
XFILLER_220_21 VPWR VGND sg13cmos5l_decap_8
X_0067_ _0067_/X _3865_/X _3866_/X _2155_/Q VPWR VGND sg13cmos5l_mux2_1
XFILLER_577_35 VPWR VGND sg13cmos5l_decap_8
XFILLER_385_107 VPWR VGND sg13cmos5l_decap_8
XFILLER_177_210 VPWR VGND sg13cmos5l_fill_2
XFILLER_296_14 VPWR VGND sg13cmos5l_decap_8
X_4875_ _4875_/X Tile_X0Y9_WW4END[4] AXI_M_SOC_RDATA4 _4920_/X _4906_/X _0793_/Q _0792_/Q
+ VPWR VGND sg13cmos5l_mux4_1
X_3826_ _3826_/X Tile_X0Y0_WW4END[9] _3872_/X _3855_/X _3862_/X _1053_/Q _1052_/Q
+ VPWR VGND sg13cmos5l_mux4_1
XFILLER_326_207 VPWR VGND sg13cmos5l_decap_8
XFILLER_446_28 VPWR VGND sg13cmos5l_decap_8
XFILLER_229_63 VPWR VGND sg13cmos5l_decap_8
X_0969_ _0969_/Q Tile_X0Y0_FrameData[2] VGND VPWR Tile_X0Y9_FrameStrobe[0] latch
X_3757_ AXI_M_SOC_ARADDR29 Tile_X0Y8_W1END[1] Tile_X0Y8_WW4END[5] Tile_X0Y8_WW4END[13]
+ _4813_/X _0477_/Q _0476_/Q VPWR VGND sg13cmos5l_mux4_1
XFILLER_593_56 VPWR VGND sg13cmos5l_decap_8
X_2708_ _4303_/A3 VPWR VGND sg13cmos5l_tielo
XFILLER_145_151 VPWR VGND sg13cmos5l_decap_4
XFILLER_3_109 VPWR VGND sg13cmos5l_fill_1
X_3688_ _3688_/X Tile_X0Y3_WW4END[6] Tile_X0Y3_WW4END[14] Tile_X0Y3_W6END[6] _4228_/X
+ _1745_/Q _1744_/Q VPWR VGND sg13cmos5l_mux4_1
X_2639_ _2639_/Q Tile_X0Y6_FrameData[24] VGND VPWR Tile_X0Y9_FrameStrobe[6] latch
XFILLER_160_154 VPWR VGND sg13cmos5l_decap_8
XFILLER_696_196 VPWR VGND sg13cmos5l_fill_1
XFILLER_448_152 VPWR VGND sg13cmos5l_decap_8
X_4309_ _4309_/X _4311_/X Tile_X0Y4_W6END[3] _4310_/X _4309_/A3 _1927_/Q _2182_/Q
+ VPWR VGND sg13cmos5l_mux4_1
XFILLER_448_163 VPWR VGND sg13cmos5l_fill_2
XFILLER_199_7 VPWR VGND sg13cmos5l_decap_8
XANTENNA__3570__X Tile_X0Y9_FrameData_O[0] VPWR VGND sg13cmos5l_antennanp
XFILLER_114_55 VPWR VGND sg13cmos5l_decap_8
XFILLER_463_177 VPWR VGND sg13cmos5l_fill_1
XFILLER_67_190 VPWR VGND sg13cmos5l_decap_8
XFILLER_366_7 VPWR VGND sg13cmos5l_decap_8
XFILLER_612_119 VPWR VGND sg13cmos5l_decap_8
XFILLER_411_42 VPWR VGND sg13cmos5l_decap_8
XFILLER_15_216 VPWR VGND sg13cmos5l_fill_2
XFILLER_130_21 VPWR VGND sg13cmos5l_decap_8
XFILLER_533_7 VPWR VGND sg13cmos5l_decap_8
XANTENNA__2914__X Tile_X0Y8_E1BEG[2] VPWR VGND sg13cmos5l_antennanp
XFILLER_90_14 VPWR VGND sg13cmos5l_decap_8
XFILLER_487_35 VPWR VGND sg13cmos5l_decap_8
XFILLER_620_196 VPWR VGND sg13cmos5l_decap_8
XFILLER_707_201 VPWR VGND sg13cmos5l_fill_1
XFILLER_130_98 VPWR VGND sg13cmos5l_decap_8
XFILLER_230_169 VPWR VGND sg13cmos5l_decap_8
XFILLER_700_7 VPWR VGND sg13cmos5l_decap_8
XFILLER_384_151 VPWR VGND sg13cmos5l_decap_8
XFILLER_637_49 VPWR VGND sg13cmos5l_decap_8
XFILLER_518_167 VPWR VGND sg13cmos5l_decap_4
XFILLER_356_28 VPWR VGND sg13cmos5l_decap_8
XFILLER_139_63 VPWR VGND sg13cmos5l_decap_8
XFILLER_533_126 VPWR VGND sg13cmos5l_decap_4
XFILLER_99_34 VPWR VGND sg13cmos5l_decap_4
XFILLER_286_91 VPWR VGND sg13cmos5l_decap_8
XANTENNA__3745__X AXI_M_SOC_ARADDR17 VPWR VGND sg13cmos5l_antennanp
XFILLER_136_140 VPWR VGND sg13cmos5l_decap_8
XFILLER_687_130 VPWR VGND sg13cmos5l_fill_2
XFILLER_486_203 VPWR VGND sg13cmos5l_fill_2
XFILLER_541_181 VPWR VGND sg13cmos5l_decap_8
XFILLER_436_83 VPWR VGND sg13cmos5l_decap_8
XFILLER_3_0 VPWR VGND sg13cmos5l_decap_8
XFILLER_151_143 VPWR VGND sg13cmos5l_decap_8
XFILLER_372_49 VPWR VGND sg13cmos5l_fill_1
XFILLER_300_107 VPWR VGND sg13cmos5l_fill_1
XFILLER_439_141 VPWR VGND sg13cmos5l_decap_8
XFILLER_392_0 VPWR VGND sg13cmos5l_decap_8
XFILLER_300_129 VPWR VGND sg13cmos5l_decap_8
XFILLER_2_186 VPWR VGND sg13cmos5l_decap_8
XFILLER_454_100 VPWR VGND sg13cmos5l_fill_2
XFILLER_452_60 VPWR VGND sg13cmos5l_fill_1
XFILLER_305_54 VPWR VGND sg13cmos5l_decap_4
XANTENNA__3480__X Tile_X0Y1_EE4BEG[6] VPWR VGND sg13cmos5l_antennanp
XFILLER_452_71 VPWR VGND sg13cmos5l_fill_2
XFILLER_48_71 VPWR VGND sg13cmos5l_decap_8
XFILLER_454_144 VPWR VGND sg13cmos5l_decap_4
XFILLER_65_138 VPWR VGND sg13cmos5l_decap_8
XFILLER_657_0 VPWR VGND sg13cmos5l_decap_8
XFILLER_454_177 VPWR VGND sg13cmos5l_decap_8
XFILLER_206_111 VPWR VGND sg13cmos5l_decap_8
XFILLER_602_96 VPWR VGND sg13cmos5l_decap_4
XFILLER_0_56 VPWR VGND sg13cmos5l_decap_8
XFILLER_73_160 VPWR VGND sg13cmos5l_fill_2
XFILLER_321_75 VPWR VGND sg13cmos5l_decap_8
XFILLER_206_155 VPWR VGND sg13cmos5l_fill_1
XFILLER_678_56 VPWR VGND sg13cmos5l_decap_8
XANTENNA__2824__X Tile_X0Y4_E2BEG[2] VPWR VGND sg13cmos5l_antennanp
X_2990_ Tile_X0Y8_FrameData_O[30] Tile_X0Y8_FrameData[30] VPWR VGND sg13cmos5l_buf_1
XFILLER_397_35 VPWR VGND sg13cmos5l_decap_8
XFILLER_611_185 VPWR VGND sg13cmos5l_decap_4
XFILLER_9_21 VPWR VGND sg13cmos5l_decap_8
XFILLER_159_210 VPWR VGND sg13cmos5l_fill_2
X_1941_ _1941_/Q Tile_X0Y4_FrameData[16] VGND VPWR Tile_X0Y9_FrameStrobe[0] latch
X_1872_ _1872_/Q Tile_X0Y3_FrameData[25] VGND VPWR Tile_X0Y9_FrameStrobe[6] latch
X_4660_ _4660_/X Tile_X0Y6_W1END[0] Tile_X0Y6_W6END[8] _4580_/X _4540_/X _2659_/Q
+ _2658_/Q VPWR VGND sg13cmos5l_mux4_1
XFILLER_547_49 VPWR VGND sg13cmos5l_decap_8
XFILLER_375_173 VPWR VGND sg13cmos5l_fill_2
XFILLER_80_91 VPWR VGND sg13cmos5l_decap_4
X_0823_ _0823_/Q Tile_X0Y9_FrameData[8] VGND VPWR Tile_X0Y9_FrameStrobe[4] latch
X_3611_ Tile_X0Y9_S2BEG[5] _4833_/X VPWR VGND sg13cmos5l_buf_1
XFILLER_694_77 VPWR VGND sg13cmos5l_decap_8
XFILLER_509_189 VPWR VGND sg13cmos5l_fill_2
XFILLER_390_110 VPWR VGND sg13cmos5l_decap_8
XFILLER_266_28 VPWR VGND sg13cmos5l_decap_8
XFILLER_524_126 VPWR VGND sg13cmos5l_fill_2
X_4591_ _4591_/X Tile_X0Y8_W2MID[4] Tile_X0Y8_W2END[4] Tile_X0Y8_W6END[4] _4791_/X
+ _0657_/Q _0656_/Q VPWR VGND sg13cmos5l_mux4_1
XANTENNA__3655__X AXI_M_SOC_AWADDR16 VPWR VGND sg13cmos5l_antennanp
X_0754_ _0754_/Q Tile_X0Y9_FrameData[13] VGND VPWR Tile_X0Y9_FrameStrobe[2] latch
X_3542_ Tile_X0Y9_E6BEG[0] _4880_/X VPWR VGND sg13cmos5l_buf_1
XFILLER_127_184 VPWR VGND sg13cmos5l_decap_8
X_3473_ Tile_X0Y1_FrameData_O[31] Tile_X0Y1_FrameData[31] VPWR VGND sg13cmos5l_buf_1
X_0685_ _0685_/Q Tile_X0Y9_FrameData[18] VGND VPWR Tile_X0Y9_FrameStrobe[0] latch
XFILLER_142_143 VPWR VGND sg13cmos5l_decap_8
X_2424_ _2424_/Q Tile_X0Y5_FrameData[13] VGND VPWR Tile_X0Y9_FrameStrobe[7] latch
XFILLER_282_49 VPWR VGND sg13cmos5l_decap_8
XFILLER_643_70 VPWR VGND sg13cmos5l_decap_8
XFILLER_215_21 VPWR VGND sg13cmos5l_decap_8
XFILLER_36_0 VPWR VGND sg13cmos5l_decap_8
X_2355_ _2355_/Q Tile_X0Y5_FrameData[18] VGND VPWR Tile_X0Y9_FrameStrobe[5] latch
XFILLER_296_180 VPWR VGND sg13cmos5l_decap_8
XANTENNA__3390__X Tile_X0Y2_E2BEGb[1] VPWR VGND sg13cmos5l_antennanp
X_1306_ _1306_/Q Tile_X0Y1_FrameData[31] VGND VPWR Tile_X0Y9_FrameStrobe[4] latch
X_2286_ _2286_/Q Tile_X0Y5_FrameData[23] VGND VPWR Tile_X0Y9_FrameStrobe[3] latch
XFILLER_215_98 VPWR VGND sg13cmos5l_decap_8
X_4025_ _4025_/X Tile_X0Y3_W2MID[5] Tile_X0Y3_W2END[5] Tile_X0Y3_W6END[5] _4209_/X
+ _1913_/Q _1912_/Q VPWR VGND sg13cmos5l_mux4_1
X_1237_ _1237_/Q Tile_X0Y1_FrameData[4] VGND VPWR Tile_X0Y9_FrameStrobe[1] latch
XFILLER_512_63 VPWR VGND sg13cmos5l_decap_8
XFILLER_398_210 VPWR VGND sg13cmos5l_fill_2
XFILLER_64_160 VPWR VGND sg13cmos5l_decap_8
X_1168_ _1168_/Q Tile_X0Y0_FrameData[27] VGND VPWR Tile_X0Y9_FrameStrobe[7] latch
XFILLER_599_181 VPWR VGND sg13cmos5l_fill_1
X_0119_ AXI_M_SOC_ARCACHE1 _0929_/Q _3775_/X VPWR VGND sg13cmos5l_or2_1
XFILLER_401_203 VPWR VGND sg13cmos5l_fill_2
X_1099_ _1099_/Q Tile_X0Y0_FrameData[0] VGND VPWR Tile_X0Y9_FrameStrobe[4] latch
XFILLER_212_125 VPWR VGND sg13cmos5l_decap_8
XFILLER_100_13 VPWR VGND sg13cmos5l_decap_8
X_4927_ _4927_/X Tile_X0Y9_N1END[3] Tile_X0Y9_N4END[3] _4899_/X _0080_/X _0705_/Q
+ _0704_/Q VPWR VGND sg13cmos5l_mux4_1
X_4858_ _4858_/X Tile_X0Y9_W2END[5] AXI_M_SOC_RDATA5 _4905_/X _4904_/X _0827_/Q _0826_/Q
+ VPWR VGND sg13cmos5l_mux4_1
XFILLER_60_28 VPWR VGND sg13cmos5l_decap_8
XFILLER_457_49 VPWR VGND sg13cmos5l_decap_8
X_3809_ _3809_/X Tile_X0Y0_W2MID[2] Tile_X0Y0_WW4END[15] _3857_/X _3856_/X _1087_/Q
+ _1086_/Q VPWR VGND sg13cmos5l_mux4_1
XFILLER_176_28 VPWR VGND sg13cmos5l_decap_8
X_4789_ _4789_/X _4705_/X Tile_X0Y9_N2MID[2] _4818_/X _4704_/X _0435_/Q _0434_/Q VPWR
+ VGND sg13cmos5l_mux4_1
XANTENNA__3565__X Tile_X0Y9_EE4BEG[11] VPWR VGND sg13cmos5l_antennanp
XFILLER_180_216 VPWR VGND sg13cmos5l_fill_2
XFILLER_109_55 VPWR VGND sg13cmos5l_fill_2
XFILLER_669_152 VPWR VGND sg13cmos5l_fill_1
XFILLER_279_125 VPWR VGND sg13cmos5l_decap_8
XFILLER_669_185 VPWR VGND sg13cmos5l_fill_1
XFILLER_133_154 VPWR VGND sg13cmos5l_decap_8
XFILLER_684_122 VPWR VGND sg13cmos5l_decap_4
XFILLER_406_42 VPWR VGND sg13cmos5l_decap_8
XFILLER_192_49 VPWR VGND sg13cmos5l_decap_8
XFILLER_553_70 VPWR VGND sg13cmos5l_decap_8
XFILLER_133_198 VPWR VGND sg13cmos5l_fill_2
XFILLER_125_21 VPWR VGND sg13cmos5l_decap_8
XFILLER_483_206 VPWR VGND sg13cmos5l_fill_1
XFILLER_483_7 VPWR VGND sg13cmos5l_decap_8
XANTENNA__2909__X Tile_X0Y6_FrameData_O[30] VPWR VGND sg13cmos5l_antennanp
XFILLER_684_188 VPWR VGND sg13cmos5l_decap_4
XFILLER_85_14 VPWR VGND sg13cmos5l_decap_8
XFILLER_684_199 VPWR VGND sg13cmos5l_fill_2
XFILLER_47_105 VPWR VGND sg13cmos5l_decap_8
XFILLER_125_98 VPWR VGND sg13cmos5l_decap_8
XFILLER_703_84 VPWR VGND sg13cmos5l_decap_8
XFILLER_235_206 VPWR VGND sg13cmos5l_decap_8
XFILLER_235_217 VPWR VGND sg13cmos5l_fill_1
XFILLER_650_7 VPWR VGND sg13cmos5l_decap_8
XFILLER_47_149 VPWR VGND sg13cmos5l_decap_8
XFILLER_422_63 VPWR VGND sg13cmos5l_decap_8
XFILLER_640_203 VPWR VGND sg13cmos5l_fill_2
XFILLER_141_20 VPWR VGND sg13cmos5l_decap_8
XFILLER_597_118 VPWR VGND sg13cmos5l_decap_4
XFILLER_451_147 VPWR VGND sg13cmos5l_fill_2
XFILLER_389_210 VPWR VGND sg13cmos5l_decap_8
XANTENNA__0148__Y AXI_M_SOC_ARCACHE2 VPWR VGND sg13cmos5l_antennanp
XFILLER_250_209 VPWR VGND sg13cmos5l_fill_2
XFILLER_498_56 VPWR VGND sg13cmos5l_decap_8
XFILLER_203_147 VPWR VGND sg13cmos5l_decap_8
XFILLER_70_185 VPWR VGND sg13cmos5l_decap_8
XFILLER_140_0 VPWR VGND sg13cmos5l_decap_8
XFILLER_357_140 VPWR VGND sg13cmos5l_decap_8
XFILLER_238_0 VPWR VGND sg13cmos5l_fill_2
XFILLER_367_49 VPWR VGND sg13cmos5l_decap_8
XFILLER_372_110 VPWR VGND sg13cmos5l_decap_8
XFILLER_664_14 VPWR VGND sg13cmos5l_decap_8
XFILLER_447_60 VPWR VGND sg13cmos5l_fill_1
XANTENNA__3475__X Tile_X0Y1_EE4BEG[1] VPWR VGND sg13cmos5l_antennanp
XFILLER_405_0 VPWR VGND sg13cmos5l_decap_8
XFILLER_109_151 VPWR VGND sg13cmos5l_decap_8
XFILLER_313_210 VPWR VGND sg13cmos5l_fill_2
XFILLER_109_195 VPWR VGND sg13cmos5l_decap_8
XFILLER_316_42 VPWR VGND sg13cmos5l_decap_4
X_0470_ _0470_/Q Tile_X0Y8_FrameData[9] VGND VPWR Tile_X0Y9_FrameStrobe[1] latch
XFILLER_680_35 VPWR VGND sg13cmos5l_decap_8
XFILLER_124_187 VPWR VGND sg13cmos5l_decap_8
XFILLER_474_206 VPWR VGND sg13cmos5l_fill_1
XFILLER_474_217 VPWR VGND sg13cmos5l_fill_1
XANTENNA__2819__X Tile_X0Y3_E1BEG[1] VPWR VGND sg13cmos5l_antennanp
XFILLER_59_81 VPWR VGND sg13cmos5l_decap_8
XFILLER_316_97 VPWR VGND sg13cmos5l_decap_8
XFILLER_59_92 VPWR VGND sg13cmos5l_fill_2
X_2140_ _2140_/Q Tile_X0Y4_FrameData[9] VGND VPWR Tile_X0Y9_FrameStrobe[6] latch
XFILLER_690_136 VPWR VGND sg13cmos5l_decap_4
XFILLER_427_133 VPWR VGND sg13cmos5l_decap_8
XFILLER_613_84 VPWR VGND sg13cmos5l_decap_8
XFILLER_226_217 VPWR VGND sg13cmos5l_fill_1
X_2071_ _2071_/Q Tile_X0Y4_FrameData[14] VGND VPWR Tile_X0Y9_FrameStrobe[4] latch
XFILLER_332_63 VPWR VGND sg13cmos5l_decap_4
XFILLER_442_114 VPWR VGND sg13cmos5l_fill_1
XFILLER_588_107 VPWR VGND sg13cmos5l_fill_1
XFILLER_53_108 VPWR VGND sg13cmos5l_decap_8
X_1022_ _1022_/Q Tile_X0Y0_FrameData[13] VGND VPWR Tile_X0Y9_FrameStrobe[2] latch
XFILLER_61_130 VPWR VGND sg13cmos5l_decap_8
XFILLER_596_140 VPWR VGND sg13cmos5l_decap_8
XFILLER_596_151 VPWR VGND sg13cmos5l_fill_2
XFILLER_201_56 VPWR VGND sg13cmos5l_decap_8
X_2973_ Tile_X0Y8_FrameData_O[13] Tile_X0Y8_FrameData[13] VPWR VGND sg13cmos5l_buf_1
XFILLER_348_140 VPWR VGND sg13cmos5l_fill_1
X_4712_ _4712_/X Tile_X0Y6_W1END[2] Tile_X0Y6_W2MID[1] Tile_X0Y6_W2END[1] _4554_/X
+ _2639_/Q _2638_/Q VPWR VGND sg13cmos5l_mux4_1
X_1924_ _1924_/Q Tile_X0Y3_FrameData[5] VGND VPWR Tile_X0Y9_FrameStrobe[7] latch
XFILLER_348_162 VPWR VGND sg13cmos5l_decap_8
XFILLER_277_49 VPWR VGND sg13cmos5l_decap_8
XFILLER_638_70 VPWR VGND sg13cmos5l_decap_8
XFILLER_348_173 VPWR VGND sg13cmos5l_fill_1
X_4643_ _4643_/X Tile_X0Y7_WW4END[0] AXI_M_SOC_RDATA16 _4684_/X _4669_/X _0273_/Q
+ _0272_/Q VPWR VGND sg13cmos5l_mux4_1
XFILLER_574_14 VPWR VGND sg13cmos5l_decap_8
XFILLER_348_195 VPWR VGND sg13cmos5l_decap_8
X_1855_ _1855_/Q Tile_X0Y3_FrameData[10] VGND VPWR Tile_X0Y9_FrameStrobe[5] latch
XANTENNA__3385__X Tile_X0Y2_E6BEG[8] VPWR VGND sg13cmos5l_antennanp
XFILLER_363_154 VPWR VGND sg13cmos5l_decap_8
X_0806_ _0806_/Q Tile_X0Y9_FrameData[25] VGND VPWR Tile_X0Y9_FrameStrobe[4] latch
X_1786_ _1786_/Q Tile_X0Y3_FrameData[15] VGND VPWR Tile_X0Y9_FrameStrobe[3] latch
X_4574_ _4574_/X _4549_/X Tile_X0Y9_N4END[14] _4548_/X _0155_/X _2483_/Q _2482_/Q
+ VPWR VGND sg13cmos5l_mux4_1
X_3525_ Tile_X0Y9_E1BEG[3] _4847_/X VPWR VGND sg13cmos5l_buf_1
XFILLER_507_63 VPWR VGND sg13cmos5l_decap_8
X_0737_ _0737_/Q Tile_X0Y9_FrameData[30] VGND VPWR Tile_X0Y9_FrameStrobe[2] latch
XFILLER_226_20 VPWR VGND sg13cmos5l_decap_8
XFILLER_115_143 VPWR VGND sg13cmos5l_decap_8
XFILLER_654_91 VPWR VGND sg13cmos5l_decap_8
X_0668_ _0668_/Q Tile_X0Y8_FrameData[3] VGND VPWR Tile_X0Y9_FrameStrobe[7] latch
X_3456_ Tile_X0Y1_FrameData_O[14] Tile_X0Y1_FrameData[14] VPWR VGND sg13cmos5l_buf_1
XFILLER_590_35 VPWR VGND sg13cmos5l_decap_8
XFILLER_226_75 VPWR VGND sg13cmos5l_fill_2
XFILLER_520_184 VPWR VGND sg13cmos5l_decap_8
X_2407_ _2407_/Q Tile_X0Y5_FrameData[30] VGND VPWR Tile_X0Y9_FrameStrobe[7] latch
X_3387_ Tile_X0Y2_E6BEG[10] _4082_/X VPWR VGND sg13cmos5l_buf_1
X_0599_ _0599_/Q Tile_X0Y8_FrameData[8] VGND VPWR Tile_X0Y9_FrameStrobe[5] latch
XFILLER_269_191 VPWR VGND sg13cmos5l_decap_8
XFILLER_130_168 VPWR VGND sg13cmos5l_decap_8
XFILLER_29_105 VPWR VGND sg13cmos5l_fill_2
X_2338_ _2338_/Q Tile_X0Y5_FrameData[3] VGND VPWR Tile_X0Y9_FrameStrobe[4] latch
XFILLER_480_209 VPWR VGND sg13cmos5l_fill_1
XFILLER_284_161 VPWR VGND sg13cmos5l_decap_8
XFILLER_217_206 VPWR VGND sg13cmos5l_fill_1
XFILLER_284_172 VPWR VGND sg13cmos5l_fill_1
X_2269_ _2269_/Q Tile_X0Y5_FrameData[8] VGND VPWR Tile_X0Y9_FrameStrobe[2] latch
XFILLER_284_194 VPWR VGND sg13cmos5l_decap_8
XFILLER_242_96 VPWR VGND sg13cmos5l_fill_2
X_4008_ _4008_/X _3981_/X _0073_/X _3980_/X Tile_X0Y0_S4END[4] _1233_/Q _1232_/Q VPWR
+ VGND sg13cmos5l_mux4_1
XFILLER_37_193 VPWR VGND sg13cmos5l_fill_1
XFILLER_441_180 VPWR VGND sg13cmos5l_decap_8
XFILLER_71_27 VPWR VGND sg13cmos5l_decap_8
XFILLER_111_89 VPWR VGND sg13cmos5l_decap_4
XFILLER_231_7 VPWR VGND sg13cmos5l_decap_8
XFILLER_138_202 VPWR VGND sg13cmos5l_decap_4
XFILLER_329_7 VPWR VGND sg13cmos5l_decap_8
XFILLER_187_49 VPWR VGND sg13cmos5l_decap_8
XFILLER_548_70 VPWR VGND sg13cmos5l_decap_8
XFILLER_484_14 VPWR VGND sg13cmos5l_decap_8
XANTENNA__3295__X Tile_X0Y0_E2BEGb[3] VPWR VGND sg13cmos5l_antennanp
XFILLER_354_154 VPWR VGND sg13cmos5l_decap_8
XFILLER_153_205 VPWR VGND sg13cmos5l_decap_4
XFILLER_634_28 VPWR VGND sg13cmos5l_decap_8
XFILLER_20_42 VPWR VGND sg13cmos5l_decap_8
XFILLER_417_63 VPWR VGND sg13cmos5l_decap_8
XFILLER_106_132 VPWR VGND sg13cmos5l_decap_8
XFILLER_698_7 VPWR VGND sg13cmos5l_decap_8
XFILLER_20_53 VPWR VGND sg13cmos5l_fill_1
XFILLER_564_91 VPWR VGND sg13cmos5l_decap_8
XFILLER_20_75 VPWR VGND sg13cmos5l_fill_2
XFILLER_136_42 VPWR VGND sg13cmos5l_decap_8
XFILLER_121_102 VPWR VGND sg13cmos5l_fill_2
XFILLER_283_70 VPWR VGND sg13cmos5l_decap_8
XFILLER_267_106 VPWR VGND sg13cmos5l_fill_2
XFILLER_672_114 VPWR VGND sg13cmos5l_fill_2
XFILLER_650_49 VPWR VGND sg13cmos5l_decap_8
XFILLER_580_90 VPWR VGND sg13cmos5l_decap_8
XFILLER_433_84 VPWR VGND sg13cmos5l_decap_8
XFILLER_188_0 VPWR VGND sg13cmos5l_decap_8
XFILLER_613_203 VPWR VGND sg13cmos5l_decap_4
XFILLER_152_74 VPWR VGND sg13cmos5l_decap_8
XFILLER_90_203 VPWR VGND sg13cmos5l_fill_2
XFILLER_35_108 VPWR VGND sg13cmos5l_decap_8
XFILLER_424_147 VPWR VGND sg13cmos5l_decap_8
XFILLER_290_142 VPWR VGND sg13cmos5l_decap_4
XFILLER_659_14 VPWR VGND sg13cmos5l_decap_8
XFILLER_424_169 VPWR VGND sg13cmos5l_decap_8
XFILLER_223_209 VPWR VGND sg13cmos5l_fill_1
XFILLER_28_182 VPWR VGND sg13cmos5l_decap_8
XFILLER_355_0 VPWR VGND sg13cmos5l_decap_8
XFILLER_432_191 VPWR VGND sg13cmos5l_decap_8
XFILLER_522_0 VPWR VGND sg13cmos5l_decap_8
XFILLER_675_35 VPWR VGND sg13cmos5l_decap_8
XFILLER_61_60 VPWR VGND sg13cmos5l_decap_8
XFILLER_394_14 VPWR VGND sg13cmos5l_decap_8
X_1640_ _1640_/Q Tile_X0Y2_FrameData[9] VGND VPWR Tile_X0Y9_FrameStrobe[6] latch
XFILLER_394_58 VPWR VGND sg13cmos5l_decap_8
XANTENNA_4 AXI_M_SOC_RDATA27 VPWR VGND sg13cmos5l_antennanp
XFILLER_345_187 VPWR VGND sg13cmos5l_decap_8
X_1571_ _1571_/Q Tile_X0Y2_FrameData[14] VGND VPWR Tile_X0Y9_FrameStrobe[4] latch
XFILLER_544_28 VPWR VGND sg13cmos5l_decap_8
XFILLER_6_77 VPWR VGND sg13cmos5l_decap_8
XFILLER_691_56 VPWR VGND sg13cmos5l_decap_8
X_0522_ _0522_/Q Tile_X0Y8_FrameData[21] VGND VPWR Tile_X0Y9_FrameStrobe[3] latch
X_3310_ Tile_X0Y0_E1BEG[2] _3802_/X VPWR VGND sg13cmos5l_buf_1
XFILLER_502_140 VPWR VGND sg13cmos5l_decap_8
X_4290_ _4290_/X _0160_/X _0110_/X _4345_/X _4349_/X _2033_/Q _2032_/Q VPWR VGND sg13cmos5l_mux4_1
XFILLER_648_133 VPWR VGND sg13cmos5l_decap_8
XFILLER_112_113 VPWR VGND sg13cmos5l_fill_2
X_3241_ Tile_X0Y0_FrameData_O[9] Tile_X0Y0_FrameData[9] VPWR VGND sg13cmos5l_buf_1
XFILLER_193_92 VPWR VGND sg13cmos5l_decap_4
X_0453_ _0453_/Q Tile_X0Y8_FrameData[26] VGND VPWR Tile_X0Y9_FrameStrobe[1] latch
X_3172_ Tile_X0Y4_E6BEG[9] _4297_/X VPWR VGND sg13cmos5l_buf_1
X_0384_ _0384_/Q Tile_X0Y7_FrameData[31] VGND VPWR Tile_X0Y9_FrameStrobe[7] latch
XFILLER_560_49 VPWR VGND sg13cmos5l_decap_8
XFILLER_343_84 VPWR VGND sg13cmos5l_fill_2
XFILLER_266_150 VPWR VGND sg13cmos5l_decap_8
X_2123_ _2123_/Q Tile_X0Y4_FrameData[26] VGND VPWR Tile_X0Y9_FrameStrobe[6] latch
XANTENNA__0069__X AXI_M_SOC_WSTRB2 VPWR VGND sg13cmos5l_antennanp
XFILLER_415_114 VPWR VGND sg13cmos5l_decap_8
X_2054_ _2054_/Q Tile_X0Y4_FrameData[31] VGND VPWR Tile_X0Y9_FrameStrobe[4] latch
XFILLER_569_14 VPWR VGND sg13cmos5l_decap_8
XFILLER_212_55 VPWR VGND sg13cmos5l_decap_8
XFILLER_281_175 VPWR VGND sg13cmos5l_decap_8
X_1005_ _1005_/Q Tile_X0Y0_FrameData[30] VGND VPWR Tile_X0Y9_FrameStrobe[2] latch
XFILLER_569_140 VPWR VGND sg13cmos5l_decap_8
XFILLER_179_168 VPWR VGND sg13cmos5l_decap_8
XFILLER_649_91 VPWR VGND sg13cmos5l_decap_8
XFILLER_194_105 VPWR VGND sg13cmos5l_decap_8
X_2956_ Tile_X0Y8_EE4BEG[12] _4756_/X VPWR VGND sg13cmos5l_buf_1
XFILLER_585_35 VPWR VGND sg13cmos5l_decap_8
XFILLER_368_92 VPWR VGND sg13cmos5l_fill_2
X_1907_ _1907_/Q Tile_X0Y3_FrameData[22] VGND VPWR Tile_X0Y9_FrameStrobe[7] latch
XFILLER_336_121 VPWR VGND sg13cmos5l_decap_8
X_2887_ Tile_X0Y6_FrameData_O[8] Tile_X0Y6_FrameData[8] VPWR VGND sg13cmos5l_buf_1
X_4626_ _4626_/X Tile_X0Y7_W2END[1] AXI_M_SOC_RDATA17 _4671_/X _4670_/X _0307_/Q _0306_/Q
+ VPWR VGND sg13cmos5l_mux4_1
XFILLER_135_216 VPWR VGND sg13cmos5l_fill_2
X_1838_ _1838_/Q Tile_X0Y3_FrameData[27] VGND VPWR Tile_X0Y9_FrameStrobe[5] latch
XFILLER_237_30 VPWR VGND sg13cmos5l_fill_1
XFILLER_454_28 VPWR VGND sg13cmos5l_decap_8
XFILLER_237_63 VPWR VGND sg13cmos5l_fill_1
X_4557_ _4557_/X _4473_/X _4589_/X _4588_/X _4472_/X _2459_/Q _2458_/Q VPWR VGND sg13cmos5l_mux4_1
X_1769_ _1769_/Q Tile_X0Y3_FrameData[0] VGND VPWR Tile_X0Y9_FrameStrobe[2] latch
XFILLER_237_85 VPWR VGND sg13cmos5l_decap_8
X_3508_ Tile_X0Y1_E2BEGb[6] _3946_/X VPWR VGND sg13cmos5l_buf_1
XFILLER_639_133 VPWR VGND sg13cmos5l_decap_8
XFILLER_173_29 VPWR VGND sg13cmos5l_fill_1
XFILLER_103_102 VPWR VGND sg13cmos5l_fill_2
X_4488_ _4488_/X Tile_X0Y6_W1END[2] Tile_X0Y6_WW4END[14] Tile_X0Y6_W6END[6] _4570_/X
+ _2629_/Q _2628_/Q VPWR VGND sg13cmos5l_mux4_1
XFILLER_534_61 VPWR VGND sg13cmos5l_fill_2
XFILLER_438_206 VPWR VGND sg13cmos5l_fill_2
XFILLER_438_217 VPWR VGND sg13cmos5l_fill_1
XFILLER_249_117 VPWR VGND sg13cmos5l_decap_4
X_3439_ Tile_X0Y4_FrameData_O[30] Tile_X0Y4_FrameData[30] VPWR VGND sg13cmos5l_buf_1
XFILLER_470_49 VPWR VGND sg13cmos5l_decap_8
XFILLER_403_21 VPWR VGND sg13cmos5l_decap_8
XFILLER_66_49 VPWR VGND sg13cmos5l_decap_8
XFILLER_257_172 VPWR VGND sg13cmos5l_decap_4
XFILLER_406_114 VPWR VGND sg13cmos5l_fill_2
XFILLER_181_7 VPWR VGND sg13cmos5l_decap_8
XFILLER_479_14 VPWR VGND sg13cmos5l_decap_8
XFILLER_610_206 VPWR VGND sg13cmos5l_decap_4
XFILLER_700_63 VPWR VGND sg13cmos5l_decap_8
XFILLER_421_128 VPWR VGND sg13cmos5l_decap_8
XFILLER_82_48 VPWR VGND sg13cmos5l_decap_8
XFILLER_479_58 VPWR VGND sg13cmos5l_fill_1
XFILLER_446_7 VPWR VGND sg13cmos5l_decap_8
XFILLER_359_213 VPWR VGND sg13cmos5l_decap_4
XFILLER_709_126 VPWR VGND sg13cmos5l_decap_8
XFILLER_25_185 VPWR VGND sg13cmos5l_decap_8
XFILLER_629_28 VPWR VGND sg13cmos5l_decap_8
XFILLER_15_42 VPWR VGND sg13cmos5l_decap_8
XFILLER_40_122 VPWR VGND sg13cmos5l_decap_4
XFILLER_25_196 VPWR VGND sg13cmos5l_fill_2
XFILLER_575_154 VPWR VGND sg13cmos5l_decap_8
XFILLER_559_91 VPWR VGND sg13cmos5l_decap_8
XFILLER_613_7 VPWR VGND sg13cmos5l_decap_8
XANTENNA__2922__X Tile_X0Y8_E2BEG[6] VPWR VGND sg13cmos5l_antennanp
XFILLER_15_86 VPWR VGND sg13cmos5l_decap_8
XFILLER_495_35 VPWR VGND sg13cmos5l_decap_8
XFILLER_278_70 VPWR VGND sg13cmos5l_decap_8
XFILLER_590_113 VPWR VGND sg13cmos5l_decap_8
XFILLER_516_210 VPWR VGND sg13cmos5l_decap_8
XFILLER_717_170 VPWR VGND sg13cmos5l_fill_1
XFILLER_31_41 VPWR VGND sg13cmos5l_decap_8
XFILLER_590_179 VPWR VGND sg13cmos5l_decap_8
XFILLER_645_49 VPWR VGND sg13cmos5l_decap_8
XFILLER_428_84 VPWR VGND sg13cmos5l_decap_8
XFILLER_327_187 VPWR VGND sg13cmos5l_decap_8
XFILLER_327_198 VPWR VGND sg13cmos5l_fill_2
XFILLER_364_28 VPWR VGND sg13cmos5l_decap_8
XFILLER_342_157 VPWR VGND sg13cmos5l_fill_1
XFILLER_294_91 VPWR VGND sg13cmos5l_decap_8
XFILLER_103_0 VPWR VGND sg13cmos5l_decap_8
XANTENNA__3753__X AXI_M_SOC_ARADDR25 VPWR VGND sg13cmos5l_antennanp
XFILLER_496_161 VPWR VGND sg13cmos5l_decap_8
XFILLER_444_72 VPWR VGND sg13cmos5l_decap_8
XFILLER_163_40 VPWR VGND sg13cmos5l_decap_8
XFILLER_645_147 VPWR VGND sg13cmos5l_decap_8
XFILLER_380_49 VPWR VGND sg13cmos5l_decap_4
XFILLER_313_21 VPWR VGND sg13cmos5l_decap_4
XFILLER_163_95 VPWR VGND sg13cmos5l_decap_8
XFILLER_472_0 VPWR VGND sg13cmos5l_decap_8
XFILLER_313_54 VPWR VGND sg13cmos5l_decap_8
XFILLER_653_180 VPWR VGND sg13cmos5l_fill_1
XFILLER_598_213 VPWR VGND sg13cmos5l_decap_4
XFILLER_56_60 VPWR VGND sg13cmos5l_decap_8
XFILLER_389_14 VPWR VGND sg13cmos5l_decap_8
XFILLER_610_63 VPWR VGND sg13cmos5l_decap_8
XFILLER_539_28 VPWR VGND sg13cmos5l_decap_8
XFILLER_686_56 VPWR VGND sg13cmos5l_decap_8
XFILLER_566_154 VPWR VGND sg13cmos5l_decap_8
XANTENNA__2832__X Tile_X0Y6_E1BEG[1] VPWR VGND sg13cmos5l_antennanp
X_2810_ Tile_X0Y3_E2BEG[0] _4148_/X VPWR VGND sg13cmos5l_buf_1
XFILLER_31_155 VPWR VGND sg13cmos5l_decap_8
X_3790_ _3790_/X Tile_X0Y0_W2MID[1] Tile_X0Y0_W2END[1] Tile_X0Y0_W6END[1] _3854_/X
+ _1157_/Q _1156_/Q VPWR VGND sg13cmos5l_mux4_1
XFILLER_715_118 VPWR VGND sg13cmos5l_decap_8
XFILLER_188_70 VPWR VGND sg13cmos5l_decap_8
XFILLER_188_81 VPWR VGND sg13cmos5l_fill_2
XFILLER_507_210 VPWR VGND sg13cmos5l_fill_2
X_2741_ Tile_X0Y3_UserCLKo Tile_X0Y3_UserCLK VPWR VGND sg13cmos5l_buf_1
XFILLER_117_205 VPWR VGND sg13cmos5l_decap_4
X_2672_ _2672_/Q Tile_X0Y6_FrameData[23] VGND VPWR Tile_X0Y9_FrameStrobe[7] latch
XFILLER_555_49 VPWR VGND sg13cmos5l_decap_8
XFILLER_318_187 VPWR VGND sg13cmos5l_fill_1
XFILLER_184_193 VPWR VGND sg13cmos5l_fill_1
X_4411_ _4411_/X AXI_M_SOC_RRESP1 _4455_/X _4459_/X _4434_/X _2281_/Q _2280_/Q VPWR
+ VGND sg13cmos5l_mux4_1
X_1623_ _1623_/Q Tile_X0Y2_FrameData[26] VGND VPWR Tile_X0Y9_FrameStrobe[6] latch
XFILLER_274_28 VPWR VGND sg13cmos5l_decap_8
XANTENNA__3663__X AXI_M_SOC_AWADDR24 VPWR VGND sg13cmos5l_antennanp
X_4342_ _4342_/X _4308_/X _0160_/X _4307_/X _0110_/X _1969_/Q _1968_/Q VPWR VGND sg13cmos5l_mux4_1
X_1554_ _1554_/Q Tile_X0Y2_FrameData[31] VGND VPWR Tile_X0Y9_FrameStrobe[4] latch
XFILLER_98_122 VPWR VGND sg13cmos5l_decap_8
XFILLER_207_55 VPWR VGND sg13cmos5l_decap_8
X_0505_ _0505_/Q Tile_X0Y8_FrameData[6] VGND VPWR Tile_X0Y9_FrameStrobe[2] latch
X_1485_ _1485_/Q Tile_X0Y2_FrameData[4] VGND VPWR Tile_X0Y9_FrameStrobe[1] latch
X_4273_ _4273_/X Tile_X0Y4_WW4END[14] AXI_M_SOC_BRESP1 _4350_/X _4314_/X _2067_/Q
+ _2066_/Q VPWR VGND sg13cmos5l_mux4_1
XFILLER_504_42 VPWR VGND sg13cmos5l_decap_8
X_0436_ _0436_/Q Tile_X0Y8_FrameData[11] VGND VPWR Tile_X0Y9_FrameStrobe[0] latch
X_3224_ Tile_X0Y0_FrameStrobe_O[12] Tile_X0Y9_FrameStrobe[12] VPWR VGND sg13cmos5l_buf_1
.ends
