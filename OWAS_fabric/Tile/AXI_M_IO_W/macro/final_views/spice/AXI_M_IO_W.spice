* NGSPICE file created from AXI_M_IO_W.ext - technology: ihp-sg13cmos5l

* Black-box entry subcircuit for sg13cmos5l_decap_8 abstract view
.subckt sg13cmos5l_decap_8 VDD VSS
.ends

* Black-box entry subcircuit for sg13cmos5l_fill_1 abstract view
.subckt sg13cmos5l_fill_1 VDD VSS
.ends

* Black-box entry subcircuit for latch abstract view
.subckt latch Q D VSS VDD GATE
.ends

* Black-box entry subcircuit for sg13cmos5l_buf_1 abstract view
.subckt sg13cmos5l_buf_1 X A VDD VSS
.ends

* Black-box entry subcircuit for sg13cmos5l_fill_2 abstract view
.subckt sg13cmos5l_fill_2 VDD VSS
.ends

* Black-box entry subcircuit for sg13cmos5l_decap_4 abstract view
.subckt sg13cmos5l_decap_4 VDD VSS
.ends

* Black-box entry subcircuit for sg13cmos5l_antennanp abstract view
.subckt sg13cmos5l_antennanp A VDD VSS
.ends

* Black-box entry subcircuit for sg13cmos5l_mux4_1 abstract view
.subckt sg13cmos5l_mux4_1 X A0 A1 A2 A3 S0 S1 VDD VSS
.ends

* Black-box entry subcircuit for sg13cmos5l_mux2_1 abstract view
.subckt sg13cmos5l_mux2_1 X A0 A1 S VDD VSS
.ends

* Black-box entry subcircuit for sg13cmos5l_tielo abstract view
.subckt sg13cmos5l_tielo L_LO VDD VSS
.ends

* Black-box entry subcircuit for sg13cmos5l_nor2b_1 abstract view
.subckt sg13cmos5l_nor2b_1 Y A B_N VDD VSS
.ends

* Black-box entry subcircuit for sg13cmos5l_or2_1 abstract view
.subckt sg13cmos5l_or2_1 X A B VDD VSS
.ends

.subckt AXI_M_IO_W AXI_M_SOC_ARADDR0 AXI_M_SOC_ARADDR1 AXI_M_SOC_ARADDR10 AXI_M_SOC_ARADDR11
+ AXI_M_SOC_ARADDR12 AXI_M_SOC_ARADDR13 AXI_M_SOC_ARADDR14 AXI_M_SOC_ARADDR15 AXI_M_SOC_ARADDR16
+ AXI_M_SOC_ARADDR17 AXI_M_SOC_ARADDR18 AXI_M_SOC_ARADDR19 AXI_M_SOC_ARADDR2 AXI_M_SOC_ARADDR20
+ AXI_M_SOC_ARADDR21 AXI_M_SOC_ARADDR22 AXI_M_SOC_ARADDR23 AXI_M_SOC_ARADDR24 AXI_M_SOC_ARADDR25
+ AXI_M_SOC_ARADDR26 AXI_M_SOC_ARADDR27 AXI_M_SOC_ARADDR28 AXI_M_SOC_ARADDR29 AXI_M_SOC_ARADDR3
+ AXI_M_SOC_ARADDR30 AXI_M_SOC_ARADDR31 AXI_M_SOC_ARADDR4 AXI_M_SOC_ARADDR5 AXI_M_SOC_ARADDR6
+ AXI_M_SOC_ARADDR7 AXI_M_SOC_ARADDR8 AXI_M_SOC_ARADDR9 AXI_M_SOC_ARBURST0 AXI_M_SOC_ARBURST1
+ AXI_M_SOC_ARCACHE0 AXI_M_SOC_ARCACHE1 AXI_M_SOC_ARCACHE2 AXI_M_SOC_ARCACHE3 AXI_M_SOC_ARLEN0
+ AXI_M_SOC_ARLEN1 AXI_M_SOC_ARLEN2 AXI_M_SOC_ARLEN3 AXI_M_SOC_ARLEN4 AXI_M_SOC_ARLEN5
+ AXI_M_SOC_ARLEN6 AXI_M_SOC_ARLEN7 AXI_M_SOC_ARLOCK AXI_M_SOC_ARREADY AXI_M_SOC_ARSIZE0
+ AXI_M_SOC_ARSIZE1 AXI_M_SOC_ARSIZE2 AXI_M_SOC_ARVALID AXI_M_SOC_AWADDR0 AXI_M_SOC_AWADDR1
+ AXI_M_SOC_AWADDR10 AXI_M_SOC_AWADDR11 AXI_M_SOC_AWADDR12 AXI_M_SOC_AWADDR13 AXI_M_SOC_AWADDR14
+ AXI_M_SOC_AWADDR15 AXI_M_SOC_AWADDR16 AXI_M_SOC_AWADDR17 AXI_M_SOC_AWADDR18 AXI_M_SOC_AWADDR19
+ AXI_M_SOC_AWADDR2 AXI_M_SOC_AWADDR20 AXI_M_SOC_AWADDR21 AXI_M_SOC_AWADDR22 AXI_M_SOC_AWADDR23
+ AXI_M_SOC_AWADDR24 AXI_M_SOC_AWADDR25 AXI_M_SOC_AWADDR26 AXI_M_SOC_AWADDR27 AXI_M_SOC_AWADDR28
+ AXI_M_SOC_AWADDR29 AXI_M_SOC_AWADDR3 AXI_M_SOC_AWADDR30 AXI_M_SOC_AWADDR31 AXI_M_SOC_AWADDR4
+ AXI_M_SOC_AWADDR5 AXI_M_SOC_AWADDR6 AXI_M_SOC_AWADDR7 AXI_M_SOC_AWADDR8 AXI_M_SOC_AWADDR9
+ AXI_M_SOC_AWBURST0 AXI_M_SOC_AWBURST1 AXI_M_SOC_AWCACHE0 AXI_M_SOC_AWCACHE1 AXI_M_SOC_AWCACHE2
+ AXI_M_SOC_AWCACHE3 AXI_M_SOC_AWLEN0 AXI_M_SOC_AWLEN1 AXI_M_SOC_AWLEN2 AXI_M_SOC_AWLEN3
+ AXI_M_SOC_AWLEN4 AXI_M_SOC_AWLEN5 AXI_M_SOC_AWLEN6 AXI_M_SOC_AWLEN7 AXI_M_SOC_AWLOCK
+ AXI_M_SOC_AWREADY AXI_M_SOC_AWSIZE0 AXI_M_SOC_AWSIZE1 AXI_M_SOC_AWSIZE2 AXI_M_SOC_AWVALID
+ AXI_M_SOC_BREADY AXI_M_SOC_BRESP0 AXI_M_SOC_BRESP1 AXI_M_SOC_BVALID AXI_M_SOC_RDATA0
+ AXI_M_SOC_RDATA1 AXI_M_SOC_RDATA10 AXI_M_SOC_RDATA11 AXI_M_SOC_RDATA12 AXI_M_SOC_RDATA13
+ AXI_M_SOC_RDATA14 AXI_M_SOC_RDATA15 AXI_M_SOC_RDATA16 AXI_M_SOC_RDATA17 AXI_M_SOC_RDATA18
+ AXI_M_SOC_RDATA19 AXI_M_SOC_RDATA2 AXI_M_SOC_RDATA20 AXI_M_SOC_RDATA21 AXI_M_SOC_RDATA22
+ AXI_M_SOC_RDATA23 AXI_M_SOC_RDATA24 AXI_M_SOC_RDATA25 AXI_M_SOC_RDATA26 AXI_M_SOC_RDATA27
+ AXI_M_SOC_RDATA28 AXI_M_SOC_RDATA29 AXI_M_SOC_RDATA3 AXI_M_SOC_RDATA30 AXI_M_SOC_RDATA31
+ AXI_M_SOC_RDATA4 AXI_M_SOC_RDATA5 AXI_M_SOC_RDATA6 AXI_M_SOC_RDATA7 AXI_M_SOC_RDATA8
+ AXI_M_SOC_RDATA9 AXI_M_SOC_RLAST AXI_M_SOC_RREADY AXI_M_SOC_RRESP0 AXI_M_SOC_RRESP1
+ AXI_M_SOC_RVALID AXI_M_SOC_WDATA0 AXI_M_SOC_WDATA1 AXI_M_SOC_WDATA10 AXI_M_SOC_WDATA11
+ AXI_M_SOC_WDATA12 AXI_M_SOC_WDATA13 AXI_M_SOC_WDATA14 AXI_M_SOC_WDATA15 AXI_M_SOC_WDATA16
+ AXI_M_SOC_WDATA17 AXI_M_SOC_WDATA18 AXI_M_SOC_WDATA19 AXI_M_SOC_WDATA2 AXI_M_SOC_WDATA20
+ AXI_M_SOC_WDATA21 AXI_M_SOC_WDATA22 AXI_M_SOC_WDATA23 AXI_M_SOC_WDATA24 AXI_M_SOC_WDATA25
+ AXI_M_SOC_WDATA26 AXI_M_SOC_WDATA27 AXI_M_SOC_WDATA28 AXI_M_SOC_WDATA29 AXI_M_SOC_WDATA3
+ AXI_M_SOC_WDATA30 AXI_M_SOC_WDATA31 AXI_M_SOC_WDATA4 AXI_M_SOC_WDATA5 AXI_M_SOC_WDATA6
+ AXI_M_SOC_WDATA7 AXI_M_SOC_WDATA8 AXI_M_SOC_WDATA9 AXI_M_SOC_WLAST AXI_M_SOC_WREADY
+ AXI_M_SOC_WSTRB0 AXI_M_SOC_WSTRB1 AXI_M_SOC_WSTRB2 AXI_M_SOC_WSTRB3 AXI_M_SOC_WVALID
+ Tile_X0Y0_E1BEG[0] Tile_X0Y0_E1BEG[1] Tile_X0Y0_E1BEG[2] Tile_X0Y0_E1BEG[3] Tile_X0Y0_E2BEG[0]
+ Tile_X0Y0_E2BEG[1] Tile_X0Y0_E2BEG[2] Tile_X0Y0_E2BEG[3] Tile_X0Y0_E2BEG[4] Tile_X0Y0_E2BEG[5]
+ Tile_X0Y0_E2BEG[6] Tile_X0Y0_E2BEG[7] Tile_X0Y0_E2BEGb[0] Tile_X0Y0_E2BEGb[1] Tile_X0Y0_E2BEGb[2]
+ Tile_X0Y0_E2BEGb[3] Tile_X0Y0_E2BEGb[4] Tile_X0Y0_E2BEGb[5] Tile_X0Y0_E2BEGb[6]
+ Tile_X0Y0_E2BEGb[7] Tile_X0Y0_E6BEG[0] Tile_X0Y0_E6BEG[10] Tile_X0Y0_E6BEG[11] Tile_X0Y0_E6BEG[1]
+ Tile_X0Y0_E6BEG[2] Tile_X0Y0_E6BEG[3] Tile_X0Y0_E6BEG[4] Tile_X0Y0_E6BEG[5] Tile_X0Y0_E6BEG[6]
+ Tile_X0Y0_E6BEG[7] Tile_X0Y0_E6BEG[8] Tile_X0Y0_E6BEG[9] Tile_X0Y0_EE4BEG[0] Tile_X0Y0_EE4BEG[10]
+ Tile_X0Y0_EE4BEG[11] Tile_X0Y0_EE4BEG[12] Tile_X0Y0_EE4BEG[13] Tile_X0Y0_EE4BEG[14]
+ Tile_X0Y0_EE4BEG[15] Tile_X0Y0_EE4BEG[1] Tile_X0Y0_EE4BEG[2] Tile_X0Y0_EE4BEG[3]
+ Tile_X0Y0_EE4BEG[4] Tile_X0Y0_EE4BEG[5] Tile_X0Y0_EE4BEG[6] Tile_X0Y0_EE4BEG[7]
+ Tile_X0Y0_EE4BEG[8] Tile_X0Y0_EE4BEG[9] Tile_X0Y0_FrameData[0] Tile_X0Y0_FrameData[10]
+ Tile_X0Y0_FrameData[11] Tile_X0Y0_FrameData[12] Tile_X0Y0_FrameData[13] Tile_X0Y0_FrameData[14]
+ Tile_X0Y0_FrameData[15] Tile_X0Y0_FrameData[16] Tile_X0Y0_FrameData[17] Tile_X0Y0_FrameData[18]
+ Tile_X0Y0_FrameData[19] Tile_X0Y0_FrameData[1] Tile_X0Y0_FrameData[20] Tile_X0Y0_FrameData[21]
+ Tile_X0Y0_FrameData[22] Tile_X0Y0_FrameData[23] Tile_X0Y0_FrameData[24] Tile_X0Y0_FrameData[25]
+ Tile_X0Y0_FrameData[26] Tile_X0Y0_FrameData[27] Tile_X0Y0_FrameData[28] Tile_X0Y0_FrameData[29]
+ Tile_X0Y0_FrameData[2] Tile_X0Y0_FrameData[30] Tile_X0Y0_FrameData[31] Tile_X0Y0_FrameData[3]
+ Tile_X0Y0_FrameData[4] Tile_X0Y0_FrameData[5] Tile_X0Y0_FrameData[6] Tile_X0Y0_FrameData[7]
+ Tile_X0Y0_FrameData[8] Tile_X0Y0_FrameData[9] Tile_X0Y0_FrameData_O[0] Tile_X0Y0_FrameData_O[10]
+ Tile_X0Y0_FrameData_O[11] Tile_X0Y0_FrameData_O[12] Tile_X0Y0_FrameData_O[13] Tile_X0Y0_FrameData_O[14]
+ Tile_X0Y0_FrameData_O[15] Tile_X0Y0_FrameData_O[16] Tile_X0Y0_FrameData_O[17] Tile_X0Y0_FrameData_O[18]
+ Tile_X0Y0_FrameData_O[19] Tile_X0Y0_FrameData_O[1] Tile_X0Y0_FrameData_O[20] Tile_X0Y0_FrameData_O[21]
+ Tile_X0Y0_FrameData_O[22] Tile_X0Y0_FrameData_O[23] Tile_X0Y0_FrameData_O[24] Tile_X0Y0_FrameData_O[25]
+ Tile_X0Y0_FrameData_O[26] Tile_X0Y0_FrameData_O[27] Tile_X0Y0_FrameData_O[28] Tile_X0Y0_FrameData_O[29]
+ Tile_X0Y0_FrameData_O[2] Tile_X0Y0_FrameData_O[30] Tile_X0Y0_FrameData_O[31] Tile_X0Y0_FrameData_O[3]
+ Tile_X0Y0_FrameData_O[4] Tile_X0Y0_FrameData_O[5] Tile_X0Y0_FrameData_O[6] Tile_X0Y0_FrameData_O[7]
+ Tile_X0Y0_FrameData_O[8] Tile_X0Y0_FrameData_O[9] Tile_X0Y0_FrameStrobe_O[0] Tile_X0Y0_FrameStrobe_O[10]
+ Tile_X0Y0_FrameStrobe_O[11] Tile_X0Y0_FrameStrobe_O[12] Tile_X0Y0_FrameStrobe_O[13]
+ Tile_X0Y0_FrameStrobe_O[14] Tile_X0Y0_FrameStrobe_O[15] Tile_X0Y0_FrameStrobe_O[16]
+ Tile_X0Y0_FrameStrobe_O[17] Tile_X0Y0_FrameStrobe_O[18] Tile_X0Y0_FrameStrobe_O[19]
+ Tile_X0Y0_FrameStrobe_O[1] Tile_X0Y0_FrameStrobe_O[2] Tile_X0Y0_FrameStrobe_O[3]
+ Tile_X0Y0_FrameStrobe_O[4] Tile_X0Y0_FrameStrobe_O[5] Tile_X0Y0_FrameStrobe_O[6]
+ Tile_X0Y0_FrameStrobe_O[7] Tile_X0Y0_FrameStrobe_O[8] Tile_X0Y0_FrameStrobe_O[9]
+ Tile_X0Y0_N1BEG[0] Tile_X0Y0_N1BEG[1] Tile_X0Y0_N1BEG[2] Tile_X0Y0_N1BEG[3] Tile_X0Y0_N2BEG[0]
+ Tile_X0Y0_N2BEG[1] Tile_X0Y0_N2BEG[2] Tile_X0Y0_N2BEG[3] Tile_X0Y0_N2BEG[4] Tile_X0Y0_N2BEG[5]
+ Tile_X0Y0_N2BEG[6] Tile_X0Y0_N2BEG[7] Tile_X0Y0_N2BEGb[0] Tile_X0Y0_N2BEGb[1] Tile_X0Y0_N2BEGb[2]
+ Tile_X0Y0_N2BEGb[3] Tile_X0Y0_N2BEGb[4] Tile_X0Y0_N2BEGb[5] Tile_X0Y0_N2BEGb[6]
+ Tile_X0Y0_N2BEGb[7] Tile_X0Y0_N4BEG[0] Tile_X0Y0_N4BEG[10] Tile_X0Y0_N4BEG[11] Tile_X0Y0_N4BEG[12]
+ Tile_X0Y0_N4BEG[13] Tile_X0Y0_N4BEG[14] Tile_X0Y0_N4BEG[15] Tile_X0Y0_N4BEG[1] Tile_X0Y0_N4BEG[2]
+ Tile_X0Y0_N4BEG[3] Tile_X0Y0_N4BEG[4] Tile_X0Y0_N4BEG[5] Tile_X0Y0_N4BEG[6] Tile_X0Y0_N4BEG[7]
+ Tile_X0Y0_N4BEG[8] Tile_X0Y0_N4BEG[9] Tile_X0Y0_S1END[0] Tile_X0Y0_S1END[1] Tile_X0Y0_S1END[2]
+ Tile_X0Y0_S1END[3] Tile_X0Y0_S2END[0] Tile_X0Y0_S2END[1] Tile_X0Y0_S2END[2] Tile_X0Y0_S2END[3]
+ Tile_X0Y0_S2END[4] Tile_X0Y0_S2END[5] Tile_X0Y0_S2END[6] Tile_X0Y0_S2END[7] Tile_X0Y0_S2MID[0]
+ Tile_X0Y0_S2MID[1] Tile_X0Y0_S2MID[2] Tile_X0Y0_S2MID[3] Tile_X0Y0_S2MID[4] Tile_X0Y0_S2MID[5]
+ Tile_X0Y0_S2MID[6] Tile_X0Y0_S2MID[7] Tile_X0Y0_S4END[0] Tile_X0Y0_S4END[10] Tile_X0Y0_S4END[11]
+ Tile_X0Y0_S4END[12] Tile_X0Y0_S4END[13] Tile_X0Y0_S4END[14] Tile_X0Y0_S4END[15]
+ Tile_X0Y0_S4END[1] Tile_X0Y0_S4END[2] Tile_X0Y0_S4END[3] Tile_X0Y0_S4END[4] Tile_X0Y0_S4END[5]
+ Tile_X0Y0_S4END[6] Tile_X0Y0_S4END[7] Tile_X0Y0_S4END[8] Tile_X0Y0_S4END[9] Tile_X0Y0_UserCLK
+ Tile_X0Y0_UserCLKo Tile_X0Y0_W1END[0] Tile_X0Y0_W1END[1] Tile_X0Y0_W1END[2] Tile_X0Y0_W1END[3]
+ Tile_X0Y0_W2END[0] Tile_X0Y0_W2END[1] Tile_X0Y0_W2END[2] Tile_X0Y0_W2END[3] Tile_X0Y0_W2END[4]
+ Tile_X0Y0_W2END[5] Tile_X0Y0_W2END[6] Tile_X0Y0_W2END[7] Tile_X0Y0_W2MID[0] Tile_X0Y0_W2MID[1]
+ Tile_X0Y0_W2MID[2] Tile_X0Y0_W2MID[3] Tile_X0Y0_W2MID[4] Tile_X0Y0_W2MID[5] Tile_X0Y0_W2MID[6]
+ Tile_X0Y0_W2MID[7] Tile_X0Y0_W6END[0] Tile_X0Y0_W6END[10] Tile_X0Y0_W6END[11] Tile_X0Y0_W6END[1]
+ Tile_X0Y0_W6END[2] Tile_X0Y0_W6END[3] Tile_X0Y0_W6END[4] Tile_X0Y0_W6END[5] Tile_X0Y0_W6END[6]
+ Tile_X0Y0_W6END[7] Tile_X0Y0_W6END[8] Tile_X0Y0_W6END[9] Tile_X0Y0_WW4END[0] Tile_X0Y0_WW4END[10]
+ Tile_X0Y0_WW4END[11] Tile_X0Y0_WW4END[12] Tile_X0Y0_WW4END[13] Tile_X0Y0_WW4END[14]
+ Tile_X0Y0_WW4END[15] Tile_X0Y0_WW4END[1] Tile_X0Y0_WW4END[2] Tile_X0Y0_WW4END[3]
+ Tile_X0Y0_WW4END[4] Tile_X0Y0_WW4END[5] Tile_X0Y0_WW4END[6] Tile_X0Y0_WW4END[7]
+ Tile_X0Y0_WW4END[8] Tile_X0Y0_WW4END[9] Tile_X0Y1_E1BEG[0] Tile_X0Y1_E1BEG[1] Tile_X0Y1_E1BEG[2]
+ Tile_X0Y1_E1BEG[3] Tile_X0Y1_E2BEG[0] Tile_X0Y1_E2BEG[1] Tile_X0Y1_E2BEG[2] Tile_X0Y1_E2BEG[3]
+ Tile_X0Y1_E2BEG[4] Tile_X0Y1_E2BEG[5] Tile_X0Y1_E2BEG[6] Tile_X0Y1_E2BEG[7] Tile_X0Y1_E2BEGb[0]
+ Tile_X0Y1_E2BEGb[1] Tile_X0Y1_E2BEGb[2] Tile_X0Y1_E2BEGb[3] Tile_X0Y1_E2BEGb[4]
+ Tile_X0Y1_E2BEGb[5] Tile_X0Y1_E2BEGb[6] Tile_X0Y1_E2BEGb[7] Tile_X0Y1_E6BEG[0] Tile_X0Y1_E6BEG[10]
+ Tile_X0Y1_E6BEG[11] Tile_X0Y1_E6BEG[1] Tile_X0Y1_E6BEG[2] Tile_X0Y1_E6BEG[3] Tile_X0Y1_E6BEG[4]
+ Tile_X0Y1_E6BEG[5] Tile_X0Y1_E6BEG[6] Tile_X0Y1_E6BEG[7] Tile_X0Y1_E6BEG[8] Tile_X0Y1_E6BEG[9]
+ Tile_X0Y1_EE4BEG[0] Tile_X0Y1_EE4BEG[10] Tile_X0Y1_EE4BEG[11] Tile_X0Y1_EE4BEG[12]
+ Tile_X0Y1_EE4BEG[13] Tile_X0Y1_EE4BEG[14] Tile_X0Y1_EE4BEG[15] Tile_X0Y1_EE4BEG[1]
+ Tile_X0Y1_EE4BEG[2] Tile_X0Y1_EE4BEG[3] Tile_X0Y1_EE4BEG[4] Tile_X0Y1_EE4BEG[5]
+ Tile_X0Y1_EE4BEG[6] Tile_X0Y1_EE4BEG[7] Tile_X0Y1_EE4BEG[8] Tile_X0Y1_EE4BEG[9]
+ Tile_X0Y1_FrameData[0] Tile_X0Y1_FrameData[10] Tile_X0Y1_FrameData[11] Tile_X0Y1_FrameData[12]
+ Tile_X0Y1_FrameData[13] Tile_X0Y1_FrameData[14] Tile_X0Y1_FrameData[15] Tile_X0Y1_FrameData[16]
+ Tile_X0Y1_FrameData[17] Tile_X0Y1_FrameData[18] Tile_X0Y1_FrameData[19] Tile_X0Y1_FrameData[1]
+ Tile_X0Y1_FrameData[20] Tile_X0Y1_FrameData[21] Tile_X0Y1_FrameData[22] Tile_X0Y1_FrameData[23]
+ Tile_X0Y1_FrameData[24] Tile_X0Y1_FrameData[25] Tile_X0Y1_FrameData[26] Tile_X0Y1_FrameData[27]
+ Tile_X0Y1_FrameData[28] Tile_X0Y1_FrameData[29] Tile_X0Y1_FrameData[2] Tile_X0Y1_FrameData[30]
+ Tile_X0Y1_FrameData[31] Tile_X0Y1_FrameData[3] Tile_X0Y1_FrameData[4] Tile_X0Y1_FrameData[5]
+ Tile_X0Y1_FrameData[6] Tile_X0Y1_FrameData[7] Tile_X0Y1_FrameData[8] Tile_X0Y1_FrameData[9]
+ Tile_X0Y1_FrameData_O[0] Tile_X0Y1_FrameData_O[10] Tile_X0Y1_FrameData_O[11] Tile_X0Y1_FrameData_O[12]
+ Tile_X0Y1_FrameData_O[13] Tile_X0Y1_FrameData_O[14] Tile_X0Y1_FrameData_O[15] Tile_X0Y1_FrameData_O[16]
+ Tile_X0Y1_FrameData_O[17] Tile_X0Y1_FrameData_O[18] Tile_X0Y1_FrameData_O[19] Tile_X0Y1_FrameData_O[1]
+ Tile_X0Y1_FrameData_O[20] Tile_X0Y1_FrameData_O[21] Tile_X0Y1_FrameData_O[22] Tile_X0Y1_FrameData_O[23]
+ Tile_X0Y1_FrameData_O[24] Tile_X0Y1_FrameData_O[25] Tile_X0Y1_FrameData_O[26] Tile_X0Y1_FrameData_O[27]
+ Tile_X0Y1_FrameData_O[28] Tile_X0Y1_FrameData_O[29] Tile_X0Y1_FrameData_O[2] Tile_X0Y1_FrameData_O[30]
+ Tile_X0Y1_FrameData_O[31] Tile_X0Y1_FrameData_O[3] Tile_X0Y1_FrameData_O[4] Tile_X0Y1_FrameData_O[5]
+ Tile_X0Y1_FrameData_O[6] Tile_X0Y1_FrameData_O[7] Tile_X0Y1_FrameData_O[8] Tile_X0Y1_FrameData_O[9]
+ Tile_X0Y1_UserCLK Tile_X0Y1_UserCLKo Tile_X0Y1_W1END[0] Tile_X0Y1_W1END[1] Tile_X0Y1_W1END[2]
+ Tile_X0Y1_W1END[3] Tile_X0Y1_W2END[0] Tile_X0Y1_W2END[1] Tile_X0Y1_W2END[2] Tile_X0Y1_W2END[3]
+ Tile_X0Y1_W2END[4] Tile_X0Y1_W2END[5] Tile_X0Y1_W2END[6] Tile_X0Y1_W2END[7] Tile_X0Y1_W2MID[0]
+ Tile_X0Y1_W2MID[1] Tile_X0Y1_W2MID[2] Tile_X0Y1_W2MID[3] Tile_X0Y1_W2MID[4] Tile_X0Y1_W2MID[5]
+ Tile_X0Y1_W2MID[6] Tile_X0Y1_W2MID[7] Tile_X0Y1_W6END[0] Tile_X0Y1_W6END[10] Tile_X0Y1_W6END[11]
+ Tile_X0Y1_W6END[1] Tile_X0Y1_W6END[2] Tile_X0Y1_W6END[3] Tile_X0Y1_W6END[4] Tile_X0Y1_W6END[5]
+ Tile_X0Y1_W6END[6] Tile_X0Y1_W6END[7] Tile_X0Y1_W6END[8] Tile_X0Y1_W6END[9] Tile_X0Y1_WW4END[0]
+ Tile_X0Y1_WW4END[10] Tile_X0Y1_WW4END[11] Tile_X0Y1_WW4END[12] Tile_X0Y1_WW4END[13]
+ Tile_X0Y1_WW4END[14] Tile_X0Y1_WW4END[15] Tile_X0Y1_WW4END[1] Tile_X0Y1_WW4END[2]
+ Tile_X0Y1_WW4END[3] Tile_X0Y1_WW4END[4] Tile_X0Y1_WW4END[5] Tile_X0Y1_WW4END[6]
+ Tile_X0Y1_WW4END[7] Tile_X0Y1_WW4END[8] Tile_X0Y1_WW4END[9] Tile_X0Y2_E1BEG[0] Tile_X0Y2_E1BEG[1]
+ Tile_X0Y2_E1BEG[2] Tile_X0Y2_E1BEG[3] Tile_X0Y2_E2BEG[0] Tile_X0Y2_E2BEG[1] Tile_X0Y2_E2BEG[2]
+ Tile_X0Y2_E2BEG[3] Tile_X0Y2_E2BEG[4] Tile_X0Y2_E2BEG[5] Tile_X0Y2_E2BEG[6] Tile_X0Y2_E2BEG[7]
+ Tile_X0Y2_E2BEGb[0] Tile_X0Y2_E2BEGb[1] Tile_X0Y2_E2BEGb[2] Tile_X0Y2_E2BEGb[3]
+ Tile_X0Y2_E2BEGb[4] Tile_X0Y2_E2BEGb[5] Tile_X0Y2_E2BEGb[6] Tile_X0Y2_E2BEGb[7]
+ Tile_X0Y2_E6BEG[0] Tile_X0Y2_E6BEG[10] Tile_X0Y2_E6BEG[11] Tile_X0Y2_E6BEG[1] Tile_X0Y2_E6BEG[2]
+ Tile_X0Y2_E6BEG[3] Tile_X0Y2_E6BEG[4] Tile_X0Y2_E6BEG[5] Tile_X0Y2_E6BEG[6] Tile_X0Y2_E6BEG[7]
+ Tile_X0Y2_E6BEG[8] Tile_X0Y2_E6BEG[9] Tile_X0Y2_EE4BEG[0] Tile_X0Y2_EE4BEG[10] Tile_X0Y2_EE4BEG[11]
+ Tile_X0Y2_EE4BEG[12] Tile_X0Y2_EE4BEG[13] Tile_X0Y2_EE4BEG[14] Tile_X0Y2_EE4BEG[15]
+ Tile_X0Y2_EE4BEG[1] Tile_X0Y2_EE4BEG[2] Tile_X0Y2_EE4BEG[3] Tile_X0Y2_EE4BEG[4]
+ Tile_X0Y2_EE4BEG[5] Tile_X0Y2_EE4BEG[6] Tile_X0Y2_EE4BEG[7] Tile_X0Y2_EE4BEG[8]
+ Tile_X0Y2_EE4BEG[9] Tile_X0Y2_FrameData[0] Tile_X0Y2_FrameData[10] Tile_X0Y2_FrameData[11]
+ Tile_X0Y2_FrameData[12] Tile_X0Y2_FrameData[13] Tile_X0Y2_FrameData[14] Tile_X0Y2_FrameData[15]
+ Tile_X0Y2_FrameData[16] Tile_X0Y2_FrameData[17] Tile_X0Y2_FrameData[18] Tile_X0Y2_FrameData[19]
+ Tile_X0Y2_FrameData[1] Tile_X0Y2_FrameData[20] Tile_X0Y2_FrameData[21] Tile_X0Y2_FrameData[22]
+ Tile_X0Y2_FrameData[23] Tile_X0Y2_FrameData[24] Tile_X0Y2_FrameData[25] Tile_X0Y2_FrameData[26]
+ Tile_X0Y2_FrameData[27] Tile_X0Y2_FrameData[28] Tile_X0Y2_FrameData[29] Tile_X0Y2_FrameData[2]
+ Tile_X0Y2_FrameData[30] Tile_X0Y2_FrameData[31] Tile_X0Y2_FrameData[3] Tile_X0Y2_FrameData[4]
+ Tile_X0Y2_FrameData[5] Tile_X0Y2_FrameData[6] Tile_X0Y2_FrameData[7] Tile_X0Y2_FrameData[8]
+ Tile_X0Y2_FrameData[9] Tile_X0Y2_FrameData_O[0] Tile_X0Y2_FrameData_O[10] Tile_X0Y2_FrameData_O[11]
+ Tile_X0Y2_FrameData_O[12] Tile_X0Y2_FrameData_O[13] Tile_X0Y2_FrameData_O[14] Tile_X0Y2_FrameData_O[15]
+ Tile_X0Y2_FrameData_O[16] Tile_X0Y2_FrameData_O[17] Tile_X0Y2_FrameData_O[18] Tile_X0Y2_FrameData_O[19]
+ Tile_X0Y2_FrameData_O[1] Tile_X0Y2_FrameData_O[20] Tile_X0Y2_FrameData_O[21] Tile_X0Y2_FrameData_O[22]
+ Tile_X0Y2_FrameData_O[23] Tile_X0Y2_FrameData_O[24] Tile_X0Y2_FrameData_O[25] Tile_X0Y2_FrameData_O[26]
+ Tile_X0Y2_FrameData_O[27] Tile_X0Y2_FrameData_O[28] Tile_X0Y2_FrameData_O[29] Tile_X0Y2_FrameData_O[2]
+ Tile_X0Y2_FrameData_O[30] Tile_X0Y2_FrameData_O[31] Tile_X0Y2_FrameData_O[3] Tile_X0Y2_FrameData_O[4]
+ Tile_X0Y2_FrameData_O[5] Tile_X0Y2_FrameData_O[6] Tile_X0Y2_FrameData_O[7] Tile_X0Y2_FrameData_O[8]
+ Tile_X0Y2_FrameData_O[9] Tile_X0Y2_UserCLK Tile_X0Y2_UserCLKo Tile_X0Y2_W1END[0]
+ Tile_X0Y2_W1END[1] Tile_X0Y2_W1END[2] Tile_X0Y2_W1END[3] Tile_X0Y2_W2END[0] Tile_X0Y2_W2END[1]
+ Tile_X0Y2_W2END[2] Tile_X0Y2_W2END[3] Tile_X0Y2_W2END[4] Tile_X0Y2_W2END[5] Tile_X0Y2_W2END[6]
+ Tile_X0Y2_W2END[7] Tile_X0Y2_W2MID[0] Tile_X0Y2_W2MID[1] Tile_X0Y2_W2MID[2] Tile_X0Y2_W2MID[3]
+ Tile_X0Y2_W2MID[4] Tile_X0Y2_W2MID[5] Tile_X0Y2_W2MID[6] Tile_X0Y2_W2MID[7] Tile_X0Y2_W6END[0]
+ Tile_X0Y2_W6END[10] Tile_X0Y2_W6END[11] Tile_X0Y2_W6END[1] Tile_X0Y2_W6END[2] Tile_X0Y2_W6END[3]
+ Tile_X0Y2_W6END[4] Tile_X0Y2_W6END[5] Tile_X0Y2_W6END[6] Tile_X0Y2_W6END[7] Tile_X0Y2_W6END[8]
+ Tile_X0Y2_W6END[9] Tile_X0Y2_WW4END[0] Tile_X0Y2_WW4END[10] Tile_X0Y2_WW4END[11]
+ Tile_X0Y2_WW4END[12] Tile_X0Y2_WW4END[13] Tile_X0Y2_WW4END[14] Tile_X0Y2_WW4END[15]
+ Tile_X0Y2_WW4END[1] Tile_X0Y2_WW4END[2] Tile_X0Y2_WW4END[3] Tile_X0Y2_WW4END[4]
+ Tile_X0Y2_WW4END[5] Tile_X0Y2_WW4END[6] Tile_X0Y2_WW4END[7] Tile_X0Y2_WW4END[8]
+ Tile_X0Y2_WW4END[9] Tile_X0Y3_E1BEG[0] Tile_X0Y3_E1BEG[1] Tile_X0Y3_E1BEG[2] Tile_X0Y3_E1BEG[3]
+ Tile_X0Y3_E2BEG[0] Tile_X0Y3_E2BEG[1] Tile_X0Y3_E2BEG[2] Tile_X0Y3_E2BEG[3] Tile_X0Y3_E2BEG[4]
+ Tile_X0Y3_E2BEG[5] Tile_X0Y3_E2BEG[6] Tile_X0Y3_E2BEG[7] Tile_X0Y3_E2BEGb[0] Tile_X0Y3_E2BEGb[1]
+ Tile_X0Y3_E2BEGb[2] Tile_X0Y3_E2BEGb[3] Tile_X0Y3_E2BEGb[4] Tile_X0Y3_E2BEGb[5]
+ Tile_X0Y3_E2BEGb[6] Tile_X0Y3_E2BEGb[7] Tile_X0Y3_E6BEG[0] Tile_X0Y3_E6BEG[10] Tile_X0Y3_E6BEG[11]
+ Tile_X0Y3_E6BEG[1] Tile_X0Y3_E6BEG[2] Tile_X0Y3_E6BEG[3] Tile_X0Y3_E6BEG[4] Tile_X0Y3_E6BEG[5]
+ Tile_X0Y3_E6BEG[6] Tile_X0Y3_E6BEG[7] Tile_X0Y3_E6BEG[8] Tile_X0Y3_E6BEG[9] Tile_X0Y3_EE4BEG[0]
+ Tile_X0Y3_EE4BEG[10] Tile_X0Y3_EE4BEG[11] Tile_X0Y3_EE4BEG[12] Tile_X0Y3_EE4BEG[13]
+ Tile_X0Y3_EE4BEG[14] Tile_X0Y3_EE4BEG[15] Tile_X0Y3_EE4BEG[1] Tile_X0Y3_EE4BEG[2]
+ Tile_X0Y3_EE4BEG[3] Tile_X0Y3_EE4BEG[4] Tile_X0Y3_EE4BEG[5] Tile_X0Y3_EE4BEG[6]
+ Tile_X0Y3_EE4BEG[7] Tile_X0Y3_EE4BEG[8] Tile_X0Y3_EE4BEG[9] Tile_X0Y3_FrameData[0]
+ Tile_X0Y3_FrameData[10] Tile_X0Y3_FrameData[11] Tile_X0Y3_FrameData[12] Tile_X0Y3_FrameData[13]
+ Tile_X0Y3_FrameData[14] Tile_X0Y3_FrameData[15] Tile_X0Y3_FrameData[16] Tile_X0Y3_FrameData[17]
+ Tile_X0Y3_FrameData[18] Tile_X0Y3_FrameData[19] Tile_X0Y3_FrameData[1] Tile_X0Y3_FrameData[20]
+ Tile_X0Y3_FrameData[21] Tile_X0Y3_FrameData[22] Tile_X0Y3_FrameData[23] Tile_X0Y3_FrameData[24]
+ Tile_X0Y3_FrameData[25] Tile_X0Y3_FrameData[26] Tile_X0Y3_FrameData[27] Tile_X0Y3_FrameData[28]
+ Tile_X0Y3_FrameData[29] Tile_X0Y3_FrameData[2] Tile_X0Y3_FrameData[30] Tile_X0Y3_FrameData[31]
+ Tile_X0Y3_FrameData[3] Tile_X0Y3_FrameData[4] Tile_X0Y3_FrameData[5] Tile_X0Y3_FrameData[6]
+ Tile_X0Y3_FrameData[7] Tile_X0Y3_FrameData[8] Tile_X0Y3_FrameData[9] Tile_X0Y3_FrameData_O[0]
+ Tile_X0Y3_FrameData_O[10] Tile_X0Y3_FrameData_O[11] Tile_X0Y3_FrameData_O[12] Tile_X0Y3_FrameData_O[13]
+ Tile_X0Y3_FrameData_O[14] Tile_X0Y3_FrameData_O[15] Tile_X0Y3_FrameData_O[16] Tile_X0Y3_FrameData_O[17]
+ Tile_X0Y3_FrameData_O[18] Tile_X0Y3_FrameData_O[19] Tile_X0Y3_FrameData_O[1] Tile_X0Y3_FrameData_O[20]
+ Tile_X0Y3_FrameData_O[21] Tile_X0Y3_FrameData_O[22] Tile_X0Y3_FrameData_O[23] Tile_X0Y3_FrameData_O[24]
+ Tile_X0Y3_FrameData_O[25] Tile_X0Y3_FrameData_O[26] Tile_X0Y3_FrameData_O[27] Tile_X0Y3_FrameData_O[28]
+ Tile_X0Y3_FrameData_O[29] Tile_X0Y3_FrameData_O[2] Tile_X0Y3_FrameData_O[30] Tile_X0Y3_FrameData_O[31]
+ Tile_X0Y3_FrameData_O[3] Tile_X0Y3_FrameData_O[4] Tile_X0Y3_FrameData_O[5] Tile_X0Y3_FrameData_O[6]
+ Tile_X0Y3_FrameData_O[7] Tile_X0Y3_FrameData_O[8] Tile_X0Y3_FrameData_O[9] Tile_X0Y3_UserCLK
+ Tile_X0Y3_UserCLKo Tile_X0Y3_W1END[0] Tile_X0Y3_W1END[1] Tile_X0Y3_W1END[2] Tile_X0Y3_W1END[3]
+ Tile_X0Y3_W2END[0] Tile_X0Y3_W2END[1] Tile_X0Y3_W2END[2] Tile_X0Y3_W2END[3] Tile_X0Y3_W2END[4]
+ Tile_X0Y3_W2END[5] Tile_X0Y3_W2END[6] Tile_X0Y3_W2END[7] Tile_X0Y3_W2MID[0] Tile_X0Y3_W2MID[1]
+ Tile_X0Y3_W2MID[2] Tile_X0Y3_W2MID[3] Tile_X0Y3_W2MID[4] Tile_X0Y3_W2MID[5] Tile_X0Y3_W2MID[6]
+ Tile_X0Y3_W2MID[7] Tile_X0Y3_W6END[0] Tile_X0Y3_W6END[10] Tile_X0Y3_W6END[11] Tile_X0Y3_W6END[1]
+ Tile_X0Y3_W6END[2] Tile_X0Y3_W6END[3] Tile_X0Y3_W6END[4] Tile_X0Y3_W6END[5] Tile_X0Y3_W6END[6]
+ Tile_X0Y3_W6END[7] Tile_X0Y3_W6END[8] Tile_X0Y3_W6END[9] Tile_X0Y3_WW4END[0] Tile_X0Y3_WW4END[10]
+ Tile_X0Y3_WW4END[11] Tile_X0Y3_WW4END[12] Tile_X0Y3_WW4END[13] Tile_X0Y3_WW4END[14]
+ Tile_X0Y3_WW4END[15] Tile_X0Y3_WW4END[1] Tile_X0Y3_WW4END[2] Tile_X0Y3_WW4END[3]
+ Tile_X0Y3_WW4END[4] Tile_X0Y3_WW4END[5] Tile_X0Y3_WW4END[6] Tile_X0Y3_WW4END[7]
+ Tile_X0Y3_WW4END[8] Tile_X0Y3_WW4END[9] Tile_X0Y4_E1BEG[0] Tile_X0Y4_E1BEG[1] Tile_X0Y4_E1BEG[2]
+ Tile_X0Y4_E1BEG[3] Tile_X0Y4_E2BEG[0] Tile_X0Y4_E2BEG[1] Tile_X0Y4_E2BEG[2] Tile_X0Y4_E2BEG[3]
+ Tile_X0Y4_E2BEG[4] Tile_X0Y4_E2BEG[5] Tile_X0Y4_E2BEG[6] Tile_X0Y4_E2BEG[7] Tile_X0Y4_E2BEGb[0]
+ Tile_X0Y4_E2BEGb[1] Tile_X0Y4_E2BEGb[2] Tile_X0Y4_E2BEGb[3] Tile_X0Y4_E2BEGb[4]
+ Tile_X0Y4_E2BEGb[5] Tile_X0Y4_E2BEGb[6] Tile_X0Y4_E2BEGb[7] Tile_X0Y4_E6BEG[0] Tile_X0Y4_E6BEG[10]
+ Tile_X0Y4_E6BEG[11] Tile_X0Y4_E6BEG[1] Tile_X0Y4_E6BEG[2] Tile_X0Y4_E6BEG[3] Tile_X0Y4_E6BEG[4]
+ Tile_X0Y4_E6BEG[5] Tile_X0Y4_E6BEG[6] Tile_X0Y4_E6BEG[7] Tile_X0Y4_E6BEG[8] Tile_X0Y4_E6BEG[9]
+ Tile_X0Y4_EE4BEG[0] Tile_X0Y4_EE4BEG[10] Tile_X0Y4_EE4BEG[11] Tile_X0Y4_EE4BEG[12]
+ Tile_X0Y4_EE4BEG[13] Tile_X0Y4_EE4BEG[14] Tile_X0Y4_EE4BEG[15] Tile_X0Y4_EE4BEG[1]
+ Tile_X0Y4_EE4BEG[2] Tile_X0Y4_EE4BEG[3] Tile_X0Y4_EE4BEG[4] Tile_X0Y4_EE4BEG[5]
+ Tile_X0Y4_EE4BEG[6] Tile_X0Y4_EE4BEG[7] Tile_X0Y4_EE4BEG[8] Tile_X0Y4_EE4BEG[9]
+ Tile_X0Y4_FrameData[0] Tile_X0Y4_FrameData[10] Tile_X0Y4_FrameData[11] Tile_X0Y4_FrameData[12]
+ Tile_X0Y4_FrameData[13] Tile_X0Y4_FrameData[14] Tile_X0Y4_FrameData[15] Tile_X0Y4_FrameData[16]
+ Tile_X0Y4_FrameData[17] Tile_X0Y4_FrameData[18] Tile_X0Y4_FrameData[19] Tile_X0Y4_FrameData[1]
+ Tile_X0Y4_FrameData[20] Tile_X0Y4_FrameData[21] Tile_X0Y4_FrameData[22] Tile_X0Y4_FrameData[23]
+ Tile_X0Y4_FrameData[24] Tile_X0Y4_FrameData[25] Tile_X0Y4_FrameData[26] Tile_X0Y4_FrameData[27]
+ Tile_X0Y4_FrameData[28] Tile_X0Y4_FrameData[29] Tile_X0Y4_FrameData[2] Tile_X0Y4_FrameData[30]
+ Tile_X0Y4_FrameData[31] Tile_X0Y4_FrameData[3] Tile_X0Y4_FrameData[4] Tile_X0Y4_FrameData[5]
+ Tile_X0Y4_FrameData[6] Tile_X0Y4_FrameData[7] Tile_X0Y4_FrameData[8] Tile_X0Y4_FrameData[9]
+ Tile_X0Y4_FrameData_O[0] Tile_X0Y4_FrameData_O[10] Tile_X0Y4_FrameData_O[11] Tile_X0Y4_FrameData_O[12]
+ Tile_X0Y4_FrameData_O[13] Tile_X0Y4_FrameData_O[14] Tile_X0Y4_FrameData_O[15] Tile_X0Y4_FrameData_O[16]
+ Tile_X0Y4_FrameData_O[17] Tile_X0Y4_FrameData_O[18] Tile_X0Y4_FrameData_O[19] Tile_X0Y4_FrameData_O[1]
+ Tile_X0Y4_FrameData_O[20] Tile_X0Y4_FrameData_O[21] Tile_X0Y4_FrameData_O[22] Tile_X0Y4_FrameData_O[23]
+ Tile_X0Y4_FrameData_O[24] Tile_X0Y4_FrameData_O[25] Tile_X0Y4_FrameData_O[26] Tile_X0Y4_FrameData_O[27]
+ Tile_X0Y4_FrameData_O[28] Tile_X0Y4_FrameData_O[29] Tile_X0Y4_FrameData_O[2] Tile_X0Y4_FrameData_O[30]
+ Tile_X0Y4_FrameData_O[31] Tile_X0Y4_FrameData_O[3] Tile_X0Y4_FrameData_O[4] Tile_X0Y4_FrameData_O[5]
+ Tile_X0Y4_FrameData_O[6] Tile_X0Y4_FrameData_O[7] Tile_X0Y4_FrameData_O[8] Tile_X0Y4_FrameData_O[9]
+ Tile_X0Y4_UserCLK Tile_X0Y4_UserCLKo Tile_X0Y4_W1END[0] Tile_X0Y4_W1END[1] Tile_X0Y4_W1END[2]
+ Tile_X0Y4_W1END[3] Tile_X0Y4_W2END[0] Tile_X0Y4_W2END[1] Tile_X0Y4_W2END[2] Tile_X0Y4_W2END[3]
+ Tile_X0Y4_W2END[4] Tile_X0Y4_W2END[5] Tile_X0Y4_W2END[6] Tile_X0Y4_W2END[7] Tile_X0Y4_W2MID[0]
+ Tile_X0Y4_W2MID[1] Tile_X0Y4_W2MID[2] Tile_X0Y4_W2MID[3] Tile_X0Y4_W2MID[4] Tile_X0Y4_W2MID[5]
+ Tile_X0Y4_W2MID[6] Tile_X0Y4_W2MID[7] Tile_X0Y4_W6END[0] Tile_X0Y4_W6END[10] Tile_X0Y4_W6END[11]
+ Tile_X0Y4_W6END[1] Tile_X0Y4_W6END[2] Tile_X0Y4_W6END[3] Tile_X0Y4_W6END[4] Tile_X0Y4_W6END[5]
+ Tile_X0Y4_W6END[6] Tile_X0Y4_W6END[7] Tile_X0Y4_W6END[8] Tile_X0Y4_W6END[9] Tile_X0Y4_WW4END[0]
+ Tile_X0Y4_WW4END[10] Tile_X0Y4_WW4END[11] Tile_X0Y4_WW4END[12] Tile_X0Y4_WW4END[13]
+ Tile_X0Y4_WW4END[14] Tile_X0Y4_WW4END[15] Tile_X0Y4_WW4END[1] Tile_X0Y4_WW4END[2]
+ Tile_X0Y4_WW4END[3] Tile_X0Y4_WW4END[4] Tile_X0Y4_WW4END[5] Tile_X0Y4_WW4END[6]
+ Tile_X0Y4_WW4END[7] Tile_X0Y4_WW4END[8] Tile_X0Y4_WW4END[9] Tile_X0Y5_E1BEG[0] Tile_X0Y5_E1BEG[1]
+ Tile_X0Y5_E1BEG[2] Tile_X0Y5_E1BEG[3] Tile_X0Y5_E2BEG[0] Tile_X0Y5_E2BEG[1] Tile_X0Y5_E2BEG[2]
+ Tile_X0Y5_E2BEG[3] Tile_X0Y5_E2BEG[4] Tile_X0Y5_E2BEG[5] Tile_X0Y5_E2BEG[6] Tile_X0Y5_E2BEG[7]
+ Tile_X0Y5_E2BEGb[0] Tile_X0Y5_E2BEGb[1] Tile_X0Y5_E2BEGb[2] Tile_X0Y5_E2BEGb[3]
+ Tile_X0Y5_E2BEGb[4] Tile_X0Y5_E2BEGb[5] Tile_X0Y5_E2BEGb[6] Tile_X0Y5_E2BEGb[7]
+ Tile_X0Y5_E6BEG[0] Tile_X0Y5_E6BEG[10] Tile_X0Y5_E6BEG[11] Tile_X0Y5_E6BEG[1] Tile_X0Y5_E6BEG[2]
+ Tile_X0Y5_E6BEG[3] Tile_X0Y5_E6BEG[4] Tile_X0Y5_E6BEG[5] Tile_X0Y5_E6BEG[6] Tile_X0Y5_E6BEG[7]
+ Tile_X0Y5_E6BEG[8] Tile_X0Y5_E6BEG[9] Tile_X0Y5_EE4BEG[0] Tile_X0Y5_EE4BEG[10] Tile_X0Y5_EE4BEG[11]
+ Tile_X0Y5_EE4BEG[12] Tile_X0Y5_EE4BEG[13] Tile_X0Y5_EE4BEG[14] Tile_X0Y5_EE4BEG[15]
+ Tile_X0Y5_EE4BEG[1] Tile_X0Y5_EE4BEG[2] Tile_X0Y5_EE4BEG[3] Tile_X0Y5_EE4BEG[4]
+ Tile_X0Y5_EE4BEG[5] Tile_X0Y5_EE4BEG[6] Tile_X0Y5_EE4BEG[7] Tile_X0Y5_EE4BEG[8]
+ Tile_X0Y5_EE4BEG[9] Tile_X0Y5_FrameData[0] Tile_X0Y5_FrameData[10] Tile_X0Y5_FrameData[11]
+ Tile_X0Y5_FrameData[12] Tile_X0Y5_FrameData[13] Tile_X0Y5_FrameData[14] Tile_X0Y5_FrameData[15]
+ Tile_X0Y5_FrameData[16] Tile_X0Y5_FrameData[17] Tile_X0Y5_FrameData[18] Tile_X0Y5_FrameData[19]
+ Tile_X0Y5_FrameData[1] Tile_X0Y5_FrameData[20] Tile_X0Y5_FrameData[21] Tile_X0Y5_FrameData[22]
+ Tile_X0Y5_FrameData[23] Tile_X0Y5_FrameData[24] Tile_X0Y5_FrameData[25] Tile_X0Y5_FrameData[26]
+ Tile_X0Y5_FrameData[27] Tile_X0Y5_FrameData[28] Tile_X0Y5_FrameData[29] Tile_X0Y5_FrameData[2]
+ Tile_X0Y5_FrameData[30] Tile_X0Y5_FrameData[31] Tile_X0Y5_FrameData[3] Tile_X0Y5_FrameData[4]
+ Tile_X0Y5_FrameData[5] Tile_X0Y5_FrameData[6] Tile_X0Y5_FrameData[7] Tile_X0Y5_FrameData[8]
+ Tile_X0Y5_FrameData[9] Tile_X0Y5_FrameData_O[0] Tile_X0Y5_FrameData_O[10] Tile_X0Y5_FrameData_O[11]
+ Tile_X0Y5_FrameData_O[12] Tile_X0Y5_FrameData_O[13] Tile_X0Y5_FrameData_O[14] Tile_X0Y5_FrameData_O[15]
+ Tile_X0Y5_FrameData_O[16] Tile_X0Y5_FrameData_O[17] Tile_X0Y5_FrameData_O[18] Tile_X0Y5_FrameData_O[19]
+ Tile_X0Y5_FrameData_O[1] Tile_X0Y5_FrameData_O[20] Tile_X0Y5_FrameData_O[21] Tile_X0Y5_FrameData_O[22]
+ Tile_X0Y5_FrameData_O[23] Tile_X0Y5_FrameData_O[24] Tile_X0Y5_FrameData_O[25] Tile_X0Y5_FrameData_O[26]
+ Tile_X0Y5_FrameData_O[27] Tile_X0Y5_FrameData_O[28] Tile_X0Y5_FrameData_O[29] Tile_X0Y5_FrameData_O[2]
+ Tile_X0Y5_FrameData_O[30] Tile_X0Y5_FrameData_O[31] Tile_X0Y5_FrameData_O[3] Tile_X0Y5_FrameData_O[4]
+ Tile_X0Y5_FrameData_O[5] Tile_X0Y5_FrameData_O[6] Tile_X0Y5_FrameData_O[7] Tile_X0Y5_FrameData_O[8]
+ Tile_X0Y5_FrameData_O[9] Tile_X0Y5_UserCLK Tile_X0Y5_UserCLKo Tile_X0Y5_W1END[0]
+ Tile_X0Y5_W1END[1] Tile_X0Y5_W1END[2] Tile_X0Y5_W1END[3] Tile_X0Y5_W2END[0] Tile_X0Y5_W2END[1]
+ Tile_X0Y5_W2END[2] Tile_X0Y5_W2END[3] Tile_X0Y5_W2END[4] Tile_X0Y5_W2END[5] Tile_X0Y5_W2END[6]
+ Tile_X0Y5_W2END[7] Tile_X0Y5_W2MID[0] Tile_X0Y5_W2MID[1] Tile_X0Y5_W2MID[2] Tile_X0Y5_W2MID[3]
+ Tile_X0Y5_W2MID[4] Tile_X0Y5_W2MID[5] Tile_X0Y5_W2MID[6] Tile_X0Y5_W2MID[7] Tile_X0Y5_W6END[0]
+ Tile_X0Y5_W6END[10] Tile_X0Y5_W6END[11] Tile_X0Y5_W6END[1] Tile_X0Y5_W6END[2] Tile_X0Y5_W6END[3]
+ Tile_X0Y5_W6END[4] Tile_X0Y5_W6END[5] Tile_X0Y5_W6END[6] Tile_X0Y5_W6END[7] Tile_X0Y5_W6END[8]
+ Tile_X0Y5_W6END[9] Tile_X0Y5_WW4END[0] Tile_X0Y5_WW4END[10] Tile_X0Y5_WW4END[11]
+ Tile_X0Y5_WW4END[12] Tile_X0Y5_WW4END[13] Tile_X0Y5_WW4END[14] Tile_X0Y5_WW4END[15]
+ Tile_X0Y5_WW4END[1] Tile_X0Y5_WW4END[2] Tile_X0Y5_WW4END[3] Tile_X0Y5_WW4END[4]
+ Tile_X0Y5_WW4END[5] Tile_X0Y5_WW4END[6] Tile_X0Y5_WW4END[7] Tile_X0Y5_WW4END[8]
+ Tile_X0Y5_WW4END[9] Tile_X0Y6_E1BEG[0] Tile_X0Y6_E1BEG[1] Tile_X0Y6_E1BEG[2] Tile_X0Y6_E1BEG[3]
+ Tile_X0Y6_E2BEG[0] Tile_X0Y6_E2BEG[1] Tile_X0Y6_E2BEG[2] Tile_X0Y6_E2BEG[3] Tile_X0Y6_E2BEG[4]
+ Tile_X0Y6_E2BEG[5] Tile_X0Y6_E2BEG[6] Tile_X0Y6_E2BEG[7] Tile_X0Y6_E2BEGb[0] Tile_X0Y6_E2BEGb[1]
+ Tile_X0Y6_E2BEGb[2] Tile_X0Y6_E2BEGb[3] Tile_X0Y6_E2BEGb[4] Tile_X0Y6_E2BEGb[5]
+ Tile_X0Y6_E2BEGb[6] Tile_X0Y6_E2BEGb[7] Tile_X0Y6_E6BEG[0] Tile_X0Y6_E6BEG[10] Tile_X0Y6_E6BEG[11]
+ Tile_X0Y6_E6BEG[1] Tile_X0Y6_E6BEG[2] Tile_X0Y6_E6BEG[3] Tile_X0Y6_E6BEG[4] Tile_X0Y6_E6BEG[5]
+ Tile_X0Y6_E6BEG[6] Tile_X0Y6_E6BEG[7] Tile_X0Y6_E6BEG[8] Tile_X0Y6_E6BEG[9] Tile_X0Y6_EE4BEG[0]
+ Tile_X0Y6_EE4BEG[10] Tile_X0Y6_EE4BEG[11] Tile_X0Y6_EE4BEG[12] Tile_X0Y6_EE4BEG[13]
+ Tile_X0Y6_EE4BEG[14] Tile_X0Y6_EE4BEG[15] Tile_X0Y6_EE4BEG[1] Tile_X0Y6_EE4BEG[2]
+ Tile_X0Y6_EE4BEG[3] Tile_X0Y6_EE4BEG[4] Tile_X0Y6_EE4BEG[5] Tile_X0Y6_EE4BEG[6]
+ Tile_X0Y6_EE4BEG[7] Tile_X0Y6_EE4BEG[8] Tile_X0Y6_EE4BEG[9] Tile_X0Y6_FrameData[0]
+ Tile_X0Y6_FrameData[10] Tile_X0Y6_FrameData[11] Tile_X0Y6_FrameData[12] Tile_X0Y6_FrameData[13]
+ Tile_X0Y6_FrameData[14] Tile_X0Y6_FrameData[15] Tile_X0Y6_FrameData[16] Tile_X0Y6_FrameData[17]
+ Tile_X0Y6_FrameData[18] Tile_X0Y6_FrameData[19] Tile_X0Y6_FrameData[1] Tile_X0Y6_FrameData[20]
+ Tile_X0Y6_FrameData[21] Tile_X0Y6_FrameData[22] Tile_X0Y6_FrameData[23] Tile_X0Y6_FrameData[24]
+ Tile_X0Y6_FrameData[25] Tile_X0Y6_FrameData[26] Tile_X0Y6_FrameData[27] Tile_X0Y6_FrameData[28]
+ Tile_X0Y6_FrameData[29] Tile_X0Y6_FrameData[2] Tile_X0Y6_FrameData[30] Tile_X0Y6_FrameData[31]
+ Tile_X0Y6_FrameData[3] Tile_X0Y6_FrameData[4] Tile_X0Y6_FrameData[5] Tile_X0Y6_FrameData[6]
+ Tile_X0Y6_FrameData[7] Tile_X0Y6_FrameData[8] Tile_X0Y6_FrameData[9] Tile_X0Y6_FrameData_O[0]
+ Tile_X0Y6_FrameData_O[10] Tile_X0Y6_FrameData_O[11] Tile_X0Y6_FrameData_O[12] Tile_X0Y6_FrameData_O[13]
+ Tile_X0Y6_FrameData_O[14] Tile_X0Y6_FrameData_O[15] Tile_X0Y6_FrameData_O[16] Tile_X0Y6_FrameData_O[17]
+ Tile_X0Y6_FrameData_O[18] Tile_X0Y6_FrameData_O[19] Tile_X0Y6_FrameData_O[1] Tile_X0Y6_FrameData_O[20]
+ Tile_X0Y6_FrameData_O[21] Tile_X0Y6_FrameData_O[22] Tile_X0Y6_FrameData_O[23] Tile_X0Y6_FrameData_O[24]
+ Tile_X0Y6_FrameData_O[25] Tile_X0Y6_FrameData_O[26] Tile_X0Y6_FrameData_O[27] Tile_X0Y6_FrameData_O[28]
+ Tile_X0Y6_FrameData_O[29] Tile_X0Y6_FrameData_O[2] Tile_X0Y6_FrameData_O[30] Tile_X0Y6_FrameData_O[31]
+ Tile_X0Y6_FrameData_O[3] Tile_X0Y6_FrameData_O[4] Tile_X0Y6_FrameData_O[5] Tile_X0Y6_FrameData_O[6]
+ Tile_X0Y6_FrameData_O[7] Tile_X0Y6_FrameData_O[8] Tile_X0Y6_FrameData_O[9] Tile_X0Y6_UserCLK
+ Tile_X0Y6_UserCLKo Tile_X0Y6_W1END[0] Tile_X0Y6_W1END[1] Tile_X0Y6_W1END[2] Tile_X0Y6_W1END[3]
+ Tile_X0Y6_W2END[0] Tile_X0Y6_W2END[1] Tile_X0Y6_W2END[2] Tile_X0Y6_W2END[3] Tile_X0Y6_W2END[4]
+ Tile_X0Y6_W2END[5] Tile_X0Y6_W2END[6] Tile_X0Y6_W2END[7] Tile_X0Y6_W2MID[0] Tile_X0Y6_W2MID[1]
+ Tile_X0Y6_W2MID[2] Tile_X0Y6_W2MID[3] Tile_X0Y6_W2MID[4] Tile_X0Y6_W2MID[5] Tile_X0Y6_W2MID[6]
+ Tile_X0Y6_W2MID[7] Tile_X0Y6_W6END[0] Tile_X0Y6_W6END[10] Tile_X0Y6_W6END[11] Tile_X0Y6_W6END[1]
+ Tile_X0Y6_W6END[2] Tile_X0Y6_W6END[3] Tile_X0Y6_W6END[4] Tile_X0Y6_W6END[5] Tile_X0Y6_W6END[6]
+ Tile_X0Y6_W6END[7] Tile_X0Y6_W6END[8] Tile_X0Y6_W6END[9] Tile_X0Y6_WW4END[0] Tile_X0Y6_WW4END[10]
+ Tile_X0Y6_WW4END[11] Tile_X0Y6_WW4END[12] Tile_X0Y6_WW4END[13] Tile_X0Y6_WW4END[14]
+ Tile_X0Y6_WW4END[15] Tile_X0Y6_WW4END[1] Tile_X0Y6_WW4END[2] Tile_X0Y6_WW4END[3]
+ Tile_X0Y6_WW4END[4] Tile_X0Y6_WW4END[5] Tile_X0Y6_WW4END[6] Tile_X0Y6_WW4END[7]
+ Tile_X0Y6_WW4END[8] Tile_X0Y6_WW4END[9] Tile_X0Y7_E1BEG[0] Tile_X0Y7_E1BEG[1] Tile_X0Y7_E1BEG[2]
+ Tile_X0Y7_E1BEG[3] Tile_X0Y7_E2BEG[0] Tile_X0Y7_E2BEG[1] Tile_X0Y7_E2BEG[2] Tile_X0Y7_E2BEG[3]
+ Tile_X0Y7_E2BEG[4] Tile_X0Y7_E2BEG[5] Tile_X0Y7_E2BEG[6] Tile_X0Y7_E2BEG[7] Tile_X0Y7_E2BEGb[0]
+ Tile_X0Y7_E2BEGb[1] Tile_X0Y7_E2BEGb[2] Tile_X0Y7_E2BEGb[3] Tile_X0Y7_E2BEGb[4]
+ Tile_X0Y7_E2BEGb[5] Tile_X0Y7_E2BEGb[6] Tile_X0Y7_E2BEGb[7] Tile_X0Y7_E6BEG[0] Tile_X0Y7_E6BEG[10]
+ Tile_X0Y7_E6BEG[11] Tile_X0Y7_E6BEG[1] Tile_X0Y7_E6BEG[2] Tile_X0Y7_E6BEG[3] Tile_X0Y7_E6BEG[4]
+ Tile_X0Y7_E6BEG[5] Tile_X0Y7_E6BEG[6] Tile_X0Y7_E6BEG[7] Tile_X0Y7_E6BEG[8] Tile_X0Y7_E6BEG[9]
+ Tile_X0Y7_EE4BEG[0] Tile_X0Y7_EE4BEG[10] Tile_X0Y7_EE4BEG[11] Tile_X0Y7_EE4BEG[12]
+ Tile_X0Y7_EE4BEG[13] Tile_X0Y7_EE4BEG[14] Tile_X0Y7_EE4BEG[15] Tile_X0Y7_EE4BEG[1]
+ Tile_X0Y7_EE4BEG[2] Tile_X0Y7_EE4BEG[3] Tile_X0Y7_EE4BEG[4] Tile_X0Y7_EE4BEG[5]
+ Tile_X0Y7_EE4BEG[6] Tile_X0Y7_EE4BEG[7] Tile_X0Y7_EE4BEG[8] Tile_X0Y7_EE4BEG[9]
+ Tile_X0Y7_FrameData[0] Tile_X0Y7_FrameData[10] Tile_X0Y7_FrameData[11] Tile_X0Y7_FrameData[12]
+ Tile_X0Y7_FrameData[13] Tile_X0Y7_FrameData[14] Tile_X0Y7_FrameData[15] Tile_X0Y7_FrameData[16]
+ Tile_X0Y7_FrameData[17] Tile_X0Y7_FrameData[18] Tile_X0Y7_FrameData[19] Tile_X0Y7_FrameData[1]
+ Tile_X0Y7_FrameData[20] Tile_X0Y7_FrameData[21] Tile_X0Y7_FrameData[22] Tile_X0Y7_FrameData[23]
+ Tile_X0Y7_FrameData[24] Tile_X0Y7_FrameData[25] Tile_X0Y7_FrameData[26] Tile_X0Y7_FrameData[27]
+ Tile_X0Y7_FrameData[28] Tile_X0Y7_FrameData[29] Tile_X0Y7_FrameData[2] Tile_X0Y7_FrameData[30]
+ Tile_X0Y7_FrameData[31] Tile_X0Y7_FrameData[3] Tile_X0Y7_FrameData[4] Tile_X0Y7_FrameData[5]
+ Tile_X0Y7_FrameData[6] Tile_X0Y7_FrameData[7] Tile_X0Y7_FrameData[8] Tile_X0Y7_FrameData[9]
+ Tile_X0Y7_FrameData_O[0] Tile_X0Y7_FrameData_O[10] Tile_X0Y7_FrameData_O[11] Tile_X0Y7_FrameData_O[12]
+ Tile_X0Y7_FrameData_O[13] Tile_X0Y7_FrameData_O[14] Tile_X0Y7_FrameData_O[15] Tile_X0Y7_FrameData_O[16]
+ Tile_X0Y7_FrameData_O[17] Tile_X0Y7_FrameData_O[18] Tile_X0Y7_FrameData_O[19] Tile_X0Y7_FrameData_O[1]
+ Tile_X0Y7_FrameData_O[20] Tile_X0Y7_FrameData_O[21] Tile_X0Y7_FrameData_O[22] Tile_X0Y7_FrameData_O[23]
+ Tile_X0Y7_FrameData_O[24] Tile_X0Y7_FrameData_O[25] Tile_X0Y7_FrameData_O[26] Tile_X0Y7_FrameData_O[27]
+ Tile_X0Y7_FrameData_O[28] Tile_X0Y7_FrameData_O[29] Tile_X0Y7_FrameData_O[2] Tile_X0Y7_FrameData_O[30]
+ Tile_X0Y7_FrameData_O[31] Tile_X0Y7_FrameData_O[3] Tile_X0Y7_FrameData_O[4] Tile_X0Y7_FrameData_O[5]
+ Tile_X0Y7_FrameData_O[6] Tile_X0Y7_FrameData_O[7] Tile_X0Y7_FrameData_O[8] Tile_X0Y7_FrameData_O[9]
+ Tile_X0Y7_UserCLK Tile_X0Y7_UserCLKo Tile_X0Y7_W1END[0] Tile_X0Y7_W1END[1] Tile_X0Y7_W1END[2]
+ Tile_X0Y7_W1END[3] Tile_X0Y7_W2END[0] Tile_X0Y7_W2END[1] Tile_X0Y7_W2END[2] Tile_X0Y7_W2END[3]
+ Tile_X0Y7_W2END[4] Tile_X0Y7_W2END[5] Tile_X0Y7_W2END[6] Tile_X0Y7_W2END[7] Tile_X0Y7_W2MID[0]
+ Tile_X0Y7_W2MID[1] Tile_X0Y7_W2MID[2] Tile_X0Y7_W2MID[3] Tile_X0Y7_W2MID[4] Tile_X0Y7_W2MID[5]
+ Tile_X0Y7_W2MID[6] Tile_X0Y7_W2MID[7] Tile_X0Y7_W6END[0] Tile_X0Y7_W6END[10] Tile_X0Y7_W6END[11]
+ Tile_X0Y7_W6END[1] Tile_X0Y7_W6END[2] Tile_X0Y7_W6END[3] Tile_X0Y7_W6END[4] Tile_X0Y7_W6END[5]
+ Tile_X0Y7_W6END[6] Tile_X0Y7_W6END[7] Tile_X0Y7_W6END[8] Tile_X0Y7_W6END[9] Tile_X0Y7_WW4END[0]
+ Tile_X0Y7_WW4END[10] Tile_X0Y7_WW4END[11] Tile_X0Y7_WW4END[12] Tile_X0Y7_WW4END[13]
+ Tile_X0Y7_WW4END[14] Tile_X0Y7_WW4END[15] Tile_X0Y7_WW4END[1] Tile_X0Y7_WW4END[2]
+ Tile_X0Y7_WW4END[3] Tile_X0Y7_WW4END[4] Tile_X0Y7_WW4END[5] Tile_X0Y7_WW4END[6]
+ Tile_X0Y7_WW4END[7] Tile_X0Y7_WW4END[8] Tile_X0Y7_WW4END[9] Tile_X0Y8_E1BEG[0] Tile_X0Y8_E1BEG[1]
+ Tile_X0Y8_E1BEG[2] Tile_X0Y8_E1BEG[3] Tile_X0Y8_E2BEG[0] Tile_X0Y8_E2BEG[1] Tile_X0Y8_E2BEG[2]
+ Tile_X0Y8_E2BEG[3] Tile_X0Y8_E2BEG[4] Tile_X0Y8_E2BEG[5] Tile_X0Y8_E2BEG[6] Tile_X0Y8_E2BEG[7]
+ Tile_X0Y8_E2BEGb[0] Tile_X0Y8_E2BEGb[1] Tile_X0Y8_E2BEGb[2] Tile_X0Y8_E2BEGb[3]
+ Tile_X0Y8_E2BEGb[4] Tile_X0Y8_E2BEGb[5] Tile_X0Y8_E2BEGb[6] Tile_X0Y8_E2BEGb[7]
+ Tile_X0Y8_E6BEG[0] Tile_X0Y8_E6BEG[10] Tile_X0Y8_E6BEG[11] Tile_X0Y8_E6BEG[1] Tile_X0Y8_E6BEG[2]
+ Tile_X0Y8_E6BEG[3] Tile_X0Y8_E6BEG[4] Tile_X0Y8_E6BEG[5] Tile_X0Y8_E6BEG[6] Tile_X0Y8_E6BEG[7]
+ Tile_X0Y8_E6BEG[8] Tile_X0Y8_E6BEG[9] Tile_X0Y8_EE4BEG[0] Tile_X0Y8_EE4BEG[10] Tile_X0Y8_EE4BEG[11]
+ Tile_X0Y8_EE4BEG[12] Tile_X0Y8_EE4BEG[13] Tile_X0Y8_EE4BEG[14] Tile_X0Y8_EE4BEG[15]
+ Tile_X0Y8_EE4BEG[1] Tile_X0Y8_EE4BEG[2] Tile_X0Y8_EE4BEG[3] Tile_X0Y8_EE4BEG[4]
+ Tile_X0Y8_EE4BEG[5] Tile_X0Y8_EE4BEG[6] Tile_X0Y8_EE4BEG[7] Tile_X0Y8_EE4BEG[8]
+ Tile_X0Y8_EE4BEG[9] Tile_X0Y8_FrameData[0] Tile_X0Y8_FrameData[10] Tile_X0Y8_FrameData[11]
+ Tile_X0Y8_FrameData[12] Tile_X0Y8_FrameData[13] Tile_X0Y8_FrameData[14] Tile_X0Y8_FrameData[15]
+ Tile_X0Y8_FrameData[16] Tile_X0Y8_FrameData[17] Tile_X0Y8_FrameData[18] Tile_X0Y8_FrameData[19]
+ Tile_X0Y8_FrameData[1] Tile_X0Y8_FrameData[20] Tile_X0Y8_FrameData[21] Tile_X0Y8_FrameData[22]
+ Tile_X0Y8_FrameData[23] Tile_X0Y8_FrameData[24] Tile_X0Y8_FrameData[25] Tile_X0Y8_FrameData[26]
+ Tile_X0Y8_FrameData[27] Tile_X0Y8_FrameData[28] Tile_X0Y8_FrameData[29] Tile_X0Y8_FrameData[2]
+ Tile_X0Y8_FrameData[30] Tile_X0Y8_FrameData[31] Tile_X0Y8_FrameData[3] Tile_X0Y8_FrameData[4]
+ Tile_X0Y8_FrameData[5] Tile_X0Y8_FrameData[6] Tile_X0Y8_FrameData[7] Tile_X0Y8_FrameData[8]
+ Tile_X0Y8_FrameData[9] Tile_X0Y8_FrameData_O[0] Tile_X0Y8_FrameData_O[10] Tile_X0Y8_FrameData_O[11]
+ Tile_X0Y8_FrameData_O[12] Tile_X0Y8_FrameData_O[13] Tile_X0Y8_FrameData_O[14] Tile_X0Y8_FrameData_O[15]
+ Tile_X0Y8_FrameData_O[16] Tile_X0Y8_FrameData_O[17] Tile_X0Y8_FrameData_O[18] Tile_X0Y8_FrameData_O[19]
+ Tile_X0Y8_FrameData_O[1] Tile_X0Y8_FrameData_O[20] Tile_X0Y8_FrameData_O[21] Tile_X0Y8_FrameData_O[22]
+ Tile_X0Y8_FrameData_O[23] Tile_X0Y8_FrameData_O[24] Tile_X0Y8_FrameData_O[25] Tile_X0Y8_FrameData_O[26]
+ Tile_X0Y8_FrameData_O[27] Tile_X0Y8_FrameData_O[28] Tile_X0Y8_FrameData_O[29] Tile_X0Y8_FrameData_O[2]
+ Tile_X0Y8_FrameData_O[30] Tile_X0Y8_FrameData_O[31] Tile_X0Y8_FrameData_O[3] Tile_X0Y8_FrameData_O[4]
+ Tile_X0Y8_FrameData_O[5] Tile_X0Y8_FrameData_O[6] Tile_X0Y8_FrameData_O[7] Tile_X0Y8_FrameData_O[8]
+ Tile_X0Y8_FrameData_O[9] Tile_X0Y8_UserCLK Tile_X0Y8_UserCLKo Tile_X0Y8_W1END[0]
+ Tile_X0Y8_W1END[1] Tile_X0Y8_W1END[2] Tile_X0Y8_W1END[3] Tile_X0Y8_W2END[0] Tile_X0Y8_W2END[1]
+ Tile_X0Y8_W2END[2] Tile_X0Y8_W2END[3] Tile_X0Y8_W2END[4] Tile_X0Y8_W2END[5] Tile_X0Y8_W2END[6]
+ Tile_X0Y8_W2END[7] Tile_X0Y8_W2MID[0] Tile_X0Y8_W2MID[1] Tile_X0Y8_W2MID[2] Tile_X0Y8_W2MID[3]
+ Tile_X0Y8_W2MID[4] Tile_X0Y8_W2MID[5] Tile_X0Y8_W2MID[6] Tile_X0Y8_W2MID[7] Tile_X0Y8_W6END[0]
+ Tile_X0Y8_W6END[10] Tile_X0Y8_W6END[11] Tile_X0Y8_W6END[1] Tile_X0Y8_W6END[2] Tile_X0Y8_W6END[3]
+ Tile_X0Y8_W6END[4] Tile_X0Y8_W6END[5] Tile_X0Y8_W6END[6] Tile_X0Y8_W6END[7] Tile_X0Y8_W6END[8]
+ Tile_X0Y8_W6END[9] Tile_X0Y8_WW4END[0] Tile_X0Y8_WW4END[10] Tile_X0Y8_WW4END[11]
+ Tile_X0Y8_WW4END[12] Tile_X0Y8_WW4END[13] Tile_X0Y8_WW4END[14] Tile_X0Y8_WW4END[15]
+ Tile_X0Y8_WW4END[1] Tile_X0Y8_WW4END[2] Tile_X0Y8_WW4END[3] Tile_X0Y8_WW4END[4]
+ Tile_X0Y8_WW4END[5] Tile_X0Y8_WW4END[6] Tile_X0Y8_WW4END[7] Tile_X0Y8_WW4END[8]
+ Tile_X0Y8_WW4END[9] Tile_X0Y9_E1BEG[0] Tile_X0Y9_E1BEG[1] Tile_X0Y9_E1BEG[2] Tile_X0Y9_E1BEG[3]
+ Tile_X0Y9_E2BEG[0] Tile_X0Y9_E2BEG[1] Tile_X0Y9_E2BEG[2] Tile_X0Y9_E2BEG[3] Tile_X0Y9_E2BEG[4]
+ Tile_X0Y9_E2BEG[5] Tile_X0Y9_E2BEG[6] Tile_X0Y9_E2BEG[7] Tile_X0Y9_E2BEGb[0] Tile_X0Y9_E2BEGb[1]
+ Tile_X0Y9_E2BEGb[2] Tile_X0Y9_E2BEGb[3] Tile_X0Y9_E2BEGb[4] Tile_X0Y9_E2BEGb[5]
+ Tile_X0Y9_E2BEGb[6] Tile_X0Y9_E2BEGb[7] Tile_X0Y9_E6BEG[0] Tile_X0Y9_E6BEG[10] Tile_X0Y9_E6BEG[11]
+ Tile_X0Y9_E6BEG[1] Tile_X0Y9_E6BEG[2] Tile_X0Y9_E6BEG[3] Tile_X0Y9_E6BEG[4] Tile_X0Y9_E6BEG[5]
+ Tile_X0Y9_E6BEG[6] Tile_X0Y9_E6BEG[7] Tile_X0Y9_E6BEG[8] Tile_X0Y9_E6BEG[9] Tile_X0Y9_EE4BEG[0]
+ Tile_X0Y9_EE4BEG[10] Tile_X0Y9_EE4BEG[11] Tile_X0Y9_EE4BEG[12] Tile_X0Y9_EE4BEG[13]
+ Tile_X0Y9_EE4BEG[14] Tile_X0Y9_EE4BEG[15] Tile_X0Y9_EE4BEG[1] Tile_X0Y9_EE4BEG[2]
+ Tile_X0Y9_EE4BEG[3] Tile_X0Y9_EE4BEG[4] Tile_X0Y9_EE4BEG[5] Tile_X0Y9_EE4BEG[6]
+ Tile_X0Y9_EE4BEG[7] Tile_X0Y9_EE4BEG[8] Tile_X0Y9_EE4BEG[9] Tile_X0Y9_FrameData[0]
+ Tile_X0Y9_FrameData[10] Tile_X0Y9_FrameData[11] Tile_X0Y9_FrameData[12] Tile_X0Y9_FrameData[13]
+ Tile_X0Y9_FrameData[14] Tile_X0Y9_FrameData[15] Tile_X0Y9_FrameData[16] Tile_X0Y9_FrameData[17]
+ Tile_X0Y9_FrameData[18] Tile_X0Y9_FrameData[19] Tile_X0Y9_FrameData[1] Tile_X0Y9_FrameData[20]
+ Tile_X0Y9_FrameData[21] Tile_X0Y9_FrameData[22] Tile_X0Y9_FrameData[23] Tile_X0Y9_FrameData[24]
+ Tile_X0Y9_FrameData[25] Tile_X0Y9_FrameData[26] Tile_X0Y9_FrameData[27] Tile_X0Y9_FrameData[28]
+ Tile_X0Y9_FrameData[29] Tile_X0Y9_FrameData[2] Tile_X0Y9_FrameData[30] Tile_X0Y9_FrameData[31]
+ Tile_X0Y9_FrameData[3] Tile_X0Y9_FrameData[4] Tile_X0Y9_FrameData[5] Tile_X0Y9_FrameData[6]
+ Tile_X0Y9_FrameData[7] Tile_X0Y9_FrameData[8] Tile_X0Y9_FrameData[9] Tile_X0Y9_FrameData_O[0]
+ Tile_X0Y9_FrameData_O[10] Tile_X0Y9_FrameData_O[11] Tile_X0Y9_FrameData_O[12] Tile_X0Y9_FrameData_O[13]
+ Tile_X0Y9_FrameData_O[14] Tile_X0Y9_FrameData_O[15] Tile_X0Y9_FrameData_O[16] Tile_X0Y9_FrameData_O[17]
+ Tile_X0Y9_FrameData_O[18] Tile_X0Y9_FrameData_O[19] Tile_X0Y9_FrameData_O[1] Tile_X0Y9_FrameData_O[20]
+ Tile_X0Y9_FrameData_O[21] Tile_X0Y9_FrameData_O[22] Tile_X0Y9_FrameData_O[23] Tile_X0Y9_FrameData_O[24]
+ Tile_X0Y9_FrameData_O[25] Tile_X0Y9_FrameData_O[26] Tile_X0Y9_FrameData_O[27] Tile_X0Y9_FrameData_O[28]
+ Tile_X0Y9_FrameData_O[29] Tile_X0Y9_FrameData_O[2] Tile_X0Y9_FrameData_O[30] Tile_X0Y9_FrameData_O[31]
+ Tile_X0Y9_FrameData_O[3] Tile_X0Y9_FrameData_O[4] Tile_X0Y9_FrameData_O[5] Tile_X0Y9_FrameData_O[6]
+ Tile_X0Y9_FrameData_O[7] Tile_X0Y9_FrameData_O[8] Tile_X0Y9_FrameData_O[9] Tile_X0Y9_FrameStrobe[0]
+ Tile_X0Y9_FrameStrobe[10] Tile_X0Y9_FrameStrobe[11] Tile_X0Y9_FrameStrobe[12] Tile_X0Y9_FrameStrobe[13]
+ Tile_X0Y9_FrameStrobe[14] Tile_X0Y9_FrameStrobe[15] Tile_X0Y9_FrameStrobe[16] Tile_X0Y9_FrameStrobe[17]
+ Tile_X0Y9_FrameStrobe[18] Tile_X0Y9_FrameStrobe[19] Tile_X0Y9_FrameStrobe[1] Tile_X0Y9_FrameStrobe[2]
+ Tile_X0Y9_FrameStrobe[3] Tile_X0Y9_FrameStrobe[4] Tile_X0Y9_FrameStrobe[5] Tile_X0Y9_FrameStrobe[6]
+ Tile_X0Y9_FrameStrobe[7] Tile_X0Y9_FrameStrobe[8] Tile_X0Y9_FrameStrobe[9] Tile_X0Y9_N1END[0]
+ Tile_X0Y9_N1END[1] Tile_X0Y9_N1END[2] Tile_X0Y9_N1END[3] Tile_X0Y9_N2END[0] Tile_X0Y9_N2END[1]
+ Tile_X0Y9_N2END[2] Tile_X0Y9_N2END[3] Tile_X0Y9_N2END[4] Tile_X0Y9_N2END[5] Tile_X0Y9_N2END[6]
+ Tile_X0Y9_N2END[7] Tile_X0Y9_N2MID[0] Tile_X0Y9_N2MID[1] Tile_X0Y9_N2MID[2] Tile_X0Y9_N2MID[3]
+ Tile_X0Y9_N2MID[4] Tile_X0Y9_N2MID[5] Tile_X0Y9_N2MID[6] Tile_X0Y9_N2MID[7] Tile_X0Y9_N4END[0]
+ Tile_X0Y9_N4END[10] Tile_X0Y9_N4END[11] Tile_X0Y9_N4END[12] Tile_X0Y9_N4END[13]
+ Tile_X0Y9_N4END[14] Tile_X0Y9_N4END[15] Tile_X0Y9_N4END[1] Tile_X0Y9_N4END[2] Tile_X0Y9_N4END[3]
+ Tile_X0Y9_N4END[4] Tile_X0Y9_N4END[5] Tile_X0Y9_N4END[6] Tile_X0Y9_N4END[7] Tile_X0Y9_N4END[8]
+ Tile_X0Y9_N4END[9] Tile_X0Y9_S1BEG[0] Tile_X0Y9_S1BEG[1] Tile_X0Y9_S1BEG[2] Tile_X0Y9_S1BEG[3]
+ Tile_X0Y9_S2BEG[0] Tile_X0Y9_S2BEG[1] Tile_X0Y9_S2BEG[2] Tile_X0Y9_S2BEG[3] Tile_X0Y9_S2BEG[4]
+ Tile_X0Y9_S2BEG[5] Tile_X0Y9_S2BEG[6] Tile_X0Y9_S2BEG[7] Tile_X0Y9_S2BEGb[0] Tile_X0Y9_S2BEGb[1]
+ Tile_X0Y9_S2BEGb[2] Tile_X0Y9_S2BEGb[3] Tile_X0Y9_S2BEGb[4] Tile_X0Y9_S2BEGb[5]
+ Tile_X0Y9_S2BEGb[6] Tile_X0Y9_S2BEGb[7] Tile_X0Y9_S4BEG[0] Tile_X0Y9_S4BEG[10] Tile_X0Y9_S4BEG[11]
+ Tile_X0Y9_S4BEG[12] Tile_X0Y9_S4BEG[13] Tile_X0Y9_S4BEG[14] Tile_X0Y9_S4BEG[15]
+ Tile_X0Y9_S4BEG[1] Tile_X0Y9_S4BEG[2] Tile_X0Y9_S4BEG[3] Tile_X0Y9_S4BEG[4] Tile_X0Y9_S4BEG[5]
+ Tile_X0Y9_S4BEG[6] Tile_X0Y9_S4BEG[7] Tile_X0Y9_S4BEG[8] Tile_X0Y9_S4BEG[9] Tile_X0Y9_UserCLK
+ Tile_X0Y9_UserCLKo Tile_X0Y9_W1END[0] Tile_X0Y9_W1END[1] Tile_X0Y9_W1END[2] Tile_X0Y9_W1END[3]
+ Tile_X0Y9_W2END[0] Tile_X0Y9_W2END[1] Tile_X0Y9_W2END[2] Tile_X0Y9_W2END[3] Tile_X0Y9_W2END[4]
+ Tile_X0Y9_W2END[5] Tile_X0Y9_W2END[6] Tile_X0Y9_W2END[7] Tile_X0Y9_W2MID[0] Tile_X0Y9_W2MID[1]
+ Tile_X0Y9_W2MID[2] Tile_X0Y9_W2MID[3] Tile_X0Y9_W2MID[4] Tile_X0Y9_W2MID[5] Tile_X0Y9_W2MID[6]
+ Tile_X0Y9_W2MID[7] Tile_X0Y9_W6END[0] Tile_X0Y9_W6END[10] Tile_X0Y9_W6END[11] Tile_X0Y9_W6END[1]
+ Tile_X0Y9_W6END[2] Tile_X0Y9_W6END[3] Tile_X0Y9_W6END[4] Tile_X0Y9_W6END[5] Tile_X0Y9_W6END[6]
+ Tile_X0Y9_W6END[7] Tile_X0Y9_W6END[8] Tile_X0Y9_W6END[9] Tile_X0Y9_WW4END[0] Tile_X0Y9_WW4END[10]
+ Tile_X0Y9_WW4END[11] Tile_X0Y9_WW4END[12] Tile_X0Y9_WW4END[13] Tile_X0Y9_WW4END[14]
+ Tile_X0Y9_WW4END[15] Tile_X0Y9_WW4END[1] Tile_X0Y9_WW4END[2] Tile_X0Y9_WW4END[3]
+ Tile_X0Y9_WW4END[4] Tile_X0Y9_WW4END[5] Tile_X0Y9_WW4END[6] Tile_X0Y9_WW4END[7]
+ Tile_X0Y9_WW4END[8] Tile_X0Y9_WW4END[9] VGND VPWR
XFILLER_100_127 VPWR VGND sg13cmos5l_decap_8
XFILLER_636_158 VPWR VGND sg13cmos5l_fill_1
XFILLER_651_70 VPWR VGND sg13cmos5l_decap_8
XFILLER_223_43 VPWR VGND sg13cmos5l_decap_8
XFILLER_223_54 VPWR VGND sg13cmos5l_fill_1
X_0367_ _0367_/Q Tile_X0Y7_FrameData[16] VGND VPWR Tile_X0Y9_FrameStrobe[6] latch
X_3155_ Tile_X0Y7_FrameData_O[25] Tile_X0Y7_FrameData[25] VPWR VGND sg13cmos5l_buf_1
XFILLER_54_203 VPWR VGND sg13cmos5l_decap_8
X_2106_ _2106_/Q Tile_X0Y4_FrameData[11] VGND VPWR Tile_X0Y9_FrameStrobe[5] latch
X_3086_ Tile_X0Y7_E2BEG[0] _4612_/X VPWR VGND sg13cmos5l_buf_1
XFILLER_299_14 VPWR VGND sg13cmos5l_decap_8
X_0298_ _0298_/Q Tile_X0Y7_FrameData[21] VGND VPWR Tile_X0Y9_FrameStrobe[4] latch
XFILLER_54_258 VPWR VGND sg13cmos5l_fill_2
X_2037_ _2037_/Q Tile_X0Y4_FrameData[16] VGND VPWR Tile_X0Y9_FrameStrobe[3] latch
XFILLER_403_139 VPWR VGND sg13cmos5l_decap_4
XFILLER_449_28 VPWR VGND sg13cmos5l_decap_8
XFILLER_52_18 VPWR VGND sg13cmos5l_fill_2
XFILLER_596_56 VPWR VGND sg13cmos5l_decap_8
XFILLER_379_91 VPWR VGND sg13cmos5l_decap_8
XANTENNA__2742__X Tile_X0Y3_FrameData_O[0] VPWR VGND sg13cmos5l_antennanp
XFILLER_167_105 VPWR VGND sg13cmos5l_decap_8
XFILLER_22_144 VPWR VGND sg13cmos5l_fill_1
XFILLER_557_154 VPWR VGND sg13cmos5l_fill_1
XFILLER_411_183 VPWR VGND sg13cmos5l_fill_2
X_3988_ _3988_/X _3902_/X _4035_/X _4034_/X Tile_X0Y0_S2MID[7] _1187_/Q _1186_/Q VPWR
+ VGND sg13cmos5l_mux4_1
XFILLER_356_238 VPWR VGND sg13cmos5l_decap_8
XFILLER_22_188 VPWR VGND sg13cmos5l_fill_1
X_2939_ Tile_X0Y8_E6BEG[7] _4767_/X VPWR VGND sg13cmos5l_buf_1
XFILLER_572_168 VPWR VGND sg13cmos5l_decap_8
XFILLER_714_140 VPWR VGND sg13cmos5l_decap_8
XFILLER_513_202 VPWR VGND sg13cmos5l_fill_2
XFILLER_465_49 VPWR VGND sg13cmos5l_decap_8
XFILLER_364_271 VPWR VGND sg13cmos5l_fill_2
XFILLER_248_84 VPWR VGND sg13cmos5l_decap_8
XFILLER_190_130 VPWR VGND sg13cmos5l_fill_1
X_4609_ _4609_/X _4663_/X _4662_/X AXI_M_SOC_RDATA18 AXI_M_SOC_RDATA22 _0341_/Q _0340_/Q
+ VPWR VGND sg13cmos5l_mux4_1
XANTENNA__3573__X Tile_X0Y9_FrameData_O[3] VPWR VGND sg13cmos5l_antennanp
XFILLER_190_152 VPWR VGND sg13cmos5l_decap_8
XFILLER_324_157 VPWR VGND sg13cmos5l_decap_8
XFILLER_513_268 VPWR VGND sg13cmos5l_decap_4
XFILLER_7_7 VPWR VGND sg13cmos5l_decap_8
XFILLER_674_209 VPWR VGND sg13cmos5l_decap_8
XFILLER_89_133 VPWR VGND sg13cmos5l_decap_8
XFILLER_77_15 VPWR VGND sg13cmos5l_decap_8
XFILLER_396_7 VPWR VGND sg13cmos5l_decap_8
XFILLER_277_234 VPWR VGND sg13cmos5l_decap_8
XFILLER_77_48 VPWR VGND sg13cmos5l_decap_8
XFILLER_682_220 VPWR VGND sg13cmos5l_decap_8
XFILLER_414_42 VPWR VGND sg13cmos5l_decap_8
XFILLER_561_70 VPWR VGND sg13cmos5l_decap_8
XFILLER_133_21 VPWR VGND sg13cmos5l_decap_8
XFILLER_493_175 VPWR VGND sg13cmos5l_decap_8
XFILLER_419_272 VPWR VGND sg13cmos5l_fill_1
XANTENNA__2917__X Tile_X0Y8_E2BEG[1] VPWR VGND sg13cmos5l_antennanp
XFILLER_563_7 VPWR VGND sg13cmos5l_decap_8
XFILLER_93_14 VPWR VGND sg13cmos5l_decap_8
XFILLER_133_98 VPWR VGND sg13cmos5l_decap_8
XFILLER_711_84 VPWR VGND sg13cmos5l_decap_8
XANTENNA_202 Tile_X0Y9_N2MID[5] VPWR VGND sg13cmos5l_antennanp
XFILLER_93_58 VPWR VGND sg13cmos5l_decap_4
XANTENNA_213 Tile_X0Y9_N4END[14] VPWR VGND sg13cmos5l_antennanp
XFILLER_650_161 VPWR VGND sg13cmos5l_decap_8
XFILLER_45_258 VPWR VGND sg13cmos5l_decap_8
XANTENNA_224 Tile_X0Y9_N4END[14] VPWR VGND sg13cmos5l_antennanp
XFILLER_430_63 VPWR VGND sg13cmos5l_decap_8
XANTENNA_235 Tile_X0Y0_FrameData[6] VPWR VGND sg13cmos5l_antennanp
XFILLER_26_63 VPWR VGND sg13cmos5l_decap_8
XFILLER_260_145 VPWR VGND sg13cmos5l_decap_8
XFILLER_60_217 VPWR VGND sg13cmos5l_decap_8
XFILLER_595_238 VPWR VGND sg13cmos5l_decap_8
XFILLER_548_121 VPWR VGND sg13cmos5l_decap_8
XFILLER_359_28 VPWR VGND sg13cmos5l_decap_8
XANTENNA__3748__X AXI_M_SOC_ARADDR20 VPWR VGND sg13cmos5l_antennanp
XFILLER_13_144 VPWR VGND sg13cmos5l_decap_8
XFILLER_158_138 VPWR VGND sg13cmos5l_decap_8
XFILLER_201_256 VPWR VGND sg13cmos5l_fill_2
XFILLER_220_0 VPWR VGND sg13cmos5l_decap_8
XFILLER_362_219 VPWR VGND sg13cmos5l_decap_8
XFILLER_318_0 VPWR VGND sg13cmos5l_decap_4
XFILLER_42_95 VPWR VGND sg13cmos5l_decap_4
XFILLER_166_171 VPWR VGND sg13cmos5l_decap_8
XFILLER_705_162 VPWR VGND sg13cmos5l_fill_2
XFILLER_504_202 VPWR VGND sg13cmos5l_decap_8
XFILLER_308_21 VPWR VGND sg13cmos5l_decap_8
XFILLER_672_14 VPWR VGND sg13cmos5l_decap_8
XANTENNA__3483__X Tile_X0Y1_EE4BEG[9] VPWR VGND sg13cmos5l_antennanp
XFILLER_504_268 VPWR VGND sg13cmos5l_decap_4
XFILLER_370_263 VPWR VGND sg13cmos5l_decap_8
XFILLER_181_185 VPWR VGND sg13cmos5l_decap_8
XFILLER_47_8 VPWR VGND sg13cmos5l_decap_8
XFILLER_330_127 VPWR VGND sg13cmos5l_decap_8
XFILLER_469_150 VPWR VGND sg13cmos5l_decap_8
XFILLER_687_0 VPWR VGND sg13cmos5l_decap_8
XFILLER_174_83 VPWR VGND sg13cmos5l_decap_8
XFILLER_122_263 VPWR VGND sg13cmos5l_decap_8
XFILLER_469_194 VPWR VGND sg13cmos5l_decap_8
XFILLER_618_147 VPWR VGND sg13cmos5l_decap_8
XFILLER_3_56 VPWR VGND sg13cmos5l_decap_8
X_1270_ _1270_/Q Tile_X0Y1_FrameData[3] VGND VPWR Tile_X0Y9_FrameStrobe[2] latch
XFILLER_324_53 VPWR VGND sg13cmos5l_fill_2
XFILLER_417_209 VPWR VGND sg13cmos5l_decap_8
XFILLER_95_147 VPWR VGND sg13cmos5l_decap_8
X_0221_ _0221_/Q Tile_X0Y7_FrameData[2] VGND VPWR Tile_X0Y9_FrameStrobe[1] latch
XFILLER_67_70 VPWR VGND sg13cmos5l_decap_8
XANTENNA__2827__X Tile_X0Y4_E2BEG[5] VPWR VGND sg13cmos5l_antennanp
XFILLER_425_231 VPWR VGND sg13cmos5l_decap_8
XFILLER_36_214 VPWR VGND sg13cmos5l_decap_8
XFILLER_190_93 VPWR VGND sg13cmos5l_decap_8
X_0152_ _0152_/X _4560_/X _4561_/X _1611_/Q VPWR VGND sg13cmos5l_mux2_1
XFILLER_621_84 VPWR VGND sg13cmos5l_decap_8
XFILLER_425_264 VPWR VGND sg13cmos5l_fill_1
XFILLER_641_161 VPWR VGND sg13cmos5l_decap_8
X_0083_ _0083_/X _4908_/X _4909_/X _2377_/Q VPWR VGND sg13cmos5l_mux2_1
XFILLER_51_228 VPWR VGND sg13cmos5l_decap_8
XFILLER_397_149 VPWR VGND sg13cmos5l_decap_8
XFILLER_251_156 VPWR VGND sg13cmos5l_decap_8
X_3911_ _3911_/X _4012_/X _4016_/X _4005_/X _3989_/X _1401_/Q _1400_/Q VPWR VGND sg13cmos5l_mux4_1
XFILLER_697_77 VPWR VGND sg13cmos5l_decap_8
XFILLER_697_88 VPWR VGND sg13cmos5l_fill_2
XFILLER_269_28 VPWR VGND sg13cmos5l_decap_8
X_4891_ _4891_/X AXI_M_SOC_RDATA7 _4916_/X _4920_/X _4900_/X _0761_/Q _0760_/Q VPWR
+ VGND sg13cmos5l_mux4_1
XANTENNA__3658__X AXI_M_SOC_AWADDR19 VPWR VGND sg13cmos5l_antennanp
XFILLER_199_91 VPWR VGND sg13cmos5l_fill_2
X_3842_ _3842_/X Tile_X0Y0_W6END[9] _3886_/X _3872_/X _3857_/X _1021_/Q _1020_/Q VPWR
+ VGND sg13cmos5l_mux4_1
XFILLER_594_271 VPWR VGND sg13cmos5l_fill_2
XFILLER_539_176 VPWR VGND sg13cmos5l_decap_8
X_3773_ _3773_/X Tile_X0Y0_WW4END[2] Tile_X0Y0_WW4END[10] Tile_X0Y0_W6END[2] _3883_/X
+ _1005_/Q _1004_/Q VPWR VGND sg13cmos5l_mux4_1
X_0985_ _0985_/Q Tile_X0Y0_FrameData[18] VGND VPWR Tile_X0Y9_FrameStrobe[1] latch
XFILLER_157_171 VPWR VGND sg13cmos5l_decap_8
X_2724_ _4658_/A3 VPWR VGND sg13cmos5l_tielo
XFILLER_306_102 VPWR VGND sg13cmos5l_decap_8
XFILLER_716_29 VPWR VGND sg13cmos5l_decap_8
XFILLER_346_271 VPWR VGND sg13cmos5l_fill_2
XFILLER_285_49 VPWR VGND sg13cmos5l_decap_8
XFILLER_646_70 VPWR VGND sg13cmos5l_decap_8
XFILLER_218_21 VPWR VGND sg13cmos5l_decap_8
XFILLER_66_0 VPWR VGND sg13cmos5l_decap_8
XFILLER_306_124 VPWR VGND sg13cmos5l_decap_8
XFILLER_582_14 VPWR VGND sg13cmos5l_decap_8
X_2655_ _2655_/Q Tile_X0Y6_FrameData[8] VGND VPWR Tile_X0Y9_FrameStrobe[6] latch
XANTENNA__3393__X Tile_X0Y2_E2BEGb[4] VPWR VGND sg13cmos5l_antennanp
XFILLER_218_76 VPWR VGND sg13cmos5l_decap_8
X_1606_ _1606_/Q Tile_X0Y2_FrameData[11] VGND VPWR Tile_X0Y9_FrameStrobe[5] latch
XFILLER_510_205 VPWR VGND sg13cmos5l_fill_1
X_2586_ _2586_/Q Tile_X0Y6_FrameData[13] VGND VPWR Tile_X0Y9_FrameStrobe[4] latch
XFILLER_510_227 VPWR VGND sg13cmos5l_decap_8
XFILLER_113_230 VPWR VGND sg13cmos5l_decap_8
XFILLER_649_261 VPWR VGND sg13cmos5l_decap_4
X_4325_ _4325_/X _3886_/X _3872_/X _3871_/X _3856_/X _1114_/Q _1113_/Q VPWR VGND sg13cmos5l_mux4_1
XFILLER_649_272 VPWR VGND sg13cmos5l_fill_1
XFILLER_609_103 VPWR VGND sg13cmos5l_decap_8
X_1537_ _1537_/Q Tile_X0Y2_FrameData[16] VGND VPWR Tile_X0Y9_FrameStrobe[3] latch
XFILLER_515_63 VPWR VGND sg13cmos5l_decap_8
XFILLER_662_91 VPWR VGND sg13cmos5l_decap_8
XFILLER_234_42 VPWR VGND sg13cmos5l_decap_8
XFILLER_609_147 VPWR VGND sg13cmos5l_decap_8
X_4256_ _4256_/X Tile_X0Y4_W2MID[7] AXI_M_SOC_BRESP0 _4313_/X _4312_/X _2101_/Q _2100_/Q
+ VPWR VGND sg13cmos5l_mux4_1
X_1468_ _1468_/Q Tile_X0Y2_FrameData[21] VGND VPWR Tile_X0Y9_FrameStrobe[1] latch
XFILLER_86_147 VPWR VGND sg13cmos5l_decap_8
XFILLER_381_81 VPWR VGND sg13cmos5l_decap_8
XFILLER_47_29 VPWR VGND sg13cmos5l_fill_2
XFILLER_274_226 VPWR VGND sg13cmos5l_decap_8
X_3207_ Tile_X0Y0_N2BEG[7] _3791_/X VPWR VGND sg13cmos5l_buf_1
XFILLER_490_112 VPWR VGND sg13cmos5l_decap_8
XANTENNA__2737__X Tile_X0Y4_E1BEG[0] VPWR VGND sg13cmos5l_antennanp
X_0419_ _0419_/Q Tile_X0Y8_FrameData[28] VGND VPWR Tile_X0Y9_FrameStrobe[0] latch
XFILLER_227_120 VPWR VGND sg13cmos5l_fill_2
X_1399_ _1399_/Q Tile_X0Y1_FrameData[2] VGND VPWR Tile_X0Y9_FrameStrobe[6] latch
X_4187_ _4187_/X AXI_M_SOC_BVALID _4226_/X _4230_/X _4211_/X _1767_/Q _1766_/Q VPWR
+ VGND sg13cmos5l_mux4_1
XFILLER_27_203 VPWR VGND sg13cmos5l_decap_8
X_3138_ Tile_X0Y7_FrameData_O[8] Tile_X0Y7_FrameData[8] VPWR VGND sg13cmos5l_buf_1
XFILLER_490_167 VPWR VGND sg13cmos5l_decap_4
XFILLER_103_35 VPWR VGND sg13cmos5l_decap_8
XFILLER_531_84 VPWR VGND sg13cmos5l_decap_8
XFILLER_490_178 VPWR VGND sg13cmos5l_decap_8
XFILLER_242_101 VPWR VGND sg13cmos5l_decap_8
XFILLER_227_186 VPWR VGND sg13cmos5l_decap_8
XFILLER_431_212 VPWR VGND sg13cmos5l_fill_2
XFILLER_27_269 VPWR VGND sg13cmos5l_decap_4
X_3069_ Tile_X0Y5_FrameData_O[28] Tile_X0Y5_FrameData[28] VPWR VGND sg13cmos5l_buf_1
XFILLER_63_28 VPWR VGND sg13cmos5l_decap_8
XFILLER_632_194 VPWR VGND sg13cmos5l_decap_4
XFILLER_577_227 VPWR VGND sg13cmos5l_decap_8
XFILLER_250_85 VPWR VGND sg13cmos5l_decap_8
XFILLER_42_228 VPWR VGND sg13cmos5l_decap_8
XFILLER_388_138 VPWR VGND sg13cmos5l_decap_8
XFILLER_179_28 VPWR VGND sg13cmos5l_fill_2
XFILLER_431_267 VPWR VGND sg13cmos5l_decap_4
XANTENNA__3568__X Tile_X0Y9_EE4BEG[14] VPWR VGND sg13cmos5l_antennanp
XFILLER_249_8 VPWR VGND sg13cmos5l_decap_8
XFILLER_592_219 VPWR VGND sg13cmos5l_decap_8
XFILLER_400_77 VPWR VGND sg13cmos5l_decap_8
XFILLER_144_7 VPWR VGND sg13cmos5l_decap_8
XFILLER_585_260 VPWR VGND sg13cmos5l_fill_1
XFILLER_585_271 VPWR VGND sg13cmos5l_fill_2
XFILLER_50_272 VPWR VGND sg13cmos5l_fill_1
XFILLER_195_255 VPWR VGND sg13cmos5l_decap_8
XFILLER_155_119 VPWR VGND sg13cmos5l_decap_8
XFILLER_12_21 VPWR VGND sg13cmos5l_decap_8
XFILLER_560_105 VPWR VGND sg13cmos5l_decap_8
XFILLER_409_42 VPWR VGND sg13cmos5l_decap_8
XFILLER_409_7 VPWR VGND sg13cmos5l_decap_8
XFILLER_337_271 VPWR VGND sg13cmos5l_fill_2
XFILLER_128_21 VPWR VGND sg13cmos5l_decap_8
XFILLER_556_70 VPWR VGND sg13cmos5l_decap_8
XFILLER_163_130 VPWR VGND sg13cmos5l_decap_8
XFILLER_699_161 VPWR VGND sg13cmos5l_fill_2
XFILLER_492_14 VPWR VGND sg13cmos5l_decap_8
XFILLER_352_252 VPWR VGND sg13cmos5l_decap_4
XFILLER_88_14 VPWR VGND sg13cmos5l_decap_8
XFILLER_702_143 VPWR VGND sg13cmos5l_fill_2
XFILLER_498_245 VPWR VGND sg13cmos5l_decap_4
XFILLER_498_256 VPWR VGND sg13cmos5l_fill_2
XFILLER_706_84 VPWR VGND sg13cmos5l_decap_8
XFILLER_501_238 VPWR VGND sg13cmos5l_decap_8
XFILLER_312_149 VPWR VGND sg13cmos5l_decap_8
XFILLER_680_7 VPWR VGND sg13cmos5l_decap_8
XFILLER_104_241 VPWR VGND sg13cmos5l_decap_8
XFILLER_642_28 VPWR VGND sg13cmos5l_decap_8
XFILLER_425_63 VPWR VGND sg13cmos5l_decap_8
XFILLER_394_4 VPWR VGND sg13cmos5l_fill_1
XFILLER_144_42 VPWR VGND sg13cmos5l_decap_8
XFILLER_655_231 VPWR VGND sg13cmos5l_fill_1
XFILLER_572_91 VPWR VGND sg13cmos5l_decap_8
XFILLER_466_131 VPWR VGND sg13cmos5l_decap_8
XFILLER_655_253 VPWR VGND sg13cmos5l_decap_4
XFILLER_77_147 VPWR VGND sg13cmos5l_decap_8
XFILLER_320_182 VPWR VGND sg13cmos5l_decap_8
XFILLER_265_215 VPWR VGND sg13cmos5l_decap_4
XFILLER_320_193 VPWR VGND sg13cmos5l_fill_1
XFILLER_92_117 VPWR VGND sg13cmos5l_fill_2
XFILLER_608_191 VPWR VGND sg13cmos5l_fill_2
XFILLER_280_218 VPWR VGND sg13cmos5l_fill_1
XFILLER_170_0 VPWR VGND sg13cmos5l_decap_8
XFILLER_85_191 VPWR VGND sg13cmos5l_decap_8
XFILLER_37_73 VPWR VGND sg13cmos5l_decap_4
XFILLER_280_229 VPWR VGND sg13cmos5l_fill_2
XFILLER_218_186 VPWR VGND sg13cmos5l_fill_1
XFILLER_422_201 VPWR VGND sg13cmos5l_decap_8
XFILLER_379_105 VPWR VGND sg13cmos5l_decap_8
XFILLER_268_0 VPWR VGND sg13cmos5l_decap_8
XFILLER_160_63 VPWR VGND sg13cmos5l_decap_8
XFILLER_623_183 VPWR VGND sg13cmos5l_decap_8
XFILLER_568_238 VPWR VGND sg13cmos5l_decap_4
XFILLER_233_156 VPWR VGND sg13cmos5l_fill_2
XFILLER_33_228 VPWR VGND sg13cmos5l_decap_8
XFILLER_667_14 VPWR VGND sg13cmos5l_decap_8
XFILLER_310_55 VPWR VGND sg13cmos5l_decap_4
XANTENNA__3478__X Tile_X0Y1_EE4BEG[4] VPWR VGND sg13cmos5l_antennanp
XFILLER_435_0 VPWR VGND sg13cmos5l_decap_8
XFILLER_186_200 VPWR VGND sg13cmos5l_decap_4
XFILLER_186_211 VPWR VGND sg13cmos5l_decap_8
XFILLER_536_113 VPWR VGND sg13cmos5l_decap_8
XFILLER_41_272 VPWR VGND sg13cmos5l_fill_1
XFILLER_602_0 VPWR VGND sg13cmos5l_decap_8
XFILLER_146_108 VPWR VGND sg13cmos5l_decap_8
XFILLER_146_119 VPWR VGND sg13cmos5l_fill_2
XFILLER_319_53 VPWR VGND sg13cmos5l_decap_8
XFILLER_139_182 VPWR VGND sg13cmos5l_decap_8
X_0770_ _0770_/Q Tile_X0Y9_FrameData[29] VGND VPWR Tile_X0Y9_FrameStrobe[3] latch
XFILLER_683_35 VPWR VGND sg13cmos5l_decap_8
XFILLER_466_70 VPWR VGND sg13cmos5l_decap_8
XFILLER_683_57 VPWR VGND sg13cmos5l_decap_8
XFILLER_551_149 VPWR VGND sg13cmos5l_fill_1
XFILLER_154_174 VPWR VGND sg13cmos5l_decap_8
X_2440_ _2440_/Q Tile_X0Y5_FrameData[31] VGND VPWR Tile_X0Y9_FrameStrobe[0] latch
XFILLER_616_84 VPWR VGND sg13cmos5l_decap_8
XFILLER_552_28 VPWR VGND sg13cmos5l_decap_8
XFILLER_335_63 VPWR VGND sg13cmos5l_decap_8
X_2371_ _2371_/Q Tile_X0Y5_FrameData[2] VGND VPWR Tile_X0Y9_FrameStrobe[5] latch
XFILLER_646_231 VPWR VGND sg13cmos5l_decap_8
X_4110_ _4110_/X _4091_/X _0064_/X _4090_/X Tile_X0Y0_S4END[9] _1455_/Q _1454_/Q VPWR
+ VGND sg13cmos5l_mux4_1
X_1322_ _1322_/Q Tile_X0Y1_FrameData[15] VGND VPWR Tile_X0Y9_FrameStrobe[4] latch
XFILLER_78_91 VPWR VGND sg13cmos5l_decap_8
XFILLER_256_204 VPWR VGND sg13cmos5l_decap_8
XFILLER_68_147 VPWR VGND sg13cmos5l_decap_8
XFILLER_606_106 VPWR VGND sg13cmos5l_fill_2
X_1253_ _1253_/Q Tile_X0Y1_FrameData[20] VGND VPWR Tile_X0Y9_FrameStrobe[2] latch
X_4041_ _4041_/X Tile_X0Y2_W2MID[6] AXI_M_SOC_AWREADY _4099_/X _4098_/X _1591_/Q _1590_/Q
+ VPWR VGND sg13cmos5l_mux4_1
XFILLER_204_56 VPWR VGND sg13cmos5l_decap_8
XFILLER_209_142 VPWR VGND sg13cmos5l_decap_8
X_0204_ _0204_/Q Tile_X0Y7_FrameData[19] VGND VPWR Tile_X0Y9_FrameStrobe[1] latch
X_1184_ _1184_/Q Tile_X0Y1_FrameData[25] VGND VPWR Tile_X0Y9_FrameStrobe[0] latch
XFILLER_351_84 VPWR VGND sg13cmos5l_decap_8
XFILLER_271_218 VPWR VGND sg13cmos5l_decap_8
XFILLER_501_21 VPWR VGND sg13cmos5l_decap_8
XFILLER_614_161 VPWR VGND sg13cmos5l_decap_8
X_0135_ AXI_M_SOC_AWLEN5 _0940_/Q _3676_/X VPWR VGND sg13cmos5l_nor2b_1
XFILLER_224_145 VPWR VGND sg13cmos5l_decap_8
XFILLER_24_217 VPWR VGND sg13cmos5l_decap_8
XFILLER_24_228 VPWR VGND sg13cmos5l_fill_1
XFILLER_91_194 VPWR VGND sg13cmos5l_decap_4
X_0066_ _3635_/A _4838_/X _4839_/X _0862_/Q VPWR VGND sg13cmos5l_mux2_1
XFILLER_501_98 VPWR VGND sg13cmos5l_decap_8
XFILLER_577_14 VPWR VGND sg13cmos5l_decap_8
XANTENNA__3388__X Tile_X0Y2_E6BEG[11] VPWR VGND sg13cmos5l_antennanp
XFILLER_220_88 VPWR VGND sg13cmos5l_decap_8
X_4874_ _4874_/X Tile_X0Y9_WW4END[5] AXI_M_SOC_RDATA5 _4921_/X _4904_/X _0795_/Q _0794_/Q
+ VPWR VGND sg13cmos5l_mux4_1
XFILLER_567_271 VPWR VGND sg13cmos5l_fill_2
XFILLER_716_224 VPWR VGND sg13cmos5l_decap_4
X_3825_ _3825_/X Tile_X0Y0_WW4END[10] Tile_X0Y0_WW4END[15] _3868_/X _3857_/X _1055_/Q
+ _1054_/Q VPWR VGND sg13cmos5l_mux4_1
XFILLER_137_119 VPWR VGND sg13cmos5l_decap_8
XFILLER_527_168 VPWR VGND sg13cmos5l_decap_8
XFILLER_229_42 VPWR VGND sg13cmos5l_decap_8
XFILLER_716_268 VPWR VGND sg13cmos5l_decap_4
XFILLER_542_105 VPWR VGND sg13cmos5l_decap_8
X_3756_ AXI_M_SOC_ARADDR28 Tile_X0Y8_W1END[0] Tile_X0Y8_WW4END[4] Tile_X0Y8_WW4END[12]
+ _4812_/X _0479_/Q _0478_/Q VPWR VGND sg13cmos5l_mux4_1
XFILLER_446_29 VPWR VGND sg13cmos5l_decap_8
X_0968_ _0968_/Q Tile_X0Y0_FrameData[3] VGND VPWR Tile_X0Y9_FrameStrobe[0] latch
XFILLER_593_35 VPWR VGND sg13cmos5l_decap_8
XFILLER_393_196 VPWR VGND sg13cmos5l_fill_2
XFILLER_376_70 VPWR VGND sg13cmos5l_decap_8
X_2707_ _4306_/A3 VPWR VGND sg13cmos5l_tielo
X_3687_ _3687_/X Tile_X0Y3_WW4END[5] Tile_X0Y3_WW4END[13] Tile_X0Y3_W6END[5] _4227_/X
+ _1747_/Q _1746_/Q VPWR VGND sg13cmos5l_mux4_1
XFILLER_145_163 VPWR VGND sg13cmos5l_decap_8
X_0899_ _0899_/Q Tile_X0Y9_FrameData[28] VGND VPWR Tile_X0Y9_FrameStrobe[7] latch
X_2638_ _2638_/Q Tile_X0Y6_FrameData[25] VGND VPWR Tile_X0Y9_FrameStrobe[6] latch
XFILLER_526_84 VPWR VGND sg13cmos5l_fill_1
XFILLER_160_133 VPWR VGND sg13cmos5l_decap_8
XFILLER_673_90 VPWR VGND sg13cmos5l_fill_2
XFILLER_550_182 VPWR VGND sg13cmos5l_fill_2
XFILLER_495_237 VPWR VGND sg13cmos5l_decap_8
XFILLER_462_28 VPWR VGND sg13cmos5l_decap_8
XFILLER_696_197 VPWR VGND sg13cmos5l_decap_8
XFILLER_58_17 VPWR VGND sg13cmos5l_fill_2
XFILLER_245_63 VPWR VGND sg13cmos5l_decap_4
X_2569_ _2569_/Q Tile_X0Y6_FrameData[30] VGND VPWR Tile_X0Y9_FrameStrobe[4] latch
XFILLER_637_220 VPWR VGND sg13cmos5l_fill_2
XFILLER_101_200 VPWR VGND sg13cmos5l_decap_8
XFILLER_245_96 VPWR VGND sg13cmos5l_decap_8
XFILLER_101_211 VPWR VGND sg13cmos5l_fill_1
X_4308_ _4308_/X Tile_X0Y5_W1END[2] Tile_X0Y5_W6END[6] _4465_/X _4422_/X _2435_/Q
+ _2434_/Q VPWR VGND sg13cmos5l_mux4_1
XFILLER_247_204 VPWR VGND sg13cmos5l_decap_8
XFILLER_101_233 VPWR VGND sg13cmos5l_decap_8
XFILLER_101_244 VPWR VGND sg13cmos5l_fill_2
XFILLER_652_201 VPWR VGND sg13cmos5l_decap_4
XFILLER_59_158 VPWR VGND sg13cmos5l_decap_8
XFILLER_652_212 VPWR VGND sg13cmos5l_decap_8
X_4239_ _4239_/X Tile_X0Y5_W2MID[6] Tile_X0Y5_W2END[6] Tile_X0Y5_W6END[6] _4430_/X
+ _2429_/Q _2428_/Q VPWR VGND sg13cmos5l_mux4_1
XFILLER_652_223 VPWR VGND sg13cmos5l_fill_1
XFILLER_74_106 VPWR VGND sg13cmos5l_decap_8
XFILLER_114_56 VPWR VGND sg13cmos5l_decap_8
XFILLER_652_256 VPWR VGND sg13cmos5l_fill_1
XFILLER_114_78 VPWR VGND sg13cmos5l_decap_8
XFILLER_261_84 VPWR VGND sg13cmos5l_decap_8
XFILLER_411_21 VPWR VGND sg13cmos5l_decap_8
XFILLER_366_8 VPWR VGND sg13cmos5l_decap_8
XFILLER_261_95 VPWR VGND sg13cmos5l_fill_1
XFILLER_255_270 VPWR VGND sg13cmos5l_fill_2
XFILLER_261_7 VPWR VGND sg13cmos5l_decap_8
XFILLER_15_206 VPWR VGND sg13cmos5l_decap_8
XFILLER_605_194 VPWR VGND sg13cmos5l_decap_8
XFILLER_359_7 VPWR VGND sg13cmos5l_decap_8
XFILLER_270_251 VPWR VGND sg13cmos5l_decap_4
XFILLER_215_167 VPWR VGND sg13cmos5l_decap_8
XFILLER_620_142 VPWR VGND sg13cmos5l_decap_4
XFILLER_620_153 VPWR VGND sg13cmos5l_decap_8
XFILLER_487_14 VPWR VGND sg13cmos5l_decap_8
XFILLER_411_98 VPWR VGND sg13cmos5l_fill_1
XFILLER_230_115 VPWR VGND sg13cmos5l_decap_8
XANTENNA__3298__X Tile_X0Y0_E2BEGb[6] VPWR VGND sg13cmos5l_antennanp
XFILLER_130_77 VPWR VGND sg13cmos5l_decap_8
XFILLER_376_119 VPWR VGND sg13cmos5l_decap_8
XFILLER_526_7 VPWR VGND sg13cmos5l_decap_8
XFILLER_23_272 VPWR VGND sg13cmos5l_fill_1
XFILLER_168_244 VPWR VGND sg13cmos5l_fill_1
XFILLER_637_28 VPWR VGND sg13cmos5l_decap_8
XFILLER_384_141 VPWR VGND sg13cmos5l_decap_8
XFILLER_707_257 VPWR VGND sg13cmos5l_fill_2
XFILLER_567_91 VPWR VGND sg13cmos5l_decap_8
XANTENNA__2930__X Tile_X0Y8_E2BEGb[6] VPWR VGND sg13cmos5l_antennanp
XFILLER_139_42 VPWR VGND sg13cmos5l_decap_8
XFILLER_183_236 VPWR VGND sg13cmos5l_decap_8
XFILLER_533_116 VPWR VGND sg13cmos5l_decap_8
XFILLER_286_70 VPWR VGND sg13cmos5l_decap_8
XFILLER_99_35 VPWR VGND sg13cmos5l_decap_8
XFILLER_526_190 VPWR VGND sg13cmos5l_decap_4
XFILLER_136_163 VPWR VGND sg13cmos5l_decap_8
XFILLER_136_174 VPWR VGND sg13cmos5l_fill_2
XFILLER_687_131 VPWR VGND sg13cmos5l_fill_1
XFILLER_340_200 VPWR VGND sg13cmos5l_decap_8
XFILLER_687_153 VPWR VGND sg13cmos5l_fill_2
XFILLER_653_49 VPWR VGND sg13cmos5l_decap_8
XFILLER_436_84 VPWR VGND sg13cmos5l_decap_8
XFILLER_151_144 VPWR VGND sg13cmos5l_decap_4
XFILLER_297_126 VPWR VGND sg13cmos5l_decap_8
XFILLER_97_209 VPWR VGND sg13cmos5l_fill_1
XFILLER_155_63 VPWR VGND sg13cmos5l_decap_8
XFILLER_151_166 VPWR VGND sg13cmos5l_decap_8
XFILLER_628_264 VPWR VGND sg13cmos5l_fill_1
XFILLER_454_112 VPWR VGND sg13cmos5l_decap_8
XFILLER_385_0 VPWR VGND sg13cmos5l_decap_8
XFILLER_238_248 VPWR VGND sg13cmos5l_decap_8
XFILLER_238_259 VPWR VGND sg13cmos5l_fill_2
XFILLER_643_245 VPWR VGND sg13cmos5l_decap_8
XFILLER_602_42 VPWR VGND sg13cmos5l_decap_8
XFILLER_253_218 VPWR VGND sg13cmos5l_decap_8
XFILLER_0_35 VPWR VGND sg13cmos5l_decap_8
XFILLER_206_112 VPWR VGND sg13cmos5l_decap_4
XFILLER_552_0 VPWR VGND sg13cmos5l_decap_8
XFILLER_206_123 VPWR VGND sg13cmos5l_decap_8
XFILLER_602_97 VPWR VGND sg13cmos5l_decap_8
XFILLER_73_161 VPWR VGND sg13cmos5l_fill_2
XFILLER_678_35 VPWR VGND sg13cmos5l_decap_8
XFILLER_611_142 VPWR VGND sg13cmos5l_decap_8
XFILLER_611_153 VPWR VGND sg13cmos5l_fill_1
XFILLER_397_14 VPWR VGND sg13cmos5l_decap_8
XFILLER_611_175 VPWR VGND sg13cmos5l_decap_4
XFILLER_410_237 VPWR VGND sg13cmos5l_decap_8
X_1940_ _1940_/Q Tile_X0Y4_FrameData[17] VGND VPWR Tile_X0Y9_FrameStrobe[0] latch
XANTENNA__3001__X Tile_X0Y5_E2BEG[4] VPWR VGND sg13cmos5l_antennanp
XFILLER_547_28 VPWR VGND sg13cmos5l_decap_8
XFILLER_375_141 VPWR VGND sg13cmos5l_decap_8
XFILLER_9_77 VPWR VGND sg13cmos5l_decap_8
X_1871_ _1871_/Q Tile_X0Y3_FrameData[26] VGND VPWR Tile_X0Y9_FrameStrobe[6] latch
XFILLER_694_56 VPWR VGND sg13cmos5l_decap_8
XFILLER_509_168 VPWR VGND sg13cmos5l_decap_8
XANTENNA__2840__X Tile_X0Y6_E2BEG[5] VPWR VGND sg13cmos5l_antennanp
X_3610_ Tile_X0Y9_S2BEG[4] _4832_/X VPWR VGND sg13cmos5l_buf_1
XFILLER_509_179 VPWR VGND sg13cmos5l_fill_1
X_0822_ _0822_/Q Tile_X0Y9_FrameData[9] VGND VPWR Tile_X0Y9_FrameStrobe[4] latch
X_4590_ _4590_/X Tile_X0Y5_W2MID[4] Tile_X0Y5_W2END[4] Tile_X0Y5_W6END[11] _4434_/X
+ _2389_/Q _2388_/Q VPWR VGND sg13cmos5l_mux4_1
XFILLER_196_70 VPWR VGND sg13cmos5l_decap_8
XFILLER_127_141 VPWR VGND sg13cmos5l_decap_8
X_3541_ Tile_X0Y9_E2BEGb[7] _4863_/X VPWR VGND sg13cmos5l_buf_1
X_0753_ _0753_/Q Tile_X0Y9_FrameData[14] VGND VPWR Tile_X0Y9_FrameStrobe[2] latch
X_3472_ Tile_X0Y1_FrameData_O[30] Tile_X0Y1_FrameData[30] VPWR VGND sg13cmos5l_buf_1
XFILLER_563_49 VPWR VGND sg13cmos5l_decap_8
XFILLER_477_204 VPWR VGND sg13cmos5l_decap_8
X_0684_ _0684_/Q Tile_X0Y9_FrameData[19] VGND VPWR Tile_X0Y9_FrameStrobe[0] latch
X_2423_ _2423_/Q Tile_X0Y5_FrameData[14] VGND VPWR Tile_X0Y9_FrameStrobe[7] latch
XFILLER_282_28 VPWR VGND sg13cmos5l_decap_8
XFILLER_678_197 VPWR VGND sg13cmos5l_decap_4
XFILLER_477_248 VPWR VGND sg13cmos5l_decap_8
XFILLER_619_231 VPWR VGND sg13cmos5l_decap_8
XFILLER_142_199 VPWR VGND sg13cmos5l_decap_8
XFILLER_619_242 VPWR VGND sg13cmos5l_fill_2
X_2354_ _2354_/Q Tile_X0Y5_FrameData[19] VGND VPWR Tile_X0Y9_FrameStrobe[5] latch
XFILLER_492_229 VPWR VGND sg13cmos5l_decap_8
XFILLER_96_242 VPWR VGND sg13cmos5l_decap_8
XFILLER_29_0 VPWR VGND sg13cmos5l_decap_8
XFILLER_296_181 VPWR VGND sg13cmos5l_fill_1
XFILLER_96_264 VPWR VGND sg13cmos5l_decap_8
X_1305_ _1305_/Q Tile_X0Y1_FrameData[0] VGND VPWR Tile_X0Y9_FrameStrobe[3] latch
XFILLER_229_259 VPWR VGND sg13cmos5l_fill_2
X_2285_ _2285_/Q Tile_X0Y5_FrameData[24] VGND VPWR Tile_X0Y9_FrameStrobe[3] latch
XFILLER_512_42 VPWR VGND sg13cmos5l_decap_8
X_4024_ _4024_/X Tile_X0Y0_W2MID[5] Tile_X0Y0_W2END[5] Tile_X0Y0_W6END[10] _3857_/X
+ _1129_/Q _1128_/Q VPWR VGND sg13cmos5l_mux4_1
X_1236_ _1236_/Q Tile_X0Y1_FrameData[5] VGND VPWR Tile_X0Y9_FrameStrobe[1] latch
XFILLER_231_21 VPWR VGND sg13cmos5l_decap_8
XFILLER_460_137 VPWR VGND sg13cmos5l_decap_8
X_1167_ _1167_/Q Tile_X0Y0_FrameData[28] VGND VPWR Tile_X0Y9_FrameStrobe[7] latch
XFILLER_64_161 VPWR VGND sg13cmos5l_decap_8
XFILLER_398_222 VPWR VGND sg13cmos5l_fill_1
XFILLER_588_35 VPWR VGND sg13cmos5l_decap_8
XFILLER_231_65 VPWR VGND sg13cmos5l_fill_1
XFILLER_602_131 VPWR VGND sg13cmos5l_decap_8
XFILLER_44_19 VPWR VGND sg13cmos5l_decap_8
XFILLER_252_262 VPWR VGND sg13cmos5l_decap_8
X_0118_ AXI_M_SOC_ARBURST1 _0931_/Q _3772_/X VPWR VGND sg13cmos5l_nor2b_1
X_1098_ _1098_/Q Tile_X0Y0_FrameData[1] VGND VPWR Tile_X0Y9_FrameStrobe[4] latch
XFILLER_212_126 VPWR VGND sg13cmos5l_decap_8
XFILLER_358_119 VPWR VGND sg13cmos5l_decap_8
XFILLER_602_186 VPWR VGND sg13cmos5l_decap_8
XFILLER_100_14 VPWR VGND sg13cmos5l_decap_8
X_0049_ AXI_M_SOC_AWCACHE0 _0936_/Q _3685_/X VPWR VGND sg13cmos5l_or2_1
X_4926_ _4926_/X Tile_X0Y9_N1END[2] Tile_X0Y9_N4END[2] _4898_/X _0081_/X _0707_/Q
+ _0706_/Q VPWR VGND sg13cmos5l_mux4_1
XFILLER_457_28 VPWR VGND sg13cmos5l_decap_8
X_4857_ _4857_/X Tile_X0Y9_W2END[6] AXI_M_SOC_RDATA6 _4903_/X _4902_/X _0829_/Q _0828_/Q
+ VPWR VGND sg13cmos5l_mux4_1
XFILLER_387_80 VPWR VGND sg13cmos5l_decap_8
XFILLER_515_105 VPWR VGND sg13cmos5l_fill_2
XANTENNA__2750__X Tile_X0Y3_FrameData_O[8] VPWR VGND sg13cmos5l_antennanp
X_3808_ _3808_/X Tile_X0Y0_W2MID[3] Tile_X0Y0_WW4END[8] _3859_/X _3858_/X _1089_/Q
+ _1088_/Q VPWR VGND sg13cmos5l_mux4_1
XFILLER_381_111 VPWR VGND sg13cmos5l_decap_8
X_4788_ _4788_/X _4711_/X Tile_X0Y9_N2MID[5] _4821_/X _4710_/X _0429_/Q _0428_/Q VPWR
+ VGND sg13cmos5l_mux4_1
X_3739_ AXI_M_SOC_ARADDR11 Tile_X0Y9_WW4END[3] Tile_X0Y9_WW4END[11] Tile_X0Y9_W6END[11]
+ _4927_/X _0737_/Q _0736_/Q VPWR VGND sg13cmos5l_mux4_1
XFILLER_530_108 VPWR VGND sg13cmos5l_fill_1
XFILLER_381_177 VPWR VGND sg13cmos5l_decap_8
XFILLER_109_67 VPWR VGND sg13cmos5l_decap_8
XFILLER_107_7 VPWR VGND sg13cmos5l_decap_8
XFILLER_669_164 VPWR VGND sg13cmos5l_fill_2
XFILLER_473_49 VPWR VGND sg13cmos5l_decap_8
XFILLER_406_21 VPWR VGND sg13cmos5l_decap_8
XFILLER_279_126 VPWR VGND sg13cmos5l_decap_8
XFILLER_69_49 VPWR VGND sg13cmos5l_decap_8
XFILLER_468_237 VPWR VGND sg13cmos5l_decap_8
XFILLER_669_197 VPWR VGND sg13cmos5l_decap_8
XANTENNA__3581__X Tile_X0Y9_FrameData_O[11] VPWR VGND sg13cmos5l_antennanp
XFILLER_133_199 VPWR VGND sg13cmos5l_decap_8
XFILLER_684_178 VPWR VGND sg13cmos5l_decap_8
XFILLER_483_8 VPWR VGND sg13cmos5l_decap_8
XFILLER_483_229 VPWR VGND sg13cmos5l_fill_1
XFILLER_436_112 VPWR VGND sg13cmos5l_decap_8
XFILLER_703_63 VPWR VGND sg13cmos5l_decap_8
XFILLER_476_7 VPWR VGND sg13cmos5l_decap_8
XFILLER_422_42 VPWR VGND sg13cmos5l_decap_8
XFILLER_235_218 VPWR VGND sg13cmos5l_decap_8
XFILLER_18_42 VPWR VGND sg13cmos5l_decap_8
XFILLER_141_21 VPWR VGND sg13cmos5l_decap_8
XFILLER_597_108 VPWR VGND sg13cmos5l_fill_1
XFILLER_451_126 VPWR VGND sg13cmos5l_decap_8
XANTENNA__2925__X Tile_X0Y8_E2BEGb[1] VPWR VGND sg13cmos5l_antennanp
XFILLER_643_7 VPWR VGND sg13cmos5l_decap_8
XFILLER_389_211 VPWR VGND sg13cmos5l_decap_8
XFILLER_18_86 VPWR VGND sg13cmos5l_fill_1
XFILLER_498_35 VPWR VGND sg13cmos5l_decap_8
XFILLER_70_120 VPWR VGND sg13cmos5l_fill_2
XFILLER_349_119 VPWR VGND sg13cmos5l_decap_8
XFILLER_648_49 VPWR VGND sg13cmos5l_decap_8
XANTENNA__3756__X AXI_M_SOC_ARADDR28 VPWR VGND sg13cmos5l_antennanp
XFILLER_133_0 VPWR VGND sg13cmos5l_decap_8
XFILLER_506_105 VPWR VGND sg13cmos5l_decap_8
XFILLER_506_116 VPWR VGND sg13cmos5l_fill_1
XFILLER_372_122 VPWR VGND sg13cmos5l_decap_8
XFILLER_357_196 VPWR VGND sg13cmos5l_decap_8
XFILLER_506_149 VPWR VGND sg13cmos5l_fill_2
XFILLER_171_206 VPWR VGND sg13cmos5l_decap_8
XFILLER_300_0 VPWR VGND sg13cmos5l_decap_8
XFILLER_521_108 VPWR VGND sg13cmos5l_decap_8
XFILLER_166_62 VPWR VGND sg13cmos5l_fill_2
XFILLER_124_133 VPWR VGND sg13cmos5l_decap_8
XFILLER_316_21 VPWR VGND sg13cmos5l_decap_8
XFILLER_680_14 VPWR VGND sg13cmos5l_decap_8
XFILLER_680_25 VPWR VGND sg13cmos5l_fill_2
XANTENNA__3491__X Tile_X0Y1_E6BEG[1] VPWR VGND sg13cmos5l_antennanp
XFILLER_463_82 VPWR VGND sg13cmos5l_decap_8
XFILLER_316_87 VPWR VGND sg13cmos5l_decap_8
XFILLER_182_50 VPWR VGND sg13cmos5l_decap_4
XFILLER_680_69 VPWR VGND sg13cmos5l_decap_8
XFILLER_675_178 VPWR VGND sg13cmos5l_fill_1
XFILLER_467_270 VPWR VGND sg13cmos5l_fill_2
XFILLER_22_7 VPWR VGND sg13cmos5l_decap_8
XFILLER_427_112 VPWR VGND sg13cmos5l_decap_8
XFILLER_613_63 VPWR VGND sg13cmos5l_decap_8
XFILLER_93_201 VPWR VGND sg13cmos5l_decap_8
XFILLER_332_42 VPWR VGND sg13cmos5l_fill_2
XFILLER_226_218 VPWR VGND sg13cmos5l_decap_8
XFILLER_293_162 VPWR VGND sg13cmos5l_decap_8
X_2070_ _2070_/Q Tile_X0Y4_FrameData[15] VGND VPWR Tile_X0Y9_FrameStrobe[4] latch
XFILLER_293_173 VPWR VGND sg13cmos5l_fill_1
XFILLER_93_256 VPWR VGND sg13cmos5l_decap_8
XFILLER_427_189 VPWR VGND sg13cmos5l_decap_8
XFILLER_75_70 VPWR VGND sg13cmos5l_fill_1
XANTENNA__2835__X Tile_X0Y6_E2BEG[0] VPWR VGND sg13cmos5l_antennanp
X_1021_ _1021_/Q Tile_X0Y0_FrameData[14] VGND VPWR Tile_X0Y9_FrameStrobe[2] latch
XFILLER_75_92 VPWR VGND sg13cmos5l_decap_8
XFILLER_689_78 VPWR VGND sg13cmos5l_decap_8
XFILLER_631_248 VPWR VGND sg13cmos5l_decap_8
XFILLER_46_194 VPWR VGND sg13cmos5l_decap_8
XFILLER_201_35 VPWR VGND sg13cmos5l_decap_8
XFILLER_596_174 VPWR VGND sg13cmos5l_fill_2
XFILLER_450_192 VPWR VGND sg13cmos5l_decap_8
X_2972_ Tile_X0Y8_FrameData_O[12] Tile_X0Y8_FrameData[12] VPWR VGND sg13cmos5l_buf_1
XFILLER_61_175 VPWR VGND sg13cmos5l_decap_8
XFILLER_558_49 VPWR VGND sg13cmos5l_decap_8
X_4711_ _4711_/X Tile_X0Y9_W2MID[2] Tile_X0Y9_W2END[2] Tile_X0Y9_W6END[2] _4904_/X
+ _0909_/Q _0908_/Q VPWR VGND sg13cmos5l_mux4_1
X_1923_ _1923_/Q Tile_X0Y3_FrameData[6] VGND VPWR Tile_X0Y9_FrameStrobe[7] latch
XFILLER_277_28 VPWR VGND sg13cmos5l_decap_8
XFILLER_537_241 VPWR VGND sg13cmos5l_decap_8
XANTENNA__3666__X AXI_M_SOC_AWADDR27 VPWR VGND sg13cmos5l_antennanp
XFILLER_147_214 VPWR VGND sg13cmos5l_decap_8
XFILLER_202_192 VPWR VGND sg13cmos5l_decap_8
X_4642_ _4642_/X Tile_X0Y7_WW4END[1] AXI_M_SOC_RDATA17 _4685_/X _4671_/X _0275_/Q
+ _0274_/Q VPWR VGND sg13cmos5l_mux4_1
XFILLER_348_185 VPWR VGND sg13cmos5l_decap_8
X_1854_ _1854_/Q Tile_X0Y3_FrameData[11] VGND VPWR Tile_X0Y9_FrameStrobe[5] latch
XFILLER_363_133 VPWR VGND sg13cmos5l_decap_4
X_0805_ _0805_/Q Tile_X0Y9_FrameData[26] VGND VPWR Tile_X0Y9_FrameStrobe[4] latch
X_4573_ _4573_/X _4547_/X Tile_X0Y9_N4END[13] _4546_/X _0153_/X _2485_/Q _2484_/Q
+ VPWR VGND sg13cmos5l_mux4_1
XFILLER_552_255 VPWR VGND sg13cmos5l_decap_8
X_1785_ _1785_/Q Tile_X0Y3_FrameData[16] VGND VPWR Tile_X0Y9_FrameStrobe[3] latch
XFILLER_512_119 VPWR VGND sg13cmos5l_decap_8
XFILLER_363_188 VPWR VGND sg13cmos5l_decap_4
X_3524_ Tile_X0Y9_E1BEG[2] _4846_/X VPWR VGND sg13cmos5l_buf_1
XFILLER_507_42 VPWR VGND sg13cmos5l_decap_8
X_0736_ _0736_/Q Tile_X0Y9_FrameData[31] VGND VPWR Tile_X0Y9_FrameStrobe[2] latch
XFILLER_293_49 VPWR VGND sg13cmos5l_decap_8
XFILLER_226_21 VPWR VGND sg13cmos5l_decap_8
XFILLER_304_255 VPWR VGND sg13cmos5l_decap_8
XFILLER_115_166 VPWR VGND sg13cmos5l_fill_2
XFILLER_170_261 VPWR VGND sg13cmos5l_decap_4
X_3455_ Tile_X0Y1_FrameData_O[13] Tile_X0Y1_FrameData[13] VPWR VGND sg13cmos5l_buf_1
XFILLER_590_14 VPWR VGND sg13cmos5l_decap_8
XFILLER_170_272 VPWR VGND sg13cmos5l_fill_1
X_0667_ _0667_/Q Tile_X0Y8_FrameData[4] VGND VPWR Tile_X0Y9_FrameStrobe[7] latch
X_2406_ _2406_/Q Tile_X0Y5_FrameData[31] VGND VPWR Tile_X0Y9_FrameStrobe[7] latch
XFILLER_130_147 VPWR VGND sg13cmos5l_decap_8
X_3386_ Tile_X0Y2_E6BEG[9] _4081_/X VPWR VGND sg13cmos5l_buf_1
XFILLER_69_231 VPWR VGND sg13cmos5l_decap_8
X_0598_ _0598_/Q Tile_X0Y8_FrameData[9] VGND VPWR Tile_X0Y9_FrameStrobe[5] latch
X_2337_ _2337_/Q Tile_X0Y5_FrameData[4] VGND VPWR Tile_X0Y9_FrameStrobe[4] latch
XFILLER_523_63 VPWR VGND sg13cmos5l_decap_8
XFILLER_29_117 VPWR VGND sg13cmos5l_decap_8
XFILLER_284_140 VPWR VGND sg13cmos5l_decap_8
XFILLER_670_91 VPWR VGND sg13cmos5l_decap_8
XFILLER_29_128 VPWR VGND sg13cmos5l_fill_2
XFILLER_242_42 VPWR VGND sg13cmos5l_decap_8
XFILLER_607_267 VPWR VGND sg13cmos5l_decap_4
X_2268_ _2268_/Q Tile_X0Y5_FrameData[9] VGND VPWR Tile_X0Y9_FrameStrobe[2] latch
X_4007_ _4007_/X _4458_/X _4462_/X _4466_/X _4434_/X _2406_/Q _2405_/Q VPWR VGND sg13cmos5l_mux4_1
XFILLER_599_56 VPWR VGND sg13cmos5l_decap_8
XANTENNA__2745__X Tile_X0Y3_FrameData_O[3] VPWR VGND sg13cmos5l_antennanp
X_1219_ _1219_/Q Tile_X0Y1_FrameData[22] VGND VPWR Tile_X0Y9_FrameStrobe[1] latch
X_2199_ _2199_/Q Tile_X0Y5_FrameData[14] VGND VPWR Tile_X0Y9_FrameStrobe[0] latch
XFILLER_37_194 VPWR VGND sg13cmos5l_decap_8
XFILLER_111_35 VPWR VGND sg13cmos5l_decap_8
XFILLER_240_243 VPWR VGND sg13cmos5l_decap_8
XFILLER_587_185 VPWR VGND sg13cmos5l_decap_8
XFILLER_71_28 VPWR VGND sg13cmos5l_decap_8
XFILLER_468_49 VPWR VGND sg13cmos5l_decap_8
X_4909_ _4909_/X _4455_/X _4459_/X _4463_/X _4433_/X _2379_/Q _2378_/Q VPWR VGND sg13cmos5l_mux4_1
XFILLER_138_203 VPWR VGND sg13cmos5l_decap_8
XANTENNA__3576__X Tile_X0Y9_FrameData_O[6] VPWR VGND sg13cmos5l_antennanp
XFILLER_329_8 VPWR VGND sg13cmos5l_decap_8
XFILLER_224_7 VPWR VGND sg13cmos5l_decap_8
XFILLER_339_196 VPWR VGND sg13cmos5l_decap_8
XFILLER_689_204 VPWR VGND sg13cmos5l_decap_8
XFILLER_354_133 VPWR VGND sg13cmos5l_decap_8
XFILLER_153_228 VPWR VGND sg13cmos5l_decap_8
XFILLER_503_119 VPWR VGND sg13cmos5l_decap_8
XFILLER_4_216 VPWR VGND sg13cmos5l_decap_4
XFILLER_20_21 VPWR VGND sg13cmos5l_decap_8
XFILLER_417_42 VPWR VGND sg13cmos5l_decap_8
XFILLER_136_21 VPWR VGND sg13cmos5l_decap_8
XFILLER_564_70 VPWR VGND sg13cmos5l_decap_8
XFILLER_657_123 VPWR VGND sg13cmos5l_decap_8
XFILLER_593_7 VPWR VGND sg13cmos5l_decap_8
XFILLER_700_241 VPWR VGND sg13cmos5l_decap_8
XFILLER_96_14 VPWR VGND sg13cmos5l_decap_8
XFILLER_310_203 VPWR VGND sg13cmos5l_decap_8
XFILLER_456_207 VPWR VGND sg13cmos5l_decap_8
XFILLER_456_218 VPWR VGND sg13cmos5l_decap_8
XFILLER_121_147 VPWR VGND sg13cmos5l_decap_8
XFILLER_136_98 VPWR VGND sg13cmos5l_fill_2
XFILLER_310_236 VPWR VGND sg13cmos5l_decap_4
XFILLER_714_84 VPWR VGND sg13cmos5l_decap_8
XFILLER_310_247 VPWR VGND sg13cmos5l_decap_8
XFILLER_650_28 VPWR VGND sg13cmos5l_decap_8
XFILLER_433_63 VPWR VGND sg13cmos5l_decap_8
XFILLER_672_159 VPWR VGND sg13cmos5l_decap_8
XFILLER_580_91 VPWR VGND sg13cmos5l_decap_4
XFILLER_152_42 VPWR VGND sg13cmos5l_decap_4
XFILLER_152_75 VPWR VGND sg13cmos5l_decap_8
XFILLER_613_215 VPWR VGND sg13cmos5l_decap_4
XFILLER_424_126 VPWR VGND sg13cmos5l_decap_8
XFILLER_290_121 VPWR VGND sg13cmos5l_fill_2
XFILLER_275_195 VPWR VGND sg13cmos5l_decap_8
XFILLER_613_237 VPWR VGND sg13cmos5l_fill_1
XFILLER_90_226 VPWR VGND sg13cmos5l_decap_8
XFILLER_302_56 VPWR VGND sg13cmos5l_decap_8
XFILLER_290_165 VPWR VGND sg13cmos5l_decap_8
XFILLER_45_51 VPWR VGND sg13cmos5l_decap_8
XFILLER_302_67 VPWR VGND sg13cmos5l_fill_1
XFILLER_28_194 VPWR VGND sg13cmos5l_decap_8
XFILLER_302_89 VPWR VGND sg13cmos5l_decap_8
XFILLER_43_142 VPWR VGND sg13cmos5l_decap_8
XFILLER_250_0 VPWR VGND sg13cmos5l_decap_8
XFILLER_348_0 VPWR VGND sg13cmos5l_decap_8
XFILLER_377_236 VPWR VGND sg13cmos5l_decap_8
XFILLER_188_147 VPWR VGND sg13cmos5l_decap_8
XFILLER_231_265 VPWR VGND sg13cmos5l_decap_8
XFILLER_675_14 VPWR VGND sg13cmos5l_decap_8
XFILLER_519_252 VPWR VGND sg13cmos5l_fill_1
XANTENNA__3486__X Tile_X0Y1_EE4BEG[12] VPWR VGND sg13cmos5l_antennanp
XFILLER_515_0 VPWR VGND sg13cmos5l_decap_8
XFILLER_196_180 VPWR VGND sg13cmos5l_decap_8
XFILLER_394_15 VPWR VGND sg13cmos5l_decap_8
XFILLER_77_8 VPWR VGND sg13cmos5l_decap_8
XFILLER_534_244 VPWR VGND sg13cmos5l_decap_8
XFILLER_144_217 VPWR VGND sg13cmos5l_decap_8
XFILLER_608_63 VPWR VGND sg13cmos5l_decap_8
XFILLER_345_188 VPWR VGND sg13cmos5l_fill_2
XANTENNA_5 AXI_M_SOC_RDATA26 VPWR VGND sg13cmos5l_antennanp
XFILLER_6_56 VPWR VGND sg13cmos5l_decap_8
X_1570_ _1570_/Q Tile_X0Y2_FrameData[15] VGND VPWR Tile_X0Y9_FrameStrobe[4] latch
XFILLER_691_35 VPWR VGND sg13cmos5l_decap_8
XFILLER_298_221 VPWR VGND sg13cmos5l_fill_1
XFILLER_648_112 VPWR VGND sg13cmos5l_decap_8
XFILLER_152_250 VPWR VGND sg13cmos5l_fill_2
X_0521_ _0521_/Q Tile_X0Y8_FrameData[22] VGND VPWR Tile_X0Y9_FrameStrobe[3] latch
XFILLER_447_207 VPWR VGND sg13cmos5l_decap_8
XFILLER_3_271 VPWR VGND sg13cmos5l_fill_2
XFILLER_193_93 VPWR VGND sg13cmos5l_decap_8
X_3240_ Tile_X0Y0_FrameData_O[8] Tile_X0Y0_FrameData[8] VPWR VGND sg13cmos5l_buf_1
XFILLER_258_118 VPWR VGND sg13cmos5l_decap_8
X_0452_ _0452_/Q Tile_X0Y8_FrameData[27] VGND VPWR Tile_X0Y9_FrameStrobe[1] latch
XFILLER_624_84 VPWR VGND sg13cmos5l_fill_2
XFILLER_502_196 VPWR VGND sg13cmos5l_decap_8
XFILLER_112_169 VPWR VGND sg13cmos5l_decap_8
XFILLER_560_28 VPWR VGND sg13cmos5l_decap_8
XFILLER_343_63 VPWR VGND sg13cmos5l_decap_8
X_3171_ Tile_X0Y4_E6BEG[8] _4296_/X VPWR VGND sg13cmos5l_buf_1
X_0383_ _0383_/Q Tile_X0Y7_FrameData[0] VGND VPWR Tile_X0Y9_FrameStrobe[6] latch
XFILLER_490_91 VPWR VGND sg13cmos5l_decap_8
X_2122_ _2122_/Q Tile_X0Y4_FrameData[27] VGND VPWR Tile_X0Y9_FrameStrobe[6] latch
XFILLER_266_162 VPWR VGND sg13cmos5l_decap_8
XFILLER_86_91 VPWR VGND sg13cmos5l_decap_8
XFILLER_604_215 VPWR VGND sg13cmos5l_decap_8
XFILLER_81_204 VPWR VGND sg13cmos5l_fill_2
X_2053_ _2053_/Q Tile_X0Y4_FrameData[0] VGND VPWR Tile_X0Y9_FrameStrobe[3] latch
XFILLER_415_148 VPWR VGND sg13cmos5l_decap_4
XFILLER_281_154 VPWR VGND sg13cmos5l_decap_8
XFILLER_19_183 VPWR VGND sg13cmos5l_decap_8
XFILLER_212_56 VPWR VGND sg13cmos5l_decap_8
X_1004_ _1004_/Q Tile_X0Y0_FrameData[31] VGND VPWR Tile_X0Y9_FrameStrobe[2] latch
XFILLER_368_203 VPWR VGND sg13cmos5l_decap_8
XFILLER_179_114 VPWR VGND sg13cmos5l_decap_8
XFILLER_368_214 VPWR VGND sg13cmos5l_fill_1
XFILLER_569_196 VPWR VGND sg13cmos5l_decap_8
XFILLER_368_236 VPWR VGND sg13cmos5l_fill_2
XFILLER_584_122 VPWR VGND sg13cmos5l_fill_1
XFILLER_368_247 VPWR VGND sg13cmos5l_fill_1
XFILLER_179_158 VPWR VGND sg13cmos5l_decap_8
XFILLER_96_0 VPWR VGND sg13cmos5l_decap_8
XFILLER_649_70 VPWR VGND sg13cmos5l_decap_8
X_2955_ Tile_X0Y8_EE4BEG[11] _4755_/X VPWR VGND sg13cmos5l_buf_1
XFILLER_585_14 VPWR VGND sg13cmos5l_decap_8
XANTENNA__3396__X Tile_X0Y2_E2BEGb[7] VPWR VGND sg13cmos5l_antennanp
XFILLER_194_117 VPWR VGND sg13cmos5l_decap_8
XFILLER_383_217 VPWR VGND sg13cmos5l_decap_8
XFILLER_368_71 VPWR VGND sg13cmos5l_decap_8
X_1906_ _1906_/Q Tile_X0Y3_FrameData[23] VGND VPWR Tile_X0Y9_FrameStrobe[7] latch
X_2886_ Tile_X0Y6_FrameData_O[7] Tile_X0Y6_FrameData[7] VPWR VGND sg13cmos5l_buf_1
X_4625_ _4625_/X Tile_X0Y7_W2END[2] AXI_M_SOC_RDATA18 _4673_/X _4672_/X _0309_/Q _0308_/Q
+ VPWR VGND sg13cmos5l_mux4_1
XFILLER_336_155 VPWR VGND sg13cmos5l_fill_1
X_1837_ _1837_/Q Tile_X0Y3_FrameData[28] VGND VPWR Tile_X0Y9_FrameStrobe[5] latch
XFILLER_518_63 VPWR VGND sg13cmos5l_decap_8
XFILLER_525_266 VPWR VGND sg13cmos5l_decap_8
XFILLER_135_239 VPWR VGND sg13cmos5l_decap_8
XFILLER_665_91 VPWR VGND sg13cmos5l_decap_8
XFILLER_237_42 VPWR VGND sg13cmos5l_decap_8
XFILLER_336_199 VPWR VGND sg13cmos5l_decap_8
X_4556_ _4556_/X _4479_/X _4595_/X _4594_/X _4478_/X _2453_/Q _2452_/Q VPWR VGND sg13cmos5l_mux4_1
X_1768_ _1768_/Q Tile_X0Y3_FrameData[1] VGND VPWR Tile_X0Y9_FrameStrobe[2] latch
XFILLER_351_147 VPWR VGND sg13cmos5l_decap_8
XFILLER_540_247 VPWR VGND sg13cmos5l_decap_8
XFILLER_639_112 VPWR VGND sg13cmos5l_decap_8
XFILLER_143_250 VPWR VGND sg13cmos5l_decap_8
X_3507_ Tile_X0Y1_E2BEGb[5] _3945_/X VPWR VGND sg13cmos5l_buf_1
X_0719_ _0719_/Q Tile_X0Y9_FrameData[16] VGND VPWR Tile_X0Y9_FrameStrobe[1] latch
XFILLER_143_272 VPWR VGND sg13cmos5l_fill_1
X_4487_ _4487_/X _4573_/X _4577_/X _4581_/X _4556_/X _2632_/Q _2631_/Q VPWR VGND sg13cmos5l_mux4_1
X_1699_ _1699_/Q Tile_X0Y3_FrameData[6] VGND VPWR Tile_X0Y9_FrameStrobe[0] latch
XFILLER_694_240 VPWR VGND sg13cmos5l_decap_8
X_3438_ Tile_X0Y4_FrameData_O[29] Tile_X0Y4_FrameData[29] VPWR VGND sg13cmos5l_buf_1
XFILLER_103_147 VPWR VGND sg13cmos5l_decap_8
XFILLER_654_104 VPWR VGND sg13cmos5l_decap_8
XFILLER_639_189 VPWR VGND sg13cmos5l_decap_8
XFILLER_534_95 VPWR VGND sg13cmos5l_decap_8
XFILLER_470_28 VPWR VGND sg13cmos5l_decap_8
XFILLER_253_63 VPWR VGND sg13cmos5l_decap_8
X_3369_ Tile_X0Y2_EE4BEG[8] _4064_/X VPWR VGND sg13cmos5l_buf_1
XFILLER_57_201 VPWR VGND sg13cmos5l_fill_2
XFILLER_66_28 VPWR VGND sg13cmos5l_decap_8
XFILLER_257_151 VPWR VGND sg13cmos5l_decap_8
XFILLER_403_22 VPWR VGND sg13cmos5l_decap_8
XFILLER_57_245 VPWR VGND sg13cmos5l_decap_4
XFILLER_174_7 VPWR VGND sg13cmos5l_decap_8
XFILLER_122_56 VPWR VGND sg13cmos5l_decap_8
XFILLER_72_248 VPWR VGND sg13cmos5l_decap_8
XFILLER_700_42 VPWR VGND sg13cmos5l_decap_8
XFILLER_610_207 VPWR VGND sg13cmos5l_fill_1
XFILLER_446_8 VPWR VGND sg13cmos5l_decap_8
XFILLER_213_232 VPWR VGND sg13cmos5l_decap_8
XFILLER_15_21 VPWR VGND sg13cmos5l_decap_8
XFILLER_709_105 VPWR VGND sg13cmos5l_decap_8
XFILLER_341_7 VPWR VGND sg13cmos5l_decap_8
XFILLER_439_7 VPWR VGND sg13cmos5l_decap_8
XFILLER_575_133 VPWR VGND sg13cmos5l_decap_8
XFILLER_559_70 VPWR VGND sg13cmos5l_decap_8
XFILLER_495_14 VPWR VGND sg13cmos5l_decap_8
XFILLER_40_156 VPWR VGND sg13cmos5l_decap_8
XFILLER_327_100 VPWR VGND sg13cmos5l_decap_8
XFILLER_178_180 VPWR VGND sg13cmos5l_decap_8
XFILLER_606_7 VPWR VGND sg13cmos5l_decap_8
XFILLER_709_84 VPWR VGND sg13cmos5l_decap_8
XFILLER_126_206 VPWR VGND sg13cmos5l_fill_1
XFILLER_645_28 VPWR VGND sg13cmos5l_decap_8
XFILLER_428_63 VPWR VGND sg13cmos5l_decap_8
XFILLER_382_261 VPWR VGND sg13cmos5l_fill_1
XFILLER_382_272 VPWR VGND sg13cmos5l_fill_1
XFILLER_575_91 VPWR VGND sg13cmos5l_decap_8
XFILLER_147_42 VPWR VGND sg13cmos5l_decap_8
XFILLER_531_214 VPWR VGND sg13cmos5l_decap_8
XFILLER_342_125 VPWR VGND sg13cmos5l_decap_8
XFILLER_294_70 VPWR VGND sg13cmos5l_decap_8
XFILLER_134_272 VPWR VGND sg13cmos5l_fill_1
XFILLER_496_140 VPWR VGND sg13cmos5l_decap_8
XFILLER_163_30 VPWR VGND sg13cmos5l_decap_8
XFILLER_661_49 VPWR VGND sg13cmos5l_decap_8
XFILLER_645_126 VPWR VGND sg13cmos5l_decap_8
XFILLER_380_28 VPWR VGND sg13cmos5l_decap_8
XFILLER_298_0 VPWR VGND sg13cmos5l_decap_8
XFILLER_295_268 VPWR VGND sg13cmos5l_decap_4
XFILLER_248_151 VPWR VGND sg13cmos5l_decap_8
XFILLER_48_234 VPWR VGND sg13cmos5l_decap_8
XFILLER_102_191 VPWR VGND sg13cmos5l_decap_8
XFILLER_313_55 VPWR VGND sg13cmos5l_decap_8
XFILLER_653_181 VPWR VGND sg13cmos5l_decap_8
XFILLER_56_50 VPWR VGND sg13cmos5l_decap_4
XFILLER_465_0 VPWR VGND sg13cmos5l_decap_8
XFILLER_263_132 VPWR VGND sg13cmos5l_decap_8
XFILLER_452_243 VPWR VGND sg13cmos5l_decap_8
XFILLER_313_88 VPWR VGND sg13cmos5l_decap_8
XFILLER_452_254 VPWR VGND sg13cmos5l_fill_1
XFILLER_63_237 VPWR VGND sg13cmos5l_decap_8
XFILLER_610_42 VPWR VGND sg13cmos5l_decap_8
XFILLER_632_0 VPWR VGND sg13cmos5l_decap_8
XFILLER_686_35 VPWR VGND sg13cmos5l_decap_8
XFILLER_420_140 VPWR VGND sg13cmos5l_decap_8
XFILLER_566_133 VPWR VGND sg13cmos5l_decap_8
XFILLER_176_106 VPWR VGND sg13cmos5l_fill_1
XFILLER_31_156 VPWR VGND sg13cmos5l_decap_8
XFILLER_176_128 VPWR VGND sg13cmos5l_decap_8
XFILLER_420_184 VPWR VGND sg13cmos5l_fill_2
XFILLER_715_119 VPWR VGND sg13cmos5l_decap_8
X_2740_ Tile_X0Y4_E1BEG[3] _4255_/X VPWR VGND sg13cmos5l_buf_1
XFILLER_619_84 VPWR VGND sg13cmos5l_decap_8
XFILLER_581_147 VPWR VGND sg13cmos5l_decap_8
X_2671_ _2671_/Q Tile_X0Y6_FrameData[24] VGND VPWR Tile_X0Y9_FrameStrobe[7] latch
XFILLER_117_228 VPWR VGND sg13cmos5l_decap_8
XFILLER_373_272 VPWR VGND sg13cmos5l_fill_1
X_4410_ _4410_/X AXI_M_SOC_RRESP0 _4456_/X _4460_/X _4432_/X _2283_/Q _2282_/Q VPWR
+ VGND sg13cmos5l_mux4_1
X_1622_ _1622_/Q Tile_X0Y2_FrameData[27] VGND VPWR Tile_X0Y9_FrameStrobe[6] latch
XFILLER_668_229 VPWR VGND sg13cmos5l_decap_8
X_4341_ _4341_/X _4305_/X _0158_/X _4304_/X _0111_/X _1971_/Q _1970_/Q VPWR VGND sg13cmos5l_mux4_1
XFILLER_98_101 VPWR VGND sg13cmos5l_fill_2
X_1553_ _1553_/Q Tile_X0Y2_FrameData[0] VGND VPWR Tile_X0Y9_FrameStrobe[3] latch
XFILLER_125_272 VPWR VGND sg13cmos5l_fill_1
XFILLER_676_240 VPWR VGND sg13cmos5l_fill_2
XFILLER_207_56 VPWR VGND sg13cmos5l_decap_8
X_0504_ _0504_/Q Tile_X0Y8_FrameData[7] VGND VPWR Tile_X0Y9_FrameStrobe[2] latch
XFILLER_140_231 VPWR VGND sg13cmos5l_decap_4
X_4272_ _4272_/X Tile_X0Y4_WW4END[15] AXI_M_SOC_BRESP0 _4351_/X _4312_/X _2069_/Q
+ _2068_/Q VPWR VGND sg13cmos5l_mux4_1
X_1484_ _1484_/Q Tile_X0Y2_FrameData[5] VGND VPWR Tile_X0Y9_FrameStrobe[1] latch
XFILLER_571_49 VPWR VGND sg13cmos5l_decap_8
XFILLER_487_184 VPWR VGND sg13cmos5l_decap_8
XFILLER_354_84 VPWR VGND sg13cmos5l_decap_8
XFILLER_504_21 VPWR VGND sg13cmos5l_decap_8
XFILLER_636_126 VPWR VGND sg13cmos5l_decap_8
XFILLER_100_106 VPWR VGND sg13cmos5l_decap_8
X_3223_ Tile_X0Y0_FrameStrobe_O[11] Tile_X0Y9_FrameStrobe[11] VPWR VGND sg13cmos5l_buf_1
X_0435_ _0435_/Q Tile_X0Y8_FrameData[12] VGND VPWR Tile_X0Y9_FrameStrobe[0] latch
XFILLER_286_268 VPWR VGND sg13cmos5l_decap_4
XFILLER_239_140 VPWR VGND sg13cmos5l_decap_8
XFILLER_223_22 VPWR VGND sg13cmos5l_decap_8
XFILLER_39_234 VPWR VGND sg13cmos5l_decap_4
X_3154_ Tile_X0Y7_FrameData_O[24] Tile_X0Y7_FrameData[24] VPWR VGND sg13cmos5l_buf_1
XFILLER_239_173 VPWR VGND sg13cmos5l_fill_1
XFILLER_11_0 VPWR VGND sg13cmos5l_decap_8
X_0366_ _0366_/Q Tile_X0Y7_FrameData[17] VGND VPWR Tile_X0Y9_FrameStrobe[6] latch
XFILLER_504_98 VPWR VGND sg13cmos5l_decap_8
XFILLER_370_50 VPWR VGND sg13cmos5l_decap_8
XFILLER_370_61 VPWR VGND sg13cmos5l_fill_1
XFILLER_39_267 VPWR VGND sg13cmos5l_decap_4
X_2105_ _2105_/Q Tile_X0Y4_FrameData[12] VGND VPWR Tile_X0Y9_FrameStrobe[5] latch
XFILLER_589_214 VPWR VGND sg13cmos5l_decap_8
XFILLER_254_143 VPWR VGND sg13cmos5l_decap_8
X_3085_ Tile_X0Y7_E1BEG[3] _4611_/X VPWR VGND sg13cmos5l_buf_1
X_0297_ _0297_/Q Tile_X0Y7_FrameData[22] VGND VPWR Tile_X0Y9_FrameStrobe[4] latch
XFILLER_520_42 VPWR VGND sg13cmos5l_decap_8
X_2036_ _2036_/Q Tile_X0Y4_FrameData[17] VGND VPWR Tile_X0Y9_FrameStrobe[3] latch
XFILLER_403_118 VPWR VGND sg13cmos5l_decap_8
XFILLER_596_35 VPWR VGND sg13cmos5l_decap_8
XFILLER_557_122 VPWR VGND sg13cmos5l_fill_2
XFILLER_411_151 VPWR VGND sg13cmos5l_decap_8
XFILLER_379_70 VPWR VGND sg13cmos5l_decap_8
XFILLER_600_251 VPWR VGND sg13cmos5l_decap_8
X_3987_ _3987_/X Tile_X0Y2_W1END[3] Tile_X0Y2_W6END[7] _4104_/X _4087_/X _1667_/Q
+ _1666_/Q VPWR VGND sg13cmos5l_mux4_1
XFILLER_356_217 VPWR VGND sg13cmos5l_decap_8
XFILLER_706_119 VPWR VGND sg13cmos5l_decap_8
XFILLER_309_111 VPWR VGND sg13cmos5l_decap_8
X_2938_ Tile_X0Y8_E6BEG[6] _4766_/X VPWR VGND sg13cmos5l_buf_1
XFILLER_309_122 VPWR VGND sg13cmos5l_fill_1
XFILLER_572_147 VPWR VGND sg13cmos5l_decap_8
XFILLER_309_144 VPWR VGND sg13cmos5l_fill_2
XFILLER_465_28 VPWR VGND sg13cmos5l_decap_8
XFILLER_248_63 VPWR VGND sg13cmos5l_decap_8
X_2869_ Tile_X0Y6_EE4BEG[6] _4518_/X VPWR VGND sg13cmos5l_buf_1
XFILLER_108_239 VPWR VGND sg13cmos5l_fill_1
XFILLER_309_199 VPWR VGND sg13cmos5l_fill_2
XFILLER_184_29 VPWR VGND sg13cmos5l_decap_8
X_4608_ _4608_/X _4661_/X _4660_/X AXI_M_SOC_RDATA19 AXI_M_SOC_RDATA23 _0343_/Q _0342_/Q
+ VPWR VGND sg13cmos5l_mux4_1
XFILLER_324_136 VPWR VGND sg13cmos5l_decap_8
XFILLER_714_196 VPWR VGND sg13cmos5l_fill_1
XFILLER_659_229 VPWR VGND sg13cmos5l_decap_8
XFILLER_513_236 VPWR VGND sg13cmos5l_decap_8
XFILLER_116_261 VPWR VGND sg13cmos5l_decap_4
X_4539_ _4539_/X AXI_M_SOC_RDATA31 _4568_/X _4572_/X _4552_/X _2529_/Q _2528_/Q VPWR
+ VGND sg13cmos5l_mux4_1
XFILLER_89_123 VPWR VGND sg13cmos5l_fill_2
XFILLER_131_220 VPWR VGND sg13cmos5l_decap_4
XFILLER_277_213 VPWR VGND sg13cmos5l_decap_8
XFILLER_481_49 VPWR VGND sg13cmos5l_decap_8
XFILLER_682_210 VPWR VGND sg13cmos5l_fill_2
XFILLER_131_253 VPWR VGND sg13cmos5l_fill_2
XFILLER_414_21 VPWR VGND sg13cmos5l_decap_8
XFILLER_627_159 VPWR VGND sg13cmos5l_fill_2
XFILLER_493_154 VPWR VGND sg13cmos5l_decap_8
XFILLER_389_7 VPWR VGND sg13cmos5l_decap_8
XFILLER_245_110 VPWR VGND sg13cmos5l_decap_8
XFILLER_133_77 VPWR VGND sg13cmos5l_decap_8
XFILLER_711_63 VPWR VGND sg13cmos5l_decap_8
XFILLER_556_7 VPWR VGND sg13cmos5l_decap_8
XFILLER_245_165 VPWR VGND sg13cmos5l_decap_8
XFILLER_650_140 VPWR VGND sg13cmos5l_decap_8
XFILLER_45_237 VPWR VGND sg13cmos5l_decap_8
XANTENNA_203 Tile_X0Y9_N2MID[5] VPWR VGND sg13cmos5l_antennanp
XFILLER_430_42 VPWR VGND sg13cmos5l_decap_8
XFILLER_260_102 VPWR VGND sg13cmos5l_decap_8
XANTENNA_214 Tile_X0Y9_N4END[14] VPWR VGND sg13cmos5l_antennanp
XANTENNA_225 Tile_X0Y9_N4END[14] VPWR VGND sg13cmos5l_antennanp
XFILLER_26_42 VPWR VGND sg13cmos5l_decap_8
XANTENNA_236 _4365_/X VPWR VGND sg13cmos5l_antennanp
XANTENNA__2933__X Tile_X0Y8_E6BEG[1] VPWR VGND sg13cmos5l_antennanp
XFILLER_13_101 VPWR VGND sg13cmos5l_fill_1
XFILLER_13_123 VPWR VGND sg13cmos5l_decap_8
XFILLER_289_70 VPWR VGND sg13cmos5l_decap_8
XFILLER_289_81 VPWR VGND sg13cmos5l_fill_2
XFILLER_158_117 VPWR VGND sg13cmos5l_decap_8
XFILLER_402_184 VPWR VGND sg13cmos5l_decap_4
XFILLER_13_167 VPWR VGND sg13cmos5l_fill_1
XFILLER_402_195 VPWR VGND sg13cmos5l_decap_8
XFILLER_9_149 VPWR VGND sg13cmos5l_decap_8
XFILLER_656_49 VPWR VGND sg13cmos5l_decap_8
XFILLER_563_147 VPWR VGND sg13cmos5l_decap_4
XFILLER_375_28 VPWR VGND sg13cmos5l_decap_8
XFILLER_213_0 VPWR VGND sg13cmos5l_decap_8
XFILLER_355_272 VPWR VGND sg13cmos5l_fill_1
XFILLER_315_103 VPWR VGND sg13cmos5l_fill_1
XFILLER_158_96 VPWR VGND sg13cmos5l_decap_8
XFILLER_315_125 VPWR VGND sg13cmos5l_fill_2
XFILLER_370_242 VPWR VGND sg13cmos5l_decap_8
XFILLER_308_44 VPWR VGND sg13cmos5l_fill_1
XFILLER_504_258 VPWR VGND sg13cmos5l_decap_4
XFILLER_308_55 VPWR VGND sg13cmos5l_decap_4
XFILLER_107_250 VPWR VGND sg13cmos5l_fill_1
XFILLER_181_164 VPWR VGND sg13cmos5l_decap_8
XFILLER_315_169 VPWR VGND sg13cmos5l_decap_8
XFILLER_308_77 VPWR VGND sg13cmos5l_decap_8
XFILLER_122_220 VPWR VGND sg13cmos5l_fill_1
XFILLER_605_42 VPWR VGND sg13cmos5l_decap_8
XFILLER_658_262 VPWR VGND sg13cmos5l_decap_8
XFILLER_122_242 VPWR VGND sg13cmos5l_decap_8
XFILLER_618_126 VPWR VGND sg13cmos5l_decap_8
XFILLER_582_0 VPWR VGND sg13cmos5l_decap_8
XFILLER_3_35 VPWR VGND sg13cmos5l_decap_8
XFILLER_605_86 VPWR VGND sg13cmos5l_decap_4
XFILLER_484_132 VPWR VGND sg13cmos5l_decap_4
XFILLER_324_43 VPWR VGND sg13cmos5l_fill_2
XFILLER_95_126 VPWR VGND sg13cmos5l_decap_8
XFILLER_484_154 VPWR VGND sg13cmos5l_fill_1
XFILLER_673_265 VPWR VGND sg13cmos5l_decap_8
X_0220_ _0220_/Q Tile_X0Y7_FrameData[3] VGND VPWR Tile_X0Y9_FrameStrobe[1] latch
XFILLER_324_87 VPWR VGND sg13cmos5l_decap_8
XFILLER_471_93 VPWR VGND sg13cmos5l_fill_2
XFILLER_425_210 VPWR VGND sg13cmos5l_decap_8
XFILLER_236_132 VPWR VGND sg13cmos5l_decap_8
X_0151_ AXI_M_SOC_AWLEN2 _0940_/Q _3673_/X VPWR VGND sg13cmos5l_nor2b_1
XFILLER_621_63 VPWR VGND sg13cmos5l_decap_8
XANTENNA__3004__X Tile_X0Y5_E2BEG[7] VPWR VGND sg13cmos5l_antennanp
XFILLER_641_140 VPWR VGND sg13cmos5l_decap_8
XFILLER_340_42 VPWR VGND sg13cmos5l_decap_8
XFILLER_440_213 VPWR VGND sg13cmos5l_decap_8
X_0082_ _0082_/X _4910_/X _4911_/X _2374_/Q VPWR VGND sg13cmos5l_mux2_1
XFILLER_251_135 VPWR VGND sg13cmos5l_decap_8
XFILLER_697_56 VPWR VGND sg13cmos5l_decap_8
XFILLER_586_228 VPWR VGND sg13cmos5l_fill_2
XFILLER_397_128 VPWR VGND sg13cmos5l_decap_8
XANTENNA__2843__X Tile_X0Y6_E2BEGb[0] VPWR VGND sg13cmos5l_antennanp
X_3910_ _3910_/X Tile_X0Y1_W1END[0] Tile_X0Y1_WW4END[0] Tile_X0Y1_W6END[8] _4008_/X
+ _1401_/Q _1400_/Q VPWR VGND sg13cmos5l_mux4_1
XFILLER_539_111 VPWR VGND sg13cmos5l_fill_2
X_4890_ _4890_/X AXI_M_SOC_RDATA6 _4917_/X _4921_/X _4902_/X _0763_/Q _0762_/Q VPWR
+ VGND sg13cmos5l_mux4_1
XFILLER_199_70 VPWR VGND sg13cmos5l_decap_8
X_3841_ _3841_/X Tile_X0Y0_W6END[1] _3887_/X _3868_/X _3855_/X _1023_/Q _1022_/Q VPWR
+ VGND sg13cmos5l_mux4_1
XFILLER_539_155 VPWR VGND sg13cmos5l_decap_8
XFILLER_149_128 VPWR VGND sg13cmos5l_decap_8
X_3772_ _3772_/X Tile_X0Y0_WW4END[1] Tile_X0Y0_WW4END[9] Tile_X0Y0_W6END[1] _3882_/X
+ _1007_/Q _1006_/Q VPWR VGND sg13cmos5l_mux4_1
X_0984_ _0984_/Q Tile_X0Y0_FrameData[19] VGND VPWR Tile_X0Y9_FrameStrobe[1] latch
XFILLER_566_49 VPWR VGND sg13cmos5l_decap_8
XFILLER_349_84 VPWR VGND sg13cmos5l_decap_8
X_2723_ _4540_/A3 VPWR VGND sg13cmos5l_tielo
XFILLER_285_28 VPWR VGND sg13cmos5l_decap_8
XFILLER_346_261 VPWR VGND sg13cmos5l_fill_1
X_2654_ _2654_/Q Tile_X0Y6_FrameData[9] VGND VPWR Tile_X0Y9_FrameStrobe[6] latch
XFILLER_361_231 VPWR VGND sg13cmos5l_fill_2
XFILLER_711_133 VPWR VGND sg13cmos5l_decap_8
XFILLER_59_0 VPWR VGND sg13cmos5l_fill_2
X_1605_ _1605_/Q Tile_X0Y2_FrameData[12] VGND VPWR Tile_X0Y9_FrameStrobe[5] latch
XFILLER_365_83 VPWR VGND sg13cmos5l_fill_1
XFILLER_321_106 VPWR VGND sg13cmos5l_decap_8
X_2585_ _2585_/Q Tile_X0Y6_FrameData[14] VGND VPWR Tile_X0Y9_FrameStrobe[4] latch
X_4324_ _4324_/X Tile_X0Y0_W1END[1] Tile_X0Y0_WW4END[13] Tile_X0Y0_W6END[5] _3882_/X
+ _1114_/Q _1113_/Q VPWR VGND sg13cmos5l_mux4_1
XFILLER_515_42 VPWR VGND sg13cmos5l_decap_8
X_1536_ _1536_/Q Tile_X0Y2_FrameData[17] VGND VPWR Tile_X0Y9_FrameStrobe[3] latch
XFILLER_113_253 VPWR VGND sg13cmos5l_decap_8
XFILLER_662_70 VPWR VGND sg13cmos5l_decap_8
XFILLER_234_21 VPWR VGND sg13cmos5l_decap_8
X_4255_ _4255_/X _4311_/X _4310_/X AXI_M_SOC_BRESP0 _4309_/X _2103_/Q _2102_/Q VPWR
+ VGND sg13cmos5l_mux4_1
XFILLER_475_143 VPWR VGND sg13cmos5l_fill_1
XFILLER_86_126 VPWR VGND sg13cmos5l_decap_8
X_1467_ _1467_/Q Tile_X0Y2_FrameData[22] VGND VPWR Tile_X0Y9_FrameStrobe[1] latch
XFILLER_381_60 VPWR VGND sg13cmos5l_decap_8
X_3206_ Tile_X0Y0_N2BEG[6] _3790_/X VPWR VGND sg13cmos5l_buf_1
X_0418_ _0418_/Q Tile_X0Y8_FrameData[29] VGND VPWR Tile_X0Y9_FrameStrobe[0] latch
X_4186_ _4186_/X AXI_M_SOC_WREADY _4227_/X _4231_/X _4209_/X _1769_/Q _1768_/Q VPWR
+ VGND sg13cmos5l_mux4_1
XFILLER_624_129 VPWR VGND sg13cmos5l_decap_8
X_1398_ _1398_/Q Tile_X0Y1_FrameData[3] VGND VPWR Tile_X0Y9_FrameStrobe[6] latch
XFILLER_416_232 VPWR VGND sg13cmos5l_decap_8
X_3137_ Tile_X0Y7_FrameData_O[7] Tile_X0Y7_FrameData[7] VPWR VGND sg13cmos5l_buf_1
XFILLER_531_63 VPWR VGND sg13cmos5l_decap_8
XFILLER_103_14 VPWR VGND sg13cmos5l_decap_8
X_0349_ _0349_/Q Tile_X0Y7_FrameData[2] VGND VPWR Tile_X0Y9_FrameStrobe[5] latch
XFILLER_416_254 VPWR VGND sg13cmos5l_decap_4
XFILLER_227_165 VPWR VGND sg13cmos5l_decap_8
XFILLER_632_140 VPWR VGND sg13cmos5l_decap_8
XFILLER_282_260 VPWR VGND sg13cmos5l_fill_2
XFILLER_250_42 VPWR VGND sg13cmos5l_decap_8
XFILLER_632_151 VPWR VGND sg13cmos5l_fill_1
XFILLER_282_271 VPWR VGND sg13cmos5l_fill_2
XFILLER_27_259 VPWR VGND sg13cmos5l_decap_4
X_3068_ Tile_X0Y5_FrameData_O[27] Tile_X0Y5_FrameData[27] VPWR VGND sg13cmos5l_buf_1
XFILLER_577_206 VPWR VGND sg13cmos5l_decap_8
XFILLER_388_117 VPWR VGND sg13cmos5l_decap_8
XFILLER_42_207 VPWR VGND sg13cmos5l_decap_8
XANTENNA__2753__X Tile_X0Y3_FrameData_O[11] VPWR VGND sg13cmos5l_antennanp
X_2019_ _2019_/Q Tile_X0Y4_FrameData[2] VGND VPWR Tile_X0Y9_FrameStrobe[2] latch
XFILLER_242_168 VPWR VGND sg13cmos5l_decap_8
XFILLER_400_56 VPWR VGND sg13cmos5l_decap_8
XFILLER_195_223 VPWR VGND sg13cmos5l_decap_8
XFILLER_250_190 VPWR VGND sg13cmos5l_decap_8
XFILLER_396_183 VPWR VGND sg13cmos5l_decap_8
XFILLER_137_7 VPWR VGND sg13cmos5l_decap_8
XFILLER_476_49 VPWR VGND sg13cmos5l_decap_8
XFILLER_10_148 VPWR VGND sg13cmos5l_decap_8
XFILLER_545_158 VPWR VGND sg13cmos5l_decap_8
XFILLER_409_21 VPWR VGND sg13cmos5l_decap_8
XFILLER_545_169 VPWR VGND sg13cmos5l_fill_1
XFILLER_148_161 VPWR VGND sg13cmos5l_decap_8
XFILLER_311_8 VPWR VGND sg13cmos5l_decap_8
XFILLER_6_119 VPWR VGND sg13cmos5l_decap_4
XANTENNA__3584__X Tile_X0Y9_FrameData_O[14] VPWR VGND sg13cmos5l_antennanp
XFILLER_699_140 VPWR VGND sg13cmos5l_decap_8
XFILLER_352_231 VPWR VGND sg13cmos5l_decap_8
XFILLER_304_7 VPWR VGND sg13cmos5l_decap_8
XFILLER_12_77 VPWR VGND sg13cmos5l_fill_2
XFILLER_498_224 VPWR VGND sg13cmos5l_decap_8
XFILLER_699_195 VPWR VGND sg13cmos5l_decap_8
XFILLER_128_77 VPWR VGND sg13cmos5l_decap_8
XFILLER_163_186 VPWR VGND sg13cmos5l_decap_8
XFILLER_706_63 VPWR VGND sg13cmos5l_decap_8
XFILLER_501_217 VPWR VGND sg13cmos5l_decap_8
XFILLER_312_128 VPWR VGND sg13cmos5l_decap_8
XFILLER_104_220 VPWR VGND sg13cmos5l_decap_8
XFILLER_425_42 VPWR VGND sg13cmos5l_decap_8
XFILLER_702_199 VPWR VGND sg13cmos5l_decap_4
XFILLER_305_191 VPWR VGND sg13cmos5l_decap_8
XFILLER_572_70 VPWR VGND sg13cmos5l_decap_8
XFILLER_144_21 VPWR VGND sg13cmos5l_decap_8
XFILLER_104_264 VPWR VGND sg13cmos5l_fill_1
XFILLER_77_115 VPWR VGND sg13cmos5l_decap_4
XANTENNA__2928__X Tile_X0Y8_E2BEGb[4] VPWR VGND sg13cmos5l_antennanp
XFILLER_77_126 VPWR VGND sg13cmos5l_decap_8
XFILLER_673_7 VPWR VGND sg13cmos5l_decap_8
XFILLER_320_161 VPWR VGND sg13cmos5l_decap_8
XFILLER_291_71 VPWR VGND sg13cmos5l_decap_8
XFILLER_615_107 VPWR VGND sg13cmos5l_decap_8
XFILLER_466_187 VPWR VGND sg13cmos5l_decap_8
XFILLER_218_143 VPWR VGND sg13cmos5l_decap_4
XFILLER_441_63 VPWR VGND sg13cmos5l_decap_8
XFILLER_670_257 VPWR VGND sg13cmos5l_decap_4
XFILLER_18_226 VPWR VGND sg13cmos5l_decap_8
XFILLER_670_268 VPWR VGND sg13cmos5l_decap_4
XFILLER_441_74 VPWR VGND sg13cmos5l_fill_2
XFILLER_481_179 VPWR VGND sg13cmos5l_decap_8
XFILLER_160_42 VPWR VGND sg13cmos5l_decap_8
XFILLER_273_271 VPWR VGND sg13cmos5l_fill_2
XFILLER_18_259 VPWR VGND sg13cmos5l_fill_2
XFILLER_623_162 VPWR VGND sg13cmos5l_decap_8
XFILLER_37_85 VPWR VGND sg13cmos5l_decap_8
XFILLER_218_198 VPWR VGND sg13cmos5l_decap_8
XFILLER_568_217 VPWR VGND sg13cmos5l_decap_8
XANTENNA__3759__X AXI_M_SOC_ARADDR31 VPWR VGND sg13cmos5l_antennanp
XFILLER_163_0 VPWR VGND sg13cmos5l_decap_8
XFILLER_422_268 VPWR VGND sg13cmos5l_decap_4
XFILLER_394_109 VPWR VGND sg13cmos5l_decap_8
XFILLER_387_161 VPWR VGND sg13cmos5l_decap_8
XFILLER_576_272 VPWR VGND sg13cmos5l_fill_1
XFILLER_536_103 VPWR VGND sg13cmos5l_fill_2
XFILLER_330_0 VPWR VGND sg13cmos5l_decap_4
XFILLER_428_0 VPWR VGND sg13cmos5l_decap_8
XFILLER_386_49 VPWR VGND sg13cmos5l_decap_8
XFILLER_319_21 VPWR VGND sg13cmos5l_decap_8
XFILLER_139_161 VPWR VGND sg13cmos5l_decap_8
XFILLER_683_14 VPWR VGND sg13cmos5l_decap_8
XFILLER_319_43 VPWR VGND sg13cmos5l_fill_2
XANTENNA__3494__X Tile_X0Y1_E6BEG[4] VPWR VGND sg13cmos5l_antennanp
XFILLER_551_117 VPWR VGND sg13cmos5l_fill_1
XFILLER_544_191 VPWR VGND sg13cmos5l_decap_8
XFILLER_154_153 VPWR VGND sg13cmos5l_decap_8
XFILLER_343_253 VPWR VGND sg13cmos5l_fill_1
XFILLER_616_63 VPWR VGND sg13cmos5l_decap_8
XFILLER_335_42 VPWR VGND sg13cmos5l_decap_8
XFILLER_303_139 VPWR VGND sg13cmos5l_decap_4
X_2370_ _2370_/Q Tile_X0Y5_FrameData[3] VGND VPWR Tile_X0Y9_FrameStrobe[5] latch
XFILLER_646_210 VPWR VGND sg13cmos5l_decap_8
X_1321_ _1321_/Q Tile_X0Y1_FrameData[16] VGND VPWR Tile_X0Y9_FrameStrobe[4] latch
XFILLER_482_92 VPWR VGND sg13cmos5l_decap_4
XFILLER_457_132 VPWR VGND sg13cmos5l_decap_8
XANTENNA__2838__X Tile_X0Y6_E2BEG[3] VPWR VGND sg13cmos5l_antennanp
XFILLER_68_126 VPWR VGND sg13cmos5l_decap_8
XFILLER_500_261 VPWR VGND sg13cmos5l_fill_1
XFILLER_500_272 VPWR VGND sg13cmos5l_fill_1
XFILLER_110_234 VPWR VGND sg13cmos5l_fill_1
X_4040_ _4040_/X Tile_X0Y2_W2MID[7] AXI_M_SOC_AWREADY _4097_/X _4096_/X _1593_/Q _1592_/Q
+ VPWR VGND sg13cmos5l_mux4_1
X_1252_ _1252_/Q Tile_X0Y1_FrameData[21] VGND VPWR Tile_X0Y9_FrameStrobe[2] latch
XFILLER_632_84 VPWR VGND sg13cmos5l_decap_8
XFILLER_204_35 VPWR VGND sg13cmos5l_decap_8
XFILLER_209_121 VPWR VGND sg13cmos5l_decap_8
X_0203_ _0203_/Q Tile_X0Y7_FrameData[20] VGND VPWR Tile_X0Y9_FrameStrobe[1] latch
XFILLER_351_63 VPWR VGND sg13cmos5l_decap_8
X_1183_ _1183_/Q Tile_X0Y1_FrameData[26] VGND VPWR Tile_X0Y9_FrameStrobe[0] latch
XFILLER_472_179 VPWR VGND sg13cmos5l_decap_8
XFILLER_224_113 VPWR VGND sg13cmos5l_decap_4
X_0134_ AXI_M_SOC_AWLEN4 _0940_/Q _3675_/X VPWR VGND sg13cmos5l_nor2b_1
XFILLER_559_206 VPWR VGND sg13cmos5l_decap_8
XFILLER_559_217 VPWR VGND sg13cmos5l_fill_2
XANTENNA__3669__X AXI_M_SOC_AWADDR30 VPWR VGND sg13cmos5l_antennanp
XFILLER_91_173 VPWR VGND sg13cmos5l_decap_8
XFILLER_501_77 VPWR VGND sg13cmos5l_decap_8
X_0065_ _3627_/A _4602_/X _4603_/X _0350_/Q VPWR VGND sg13cmos5l_mux2_1
XFILLER_220_56 VPWR VGND sg13cmos5l_decap_8
XFILLER_177_212 VPWR VGND sg13cmos5l_fill_2
X_4873_ _4873_/X Tile_X0Y9_WW4END[6] AXI_M_SOC_RDATA6 _4922_/X _4902_/X _0797_/Q _0796_/Q
+ VPWR VGND sg13cmos5l_mux4_1
XFILLER_378_194 VPWR VGND sg13cmos5l_decap_4
XFILLER_177_256 VPWR VGND sg13cmos5l_decap_8
X_3824_ _3824_/X Tile_X0Y0_WW4END[8] Tile_X0Y0_WW4END[11] _3864_/X _3859_/X _1057_/Q
+ _1056_/Q VPWR VGND sg13cmos5l_mux4_1
XFILLER_393_131 VPWR VGND sg13cmos5l_fill_1
XFILLER_296_49 VPWR VGND sg13cmos5l_decap_8
XFILLER_229_21 VPWR VGND sg13cmos5l_decap_8
XFILLER_716_247 VPWR VGND sg13cmos5l_decap_8
XFILLER_192_204 VPWR VGND sg13cmos5l_decap_8
XFILLER_657_81 VPWR VGND sg13cmos5l_decap_8
XFILLER_192_215 VPWR VGND sg13cmos5l_fill_1
XFILLER_393_164 VPWR VGND sg13cmos5l_decap_8
X_3755_ AXI_M_SOC_ARADDR27 Tile_X0Y8_WW4END[3] Tile_X0Y8_WW4END[11] Tile_X0Y8_W6END[11]
+ _4811_/X _0481_/Q _0480_/Q VPWR VGND sg13cmos5l_mux4_1
XFILLER_593_14 VPWR VGND sg13cmos5l_decap_8
X_0967_ _0967_/Q Tile_X0Y0_FrameData[4] VGND VPWR Tile_X0Y9_FrameStrobe[0] latch
X_2706_ _4198_/A3 VPWR VGND sg13cmos5l_tielo
XFILLER_535_180 VPWR VGND sg13cmos5l_fill_2
XFILLER_145_142 VPWR VGND sg13cmos5l_decap_8
XFILLER_229_98 VPWR VGND sg13cmos5l_decap_8
X_3686_ _3686_/X Tile_X0Y3_WW4END[4] Tile_X0Y3_WW4END[12] Tile_X0Y3_W6END[4] _4226_/X
+ _1749_/Q _1748_/Q VPWR VGND sg13cmos5l_mux4_1
X_0898_ _0898_/Q Tile_X0Y9_FrameData[29] VGND VPWR Tile_X0Y9_FrameStrobe[7] latch
XFILLER_334_253 VPWR VGND sg13cmos5l_decap_8
X_2637_ _2637_/Q Tile_X0Y6_FrameData[26] VGND VPWR Tile_X0Y9_FrameStrobe[6] latch
XFILLER_160_112 VPWR VGND sg13cmos5l_decap_8
XFILLER_145_197 VPWR VGND sg13cmos5l_decap_8
XFILLER_495_216 VPWR VGND sg13cmos5l_decap_8
XFILLER_696_176 VPWR VGND sg13cmos5l_fill_1
XFILLER_245_42 VPWR VGND sg13cmos5l_decap_8
XFILLER_99_240 VPWR VGND sg13cmos5l_decap_4
X_2568_ _2568_/Q Tile_X0Y6_FrameData[31] VGND VPWR Tile_X0Y9_FrameStrobe[4] latch
XFILLER_245_75 VPWR VGND sg13cmos5l_decap_8
XFILLER_392_81 VPWR VGND sg13cmos5l_decap_4
XFILLER_59_104 VPWR VGND sg13cmos5l_decap_8
XANTENNA__2748__X Tile_X0Y3_FrameData_O[6] VPWR VGND sg13cmos5l_antennanp
X_1519_ _1519_/Q Tile_X0Y2_FrameData[2] VGND VPWR Tile_X0Y9_FrameStrobe[2] latch
X_4307_ _4307_/X Tile_X0Y3_W1END[2] Tile_X0Y3_W6END[10] _4215_/X _4192_/X _1885_/Q
+ _1884_/Q VPWR VGND sg13cmos5l_mux4_1
X_2499_ _2499_/Q Tile_X0Y6_FrameData[4] VGND VPWR Tile_X0Y9_FrameStrobe[1] latch
XFILLER_637_254 VPWR VGND sg13cmos5l_fill_1
XFILLER_302_183 VPWR VGND sg13cmos5l_decap_8
X_4238_ _4238_/X Tile_X0Y2_W2MID[6] Tile_X0Y2_W2END[6] Tile_X0Y2_W6END[9] _4099_/X
+ _1627_/Q _1626_/Q VPWR VGND sg13cmos5l_mux4_1
XFILLER_542_84 VPWR VGND sg13cmos5l_decap_8
XFILLER_101_267 VPWR VGND sg13cmos5l_decap_4
XFILLER_114_35 VPWR VGND sg13cmos5l_decap_8
X_4169_ _4169_/X Tile_X0Y3_WW4END[10] AXI_M_SOC_BVALID _4232_/X _4209_/X _1803_/Q
+ _1802_/Q VPWR VGND sg13cmos5l_mux4_1
XFILLER_215_102 VPWR VGND sg13cmos5l_fill_2
XFILLER_605_173 VPWR VGND sg13cmos5l_decap_8
XANTENNA__3579__X Tile_X0Y9_FrameData_O[9] VPWR VGND sg13cmos5l_antennanp
XFILLER_404_235 VPWR VGND sg13cmos5l_fill_1
XFILLER_82_173 VPWR VGND sg13cmos5l_decap_8
XFILLER_620_121 VPWR VGND sg13cmos5l_decap_8
XFILLER_215_157 VPWR VGND sg13cmos5l_fill_2
XFILLER_411_77 VPWR VGND sg13cmos5l_decap_8
XFILLER_404_257 VPWR VGND sg13cmos5l_decap_8
XFILLER_254_7 VPWR VGND sg13cmos5l_decap_8
XFILLER_130_56 VPWR VGND sg13cmos5l_decap_8
XFILLER_558_250 VPWR VGND sg13cmos5l_decap_8
XFILLER_23_262 VPWR VGND sg13cmos5l_fill_2
XFILLER_421_7 VPWR VGND sg13cmos5l_decap_8
XFILLER_23_21 VPWR VGND sg13cmos5l_decap_8
XFILLER_384_131 VPWR VGND sg13cmos5l_fill_2
XFILLER_573_231 VPWR VGND sg13cmos5l_decap_8
XFILLER_519_7 VPWR VGND sg13cmos5l_decap_8
XFILLER_567_70 VPWR VGND sg13cmos5l_decap_8
XFILLER_139_21 VPWR VGND sg13cmos5l_decap_8
XFILLER_183_215 VPWR VGND sg13cmos5l_decap_8
XFILLER_23_76 VPWR VGND sg13cmos5l_decap_4
XFILLER_23_87 VPWR VGND sg13cmos5l_fill_1
XFILLER_99_14 VPWR VGND sg13cmos5l_decap_8
XFILLER_136_142 VPWR VGND sg13cmos5l_decap_8
XFILLER_139_98 VPWR VGND sg13cmos5l_decap_8
XFILLER_653_28 VPWR VGND sg13cmos5l_decap_8
XFILLER_541_150 VPWR VGND sg13cmos5l_fill_1
XFILLER_136_186 VPWR VGND sg13cmos5l_decap_8
XFILLER_436_63 VPWR VGND sg13cmos5l_decap_8
XFILLER_583_91 VPWR VGND sg13cmos5l_decap_4
XFILLER_155_42 VPWR VGND sg13cmos5l_decap_8
XFILLER_541_183 VPWR VGND sg13cmos5l_fill_2
XFILLER_372_29 VPWR VGND sg13cmos5l_decap_8
XFILLER_439_165 VPWR VGND sg13cmos5l_decap_8
XFILLER_494_271 VPWR VGND sg13cmos5l_fill_2
XFILLER_305_56 VPWR VGND sg13cmos5l_decap_8
XFILLER_238_227 VPWR VGND sg13cmos5l_decap_8
XFILLER_305_67 VPWR VGND sg13cmos5l_fill_2
XFILLER_643_224 VPWR VGND sg13cmos5l_decap_8
XFILLER_452_84 VPWR VGND sg13cmos5l_fill_1
XFILLER_602_21 VPWR VGND sg13cmos5l_decap_8
XFILLER_48_73 VPWR VGND sg13cmos5l_fill_1
XFILLER_280_0 VPWR VGND sg13cmos5l_decap_8
XFILLER_378_0 VPWR VGND sg13cmos5l_decap_4
XFILLER_0_14 VPWR VGND sg13cmos5l_decap_8
XFILLER_171_85 VPWR VGND sg13cmos5l_decap_8
XFILLER_246_271 VPWR VGND sg13cmos5l_fill_2
XFILLER_73_151 VPWR VGND sg13cmos5l_fill_2
XFILLER_678_14 VPWR VGND sg13cmos5l_decap_8
XANTENNA__3489__X Tile_X0Y1_EE4BEG[15] VPWR VGND sg13cmos5l_antennanp
XFILLER_545_0 VPWR VGND sg13cmos5l_decap_8
XFILLER_678_69 VPWR VGND sg13cmos5l_decap_4
XFILLER_321_99 VPWR VGND sg13cmos5l_decap_8
XFILLER_410_216 VPWR VGND sg13cmos5l_decap_8
XFILLER_14_240 VPWR VGND sg13cmos5l_decap_8
XFILLER_549_261 VPWR VGND sg13cmos5l_decap_4
XFILLER_712_0 VPWR VGND sg13cmos5l_decap_8
XFILLER_549_272 VPWR VGND sg13cmos5l_fill_1
XFILLER_375_120 VPWR VGND sg13cmos5l_decap_8
XFILLER_9_56 VPWR VGND sg13cmos5l_decap_8
X_1870_ _1870_/Q Tile_X0Y3_FrameData[27] VGND VPWR Tile_X0Y9_FrameStrobe[6] latch
XFILLER_694_35 VPWR VGND sg13cmos5l_decap_8
XFILLER_119_109 VPWR VGND sg13cmos5l_decap_8
X_0821_ _0821_/Q Tile_X0Y9_FrameData[10] VGND VPWR Tile_X0Y9_FrameStrobe[4] latch
XFILLER_564_264 VPWR VGND sg13cmos5l_fill_1
XFILLER_174_237 VPWR VGND sg13cmos5l_decap_8
XFILLER_127_120 VPWR VGND sg13cmos5l_decap_8
XFILLER_713_239 VPWR VGND sg13cmos5l_decap_8
X_3540_ Tile_X0Y9_E2BEGb[6] _4862_/X VPWR VGND sg13cmos5l_buf_1
X_0752_ _0752_/Q Tile_X0Y9_FrameData[15] VGND VPWR Tile_X0Y9_FrameStrobe[2] latch
XFILLER_517_191 VPWR VGND sg13cmos5l_decap_8
XFILLER_627_84 VPWR VGND sg13cmos5l_decap_8
XFILLER_142_112 VPWR VGND sg13cmos5l_decap_8
X_3471_ Tile_X0Y1_FrameData_O[29] Tile_X0Y1_FrameData[29] VPWR VGND sg13cmos5l_buf_1
XFILLER_563_28 VPWR VGND sg13cmos5l_decap_8
XFILLER_50_4 VPWR VGND sg13cmos5l_fill_1
X_0683_ _0683_/Q Tile_X0Y9_FrameData[20] VGND VPWR Tile_X0Y9_FrameStrobe[0] latch
XFILLER_532_183 VPWR VGND sg13cmos5l_decap_8
XFILLER_493_91 VPWR VGND sg13cmos5l_decap_8
X_2422_ _2422_/Q Tile_X0Y5_FrameData[15] VGND VPWR Tile_X0Y9_FrameStrobe[7] latch
XFILLER_532_194 VPWR VGND sg13cmos5l_fill_2
XFILLER_477_227 VPWR VGND sg13cmos5l_decap_8
XFILLER_346_96 VPWR VGND sg13cmos5l_decap_8
XFILLER_619_210 VPWR VGND sg13cmos5l_decap_8
XFILLER_142_178 VPWR VGND sg13cmos5l_decap_8
XFILLER_693_135 VPWR VGND sg13cmos5l_decap_4
X_2353_ _2353_/Q Tile_X0Y5_FrameData[20] VGND VPWR Tile_X0Y9_FrameStrobe[5] latch
XFILLER_96_221 VPWR VGND sg13cmos5l_decap_8
XFILLER_215_56 VPWR VGND sg13cmos5l_decap_8
X_1304_ _1304_/Q Tile_X0Y1_FrameData[1] VGND VPWR Tile_X0Y9_FrameStrobe[3] latch
XFILLER_215_78 VPWR VGND sg13cmos5l_decap_8
X_2284_ _2284_/Q Tile_X0Y5_FrameData[25] VGND VPWR Tile_X0Y9_FrameStrobe[3] latch
XFILLER_362_84 VPWR VGND sg13cmos5l_decap_8
XFILLER_512_21 VPWR VGND sg13cmos5l_decap_8
X_4023_ _4023_/X Tile_X0Y3_W2MID[6] Tile_X0Y3_W2END[6] Tile_X0Y3_W6END[6] _4207_/X
+ _1915_/Q _1914_/Q VPWR VGND sg13cmos5l_mux4_1
X_1235_ _1235_/Q Tile_X0Y1_FrameData[6] VGND VPWR Tile_X0Y9_FrameStrobe[1] latch
XFILLER_634_257 VPWR VGND sg13cmos5l_fill_1
XFILLER_244_219 VPWR VGND sg13cmos5l_decap_8
XFILLER_460_116 VPWR VGND sg13cmos5l_decap_8
XFILLER_64_140 VPWR VGND sg13cmos5l_decap_8
X_1166_ _1166_/Q Tile_X0Y0_FrameData[29] VGND VPWR Tile_X0Y9_FrameStrobe[7] latch
XFILLER_588_14 VPWR VGND sg13cmos5l_decap_8
XFILLER_512_98 VPWR VGND sg13cmos5l_decap_8
XFILLER_398_201 VPWR VGND sg13cmos5l_decap_8
XANTENNA__3399__X Tile_X0Y2_E2BEG[2] VPWR VGND sg13cmos5l_antennanp
X_0117_ AXI_M_SOC_ARCACHE0 _3774_/X _0929_/Q VPWR VGND sg13cmos5l_or2_1
XFILLER_212_105 VPWR VGND sg13cmos5l_decap_8
X_1097_ _1097_/Q Tile_X0Y0_FrameData[2] VGND VPWR Tile_X0Y9_FrameStrobe[4] latch
XFILLER_401_227 VPWR VGND sg13cmos5l_decap_8
X_0048_ AXI_M_SOC_AWCACHE1 _0936_/Q _3686_/X VPWR VGND sg13cmos5l_or2_1
X_4925_ _4925_/X Tile_X0Y9_N1END[1] Tile_X0Y9_N4END[1] _4897_/X _0082_/X _0709_/Q
+ _0708_/Q VPWR VGND sg13cmos5l_mux4_1
XFILLER_205_190 VPWR VGND sg13cmos5l_decap_4
X_4856_ _4856_/X Tile_X0Y9_W2END[7] AXI_M_SOC_RDATA7 _4901_/X _4900_/X _0831_/Q _0830_/Q
+ VPWR VGND sg13cmos5l_mux4_1
XFILLER_555_264 VPWR VGND sg13cmos5l_decap_8
X_3807_ _3807_/X Tile_X0Y0_W2MID[4] Tile_X0Y0_WW4END[1] _3859_/X _3858_/X _1091_/Q
+ _1090_/Q VPWR VGND sg13cmos5l_mux4_1
X_1999_ _1999_/Q Tile_X0Y4_FrameData[22] VGND VPWR Tile_X0Y9_FrameStrobe[2] latch
X_4787_ _4787_/X _4703_/X Tile_X0Y9_N2MID[1] _4817_/X _4702_/X _0437_/Q _0436_/Q VPWR
+ VGND sg13cmos5l_mux4_1
XFILLER_118_131 VPWR VGND sg13cmos5l_decap_8
XFILLER_165_259 VPWR VGND sg13cmos5l_decap_4
XFILLER_570_245 VPWR VGND sg13cmos5l_decap_8
XFILLER_307_231 VPWR VGND sg13cmos5l_decap_8
X_3738_ AXI_M_SOC_ARADDR10 Tile_X0Y9_WW4END[2] Tile_X0Y9_WW4END[10] Tile_X0Y9_W6END[10]
+ _4926_/X _0739_/Q _0738_/Q VPWR VGND sg13cmos5l_mux4_1
XFILLER_307_242 VPWR VGND sg13cmos5l_fill_2
XFILLER_570_256 VPWR VGND sg13cmos5l_fill_2
XFILLER_669_121 VPWR VGND sg13cmos5l_decap_4
XFILLER_118_175 VPWR VGND sg13cmos5l_fill_1
XFILLER_473_28 VPWR VGND sg13cmos5l_decap_8
XFILLER_133_112 VPWR VGND sg13cmos5l_decap_4
XFILLER_322_212 VPWR VGND sg13cmos5l_decap_8
X_3669_ AXI_M_SOC_AWADDR30 Tile_X0Y4_W1END[2] Tile_X0Y4_WW4END[6] Tile_X0Y4_WW4END[14]
+ _4350_/X _1985_/Q _1984_/Q VPWR VGND sg13cmos5l_mux4_1
XFILLER_712_272 VPWR VGND sg13cmos5l_fill_1
XFILLER_69_28 VPWR VGND sg13cmos5l_decap_8
XFILLER_279_105 VPWR VGND sg13cmos5l_decap_8
XFILLER_468_216 VPWR VGND sg13cmos5l_decap_8
XFILLER_684_157 VPWR VGND sg13cmos5l_decap_8
XFILLER_406_77 VPWR VGND sg13cmos5l_fill_1
XFILLER_125_56 VPWR VGND sg13cmos5l_decap_8
XFILLER_703_42 VPWR VGND sg13cmos5l_decap_8
XFILLER_87_254 VPWR VGND sg13cmos5l_decap_4
XFILLER_287_182 VPWR VGND sg13cmos5l_decap_8
XFILLER_272_84 VPWR VGND sg13cmos5l_decap_8
XFILLER_422_21 VPWR VGND sg13cmos5l_decap_8
XFILLER_272_95 VPWR VGND sg13cmos5l_fill_2
XFILLER_18_21 VPWR VGND sg13cmos5l_decap_8
XFILLER_371_7 VPWR VGND sg13cmos5l_decap_8
XFILLER_625_268 VPWR VGND sg13cmos5l_decap_4
XFILLER_469_7 VPWR VGND sg13cmos5l_decap_8
XFILLER_451_105 VPWR VGND sg13cmos5l_decap_8
XFILLER_422_98 VPWR VGND sg13cmos5l_decap_8
XFILLER_640_238 VPWR VGND sg13cmos5l_decap_8
XFILLER_498_14 VPWR VGND sg13cmos5l_decap_8
XFILLER_55_162 VPWR VGND sg13cmos5l_fill_1
XFILLER_444_190 VPWR VGND sg13cmos5l_decap_8
XFILLER_141_77 VPWR VGND sg13cmos5l_decap_8
XFILLER_636_7 VPWR VGND sg13cmos5l_decap_8
XFILLER_203_105 VPWR VGND sg13cmos5l_fill_2
XFILLER_389_256 VPWR VGND sg13cmos5l_decap_8
XANTENNA__3102__X Tile_X0Y7_E6BEG[0] VPWR VGND sg13cmos5l_antennanp
XFILLER_648_28 VPWR VGND sg13cmos5l_decap_8
XFILLER_203_149 VPWR VGND sg13cmos5l_decap_8
XFILLER_70_165 VPWR VGND sg13cmos5l_decap_8
XFILLER_34_42 VPWR VGND sg13cmos5l_decap_8
XFILLER_70_176 VPWR VGND sg13cmos5l_fill_2
XFILLER_578_91 VPWR VGND sg13cmos5l_decap_8
XANTENNA__2941__X Tile_X0Y8_E6BEG[9] VPWR VGND sg13cmos5l_antennanp
XFILLER_11_210 VPWR VGND sg13cmos5l_decap_8
XFILLER_367_29 VPWR VGND sg13cmos5l_decap_8
XFILLER_400_260 VPWR VGND sg13cmos5l_fill_1
XFILLER_546_253 VPWR VGND sg13cmos5l_fill_1
XFILLER_211_182 VPWR VGND sg13cmos5l_fill_1
XFILLER_372_101 VPWR VGND sg13cmos5l_decap_8
XFILLER_357_175 VPWR VGND sg13cmos5l_decap_8
XFILLER_126_0 VPWR VGND sg13cmos5l_decap_8
XFILLER_664_49 VPWR VGND sg13cmos5l_decap_8
XFILLER_561_256 VPWR VGND sg13cmos5l_fill_1
XFILLER_50_63 VPWR VGND sg13cmos5l_decap_8
XFILLER_447_84 VPWR VGND sg13cmos5l_fill_2
XFILLER_109_164 VPWR VGND sg13cmos5l_fill_1
XFILLER_50_74 VPWR VGND sg13cmos5l_fill_1
XFILLER_50_85 VPWR VGND sg13cmos5l_decap_8
XFILLER_383_28 VPWR VGND sg13cmos5l_decap_4
XFILLER_372_189 VPWR VGND sg13cmos5l_decap_8
XFILLER_109_186 VPWR VGND sg13cmos5l_decap_4
XFILLER_124_112 VPWR VGND sg13cmos5l_decap_8
XFILLER_514_161 VPWR VGND sg13cmos5l_fill_2
XFILLER_383_39 VPWR VGND sg13cmos5l_fill_2
XFILLER_703_272 VPWR VGND sg13cmos5l_fill_1
XFILLER_313_223 VPWR VGND sg13cmos5l_fill_1
XFILLER_675_102 VPWR VGND sg13cmos5l_fill_1
XFILLER_313_245 VPWR VGND sg13cmos5l_decap_8
XFILLER_675_124 VPWR VGND sg13cmos5l_fill_2
XFILLER_495_0 VPWR VGND sg13cmos5l_decap_8
XFILLER_316_66 VPWR VGND sg13cmos5l_decap_8
XFILLER_285_119 VPWR VGND sg13cmos5l_decap_8
XFILLER_59_83 VPWR VGND sg13cmos5l_decap_8
XFILLER_278_160 VPWR VGND sg13cmos5l_fill_1
XFILLER_78_254 VPWR VGND sg13cmos5l_decap_4
XFILLER_613_42 VPWR VGND sg13cmos5l_decap_8
XFILLER_278_182 VPWR VGND sg13cmos5l_decap_8
XFILLER_616_224 VPWR VGND sg13cmos5l_decap_4
XFILLER_690_149 VPWR VGND sg13cmos5l_fill_1
XFILLER_662_0 VPWR VGND sg13cmos5l_decap_8
XFILLER_332_21 VPWR VGND sg13cmos5l_decap_8
XFILLER_293_141 VPWR VGND sg13cmos5l_decap_8
XFILLER_38_129 VPWR VGND sg13cmos5l_decap_8
XFILLER_15_7 VPWR VGND sg13cmos5l_decap_8
XFILLER_616_257 VPWR VGND sg13cmos5l_decap_8
XFILLER_427_168 VPWR VGND sg13cmos5l_decap_8
XFILLER_689_35 VPWR VGND sg13cmos5l_decap_8
XFILLER_219_271 VPWR VGND sg13cmos5l_fill_2
X_1020_ _1020_/Q Tile_X0Y0_FrameData[15] VGND VPWR Tile_X0Y9_FrameStrobe[2] latch
XFILLER_689_57 VPWR VGND sg13cmos5l_decap_4
XFILLER_631_227 VPWR VGND sg13cmos5l_decap_8
XFILLER_201_14 VPWR VGND sg13cmos5l_decap_8
XFILLER_596_131 VPWR VGND sg13cmos5l_fill_1
XANTENNA__3012__X Tile_X0Y5_E2BEGb[7] VPWR VGND sg13cmos5l_antennanp
XFILLER_596_153 VPWR VGND sg13cmos5l_decap_8
XFILLER_61_154 VPWR VGND sg13cmos5l_decap_8
X_2971_ Tile_X0Y8_FrameData_O[11] Tile_X0Y8_FrameData[11] VPWR VGND sg13cmos5l_buf_1
XFILLER_558_28 VPWR VGND sg13cmos5l_decap_8
XANTENNA__2851__X Tile_X0Y6_E6BEG[0] VPWR VGND sg13cmos5l_antennanp
X_4710_ _4710_/X Tile_X0Y6_W1END[1] Tile_X0Y6_W2MID[2] Tile_X0Y6_W2END[2] _4556_/X
+ _2641_/Q _2640_/Q VPWR VGND sg13cmos5l_mux4_1
XFILLER_61_198 VPWR VGND sg13cmos5l_fill_2
X_1922_ _1922_/Q Tile_X0Y3_FrameData[7] VGND VPWR Tile_X0Y9_FrameStrobe[7] latch
XFILLER_537_264 VPWR VGND sg13cmos5l_decap_8
XFILLER_348_175 VPWR VGND sg13cmos5l_fill_2
X_1853_ _1853_/Q Tile_X0Y3_FrameData[12] VGND VPWR Tile_X0Y9_FrameStrobe[5] latch
X_4641_ _4641_/X Tile_X0Y7_WW4END[2] AXI_M_SOC_RDATA18 _4686_/X _4673_/X _0277_/Q
+ _0276_/Q VPWR VGND sg13cmos5l_mux4_1
XFILLER_147_248 VPWR VGND sg13cmos5l_decap_8
X_0804_ _0804_/Q Tile_X0Y9_FrameData[27] VGND VPWR Tile_X0Y9_FrameStrobe[4] latch
XFILLER_552_234 VPWR VGND sg13cmos5l_decap_8
X_4572_ _4572_/X _4545_/X Tile_X0Y9_N4END[12] _4544_/X _0152_/X _2487_/Q _2486_/Q
+ VPWR VGND sg13cmos5l_mux4_1
XFILLER_698_227 VPWR VGND sg13cmos5l_decap_8
X_1784_ _1784_/Q Tile_X0Y3_FrameData[17] VGND VPWR Tile_X0Y9_FrameStrobe[3] latch
XFILLER_698_238 VPWR VGND sg13cmos5l_fill_1
XFILLER_574_49 VPWR VGND sg13cmos5l_decap_8
XFILLER_357_84 VPWR VGND sg13cmos5l_decap_8
XFILLER_507_21 VPWR VGND sg13cmos5l_decap_8
XFILLER_505_150 VPWR VGND sg13cmos5l_decap_8
XFILLER_293_28 VPWR VGND sg13cmos5l_decap_8
X_0735_ _0735_/Q Tile_X0Y9_FrameData[0] VGND VPWR Tile_X0Y9_FrameStrobe[1] latch
X_3523_ Tile_X0Y9_E1BEG[1] _4845_/X VPWR VGND sg13cmos5l_buf_1
XFILLER_304_234 VPWR VGND sg13cmos5l_decap_8
XFILLER_115_145 VPWR VGND sg13cmos5l_decap_8
XFILLER_520_120 VPWR VGND sg13cmos5l_decap_8
X_3454_ Tile_X0Y1_FrameData_O[12] Tile_X0Y1_FrameData[12] VPWR VGND sg13cmos5l_buf_1
X_0666_ _0666_/Q Tile_X0Y8_FrameData[5] VGND VPWR Tile_X0Y9_FrameStrobe[7] latch
XFILLER_507_98 VPWR VGND sg13cmos5l_decap_8
XFILLER_41_0 VPWR VGND sg13cmos5l_fill_2
X_2405_ _2405_/Q Tile_X0Y5_FrameData[0] VGND VPWR Tile_X0Y9_FrameStrobe[6] latch
XFILLER_130_126 VPWR VGND sg13cmos5l_decap_8
XFILLER_69_210 VPWR VGND sg13cmos5l_decap_8
XFILLER_373_83 VPWR VGND sg13cmos5l_decap_8
X_3385_ Tile_X0Y2_E6BEG[8] _4080_/X VPWR VGND sg13cmos5l_buf_1
XFILLER_276_119 VPWR VGND sg13cmos5l_decap_8
X_0597_ _0597_/Q Tile_X0Y8_FrameData[10] VGND VPWR Tile_X0Y9_FrameStrobe[5] latch
XFILLER_520_197 VPWR VGND sg13cmos5l_fill_2
XFILLER_681_116 VPWR VGND sg13cmos5l_decap_4
XFILLER_523_42 VPWR VGND sg13cmos5l_decap_8
X_2336_ _2336_/Q Tile_X0Y5_FrameData[5] VGND VPWR Tile_X0Y9_FrameStrobe[4] latch
XFILLER_473_230 VPWR VGND sg13cmos5l_decap_8
XFILLER_242_21 VPWR VGND sg13cmos5l_decap_8
XFILLER_674_190 VPWR VGND sg13cmos5l_decap_8
XFILLER_418_157 VPWR VGND sg13cmos5l_decap_8
X_2267_ _2267_/Q Tile_X0Y5_FrameData[10] VGND VPWR Tile_X0Y9_FrameStrobe[2] latch
XFILLER_418_168 VPWR VGND sg13cmos5l_fill_2
XFILLER_433_105 VPWR VGND sg13cmos5l_decap_8
XFILLER_599_35 VPWR VGND sg13cmos5l_decap_8
X_4006_ _4006_/X Tile_X0Y5_W1END[3] Tile_X0Y5_WW4END[3] Tile_X0Y5_W6END[11] _4454_/X
+ _2406_/Q _2405_/Q VPWR VGND sg13cmos5l_mux4_1
XFILLER_284_196 VPWR VGND sg13cmos5l_decap_8
XFILLER_84_268 VPWR VGND sg13cmos5l_decap_4
X_1218_ _1218_/Q Tile_X0Y1_FrameData[23] VGND VPWR Tile_X0Y9_FrameStrobe[1] latch
XFILLER_242_87 VPWR VGND sg13cmos5l_decap_8
XFILLER_37_151 VPWR VGND sg13cmos5l_fill_1
XFILLER_225_230 VPWR VGND sg13cmos5l_fill_2
X_2198_ _2198_/Q Tile_X0Y5_FrameData[15] VGND VPWR Tile_X0Y9_FrameStrobe[0] latch
XFILLER_599_79 VPWR VGND sg13cmos5l_decap_8
XFILLER_52_110 VPWR VGND sg13cmos5l_decap_4
XFILLER_111_14 VPWR VGND sg13cmos5l_decap_8
X_1149_ _1149_/Q Tile_X0Y0_FrameData[14] VGND VPWR Tile_X0Y9_FrameStrobe[6] latch
XFILLER_587_153 VPWR VGND sg13cmos5l_decap_4
XFILLER_587_164 VPWR VGND sg13cmos5l_decap_8
XFILLER_386_215 VPWR VGND sg13cmos5l_fill_2
XFILLER_468_28 VPWR VGND sg13cmos5l_decap_8
XFILLER_197_137 VPWR VGND sg13cmos5l_decap_8
XANTENNA__2761__X Tile_X0Y3_FrameData_O[19] VPWR VGND sg13cmos5l_antennanp
XFILLER_386_259 VPWR VGND sg13cmos5l_decap_8
X_4908_ _4908_/X Tile_X0Y5_W1END[0] Tile_X0Y5_WW4END[12] Tile_X0Y5_W6END[4] _4451_/X
+ _2379_/Q _2378_/Q VPWR VGND sg13cmos5l_mux4_1
XFILLER_200_119 VPWR VGND sg13cmos5l_decap_4
XFILLER_339_175 VPWR VGND sg13cmos5l_decap_8
X_4839_ _4839_/X _4921_/X _4925_/X _4929_/X _4904_/X _0864_/Q _0863_/Q VPWR VGND sg13cmos5l_mux4_1
XFILLER_354_112 VPWR VGND sg13cmos5l_decap_8
XFILLER_138_248 VPWR VGND sg13cmos5l_decap_4
XFILLER_217_7 VPWR VGND sg13cmos5l_decap_8
XFILLER_484_49 VPWR VGND sg13cmos5l_decap_8
XFILLER_267_84 VPWR VGND sg13cmos5l_decap_8
XFILLER_417_21 VPWR VGND sg13cmos5l_decap_8
XFILLER_354_189 VPWR VGND sg13cmos5l_decap_8
XANTENNA__3592__X Tile_X0Y9_FrameData_O[22] VPWR VGND sg13cmos5l_antennanp
XFILLER_106_134 VPWR VGND sg13cmos5l_decap_8
XFILLER_697_260 VPWR VGND sg13cmos5l_decap_8
XFILLER_697_271 VPWR VGND sg13cmos5l_fill_2
XFILLER_657_102 VPWR VGND sg13cmos5l_decap_8
XFILLER_700_220 VPWR VGND sg13cmos5l_decap_8
XFILLER_20_77 VPWR VGND sg13cmos5l_decap_8
XFILLER_106_167 VPWR VGND sg13cmos5l_decap_8
XFILLER_417_98 VPWR VGND sg13cmos5l_decap_8
XFILLER_136_77 VPWR VGND sg13cmos5l_decap_8
XFILLER_700_264 VPWR VGND sg13cmos5l_fill_1
XFILLER_714_63 VPWR VGND sg13cmos5l_decap_8
XFILLER_586_7 VPWR VGND sg13cmos5l_decap_8
XFILLER_96_59 VPWR VGND sg13cmos5l_fill_2
XFILLER_433_42 VPWR VGND sg13cmos5l_decap_8
XFILLER_580_70 VPWR VGND sg13cmos5l_decap_8
XFILLER_29_42 VPWR VGND sg13cmos5l_decap_8
XFILLER_152_21 VPWR VGND sg13cmos5l_decap_8
XFILLER_665_190 VPWR VGND sg13cmos5l_decap_8
XANTENNA__2936__X Tile_X0Y8_E6BEG[4] VPWR VGND sg13cmos5l_antennanp
XFILLER_75_235 VPWR VGND sg13cmos5l_decap_4
XFILLER_275_163 VPWR VGND sg13cmos5l_decap_4
XFILLER_424_105 VPWR VGND sg13cmos5l_decap_8
XFILLER_29_86 VPWR VGND sg13cmos5l_decap_8
XFILLER_680_160 VPWR VGND sg13cmos5l_decap_4
XFILLER_302_35 VPWR VGND sg13cmos5l_decap_8
XFILLER_45_30 VPWR VGND sg13cmos5l_decap_8
XFILLER_28_173 VPWR VGND sg13cmos5l_decap_8
XFILLER_43_121 VPWR VGND sg13cmos5l_decap_8
XFILLER_659_49 VPWR VGND sg13cmos5l_decap_8
XFILLER_621_260 VPWR VGND sg13cmos5l_decap_8
XFILLER_621_271 VPWR VGND sg13cmos5l_fill_2
XFILLER_432_182 VPWR VGND sg13cmos5l_decap_8
XFILLER_593_101 VPWR VGND sg13cmos5l_fill_2
XFILLER_578_186 VPWR VGND sg13cmos5l_decap_8
XFILLER_231_255 VPWR VGND sg13cmos5l_decap_4
XFILLER_243_0 VPWR VGND sg13cmos5l_decap_8
XFILLER_43_198 VPWR VGND sg13cmos5l_decap_8
XFILLER_593_145 VPWR VGND sg13cmos5l_decap_4
XFILLER_519_231 VPWR VGND sg13cmos5l_decap_4
XFILLER_392_207 VPWR VGND sg13cmos5l_decap_8
XFILLER_101_91 VPWR VGND sg13cmos5l_decap_8
XFILLER_129_215 VPWR VGND sg13cmos5l_decap_8
XFILLER_129_226 VPWR VGND sg13cmos5l_fill_2
XFILLER_196_170 VPWR VGND sg13cmos5l_fill_2
XFILLER_410_0 VPWR VGND sg13cmos5l_decap_8
XFILLER_61_84 VPWR VGND sg13cmos5l_decap_8
XFILLER_508_0 VPWR VGND sg13cmos5l_decap_8
XFILLER_345_134 VPWR VGND sg13cmos5l_decap_4
XFILLER_608_42 VPWR VGND sg13cmos5l_decap_8
XFILLER_345_167 VPWR VGND sg13cmos5l_decap_8
XFILLER_177_95 VPWR VGND sg13cmos5l_fill_1
XFILLER_6_35 VPWR VGND sg13cmos5l_decap_8
XANTENNA_6 AXI_M_SOC_RDATA26 VPWR VGND sg13cmos5l_antennanp
XFILLER_691_14 VPWR VGND sg13cmos5l_decap_8
XFILLER_327_43 VPWR VGND sg13cmos5l_decap_4
X_0520_ _0520_/Q Tile_X0Y8_FrameData[23] VGND VPWR Tile_X0Y9_FrameStrobe[3] latch
XFILLER_499_182 VPWR VGND sg13cmos5l_decap_8
XFILLER_112_115 VPWR VGND sg13cmos5l_decap_4
XFILLER_301_215 VPWR VGND sg13cmos5l_fill_2
XFILLER_258_108 VPWR VGND sg13cmos5l_fill_2
X_0451_ _0451_/Q Tile_X0Y8_FrameData[28] VGND VPWR Tile_X0Y9_FrameStrobe[1] latch
XFILLER_624_63 VPWR VGND sg13cmos5l_decap_8
XFILLER_502_175 VPWR VGND sg13cmos5l_decap_8
XFILLER_648_168 VPWR VGND sg13cmos5l_decap_8
XANTENNA__3007__X Tile_X0Y5_E2BEGb[2] VPWR VGND sg13cmos5l_antennanp
XFILLER_112_148 VPWR VGND sg13cmos5l_decap_8
XFILLER_663_116 VPWR VGND sg13cmos5l_decap_8
XFILLER_343_42 VPWR VGND sg13cmos5l_decap_8
XFILLER_301_259 VPWR VGND sg13cmos5l_fill_2
X_3170_ Tile_X0Y4_E6BEG[7] _4295_/X VPWR VGND sg13cmos5l_buf_1
X_0382_ _0382_/Q Tile_X0Y7_FrameData[1] VGND VPWR Tile_X0Y9_FrameStrobe[6] latch
XFILLER_490_70 VPWR VGND sg13cmos5l_decap_8
XFILLER_86_70 VPWR VGND sg13cmos5l_decap_8
X_2121_ _2121_/Q Tile_X0Y4_FrameData[28] VGND VPWR Tile_X0Y9_FrameStrobe[6] latch
XANTENNA__2846__X Tile_X0Y6_E2BEGb[3] VPWR VGND sg13cmos5l_antennanp
XFILLER_455_263 VPWR VGND sg13cmos5l_fill_2
XFILLER_120_192 VPWR VGND sg13cmos5l_decap_4
XFILLER_66_246 VPWR VGND sg13cmos5l_decap_8
XFILLER_66_268 VPWR VGND sg13cmos5l_decap_4
X_2052_ _2052_/Q Tile_X0Y4_FrameData[1] VGND VPWR Tile_X0Y9_FrameStrobe[3] latch
XFILLER_281_133 VPWR VGND sg13cmos5l_decap_8
XFILLER_640_84 VPWR VGND sg13cmos5l_decap_8
XFILLER_19_162 VPWR VGND sg13cmos5l_decap_8
XFILLER_212_35 VPWR VGND sg13cmos5l_decap_8
XFILLER_81_238 VPWR VGND sg13cmos5l_decap_8
X_1003_ _1003_/Q Tile_X0Y0_FrameData[0] VGND VPWR Tile_X0Y9_FrameStrobe[1] latch
XFILLER_569_49 VPWR VGND sg13cmos5l_decap_8
XFILLER_430_119 VPWR VGND sg13cmos5l_decap_8
XFILLER_569_175 VPWR VGND sg13cmos5l_decap_8
XFILLER_584_112 VPWR VGND sg13cmos5l_fill_1
XFILLER_222_255 VPWR VGND sg13cmos5l_decap_8
XFILLER_368_259 VPWR VGND sg13cmos5l_fill_1
X_2954_ Tile_X0Y8_EE4BEG[10] _4754_/X VPWR VGND sg13cmos5l_buf_1
XFILLER_368_50 VPWR VGND sg13cmos5l_decap_8
XFILLER_89_0 VPWR VGND sg13cmos5l_decap_8
X_1905_ _1905_/Q Tile_X0Y3_FrameData[24] VGND VPWR Tile_X0Y9_FrameStrobe[7] latch
XFILLER_525_212 VPWR VGND sg13cmos5l_decap_8
X_2885_ Tile_X0Y6_FrameData_O[6] Tile_X0Y6_FrameData[6] VPWR VGND sg13cmos5l_buf_1
XFILLER_525_223 VPWR VGND sg13cmos5l_fill_1
XFILLER_518_42 VPWR VGND sg13cmos5l_decap_8
X_4624_ _4624_/X Tile_X0Y7_W2END[3] AXI_M_SOC_RDATA19 _4675_/X _4674_/X _0311_/Q _0310_/Q
+ VPWR VGND sg13cmos5l_mux4_1
XFILLER_525_245 VPWR VGND sg13cmos5l_decap_8
X_1836_ _1836_/Q Tile_X0Y3_FrameData[29] VGND VPWR Tile_X0Y9_FrameStrobe[5] latch
XFILLER_135_218 VPWR VGND sg13cmos5l_decap_8
XFILLER_665_70 VPWR VGND sg13cmos5l_decap_8
XFILLER_336_167 VPWR VGND sg13cmos5l_decap_4
XFILLER_237_21 VPWR VGND sg13cmos5l_decap_8
X_1767_ _1767_/Q Tile_X0Y3_FrameData[2] VGND VPWR Tile_X0Y9_FrameStrobe[2] latch
X_4555_ _4555_/X _4471_/X _4587_/X _4586_/X _4470_/X _2461_/Q _2460_/Q VPWR VGND sg13cmos5l_mux4_1
XFILLER_540_226 VPWR VGND sg13cmos5l_decap_8
XFILLER_497_119 VPWR VGND sg13cmos5l_decap_8
XFILLER_351_126 VPWR VGND sg13cmos5l_decap_8
XFILLER_686_219 VPWR VGND sg13cmos5l_decap_8
XFILLER_237_65 VPWR VGND sg13cmos5l_decap_8
XFILLER_679_271 VPWR VGND sg13cmos5l_fill_2
XFILLER_237_76 VPWR VGND sg13cmos5l_fill_2
X_0718_ _0718_/Q Tile_X0Y9_FrameData[17] VGND VPWR Tile_X0Y9_FrameStrobe[1] latch
X_3506_ Tile_X0Y1_E2BEGb[4] _3944_/X VPWR VGND sg13cmos5l_buf_1
XFILLER_289_233 VPWR VGND sg13cmos5l_fill_1
X_1698_ _1698_/Q Tile_X0Y3_FrameData[7] VGND VPWR Tile_X0Y9_FrameStrobe[0] latch
X_4486_ _4486_/X Tile_X0Y6_W1END[1] Tile_X0Y6_WW4END[13] Tile_X0Y6_W6END[5] _4569_/X
+ _2632_/Q _2631_/Q VPWR VGND sg13cmos5l_mux4_1
XFILLER_103_126 VPWR VGND sg13cmos5l_decap_8
XFILLER_534_63 VPWR VGND sg13cmos5l_decap_8
XFILLER_249_108 VPWR VGND sg13cmos5l_fill_1
X_0649_ _0649_/Q Tile_X0Y8_FrameData[22] VGND VPWR Tile_X0Y9_FrameStrobe[7] latch
X_3437_ Tile_X0Y4_FrameData_O[28] Tile_X0Y4_FrameData[28] VPWR VGND sg13cmos5l_buf_1
XFILLER_639_168 VPWR VGND sg13cmos5l_decap_8
XFILLER_106_36 VPWR VGND sg13cmos5l_decap_8
XFILLER_253_42 VPWR VGND sg13cmos5l_decap_8
X_3368_ Tile_X0Y2_EE4BEG[7] _4063_/X VPWR VGND sg13cmos5l_buf_1
XFILLER_654_149 VPWR VGND sg13cmos5l_decap_8
XANTENNA__2756__X Tile_X0Y3_FrameData_O[14] VPWR VGND sg13cmos5l_antennanp
XFILLER_57_224 VPWR VGND sg13cmos5l_decap_8
XFILLER_111_181 VPWR VGND sg13cmos5l_decap_8
X_2319_ _2319_/Q Tile_X0Y5_FrameData[22] VGND VPWR Tile_X0Y9_FrameStrobe[4] latch
XFILLER_446_263 VPWR VGND sg13cmos5l_fill_2
X_3299_ Tile_X0Y0_E2BEGb[7] _3819_/X VPWR VGND sg13cmos5l_buf_1
XFILLER_272_100 VPWR VGND sg13cmos5l_decap_4
XFILLER_461_211 VPWR VGND sg13cmos5l_decap_8
XFILLER_406_127 VPWR VGND sg13cmos5l_decap_4
XFILLER_122_35 VPWR VGND sg13cmos5l_decap_8
XFILLER_550_84 VPWR VGND sg13cmos5l_decap_8
XFILLER_72_227 VPWR VGND sg13cmos5l_decap_8
XFILLER_700_21 VPWR VGND sg13cmos5l_decap_8
XFILLER_167_7 VPWR VGND sg13cmos5l_decap_8
XFILLER_82_28 VPWR VGND sg13cmos5l_decap_8
XFILLER_421_119 VPWR VGND sg13cmos5l_decap_8
XFILLER_272_188 VPWR VGND sg13cmos5l_decap_8
XFILLER_213_211 VPWR VGND sg13cmos5l_decap_8
XFILLER_479_49 VPWR VGND sg13cmos5l_decap_8
XFILLER_603_271 VPWR VGND sg13cmos5l_fill_2
XFILLER_198_28 VPWR VGND sg13cmos5l_decap_8
XFILLER_700_98 VPWR VGND sg13cmos5l_fill_1
XFILLER_575_112 VPWR VGND sg13cmos5l_decap_8
XANTENNA__3587__X Tile_X0Y9_FrameData_O[17] VPWR VGND sg13cmos5l_antennanp
XFILLER_25_187 VPWR VGND sg13cmos5l_decap_8
XFILLER_334_7 VPWR VGND sg13cmos5l_decap_8
XFILLER_15_88 VPWR VGND sg13cmos5l_decap_8
XFILLER_575_189 VPWR VGND sg13cmos5l_decap_8
XFILLER_516_201 VPWR VGND sg13cmos5l_decap_4
XFILLER_709_63 VPWR VGND sg13cmos5l_decap_8
XFILLER_327_134 VPWR VGND sg13cmos5l_decap_8
XFILLER_501_7 VPWR VGND sg13cmos5l_decap_8
XFILLER_31_21 VPWR VGND sg13cmos5l_decap_8
XFILLER_428_42 VPWR VGND sg13cmos5l_decap_8
XFILLER_382_251 VPWR VGND sg13cmos5l_decap_4
XFILLER_575_70 VPWR VGND sg13cmos5l_decap_8
XFILLER_147_21 VPWR VGND sg13cmos5l_decap_8
XFILLER_193_184 VPWR VGND sg13cmos5l_decap_8
XFILLER_31_65 VPWR VGND sg13cmos5l_decap_8
XFILLER_488_119 VPWR VGND sg13cmos5l_fill_2
XFILLER_134_240 VPWR VGND sg13cmos5l_decap_8
XFILLER_661_28 VPWR VGND sg13cmos5l_decap_8
XFILLER_295_203 VPWR VGND sg13cmos5l_decap_4
XFILLER_444_63 VPWR VGND sg13cmos5l_fill_1
XFILLER_350_181 VPWR VGND sg13cmos5l_decap_8
XFILLER_645_105 VPWR VGND sg13cmos5l_decap_8
XFILLER_0_231 VPWR VGND sg13cmos5l_decap_8
XFILLER_496_196 VPWR VGND sg13cmos5l_decap_8
XFILLER_248_141 VPWR VGND sg13cmos5l_fill_2
XFILLER_193_0 VPWR VGND sg13cmos5l_decap_8
XFILLER_48_213 VPWR VGND sg13cmos5l_decap_8
XFILLER_102_170 VPWR VGND sg13cmos5l_decap_8
XFILLER_653_160 VPWR VGND sg13cmos5l_decap_8
XFILLER_248_196 VPWR VGND sg13cmos5l_decap_8
XFILLER_598_204 VPWR VGND sg13cmos5l_fill_2
XFILLER_452_222 VPWR VGND sg13cmos5l_decap_8
XFILLER_63_216 VPWR VGND sg13cmos5l_decap_8
XFILLER_610_21 VPWR VGND sg13cmos5l_decap_8
XFILLER_460_95 VPWR VGND sg13cmos5l_decap_8
XFILLER_360_0 VPWR VGND sg13cmos5l_decap_8
XFILLER_598_248 VPWR VGND sg13cmos5l_decap_8
XFILLER_458_0 VPWR VGND sg13cmos5l_decap_8
XFILLER_56_95 VPWR VGND sg13cmos5l_decap_8
XFILLER_204_200 VPWR VGND sg13cmos5l_decap_4
XFILLER_263_188 VPWR VGND sg13cmos5l_decap_8
XFILLER_389_49 VPWR VGND sg13cmos5l_decap_8
XFILLER_263_199 VPWR VGND sg13cmos5l_fill_2
XFILLER_610_76 VPWR VGND sg13cmos5l_decap_8
XFILLER_16_165 VPWR VGND sg13cmos5l_fill_2
XFILLER_71_260 VPWR VGND sg13cmos5l_fill_1
XFILLER_686_14 VPWR VGND sg13cmos5l_decap_8
XFILLER_204_255 VPWR VGND sg13cmos5l_fill_2
XFILLER_566_112 VPWR VGND sg13cmos5l_decap_8
XANTENNA__3497__X Tile_X0Y1_E6BEG[7] VPWR VGND sg13cmos5l_antennanp
XFILLER_625_0 VPWR VGND sg13cmos5l_decap_8
XFILLER_31_113 VPWR VGND sg13cmos5l_decap_8
XFILLER_82_7 VPWR VGND sg13cmos5l_decap_8
XFILLER_566_189 VPWR VGND sg13cmos5l_decap_8
XFILLER_358_270 VPWR VGND sg13cmos5l_fill_2
XFILLER_619_63 VPWR VGND sg13cmos5l_decap_8
XFILLER_318_112 VPWR VGND sg13cmos5l_decap_8
XFILLER_581_126 VPWR VGND sg13cmos5l_decap_8
XFILLER_507_223 VPWR VGND sg13cmos5l_decap_8
XFILLER_318_123 VPWR VGND sg13cmos5l_fill_2
XFILLER_338_42 VPWR VGND sg13cmos5l_decap_4
X_2670_ _2670_/Q Tile_X0Y6_FrameData[25] VGND VPWR Tile_X0Y9_FrameStrobe[7] latch
XFILLER_117_207 VPWR VGND sg13cmos5l_decap_8
XFILLER_184_162 VPWR VGND sg13cmos5l_decap_8
XFILLER_485_70 VPWR VGND sg13cmos5l_decap_8
XFILLER_485_81 VPWR VGND sg13cmos5l_fill_2
X_1621_ _1621_/Q Tile_X0Y2_FrameData[28] VGND VPWR Tile_X0Y9_FrameStrobe[6] latch
XFILLER_338_86 VPWR VGND sg13cmos5l_decap_4
XFILLER_333_115 VPWR VGND sg13cmos5l_decap_8
XFILLER_318_189 VPWR VGND sg13cmos5l_decap_8
XFILLER_333_137 VPWR VGND sg13cmos5l_decap_8
XFILLER_333_148 VPWR VGND sg13cmos5l_decap_8
X_1552_ _1552_/Q Tile_X0Y2_FrameData[1] VGND VPWR Tile_X0Y9_FrameStrobe[3] latch
X_4340_ _4340_/X _4302_/X _0099_/X _4301_/X _0112_/X _1973_/Q _1972_/Q VPWR VGND sg13cmos5l_mux4_1
XFILLER_125_262 VPWR VGND sg13cmos5l_fill_2
XFILLER_207_35 VPWR VGND sg13cmos5l_decap_8
XFILLER_635_84 VPWR VGND sg13cmos5l_decap_8
XFILLER_140_210 VPWR VGND sg13cmos5l_decap_8
X_0503_ _0503_/Q Tile_X0Y8_FrameData[8] VGND VPWR Tile_X0Y9_FrameStrobe[2] latch
X_4271_ _4271_/X Tile_X0Y4_W2END[0] AXI_M_SOC_BRESP0 _4313_/X _4312_/X _2071_/Q _2070_/Q
+ VPWR VGND sg13cmos5l_mux4_1
XFILLER_571_28 VPWR VGND sg13cmos5l_decap_8
XFILLER_354_63 VPWR VGND sg13cmos5l_decap_8
XFILLER_286_203 VPWR VGND sg13cmos5l_decap_8
X_1483_ _1483_/Q Tile_X0Y2_FrameData[6] VGND VPWR Tile_X0Y9_FrameStrobe[1] latch
XFILLER_636_105 VPWR VGND sg13cmos5l_decap_8
XFILLER_98_168 VPWR VGND sg13cmos5l_decap_8
X_3222_ Tile_X0Y0_FrameStrobe_O[10] Tile_X0Y9_FrameStrobe[10] VPWR VGND sg13cmos5l_buf_1
XFILLER_98_179 VPWR VGND sg13cmos5l_fill_1
X_0434_ _0434_/Q Tile_X0Y8_FrameData[13] VGND VPWR Tile_X0Y9_FrameStrobe[0] latch
XFILLER_290_29 VPWR VGND sg13cmos5l_decap_8
XFILLER_286_258 VPWR VGND sg13cmos5l_fill_1
XFILLER_39_202 VPWR VGND sg13cmos5l_decap_4
XFILLER_428_252 VPWR VGND sg13cmos5l_decap_8
X_3153_ Tile_X0Y7_FrameData_O[23] Tile_X0Y7_FrameData[23] VPWR VGND sg13cmos5l_buf_1
XFILLER_504_77 VPWR VGND sg13cmos5l_decap_8
X_0365_ _0365_/Q Tile_X0Y7_FrameData[18] VGND VPWR Tile_X0Y9_FrameStrobe[6] latch
XFILLER_428_263 VPWR VGND sg13cmos5l_fill_2
XFILLER_651_119 VPWR VGND sg13cmos5l_decap_8
XFILLER_443_211 VPWR VGND sg13cmos5l_decap_8
X_2104_ _2104_/Q Tile_X0Y4_FrameData[13] VGND VPWR Tile_X0Y9_FrameStrobe[5] latch
XFILLER_254_122 VPWR VGND sg13cmos5l_decap_8
XFILLER_644_182 VPWR VGND sg13cmos5l_decap_8
X_3084_ Tile_X0Y7_E1BEG[2] _4610_/X VPWR VGND sg13cmos5l_buf_1
X_0296_ _0296_/Q Tile_X0Y7_FrameData[23] VGND VPWR Tile_X0Y9_FrameStrobe[4] latch
XFILLER_520_21 VPWR VGND sg13cmos5l_decap_8
XFILLER_54_238 VPWR VGND sg13cmos5l_decap_8
X_2035_ _2035_/Q Tile_X0Y4_FrameData[18] VGND VPWR Tile_X0Y9_FrameStrobe[3] latch
XFILLER_54_249 VPWR VGND sg13cmos5l_fill_2
XFILLER_254_188 VPWR VGND sg13cmos5l_decap_4
XFILLER_299_49 VPWR VGND sg13cmos5l_decap_8
XFILLER_520_87 VPWR VGND sg13cmos5l_decap_8
XFILLER_596_14 VPWR VGND sg13cmos5l_decap_8
XFILLER_520_98 VPWR VGND sg13cmos5l_fill_1
XFILLER_62_271 VPWR VGND sg13cmos5l_fill_2
XFILLER_22_135 VPWR VGND sg13cmos5l_decap_8
XFILLER_557_145 VPWR VGND sg13cmos5l_decap_8
XANTENNA__3200__X Tile_X0Y0_N2BEG[0] VPWR VGND sg13cmos5l_antennanp
XFILLER_210_225 VPWR VGND sg13cmos5l_fill_2
X_3986_ _3986_/X Tile_X0Y0_W1END[3] Tile_X0Y0_W6END[11] _3863_/X _3880_/X _1135_/Q
+ _1134_/Q VPWR VGND sg13cmos5l_mux4_1
XFILLER_411_185 VPWR VGND sg13cmos5l_fill_1
X_2937_ Tile_X0Y8_E6BEG[5] _4765_/X VPWR VGND sg13cmos5l_buf_1
XFILLER_572_126 VPWR VGND sg13cmos5l_decap_8
XFILLER_676_91 VPWR VGND sg13cmos5l_fill_1
XFILLER_248_42 VPWR VGND sg13cmos5l_decap_8
XFILLER_364_251 VPWR VGND sg13cmos5l_decap_4
XFILLER_30_190 VPWR VGND sg13cmos5l_decap_8
X_2868_ Tile_X0Y6_EE4BEG[5] _4517_/X VPWR VGND sg13cmos5l_buf_1
XFILLER_395_92 VPWR VGND sg13cmos5l_decap_4
XFILLER_324_115 VPWR VGND sg13cmos5l_decap_8
X_4607_ _4607_/X _4691_/X _4695_/X _4699_/X _4668_/X _0346_/Q _0345_/Q VPWR VGND sg13cmos5l_mux4_1
XFILLER_714_175 VPWR VGND sg13cmos5l_decap_8
X_1819_ _1819_/Q Tile_X0Y3_FrameData[14] VGND VPWR Tile_X0Y9_FrameStrobe[4] latch
XFILLER_659_208 VPWR VGND sg13cmos5l_decap_8
X_2799_ Tile_X0Y3_E6BEG[9] _4189_/X VPWR VGND sg13cmos5l_buf_1
XFILLER_116_240 VPWR VGND sg13cmos5l_decap_8
X_4538_ _4538_/X AXI_M_SOC_RDATA30 _4569_/X _4573_/X _4554_/X _2531_/Q _2530_/Q VPWR
+ VGND sg13cmos5l_mux4_1
XFILLER_89_102 VPWR VGND sg13cmos5l_decap_8
XFILLER_545_84 VPWR VGND sg13cmos5l_decap_8
XFILLER_117_35 VPWR VGND sg13cmos5l_decap_8
XFILLER_190_187 VPWR VGND sg13cmos5l_decap_8
XFILLER_481_28 VPWR VGND sg13cmos5l_decap_8
X_4469_ _4469_/X Tile_X0Y7_W2MID[7] Tile_X0Y7_W2END[7] Tile_X0Y7_W6END[7] _4669_/X
+ _0407_/Q _0406_/Q VPWR VGND sg13cmos5l_mux4_1
XFILLER_264_74 VPWR VGND sg13cmos5l_decap_8
XFILLER_89_168 VPWR VGND sg13cmos5l_decap_8
XFILLER_627_116 VPWR VGND sg13cmos5l_decap_4
XFILLER_627_127 VPWR VGND sg13cmos5l_decap_8
XFILLER_493_133 VPWR VGND sg13cmos5l_decap_8
XFILLER_277_258 VPWR VGND sg13cmos5l_fill_1
XFILLER_291_8 VPWR VGND sg13cmos5l_decap_8
XFILLER_682_266 VPWR VGND sg13cmos5l_decap_8
XFILLER_419_252 VPWR VGND sg13cmos5l_decap_8
XFILLER_414_77 VPWR VGND sg13cmos5l_fill_2
XFILLER_642_119 VPWR VGND sg13cmos5l_decap_8
XFILLER_284_7 VPWR VGND sg13cmos5l_decap_8
XFILLER_133_56 VPWR VGND sg13cmos5l_decap_8
XFILLER_434_211 VPWR VGND sg13cmos5l_fill_2
XFILLER_711_42 VPWR VGND sg13cmos5l_decap_8
XFILLER_635_182 VPWR VGND sg13cmos5l_decap_8
XFILLER_245_133 VPWR VGND sg13cmos5l_decap_8
XFILLER_45_216 VPWR VGND sg13cmos5l_decap_8
XFILLER_280_84 VPWR VGND sg13cmos5l_decap_8
XFILLER_434_255 VPWR VGND sg13cmos5l_fill_2
XFILLER_430_21 VPWR VGND sg13cmos5l_decap_8
XANTENNA_204 Tile_X0Y9_N2MID[6] VPWR VGND sg13cmos5l_antennanp
XFILLER_26_21 VPWR VGND sg13cmos5l_decap_8
XFILLER_451_7 VPWR VGND sg13cmos5l_decap_8
XANTENNA_215 Tile_X0Y9_N4END[14] VPWR VGND sg13cmos5l_antennanp
XANTENNA_226 Tile_X0Y9_N4END[14] VPWR VGND sg13cmos5l_antennanp
XFILLER_595_207 VPWR VGND sg13cmos5l_decap_8
XFILLER_549_7 VPWR VGND sg13cmos5l_decap_8
XANTENNA_237 _4594_/X VPWR VGND sg13cmos5l_antennanp
XFILLER_198_210 VPWR VGND sg13cmos5l_fill_1
XFILLER_650_196 VPWR VGND sg13cmos5l_decap_8
XFILLER_430_98 VPWR VGND sg13cmos5l_decap_8
XFILLER_399_181 VPWR VGND sg13cmos5l_decap_8
XFILLER_198_232 VPWR VGND sg13cmos5l_decap_8
XFILLER_402_163 VPWR VGND sg13cmos5l_decap_8
XFILLER_201_214 VPWR VGND sg13cmos5l_decap_8
XFILLER_716_7 VPWR VGND sg13cmos5l_decap_4
XFILLER_289_93 VPWR VGND sg13cmos5l_fill_2
XANTENNA__3110__X Tile_X0Y7_E6BEG[8] VPWR VGND sg13cmos5l_antennanp
XFILLER_347_229 VPWR VGND sg13cmos5l_decap_8
XFILLER_9_128 VPWR VGND sg13cmos5l_decap_8
XFILLER_656_28 VPWR VGND sg13cmos5l_decap_8
XFILLER_563_126 VPWR VGND sg13cmos5l_decap_8
XFILLER_439_63 VPWR VGND sg13cmos5l_decap_8
XFILLER_42_42 VPWR VGND sg13cmos5l_decap_8
XFILLER_439_74 VPWR VGND sg13cmos5l_fill_2
XFILLER_586_91 VPWR VGND sg13cmos5l_decap_8
XFILLER_21_190 VPWR VGND sg13cmos5l_decap_8
XFILLER_158_64 VPWR VGND sg13cmos5l_decap_4
XFILLER_705_164 VPWR VGND sg13cmos5l_fill_1
XFILLER_181_121 VPWR VGND sg13cmos5l_decap_8
XFILLER_370_221 VPWR VGND sg13cmos5l_decap_8
XFILLER_181_143 VPWR VGND sg13cmos5l_decap_8
XFILLER_504_237 VPWR VGND sg13cmos5l_decap_8
XFILLER_315_148 VPWR VGND sg13cmos5l_decap_8
XFILLER_206_0 VPWR VGND sg13cmos5l_decap_8
XFILLER_455_73 VPWR VGND sg13cmos5l_decap_4
XFILLER_469_130 VPWR VGND sg13cmos5l_decap_8
XFILLER_605_21 VPWR VGND sg13cmos5l_decap_8
XFILLER_469_141 VPWR VGND sg13cmos5l_fill_2
XFILLER_658_252 VPWR VGND sg13cmos5l_fill_2
XFILLER_391_28 VPWR VGND sg13cmos5l_decap_8
XFILLER_323_181 VPWR VGND sg13cmos5l_decap_4
XFILLER_618_105 VPWR VGND sg13cmos5l_decap_8
XFILLER_3_14 VPWR VGND sg13cmos5l_decap_8
XFILLER_469_185 VPWR VGND sg13cmos5l_fill_2
XFILLER_324_22 VPWR VGND sg13cmos5l_decap_8
XFILLER_95_105 VPWR VGND sg13cmos5l_decap_8
XFILLER_673_244 VPWR VGND sg13cmos5l_decap_8
XFILLER_324_55 VPWR VGND sg13cmos5l_fill_1
XFILLER_268_269 VPWR VGND sg13cmos5l_decap_4
XFILLER_575_0 VPWR VGND sg13cmos5l_decap_8
XFILLER_324_66 VPWR VGND sg13cmos5l_decap_8
XFILLER_484_166 VPWR VGND sg13cmos5l_fill_1
XFILLER_471_72 VPWR VGND sg13cmos5l_decap_8
XFILLER_283_217 VPWR VGND sg13cmos5l_decap_8
XFILLER_484_188 VPWR VGND sg13cmos5l_decap_8
XFILLER_633_119 VPWR VGND sg13cmos5l_decap_8
XFILLER_236_111 VPWR VGND sg13cmos5l_decap_8
XFILLER_621_42 VPWR VGND sg13cmos5l_decap_8
X_0150_ _0150_/X _4566_/X _4567_/X _1602_/Q VPWR VGND sg13cmos5l_mux2_1
XFILLER_340_21 VPWR VGND sg13cmos5l_decap_8
X_0081_ _0081_/X _4912_/X _4913_/X _2371_/Q VPWR VGND sg13cmos5l_mux2_1
XFILLER_251_114 VPWR VGND sg13cmos5l_decap_8
XFILLER_397_107 VPWR VGND sg13cmos5l_decap_8
XFILLER_697_35 VPWR VGND sg13cmos5l_decap_8
XFILLER_641_196 VPWR VGND sg13cmos5l_decap_8
XFILLER_189_221 VPWR VGND sg13cmos5l_decap_8
XFILLER_44_260 VPWR VGND sg13cmos5l_fill_1
XFILLER_189_232 VPWR VGND sg13cmos5l_fill_2
XFILLER_539_134 VPWR VGND sg13cmos5l_decap_8
X_3840_ _3840_/X Tile_X0Y0_WW4END[11] _3879_/X _3864_/X _3853_/X _1025_/Q _1024_/Q
+ VPWR VGND sg13cmos5l_mux4_1
XANTENNA__3020__X Tile_X0Y5_E6BEG[7] VPWR VGND sg13cmos5l_antennanp
XFILLER_594_251 VPWR VGND sg13cmos5l_fill_1
XFILLER_594_262 VPWR VGND sg13cmos5l_fill_2
XFILLER_338_229 VPWR VGND sg13cmos5l_decap_4
XFILLER_554_115 VPWR VGND sg13cmos5l_decap_4
XFILLER_566_28 VPWR VGND sg13cmos5l_decap_8
XFILLER_349_63 VPWR VGND sg13cmos5l_decap_8
X_0983_ _0983_/Q Tile_X0Y0_FrameData[20] VGND VPWR Tile_X0Y9_FrameStrobe[1] latch
X_3771_ _3771_/X Tile_X0Y0_WW4END[0] Tile_X0Y0_WW4END[8] Tile_X0Y0_W6END[0] _3881_/X
+ _1009_/Q _1008_/Q VPWR VGND sg13cmos5l_mux4_1
XFILLER_496_91 VPWR VGND sg13cmos5l_decap_8
X_2722_ _4657_/A3 VPWR VGND sg13cmos5l_tielo
XFILLER_361_210 VPWR VGND sg13cmos5l_decap_8
X_2653_ _2653_/Q Tile_X0Y6_FrameData[10] VGND VPWR Tile_X0Y9_FrameStrobe[6] latch
XFILLER_172_143 VPWR VGND sg13cmos5l_fill_1
XFILLER_711_112 VPWR VGND sg13cmos5l_decap_8
XFILLER_218_56 VPWR VGND sg13cmos5l_decap_8
X_1604_ _1604_/Q Tile_X0Y2_FrameData[13] VGND VPWR Tile_X0Y9_FrameStrobe[5] latch
X_2584_ _2584_/Q Tile_X0Y6_FrameData[15] VGND VPWR Tile_X0Y9_FrameStrobe[4] latch
XFILLER_582_49 VPWR VGND sg13cmos5l_decap_8
XFILLER_515_21 VPWR VGND sg13cmos5l_decap_8
X_4323_ _4323_/X _4804_/X _4808_/X _4812_/X _4785_/X _0647_/Q _0646_/Q VPWR VGND sg13cmos5l_mux4_1
X_1535_ _1535_/Q Tile_X0Y2_FrameData[18] VGND VPWR Tile_X0Y9_FrameStrobe[3] latch
XFILLER_314_181 VPWR VGND sg13cmos5l_decap_8
XANTENNA__3690__X AXI_M_SOC_WDATA0 VPWR VGND sg13cmos5l_antennanp
XFILLER_259_225 VPWR VGND sg13cmos5l_fill_2
XFILLER_475_122 VPWR VGND sg13cmos5l_decap_8
XFILLER_86_105 VPWR VGND sg13cmos5l_decap_8
X_1466_ _1466_/Q Tile_X0Y2_FrameData[23] VGND VPWR Tile_X0Y9_FrameStrobe[1] latch
X_4254_ _4254_/X _4308_/X _4307_/X AXI_M_SOC_BRESP1 _4306_/X _2105_/Q _2104_/Q VPWR
+ VGND sg13cmos5l_mux4_1
XFILLER_664_233 VPWR VGND sg13cmos5l_decap_8
XFILLER_515_98 VPWR VGND sg13cmos5l_decap_8
XFILLER_259_269 VPWR VGND sg13cmos5l_decap_4
X_0417_ _0417_/Q Tile_X0Y8_FrameData[30] VGND VPWR Tile_X0Y9_FrameStrobe[0] latch
X_3205_ Tile_X0Y0_N2BEG[5] _3789_/X VPWR VGND sg13cmos5l_buf_1
XFILLER_234_88 VPWR VGND sg13cmos5l_decap_8
X_1397_ _1397_/Q Tile_X0Y1_FrameData[4] VGND VPWR Tile_X0Y9_FrameStrobe[6] latch
X_4185_ _4185_/X AXI_M_SOC_BVALID _4228_/X _4232_/X _4207_/X _1771_/Q _1770_/Q VPWR
+ VGND sg13cmos5l_mux4_1
XFILLER_475_199 VPWR VGND sg13cmos5l_decap_8
XFILLER_416_211 VPWR VGND sg13cmos5l_decap_8
XFILLER_531_42 VPWR VGND sg13cmos5l_decap_8
XFILLER_617_182 VPWR VGND sg13cmos5l_decap_8
XFILLER_490_147 VPWR VGND sg13cmos5l_decap_8
X_0348_ _0348_/Q Tile_X0Y7_FrameData[3] VGND VPWR Tile_X0Y9_FrameStrobe[5] latch
X_3136_ Tile_X0Y7_FrameData_O[6] Tile_X0Y7_FrameData[6] VPWR VGND sg13cmos5l_buf_1
XFILLER_490_158 VPWR VGND sg13cmos5l_fill_2
XFILLER_250_21 VPWR VGND sg13cmos5l_decap_8
XFILLER_27_238 VPWR VGND sg13cmos5l_decap_8
XFILLER_94_193 VPWR VGND sg13cmos5l_decap_8
X_3067_ Tile_X0Y5_FrameData_O[26] Tile_X0Y5_FrameData[26] VPWR VGND sg13cmos5l_buf_1
X_0279_ _0279_/Q Tile_X0Y7_FrameData[8] VGND VPWR Tile_X0Y9_FrameStrobe[3] latch
XFILLER_242_136 VPWR VGND sg13cmos5l_decap_8
X_2018_ _2018_/Q Tile_X0Y4_FrameData[3] VGND VPWR Tile_X0Y9_FrameStrobe[2] latch
XFILLER_35_271 VPWR VGND sg13cmos5l_fill_2
XFILLER_400_35 VPWR VGND sg13cmos5l_decap_8
XFILLER_50_230 VPWR VGND sg13cmos5l_decap_4
XFILLER_585_251 VPWR VGND sg13cmos5l_decap_8
XFILLER_50_241 VPWR VGND sg13cmos5l_fill_2
XFILLER_329_218 VPWR VGND sg13cmos5l_decap_8
XFILLER_396_173 VPWR VGND sg13cmos5l_fill_2
XFILLER_476_28 VPWR VGND sg13cmos5l_decap_8
X_3969_ _3969_/X AXI_M_SOC_ARREADY _4014_/X _4018_/X _3991_/X _1271_/Q _1270_/Q VPWR
+ VGND sg13cmos5l_mux4_1
XFILLER_148_140 VPWR VGND sg13cmos5l_decap_8
XFILLER_12_56 VPWR VGND sg13cmos5l_decap_8
XFILLER_553_170 VPWR VGND sg13cmos5l_decap_8
XFILLER_498_203 VPWR VGND sg13cmos5l_decap_8
XFILLER_352_210 VPWR VGND sg13cmos5l_decap_8
XFILLER_699_163 VPWR VGND sg13cmos5l_fill_1
XFILLER_409_77 VPWR VGND sg13cmos5l_decap_8
XFILLER_699_174 VPWR VGND sg13cmos5l_decap_8
XFILLER_553_181 VPWR VGND sg13cmos5l_fill_2
XFILLER_128_56 VPWR VGND sg13cmos5l_decap_8
XFILLER_163_165 VPWR VGND sg13cmos5l_decap_8
XFILLER_706_42 VPWR VGND sg13cmos5l_decap_8
XFILLER_702_145 VPWR VGND sg13cmos5l_fill_1
XFILLER_492_49 VPWR VGND sg13cmos5l_decap_8
XFILLER_312_107 VPWR VGND sg13cmos5l_decap_8
XFILLER_275_84 VPWR VGND sg13cmos5l_decap_8
XFILLER_425_21 VPWR VGND sg13cmos5l_decap_8
XFILLER_275_95 VPWR VGND sg13cmos5l_fill_2
XFILLER_499_7 VPWR VGND sg13cmos5l_decap_8
XFILLER_655_211 VPWR VGND sg13cmos5l_decap_8
XFILLER_320_140 VPWR VGND sg13cmos5l_decap_8
XFILLER_425_98 VPWR VGND sg13cmos5l_decap_8
XFILLER_291_50 VPWR VGND sg13cmos5l_decap_8
XFILLER_466_166 VPWR VGND sg13cmos5l_decap_8
XFILLER_144_77 VPWR VGND sg13cmos5l_decap_8
XFILLER_265_228 VPWR VGND sg13cmos5l_decap_8
XFILLER_666_7 VPWR VGND sg13cmos5l_decap_8
XFILLER_481_114 VPWR VGND sg13cmos5l_fill_1
XANTENNA__3105__X Tile_X0Y7_E6BEG[3] VPWR VGND sg13cmos5l_antennanp
XFILLER_218_122 VPWR VGND sg13cmos5l_decap_8
XFILLER_670_236 VPWR VGND sg13cmos5l_decap_8
XFILLER_441_42 VPWR VGND sg13cmos5l_decap_8
XFILLER_18_205 VPWR VGND sg13cmos5l_decap_8
XFILLER_92_119 VPWR VGND sg13cmos5l_fill_1
XFILLER_481_158 VPWR VGND sg13cmos5l_decap_4
XFILLER_407_244 VPWR VGND sg13cmos5l_decap_8
XFILLER_160_21 VPWR VGND sg13cmos5l_decap_8
XFILLER_37_53 VPWR VGND sg13cmos5l_decap_8
XFILLER_37_64 VPWR VGND sg13cmos5l_fill_2
XFILLER_273_261 VPWR VGND sg13cmos5l_fill_1
XANTENNA__2944__X Tile_X0Y8_EE4BEG[0] VPWR VGND sg13cmos5l_antennanp
XFILLER_233_125 VPWR VGND sg13cmos5l_fill_2
XFILLER_422_236 VPWR VGND sg13cmos5l_decap_8
XFILLER_160_98 VPWR VGND sg13cmos5l_decap_8
XFILLER_26_271 VPWR VGND sg13cmos5l_fill_2
XFILLER_233_169 VPWR VGND sg13cmos5l_decap_8
XFILLER_156_0 VPWR VGND sg13cmos5l_decap_4
XFILLER_667_49 VPWR VGND sg13cmos5l_decap_8
XFILLER_310_79 VPWR VGND sg13cmos5l_decap_8
XFILLER_597_90 VPWR VGND sg13cmos5l_decap_8
XFILLER_169_63 VPWR VGND sg13cmos5l_decap_8
XFILLER_186_246 VPWR VGND sg13cmos5l_decap_8
XFILLER_53_96 VPWR VGND sg13cmos5l_decap_4
XFILLER_387_195 VPWR VGND sg13cmos5l_decap_4
XFILLER_386_28 VPWR VGND sg13cmos5l_decap_8
XFILLER_323_0 VPWR VGND sg13cmos5l_decap_4
XFILLER_139_140 VPWR VGND sg13cmos5l_decap_8
XFILLER_536_148 VPWR VGND sg13cmos5l_decap_8
XFILLER_328_262 VPWR VGND sg13cmos5l_decap_8
XFILLER_154_110 VPWR VGND sg13cmos5l_fill_1
XFILLER_544_170 VPWR VGND sg13cmos5l_decap_8
XFILLER_466_83 VPWR VGND sg13cmos5l_decap_8
XFILLER_343_221 VPWR VGND sg13cmos5l_decap_8
XFILLER_154_132 VPWR VGND sg13cmos5l_decap_8
XFILLER_466_94 VPWR VGND sg13cmos5l_fill_1
XFILLER_616_42 VPWR VGND sg13cmos5l_decap_8
XFILLER_5_142 VPWR VGND sg13cmos5l_fill_2
XFILLER_185_73 VPWR VGND sg13cmos5l_decap_8
XFILLER_692_0 VPWR VGND sg13cmos5l_decap_8
XFILLER_335_21 VPWR VGND sg13cmos5l_decap_8
XFILLER_303_129 VPWR VGND sg13cmos5l_fill_2
XFILLER_482_71 VPWR VGND sg13cmos5l_decap_8
XFILLER_457_111 VPWR VGND sg13cmos5l_decap_8
X_1320_ _1320_/Q Tile_X0Y1_FrameData[17] VGND VPWR Tile_X0Y9_FrameStrobe[4] latch
XFILLER_68_105 VPWR VGND sg13cmos5l_decap_8
XFILLER_335_98 VPWR VGND sg13cmos5l_decap_8
XFILLER_110_213 VPWR VGND sg13cmos5l_decap_4
XFILLER_646_266 VPWR VGND sg13cmos5l_decap_8
XFILLER_311_184 VPWR VGND sg13cmos5l_fill_1
X_1251_ _1251_/Q Tile_X0Y1_FrameData[22] VGND VPWR Tile_X0Y9_FrameStrobe[2] latch
XFILLER_632_63 VPWR VGND sg13cmos5l_decap_8
XFILLER_606_108 VPWR VGND sg13cmos5l_fill_1
XFILLER_457_177 VPWR VGND sg13cmos5l_fill_1
XFILLER_204_14 VPWR VGND sg13cmos5l_decap_8
XFILLER_457_199 VPWR VGND sg13cmos5l_decap_8
XFILLER_256_239 VPWR VGND sg13cmos5l_decap_8
XANTENNA__3015__X Tile_X0Y5_E6BEG[2] VPWR VGND sg13cmos5l_antennanp
XFILLER_83_108 VPWR VGND sg13cmos5l_decap_4
X_0202_ _0202_/Q Tile_X0Y7_FrameData[21] VGND VPWR Tile_X0Y9_FrameStrobe[1] latch
XFILLER_351_42 VPWR VGND sg13cmos5l_decap_8
X_1182_ _1182_/Q Tile_X0Y1_FrameData[27] VGND VPWR Tile_X0Y9_FrameStrobe[0] latch
XFILLER_76_171 VPWR VGND sg13cmos5l_fill_1
XANTENNA__2854__X Tile_X0Y6_E6BEG[3] VPWR VGND sg13cmos5l_antennanp
XFILLER_209_177 VPWR VGND sg13cmos5l_decap_8
XFILLER_94_81 VPWR VGND sg13cmos5l_decap_8
X_0133_ AXI_M_SOC_AWSIZE2 _0939_/Q _3681_/X VPWR VGND sg13cmos5l_nor2b_1
XFILLER_413_214 VPWR VGND sg13cmos5l_decap_8
XFILLER_91_152 VPWR VGND sg13cmos5l_decap_8
XFILLER_501_56 VPWR VGND sg13cmos5l_decap_8
X_0064_ _0064_/X _4108_/X _4109_/X _2666_/Q VPWR VGND sg13cmos5l_mux2_1
XFILLER_413_258 VPWR VGND sg13cmos5l_decap_8
XFILLER_220_35 VPWR VGND sg13cmos5l_decap_8
XFILLER_378_151 VPWR VGND sg13cmos5l_decap_8
X_4872_ _4872_/X Tile_X0Y9_WW4END[7] AXI_M_SOC_RDATA7 _4923_/X _4900_/X _0799_/Q _0798_/Q
+ VPWR VGND sg13cmos5l_mux4_1
XFILLER_577_49 VPWR VGND sg13cmos5l_decap_8
XFILLER_177_235 VPWR VGND sg13cmos5l_decap_8
XFILLER_393_110 VPWR VGND sg13cmos5l_decap_8
X_3823_ _3823_/X Tile_X0Y0_WW4END[6] Tile_X0Y0_WW4END[12] _3875_/X _3858_/X _1059_/Q
+ _1058_/Q VPWR VGND sg13cmos5l_mux4_1
XFILLER_296_28 VPWR VGND sg13cmos5l_decap_8
XFILLER_582_232 VPWR VGND sg13cmos5l_decap_8
X_3754_ AXI_M_SOC_ARADDR26 Tile_X0Y8_WW4END[2] Tile_X0Y8_WW4END[10] Tile_X0Y8_W6END[10]
+ _4810_/X _0483_/Q _0482_/Q VPWR VGND sg13cmos5l_mux4_1
XFILLER_71_0 VPWR VGND sg13cmos5l_decap_8
X_0966_ _0966_/Q Tile_X0Y0_FrameData[5] VGND VPWR Tile_X0Y9_FrameStrobe[0] latch
XFILLER_145_110 VPWR VGND sg13cmos5l_decap_8
XFILLER_192_249 VPWR VGND sg13cmos5l_decap_8
XFILLER_229_77 VPWR VGND sg13cmos5l_decap_8
X_2705_ _4309_/A3 VPWR VGND sg13cmos5l_tielo
X_3685_ _3685_/X Tile_X0Y3_WW4END[3] Tile_X0Y3_WW4END[11] Tile_X0Y3_W6END[3] _4225_/X
+ _1751_/Q _1750_/Q VPWR VGND sg13cmos5l_mux4_1
XFILLER_334_232 VPWR VGND sg13cmos5l_decap_8
X_0897_ _0897_/Q Tile_X0Y9_FrameData[30] VGND VPWR Tile_X0Y9_FrameStrobe[7] latch
XFILLER_526_42 VPWR VGND sg13cmos5l_decap_8
X_2636_ _2636_/Q Tile_X0Y6_FrameData[27] VGND VPWR Tile_X0Y9_FrameStrobe[6] latch
XFILLER_550_151 VPWR VGND sg13cmos5l_decap_8
XFILLER_696_155 VPWR VGND sg13cmos5l_decap_8
XFILLER_245_21 VPWR VGND sg13cmos5l_decap_8
X_2567_ _2567_/Q Tile_X0Y6_FrameData[0] VGND VPWR Tile_X0Y9_FrameStrobe[3] latch
XFILLER_696_188 VPWR VGND sg13cmos5l_fill_2
XFILLER_392_60 VPWR VGND sg13cmos5l_decap_8
XFILLER_58_19 VPWR VGND sg13cmos5l_fill_1
XFILLER_160_179 VPWR VGND sg13cmos5l_decap_4
X_4306_ _4306_/X _4308_/X Tile_X0Y4_W6END[2] _4307_/X _4306_/A3 _1929_/Q _1928_/Q
+ VPWR VGND sg13cmos5l_mux4_1
XFILLER_448_133 VPWR VGND sg13cmos5l_decap_8
XFILLER_302_140 VPWR VGND sg13cmos5l_decap_8
X_1518_ _1518_/Q Tile_X0Y2_FrameData[3] VGND VPWR Tile_X0Y9_FrameStrobe[2] latch
X_2498_ _2498_/Q Tile_X0Y6_FrameData[5] VGND VPWR Tile_X0Y9_FrameStrobe[1] latch
XFILLER_59_138 VPWR VGND sg13cmos5l_fill_2
XFILLER_114_14 VPWR VGND sg13cmos5l_decap_8
X_4237_ _4237_/X Tile_X0Y5_W2MID[7] Tile_X0Y5_W2END[7] Tile_X0Y5_W6END[7] _4467_/X
+ _2431_/Q _2430_/Q VPWR VGND sg13cmos5l_mux4_1
XFILLER_542_63 VPWR VGND sg13cmos5l_decap_8
X_1449_ _1449_/Q Tile_X0Y2_FrameData[8] VGND VPWR Tile_X0Y9_FrameStrobe[0] latch
XFILLER_463_114 VPWR VGND sg13cmos5l_decap_8
XFILLER_247_239 VPWR VGND sg13cmos5l_decap_8
XFILLER_261_42 VPWR VGND sg13cmos5l_decap_8
XFILLER_261_53 VPWR VGND sg13cmos5l_fill_1
X_4168_ _4168_/X Tile_X0Y3_WW4END[11] AXI_M_SOC_WREADY _4233_/X _4211_/X _1805_/Q
+ _1804_/Q VPWR VGND sg13cmos5l_mux4_1
XFILLER_463_158 VPWR VGND sg13cmos5l_fill_2
XFILLER_262_209 VPWR VGND sg13cmos5l_decap_8
XFILLER_67_182 VPWR VGND sg13cmos5l_decap_8
XFILLER_605_130 VPWR VGND sg13cmos5l_fill_1
XFILLER_261_75 VPWR VGND sg13cmos5l_fill_2
XFILLER_605_152 VPWR VGND sg13cmos5l_decap_8
XFILLER_255_272 VPWR VGND sg13cmos5l_fill_1
XANTENNA__2764__X Tile_X0Y3_FrameData_O[22] VPWR VGND sg13cmos5l_antennanp
X_3119_ Tile_X0Y7_EE4BEG[5] _4633_/X VPWR VGND sg13cmos5l_buf_1
XFILLER_215_125 VPWR VGND sg13cmos5l_decap_8
X_4099_ _4099_/X _4023_/X _4131_/X _4130_/X _4022_/X _1447_/Q _1446_/Q VPWR VGND sg13cmos5l_mux4_1
XFILLER_270_220 VPWR VGND sg13cmos5l_fill_2
XFILLER_471_180 VPWR VGND sg13cmos5l_decap_8
XFILLER_411_56 VPWR VGND sg13cmos5l_decap_8
XFILLER_130_35 VPWR VGND sg13cmos5l_decap_8
XFILLER_23_230 VPWR VGND sg13cmos5l_decap_8
XFILLER_90_28 VPWR VGND sg13cmos5l_decap_4
XFILLER_620_188 VPWR VGND sg13cmos5l_decap_8
XFILLER_247_7 VPWR VGND sg13cmos5l_decap_8
XFILLER_487_49 VPWR VGND sg13cmos5l_decap_8
XFILLER_90_39 VPWR VGND sg13cmos5l_decap_8
XFILLER_707_204 VPWR VGND sg13cmos5l_fill_2
XFILLER_369_184 VPWR VGND sg13cmos5l_fill_2
XFILLER_168_235 VPWR VGND sg13cmos5l_decap_8
XFILLER_573_210 VPWR VGND sg13cmos5l_decap_8
XANTENNA__3595__X Tile_X0Y9_FrameData_O[25] VPWR VGND sg13cmos5l_antennanp
XFILLER_168_268 VPWR VGND sg13cmos5l_decap_4
XFILLER_518_148 VPWR VGND sg13cmos5l_decap_4
XFILLER_384_154 VPWR VGND sg13cmos5l_decap_8
XFILLER_707_259 VPWR VGND sg13cmos5l_fill_1
XFILLER_573_254 VPWR VGND sg13cmos5l_decap_8
XFILLER_414_7 VPWR VGND sg13cmos5l_decap_8
XFILLER_717_30 VPWR VGND sg13cmos5l_fill_1
XFILLER_139_77 VPWR VGND sg13cmos5l_decap_8
XFILLER_526_170 VPWR VGND sg13cmos5l_fill_2
XFILLER_717_63 VPWR VGND sg13cmos5l_decap_8
XFILLER_325_232 VPWR VGND sg13cmos5l_decap_4
XFILLER_717_74 VPWR VGND sg13cmos5l_fill_1
XFILLER_687_122 VPWR VGND sg13cmos5l_decap_8
XFILLER_436_42 VPWR VGND sg13cmos5l_decap_8
XFILLER_325_265 VPWR VGND sg13cmos5l_decap_8
XFILLER_155_21 VPWR VGND sg13cmos5l_decap_8
XFILLER_583_70 VPWR VGND sg13cmos5l_decap_8
XFILLER_2_112 VPWR VGND sg13cmos5l_decap_8
XFILLER_687_166 VPWR VGND sg13cmos5l_fill_1
XANTENNA__2939__X Tile_X0Y8_E6BEG[7] VPWR VGND sg13cmos5l_antennanp
XFILLER_687_177 VPWR VGND sg13cmos5l_decap_4
XFILLER_439_111 VPWR VGND sg13cmos5l_decap_8
XFILLER_340_268 VPWR VGND sg13cmos5l_decap_4
XFILLER_2_156 VPWR VGND sg13cmos5l_fill_1
XFILLER_155_98 VPWR VGND sg13cmos5l_decap_8
XFILLER_439_144 VPWR VGND sg13cmos5l_decap_8
XFILLER_2_178 VPWR VGND sg13cmos5l_fill_1
XFILLER_305_35 VPWR VGND sg13cmos5l_decap_8
XFILLER_238_206 VPWR VGND sg13cmos5l_decap_8
XFILLER_643_203 VPWR VGND sg13cmos5l_decap_8
XFILLER_48_41 VPWR VGND sg13cmos5l_decap_8
XFILLER_65_119 VPWR VGND sg13cmos5l_decap_8
XFILLER_454_147 VPWR VGND sg13cmos5l_decap_8
XFILLER_171_64 VPWR VGND sg13cmos5l_decap_8
XFILLER_246_250 VPWR VGND sg13cmos5l_decap_8
XFILLER_273_0 VPWR VGND sg13cmos5l_decap_8
XFILLER_58_193 VPWR VGND sg13cmos5l_decap_8
XFILLER_73_130 VPWR VGND sg13cmos5l_decap_8
XFILLER_73_163 VPWR VGND sg13cmos5l_fill_1
XFILLER_206_158 VPWR VGND sg13cmos5l_decap_8
XFILLER_73_174 VPWR VGND sg13cmos5l_decap_8
XFILLER_321_78 VPWR VGND sg13cmos5l_decap_8
XFILLER_261_253 VPWR VGND sg13cmos5l_decap_8
XFILLER_440_0 VPWR VGND sg13cmos5l_decap_8
XFILLER_64_84 VPWR VGND sg13cmos5l_decap_8
XFILLER_538_0 VPWR VGND sg13cmos5l_decap_8
XFILLER_549_240 VPWR VGND sg13cmos5l_decap_8
XFILLER_159_202 VPWR VGND sg13cmos5l_fill_1
XFILLER_397_49 VPWR VGND sg13cmos5l_fill_1
XFILLER_9_35 VPWR VGND sg13cmos5l_decap_8
XFILLER_694_14 VPWR VGND sg13cmos5l_decap_8
XFILLER_159_257 VPWR VGND sg13cmos5l_decap_4
XFILLER_705_0 VPWR VGND sg13cmos5l_decap_8
XFILLER_159_268 VPWR VGND sg13cmos5l_decap_4
XFILLER_509_148 VPWR VGND sg13cmos5l_decap_8
XFILLER_174_216 VPWR VGND sg13cmos5l_decap_8
X_0820_ _0820_/Q Tile_X0Y9_FrameData[11] VGND VPWR Tile_X0Y9_FrameStrobe[4] latch
XFILLER_524_107 VPWR VGND sg13cmos5l_decap_4
XFILLER_477_93 VPWR VGND sg13cmos5l_decap_8
XFILLER_390_113 VPWR VGND sg13cmos5l_decap_8
XFILLER_713_218 VPWR VGND sg13cmos5l_decap_8
XFILLER_524_118 VPWR VGND sg13cmos5l_fill_1
XFILLER_517_170 VPWR VGND sg13cmos5l_decap_8
X_0751_ _0751_/Q Tile_X0Y9_FrameData[16] VGND VPWR Tile_X0Y9_FrameStrobe[2] latch
XFILLER_627_63 VPWR VGND sg13cmos5l_decap_8
XFILLER_346_42 VPWR VGND sg13cmos5l_decap_8
XFILLER_316_254 VPWR VGND sg13cmos5l_decap_8
XFILLER_127_176 VPWR VGND sg13cmos5l_decap_8
X_0682_ _0682_/Q Tile_X0Y9_FrameData[21] VGND VPWR Tile_X0Y9_FrameStrobe[0] latch
X_3470_ Tile_X0Y1_FrameData_O[28] Tile_X0Y1_FrameData[28] VPWR VGND sg13cmos5l_buf_1
XFILLER_331_202 VPWR VGND sg13cmos5l_decap_8
XFILLER_493_70 VPWR VGND sg13cmos5l_decap_8
XFILLER_288_106 VPWR VGND sg13cmos5l_decap_8
XFILLER_89_70 VPWR VGND sg13cmos5l_decap_8
X_2421_ _2421_/Q Tile_X0Y5_FrameData[16] VGND VPWR Tile_X0Y9_FrameStrobe[7] latch
XFILLER_331_235 VPWR VGND sg13cmos5l_decap_8
XANTENNA__2849__X Tile_X0Y6_E2BEGb[6] VPWR VGND sg13cmos5l_antennanp
XFILLER_142_157 VPWR VGND sg13cmos5l_decap_8
XFILLER_693_114 VPWR VGND sg13cmos5l_decap_8
XFILLER_331_257 VPWR VGND sg13cmos5l_decap_8
XFILLER_96_200 VPWR VGND sg13cmos5l_decap_8
XFILLER_693_147 VPWR VGND sg13cmos5l_decap_8
X_2352_ _2352_/Q Tile_X0Y5_FrameData[21] VGND VPWR Tile_X0Y9_FrameStrobe[5] latch
XFILLER_215_35 VPWR VGND sg13cmos5l_decap_8
XFILLER_643_84 VPWR VGND sg13cmos5l_decap_8
XFILLER_296_150 VPWR VGND sg13cmos5l_decap_8
X_1303_ _1303_/Q Tile_X0Y1_FrameData[2] VGND VPWR Tile_X0Y9_FrameStrobe[3] latch
XFILLER_485_272 VPWR VGND sg13cmos5l_fill_1
XFILLER_362_63 VPWR VGND sg13cmos5l_decap_8
X_2283_ _2283_/Q Tile_X0Y5_FrameData[26] VGND VPWR Tile_X0Y9_FrameStrobe[3] latch
XFILLER_634_225 VPWR VGND sg13cmos5l_fill_2
XFILLER_445_136 VPWR VGND sg13cmos5l_decap_4
X_1234_ _1234_/Q Tile_X0Y1_FrameData[7] VGND VPWR Tile_X0Y9_FrameStrobe[1] latch
X_4022_ _4022_/X Tile_X0Y0_W2MID[6] Tile_X0Y0_W2END[6] Tile_X0Y0_W6END[9] _3855_/X
+ _1131_/Q _1130_/Q VPWR VGND sg13cmos5l_mux4_1
XFILLER_49_182 VPWR VGND sg13cmos5l_decap_4
XFILLER_512_77 VPWR VGND sg13cmos5l_decap_8
XFILLER_237_272 VPWR VGND sg13cmos5l_fill_1
X_1165_ _1165_/Q Tile_X0Y0_FrameData[30] VGND VPWR Tile_X0Y9_FrameStrobe[7] latch
X_0116_ AXI_M_SOC_ARLEN7 _0933_/Q _3767_/X VPWR VGND sg13cmos5l_nor2b_1
XFILLER_599_195 VPWR VGND sg13cmos5l_decap_4
X_1096_ _1096_/Q Tile_X0Y0_FrameData[3] VGND VPWR Tile_X0Y9_FrameStrobe[4] latch
XFILLER_64_196 VPWR VGND sg13cmos5l_decap_8
XFILLER_401_206 VPWR VGND sg13cmos5l_decap_8
XFILLER_398_268 VPWR VGND sg13cmos5l_decap_4
X_0047_ AXI_M_SOC_AWCACHE2 _0936_/Q _3687_/X VPWR VGND sg13cmos5l_nor2b_1
X_4924_ _4924_/X Tile_X0Y9_N1END[0] Tile_X0Y9_N4END[0] _4896_/X _0083_/X _0711_/Q
+ _0710_/Q VPWR VGND sg13cmos5l_mux4_1
XFILLER_668_70 VPWR VGND sg13cmos5l_decap_8
XFILLER_100_49 VPWR VGND sg13cmos5l_decap_8
X_4855_ _4855_/X Tile_X0Y9_W2MID[0] AXI_M_SOC_RDATA7 _4901_/X _4900_/X _0833_/Q _0832_/Q
+ VPWR VGND sg13cmos5l_mux4_1
XFILLER_20_222 VPWR VGND sg13cmos5l_decap_8
XFILLER_555_243 VPWR VGND sg13cmos5l_decap_8
X_3806_ _3806_/X Tile_X0Y0_W2MID[5] Tile_X0Y0_W2END[2] _3857_/X _3856_/X _1093_/Q
+ _1092_/Q VPWR VGND sg13cmos5l_mux4_1
XFILLER_165_216 VPWR VGND sg13cmos5l_decap_8
XFILLER_220_183 VPWR VGND sg13cmos5l_decap_8
X_4786_ _4786_/X _4713_/X Tile_X0Y9_N2MID[6] _4822_/X _4712_/X _0427_/Q _0426_/Q VPWR
+ VGND sg13cmos5l_mux4_1
XFILLER_515_107 VPWR VGND sg13cmos5l_fill_1
XFILLER_381_102 VPWR VGND sg13cmos5l_fill_2
X_1998_ _1998_/Q Tile_X0Y4_FrameData[23] VGND VPWR Tile_X0Y9_FrameStrobe[2] latch
XFILLER_704_218 VPWR VGND sg13cmos5l_decap_4
XFILLER_118_110 VPWR VGND sg13cmos5l_decap_8
XFILLER_570_224 VPWR VGND sg13cmos5l_decap_8
XFILLER_307_210 VPWR VGND sg13cmos5l_decap_8
X_3737_ AXI_M_SOC_ARADDR9 Tile_X0Y9_WW4END[1] Tile_X0Y9_WW4END[9] Tile_X0Y9_W6END[9]
+ _4925_/X _0741_/Q _0740_/Q VPWR VGND sg13cmos5l_mux4_1
XFILLER_537_63 VPWR VGND sg13cmos5l_decap_8
XFILLER_381_146 VPWR VGND sg13cmos5l_decap_8
X_0949_ _0949_/Q Tile_X0Y0_FrameData[22] VGND VPWR Tile_X0Y9_FrameStrobe[0] latch
XFILLER_669_100 VPWR VGND sg13cmos5l_decap_8
XFILLER_109_36 VPWR VGND sg13cmos5l_decap_8
X_3668_ AXI_M_SOC_AWADDR29 Tile_X0Y4_W1END[1] Tile_X0Y4_WW4END[5] Tile_X0Y4_WW4END[13]
+ _4349_/X _1987_/Q _1986_/Q VPWR VGND sg13cmos5l_mux4_1
XFILLER_712_251 VPWR VGND sg13cmos5l_decap_8
XFILLER_523_162 VPWR VGND sg13cmos5l_decap_8
XFILLER_322_235 VPWR VGND sg13cmos5l_fill_1
XANTENNA__2759__X Tile_X0Y3_FrameData_O[17] VPWR VGND sg13cmos5l_antennanp
XFILLER_133_146 VPWR VGND sg13cmos5l_decap_8
X_2619_ _2619_/Q Tile_X0Y6_FrameData[12] VGND VPWR Tile_X0Y9_FrameStrobe[5] latch
XFILLER_684_103 VPWR VGND sg13cmos5l_decap_4
X_3599_ Tile_X0Y9_FrameData_O[29] Tile_X0Y9_FrameData[29] VPWR VGND sg13cmos5l_buf_1
XFILLER_684_136 VPWR VGND sg13cmos5l_decap_8
XFILLER_406_56 VPWR VGND sg13cmos5l_decap_8
XFILLER_87_200 VPWR VGND sg13cmos5l_fill_1
XFILLER_553_84 VPWR VGND sg13cmos5l_decap_4
XFILLER_294_109 VPWR VGND sg13cmos5l_fill_1
XFILLER_125_35 VPWR VGND sg13cmos5l_decap_8
XFILLER_703_21 VPWR VGND sg13cmos5l_decap_8
XFILLER_287_161 VPWR VGND sg13cmos5l_decap_8
XFILLER_87_244 VPWR VGND sg13cmos5l_fill_2
XFILLER_476_272 VPWR VGND sg13cmos5l_fill_1
XFILLER_272_63 VPWR VGND sg13cmos5l_decap_8
XFILLER_197_7 VPWR VGND sg13cmos5l_decap_8
XFILLER_85_28 VPWR VGND sg13cmos5l_decap_8
XFILLER_625_236 VPWR VGND sg13cmos5l_decap_4
XFILLER_47_119 VPWR VGND sg13cmos5l_fill_1
XFILLER_436_147 VPWR VGND sg13cmos5l_decap_8
XFILLER_703_98 VPWR VGND sg13cmos5l_decap_8
XFILLER_228_250 VPWR VGND sg13cmos5l_decap_8
XFILLER_228_261 VPWR VGND sg13cmos5l_fill_1
XFILLER_228_272 VPWR VGND sg13cmos5l_fill_1
XFILLER_422_77 VPWR VGND sg13cmos5l_decap_8
XFILLER_640_217 VPWR VGND sg13cmos5l_decap_8
XFILLER_364_7 VPWR VGND sg13cmos5l_decap_8
XFILLER_18_77 VPWR VGND sg13cmos5l_decap_8
XFILLER_141_56 VPWR VGND sg13cmos5l_decap_8
XFILLER_70_122 VPWR VGND sg13cmos5l_fill_1
XFILLER_389_268 VPWR VGND sg13cmos5l_decap_4
XFILLER_203_128 VPWR VGND sg13cmos5l_decap_8
XFILLER_70_144 VPWR VGND sg13cmos5l_decap_8
XFILLER_531_7 VPWR VGND sg13cmos5l_decap_8
XFILLER_34_21 VPWR VGND sg13cmos5l_decap_8
XFILLER_629_7 VPWR VGND sg13cmos5l_decap_8
XFILLER_578_70 VPWR VGND sg13cmos5l_decap_8
XFILLER_34_76 VPWR VGND sg13cmos5l_fill_1
XFILLER_211_161 VPWR VGND sg13cmos5l_decap_8
XFILLER_34_98 VPWR VGND sg13cmos5l_decap_8
XFILLER_357_154 VPWR VGND sg13cmos5l_decap_8
XFILLER_297_71 VPWR VGND sg13cmos5l_decap_8
XFILLER_400_272 VPWR VGND sg13cmos5l_fill_1
XFILLER_211_194 VPWR VGND sg13cmos5l_decap_8
XFILLER_412_4 VPWR VGND sg13cmos5l_fill_1
XFILLER_7_248 VPWR VGND sg13cmos5l_fill_1
XFILLER_664_28 VPWR VGND sg13cmos5l_decap_8
XFILLER_50_42 VPWR VGND sg13cmos5l_decap_8
XFILLER_372_157 VPWR VGND sg13cmos5l_decap_4
XFILLER_119_0 VPWR VGND sg13cmos5l_decap_8
XFILLER_514_140 VPWR VGND sg13cmos5l_decap_8
XFILLER_166_64 VPWR VGND sg13cmos5l_fill_1
XFILLER_124_168 VPWR VGND sg13cmos5l_fill_1
XFILLER_1_0 VPWR VGND sg13cmos5l_decap_8
XFILLER_313_268 VPWR VGND sg13cmos5l_decap_4
XFILLER_59_62 VPWR VGND sg13cmos5l_decap_8
XFILLER_675_169 VPWR VGND sg13cmos5l_decap_8
XFILLER_613_21 VPWR VGND sg13cmos5l_decap_8
XFILLER_390_0 VPWR VGND sg13cmos5l_decap_8
XFILLER_690_106 VPWR VGND sg13cmos5l_fill_1
XFILLER_182_63 VPWR VGND sg13cmos5l_decap_8
XFILLER_488_0 VPWR VGND sg13cmos5l_decap_8
XFILLER_467_272 VPWR VGND sg13cmos5l_fill_1
XFILLER_690_128 VPWR VGND sg13cmos5l_decap_8
XFILLER_293_120 VPWR VGND sg13cmos5l_decap_8
XFILLER_427_147 VPWR VGND sg13cmos5l_decap_8
XFILLER_332_44 VPWR VGND sg13cmos5l_fill_1
XFILLER_219_250 VPWR VGND sg13cmos5l_decap_8
XFILLER_93_236 VPWR VGND sg13cmos5l_decap_4
XFILLER_689_14 VPWR VGND sg13cmos5l_decap_8
XFILLER_115_90 VPWR VGND sg13cmos5l_decap_8
XFILLER_655_0 VPWR VGND sg13cmos5l_decap_8
XFILLER_631_206 VPWR VGND sg13cmos5l_decap_8
XFILLER_93_269 VPWR VGND sg13cmos5l_decap_4
XFILLER_332_88 VPWR VGND sg13cmos5l_decap_8
XFILLER_442_139 VPWR VGND sg13cmos5l_decap_8
XFILLER_234_264 VPWR VGND sg13cmos5l_decap_8
XFILLER_61_133 VPWR VGND sg13cmos5l_decap_8
X_2970_ Tile_X0Y8_FrameData_O[10] Tile_X0Y8_FrameData[10] VPWR VGND sg13cmos5l_buf_1
XFILLER_596_176 VPWR VGND sg13cmos5l_fill_1
XFILLER_488_70 VPWR VGND sg13cmos5l_decap_8
XFILLER_395_227 VPWR VGND sg13cmos5l_decap_8
XFILLER_596_198 VPWR VGND sg13cmos5l_decap_8
X_1921_ _1921_/Q Tile_X0Y3_FrameData[8] VGND VPWR Tile_X0Y9_FrameStrobe[7] latch
XFILLER_91_82 VPWR VGND sg13cmos5l_decap_8
XFILLER_537_232 VPWR VGND sg13cmos5l_fill_2
XFILLER_348_143 VPWR VGND sg13cmos5l_decap_8
X_4640_ _4640_/X Tile_X0Y7_WW4END[3] AXI_M_SOC_RDATA19 _4687_/X _4675_/X _0279_/Q
+ _0278_/Q VPWR VGND sg13cmos5l_mux4_1
X_1852_ _1852_/Q Tile_X0Y3_FrameData[13] VGND VPWR Tile_X0Y9_FrameStrobe[5] latch
XFILLER_638_84 VPWR VGND sg13cmos5l_decap_8
XFILLER_698_206 VPWR VGND sg13cmos5l_decap_8
X_0803_ _0803_/Q Tile_X0Y9_FrameData[28] VGND VPWR Tile_X0Y9_FrameStrobe[4] latch
XFILLER_574_28 VPWR VGND sg13cmos5l_decap_8
X_4571_ _4571_/X _4551_/X Tile_X0Y9_N4END[15] _4550_/X _0150_/X _2489_/Q _2488_/Q
+ VPWR VGND sg13cmos5l_mux4_1
XFILLER_357_63 VPWR VGND sg13cmos5l_decap_8
X_1783_ _1783_/Q Tile_X0Y3_FrameData[18] VGND VPWR Tile_X0Y9_FrameStrobe[3] latch
XFILLER_552_268 VPWR VGND sg13cmos5l_decap_4
X_3522_ Tile_X0Y9_E1BEG[0] _4844_/X VPWR VGND sg13cmos5l_buf_1
X_0734_ _0734_/Q Tile_X0Y9_FrameData[1] VGND VPWR Tile_X0Y9_FrameStrobe[1] latch
XFILLER_304_213 VPWR VGND sg13cmos5l_decap_8
XFILLER_115_135 VPWR VGND sg13cmos5l_fill_2
XFILLER_505_184 VPWR VGND sg13cmos5l_decap_8
XFILLER_666_103 VPWR VGND sg13cmos5l_decap_8
XFILLER_507_77 VPWR VGND sg13cmos5l_decap_8
X_3453_ Tile_X0Y1_FrameData_O[11] Tile_X0Y1_FrameData[11] VPWR VGND sg13cmos5l_buf_1
XFILLER_654_83 VPWR VGND sg13cmos5l_decap_8
XFILLER_505_195 VPWR VGND sg13cmos5l_fill_1
XFILLER_371_190 VPWR VGND sg13cmos5l_decap_4
X_0665_ _0665_/Q Tile_X0Y8_FrameData[6] VGND VPWR Tile_X0Y9_FrameStrobe[7] latch
XFILLER_130_105 VPWR VGND sg13cmos5l_decap_8
XFILLER_226_56 VPWR VGND sg13cmos5l_fill_2
XFILLER_520_154 VPWR VGND sg13cmos5l_decap_8
XFILLER_304_268 VPWR VGND sg13cmos5l_decap_4
X_2404_ _2404_/Q Tile_X0Y5_FrameData[1] VGND VPWR Tile_X0Y9_FrameStrobe[6] latch
XFILLER_590_49 VPWR VGND sg13cmos5l_decap_8
X_0596_ _0596_/Q Tile_X0Y8_FrameData[11] VGND VPWR Tile_X0Y9_FrameStrobe[5] latch
X_3384_ Tile_X0Y2_E6BEG[7] _4079_/X VPWR VGND sg13cmos5l_buf_1
XFILLER_523_21 VPWR VGND sg13cmos5l_decap_8
XFILLER_34_0 VPWR VGND sg13cmos5l_decap_8
XFILLER_458_261 VPWR VGND sg13cmos5l_decap_4
X_2335_ _2335_/Q Tile_X0Y5_FrameData[6] VGND VPWR Tile_X0Y9_FrameStrobe[4] latch
XFILLER_69_266 VPWR VGND sg13cmos5l_decap_8
XFILLER_418_136 VPWR VGND sg13cmos5l_decap_8
X_2266_ _2266_/Q Tile_X0Y5_FrameData[11] VGND VPWR Tile_X0Y9_FrameStrobe[2] latch
XFILLER_599_14 VPWR VGND sg13cmos5l_decap_8
XFILLER_523_98 VPWR VGND sg13cmos5l_decap_8
XFILLER_284_175 VPWR VGND sg13cmos5l_decap_8
X_4005_ _4005_/X _3981_/X _0073_/X _3980_/X Tile_X0Y0_S4END[4] _1209_/Q _1208_/Q VPWR
+ VGND sg13cmos5l_mux4_1
X_1217_ _1217_/Q Tile_X0Y1_FrameData[24] VGND VPWR Tile_X0Y9_FrameStrobe[1] latch
X_2197_ _2197_/Q Tile_X0Y5_FrameData[16] VGND VPWR Tile_X0Y9_FrameStrobe[0] latch
XANTENNA__3203__X Tile_X0Y0_N2BEG[3] VPWR VGND sg13cmos5l_antennanp
XFILLER_622_239 VPWR VGND sg13cmos5l_decap_4
X_1148_ _1148_/Q Tile_X0Y0_FrameData[15] VGND VPWR Tile_X0Y9_FrameStrobe[6] latch
XFILLER_679_91 VPWR VGND sg13cmos5l_decap_8
XFILLER_197_116 VPWR VGND sg13cmos5l_decap_8
XFILLER_630_272 VPWR VGND sg13cmos5l_fill_1
X_1079_ _1079_/Q Tile_X0Y0_FrameData[20] VGND VPWR Tile_X0Y9_FrameStrobe[4] latch
XFILLER_52_166 VPWR VGND sg13cmos5l_fill_2
XFILLER_398_70 VPWR VGND sg13cmos5l_decap_8
XFILLER_386_238 VPWR VGND sg13cmos5l_decap_8
X_4907_ _4907_/X Tile_X0Y9_N2MID[3] Tile_X0Y9_N2END[3] _4935_/X _4819_/X _0689_/Q
+ _0688_/Q VPWR VGND sg13cmos5l_mux4_1
XFILLER_339_154 VPWR VGND sg13cmos5l_decap_8
X_4838_ _4838_/X Tile_X0Y9_W1END[1] Tile_X0Y9_WW4END[13] Tile_X0Y9_W6END[5] _4917_/X
+ _0864_/Q _0863_/Q VPWR VGND sg13cmos5l_mux4_1
XFILLER_548_84 VPWR VGND sg13cmos5l_decap_8
XFILLER_543_202 VPWR VGND sg13cmos5l_decap_4
XFILLER_138_238 VPWR VGND sg13cmos5l_decap_4
XFILLER_484_28 VPWR VGND sg13cmos5l_decap_8
XFILLER_689_228 VPWR VGND sg13cmos5l_decap_8
XFILLER_267_63 VPWR VGND sg13cmos5l_decap_8
X_4769_ _4769_/X AXI_M_SOC_RDATA13 _4802_/X _4806_/X _4788_/X _0509_/Q _0508_/Q VPWR
+ VGND sg13cmos5l_mux4_1
XFILLER_543_257 VPWR VGND sg13cmos5l_decap_8
XFILLER_543_268 VPWR VGND sg13cmos5l_decap_4
XFILLER_354_168 VPWR VGND sg13cmos5l_decap_8
XFILLER_112_7 VPWR VGND sg13cmos5l_decap_8
XFILLER_4_207 VPWR VGND sg13cmos5l_decap_4
XFILLER_146_271 VPWR VGND sg13cmos5l_fill_2
XFILLER_161_230 VPWR VGND sg13cmos5l_fill_2
XFILLER_20_56 VPWR VGND sg13cmos5l_decap_8
XFILLER_417_77 VPWR VGND sg13cmos5l_decap_8
XFILLER_136_56 VPWR VGND sg13cmos5l_decap_8
XFILLER_121_105 VPWR VGND sg13cmos5l_decap_8
XFILLER_714_42 VPWR VGND sg13cmos5l_decap_8
XFILLER_657_158 VPWR VGND sg13cmos5l_decap_8
XFILLER_511_176 VPWR VGND sg13cmos5l_fill_1
XFILLER_283_84 VPWR VGND sg13cmos5l_decap_8
XFILLER_96_38 VPWR VGND sg13cmos5l_decap_8
XFILLER_657_169 VPWR VGND sg13cmos5l_decap_8
XFILLER_433_21 VPWR VGND sg13cmos5l_decap_8
XFILLER_449_261 VPWR VGND sg13cmos5l_fill_1
XFILLER_672_117 VPWR VGND sg13cmos5l_decap_8
XFILLER_481_7 VPWR VGND sg13cmos5l_decap_8
XFILLER_29_21 VPWR VGND sg13cmos5l_decap_8
XFILLER_579_7 VPWR VGND sg13cmos5l_decap_8
XFILLER_433_98 VPWR VGND sg13cmos5l_decap_8
XFILLER_29_76 VPWR VGND sg13cmos5l_fill_2
XFILLER_613_228 VPWR VGND sg13cmos5l_decap_8
XFILLER_302_14 VPWR VGND sg13cmos5l_decap_8
XANTENNA__3113__X Tile_X0Y7_E6BEG[11] VPWR VGND sg13cmos5l_antennanp
XFILLER_28_152 VPWR VGND sg13cmos5l_decap_8
XFILLER_216_231 VPWR VGND sg13cmos5l_decap_8
XFILLER_680_194 VPWR VGND sg13cmos5l_decap_8
XFILLER_659_28 VPWR VGND sg13cmos5l_decap_8
XFILLER_231_201 VPWR VGND sg13cmos5l_fill_1
XFILLER_432_161 VPWR VGND sg13cmos5l_decap_8
XANTENNA__2952__X Tile_X0Y8_EE4BEG[8] VPWR VGND sg13cmos5l_antennanp
XFILLER_578_154 VPWR VGND sg13cmos5l_decap_8
XFILLER_45_86 VPWR VGND sg13cmos5l_decap_8
XFILLER_378_29 VPWR VGND sg13cmos5l_decap_8
XFILLER_231_234 VPWR VGND sg13cmos5l_decap_8
XFILLER_43_177 VPWR VGND sg13cmos5l_decap_8
XFILLER_593_124 VPWR VGND sg13cmos5l_decap_8
XFILLER_593_157 VPWR VGND sg13cmos5l_decap_8
XFILLER_519_243 VPWR VGND sg13cmos5l_decap_8
XFILLER_236_0 VPWR VGND sg13cmos5l_decap_8
XFILLER_458_73 VPWR VGND sg13cmos5l_decap_8
XFILLER_385_260 VPWR VGND sg13cmos5l_decap_4
XFILLER_675_49 VPWR VGND sg13cmos5l_fill_2
XFILLER_61_63 VPWR VGND sg13cmos5l_decap_8
XFILLER_458_84 VPWR VGND sg13cmos5l_fill_2
XFILLER_345_113 VPWR VGND sg13cmos5l_decap_8
XFILLER_608_21 VPWR VGND sg13cmos5l_decap_8
XFILLER_177_74 VPWR VGND sg13cmos5l_decap_8
XFILLER_345_146 VPWR VGND sg13cmos5l_decap_8
XFILLER_6_14 VPWR VGND sg13cmos5l_decap_8
XFILLER_403_0 VPWR VGND sg13cmos5l_decap_4
XFILLER_534_268 VPWR VGND sg13cmos5l_decap_4
XFILLER_360_105 VPWR VGND sg13cmos5l_decap_8
XFILLER_327_22 VPWR VGND sg13cmos5l_decap_8
XANTENNA_7 AXI_M_SOC_RDATA26 VPWR VGND sg13cmos5l_antennanp
XFILLER_137_271 VPWR VGND sg13cmos5l_fill_2
XFILLER_608_98 VPWR VGND sg13cmos5l_fill_1
XFILLER_499_161 VPWR VGND sg13cmos5l_decap_8
XFILLER_327_66 VPWR VGND sg13cmos5l_decap_8
XFILLER_298_212 VPWR VGND sg13cmos5l_decap_8
XFILLER_152_241 VPWR VGND sg13cmos5l_decap_4
XFILLER_152_252 VPWR VGND sg13cmos5l_fill_1
XFILLER_624_42 VPWR VGND sg13cmos5l_decap_8
XFILLER_502_154 VPWR VGND sg13cmos5l_decap_8
X_0450_ _0450_/Q Tile_X0Y8_FrameData[29] VGND VPWR Tile_X0Y9_FrameStrobe[1] latch
XFILLER_648_147 VPWR VGND sg13cmos5l_decap_8
XFILLER_343_21 VPWR VGND sg13cmos5l_decap_8
XFILLER_663_106 VPWR VGND sg13cmos5l_fill_2
XFILLER_624_86 VPWR VGND sg13cmos5l_fill_1
X_0381_ _0381_/Q Tile_X0Y7_FrameData[2] VGND VPWR Tile_X0Y9_FrameStrobe[6] latch
XFILLER_66_203 VPWR VGND sg13cmos5l_decap_8
X_2120_ _2120_/Q Tile_X0Y4_FrameData[29] VGND VPWR Tile_X0Y9_FrameStrobe[6] latch
XFILLER_120_171 VPWR VGND sg13cmos5l_decap_8
XFILLER_281_112 VPWR VGND sg13cmos5l_decap_8
X_2051_ _2051_/Q Tile_X0Y4_FrameData[2] VGND VPWR Tile_X0Y9_FrameStrobe[3] latch
XFILLER_266_197 VPWR VGND sg13cmos5l_fill_1
XFILLER_212_14 VPWR VGND sg13cmos5l_decap_8
XFILLER_640_63 VPWR VGND sg13cmos5l_decap_8
XFILLER_415_128 VPWR VGND sg13cmos5l_fill_1
XFILLER_81_206 VPWR VGND sg13cmos5l_fill_1
XANTENNA__3023__X Tile_X0Y5_E6BEG[10] VPWR VGND sg13cmos5l_antennanp
X_1002_ _1002_/Q Tile_X0Y0_FrameData[1] VGND VPWR Tile_X0Y9_FrameStrobe[1] latch
XFILLER_569_28 VPWR VGND sg13cmos5l_decap_8
XFILLER_281_189 VPWR VGND sg13cmos5l_decap_8
XFILLER_34_133 VPWR VGND sg13cmos5l_decap_4
XFILLER_569_154 VPWR VGND sg13cmos5l_decap_8
XFILLER_499_91 VPWR VGND sg13cmos5l_decap_8
XANTENNA__2862__X Tile_X0Y6_E6BEG[11] VPWR VGND sg13cmos5l_antennanp
XFILLER_612_272 VPWR VGND sg13cmos5l_fill_1
XFILLER_423_183 VPWR VGND sg13cmos5l_decap_8
XFILLER_288_29 VPWR VGND sg13cmos5l_decap_8
XFILLER_368_238 VPWR VGND sg13cmos5l_fill_1
X_2953_ Tile_X0Y8_EE4BEG[9] _4753_/X VPWR VGND sg13cmos5l_buf_1
X_1904_ _1904_/Q Tile_X0Y3_FrameData[25] VGND VPWR Tile_X0Y9_FrameStrobe[7] latch
XFILLER_584_179 VPWR VGND sg13cmos5l_decap_8
XFILLER_187_171 VPWR VGND sg13cmos5l_decap_8
XFILLER_187_182 VPWR VGND sg13cmos5l_fill_2
X_2884_ Tile_X0Y6_FrameData_O[5] Tile_X0Y6_FrameData[5] VPWR VGND sg13cmos5l_buf_1
XFILLER_585_49 VPWR VGND sg13cmos5l_decap_8
XFILLER_518_21 VPWR VGND sg13cmos5l_decap_8
XFILLER_336_124 VPWR VGND sg13cmos5l_decap_8
X_4623_ _4623_/X Tile_X0Y7_W2END[4] AXI_M_SOC_RDATA20 _4675_/X _4674_/X _0313_/Q _0312_/Q
+ VPWR VGND sg13cmos5l_mux4_1
X_1835_ _1835_/Q Tile_X0Y3_FrameData[30] VGND VPWR Tile_X0Y9_FrameStrobe[5] latch
XANTENNA__3693__X AXI_M_SOC_WDATA3 VPWR VGND sg13cmos5l_antennanp
XFILLER_391_252 VPWR VGND sg13cmos5l_decap_8
XFILLER_351_105 VPWR VGND sg13cmos5l_decap_8
X_4554_ _4554_/X _4481_/X _4597_/X _4596_/X _4480_/X _2451_/Q _2450_/Q VPWR VGND sg13cmos5l_mux4_1
X_1766_ _1766_/Q Tile_X0Y3_FrameData[3] VGND VPWR Tile_X0Y9_FrameStrobe[2] latch
XFILLER_518_98 VPWR VGND sg13cmos5l_decap_8
XFILLER_289_212 VPWR VGND sg13cmos5l_decap_8
X_3505_ Tile_X0Y1_E2BEGb[3] _3943_/X VPWR VGND sg13cmos5l_buf_1
XFILLER_384_72 VPWR VGND sg13cmos5l_decap_8
X_0717_ _0717_/Q Tile_X0Y9_FrameData[18] VGND VPWR Tile_X0Y9_FrameStrobe[1] latch
X_4485_ _4485_/X _4572_/X _4576_/X _4580_/X _4558_/X _2635_/Q _2634_/Q VPWR VGND sg13cmos5l_mux4_1
X_1697_ _1697_/Q Tile_X0Y3_FrameData[8] VGND VPWR Tile_X0Y9_FrameStrobe[0] latch
XFILLER_237_99 VPWR VGND sg13cmos5l_decap_8
XFILLER_103_105 VPWR VGND sg13cmos5l_decap_8
XFILLER_639_147 VPWR VGND sg13cmos5l_decap_8
XFILLER_534_42 VPWR VGND sg13cmos5l_decap_8
X_3436_ Tile_X0Y4_FrameData_O[27] Tile_X0Y4_FrameData[27] VPWR VGND sg13cmos5l_buf_1
X_0648_ _0648_/Q Tile_X0Y8_FrameData[23] VGND VPWR Tile_X0Y9_FrameStrobe[7] latch
XFILLER_106_15 VPWR VGND sg13cmos5l_decap_8
XFILLER_253_21 VPWR VGND sg13cmos5l_decap_8
X_3367_ Tile_X0Y2_EE4BEG[6] _4062_/X VPWR VGND sg13cmos5l_buf_1
X_0579_ _0579_/Q Tile_X0Y8_FrameData[28] VGND VPWR Tile_X0Y9_FrameStrobe[5] latch
XFILLER_111_160 VPWR VGND sg13cmos5l_decap_8
XFILLER_446_242 VPWR VGND sg13cmos5l_decap_8
X_2318_ _2318_/Q Tile_X0Y5_FrameData[23] VGND VPWR Tile_X0Y9_FrameStrobe[4] latch
XFILLER_253_98 VPWR VGND sg13cmos5l_decap_8
X_3298_ Tile_X0Y0_E2BEGb[6] _3818_/X VPWR VGND sg13cmos5l_buf_1
XFILLER_406_106 VPWR VGND sg13cmos5l_decap_8
XFILLER_403_57 VPWR VGND sg13cmos5l_decap_8
XFILLER_257_186 VPWR VGND sg13cmos5l_decap_8
XFILLER_122_14 VPWR VGND sg13cmos5l_decap_8
XFILLER_550_63 VPWR VGND sg13cmos5l_decap_8
XFILLER_272_123 VPWR VGND sg13cmos5l_decap_4
X_2249_ _2249_/Q Tile_X0Y5_FrameData[28] VGND VPWR Tile_X0Y9_FrameStrobe[2] latch
XFILLER_662_183 VPWR VGND sg13cmos5l_decap_8
XFILLER_406_139 VPWR VGND sg13cmos5l_decap_8
XFILLER_72_206 VPWR VGND sg13cmos5l_decap_8
XFILLER_403_79 VPWR VGND sg13cmos5l_decap_8
XFILLER_272_167 VPWR VGND sg13cmos5l_decap_8
XFILLER_479_28 VPWR VGND sg13cmos5l_decap_8
XFILLER_603_250 VPWR VGND sg13cmos5l_decap_8
XANTENNA__2772__X Tile_X0Y3_FrameData_O[30] VPWR VGND sg13cmos5l_antennanp
XFILLER_700_77 VPWR VGND sg13cmos5l_decap_8
XFILLER_414_183 VPWR VGND sg13cmos5l_decap_8
XFILLER_25_166 VPWR VGND sg13cmos5l_decap_8
XFILLER_80_272 VPWR VGND sg13cmos5l_fill_1
XFILLER_202_91 VPWR VGND sg13cmos5l_decap_8
XFILLER_213_256 VPWR VGND sg13cmos5l_fill_1
XFILLER_15_56 VPWR VGND sg13cmos5l_decap_8
XFILLER_374_208 VPWR VGND sg13cmos5l_fill_2
XFILLER_575_168 VPWR VGND sg13cmos5l_decap_8
XFILLER_709_42 VPWR VGND sg13cmos5l_decap_8
XFILLER_717_151 VPWR VGND sg13cmos5l_decap_8
XFILLER_495_49 VPWR VGND sg13cmos5l_decap_8
XFILLER_278_84 VPWR VGND sg13cmos5l_decap_8
XFILLER_428_21 VPWR VGND sg13cmos5l_decap_8
XFILLER_516_268 VPWR VGND sg13cmos5l_decap_4
XFILLER_119_260 VPWR VGND sg13cmos5l_fill_2
XFILLER_428_98 VPWR VGND sg13cmos5l_decap_8
XFILLER_147_77 VPWR VGND sg13cmos5l_decap_8
XFILLER_696_7 VPWR VGND sg13cmos5l_decap_8
XANTENNA__3108__X Tile_X0Y7_E6BEG[6] VPWR VGND sg13cmos5l_antennanp
XFILLER_444_42 VPWR VGND sg13cmos5l_decap_8
XFILLER_0_210 VPWR VGND sg13cmos5l_decap_8
XFILLER_163_21 VPWR VGND sg13cmos5l_fill_2
XFILLER_685_264 VPWR VGND sg13cmos5l_decap_8
XFILLER_591_70 VPWR VGND sg13cmos5l_decap_8
XFILLER_295_215 VPWR VGND sg13cmos5l_decap_8
XFILLER_496_175 VPWR VGND sg13cmos5l_decap_8
XFILLER_295_226 VPWR VGND sg13cmos5l_fill_1
XANTENNA__2947__X Tile_X0Y8_EE4BEG[3] VPWR VGND sg13cmos5l_antennanp
XFILLER_163_87 VPWR VGND sg13cmos5l_fill_1
XFILLER_248_175 VPWR VGND sg13cmos5l_decap_8
XFILLER_186_0 VPWR VGND sg13cmos5l_decap_8
XFILLER_48_269 VPWR VGND sg13cmos5l_decap_4
XFILLER_263_123 VPWR VGND sg13cmos5l_fill_2
XFILLER_460_74 VPWR VGND sg13cmos5l_decap_8
XFILLER_56_74 VPWR VGND sg13cmos5l_decap_8
XFILLER_263_167 VPWR VGND sg13cmos5l_decap_8
XFILLER_389_28 VPWR VGND sg13cmos5l_decap_8
XFILLER_601_209 VPWR VGND sg13cmos5l_decap_8
XFILLER_412_109 VPWR VGND sg13cmos5l_decap_8
XANTENNA__3778__X AXI_M_SOC_ARVALID VPWR VGND sg13cmos5l_antennanp
XFILLER_353_0 VPWR VGND sg13cmos5l_decap_8
XFILLER_16_144 VPWR VGND sg13cmos5l_decap_8
XFILLER_405_172 VPWR VGND sg13cmos5l_decap_8
XFILLER_204_234 VPWR VGND sg13cmos5l_fill_2
XFILLER_71_272 VPWR VGND sg13cmos5l_fill_1
XFILLER_469_61 VPWR VGND sg13cmos5l_decap_8
XFILLER_469_72 VPWR VGND sg13cmos5l_decap_8
XFILLER_686_59 VPWR VGND sg13cmos5l_decap_8
XFILLER_520_0 VPWR VGND sg13cmos5l_decap_8
XFILLER_469_94 VPWR VGND sg13cmos5l_decap_8
XFILLER_566_168 VPWR VGND sg13cmos5l_decap_8
XFILLER_72_95 VPWR VGND sg13cmos5l_decap_8
XFILLER_618_0 VPWR VGND sg13cmos5l_decap_8
XFILLER_708_140 VPWR VGND sg13cmos5l_fill_2
XFILLER_619_42 VPWR VGND sg13cmos5l_decap_8
XFILLER_581_105 VPWR VGND sg13cmos5l_decap_8
XFILLER_507_202 VPWR VGND sg13cmos5l_decap_8
XFILLER_169_182 VPWR VGND sg13cmos5l_decap_8
XFILLER_188_84 VPWR VGND sg13cmos5l_decap_8
XFILLER_338_21 VPWR VGND sg13cmos5l_decap_8
XFILLER_184_141 VPWR VGND sg13cmos5l_decap_8
XFILLER_75_7 VPWR VGND sg13cmos5l_decap_8
XFILLER_318_146 VPWR VGND sg13cmos5l_decap_8
XFILLER_373_263 VPWR VGND sg13cmos5l_fill_2
XFILLER_338_65 VPWR VGND sg13cmos5l_decap_8
XFILLER_318_168 VPWR VGND sg13cmos5l_decap_8
X_1620_ _1620_/Q Tile_X0Y2_FrameData[29] VGND VPWR Tile_X0Y9_FrameStrobe[6] latch
XFILLER_522_205 VPWR VGND sg13cmos5l_fill_2
XFILLER_338_98 VPWR VGND sg13cmos5l_decap_8
XFILLER_207_14 VPWR VGND sg13cmos5l_decap_8
X_1551_ _1551_/Q Tile_X0Y2_FrameData[2] VGND VPWR Tile_X0Y9_FrameStrobe[3] latch
XFILLER_635_63 VPWR VGND sg13cmos5l_decap_8
XANTENNA__3018__X Tile_X0Y5_E6BEG[5] VPWR VGND sg13cmos5l_antennanp
XFILLER_354_42 VPWR VGND sg13cmos5l_decap_8
X_0502_ _0502_/Q Tile_X0Y8_FrameData[9] VGND VPWR Tile_X0Y9_FrameStrobe[2] latch
XFILLER_676_242 VPWR VGND sg13cmos5l_fill_1
X_4270_ _4270_/X Tile_X0Y4_W2END[1] AXI_M_SOC_BRESP1 _4315_/X _4314_/X _2073_/Q _2072_/Q
+ VPWR VGND sg13cmos5l_mux4_1
XFILLER_530_260 VPWR VGND sg13cmos5l_decap_8
XFILLER_487_153 VPWR VGND sg13cmos5l_decap_8
X_1482_ _1482_/Q Tile_X0Y2_FrameData[7] VGND VPWR Tile_X0Y9_FrameStrobe[1] latch
XFILLER_530_271 VPWR VGND sg13cmos5l_fill_2
XFILLER_98_147 VPWR VGND sg13cmos5l_decap_8
XFILLER_676_264 VPWR VGND sg13cmos5l_decap_8
XFILLER_140_244 VPWR VGND sg13cmos5l_decap_8
XFILLER_341_193 VPWR VGND sg13cmos5l_decap_8
X_3221_ Tile_X0Y0_FrameStrobe_O[9] Tile_X0Y9_FrameStrobe[9] VPWR VGND sg13cmos5l_buf_1
XFILLER_691_212 VPWR VGND sg13cmos5l_decap_8
XANTENNA__2857__X Tile_X0Y6_E6BEG[6] VPWR VGND sg13cmos5l_antennanp
X_0433_ _0433_/Q Tile_X0Y8_FrameData[14] VGND VPWR Tile_X0Y9_FrameStrobe[0] latch
XFILLER_691_245 VPWR VGND sg13cmos5l_decap_8
XFILLER_504_56 VPWR VGND sg13cmos5l_decap_8
XFILLER_428_231 VPWR VGND sg13cmos5l_decap_8
X_3152_ Tile_X0Y7_FrameData_O[22] Tile_X0Y7_FrameData[22] VPWR VGND sg13cmos5l_buf_1
X_0364_ _0364_/Q Tile_X0Y7_FrameData[19] VGND VPWR Tile_X0Y9_FrameStrobe[6] latch
XFILLER_651_84 VPWR VGND sg13cmos5l_decap_8
XFILLER_644_161 VPWR VGND sg13cmos5l_decap_8
X_2103_ _2103_/Q Tile_X0Y4_FrameData[14] VGND VPWR Tile_X0Y9_FrameStrobe[5] latch
X_0295_ _0295_/Q Tile_X0Y7_FrameData[24] VGND VPWR Tile_X0Y9_FrameStrobe[4] latch
X_3083_ Tile_X0Y7_E1BEG[1] _4609_/X VPWR VGND sg13cmos5l_buf_1
XFILLER_54_217 VPWR VGND sg13cmos5l_decap_8
X_2034_ _2034_/Q Tile_X0Y4_FrameData[19] VGND VPWR Tile_X0Y9_FrameStrobe[3] latch
XFILLER_299_28 VPWR VGND sg13cmos5l_decap_8
XFILLER_411_120 VPWR VGND sg13cmos5l_fill_2
XFILLER_22_114 VPWR VGND sg13cmos5l_decap_8
XFILLER_210_204 VPWR VGND sg13cmos5l_decap_8
X_3985_ _3985_/X Tile_X0Y2_W1END[2] Tile_X0Y2_W6END[6] _4107_/X _4086_/X _1669_/Q
+ _1668_/Q VPWR VGND sg13cmos5l_mux4_1
XFILLER_167_119 VPWR VGND sg13cmos5l_decap_8
XFILLER_572_105 VPWR VGND sg13cmos5l_decap_8
XFILLER_529_42 VPWR VGND sg13cmos5l_decap_8
XFILLER_210_248 VPWR VGND sg13cmos5l_decap_8
X_2936_ Tile_X0Y8_E6BEG[4] _4764_/X VPWR VGND sg13cmos5l_buf_1
XFILLER_529_53 VPWR VGND sg13cmos5l_fill_1
XFILLER_349_271 VPWR VGND sg13cmos5l_fill_2
XFILLER_676_70 VPWR VGND sg13cmos5l_decap_8
XFILLER_248_21 VPWR VGND sg13cmos5l_decap_8
XFILLER_364_230 VPWR VGND sg13cmos5l_decap_8
XFILLER_175_141 VPWR VGND sg13cmos5l_decap_8
X_2867_ Tile_X0Y6_EE4BEG[4] _4516_/X VPWR VGND sg13cmos5l_buf_1
XFILLER_395_71 VPWR VGND sg13cmos5l_decap_8
XFILLER_190_100 VPWR VGND sg13cmos5l_decap_8
XFILLER_714_154 VPWR VGND sg13cmos5l_decap_8
X_4606_ _4606_/X Tile_X0Y7_W1END[3] Tile_X0Y7_WW4END[15] Tile_X0Y7_W6END[7] _4687_/X
+ _0346_/Q _0345_/Q VPWR VGND sg13cmos5l_mux4_1
X_1818_ _1818_/Q Tile_X0Y3_FrameData[15] VGND VPWR Tile_X0Y9_FrameStrobe[4] latch
XFILLER_580_160 VPWR VGND sg13cmos5l_fill_2
X_2798_ Tile_X0Y3_E6BEG[8] _4188_/X VPWR VGND sg13cmos5l_buf_1
XFILLER_580_193 VPWR VGND sg13cmos5l_decap_4
X_4537_ _4537_/X AXI_M_SOC_RDATA29 _4570_/X _4574_/X _4556_/X _2533_/Q _2532_/Q VPWR
+ VGND sg13cmos5l_mux4_1
XFILLER_545_63 VPWR VGND sg13cmos5l_decap_8
XFILLER_117_14 VPWR VGND sg13cmos5l_decap_8
XFILLER_190_166 VPWR VGND sg13cmos5l_decap_8
X_1749_ _1749_/Q Tile_X0Y3_FrameData[20] VGND VPWR Tile_X0Y9_FrameStrobe[2] latch
XFILLER_692_80 VPWR VGND sg13cmos5l_decap_8
XFILLER_478_131 VPWR VGND sg13cmos5l_decap_8
XFILLER_264_42 VPWR VGND sg13cmos5l_decap_8
XFILLER_89_125 VPWR VGND sg13cmos5l_fill_1
XFILLER_667_242 VPWR VGND sg13cmos5l_decap_8
XFILLER_264_53 VPWR VGND sg13cmos5l_fill_1
X_4468_ _4468_/X Tile_X0Y4_W2MID[7] Tile_X0Y4_W2END[7] Tile_X0Y4_W6END[8] _4313_/X
+ _2137_/Q _2136_/Q VPWR VGND sg13cmos5l_mux4_1
XFILLER_521_271 VPWR VGND sg13cmos5l_fill_2
XFILLER_117_69 VPWR VGND sg13cmos5l_decap_8
XFILLER_77_29 VPWR VGND sg13cmos5l_decap_8
XFILLER_89_147 VPWR VGND sg13cmos5l_decap_8
XFILLER_332_193 VPWR VGND sg13cmos5l_decap_8
XFILLER_493_112 VPWR VGND sg13cmos5l_decap_8
XANTENNA__2767__X Tile_X0Y3_FrameData_O[25] VPWR VGND sg13cmos5l_antennanp
XFILLER_131_255 VPWR VGND sg13cmos5l_fill_1
X_3419_ Tile_X0Y4_FrameData_O[10] Tile_X0Y4_FrameData[10] VPWR VGND sg13cmos5l_buf_1
XFILLER_682_212 VPWR VGND sg13cmos5l_fill_1
X_4399_ _4399_/X Tile_X0Y5_WW4END[4] AXI_M_SOC_RVALID _4455_/X _4433_/X _2305_/Q _2304_/Q
+ VPWR VGND sg13cmos5l_mux4_1
XFILLER_419_231 VPWR VGND sg13cmos5l_decap_8
XFILLER_414_56 VPWR VGND sg13cmos5l_decap_8
XFILLER_561_84 VPWR VGND sg13cmos5l_decap_8
XFILLER_133_35 VPWR VGND sg13cmos5l_decap_8
XFILLER_711_21 VPWR VGND sg13cmos5l_decap_8
XFILLER_493_189 VPWR VGND sg13cmos5l_decap_4
XFILLER_635_161 VPWR VGND sg13cmos5l_decap_8
XFILLER_280_63 VPWR VGND sg13cmos5l_decap_8
XFILLER_277_7 VPWR VGND sg13cmos5l_decap_8
XANTENNA_205 Tile_X0Y9_N2MID[6] VPWR VGND sg13cmos5l_antennanp
XFILLER_711_98 VPWR VGND sg13cmos5l_decap_8
XANTENNA_216 Tile_X0Y9_N4END[14] VPWR VGND sg13cmos5l_antennanp
XANTENNA_227 Tile_X0Y9_N4END[14] VPWR VGND sg13cmos5l_antennanp
XANTENNA__3598__X Tile_X0Y9_FrameData_O[28] VPWR VGND sg13cmos5l_antennanp
XFILLER_650_175 VPWR VGND sg13cmos5l_decap_8
XANTENNA_238 _4594_/X VPWR VGND sg13cmos5l_antennanp
XFILLER_430_77 VPWR VGND sg13cmos5l_decap_8
XFILLER_444_7 VPWR VGND sg13cmos5l_decap_8
XFILLER_588_271 VPWR VGND sg13cmos5l_fill_2
XFILLER_26_77 VPWR VGND sg13cmos5l_decap_8
XFILLER_260_159 VPWR VGND sg13cmos5l_decap_8
XFILLER_158_4 VPWR VGND sg13cmos5l_fill_1
XFILLER_198_255 VPWR VGND sg13cmos5l_fill_2
XFILLER_347_208 VPWR VGND sg13cmos5l_decap_8
XFILLER_13_158 VPWR VGND sg13cmos5l_decap_8
XFILLER_9_107 VPWR VGND sg13cmos5l_decap_8
XFILLER_611_7 VPWR VGND sg13cmos5l_decap_8
XFILLER_563_105 VPWR VGND sg13cmos5l_decap_8
XFILLER_439_42 VPWR VGND sg13cmos5l_decap_8
XFILLER_42_21 VPWR VGND sg13cmos5l_decap_8
XFILLER_709_7 VPWR VGND sg13cmos5l_decap_8
XFILLER_586_70 VPWR VGND sg13cmos5l_decap_8
XFILLER_158_43 VPWR VGND sg13cmos5l_decap_8
XFILLER_166_185 VPWR VGND sg13cmos5l_decap_8
XFILLER_504_216 VPWR VGND sg13cmos5l_decap_8
XFILLER_571_182 VPWR VGND sg13cmos5l_decap_8
XFILLER_308_35 VPWR VGND sg13cmos5l_decap_8
XFILLER_107_241 VPWR VGND sg13cmos5l_decap_8
XFILLER_672_28 VPWR VGND sg13cmos5l_decap_8
XFILLER_101_0 VPWR VGND sg13cmos5l_decap_8
XFILLER_455_85 VPWR VGND sg13cmos5l_decap_8
XFILLER_330_108 VPWR VGND sg13cmos5l_decap_8
XFILLER_330_119 VPWR VGND sg13cmos5l_fill_1
XFILLER_181_199 VPWR VGND sg13cmos5l_decap_8
XFILLER_512_260 VPWR VGND sg13cmos5l_fill_2
XFILLER_323_160 VPWR VGND sg13cmos5l_decap_8
XFILLER_469_164 VPWR VGND sg13cmos5l_decap_8
XFILLER_323_193 VPWR VGND sg13cmos5l_decap_8
XFILLER_174_97 VPWR VGND sg13cmos5l_decap_4
XFILLER_673_223 VPWR VGND sg13cmos5l_decap_8
XFILLER_268_259 VPWR VGND sg13cmos5l_fill_2
XFILLER_484_145 VPWR VGND sg13cmos5l_decap_8
XFILLER_190_30 VPWR VGND sg13cmos5l_fill_1
XFILLER_621_21 VPWR VGND sg13cmos5l_decap_8
XFILLER_471_95 VPWR VGND sg13cmos5l_fill_1
XFILLER_470_0 VPWR VGND sg13cmos5l_decap_8
XFILLER_190_52 VPWR VGND sg13cmos5l_decap_8
XFILLER_67_84 VPWR VGND sg13cmos5l_decap_8
XFILLER_568_0 VPWR VGND sg13cmos5l_decap_8
XFILLER_425_256 VPWR VGND sg13cmos5l_decap_4
XFILLER_36_228 VPWR VGND sg13cmos5l_decap_4
XFILLER_36_239 VPWR VGND sg13cmos5l_decap_4
X_0080_ _0080_/X _4914_/X _4915_/X _2368_/Q VPWR VGND sg13cmos5l_mux2_1
XFILLER_697_14 VPWR VGND sg13cmos5l_decap_8
XFILLER_621_98 VPWR VGND sg13cmos5l_decap_8
XFILLER_641_175 VPWR VGND sg13cmos5l_decap_8
XFILLER_340_88 VPWR VGND sg13cmos5l_decap_8
XFILLER_83_72 VPWR VGND sg13cmos5l_fill_1
XANTENNA__3301__X Tile_X0Y0_E2BEG[1] VPWR VGND sg13cmos5l_antennanp
XFILLER_83_94 VPWR VGND sg13cmos5l_decap_8
XFILLER_44_272 VPWR VGND sg13cmos5l_fill_1
XFILLER_189_255 VPWR VGND sg13cmos5l_decap_8
XFILLER_349_42 VPWR VGND sg13cmos5l_decap_8
X_3770_ _3770_/X Tile_X0Y1_WW4END[3] Tile_X0Y1_WW4END[11] Tile_X0Y1_W6END[11] _4019_/X
+ _1235_/Q _1234_/Q VPWR VGND sg13cmos5l_mux4_1
X_0982_ _0982_/Q Tile_X0Y0_FrameData[21] VGND VPWR Tile_X0Y9_FrameStrobe[1] latch
XFILLER_496_70 VPWR VGND sg13cmos5l_decap_8
X_2721_ _4659_/A3 VPWR VGND sg13cmos5l_tielo
XFILLER_554_149 VPWR VGND sg13cmos5l_decap_8
XFILLER_12_180 VPWR VGND sg13cmos5l_decap_8
XFILLER_346_241 VPWR VGND sg13cmos5l_decap_4
XFILLER_157_152 VPWR VGND sg13cmos5l_decap_8
XFILLER_8_140 VPWR VGND sg13cmos5l_decap_8
XFILLER_157_163 VPWR VGND sg13cmos5l_fill_1
XFILLER_157_185 VPWR VGND sg13cmos5l_decap_8
X_2652_ _2652_/Q Tile_X0Y6_FrameData[11] VGND VPWR Tile_X0Y9_FrameStrobe[6] latch
XFILLER_646_84 VPWR VGND sg13cmos5l_decap_8
XFILLER_218_35 VPWR VGND sg13cmos5l_decap_8
XFILLER_562_182 VPWR VGND sg13cmos5l_decap_8
XFILLER_306_138 VPWR VGND sg13cmos5l_decap_4
XFILLER_306_149 VPWR VGND sg13cmos5l_decap_4
X_1603_ _1603_/Q Tile_X0Y2_FrameData[14] VGND VPWR Tile_X0Y9_FrameStrobe[5] latch
XFILLER_582_28 VPWR VGND sg13cmos5l_decap_8
XFILLER_365_63 VPWR VGND sg13cmos5l_decap_8
X_2583_ _2583_/Q Tile_X0Y6_FrameData[16] VGND VPWR Tile_X0Y9_FrameStrobe[4] latch
XFILLER_365_74 VPWR VGND sg13cmos5l_fill_2
XFILLER_649_220 VPWR VGND sg13cmos5l_decap_8
XFILLER_172_188 VPWR VGND sg13cmos5l_decap_8
XFILLER_172_199 VPWR VGND sg13cmos5l_fill_1
X_4322_ _4322_/X Tile_X0Y8_W1END[0] Tile_X0Y8_WW4END[0] Tile_X0Y8_W6END[8] _4800_/X
+ _0647_/Q _0646_/Q VPWR VGND sg13cmos5l_mux4_1
X_1534_ _1534_/Q Tile_X0Y2_FrameData[19] VGND VPWR Tile_X0Y9_FrameStrobe[3] latch
XFILLER_259_204 VPWR VGND sg13cmos5l_decap_8
XFILLER_113_244 VPWR VGND sg13cmos5l_fill_2
XFILLER_664_212 VPWR VGND sg13cmos5l_decap_8
XFILLER_609_117 VPWR VGND sg13cmos5l_decap_4
X_4253_ _4253_/X _4305_/X _4304_/X AXI_M_SOC_BRESP0 _4303_/X _2107_/Q _2106_/Q VPWR
+ VGND sg13cmos5l_mux4_1
XFILLER_609_128 VPWR VGND sg13cmos5l_decap_8
XFILLER_515_77 VPWR VGND sg13cmos5l_decap_8
X_1465_ _1465_/Q Tile_X0Y2_FrameData[24] VGND VPWR Tile_X0Y9_FrameStrobe[1] latch
XFILLER_609_139 VPWR VGND sg13cmos5l_fill_1
X_3204_ Tile_X0Y0_N2BEG[4] _3788_/X VPWR VGND sg13cmos5l_buf_1
XFILLER_234_67 VPWR VGND sg13cmos5l_decap_8
X_0416_ _0416_/Q Tile_X0Y7_FrameData[31] VGND VPWR Tile_X0Y9_FrameStrobe[0] latch
X_4184_ _4184_/X AXI_M_SOC_WREADY _4229_/X _4233_/X _4205_/X _1773_/Q _1772_/Q VPWR
+ VGND sg13cmos5l_mux4_1
X_1396_ _1396_/Q Tile_X0Y1_FrameData[5] VGND VPWR Tile_X0Y9_FrameStrobe[6] latch
XFILLER_531_21 VPWR VGND sg13cmos5l_decap_8
XFILLER_381_95 VPWR VGND sg13cmos5l_decap_8
XFILLER_617_161 VPWR VGND sg13cmos5l_decap_8
XFILLER_490_126 VPWR VGND sg13cmos5l_decap_8
X_3135_ Tile_X0Y7_FrameData_O[5] Tile_X0Y7_FrameData[5] VPWR VGND sg13cmos5l_buf_1
X_0347_ _0347_/Q Tile_X0Y7_FrameData[4] VGND VPWR Tile_X0Y9_FrameStrobe[5] latch
XFILLER_27_217 VPWR VGND sg13cmos5l_decap_8
XFILLER_94_172 VPWR VGND sg13cmos5l_decap_8
XFILLER_103_49 VPWR VGND sg13cmos5l_decap_8
X_3066_ Tile_X0Y5_FrameData_O[25] Tile_X0Y5_FrameData[25] VPWR VGND sg13cmos5l_buf_1
X_0278_ _0278_/Q Tile_X0Y7_FrameData[9] VGND VPWR Tile_X0Y9_FrameStrobe[3] latch
XFILLER_242_115 VPWR VGND sg13cmos5l_decap_8
X_2017_ _2017_/Q Tile_X0Y4_FrameData[4] VGND VPWR Tile_X0Y9_FrameStrobe[2] latch
XFILLER_400_14 VPWR VGND sg13cmos5l_decap_8
XANTENNA__3211__X Tile_X0Y0_N1BEG[3] VPWR VGND sg13cmos5l_antennanp
XFILLER_250_99 VPWR VGND sg13cmos5l_decap_8
XFILLER_585_230 VPWR VGND sg13cmos5l_decap_8
XFILLER_545_105 VPWR VGND sg13cmos5l_decap_8
X_3968_ _3968_/X AXI_M_SOC_ARREADY _4015_/X _4019_/X _3989_/X _1273_/Q _1272_/Q VPWR
+ VGND sg13cmos5l_mux4_1
XFILLER_195_269 VPWR VGND sg13cmos5l_decap_4
X_2919_ Tile_X0Y8_E2BEG[3] _4731_/X VPWR VGND sg13cmos5l_buf_1
XFILLER_337_241 VPWR VGND sg13cmos5l_fill_2
XFILLER_259_97 VPWR VGND sg13cmos5l_decap_8
X_3899_ _3899_/X Tile_X0Y1_W2MID[2] Tile_X0Y1_W2END[2] Tile_X0Y1_W6END[2] _3992_/X
+ _1407_/Q _1406_/Q VPWR VGND sg13cmos5l_mux4_1
XFILLER_12_35 VPWR VGND sg13cmos5l_decap_8
XFILLER_560_119 VPWR VGND sg13cmos5l_decap_8
XFILLER_409_56 VPWR VGND sg13cmos5l_decap_8
XFILLER_148_196 VPWR VGND sg13cmos5l_decap_8
XFILLER_128_35 VPWR VGND sg13cmos5l_decap_8
XFILLER_556_84 VPWR VGND sg13cmos5l_decap_8
XFILLER_12_79 VPWR VGND sg13cmos5l_fill_1
XFILLER_163_144 VPWR VGND sg13cmos5l_decap_8
XFILLER_706_21 VPWR VGND sg13cmos5l_decap_8
XFILLER_492_28 VPWR VGND sg13cmos5l_decap_8
XFILLER_275_63 VPWR VGND sg13cmos5l_decap_8
XFILLER_88_28 VPWR VGND sg13cmos5l_decap_8
XFILLER_706_98 VPWR VGND sg13cmos5l_decap_8
XFILLER_5_7 VPWR VGND sg13cmos5l_decap_8
XFILLER_104_255 VPWR VGND sg13cmos5l_decap_8
XFILLER_425_77 VPWR VGND sg13cmos5l_decap_8
XFILLER_144_56 VPWR VGND sg13cmos5l_decap_8
XFILLER_466_145 VPWR VGND sg13cmos5l_decap_8
XFILLER_441_21 VPWR VGND sg13cmos5l_decap_8
XFILLER_218_112 VPWR VGND sg13cmos5l_fill_2
XFILLER_561_7 VPWR VGND sg13cmos5l_decap_8
XFILLER_407_223 VPWR VGND sg13cmos5l_decap_8
XFILLER_37_32 VPWR VGND sg13cmos5l_decap_8
XFILLER_659_7 VPWR VGND sg13cmos5l_decap_8
XFILLER_233_104 VPWR VGND sg13cmos5l_decap_8
XFILLER_422_215 VPWR VGND sg13cmos5l_decap_8
XFILLER_160_77 VPWR VGND sg13cmos5l_decap_8
XANTENNA__3121__X Tile_X0Y7_EE4BEG[7] VPWR VGND sg13cmos5l_antennanp
XFILLER_442_4 VPWR VGND sg13cmos5l_fill_1
XFILLER_667_28 VPWR VGND sg13cmos5l_decap_8
XFILLER_41_231 VPWR VGND sg13cmos5l_decap_4
XFILLER_53_53 VPWR VGND sg13cmos5l_decap_8
XANTENNA__2960__X Tile_X0Y8_FrameData_O[0] VPWR VGND sg13cmos5l_antennanp
XFILLER_149_0 VPWR VGND sg13cmos5l_decap_8
XFILLER_169_42 VPWR VGND sg13cmos5l_decap_8
XFILLER_53_75 VPWR VGND sg13cmos5l_decap_8
XFILLER_536_105 VPWR VGND sg13cmos5l_fill_1
XFILLER_241_192 VPWR VGND sg13cmos5l_decap_8
XFILLER_186_225 VPWR VGND sg13cmos5l_decap_8
XFILLER_387_185 VPWR VGND sg13cmos5l_fill_2
XFILLER_536_127 VPWR VGND sg13cmos5l_decap_8
XFILLER_328_241 VPWR VGND sg13cmos5l_decap_8
XFILLER_316_0 VPWR VGND sg13cmos5l_decap_8
XFILLER_343_200 VPWR VGND sg13cmos5l_decap_8
XFILLER_319_67 VPWR VGND sg13cmos5l_fill_1
XFILLER_139_196 VPWR VGND sg13cmos5l_decap_8
XFILLER_616_21 VPWR VGND sg13cmos5l_decap_8
XFILLER_5_121 VPWR VGND sg13cmos5l_decap_8
XFILLER_319_89 VPWR VGND sg13cmos5l_decap_8
XFILLER_185_52 VPWR VGND sg13cmos5l_decap_8
XFILLER_154_188 VPWR VGND sg13cmos5l_decap_8
XFILLER_616_98 VPWR VGND sg13cmos5l_decap_8
XFILLER_685_0 VPWR VGND sg13cmos5l_decap_8
XFILLER_311_141 VPWR VGND sg13cmos5l_fill_1
XFILLER_646_245 VPWR VGND sg13cmos5l_decap_8
XFILLER_500_252 VPWR VGND sg13cmos5l_decap_4
XFILLER_110_225 VPWR VGND sg13cmos5l_decap_8
XFILLER_632_42 VPWR VGND sg13cmos5l_decap_8
X_1250_ _1250_/Q Tile_X0Y1_FrameData[23] VGND VPWR Tile_X0Y9_FrameStrobe[2] latch
XFILLER_256_218 VPWR VGND sg13cmos5l_decap_8
XFILLER_311_196 VPWR VGND sg13cmos5l_fill_2
XFILLER_351_21 VPWR VGND sg13cmos5l_decap_8
X_0201_ _0201_/Q Tile_X0Y7_FrameData[22] VGND VPWR Tile_X0Y9_FrameStrobe[1] latch
XFILLER_661_226 VPWR VGND sg13cmos5l_decap_8
X_1181_ _1181_/Q Tile_X0Y1_FrameData[28] VGND VPWR Tile_X0Y9_FrameStrobe[0] latch
XFILLER_472_148 VPWR VGND sg13cmos5l_decap_8
XFILLER_209_156 VPWR VGND sg13cmos5l_decap_8
XFILLER_94_60 VPWR VGND sg13cmos5l_decap_8
XFILLER_264_262 VPWR VGND sg13cmos5l_decap_8
X_0132_ AXI_M_SOC_AWLEN7 _0940_/Q _3678_/X VPWR VGND sg13cmos5l_nor2b_1
XFILLER_351_98 VPWR VGND sg13cmos5l_decap_8
XFILLER_91_131 VPWR VGND sg13cmos5l_decap_8
XFILLER_501_35 VPWR VGND sg13cmos5l_decap_8
XFILLER_220_14 VPWR VGND sg13cmos5l_decap_8
X_0063_ _3628_/A _4604_/X _4605_/X _0347_/Q VPWR VGND sg13cmos5l_mux2_1
X_4940_ _4940_/X Tile_X0Y3_WW4END[3] Tile_X0Y3_WW4END[11] Tile_X0Y3_W6END[11] _4233_/X
+ _1735_/Q _1734_/Q VPWR VGND sg13cmos5l_mux4_1
XFILLER_614_197 VPWR VGND sg13cmos5l_decap_8
XFILLER_413_237 VPWR VGND sg13cmos5l_decap_8
XFILLER_224_159 VPWR VGND sg13cmos5l_decap_8
XANTENNA__3031__X Tile_X0Y5_EE4BEG[6] VPWR VGND sg13cmos5l_antennanp
XFILLER_17_272 VPWR VGND sg13cmos5l_fill_1
X_4871_ _4871_/X Tile_X0Y9_WW4END[8] AXI_M_SOC_RDATA7 _4924_/X _4901_/X _0801_/Q _0800_/Q
+ VPWR VGND sg13cmos5l_mux4_1
XFILLER_577_28 VPWR VGND sg13cmos5l_decap_8
XANTENNA__2870__X Tile_X0Y6_EE4BEG[7] VPWR VGND sg13cmos5l_antennanp
X_3822_ _3822_/X Tile_X0Y0_WW4END[5] Tile_X0Y0_WW4END[13] _3871_/X _3856_/X _1061_/Q
+ _1060_/Q VPWR VGND sg13cmos5l_mux4_1
XFILLER_582_211 VPWR VGND sg13cmos5l_decap_8
XFILLER_716_238 VPWR VGND sg13cmos5l_fill_1
X_3753_ AXI_M_SOC_ARADDR25 Tile_X0Y8_WW4END[1] Tile_X0Y8_WW4END[9] Tile_X0Y8_W6END[9]
+ _4809_/X _0485_/Q _0484_/Q VPWR VGND sg13cmos5l_mux4_1
X_0965_ _0965_/Q Tile_X0Y0_FrameData[6] VGND VPWR Tile_X0Y9_FrameStrobe[0] latch
XFILLER_229_56 VPWR VGND sg13cmos5l_decap_8
X_2704_ _4193_/A3 VPWR VGND sg13cmos5l_tielo
XFILLER_542_119 VPWR VGND sg13cmos5l_decap_8
XFILLER_334_211 VPWR VGND sg13cmos5l_decap_8
X_3684_ _3684_/X Tile_X0Y3_WW4END[2] Tile_X0Y3_WW4END[10] Tile_X0Y3_W6END[2] _4224_/X
+ _1753_/Q _1752_/Q VPWR VGND sg13cmos5l_mux4_1
XFILLER_593_49 VPWR VGND sg13cmos5l_decap_8
XFILLER_376_84 VPWR VGND sg13cmos5l_decap_8
XFILLER_145_133 VPWR VGND sg13cmos5l_decap_4
X_0896_ _0896_/Q Tile_X0Y9_FrameData[31] VGND VPWR Tile_X0Y9_FrameStrobe[7] latch
XFILLER_64_0 VPWR VGND sg13cmos5l_decap_8
XFILLER_526_21 VPWR VGND sg13cmos5l_decap_8
X_2635_ _2635_/Q Tile_X0Y6_FrameData[28] VGND VPWR Tile_X0Y9_FrameStrobe[6] latch
XFILLER_145_177 VPWR VGND sg13cmos5l_decap_4
X_2566_ _2566_/Q Tile_X0Y6_FrameData[1] VGND VPWR Tile_X0Y9_FrameStrobe[3] latch
XFILLER_160_147 VPWR VGND sg13cmos5l_decap_8
XFILLER_299_181 VPWR VGND sg13cmos5l_decap_4
X_4305_ _4305_/X Tile_X0Y5_W1END[1] Tile_X0Y5_W6END[5] _4464_/X _4419_/X _2437_/Q
+ _2436_/Q VPWR VGND sg13cmos5l_mux4_1
XFILLER_448_112 VPWR VGND sg13cmos5l_decap_8
X_1517_ _1517_/Q Tile_X0Y2_FrameData[4] VGND VPWR Tile_X0Y9_FrameStrobe[2] latch
X_2497_ _2497_/Q Tile_X0Y6_FrameData[6] VGND VPWR Tile_X0Y9_FrameStrobe[1] latch
XANTENNA__3206__X Tile_X0Y0_N2BEG[6] VPWR VGND sg13cmos5l_antennanp
XFILLER_542_42 VPWR VGND sg13cmos5l_decap_8
X_4236_ _4236_/X Tile_X0Y2_W2MID[7] Tile_X0Y2_W2END[7] Tile_X0Y2_W6END[8] _4097_/X
+ _1629_/Q _1628_/Q VPWR VGND sg13cmos5l_mux4_1
XFILLER_4_91 VPWR VGND sg13cmos5l_decap_8
XFILLER_247_218 VPWR VGND sg13cmos5l_decap_8
X_1448_ _1448_/Q Tile_X0Y2_FrameData[9] VGND VPWR Tile_X0Y9_FrameStrobe[0] latch
XFILLER_261_21 VPWR VGND sg13cmos5l_decap_8
XFILLER_463_137 VPWR VGND sg13cmos5l_decap_8
X_4167_ _4167_/X Tile_X0Y3_WW4END[12] AXI_M_SOC_BVALID _4234_/X _4210_/X _1807_/Q
+ _1806_/Q VPWR VGND sg13cmos5l_mux4_1
X_1379_ _1379_/Q Tile_X0Y1_FrameData[22] VGND VPWR Tile_X0Y9_FrameStrobe[6] latch
XFILLER_67_161 VPWR VGND sg13cmos5l_decap_8
X_3118_ Tile_X0Y7_EE4BEG[4] _4632_/X VPWR VGND sg13cmos5l_buf_1
XFILLER_82_131 VPWR VGND sg13cmos5l_decap_8
X_4098_ _4098_/X _4033_/X _4141_/X _4140_/X _4032_/X _1437_/Q _1436_/Q VPWR VGND sg13cmos5l_mux4_1
XFILLER_411_35 VPWR VGND sg13cmos5l_decap_8
XFILLER_130_14 VPWR VGND sg13cmos5l_decap_8
X_3049_ Tile_X0Y5_FrameData_O[8] Tile_X0Y5_FrameData[8] VPWR VGND sg13cmos5l_buf_1
XFILLER_215_159 VPWR VGND sg13cmos5l_fill_1
XFILLER_82_197 VPWR VGND sg13cmos5l_decap_8
XFILLER_620_167 VPWR VGND sg13cmos5l_decap_8
XFILLER_487_28 VPWR VGND sg13cmos5l_decap_8
XFILLER_230_129 VPWR VGND sg13cmos5l_decap_8
XFILLER_558_241 VPWR VGND sg13cmos5l_fill_2
XFILLER_369_152 VPWR VGND sg13cmos5l_decap_8
XFILLER_223_170 VPWR VGND sg13cmos5l_fill_2
XFILLER_412_270 VPWR VGND sg13cmos5l_fill_2
XFILLER_168_214 VPWR VGND sg13cmos5l_decap_8
XANTENNA__2780__X Tile_X0Y3_EE4BEG[6] VPWR VGND sg13cmos5l_antennanp
XFILLER_518_105 VPWR VGND sg13cmos5l_decap_4
XFILLER_23_264 VPWR VGND sg13cmos5l_fill_1
XFILLER_142_7 VPWR VGND sg13cmos5l_decap_8
XFILLER_518_116 VPWR VGND sg13cmos5l_fill_2
XFILLER_384_111 VPWR VGND sg13cmos5l_fill_2
XFILLER_384_133 VPWR VGND sg13cmos5l_fill_1
XFILLER_210_91 VPWR VGND sg13cmos5l_decap_8
XFILLER_707_238 VPWR VGND sg13cmos5l_fill_1
XFILLER_384_177 VPWR VGND sg13cmos5l_decap_8
XFILLER_139_56 VPWR VGND sg13cmos5l_decap_8
XFILLER_715_271 VPWR VGND sg13cmos5l_fill_2
XFILLER_407_7 VPWR VGND sg13cmos5l_decap_8
XFILLER_286_84 VPWR VGND sg13cmos5l_decap_8
XFILLER_436_21 VPWR VGND sg13cmos5l_decap_8
XFILLER_99_49 VPWR VGND sg13cmos5l_decap_8
XFILLER_325_244 VPWR VGND sg13cmos5l_decap_8
XFILLER_191_261 VPWR VGND sg13cmos5l_decap_4
XFILLER_151_114 VPWR VGND sg13cmos5l_decap_8
XFILLER_436_98 VPWR VGND sg13cmos5l_decap_8
XFILLER_340_247 VPWR VGND sg13cmos5l_decap_8
XFILLER_2_135 VPWR VGND sg13cmos5l_decap_8
XFILLER_305_14 VPWR VGND sg13cmos5l_decap_8
XANTENNA__3116__X Tile_X0Y7_EE4BEG[2] VPWR VGND sg13cmos5l_antennanp
XFILLER_48_20 VPWR VGND sg13cmos5l_decap_8
XFILLER_452_42 VPWR VGND sg13cmos5l_decap_8
XFILLER_171_21 VPWR VGND sg13cmos5l_decap_8
XFILLER_452_75 VPWR VGND sg13cmos5l_decap_8
XFILLER_454_126 VPWR VGND sg13cmos5l_decap_8
XANTENNA__2955__X Tile_X0Y8_EE4BEG[11] VPWR VGND sg13cmos5l_antennanp
XFILLER_602_56 VPWR VGND sg13cmos5l_fill_2
XFILLER_0_49 VPWR VGND sg13cmos5l_decap_8
XFILLER_73_153 VPWR VGND sg13cmos5l_fill_1
XFILLER_104_92 VPWR VGND sg13cmos5l_decap_8
XFILLER_206_137 VPWR VGND sg13cmos5l_decap_8
XFILLER_266_0 VPWR VGND sg13cmos5l_decap_8
XFILLER_261_232 VPWR VGND sg13cmos5l_decap_8
XFILLER_678_49 VPWR VGND sg13cmos5l_decap_8
XFILLER_64_63 VPWR VGND sg13cmos5l_decap_8
XFILLER_397_28 VPWR VGND sg13cmos5l_decap_8
XFILLER_159_214 VPWR VGND sg13cmos5l_fill_1
XFILLER_9_14 VPWR VGND sg13cmos5l_decap_8
XFILLER_433_0 VPWR VGND sg13cmos5l_decap_8
XFILLER_509_105 VPWR VGND sg13cmos5l_decap_8
XFILLER_14_264 VPWR VGND sg13cmos5l_fill_1
XFILLER_564_233 VPWR VGND sg13cmos5l_decap_8
XFILLER_564_244 VPWR VGND sg13cmos5l_decap_8
XFILLER_564_255 VPWR VGND sg13cmos5l_fill_1
XFILLER_600_0 VPWR VGND sg13cmos5l_decap_8
XFILLER_713_208 VPWR VGND sg13cmos5l_fill_2
XFILLER_375_188 VPWR VGND sg13cmos5l_decap_8
XFILLER_627_42 VPWR VGND sg13cmos5l_decap_8
XFILLER_316_211 VPWR VGND sg13cmos5l_decap_8
X_0750_ _0750_/Q Tile_X0Y9_FrameData[17] VGND VPWR Tile_X0Y9_FrameStrobe[2] latch
XFILLER_196_84 VPWR VGND sg13cmos5l_decap_8
XFILLER_706_271 VPWR VGND sg13cmos5l_fill_2
XFILLER_678_101 VPWR VGND sg13cmos5l_decap_4
XFILLER_346_21 VPWR VGND sg13cmos5l_decap_8
XFILLER_127_155 VPWR VGND sg13cmos5l_decap_8
XFILLER_532_130 VPWR VGND sg13cmos5l_decap_8
XFILLER_182_261 VPWR VGND sg13cmos5l_decap_8
X_0681_ _0681_/Q Tile_X0Y9_FrameData[22] VGND VPWR Tile_X0Y9_FrameStrobe[0] latch
XFILLER_678_134 VPWR VGND sg13cmos5l_decap_4
XFILLER_182_272 VPWR VGND sg13cmos5l_fill_1
X_2420_ _2420_/Q Tile_X0Y5_FrameData[17] VGND VPWR Tile_X0Y9_FrameStrobe[7] latch
XFILLER_142_136 VPWR VGND sg13cmos5l_decap_8
XFILLER_678_167 VPWR VGND sg13cmos5l_decap_8
XFILLER_477_218 VPWR VGND sg13cmos5l_fill_2
XFILLER_288_129 VPWR VGND sg13cmos5l_decap_8
XFILLER_619_201 VPWR VGND sg13cmos5l_fill_2
X_2351_ _2351_/Q Tile_X0Y5_FrameData[22] VGND VPWR Tile_X0Y9_FrameStrobe[5] latch
XFILLER_643_63 VPWR VGND sg13cmos5l_decap_8
XFILLER_215_14 VPWR VGND sg13cmos5l_decap_8
XANTENNA__3026__X Tile_X0Y5_EE4BEG[1] VPWR VGND sg13cmos5l_antennanp
XFILLER_693_159 VPWR VGND sg13cmos5l_decap_8
XFILLER_362_42 VPWR VGND sg13cmos5l_decap_8
X_1302_ _1302_/Q Tile_X0Y1_FrameData[3] VGND VPWR Tile_X0Y9_FrameStrobe[3] latch
XFILLER_485_262 VPWR VGND sg13cmos5l_fill_2
XFILLER_150_191 VPWR VGND sg13cmos5l_decap_4
X_2282_ _2282_/Q Tile_X0Y5_FrameData[27] VGND VPWR Tile_X0Y9_FrameStrobe[3] latch
XFILLER_445_104 VPWR VGND sg13cmos5l_decap_4
XFILLER_96_256 VPWR VGND sg13cmos5l_fill_1
XFILLER_445_115 VPWR VGND sg13cmos5l_decap_8
X_4021_ _4021_/X Tile_X0Y3_W2MID[7] Tile_X0Y3_W2END[7] Tile_X0Y3_W6END[7] _4205_/X
+ _1917_/Q _1916_/Q VPWR VGND sg13cmos5l_mux4_1
XFILLER_56_109 VPWR VGND sg13cmos5l_decap_8
XANTENNA__2865__X Tile_X0Y6_EE4BEG[2] VPWR VGND sg13cmos5l_antennanp
X_1233_ _1233_/Q Tile_X0Y1_FrameData[8] VGND VPWR Tile_X0Y9_FrameStrobe[1] latch
XFILLER_49_161 VPWR VGND sg13cmos5l_decap_8
XFILLER_512_56 VPWR VGND sg13cmos5l_decap_8
XFILLER_237_262 VPWR VGND sg13cmos5l_fill_2
XFILLER_49_194 VPWR VGND sg13cmos5l_decap_8
X_1164_ _1164_/Q Tile_X0Y0_FrameData[31] VGND VPWR Tile_X0Y9_FrameStrobe[7] latch
XFILLER_599_141 VPWR VGND sg13cmos5l_fill_2
XFILLER_231_35 VPWR VGND sg13cmos5l_decap_8
XFILLER_453_170 VPWR VGND sg13cmos5l_decap_8
X_0115_ AXI_M_SOC_ARSIZE0 _0932_/Q _3768_/X VPWR VGND sg13cmos5l_nor2b_1
XFILLER_64_175 VPWR VGND sg13cmos5l_decap_8
X_1095_ _1095_/Q Tile_X0Y0_FrameData[4] VGND VPWR Tile_X0Y9_FrameStrobe[4] latch
XFILLER_588_49 VPWR VGND sg13cmos5l_decap_8
XFILLER_231_79 VPWR VGND sg13cmos5l_decap_8
XFILLER_602_156 VPWR VGND sg13cmos5l_decap_8
XFILLER_398_258 VPWR VGND sg13cmos5l_fill_2
X_0046_ _0046_/X _4220_/X _4221_/X _0380_/Q VPWR VGND sg13cmos5l_mux2_1
X_4923_ _4923_/X Tile_X0Y9_N1END[3] Tile_X0Y9_N4END[3] _4899_/X _0080_/X _0713_/Q
+ _0712_/Q VPWR VGND sg13cmos5l_mux4_1
XANTENNA__3696__X AXI_M_SOC_WDATA6 VPWR VGND sg13cmos5l_antennanp
XFILLER_100_28 VPWR VGND sg13cmos5l_decap_8
XFILLER_555_200 VPWR VGND sg13cmos5l_fill_1
X_4854_ _4854_/X Tile_X0Y9_W2MID[1] AXI_M_SOC_RDATA6 _4903_/X _4902_/X _0835_/Q _0834_/Q
+ VPWR VGND sg13cmos5l_mux4_1
XFILLER_555_222 VPWR VGND sg13cmos5l_decap_8
XFILLER_220_151 VPWR VGND sg13cmos5l_decap_4
X_3805_ _3805_/X Tile_X0Y0_W2MID[3] Tile_X0Y0_W2MID[6] _3855_/X _3854_/X _1095_/Q
+ _1094_/Q VPWR VGND sg13cmos5l_mux4_1
X_4785_ _4785_/X _4701_/X Tile_X0Y9_N2MID[0] _4816_/X _4700_/X _0439_/Q _0438_/Q VPWR
+ VGND sg13cmos5l_mux4_1
XFILLER_387_94 VPWR VGND sg13cmos5l_decap_4
X_1997_ _1997_/Q Tile_X0Y4_FrameData[24] VGND VPWR Tile_X0Y9_FrameStrobe[2] latch
XFILLER_570_203 VPWR VGND sg13cmos5l_decap_8
XFILLER_537_42 VPWR VGND sg13cmos5l_decap_8
X_3736_ AXI_M_SOC_ARADDR8 Tile_X0Y9_WW4END[0] Tile_X0Y9_WW4END[8] Tile_X0Y9_W6END[8]
+ _4924_/X _0743_/Q _0742_/Q VPWR VGND sg13cmos5l_mux4_1
X_0948_ _0948_/Q Tile_X0Y0_FrameData[23] VGND VPWR Tile_X0Y9_FrameStrobe[0] latch
XFILLER_109_15 VPWR VGND sg13cmos5l_decap_8
XFILLER_256_21 VPWR VGND sg13cmos5l_decap_8
X_3667_ AXI_M_SOC_AWADDR28 Tile_X0Y4_W1END[0] Tile_X0Y4_WW4END[4] Tile_X0Y4_WW4END[12]
+ _4348_/X _1989_/Q _1988_/Q VPWR VGND sg13cmos5l_mux4_1
X_0879_ _0879_/Q Tile_X0Y9_FrameData[16] VGND VPWR Tile_X0Y9_FrameStrobe[6] latch
XFILLER_256_65 VPWR VGND sg13cmos5l_decap_8
XFILLER_133_125 VPWR VGND sg13cmos5l_decap_8
X_2618_ _2618_/Q Tile_X0Y6_FrameData[13] VGND VPWR Tile_X0Y9_FrameStrobe[5] latch
XFILLER_256_98 VPWR VGND sg13cmos5l_decap_8
X_3598_ Tile_X0Y9_FrameData_O[28] Tile_X0Y9_FrameData[28] VPWR VGND sg13cmos5l_buf_1
XFILLER_406_35 VPWR VGND sg13cmos5l_decap_8
XFILLER_553_63 VPWR VGND sg13cmos5l_decap_8
XFILLER_125_14 VPWR VGND sg13cmos5l_decap_8
X_2549_ _2549_/Q Tile_X0Y6_FrameData[18] VGND VPWR Tile_X0Y9_FrameStrobe[3] latch
XFILLER_287_140 VPWR VGND sg13cmos5l_decap_8
XFILLER_87_223 VPWR VGND sg13cmos5l_decap_8
XFILLER_272_42 VPWR VGND sg13cmos5l_decap_8
XFILLER_436_126 VPWR VGND sg13cmos5l_decap_8
XANTENNA__2775__X Tile_X0Y3_EE4BEG[1] VPWR VGND sg13cmos5l_antennanp
X_4219_ _4219_/X _4690_/X _4694_/X _4698_/X _4673_/X _0385_/Q _0384_/Q VPWR VGND sg13cmos5l_mux4_1
XFILLER_703_77 VPWR VGND sg13cmos5l_decap_8
XFILLER_692_192 VPWR VGND sg13cmos5l_decap_8
XFILLER_205_91 VPWR VGND sg13cmos5l_decap_8
XFILLER_422_56 VPWR VGND sg13cmos5l_decap_8
XFILLER_18_56 VPWR VGND sg13cmos5l_decap_8
XFILLER_141_35 VPWR VGND sg13cmos5l_decap_8
XFILLER_389_225 VPWR VGND sg13cmos5l_fill_2
XFILLER_498_49 VPWR VGND sg13cmos5l_decap_8
XFILLER_357_7 VPWR VGND sg13cmos5l_decap_8
XFILLER_243_265 VPWR VGND sg13cmos5l_decap_8
XFILLER_70_189 VPWR VGND sg13cmos5l_decap_8
XFILLER_524_7 VPWR VGND sg13cmos5l_decap_8
XFILLER_211_140 VPWR VGND sg13cmos5l_decap_8
XFILLER_357_133 VPWR VGND sg13cmos5l_decap_8
XFILLER_297_50 VPWR VGND sg13cmos5l_decap_8
XFILLER_546_244 VPWR VGND sg13cmos5l_decap_8
XFILLER_297_94 VPWR VGND sg13cmos5l_decap_8
XFILLER_7_227 VPWR VGND sg13cmos5l_decap_8
XFILLER_50_21 VPWR VGND sg13cmos5l_decap_8
XFILLER_447_42 VPWR VGND sg13cmos5l_decap_8
XFILLER_109_122 VPWR VGND sg13cmos5l_decap_8
XFILLER_372_136 VPWR VGND sg13cmos5l_decap_8
XFILLER_594_70 VPWR VGND sg13cmos5l_decap_8
XFILLER_166_21 VPWR VGND sg13cmos5l_decap_8
XFILLER_109_155 VPWR VGND sg13cmos5l_decap_8
XFILLER_164_250 VPWR VGND sg13cmos5l_decap_8
XFILLER_703_241 VPWR VGND sg13cmos5l_decap_8
XFILLER_164_272 VPWR VGND sg13cmos5l_fill_1
XFILLER_514_163 VPWR VGND sg13cmos5l_fill_1
XFILLER_124_147 VPWR VGND sg13cmos5l_decap_8
XFILLER_459_229 VPWR VGND sg13cmos5l_fill_1
XFILLER_132_180 VPWR VGND sg13cmos5l_decap_8
XFILLER_427_126 VPWR VGND sg13cmos5l_decap_8
XFILLER_383_0 VPWR VGND sg13cmos5l_decap_8
XFILLER_93_215 VPWR VGND sg13cmos5l_decap_8
XFILLER_683_192 VPWR VGND sg13cmos5l_decap_8
XFILLER_613_77 VPWR VGND sg13cmos5l_fill_2
XFILLER_482_254 VPWR VGND sg13cmos5l_decap_8
XFILLER_46_120 VPWR VGND sg13cmos5l_decap_8
XFILLER_46_131 VPWR VGND sg13cmos5l_fill_1
XFILLER_550_0 VPWR VGND sg13cmos5l_decap_8
XFILLER_46_153 VPWR VGND sg13cmos5l_decap_4
XFILLER_234_221 VPWR VGND sg13cmos5l_decap_8
XFILLER_648_0 VPWR VGND sg13cmos5l_decap_8
XFILLER_234_243 VPWR VGND sg13cmos5l_decap_8
XFILLER_61_112 VPWR VGND sg13cmos5l_decap_8
XFILLER_201_49 VPWR VGND sg13cmos5l_decap_8
XFILLER_395_206 VPWR VGND sg13cmos5l_decap_8
XFILLER_91_61 VPWR VGND sg13cmos5l_decap_8
X_1920_ _1920_/Q Tile_X0Y3_FrameData[9] VGND VPWR Tile_X0Y9_FrameStrobe[7] latch
XFILLER_61_189 VPWR VGND sg13cmos5l_fill_2
XFILLER_348_133 VPWR VGND sg13cmos5l_fill_2
X_1851_ _1851_/Q Tile_X0Y3_FrameData[14] VGND VPWR Tile_X0Y9_FrameStrobe[5] latch
XFILLER_638_63 VPWR VGND sg13cmos5l_decap_8
XFILLER_537_255 VPWR VGND sg13cmos5l_fill_2
XFILLER_147_228 VPWR VGND sg13cmos5l_decap_4
XFILLER_348_177 VPWR VGND sg13cmos5l_fill_1
XFILLER_552_214 VPWR VGND sg13cmos5l_decap_4
X_0802_ _0802_/Q Tile_X0Y9_FrameData[29] VGND VPWR Tile_X0Y9_FrameStrobe[4] latch
XFILLER_357_42 VPWR VGND sg13cmos5l_decap_8
XFILLER_348_199 VPWR VGND sg13cmos5l_decap_8
X_4570_ _4570_/X _4549_/X Tile_X0Y9_N4END[14] _4548_/X _0155_/X _2491_/Q _2490_/Q
+ VPWR VGND sg13cmos5l_mux4_1
X_1782_ _1782_/Q Tile_X0Y3_FrameData[19] VGND VPWR Tile_X0Y9_FrameStrobe[3] latch
XFILLER_363_158 VPWR VGND sg13cmos5l_fill_2
XFILLER_155_250 VPWR VGND sg13cmos5l_decap_8
X_3521_ Tile_X0Y1_E1BEG[3] _3931_/X VPWR VGND sg13cmos5l_buf_1
X_0733_ _0733_/Q Tile_X0Y9_FrameData[2] VGND VPWR Tile_X0Y9_FrameStrobe[1] latch
XFILLER_155_272 VPWR VGND sg13cmos5l_fill_1
XFILLER_6_260 VPWR VGND sg13cmos5l_decap_4
XFILLER_654_62 VPWR VGND sg13cmos5l_decap_8
XFILLER_507_56 VPWR VGND sg13cmos5l_decap_8
XFILLER_170_231 VPWR VGND sg13cmos5l_fill_2
X_3452_ Tile_X0Y1_FrameData_O[10] Tile_X0Y1_FrameData[10] VPWR VGND sg13cmos5l_buf_1
X_0664_ _0664_/Q Tile_X0Y8_FrameData[7] VGND VPWR Tile_X0Y9_FrameStrobe[7] latch
XFILLER_226_35 VPWR VGND sg13cmos5l_decap_8
X_2403_ _2403_/Q Tile_X0Y5_FrameData[2] VGND VPWR Tile_X0Y9_FrameStrobe[6] latch
XFILLER_590_28 VPWR VGND sg13cmos5l_decap_8
X_3383_ Tile_X0Y2_E6BEG[6] _4078_/X VPWR VGND sg13cmos5l_buf_1
XFILLER_226_79 VPWR VGND sg13cmos5l_decap_8
X_0595_ _0595_/Q Tile_X0Y8_FrameData[12] VGND VPWR Tile_X0Y9_FrameStrobe[5] latch
XFILLER_458_240 VPWR VGND sg13cmos5l_decap_8
X_2334_ _2334_/Q Tile_X0Y5_FrameData[7] VGND VPWR Tile_X0Y9_FrameStrobe[4] latch
XFILLER_520_199 VPWR VGND sg13cmos5l_fill_1
XFILLER_269_173 VPWR VGND sg13cmos5l_decap_8
XFILLER_69_245 VPWR VGND sg13cmos5l_decap_8
XFILLER_681_129 VPWR VGND sg13cmos5l_decap_8
XFILLER_27_0 VPWR VGND sg13cmos5l_decap_8
XFILLER_269_195 VPWR VGND sg13cmos5l_decap_8
XFILLER_607_226 VPWR VGND sg13cmos5l_decap_4
XFILLER_523_77 VPWR VGND sg13cmos5l_decap_8
X_2265_ _2265_/Q Tile_X0Y5_FrameData[12] VGND VPWR Tile_X0Y9_FrameStrobe[2] latch
XFILLER_284_154 VPWR VGND sg13cmos5l_decap_8
XFILLER_473_265 VPWR VGND sg13cmos5l_decap_8
XFILLER_242_56 VPWR VGND sg13cmos5l_fill_2
X_4004_ _4004_/X _4457_/X _4461_/X _4465_/X _4432_/X _2409_/Q _2408_/Q VPWR VGND sg13cmos5l_mux4_1
X_1216_ _1216_/Q Tile_X0Y1_FrameData[25] VGND VPWR Tile_X0Y9_FrameStrobe[1] latch
XFILLER_622_207 VPWR VGND sg13cmos5l_decap_8
XFILLER_37_131 VPWR VGND sg13cmos5l_fill_1
X_2196_ _2196_/Q Tile_X0Y5_FrameData[17] VGND VPWR Tile_X0Y9_FrameStrobe[0] latch
XFILLER_433_129 VPWR VGND sg13cmos5l_decap_8
XFILLER_615_270 VPWR VGND sg13cmos5l_fill_2
XFILLER_1_70 VPWR VGND sg13cmos5l_fill_2
XFILLER_225_232 VPWR VGND sg13cmos5l_fill_1
X_1147_ _1147_/Q Tile_X0Y0_FrameData[16] VGND VPWR Tile_X0Y9_FrameStrobe[6] latch
XFILLER_52_101 VPWR VGND sg13cmos5l_fill_2
XFILLER_225_254 VPWR VGND sg13cmos5l_decap_4
XFILLER_52_123 VPWR VGND sg13cmos5l_decap_8
XFILLER_441_173 VPWR VGND sg13cmos5l_decap_8
XFILLER_111_49 VPWR VGND sg13cmos5l_decap_8
X_1078_ _1078_/Q Tile_X0Y0_FrameData[21] VGND VPWR Tile_X0Y9_FrameStrobe[4] latch
XFILLER_240_235 VPWR VGND sg13cmos5l_fill_1
XFILLER_240_257 VPWR VGND sg13cmos5l_decap_8
X_4906_ _4906_/X Tile_X0Y9_N2MID[4] Tile_X0Y9_N2END[4] _4936_/X _4820_/X _0687_/Q
+ _0686_/Q VPWR VGND sg13cmos5l_mux4_1
XFILLER_587_199 VPWR VGND sg13cmos5l_decap_8
XFILLER_52_189 VPWR VGND sg13cmos5l_fill_2
XFILLER_240_268 VPWR VGND sg13cmos5l_decap_4
XFILLER_339_133 VPWR VGND sg13cmos5l_decap_8
XFILLER_528_244 VPWR VGND sg13cmos5l_fill_2
XFILLER_138_217 VPWR VGND sg13cmos5l_decap_8
X_4837_ _4837_/X _4920_/X _4924_/X _4928_/X _4906_/X _0867_/Q _0866_/Q VPWR VGND sg13cmos5l_mux4_1
XFILLER_548_63 VPWR VGND sg13cmos5l_decap_8
XFILLER_394_261 VPWR VGND sg13cmos5l_decap_8
XFILLER_394_272 VPWR VGND sg13cmos5l_fill_1
XFILLER_695_91 VPWR VGND sg13cmos5l_decap_8
XFILLER_267_42 VPWR VGND sg13cmos5l_decap_8
XFILLER_543_236 VPWR VGND sg13cmos5l_decap_8
X_4768_ _4768_/X AXI_M_SOC_RDATA12 _4803_/X _4807_/X _4790_/X _0511_/Q _0510_/Q VPWR
+ VGND sg13cmos5l_mux4_1
XFILLER_354_147 VPWR VGND sg13cmos5l_decap_8
X_3719_ AXI_M_SOC_WDATA29 Tile_X0Y6_W1END[1] Tile_X0Y6_WW4END[5] Tile_X0Y6_WW4END[13]
+ _4581_/X _2501_/Q _2500_/Q VPWR VGND sg13cmos5l_mux4_1
X_4699_ _4699_/X _4667_/X Tile_X0Y9_N4END[11] _4666_/X _0053_/X _0185_/Q _0184_/Q
+ VPWR VGND sg13cmos5l_mux4_1
XFILLER_20_35 VPWR VGND sg13cmos5l_decap_8
XFILLER_417_56 VPWR VGND sg13cmos5l_decap_8
XFILLER_105_7 VPWR VGND sg13cmos5l_decap_8
XFILLER_136_35 VPWR VGND sg13cmos5l_decap_8
XFILLER_564_84 VPWR VGND sg13cmos5l_decap_8
XFILLER_161_253 VPWR VGND sg13cmos5l_decap_8
XFILLER_714_21 VPWR VGND sg13cmos5l_decap_8
XFILLER_511_144 VPWR VGND sg13cmos5l_decap_8
XFILLER_657_137 VPWR VGND sg13cmos5l_decap_8
XFILLER_283_63 VPWR VGND sg13cmos5l_decap_8
XFILLER_700_255 VPWR VGND sg13cmos5l_decap_8
XFILLER_96_28 VPWR VGND sg13cmos5l_fill_2
XFILLER_310_217 VPWR VGND sg13cmos5l_decap_4
XFILLER_449_240 VPWR VGND sg13cmos5l_decap_8
XFILLER_114_191 VPWR VGND sg13cmos5l_decap_8
XFILLER_714_98 VPWR VGND sg13cmos5l_decap_8
XFILLER_275_121 VPWR VGND sg13cmos5l_decap_8
XFILLER_665_181 VPWR VGND sg13cmos5l_fill_2
XFILLER_464_221 VPWR VGND sg13cmos5l_decap_4
XFILLER_75_204 VPWR VGND sg13cmos5l_decap_8
XFILLER_433_77 VPWR VGND sg13cmos5l_decap_8
XFILLER_474_7 VPWR VGND sg13cmos5l_decap_8
XFILLER_28_131 VPWR VGND sg13cmos5l_decap_8
XFILLER_45_10 VPWR VGND sg13cmos5l_fill_1
XFILLER_641_7 VPWR VGND sg13cmos5l_decap_8
XFILLER_216_254 VPWR VGND sg13cmos5l_decap_4
XFILLER_83_270 VPWR VGND sg13cmos5l_fill_2
XFILLER_432_140 VPWR VGND sg13cmos5l_decap_8
XFILLER_290_179 VPWR VGND sg13cmos5l_decap_8
XFILLER_589_70 VPWR VGND sg13cmos5l_decap_8
XFILLER_578_133 VPWR VGND sg13cmos5l_decap_8
XFILLER_45_65 VPWR VGND sg13cmos5l_decap_8
XFILLER_377_206 VPWR VGND sg13cmos5l_decap_8
XFILLER_43_156 VPWR VGND sg13cmos5l_decap_8
XFILLER_188_128 VPWR VGND sg13cmos5l_decap_4
XFILLER_129_206 VPWR VGND sg13cmos5l_fill_2
XFILLER_675_28 VPWR VGND sg13cmos5l_decap_8
XFILLER_61_42 VPWR VGND sg13cmos5l_decap_8
XFILLER_196_172 VPWR VGND sg13cmos5l_fill_1
XFILLER_131_0 VPWR VGND sg13cmos5l_decap_4
XFILLER_385_272 VPWR VGND sg13cmos5l_fill_1
XFILLER_196_194 VPWR VGND sg13cmos5l_decap_8
XFILLER_229_0 VPWR VGND sg13cmos5l_decap_8
XFILLER_534_214 VPWR VGND sg13cmos5l_decap_8
XFILLER_177_53 VPWR VGND sg13cmos5l_decap_8
XFILLER_394_29 VPWR VGND sg13cmos5l_decap_8
XFILLER_534_258 VPWR VGND sg13cmos5l_decap_8
XFILLER_137_250 VPWR VGND sg13cmos5l_decap_4
XANTENNA_8 AXI_M_SOC_RDATA26 VPWR VGND sg13cmos5l_antennanp
XFILLER_499_140 VPWR VGND sg13cmos5l_decap_8
XFILLER_152_220 VPWR VGND sg13cmos5l_decap_8
XFILLER_688_262 VPWR VGND sg13cmos5l_decap_8
XFILLER_691_49 VPWR VGND sg13cmos5l_decap_8
XFILLER_502_133 VPWR VGND sg13cmos5l_decap_8
XFILLER_648_126 VPWR VGND sg13cmos5l_decap_8
XFILLER_624_21 VPWR VGND sg13cmos5l_decap_8
XFILLER_152_264 VPWR VGND sg13cmos5l_decap_8
XFILLER_598_0 VPWR VGND sg13cmos5l_decap_8
XFILLER_3_252 VPWR VGND sg13cmos5l_decap_4
XFILLER_298_257 VPWR VGND sg13cmos5l_fill_2
XFILLER_193_63 VPWR VGND sg13cmos5l_decap_8
XFILLER_105_180 VPWR VGND sg13cmos5l_decap_8
X_0380_ _0380_/Q Tile_X0Y7_FrameData[3] VGND VPWR Tile_X0Y9_FrameStrobe[6] latch
XFILLER_20_7 VPWR VGND sg13cmos5l_decap_8
XFILLER_343_77 VPWR VGND sg13cmos5l_decap_4
XFILLER_343_88 VPWR VGND sg13cmos5l_decap_8
XFILLER_455_254 VPWR VGND sg13cmos5l_decap_4
XANTENNA__3304__X Tile_X0Y0_E2BEG[4] VPWR VGND sg13cmos5l_antennanp
XFILLER_640_42 VPWR VGND sg13cmos5l_decap_8
XFILLER_415_107 VPWR VGND sg13cmos5l_decap_8
XFILLER_266_176 VPWR VGND sg13cmos5l_decap_8
X_2050_ _2050_/Q Tile_X0Y4_FrameData[3] VGND VPWR Tile_X0Y9_FrameStrobe[3] latch
XFILLER_671_162 VPWR VGND sg13cmos5l_fill_1
XFILLER_604_229 VPWR VGND sg13cmos5l_decap_4
X_1001_ _1001_/Q Tile_X0Y0_FrameData[2] VGND VPWR Tile_X0Y9_FrameStrobe[1] latch
XFILLER_207_254 VPWR VGND sg13cmos5l_fill_1
XFILLER_281_168 VPWR VGND sg13cmos5l_decap_8
XFILLER_423_140 VPWR VGND sg13cmos5l_decap_8
XFILLER_19_197 VPWR VGND sg13cmos5l_fill_1
XFILLER_569_133 VPWR VGND sg13cmos5l_decap_8
XFILLER_499_70 VPWR VGND sg13cmos5l_decap_8
XFILLER_612_251 VPWR VGND sg13cmos5l_decap_8
XFILLER_34_145 VPWR VGND sg13cmos5l_decap_8
XFILLER_222_235 VPWR VGND sg13cmos5l_decap_8
XFILLER_34_167 VPWR VGND sg13cmos5l_fill_1
XFILLER_222_246 VPWR VGND sg13cmos5l_fill_2
X_2952_ Tile_X0Y8_EE4BEG[8] _4752_/X VPWR VGND sg13cmos5l_buf_1
XFILLER_649_84 VPWR VGND sg13cmos5l_decap_8
XFILLER_584_158 VPWR VGND sg13cmos5l_decap_8
X_1903_ _1903_/Q Tile_X0Y3_FrameData[26] VGND VPWR Tile_X0Y9_FrameStrobe[7] latch
XFILLER_585_28 VPWR VGND sg13cmos5l_decap_8
X_2883_ Tile_X0Y6_FrameData_O[4] Tile_X0Y6_FrameData[4] VPWR VGND sg13cmos5l_buf_1
XFILLER_525_203 VPWR VGND sg13cmos5l_fill_2
XFILLER_376_272 VPWR VGND sg13cmos5l_fill_1
XFILLER_336_103 VPWR VGND sg13cmos5l_decap_8
X_1834_ _1834_/Q Tile_X0Y3_FrameData[31] VGND VPWR Tile_X0Y9_FrameStrobe[5] latch
X_4622_ _4622_/X Tile_X0Y7_W2END[5] AXI_M_SOC_RDATA21 _4673_/X _4672_/X _0315_/Q _0314_/Q
+ VPWR VGND sg13cmos5l_mux4_1
XFILLER_592_180 VPWR VGND sg13cmos5l_decap_8
XFILLER_391_231 VPWR VGND sg13cmos5l_decap_8
XFILLER_128_250 VPWR VGND sg13cmos5l_decap_8
X_4553_ _4553_/X _4469_/X _4585_/X _4584_/X _4468_/X _2463_/Q _2462_/Q VPWR VGND sg13cmos5l_mux4_1
XFILLER_518_77 VPWR VGND sg13cmos5l_decap_8
XFILLER_128_272 VPWR VGND sg13cmos5l_fill_1
X_1765_ _1765_/Q Tile_X0Y3_FrameData[4] VGND VPWR Tile_X0Y9_FrameStrobe[2] latch
XFILLER_237_56 VPWR VGND sg13cmos5l_fill_2
X_0716_ _0716_/Q Tile_X0Y9_FrameData[19] VGND VPWR Tile_X0Y9_FrameStrobe[1] latch
X_3504_ Tile_X0Y1_E2BEGb[2] _3942_/X VPWR VGND sg13cmos5l_buf_1
X_4484_ _4484_/X Tile_X0Y6_W1END[0] Tile_X0Y6_WW4END[12] Tile_X0Y6_W6END[4] _4568_/X
+ _2635_/Q _2634_/Q VPWR VGND sg13cmos5l_mux4_1
X_1696_ _1696_/Q Tile_X0Y3_FrameData[9] VGND VPWR Tile_X0Y9_FrameStrobe[0] latch
XFILLER_639_126 VPWR VGND sg13cmos5l_decap_8
XFILLER_534_21 VPWR VGND sg13cmos5l_decap_8
XFILLER_143_264 VPWR VGND sg13cmos5l_fill_1
X_3435_ Tile_X0Y4_FrameData_O[26] Tile_X0Y4_FrameData[26] VPWR VGND sg13cmos5l_buf_1
X_0647_ _0647_/Q Tile_X0Y8_FrameData[24] VGND VPWR Tile_X0Y9_FrameStrobe[7] latch
XFILLER_289_268 VPWR VGND sg13cmos5l_decap_4
XFILLER_694_254 VPWR VGND sg13cmos5l_decap_8
X_3366_ Tile_X0Y2_EE4BEG[5] _4061_/X VPWR VGND sg13cmos5l_buf_1
XFILLER_654_118 VPWR VGND sg13cmos5l_decap_8
X_0578_ _0578_/Q Tile_X0Y8_FrameData[29] VGND VPWR Tile_X0Y9_FrameStrobe[5] latch
X_2317_ _2317_/Q Tile_X0Y5_FrameData[24] VGND VPWR Tile_X0Y9_FrameStrobe[4] latch
XFILLER_300_250 VPWR VGND sg13cmos5l_decap_8
XFILLER_253_77 VPWR VGND sg13cmos5l_decap_8
XFILLER_300_261 VPWR VGND sg13cmos5l_fill_1
X_3297_ Tile_X0Y0_E2BEGb[5] _3817_/X VPWR VGND sg13cmos5l_buf_1
XFILLER_300_272 VPWR VGND sg13cmos5l_fill_1
XANTENNA__3214__X Tile_X0Y0_FrameStrobe_O[2] VPWR VGND sg13cmos5l_antennanp
XFILLER_257_165 VPWR VGND sg13cmos5l_decap_8
XFILLER_550_42 VPWR VGND sg13cmos5l_decap_8
XFILLER_403_36 VPWR VGND sg13cmos5l_decap_8
XFILLER_662_162 VPWR VGND sg13cmos5l_decap_8
X_2248_ _2248_/Q Tile_X0Y5_FrameData[29] VGND VPWR Tile_X0Y9_FrameStrobe[2] latch
XFILLER_461_235 VPWR VGND sg13cmos5l_fill_2
XFILLER_272_146 VPWR VGND sg13cmos5l_decap_8
X_2179_ _2179_/Q Tile_X0Y4_FrameData[2] VGND VPWR Tile_X0Y9_FrameStrobe[7] latch
XFILLER_700_56 VPWR VGND sg13cmos5l_decap_8
XFILLER_414_151 VPWR VGND sg13cmos5l_decap_8
XFILLER_25_145 VPWR VGND sg13cmos5l_decap_8
XFILLER_202_70 VPWR VGND sg13cmos5l_decap_8
XFILLER_213_246 VPWR VGND sg13cmos5l_decap_8
XFILLER_15_35 VPWR VGND sg13cmos5l_decap_8
XFILLER_709_119 VPWR VGND sg13cmos5l_decap_8
XFILLER_40_115 VPWR VGND sg13cmos5l_decap_4
XFILLER_213_268 VPWR VGND sg13cmos5l_decap_4
XFILLER_575_147 VPWR VGND sg13cmos5l_decap_8
XFILLER_559_84 VPWR VGND sg13cmos5l_decap_8
XFILLER_709_21 VPWR VGND sg13cmos5l_decap_8
XFILLER_717_130 VPWR VGND sg13cmos5l_decap_8
XFILLER_495_28 VPWR VGND sg13cmos5l_decap_8
XFILLER_278_63 VPWR VGND sg13cmos5l_decap_8
XFILLER_367_272 VPWR VGND sg13cmos5l_fill_1
XFILLER_327_8 VPWR VGND sg13cmos5l_decap_8
XFILLER_327_114 VPWR VGND sg13cmos5l_decap_4
XFILLER_178_194 VPWR VGND sg13cmos5l_decap_8
XFILLER_717_174 VPWR VGND sg13cmos5l_decap_8
XFILLER_516_214 VPWR VGND sg13cmos5l_decap_8
XFILLER_222_7 VPWR VGND sg13cmos5l_decap_8
XFILLER_583_180 VPWR VGND sg13cmos5l_decap_8
XFILLER_382_231 VPWR VGND sg13cmos5l_decap_4
XFILLER_717_196 VPWR VGND sg13cmos5l_decap_8
XFILLER_709_98 VPWR VGND sg13cmos5l_decap_8
XFILLER_193_153 VPWR VGND sg13cmos5l_decap_4
XFILLER_193_164 VPWR VGND sg13cmos5l_decap_8
XFILLER_193_175 VPWR VGND sg13cmos5l_fill_2
XFILLER_428_77 VPWR VGND sg13cmos5l_decap_8
XFILLER_119_272 VPWR VGND sg13cmos5l_fill_1
XFILLER_147_56 VPWR VGND sg13cmos5l_decap_8
XFILLER_531_228 VPWR VGND sg13cmos5l_decap_8
XFILLER_342_139 VPWR VGND sg13cmos5l_decap_8
XFILLER_294_84 VPWR VGND sg13cmos5l_decap_8
XFILLER_444_21 VPWR VGND sg13cmos5l_decap_8
XFILLER_591_7 VPWR VGND sg13cmos5l_decap_8
XFILLER_496_154 VPWR VGND sg13cmos5l_decap_8
XFILLER_689_7 VPWR VGND sg13cmos5l_decap_8
XFILLER_163_55 VPWR VGND sg13cmos5l_fill_2
XFILLER_248_121 VPWR VGND sg13cmos5l_decap_4
XFILLER_437_232 VPWR VGND sg13cmos5l_fill_1
XFILLER_313_14 VPWR VGND sg13cmos5l_decap_8
XFILLER_248_143 VPWR VGND sg13cmos5l_fill_1
XANTENNA__3124__X Tile_X0Y7_EE4BEG[10] VPWR VGND sg13cmos5l_antennanp
XFILLER_460_42 VPWR VGND sg13cmos5l_decap_4
XFILLER_263_102 VPWR VGND sg13cmos5l_decap_8
XFILLER_48_248 VPWR VGND sg13cmos5l_decap_8
XFILLER_460_53 VPWR VGND sg13cmos5l_decap_8
XFILLER_313_69 VPWR VGND sg13cmos5l_decap_4
XFILLER_653_195 VPWR VGND sg13cmos5l_decap_8
XFILLER_263_146 VPWR VGND sg13cmos5l_decap_8
XANTENNA__2963__X Tile_X0Y8_FrameData_O[3] VPWR VGND sg13cmos5l_antennanp
XFILLER_179_0 VPWR VGND sg13cmos5l_decap_8
XFILLER_610_56 VPWR VGND sg13cmos5l_decap_8
XFILLER_405_151 VPWR VGND sg13cmos5l_decap_8
XFILLER_610_67 VPWR VGND sg13cmos5l_fill_2
XFILLER_16_167 VPWR VGND sg13cmos5l_fill_1
XFILLER_405_195 VPWR VGND sg13cmos5l_decap_8
XFILLER_346_0 VPWR VGND sg13cmos5l_decap_8
XFILLER_16_189 VPWR VGND sg13cmos5l_decap_8
XFILLER_204_257 VPWR VGND sg13cmos5l_fill_1
XFILLER_72_63 VPWR VGND sg13cmos5l_decap_8
XFILLER_566_147 VPWR VGND sg13cmos5l_decap_8
XFILLER_619_21 VPWR VGND sg13cmos5l_decap_8
XFILLER_169_161 VPWR VGND sg13cmos5l_decap_8
XFILLER_188_63 VPWR VGND sg13cmos5l_decap_8
XFILLER_513_0 VPWR VGND sg13cmos5l_decap_8
XFILLER_358_272 VPWR VGND sg13cmos5l_fill_1
XFILLER_708_163 VPWR VGND sg13cmos5l_decap_4
XFILLER_184_120 VPWR VGND sg13cmos5l_decap_8
XFILLER_507_247 VPWR VGND sg13cmos5l_decap_4
XFILLER_373_242 VPWR VGND sg13cmos5l_decap_8
XFILLER_338_55 VPWR VGND sg13cmos5l_fill_2
XFILLER_68_7 VPWR VGND sg13cmos5l_decap_8
XFILLER_485_94 VPWR VGND sg13cmos5l_fill_2
XFILLER_184_197 VPWR VGND sg13cmos5l_decap_8
XFILLER_635_42 VPWR VGND sg13cmos5l_decap_8
XFILLER_522_239 VPWR VGND sg13cmos5l_decap_8
X_1550_ _1550_/Q Tile_X0Y2_FrameData[3] VGND VPWR Tile_X0Y9_FrameStrobe[3] latch
XFILLER_125_242 VPWR VGND sg13cmos5l_decap_8
XFILLER_125_253 VPWR VGND sg13cmos5l_fill_2
XFILLER_487_110 VPWR VGND sg13cmos5l_fill_1
XFILLER_354_21 VPWR VGND sg13cmos5l_decap_8
XFILLER_125_264 VPWR VGND sg13cmos5l_fill_1
X_0501_ _0501_/Q Tile_X0Y8_FrameData[10] VGND VPWR Tile_X0Y9_FrameStrobe[2] latch
X_1481_ _1481_/Q Tile_X0Y2_FrameData[8] VGND VPWR Tile_X0Y9_FrameStrobe[1] latch
XFILLER_341_172 VPWR VGND sg13cmos5l_decap_8
X_3220_ Tile_X0Y0_FrameStrobe_O[8] Tile_X0Y9_FrameStrobe[8] VPWR VGND sg13cmos5l_buf_1
X_0432_ _0432_/Q Tile_X0Y8_FrameData[15] VGND VPWR Tile_X0Y9_FrameStrobe[0] latch
XFILLER_487_198 VPWR VGND sg13cmos5l_decap_8
XFILLER_354_98 VPWR VGND sg13cmos5l_decap_8
XFILLER_504_35 VPWR VGND sg13cmos5l_decap_8
XFILLER_428_210 VPWR VGND sg13cmos5l_decap_8
X_3151_ Tile_X0Y7_FrameData_O[21] Tile_X0Y7_FrameData[21] VPWR VGND sg13cmos5l_buf_1
XFILLER_651_63 VPWR VGND sg13cmos5l_decap_8
X_0363_ _0363_/Q Tile_X0Y7_FrameData[20] VGND VPWR Tile_X0Y9_FrameStrobe[6] latch
XFILLER_239_154 VPWR VGND sg13cmos5l_decap_4
XANTENNA__3034__X Tile_X0Y5_EE4BEG[9] VPWR VGND sg13cmos5l_antennanp
XFILLER_691_268 VPWR VGND sg13cmos5l_decap_4
XFILLER_223_36 VPWR VGND sg13cmos5l_decap_8
XFILLER_644_140 VPWR VGND sg13cmos5l_decap_8
X_2102_ _2102_/Q Tile_X0Y4_FrameData[15] VGND VPWR Tile_X0Y9_FrameStrobe[5] latch
X_3082_ Tile_X0Y7_E1BEG[0] _4608_/X VPWR VGND sg13cmos5l_buf_1
X_0294_ _0294_/Q Tile_X0Y7_FrameData[25] VGND VPWR Tile_X0Y9_FrameStrobe[4] latch
XANTENNA__2873__X Tile_X0Y6_EE4BEG[10] VPWR VGND sg13cmos5l_antennanp
X_2033_ _2033_/Q Tile_X0Y4_FrameData[20] VGND VPWR Tile_X0Y9_FrameStrobe[3] latch
XFILLER_47_270 VPWR VGND sg13cmos5l_fill_2
XFILLER_443_268 VPWR VGND sg13cmos5l_decap_4
XFILLER_597_261 VPWR VGND sg13cmos5l_decap_4
XFILLER_597_272 VPWR VGND sg13cmos5l_fill_1
XFILLER_596_49 VPWR VGND sg13cmos5l_decap_8
X_3984_ _3984_/X Tile_X0Y0_W1END[2] Tile_X0Y0_W6END[10] _3867_/X _3861_/X _1137_/Q
+ _1136_/Q VPWR VGND sg13cmos5l_mux4_1
XFILLER_379_84 VPWR VGND sg13cmos5l_decap_8
XFILLER_94_0 VPWR VGND sg13cmos5l_decap_8
XFILLER_529_21 VPWR VGND sg13cmos5l_decap_8
XFILLER_210_227 VPWR VGND sg13cmos5l_fill_1
XFILLER_349_250 VPWR VGND sg13cmos5l_decap_8
XFILLER_210_238 VPWR VGND sg13cmos5l_decap_8
X_2935_ Tile_X0Y8_E6BEG[3] _4763_/X VPWR VGND sg13cmos5l_buf_1
X_2866_ Tile_X0Y6_EE4BEG[3] _4515_/X VPWR VGND sg13cmos5l_buf_1
XFILLER_395_50 VPWR VGND sg13cmos5l_decap_8
XFILLER_714_133 VPWR VGND sg13cmos5l_decap_8
X_4605_ _4605_/X _4690_/X _4694_/X _4698_/X _4670_/X _0349_/Q _0348_/Q VPWR VGND sg13cmos5l_mux4_1
XFILLER_248_77 VPWR VGND sg13cmos5l_decap_8
X_1817_ _1817_/Q Tile_X0Y3_FrameData[16] VGND VPWR Tile_X0Y9_FrameStrobe[4] latch
X_2797_ Tile_X0Y3_E6BEG[7] _4187_/X VPWR VGND sg13cmos5l_buf_1
XANTENNA__3209__X Tile_X0Y0_N1BEG[1] VPWR VGND sg13cmos5l_antennanp
XFILLER_580_172 VPWR VGND sg13cmos5l_decap_8
XFILLER_545_42 VPWR VGND sg13cmos5l_decap_8
XFILLER_7_91 VPWR VGND sg13cmos5l_decap_8
X_1748_ _1748_/Q Tile_X0Y3_FrameData[21] VGND VPWR Tile_X0Y9_FrameStrobe[2] latch
X_4536_ _4536_/X AXI_M_SOC_RDATA28 _4571_/X _4575_/X _4558_/X _2535_/Q _2534_/Q VPWR
+ VGND sg13cmos5l_mux4_1
XFILLER_264_21 VPWR VGND sg13cmos5l_decap_8
XFILLER_667_221 VPWR VGND sg13cmos5l_decap_8
XFILLER_521_250 VPWR VGND sg13cmos5l_decap_8
X_1679_ _1679_/Q Tile_X0Y3_FrameData[26] VGND VPWR Tile_X0Y9_FrameStrobe[0] latch
X_4467_ _4467_/X _4353_/X _4469_/X _4468_/X _4352_/X _2205_/Q _2204_/Q VPWR VGND sg13cmos5l_mux4_1
XFILLER_521_261 VPWR VGND sg13cmos5l_fill_1
XFILLER_332_172 VPWR VGND sg13cmos5l_decap_8
XFILLER_277_227 VPWR VGND sg13cmos5l_decap_8
X_3418_ Tile_X0Y4_FrameData_O[9] Tile_X0Y4_FrameData[9] VPWR VGND sg13cmos5l_buf_1
XFILLER_264_98 VPWR VGND sg13cmos5l_decap_8
X_4398_ _4398_/X Tile_X0Y5_WW4END[5] AXI_M_SOC_RLAST _4456_/X _4431_/X _2307_/Q _2306_/Q
+ VPWR VGND sg13cmos5l_mux4_1
XFILLER_478_198 VPWR VGND sg13cmos5l_fill_2
XFILLER_419_210 VPWR VGND sg13cmos5l_decap_8
XFILLER_414_35 VPWR VGND sg13cmos5l_decap_8
XFILLER_133_14 VPWR VGND sg13cmos5l_decap_8
X_3349_ Tile_X0Y2_FrameData_O[20] Tile_X0Y2_FrameData[20] VPWR VGND sg13cmos5l_buf_1
XFILLER_561_63 VPWR VGND sg13cmos5l_decap_8
XFILLER_97_181 VPWR VGND sg13cmos5l_decap_8
XFILLER_493_168 VPWR VGND sg13cmos5l_decap_8
XFILLER_635_140 VPWR VGND sg13cmos5l_decap_8
XFILLER_414_79 VPWR VGND sg13cmos5l_fill_1
XFILLER_280_42 VPWR VGND sg13cmos5l_decap_8
XFILLER_245_124 VPWR VGND sg13cmos5l_decap_4
XFILLER_45_207 VPWR VGND sg13cmos5l_fill_2
XFILLER_711_77 VPWR VGND sg13cmos5l_decap_8
XANTENNA__2783__X Tile_X0Y3_EE4BEG[9] VPWR VGND sg13cmos5l_antennanp
XFILLER_172_7 VPWR VGND sg13cmos5l_decap_8
XFILLER_434_257 VPWR VGND sg13cmos5l_fill_1
XANTENNA_206 Tile_X0Y9_N2MID[6] VPWR VGND sg13cmos5l_antennanp
XFILLER_650_154 VPWR VGND sg13cmos5l_decap_8
XFILLER_245_179 VPWR VGND sg13cmos5l_fill_2
XANTENNA_217 Tile_X0Y9_N4END[14] VPWR VGND sg13cmos5l_antennanp
XFILLER_213_91 VPWR VGND sg13cmos5l_decap_8
XFILLER_430_56 VPWR VGND sg13cmos5l_decap_8
XANTENNA_228 Tile_X0Y0_FrameData[6] VPWR VGND sg13cmos5l_antennanp
XANTENNA_239 _4594_/X VPWR VGND sg13cmos5l_antennanp
XFILLER_198_201 VPWR VGND sg13cmos5l_decap_8
XFILLER_26_56 VPWR VGND sg13cmos5l_decap_8
XFILLER_260_138 VPWR VGND sg13cmos5l_decap_8
XFILLER_548_114 VPWR VGND sg13cmos5l_decap_8
XFILLER_548_136 VPWR VGND sg13cmos5l_decap_8
XFILLER_437_7 VPWR VGND sg13cmos5l_decap_8
XFILLER_13_137 VPWR VGND sg13cmos5l_decap_8
XFILLER_439_21 VPWR VGND sg13cmos5l_decap_8
XFILLER_289_95 VPWR VGND sg13cmos5l_fill_1
XFILLER_201_249 VPWR VGND sg13cmos5l_decap_8
XFILLER_158_22 VPWR VGND sg13cmos5l_decap_8
XFILLER_604_7 VPWR VGND sg13cmos5l_decap_8
XFILLER_355_231 VPWR VGND sg13cmos5l_decap_8
XFILLER_166_142 VPWR VGND sg13cmos5l_decap_8
XFILLER_705_133 VPWR VGND sg13cmos5l_fill_1
XFILLER_42_88 VPWR VGND sg13cmos5l_decap_8
XFILLER_355_253 VPWR VGND sg13cmos5l_fill_2
XFILLER_318_4 VPWR VGND sg13cmos5l_fill_1
XFILLER_571_161 VPWR VGND sg13cmos5l_decap_8
XFILLER_308_14 VPWR VGND sg13cmos5l_decap_8
XANTENNA__3119__X Tile_X0Y7_EE4BEG[5] VPWR VGND sg13cmos5l_antennanp
XFILLER_455_42 VPWR VGND sg13cmos5l_fill_2
XFILLER_308_180 VPWR VGND sg13cmos5l_decap_8
XFILLER_308_191 VPWR VGND sg13cmos5l_fill_1
XFILLER_370_256 VPWR VGND sg13cmos5l_decap_8
XFILLER_174_21 VPWR VGND sg13cmos5l_decap_8
XFILLER_181_178 VPWR VGND sg13cmos5l_decap_8
XANTENNA__2958__X Tile_X0Y8_EE4BEG[14] VPWR VGND sg13cmos5l_antennanp
XFILLER_658_254 VPWR VGND sg13cmos5l_fill_1
XFILLER_512_272 VPWR VGND sg13cmos5l_fill_1
XFILLER_174_76 VPWR VGND sg13cmos5l_decap_8
XFILLER_673_202 VPWR VGND sg13cmos5l_decap_8
XFILLER_605_56 VPWR VGND sg13cmos5l_fill_2
XFILLER_122_256 VPWR VGND sg13cmos5l_decap_8
XFILLER_3_49 VPWR VGND sg13cmos5l_decap_8
XFILLER_107_81 VPWR VGND sg13cmos5l_decap_8
XFILLER_296_0 VPWR VGND sg13cmos5l_decap_8
XFILLER_471_63 VPWR VGND sg13cmos5l_decap_4
XFILLER_67_63 VPWR VGND sg13cmos5l_decap_8
XFILLER_276_271 VPWR VGND sg13cmos5l_fill_2
XFILLER_425_224 VPWR VGND sg13cmos5l_decap_8
XFILLER_626_184 VPWR VGND sg13cmos5l_fill_1
XFILLER_463_0 VPWR VGND sg13cmos5l_decap_8
XFILLER_236_146 VPWR VGND sg13cmos5l_decap_8
XFILLER_621_77 VPWR VGND sg13cmos5l_decap_8
XFILLER_291_252 VPWR VGND sg13cmos5l_decap_8
XFILLER_641_154 VPWR VGND sg13cmos5l_decap_8
XFILLER_340_56 VPWR VGND sg13cmos5l_decap_4
XFILLER_83_51 VPWR VGND sg13cmos5l_decap_8
XFILLER_440_227 VPWR VGND sg13cmos5l_decap_4
XFILLER_630_0 VPWR VGND sg13cmos5l_decap_8
XFILLER_251_149 VPWR VGND sg13cmos5l_decap_8
XFILLER_199_84 VPWR VGND sg13cmos5l_decap_8
XFILLER_594_242 VPWR VGND sg13cmos5l_decap_4
XFILLER_349_21 VPWR VGND sg13cmos5l_decap_8
XFILLER_539_169 VPWR VGND sg13cmos5l_decap_8
X_0981_ _0981_/Q Tile_X0Y0_FrameData[22] VGND VPWR Tile_X0Y9_FrameStrobe[1] latch
X_2720_ _4775_/A3 VPWR VGND sg13cmos5l_tielo
XFILLER_349_98 VPWR VGND sg13cmos5l_decap_8
XFILLER_200_260 VPWR VGND sg13cmos5l_fill_1
XFILLER_200_271 VPWR VGND sg13cmos5l_fill_2
X_2651_ _2651_/Q Tile_X0Y6_FrameData[12] VGND VPWR Tile_X0Y9_FrameStrobe[6] latch
XFILLER_646_63 VPWR VGND sg13cmos5l_decap_8
XFILLER_218_14 VPWR VGND sg13cmos5l_decap_8
XFILLER_562_161 VPWR VGND sg13cmos5l_decap_8
XFILLER_306_117 VPWR VGND sg13cmos5l_decap_8
XANTENNA__3029__X Tile_X0Y5_EE4BEG[4] VPWR VGND sg13cmos5l_antennanp
X_1602_ _1602_/Q Tile_X0Y2_FrameData[15] VGND VPWR Tile_X0Y9_FrameStrobe[5] latch
XFILLER_365_42 VPWR VGND sg13cmos5l_decap_8
X_2582_ _2582_/Q Tile_X0Y6_FrameData[17] VGND VPWR Tile_X0Y9_FrameStrobe[4] latch
XFILLER_711_147 VPWR VGND sg13cmos5l_decap_8
XANTENNA__2868__X Tile_X0Y6_EE4BEG[5] VPWR VGND sg13cmos5l_antennanp
X_1533_ _1533_/Q Tile_X0Y2_FrameData[20] VGND VPWR Tile_X0Y9_FrameStrobe[3] latch
X_4321_ _4321_/X _3885_/X _3876_/X _3875_/X _3858_/X _1117_/Q _1116_/Q VPWR VGND sg13cmos5l_mux4_1
XFILLER_649_232 VPWR VGND sg13cmos5l_decap_8
XFILLER_649_243 VPWR VGND sg13cmos5l_fill_1
XFILLER_113_223 VPWR VGND sg13cmos5l_decap_8
XFILLER_649_254 VPWR VGND sg13cmos5l_decap_8
XFILLER_515_56 VPWR VGND sg13cmos5l_decap_8
X_4252_ _4252_/X _4302_/X _4301_/X AXI_M_SOC_BRESP1 _4300_/X _2109_/Q _2108_/Q VPWR
+ VGND sg13cmos5l_mux4_1
X_1464_ _1464_/Q Tile_X0Y2_FrameData[25] VGND VPWR Tile_X0Y9_FrameStrobe[1] latch
XFILLER_662_84 VPWR VGND sg13cmos5l_decap_8
XFILLER_381_30 VPWR VGND sg13cmos5l_fill_1
XFILLER_234_35 VPWR VGND sg13cmos5l_decap_8
X_3203_ Tile_X0Y0_N2BEG[3] _3787_/X VPWR VGND sg13cmos5l_buf_1
X_0415_ _0415_/Q Tile_X0Y7_FrameData[0] VGND VPWR Tile_X0Y9_FrameStrobe[7] latch
X_4183_ _4183_/X _0046_/X Tile_X0Y0_S4END[15] _4230_/X _4234_/X _1775_/Q _1774_/Q
+ VPWR VGND sg13cmos5l_mux4_1
XFILLER_381_74 VPWR VGND sg13cmos5l_decap_8
XFILLER_274_208 VPWR VGND sg13cmos5l_decap_8
X_1395_ _1395_/Q Tile_X0Y1_FrameData[6] VGND VPWR Tile_X0Y9_FrameStrobe[6] latch
XFILLER_274_219 VPWR VGND sg13cmos5l_decap_8
XFILLER_490_105 VPWR VGND sg13cmos5l_decap_8
XFILLER_227_113 VPWR VGND sg13cmos5l_decap_8
X_3134_ Tile_X0Y7_FrameData_O[4] Tile_X0Y7_FrameData[4] VPWR VGND sg13cmos5l_buf_1
X_0346_ _0346_/Q Tile_X0Y7_FrameData[5] VGND VPWR Tile_X0Y9_FrameStrobe[5] latch
XFILLER_94_151 VPWR VGND sg13cmos5l_decap_8
XANTENNA__3699__X AXI_M_SOC_WDATA9 VPWR VGND sg13cmos5l_antennanp
XFILLER_531_77 VPWR VGND sg13cmos5l_decap_8
XFILLER_103_28 VPWR VGND sg13cmos5l_decap_8
X_3065_ Tile_X0Y5_FrameData_O[24] Tile_X0Y5_FrameData[24] VPWR VGND sg13cmos5l_buf_1
XFILLER_227_179 VPWR VGND sg13cmos5l_decap_8
X_0277_ _0277_/Q Tile_X0Y7_FrameData[10] VGND VPWR Tile_X0Y9_FrameStrobe[3] latch
XFILLER_531_99 VPWR VGND sg13cmos5l_fill_1
X_2016_ _2016_/Q Tile_X0Y4_FrameData[5] VGND VPWR Tile_X0Y9_FrameStrobe[2] latch
XFILLER_632_187 VPWR VGND sg13cmos5l_decap_8
XFILLER_250_78 VPWR VGND sg13cmos5l_decap_8
XFILLER_632_198 VPWR VGND sg13cmos5l_fill_1
XFILLER_235_190 VPWR VGND sg13cmos5l_decap_8
XFILLER_396_131 VPWR VGND sg13cmos5l_decap_8
XFILLER_50_243 VPWR VGND sg13cmos5l_fill_1
XFILLER_195_215 VPWR VGND sg13cmos5l_decap_4
XFILLER_396_175 VPWR VGND sg13cmos5l_fill_1
XFILLER_50_265 VPWR VGND sg13cmos5l_decap_8
XFILLER_195_237 VPWR VGND sg13cmos5l_decap_4
X_3967_ _3967_/X _0084_/X Tile_X0Y0_S4END[7] _4016_/X _4005_/X _1275_/Q _1274_/Q VPWR
+ VGND sg13cmos5l_mux4_1
XFILLER_195_248 VPWR VGND sg13cmos5l_decap_8
XFILLER_259_65 VPWR VGND sg13cmos5l_decap_4
X_2918_ Tile_X0Y8_E2BEG[2] _4730_/X VPWR VGND sg13cmos5l_buf_1
XFILLER_12_14 VPWR VGND sg13cmos5l_decap_8
X_3898_ _3898_/X Tile_X0Y2_W2MID[2] Tile_X0Y2_W2END[2] Tile_X0Y2_W6END[2] _4100_/X
+ _1655_/Q _1654_/Q VPWR VGND sg13cmos5l_mux4_1
XFILLER_409_35 VPWR VGND sg13cmos5l_decap_8
XFILLER_337_264 VPWR VGND sg13cmos5l_decap_8
XFILLER_148_175 VPWR VGND sg13cmos5l_decap_4
XFILLER_128_14 VPWR VGND sg13cmos5l_decap_8
XFILLER_556_63 VPWR VGND sg13cmos5l_decap_8
X_2849_ Tile_X0Y6_E2BEGb[6] _4510_/X VPWR VGND sg13cmos5l_buf_1
XFILLER_699_154 VPWR VGND sg13cmos5l_decap_8
XFILLER_163_123 VPWR VGND sg13cmos5l_decap_8
XFILLER_275_42 VPWR VGND sg13cmos5l_decap_8
XFILLER_702_125 VPWR VGND sg13cmos5l_decap_4
XFILLER_352_245 VPWR VGND sg13cmos5l_decap_8
XFILLER_498_238 VPWR VGND sg13cmos5l_decap_8
XFILLER_702_136 VPWR VGND sg13cmos5l_decap_8
XFILLER_352_256 VPWR VGND sg13cmos5l_fill_2
XANTENNA__2778__X Tile_X0Y3_EE4BEG[4] VPWR VGND sg13cmos5l_antennanp
X_4519_ _4519_/X Tile_X0Y6_WW4END[8] AXI_M_SOC_RDATA31 _4576_/X _4553_/X _2569_/Q
+ _2568_/Q VPWR VGND sg13cmos5l_mux4_1
XFILLER_706_77 VPWR VGND sg13cmos5l_decap_8
XFILLER_104_234 VPWR VGND sg13cmos5l_decap_8
XFILLER_466_102 VPWR VGND sg13cmos5l_fill_1
XFILLER_425_56 VPWR VGND sg13cmos5l_decap_8
XFILLER_208_91 VPWR VGND sg13cmos5l_decap_8
XFILLER_572_84 VPWR VGND sg13cmos5l_decap_8
XFILLER_466_124 VPWR VGND sg13cmos5l_decap_8
XFILLER_144_35 VPWR VGND sg13cmos5l_decap_8
XFILLER_394_8 VPWR VGND sg13cmos5l_decap_8
XFILLER_320_175 VPWR VGND sg13cmos5l_decap_8
XFILLER_265_208 VPWR VGND sg13cmos5l_decap_8
XFILLER_265_219 VPWR VGND sg13cmos5l_fill_2
XFILLER_387_7 VPWR VGND sg13cmos5l_decap_8
XFILLER_291_85 VPWR VGND sg13cmos5l_decap_8
XFILLER_258_271 VPWR VGND sg13cmos5l_fill_2
XFILLER_608_173 VPWR VGND sg13cmos5l_decap_4
XFILLER_37_11 VPWR VGND sg13cmos5l_decap_8
XFILLER_85_151 VPWR VGND sg13cmos5l_decap_4
XFILLER_608_184 VPWR VGND sg13cmos5l_decap_8
XFILLER_85_184 VPWR VGND sg13cmos5l_decap_8
XFILLER_218_179 VPWR VGND sg13cmos5l_decap_8
XFILLER_554_7 VPWR VGND sg13cmos5l_decap_8
XANTENNA__3402__X Tile_X0Y2_E2BEG[5] VPWR VGND sg13cmos5l_antennanp
XFILLER_37_77 VPWR VGND sg13cmos5l_fill_1
XFILLER_160_56 VPWR VGND sg13cmos5l_decap_8
XFILLER_233_127 VPWR VGND sg13cmos5l_fill_1
XFILLER_422_249 VPWR VGND sg13cmos5l_fill_2
XFILLER_310_15 VPWR VGND sg13cmos5l_fill_2
XFILLER_233_149 VPWR VGND sg13cmos5l_decap_8
XFILLER_310_48 VPWR VGND sg13cmos5l_decap_8
XFILLER_53_32 VPWR VGND sg13cmos5l_decap_8
XFILLER_310_59 VPWR VGND sg13cmos5l_fill_1
XFILLER_169_21 VPWR VGND sg13cmos5l_decap_8
XFILLER_41_243 VPWR VGND sg13cmos5l_fill_1
XFILLER_241_171 VPWR VGND sg13cmos5l_decap_8
XFILLER_41_265 VPWR VGND sg13cmos5l_decap_8
XFILLER_169_98 VPWR VGND sg13cmos5l_decap_8
XFILLER_139_175 VPWR VGND sg13cmos5l_decap_8
XFILLER_154_101 VPWR VGND sg13cmos5l_decap_8
XFILLER_683_28 VPWR VGND sg13cmos5l_decap_8
XFILLER_466_63 VPWR VGND sg13cmos5l_decap_8
XFILLER_211_0 VPWR VGND sg13cmos5l_decap_8
XFILLER_185_42 VPWR VGND sg13cmos5l_fill_2
XFILLER_309_0 VPWR VGND sg13cmos5l_decap_8
XFILLER_154_167 VPWR VGND sg13cmos5l_decap_8
XFILLER_616_77 VPWR VGND sg13cmos5l_decap_8
XFILLER_335_56 VPWR VGND sg13cmos5l_decap_8
XFILLER_78_51 VPWR VGND sg13cmos5l_decap_8
XFILLER_78_62 VPWR VGND sg13cmos5l_fill_1
XFILLER_500_231 VPWR VGND sg13cmos5l_decap_8
XFILLER_646_224 VPWR VGND sg13cmos5l_decap_8
XFILLER_632_21 VPWR VGND sg13cmos5l_decap_8
XFILLER_580_0 VPWR VGND sg13cmos5l_decap_8
XFILLER_78_84 VPWR VGND sg13cmos5l_decap_8
XFILLER_678_0 VPWR VGND sg13cmos5l_decap_8
XFILLER_209_102 VPWR VGND sg13cmos5l_fill_2
X_0200_ _0200_/Q Tile_X0Y7_FrameData[23] VGND VPWR Tile_X0Y9_FrameStrobe[1] latch
X_1180_ _1180_/Q Tile_X0Y1_FrameData[29] VGND VPWR Tile_X0Y9_FrameStrobe[0] latch
XFILLER_632_98 VPWR VGND sg13cmos5l_decap_8
XFILLER_204_49 VPWR VGND sg13cmos5l_decap_8
XFILLER_209_135 VPWR VGND sg13cmos5l_decap_8
XFILLER_264_241 VPWR VGND sg13cmos5l_decap_8
X_0131_ AXI_M_SOC_AWSIZE1 _0939_/Q _3680_/X VPWR VGND sg13cmos5l_or2_1
XFILLER_351_77 VPWR VGND sg13cmos5l_decap_8
XFILLER_91_110 VPWR VGND sg13cmos5l_decap_8
XFILLER_501_14 VPWR VGND sg13cmos5l_decap_8
XFILLER_614_154 VPWR VGND sg13cmos5l_decap_8
XANTENNA__3312__X Tile_X0Y4_EE4BEG[0] VPWR VGND sg13cmos5l_antennanp
XFILLER_224_138 VPWR VGND sg13cmos5l_decap_8
X_0062_ _3629_/A _4606_/X _4607_/X _0344_/Q VPWR VGND sg13cmos5l_mux2_1
XFILLER_17_251 VPWR VGND sg13cmos5l_decap_4
XFILLER_217_190 VPWR VGND sg13cmos5l_decap_8
XFILLER_91_187 VPWR VGND sg13cmos5l_decap_8
XFILLER_91_198 VPWR VGND sg13cmos5l_fill_2
X_4870_ _4870_/X Tile_X0Y9_WW4END[9] AXI_M_SOC_RDATA6 _4925_/X _4903_/X _0803_/Q _0802_/Q
+ VPWR VGND sg13cmos5l_mux4_1
XFILLER_567_231 VPWR VGND sg13cmos5l_fill_2
XFILLER_32_232 VPWR VGND sg13cmos5l_decap_4
XFILLER_421_271 VPWR VGND sg13cmos5l_fill_2
XFILLER_232_182 VPWR VGND sg13cmos5l_decap_8
X_3821_ _3821_/X Tile_X0Y0_WW4END[4] Tile_X0Y0_WW4END[14] _3867_/X _3854_/X _1063_/Q
+ _1062_/Q VPWR VGND sg13cmos5l_mux4_1
XFILLER_527_106 VPWR VGND sg13cmos5l_decap_4
XFILLER_393_101 VPWR VGND sg13cmos5l_fill_2
XFILLER_716_217 VPWR VGND sg13cmos5l_decap_8
XFILLER_300_70 VPWR VGND sg13cmos5l_fill_1
XFILLER_716_228 VPWR VGND sg13cmos5l_fill_2
XFILLER_527_139 VPWR VGND sg13cmos5l_fill_1
X_0964_ _0964_/Q Tile_X0Y0_FrameData[7] VGND VPWR Tile_X0Y9_FrameStrobe[0] latch
X_3752_ AXI_M_SOC_ARADDR24 Tile_X0Y8_WW4END[0] Tile_X0Y8_WW4END[8] Tile_X0Y8_W6END[8]
+ _4808_/X _0487_/Q _0486_/Q VPWR VGND sg13cmos5l_mux4_1
XFILLER_393_156 VPWR VGND sg13cmos5l_fill_1
XFILLER_582_256 VPWR VGND sg13cmos5l_decap_4
XFILLER_229_35 VPWR VGND sg13cmos5l_decap_8
XFILLER_657_95 VPWR VGND sg13cmos5l_decap_8
XFILLER_393_178 VPWR VGND sg13cmos5l_decap_4
X_2703_ _4192_/A3 VPWR VGND sg13cmos5l_tielo
XFILLER_593_28 VPWR VGND sg13cmos5l_decap_8
XFILLER_393_189 VPWR VGND sg13cmos5l_decap_8
XFILLER_376_63 VPWR VGND sg13cmos5l_decap_8
X_0895_ _0895_/Q Tile_X0Y9_FrameData[0] VGND VPWR Tile_X0Y9_FrameStrobe[6] latch
X_3683_ _3683_/X Tile_X0Y3_WW4END[1] Tile_X0Y3_WW4END[9] Tile_X0Y3_W6END[1] _4223_/X
+ _1755_/Q _1754_/Q VPWR VGND sg13cmos5l_mux4_1
XFILLER_145_156 VPWR VGND sg13cmos5l_decap_8
X_2634_ _2634_/Q Tile_X0Y6_FrameData[29] VGND VPWR Tile_X0Y9_FrameStrobe[6] latch
XFILLER_696_124 VPWR VGND sg13cmos5l_fill_2
XFILLER_334_267 VPWR VGND sg13cmos5l_decap_4
XFILLER_57_0 VPWR VGND sg13cmos5l_fill_1
XFILLER_673_72 VPWR VGND sg13cmos5l_decap_8
XFILLER_526_77 VPWR VGND sg13cmos5l_decap_8
XFILLER_160_126 VPWR VGND sg13cmos5l_decap_8
X_2565_ _2565_/Q Tile_X0Y6_FrameData[2] VGND VPWR Tile_X0Y9_FrameStrobe[3] latch
XFILLER_550_175 VPWR VGND sg13cmos5l_decap_8
XFILLER_488_271 VPWR VGND sg13cmos5l_fill_2
XFILLER_245_56 VPWR VGND sg13cmos5l_decap_8
X_1516_ _1516_/Q Tile_X0Y2_FrameData[5] VGND VPWR Tile_X0Y9_FrameStrobe[2] latch
X_4304_ _4304_/X Tile_X0Y3_W1END[1] Tile_X0Y3_W6END[9] _4235_/X _4201_/X _1887_/Q
+ _1886_/Q VPWR VGND sg13cmos5l_mux4_1
XFILLER_637_202 VPWR VGND sg13cmos5l_decap_8
XFILLER_245_67 VPWR VGND sg13cmos5l_fill_1
X_2496_ _2496_/Q Tile_X0Y6_FrameData[7] VGND VPWR Tile_X0Y9_FrameStrobe[1] latch
XFILLER_245_89 VPWR VGND sg13cmos5l_decap_8
XFILLER_542_21 VPWR VGND sg13cmos5l_decap_8
XFILLER_59_118 VPWR VGND sg13cmos5l_decap_4
XFILLER_4_70 VPWR VGND sg13cmos5l_decap_8
X_1447_ _1447_/Q Tile_X0Y2_FrameData[10] VGND VPWR Tile_X0Y9_FrameStrobe[0] latch
X_4235_ _4235_/X _4197_/X _0088_/X _4196_/X Tile_X0Y0_S4END[13] _1703_/Q _1702_/Q
+ VPWR VGND sg13cmos5l_mux4_1
XFILLER_302_197 VPWR VGND sg13cmos5l_decap_4
X_4166_ _4166_/X Tile_X0Y3_WW4END[13] AXI_M_SOC_WREADY _4235_/X _4208_/X _1809_/Q
+ _1808_/Q VPWR VGND sg13cmos5l_mux4_1
XFILLER_67_140 VPWR VGND sg13cmos5l_decap_8
XFILLER_114_49 VPWR VGND sg13cmos5l_decap_8
X_1378_ _1378_/Q Tile_X0Y1_FrameData[23] VGND VPWR Tile_X0Y9_FrameStrobe[6] latch
XFILLER_652_238 VPWR VGND sg13cmos5l_decap_8
XFILLER_542_98 VPWR VGND sg13cmos5l_decap_8
XFILLER_82_110 VPWR VGND sg13cmos5l_decap_8
X_0329_ _0329_/Q Tile_X0Y7_FrameData[22] VGND VPWR Tile_X0Y9_FrameStrobe[5] latch
X_3117_ Tile_X0Y7_EE4BEG[3] _4631_/X VPWR VGND sg13cmos5l_buf_1
XFILLER_411_14 VPWR VGND sg13cmos5l_decap_8
X_4097_ _4097_/X _4021_/X _4129_/X _4128_/X _4020_/X _1449_/Q _1448_/Q VPWR VGND sg13cmos5l_mux4_1
XANTENNA__3222__X Tile_X0Y0_FrameStrobe_O[10] VPWR VGND sg13cmos5l_antennanp
XFILLER_270_222 VPWR VGND sg13cmos5l_fill_1
X_3048_ Tile_X0Y5_FrameData_O[7] Tile_X0Y5_FrameData[7] VPWR VGND sg13cmos5l_buf_1
XFILLER_605_187 VPWR VGND sg13cmos5l_decap_8
XFILLER_82_187 VPWR VGND sg13cmos5l_fill_2
XFILLER_620_135 VPWR VGND sg13cmos5l_decap_8
XFILLER_270_255 VPWR VGND sg13cmos5l_fill_1
XFILLER_698_91 VPWR VGND sg13cmos5l_decap_8
XFILLER_230_108 VPWR VGND sg13cmos5l_decap_8
XFILLER_210_70 VPWR VGND sg13cmos5l_decap_8
XFILLER_168_259 VPWR VGND sg13cmos5l_fill_2
XFILLER_518_139 VPWR VGND sg13cmos5l_decap_4
XFILLER_23_35 VPWR VGND sg13cmos5l_decap_4
XFILLER_135_7 VPWR VGND sg13cmos5l_decap_8
XFILLER_573_245 VPWR VGND sg13cmos5l_decap_4
XFILLER_567_84 VPWR VGND sg13cmos5l_decap_8
XFILLER_139_35 VPWR VGND sg13cmos5l_decap_8
XFILLER_183_229 VPWR VGND sg13cmos5l_decap_8
XFILLER_533_109 VPWR VGND sg13cmos5l_decap_8
XFILLER_286_63 VPWR VGND sg13cmos5l_decap_8
XFILLER_99_28 VPWR VGND sg13cmos5l_decap_8
XFILLER_526_183 VPWR VGND sg13cmos5l_decap_8
XFILLER_526_194 VPWR VGND sg13cmos5l_fill_1
XFILLER_302_7 VPWR VGND sg13cmos5l_decap_8
XFILLER_136_156 VPWR VGND sg13cmos5l_decap_8
XFILLER_219_90 VPWR VGND sg13cmos5l_decap_8
XFILLER_687_146 VPWR VGND sg13cmos5l_decap_8
XFILLER_436_77 VPWR VGND sg13cmos5l_decap_8
XFILLER_297_108 VPWR VGND sg13cmos5l_decap_4
XFILLER_151_137 VPWR VGND sg13cmos5l_decap_8
XFILLER_297_119 VPWR VGND sg13cmos5l_decap_8
XFILLER_155_56 VPWR VGND sg13cmos5l_decap_8
XFILLER_151_159 VPWR VGND sg13cmos5l_decap_8
XFILLER_452_21 VPWR VGND sg13cmos5l_decap_8
XFILLER_671_7 VPWR VGND sg13cmos5l_decap_8
XFILLER_628_268 VPWR VGND sg13cmos5l_decap_4
XFILLER_454_105 VPWR VGND sg13cmos5l_decap_8
XFILLER_643_238 VPWR VGND sg13cmos5l_decap_8
XFILLER_58_151 VPWR VGND sg13cmos5l_decap_8
XFILLER_602_35 VPWR VGND sg13cmos5l_decap_8
XFILLER_0_28 VPWR VGND sg13cmos5l_decap_8
XFILLER_321_14 VPWR VGND sg13cmos5l_fill_2
XANTENNA__3132__X Tile_X0Y7_FrameData_O[2] VPWR VGND sg13cmos5l_antennanp
XFILLER_171_99 VPWR VGND sg13cmos5l_decap_4
XFILLER_206_105 VPWR VGND sg13cmos5l_decap_8
XFILLER_611_102 VPWR VGND sg13cmos5l_decap_4
XFILLER_462_171 VPWR VGND sg13cmos5l_fill_1
XFILLER_678_28 VPWR VGND sg13cmos5l_decap_8
XFILLER_64_42 VPWR VGND sg13cmos5l_decap_8
XFILLER_161_0 VPWR VGND sg13cmos5l_fill_2
XFILLER_611_135 VPWR VGND sg13cmos5l_decap_8
XANTENNA__2971__X Tile_X0Y8_FrameData_O[11] VPWR VGND sg13cmos5l_antennanp
XFILLER_259_0 VPWR VGND sg13cmos5l_fill_2
XFILLER_611_179 VPWR VGND sg13cmos5l_fill_2
XFILLER_214_193 VPWR VGND sg13cmos5l_decap_8
XFILLER_564_212 VPWR VGND sg13cmos5l_decap_8
XFILLER_426_0 VPWR VGND sg13cmos5l_decap_8
XFILLER_375_134 VPWR VGND sg13cmos5l_decap_8
XFILLER_694_49 VPWR VGND sg13cmos5l_decap_8
XFILLER_627_21 VPWR VGND sg13cmos5l_decap_8
XFILLER_196_63 VPWR VGND sg13cmos5l_decap_8
XFILLER_127_134 VPWR VGND sg13cmos5l_decap_8
X_0680_ _0680_/Q Tile_X0Y9_FrameData[23] VGND VPWR Tile_X0Y9_FrameStrobe[0] latch
XFILLER_142_126 VPWR VGND sg13cmos5l_decap_8
XANTENNA__3307__X Tile_X0Y0_E2BEG[7] VPWR VGND sg13cmos5l_antennanp
XFILLER_643_42 VPWR VGND sg13cmos5l_decap_8
X_2350_ _2350_/Q Tile_X0Y5_FrameData[23] VGND VPWR Tile_X0Y9_FrameStrobe[5] latch
XFILLER_619_224 VPWR VGND sg13cmos5l_decap_8
XFILLER_362_21 VPWR VGND sg13cmos5l_decap_8
X_1301_ _1301_/Q Tile_X0Y1_FrameData[4] VGND VPWR Tile_X0Y9_FrameStrobe[3] latch
XFILLER_96_235 VPWR VGND sg13cmos5l_decap_8
X_2281_ _2281_/Q Tile_X0Y5_FrameData[28] VGND VPWR Tile_X0Y9_FrameStrobe[3] latch
XFILLER_296_174 VPWR VGND sg13cmos5l_decap_8
XFILLER_634_205 VPWR VGND sg13cmos5l_decap_4
X_4020_ _4020_/X Tile_X0Y0_W2MID[7] Tile_X0Y0_W2END[7] Tile_X0Y0_W6END[8] _3853_/X
+ _1133_/Q _1132_/Q VPWR VGND sg13cmos5l_mux4_1
X_1232_ _1232_/Q Tile_X0Y1_FrameData[9] VGND VPWR Tile_X0Y9_FrameStrobe[1] latch
XFILLER_362_98 VPWR VGND sg13cmos5l_decap_8
XFILLER_512_35 VPWR VGND sg13cmos5l_decap_8
XFILLER_237_241 VPWR VGND sg13cmos5l_decap_8
XFILLER_231_14 VPWR VGND sg13cmos5l_decap_8
X_1163_ _1163_/Q Tile_X0Y0_FrameData[0] VGND VPWR Tile_X0Y9_FrameStrobe[6] latch
XANTENNA__3042__X Tile_X0Y5_FrameData_O[1] VPWR VGND sg13cmos5l_antennanp
X_0114_ AXI_M_SOC_ARLOCK _0930_/Q _3773_/X VPWR VGND sg13cmos5l_nor2b_1
XFILLER_64_154 VPWR VGND sg13cmos5l_decap_8
XFILLER_642_271 VPWR VGND sg13cmos5l_fill_2
XFILLER_252_222 VPWR VGND sg13cmos5l_decap_8
XFILLER_588_28 VPWR VGND sg13cmos5l_decap_8
XFILLER_398_215 VPWR VGND sg13cmos5l_decap_8
XFILLER_252_233 VPWR VGND sg13cmos5l_fill_1
X_1094_ _1094_/Q Tile_X0Y0_FrameData[5] VGND VPWR Tile_X0Y9_FrameStrobe[4] latch
XFILLER_602_124 VPWR VGND sg13cmos5l_decap_8
XANTENNA__2881__X Tile_X0Y6_FrameData_O[2] VPWR VGND sg13cmos5l_antennanp
X_0045_ _3626_/A _4600_/X _4601_/X _0353_/Q VPWR VGND sg13cmos5l_mux2_1
X_4922_ _4922_/X Tile_X0Y9_N1END[2] Tile_X0Y9_N4END[2] _4898_/X _0081_/X _0715_/Q
+ _0714_/Q VPWR VGND sg13cmos5l_mux4_1
XFILLER_212_119 VPWR VGND sg13cmos5l_decap_8
X_4853_ _4853_/X Tile_X0Y9_W2MID[2] AXI_M_SOC_RDATA5 _4905_/X _4904_/X _0837_/Q _0836_/Q
+ VPWR VGND sg13cmos5l_mux4_1
XFILLER_220_130 VPWR VGND sg13cmos5l_decap_8
XFILLER_610_190 VPWR VGND sg13cmos5l_fill_1
X_3804_ _3804_/X Tile_X0Y0_W2MID[0] Tile_X0Y0_W2MID[7] _3853_/X _3852_/X _1097_/Q
+ _1096_/Q VPWR VGND sg13cmos5l_mux4_1
XFILLER_387_73 VPWR VGND sg13cmos5l_decap_8
X_4784_ _4784_/X _4715_/X Tile_X0Y9_N2MID[7] _4823_/X _4714_/X _0425_/Q _0424_/Q VPWR
+ VGND sg13cmos5l_mux4_1
XFILLER_20_257 VPWR VGND sg13cmos5l_decap_4
X_1996_ _1996_/Q Tile_X0Y4_FrameData[25] VGND VPWR Tile_X0Y9_FrameStrobe[2] latch
XFILLER_537_21 VPWR VGND sg13cmos5l_decap_8
X_3735_ AXI_M_SOC_ARADDR7 Tile_X0Y9_WW4END[7] Tile_X0Y9_WW4END[15] Tile_X0Y9_W6END[7]
+ _4923_/X _0745_/Q _0744_/Q VPWR VGND sg13cmos5l_mux4_1
X_0947_ _0947_/Q Tile_X0Y0_FrameData[24] VGND VPWR Tile_X0Y9_FrameStrobe[0] latch
XFILLER_118_145 VPWR VGND sg13cmos5l_decap_4
XFILLER_684_82 VPWR VGND sg13cmos5l_decap_8
X_3666_ AXI_M_SOC_AWADDR27 Tile_X0Y4_WW4END[3] Tile_X0Y4_WW4END[11] Tile_X0Y4_W6END[11]
+ _4347_/X _1991_/Q _1990_/Q VPWR VGND sg13cmos5l_mux4_1
XFILLER_537_98 VPWR VGND sg13cmos5l_decap_8
XFILLER_307_267 VPWR VGND sg13cmos5l_decap_4
X_0878_ _0878_/Q Tile_X0Y9_FrameData[17] VGND VPWR Tile_X0Y9_FrameStrobe[6] latch
X_2617_ _2617_/Q Tile_X0Y6_FrameData[14] VGND VPWR Tile_X0Y9_FrameStrobe[5] latch
XFILLER_256_88 VPWR VGND sg13cmos5l_fill_2
XFILLER_406_14 VPWR VGND sg13cmos5l_decap_8
XFILLER_279_119 VPWR VGND sg13cmos5l_decap_8
XANTENNA__3217__X Tile_X0Y0_FrameStrobe_O[5] VPWR VGND sg13cmos5l_antennanp
X_3597_ Tile_X0Y9_FrameData_O[27] Tile_X0Y9_FrameData[27] VPWR VGND sg13cmos5l_buf_1
XFILLER_553_42 VPWR VGND sg13cmos5l_decap_8
X_2548_ _2548_/Q Tile_X0Y6_FrameData[19] VGND VPWR Tile_X0Y9_FrameStrobe[3] latch
XFILLER_272_21 VPWR VGND sg13cmos5l_decap_8
XFILLER_87_246 VPWR VGND sg13cmos5l_fill_1
X_2479_ _2479_/Q Tile_X0Y6_FrameData[24] VGND VPWR Tile_X0Y9_FrameStrobe[1] latch
XFILLER_436_105 VPWR VGND sg13cmos5l_decap_8
XFILLER_703_56 VPWR VGND sg13cmos5l_decap_8
XFILLER_692_171 VPWR VGND sg13cmos5l_decap_8
XFILLER_287_196 VPWR VGND sg13cmos5l_decap_8
X_4218_ _4218_/X Tile_X0Y7_W1END[2] Tile_X0Y7_WW4END[2] Tile_X0Y7_W6END[10] _4686_/X
+ _0385_/Q _0384_/Q VPWR VGND sg13cmos5l_mux4_1
XFILLER_205_70 VPWR VGND sg13cmos5l_decap_8
XFILLER_422_35 VPWR VGND sg13cmos5l_decap_8
XFILLER_228_241 VPWR VGND sg13cmos5l_decap_4
XFILLER_18_35 VPWR VGND sg13cmos5l_decap_8
XFILLER_141_14 VPWR VGND sg13cmos5l_decap_8
X_4149_ _4149_/X Tile_X0Y3_W2MID[6] AXI_M_SOC_BVALID _4207_/X _4206_/X _1843_/Q _1842_/Q
+ VPWR VGND sg13cmos5l_mux4_1
XFILLER_55_132 VPWR VGND sg13cmos5l_fill_2
XFILLER_451_119 VPWR VGND sg13cmos5l_decap_8
XFILLER_243_200 VPWR VGND sg13cmos5l_decap_8
XFILLER_633_271 VPWR VGND sg13cmos5l_fill_2
XFILLER_389_204 VPWR VGND sg13cmos5l_decap_8
XFILLER_498_28 VPWR VGND sg13cmos5l_decap_8
XFILLER_70_113 VPWR VGND sg13cmos5l_decap_8
XFILLER_55_198 VPWR VGND sg13cmos5l_fill_2
XANTENNA__2791__X Tile_X0Y3_E6BEG[1] VPWR VGND sg13cmos5l_antennanp
XFILLER_252_7 VPWR VGND sg13cmos5l_decap_8
XFILLER_34_56 VPWR VGND sg13cmos5l_decap_4
XFILLER_357_112 VPWR VGND sg13cmos5l_decap_8
XFILLER_11_224 VPWR VGND sg13cmos5l_decap_8
XFILLER_517_7 VPWR VGND sg13cmos5l_decap_8
XFILLER_447_21 VPWR VGND sg13cmos5l_decap_8
XFILLER_372_115 VPWR VGND sg13cmos5l_decap_8
XFILLER_357_189 VPWR VGND sg13cmos5l_decap_8
XFILLER_594_93 VPWR VGND sg13cmos5l_decap_8
XFILLER_166_55 VPWR VGND sg13cmos5l_decap_8
XFILLER_50_99 VPWR VGND sg13cmos5l_decap_8
XFILLER_124_126 VPWR VGND sg13cmos5l_decap_8
XFILLER_316_14 VPWR VGND sg13cmos5l_decap_8
XANTENNA__3127__X Tile_X0Y7_EE4BEG[13] VPWR VGND sg13cmos5l_antennanp
XFILLER_463_42 VPWR VGND sg13cmos5l_decap_4
XFILLER_313_259 VPWR VGND sg13cmos5l_decap_4
XFILLER_463_75 VPWR VGND sg13cmos5l_decap_8
XFILLER_59_53 VPWR VGND sg13cmos5l_decap_4
XANTENNA__2966__X Tile_X0Y8_FrameData_O[6] VPWR VGND sg13cmos5l_antennanp
XFILLER_182_43 VPWR VGND sg13cmos5l_decap_8
XFILLER_182_54 VPWR VGND sg13cmos5l_fill_2
XFILLER_467_263 VPWR VGND sg13cmos5l_decap_8
XFILLER_78_246 VPWR VGND sg13cmos5l_decap_4
XFILLER_59_97 VPWR VGND sg13cmos5l_decap_8
XFILLER_427_105 VPWR VGND sg13cmos5l_decap_8
XFILLER_683_171 VPWR VGND sg13cmos5l_decap_8
XFILLER_613_56 VPWR VGND sg13cmos5l_decap_8
XFILLER_482_211 VPWR VGND sg13cmos5l_decap_4
XFILLER_278_196 VPWR VGND sg13cmos5l_decap_8
XFILLER_182_98 VPWR VGND sg13cmos5l_decap_8
XFILLER_482_233 VPWR VGND sg13cmos5l_decap_8
XFILLER_332_35 VPWR VGND sg13cmos5l_decap_8
XFILLER_293_155 VPWR VGND sg13cmos5l_decap_8
XFILLER_115_81 VPWR VGND sg13cmos5l_fill_2
XFILLER_376_0 VPWR VGND sg13cmos5l_decap_4
XFILLER_93_249 VPWR VGND sg13cmos5l_decap_8
XFILLER_293_188 VPWR VGND sg13cmos5l_decap_4
XFILLER_75_63 VPWR VGND sg13cmos5l_decap_8
XFILLER_293_199 VPWR VGND sg13cmos5l_decap_8
XFILLER_435_193 VPWR VGND sg13cmos5l_decap_8
XFILLER_543_0 VPWR VGND sg13cmos5l_decap_8
XFILLER_450_130 VPWR VGND sg13cmos5l_fill_1
XFILLER_46_187 VPWR VGND sg13cmos5l_decap_8
XFILLER_450_152 VPWR VGND sg13cmos5l_decap_4
XFILLER_201_28 VPWR VGND sg13cmos5l_decap_8
XFILLER_596_167 VPWR VGND sg13cmos5l_decap_8
XFILLER_450_185 VPWR VGND sg13cmos5l_decap_8
XFILLER_61_168 VPWR VGND sg13cmos5l_decap_8
XFILLER_98_7 VPWR VGND sg13cmos5l_decap_8
XFILLER_348_112 VPWR VGND sg13cmos5l_decap_8
XFILLER_710_0 VPWR VGND sg13cmos5l_decap_8
XFILLER_638_42 VPWR VGND sg13cmos5l_decap_8
XFILLER_147_207 VPWR VGND sg13cmos5l_decap_8
X_1850_ _1850_/Q Tile_X0Y3_FrameData[15] VGND VPWR Tile_X0Y9_FrameStrobe[5] latch
XFILLER_202_185 VPWR VGND sg13cmos5l_decap_8
XFILLER_357_21 VPWR VGND sg13cmos5l_decap_8
X_0801_ _0801_/Q Tile_X0Y9_FrameData[30] VGND VPWR Tile_X0Y9_FrameStrobe[4] latch
X_1781_ _1781_/Q Tile_X0Y3_FrameData[20] VGND VPWR Tile_X0Y9_FrameStrobe[3] latch
XFILLER_552_248 VPWR VGND sg13cmos5l_decap_8
X_3520_ Tile_X0Y1_E1BEG[2] _3930_/X VPWR VGND sg13cmos5l_buf_1
X_0732_ _0732_/Q Tile_X0Y9_FrameData[3] VGND VPWR Tile_X0Y9_FrameStrobe[1] latch
XFILLER_357_98 VPWR VGND sg13cmos5l_decap_8
XFILLER_507_35 VPWR VGND sg13cmos5l_decap_8
XFILLER_505_164 VPWR VGND sg13cmos5l_decap_4
XFILLER_170_221 VPWR VGND sg13cmos5l_fill_2
XFILLER_226_14 VPWR VGND sg13cmos5l_decap_8
X_0663_ _0663_/Q Tile_X0Y8_FrameData[8] VGND VPWR Tile_X0Y9_FrameStrobe[7] latch
X_3451_ Tile_X0Y1_FrameData_O[9] Tile_X0Y1_FrameData[9] VPWR VGND sg13cmos5l_buf_1
XFILLER_115_137 VPWR VGND sg13cmos5l_fill_1
XANTENNA__3037__X Tile_X0Y5_EE4BEG[12] VPWR VGND sg13cmos5l_antennanp
XFILLER_304_248 VPWR VGND sg13cmos5l_decap_8
XFILLER_115_159 VPWR VGND sg13cmos5l_decap_8
XFILLER_170_254 VPWR VGND sg13cmos5l_decap_8
XFILLER_520_134 VPWR VGND sg13cmos5l_decap_4
X_2402_ _2402_/Q Tile_X0Y5_FrameData[3] VGND VPWR Tile_X0Y9_FrameStrobe[6] latch
X_3382_ Tile_X0Y2_E6BEG[5] _4077_/X VPWR VGND sg13cmos5l_buf_1
XFILLER_666_138 VPWR VGND sg13cmos5l_decap_4
X_0594_ _0594_/Q Tile_X0Y8_FrameData[13] VGND VPWR Tile_X0Y9_FrameStrobe[5] latch
XFILLER_69_224 VPWR VGND sg13cmos5l_decap_8
XFILLER_269_152 VPWR VGND sg13cmos5l_decap_8
XANTENNA__2876__X Tile_X0Y6_EE4BEG[13] VPWR VGND sg13cmos5l_antennanp
X_2333_ _2333_/Q Tile_X0Y5_FrameData[8] VGND VPWR Tile_X0Y9_FrameStrobe[4] latch
XFILLER_523_56 VPWR VGND sg13cmos5l_decap_8
X_2264_ _2264_/Q Tile_X0Y5_FrameData[13] VGND VPWR Tile_X0Y9_FrameStrobe[2] latch
XFILLER_607_238 VPWR VGND sg13cmos5l_fill_1
XFILLER_284_133 VPWR VGND sg13cmos5l_decap_8
XFILLER_242_35 VPWR VGND sg13cmos5l_decap_8
X_1215_ _1215_/Q Tile_X0Y1_FrameData[26] VGND VPWR Tile_X0Y9_FrameStrobe[1] latch
X_4003_ _4003_/X Tile_X0Y5_W1END[2] Tile_X0Y5_WW4END[2] Tile_X0Y5_W6END[10] _4453_/X
+ _2409_/Q _2408_/Q VPWR VGND sg13cmos5l_mux4_1
X_2195_ _2195_/Q Tile_X0Y5_FrameData[18] VGND VPWR Tile_X0Y9_FrameStrobe[0] latch
XFILLER_599_49 VPWR VGND sg13cmos5l_decap_8
XFILLER_426_182 VPWR VGND sg13cmos5l_decap_8
XFILLER_1_82 VPWR VGND sg13cmos5l_decap_8
X_1146_ _1146_/Q Tile_X0Y0_FrameData[17] VGND VPWR Tile_X0Y9_FrameStrobe[6] latch
XFILLER_225_244 VPWR VGND sg13cmos5l_fill_2
XFILLER_92_271 VPWR VGND sg13cmos5l_fill_2
XFILLER_587_123 VPWR VGND sg13cmos5l_fill_2
XFILLER_37_187 VPWR VGND sg13cmos5l_decap_8
XFILLER_441_152 VPWR VGND sg13cmos5l_decap_8
XFILLER_111_28 VPWR VGND sg13cmos5l_decap_8
X_1077_ _1077_/Q Tile_X0Y0_FrameData[22] VGND VPWR Tile_X0Y9_FrameStrobe[4] latch
XANTENNA__3500__X Tile_X0Y1_E6BEG[10] VPWR VGND sg13cmos5l_antennanp
XFILLER_587_178 VPWR VGND sg13cmos5l_decap_8
X_4905_ _4905_/X Tile_X0Y9_N2MID[2] Tile_X0Y9_N2END[2] _4934_/X _4818_/X _0691_/Q
+ _0690_/Q VPWR VGND sg13cmos5l_mux4_1
XFILLER_339_112 VPWR VGND sg13cmos5l_decap_8
XFILLER_398_94 VPWR VGND sg13cmos5l_fill_2
XFILLER_528_223 VPWR VGND sg13cmos5l_decap_8
XFILLER_548_42 VPWR VGND sg13cmos5l_decap_8
XFILLER_394_240 VPWR VGND sg13cmos5l_decap_8
X_4836_ _4836_/X Tile_X0Y9_W1END[0] Tile_X0Y9_WW4END[12] Tile_X0Y9_W6END[4] _4916_/X
+ _0867_/Q _0866_/Q VPWR VGND sg13cmos5l_mux4_1
XFILLER_695_70 VPWR VGND sg13cmos5l_decap_8
XFILLER_267_21 VPWR VGND sg13cmos5l_decap_8
XFILLER_354_126 VPWR VGND sg13cmos5l_decap_8
X_4767_ _4767_/X AXI_M_SOC_RDATA11 _4804_/X _4808_/X _4791_/X _0513_/Q _0512_/Q VPWR
+ VGND sg13cmos5l_mux4_1
X_1979_ _1979_/Q Tile_X0Y4_FrameData[10] VGND VPWR Tile_X0Y9_FrameStrobe[1] latch
X_3718_ AXI_M_SOC_WDATA28 Tile_X0Y6_W1END[0] Tile_X0Y6_WW4END[4] Tile_X0Y6_WW4END[12]
+ _4580_/X _2503_/Q _2502_/Q VPWR VGND sg13cmos5l_mux4_1
XFILLER_267_98 VPWR VGND sg13cmos5l_decap_8
XFILLER_20_14 VPWR VGND sg13cmos5l_decap_8
X_4698_ _4698_/X _4665_/X Tile_X0Y9_N4END[10] _4664_/X _0054_/X _0187_/Q _0186_/Q
+ VPWR VGND sg13cmos5l_mux4_1
XFILLER_417_35 VPWR VGND sg13cmos5l_decap_8
XFILLER_564_63 VPWR VGND sg13cmos5l_decap_8
XFILLER_136_14 VPWR VGND sg13cmos5l_decap_8
X_3649_ AXI_M_SOC_AWADDR10 Tile_X0Y5_WW4END[2] Tile_X0Y5_WW4END[10] Tile_X0Y5_W6END[10]
+ _4461_/X _2251_/Q _2250_/Q VPWR VGND sg13cmos5l_mux4_1
XFILLER_511_112 VPWR VGND sg13cmos5l_decap_4
XFILLER_106_148 VPWR VGND sg13cmos5l_decap_4
XFILLER_657_116 VPWR VGND sg13cmos5l_decap_8
XFILLER_283_42 VPWR VGND sg13cmos5l_decap_8
XFILLER_700_234 VPWR VGND sg13cmos5l_decap_8
XFILLER_114_170 VPWR VGND sg13cmos5l_decap_8
XFILLER_310_229 VPWR VGND sg13cmos5l_decap_8
XANTENNA__2786__X Tile_X0Y3_EE4BEG[12] VPWR VGND sg13cmos5l_antennanp
XFILLER_714_77 VPWR VGND sg13cmos5l_decap_8
XFILLER_275_100 VPWR VGND sg13cmos5l_decap_8
XFILLER_433_56 VPWR VGND sg13cmos5l_decap_8
XFILLER_580_84 VPWR VGND sg13cmos5l_decap_8
XFILLER_152_35 VPWR VGND sg13cmos5l_decap_8
XFILLER_580_95 VPWR VGND sg13cmos5l_fill_2
XFILLER_29_67 VPWR VGND sg13cmos5l_fill_2
XFILLER_152_46 VPWR VGND sg13cmos5l_fill_1
XFILLER_29_78 VPWR VGND sg13cmos5l_fill_1
XFILLER_152_68 VPWR VGND sg13cmos5l_decap_8
XFILLER_680_152 VPWR VGND sg13cmos5l_fill_1
XFILLER_28_110 VPWR VGND sg13cmos5l_decap_8
XFILLER_613_208 VPWR VGND sg13cmos5l_decap_8
XFILLER_424_119 VPWR VGND sg13cmos5l_decap_8
XFILLER_275_188 VPWR VGND sg13cmos5l_decap_8
XFILLER_216_200 VPWR VGND sg13cmos5l_decap_8
XFILLER_613_219 VPWR VGND sg13cmos5l_fill_2
XFILLER_467_7 VPWR VGND sg13cmos5l_decap_8
XFILLER_90_219 VPWR VGND sg13cmos5l_decap_8
XFILLER_417_182 VPWR VGND sg13cmos5l_decap_8
XFILLER_290_158 VPWR VGND sg13cmos5l_decap_8
XFILLER_578_112 VPWR VGND sg13cmos5l_decap_8
XFILLER_302_49 VPWR VGND sg13cmos5l_decap_8
XFILLER_621_230 VPWR VGND sg13cmos5l_decap_8
XFILLER_45_44 VPWR VGND sg13cmos5l_decap_8
XFILLER_28_187 VPWR VGND sg13cmos5l_decap_8
XFILLER_589_82 VPWR VGND sg13cmos5l_decap_8
XFILLER_634_7 VPWR VGND sg13cmos5l_decap_8
XFILLER_43_135 VPWR VGND sg13cmos5l_decap_8
XANTENNA__3410__X Tile_X0Y4_FrameData_O[1] VPWR VGND sg13cmos5l_antennanp
XFILLER_432_196 VPWR VGND sg13cmos5l_fill_2
XFILLER_377_229 VPWR VGND sg13cmos5l_decap_8
XFILLER_458_42 VPWR VGND sg13cmos5l_fill_2
XFILLER_519_267 VPWR VGND sg13cmos5l_decap_4
XFILLER_61_98 VPWR VGND sg13cmos5l_decap_8
XFILLER_534_237 VPWR VGND sg13cmos5l_decap_8
XFILLER_124_0 VPWR VGND sg13cmos5l_decap_8
XFILLER_608_56 VPWR VGND sg13cmos5l_decap_8
XFILLER_137_262 VPWR VGND sg13cmos5l_fill_2
XANTENNA_9 AXI_M_SOC_RDATA26 VPWR VGND sg13cmos5l_antennanp
XFILLER_6_49 VPWR VGND sg13cmos5l_decap_8
XFILLER_691_28 VPWR VGND sg13cmos5l_decap_8
XFILLER_542_270 VPWR VGND sg13cmos5l_fill_2
XFILLER_502_112 VPWR VGND sg13cmos5l_decap_8
XFILLER_648_105 VPWR VGND sg13cmos5l_decap_8
XFILLER_193_42 VPWR VGND sg13cmos5l_decap_8
XFILLER_499_196 VPWR VGND sg13cmos5l_decap_8
XFILLER_493_0 VPWR VGND sg13cmos5l_decap_8
XFILLER_624_77 VPWR VGND sg13cmos5l_decap_8
XFILLER_502_189 VPWR VGND sg13cmos5l_decap_8
XFILLER_663_108 VPWR VGND sg13cmos5l_fill_1
XFILLER_126_91 VPWR VGND sg13cmos5l_decap_8
XFILLER_343_56 VPWR VGND sg13cmos5l_decap_8
XFILLER_120_140 VPWR VGND sg13cmos5l_decap_8
XFILLER_455_233 VPWR VGND sg13cmos5l_decap_8
XFILLER_490_84 VPWR VGND sg13cmos5l_decap_8
XFILLER_66_227 VPWR VGND sg13cmos5l_fill_2
XFILLER_660_0 VPWR VGND sg13cmos5l_decap_8
XFILLER_640_21 VPWR VGND sg13cmos5l_decap_8
XFILLER_86_84 VPWR VGND sg13cmos5l_decap_8
XFILLER_13_7 VPWR VGND sg13cmos5l_decap_8
XFILLER_207_222 VPWR VGND sg13cmos5l_decap_8
X_1000_ _1000_/Q Tile_X0Y0_FrameData[3] VGND VPWR Tile_X0Y9_FrameStrobe[1] latch
XFILLER_408_182 VPWR VGND sg13cmos5l_decap_8
XFILLER_281_147 VPWR VGND sg13cmos5l_decap_8
XFILLER_640_98 VPWR VGND sg13cmos5l_decap_8
XFILLER_19_176 VPWR VGND sg13cmos5l_decap_8
XFILLER_212_49 VPWR VGND sg13cmos5l_decap_8
XFILLER_569_112 VPWR VGND sg13cmos5l_decap_8
XFILLER_74_271 VPWR VGND sg13cmos5l_fill_2
XFILLER_612_230 VPWR VGND sg13cmos5l_decap_8
XFILLER_470_269 VPWR VGND sg13cmos5l_decap_4
XFILLER_179_107 VPWR VGND sg13cmos5l_decap_8
XANTENNA__3320__X Tile_X0Y4_EE4BEG[8] VPWR VGND sg13cmos5l_antennanp
XFILLER_569_189 VPWR VGND sg13cmos5l_decap_8
X_2951_ Tile_X0Y8_EE4BEG[7] _4751_/X VPWR VGND sg13cmos5l_buf_1
XFILLER_649_63 VPWR VGND sg13cmos5l_decap_8
X_1902_ _1902_/Q Tile_X0Y3_FrameData[27] VGND VPWR Tile_X0Y9_FrameStrobe[7] latch
X_2882_ Tile_X0Y6_FrameData_O[3] Tile_X0Y6_FrameData[3] VPWR VGND sg13cmos5l_buf_1
XFILLER_368_64 VPWR VGND sg13cmos5l_decap_8
XFILLER_368_86 VPWR VGND sg13cmos5l_fill_2
X_4621_ _4621_/X Tile_X0Y7_W2END[6] AXI_M_SOC_RDATA22 _4671_/X _4670_/X _0317_/Q _0316_/Q
+ VPWR VGND sg13cmos5l_mux4_1
X_1833_ _1833_/Q Tile_X0Y3_FrameData[0] VGND VPWR Tile_X0Y9_FrameStrobe[4] latch
XFILLER_336_148 VPWR VGND sg13cmos5l_decap_8
XFILLER_518_56 VPWR VGND sg13cmos5l_decap_8
XFILLER_525_259 VPWR VGND sg13cmos5l_decap_8
X_4552_ _4552_/X _4483_/X _4599_/X _4598_/X _4482_/X _2449_/Q _2448_/Q VPWR VGND sg13cmos5l_mux4_1
X_1764_ _1764_/Q Tile_X0Y3_FrameData[5] VGND VPWR Tile_X0Y9_FrameStrobe[2] latch
XFILLER_665_84 VPWR VGND sg13cmos5l_decap_8
XFILLER_679_230 VPWR VGND sg13cmos5l_decap_4
XFILLER_237_35 VPWR VGND sg13cmos5l_decap_8
XFILLER_679_241 VPWR VGND sg13cmos5l_fill_1
X_3503_ Tile_X0Y1_E2BEGb[1] _3941_/X VPWR VGND sg13cmos5l_buf_1
X_0715_ _0715_/Q Tile_X0Y9_FrameData[20] VGND VPWR Tile_X0Y9_FrameStrobe[1] latch
X_4483_ _4483_/X Tile_X0Y7_W2MID[0] Tile_X0Y7_W2END[0] Tile_X0Y7_W6END[0] _4668_/X
+ _0393_/Q _0392_/Q VPWR VGND sg13cmos5l_mux4_1
XFILLER_143_243 VPWR VGND sg13cmos5l_decap_8
X_1695_ _1695_/Q Tile_X0Y3_FrameData[10] VGND VPWR Tile_X0Y9_FrameStrobe[0] latch
XFILLER_639_105 VPWR VGND sg13cmos5l_decap_8
X_3434_ Tile_X0Y4_FrameData_O[25] Tile_X0Y4_FrameData[25] VPWR VGND sg13cmos5l_buf_1
X_0646_ _0646_/Q Tile_X0Y8_FrameData[25] VGND VPWR Tile_X0Y9_FrameStrobe[7] latch
XFILLER_694_233 VPWR VGND sg13cmos5l_decap_8
X_0577_ _0577_/Q Tile_X0Y8_FrameData[30] VGND VPWR Tile_X0Y9_FrameStrobe[5] latch
X_3365_ Tile_X0Y2_EE4BEG[4] _4060_/X VPWR VGND sg13cmos5l_buf_1
XFILLER_534_88 VPWR VGND sg13cmos5l_decap_8
XFILLER_257_100 VPWR VGND sg13cmos5l_decap_8
XFILLER_253_56 VPWR VGND sg13cmos5l_decap_8
X_2316_ _2316_/Q Tile_X0Y5_FrameData[25] VGND VPWR Tile_X0Y9_FrameStrobe[4] latch
XFILLER_647_182 VPWR VGND sg13cmos5l_decap_8
XFILLER_446_233 VPWR VGND sg13cmos5l_fill_2
XFILLER_257_144 VPWR VGND sg13cmos5l_decap_8
X_3296_ Tile_X0Y0_E2BEGb[4] _3816_/X VPWR VGND sg13cmos5l_buf_1
XFILLER_550_21 VPWR VGND sg13cmos5l_decap_8
XFILLER_403_15 VPWR VGND sg13cmos5l_decap_8
XFILLER_662_141 VPWR VGND sg13cmos5l_decap_8
XFILLER_57_238 VPWR VGND sg13cmos5l_decap_8
XFILLER_111_195 VPWR VGND sg13cmos5l_decap_8
X_2247_ _2247_/Q Tile_X0Y5_FrameData[30] VGND VPWR Tile_X0Y9_FrameStrobe[2] latch
XFILLER_122_49 VPWR VGND sg13cmos5l_decap_8
X_2178_ _2178_/Q Tile_X0Y4_FrameData[3] VGND VPWR Tile_X0Y9_FrameStrobe[7] latch
XFILLER_550_98 VPWR VGND sg13cmos5l_fill_2
XFILLER_700_35 VPWR VGND sg13cmos5l_decap_8
XFILLER_65_271 VPWR VGND sg13cmos5l_fill_2
XFILLER_461_269 VPWR VGND sg13cmos5l_decap_4
X_1129_ _1129_/Q Tile_X0Y0_FrameData[2] VGND VPWR Tile_X0Y9_FrameStrobe[5] latch
XANTENNA__3230__X Tile_X0Y0_FrameStrobe_O[18] VPWR VGND sg13cmos5l_antennanp
XFILLER_213_225 VPWR VGND sg13cmos5l_decap_8
XFILLER_359_207 VPWR VGND sg13cmos5l_decap_4
XFILLER_15_14 VPWR VGND sg13cmos5l_decap_8
XFILLER_359_218 VPWR VGND sg13cmos5l_fill_1
XFILLER_575_126 VPWR VGND sg13cmos5l_decap_8
XFILLER_559_63 VPWR VGND sg13cmos5l_decap_8
XFILLER_40_149 VPWR VGND sg13cmos5l_decap_8
XFILLER_278_42 VPWR VGND sg13cmos5l_decap_8
XFILLER_367_251 VPWR VGND sg13cmos5l_decap_8
XFILLER_178_162 VPWR VGND sg13cmos5l_decap_8
XFILLER_382_210 VPWR VGND sg13cmos5l_decap_8
X_4819_ _4819_/X Tile_X0Y7_W2MID[4] Tile_X0Y7_W2END[4] Tile_X0Y7_W6END[11] _4675_/X
+ _0365_/Q _0364_/Q VPWR VGND sg13cmos5l_mux4_1
XFILLER_709_77 VPWR VGND sg13cmos5l_decap_8
XFILLER_193_132 VPWR VGND sg13cmos5l_decap_8
XFILLER_327_148 VPWR VGND sg13cmos5l_fill_2
XFILLER_31_35 VPWR VGND sg13cmos5l_fill_2
XFILLER_428_56 VPWR VGND sg13cmos5l_decap_8
XFILLER_215_7 VPWR VGND sg13cmos5l_decap_8
XFILLER_575_84 VPWR VGND sg13cmos5l_decap_8
XFILLER_147_35 VPWR VGND sg13cmos5l_decap_8
XFILLER_531_207 VPWR VGND sg13cmos5l_decap_8
XFILLER_31_79 VPWR VGND sg13cmos5l_decap_4
XFILLER_294_63 VPWR VGND sg13cmos5l_decap_8
XFILLER_335_181 VPWR VGND sg13cmos5l_decap_8
XFILLER_134_254 VPWR VGND sg13cmos5l_fill_2
XFILLER_496_133 VPWR VGND sg13cmos5l_decap_8
XFILLER_350_140 VPWR VGND sg13cmos5l_decap_8
XFILLER_584_7 VPWR VGND sg13cmos5l_decap_8
XFILLER_350_195 VPWR VGND sg13cmos5l_decap_8
XFILLER_248_100 VPWR VGND sg13cmos5l_decap_8
XFILLER_645_119 VPWR VGND sg13cmos5l_decap_8
XANTENNA__3405__X Tile_X0Y2_E1BEG[0] VPWR VGND sg13cmos5l_antennanp
XFILLER_0_245 VPWR VGND sg13cmos5l_decap_4
XFILLER_48_227 VPWR VGND sg13cmos5l_decap_8
XFILLER_460_21 VPWR VGND sg13cmos5l_decap_8
XFILLER_102_184 VPWR VGND sg13cmos5l_decap_8
XFILLER_56_43 VPWR VGND sg13cmos5l_decap_8
XFILLER_452_214 VPWR VGND sg13cmos5l_fill_1
XFILLER_653_174 VPWR VGND sg13cmos5l_decap_8
XFILLER_56_54 VPWR VGND sg13cmos5l_fill_1
XFILLER_452_236 VPWR VGND sg13cmos5l_decap_8
XFILLER_610_35 VPWR VGND sg13cmos5l_decap_8
XFILLER_405_130 VPWR VGND sg13cmos5l_decap_8
XFILLER_16_113 VPWR VGND sg13cmos5l_fill_2
XFILLER_452_269 VPWR VGND sg13cmos5l_decap_4
XANTENNA__3140__X Tile_X0Y7_FrameData_O[10] VPWR VGND sg13cmos5l_antennanp
XFILLER_204_236 VPWR VGND sg13cmos5l_fill_1
XFILLER_112_93 VPWR VGND sg13cmos5l_fill_1
XFILLER_72_42 VPWR VGND sg13cmos5l_decap_8
XFILLER_686_28 VPWR VGND sg13cmos5l_decap_8
XFILLER_420_133 VPWR VGND sg13cmos5l_decap_8
XFILLER_566_126 VPWR VGND sg13cmos5l_decap_8
XFILLER_241_0 VPWR VGND sg13cmos5l_decap_8
XFILLER_169_140 VPWR VGND sg13cmos5l_decap_8
XFILLER_188_42 VPWR VGND sg13cmos5l_decap_8
XFILLER_339_0 VPWR VGND sg13cmos5l_decap_8
XFILLER_31_149 VPWR VGND sg13cmos5l_decap_8
XFILLER_619_77 VPWR VGND sg13cmos5l_decap_8
XFILLER_507_237 VPWR VGND sg13cmos5l_decap_4
XFILLER_708_197 VPWR VGND sg13cmos5l_decap_4
XFILLER_506_0 VPWR VGND sg13cmos5l_decap_8
XFILLER_184_176 VPWR VGND sg13cmos5l_decap_8
XFILLER_635_21 VPWR VGND sg13cmos5l_decap_8
XFILLER_333_129 VPWR VGND sg13cmos5l_fill_1
XFILLER_326_181 VPWR VGND sg13cmos5l_decap_8
XFILLER_676_200 VPWR VGND sg13cmos5l_fill_1
X_0500_ _0500_/Q Tile_X0Y8_FrameData[11] VGND VPWR Tile_X0Y9_FrameStrobe[2] latch
XFILLER_676_222 VPWR VGND sg13cmos5l_decap_8
X_1480_ _1480_/Q Tile_X0Y2_FrameData[9] VGND VPWR Tile_X0Y9_FrameStrobe[1] latch
XFILLER_207_49 VPWR VGND sg13cmos5l_decap_8
XFILLER_635_98 VPWR VGND sg13cmos5l_decap_8
XFILLER_140_224 VPWR VGND sg13cmos5l_decap_8
XFILLER_140_235 VPWR VGND sg13cmos5l_fill_2
X_0431_ _0431_/Q Tile_X0Y8_FrameData[16] VGND VPWR Tile_X0Y9_FrameStrobe[0] latch
XFILLER_354_77 VPWR VGND sg13cmos5l_decap_8
XFILLER_286_217 VPWR VGND sg13cmos5l_decap_8
XFILLER_487_177 VPWR VGND sg13cmos5l_decap_8
XFILLER_636_119 VPWR VGND sg13cmos5l_decap_8
XFILLER_504_14 VPWR VGND sg13cmos5l_decap_8
XANTENNA__3315__X Tile_X0Y4_EE4BEG[3] VPWR VGND sg13cmos5l_antennanp
XFILLER_140_268 VPWR VGND sg13cmos5l_decap_4
XFILLER_97_94 VPWR VGND sg13cmos5l_decap_8
XFILLER_651_42 VPWR VGND sg13cmos5l_decap_8
XFILLER_239_133 VPWR VGND sg13cmos5l_decap_8
X_0362_ _0362_/Q Tile_X0Y7_FrameData[21] VGND VPWR Tile_X0Y9_FrameStrobe[6] latch
X_3150_ Tile_X0Y7_FrameData_O[20] Tile_X0Y7_FrameData[20] VPWR VGND sg13cmos5l_buf_1
XFILLER_223_15 VPWR VGND sg13cmos5l_decap_8
XFILLER_39_227 VPWR VGND sg13cmos5l_decap_8
XFILLER_39_238 VPWR VGND sg13cmos5l_fill_1
XFILLER_294_261 VPWR VGND sg13cmos5l_fill_1
XFILLER_239_166 VPWR VGND sg13cmos5l_decap_8
X_2101_ _2101_/Q Tile_X0Y4_FrameData[16] VGND VPWR Tile_X0Y9_FrameStrobe[5] latch
XFILLER_370_43 VPWR VGND sg13cmos5l_decap_8
X_3081_ Tile_X0Y4_E2BEGb[7] _4271_/X VPWR VGND sg13cmos5l_buf_1
X_0293_ _0293_/Q Tile_X0Y7_FrameData[26] VGND VPWR Tile_X0Y9_FrameStrobe[4] latch
XFILLER_589_207 VPWR VGND sg13cmos5l_decap_8
XFILLER_443_225 VPWR VGND sg13cmos5l_fill_2
XFILLER_254_136 VPWR VGND sg13cmos5l_decap_8
X_2032_ _2032_/Q Tile_X0Y4_FrameData[21] VGND VPWR Tile_X0Y9_FrameStrobe[3] latch
XFILLER_644_196 VPWR VGND sg13cmos5l_decap_8
XFILLER_520_35 VPWR VGND sg13cmos5l_decap_8
XANTENNA__3050__X Tile_X0Y5_FrameData_O[9] VPWR VGND sg13cmos5l_antennanp
XFILLER_62_252 VPWR VGND sg13cmos5l_fill_2
XFILLER_62_263 VPWR VGND sg13cmos5l_fill_2
XFILLER_411_122 VPWR VGND sg13cmos5l_fill_1
XFILLER_600_222 VPWR VGND sg13cmos5l_decap_8
XFILLER_596_28 VPWR VGND sg13cmos5l_decap_8
XFILLER_411_144 VPWR VGND sg13cmos5l_decap_8
X_3983_ _3983_/X Tile_X0Y2_W1END[1] Tile_X0Y2_W6END[5] _4110_/X _4085_/X _1671_/Q
+ _1670_/Q VPWR VGND sg13cmos5l_mux4_1
XFILLER_600_244 VPWR VGND sg13cmos5l_decap_8
X_2934_ Tile_X0Y8_E6BEG[2] _4762_/X VPWR VGND sg13cmos5l_buf_1
XFILLER_309_104 VPWR VGND sg13cmos5l_decap_8
XFILLER_87_0 VPWR VGND sg13cmos5l_decap_4
XFILLER_175_121 VPWR VGND sg13cmos5l_decap_4
XFILLER_565_170 VPWR VGND sg13cmos5l_fill_1
XFILLER_714_112 VPWR VGND sg13cmos5l_decap_8
X_2865_ Tile_X0Y6_EE4BEG[2] _4514_/X VPWR VGND sg13cmos5l_buf_1
XFILLER_309_137 VPWR VGND sg13cmos5l_decap_8
XFILLER_565_192 VPWR VGND sg13cmos5l_decap_4
XFILLER_248_56 VPWR VGND sg13cmos5l_decap_8
X_4604_ _4604_/X Tile_X0Y7_W1END[2] Tile_X0Y7_WW4END[14] Tile_X0Y7_W6END[6] _4686_/X
+ _0349_/Q _0348_/Q VPWR VGND sg13cmos5l_mux4_1
X_1816_ _1816_/Q Tile_X0Y3_FrameData[17] VGND VPWR Tile_X0Y9_FrameStrobe[4] latch
XFILLER_175_176 VPWR VGND sg13cmos5l_decap_4
X_2796_ Tile_X0Y3_E6BEG[6] _4186_/X VPWR VGND sg13cmos5l_buf_1
XFILLER_545_21 VPWR VGND sg13cmos5l_decap_8
XFILLER_7_70 VPWR VGND sg13cmos5l_decap_8
XFILLER_513_218 VPWR VGND sg13cmos5l_decap_4
XFILLER_324_129 VPWR VGND sg13cmos5l_decap_8
XFILLER_513_229 VPWR VGND sg13cmos5l_decap_8
XFILLER_714_189 VPWR VGND sg13cmos5l_decap_8
X_4535_ _4535_/X AXI_M_SOC_RDATA27 _4572_/X _4576_/X _4559_/X _2537_/Q _2536_/Q VPWR
+ VGND sg13cmos5l_mux4_1
XFILLER_317_181 VPWR VGND sg13cmos5l_decap_8
X_1747_ _1747_/Q Tile_X0Y3_FrameData[22] VGND VPWR Tile_X0Y9_FrameStrobe[2] latch
XFILLER_116_254 VPWR VGND sg13cmos5l_decap_8
XFILLER_332_151 VPWR VGND sg13cmos5l_decap_8
XFILLER_89_116 VPWR VGND sg13cmos5l_decap_8
X_4466_ _4466_/X _4427_/X _0097_/X _4426_/X _0156_/X _2207_/Q _2206_/Q VPWR VGND sg13cmos5l_mux4_1
XFILLER_545_98 VPWR VGND sg13cmos5l_decap_8
XFILLER_117_49 VPWR VGND sg13cmos5l_decap_4
XFILLER_131_213 VPWR VGND sg13cmos5l_decap_8
X_1678_ _1678_/Q Tile_X0Y3_FrameData[27] VGND VPWR Tile_X0Y9_FrameStrobe[0] latch
XFILLER_131_224 VPWR VGND sg13cmos5l_fill_1
XFILLER_277_206 VPWR VGND sg13cmos5l_decap_8
X_3417_ Tile_X0Y4_FrameData_O[8] Tile_X0Y4_FrameData[8] VPWR VGND sg13cmos5l_buf_1
X_0629_ _0629_/Q Tile_X0Y8_FrameData[10] VGND VPWR Tile_X0Y9_FrameStrobe[6] latch
XFILLER_682_203 VPWR VGND sg13cmos5l_decap_8
XFILLER_414_14 VPWR VGND sg13cmos5l_decap_8
XANTENNA__3225__X Tile_X0Y0_FrameStrobe_O[13] VPWR VGND sg13cmos5l_antennanp
X_4397_ _4397_/X Tile_X0Y5_WW4END[6] AXI_M_SOC_RRESP0 _4457_/X _4429_/X _2309_/Q _2308_/Q
+ VPWR VGND sg13cmos5l_mux4_1
XFILLER_561_42 VPWR VGND sg13cmos5l_decap_8
XFILLER_493_147 VPWR VGND sg13cmos5l_decap_8
X_3348_ Tile_X0Y2_FrameData_O[19] Tile_X0Y2_FrameData[19] VPWR VGND sg13cmos5l_buf_1
XFILLER_280_21 VPWR VGND sg13cmos5l_decap_8
XFILLER_245_103 VPWR VGND sg13cmos5l_decap_8
X_3279_ Tile_X0Y0_EE4BEG[15] _3835_/X VPWR VGND sg13cmos5l_buf_1
XFILLER_711_56 VPWR VGND sg13cmos5l_decap_8
XFILLER_650_133 VPWR VGND sg13cmos5l_decap_8
XFILLER_280_98 VPWR VGND sg13cmos5l_decap_8
XFILLER_245_158 VPWR VGND sg13cmos5l_decap_8
XFILLER_213_70 VPWR VGND sg13cmos5l_decap_8
XFILLER_430_35 VPWR VGND sg13cmos5l_decap_8
XFILLER_38_271 VPWR VGND sg13cmos5l_fill_2
XANTENNA_207 Tile_X0Y9_N2MID[6] VPWR VGND sg13cmos5l_antennanp
XANTENNA_218 Tile_X0Y9_N4END[14] VPWR VGND sg13cmos5l_antennanp
XFILLER_26_35 VPWR VGND sg13cmos5l_decap_8
XANTENNA_229 Tile_X0Y0_FrameData[6] VPWR VGND sg13cmos5l_antennanp
XFILLER_165_7 VPWR VGND sg13cmos5l_decap_8
XFILLER_53_252 VPWR VGND sg13cmos5l_decap_4
XFILLER_402_133 VPWR VGND sg13cmos5l_fill_2
XFILLER_289_63 VPWR VGND sg13cmos5l_decap_8
XFILLER_13_116 VPWR VGND sg13cmos5l_decap_8
XFILLER_402_177 VPWR VGND sg13cmos5l_decap_8
XFILLER_332_7 VPWR VGND sg13cmos5l_decap_8
XFILLER_355_210 VPWR VGND sg13cmos5l_decap_8
XFILLER_166_121 VPWR VGND sg13cmos5l_decap_8
XFILLER_42_78 VPWR VGND sg13cmos5l_fill_2
XFILLER_571_140 VPWR VGND sg13cmos5l_decap_8
XFILLER_315_118 VPWR VGND sg13cmos5l_decap_8
XFILLER_455_21 VPWR VGND sg13cmos5l_decap_8
XFILLER_370_213 VPWR VGND sg13cmos5l_fill_1
XFILLER_107_210 VPWR VGND sg13cmos5l_decap_8
XFILLER_181_135 VPWR VGND sg13cmos5l_fill_1
XFILLER_370_235 VPWR VGND sg13cmos5l_decap_8
XFILLER_308_48 VPWR VGND sg13cmos5l_decap_8
XFILLER_181_157 VPWR VGND sg13cmos5l_decap_8
XFILLER_308_59 VPWR VGND sg13cmos5l_fill_1
XFILLER_658_211 VPWR VGND sg13cmos5l_decap_4
XFILLER_122_202 VPWR VGND sg13cmos5l_decap_8
XFILLER_605_35 VPWR VGND sg13cmos5l_decap_8
XFILLER_122_235 VPWR VGND sg13cmos5l_decap_8
XFILLER_618_119 VPWR VGND sg13cmos5l_decap_8
XFILLER_3_28 VPWR VGND sg13cmos5l_decap_8
XANTENNA__3135__X Tile_X0Y7_FrameData_O[5] VPWR VGND sg13cmos5l_antennanp
XFILLER_484_136 VPWR VGND sg13cmos5l_fill_2
XFILLER_471_42 VPWR VGND sg13cmos5l_decap_8
XFILLER_324_36 VPWR VGND sg13cmos5l_decap_8
XFILLER_95_119 VPWR VGND sg13cmos5l_decap_8
XFILLER_190_21 VPWR VGND sg13cmos5l_decap_8
XFILLER_67_42 VPWR VGND sg13cmos5l_decap_8
XFILLER_673_258 VPWR VGND sg13cmos5l_decap_8
XFILLER_191_0 VPWR VGND sg13cmos5l_decap_8
XFILLER_626_141 VPWR VGND sg13cmos5l_decap_4
XFILLER_471_86 VPWR VGND sg13cmos5l_decap_8
XFILLER_425_203 VPWR VGND sg13cmos5l_decap_8
XFILLER_289_0 VPWR VGND sg13cmos5l_decap_8
XANTENNA__2974__X Tile_X0Y8_FrameData_O[14] VPWR VGND sg13cmos5l_antennanp
XFILLER_236_125 VPWR VGND sg13cmos5l_decap_8
XFILLER_621_56 VPWR VGND sg13cmos5l_decap_8
XFILLER_291_231 VPWR VGND sg13cmos5l_decap_8
XFILLER_641_133 VPWR VGND sg13cmos5l_decap_8
XFILLER_340_35 VPWR VGND sg13cmos5l_decap_8
XFILLER_456_0 VPWR VGND sg13cmos5l_decap_8
XFILLER_440_206 VPWR VGND sg13cmos5l_decap_8
XFILLER_251_128 VPWR VGND sg13cmos5l_decap_8
XFILLER_189_202 VPWR VGND sg13cmos5l_decap_4
XFILLER_697_49 VPWR VGND sg13cmos5l_decap_8
XFILLER_539_104 VPWR VGND sg13cmos5l_decap_8
XFILLER_199_63 VPWR VGND sg13cmos5l_decap_8
XFILLER_623_0 VPWR VGND sg13cmos5l_decap_8
XFILLER_539_148 VPWR VGND sg13cmos5l_decap_8
X_0980_ _0980_/Q Tile_X0Y0_FrameData[23] VGND VPWR Tile_X0Y9_FrameStrobe[1] latch
XFILLER_80_7 VPWR VGND sg13cmos5l_decap_8
XFILLER_349_77 VPWR VGND sg13cmos5l_decap_8
XFILLER_157_132 VPWR VGND sg13cmos5l_fill_2
XFILLER_346_254 VPWR VGND sg13cmos5l_decap_8
XFILLER_646_42 VPWR VGND sg13cmos5l_decap_8
XFILLER_562_140 VPWR VGND sg13cmos5l_decap_8
X_2650_ _2650_/Q Tile_X0Y6_FrameData[13] VGND VPWR Tile_X0Y9_FrameStrobe[6] latch
XFILLER_8_164 VPWR VGND sg13cmos5l_fill_2
XFILLER_172_113 VPWR VGND sg13cmos5l_decap_4
XFILLER_365_21 VPWR VGND sg13cmos5l_decap_8
XFILLER_361_224 VPWR VGND sg13cmos5l_decap_8
X_1601_ _1601_/Q Tile_X0Y2_FrameData[16] VGND VPWR Tile_X0Y9_FrameStrobe[5] latch
X_2581_ _2581_/Q Tile_X0Y6_FrameData[18] VGND VPWR Tile_X0Y9_FrameStrobe[4] latch
XFILLER_711_126 VPWR VGND sg13cmos5l_decap_8
X_4320_ _4320_/X Tile_X0Y0_W1END[0] Tile_X0Y0_WW4END[12] Tile_X0Y0_W6END[4] _3881_/X
+ _1117_/Q _1116_/Q VPWR VGND sg13cmos5l_mux4_1
X_1532_ _1532_/Q Tile_X0Y2_FrameData[21] VGND VPWR Tile_X0Y9_FrameStrobe[3] latch
XFILLER_515_35 VPWR VGND sg13cmos5l_decap_8
X_4251_ _4251_/X Tile_X0Y5_W2MID[0] Tile_X0Y5_W2END[0] Tile_X0Y5_W6END[0] _4428_/X
+ _2417_/Q _2416_/Q VPWR VGND sg13cmos5l_mux4_1
XFILLER_662_63 VPWR VGND sg13cmos5l_decap_8
XFILLER_314_195 VPWR VGND sg13cmos5l_decap_8
XFILLER_234_14 VPWR VGND sg13cmos5l_decap_8
X_1463_ _1463_/Q Tile_X0Y2_FrameData[26] VGND VPWR Tile_X0Y9_FrameStrobe[1] latch
XANTENNA__3045__X Tile_X0Y5_FrameData_O[4] VPWR VGND sg13cmos5l_antennanp
XFILLER_113_268 VPWR VGND sg13cmos5l_decap_4
XFILLER_475_136 VPWR VGND sg13cmos5l_decap_8
XFILLER_86_119 VPWR VGND sg13cmos5l_decap_8
X_3202_ Tile_X0Y0_N2BEG[2] _3786_/X VPWR VGND sg13cmos5l_buf_1
X_0414_ _0414_/Q Tile_X0Y7_FrameData[1] VGND VPWR Tile_X0Y9_FrameStrobe[7] latch
X_1394_ _1394_/Q Tile_X0Y1_FrameData[7] VGND VPWR Tile_X0Y9_FrameStrobe[6] latch
X_4182_ _4182_/X _0087_/X Tile_X0Y0_S4END[14] _4231_/X _4235_/X _1777_/Q _1776_/Q
+ VPWR VGND sg13cmos5l_mux4_1
XFILLER_664_258 VPWR VGND sg13cmos5l_fill_2
XFILLER_475_158 VPWR VGND sg13cmos5l_decap_4
XFILLER_79_182 VPWR VGND sg13cmos5l_decap_8
XFILLER_267_272 VPWR VGND sg13cmos5l_fill_1
XANTENNA__2884__X Tile_X0Y6_FrameData_O[5] VPWR VGND sg13cmos5l_antennanp
XFILLER_94_130 VPWR VGND sg13cmos5l_decap_8
X_3133_ Tile_X0Y7_FrameData_O[3] Tile_X0Y7_FrameData[3] VPWR VGND sg13cmos5l_buf_1
X_0345_ _0345_/Q Tile_X0Y7_FrameData[6] VGND VPWR Tile_X0Y9_FrameStrobe[5] latch
XFILLER_416_225 VPWR VGND sg13cmos5l_decap_8
XFILLER_531_56 VPWR VGND sg13cmos5l_decap_8
XFILLER_282_231 VPWR VGND sg13cmos5l_decap_8
XFILLER_227_158 VPWR VGND sg13cmos5l_decap_8
XFILLER_416_247 VPWR VGND sg13cmos5l_decap_8
X_0276_ _0276_/Q Tile_X0Y7_FrameData[11] VGND VPWR Tile_X0Y9_FrameStrobe[3] latch
X_3064_ Tile_X0Y5_FrameData_O[23] Tile_X0Y5_FrameData[23] VPWR VGND sg13cmos5l_buf_1
XFILLER_632_133 VPWR VGND sg13cmos5l_decap_8
XFILLER_416_258 VPWR VGND sg13cmos5l_fill_1
XFILLER_250_35 VPWR VGND sg13cmos5l_decap_8
X_2015_ _2015_/Q Tile_X0Y4_FrameData[6] VGND VPWR Tile_X0Y9_FrameStrobe[2] latch
XFILLER_431_228 VPWR VGND sg13cmos5l_decap_4
XFILLER_396_110 VPWR VGND sg13cmos5l_decap_8
XFILLER_400_49 VPWR VGND sg13cmos5l_decap_8
XFILLER_687_60 VPWR VGND sg13cmos5l_fill_1
XFILLER_259_22 VPWR VGND sg13cmos5l_decap_8
X_3966_ _3966_/X _0095_/X Tile_X0Y0_S4END[6] _4017_/X _4002_/X _1277_/Q _1276_/Q VPWR
+ VGND sg13cmos5l_mux4_1
X_2917_ Tile_X0Y8_E2BEG[1] _4729_/X VPWR VGND sg13cmos5l_buf_1
XFILLER_409_14 VPWR VGND sg13cmos5l_decap_8
X_3897_ _3897_/X Tile_X0Y1_W2MID[3] Tile_X0Y1_W2END[3] Tile_X0Y1_W6END[3] _3994_/X
+ _1409_/Q _1408_/Q VPWR VGND sg13cmos5l_mux4_1
XFILLER_148_154 VPWR VGND sg13cmos5l_decap_8
XFILLER_556_42 VPWR VGND sg13cmos5l_decap_8
XFILLER_699_133 VPWR VGND sg13cmos5l_decap_8
XFILLER_163_102 VPWR VGND sg13cmos5l_decap_8
X_2848_ Tile_X0Y6_E2BEGb[5] _4509_/X VPWR VGND sg13cmos5l_buf_1
XFILLER_275_21 VPWR VGND sg13cmos5l_decap_8
XFILLER_498_217 VPWR VGND sg13cmos5l_decap_8
XFILLER_352_224 VPWR VGND sg13cmos5l_decap_8
XFILLER_699_188 VPWR VGND sg13cmos5l_decap_8
X_2779_ Tile_X0Y3_EE4BEG[5] _4169_/X VPWR VGND sg13cmos5l_buf_1
XFILLER_163_179 VPWR VGND sg13cmos5l_decap_8
XFILLER_706_56 VPWR VGND sg13cmos5l_decap_8
X_4518_ _4518_/X Tile_X0Y6_WW4END[9] AXI_M_SOC_RDATA30 _4577_/X _4555_/X _2571_/Q
+ _2570_/Q VPWR VGND sg13cmos5l_mux4_1
XFILLER_104_202 VPWR VGND sg13cmos5l_decap_8
XFILLER_425_35 VPWR VGND sg13cmos5l_decap_8
XFILLER_305_162 VPWR VGND sg13cmos5l_fill_1
XFILLER_208_70 VPWR VGND sg13cmos5l_decap_8
XFILLER_305_184 VPWR VGND sg13cmos5l_decap_8
XFILLER_710_170 VPWR VGND sg13cmos5l_fill_2
XFILLER_572_63 VPWR VGND sg13cmos5l_decap_8
XFILLER_144_14 VPWR VGND sg13cmos5l_decap_8
X_4449_ _4449_/X Tile_X0Y9_W1END[3] Tile_X0Y9_WW4END[3] Tile_X0Y9_W6END[11] _4919_/X
+ _0894_/Q _0893_/Q VPWR VGND sg13cmos5l_mux4_1
XFILLER_77_108 VPWR VGND sg13cmos5l_decap_8
XFILLER_320_154 VPWR VGND sg13cmos5l_decap_8
XFILLER_291_64 VPWR VGND sg13cmos5l_decap_8
XFILLER_258_261 VPWR VGND sg13cmos5l_fill_2
XANTENNA__2794__X Tile_X0Y3_E6BEG[4] VPWR VGND sg13cmos5l_antennanp
XFILLER_608_152 VPWR VGND sg13cmos5l_decap_8
XFILLER_218_114 VPWR VGND sg13cmos5l_fill_1
XFILLER_85_130 VPWR VGND sg13cmos5l_decap_8
XFILLER_282_7 VPWR VGND sg13cmos5l_decap_8
XFILLER_218_136 VPWR VGND sg13cmos5l_decap_8
XFILLER_474_180 VPWR VGND sg13cmos5l_fill_2
XFILLER_218_147 VPWR VGND sg13cmos5l_fill_1
XFILLER_224_91 VPWR VGND sg13cmos5l_fill_1
XFILLER_441_56 VPWR VGND sg13cmos5l_decap_8
XFILLER_18_219 VPWR VGND sg13cmos5l_decap_8
XFILLER_407_258 VPWR VGND sg13cmos5l_decap_8
XFILLER_160_35 VPWR VGND sg13cmos5l_decap_8
XFILLER_407_269 VPWR VGND sg13cmos5l_decap_4
XFILLER_623_155 VPWR VGND sg13cmos5l_decap_8
XFILLER_547_7 VPWR VGND sg13cmos5l_decap_8
XFILLER_53_11 VPWR VGND sg13cmos5l_decap_8
XFILLER_241_150 VPWR VGND sg13cmos5l_decap_8
XFILLER_576_243 VPWR VGND sg13cmos5l_decap_4
XFILLER_714_7 VPWR VGND sg13cmos5l_decap_8
XFILLER_330_4 VPWR VGND sg13cmos5l_fill_1
XFILLER_387_187 VPWR VGND sg13cmos5l_fill_1
XFILLER_169_77 VPWR VGND sg13cmos5l_decap_8
XFILLER_319_14 VPWR VGND sg13cmos5l_decap_8
XFILLER_139_154 VPWR VGND sg13cmos5l_decap_8
XFILLER_591_268 VPWR VGND sg13cmos5l_decap_4
XFILLER_466_42 VPWR VGND sg13cmos5l_decap_8
XFILLER_319_36 VPWR VGND sg13cmos5l_decap_8
XFILLER_185_21 VPWR VGND sg13cmos5l_decap_8
XFILLER_544_184 VPWR VGND sg13cmos5l_decap_8
XANTENNA__2969__X Tile_X0Y8_FrameData_O[9] VPWR VGND sg13cmos5l_antennanp
XFILLER_154_146 VPWR VGND sg13cmos5l_decap_8
XFILLER_489_239 VPWR VGND sg13cmos5l_decap_4
XFILLER_204_0 VPWR VGND sg13cmos5l_decap_8
XFILLER_616_56 VPWR VGND sg13cmos5l_decap_8
XFILLER_185_98 VPWR VGND sg13cmos5l_decap_8
XFILLER_335_35 VPWR VGND sg13cmos5l_decap_8
XFILLER_500_210 VPWR VGND sg13cmos5l_decap_8
XFILLER_646_203 VPWR VGND sg13cmos5l_decap_8
XFILLER_497_272 VPWR VGND sg13cmos5l_fill_1
XFILLER_482_63 VPWR VGND sg13cmos5l_decap_4
XFILLER_311_132 VPWR VGND sg13cmos5l_decap_8
XFILLER_482_85 VPWR VGND sg13cmos5l_decap_8
XFILLER_457_125 VPWR VGND sg13cmos5l_decap_8
XFILLER_482_96 VPWR VGND sg13cmos5l_fill_2
XFILLER_68_119 VPWR VGND sg13cmos5l_decap_8
XFILLER_573_0 VPWR VGND sg13cmos5l_decap_8
XFILLER_311_198 VPWR VGND sg13cmos5l_fill_1
XFILLER_632_77 VPWR VGND sg13cmos5l_decap_8
XFILLER_204_28 VPWR VGND sg13cmos5l_decap_8
XFILLER_209_114 VPWR VGND sg13cmos5l_decap_8
XFILLER_264_220 VPWR VGND sg13cmos5l_decap_8
XFILLER_134_91 VPWR VGND sg13cmos5l_decap_8
XFILLER_351_56 VPWR VGND sg13cmos5l_decap_8
X_0130_ AXI_M_SOC_AWSIZE0 _0939_/Q _3679_/X VPWR VGND sg13cmos5l_nor2b_1
XFILLER_614_144 VPWR VGND sg13cmos5l_fill_2
XFILLER_94_95 VPWR VGND sg13cmos5l_decap_8
XFILLER_17_230 VPWR VGND sg13cmos5l_decap_8
X_0061_ _3176_/A _3926_/X _3927_/X _1899_/Q VPWR VGND sg13cmos5l_mux2_1
XFILLER_413_228 VPWR VGND sg13cmos5l_fill_2
XFILLER_91_166 VPWR VGND sg13cmos5l_decap_8
XFILLER_567_210 VPWR VGND sg13cmos5l_decap_8
XFILLER_220_49 VPWR VGND sg13cmos5l_decap_8
XFILLER_32_211 VPWR VGND sg13cmos5l_decap_8
XFILLER_232_161 VPWR VGND sg13cmos5l_decap_8
X_3820_ _3820_/X Tile_X0Y0_WW4END[7] Tile_X0Y0_WW4END[15] _3863_/X _3852_/X _1065_/Q
+ _1064_/Q VPWR VGND sg13cmos5l_mux4_1
XFILLER_32_266 VPWR VGND sg13cmos5l_decap_8
XFILLER_378_187 VPWR VGND sg13cmos5l_decap_8
XFILLER_177_249 VPWR VGND sg13cmos5l_decap_8
XFILLER_393_124 VPWR VGND sg13cmos5l_decap_8
X_3751_ AXI_M_SOC_ARADDR23 Tile_X0Y8_WW4END[7] Tile_X0Y8_WW4END[15] Tile_X0Y8_W6END[7]
+ _4807_/X _0489_/Q _0488_/Q VPWR VGND sg13cmos5l_mux4_1
XFILLER_300_93 VPWR VGND sg13cmos5l_decap_8
XFILLER_229_14 VPWR VGND sg13cmos5l_decap_8
X_0963_ _0963_/Q Tile_X0Y0_FrameData[8] VGND VPWR Tile_X0Y9_FrameStrobe[0] latch
XFILLER_582_246 VPWR VGND sg13cmos5l_fill_2
X_2702_ _4201_/A3 VPWR VGND sg13cmos5l_tielo
XFILLER_582_268 VPWR VGND sg13cmos5l_decap_4
XFILLER_376_53 VPWR VGND sg13cmos5l_fill_2
X_3682_ _3682_/X Tile_X0Y3_WW4END[0] Tile_X0Y3_WW4END[8] Tile_X0Y3_W6END[0] _4222_/X
+ _1757_/Q _1756_/Q VPWR VGND sg13cmos5l_mux4_1
X_0894_ _0894_/Q Tile_X0Y9_FrameData[1] VGND VPWR Tile_X0Y9_FrameStrobe[6] latch
XFILLER_145_124 VPWR VGND sg13cmos5l_decap_4
XANTENNA__2879__X Tile_X0Y6_FrameData_O[0] VPWR VGND sg13cmos5l_antennanp
X_2633_ _2633_/Q Tile_X0Y6_FrameData[30] VGND VPWR Tile_X0Y9_FrameStrobe[6] latch
XFILLER_334_246 VPWR VGND sg13cmos5l_decap_8
XFILLER_160_105 VPWR VGND sg13cmos5l_decap_8
XFILLER_550_165 VPWR VGND sg13cmos5l_fill_2
X_2564_ _2564_/Q Tile_X0Y6_FrameData[3] VGND VPWR Tile_X0Y9_FrameStrobe[3] latch
XFILLER_696_169 VPWR VGND sg13cmos5l_decap_8
XFILLER_495_209 VPWR VGND sg13cmos5l_decap_8
XFILLER_299_150 VPWR VGND sg13cmos5l_decap_8
XFILLER_245_35 VPWR VGND sg13cmos5l_decap_8
XFILLER_99_233 VPWR VGND sg13cmos5l_decap_8
X_4303_ _4303_/X _4305_/X Tile_X0Y4_W6END[1] _4304_/X _4303_/A3 _1931_/Q _1930_/Q
+ VPWR VGND sg13cmos5l_mux4_1
XFILLER_550_198 VPWR VGND sg13cmos5l_decap_8
XFILLER_488_261 VPWR VGND sg13cmos5l_fill_1
XFILLER_302_110 VPWR VGND sg13cmos5l_fill_2
XFILLER_99_244 VPWR VGND sg13cmos5l_fill_1
X_1515_ _1515_/Q Tile_X0Y2_FrameData[6] VGND VPWR Tile_X0Y9_FrameStrobe[2] latch
XFILLER_99_266 VPWR VGND sg13cmos5l_decap_8
X_2495_ _2495_/Q Tile_X0Y6_FrameData[8] VGND VPWR Tile_X0Y9_FrameStrobe[1] latch
XFILLER_392_85 VPWR VGND sg13cmos5l_fill_2
X_4234_ _4234_/X _4195_/X _0089_/X _4194_/X Tile_X0Y0_S4END[12] _1705_/Q _1704_/Q
+ VPWR VGND sg13cmos5l_mux4_1
X_1446_ _1446_/Q Tile_X0Y2_FrameData[11] VGND VPWR Tile_X0Y9_FrameStrobe[0] latch
XFILLER_448_158 VPWR VGND sg13cmos5l_decap_8
XFILLER_302_176 VPWR VGND sg13cmos5l_decap_8
XFILLER_114_28 VPWR VGND sg13cmos5l_decap_8
XFILLER_542_77 VPWR VGND sg13cmos5l_decap_8
X_4165_ _4165_/X Tile_X0Y3_WW4END[14] AXI_M_SOC_BVALID _4215_/X _4206_/X _1811_/Q
+ _1810_/Q VPWR VGND sg13cmos5l_mux4_1
XFILLER_463_128 VPWR VGND sg13cmos5l_fill_2
X_1377_ _1377_/Q Tile_X0Y1_FrameData[24] VGND VPWR Tile_X0Y9_FrameStrobe[6] latch
XANTENNA__3503__X Tile_X0Y1_E2BEGb[1] VPWR VGND sg13cmos5l_antennanp
X_3116_ Tile_X0Y7_EE4BEG[2] _4630_/X VPWR VGND sg13cmos5l_buf_1
X_0328_ _0328_/Q Tile_X0Y7_FrameData[23] VGND VPWR Tile_X0Y9_FrameStrobe[5] latch
X_4096_ _4096_/X _4035_/X _4143_/X _4142_/X _4034_/X _1435_/Q _1434_/Q VPWR VGND sg13cmos5l_mux4_1
XFILLER_67_196 VPWR VGND sg13cmos5l_decap_8
XFILLER_605_166 VPWR VGND sg13cmos5l_decap_8
X_3047_ Tile_X0Y5_FrameData_O[6] Tile_X0Y5_FrameData[6] VPWR VGND sg13cmos5l_buf_1
XFILLER_660_272 VPWR VGND sg13cmos5l_fill_1
XFILLER_404_228 VPWR VGND sg13cmos5l_decap_8
X_0259_ _0259_/Q Tile_X0Y7_FrameData[28] VGND VPWR Tile_X0Y9_FrameStrobe[3] latch
XFILLER_620_114 VPWR VGND sg13cmos5l_decap_8
XFILLER_82_166 VPWR VGND sg13cmos5l_decap_8
XFILLER_698_70 VPWR VGND sg13cmos5l_decap_8
XFILLER_471_194 VPWR VGND sg13cmos5l_decap_8
XFILLER_369_121 VPWR VGND sg13cmos5l_fill_2
XFILLER_130_49 VPWR VGND sg13cmos5l_decap_8
XFILLER_23_222 VPWR VGND sg13cmos5l_fill_1
XFILLER_223_172 VPWR VGND sg13cmos5l_fill_1
XFILLER_412_272 VPWR VGND sg13cmos5l_fill_1
XFILLER_23_255 VPWR VGND sg13cmos5l_decap_8
XFILLER_23_14 VPWR VGND sg13cmos5l_decap_8
XFILLER_384_124 VPWR VGND sg13cmos5l_decap_8
XFILLER_573_224 VPWR VGND sg13cmos5l_decap_8
XFILLER_567_63 VPWR VGND sg13cmos5l_decap_8
XFILLER_139_14 VPWR VGND sg13cmos5l_decap_8
X_3949_ _3949_/X Tile_X0Y1_WW4END[14] AXI_M_SOC_ARREADY _3999_/X _3990_/X _1311_/Q
+ _1310_/Q VPWR VGND sg13cmos5l_mux4_1
XFILLER_183_208 VPWR VGND sg13cmos5l_decap_8
XFILLER_384_168 VPWR VGND sg13cmos5l_fill_2
XFILLER_23_69 VPWR VGND sg13cmos5l_decap_8
XFILLER_573_268 VPWR VGND sg13cmos5l_decap_4
XFILLER_286_42 VPWR VGND sg13cmos5l_decap_8
XFILLER_128_7 VPWR VGND sg13cmos5l_decap_8
XFILLER_136_135 VPWR VGND sg13cmos5l_decap_8
XANTENNA__2789__X Tile_X0Y3_EE4BEG[15] VPWR VGND sg13cmos5l_antennanp
XFILLER_687_103 VPWR VGND sg13cmos5l_decap_4
XFILLER_191_241 VPWR VGND sg13cmos5l_decap_8
XFILLER_191_252 VPWR VGND sg13cmos5l_fill_2
XFILLER_541_143 VPWR VGND sg13cmos5l_decap_8
XFILLER_436_56 VPWR VGND sg13cmos5l_decap_8
XFILLER_155_35 VPWR VGND sg13cmos5l_decap_8
XFILLER_583_84 VPWR VGND sg13cmos5l_decap_8
XFILLER_2_126 VPWR VGND sg13cmos5l_decap_4
XFILLER_479_272 VPWR VGND sg13cmos5l_fill_1
XFILLER_497_7 VPWR VGND sg13cmos5l_decap_8
XFILLER_439_125 VPWR VGND sg13cmos5l_decap_4
XFILLER_695_180 VPWR VGND sg13cmos5l_decap_8
XFILLER_494_242 VPWR VGND sg13cmos5l_decap_8
XFILLER_439_158 VPWR VGND sg13cmos5l_decap_8
XFILLER_305_49 VPWR VGND sg13cmos5l_decap_8
XFILLER_643_217 VPWR VGND sg13cmos5l_decap_8
XFILLER_48_55 VPWR VGND sg13cmos5l_decap_4
XFILLER_664_7 VPWR VGND sg13cmos5l_decap_8
XFILLER_602_14 VPWR VGND sg13cmos5l_decap_8
XFILLER_58_130 VPWR VGND sg13cmos5l_decap_8
XFILLER_48_66 VPWR VGND sg13cmos5l_decap_8
XANTENNA__3413__X Tile_X0Y4_FrameData_O[4] VPWR VGND sg13cmos5l_antennanp
XFILLER_378_4 VPWR VGND sg13cmos5l_fill_1
XFILLER_100_260 VPWR VGND sg13cmos5l_fill_1
XFILLER_171_78 VPWR VGND sg13cmos5l_decap_8
XFILLER_602_58 VPWR VGND sg13cmos5l_fill_1
XFILLER_246_264 VPWR VGND sg13cmos5l_decap_8
XFILLER_73_144 VPWR VGND sg13cmos5l_decap_8
XFILLER_64_21 VPWR VGND sg13cmos5l_decap_8
XFILLER_651_272 VPWR VGND sg13cmos5l_fill_1
XFILLER_321_48 VPWR VGND sg13cmos5l_fill_2
XFILLER_549_210 VPWR VGND sg13cmos5l_decap_8
XFILLER_73_199 VPWR VGND sg13cmos5l_fill_2
XFILLER_261_267 VPWR VGND sg13cmos5l_decap_4
XFILLER_410_209 VPWR VGND sg13cmos5l_decap_8
XFILLER_14_233 VPWR VGND sg13cmos5l_decap_8
XFILLER_154_0 VPWR VGND sg13cmos5l_decap_8
XFILLER_64_98 VPWR VGND sg13cmos5l_decap_8
XFILLER_403_261 VPWR VGND sg13cmos5l_decap_8
XFILLER_214_172 VPWR VGND sg13cmos5l_decap_8
XFILLER_549_254 VPWR VGND sg13cmos5l_decap_8
XFILLER_403_272 VPWR VGND sg13cmos5l_fill_1
XFILLER_14_255 VPWR VGND sg13cmos5l_decap_4
XFILLER_9_49 VPWR VGND sg13cmos5l_decap_8
XFILLER_375_113 VPWR VGND sg13cmos5l_decap_8
XFILLER_694_28 VPWR VGND sg13cmos5l_decap_8
XFILLER_477_63 VPWR VGND sg13cmos5l_decap_4
XFILLER_321_0 VPWR VGND sg13cmos5l_decap_8
XFILLER_196_42 VPWR VGND sg13cmos5l_decap_8
XFILLER_419_0 VPWR VGND sg13cmos5l_decap_8
XFILLER_167_260 VPWR VGND sg13cmos5l_decap_4
XFILLER_706_240 VPWR VGND sg13cmos5l_fill_2
XFILLER_127_113 VPWR VGND sg13cmos5l_decap_8
XFILLER_80_97 VPWR VGND sg13cmos5l_fill_2
XFILLER_517_184 VPWR VGND sg13cmos5l_decap_8
XFILLER_627_77 VPWR VGND sg13cmos5l_decap_8
XFILLER_129_91 VPWR VGND sg13cmos5l_decap_8
XFILLER_346_56 VPWR VGND sg13cmos5l_decap_4
XFILLER_142_105 VPWR VGND sg13cmos5l_decap_8
XFILLER_331_216 VPWR VGND sg13cmos5l_decap_4
XFILLER_532_176 VPWR VGND sg13cmos5l_decap_8
XFILLER_493_84 VPWR VGND sg13cmos5l_decap_8
XFILLER_690_0 VPWR VGND sg13cmos5l_decap_8
XFILLER_643_21 VPWR VGND sg13cmos5l_decap_8
XFILLER_346_89 VPWR VGND sg13cmos5l_decap_8
XFILLER_89_84 VPWR VGND sg13cmos5l_decap_4
XFILLER_135_190 VPWR VGND sg13cmos5l_decap_8
XFILLER_331_249 VPWR VGND sg13cmos5l_fill_1
XFILLER_89_95 VPWR VGND sg13cmos5l_decap_8
XFILLER_693_128 VPWR VGND sg13cmos5l_decap_8
XFILLER_693_139 VPWR VGND sg13cmos5l_fill_1
XFILLER_96_214 VPWR VGND sg13cmos5l_decap_8
X_1300_ _1300_/Q Tile_X0Y1_FrameData[5] VGND VPWR Tile_X0Y9_FrameStrobe[3] latch
XFILLER_686_191 VPWR VGND sg13cmos5l_decap_8
XFILLER_215_49 VPWR VGND sg13cmos5l_decap_8
X_2280_ _2280_/Q Tile_X0Y5_FrameData[29] VGND VPWR Tile_X0Y9_FrameStrobe[3] latch
XFILLER_643_98 VPWR VGND sg13cmos5l_decap_8
XFILLER_296_164 VPWR VGND sg13cmos5l_fill_2
XFILLER_485_264 VPWR VGND sg13cmos5l_fill_1
XFILLER_362_77 VPWR VGND sg13cmos5l_decap_8
X_1231_ _1231_/Q Tile_X0Y1_FrameData[10] VGND VPWR Tile_X0Y9_FrameStrobe[1] latch
XFILLER_512_14 VPWR VGND sg13cmos5l_decap_8
XANTENNA__3323__X Tile_X0Y4_EE4BEG[11] VPWR VGND sg13cmos5l_antennanp
XFILLER_438_191 VPWR VGND sg13cmos5l_decap_8
X_1162_ _1162_/Q Tile_X0Y0_FrameData[1] VGND VPWR Tile_X0Y9_FrameStrobe[6] latch
XFILLER_460_109 VPWR VGND sg13cmos5l_decap_8
XFILLER_237_264 VPWR VGND sg13cmos5l_fill_1
XFILLER_599_143 VPWR VGND sg13cmos5l_fill_1
XFILLER_64_133 VPWR VGND sg13cmos5l_decap_8
XFILLER_599_154 VPWR VGND sg13cmos5l_decap_4
X_0113_ _3185_/A _3908_/X _3909_/X _1396_/Q VPWR VGND sg13cmos5l_mux2_1
X_1093_ _1093_/Q Tile_X0Y0_FrameData[6] VGND VPWR Tile_X0Y9_FrameStrobe[4] latch
X_0044_ _3633_/A _4722_/X _4723_/X _0600_/Q VPWR VGND sg13cmos5l_mux2_1
X_4921_ _4921_/X Tile_X0Y9_N1END[1] Tile_X0Y9_N4END[1] _4897_/X _0082_/X _0717_/Q
+ _0716_/Q VPWR VGND sg13cmos5l_mux4_1
XFILLER_205_183 VPWR VGND sg13cmos5l_decap_8
X_4852_ _4852_/X Tile_X0Y9_W2MID[3] AXI_M_SOC_RDATA4 _4907_/X _4906_/X _0839_/Q _0838_/Q
+ VPWR VGND sg13cmos5l_mux4_1
XFILLER_205_194 VPWR VGND sg13cmos5l_fill_2
XFILLER_668_84 VPWR VGND sg13cmos5l_decap_4
X_3803_ _3803_/X _3851_/X Tile_X0Y0_WW4END[4] Tile_X0Y0_WW4END[5] Tile_X0Y0_S1END[3]
+ _1099_/Q _1098_/Q VPWR VGND sg13cmos5l_mux4_1
XFILLER_366_135 VPWR VGND sg13cmos5l_decap_4
XFILLER_20_236 VPWR VGND sg13cmos5l_decap_8
X_4783_ _4783_/X Tile_X0Y9_W1END[3] Tile_X0Y9_W6END[7] _4931_/X _4895_/X _0921_/Q
+ _0920_/Q VPWR VGND sg13cmos5l_mux4_1
X_1995_ _1995_/Q Tile_X0Y4_FrameData[26] VGND VPWR Tile_X0Y9_FrameStrobe[2] latch
XFILLER_555_257 VPWR VGND sg13cmos5l_decap_8
XFILLER_366_168 VPWR VGND sg13cmos5l_decap_4
XFILLER_158_271 VPWR VGND sg13cmos5l_fill_2
X_3734_ AXI_M_SOC_ARADDR6 Tile_X0Y9_WW4END[6] Tile_X0Y9_WW4END[14] Tile_X0Y9_W6END[6]
+ _4922_/X _0747_/Q _0746_/Q VPWR VGND sg13cmos5l_mux4_1
X_0946_ _0946_/Q Tile_X0Y0_FrameData[25] VGND VPWR Tile_X0Y9_FrameStrobe[0] latch
XFILLER_118_124 VPWR VGND sg13cmos5l_decap_8
XFILLER_684_61 VPWR VGND sg13cmos5l_decap_8
XFILLER_307_224 VPWR VGND sg13cmos5l_decap_8
XFILLER_570_238 VPWR VGND sg13cmos5l_decap_8
XFILLER_508_184 VPWR VGND sg13cmos5l_decap_4
XFILLER_712_210 VPWR VGND sg13cmos5l_decap_8
X_3665_ AXI_M_SOC_AWADDR26 Tile_X0Y4_WW4END[2] Tile_X0Y4_WW4END[10] Tile_X0Y4_W6END[10]
+ _4346_/X _1993_/Q _1992_/Q VPWR VGND sg13cmos5l_mux4_1
XFILLER_669_114 VPWR VGND sg13cmos5l_decap_8
X_0877_ _0877_/Q Tile_X0Y9_FrameData[18] VGND VPWR Tile_X0Y9_FrameStrobe[6] latch
XFILLER_523_132 VPWR VGND sg13cmos5l_decap_8
XFILLER_133_105 VPWR VGND sg13cmos5l_decap_8
XFILLER_133_116 VPWR VGND sg13cmos5l_fill_2
X_2616_ _2616_/Q Tile_X0Y6_FrameData[15] VGND VPWR Tile_X0Y9_FrameStrobe[5] latch
X_3596_ Tile_X0Y9_FrameData_O[26] Tile_X0Y9_FrameData[26] VPWR VGND sg13cmos5l_buf_1
XFILLER_468_209 VPWR VGND sg13cmos5l_decap_8
XFILLER_553_21 VPWR VGND sg13cmos5l_decap_8
X_2547_ _2547_/Q Tile_X0Y6_FrameData[20] VGND VPWR Tile_X0Y9_FrameStrobe[3] latch
XFILLER_476_231 VPWR VGND sg13cmos5l_decap_8
XFILLER_125_49 VPWR VGND sg13cmos5l_decap_8
X_2478_ _2478_/Q Tile_X0Y6_FrameData[25] VGND VPWR Tile_X0Y9_FrameStrobe[1] latch
XFILLER_141_193 VPWR VGND sg13cmos5l_decap_8
XFILLER_703_35 VPWR VGND sg13cmos5l_decap_8
XFILLER_692_150 VPWR VGND sg13cmos5l_decap_8
XFILLER_287_175 VPWR VGND sg13cmos5l_decap_8
XFILLER_625_206 VPWR VGND sg13cmos5l_fill_2
X_4217_ _4217_/X _4689_/X _4693_/X _4697_/X _4671_/X _0388_/Q _0387_/Q VPWR VGND sg13cmos5l_mux4_1
XFILLER_272_77 VPWR VGND sg13cmos5l_decap_8
X_1429_ _1429_/Q Tile_X0Y2_FrameData[28] VGND VPWR Tile_X0Y9_FrameStrobe[0] latch
XFILLER_422_14 VPWR VGND sg13cmos5l_decap_8
XANTENNA__3233__X Tile_X0Y0_FrameData_O[1] VPWR VGND sg13cmos5l_antennanp
XFILLER_18_14 VPWR VGND sg13cmos5l_decap_8
X_4148_ _4148_/X Tile_X0Y3_W2MID[7] AXI_M_SOC_WREADY _4205_/X _4204_/X _1845_/Q _1844_/Q
+ VPWR VGND sg13cmos5l_mux4_1
XFILLER_55_111 VPWR VGND sg13cmos5l_decap_8
XFILLER_444_183 VPWR VGND sg13cmos5l_decap_8
X_4079_ _4079_/X AXI_M_SOC_AWREADY _4120_/X _4124_/X _4103_/X _1515_/Q _1514_/Q VPWR
+ VGND sg13cmos5l_mux4_1
XFILLER_389_227 VPWR VGND sg13cmos5l_fill_1
XFILLER_502_91 VPWR VGND sg13cmos5l_decap_8
XFILLER_243_256 VPWR VGND sg13cmos5l_fill_2
XFILLER_389_249 VPWR VGND sg13cmos5l_decap_8
XFILLER_70_158 VPWR VGND sg13cmos5l_decap_8
XFILLER_34_35 VPWR VGND sg13cmos5l_decap_8
XFILLER_397_260 VPWR VGND sg13cmos5l_decap_8
XFILLER_397_271 VPWR VGND sg13cmos5l_fill_2
XFILLER_245_7 VPWR VGND sg13cmos5l_decap_8
XFILLER_578_84 VPWR VGND sg13cmos5l_decap_8
XFILLER_11_203 VPWR VGND sg13cmos5l_decap_8
XFILLER_400_253 VPWR VGND sg13cmos5l_decap_8
XFILLER_211_175 VPWR VGND sg13cmos5l_decap_8
XFILLER_357_168 VPWR VGND sg13cmos5l_decap_8
XFILLER_297_85 VPWR VGND sg13cmos5l_fill_2
XFILLER_546_268 VPWR VGND sg13cmos5l_decap_4
XFILLER_149_271 VPWR VGND sg13cmos5l_fill_2
XFILLER_50_56 VPWR VGND sg13cmos5l_decap_8
XFILLER_365_190 VPWR VGND sg13cmos5l_decap_8
XFILLER_164_241 VPWR VGND sg13cmos5l_fill_2
XFILLER_50_78 VPWR VGND sg13cmos5l_decap_8
XANTENNA__3408__X Tile_X0Y2_E1BEG[3] VPWR VGND sg13cmos5l_antennanp
XFILLER_124_105 VPWR VGND sg13cmos5l_decap_8
XFILLER_514_154 VPWR VGND sg13cmos5l_decap_8
XFILLER_313_216 VPWR VGND sg13cmos5l_decap_8
XFILLER_463_21 VPWR VGND sg13cmos5l_decap_8
XFILLER_380_182 VPWR VGND sg13cmos5l_decap_8
XFILLER_675_117 VPWR VGND sg13cmos5l_decap_8
XFILLER_316_59 VPWR VGND sg13cmos5l_decap_8
XFILLER_278_131 VPWR VGND sg13cmos5l_decap_8
XFILLER_182_22 VPWR VGND sg13cmos5l_decap_8
XFILLER_278_153 VPWR VGND sg13cmos5l_decap_8
XFILLER_59_76 VPWR VGND sg13cmos5l_decap_8
XFILLER_613_35 VPWR VGND sg13cmos5l_decap_8
XFILLER_278_175 VPWR VGND sg13cmos5l_decap_8
XFILLER_616_217 VPWR VGND sg13cmos5l_decap_8
XFILLER_78_269 VPWR VGND sg13cmos5l_decap_4
XFILLER_616_228 VPWR VGND sg13cmos5l_fill_1
XFILLER_332_14 VPWR VGND sg13cmos5l_decap_8
XFILLER_293_134 VPWR VGND sg13cmos5l_decap_8
XANTENNA__3143__X Tile_X0Y7_FrameData_O[13] VPWR VGND sg13cmos5l_antennanp
XFILLER_689_28 VPWR VGND sg13cmos5l_decap_8
XFILLER_46_111 VPWR VGND sg13cmos5l_fill_2
XFILLER_435_161 VPWR VGND sg13cmos5l_decap_8
XFILLER_271_0 VPWR VGND sg13cmos5l_decap_8
XFILLER_234_212 VPWR VGND sg13cmos5l_fill_2
XANTENNA__2982__X Tile_X0Y8_FrameData_O[22] VPWR VGND sg13cmos5l_antennanp
XFILLER_624_272 VPWR VGND sg13cmos5l_fill_1
XFILLER_369_0 VPWR VGND sg13cmos5l_decap_8
XFILLER_412_80 VPWR VGND sg13cmos5l_fill_1
XFILLER_596_124 VPWR VGND sg13cmos5l_decap_8
XFILLER_61_147 VPWR VGND sg13cmos5l_decap_8
XFILLER_131_92 VPWR VGND sg13cmos5l_decap_4
XFILLER_536_0 VPWR VGND sg13cmos5l_decap_8
XFILLER_199_182 VPWR VGND sg13cmos5l_decap_8
XFILLER_638_21 VPWR VGND sg13cmos5l_decap_8
XFILLER_348_135 VPWR VGND sg13cmos5l_fill_1
XFILLER_91_96 VPWR VGND sg13cmos5l_decap_8
XFILLER_703_0 VPWR VGND sg13cmos5l_decap_8
XFILLER_348_168 VPWR VGND sg13cmos5l_decap_8
X_0800_ _0800_/Q Tile_X0Y9_FrameData[31] VGND VPWR Tile_X0Y9_FrameStrobe[4] latch
X_1780_ _1780_/Q Tile_X0Y3_FrameData[21] VGND VPWR Tile_X0Y9_FrameStrobe[3] latch
XFILLER_638_98 VPWR VGND sg13cmos5l_decap_8
XFILLER_552_227 VPWR VGND sg13cmos5l_decap_8
X_0731_ _0731_/Q Tile_X0Y9_FrameData[4] VGND VPWR Tile_X0Y9_FrameStrobe[1] latch
XFILLER_357_77 VPWR VGND sg13cmos5l_decap_8
XFILLER_507_14 VPWR VGND sg13cmos5l_decap_8
XFILLER_505_143 VPWR VGND sg13cmos5l_decap_8
XANTENNA__3318__X Tile_X0Y4_EE4BEG[6] VPWR VGND sg13cmos5l_antennanp
XFILLER_654_42 VPWR VGND sg13cmos5l_fill_2
X_3450_ Tile_X0Y1_FrameData_O[8] Tile_X0Y1_FrameData[8] VPWR VGND sg13cmos5l_buf_1
X_0662_ _0662_/Q Tile_X0Y8_FrameData[9] VGND VPWR Tile_X0Y9_FrameStrobe[7] latch
XFILLER_560_271 VPWR VGND sg13cmos5l_fill_2
XFILLER_520_113 VPWR VGND sg13cmos5l_decap_8
XFILLER_373_21 VPWR VGND sg13cmos5l_decap_8
XFILLER_304_227 VPWR VGND sg13cmos5l_decap_8
X_2401_ _2401_/Q Tile_X0Y5_FrameData[4] VGND VPWR Tile_X0Y9_FrameStrobe[6] latch
XFILLER_654_97 VPWR VGND sg13cmos5l_decap_8
X_3381_ Tile_X0Y2_E6BEG[4] _4076_/X VPWR VGND sg13cmos5l_buf_1
XFILLER_269_120 VPWR VGND sg13cmos5l_fill_1
X_0593_ _0593_/Q Tile_X0Y8_FrameData[14] VGND VPWR Tile_X0Y9_FrameStrobe[5] latch
XFILLER_130_119 VPWR VGND sg13cmos5l_decap_8
XFILLER_69_203 VPWR VGND sg13cmos5l_decap_8
XFILLER_373_76 VPWR VGND sg13cmos5l_decap_8
XFILLER_269_131 VPWR VGND sg13cmos5l_decap_8
XFILLER_520_168 VPWR VGND sg13cmos5l_decap_4
X_2332_ _2332_/Q Tile_X0Y5_FrameData[9] VGND VPWR Tile_X0Y9_FrameStrobe[4] latch
XFILLER_520_179 VPWR VGND sg13cmos5l_decap_8
XFILLER_123_182 VPWR VGND sg13cmos5l_decap_8
XFILLER_681_109 VPWR VGND sg13cmos5l_decap_8
XFILLER_523_35 VPWR VGND sg13cmos5l_decap_8
XFILLER_284_112 VPWR VGND sg13cmos5l_decap_8
XFILLER_670_63 VPWR VGND sg13cmos5l_fill_2
X_2263_ _2263_/Q Tile_X0Y5_FrameData[14] VGND VPWR Tile_X0Y9_FrameStrobe[2] latch
XFILLER_473_223 VPWR VGND sg13cmos5l_decap_8
XFILLER_242_14 VPWR VGND sg13cmos5l_decap_8
XANTENNA__3053__X Tile_X0Y5_FrameData_O[12] VPWR VGND sg13cmos5l_antennanp
XFILLER_84_206 VPWR VGND sg13cmos5l_decap_4
X_4002_ _4002_/X _3983_/X _0096_/X _3982_/X Tile_X0Y0_S4END[5] _1207_/Q _1206_/Q VPWR
+ VGND sg13cmos5l_mux4_1
X_1214_ _1214_/Q Tile_X0Y1_FrameData[27] VGND VPWR Tile_X0Y9_FrameStrobe[1] latch
XFILLER_599_28 VPWR VGND sg13cmos5l_decap_8
XFILLER_242_58 VPWR VGND sg13cmos5l_fill_1
X_2194_ _2194_/Q Tile_X0Y5_FrameData[19] VGND VPWR Tile_X0Y9_FrameStrobe[0] latch
XFILLER_284_189 VPWR VGND sg13cmos5l_decap_8
XFILLER_426_161 VPWR VGND sg13cmos5l_decap_8
XANTENNA__2892__X Tile_X0Y6_FrameData_O[13] VPWR VGND sg13cmos5l_antennanp
XFILLER_225_223 VPWR VGND sg13cmos5l_decap_8
XFILLER_615_272 VPWR VGND sg13cmos5l_fill_1
XFILLER_92_250 VPWR VGND sg13cmos5l_decap_8
X_1145_ _1145_/Q Tile_X0Y0_FrameData[18] VGND VPWR Tile_X0Y9_FrameStrobe[6] latch
XFILLER_441_131 VPWR VGND sg13cmos5l_decap_8
XFILLER_52_114 VPWR VGND sg13cmos5l_fill_2
X_1076_ _1076_/Q Tile_X0Y0_FrameData[23] VGND VPWR Tile_X0Y9_FrameStrobe[4] latch
XFILLER_386_208 VPWR VGND sg13cmos5l_decap_8
X_4904_ _4904_/X Tile_X0Y9_N2MID[5] Tile_X0Y9_N2END[5] _4937_/X _4821_/X _0685_/Q
+ _0684_/Q VPWR VGND sg13cmos5l_mux4_1
XFILLER_528_202 VPWR VGND sg13cmos5l_decap_8
XFILLER_548_21 VPWR VGND sg13cmos5l_decap_8
X_4835_ _4835_/X Tile_X0Y9_W1END[3] Tile_X0Y9_W2MID[0] Tile_X0Y9_W2END[0] _4900_/X
+ _0869_/Q _0868_/Q VPWR VGND sg13cmos5l_mux4_1
XFILLER_528_257 VPWR VGND sg13cmos5l_decap_4
XFILLER_528_268 VPWR VGND sg13cmos5l_decap_4
XFILLER_339_168 VPWR VGND sg13cmos5l_decap_8
XFILLER_354_105 VPWR VGND sg13cmos5l_decap_8
X_4766_ _4766_/X AXI_M_SOC_RDATA10 _4805_/X _4809_/X _4789_/X _0515_/Q _0514_/Q VPWR
+ VGND sg13cmos5l_mux4_1
XFILLER_548_98 VPWR VGND sg13cmos5l_fill_2
X_1978_ _1978_/Q Tile_X0Y4_FrameData[11] VGND VPWR Tile_X0Y9_FrameStrobe[1] latch
XFILLER_146_230 VPWR VGND sg13cmos5l_decap_4
X_3717_ AXI_M_SOC_WDATA27 Tile_X0Y6_WW4END[3] Tile_X0Y6_WW4END[11] Tile_X0Y6_W6END[11]
+ _4579_/X _2505_/Q _2504_/Q VPWR VGND sg13cmos5l_mux4_1
XFILLER_267_77 VPWR VGND sg13cmos5l_decap_8
X_0929_ _0929_/Q Tile_X0Y9_FrameData[20] VGND VPWR Tile_X0Y9_FrameStrobe[8] latch
XFILLER_417_14 VPWR VGND sg13cmos5l_decap_8
X_4697_ _4697_/X _4663_/X Tile_X0Y9_N4END[9] _4662_/X _0055_/X _0189_/Q _0188_/Q VPWR
+ VGND sg13cmos5l_mux4_1
XANTENNA__3228__X Tile_X0Y0_FrameStrobe_O[16] VPWR VGND sg13cmos5l_antennanp
XFILLER_564_42 VPWR VGND sg13cmos5l_decap_8
XFILLER_106_127 VPWR VGND sg13cmos5l_decap_8
X_3648_ AXI_M_SOC_AWADDR9 Tile_X0Y5_WW4END[1] Tile_X0Y5_WW4END[9] Tile_X0Y5_W6END[9]
+ _4460_/X _2253_/Q _2252_/Q VPWR VGND sg13cmos5l_mux4_1
XFILLER_697_253 VPWR VGND sg13cmos5l_decap_8
XFILLER_700_213 VPWR VGND sg13cmos5l_decap_8
XFILLER_283_21 VPWR VGND sg13cmos5l_decap_8
XFILLER_362_193 VPWR VGND sg13cmos5l_decap_8
XFILLER_161_266 VPWR VGND sg13cmos5l_decap_8
X_3579_ Tile_X0Y9_FrameData_O[9] Tile_X0Y9_FrameData[9] VPWR VGND sg13cmos5l_buf_1
XFILLER_714_56 VPWR VGND sg13cmos5l_decap_8
XFILLER_700_268 VPWR VGND sg13cmos5l_decap_4
XFILLER_283_98 VPWR VGND sg13cmos5l_decap_8
XFILLER_433_35 VPWR VGND sg13cmos5l_decap_8
XFILLER_216_92 VPWR VGND sg13cmos5l_fill_1
XFILLER_580_63 VPWR VGND sg13cmos5l_decap_8
XFILLER_29_35 VPWR VGND sg13cmos5l_decap_8
XFILLER_152_14 VPWR VGND sg13cmos5l_decap_8
XFILLER_195_7 VPWR VGND sg13cmos5l_decap_8
XFILLER_464_234 VPWR VGND sg13cmos5l_decap_4
XFILLER_29_57 VPWR VGND sg13cmos5l_fill_2
XFILLER_275_156 VPWR VGND sg13cmos5l_decap_8
XFILLER_75_239 VPWR VGND sg13cmos5l_fill_1
XFILLER_680_164 VPWR VGND sg13cmos5l_fill_2
XFILLER_606_272 VPWR VGND sg13cmos5l_fill_1
XFILLER_362_7 VPWR VGND sg13cmos5l_decap_8
XFILLER_302_28 VPWR VGND sg13cmos5l_decap_8
XFILLER_28_166 VPWR VGND sg13cmos5l_decap_8
XFILLER_216_245 VPWR VGND sg13cmos5l_decap_4
XFILLER_45_23 VPWR VGND sg13cmos5l_decap_8
XFILLER_83_272 VPWR VGND sg13cmos5l_fill_1
XFILLER_232_91 VPWR VGND sg13cmos5l_decap_8
XFILLER_43_114 VPWR VGND sg13cmos5l_decap_8
XFILLER_621_253 VPWR VGND sg13cmos5l_decap_8
XFILLER_432_175 VPWR VGND sg13cmos5l_decap_8
XFILLER_578_168 VPWR VGND sg13cmos5l_fill_1
XFILLER_578_179 VPWR VGND sg13cmos5l_decap_8
XFILLER_627_7 VPWR VGND sg13cmos5l_decap_8
XFILLER_231_248 VPWR VGND sg13cmos5l_decap_8
XFILLER_231_259 VPWR VGND sg13cmos5l_fill_2
XFILLER_458_21 VPWR VGND sg13cmos5l_decap_8
XFILLER_593_138 VPWR VGND sg13cmos5l_decap_8
XFILLER_519_224 VPWR VGND sg13cmos5l_decap_8
XFILLER_593_149 VPWR VGND sg13cmos5l_fill_1
XFILLER_519_235 VPWR VGND sg13cmos5l_fill_1
XFILLER_101_84 VPWR VGND sg13cmos5l_decap_8
XFILLER_51_191 VPWR VGND sg13cmos5l_decap_8
XFILLER_196_163 VPWR VGND sg13cmos5l_decap_8
XFILLER_177_22 VPWR VGND sg13cmos5l_fill_2
XFILLER_61_77 VPWR VGND sg13cmos5l_decap_8
XFILLER_345_127 VPWR VGND sg13cmos5l_decap_8
XFILLER_608_35 VPWR VGND sg13cmos5l_decap_8
XFILLER_345_138 VPWR VGND sg13cmos5l_fill_1
XFILLER_177_88 VPWR VGND sg13cmos5l_decap_8
XFILLER_6_28 VPWR VGND sg13cmos5l_decap_8
XANTENNA__3138__X Tile_X0Y7_FrameData_O[8] VPWR VGND sg13cmos5l_antennanp
XFILLER_688_220 VPWR VGND sg13cmos5l_decap_8
XFILLER_117_0 VPWR VGND sg13cmos5l_decap_8
XFILLER_474_42 VPWR VGND sg13cmos5l_decap_8
XFILLER_327_36 VPWR VGND sg13cmos5l_decap_8
XFILLER_360_119 VPWR VGND sg13cmos5l_decap_4
XFILLER_327_47 VPWR VGND sg13cmos5l_fill_2
XFILLER_193_21 VPWR VGND sg13cmos5l_decap_8
XFILLER_353_182 VPWR VGND sg13cmos5l_decap_8
XFILLER_499_175 VPWR VGND sg13cmos5l_decap_8
XFILLER_3_232 VPWR VGND sg13cmos5l_decap_8
XANTENNA__2977__X Tile_X0Y8_FrameData_O[17] VPWR VGND sg13cmos5l_antennanp
XFILLER_3_243 VPWR VGND sg13cmos5l_fill_2
XFILLER_301_208 VPWR VGND sg13cmos5l_fill_2
XFILLER_10_70 VPWR VGND sg13cmos5l_decap_8
XFILLER_112_119 VPWR VGND sg13cmos5l_fill_1
XFILLER_624_56 VPWR VGND sg13cmos5l_decap_8
XFILLER_502_168 VPWR VGND sg13cmos5l_decap_8
XFILLER_407_91 VPWR VGND sg13cmos5l_fill_2
XFILLER_10_81 VPWR VGND sg13cmos5l_fill_1
XFILLER_126_70 VPWR VGND sg13cmos5l_decap_8
XFILLER_343_35 VPWR VGND sg13cmos5l_decap_8
XFILLER_486_0 VPWR VGND sg13cmos5l_decap_8
XFILLER_455_212 VPWR VGND sg13cmos5l_decap_8
XFILLER_490_63 VPWR VGND sg13cmos5l_decap_8
XFILLER_86_63 VPWR VGND sg13cmos5l_decap_8
XFILLER_66_217 VPWR VGND sg13cmos5l_decap_4
XFILLER_120_185 VPWR VGND sg13cmos5l_decap_8
XFILLER_671_142 VPWR VGND sg13cmos5l_fill_2
XFILLER_66_239 VPWR VGND sg13cmos5l_decap_8
XFILLER_19_122 VPWR VGND sg13cmos5l_decap_4
XFILLER_207_201 VPWR VGND sg13cmos5l_decap_8
XFILLER_653_0 VPWR VGND sg13cmos5l_decap_8
XFILLER_281_126 VPWR VGND sg13cmos5l_decap_8
XFILLER_19_155 VPWR VGND sg13cmos5l_decap_8
XFILLER_212_28 VPWR VGND sg13cmos5l_decap_8
XFILLER_640_77 VPWR VGND sg13cmos5l_decap_8
XANTENNA__3601__X Tile_X0Y9_FrameData_O[31] VPWR VGND sg13cmos5l_antennanp
XFILLER_142_91 VPWR VGND sg13cmos5l_decap_8
XFILLER_222_204 VPWR VGND sg13cmos5l_fill_2
XFILLER_569_168 VPWR VGND sg13cmos5l_decap_8
XFILLER_649_42 VPWR VGND sg13cmos5l_decap_8
XFILLER_584_105 VPWR VGND sg13cmos5l_decap_8
X_2950_ Tile_X0Y8_EE4BEG[6] _4750_/X VPWR VGND sg13cmos5l_buf_1
XFILLER_423_197 VPWR VGND sg13cmos5l_decap_8
X_1901_ _1901_/Q Tile_X0Y3_FrameData[28] VGND VPWR Tile_X0Y9_FrameStrobe[7] latch
XFILLER_368_43 VPWR VGND sg13cmos5l_decap_8
X_2881_ Tile_X0Y6_FrameData_O[2] Tile_X0Y6_FrameData[2] VPWR VGND sg13cmos5l_buf_1
XFILLER_376_263 VPWR VGND sg13cmos5l_fill_2
X_4620_ _4620_/X Tile_X0Y7_W2END[7] AXI_M_SOC_RDATA23 _4669_/X _4668_/X _0319_/Q _0318_/Q
+ VPWR VGND sg13cmos5l_mux4_1
X_1832_ _1832_/Q Tile_X0Y3_FrameData[1] VGND VPWR Tile_X0Y9_FrameStrobe[4] latch
XFILLER_518_35 VPWR VGND sg13cmos5l_decap_8
XFILLER_525_238 VPWR VGND sg13cmos5l_decap_8
XFILLER_336_138 VPWR VGND sg13cmos5l_fill_2
XFILLER_128_241 VPWR VGND sg13cmos5l_decap_4
X_4551_ _4551_/X Tile_X0Y7_W1END[3] Tile_X0Y7_W6END[7] _4699_/X _4659_/X _0409_/Q
+ _0408_/Q VPWR VGND sg13cmos5l_mux4_1
XFILLER_665_63 VPWR VGND sg13cmos5l_decap_8
X_1763_ _1763_/Q Tile_X0Y3_FrameData[6] VGND VPWR Tile_X0Y9_FrameStrobe[2] latch
XFILLER_237_14 VPWR VGND sg13cmos5l_decap_8
XFILLER_391_266 VPWR VGND sg13cmos5l_decap_8
XANTENNA__3048__X Tile_X0Y5_FrameData_O[7] VPWR VGND sg13cmos5l_antennanp
X_3502_ Tile_X0Y1_E2BEGb[0] _3940_/X VPWR VGND sg13cmos5l_buf_1
XFILLER_540_219 VPWR VGND sg13cmos5l_decap_8
XFILLER_384_42 VPWR VGND sg13cmos5l_decap_4
XFILLER_351_119 VPWR VGND sg13cmos5l_decap_8
X_0714_ _0714_/Q Tile_X0Y9_FrameData[21] VGND VPWR Tile_X0Y9_FrameStrobe[1] latch
X_4482_ _4482_/X Tile_X0Y4_W1END[3] Tile_X0Y4_W2MID[0] Tile_X0Y4_W2END[0] _4312_/X
+ _2123_/Q _2122_/Q VPWR VGND sg13cmos5l_mux4_1
X_1694_ _1694_/Q Tile_X0Y3_FrameData[11] VGND VPWR Tile_X0Y9_FrameStrobe[0] latch
XFILLER_344_182 VPWR VGND sg13cmos5l_decap_8
XFILLER_289_226 VPWR VGND sg13cmos5l_decap_8
XANTENNA__2887__X Tile_X0Y6_FrameData_O[8] VPWR VGND sg13cmos5l_antennanp
X_3433_ Tile_X0Y4_FrameData_O[24] Tile_X0Y4_FrameData[24] VPWR VGND sg13cmos5l_buf_1
XFILLER_694_212 VPWR VGND sg13cmos5l_decap_8
X_0645_ _0645_/Q Tile_X0Y8_FrameData[26] VGND VPWR Tile_X0Y9_FrameStrobe[7] latch
XFILLER_289_248 VPWR VGND sg13cmos5l_decap_4
XFILLER_103_119 VPWR VGND sg13cmos5l_decap_8
XFILLER_681_51 VPWR VGND sg13cmos5l_decap_8
XFILLER_534_56 VPWR VGND sg13cmos5l_decap_8
X_3364_ Tile_X0Y2_EE4BEG[3] _4059_/X VPWR VGND sg13cmos5l_buf_1
XFILLER_106_29 VPWR VGND sg13cmos5l_decap_8
X_0576_ _0576_/Q Tile_X0Y8_FrameData[31] VGND VPWR Tile_X0Y9_FrameStrobe[5] latch
XFILLER_32_0 VPWR VGND sg13cmos5l_decap_8
XFILLER_253_35 VPWR VGND sg13cmos5l_decap_8
XFILLER_647_161 VPWR VGND sg13cmos5l_decap_8
X_2315_ _2315_/Q Tile_X0Y5_FrameData[26] VGND VPWR Tile_X0Y9_FrameStrobe[4] latch
X_3295_ Tile_X0Y0_E2BEGb[3] _3815_/X VPWR VGND sg13cmos5l_buf_1
XFILLER_111_174 VPWR VGND sg13cmos5l_decap_8
XFILLER_446_256 VPWR VGND sg13cmos5l_decap_8
X_2246_ _2246_/Q Tile_X0Y5_FrameData[31] VGND VPWR Tile_X0Y9_FrameStrobe[2] latch
XFILLER_272_104 VPWR VGND sg13cmos5l_fill_2
XFILLER_461_204 VPWR VGND sg13cmos5l_decap_8
XFILLER_550_77 VPWR VGND sg13cmos5l_decap_8
XFILLER_122_28 VPWR VGND sg13cmos5l_decap_8
XFILLER_700_14 VPWR VGND sg13cmos5l_decap_8
XFILLER_662_197 VPWR VGND sg13cmos5l_decap_4
X_2177_ _2177_/Q Tile_X0Y4_FrameData[4] VGND VPWR Tile_X0Y9_FrameStrobe[7] latch
XANTENNA__3511__X Tile_X0Y1_E2BEG[1] VPWR VGND sg13cmos5l_antennanp
XFILLER_25_103 VPWR VGND sg13cmos5l_decap_4
XFILLER_213_204 VPWR VGND sg13cmos5l_decap_8
X_1128_ _1128_/Q Tile_X0Y0_FrameData[3] VGND VPWR Tile_X0Y9_FrameStrobe[5] latch
XFILLER_603_264 VPWR VGND sg13cmos5l_decap_8
XFILLER_559_42 VPWR VGND sg13cmos5l_decap_8
XFILLER_575_105 VPWR VGND sg13cmos5l_decap_8
X_1059_ _1059_/Q Tile_X0Y0_FrameData[8] VGND VPWR Tile_X0Y9_FrameStrobe[3] latch
XFILLER_278_21 VPWR VGND sg13cmos5l_decap_8
XFILLER_178_141 VPWR VGND sg13cmos5l_decap_8
XFILLER_367_230 VPWR VGND sg13cmos5l_decap_8
XFILLER_33_191 VPWR VGND sg13cmos5l_decap_8
XFILLER_590_108 VPWR VGND sg13cmos5l_decap_4
XFILLER_193_100 VPWR VGND sg13cmos5l_decap_8
XFILLER_709_56 VPWR VGND sg13cmos5l_decap_8
XFILLER_717_165 VPWR VGND sg13cmos5l_decap_4
XFILLER_516_205 VPWR VGND sg13cmos5l_fill_2
X_4818_ _4818_/X Tile_X0Y7_W2MID[5] Tile_X0Y7_W2END[5] Tile_X0Y7_W6END[10] _4673_/X
+ _0367_/Q _0366_/Q VPWR VGND sg13cmos5l_mux4_1
XFILLER_278_98 VPWR VGND sg13cmos5l_decap_8
XFILLER_327_127 VPWR VGND sg13cmos5l_decap_8
XFILLER_31_14 VPWR VGND sg13cmos5l_decap_8
XFILLER_428_35 VPWR VGND sg13cmos5l_decap_8
XFILLER_382_244 VPWR VGND sg13cmos5l_decap_8
XFILLER_147_14 VPWR VGND sg13cmos5l_decap_8
XFILLER_575_63 VPWR VGND sg13cmos5l_decap_8
XFILLER_382_255 VPWR VGND sg13cmos5l_fill_2
X_4749_ _4749_/X Tile_X0Y8_WW4END[10] AXI_M_SOC_RDATA13 _4810_/X _4789_/X _0549_/Q
+ _0548_/Q VPWR VGND sg13cmos5l_mux4_1
XFILLER_294_42 VPWR VGND sg13cmos5l_decap_8
XFILLER_110_7 VPWR VGND sg13cmos5l_decap_8
XFILLER_524_260 VPWR VGND sg13cmos5l_decap_4
XFILLER_208_7 VPWR VGND sg13cmos5l_decap_8
XFILLER_134_233 VPWR VGND sg13cmos5l_decap_8
XFILLER_496_112 VPWR VGND sg13cmos5l_decap_8
XANTENNA__2797__X Tile_X0Y3_E6BEG[7] VPWR VGND sg13cmos5l_antennanp
XFILLER_444_56 VPWR VGND sg13cmos5l_decap_8
XFILLER_350_174 VPWR VGND sg13cmos5l_decap_8
XFILLER_295_207 VPWR VGND sg13cmos5l_fill_1
XFILLER_0_224 VPWR VGND sg13cmos5l_decap_8
XFILLER_496_189 VPWR VGND sg13cmos5l_decap_8
XFILLER_638_161 VPWR VGND sg13cmos5l_decap_8
XFILLER_163_57 VPWR VGND sg13cmos5l_fill_1
XFILLER_0_257 VPWR VGND sg13cmos5l_decap_4
XFILLER_163_68 VPWR VGND sg13cmos5l_decap_4
XFILLER_577_7 VPWR VGND sg13cmos5l_decap_8
XFILLER_48_206 VPWR VGND sg13cmos5l_decap_8
XFILLER_248_134 VPWR VGND sg13cmos5l_decap_8
XFILLER_102_163 VPWR VGND sg13cmos5l_decap_8
XFILLER_248_189 VPWR VGND sg13cmos5l_decap_8
XFILLER_63_209 VPWR VGND sg13cmos5l_decap_8
XFILLER_460_88 VPWR VGND sg13cmos5l_decap_8
XFILLER_610_14 VPWR VGND sg13cmos5l_decap_8
XANTENNA__3421__X Tile_X0Y4_FrameData_O[12] VPWR VGND sg13cmos5l_antennanp
XFILLER_56_88 VPWR VGND sg13cmos5l_decap_8
XFILLER_56_272 VPWR VGND sg13cmos5l_fill_1
XFILLER_204_204 VPWR VGND sg13cmos5l_fill_2
XFILLER_71_242 VPWR VGND sg13cmos5l_decap_8
XFILLER_460_270 VPWR VGND sg13cmos5l_fill_2
XFILLER_112_72 VPWR VGND sg13cmos5l_decap_8
XFILLER_16_158 VPWR VGND sg13cmos5l_decap_8
XFILLER_72_21 VPWR VGND sg13cmos5l_decap_8
XFILLER_420_112 VPWR VGND sg13cmos5l_decap_8
XFILLER_566_105 VPWR VGND sg13cmos5l_decap_8
XFILLER_469_42 VPWR VGND sg13cmos5l_decap_4
XFILLER_204_248 VPWR VGND sg13cmos5l_decap_8
XFILLER_188_21 VPWR VGND sg13cmos5l_decap_8
XFILLER_72_87 VPWR VGND sg13cmos5l_fill_1
XFILLER_358_252 VPWR VGND sg13cmos5l_decap_4
XFILLER_358_263 VPWR VGND sg13cmos5l_decap_8
XFILLER_234_0 VPWR VGND sg13cmos5l_decap_8
XFILLER_619_56 VPWR VGND sg13cmos5l_decap_8
XFILLER_581_119 VPWR VGND sg13cmos5l_decap_8
XFILLER_373_200 VPWR VGND sg13cmos5l_decap_8
XFILLER_318_105 VPWR VGND sg13cmos5l_decap_8
XFILLER_507_216 VPWR VGND sg13cmos5l_decap_8
XFILLER_169_196 VPWR VGND sg13cmos5l_decap_8
XFILLER_188_98 VPWR VGND sg13cmos5l_fill_2
XFILLER_574_182 VPWR VGND sg13cmos5l_decap_8
XFILLER_338_35 VPWR VGND sg13cmos5l_decap_8
XFILLER_338_46 VPWR VGND sg13cmos5l_fill_2
XFILLER_184_155 VPWR VGND sg13cmos5l_decap_8
XFILLER_485_63 VPWR VGND sg13cmos5l_decap_8
XFILLER_338_57 VPWR VGND sg13cmos5l_fill_1
XFILLER_401_0 VPWR VGND sg13cmos5l_decap_4
XFILLER_338_79 VPWR VGND sg13cmos5l_decap_8
XFILLER_333_108 VPWR VGND sg13cmos5l_decap_8
XFILLER_326_160 VPWR VGND sg13cmos5l_decap_8
XFILLER_487_101 VPWR VGND sg13cmos5l_decap_8
XFILLER_207_28 VPWR VGND sg13cmos5l_decap_8
XFILLER_635_77 VPWR VGND sg13cmos5l_decap_8
XFILLER_140_203 VPWR VGND sg13cmos5l_decap_8
XFILLER_98_117 VPWR VGND sg13cmos5l_decap_4
XFILLER_354_56 VPWR VGND sg13cmos5l_decap_8
XFILLER_137_91 VPWR VGND sg13cmos5l_decap_8
X_0430_ _0430_/Q Tile_X0Y8_FrameData[17] VGND VPWR Tile_X0Y9_FrameStrobe[0] latch
XFILLER_97_73 VPWR VGND sg13cmos5l_decap_8
XFILLER_140_258 VPWR VGND sg13cmos5l_decap_8
XFILLER_651_21 VPWR VGND sg13cmos5l_decap_8
XFILLER_691_226 VPWR VGND sg13cmos5l_decap_4
X_0361_ _0361_/Q Tile_X0Y7_FrameData[22] VGND VPWR Tile_X0Y9_FrameStrobe[6] latch
XFILLER_691_259 VPWR VGND sg13cmos5l_fill_2
XFILLER_428_245 VPWR VGND sg13cmos5l_decap_8
XFILLER_370_22 VPWR VGND sg13cmos5l_decap_8
X_2100_ _2100_/Q Tile_X0Y4_FrameData[17] VGND VPWR Tile_X0Y9_FrameStrobe[5] latch
X_3080_ Tile_X0Y4_E2BEGb[6] _4270_/X VPWR VGND sg13cmos5l_buf_1
XFILLER_651_98 VPWR VGND sg13cmos5l_decap_8
XFILLER_443_204 VPWR VGND sg13cmos5l_decap_8
X_0292_ _0292_/Q Tile_X0Y7_FrameData[27] VGND VPWR Tile_X0Y9_FrameStrobe[4] latch
XFILLER_644_175 VPWR VGND sg13cmos5l_decap_8
X_2031_ _2031_/Q Tile_X0Y4_FrameData[22] VGND VPWR Tile_X0Y9_FrameStrobe[3] latch
XFILLER_520_14 VPWR VGND sg13cmos5l_decap_8
XFILLER_370_99 VPWR VGND sg13cmos5l_decap_4
XANTENNA__3331__X Tile_X0Y2_FrameData_O[2] VPWR VGND sg13cmos5l_antennanp
XFILLER_47_272 VPWR VGND sg13cmos5l_fill_1
XFILLER_303_71 VPWR VGND sg13cmos5l_fill_2
XFILLER_62_231 VPWR VGND sg13cmos5l_decap_8
XFILLER_262_181 VPWR VGND sg13cmos5l_decap_8
X_3982_ _3982_/X Tile_X0Y0_W1END[1] Tile_X0Y0_W6END[9] _3871_/X _3860_/X _1139_/Q
+ _1138_/Q VPWR VGND sg13cmos5l_mux4_1
XFILLER_22_128 VPWR VGND sg13cmos5l_decap_8
XFILLER_210_218 VPWR VGND sg13cmos5l_decap_8
X_2933_ Tile_X0Y8_E6BEG[1] _4761_/X VPWR VGND sg13cmos5l_buf_1
XFILLER_175_100 VPWR VGND sg13cmos5l_decap_8
XFILLER_572_119 VPWR VGND sg13cmos5l_decap_8
X_2864_ Tile_X0Y6_EE4BEG[1] _4513_/X VPWR VGND sg13cmos5l_buf_1
XFILLER_676_84 VPWR VGND sg13cmos5l_decap_8
XFILLER_248_35 VPWR VGND sg13cmos5l_decap_8
XFILLER_529_89 VPWR VGND sg13cmos5l_decap_8
XFILLER_364_244 VPWR VGND sg13cmos5l_decap_8
XFILLER_30_183 VPWR VGND sg13cmos5l_decap_8
XFILLER_175_155 VPWR VGND sg13cmos5l_decap_8
X_1815_ _1815_/Q Tile_X0Y3_FrameData[18] VGND VPWR Tile_X0Y9_FrameStrobe[4] latch
X_4603_ _4603_/X _4689_/X _4693_/X _4697_/X _4672_/X _0352_/Q _0351_/Q VPWR VGND sg13cmos5l_mux4_1
XFILLER_364_255 VPWR VGND sg13cmos5l_fill_2
X_2795_ Tile_X0Y3_E6BEG[5] _4185_/X VPWR VGND sg13cmos5l_buf_1
XFILLER_395_85 VPWR VGND sg13cmos5l_decap_8
XFILLER_324_108 VPWR VGND sg13cmos5l_decap_8
XFILLER_190_114 VPWR VGND sg13cmos5l_decap_4
XFILLER_714_168 VPWR VGND sg13cmos5l_decap_8
XFILLER_395_96 VPWR VGND sg13cmos5l_fill_2
X_4534_ _4534_/X AXI_M_SOC_RDATA26 _4573_/X _4577_/X _4557_/X _2539_/Q _2538_/Q VPWR
+ VGND sg13cmos5l_mux4_1
X_1746_ _1746_/Q Tile_X0Y3_FrameData[23] VGND VPWR Tile_X0Y9_FrameStrobe[2] latch
XFILLER_506_271 VPWR VGND sg13cmos5l_fill_2
XFILLER_116_233 VPWR VGND sg13cmos5l_decap_8
XFILLER_667_212 VPWR VGND sg13cmos5l_fill_2
XFILLER_545_77 VPWR VGND sg13cmos5l_decap_8
XFILLER_332_130 VPWR VGND sg13cmos5l_decap_8
XFILLER_117_28 VPWR VGND sg13cmos5l_decap_8
X_4465_ _4465_/X _4424_/X _0100_/X _4423_/X _0140_/X _2209_/Q _2208_/Q VPWR VGND sg13cmos5l_mux4_1
X_1677_ _1677_/Q Tile_X0Y3_FrameData[28] VGND VPWR Tile_X0Y9_FrameStrobe[0] latch
XFILLER_692_94 VPWR VGND sg13cmos5l_decap_8
XANTENNA__3506__X Tile_X0Y1_E2BEGb[4] VPWR VGND sg13cmos5l_antennanp
X_3416_ Tile_X0Y4_FrameData_O[7] Tile_X0Y4_FrameData[7] VPWR VGND sg13cmos5l_buf_1
XFILLER_667_256 VPWR VGND sg13cmos5l_decap_4
XFILLER_264_67 VPWR VGND sg13cmos5l_decap_8
X_0628_ _0628_/Q Tile_X0Y8_FrameData[11] VGND VPWR Tile_X0Y9_FrameStrobe[6] latch
X_4396_ _4396_/X Tile_X0Y5_WW4END[7] AXI_M_SOC_RRESP1 _4458_/X _4428_/X _2311_/Q _2310_/Q
+ VPWR VGND sg13cmos5l_mux4_1
XFILLER_561_21 VPWR VGND sg13cmos5l_decap_8
XFILLER_493_126 VPWR VGND sg13cmos5l_decap_8
X_3347_ Tile_X0Y2_FrameData_O[18] Tile_X0Y2_FrameData[18] VPWR VGND sg13cmos5l_buf_1
X_0559_ _0559_/Q Tile_X0Y8_FrameData[16] VGND VPWR Tile_X0Y9_FrameStrobe[4] latch
XFILLER_97_172 VPWR VGND sg13cmos5l_fill_2
XFILLER_682_259 VPWR VGND sg13cmos5l_decap_8
XFILLER_285_262 VPWR VGND sg13cmos5l_decap_8
XFILLER_561_98 VPWR VGND sg13cmos5l_decap_8
XFILLER_133_49 VPWR VGND sg13cmos5l_decap_8
X_3278_ Tile_X0Y0_EE4BEG[14] _3834_/X VPWR VGND sg13cmos5l_buf_1
XFILLER_711_35 VPWR VGND sg13cmos5l_decap_8
XFILLER_635_175 VPWR VGND sg13cmos5l_decap_8
XFILLER_650_112 VPWR VGND sg13cmos5l_decap_8
XFILLER_280_77 VPWR VGND sg13cmos5l_decap_8
X_2229_ _2229_/Q Tile_X0Y5_FrameData[16] VGND VPWR Tile_X0Y9_FrameStrobe[1] latch
XFILLER_430_14 VPWR VGND sg13cmos5l_decap_8
XFILLER_38_250 VPWR VGND sg13cmos5l_decap_8
XFILLER_434_248 VPWR VGND sg13cmos5l_decap_8
XANTENNA__3241__X Tile_X0Y0_FrameData_O[9] VPWR VGND sg13cmos5l_antennanp
XFILLER_26_14 VPWR VGND sg13cmos5l_decap_8
XANTENNA_208 Tile_X0Y9_N4END[14] VPWR VGND sg13cmos5l_antennanp
XANTENNA_219 Tile_X0Y9_N4END[14] VPWR VGND sg13cmos5l_antennanp
XFILLER_253_170 VPWR VGND sg13cmos5l_decap_8
XFILLER_650_189 VPWR VGND sg13cmos5l_decap_8
XFILLER_402_112 VPWR VGND sg13cmos5l_decap_8
XFILLER_399_174 VPWR VGND sg13cmos5l_decap_8
XFILLER_289_42 VPWR VGND sg13cmos5l_decap_8
XFILLER_510_91 VPWR VGND sg13cmos5l_decap_8
XFILLER_201_207 VPWR VGND sg13cmos5l_decap_8
XFILLER_402_156 VPWR VGND sg13cmos5l_decap_8
XFILLER_289_86 VPWR VGND sg13cmos5l_decap_8
XFILLER_166_100 VPWR VGND sg13cmos5l_decap_8
XFILLER_563_119 VPWR VGND sg13cmos5l_decap_8
XFILLER_439_56 VPWR VGND sg13cmos5l_decap_8
XFILLER_42_35 VPWR VGND sg13cmos5l_decap_8
XFILLER_325_7 VPWR VGND sg13cmos5l_decap_8
XFILLER_21_161 VPWR VGND sg13cmos5l_fill_1
XFILLER_586_84 VPWR VGND sg13cmos5l_decap_8
XFILLER_21_183 VPWR VGND sg13cmos5l_decap_8
XFILLER_158_57 VPWR VGND sg13cmos5l_decap_8
XFILLER_355_255 VPWR VGND sg13cmos5l_fill_1
XFILLER_181_114 VPWR VGND sg13cmos5l_decap_8
XFILLER_166_199 VPWR VGND sg13cmos5l_decap_8
XFILLER_455_44 VPWR VGND sg13cmos5l_fill_1
XFILLER_571_196 VPWR VGND sg13cmos5l_decap_8
XFILLER_469_101 VPWR VGND sg13cmos5l_decap_8
XFILLER_455_77 VPWR VGND sg13cmos5l_fill_1
XFILLER_469_123 VPWR VGND sg13cmos5l_decap_8
XFILLER_694_7 VPWR VGND sg13cmos5l_decap_8
XFILLER_605_14 VPWR VGND sg13cmos5l_decap_8
XANTENNA__3416__X Tile_X0Y4_FrameData_O[7] VPWR VGND sg13cmos5l_antennanp
XFILLER_658_245 VPWR VGND sg13cmos5l_decap_8
XFILLER_323_174 VPWR VGND sg13cmos5l_decap_8
XFILLER_323_185 VPWR VGND sg13cmos5l_fill_1
XFILLER_469_178 VPWR VGND sg13cmos5l_decap_8
XFILLER_471_21 VPWR VGND sg13cmos5l_decap_8
XFILLER_324_15 VPWR VGND sg13cmos5l_decap_8
XFILLER_88_150 VPWR VGND sg13cmos5l_decap_8
XFILLER_67_21 VPWR VGND sg13cmos5l_decap_8
XFILLER_673_237 VPWR VGND sg13cmos5l_decap_8
XFILLER_324_48 VPWR VGND sg13cmos5l_fill_2
XFILLER_236_104 VPWR VGND sg13cmos5l_decap_8
XFILLER_626_164 VPWR VGND sg13cmos5l_decap_4
XFILLER_621_35 VPWR VGND sg13cmos5l_decap_8
XFILLER_291_210 VPWR VGND sg13cmos5l_decap_8
XFILLER_190_66 VPWR VGND sg13cmos5l_decap_4
XFILLER_67_98 VPWR VGND sg13cmos5l_decap_8
XFILLER_626_175 VPWR VGND sg13cmos5l_fill_2
XFILLER_184_0 VPWR VGND sg13cmos5l_decap_4
XFILLER_641_112 VPWR VGND sg13cmos5l_decap_8
XFILLER_340_14 VPWR VGND sg13cmos5l_decap_8
XANTENNA__3151__X Tile_X0Y7_FrameData_O[21] VPWR VGND sg13cmos5l_antennanp
XFILLER_29_272 VPWR VGND sg13cmos5l_fill_1
XFILLER_251_107 VPWR VGND sg13cmos5l_decap_8
XFILLER_697_28 VPWR VGND sg13cmos5l_decap_8
XFILLER_44_231 VPWR VGND sg13cmos5l_fill_1
XFILLER_641_189 VPWR VGND sg13cmos5l_decap_8
XFILLER_351_0 VPWR VGND sg13cmos5l_decap_8
XFILLER_244_170 VPWR VGND sg13cmos5l_fill_1
XFILLER_189_214 VPWR VGND sg13cmos5l_decap_8
XFILLER_44_253 VPWR VGND sg13cmos5l_decap_8
XANTENNA__2990__X Tile_X0Y8_FrameData_O[30] VPWR VGND sg13cmos5l_antennanp
XFILLER_199_42 VPWR VGND sg13cmos5l_decap_8
XFILLER_449_0 VPWR VGND sg13cmos5l_decap_8
XFILLER_539_127 VPWR VGND sg13cmos5l_decap_8
XFILLER_420_91 VPWR VGND sg13cmos5l_decap_8
XFILLER_189_269 VPWR VGND sg13cmos5l_decap_4
XFILLER_594_255 VPWR VGND sg13cmos5l_decap_8
XFILLER_616_0 VPWR VGND sg13cmos5l_decap_8
XFILLER_554_108 VPWR VGND sg13cmos5l_decap_8
XFILLER_554_119 VPWR VGND sg13cmos5l_fill_2
XFILLER_349_56 VPWR VGND sg13cmos5l_decap_8
XFILLER_496_84 VPWR VGND sg13cmos5l_decap_8
XFILLER_547_182 VPWR VGND sg13cmos5l_fill_2
XFILLER_200_251 VPWR VGND sg13cmos5l_decap_8
XFILLER_646_21 VPWR VGND sg13cmos5l_decap_8
XFILLER_12_194 VPWR VGND sg13cmos5l_decap_8
XFILLER_73_7 VPWR VGND sg13cmos5l_decap_8
XFILLER_8_154 VPWR VGND sg13cmos5l_fill_2
XFILLER_361_203 VPWR VGND sg13cmos5l_decap_8
X_1600_ _1600_/Q Tile_X0Y2_FrameData[17] VGND VPWR Tile_X0Y9_FrameStrobe[5] latch
XFILLER_711_105 VPWR VGND sg13cmos5l_decap_8
XFILLER_172_136 VPWR VGND sg13cmos5l_decap_8
X_2580_ _2580_/Q Tile_X0Y6_FrameData[19] VGND VPWR Tile_X0Y9_FrameStrobe[4] latch
XFILLER_646_98 VPWR VGND sg13cmos5l_decap_8
XFILLER_562_196 VPWR VGND sg13cmos5l_fill_2
X_1531_ _1531_/Q Tile_X0Y2_FrameData[22] VGND VPWR Tile_X0Y9_FrameStrobe[3] latch
XFILLER_704_190 VPWR VGND sg13cmos5l_decap_8
XFILLER_503_230 VPWR VGND sg13cmos5l_decap_8
XFILLER_515_14 VPWR VGND sg13cmos5l_decap_8
XFILLER_503_252 VPWR VGND sg13cmos5l_decap_8
XANTENNA__3326__X Tile_X0Y4_EE4BEG[14] VPWR VGND sg13cmos5l_antennanp
XFILLER_662_42 VPWR VGND sg13cmos5l_decap_8
XFILLER_314_174 VPWR VGND sg13cmos5l_decap_8
X_4250_ _4250_/X Tile_X0Y2_W1END[3] Tile_X0Y2_W2MID[0] Tile_X0Y2_W2END[0] _4096_/X
+ _1615_/Q _1614_/Q VPWR VGND sg13cmos5l_mux4_1
XFILLER_259_218 VPWR VGND sg13cmos5l_decap_8
X_1462_ _1462_/Q Tile_X0Y2_FrameData[27] VGND VPWR Tile_X0Y9_FrameStrobe[1] latch
XFILLER_381_21 VPWR VGND sg13cmos5l_decap_8
X_3201_ Tile_X0Y0_N2BEG[1] _3785_/X VPWR VGND sg13cmos5l_buf_1
XFILLER_664_226 VPWR VGND sg13cmos5l_decap_8
X_0413_ _0413_/Q Tile_X0Y7_FrameData[2] VGND VPWR Tile_X0Y9_FrameStrobe[7] latch
X_4181_ _4181_/X _0088_/X Tile_X0Y0_S4END[13] _4232_/X _4215_/X _1779_/Q _1778_/Q
+ VPWR VGND sg13cmos5l_mux4_1
XFILLER_79_161 VPWR VGND sg13cmos5l_decap_8
X_1393_ _1393_/Q Tile_X0Y1_FrameData[8] VGND VPWR Tile_X0Y9_FrameStrobe[6] latch
XFILLER_267_240 VPWR VGND sg13cmos5l_fill_2
X_3132_ Tile_X0Y7_FrameData_O[2] Tile_X0Y7_FrameData[2] VPWR VGND sg13cmos5l_buf_1
X_0344_ _0344_/Q Tile_X0Y7_FrameData[7] VGND VPWR Tile_X0Y9_FrameStrobe[5] latch
XFILLER_416_204 VPWR VGND sg13cmos5l_decap_8
XFILLER_531_35 VPWR VGND sg13cmos5l_decap_8
XFILLER_617_175 VPWR VGND sg13cmos5l_decap_8
XFILLER_282_210 VPWR VGND sg13cmos5l_decap_8
XFILLER_672_270 VPWR VGND sg13cmos5l_fill_2
XFILLER_632_112 VPWR VGND sg13cmos5l_decap_8
X_3063_ Tile_X0Y5_FrameData_O[22] Tile_X0Y5_FrameData[22] VPWR VGND sg13cmos5l_buf_1
XFILLER_250_14 VPWR VGND sg13cmos5l_decap_8
X_0275_ _0275_/Q Tile_X0Y7_FrameData[12] VGND VPWR Tile_X0Y9_FrameStrobe[3] latch
XANTENNA__3061__X Tile_X0Y5_FrameData_O[20] VPWR VGND sg13cmos5l_antennanp
XFILLER_94_186 VPWR VGND sg13cmos5l_decap_8
X_2014_ _2014_/Q Tile_X0Y4_FrameData[7] VGND VPWR Tile_X0Y9_FrameStrobe[2] latch
XFILLER_35_220 VPWR VGND sg13cmos5l_fill_2
XFILLER_242_129 VPWR VGND sg13cmos5l_decap_8
XFILLER_35_253 VPWR VGND sg13cmos5l_decap_4
XFILLER_400_28 VPWR VGND sg13cmos5l_decap_8
XFILLER_35_264 VPWR VGND sg13cmos5l_decap_8
XFILLER_585_244 VPWR VGND sg13cmos5l_decap_8
XFILLER_250_162 VPWR VGND sg13cmos5l_decap_8
XFILLER_396_166 VPWR VGND sg13cmos5l_decap_8
X_3965_ _3965_/X _0096_/X Tile_X0Y0_S4END[5] _4018_/X _3999_/X _1279_/Q _1278_/Q VPWR
+ VGND sg13cmos5l_mux4_1
XFILLER_545_119 VPWR VGND sg13cmos5l_decap_4
X_2916_ Tile_X0Y8_E2BEG[0] _4728_/X VPWR VGND sg13cmos5l_buf_1
XFILLER_148_133 VPWR VGND sg13cmos5l_decap_8
X_3896_ _3896_/X Tile_X0Y2_W2MID[3] Tile_X0Y2_W2END[3] Tile_X0Y2_W6END[3] _4102_/X
+ _1657_/Q _1656_/Q VPWR VGND sg13cmos5l_mux4_1
XFILLER_556_21 VPWR VGND sg13cmos5l_decap_8
X_2847_ Tile_X0Y6_E2BEGb[4] _4508_/X VPWR VGND sg13cmos5l_buf_1
XFILLER_553_152 VPWR VGND sg13cmos5l_decap_8
XFILLER_12_49 VPWR VGND sg13cmos5l_decap_8
XFILLER_352_203 VPWR VGND sg13cmos5l_decap_8
XFILLER_699_167 VPWR VGND sg13cmos5l_decap_8
XFILLER_128_49 VPWR VGND sg13cmos5l_decap_8
X_2778_ Tile_X0Y3_EE4BEG[4] _4168_/X VPWR VGND sg13cmos5l_buf_1
XFILLER_556_98 VPWR VGND sg13cmos5l_decap_8
XFILLER_163_158 VPWR VGND sg13cmos5l_decap_8
XFILLER_706_35 VPWR VGND sg13cmos5l_decap_8
XFILLER_275_77 VPWR VGND sg13cmos5l_decap_8
X_1729_ _1729_/Q Tile_X0Y3_FrameData[8] VGND VPWR Tile_X0Y9_FrameStrobe[1] latch
X_4517_ _4517_/X Tile_X0Y6_WW4END[10] AXI_M_SOC_RDATA29 _4578_/X _4557_/X _2573_/Q
+ _2572_/Q VPWR VGND sg13cmos5l_mux4_1
XFILLER_425_14 VPWR VGND sg13cmos5l_decap_8
XANTENNA__3236__X Tile_X0Y0_FrameData_O[4] VPWR VGND sg13cmos5l_antennanp
XFILLER_572_42 VPWR VGND sg13cmos5l_decap_8
X_4448_ _4448_/X _4015_/X _4019_/X _3996_/X _3988_/X _1356_/Q _1355_/Q VPWR VGND sg13cmos5l_mux4_1
XFILLER_655_204 VPWR VGND sg13cmos5l_decap_8
XFILLER_320_133 VPWR VGND sg13cmos5l_decap_8
XFILLER_710_193 VPWR VGND sg13cmos5l_decap_8
XFILLER_104_269 VPWR VGND sg13cmos5l_decap_4
XFILLER_291_43 VPWR VGND sg13cmos5l_decap_8
X_4379_ _4379_/X Tile_X0Y5_W2MID[0] AXI_M_SOC_RRESP1 _4467_/X _4428_/X _2345_/Q _2344_/Q
+ VPWR VGND sg13cmos5l_mux4_1
XFILLER_466_159 VPWR VGND sg13cmos5l_decap_8
XFILLER_258_240 VPWR VGND sg13cmos5l_decap_8
XFILLER_608_131 VPWR VGND sg13cmos5l_decap_8
XFILLER_505_91 VPWR VGND sg13cmos5l_decap_8
XFILLER_481_107 VPWR VGND sg13cmos5l_decap_8
XFILLER_670_207 VPWR VGND sg13cmos5l_fill_1
XFILLER_224_70 VPWR VGND sg13cmos5l_decap_8
XFILLER_670_229 VPWR VGND sg13cmos5l_decap_8
XFILLER_441_35 VPWR VGND sg13cmos5l_decap_8
XFILLER_623_112 VPWR VGND sg13cmos5l_decap_8
XFILLER_407_237 VPWR VGND sg13cmos5l_decap_8
XFILLER_273_232 VPWR VGND sg13cmos5l_decap_8
XFILLER_160_14 VPWR VGND sg13cmos5l_decap_8
XFILLER_37_46 VPWR VGND sg13cmos5l_decap_8
XFILLER_273_243 VPWR VGND sg13cmos5l_fill_2
XFILLER_275_7 VPWR VGND sg13cmos5l_decap_8
XFILLER_233_118 VPWR VGND sg13cmos5l_decap_8
XFILLER_422_229 VPWR VGND sg13cmos5l_decap_8
XFILLER_26_264 VPWR VGND sg13cmos5l_decap_8
XFILLER_576_222 VPWR VGND sg13cmos5l_decap_8
XFILLER_387_122 VPWR VGND sg13cmos5l_decap_8
XFILLER_156_4 VPWR VGND sg13cmos5l_fill_1
XFILLER_240_91 VPWR VGND sg13cmos5l_decap_8
XFILLER_597_83 VPWR VGND sg13cmos5l_decap_8
XFILLER_576_255 VPWR VGND sg13cmos5l_decap_8
XFILLER_53_67 VPWR VGND sg13cmos5l_decap_4
XFILLER_169_56 VPWR VGND sg13cmos5l_decap_8
XFILLER_53_89 VPWR VGND sg13cmos5l_decap_8
XFILLER_186_239 VPWR VGND sg13cmos5l_decap_8
XFILLER_707_7 VPWR VGND sg13cmos5l_decap_8
XFILLER_139_133 VPWR VGND sg13cmos5l_decap_8
XFILLER_466_21 VPWR VGND sg13cmos5l_decap_8
XFILLER_323_4 VPWR VGND sg13cmos5l_fill_1
XFILLER_591_258 VPWR VGND sg13cmos5l_decap_4
XFILLER_328_255 VPWR VGND sg13cmos5l_decap_8
XFILLER_194_261 VPWR VGND sg13cmos5l_decap_4
XFILLER_319_48 VPWR VGND sg13cmos5l_fill_2
XFILLER_194_272 VPWR VGND sg13cmos5l_fill_1
XFILLER_544_163 VPWR VGND sg13cmos5l_decap_8
XFILLER_343_214 VPWR VGND sg13cmos5l_decap_8
XFILLER_185_44 VPWR VGND sg13cmos5l_fill_1
XFILLER_343_236 VPWR VGND sg13cmos5l_decap_4
XFILLER_616_35 VPWR VGND sg13cmos5l_decap_8
XFILLER_5_135 VPWR VGND sg13cmos5l_decap_8
XFILLER_185_66 VPWR VGND sg13cmos5l_decap_8
XFILLER_343_258 VPWR VGND sg13cmos5l_decap_4
XFILLER_335_14 VPWR VGND sg13cmos5l_decap_8
XANTENNA__3146__X Tile_X0Y7_FrameData_O[16] VPWR VGND sg13cmos5l_antennanp
XFILLER_482_42 VPWR VGND sg13cmos5l_decap_8
XFILLER_162_180 VPWR VGND sg13cmos5l_decap_4
XFILLER_311_111 VPWR VGND sg13cmos5l_decap_8
XFILLER_701_171 VPWR VGND sg13cmos5l_decap_8
XFILLER_457_104 VPWR VGND sg13cmos5l_decap_8
XANTENNA__2985__X Tile_X0Y8_FrameData_O[25] VPWR VGND sg13cmos5l_antennanp
XFILLER_110_206 VPWR VGND sg13cmos5l_decap_8
XFILLER_399_0 VPWR VGND sg13cmos5l_decap_8
XFILLER_110_217 VPWR VGND sg13cmos5l_fill_1
XFILLER_311_177 VPWR VGND sg13cmos5l_decap_8
XFILLER_646_259 VPWR VGND sg13cmos5l_decap_8
XFILLER_632_56 VPWR VGND sg13cmos5l_decap_8
XFILLER_661_218 VPWR VGND sg13cmos5l_fill_1
XFILLER_472_118 VPWR VGND sg13cmos5l_fill_2
XFILLER_134_70 VPWR VGND sg13cmos5l_decap_8
XFILLER_351_35 VPWR VGND sg13cmos5l_decap_8
XFILLER_465_170 VPWR VGND sg13cmos5l_decap_8
XFILLER_566_0 VPWR VGND sg13cmos5l_decap_8
XFILLER_465_192 VPWR VGND sg13cmos5l_fill_1
XFILLER_94_74 VPWR VGND sg13cmos5l_decap_8
XFILLER_480_162 VPWR VGND sg13cmos5l_fill_2
XFILLER_413_207 VPWR VGND sg13cmos5l_decap_8
XFILLER_91_145 VPWR VGND sg13cmos5l_decap_8
X_0060_ _3177_/A _3924_/X _3925_/X _1896_/Q VPWR VGND sg13cmos5l_mux2_1
XFILLER_501_49 VPWR VGND sg13cmos5l_decap_8
XFILLER_406_270 VPWR VGND sg13cmos5l_fill_2
XFILLER_220_28 VPWR VGND sg13cmos5l_decap_8
XFILLER_378_122 VPWR VGND sg13cmos5l_decap_8
XFILLER_232_140 VPWR VGND sg13cmos5l_decap_8
XFILLER_567_233 VPWR VGND sg13cmos5l_fill_1
XFILLER_378_144 VPWR VGND sg13cmos5l_decap_8
XFILLER_177_228 VPWR VGND sg13cmos5l_decap_8
XFILLER_657_42 VPWR VGND sg13cmos5l_decap_8
X_3750_ AXI_M_SOC_ARADDR22 Tile_X0Y8_WW4END[6] Tile_X0Y8_WW4END[14] Tile_X0Y8_W6END[6]
+ _4806_/X _0491_/Q _0490_/Q VPWR VGND sg13cmos5l_mux4_1
XFILLER_582_225 VPWR VGND sg13cmos5l_decap_8
X_0962_ _0962_/Q Tile_X0Y0_FrameData[9] VGND VPWR Tile_X0Y9_FrameStrobe[0] latch
X_2701_ _4084_/A3 VPWR VGND sg13cmos5l_tielo
X_3681_ _3681_/X Tile_X0Y2_WW4END[3] Tile_X0Y2_WW4END[11] Tile_X0Y2_W6END[11] _4127_/X
+ _1483_/Q _1482_/Q VPWR VGND sg13cmos5l_mux4_1
XFILLER_535_141 VPWR VGND sg13cmos5l_decap_8
XFILLER_319_266 VPWR VGND sg13cmos5l_decap_8
XFILLER_145_103 VPWR VGND sg13cmos5l_decap_8
XFILLER_185_272 VPWR VGND sg13cmos5l_fill_1
X_0893_ _0893_/Q Tile_X0Y9_FrameData[2] VGND VPWR Tile_X0Y9_FrameStrobe[6] latch
X_2632_ _2632_/Q Tile_X0Y6_FrameData[31] VGND VPWR Tile_X0Y9_FrameStrobe[6] latch
XFILLER_550_100 VPWR VGND sg13cmos5l_fill_1
XFILLER_334_225 VPWR VGND sg13cmos5l_decap_8
XFILLER_376_98 VPWR VGND sg13cmos5l_decap_8
XFILLER_550_122 VPWR VGND sg13cmos5l_fill_1
XFILLER_535_196 VPWR VGND sg13cmos5l_fill_2
XFILLER_526_35 VPWR VGND sg13cmos5l_decap_8
XFILLER_309_70 VPWR VGND sg13cmos5l_decap_4
XFILLER_696_126 VPWR VGND sg13cmos5l_fill_1
XFILLER_550_144 VPWR VGND sg13cmos5l_decap_8
X_2563_ _2563_/Q Tile_X0Y6_FrameData[4] VGND VPWR Tile_X0Y9_FrameStrobe[3] latch
XFILLER_245_14 VPWR VGND sg13cmos5l_decap_8
XANTENNA__3056__X Tile_X0Y5_FrameData_O[15] VPWR VGND sg13cmos5l_antennanp
XFILLER_99_212 VPWR VGND sg13cmos5l_decap_8
XFILLER_392_42 VPWR VGND sg13cmos5l_decap_4
X_1514_ _1514_/Q Tile_X0Y2_FrameData[7] VGND VPWR Tile_X0Y9_FrameStrobe[2] latch
X_4302_ _4302_/X Tile_X0Y5_W1END[0] Tile_X0Y5_W6END[4] _4463_/X _4416_/X _2439_/Q
+ _2438_/Q VPWR VGND sg13cmos5l_mux4_1
XFILLER_392_53 VPWR VGND sg13cmos5l_decap_8
X_2494_ _2494_/Q Tile_X0Y6_FrameData[9] VGND VPWR Tile_X0Y9_FrameStrobe[1] latch
XFILLER_302_133 VPWR VGND sg13cmos5l_decap_8
XFILLER_448_126 VPWR VGND sg13cmos5l_decap_8
X_4233_ _4233_/X _4203_/X _0046_/X _4202_/X Tile_X0Y0_S4END[15] _1707_/Q _1706_/Q
+ VPWR VGND sg13cmos5l_mux4_1
XANTENNA__2895__X Tile_X0Y6_FrameData_O[16] VPWR VGND sg13cmos5l_antennanp
X_1445_ _1445_/Q Tile_X0Y2_FrameData[12] VGND VPWR Tile_X0Y9_FrameStrobe[0] latch
XFILLER_542_56 VPWR VGND sg13cmos5l_decap_8
XFILLER_463_107 VPWR VGND sg13cmos5l_decap_8
X_4164_ _4164_/X Tile_X0Y3_WW4END[15] AXI_M_SOC_WREADY _4212_/X _4204_/X _1813_/Q
+ _1812_/Q VPWR VGND sg13cmos5l_mux4_1
X_1376_ _1376_/Q Tile_X0Y1_FrameData[25] VGND VPWR Tile_X0Y9_FrameStrobe[6] latch
XFILLER_261_35 VPWR VGND sg13cmos5l_decap_8
XFILLER_456_181 VPWR VGND sg13cmos5l_decap_8
X_3115_ Tile_X0Y7_EE4BEG[1] _4629_/X VPWR VGND sg13cmos5l_buf_1
X_0327_ _0327_/Q Tile_X0Y7_FrameData[24] VGND VPWR Tile_X0Y9_FrameStrobe[5] latch
XFILLER_261_68 VPWR VGND sg13cmos5l_decap_8
X_4095_ _4095_/X Tile_X0Y3_W1END[3] Tile_X0Y3_W6END[7] _4212_/X _4193_/X _1919_/Q
+ _1918_/Q VPWR VGND sg13cmos5l_mux4_1
XFILLER_67_175 VPWR VGND sg13cmos5l_decap_8
XFILLER_605_145 VPWR VGND sg13cmos5l_decap_8
XFILLER_471_140 VPWR VGND sg13cmos5l_fill_2
XFILLER_215_118 VPWR VGND sg13cmos5l_decap_8
X_3046_ Tile_X0Y5_FrameData_O[5] Tile_X0Y5_FrameData[5] VPWR VGND sg13cmos5l_buf_1
XFILLER_270_213 VPWR VGND sg13cmos5l_decap_8
XFILLER_82_145 VPWR VGND sg13cmos5l_decap_8
X_0258_ _0258_/Q Tile_X0Y7_FrameData[29] VGND VPWR Tile_X0Y9_FrameStrobe[3] latch
XFILLER_471_173 VPWR VGND sg13cmos5l_decap_8
XFILLER_411_49 VPWR VGND sg13cmos5l_decap_8
XFILLER_130_28 VPWR VGND sg13cmos5l_decap_8
XFILLER_82_189 VPWR VGND sg13cmos5l_fill_1
X_0189_ _0189_/Q Tile_X0Y7_FrameData[2] VGND VPWR Tile_X0Y9_FrameStrobe[0] latch
XFILLER_223_162 VPWR VGND sg13cmos5l_fill_1
XFILLER_369_166 VPWR VGND sg13cmos5l_decap_4
XFILLER_369_177 VPWR VGND sg13cmos5l_decap_8
XFILLER_168_228 VPWR VGND sg13cmos5l_decap_8
XFILLER_573_203 VPWR VGND sg13cmos5l_decap_8
XFILLER_567_42 VPWR VGND sg13cmos5l_decap_8
X_3948_ _3948_/X Tile_X0Y1_WW4END[15] AXI_M_SOC_ARREADY _3996_/X _3988_/X _1313_/Q
+ _1312_/Q VPWR VGND sg13cmos5l_mux4_1
XFILLER_286_21 VPWR VGND sg13cmos5l_decap_8
XFILLER_526_141 VPWR VGND sg13cmos5l_decap_8
XFILLER_717_34 VPWR VGND sg13cmos5l_fill_1
XFILLER_715_252 VPWR VGND sg13cmos5l_decap_8
X_3879_ _3879_/X _3851_/X _0078_/X Tile_X0Y0_S1END[3] Tile_X0Y0_S4END[3] _0981_/Q
+ _0980_/Q VPWR VGND sg13cmos5l_mux4_1
XFILLER_526_163 VPWR VGND sg13cmos5l_decap_8
XFILLER_191_220 VPWR VGND sg13cmos5l_decap_8
XFILLER_717_56 VPWR VGND sg13cmos5l_decap_8
XFILLER_325_225 VPWR VGND sg13cmos5l_decap_8
XFILLER_325_236 VPWR VGND sg13cmos5l_fill_1
XFILLER_717_78 VPWR VGND sg13cmos5l_decap_4
XFILLER_286_98 VPWR VGND sg13cmos5l_decap_8
XFILLER_687_115 VPWR VGND sg13cmos5l_decap_8
XFILLER_436_35 VPWR VGND sg13cmos5l_decap_8
XFILLER_325_258 VPWR VGND sg13cmos5l_decap_8
XFILLER_155_14 VPWR VGND sg13cmos5l_decap_8
XFILLER_583_63 VPWR VGND sg13cmos5l_decap_8
XFILLER_2_105 VPWR VGND sg13cmos5l_decap_8
XFILLER_479_251 VPWR VGND sg13cmos5l_decap_8
XFILLER_340_239 VPWR VGND sg13cmos5l_fill_1
XFILLER_541_199 VPWR VGND sg13cmos5l_decap_4
XFILLER_3_7 VPWR VGND sg13cmos5l_decap_8
XFILLER_439_104 VPWR VGND sg13cmos5l_decap_8
XFILLER_2_149 VPWR VGND sg13cmos5l_decap_8
XFILLER_494_221 VPWR VGND sg13cmos5l_decap_8
XFILLER_439_137 VPWR VGND sg13cmos5l_decap_8
XANTENNA__0102__Y AXI_M_SOC_ARLEN5 VPWR VGND sg13cmos5l_antennanp
XFILLER_305_28 VPWR VGND sg13cmos5l_decap_8
XFILLER_392_7 VPWR VGND sg13cmos5l_decap_8
XFILLER_48_34 VPWR VGND sg13cmos5l_decap_8
XFILLER_452_56 VPWR VGND sg13cmos5l_decap_4
XFILLER_171_35 VPWR VGND sg13cmos5l_fill_1
XFILLER_246_243 VPWR VGND sg13cmos5l_decap_8
XFILLER_73_101 VPWR VGND sg13cmos5l_fill_1
XFILLER_100_272 VPWR VGND sg13cmos5l_fill_1
XFILLER_657_7 VPWR VGND sg13cmos5l_decap_8
XFILLER_58_186 VPWR VGND sg13cmos5l_decap_8
XFILLER_321_16 VPWR VGND sg13cmos5l_fill_1
XFILLER_261_202 VPWR VGND sg13cmos5l_fill_2
XFILLER_261_246 VPWR VGND sg13cmos5l_decap_8
XFILLER_64_77 VPWR VGND sg13cmos5l_decap_8
XFILLER_14_212 VPWR VGND sg13cmos5l_decap_8
XFILLER_549_233 VPWR VGND sg13cmos5l_decap_8
XFILLER_403_240 VPWR VGND sg13cmos5l_decap_8
XFILLER_401_71 VPWR VGND sg13cmos5l_decap_8
XFILLER_9_28 VPWR VGND sg13cmos5l_decap_8
XFILLER_147_0 VPWR VGND sg13cmos5l_decap_8
XFILLER_80_21 VPWR VGND sg13cmos5l_decap_8
XFILLER_477_42 VPWR VGND sg13cmos5l_decap_8
XFILLER_80_32 VPWR VGND sg13cmos5l_fill_2
XFILLER_196_21 VPWR VGND sg13cmos5l_decap_8
XFILLER_174_209 VPWR VGND sg13cmos5l_decap_8
XFILLER_375_169 VPWR VGND sg13cmos5l_decap_4
XFILLER_390_106 VPWR VGND sg13cmos5l_decap_8
XFILLER_167_272 VPWR VGND sg13cmos5l_fill_1
XFILLER_517_163 VPWR VGND sg13cmos5l_decap_8
XFILLER_314_0 VPWR VGND sg13cmos5l_fill_2
XFILLER_627_56 VPWR VGND sg13cmos5l_decap_8
XFILLER_13_92 VPWR VGND sg13cmos5l_decap_8
XFILLER_182_231 VPWR VGND sg13cmos5l_decap_8
XFILLER_196_98 VPWR VGND sg13cmos5l_fill_2
XFILLER_346_35 VPWR VGND sg13cmos5l_decap_8
XFILLER_316_247 VPWR VGND sg13cmos5l_decap_8
XFILLER_129_70 VPWR VGND sg13cmos5l_decap_8
XFILLER_127_169 VPWR VGND sg13cmos5l_decap_8
XFILLER_316_269 VPWR VGND sg13cmos5l_decap_4
XFILLER_493_63 VPWR VGND sg13cmos5l_decap_8
XFILLER_89_63 VPWR VGND sg13cmos5l_decap_8
XFILLER_331_228 VPWR VGND sg13cmos5l_decap_8
XFILLER_693_107 VPWR VGND sg13cmos5l_decap_8
XFILLER_686_170 VPWR VGND sg13cmos5l_decap_8
XFILLER_683_0 VPWR VGND sg13cmos5l_decap_8
XFILLER_643_77 VPWR VGND sg13cmos5l_decap_8
XFILLER_485_232 VPWR VGND sg13cmos5l_decap_8
XFILLER_150_161 VPWR VGND sg13cmos5l_fill_2
XFILLER_215_28 VPWR VGND sg13cmos5l_decap_8
XFILLER_36_7 VPWR VGND sg13cmos5l_decap_8
XFILLER_296_143 VPWR VGND sg13cmos5l_decap_8
XANTENNA__3604__X Tile_X0Y9_S1BEG[2] VPWR VGND sg13cmos5l_antennanp
XFILLER_362_56 VPWR VGND sg13cmos5l_decap_8
X_1230_ _1230_/Q Tile_X0Y1_FrameData[11] VGND VPWR Tile_X0Y9_FrameStrobe[1] latch
XFILLER_445_129 VPWR VGND sg13cmos5l_decap_8
XFILLER_237_210 VPWR VGND sg13cmos5l_decap_8
XFILLER_599_100 VPWR VGND sg13cmos5l_decap_8
X_1161_ _1161_/Q Tile_X0Y0_FrameData[2] VGND VPWR Tile_X0Y9_FrameStrobe[6] latch
XFILLER_49_175 VPWR VGND sg13cmos5l_decap_8
XFILLER_64_112 VPWR VGND sg13cmos5l_decap_8
XFILLER_49_186 VPWR VGND sg13cmos5l_fill_1
XFILLER_453_140 VPWR VGND sg13cmos5l_decap_8
X_0112_ _0112_/X _4320_/X _4321_/X _1115_/Q VPWR VGND sg13cmos5l_mux2_1
X_1092_ _1092_/Q Tile_X0Y0_FrameData[7] VGND VPWR Tile_X0Y9_FrameStrobe[4] latch
XFILLER_602_104 VPWR VGND sg13cmos5l_decap_4
XFILLER_231_49 VPWR VGND sg13cmos5l_decap_8
XFILLER_453_184 VPWR VGND sg13cmos5l_decap_4
XFILLER_599_188 VPWR VGND sg13cmos5l_decap_8
X_0043_ _3632_/A _4720_/X _4721_/X _0603_/Q VPWR VGND sg13cmos5l_mux2_1
X_4920_ _4920_/X Tile_X0Y9_N1END[0] Tile_X0Y9_N4END[0] _4896_/X _0083_/X _0719_/Q
+ _0718_/Q VPWR VGND sg13cmos5l_mux4_1
XFILLER_64_189 VPWR VGND sg13cmos5l_decap_8
XFILLER_599_199 VPWR VGND sg13cmos5l_fill_1
XFILLER_205_162 VPWR VGND sg13cmos5l_decap_8
X_4851_ _4851_/X Tile_X0Y9_W2MID[4] AXI_M_SOC_RDATA3 _4907_/X _4906_/X _0841_/Q _0840_/Q
+ VPWR VGND sg13cmos5l_mux4_1
XFILLER_668_63 VPWR VGND sg13cmos5l_decap_8
X_3802_ _3802_/X _3850_/X Tile_X0Y0_W2END[6] Tile_X0Y0_W2END[7] Tile_X0Y0_S1END[2]
+ _1101_/Q _1100_/Q VPWR VGND sg13cmos5l_mux4_1
XFILLER_366_125 VPWR VGND sg13cmos5l_fill_2
XFILLER_20_215 VPWR VGND sg13cmos5l_decap_8
XFILLER_555_236 VPWR VGND sg13cmos5l_decap_8
X_1994_ _1994_/Q Tile_X0Y4_FrameData[27] VGND VPWR Tile_X0Y9_FrameStrobe[2] latch
X_4782_ _4782_/X Tile_X0Y7_W1END[3] Tile_X0Y7_W6END[11] _4699_/X _4659_/X _0373_/Q
+ _0372_/Q VPWR VGND sg13cmos5l_mux4_1
XFILLER_158_261 VPWR VGND sg13cmos5l_fill_1
X_0945_ _0945_/Q Tile_X0Y0_FrameData[26] VGND VPWR Tile_X0Y9_FrameStrobe[0] latch
X_3733_ AXI_M_SOC_ARADDR5 Tile_X0Y9_WW4END[5] Tile_X0Y9_WW4END[13] Tile_X0Y9_W6END[5]
+ _4921_/X _0749_/Q _0748_/Q VPWR VGND sg13cmos5l_mux4_1
XFILLER_118_103 VPWR VGND sg13cmos5l_decap_8
XFILLER_307_203 VPWR VGND sg13cmos5l_decap_8
XFILLER_9_260 VPWR VGND sg13cmos5l_fill_2
XFILLER_570_217 VPWR VGND sg13cmos5l_decap_8
XFILLER_537_56 VPWR VGND sg13cmos5l_decap_8
XFILLER_381_139 VPWR VGND sg13cmos5l_decap_8
XFILLER_109_29 VPWR VGND sg13cmos5l_decap_8
X_0876_ _0876_/Q Tile_X0Y9_FrameData[19] VGND VPWR Tile_X0Y9_FrameStrobe[6] latch
X_3664_ AXI_M_SOC_AWADDR25 Tile_X0Y4_WW4END[1] Tile_X0Y4_WW4END[9] Tile_X0Y4_W6END[9]
+ _4345_/X _1995_/Q _1994_/Q VPWR VGND sg13cmos5l_mux4_1
XFILLER_62_0 VPWR VGND sg13cmos5l_decap_8
XFILLER_307_258 VPWR VGND sg13cmos5l_decap_4
XFILLER_256_35 VPWR VGND sg13cmos5l_fill_2
X_2615_ _2615_/Q Tile_X0Y6_FrameData[16] VGND VPWR Tile_X0Y9_FrameStrobe[5] latch
XFILLER_523_155 VPWR VGND sg13cmos5l_decap_8
X_3595_ Tile_X0Y9_FrameData_O[25] Tile_X0Y9_FrameData[25] VPWR VGND sg13cmos5l_buf_1
XFILLER_133_139 VPWR VGND sg13cmos5l_decap_8
XFILLER_322_228 VPWR VGND sg13cmos5l_decap_8
XFILLER_684_107 VPWR VGND sg13cmos5l_fill_2
XFILLER_523_199 VPWR VGND sg13cmos5l_decap_8
X_2546_ _2546_/Q Tile_X0Y6_FrameData[21] VGND VPWR Tile_X0Y9_FrameStrobe[3] latch
XFILLER_684_129 VPWR VGND sg13cmos5l_decap_8
XFILLER_406_49 VPWR VGND sg13cmos5l_decap_8
XFILLER_553_77 VPWR VGND sg13cmos5l_decap_8
XFILLER_125_28 VPWR VGND sg13cmos5l_decap_8
XFILLER_87_215 VPWR VGND sg13cmos5l_fill_1
X_2477_ _2477_/Q Tile_X0Y6_FrameData[26] VGND VPWR Tile_X0Y9_FrameStrobe[1] latch
XFILLER_703_14 VPWR VGND sg13cmos5l_decap_8
XFILLER_287_154 VPWR VGND sg13cmos5l_decap_8
XANTENNA__3514__X Tile_X0Y1_E2BEG[4] VPWR VGND sg13cmos5l_antennanp
XFILLER_141_172 VPWR VGND sg13cmos5l_decap_8
XFILLER_87_237 VPWR VGND sg13cmos5l_decap_8
XFILLER_272_56 VPWR VGND sg13cmos5l_decap_8
XFILLER_491_202 VPWR VGND sg13cmos5l_decap_8
X_1428_ _1428_/Q Tile_X0Y2_FrameData[29] VGND VPWR Tile_X0Y9_FrameStrobe[0] latch
X_4216_ _4216_/X Tile_X0Y7_W1END[1] Tile_X0Y7_WW4END[1] Tile_X0Y7_W6END[9] _4685_/X
+ _0388_/Q _0387_/Q VPWR VGND sg13cmos5l_mux4_1
X_4147_ _4147_/X _4203_/X _4202_/X AXI_M_SOC_WREADY _4201_/X _1847_/Q _1846_/Q VPWR
+ VGND sg13cmos5l_mux4_1
XFILLER_95_270 VPWR VGND sg13cmos5l_fill_2
X_1359_ _1359_/Q Tile_X0Y1_FrameData[10] VGND VPWR Tile_X0Y9_FrameStrobe[5] latch
XFILLER_444_162 VPWR VGND sg13cmos5l_decap_8
XFILLER_141_49 VPWR VGND sg13cmos5l_decap_8
X_4078_ _4078_/X AXI_M_SOC_AWREADY _4121_/X _4125_/X _4101_/X _1517_/Q _1516_/Q VPWR
+ VGND sg13cmos5l_mux4_1
XFILLER_502_70 VPWR VGND sg13cmos5l_decap_8
X_3029_ Tile_X0Y5_EE4BEG[4] _4392_/X VPWR VGND sg13cmos5l_buf_1
XFILLER_70_137 VPWR VGND sg13cmos5l_decap_8
XFILLER_34_14 VPWR VGND sg13cmos5l_decap_8
XFILLER_578_63 VPWR VGND sg13cmos5l_decap_8
XFILLER_601_181 VPWR VGND sg13cmos5l_decap_4
XFILLER_546_214 VPWR VGND sg13cmos5l_fill_2
XFILLER_34_69 VPWR VGND sg13cmos5l_decap_8
XFILLER_140_7 VPWR VGND sg13cmos5l_decap_8
XFILLER_211_154 VPWR VGND sg13cmos5l_decap_8
XFILLER_357_147 VPWR VGND sg13cmos5l_decap_8
XFILLER_297_64 VPWR VGND sg13cmos5l_decap_8
XFILLER_238_7 VPWR VGND sg13cmos5l_decap_8
XFILLER_400_265 VPWR VGND sg13cmos5l_decap_8
XFILLER_211_187 VPWR VGND sg13cmos5l_decap_8
XFILLER_11_259 VPWR VGND sg13cmos5l_fill_2
XFILLER_412_8 VPWR VGND sg13cmos5l_decap_8
XFILLER_50_35 VPWR VGND sg13cmos5l_decap_8
XFILLER_164_220 VPWR VGND sg13cmos5l_decap_8
XFILLER_109_136 VPWR VGND sg13cmos5l_decap_4
XFILLER_405_7 VPWR VGND sg13cmos5l_decap_8
XFILLER_166_35 VPWR VGND sg13cmos5l_decap_4
XFILLER_164_264 VPWR VGND sg13cmos5l_fill_1
XFILLER_703_255 VPWR VGND sg13cmos5l_fill_2
XFILLER_380_161 VPWR VGND sg13cmos5l_decap_8
XFILLER_514_199 VPWR VGND sg13cmos5l_decap_8
XFILLER_668_192 VPWR VGND sg13cmos5l_fill_2
XFILLER_613_14 VPWR VGND sg13cmos5l_decap_8
XFILLER_321_272 VPWR VGND sg13cmos5l_fill_1
XANTENNA__3424__X Tile_X0Y4_FrameData_O[15] VPWR VGND sg13cmos5l_antennanp
XFILLER_132_194 VPWR VGND sg13cmos5l_decap_8
XFILLER_482_224 VPWR VGND sg13cmos5l_fill_2
XFILLER_219_243 VPWR VGND sg13cmos5l_decap_8
XFILLER_75_21 VPWR VGND sg13cmos5l_decap_8
XFILLER_93_229 VPWR VGND sg13cmos5l_decap_8
XFILLER_482_268 VPWR VGND sg13cmos5l_decap_4
XFILLER_435_140 VPWR VGND sg13cmos5l_decap_8
XFILLER_264_0 VPWR VGND sg13cmos5l_decap_8
XFILLER_234_257 VPWR VGND sg13cmos5l_decap_8
XFILLER_61_126 VPWR VGND sg13cmos5l_decap_8
XFILLER_131_71 VPWR VGND sg13cmos5l_decap_8
XFILLER_199_161 VPWR VGND sg13cmos5l_decap_8
XFILLER_91_42 VPWR VGND sg13cmos5l_fill_2
XFILLER_488_63 VPWR VGND sg13cmos5l_decap_8
XFILLER_431_0 VPWR VGND sg13cmos5l_decap_8
XFILLER_91_75 VPWR VGND sg13cmos5l_decap_8
XFILLER_529_0 VPWR VGND sg13cmos5l_decap_8
XFILLER_537_225 VPWR VGND sg13cmos5l_decap_8
XFILLER_638_77 VPWR VGND sg13cmos5l_decap_8
XFILLER_357_56 VPWR VGND sg13cmos5l_decap_8
X_0730_ _0730_/Q Tile_X0Y9_FrameData[5] VGND VPWR Tile_X0Y9_FrameStrobe[1] latch
XFILLER_505_122 VPWR VGND sg13cmos5l_decap_8
XFILLER_654_21 VPWR VGND sg13cmos5l_decap_8
XFILLER_155_264 VPWR VGND sg13cmos5l_fill_1
XFILLER_115_117 VPWR VGND sg13cmos5l_decap_4
X_0661_ _0661_/Q Tile_X0Y8_FrameData[10] VGND VPWR Tile_X0Y9_FrameStrobe[7] latch
XFILLER_371_161 VPWR VGND sg13cmos5l_fill_1
XFILLER_304_206 VPWR VGND sg13cmos5l_decap_8
XFILLER_115_128 VPWR VGND sg13cmos5l_decap_8
XFILLER_170_223 VPWR VGND sg13cmos5l_fill_1
XFILLER_505_177 VPWR VGND sg13cmos5l_decap_8
X_2400_ _2400_/Q Tile_X0Y5_FrameData[5] VGND VPWR Tile_X0Y9_FrameStrobe[6] latch
XFILLER_654_76 VPWR VGND sg13cmos5l_decap_8
XFILLER_371_183 VPWR VGND sg13cmos5l_decap_8
XFILLER_371_194 VPWR VGND sg13cmos5l_fill_2
X_3380_ Tile_X0Y2_E6BEG[3] _4075_/X VPWR VGND sg13cmos5l_buf_1
XFILLER_226_49 VPWR VGND sg13cmos5l_decap_8
X_0592_ _0592_/Q Tile_X0Y8_FrameData[15] VGND VPWR Tile_X0Y9_FrameStrobe[5] latch
XFILLER_520_147 VPWR VGND sg13cmos5l_decap_8
X_2331_ _2331_/Q Tile_X0Y5_FrameData[10] VGND VPWR Tile_X0Y9_FrameStrobe[4] latch
XFILLER_123_161 VPWR VGND sg13cmos5l_decap_8
XFILLER_523_14 VPWR VGND sg13cmos5l_decap_8
XFILLER_458_254 VPWR VGND sg13cmos5l_decap_8
XANTENNA__3334__X Tile_X0Y2_FrameData_O[5] VPWR VGND sg13cmos5l_antennanp
XFILLER_312_272 VPWR VGND sg13cmos5l_fill_1
XFILLER_670_42 VPWR VGND sg13cmos5l_decap_8
XFILLER_607_207 VPWR VGND sg13cmos5l_decap_4
X_2262_ _2262_/Q Tile_X0Y5_FrameData[15] VGND VPWR Tile_X0Y9_FrameStrobe[2] latch
XFILLER_69_259 VPWR VGND sg13cmos5l_decap_8
XFILLER_418_118 VPWR VGND sg13cmos5l_decap_4
XFILLER_418_129 VPWR VGND sg13cmos5l_decap_8
X_4001_ _4001_/X _4456_/X _4460_/X _4464_/X _4430_/X _2412_/Q _2411_/Q VPWR VGND sg13cmos5l_mux4_1
XFILLER_670_86 VPWR VGND sg13cmos5l_fill_1
XFILLER_84_218 VPWR VGND sg13cmos5l_decap_4
X_1213_ _1213_/Q Tile_X0Y1_FrameData[28] VGND VPWR Tile_X0Y9_FrameStrobe[1] latch
XFILLER_37_101 VPWR VGND sg13cmos5l_decap_8
X_2193_ _2193_/Q Tile_X0Y5_FrameData[20] VGND VPWR Tile_X0Y9_FrameStrobe[0] latch
XFILLER_284_168 VPWR VGND sg13cmos5l_decap_8
XFILLER_426_140 VPWR VGND sg13cmos5l_decap_8
XFILLER_37_112 VPWR VGND sg13cmos5l_fill_2
X_1144_ _1144_/Q Tile_X0Y0_FrameData[19] VGND VPWR Tile_X0Y9_FrameStrobe[6] latch
XFILLER_441_110 VPWR VGND sg13cmos5l_decap_8
XFILLER_225_246 VPWR VGND sg13cmos5l_fill_1
XFILLER_1_95 VPWR VGND sg13cmos5l_decap_8
XFILLER_679_51 VPWR VGND sg13cmos5l_decap_8
X_1075_ _1075_/Q Tile_X0Y0_FrameData[24] VGND VPWR Tile_X0Y9_FrameStrobe[4] latch
XFILLER_679_84 VPWR VGND sg13cmos5l_decap_8
XFILLER_240_205 VPWR VGND sg13cmos5l_decap_4
XFILLER_52_137 VPWR VGND sg13cmos5l_fill_1
XFILLER_197_109 VPWR VGND sg13cmos5l_decap_8
X_4903_ _4903_/X Tile_X0Y9_N2MID[1] Tile_X0Y9_N2END[1] _4933_/X _4817_/X _0693_/Q
+ _0692_/Q VPWR VGND sg13cmos5l_mux4_1
XFILLER_52_159 VPWR VGND sg13cmos5l_decap_8
XFILLER_441_187 VPWR VGND sg13cmos5l_decap_4
XFILLER_398_63 VPWR VGND sg13cmos5l_decap_8
XFILLER_441_198 VPWR VGND sg13cmos5l_fill_1
XFILLER_379_272 VPWR VGND sg13cmos5l_fill_1
X_4834_ _4834_/X Tile_X0Y9_W1END[2] Tile_X0Y9_W2MID[1] Tile_X0Y9_W2END[1] _4902_/X
+ _0871_/Q _0870_/Q VPWR VGND sg13cmos5l_mux4_1
XFILLER_60_181 VPWR VGND sg13cmos5l_decap_8
XFILLER_339_147 VPWR VGND sg13cmos5l_decap_8
XFILLER_548_77 VPWR VGND sg13cmos5l_decap_8
XFILLER_543_206 VPWR VGND sg13cmos5l_fill_2
X_4765_ _4765_/X AXI_M_SOC_RDATA9 _4806_/X _4810_/X _4787_/X _0517_/Q _0516_/Q VPWR
+ VGND sg13cmos5l_mux4_1
X_1977_ _1977_/Q Tile_X0Y4_FrameData[12] VGND VPWR Tile_X0Y9_FrameStrobe[1] latch
XANTENNA__3509__X Tile_X0Y1_E2BEGb[7] VPWR VGND sg13cmos5l_antennanp
XFILLER_267_56 VPWR VGND sg13cmos5l_decap_8
XFILLER_347_180 VPWR VGND sg13cmos5l_decap_8
X_3716_ AXI_M_SOC_WDATA26 Tile_X0Y6_WW4END[2] Tile_X0Y6_WW4END[10] Tile_X0Y6_W6END[10]
+ _4578_/X _2507_/Q _2506_/Q VPWR VGND sg13cmos5l_mux4_1
X_0928_ _0928_/Q Tile_X0Y9_FrameData[31] VGND VPWR Tile_X0Y9_FrameStrobe[0] latch
X_4696_ _4696_/X _4661_/X Tile_X0Y9_N4END[8] _4660_/X _0056_/X _0191_/Q _0190_/Q VPWR
+ VGND sg13cmos5l_mux4_1
XFILLER_564_21 VPWR VGND sg13cmos5l_decap_8
XFILLER_146_264 VPWR VGND sg13cmos5l_fill_1
XFILLER_697_232 VPWR VGND sg13cmos5l_decap_8
XFILLER_106_117 VPWR VGND sg13cmos5l_fill_2
X_0859_ _0859_/Q Tile_X0Y9_FrameData[4] VGND VPWR Tile_X0Y9_FrameStrobe[5] latch
X_3647_ AXI_M_SOC_AWADDR8 Tile_X0Y5_WW4END[0] Tile_X0Y5_WW4END[8] Tile_X0Y5_W6END[8]
+ _4459_/X _2255_/Q _2254_/Q VPWR VGND sg13cmos5l_mux4_1
XFILLER_161_223 VPWR VGND sg13cmos5l_decap_8
XFILLER_551_272 VPWR VGND sg13cmos5l_fill_1
XFILLER_20_49 VPWR VGND sg13cmos5l_decap_8
XFILLER_136_49 VPWR VGND sg13cmos5l_decap_8
XFILLER_564_98 VPWR VGND sg13cmos5l_decap_8
XFILLER_714_35 VPWR VGND sg13cmos5l_decap_8
X_3578_ Tile_X0Y9_FrameData_O[8] Tile_X0Y9_FrameData[8] VPWR VGND sg13cmos5l_buf_1
XFILLER_283_77 VPWR VGND sg13cmos5l_decap_8
X_2529_ _2529_/Q Tile_X0Y6_FrameData[6] VGND VPWR Tile_X0Y9_FrameStrobe[2] latch
XFILLER_433_14 VPWR VGND sg13cmos5l_decap_8
XANTENNA__3244__X Tile_X0Y0_FrameData_O[12] VPWR VGND sg13cmos5l_antennanp
XFILLER_449_254 VPWR VGND sg13cmos5l_decap_8
XFILLER_303_272 VPWR VGND sg13cmos5l_fill_1
XFILLER_29_14 VPWR VGND sg13cmos5l_decap_8
XFILLER_665_151 VPWR VGND sg13cmos5l_decap_8
XFILLER_580_42 VPWR VGND sg13cmos5l_decap_8
XFILLER_188_7 VPWR VGND sg13cmos5l_decap_8
XFILLER_513_91 VPWR VGND sg13cmos5l_decap_8
XFILLER_216_224 VPWR VGND sg13cmos5l_decap_8
XFILLER_680_187 VPWR VGND sg13cmos5l_decap_8
XFILLER_28_145 VPWR VGND sg13cmos5l_decap_8
XFILLER_83_251 VPWR VGND sg13cmos5l_decap_8
XFILLER_83_262 VPWR VGND sg13cmos5l_fill_1
XFILLER_355_7 VPWR VGND sg13cmos5l_decap_8
XFILLER_432_154 VPWR VGND sg13cmos5l_decap_8
XFILLER_578_147 VPWR VGND sg13cmos5l_decap_8
XFILLER_45_79 VPWR VGND sg13cmos5l_decap_8
XFILLER_432_198 VPWR VGND sg13cmos5l_fill_1
XANTENNA__0108__X AXI_M_SOC_ARBURST0 VPWR VGND sg13cmos5l_antennanp
XFILLER_522_7 VPWR VGND sg13cmos5l_decap_8
XFILLER_51_170 VPWR VGND sg13cmos5l_decap_8
XFILLER_196_142 VPWR VGND sg13cmos5l_decap_8
XFILLER_61_23 VPWR VGND sg13cmos5l_fill_1
XFILLER_458_44 VPWR VGND sg13cmos5l_fill_1
XFILLER_385_253 VPWR VGND sg13cmos5l_decap_8
XFILLER_385_264 VPWR VGND sg13cmos5l_fill_1
XFILLER_61_56 VPWR VGND sg13cmos5l_decap_8
XFILLER_345_106 VPWR VGND sg13cmos5l_decap_8
XFILLER_608_14 VPWR VGND sg13cmos5l_decap_8
XANTENNA__3419__X Tile_X0Y4_FrameData_O[10] VPWR VGND sg13cmos5l_antennanp
XFILLER_534_228 VPWR VGND sg13cmos5l_fill_2
XFILLER_177_67 VPWR VGND sg13cmos5l_decap_8
XFILLER_403_4 VPWR VGND sg13cmos5l_fill_1
XFILLER_327_15 VPWR VGND sg13cmos5l_decap_8
XFILLER_474_21 VPWR VGND sg13cmos5l_decap_8
XFILLER_353_161 VPWR VGND sg13cmos5l_decap_8
XFILLER_499_154 VPWR VGND sg13cmos5l_decap_8
XFILLER_327_59 VPWR VGND sg13cmos5l_decap_8
XFILLER_542_272 VPWR VGND sg13cmos5l_fill_1
XFILLER_152_234 VPWR VGND sg13cmos5l_decap_8
XFILLER_152_245 VPWR VGND sg13cmos5l_fill_1
XFILLER_474_98 VPWR VGND sg13cmos5l_decap_8
XFILLER_502_147 VPWR VGND sg13cmos5l_decap_8
XFILLER_624_35 VPWR VGND sg13cmos5l_decap_8
XFILLER_407_70 VPWR VGND sg13cmos5l_decap_8
XFILLER_343_14 VPWR VGND sg13cmos5l_decap_8
XANTENNA__3154__X Tile_X0Y7_FrameData_O[24] VPWR VGND sg13cmos5l_antennanp
XFILLER_105_194 VPWR VGND sg13cmos5l_fill_1
XFILLER_490_42 VPWR VGND sg13cmos5l_decap_8
XFILLER_86_42 VPWR VGND sg13cmos5l_decap_8
XFILLER_656_173 VPWR VGND sg13cmos5l_fill_2
XFILLER_510_180 VPWR VGND sg13cmos5l_decap_8
XFILLER_381_0 VPWR VGND sg13cmos5l_decap_8
XANTENNA__2993__X Tile_X0Y5_E1BEG[0] VPWR VGND sg13cmos5l_antennanp
XFILLER_479_0 VPWR VGND sg13cmos5l_decap_8
XFILLER_266_157 VPWR VGND sg13cmos5l_fill_2
XFILLER_281_105 VPWR VGND sg13cmos5l_decap_8
XFILLER_640_56 VPWR VGND sg13cmos5l_decap_8
XFILLER_423_91 VPWR VGND sg13cmos5l_decap_8
XFILLER_408_151 VPWR VGND sg13cmos5l_decap_8
XFILLER_470_227 VPWR VGND sg13cmos5l_decap_8
XFILLER_19_91 VPWR VGND sg13cmos5l_fill_2
XFILLER_142_70 VPWR VGND sg13cmos5l_decap_8
XFILLER_671_198 VPWR VGND sg13cmos5l_decap_8
XFILLER_646_0 VPWR VGND sg13cmos5l_decap_8
XFILLER_423_154 VPWR VGND sg13cmos5l_fill_1
XFILLER_34_126 VPWR VGND sg13cmos5l_decap_8
XFILLER_569_147 VPWR VGND sg13cmos5l_decap_8
XFILLER_499_84 VPWR VGND sg13cmos5l_decap_8
XFILLER_34_137 VPWR VGND sg13cmos5l_fill_1
XFILLER_649_21 VPWR VGND sg13cmos5l_decap_8
XFILLER_612_265 VPWR VGND sg13cmos5l_decap_8
XFILLER_368_22 VPWR VGND sg13cmos5l_decap_8
XFILLER_187_131 VPWR VGND sg13cmos5l_decap_8
X_1900_ _1900_/Q Tile_X0Y3_FrameData[29] VGND VPWR Tile_X0Y9_FrameStrobe[7] latch
X_2880_ Tile_X0Y6_FrameData_O[1] Tile_X0Y6_FrameData[1] VPWR VGND sg13cmos5l_buf_1
XFILLER_649_98 VPWR VGND sg13cmos5l_decap_8
XFILLER_42_192 VPWR VGND sg13cmos5l_fill_1
XFILLER_230_271 VPWR VGND sg13cmos5l_fill_2
X_1831_ _1831_/Q Tile_X0Y3_FrameData[2] VGND VPWR Tile_X0Y9_FrameStrobe[4] latch
XFILLER_368_88 VPWR VGND sg13cmos5l_fill_1
XFILLER_518_14 VPWR VGND sg13cmos5l_decap_8
XFILLER_336_117 VPWR VGND sg13cmos5l_decap_8
XANTENNA__3329__X Tile_X0Y2_FrameData_O[0] VPWR VGND sg13cmos5l_antennanp
XFILLER_128_220 VPWR VGND sg13cmos5l_decap_8
XFILLER_665_42 VPWR VGND sg13cmos5l_decap_8
XFILLER_592_194 VPWR VGND sg13cmos5l_decap_4
XFILLER_329_180 VPWR VGND sg13cmos5l_decap_8
X_1762_ _1762_/Q Tile_X0Y3_FrameData[7] VGND VPWR Tile_X0Y9_FrameStrobe[2] latch
X_4550_ _4550_/X Tile_X0Y5_W1END[3] Tile_X0Y5_W6END[11] _4466_/X _4425_/X _2397_/Q
+ _2396_/Q VPWR VGND sg13cmos5l_mux4_1
XFILLER_391_245 VPWR VGND sg13cmos5l_decap_8
XFILLER_384_21 VPWR VGND sg13cmos5l_decap_8
X_0713_ _0713_/Q Tile_X0Y9_FrameData[22] VGND VPWR Tile_X0Y9_FrameStrobe[1] latch
X_3501_ Tile_X0Y1_E6BEG[11] _3975_/X VPWR VGND sg13cmos5l_buf_1
XFILLER_344_161 VPWR VGND sg13cmos5l_decap_8
X_1693_ _1693_/Q Tile_X0Y3_FrameData[12] VGND VPWR Tile_X0Y9_FrameStrobe[0] latch
X_4481_ _4481_/X Tile_X0Y7_W2MID[1] Tile_X0Y7_W2END[1] Tile_X0Y7_W6END[1] _4670_/X
+ _0395_/Q _0394_/Q VPWR VGND sg13cmos5l_mux4_1
XFILLER_384_54 VPWR VGND sg13cmos5l_decap_4
XFILLER_384_65 VPWR VGND sg13cmos5l_decap_8
XFILLER_289_205 VPWR VGND sg13cmos5l_decap_8
X_0644_ _0644_/Q Tile_X0Y8_FrameData[27] VGND VPWR Tile_X0Y9_FrameStrobe[7] latch
X_3432_ Tile_X0Y4_FrameData_O[23] Tile_X0Y4_FrameData[23] VPWR VGND sg13cmos5l_buf_1
XFILLER_534_35 VPWR VGND sg13cmos5l_decap_8
X_3363_ Tile_X0Y2_EE4BEG[2] _4058_/X VPWR VGND sg13cmos5l_buf_1
XFILLER_253_14 VPWR VGND sg13cmos5l_decap_8
X_0575_ _0575_/Q Tile_X0Y8_FrameData[0] VGND VPWR Tile_X0Y9_FrameStrobe[4] latch
XFILLER_694_268 VPWR VGND sg13cmos5l_decap_4
XANTENNA__3064__X Tile_X0Y5_FrameData_O[23] VPWR VGND sg13cmos5l_antennanp
XFILLER_647_140 VPWR VGND sg13cmos5l_decap_8
XFILLER_297_260 VPWR VGND sg13cmos5l_fill_1
XFILLER_681_96 VPWR VGND sg13cmos5l_decap_4
XFILLER_297_271 VPWR VGND sg13cmos5l_fill_2
X_2314_ _2314_/Q Tile_X0Y5_FrameData[27] VGND VPWR Tile_X0Y9_FrameStrobe[4] latch
X_3294_ Tile_X0Y0_E2BEGb[2] _3814_/X VPWR VGND sg13cmos5l_buf_1
XFILLER_111_153 VPWR VGND sg13cmos5l_decap_8
XFILLER_25_0 VPWR VGND sg13cmos5l_decap_8
X_2245_ _2245_/Q Tile_X0Y5_FrameData[0] VGND VPWR Tile_X0Y9_FrameStrobe[1] latch
XFILLER_446_268 VPWR VGND sg13cmos5l_decap_4
XFILLER_257_179 VPWR VGND sg13cmos5l_decap_8
XFILLER_550_56 VPWR VGND sg13cmos5l_decap_8
XFILLER_272_116 VPWR VGND sg13cmos5l_decap_8
XFILLER_662_176 VPWR VGND sg13cmos5l_decap_8
XFILLER_272_127 VPWR VGND sg13cmos5l_fill_1
X_2176_ _2176_/Q Tile_X0Y4_FrameData[5] VGND VPWR Tile_X0Y9_FrameStrobe[7] latch
XFILLER_272_138 VPWR VGND sg13cmos5l_fill_1
X_1127_ _1127_/Q Tile_X0Y0_FrameData[4] VGND VPWR Tile_X0Y9_FrameStrobe[5] latch
XFILLER_25_115 VPWR VGND sg13cmos5l_fill_2
XFILLER_603_243 VPWR VGND sg13cmos5l_decap_8
XFILLER_414_165 VPWR VGND sg13cmos5l_decap_4
XFILLER_559_21 VPWR VGND sg13cmos5l_decap_8
XFILLER_414_176 VPWR VGND sg13cmos5l_decap_8
XFILLER_280_182 VPWR VGND sg13cmos5l_decap_8
XFILLER_25_159 VPWR VGND sg13cmos5l_decap_8
X_1058_ _1058_/Q Tile_X0Y0_FrameData[9] VGND VPWR Tile_X0Y9_FrameStrobe[3] latch
XFILLER_202_84 VPWR VGND sg13cmos5l_decap_8
XFILLER_15_49 VPWR VGND sg13cmos5l_decap_8
XFILLER_559_98 VPWR VGND sg13cmos5l_decap_8
XFILLER_709_35 VPWR VGND sg13cmos5l_decap_8
XFILLER_717_144 VPWR VGND sg13cmos5l_decap_8
X_4817_ _4817_/X Tile_X0Y7_W2MID[6] Tile_X0Y7_W2END[6] Tile_X0Y7_W6END[9] _4671_/X
+ _0369_/Q _0368_/Q VPWR VGND sg13cmos5l_mux4_1
XFILLER_278_77 VPWR VGND sg13cmos5l_decap_8
XFILLER_428_14 VPWR VGND sg13cmos5l_decap_8
XANTENNA__3239__X Tile_X0Y0_FrameData_O[7] VPWR VGND sg13cmos5l_antennanp
XFILLER_516_228 VPWR VGND sg13cmos5l_decap_4
XFILLER_717_188 VPWR VGND sg13cmos5l_decap_4
XFILLER_575_42 VPWR VGND sg13cmos5l_decap_8
XFILLER_119_242 VPWR VGND sg13cmos5l_decap_8
X_4748_ _4748_/X Tile_X0Y8_WW4END[11] AXI_M_SOC_RDATA12 _4811_/X _4791_/X _0551_/Q
+ _0550_/Q VPWR VGND sg13cmos5l_mux4_1
XFILLER_294_21 VPWR VGND sg13cmos5l_decap_8
XFILLER_134_212 VPWR VGND sg13cmos5l_decap_8
X_4679_ _4679_/X _4227_/X _4231_/X _4235_/X _4208_/X _1862_/Q _1861_/Q VPWR VGND sg13cmos5l_mux4_1
XFILLER_524_272 VPWR VGND sg13cmos5l_fill_1
XFILLER_508_91 VPWR VGND sg13cmos5l_decap_8
XFILLER_103_7 VPWR VGND sg13cmos5l_decap_8
XFILLER_134_256 VPWR VGND sg13cmos5l_fill_1
XFILLER_294_98 VPWR VGND sg13cmos5l_decap_8
XFILLER_444_35 VPWR VGND sg13cmos5l_decap_8
XFILLER_591_63 VPWR VGND sg13cmos5l_decap_8
XFILLER_163_14 VPWR VGND sg13cmos5l_decap_8
XFILLER_685_257 VPWR VGND sg13cmos5l_decap_8
XFILLER_496_168 VPWR VGND sg13cmos5l_decap_8
XFILLER_638_140 VPWR VGND sg13cmos5l_decap_8
XFILLER_472_7 VPWR VGND sg13cmos5l_decap_8
XFILLER_437_268 VPWR VGND sg13cmos5l_decap_4
XFILLER_313_28 VPWR VGND sg13cmos5l_decap_4
XFILLER_248_168 VPWR VGND sg13cmos5l_decap_8
XANTENNA__3702__X AXI_M_SOC_WDATA12 VPWR VGND sg13cmos5l_antennanp
XFILLER_263_116 VPWR VGND sg13cmos5l_decap_8
XFILLER_56_67 VPWR VGND sg13cmos5l_decap_8
XFILLER_256_190 VPWR VGND sg13cmos5l_decap_8
XFILLER_16_115 VPWR VGND sg13cmos5l_fill_1
XFILLER_71_210 VPWR VGND sg13cmos5l_decap_4
XFILLER_405_165 VPWR VGND sg13cmos5l_decap_8
XFILLER_469_21 VPWR VGND sg13cmos5l_decap_8
XFILLER_271_182 VPWR VGND sg13cmos5l_decap_4
XFILLER_469_54 VPWR VGND sg13cmos5l_decap_8
XFILLER_469_87 VPWR VGND sg13cmos5l_decap_8
XFILLER_24_170 VPWR VGND sg13cmos5l_decap_4
XFILLER_358_231 VPWR VGND sg13cmos5l_decap_8
XFILLER_212_260 VPWR VGND sg13cmos5l_decap_4
XFILLER_619_35 VPWR VGND sg13cmos5l_decap_8
XFILLER_169_175 VPWR VGND sg13cmos5l_decap_8
XFILLER_188_77 VPWR VGND sg13cmos5l_decap_8
XFILLER_574_161 VPWR VGND sg13cmos5l_decap_8
XFILLER_338_14 VPWR VGND sg13cmos5l_decap_8
XFILLER_373_212 VPWR VGND sg13cmos5l_decap_8
XANTENNA__3149__X Tile_X0Y7_FrameData_O[19] VPWR VGND sg13cmos5l_antennanp
XFILLER_184_134 VPWR VGND sg13cmos5l_decap_8
XFILLER_227_0 VPWR VGND sg13cmos5l_decap_4
XFILLER_485_42 VPWR VGND sg13cmos5l_decap_8
XFILLER_318_139 VPWR VGND sg13cmos5l_decap_8
XFILLER_373_256 VPWR VGND sg13cmos5l_decap_8
XANTENNA__2988__X Tile_X0Y8_FrameData_O[28] VPWR VGND sg13cmos5l_antennanp
XFILLER_515_261 VPWR VGND sg13cmos5l_fill_1
XFILLER_635_56 VPWR VGND sg13cmos5l_decap_8
XFILLER_341_131 VPWR VGND sg13cmos5l_decap_4
XFILLER_137_70 VPWR VGND sg13cmos5l_decap_8
XFILLER_354_35 VPWR VGND sg13cmos5l_decap_8
XFILLER_530_253 VPWR VGND sg13cmos5l_decap_8
XFILLER_487_146 VPWR VGND sg13cmos5l_decap_8
XFILLER_596_0 VPWR VGND sg13cmos5l_decap_8
XFILLER_341_186 VPWR VGND sg13cmos5l_decap_8
XFILLER_691_205 VPWR VGND sg13cmos5l_decap_8
XFILLER_279_271 VPWR VGND sg13cmos5l_fill_2
X_0360_ _0360_/Q Tile_X0Y7_FrameData[23] VGND VPWR Tile_X0Y9_FrameStrobe[6] latch
XFILLER_691_238 VPWR VGND sg13cmos5l_decap_8
XFILLER_504_49 VPWR VGND sg13cmos5l_decap_8
XFILLER_428_224 VPWR VGND sg13cmos5l_decap_8
XFILLER_294_230 VPWR VGND sg13cmos5l_fill_1
XFILLER_651_77 VPWR VGND sg13cmos5l_decap_8
X_0291_ _0291_/Q Tile_X0Y7_FrameData[28] VGND VPWR Tile_X0Y9_FrameStrobe[4] latch
XANTENNA__3612__X Tile_X0Y9_S2BEG[6] VPWR VGND sg13cmos5l_antennanp
XFILLER_644_154 VPWR VGND sg13cmos5l_decap_8
X_2030_ _2030_/Q Tile_X0Y4_FrameData[23] VGND VPWR Tile_X0Y9_FrameStrobe[3] latch
XFILLER_443_227 VPWR VGND sg13cmos5l_fill_1
XFILLER_303_50 VPWR VGND sg13cmos5l_decap_8
XFILLER_62_210 VPWR VGND sg13cmos5l_decap_8
XFILLER_597_231 VPWR VGND sg13cmos5l_decap_8
XFILLER_597_242 VPWR VGND sg13cmos5l_fill_1
XFILLER_379_21 VPWR VGND sg13cmos5l_decap_8
XFILLER_411_113 VPWR VGND sg13cmos5l_decap_8
XFILLER_22_107 VPWR VGND sg13cmos5l_decap_8
X_3981_ _3981_/X Tile_X0Y2_W1END[0] Tile_X0Y2_W6END[4] _4113_/X _4084_/X _1673_/Q
+ _1672_/Q VPWR VGND sg13cmos5l_mux4_1
X_2932_ Tile_X0Y8_E6BEG[0] _4760_/X VPWR VGND sg13cmos5l_buf_1
XFILLER_203_260 VPWR VGND sg13cmos5l_fill_2
XFILLER_379_98 VPWR VGND sg13cmos5l_decap_8
XFILLER_15_192 VPWR VGND sg13cmos5l_decap_8
XFILLER_529_35 VPWR VGND sg13cmos5l_decap_8
XFILLER_203_271 VPWR VGND sg13cmos5l_fill_2
XFILLER_676_63 VPWR VGND sg13cmos5l_decap_8
X_2863_ Tile_X0Y6_EE4BEG[0] _4512_/X VPWR VGND sg13cmos5l_buf_1
XFILLER_565_161 VPWR VGND sg13cmos5l_decap_8
XFILLER_248_14 VPWR VGND sg13cmos5l_decap_8
XANTENNA__3059__X Tile_X0Y5_FrameData_O[18] VPWR VGND sg13cmos5l_antennanp
XFILLER_364_223 VPWR VGND sg13cmos5l_decap_8
XFILLER_175_134 VPWR VGND sg13cmos5l_decap_8
X_4602_ _4602_/X Tile_X0Y7_W1END[1] Tile_X0Y7_WW4END[13] Tile_X0Y7_W6END[5] _4685_/X
+ _0352_/Q _0351_/Q VPWR VGND sg13cmos5l_mux4_1
X_1814_ _1814_/Q Tile_X0Y3_FrameData[19] VGND VPWR Tile_X0Y9_FrameStrobe[4] latch
XFILLER_395_64 VPWR VGND sg13cmos5l_decap_8
XFILLER_714_147 VPWR VGND sg13cmos5l_decap_8
X_2794_ Tile_X0Y3_E6BEG[4] _4184_/X VPWR VGND sg13cmos5l_buf_1
XANTENNA__2898__X Tile_X0Y6_FrameData_O[19] VPWR VGND sg13cmos5l_antennanp
XFILLER_190_126 VPWR VGND sg13cmos5l_decap_4
X_4533_ _4533_/X AXI_M_SOC_RDATA25 _4574_/X _4578_/X _4555_/X _2541_/Q _2540_/Q VPWR
+ VGND sg13cmos5l_mux4_1
XFILLER_116_212 VPWR VGND sg13cmos5l_decap_8
X_1745_ _1745_/Q Tile_X0Y3_FrameData[24] VGND VPWR Tile_X0Y9_FrameStrobe[2] latch
XFILLER_580_186 VPWR VGND sg13cmos5l_decap_8
XFILLER_580_197 VPWR VGND sg13cmos5l_fill_1
XFILLER_545_56 VPWR VGND sg13cmos5l_decap_8
XFILLER_190_159 VPWR VGND sg13cmos5l_decap_8
XFILLER_692_73 VPWR VGND sg13cmos5l_decap_8
X_4464_ _4464_/X _4421_/X _0159_/X _4420_/X _0145_/X _2211_/Q _2210_/Q VPWR VGND sg13cmos5l_mux4_1
X_1676_ _1676_/Q Tile_X0Y3_FrameData[29] VGND VPWR Tile_X0Y9_FrameStrobe[0] latch
XFILLER_264_35 VPWR VGND sg13cmos5l_decap_8
XFILLER_667_235 VPWR VGND sg13cmos5l_decap_8
X_3415_ Tile_X0Y4_FrameData_O[6] Tile_X0Y4_FrameData[6] VPWR VGND sg13cmos5l_buf_1
X_0627_ _0627_/Q Tile_X0Y8_FrameData[12] VGND VPWR Tile_X0Y9_FrameStrobe[6] latch
XFILLER_332_186 VPWR VGND sg13cmos5l_decap_8
X_4395_ _4395_/X Tile_X0Y5_WW4END[8] AXI_M_SOC_RRESP1 _4459_/X _4467_/X _2313_/Q _2312_/Q
+ VPWR VGND sg13cmos5l_mux4_1
XFILLER_493_105 VPWR VGND sg13cmos5l_decap_8
XFILLER_682_227 VPWR VGND sg13cmos5l_decap_4
X_0558_ _0558_/Q Tile_X0Y8_FrameData[17] VGND VPWR Tile_X0Y9_FrameStrobe[4] latch
X_3346_ Tile_X0Y2_FrameData_O[17] Tile_X0Y2_FrameData[17] VPWR VGND sg13cmos5l_buf_1
XFILLER_419_224 VPWR VGND sg13cmos5l_decap_8
XFILLER_414_49 VPWR VGND sg13cmos5l_decap_8
XFILLER_486_190 VPWR VGND sg13cmos5l_fill_2
XFILLER_344_90 VPWR VGND sg13cmos5l_decap_8
XFILLER_133_28 VPWR VGND sg13cmos5l_decap_8
XFILLER_561_77 VPWR VGND sg13cmos5l_decap_8
XFILLER_285_252 VPWR VGND sg13cmos5l_decap_8
XFILLER_97_195 VPWR VGND sg13cmos5l_decap_8
XFILLER_711_14 VPWR VGND sg13cmos5l_decap_8
X_0489_ _0489_/Q Tile_X0Y8_FrameData[22] VGND VPWR Tile_X0Y9_FrameStrobe[2] latch
X_3277_ Tile_X0Y0_EE4BEG[13] _3833_/X VPWR VGND sg13cmos5l_buf_1
XFILLER_635_154 VPWR VGND sg13cmos5l_decap_8
XANTENNA__3522__X Tile_X0Y9_E1BEG[0] VPWR VGND sg13cmos5l_antennanp
XFILLER_280_56 VPWR VGND sg13cmos5l_decap_8
X_2228_ _2228_/Q Tile_X0Y5_FrameData[17] VGND VPWR Tile_X0Y9_FrameStrobe[1] latch
XANTENNA_209 Tile_X0Y9_N4END[14] VPWR VGND sg13cmos5l_antennanp
X_2159_ _2159_/Q Tile_X0Y4_FrameData[22] VGND VPWR Tile_X0Y9_FrameStrobe[7] latch
XFILLER_53_210 VPWR VGND sg13cmos5l_decap_8
XFILLER_399_131 VPWR VGND sg13cmos5l_decap_4
XFILLER_650_168 VPWR VGND sg13cmos5l_decap_8
XFILLER_399_142 VPWR VGND sg13cmos5l_decap_8
XFILLER_588_253 VPWR VGND sg13cmos5l_decap_8
XFILLER_289_21 VPWR VGND sg13cmos5l_decap_8
XFILLER_158_8 VPWR VGND sg13cmos5l_decap_8
XFILLER_510_70 VPWR VGND sg13cmos5l_decap_8
XFILLER_198_248 VPWR VGND sg13cmos5l_decap_4
XFILLER_548_128 VPWR VGND sg13cmos5l_fill_1
XFILLER_439_35 VPWR VGND sg13cmos5l_decap_8
XFILLER_42_14 VPWR VGND sg13cmos5l_fill_2
XFILLER_21_140 VPWR VGND sg13cmos5l_fill_2
XFILLER_586_63 VPWR VGND sg13cmos5l_decap_8
XFILLER_158_36 VPWR VGND sg13cmos5l_decap_8
XFILLER_220_7 VPWR VGND sg13cmos5l_decap_8
XFILLER_355_245 VPWR VGND sg13cmos5l_decap_4
XFILLER_166_178 VPWR VGND sg13cmos5l_decap_8
XFILLER_504_209 VPWR VGND sg13cmos5l_decap_8
XFILLER_308_150 VPWR VGND sg13cmos5l_decap_8
XANTENNA__0105__Y AXI_M_SOC_ARLEN4 VPWR VGND sg13cmos5l_antennanp
XFILLER_571_175 VPWR VGND sg13cmos5l_decap_8
XFILLER_308_28 VPWR VGND sg13cmos5l_decap_8
XFILLER_308_172 VPWR VGND sg13cmos5l_decap_4
XFILLER_713_180 VPWR VGND sg13cmos5l_decap_8
XFILLER_174_35 VPWR VGND sg13cmos5l_decap_4
XFILLER_512_253 VPWR VGND sg13cmos5l_decap_8
XFILLER_323_153 VPWR VGND sg13cmos5l_decap_8
XFILLER_687_7 VPWR VGND sg13cmos5l_decap_8
XFILLER_673_216 VPWR VGND sg13cmos5l_decap_8
XFILLER_107_95 VPWR VGND sg13cmos5l_decap_8
XFILLER_276_252 VPWR VGND sg13cmos5l_decap_8
XFILLER_621_14 VPWR VGND sg13cmos5l_decap_8
XFILLER_67_77 VPWR VGND sg13cmos5l_decap_8
XANTENNA__3432__X Tile_X0Y4_FrameData_O[23] VPWR VGND sg13cmos5l_antennanp
XFILLER_681_260 VPWR VGND sg13cmos5l_fill_2
XFILLER_492_182 VPWR VGND sg13cmos5l_decap_8
XFILLER_425_238 VPWR VGND sg13cmos5l_decap_8
XFILLER_229_190 VPWR VGND sg13cmos5l_decap_8
XFILLER_425_249 VPWR VGND sg13cmos5l_decap_8
XFILLER_177_0 VPWR VGND sg13cmos5l_decap_4
XFILLER_83_21 VPWR VGND sg13cmos5l_decap_8
XFILLER_641_168 VPWR VGND sg13cmos5l_decap_8
XFILLER_433_260 VPWR VGND sg13cmos5l_fill_2
XFILLER_199_21 VPWR VGND sg13cmos5l_decap_8
XFILLER_701_91 VPWR VGND sg13cmos5l_decap_8
XFILLER_579_253 VPWR VGND sg13cmos5l_fill_2
XFILLER_83_65 VPWR VGND sg13cmos5l_decap_8
XFILLER_433_271 VPWR VGND sg13cmos5l_fill_2
XFILLER_420_70 VPWR VGND sg13cmos5l_decap_8
XFILLER_344_0 VPWR VGND sg13cmos5l_decap_8
XFILLER_16_70 VPWR VGND sg13cmos5l_decap_8
XFILLER_349_35 VPWR VGND sg13cmos5l_decap_8
XFILLER_547_150 VPWR VGND sg13cmos5l_decap_8
XFILLER_547_161 VPWR VGND sg13cmos5l_fill_1
XFILLER_496_63 VPWR VGND sg13cmos5l_decap_8
XFILLER_200_230 VPWR VGND sg13cmos5l_decap_8
XFILLER_511_0 VPWR VGND sg13cmos5l_decap_8
XFILLER_12_173 VPWR VGND sg13cmos5l_decap_8
XFILLER_609_0 VPWR VGND sg13cmos5l_decap_8
XFILLER_157_145 VPWR VGND sg13cmos5l_decap_8
XFILLER_346_245 VPWR VGND sg13cmos5l_fill_1
XFILLER_157_178 VPWR VGND sg13cmos5l_decap_8
XFILLER_8_166 VPWR VGND sg13cmos5l_fill_1
XFILLER_306_109 VPWR VGND sg13cmos5l_fill_1
XFILLER_218_28 VPWR VGND sg13cmos5l_decap_8
XFILLER_8_188 VPWR VGND sg13cmos5l_fill_2
XFILLER_66_7 VPWR VGND sg13cmos5l_decap_8
XFILLER_646_77 VPWR VGND sg13cmos5l_decap_8
XFILLER_562_175 VPWR VGND sg13cmos5l_decap_8
XANTENNA__3607__X Tile_X0Y9_S2BEG[1] VPWR VGND sg13cmos5l_antennanp
XFILLER_148_91 VPWR VGND sg13cmos5l_decap_8
XFILLER_365_56 VPWR VGND sg13cmos5l_decap_8
X_1530_ _1530_/Q Tile_X0Y2_FrameData[23] VGND VPWR Tile_X0Y9_FrameStrobe[3] latch
XFILLER_649_213 VPWR VGND sg13cmos5l_decap_8
XFILLER_662_21 VPWR VGND sg13cmos5l_decap_8
X_1461_ _1461_/Q Tile_X0Y2_FrameData[28] VGND VPWR Tile_X0Y9_FrameStrobe[1] latch
XFILLER_113_237 VPWR VGND sg13cmos5l_decap_8
XFILLER_649_268 VPWR VGND sg13cmos5l_decap_4
XFILLER_664_205 VPWR VGND sg13cmos5l_decap_8
X_0412_ _0412_/Q Tile_X0Y7_FrameData[3] VGND VPWR Tile_X0Y9_FrameStrobe[7] latch
X_3200_ Tile_X0Y0_N2BEG[0] _3784_/X VPWR VGND sg13cmos5l_buf_1
XFILLER_79_140 VPWR VGND sg13cmos5l_decap_8
X_1392_ _1392_/Q Tile_X0Y1_FrameData[9] VGND VPWR Tile_X0Y9_FrameStrobe[6] latch
X_4180_ _4180_/X _0089_/X Tile_X0Y0_S4END[12] _4233_/X _4212_/X _1781_/Q _1780_/Q
+ VPWR VGND sg13cmos5l_mux4_1
XFILLER_662_98 VPWR VGND sg13cmos5l_decap_8
XFILLER_234_49 VPWR VGND sg13cmos5l_decap_4
XFILLER_617_132 VPWR VGND sg13cmos5l_fill_1
X_0343_ _0343_/Q Tile_X0Y7_FrameData[8] VGND VPWR Tile_X0Y9_FrameStrobe[5] latch
X_3131_ Tile_X0Y7_FrameData_O[1] Tile_X0Y7_FrameData[1] VPWR VGND sg13cmos5l_buf_1
XFILLER_381_88 VPWR VGND sg13cmos5l_decap_8
XFILLER_531_14 VPWR VGND sg13cmos5l_decap_8
XANTENNA__3342__X Tile_X0Y2_FrameData_O[13] VPWR VGND sg13cmos5l_antennanp
XFILLER_617_154 VPWR VGND sg13cmos5l_decap_8
XFILLER_490_119 VPWR VGND sg13cmos5l_decap_8
XFILLER_314_71 VPWR VGND sg13cmos5l_decap_8
X_3062_ Tile_X0Y5_FrameData_O[21] Tile_X0Y5_FrameData[21] VPWR VGND sg13cmos5l_buf_1
XFILLER_94_165 VPWR VGND sg13cmos5l_decap_8
X_0274_ _0274_/Q Tile_X0Y7_FrameData[13] VGND VPWR Tile_X0Y9_FrameStrobe[3] latch
XFILLER_617_198 VPWR VGND sg13cmos5l_decap_8
XFILLER_483_193 VPWR VGND sg13cmos5l_fill_1
X_2013_ _2013_/Q Tile_X0Y4_FrameData[8] VGND VPWR Tile_X0Y9_FrameStrobe[2] latch
XFILLER_242_108 VPWR VGND sg13cmos5l_decap_8
XFILLER_431_208 VPWR VGND sg13cmos5l_decap_4
XFILLER_424_271 VPWR VGND sg13cmos5l_fill_2
XFILLER_330_70 VPWR VGND sg13cmos5l_fill_2
XFILLER_250_141 VPWR VGND sg13cmos5l_decap_8
XFILLER_585_223 VPWR VGND sg13cmos5l_decap_8
X_3964_ _3964_/X _0073_/X Tile_X0Y0_S4END[4] _4019_/X _3996_/X _1281_/Q _1280_/Q VPWR
+ VGND sg13cmos5l_mux4_1
XFILLER_92_0 VPWR VGND sg13cmos5l_decap_8
XFILLER_148_112 VPWR VGND sg13cmos5l_decap_8
X_2915_ Tile_X0Y8_E1BEG[3] _4727_/X VPWR VGND sg13cmos5l_buf_1
X_3895_ _3895_/X Tile_X0Y1_W2MID[4] Tile_X0Y1_W2END[4] Tile_X0Y1_W6END[4] _3995_/X
+ _1411_/Q _1410_/Q VPWR VGND sg13cmos5l_mux4_1
XFILLER_337_234 VPWR VGND sg13cmos5l_decap_8
X_2846_ Tile_X0Y6_E2BEGb[3] _4507_/X VPWR VGND sg13cmos5l_buf_1
XFILLER_12_28 VPWR VGND sg13cmos5l_decap_8
XFILLER_409_49 VPWR VGND sg13cmos5l_decap_8
XFILLER_148_189 VPWR VGND sg13cmos5l_decap_8
XFILLER_128_28 VPWR VGND sg13cmos5l_decap_8
XFILLER_556_77 VPWR VGND sg13cmos5l_decap_8
XFILLER_706_14 VPWR VGND sg13cmos5l_decap_8
XFILLER_163_137 VPWR VGND sg13cmos5l_decap_8
X_2777_ Tile_X0Y3_EE4BEG[3] _4167_/X VPWR VGND sg13cmos5l_buf_1
XANTENNA__3517__X Tile_X0Y1_E2BEG[7] VPWR VGND sg13cmos5l_antennanp
XFILLER_275_56 VPWR VGND sg13cmos5l_decap_8
X_4516_ _4516_/X Tile_X0Y6_WW4END[11] AXI_M_SOC_RDATA28 _4579_/X _4559_/X _2575_/Q
+ _2574_/Q VPWR VGND sg13cmos5l_mux4_1
XFILLER_305_131 VPWR VGND sg13cmos5l_decap_8
X_1728_ _1728_/Q Tile_X0Y3_FrameData[9] VGND VPWR Tile_X0Y9_FrameStrobe[1] latch
XFILLER_305_142 VPWR VGND sg13cmos5l_decap_8
XFILLER_572_21 VPWR VGND sg13cmos5l_decap_8
XFILLER_305_153 VPWR VGND sg13cmos5l_fill_1
X_4447_ _4447_/X Tile_X0Y1_W1END[3] Tile_X0Y1_WW4END[15] Tile_X0Y1_W6END[7] _4011_/X
+ _1356_/Q _1355_/Q VPWR VGND sg13cmos5l_mux4_1
XFILLER_320_112 VPWR VGND sg13cmos5l_decap_8
XFILLER_171_192 VPWR VGND sg13cmos5l_decap_8
X_1659_ _1659_/Q Tile_X0Y2_FrameData[22] VGND VPWR Tile_X0Y9_FrameStrobe[7] latch
XFILLER_104_248 VPWR VGND sg13cmos5l_decap_8
XFILLER_291_22 VPWR VGND sg13cmos5l_decap_8
XFILLER_572_98 VPWR VGND sg13cmos5l_decap_8
XFILLER_466_138 VPWR VGND sg13cmos5l_decap_8
XFILLER_144_49 VPWR VGND sg13cmos5l_decap_8
X_4378_ _4378_/X Tile_X0Y5_W2MID[1] AXI_M_SOC_RRESP0 _4430_/X _4429_/X _2347_/Q _2346_/Q
+ VPWR VGND sg13cmos5l_mux4_1
XFILLER_608_110 VPWR VGND sg13cmos5l_decap_8
XFILLER_505_70 VPWR VGND sg13cmos5l_decap_8
XFILLER_320_189 VPWR VGND sg13cmos5l_decap_4
X_3329_ Tile_X0Y2_FrameData_O[0] Tile_X0Y2_FrameData[0] VPWR VGND sg13cmos5l_buf_1
XFILLER_441_14 VPWR VGND sg13cmos5l_decap_8
XANTENNA__3252__X Tile_X0Y0_FrameData_O[20] VPWR VGND sg13cmos5l_antennanp
XFILLER_407_216 VPWR VGND sg13cmos5l_decap_8
XFILLER_37_25 VPWR VGND sg13cmos5l_decap_8
XFILLER_170_7 VPWR VGND sg13cmos5l_decap_8
XFILLER_422_208 VPWR VGND sg13cmos5l_decap_8
XFILLER_226_160 VPWR VGND sg13cmos5l_fill_2
XFILLER_26_232 VPWR VGND sg13cmos5l_decap_4
XFILLER_268_7 VPWR VGND sg13cmos5l_decap_8
XFILLER_521_91 VPWR VGND sg13cmos5l_decap_8
XFILLER_415_271 VPWR VGND sg13cmos5l_fill_2
XFILLER_576_201 VPWR VGND sg13cmos5l_decap_8
XFILLER_442_8 VPWR VGND sg13cmos5l_decap_8
XFILLER_240_70 VPWR VGND sg13cmos5l_decap_8
XFILLER_41_224 VPWR VGND sg13cmos5l_decap_8
XFILLER_53_46 VPWR VGND sg13cmos5l_decap_8
XFILLER_430_252 VPWR VGND sg13cmos5l_decap_8
XFILLER_435_7 VPWR VGND sg13cmos5l_decap_8
XFILLER_41_235 VPWR VGND sg13cmos5l_fill_1
XFILLER_169_35 VPWR VGND sg13cmos5l_decap_8
XFILLER_186_218 VPWR VGND sg13cmos5l_decap_8
XFILLER_387_178 VPWR VGND sg13cmos5l_decap_8
XFILLER_241_185 VPWR VGND sg13cmos5l_decap_8
XFILLER_139_112 VPWR VGND sg13cmos5l_decap_8
XFILLER_591_226 VPWR VGND sg13cmos5l_fill_1
XFILLER_328_234 VPWR VGND sg13cmos5l_decap_8
XFILLER_194_240 VPWR VGND sg13cmos5l_decap_8
XFILLER_602_7 VPWR VGND sg13cmos5l_decap_8
XFILLER_544_142 VPWR VGND sg13cmos5l_decap_8
XFILLER_139_189 VPWR VGND sg13cmos5l_decap_8
XFILLER_466_77 VPWR VGND sg13cmos5l_fill_2
XFILLER_616_14 VPWR VGND sg13cmos5l_decap_8
XANTENNA__3427__X Tile_X0Y4_FrameData_O[18] VPWR VGND sg13cmos5l_antennanp
XFILLER_482_21 VPWR VGND sg13cmos5l_decap_8
XFILLER_500_245 VPWR VGND sg13cmos5l_decap_8
XFILLER_646_238 VPWR VGND sg13cmos5l_decap_8
XFILLER_500_256 VPWR VGND sg13cmos5l_fill_1
XFILLER_632_35 VPWR VGND sg13cmos5l_decap_8
XFILLER_415_70 VPWR VGND sg13cmos5l_decap_8
XFILLER_78_98 VPWR VGND sg13cmos5l_fill_2
XFILLER_294_0 VPWR VGND sg13cmos5l_decap_8
XFILLER_311_189 VPWR VGND sg13cmos5l_decap_8
XFILLER_351_14 VPWR VGND sg13cmos5l_decap_8
XANTENNA__3162__X Tile_X0Y7_UserCLKo VPWR VGND sg13cmos5l_antennanp
XFILLER_209_149 VPWR VGND sg13cmos5l_decap_8
XFILLER_94_42 VPWR VGND sg13cmos5l_decap_4
XFILLER_94_53 VPWR VGND sg13cmos5l_decap_8
XFILLER_461_0 VPWR VGND sg13cmos5l_decap_8
XFILLER_264_255 VPWR VGND sg13cmos5l_decap_8
XFILLER_614_146 VPWR VGND sg13cmos5l_fill_1
XFILLER_559_0 VPWR VGND sg13cmos5l_decap_8
XFILLER_480_141 VPWR VGND sg13cmos5l_decap_8
XFILLER_91_124 VPWR VGND sg13cmos5l_decap_8
XFILLER_501_28 VPWR VGND sg13cmos5l_decap_8
XFILLER_614_168 VPWR VGND sg13cmos5l_fill_1
XFILLER_431_91 VPWR VGND sg13cmos5l_decap_8
XFILLER_378_101 VPWR VGND sg13cmos5l_decap_8
XFILLER_150_81 VPWR VGND sg13cmos5l_decap_8
XFILLER_657_21 VPWR VGND sg13cmos5l_decap_8
XFILLER_582_204 VPWR VGND sg13cmos5l_decap_8
XFILLER_232_196 VPWR VGND sg13cmos5l_decap_8
X_0961_ _0961_/Q Tile_X0Y0_FrameData[10] VGND VPWR Tile_X0Y9_FrameStrobe[0] latch
XFILLER_709_272 VPWR VGND sg13cmos5l_fill_1
XFILLER_582_248 VPWR VGND sg13cmos5l_fill_1
XFILLER_376_22 VPWR VGND sg13cmos5l_decap_8
X_2700_ _3976_/A3 VPWR VGND sg13cmos5l_tielo
XFILLER_185_251 VPWR VGND sg13cmos5l_decap_8
X_3680_ _3680_/X Tile_X0Y2_WW4END[2] Tile_X0Y2_WW4END[10] Tile_X0Y2_W6END[10] _4126_/X
+ _1485_/Q _1484_/Q VPWR VGND sg13cmos5l_mux4_1
XFILLER_229_49 VPWR VGND sg13cmos5l_decap_8
X_0892_ _0892_/Q Tile_X0Y9_FrameData[3] VGND VPWR Tile_X0Y9_FrameStrobe[6] latch
XFILLER_376_55 VPWR VGND sg13cmos5l_fill_1
XFILLER_334_204 VPWR VGND sg13cmos5l_decap_8
XFILLER_376_77 VPWR VGND sg13cmos5l_decap_8
X_2631_ _2631_/Q Tile_X0Y6_FrameData[0] VGND VPWR Tile_X0Y9_FrameStrobe[5] latch
XFILLER_145_137 VPWR VGND sg13cmos5l_fill_2
XFILLER_526_14 VPWR VGND sg13cmos5l_decap_8
XANTENNA__3337__X Tile_X0Y2_FrameData_O[8] VPWR VGND sg13cmos5l_antennanp
XFILLER_696_105 VPWR VGND sg13cmos5l_decap_4
XFILLER_673_42 VPWR VGND sg13cmos5l_decap_8
X_2562_ _2562_/Q Tile_X0Y6_FrameData[5] VGND VPWR Tile_X0Y9_FrameStrobe[3] latch
XFILLER_550_167 VPWR VGND sg13cmos5l_fill_1
XFILLER_392_21 VPWR VGND sg13cmos5l_decap_8
XFILLER_689_190 VPWR VGND sg13cmos5l_decap_8
X_4301_ _4301_/X Tile_X0Y3_W1END[0] Tile_X0Y3_W6END[8] _4234_/X _4198_/X _1889_/Q
+ _1888_/Q VPWR VGND sg13cmos5l_mux4_1
XFILLER_153_170 VPWR VGND sg13cmos5l_decap_4
X_1513_ _1513_/Q Tile_X0Y2_FrameData[8] VGND VPWR Tile_X0Y9_FrameStrobe[2] latch
XFILLER_488_252 VPWR VGND sg13cmos5l_decap_4
XFILLER_153_181 VPWR VGND sg13cmos5l_decap_8
X_2493_ _2493_/Q Tile_X0Y6_FrameData[10] VGND VPWR Tile_X0Y9_FrameStrobe[1] latch
XFILLER_4_180 VPWR VGND sg13cmos5l_decap_8
XFILLER_448_105 VPWR VGND sg13cmos5l_decap_8
XFILLER_299_174 VPWR VGND sg13cmos5l_decap_8
XFILLER_299_185 VPWR VGND sg13cmos5l_fill_1
XFILLER_637_216 VPWR VGND sg13cmos5l_decap_4
X_4232_ _4232_/X _4200_/X _0087_/X _4199_/X Tile_X0Y0_S4END[14] _1709_/Q _1708_/Q
+ VPWR VGND sg13cmos5l_mux4_1
XFILLER_101_207 VPWR VGND sg13cmos5l_decap_4
X_1444_ _1444_/Q Tile_X0Y2_FrameData[13] VGND VPWR Tile_X0Y9_FrameStrobe[0] latch
XFILLER_542_35 VPWR VGND sg13cmos5l_decap_8
XFILLER_4_84 VPWR VGND sg13cmos5l_decap_8
X_1375_ _1375_/Q Tile_X0Y1_FrameData[26] VGND VPWR Tile_X0Y9_FrameStrobe[6] latch
X_4163_ _4163_/X Tile_X0Y3_W2END[0] AXI_M_SOC_WREADY _4205_/X _4204_/X _1815_/Q _1814_/Q
+ VPWR VGND sg13cmos5l_mux4_1
XFILLER_261_14 VPWR VGND sg13cmos5l_decap_8
XANTENNA__3072__X Tile_X0Y5_FrameData_O[31] VPWR VGND sg13cmos5l_antennanp
XFILLER_652_219 VPWR VGND sg13cmos5l_decap_4
XFILLER_255_222 VPWR VGND sg13cmos5l_decap_4
X_0326_ _0326_/Q Tile_X0Y7_FrameData[25] VGND VPWR Tile_X0Y9_FrameStrobe[5] latch
X_3114_ Tile_X0Y7_EE4BEG[0] _4628_/X VPWR VGND sg13cmos5l_buf_1
XFILLER_67_154 VPWR VGND sg13cmos5l_decap_8
X_4094_ _4094_/X Tile_X0Y1_W1END[3] Tile_X0Y1_W6END[11] _3996_/X _3979_/X _1383_/Q
+ _1382_/Q VPWR VGND sg13cmos5l_mux4_1
XFILLER_660_241 VPWR VGND sg13cmos5l_decap_8
XFILLER_82_124 VPWR VGND sg13cmos5l_decap_8
XFILLER_411_28 VPWR VGND sg13cmos5l_decap_8
X_0257_ _0257_/Q Tile_X0Y7_FrameData[30] VGND VPWR Tile_X0Y9_FrameStrobe[3] latch
X_3045_ Tile_X0Y5_FrameData_O[4] Tile_X0Y5_FrameData[4] VPWR VGND sg13cmos5l_buf_1
XFILLER_208_182 VPWR VGND sg13cmos5l_decap_8
X_0188_ _0188_/Q Tile_X0Y7_FrameData[3] VGND VPWR Tile_X0Y9_FrameStrobe[0] latch
XFILLER_369_123 VPWR VGND sg13cmos5l_fill_1
XFILLER_558_234 VPWR VGND sg13cmos5l_decap_8
XFILLER_412_263 VPWR VGND sg13cmos5l_decap_8
XFILLER_567_21 VPWR VGND sg13cmos5l_decap_8
XFILLER_23_268 VPWR VGND sg13cmos5l_decap_4
XFILLER_210_84 VPWR VGND sg13cmos5l_decap_8
X_3947_ _3947_/X Tile_X0Y1_W2END[0] AXI_M_SOC_ARREADY _3989_/X _3988_/X _1315_/Q _1314_/Q
+ VPWR VGND sg13cmos5l_mux4_1
XFILLER_384_148 VPWR VGND sg13cmos5l_fill_2
XFILLER_715_231 VPWR VGND sg13cmos5l_fill_2
XFILLER_567_98 VPWR VGND sg13cmos5l_decap_8
XFILLER_139_49 VPWR VGND sg13cmos5l_decap_8
XFILLER_717_24 VPWR VGND sg13cmos5l_fill_2
X_3878_ _3878_/X _4343_/X _4347_/X _4351_/X _4319_/X _2148_/Q _2147_/Q VPWR VGND sg13cmos5l_mux4_1
XFILLER_286_77 VPWR VGND sg13cmos5l_decap_8
X_2829_ Tile_X0Y4_E2BEG[7] _4263_/X VPWR VGND sg13cmos5l_buf_1
XFILLER_436_14 VPWR VGND sg13cmos5l_decap_8
XANTENNA__3247__X Tile_X0Y0_FrameData_O[15] VPWR VGND sg13cmos5l_antennanp
XFILLER_583_42 VPWR VGND sg13cmos5l_decap_8
XFILLER_340_207 VPWR VGND sg13cmos5l_decap_4
XFILLER_479_230 VPWR VGND sg13cmos5l_decap_8
XFILLER_628_227 VPWR VGND sg13cmos5l_decap_8
XFILLER_695_193 VPWR VGND sg13cmos5l_fill_2
XFILLER_452_35 VPWR VGND sg13cmos5l_decap_8
XFILLER_235_70 VPWR VGND sg13cmos5l_fill_2
XFILLER_171_14 VPWR VGND sg13cmos5l_decap_8
XFILLER_452_68 VPWR VGND sg13cmos5l_decap_8
XFILLER_454_119 VPWR VGND sg13cmos5l_decap_8
XFILLER_385_7 VPWR VGND sg13cmos5l_decap_8
XFILLER_636_271 VPWR VGND sg13cmos5l_fill_2
XFILLER_246_222 VPWR VGND sg13cmos5l_decap_8
XFILLER_58_165 VPWR VGND sg13cmos5l_decap_8
XFILLER_602_49 VPWR VGND sg13cmos5l_decap_8
XFILLER_447_193 VPWR VGND sg13cmos5l_decap_8
XFILLER_104_52 VPWR VGND sg13cmos5l_decap_4
XFILLER_651_252 VPWR VGND sg13cmos5l_decap_4
XFILLER_552_7 VPWR VGND sg13cmos5l_decap_8
XANTENNA__3710__X AXI_M_SOC_WDATA20 VPWR VGND sg13cmos5l_antennanp
XFILLER_261_225 VPWR VGND sg13cmos5l_decap_8
XFILLER_104_85 VPWR VGND sg13cmos5l_decap_8
XFILLER_251_91 VPWR VGND sg13cmos5l_fill_2
XFILLER_64_56 VPWR VGND sg13cmos5l_decap_8
XFILLER_611_149 VPWR VGND sg13cmos5l_decap_4
XFILLER_401_50 VPWR VGND sg13cmos5l_decap_8
XFILLER_477_21 VPWR VGND sg13cmos5l_decap_8
XFILLER_564_226 VPWR VGND sg13cmos5l_decap_8
XFILLER_375_148 VPWR VGND sg13cmos5l_decap_8
XFILLER_80_55 VPWR VGND sg13cmos5l_decap_8
XFILLER_517_142 VPWR VGND sg13cmos5l_decap_8
XFILLER_706_242 VPWR VGND sg13cmos5l_fill_1
XFILLER_627_35 VPWR VGND sg13cmos5l_decap_8
XFILLER_316_204 VPWR VGND sg13cmos5l_decap_8
XFILLER_196_77 VPWR VGND sg13cmos5l_decap_8
XFILLER_706_264 VPWR VGND sg13cmos5l_fill_1
XFILLER_346_14 VPWR VGND sg13cmos5l_decap_8
XANTENNA__3157__X Tile_X0Y7_FrameData_O[27] VPWR VGND sg13cmos5l_antennanp
XFILLER_127_148 VPWR VGND sg13cmos5l_decap_8
XFILLER_678_105 VPWR VGND sg13cmos5l_fill_1
XFILLER_493_42 VPWR VGND sg13cmos5l_decap_8
XFILLER_307_0 VPWR VGND sg13cmos5l_decap_8
XFILLER_678_127 VPWR VGND sg13cmos5l_decap_8
XFILLER_532_145 VPWR VGND sg13cmos5l_fill_2
XFILLER_89_42 VPWR VGND sg13cmos5l_decap_8
XFILLER_678_138 VPWR VGND sg13cmos5l_fill_1
XANTENNA__2996__X Tile_X0Y5_E1BEG[3] VPWR VGND sg13cmos5l_antennanp
XFILLER_643_56 VPWR VGND sg13cmos5l_decap_8
XFILLER_485_211 VPWR VGND sg13cmos5l_decap_8
XFILLER_426_91 VPWR VGND sg13cmos5l_decap_8
XFILLER_296_122 VPWR VGND sg13cmos5l_decap_8
XFILLER_619_238 VPWR VGND sg13cmos5l_decap_4
XFILLER_145_70 VPWR VGND sg13cmos5l_decap_4
XFILLER_1_150 VPWR VGND sg13cmos5l_fill_1
XFILLER_362_35 VPWR VGND sg13cmos5l_decap_8
XFILLER_485_255 VPWR VGND sg13cmos5l_decap_8
XFILLER_150_184 VPWR VGND sg13cmos5l_decap_8
XFILLER_676_0 VPWR VGND sg13cmos5l_decap_8
XFILLER_296_166 VPWR VGND sg13cmos5l_fill_1
XFILLER_150_195 VPWR VGND sg13cmos5l_fill_1
XFILLER_96_249 VPWR VGND sg13cmos5l_decap_8
XFILLER_29_7 VPWR VGND sg13cmos5l_decap_8
XFILLER_49_154 VPWR VGND sg13cmos5l_decap_8
X_1160_ _1160_/Q Tile_X0Y0_FrameData[3] VGND VPWR Tile_X0Y9_FrameStrobe[6] latch
XFILLER_512_49 VPWR VGND sg13cmos5l_decap_8
XFILLER_237_255 VPWR VGND sg13cmos5l_decap_8
X_0111_ _0111_/X _4324_/X _4325_/X _1112_/Q VPWR VGND sg13cmos5l_mux2_1
XFILLER_642_252 VPWR VGND sg13cmos5l_decap_4
XFILLER_231_28 VPWR VGND sg13cmos5l_decap_8
X_1091_ _1091_/Q Tile_X0Y0_FrameData[8] VGND VPWR Tile_X0Y9_FrameStrobe[4] latch
XANTENNA__3620__X Tile_X0Y9_S2BEGb[6] VPWR VGND sg13cmos5l_antennanp
XFILLER_64_168 VPWR VGND sg13cmos5l_decap_8
X_0042_ _3631_/A _4718_/X _4719_/X _0606_/Q VPWR VGND sg13cmos5l_mux2_1
XFILLER_453_196 VPWR VGND sg13cmos5l_decap_8
XFILLER_602_138 VPWR VGND sg13cmos5l_decap_4
XFILLER_602_149 VPWR VGND sg13cmos5l_decap_8
XFILLER_311_50 VPWR VGND sg13cmos5l_fill_1
XFILLER_252_269 VPWR VGND sg13cmos5l_decap_4
XFILLER_668_42 VPWR VGND sg13cmos5l_decap_8
XFILLER_311_72 VPWR VGND sg13cmos5l_decap_8
X_4850_ _4850_/X Tile_X0Y9_W2MID[5] AXI_M_SOC_RDATA2 _4905_/X _4904_/X _0843_/Q _0842_/Q
+ VPWR VGND sg13cmos5l_mux4_1
XFILLER_387_21 VPWR VGND sg13cmos5l_decap_8
XFILLER_366_104 VPWR VGND sg13cmos5l_decap_8
X_3801_ _3801_/X _3849_/X Tile_X0Y0_W2END[4] Tile_X0Y0_W2END[5] Tile_X0Y0_S1END[1]
+ _1103_/Q _1102_/Q VPWR VGND sg13cmos5l_mux4_1
XFILLER_20_205 VPWR VGND sg13cmos5l_fill_2
XFILLER_555_215 VPWR VGND sg13cmos5l_decap_8
XFILLER_220_144 VPWR VGND sg13cmos5l_decap_8
X_4781_ _4781_/X Tile_X0Y9_W1END[2] Tile_X0Y9_W6END[6] _4930_/X _4894_/X _0923_/Q
+ _0922_/Q VPWR VGND sg13cmos5l_mux4_1
X_1993_ _1993_/Q Tile_X0Y4_FrameData[28] VGND VPWR Tile_X0Y9_FrameStrobe[2] latch
X_3732_ AXI_M_SOC_ARADDR4 Tile_X0Y9_WW4END[4] Tile_X0Y9_WW4END[12] Tile_X0Y9_W6END[4]
+ _4920_/X _0751_/Q _0750_/Q VPWR VGND sg13cmos5l_mux4_1
XFILLER_387_87 VPWR VGND sg13cmos5l_decap_8
X_0944_ _0944_/Q Tile_X0Y0_FrameData[27] VGND VPWR Tile_X0Y9_FrameStrobe[0] latch
XFILLER_537_35 VPWR VGND sg13cmos5l_decap_8
XFILLER_381_118 VPWR VGND sg13cmos5l_decap_8
XFILLER_173_221 VPWR VGND sg13cmos5l_fill_1
X_3663_ AXI_M_SOC_AWADDR24 Tile_X0Y4_WW4END[0] Tile_X0Y4_WW4END[8] Tile_X0Y4_W6END[8]
+ _4344_/X _1997_/Q _1996_/Q VPWR VGND sg13cmos5l_mux4_1
XFILLER_523_112 VPWR VGND sg13cmos5l_decap_8
XFILLER_256_14 VPWR VGND sg13cmos5l_decap_8
XANTENNA__3067__X Tile_X0Y5_FrameData_O[26] VPWR VGND sg13cmos5l_antennanp
X_0875_ _0875_/Q Tile_X0Y9_FrameData[20] VGND VPWR Tile_X0Y9_FrameStrobe[6] latch
XFILLER_508_197 VPWR VGND sg13cmos5l_decap_8
XFILLER_523_123 VPWR VGND sg13cmos5l_fill_2
XFILLER_173_254 VPWR VGND sg13cmos5l_decap_4
XFILLER_684_96 VPWR VGND sg13cmos5l_decap_8
X_2614_ _2614_/Q Tile_X0Y6_FrameData[17] VGND VPWR Tile_X0Y9_FrameStrobe[5] latch
XFILLER_712_245 VPWR VGND sg13cmos5l_fill_2
X_3594_ Tile_X0Y9_FrameData_O[24] Tile_X0Y9_FrameData[24] VPWR VGND sg13cmos5l_buf_1
XFILLER_55_0 VPWR VGND sg13cmos5l_fill_2
XFILLER_523_178 VPWR VGND sg13cmos5l_decap_8
X_2545_ _2545_/Q Tile_X0Y6_FrameData[22] VGND VPWR Tile_X0Y9_FrameStrobe[3] latch
XFILLER_406_28 VPWR VGND sg13cmos5l_decap_8
XFILLER_553_56 VPWR VGND sg13cmos5l_decap_8
XFILLER_287_133 VPWR VGND sg13cmos5l_decap_8
XFILLER_141_151 VPWR VGND sg13cmos5l_decap_8
X_2476_ _2476_/Q Tile_X0Y6_FrameData[27] VGND VPWR Tile_X0Y9_FrameStrobe[1] latch
XFILLER_330_262 VPWR VGND sg13cmos5l_fill_2
XFILLER_272_35 VPWR VGND sg13cmos5l_decap_8
XFILLER_476_255 VPWR VGND sg13cmos5l_decap_4
X_4215_ _4215_/X _4200_/X _0087_/X _4199_/X Tile_X0Y0_S4END[14] _1701_/Q _1700_/Q
+ VPWR VGND sg13cmos5l_mux4_1
X_1427_ _1427_/Q Tile_X0Y2_FrameData[30] VGND VPWR Tile_X0Y9_FrameStrobe[0] latch
XFILLER_436_119 VPWR VGND sg13cmos5l_decap_8
XFILLER_491_225 VPWR VGND sg13cmos5l_fill_2
XFILLER_692_185 VPWR VGND sg13cmos5l_decap_8
XFILLER_228_233 VPWR VGND sg13cmos5l_fill_1
XFILLER_429_182 VPWR VGND sg13cmos5l_decap_8
X_4146_ _4146_/X _4200_/X _4199_/X AXI_M_SOC_BVALID _4198_/X _1849_/Q _1848_/Q VPWR
+ VGND sg13cmos5l_mux4_1
XFILLER_205_84 VPWR VGND sg13cmos5l_decap_8
X_1358_ _1358_/Q Tile_X0Y1_FrameData[11] VGND VPWR Tile_X0Y9_FrameStrobe[5] latch
XFILLER_422_49 VPWR VGND sg13cmos5l_decap_8
XFILLER_18_49 VPWR VGND sg13cmos5l_decap_8
XFILLER_444_141 VPWR VGND sg13cmos5l_decap_8
XFILLER_141_28 VPWR VGND sg13cmos5l_decap_8
X_0309_ _0309_/Q Tile_X0Y7_FrameData[10] VGND VPWR Tile_X0Y9_FrameStrobe[4] latch
X_4077_ _4077_/X AXI_M_SOC_AWREADY _4122_/X _4126_/X _4099_/X _1519_/Q _1518_/Q VPWR
+ VGND sg13cmos5l_mux4_1
XANTENNA__3530__X Tile_X0Y9_E2BEG[4] VPWR VGND sg13cmos5l_antennanp
X_1289_ _1289_/Q Tile_X0Y1_FrameData[16] VGND VPWR Tile_X0Y9_FrameStrobe[3] latch
XFILLER_389_218 VPWR VGND sg13cmos5l_decap_8
X_3028_ Tile_X0Y5_EE4BEG[3] _4391_/X VPWR VGND sg13cmos5l_buf_1
XFILLER_578_42 VPWR VGND sg13cmos5l_decap_8
XFILLER_211_133 VPWR VGND sg13cmos5l_decap_8
XFILLER_297_43 VPWR VGND sg13cmos5l_decap_8
XFILLER_357_126 VPWR VGND sg13cmos5l_decap_8
XFILLER_133_7 VPWR VGND sg13cmos5l_decap_8
XFILLER_50_14 VPWR VGND sg13cmos5l_decap_8
XFILLER_447_35 VPWR VGND sg13cmos5l_decap_8
XFILLER_109_115 VPWR VGND sg13cmos5l_decap_8
XFILLER_372_129 VPWR VGND sg13cmos5l_decap_8
XFILLER_166_14 VPWR VGND sg13cmos5l_decap_8
XFILLER_594_63 VPWR VGND sg13cmos5l_decap_8
XFILLER_109_148 VPWR VGND sg13cmos5l_decap_8
XFILLER_703_234 VPWR VGND sg13cmos5l_decap_8
XFILLER_380_140 VPWR VGND sg13cmos5l_decap_8
XFILLER_300_7 VPWR VGND sg13cmos5l_decap_8
XANTENNA__3705__X AXI_M_SOC_WDATA15 VPWR VGND sg13cmos5l_antennanp
XFILLER_132_173 VPWR VGND sg13cmos5l_decap_8
XFILLER_463_89 VPWR VGND sg13cmos5l_decap_4
XFILLER_482_203 VPWR VGND sg13cmos5l_fill_1
XFILLER_427_119 VPWR VGND sg13cmos5l_decap_8
XFILLER_115_51 VPWR VGND sg13cmos5l_fill_2
XFILLER_683_185 VPWR VGND sg13cmos5l_decap_8
XFILLER_93_208 VPWR VGND sg13cmos5l_decap_8
XFILLER_609_271 VPWR VGND sg13cmos5l_fill_2
XFILLER_482_247 VPWR VGND sg13cmos5l_decap_8
XFILLER_86_260 VPWR VGND sg13cmos5l_fill_2
XFILLER_293_169 VPWR VGND sg13cmos5l_decap_4
XFILLER_624_263 VPWR VGND sg13cmos5l_fill_1
XANTENNA__3440__X Tile_X0Y4_FrameData_O[31] VPWR VGND sg13cmos5l_antennanp
XFILLER_46_146 VPWR VGND sg13cmos5l_decap_8
XFILLER_46_157 VPWR VGND sg13cmos5l_fill_2
XFILLER_412_71 VPWR VGND sg13cmos5l_decap_8
XFILLER_234_236 VPWR VGND sg13cmos5l_decap_8
XFILLER_75_99 VPWR VGND sg13cmos5l_decap_8
XFILLER_61_105 VPWR VGND sg13cmos5l_decap_8
XFILLER_131_50 VPWR VGND sg13cmos5l_decap_8
XFILLER_91_21 VPWR VGND sg13cmos5l_decap_8
XFILLER_257_0 VPWR VGND sg13cmos5l_decap_8
XFILLER_488_42 VPWR VGND sg13cmos5l_decap_8
XFILLER_450_199 VPWR VGND sg13cmos5l_decap_8
XFILLER_348_126 VPWR VGND sg13cmos5l_decap_8
XFILLER_202_155 VPWR VGND sg13cmos5l_fill_2
XFILLER_424_0 VPWR VGND sg13cmos5l_decap_8
XFILLER_537_248 VPWR VGND sg13cmos5l_decap_8
XFILLER_638_56 VPWR VGND sg13cmos5l_decap_8
XFILLER_24_70 VPWR VGND sg13cmos5l_fill_2
XFILLER_202_199 VPWR VGND sg13cmos5l_fill_2
XFILLER_552_207 VPWR VGND sg13cmos5l_decap_8
XFILLER_357_35 VPWR VGND sg13cmos5l_decap_8
XFILLER_552_218 VPWR VGND sg13cmos5l_fill_2
XFILLER_155_221 VPWR VGND sg13cmos5l_decap_8
XFILLER_545_270 VPWR VGND sg13cmos5l_fill_2
XFILLER_155_243 VPWR VGND sg13cmos5l_decap_8
XFILLER_560_240 VPWR VGND sg13cmos5l_decap_8
X_0660_ _0660_/Q Tile_X0Y8_FrameData[11] VGND VPWR Tile_X0Y9_FrameStrobe[7] latch
XFILLER_6_264 VPWR VGND sg13cmos5l_fill_1
XFILLER_654_55 VPWR VGND sg13cmos5l_decap_8
XFILLER_507_49 VPWR VGND sg13cmos5l_decap_8
XFILLER_226_28 VPWR VGND sg13cmos5l_decap_8
X_0591_ _0591_/Q Tile_X0Y8_FrameData[16] VGND VPWR Tile_X0Y9_FrameStrobe[5] latch
XANTENNA__3615__X Tile_X0Y9_S2BEGb[1] VPWR VGND sg13cmos5l_antennanp
XFILLER_170_268 VPWR VGND sg13cmos5l_decap_4
XFILLER_659_160 VPWR VGND sg13cmos5l_decap_8
XFILLER_458_211 VPWR VGND sg13cmos5l_decap_8
XFILLER_156_91 VPWR VGND sg13cmos5l_decap_8
XFILLER_659_171 VPWR VGND sg13cmos5l_fill_1
X_2330_ _2330_/Q Tile_X0Y5_FrameData[11] VGND VPWR Tile_X0Y9_FrameStrobe[4] latch
XFILLER_458_233 VPWR VGND sg13cmos5l_decap_8
XFILLER_659_193 VPWR VGND sg13cmos5l_fill_2
XFILLER_670_21 VPWR VGND sg13cmos5l_decap_8
XFILLER_69_238 VPWR VGND sg13cmos5l_decap_8
XFILLER_269_166 VPWR VGND sg13cmos5l_decap_8
X_2261_ _2261_/Q Tile_X0Y5_FrameData[16] VGND VPWR Tile_X0Y9_FrameStrobe[2] latch
XFILLER_674_163 VPWR VGND sg13cmos5l_decap_4
XFILLER_269_188 VPWR VGND sg13cmos5l_decap_8
XFILLER_607_219 VPWR VGND sg13cmos5l_decap_8
X_4000_ _4000_/X Tile_X0Y5_W1END[1] Tile_X0Y5_WW4END[1] Tile_X0Y5_W6END[9] _4452_/X
+ _2412_/Q _2411_/Q VPWR VGND sg13cmos5l_mux4_1
X_1212_ _1212_/Q Tile_X0Y1_FrameData[29] VGND VPWR Tile_X0Y9_FrameStrobe[1] latch
XFILLER_284_147 VPWR VGND sg13cmos5l_decap_8
X_2192_ _2192_/Q Tile_X0Y5_FrameData[21] VGND VPWR Tile_X0Y9_FrameStrobe[0] latch
XFILLER_670_98 VPWR VGND sg13cmos5l_decap_8
XFILLER_242_49 VPWR VGND sg13cmos5l_decap_8
XFILLER_603_70 VPWR VGND sg13cmos5l_decap_8
XFILLER_37_124 VPWR VGND sg13cmos5l_decap_8
X_1143_ _1143_/Q Tile_X0Y0_FrameData[20] VGND VPWR Tile_X0Y9_FrameStrobe[6] latch
XFILLER_615_263 VPWR VGND sg13cmos5l_decap_8
XANTENNA__3350__X Tile_X0Y2_FrameData_O[21] VPWR VGND sg13cmos5l_antennanp
XFILLER_1_63 VPWR VGND sg13cmos5l_decap_8
XFILLER_322_60 VPWR VGND sg13cmos5l_fill_1
XFILLER_679_30 VPWR VGND sg13cmos5l_decap_8
XFILLER_426_196 VPWR VGND sg13cmos5l_decap_8
XFILLER_225_258 VPWR VGND sg13cmos5l_fill_1
X_1074_ _1074_/Q Tile_X0Y0_FrameData[25] VGND VPWR Tile_X0Y9_FrameStrobe[4] latch
XFILLER_441_166 VPWR VGND sg13cmos5l_decap_8
X_4902_ _4902_/X Tile_X0Y9_N2MID[6] Tile_X0Y9_N2END[6] _4938_/X _4822_/X _0683_/Q
+ _0682_/Q VPWR VGND sg13cmos5l_mux4_1
XFILLER_398_42 VPWR VGND sg13cmos5l_decap_8
XFILLER_240_228 VPWR VGND sg13cmos5l_decap_8
X_4833_ _4833_/X Tile_X0Y9_W1END[1] Tile_X0Y9_W2MID[2] Tile_X0Y9_W2END[2] _4904_/X
+ _0873_/Q _0872_/Q VPWR VGND sg13cmos5l_mux4_1
XFILLER_60_160 VPWR VGND sg13cmos5l_decap_8
XFILLER_339_126 VPWR VGND sg13cmos5l_decap_8
XFILLER_528_237 VPWR VGND sg13cmos5l_decap_8
XFILLER_548_56 VPWR VGND sg13cmos5l_decap_8
XFILLER_394_254 VPWR VGND sg13cmos5l_decap_8
X_4764_ _4764_/X AXI_M_SOC_RDATA8 _4807_/X _4811_/X _4785_/X _0519_/Q _0518_/Q VPWR
+ VGND sg13cmos5l_mux4_1
X_1976_ _1976_/Q Tile_X0Y4_FrameData[13] VGND VPWR Tile_X0Y9_FrameStrobe[1] latch
XFILLER_695_84 VPWR VGND sg13cmos5l_decap_8
XFILLER_267_35 VPWR VGND sg13cmos5l_decap_8
XFILLER_543_229 VPWR VGND sg13cmos5l_decap_8
X_3715_ AXI_M_SOC_WDATA25 Tile_X0Y6_WW4END[1] Tile_X0Y6_WW4END[9] Tile_X0Y6_W6END[9]
+ _4577_/X _2509_/Q _2508_/Q VPWR VGND sg13cmos5l_mux4_1
X_0927_ _0927_/Q Tile_X0Y9_FrameData[0] VGND VPWR Tile_X0Y9_FrameStrobe[7] latch
X_4695_ _4695_/X _4667_/X Tile_X0Y9_N4END[11] _4666_/X _0053_/X _0193_/Q _0192_/Q
+ VPWR VGND sg13cmos5l_mux4_1
XFILLER_697_211 VPWR VGND sg13cmos5l_decap_8
X_3646_ AXI_M_SOC_AWADDR7 Tile_X0Y5_WW4END[7] Tile_X0Y5_WW4END[15] Tile_X0Y5_W6END[7]
+ _4458_/X _2257_/Q _2256_/Q VPWR VGND sg13cmos5l_mux4_1
XFILLER_20_28 VPWR VGND sg13cmos5l_decap_8
X_0858_ _0858_/Q Tile_X0Y9_FrameData[5] VGND VPWR Tile_X0Y9_FrameStrobe[5] latch
XFILLER_417_49 VPWR VGND sg13cmos5l_decap_8
XFILLER_362_162 VPWR VGND sg13cmos5l_decap_8
XFILLER_564_77 VPWR VGND sg13cmos5l_decap_8
XFILLER_136_28 VPWR VGND sg13cmos5l_decap_8
XFILLER_161_246 VPWR VGND sg13cmos5l_decap_8
XFILLER_714_14 VPWR VGND sg13cmos5l_decap_8
X_3577_ Tile_X0Y9_FrameData_O[7] Tile_X0Y9_FrameData[7] VPWR VGND sg13cmos5l_buf_1
XANTENNA__3525__X Tile_X0Y9_E1BEG[3] VPWR VGND sg13cmos5l_antennanp
X_0789_ _0789_/Q Tile_X0Y9_FrameData[10] VGND VPWR Tile_X0Y9_FrameStrobe[3] latch
XFILLER_283_56 VPWR VGND sg13cmos5l_decap_8
XFILLER_700_248 VPWR VGND sg13cmos5l_decap_8
XFILLER_449_222 VPWR VGND sg13cmos5l_decap_4
X_2528_ _2528_/Q Tile_X0Y6_FrameData[7] VGND VPWR Tile_X0Y9_FrameStrobe[2] latch
XFILLER_449_233 VPWR VGND sg13cmos5l_decap_8
XFILLER_665_130 VPWR VGND sg13cmos5l_decap_8
XFILLER_580_21 VPWR VGND sg13cmos5l_decap_8
XFILLER_114_184 VPWR VGND sg13cmos5l_decap_8
XFILLER_275_114 VPWR VGND sg13cmos5l_decap_8
X_2459_ _2459_/Q Tile_X0Y6_FrameData[12] VGND VPWR Tile_X0Y9_FrameStrobe[0] latch
XFILLER_464_214 VPWR VGND sg13cmos5l_decap_8
XFILLER_665_174 VPWR VGND sg13cmos5l_decap_8
XFILLER_464_225 VPWR VGND sg13cmos5l_fill_2
XFILLER_29_59 VPWR VGND sg13cmos5l_fill_1
XFILLER_513_70 VPWR VGND sg13cmos5l_decap_8
XFILLER_464_269 VPWR VGND sg13cmos5l_decap_4
XFILLER_290_106 VPWR VGND sg13cmos5l_decap_4
XFILLER_606_252 VPWR VGND sg13cmos5l_decap_4
XFILLER_290_117 VPWR VGND sg13cmos5l_decap_4
XFILLER_28_124 VPWR VGND sg13cmos5l_decap_8
XFILLER_83_230 VPWR VGND sg13cmos5l_decap_8
X_4129_ _4129_/X Tile_X0Y4_W2MID[7] Tile_X0Y4_W2END[7] Tile_X0Y4_W6END[7] _4313_/X
+ _2173_/Q _2172_/Q VPWR VGND sg13cmos5l_mux4_1
XFILLER_216_214 VPWR VGND sg13cmos5l_fill_2
XANTENNA__3260__X Tile_X0Y0_FrameData_O[28] VPWR VGND sg13cmos5l_antennanp
XFILLER_232_71 VPWR VGND sg13cmos5l_decap_8
XFILLER_417_196 VPWR VGND sg13cmos5l_decap_4
XFILLER_232_82 VPWR VGND sg13cmos5l_fill_2
XFILLER_432_133 VPWR VGND sg13cmos5l_decap_8
XFILLER_589_63 VPWR VGND sg13cmos5l_decap_8
XFILLER_578_126 VPWR VGND sg13cmos5l_decap_8
XFILLER_621_244 VPWR VGND sg13cmos5l_fill_2
XFILLER_45_58 VPWR VGND sg13cmos5l_decap_8
XFILLER_589_96 VPWR VGND sg13cmos5l_fill_1
XFILLER_43_149 VPWR VGND sg13cmos5l_decap_8
XFILLER_250_7 VPWR VGND sg13cmos5l_decap_8
XFILLER_348_7 VPWR VGND sg13cmos5l_decap_8
XFILLER_101_42 VPWR VGND sg13cmos5l_decap_8
XFILLER_196_121 VPWR VGND sg13cmos5l_decap_8
XFILLER_385_232 VPWR VGND sg13cmos5l_decap_8
XFILLER_177_24 VPWR VGND sg13cmos5l_fill_1
XFILLER_515_7 VPWR VGND sg13cmos5l_decap_8
XFILLER_131_4 VPWR VGND sg13cmos5l_fill_1
XFILLER_534_207 VPWR VGND sg13cmos5l_decap_8
XFILLER_196_187 VPWR VGND sg13cmos5l_decap_8
XFILLER_177_46 VPWR VGND sg13cmos5l_decap_8
XFILLER_137_232 VPWR VGND sg13cmos5l_decap_8
XFILLER_137_254 VPWR VGND sg13cmos5l_fill_1
XANTENNA__0124__X AXI_M_SOC_ARSIZE1 VPWR VGND sg13cmos5l_antennanp
XFILLER_353_140 VPWR VGND sg13cmos5l_decap_8
XFILLER_542_240 VPWR VGND sg13cmos5l_decap_8
XFILLER_499_133 VPWR VGND sg13cmos5l_decap_8
XFILLER_152_213 VPWR VGND sg13cmos5l_decap_8
XFILLER_502_126 VPWR VGND sg13cmos5l_decap_8
XFILLER_648_119 VPWR VGND sg13cmos5l_decap_8
XFILLER_624_14 VPWR VGND sg13cmos5l_decap_8
XANTENNA__3435__X Tile_X0Y4_FrameData_O[26] VPWR VGND sg13cmos5l_antennanp
XFILLER_152_257 VPWR VGND sg13cmos5l_decap_8
XFILLER_193_56 VPWR VGND sg13cmos5l_decap_8
XFILLER_3_256 VPWR VGND sg13cmos5l_fill_2
XFILLER_105_173 VPWR VGND sg13cmos5l_decap_8
XFILLER_490_21 VPWR VGND sg13cmos5l_decap_8
XFILLER_120_110 VPWR VGND sg13cmos5l_decap_8
XFILLER_86_21 VPWR VGND sg13cmos5l_decap_8
XFILLER_266_136 VPWR VGND sg13cmos5l_decap_8
XFILLER_704_91 VPWR VGND sg13cmos5l_decap_8
XFILLER_455_247 VPWR VGND sg13cmos5l_decap_8
XFILLER_59_260 VPWR VGND sg13cmos5l_fill_2
XFILLER_490_98 VPWR VGND sg13cmos5l_decap_8
XFILLER_455_258 VPWR VGND sg13cmos5l_fill_1
XFILLER_671_144 VPWR VGND sg13cmos5l_fill_1
XFILLER_640_35 VPWR VGND sg13cmos5l_decap_8
XFILLER_423_70 VPWR VGND sg13cmos5l_decap_8
XFILLER_408_130 VPWR VGND sg13cmos5l_decap_8
XFILLER_266_169 VPWR VGND sg13cmos5l_decap_8
XFILLER_86_98 VPWR VGND sg13cmos5l_decap_8
XFILLER_671_155 VPWR VGND sg13cmos5l_decap_8
XFILLER_374_0 VPWR VGND sg13cmos5l_decap_4
XFILLER_19_70 VPWR VGND sg13cmos5l_decap_8
XFILLER_74_230 VPWR VGND sg13cmos5l_decap_4
XANTENNA__3170__X Tile_X0Y4_E6BEG[7] VPWR VGND sg13cmos5l_antennanp
XFILLER_207_236 VPWR VGND sg13cmos5l_decap_8
XFILLER_274_180 VPWR VGND sg13cmos5l_decap_8
XFILLER_74_263 VPWR VGND sg13cmos5l_fill_2
XFILLER_408_196 VPWR VGND sg13cmos5l_decap_8
XFILLER_207_247 VPWR VGND sg13cmos5l_decap_8
XFILLER_423_133 VPWR VGND sg13cmos5l_decap_8
XFILLER_569_126 VPWR VGND sg13cmos5l_decap_8
XFILLER_499_63 VPWR VGND sg13cmos5l_decap_8
XFILLER_612_244 VPWR VGND sg13cmos5l_decap_8
XFILLER_222_206 VPWR VGND sg13cmos5l_fill_1
XFILLER_541_0 VPWR VGND sg13cmos5l_decap_8
XFILLER_639_0 VPWR VGND sg13cmos5l_decap_8
XFILLER_187_110 VPWR VGND sg13cmos5l_decap_8
XFILLER_376_210 VPWR VGND sg13cmos5l_decap_8
XFILLER_649_77 VPWR VGND sg13cmos5l_decap_8
XFILLER_35_91 VPWR VGND sg13cmos5l_fill_1
XFILLER_96_7 VPWR VGND sg13cmos5l_decap_8
XFILLER_577_192 VPWR VGND sg13cmos5l_decap_8
X_1830_ _1830_/Q Tile_X0Y3_FrameData[3] VGND VPWR Tile_X0Y9_FrameStrobe[4] latch
XFILLER_368_78 VPWR VGND sg13cmos5l_fill_1
XFILLER_665_21 VPWR VGND sg13cmos5l_decap_8
XFILLER_592_173 VPWR VGND sg13cmos5l_decap_8
XFILLER_391_224 VPWR VGND sg13cmos5l_decap_8
X_1761_ _1761_/Q Tile_X0Y3_FrameData[8] VGND VPWR Tile_X0Y9_FrameStrobe[2] latch
XFILLER_679_211 VPWR VGND sg13cmos5l_decap_8
X_3500_ Tile_X0Y1_E6BEG[10] _3974_/X VPWR VGND sg13cmos5l_buf_1
XFILLER_344_140 VPWR VGND sg13cmos5l_decap_8
X_0712_ _0712_/Q Tile_X0Y9_FrameData[23] VGND VPWR Tile_X0Y9_FrameStrobe[1] latch
X_4480_ _4480_/X Tile_X0Y4_W1END[2] Tile_X0Y4_W2MID[1] Tile_X0Y4_W2END[1] _4314_/X
+ _2125_/Q _2124_/Q VPWR VGND sg13cmos5l_mux4_1
XFILLER_665_98 VPWR VGND sg13cmos5l_decap_8
X_1692_ _1692_/Q Tile_X0Y3_FrameData[13] VGND VPWR Tile_X0Y9_FrameStrobe[0] latch
XFILLER_533_262 VPWR VGND sg13cmos5l_fill_2
XFILLER_237_49 VPWR VGND sg13cmos5l_decap_8
X_3431_ Tile_X0Y4_FrameData_O[22] Tile_X0Y4_FrameData[22] VPWR VGND sg13cmos5l_buf_1
X_0643_ _0643_/Q Tile_X0Y8_FrameData[28] VGND VPWR Tile_X0Y9_FrameStrobe[7] latch
XFILLER_534_14 VPWR VGND sg13cmos5l_decap_8
XFILLER_143_257 VPWR VGND sg13cmos5l_decap_8
XFILLER_639_119 VPWR VGND sg13cmos5l_decap_8
XANTENNA__3345__X Tile_X0Y2_FrameData_O[16] VPWR VGND sg13cmos5l_antennanp
XFILLER_143_268 VPWR VGND sg13cmos5l_decap_4
XFILLER_681_42 VPWR VGND sg13cmos5l_fill_2
X_3362_ Tile_X0Y2_EE4BEG[1] _4057_/X VPWR VGND sg13cmos5l_buf_1
XFILLER_694_247 VPWR VGND sg13cmos5l_decap_8
X_0574_ _0574_/Q Tile_X0Y8_FrameData[1] VGND VPWR Tile_X0Y9_FrameStrobe[4] latch
X_2313_ _2313_/Q Tile_X0Y5_FrameData[28] VGND VPWR Tile_X0Y9_FrameStrobe[4] latch
XFILLER_111_132 VPWR VGND sg13cmos5l_decap_8
XFILLER_300_221 VPWR VGND sg13cmos5l_decap_8
XFILLER_257_114 VPWR VGND sg13cmos5l_fill_2
X_3293_ Tile_X0Y0_E2BEGb[1] _3813_/X VPWR VGND sg13cmos5l_buf_1
XFILLER_300_243 VPWR VGND sg13cmos5l_decap_8
XFILLER_614_91 VPWR VGND sg13cmos5l_decap_8
XFILLER_647_196 VPWR VGND sg13cmos5l_decap_8
X_2244_ _2244_/Q Tile_X0Y5_FrameData[1] VGND VPWR Tile_X0Y9_FrameStrobe[1] latch
XFILLER_257_158 VPWR VGND sg13cmos5l_decap_8
XFILLER_550_35 VPWR VGND sg13cmos5l_decap_8
XFILLER_403_29 VPWR VGND sg13cmos5l_decap_8
XFILLER_18_0 VPWR VGND sg13cmos5l_decap_8
XFILLER_662_155 VPWR VGND sg13cmos5l_decap_8
XANTENNA__3080__X Tile_X0Y4_E2BEGb[6] VPWR VGND sg13cmos5l_antennanp
X_2175_ _2175_/Q Tile_X0Y4_FrameData[6] VGND VPWR Tile_X0Y9_FrameStrobe[7] latch
XFILLER_461_228 VPWR VGND sg13cmos5l_decap_8
XFILLER_265_180 VPWR VGND sg13cmos5l_decap_8
XFILLER_65_263 VPWR VGND sg13cmos5l_fill_2
XFILLER_603_222 VPWR VGND sg13cmos5l_decap_8
X_1126_ _1126_/Q Tile_X0Y0_FrameData[5] VGND VPWR Tile_X0Y9_FrameStrobe[5] latch
XFILLER_700_49 VPWR VGND sg13cmos5l_decap_8
XFILLER_414_144 VPWR VGND sg13cmos5l_decap_8
XFILLER_280_161 VPWR VGND sg13cmos5l_decap_8
XFILLER_25_138 VPWR VGND sg13cmos5l_decap_8
XFILLER_202_63 VPWR VGND sg13cmos5l_decap_8
XFILLER_213_239 VPWR VGND sg13cmos5l_decap_8
X_1057_ _1057_/Q Tile_X0Y0_FrameData[10] VGND VPWR Tile_X0Y9_FrameStrobe[3] latch
XFILLER_15_28 VPWR VGND sg13cmos5l_decap_8
XFILLER_40_108 VPWR VGND sg13cmos5l_decap_8
XFILLER_178_121 VPWR VGND sg13cmos5l_decap_8
XFILLER_559_77 VPWR VGND sg13cmos5l_decap_8
XFILLER_40_119 VPWR VGND sg13cmos5l_fill_2
XFILLER_178_132 VPWR VGND sg13cmos5l_fill_2
XFILLER_709_14 VPWR VGND sg13cmos5l_decap_8
XFILLER_717_123 VPWR VGND sg13cmos5l_decap_8
XFILLER_278_56 VPWR VGND sg13cmos5l_decap_8
XFILLER_221_272 VPWR VGND sg13cmos5l_fill_1
X_4816_ _4816_/X Tile_X0Y7_W2MID[7] Tile_X0Y7_W2END[7] Tile_X0Y7_W6END[8] _4669_/X
+ _0371_/Q _0370_/Q VPWR VGND sg13cmos5l_mux4_1
XFILLER_327_107 VPWR VGND sg13cmos5l_decap_8
XFILLER_178_187 VPWR VGND sg13cmos5l_decap_8
XFILLER_575_21 VPWR VGND sg13cmos5l_decap_8
XFILLER_327_118 VPWR VGND sg13cmos5l_fill_2
XFILLER_382_224 VPWR VGND sg13cmos5l_decap_8
XFILLER_119_221 VPWR VGND sg13cmos5l_decap_8
XFILLER_382_235 VPWR VGND sg13cmos5l_fill_2
XFILLER_193_146 VPWR VGND sg13cmos5l_decap_8
X_4747_ _4747_/X Tile_X0Y8_WW4END[12] AXI_M_SOC_RDATA11 _4812_/X _4790_/X _0553_/Q
+ _0552_/Q VPWR VGND sg13cmos5l_mux4_1
X_1959_ _1959_/Q Tile_X0Y4_FrameData[30] VGND VPWR Tile_X0Y9_FrameStrobe[1] latch
XFILLER_382_268 VPWR VGND sg13cmos5l_decap_4
XFILLER_335_140 VPWR VGND sg13cmos5l_decap_4
XFILLER_147_49 VPWR VGND sg13cmos5l_decap_8
X_4678_ _4678_/X Tile_X0Y3_W1END[1] Tile_X0Y3_WW4END[13] Tile_X0Y3_W6END[5] _4223_/X
+ _1862_/Q _1861_/Q VPWR VGND sg13cmos5l_mux4_1
XFILLER_575_98 VPWR VGND sg13cmos5l_decap_8
XFILLER_508_70 VPWR VGND sg13cmos5l_decap_8
XFILLER_294_77 VPWR VGND sg13cmos5l_decap_8
X_3629_ Tile_X0Y9_S4BEG[7] _3629_/A VPWR VGND sg13cmos5l_buf_1
XFILLER_444_14 VPWR VGND sg13cmos5l_decap_8
XFILLER_335_195 VPWR VGND sg13cmos5l_decap_8
XANTENNA__3255__X Tile_X0Y0_FrameData_O[23] VPWR VGND sg13cmos5l_antennanp
XFILLER_227_71 VPWR VGND sg13cmos5l_decap_8
XFILLER_591_42 VPWR VGND sg13cmos5l_decap_8
XFILLER_496_147 VPWR VGND sg13cmos5l_decap_8
XFILLER_350_154 VPWR VGND sg13cmos5l_decap_4
XFILLER_0_204 VPWR VGND sg13cmos5l_fill_2
XFILLER_163_37 VPWR VGND sg13cmos5l_decap_4
XFILLER_288_272 VPWR VGND sg13cmos5l_fill_1
XFILLER_163_48 VPWR VGND sg13cmos5l_decap_8
XFILLER_248_114 VPWR VGND sg13cmos5l_decap_8
XFILLER_102_132 VPWR VGND sg13cmos5l_decap_8
XFILLER_298_7 VPWR VGND sg13cmos5l_decap_8
XFILLER_248_125 VPWR VGND sg13cmos5l_fill_2
XFILLER_524_91 VPWR VGND sg13cmos5l_fill_2
XFILLER_653_133 VPWR VGND sg13cmos5l_decap_4
XFILLER_248_158 VPWR VGND sg13cmos5l_fill_2
XFILLER_460_35 VPWR VGND sg13cmos5l_decap_8
XFILLER_102_198 VPWR VGND sg13cmos5l_decap_8
XFILLER_243_81 VPWR VGND sg13cmos5l_fill_1
XFILLER_465_7 VPWR VGND sg13cmos5l_decap_8
XFILLER_653_188 VPWR VGND sg13cmos5l_decap_8
XFILLER_263_139 VPWR VGND sg13cmos5l_decap_8
XFILLER_56_252 VPWR VGND sg13cmos5l_fill_2
XFILLER_405_144 VPWR VGND sg13cmos5l_decap_8
XFILLER_610_49 VPWR VGND sg13cmos5l_decap_8
XANTENNA__0119__X AXI_M_SOC_ARCACHE1 VPWR VGND sg13cmos5l_antennanp
XFILLER_632_7 VPWR VGND sg13cmos5l_decap_8
XFILLER_460_272 VPWR VGND sg13cmos5l_fill_1
XFILLER_405_188 VPWR VGND sg13cmos5l_decap_8
XFILLER_72_56 VPWR VGND sg13cmos5l_decap_8
XFILLER_420_147 VPWR VGND sg13cmos5l_decap_4
XFILLER_358_210 VPWR VGND sg13cmos5l_decap_8
XFILLER_420_158 VPWR VGND sg13cmos5l_fill_1
XFILLER_619_14 VPWR VGND sg13cmos5l_decap_8
XFILLER_559_192 VPWR VGND sg13cmos5l_decap_8
XFILLER_169_154 VPWR VGND sg13cmos5l_decap_8
XFILLER_188_56 VPWR VGND sg13cmos5l_decap_8
XFILLER_212_272 VPWR VGND sg13cmos5l_fill_1
XFILLER_574_140 VPWR VGND sg13cmos5l_decap_8
XFILLER_184_113 VPWR VGND sg13cmos5l_decap_8
XFILLER_708_167 VPWR VGND sg13cmos5l_fill_2
XFILLER_485_21 VPWR VGND sg13cmos5l_decap_8
XFILLER_373_235 VPWR VGND sg13cmos5l_decap_8
XFILLER_122_0 VPWR VGND sg13cmos5l_decap_8
XFILLER_373_268 VPWR VGND sg13cmos5l_decap_4
XFILLER_635_35 VPWR VGND sg13cmos5l_decap_8
XFILLER_418_70 VPWR VGND sg13cmos5l_decap_8
XFILLER_418_81 VPWR VGND sg13cmos5l_fill_2
XFILLER_326_195 VPWR VGND sg13cmos5l_decap_4
XFILLER_354_14 VPWR VGND sg13cmos5l_decap_8
XANTENNA__3165__X Tile_X0Y4_E6BEG[2] VPWR VGND sg13cmos5l_antennanp
XFILLER_125_268 VPWR VGND sg13cmos5l_decap_4
XFILLER_341_165 VPWR VGND sg13cmos5l_decap_8
XFILLER_491_0 VPWR VGND sg13cmos5l_decap_8
XFILLER_589_0 VPWR VGND sg13cmos5l_decap_8
XFILLER_428_203 VPWR VGND sg13cmos5l_decap_8
XFILLER_504_28 VPWR VGND sg13cmos5l_decap_8
XFILLER_651_56 VPWR VGND sg13cmos5l_decap_8
XFILLER_434_91 VPWR VGND sg13cmos5l_decap_8
XFILLER_239_147 VPWR VGND sg13cmos5l_decap_8
XFILLER_223_29 VPWR VGND sg13cmos5l_decap_8
X_0290_ _0290_/Q Tile_X0Y7_FrameData[29] VGND VPWR Tile_X0Y9_FrameStrobe[4] latch
XFILLER_644_133 VPWR VGND sg13cmos5l_decap_8
XFILLER_239_158 VPWR VGND sg13cmos5l_fill_1
XFILLER_11_7 VPWR VGND sg13cmos5l_decap_8
XFILLER_370_57 VPWR VGND sg13cmos5l_decap_4
XFILLER_153_92 VPWR VGND sg13cmos5l_decap_8
XFILLER_303_73 VPWR VGND sg13cmos5l_fill_1
XFILLER_520_49 VPWR VGND sg13cmos5l_fill_2
XFILLER_303_95 VPWR VGND sg13cmos5l_decap_4
XFILLER_597_254 VPWR VGND sg13cmos5l_fill_2
X_3980_ _3980_/X Tile_X0Y0_W1END[0] Tile_X0Y0_W6END[8] _3875_/X _3862_/X _1141_/Q
+ _1140_/Q VPWR VGND sg13cmos5l_mux4_1
XFILLER_557_118 VPWR VGND sg13cmos5l_decap_4
X_2931_ Tile_X0Y8_E2BEGb[7] _4743_/X VPWR VGND sg13cmos5l_buf_1
XFILLER_379_77 VPWR VGND sg13cmos5l_decap_8
XFILLER_600_258 VPWR VGND sg13cmos5l_fill_2
XFILLER_529_14 VPWR VGND sg13cmos5l_decap_8
XFILLER_411_158 VPWR VGND sg13cmos5l_decap_4
XFILLER_349_243 VPWR VGND sg13cmos5l_decap_8
XFILLER_676_42 VPWR VGND sg13cmos5l_decap_8
XFILLER_565_140 VPWR VGND sg13cmos5l_decap_8
X_2862_ Tile_X0Y6_E6BEG[11] _4539_/X VPWR VGND sg13cmos5l_buf_1
XFILLER_364_202 VPWR VGND sg13cmos5l_decap_8
XFILLER_309_118 VPWR VGND sg13cmos5l_decap_4
X_4601_ _4601_/X _4688_/X _4692_/X _4696_/X _4674_/X _0355_/Q _0354_/Q VPWR VGND sg13cmos5l_mux4_1
X_1813_ _1813_/Q Tile_X0Y3_FrameData[20] VGND VPWR Tile_X0Y9_FrameStrobe[4] latch
XFILLER_395_43 VPWR VGND sg13cmos5l_decap_8
XFILLER_714_126 VPWR VGND sg13cmos5l_decap_8
X_2793_ Tile_X0Y3_E6BEG[3] _4183_/X VPWR VGND sg13cmos5l_buf_1
XFILLER_317_140 VPWR VGND sg13cmos5l_decap_4
X_4532_ _4532_/X AXI_M_SOC_RDATA24 _4575_/X _4579_/X _4553_/X _2543_/Q _2542_/Q VPWR
+ VGND sg13cmos5l_mux4_1
X_1744_ _1744_/Q Tile_X0Y3_FrameData[25] VGND VPWR Tile_X0Y9_FrameStrobe[2] latch
XFILLER_506_262 VPWR VGND sg13cmos5l_fill_2
XFILLER_7_84 VPWR VGND sg13cmos5l_decap_8
XFILLER_545_35 VPWR VGND sg13cmos5l_decap_8
XFILLER_478_103 VPWR VGND sg13cmos5l_decap_8
X_4463_ _4463_/X _4418_/X _0157_/X _4417_/X _0143_/X _2213_/Q _2212_/Q VPWR VGND sg13cmos5l_mux4_1
XFILLER_264_14 VPWR VGND sg13cmos5l_decap_8
X_1675_ _1675_/Q Tile_X0Y3_FrameData[30] VGND VPWR Tile_X0Y9_FrameStrobe[0] latch
XFILLER_521_232 VPWR VGND sg13cmos5l_decap_8
XANTENNA__3075__X Tile_X0Y4_E2BEGb[1] VPWR VGND sg13cmos5l_antennanp
XFILLER_521_243 VPWR VGND sg13cmos5l_decap_8
X_3414_ Tile_X0Y4_FrameData_O[5] Tile_X0Y4_FrameData[5] VPWR VGND sg13cmos5l_buf_1
XFILLER_478_147 VPWR VGND sg13cmos5l_fill_1
XFILLER_332_165 VPWR VGND sg13cmos5l_decap_8
X_0626_ _0626_/Q Tile_X0Y8_FrameData[13] VGND VPWR Tile_X0Y9_FrameStrobe[6] latch
X_4394_ _4394_/X Tile_X0Y5_WW4END[9] AXI_M_SOC_RRESP0 _4460_/X _4430_/X _2315_/Q _2314_/Q
+ VPWR VGND sg13cmos5l_mux4_1
XFILLER_478_169 VPWR VGND sg13cmos5l_fill_1
XFILLER_419_203 VPWR VGND sg13cmos5l_decap_8
X_3345_ Tile_X0Y2_FrameData_O[16] Tile_X0Y2_FrameData[16] VPWR VGND sg13cmos5l_buf_1
XFILLER_414_28 VPWR VGND sg13cmos5l_decap_8
X_0557_ _0557_/Q Tile_X0Y8_FrameData[18] VGND VPWR Tile_X0Y9_FrameStrobe[4] latch
XFILLER_561_56 VPWR VGND sg13cmos5l_decap_8
XFILLER_285_231 VPWR VGND sg13cmos5l_decap_8
XFILLER_635_133 VPWR VGND sg13cmos5l_decap_8
X_3276_ Tile_X0Y0_EE4BEG[12] _3832_/X VPWR VGND sg13cmos5l_buf_1
XFILLER_280_35 VPWR VGND sg13cmos5l_decap_8
X_0488_ _0488_/Q Tile_X0Y8_FrameData[23] VGND VPWR Tile_X0Y9_FrameStrobe[2] latch
XFILLER_245_117 VPWR VGND sg13cmos5l_decap_8
X_2227_ _2227_/Q Tile_X0Y5_FrameData[18] VGND VPWR Tile_X0Y9_FrameStrobe[1] latch
XFILLER_690_272 VPWR VGND sg13cmos5l_fill_1
XFILLER_245_128 VPWR VGND sg13cmos5l_fill_2
XFILLER_399_110 VPWR VGND sg13cmos5l_decap_8
XFILLER_650_147 VPWR VGND sg13cmos5l_decap_8
XFILLER_213_84 VPWR VGND sg13cmos5l_decap_8
X_2158_ _2158_/Q Tile_X0Y4_FrameData[23] VGND VPWR Tile_X0Y9_FrameStrobe[7] latch
XFILLER_430_49 VPWR VGND sg13cmos5l_decap_8
XFILLER_260_109 VPWR VGND sg13cmos5l_fill_1
XFILLER_588_243 VPWR VGND sg13cmos5l_fill_2
XFILLER_26_49 VPWR VGND sg13cmos5l_decap_8
X_1109_ _1109_/Q Tile_X0Y0_FrameData[22] VGND VPWR Tile_X0Y9_FrameStrobe[5] latch
XFILLER_442_272 VPWR VGND sg13cmos5l_fill_1
X_2089_ _2089_/Q Tile_X0Y4_FrameData[28] VGND VPWR Tile_X0Y9_FrameStrobe[5] latch
XFILLER_548_107 VPWR VGND sg13cmos5l_decap_8
XFILLER_439_14 VPWR VGND sg13cmos5l_decap_8
XFILLER_586_42 VPWR VGND sg13cmos5l_decap_8
XFILLER_158_15 VPWR VGND sg13cmos5l_decap_8
XFILLER_355_224 VPWR VGND sg13cmos5l_decap_8
XFILLER_166_135 VPWR VGND sg13cmos5l_decap_8
XFILLER_705_126 VPWR VGND sg13cmos5l_decap_8
XFILLER_318_8 VPWR VGND sg13cmos5l_decap_8
XFILLER_181_105 VPWR VGND sg13cmos5l_decap_4
XFILLER_571_154 VPWR VGND sg13cmos5l_decap_8
XFILLER_213_7 VPWR VGND sg13cmos5l_decap_8
XFILLER_455_35 VPWR VGND sg13cmos5l_decap_8
XFILLER_370_249 VPWR VGND sg13cmos5l_decap_8
XFILLER_323_110 VPWR VGND sg13cmos5l_fill_1
XFILLER_174_14 VPWR VGND sg13cmos5l_decap_8
XFILLER_512_221 VPWR VGND sg13cmos5l_decap_8
XFILLER_323_132 VPWR VGND sg13cmos5l_decap_8
XFILLER_122_216 VPWR VGND sg13cmos5l_decap_4
XFILLER_174_69 VPWR VGND sg13cmos5l_decap_8
XFILLER_658_269 VPWR VGND sg13cmos5l_decap_4
XFILLER_605_49 VPWR VGND sg13cmos5l_decap_8
XFILLER_107_41 VPWR VGND sg13cmos5l_decap_4
XFILLER_122_249 VPWR VGND sg13cmos5l_decap_8
XFILLER_582_7 VPWR VGND sg13cmos5l_decap_8
XFILLER_107_74 VPWR VGND sg13cmos5l_decap_8
XANTENNA__3713__X AXI_M_SOC_WDATA23 VPWR VGND sg13cmos5l_antennanp
XFILLER_626_111 VPWR VGND sg13cmos5l_fill_2
XFILLER_471_56 VPWR VGND sg13cmos5l_decap_8
XFILLER_471_67 VPWR VGND sg13cmos5l_fill_2
XFILLER_130_271 VPWR VGND sg13cmos5l_fill_2
XFILLER_88_185 VPWR VGND sg13cmos5l_decap_8
XFILLER_67_56 VPWR VGND sg13cmos5l_decap_8
XFILLER_492_161 VPWR VGND sg13cmos5l_decap_8
XFILLER_425_217 VPWR VGND sg13cmos5l_decap_8
XFILLER_236_139 VPWR VGND sg13cmos5l_decap_8
XFILLER_291_245 VPWR VGND sg13cmos5l_decap_8
XFILLER_641_147 VPWR VGND sg13cmos5l_decap_8
XFILLER_340_49 VPWR VGND sg13cmos5l_decap_8
XFILLER_579_232 VPWR VGND sg13cmos5l_decap_8
XFILLER_123_95 VPWR VGND sg13cmos5l_decap_8
XFILLER_83_44 VPWR VGND sg13cmos5l_decap_8
XFILLER_701_70 VPWR VGND sg13cmos5l_decap_8
XFILLER_199_77 VPWR VGND sg13cmos5l_decap_8
XFILLER_594_246 VPWR VGND sg13cmos5l_fill_1
XFILLER_349_14 VPWR VGND sg13cmos5l_decap_8
XFILLER_337_0 VPWR VGND sg13cmos5l_decap_8
XFILLER_496_42 VPWR VGND sg13cmos5l_decap_8
XFILLER_12_152 VPWR VGND sg13cmos5l_decap_8
XFILLER_157_113 VPWR VGND sg13cmos5l_decap_4
XFILLER_547_184 VPWR VGND sg13cmos5l_fill_1
XANTENNA__2999__X Tile_X0Y5_E2BEG[2] VPWR VGND sg13cmos5l_antennanp
XFILLER_8_156 VPWR VGND sg13cmos5l_fill_1
XFILLER_504_0 VPWR VGND sg13cmos5l_decap_8
XFILLER_646_56 VPWR VGND sg13cmos5l_decap_8
XFILLER_562_154 VPWR VGND sg13cmos5l_decap_8
XFILLER_429_91 VPWR VGND sg13cmos5l_decap_8
XFILLER_365_35 VPWR VGND sg13cmos5l_decap_8
XFILLER_148_70 VPWR VGND sg13cmos5l_decap_8
XFILLER_562_198 VPWR VGND sg13cmos5l_fill_1
XFILLER_314_132 VPWR VGND sg13cmos5l_decap_8
XFILLER_180_160 VPWR VGND sg13cmos5l_fill_1
X_1460_ _1460_/Q Tile_X0Y2_FrameData[29] VGND VPWR Tile_X0Y9_FrameStrobe[1] latch
XFILLER_180_182 VPWR VGND sg13cmos5l_decap_8
XFILLER_515_49 VPWR VGND sg13cmos5l_decap_8
X_0411_ _0411_/Q Tile_X0Y7_FrameData[4] VGND VPWR Tile_X0Y9_FrameStrobe[7] latch
XFILLER_662_77 VPWR VGND sg13cmos5l_decap_8
XFILLER_234_28 VPWR VGND sg13cmos5l_decap_8
X_1391_ _1391_/Q Tile_X0Y1_FrameData[10] VGND VPWR Tile_X0Y9_FrameStrobe[6] latch
XANTENNA__3623__X Tile_X0Y9_S4BEG[1] VPWR VGND sg13cmos5l_antennanp
X_3130_ Tile_X0Y7_FrameData_O[0] Tile_X0Y7_FrameData[0] VPWR VGND sg13cmos5l_buf_1
XFILLER_381_67 VPWR VGND sg13cmos5l_decap_8
X_0342_ _0342_/Q Tile_X0Y7_FrameData[9] VGND VPWR Tile_X0Y9_FrameStrobe[5] latch
XFILLER_267_253 VPWR VGND sg13cmos5l_fill_2
XFILLER_79_196 VPWR VGND sg13cmos5l_decap_8
XFILLER_314_50 VPWR VGND sg13cmos5l_decap_8
X_3061_ Tile_X0Y5_FrameData_O[20] Tile_X0Y5_FrameData[20] VPWR VGND sg13cmos5l_buf_1
XFILLER_672_272 VPWR VGND sg13cmos5l_fill_1
X_0273_ _0273_/Q Tile_X0Y7_FrameData[14] VGND VPWR Tile_X0Y9_FrameStrobe[3] latch
XFILLER_416_239 VPWR VGND sg13cmos5l_decap_4
X_2012_ _2012_/Q Tile_X0Y4_FrameData[9] VGND VPWR Tile_X0Y9_FrameStrobe[2] latch
XFILLER_282_256 VPWR VGND sg13cmos5l_decap_4
XFILLER_632_147 VPWR VGND sg13cmos5l_decap_4
XFILLER_250_49 VPWR VGND sg13cmos5l_fill_1
XFILLER_611_70 VPWR VGND sg13cmos5l_decap_8
XFILLER_235_183 VPWR VGND sg13cmos5l_decap_8
XFILLER_585_202 VPWR VGND sg13cmos5l_decap_8
XFILLER_250_120 VPWR VGND sg13cmos5l_decap_8
XFILLER_396_124 VPWR VGND sg13cmos5l_decap_8
XFILLER_330_93 VPWR VGND sg13cmos5l_decap_8
X_3963_ _3963_/X Tile_X0Y1_WW4END[0] AXI_M_SOC_ARREADY _4008_/X _3989_/X _1283_/Q
+ _1282_/Q VPWR VGND sg13cmos5l_mux4_1
XFILLER_195_208 VPWR VGND sg13cmos5l_decap_8
XFILLER_259_36 VPWR VGND sg13cmos5l_fill_1
X_2914_ Tile_X0Y8_E1BEG[2] _4726_/X VPWR VGND sg13cmos5l_buf_1
XFILLER_250_197 VPWR VGND sg13cmos5l_decap_8
XFILLER_337_202 VPWR VGND sg13cmos5l_decap_4
X_3894_ _3894_/X Tile_X0Y2_W2MID[4] Tile_X0Y2_W2END[4] Tile_X0Y2_W6END[4] _4103_/X
+ _1659_/Q _1658_/Q VPWR VGND sg13cmos5l_mux4_1
XFILLER_85_0 VPWR VGND sg13cmos5l_decap_8
X_2845_ Tile_X0Y6_E2BEGb[2] _4506_/X VPWR VGND sg13cmos5l_buf_1
XFILLER_409_28 VPWR VGND sg13cmos5l_decap_8
XFILLER_148_168 VPWR VGND sg13cmos5l_decap_8
XFILLER_556_56 VPWR VGND sg13cmos5l_decap_8
XFILLER_339_91 VPWR VGND sg13cmos5l_decap_8
XFILLER_699_147 VPWR VGND sg13cmos5l_decap_8
XFILLER_163_116 VPWR VGND sg13cmos5l_decap_8
X_2776_ Tile_X0Y3_EE4BEG[2] _4166_/X VPWR VGND sg13cmos5l_buf_1
XFILLER_702_107 VPWR VGND sg13cmos5l_fill_1
XFILLER_275_35 VPWR VGND sg13cmos5l_decap_8
XFILLER_352_238 VPWR VGND sg13cmos5l_decap_8
X_4515_ _4515_/X Tile_X0Y6_WW4END[12] AXI_M_SOC_RDATA27 _4580_/X _4558_/X _2577_/Q
+ _2576_/Q VPWR VGND sg13cmos5l_mux4_1
X_1727_ _1727_/Q Tile_X0Y3_FrameData[10] VGND VPWR Tile_X0Y9_FrameStrobe[1] latch
XFILLER_171_171 VPWR VGND sg13cmos5l_decap_8
X_4446_ _4446_/X _4922_/X _4926_/X _4930_/X _4905_/X _0897_/Q _0896_/Q VPWR VGND sg13cmos5l_mux4_1
XFILLER_360_260 VPWR VGND sg13cmos5l_fill_1
XFILLER_104_227 VPWR VGND sg13cmos5l_decap_8
X_1658_ _1658_/Q Tile_X0Y2_FrameData[23] VGND VPWR Tile_X0Y9_FrameStrobe[7] latch
XFILLER_425_49 VPWR VGND sg13cmos5l_decap_8
XFILLER_360_271 VPWR VGND sg13cmos5l_fill_2
XFILLER_208_84 VPWR VGND sg13cmos5l_decap_8
XFILLER_305_198 VPWR VGND sg13cmos5l_decap_8
XFILLER_572_77 VPWR VGND sg13cmos5l_decap_8
XFILLER_144_28 VPWR VGND sg13cmos5l_decap_8
X_0609_ _0609_/Q Tile_X0Y8_FrameData[30] VGND VPWR Tile_X0Y9_FrameStrobe[6] latch
X_4377_ _4377_/X Tile_X0Y5_W2MID[2] AXI_M_SOC_RLAST _4432_/X _4431_/X _2349_/Q _2348_/Q
+ VPWR VGND sg13cmos5l_mux4_1
XANTENNA__3533__X Tile_X0Y9_E2BEG[7] VPWR VGND sg13cmos5l_antennanp
X_1589_ _1589_/Q Tile_X0Y2_FrameData[28] VGND VPWR Tile_X0Y9_FrameStrobe[5] latch
XFILLER_320_168 VPWR VGND sg13cmos5l_decap_8
XFILLER_112_260 VPWR VGND sg13cmos5l_fill_1
X_3328_ Tile_X0Y2_UserCLKo Tile_X0Y2_UserCLK VPWR VGND sg13cmos5l_buf_1
XFILLER_291_78 VPWR VGND sg13cmos5l_decap_8
XFILLER_608_166 VPWR VGND sg13cmos5l_decap_8
XFILLER_85_144 VPWR VGND sg13cmos5l_decap_8
XFILLER_663_272 VPWR VGND sg13cmos5l_fill_1
XFILLER_85_155 VPWR VGND sg13cmos5l_fill_1
X_3259_ Tile_X0Y0_FrameData_O[27] Tile_X0Y0_FrameData[27] VPWR VGND sg13cmos5l_buf_1
XFILLER_85_177 VPWR VGND sg13cmos5l_decap_8
XFILLER_273_245 VPWR VGND sg13cmos5l_fill_1
XFILLER_160_49 VPWR VGND sg13cmos5l_decap_8
XFILLER_623_169 VPWR VGND sg13cmos5l_decap_8
XFILLER_163_7 VPWR VGND sg13cmos5l_decap_8
XFILLER_631_180 VPWR VGND sg13cmos5l_fill_1
XFILLER_53_25 VPWR VGND sg13cmos5l_decap_8
XFILLER_430_231 VPWR VGND sg13cmos5l_decap_8
XFILLER_169_14 VPWR VGND sg13cmos5l_decap_8
XFILLER_241_164 VPWR VGND sg13cmos5l_decap_8
XFILLER_576_268 VPWR VGND sg13cmos5l_decap_4
XFILLER_387_168 VPWR VGND sg13cmos5l_fill_2
XFILLER_428_7 VPWR VGND sg13cmos5l_decap_8
XFILLER_328_213 VPWR VGND sg13cmos5l_decap_8
XANTENNA__0116__Y AXI_M_SOC_ARLEN7 VPWR VGND sg13cmos5l_antennanp
XFILLER_544_121 VPWR VGND sg13cmos5l_decap_8
XFILLER_319_28 VPWR VGND sg13cmos5l_fill_1
XFILLER_139_168 VPWR VGND sg13cmos5l_decap_8
XANTENNA__3708__X AXI_M_SOC_WDATA18 VPWR VGND sg13cmos5l_antennanp
XFILLER_466_56 VPWR VGND sg13cmos5l_decap_8
XFILLER_185_35 VPWR VGND sg13cmos5l_decap_8
XFILLER_544_198 VPWR VGND sg13cmos5l_decap_8
XFILLER_343_249 VPWR VGND sg13cmos5l_decap_4
XFILLER_698_191 VPWR VGND sg13cmos5l_decap_8
XFILLER_497_231 VPWR VGND sg13cmos5l_decap_8
XFILLER_351_271 VPWR VGND sg13cmos5l_fill_2
XFILLER_335_49 VPWR VGND sg13cmos5l_decap_8
XFILLER_500_224 VPWR VGND sg13cmos5l_decap_8
XFILLER_646_217 VPWR VGND sg13cmos5l_decap_8
XFILLER_632_14 VPWR VGND sg13cmos5l_decap_8
XFILLER_457_139 VPWR VGND sg13cmos5l_fill_2
XANTENNA__3443__X Tile_X0Y1_FrameData_O[1] VPWR VGND sg13cmos5l_antennanp
XFILLER_500_268 VPWR VGND sg13cmos5l_decap_4
XFILLER_76_100 VPWR VGND sg13cmos5l_fill_1
XFILLER_415_93 VPWR VGND sg13cmos5l_decap_8
XFILLER_209_128 VPWR VGND sg13cmos5l_decap_8
XFILLER_94_21 VPWR VGND sg13cmos5l_decap_8
XFILLER_287_0 VPWR VGND sg13cmos5l_decap_8
XFILLER_654_272 VPWR VGND sg13cmos5l_fill_1
XFILLER_264_234 VPWR VGND sg13cmos5l_decap_8
XFILLER_91_103 VPWR VGND sg13cmos5l_decap_8
XFILLER_712_91 VPWR VGND sg13cmos5l_decap_8
XFILLER_17_211 VPWR VGND sg13cmos5l_decap_4
XFILLER_217_150 VPWR VGND sg13cmos5l_decap_8
XFILLER_431_70 VPWR VGND sg13cmos5l_decap_8
XFILLER_454_0 VPWR VGND sg13cmos5l_decap_8
XFILLER_17_244 VPWR VGND sg13cmos5l_decap_8
XFILLER_406_272 VPWR VGND sg13cmos5l_fill_1
XFILLER_217_183 VPWR VGND sg13cmos5l_decap_8
XFILLER_421_220 VPWR VGND sg13cmos5l_fill_1
XFILLER_622_180 VPWR VGND sg13cmos5l_decap_8
XFILLER_567_224 VPWR VGND sg13cmos5l_decap_8
XFILLER_421_242 VPWR VGND sg13cmos5l_decap_8
XFILLER_421_253 VPWR VGND sg13cmos5l_fill_1
XFILLER_32_225 VPWR VGND sg13cmos5l_decap_8
XFILLER_621_0 VPWR VGND sg13cmos5l_decap_8
XFILLER_32_236 VPWR VGND sg13cmos5l_fill_2
XFILLER_232_175 VPWR VGND sg13cmos5l_decap_8
XFILLER_300_63 VPWR VGND sg13cmos5l_decap_8
X_0960_ _0960_/Q Tile_X0Y0_FrameData[11] VGND VPWR Tile_X0Y9_FrameStrobe[0] latch
XFILLER_709_251 VPWR VGND sg13cmos5l_decap_4
XFILLER_300_85 VPWR VGND sg13cmos5l_fill_1
XFILLER_393_149 VPWR VGND sg13cmos5l_decap_8
XFILLER_229_28 VPWR VGND sg13cmos5l_decap_8
XFILLER_657_88 VPWR VGND sg13cmos5l_decap_8
X_0891_ _0891_/Q Tile_X0Y9_FrameData[4] VGND VPWR Tile_X0Y9_FrameStrobe[6] latch
XANTENNA__3618__X Tile_X0Y9_S2BEGb[4] VPWR VGND sg13cmos5l_antennanp
X_2630_ _2630_/Q Tile_X0Y6_FrameData[1] VGND VPWR Tile_X0Y9_FrameStrobe[5] latch
XFILLER_535_176 VPWR VGND sg13cmos5l_decap_4
XFILLER_673_21 VPWR VGND sg13cmos5l_decap_8
XFILLER_145_149 VPWR VGND sg13cmos5l_decap_8
XFILLER_535_198 VPWR VGND sg13cmos5l_fill_1
XFILLER_696_117 VPWR VGND sg13cmos5l_decap_8
X_2561_ _2561_/Q Tile_X0Y6_FrameData[6] VGND VPWR Tile_X0Y9_FrameStrobe[3] latch
XFILLER_160_119 VPWR VGND sg13cmos5l_decap_8
X_4300_ _4300_/X _4302_/X Tile_X0Y4_W6END[0] _4301_/X _4300_/A3 _1933_/Q _1932_/Q
+ VPWR VGND sg13cmos5l_mux4_1
X_1512_ _1512_/Q Tile_X0Y2_FrameData[9] VGND VPWR Tile_X0Y9_FrameStrobe[2] latch
X_2492_ _2492_/Q Tile_X0Y6_FrameData[11] VGND VPWR Tile_X0Y9_FrameStrobe[1] latch
XFILLER_299_164 VPWR VGND sg13cmos5l_fill_2
XFILLER_245_49 VPWR VGND sg13cmos5l_decap_8
X_4231_ _4231_/X _4197_/X _0088_/X _4196_/X Tile_X0Y0_S4END[13] _1711_/Q _1710_/Q
+ VPWR VGND sg13cmos5l_mux4_1
X_1443_ _1443_/Q Tile_X0Y2_FrameData[14] VGND VPWR Tile_X0Y9_FrameStrobe[0] latch
XFILLER_606_92 VPWR VGND sg13cmos5l_decap_8
XFILLER_542_14 VPWR VGND sg13cmos5l_decap_8
XFILLER_4_63 VPWR VGND sg13cmos5l_decap_8
XANTENNA__3353__X Tile_X0Y2_FrameData_O[24] VPWR VGND sg13cmos5l_antennanp
X_4162_ _4162_/X Tile_X0Y3_W2END[1] AXI_M_SOC_BVALID _4207_/X _4206_/X _1817_/Q _1816_/Q
+ VPWR VGND sg13cmos5l_mux4_1
X_1374_ _1374_/Q Tile_X0Y1_FrameData[27] VGND VPWR Tile_X0Y9_FrameStrobe[6] latch
XFILLER_255_201 VPWR VGND sg13cmos5l_decap_8
XFILLER_67_133 VPWR VGND sg13cmos5l_decap_8
X_3113_ Tile_X0Y7_E6BEG[11] _4655_/X VPWR VGND sg13cmos5l_buf_1
X_0325_ _0325_/Q Tile_X0Y7_FrameData[26] VGND VPWR Tile_X0Y9_FrameStrobe[5] latch
X_4093_ _4093_/X Tile_X0Y3_W1END[2] Tile_X0Y3_W6END[6] _4215_/X _4192_/X _1921_/Q
+ _1920_/Q VPWR VGND sg13cmos5l_mux4_1
XFILLER_82_103 VPWR VGND sg13cmos5l_decap_8
XFILLER_622_91 VPWR VGND sg13cmos5l_decap_4
XFILLER_471_131 VPWR VGND sg13cmos5l_decap_4
XFILLER_255_256 VPWR VGND sg13cmos5l_fill_2
X_3044_ Tile_X0Y5_FrameData_O[3] Tile_X0Y5_FrameData[3] VPWR VGND sg13cmos5l_buf_1
X_0256_ _0256_/Q Tile_X0Y7_FrameData[31] VGND VPWR Tile_X0Y9_FrameStrobe[3] latch
XFILLER_341_70 VPWR VGND sg13cmos5l_decap_8
XFILLER_208_161 VPWR VGND sg13cmos5l_decap_8
XFILLER_223_120 VPWR VGND sg13cmos5l_decap_8
X_0187_ _0187_/Q Tile_X0Y7_FrameData[4] VGND VPWR Tile_X0Y9_FrameStrobe[0] latch
XFILLER_698_84 VPWR VGND sg13cmos5l_decap_8
XFILLER_90_180 VPWR VGND sg13cmos5l_decap_8
XFILLER_558_257 VPWR VGND sg13cmos5l_fill_2
XFILLER_210_63 VPWR VGND sg13cmos5l_decap_8
X_3946_ _3946_/X Tile_X0Y1_W2END[1] AXI_M_SOC_ARREADY _3991_/X _3990_/X _1317_/Q _1316_/Q
+ VPWR VGND sg13cmos5l_mux4_1
XFILLER_23_28 VPWR VGND sg13cmos5l_decap_8
XFILLER_573_238 VPWR VGND sg13cmos5l_decap_8
XFILLER_23_39 VPWR VGND sg13cmos5l_fill_2
XFILLER_715_210 VPWR VGND sg13cmos5l_decap_8
XFILLER_573_249 VPWR VGND sg13cmos5l_fill_2
XFILLER_567_77 VPWR VGND sg13cmos5l_decap_8
XFILLER_139_28 VPWR VGND sg13cmos5l_decap_8
X_3877_ _3877_/X Tile_X0Y4_W1END[3] Tile_X0Y4_WW4END[3] Tile_X0Y4_W6END[11] _4339_/X
+ _2148_/Q _2147_/Q VPWR VGND sg13cmos5l_mux4_1
XANTENNA__3528__X Tile_X0Y9_E2BEG[2] VPWR VGND sg13cmos5l_antennanp
XFILLER_286_56 VPWR VGND sg13cmos5l_decap_8
X_2828_ Tile_X0Y4_E2BEG[6] _4262_/X VPWR VGND sg13cmos5l_buf_1
XFILLER_526_176 VPWR VGND sg13cmos5l_decap_8
XFILLER_583_21 VPWR VGND sg13cmos5l_decap_8
XFILLER_541_113 VPWR VGND sg13cmos5l_fill_2
XFILLER_136_149 VPWR VGND sg13cmos5l_decap_8
XFILLER_392_193 VPWR VGND sg13cmos5l_decap_8
XFILLER_219_83 VPWR VGND sg13cmos5l_decap_8
X_2759_ Tile_X0Y3_FrameData_O[17] Tile_X0Y3_FrameData[17] VPWR VGND sg13cmos5l_buf_1
XFILLER_687_139 VPWR VGND sg13cmos5l_decap_8
XFILLER_144_160 VPWR VGND sg13cmos5l_fill_1
XFILLER_541_179 VPWR VGND sg13cmos5l_decap_4
XFILLER_333_260 VPWR VGND sg13cmos5l_fill_1
XFILLER_155_49 VPWR VGND sg13cmos5l_decap_8
XFILLER_144_182 VPWR VGND sg13cmos5l_decap_8
XFILLER_516_70 VPWR VGND sg13cmos5l_decap_8
X_4429_ _4429_/X _4365_/X _4481_/X _4480_/X _4364_/X _2193_/Q _2192_/Q VPWR VGND sg13cmos5l_mux4_1
XFILLER_452_14 VPWR VGND sg13cmos5l_decap_8
XANTENNA__3263__X Tile_X0Y0_FrameData_O[31] VPWR VGND sg13cmos5l_antennanp
XFILLER_494_256 VPWR VGND sg13cmos5l_decap_4
XFILLER_246_201 VPWR VGND sg13cmos5l_decap_8
XFILLER_602_28 VPWR VGND sg13cmos5l_decap_8
XFILLER_58_144 VPWR VGND sg13cmos5l_decap_8
XFILLER_447_172 VPWR VGND sg13cmos5l_decap_8
XFILLER_280_7 VPWR VGND sg13cmos5l_decap_8
XFILLER_104_42 VPWR VGND sg13cmos5l_fill_2
XFILLER_651_231 VPWR VGND sg13cmos5l_decap_8
XFILLER_251_70 VPWR VGND sg13cmos5l_decap_8
XFILLER_64_35 VPWR VGND sg13cmos5l_decap_8
XFILLER_611_106 VPWR VGND sg13cmos5l_fill_1
XFILLER_545_7 VPWR VGND sg13cmos5l_decap_8
XFILLER_549_224 VPWR VGND sg13cmos5l_fill_2
XFILLER_214_186 VPWR VGND sg13cmos5l_decap_8
XFILLER_549_268 VPWR VGND sg13cmos5l_decap_4
XANTENNA__0127__X AXI_M_SOC_WLAST VPWR VGND sg13cmos5l_antennanp
XFILLER_712_7 VPWR VGND sg13cmos5l_decap_8
XFILLER_564_205 VPWR VGND sg13cmos5l_decap_8
XFILLER_375_127 VPWR VGND sg13cmos5l_decap_8
XFILLER_120_96 VPWR VGND sg13cmos5l_decap_8
XFILLER_517_110 VPWR VGND sg13cmos5l_decap_8
XFILLER_627_14 VPWR VGND sg13cmos5l_decap_8
XANTENNA__3438__X Tile_X0Y4_FrameData_O[29] VPWR VGND sg13cmos5l_antennanp
XFILLER_196_56 VPWR VGND sg13cmos5l_decap_8
XFILLER_127_127 VPWR VGND sg13cmos5l_decap_8
XFILLER_13_72 VPWR VGND sg13cmos5l_decap_8
XFILLER_13_83 VPWR VGND sg13cmos5l_fill_2
XFILLER_383_182 VPWR VGND sg13cmos5l_decap_8
XFILLER_493_21 VPWR VGND sg13cmos5l_decap_8
XFILLER_517_198 VPWR VGND sg13cmos5l_decap_8
XFILLER_89_21 VPWR VGND sg13cmos5l_decap_8
XFILLER_202_0 VPWR VGND sg13cmos5l_decap_8
XFILLER_142_119 VPWR VGND sg13cmos5l_decap_8
XFILLER_707_91 VPWR VGND sg13cmos5l_decap_8
XFILLER_493_98 VPWR VGND sg13cmos5l_decap_8
XFILLER_324_271 VPWR VGND sg13cmos5l_fill_2
XFILLER_643_35 VPWR VGND sg13cmos5l_decap_8
XFILLER_426_70 VPWR VGND sg13cmos5l_decap_8
XFILLER_619_217 VPWR VGND sg13cmos5l_decap_8
XFILLER_362_14 VPWR VGND sg13cmos5l_decap_8
XANTENNA__3173__X Tile_X0Y4_E6BEG[10] VPWR VGND sg13cmos5l_antennanp
XFILLER_96_228 VPWR VGND sg13cmos5l_decap_8
XFILLER_634_209 VPWR VGND sg13cmos5l_fill_2
XFILLER_571_0 VPWR VGND sg13cmos5l_decap_8
XFILLER_296_189 VPWR VGND sg13cmos5l_fill_2
XFILLER_669_0 VPWR VGND sg13cmos5l_decap_8
XFILLER_438_172 VPWR VGND sg13cmos5l_decap_8
XFILLER_512_28 VPWR VGND sg13cmos5l_decap_8
XFILLER_642_231 VPWR VGND sg13cmos5l_decap_8
X_0110_ _0110_/X _4328_/X _4329_/X _1109_/Q VPWR VGND sg13cmos5l_mux2_1
X_1090_ _1090_/Q Tile_X0Y0_FrameData[9] VGND VPWR Tile_X0Y9_FrameStrobe[4] latch
XFILLER_453_164 VPWR VGND sg13cmos5l_fill_2
XFILLER_64_147 VPWR VGND sg13cmos5l_decap_8
XFILLER_398_208 VPWR VGND sg13cmos5l_decap_8
XFILLER_602_117 VPWR VGND sg13cmos5l_decap_8
X_0041_ _3630_/A _4716_/X _4717_/X _0609_/Q VPWR VGND sg13cmos5l_mux2_1
XFILLER_668_21 VPWR VGND sg13cmos5l_decap_8
XFILLER_260_270 VPWR VGND sg13cmos5l_fill_2
XFILLER_610_161 VPWR VGND sg13cmos5l_fill_1
XFILLER_220_123 VPWR VGND sg13cmos5l_decap_8
X_3800_ _3800_/X _3848_/X Tile_X0Y0_W2END[0] Tile_X0Y0_W2END[1] Tile_X0Y0_S1END[0]
+ _1105_/Q _1104_/Q VPWR VGND sg13cmos5l_mux4_1
X_4780_ _4780_/X Tile_X0Y7_W1END[2] Tile_X0Y7_W6END[10] _4698_/X _4658_/X _0375_/Q
+ _0374_/Q VPWR VGND sg13cmos5l_mux4_1
XFILLER_610_183 VPWR VGND sg13cmos5l_decap_8
X_1992_ _1992_/Q Tile_X0Y4_FrameData[29] VGND VPWR Tile_X0Y9_FrameStrobe[2] latch
XFILLER_366_127 VPWR VGND sg13cmos5l_fill_1
XFILLER_158_230 VPWR VGND sg13cmos5l_decap_4
XFILLER_387_66 VPWR VGND sg13cmos5l_decap_8
X_3731_ AXI_M_SOC_ARADDR3 Tile_X0Y9_WW4END[3] Tile_X0Y9_WW4END[11] Tile_X0Y9_W6END[3]
+ _4919_/X _0753_/Q _0752_/Q VPWR VGND sg13cmos5l_mux4_1
XFILLER_158_241 VPWR VGND sg13cmos5l_decap_8
X_0943_ _0943_/Q Tile_X0Y0_FrameData[28] VGND VPWR Tile_X0Y9_FrameStrobe[0] latch
XFILLER_537_14 VPWR VGND sg13cmos5l_decap_8
XANTENNA__3348__X Tile_X0Y2_FrameData_O[19] VPWR VGND sg13cmos5l_antennanp
X_3662_ AXI_M_SOC_AWADDR23 Tile_X0Y4_WW4END[7] Tile_X0Y4_WW4END[15] Tile_X0Y4_W6END[7]
+ _4343_/X _1999_/Q _1998_/Q VPWR VGND sg13cmos5l_mux4_1
X_0874_ _0874_/Q Tile_X0Y9_FrameData[21] VGND VPWR Tile_X0Y9_FrameStrobe[6] latch
XFILLER_563_271 VPWR VGND sg13cmos5l_fill_2
XFILLER_508_176 VPWR VGND sg13cmos5l_fill_1
XFILLER_118_138 VPWR VGND sg13cmos5l_decap_8
XFILLER_684_75 VPWR VGND sg13cmos5l_decap_8
XFILLER_307_238 VPWR VGND sg13cmos5l_decap_4
XFILLER_118_149 VPWR VGND sg13cmos5l_fill_1
X_2613_ _2613_/Q Tile_X0Y6_FrameData[18] VGND VPWR Tile_X0Y9_FrameStrobe[5] latch
XFILLER_173_266 VPWR VGND sg13cmos5l_decap_8
X_3593_ Tile_X0Y9_FrameData_O[23] Tile_X0Y9_FrameData[23] VPWR VGND sg13cmos5l_buf_1
XFILLER_322_219 VPWR VGND sg13cmos5l_fill_2
X_2544_ _2544_/Q Tile_X0Y6_FrameData[23] VGND VPWR Tile_X0Y9_FrameStrobe[3] latch
XFILLER_553_35 VPWR VGND sg13cmos5l_decap_8
XFILLER_287_112 VPWR VGND sg13cmos5l_decap_8
XFILLER_141_130 VPWR VGND sg13cmos5l_decap_8
XFILLER_677_172 VPWR VGND sg13cmos5l_decap_8
XFILLER_272_14 VPWR VGND sg13cmos5l_decap_8
X_2475_ _2475_/Q Tile_X0Y6_FrameData[28] VGND VPWR Tile_X0Y9_FrameStrobe[1] latch
XFILLER_677_183 VPWR VGND sg13cmos5l_fill_2
XFILLER_330_241 VPWR VGND sg13cmos5l_decap_8
XANTENNA__3083__X Tile_X0Y7_E1BEG[1] VPWR VGND sg13cmos5l_antennanp
XFILLER_476_245 VPWR VGND sg13cmos5l_fill_2
X_4214_ _4214_/X _4688_/X _4692_/X _4696_/X _4669_/X _0391_/Q _0390_/Q VPWR VGND sg13cmos5l_mux4_1
X_1426_ _1426_/Q Tile_X0Y1_FrameData[31] VGND VPWR Tile_X0Y9_FrameStrobe[0] latch
XFILLER_703_49 VPWR VGND sg13cmos5l_decap_8
XFILLER_692_164 VPWR VGND sg13cmos5l_decap_8
XFILLER_287_189 VPWR VGND sg13cmos5l_decap_8
XFILLER_429_161 VPWR VGND sg13cmos5l_decap_8
XFILLER_205_63 VPWR VGND sg13cmos5l_decap_8
X_4145_ _4145_/X _4197_/X Tile_X0Y3_WW4END[7] _4196_/X AXI_M_SOC_WREADY _1851_/Q _1850_/Q
+ VPWR VGND sg13cmos5l_mux4_1
XFILLER_422_28 VPWR VGND sg13cmos5l_decap_8
X_1357_ _1357_/Q Tile_X0Y1_FrameData[12] VGND VPWR Tile_X0Y9_FrameStrobe[5] latch
XFILLER_228_245 VPWR VGND sg13cmos5l_fill_1
XFILLER_18_28 VPWR VGND sg13cmos5l_decap_8
XFILLER_95_272 VPWR VGND sg13cmos5l_fill_1
XFILLER_491_259 VPWR VGND sg13cmos5l_fill_2
XFILLER_352_91 VPWR VGND sg13cmos5l_decap_8
X_0308_ _0308_/Q Tile_X0Y7_FrameData[11] VGND VPWR Tile_X0Y9_FrameStrobe[4] latch
XFILLER_633_242 VPWR VGND sg13cmos5l_decap_8
XFILLER_55_125 VPWR VGND sg13cmos5l_decap_8
X_4076_ _4076_/X AXI_M_SOC_AWREADY _4123_/X _4127_/X _4097_/X _1521_/Q _1520_/Q VPWR
+ VGND sg13cmos5l_mux4_1
X_1288_ _1288_/Q Tile_X0Y1_FrameData[17] VGND VPWR Tile_X0Y9_FrameStrobe[3] latch
X_3027_ Tile_X0Y5_EE4BEG[2] _4390_/X VPWR VGND sg13cmos5l_buf_1
XFILLER_444_197 VPWR VGND sg13cmos5l_decap_8
X_0239_ _0239_/Q Tile_X0Y7_FrameData[16] VGND VPWR Tile_X0Y9_FrameStrobe[2] latch
XFILLER_70_106 VPWR VGND sg13cmos5l_decap_8
XFILLER_578_21 VPWR VGND sg13cmos5l_decap_8
XFILLER_397_230 VPWR VGND sg13cmos5l_decap_8
XFILLER_251_270 VPWR VGND sg13cmos5l_fill_2
XFILLER_211_112 VPWR VGND sg13cmos5l_decap_8
XFILLER_34_49 VPWR VGND sg13cmos5l_decap_8
XFILLER_297_22 VPWR VGND sg13cmos5l_decap_8
XFILLER_357_105 VPWR VGND sg13cmos5l_decap_8
XFILLER_400_223 VPWR VGND sg13cmos5l_fill_2
XFILLER_578_98 VPWR VGND sg13cmos5l_decap_8
XFILLER_11_217 VPWR VGND sg13cmos5l_decap_8
XFILLER_149_241 VPWR VGND sg13cmos5l_decap_8
X_3929_ _3929_/X _3983_/X Tile_X0Y1_WW4END[5] _3982_/X AXI_M_SOC_ARREADY _1351_/Q
+ _1350_/Q VPWR VGND sg13cmos5l_mux4_1
XFILLER_447_14 VPWR VGND sg13cmos5l_decap_8
XANTENNA__3258__X Tile_X0Y0_FrameData_O[26] VPWR VGND sg13cmos5l_antennanp
XFILLER_372_108 VPWR VGND sg13cmos5l_fill_2
XFILLER_594_42 VPWR VGND sg13cmos5l_decap_8
XFILLER_126_7 VPWR VGND sg13cmos5l_decap_8
XFILLER_703_202 VPWR VGND sg13cmos5l_decap_4
XFILLER_594_86 VPWR VGND sg13cmos5l_decap_8
XFILLER_166_48 VPWR VGND sg13cmos5l_decap_8
XFILLER_124_119 VPWR VGND sg13cmos5l_decap_8
XFILLER_463_35 VPWR VGND sg13cmos5l_decap_8
XFILLER_380_196 VPWR VGND sg13cmos5l_decap_8
XFILLER_117_193 VPWR VGND sg13cmos5l_decap_8
XFILLER_463_46 VPWR VGND sg13cmos5l_fill_1
XFILLER_278_112 VPWR VGND sg13cmos5l_decap_8
XFILLER_59_35 VPWR VGND sg13cmos5l_decap_4
XFILLER_59_46 VPWR VGND sg13cmos5l_decap_8
XFILLER_132_152 VPWR VGND sg13cmos5l_decap_8
XFILLER_495_7 VPWR VGND sg13cmos5l_decap_8
XFILLER_613_49 VPWR VGND sg13cmos5l_decap_8
XFILLER_278_189 VPWR VGND sg13cmos5l_decap_8
XFILLER_219_201 VPWR VGND sg13cmos5l_fill_1
XFILLER_482_215 VPWR VGND sg13cmos5l_fill_2
XFILLER_332_28 VPWR VGND sg13cmos5l_decap_8
XFILLER_219_234 VPWR VGND sg13cmos5l_fill_1
XFILLER_662_7 VPWR VGND sg13cmos5l_decap_8
XFILLER_293_148 VPWR VGND sg13cmos5l_decap_8
XFILLER_115_74 VPWR VGND sg13cmos5l_decap_8
XANTENNA__3721__X AXI_M_SOC_WDATA31 VPWR VGND sg13cmos5l_antennanp
XFILLER_86_272 VPWR VGND sg13cmos5l_fill_1
XFILLER_376_4 VPWR VGND sg13cmos5l_fill_1
XFILLER_75_56 VPWR VGND sg13cmos5l_decap_8
XFILLER_412_50 VPWR VGND sg13cmos5l_decap_8
XFILLER_435_175 VPWR VGND sg13cmos5l_decap_4
XFILLER_435_186 VPWR VGND sg13cmos5l_decap_8
XFILLER_450_123 VPWR VGND sg13cmos5l_decap_8
XFILLER_450_145 VPWR VGND sg13cmos5l_decap_8
XFILLER_488_21 VPWR VGND sg13cmos5l_decap_8
XFILLER_450_156 VPWR VGND sg13cmos5l_fill_1
XFILLER_450_178 VPWR VGND sg13cmos5l_decap_8
XFILLER_152_0 VPWR VGND sg13cmos5l_decap_8
XFILLER_202_112 VPWR VGND sg13cmos5l_decap_8
XFILLER_348_105 VPWR VGND sg13cmos5l_decap_8
XFILLER_199_196 VPWR VGND sg13cmos5l_fill_2
XFILLER_638_35 VPWR VGND sg13cmos5l_decap_8
XFILLER_202_178 VPWR VGND sg13cmos5l_decap_8
XFILLER_357_14 VPWR VGND sg13cmos5l_decap_8
XANTENNA__3168__X Tile_X0Y4_E6BEG[5] VPWR VGND sg13cmos5l_antennanp
XFILLER_155_200 VPWR VGND sg13cmos5l_decap_8
XFILLER_417_0 VPWR VGND sg13cmos5l_decap_8
XFILLER_10_250 VPWR VGND sg13cmos5l_decap_8
XFILLER_10_261 VPWR VGND sg13cmos5l_fill_1
XFILLER_6_210 VPWR VGND sg13cmos5l_decap_8
XFILLER_356_182 VPWR VGND sg13cmos5l_decap_8
XFILLER_507_28 VPWR VGND sg13cmos5l_decap_8
XFILLER_505_157 VPWR VGND sg13cmos5l_decap_8
XFILLER_170_214 VPWR VGND sg13cmos5l_decap_8
XFILLER_505_168 VPWR VGND sg13cmos5l_fill_2
XFILLER_437_91 VPWR VGND sg13cmos5l_decap_8
XANTENNA__2800__X Tile_X0Y3_E6BEG[10] VPWR VGND sg13cmos5l_antennanp
XFILLER_108_182 VPWR VGND sg13cmos5l_decap_8
X_0590_ _0590_/Q Tile_X0Y8_FrameData[17] VGND VPWR Tile_X0Y9_FrameStrobe[5] latch
XFILLER_520_127 VPWR VGND sg13cmos5l_decap_8
XFILLER_373_35 VPWR VGND sg13cmos5l_decap_4
XFILLER_156_70 VPWR VGND sg13cmos5l_decap_8
XFILLER_520_138 VPWR VGND sg13cmos5l_fill_2
XFILLER_312_252 VPWR VGND sg13cmos5l_decap_8
XFILLER_69_217 VPWR VGND sg13cmos5l_decap_8
XFILLER_269_145 VPWR VGND sg13cmos5l_decap_8
XFILLER_312_263 VPWR VGND sg13cmos5l_fill_2
X_2260_ _2260_/Q Tile_X0Y5_FrameData[17] VGND VPWR Tile_X0Y9_FrameStrobe[2] latch
XFILLER_123_196 VPWR VGND sg13cmos5l_decap_4
XFILLER_523_49 VPWR VGND sg13cmos5l_decap_8
XFILLER_306_95 VPWR VGND sg13cmos5l_decap_8
XFILLER_284_126 VPWR VGND sg13cmos5l_decap_8
X_1211_ _1211_/Q Tile_X0Y1_FrameData[30] VGND VPWR Tile_X0Y9_FrameStrobe[1] latch
XFILLER_674_197 VPWR VGND sg13cmos5l_decap_4
XFILLER_473_237 VPWR VGND sg13cmos5l_decap_8
XFILLER_242_28 VPWR VGND sg13cmos5l_decap_8
X_2191_ _2191_/Q Tile_X0Y5_FrameData[22] VGND VPWR Tile_X0Y9_FrameStrobe[0] latch
XANTENNA__3631__X Tile_X0Y9_S4BEG[9] VPWR VGND sg13cmos5l_antennanp
XFILLER_77_272 VPWR VGND sg13cmos5l_fill_1
XFILLER_1_42 VPWR VGND sg13cmos5l_decap_8
X_1142_ _1142_/Q Tile_X0Y0_FrameData[21] VGND VPWR Tile_X0Y9_FrameStrobe[6] latch
XFILLER_615_242 VPWR VGND sg13cmos5l_decap_8
XFILLER_630_201 VPWR VGND sg13cmos5l_decap_4
XFILLER_426_175 VPWR VGND sg13cmos5l_decap_8
XFILLER_322_72 VPWR VGND sg13cmos5l_fill_2
XFILLER_292_192 VPWR VGND sg13cmos5l_decap_8
X_1073_ _1073_/Q Tile_X0Y0_FrameData[26] VGND VPWR Tile_X0Y9_FrameStrobe[4] latch
XFILLER_630_234 VPWR VGND sg13cmos5l_fill_2
XFILLER_441_145 VPWR VGND sg13cmos5l_decap_8
XFILLER_398_21 VPWR VGND sg13cmos5l_decap_8
X_4901_ _4901_/X Tile_X0Y9_N2MID[0] Tile_X0Y9_N2END[0] _4932_/X _4816_/X _0695_/Q
+ _0694_/Q VPWR VGND sg13cmos5l_mux4_1
XFILLER_240_218 VPWR VGND sg13cmos5l_fill_2
XFILLER_339_105 VPWR VGND sg13cmos5l_decap_8
XFILLER_398_87 VPWR VGND sg13cmos5l_decap_8
X_4832_ _4832_/X Tile_X0Y9_W1END[0] Tile_X0Y9_W2MID[3] Tile_X0Y9_W2END[3] _4906_/X
+ _0875_/Q _0874_/Q VPWR VGND sg13cmos5l_mux4_1
XFILLER_595_160 VPWR VGND sg13cmos5l_fill_1
XFILLER_528_216 VPWR VGND sg13cmos5l_decap_8
XANTENNA_190 Tile_X0Y9_FrameStrobe[9] VPWR VGND sg13cmos5l_antennanp
XFILLER_548_35 VPWR VGND sg13cmos5l_decap_8
XFILLER_394_233 VPWR VGND sg13cmos5l_decap_8
XFILLER_695_63 VPWR VGND sg13cmos5l_decap_8
XFILLER_267_14 VPWR VGND sg13cmos5l_decap_8
X_1975_ _1975_/Q Tile_X0Y4_FrameData[14] VGND VPWR Tile_X0Y9_FrameStrobe[1] latch
X_4763_ _4763_/X Tile_X0Y9_N4END[7] _0074_/X _4808_/X _4812_/X _0521_/Q _0520_/Q VPWR
+ VGND sg13cmos5l_mux4_1
XANTENNA__3078__X Tile_X0Y4_E2BEGb[4] VPWR VGND sg13cmos5l_antennanp
XFILLER_354_119 VPWR VGND sg13cmos5l_decap_8
X_0926_ _0926_/Q Tile_X0Y9_FrameData[1] VGND VPWR Tile_X0Y9_FrameStrobe[7] latch
X_3714_ AXI_M_SOC_WDATA24 Tile_X0Y6_WW4END[0] Tile_X0Y6_WW4END[8] Tile_X0Y6_W6END[8]
+ _4576_/X _2511_/Q _2510_/Q VPWR VGND sg13cmos5l_mux4_1
X_4694_ _4694_/X _4665_/X Tile_X0Y9_N4END[10] _4664_/X _0054_/X _0195_/Q _0194_/Q
+ VPWR VGND sg13cmos5l_mux4_1
XFILLER_146_255 VPWR VGND sg13cmos5l_fill_2
XFILLER_551_230 VPWR VGND sg13cmos5l_fill_2
XFILLER_417_28 VPWR VGND sg13cmos5l_decap_8
XFILLER_362_141 VPWR VGND sg13cmos5l_fill_2
X_0857_ _0857_/Q Tile_X0Y9_FrameData[6] VGND VPWR Tile_X0Y9_FrameStrobe[5] latch
X_3645_ AXI_M_SOC_AWADDR6 Tile_X0Y5_WW4END[6] Tile_X0Y5_WW4END[14] Tile_X0Y5_W6END[6]
+ _4457_/X _2259_/Q _2258_/Q VPWR VGND sg13cmos5l_mux4_1
XFILLER_106_119 VPWR VGND sg13cmos5l_fill_1
XFILLER_564_56 VPWR VGND sg13cmos5l_decap_8
XFILLER_511_105 VPWR VGND sg13cmos5l_decap_8
XFILLER_347_91 VPWR VGND sg13cmos5l_decap_8
XFILLER_697_267 VPWR VGND sg13cmos5l_decap_4
X_3576_ Tile_X0Y9_FrameData_O[6] Tile_X0Y9_FrameData[6] VPWR VGND sg13cmos5l_buf_1
XFILLER_657_109 VPWR VGND sg13cmos5l_decap_8
X_0788_ _0788_/Q Tile_X0Y9_FrameData[11] VGND VPWR Tile_X0Y9_FrameStrobe[3] latch
XFILLER_700_227 VPWR VGND sg13cmos5l_decap_8
XFILLER_283_35 VPWR VGND sg13cmos5l_decap_8
XFILLER_449_201 VPWR VGND sg13cmos5l_decap_8
X_2527_ _2527_/Q Tile_X0Y6_FrameData[8] VGND VPWR Tile_X0Y9_FrameStrobe[2] latch
XFILLER_114_163 VPWR VGND sg13cmos5l_decap_8
X_2458_ _2458_/Q Tile_X0Y6_FrameData[13] VGND VPWR Tile_X0Y9_FrameStrobe[0] latch
XFILLER_433_49 VPWR VGND sg13cmos5l_decap_8
XFILLER_580_77 VPWR VGND sg13cmos5l_decap_8
XFILLER_29_49 VPWR VGND sg13cmos5l_fill_1
XFILLER_152_28 VPWR VGND sg13cmos5l_decap_8
X_1409_ _1409_/Q Tile_X0Y1_FrameData[24] VGND VPWR Tile_X0Y9_FrameStrobe[7] latch
XFILLER_680_123 VPWR VGND sg13cmos5l_fill_1
XFILLER_665_197 VPWR VGND sg13cmos5l_decap_4
X_2389_ _2389_/Q Tile_X0Y5_FrameData[16] VGND VPWR Tile_X0Y9_FrameStrobe[6] latch
XANTENNA__3541__X Tile_X0Y9_E2BEGb[7] VPWR VGND sg13cmos5l_antennanp
XFILLER_68_272 VPWR VGND sg13cmos5l_fill_1
XFILLER_680_145 VPWR VGND sg13cmos5l_decap_8
XFILLER_606_231 VPWR VGND sg13cmos5l_decap_8
X_4128_ _4128_/X Tile_X0Y1_W2MID[7] Tile_X0Y1_W2END[7] Tile_X0Y1_W6END[8] _3989_/X
+ _1381_/Q _1380_/Q VPWR VGND sg13cmos5l_mux4_1
XFILLER_417_153 VPWR VGND sg13cmos5l_fill_1
XFILLER_232_50 VPWR VGND sg13cmos5l_decap_8
XFILLER_432_112 VPWR VGND sg13cmos5l_decap_8
XFILLER_589_42 VPWR VGND sg13cmos5l_decap_8
XFILLER_578_105 VPWR VGND sg13cmos5l_decap_8
X_4059_ _4059_/X Tile_X0Y2_WW4END[12] AXI_M_SOC_AWREADY _4113_/X _4102_/X _1555_/Q
+ _1554_/Q VPWR VGND sg13cmos5l_mux4_1
XFILLER_621_223 VPWR VGND sg13cmos5l_decap_8
XFILLER_45_37 VPWR VGND sg13cmos5l_decap_8
XFILLER_43_128 VPWR VGND sg13cmos5l_decap_8
XFILLER_621_267 VPWR VGND sg13cmos5l_decap_4
XFILLER_101_21 VPWR VGND sg13cmos5l_decap_8
XFILLER_432_189 VPWR VGND sg13cmos5l_decap_8
XFILLER_385_211 VPWR VGND sg13cmos5l_decap_8
XFILLER_243_7 VPWR VGND sg13cmos5l_decap_8
XFILLER_458_35 VPWR VGND sg13cmos5l_decap_8
XFILLER_101_98 VPWR VGND sg13cmos5l_decap_8
XFILLER_410_7 VPWR VGND sg13cmos5l_decap_8
XFILLER_137_211 VPWR VGND sg13cmos5l_decap_8
XFILLER_527_271 VPWR VGND sg13cmos5l_fill_2
XFILLER_508_7 VPWR VGND sg13cmos5l_decap_8
XFILLER_608_49 VPWR VGND sg13cmos5l_decap_8
XFILLER_338_182 VPWR VGND sg13cmos5l_decap_4
XFILLER_499_112 VPWR VGND sg13cmos5l_decap_8
XFILLER_688_234 VPWR VGND sg13cmos5l_decap_8
XANTENNA__3716__X AXI_M_SOC_WDATA26 VPWR VGND sg13cmos5l_antennanp
XFILLER_542_263 VPWR VGND sg13cmos5l_decap_8
XFILLER_474_56 VPWR VGND sg13cmos5l_decap_8
XFILLER_502_105 VPWR VGND sg13cmos5l_decap_8
XFILLER_193_35 VPWR VGND sg13cmos5l_decap_8
XFILLER_353_196 VPWR VGND sg13cmos5l_decap_8
XFILLER_499_189 VPWR VGND sg13cmos5l_decap_8
XFILLER_105_141 VPWR VGND sg13cmos5l_decap_4
XFILLER_656_120 VPWR VGND sg13cmos5l_decap_8
XFILLER_126_84 VPWR VGND sg13cmos5l_decap_8
XFILLER_343_49 VPWR VGND sg13cmos5l_decap_8
XFILLER_120_133 VPWR VGND sg13cmos5l_decap_8
XFILLER_704_70 VPWR VGND sg13cmos5l_decap_8
XFILLER_656_175 VPWR VGND sg13cmos5l_fill_1
XFILLER_455_226 VPWR VGND sg13cmos5l_decap_8
XFILLER_490_77 VPWR VGND sg13cmos5l_decap_8
XFILLER_656_197 VPWR VGND sg13cmos5l_decap_4
XFILLER_640_14 VPWR VGND sg13cmos5l_decap_8
XFILLER_86_77 VPWR VGND sg13cmos5l_decap_8
XANTENNA__3451__X Tile_X0Y1_FrameData_O[9] VPWR VGND sg13cmos5l_antennanp
XFILLER_59_272 VPWR VGND sg13cmos5l_fill_1
XFILLER_207_215 VPWR VGND sg13cmos5l_decap_8
XFILLER_408_175 VPWR VGND sg13cmos5l_decap_8
XFILLER_19_93 VPWR VGND sg13cmos5l_fill_1
XFILLER_74_242 VPWR VGND sg13cmos5l_decap_8
XFILLER_569_105 VPWR VGND sg13cmos5l_decap_8
XFILLER_499_42 VPWR VGND sg13cmos5l_decap_8
XFILLER_423_112 VPWR VGND sg13cmos5l_decap_8
XFILLER_367_0 VPWR VGND sg13cmos5l_decap_4
XFILLER_19_169 VPWR VGND sg13cmos5l_decap_8
XFILLER_612_223 VPWR VGND sg13cmos5l_decap_8
XFILLER_534_0 VPWR VGND sg13cmos5l_decap_8
XFILLER_649_56 VPWR VGND sg13cmos5l_decap_8
XFILLER_577_171 VPWR VGND sg13cmos5l_decap_8
XFILLER_368_57 VPWR VGND sg13cmos5l_decap_8
XFILLER_89_7 VPWR VGND sg13cmos5l_decap_8
XFILLER_701_0 VPWR VGND sg13cmos5l_decap_8
XFILLER_525_219 VPWR VGND sg13cmos5l_decap_4
X_1760_ _1760_/Q Tile_X0Y3_FrameData[9] VGND VPWR Tile_X0Y9_FrameStrobe[2] latch
XFILLER_518_271 VPWR VGND sg13cmos5l_fill_2
XFILLER_518_49 VPWR VGND sg13cmos5l_decap_8
X_0711_ _0711_/Q Tile_X0Y9_FrameData[24] VGND VPWR Tile_X0Y9_FrameStrobe[1] latch
XFILLER_665_77 VPWR VGND sg13cmos5l_decap_8
XFILLER_237_28 VPWR VGND sg13cmos5l_decap_8
X_1691_ _1691_/Q Tile_X0Y3_FrameData[14] VGND VPWR Tile_X0Y9_FrameStrobe[0] latch
XFILLER_533_241 VPWR VGND sg13cmos5l_decap_8
XANTENNA__3626__X Tile_X0Y9_S4BEG[4] VPWR VGND sg13cmos5l_antennanp
XFILLER_167_91 VPWR VGND sg13cmos5l_decap_8
XFILLER_143_225 VPWR VGND sg13cmos5l_decap_4
X_3430_ Tile_X0Y4_FrameData_O[21] Tile_X0Y4_FrameData[21] VPWR VGND sg13cmos5l_buf_1
XFILLER_143_236 VPWR VGND sg13cmos5l_decap_8
X_0642_ _0642_/Q Tile_X0Y8_FrameData[29] VGND VPWR Tile_X0Y9_FrameStrobe[7] latch
XFILLER_679_267 VPWR VGND sg13cmos5l_decap_4
XFILLER_681_21 VPWR VGND sg13cmos5l_decap_8
XFILLER_317_61 VPWR VGND sg13cmos5l_fill_1
XFILLER_694_226 VPWR VGND sg13cmos5l_decap_8
X_3361_ Tile_X0Y2_EE4BEG[0] _4056_/X VPWR VGND sg13cmos5l_buf_1
X_0573_ _0573_/Q Tile_X0Y8_FrameData[2] VGND VPWR Tile_X0Y9_FrameStrobe[4] latch
XFILLER_681_65 VPWR VGND sg13cmos5l_fill_2
XFILLER_297_240 VPWR VGND sg13cmos5l_fill_1
X_2312_ _2312_/Q Tile_X0Y5_FrameData[29] VGND VPWR Tile_X0Y9_FrameStrobe[4] latch
XFILLER_111_111 VPWR VGND sg13cmos5l_decap_8
X_3292_ Tile_X0Y0_E2BEGb[0] _3812_/X VPWR VGND sg13cmos5l_buf_1
XFILLER_253_49 VPWR VGND sg13cmos5l_decap_8
XFILLER_183_90 VPWR VGND sg13cmos5l_decap_8
XFILLER_614_70 VPWR VGND sg13cmos5l_decap_8
XFILLER_501_182 VPWR VGND sg13cmos5l_decap_8
XFILLER_647_175 VPWR VGND sg13cmos5l_decap_8
XFILLER_446_226 VPWR VGND sg13cmos5l_decap_8
XFILLER_257_137 VPWR VGND sg13cmos5l_decap_8
X_2243_ _2243_/Q Tile_X0Y5_FrameData[2] VGND VPWR Tile_X0Y9_FrameStrobe[1] latch
XFILLER_550_14 VPWR VGND sg13cmos5l_decap_8
XANTENNA__3361__X Tile_X0Y2_EE4BEG[0] VPWR VGND sg13cmos5l_antennanp
XFILLER_662_134 VPWR VGND sg13cmos5l_decap_8
XFILLER_111_188 VPWR VGND sg13cmos5l_decap_8
XFILLER_333_71 VPWR VGND sg13cmos5l_decap_8
X_2174_ _2174_/Q Tile_X0Y4_FrameData[7] VGND VPWR Tile_X0Y9_FrameStrobe[7] latch
XFILLER_461_218 VPWR VGND sg13cmos5l_fill_2
XFILLER_65_231 VPWR VGND sg13cmos5l_decap_8
XFILLER_603_201 VPWR VGND sg13cmos5l_decap_8
X_1125_ _1125_/Q Tile_X0Y0_FrameData[6] VGND VPWR Tile_X0Y9_FrameStrobe[5] latch
XFILLER_700_28 VPWR VGND sg13cmos5l_decap_8
XFILLER_280_140 VPWR VGND sg13cmos5l_decap_8
XFILLER_202_42 VPWR VGND sg13cmos5l_decap_8
XFILLER_80_223 VPWR VGND sg13cmos5l_decap_4
XFILLER_630_91 VPWR VGND sg13cmos5l_decap_8
XFILLER_80_234 VPWR VGND sg13cmos5l_decap_4
XFILLER_213_218 VPWR VGND sg13cmos5l_decap_8
X_1056_ _1056_/Q Tile_X0Y0_FrameData[11] VGND VPWR Tile_X0Y9_FrameStrobe[3] latch
XFILLER_18_191 VPWR VGND sg13cmos5l_decap_8
XFILLER_178_100 VPWR VGND sg13cmos5l_decap_8
XFILLER_559_56 VPWR VGND sg13cmos5l_decap_8
XFILLER_575_119 VPWR VGND sg13cmos5l_decap_8
XFILLER_717_102 VPWR VGND sg13cmos5l_decap_8
XFILLER_568_182 VPWR VGND sg13cmos5l_decap_8
XFILLER_278_35 VPWR VGND sg13cmos5l_decap_8
XFILLER_33_183 VPWR VGND sg13cmos5l_fill_1
XFILLER_178_155 VPWR VGND sg13cmos5l_decap_8
XFILLER_367_244 VPWR VGND sg13cmos5l_decap_8
X_4815_ _4815_/X _4783_/X Tile_X0Y9_N4END[7] _4782_/X _0074_/X _0441_/Q _0440_/Q VPWR
+ VGND sg13cmos5l_mux4_1
XFILLER_583_130 VPWR VGND sg13cmos5l_decap_8
XFILLER_583_141 VPWR VGND sg13cmos5l_fill_1
XFILLER_382_203 VPWR VGND sg13cmos5l_decap_8
XFILLER_193_114 VPWR VGND sg13cmos5l_decap_4
XFILLER_193_125 VPWR VGND sg13cmos5l_decap_8
X_4746_ _4746_/X Tile_X0Y8_WW4END[13] AXI_M_SOC_RDATA10 _4813_/X _4788_/X _0555_/Q
+ _0554_/Q VPWR VGND sg13cmos5l_mux4_1
X_1958_ _1958_/Q Tile_X0Y4_FrameData[31] VGND VPWR Tile_X0Y9_FrameStrobe[1] latch
XFILLER_428_49 VPWR VGND sg13cmos5l_decap_8
XFILLER_31_28 VPWR VGND sg13cmos5l_decap_8
XFILLER_147_28 VPWR VGND sg13cmos5l_decap_8
XFILLER_575_77 VPWR VGND sg13cmos5l_decap_8
X_0909_ _0909_/Q Tile_X0Y9_FrameData[18] VGND VPWR Tile_X0Y9_FrameStrobe[7] latch
X_1889_ _1889_/Q Tile_X0Y3_FrameData[8] VGND VPWR Tile_X0Y9_FrameStrobe[6] latch
X_4677_ _4677_/X _4226_/X _4230_/X _4234_/X _4210_/X _1865_/Q _1864_/Q VPWR VGND sg13cmos5l_mux4_1
XANTENNA__3536__X Tile_X0Y9_E2BEGb[2] VPWR VGND sg13cmos5l_antennanp
XFILLER_294_56 VPWR VGND sg13cmos5l_decap_8
XFILLER_335_174 VPWR VGND sg13cmos5l_decap_8
X_3628_ Tile_X0Y9_S4BEG[6] _3628_/A VPWR VGND sg13cmos5l_buf_1
XFILLER_134_247 VPWR VGND sg13cmos5l_decap_8
XFILLER_227_50 VPWR VGND sg13cmos5l_decap_8
XFILLER_591_21 VPWR VGND sg13cmos5l_decap_8
XFILLER_350_133 VPWR VGND sg13cmos5l_decap_8
XFILLER_496_126 VPWR VGND sg13cmos5l_decap_8
X_3559_ Tile_X0Y9_EE4BEG[5] _4869_/X VPWR VGND sg13cmos5l_buf_1
XFILLER_350_188 VPWR VGND sg13cmos5l_decap_8
XFILLER_0_238 VPWR VGND sg13cmos5l_decap_8
XFILLER_0_249 VPWR VGND sg13cmos5l_fill_1
XFILLER_653_112 VPWR VGND sg13cmos5l_decap_8
XFILLER_193_7 VPWR VGND sg13cmos5l_decap_8
XFILLER_460_14 VPWR VGND sg13cmos5l_decap_8
XANTENNA__3271__X Tile_X0Y0_EE4BEG[7] VPWR VGND sg13cmos5l_antennanp
XFILLER_102_177 VPWR VGND sg13cmos5l_decap_8
XFILLER_452_207 VPWR VGND sg13cmos5l_decap_8
XFILLER_653_167 VPWR VGND sg13cmos5l_decap_8
XFILLER_56_36 VPWR VGND sg13cmos5l_decap_8
XFILLER_56_220 VPWR VGND sg13cmos5l_decap_8
XFILLER_405_123 VPWR VGND sg13cmos5l_decap_8
XFILLER_610_28 VPWR VGND sg13cmos5l_decap_8
XFILLER_360_7 VPWR VGND sg13cmos5l_decap_8
XFILLER_16_106 VPWR VGND sg13cmos5l_decap_8
XFILLER_458_7 VPWR VGND sg13cmos5l_decap_8
XFILLER_112_42 VPWR VGND sg13cmos5l_decap_8
XFILLER_271_162 VPWR VGND sg13cmos5l_fill_2
XFILLER_71_256 VPWR VGND sg13cmos5l_decap_4
XFILLER_112_86 VPWR VGND sg13cmos5l_decap_8
XFILLER_420_126 VPWR VGND sg13cmos5l_decap_8
XFILLER_271_195 VPWR VGND sg13cmos5l_fill_2
XFILLER_72_35 VPWR VGND sg13cmos5l_decap_8
XFILLER_566_119 VPWR VGND sg13cmos5l_decap_8
XFILLER_625_7 VPWR VGND sg13cmos5l_decap_8
XFILLER_559_171 VPWR VGND sg13cmos5l_decap_8
XFILLER_169_133 VPWR VGND sg13cmos5l_decap_8
XFILLER_188_35 VPWR VGND sg13cmos5l_decap_8
XFILLER_318_119 VPWR VGND sg13cmos5l_decap_4
XFILLER_574_196 VPWR VGND sg13cmos5l_decap_8
XFILLER_326_130 VPWR VGND sg13cmos5l_fill_2
XFILLER_184_169 VPWR VGND sg13cmos5l_decap_8
XFILLER_485_77 VPWR VGND sg13cmos5l_decap_4
XANTENNA_90 Tile_X0Y1_FrameData[6] VPWR VGND sg13cmos5l_antennanp
XFILLER_635_14 VPWR VGND sg13cmos5l_decap_8
XFILLER_515_252 VPWR VGND sg13cmos5l_decap_8
XANTENNA__3446__X Tile_X0Y1_FrameData_O[4] VPWR VGND sg13cmos5l_antennanp
XFILLER_115_0 VPWR VGND sg13cmos5l_decap_8
XFILLER_341_100 VPWR VGND sg13cmos5l_decap_8
XFILLER_326_174 VPWR VGND sg13cmos5l_decap_8
XFILLER_192_191 VPWR VGND sg13cmos5l_decap_8
XFILLER_676_215 VPWR VGND sg13cmos5l_decap_8
XFILLER_530_233 VPWR VGND sg13cmos5l_decap_4
XFILLER_97_21 VPWR VGND sg13cmos5l_decap_8
XFILLER_140_217 VPWR VGND sg13cmos5l_decap_8
XFILLER_629_131 VPWR VGND sg13cmos5l_decap_8
XFILLER_715_91 VPWR VGND sg13cmos5l_decap_4
XFILLER_239_115 VPWR VGND sg13cmos5l_decap_8
XFILLER_97_87 VPWR VGND sg13cmos5l_decap_8
XFILLER_651_35 VPWR VGND sg13cmos5l_decap_8
XFILLER_434_70 VPWR VGND sg13cmos5l_decap_8
XFILLER_484_0 VPWR VGND sg13cmos5l_decap_8
XFILLER_644_112 VPWR VGND sg13cmos5l_decap_8
XFILLER_629_197 VPWR VGND sg13cmos5l_decap_8
XANTENNA__3181__X Tile_X0Y0_N4BEG[5] VPWR VGND sg13cmos5l_antennanp
XFILLER_153_71 VPWR VGND sg13cmos5l_decap_8
XFILLER_370_36 VPWR VGND sg13cmos5l_decap_8
XFILLER_47_231 VPWR VGND sg13cmos5l_decap_8
XFILLER_443_218 VPWR VGND sg13cmos5l_decap_8
XFILLER_370_69 VPWR VGND sg13cmos5l_fill_2
XFILLER_254_129 VPWR VGND sg13cmos5l_decap_8
XFILLER_651_0 VPWR VGND sg13cmos5l_decap_8
XFILLER_644_189 VPWR VGND sg13cmos5l_decap_8
XFILLER_520_28 VPWR VGND sg13cmos5l_decap_8
XFILLER_597_211 VPWR VGND sg13cmos5l_decap_8
XFILLER_597_222 VPWR VGND sg13cmos5l_fill_2
XFILLER_451_262 VPWR VGND sg13cmos5l_decap_8
XFILLER_62_245 VPWR VGND sg13cmos5l_decap_8
XFILLER_600_215 VPWR VGND sg13cmos5l_decap_8
XFILLER_262_195 VPWR VGND sg13cmos5l_decap_8
XFILLER_600_237 VPWR VGND sg13cmos5l_decap_8
X_2930_ Tile_X0Y8_E2BEGb[6] _4742_/X VPWR VGND sg13cmos5l_buf_1
XFILLER_349_222 VPWR VGND sg13cmos5l_decap_8
XFILLER_676_21 VPWR VGND sg13cmos5l_decap_8
X_2861_ Tile_X0Y6_E6BEG[10] _4538_/X VPWR VGND sg13cmos5l_buf_1
XFILLER_30_142 VPWR VGND sg13cmos5l_decap_8
XFILLER_175_114 VPWR VGND sg13cmos5l_decap_8
XFILLER_87_4 VPWR VGND sg13cmos5l_fill_1
XFILLER_395_22 VPWR VGND sg13cmos5l_decap_8
XFILLER_30_153 VPWR VGND sg13cmos5l_fill_2
XFILLER_175_125 VPWR VGND sg13cmos5l_fill_2
XFILLER_714_105 VPWR VGND sg13cmos5l_decap_8
X_4600_ _4600_/X Tile_X0Y7_W1END[0] Tile_X0Y7_WW4END[12] Tile_X0Y7_W6END[4] _4684_/X
+ _0355_/Q _0354_/Q VPWR VGND sg13cmos5l_mux4_1
X_1812_ _1812_/Q Tile_X0Y3_FrameData[21] VGND VPWR Tile_X0Y9_FrameStrobe[4] latch
XFILLER_565_185 VPWR VGND sg13cmos5l_decap_8
X_2792_ Tile_X0Y3_E6BEG[2] _4182_/X VPWR VGND sg13cmos5l_buf_1
XFILLER_565_196 VPWR VGND sg13cmos5l_fill_1
XFILLER_248_49 VPWR VGND sg13cmos5l_decap_8
XFILLER_609_70 VPWR VGND sg13cmos5l_decap_4
XFILLER_30_197 VPWR VGND sg13cmos5l_fill_1
XFILLER_175_169 VPWR VGND sg13cmos5l_decap_8
XFILLER_609_81 VPWR VGND sg13cmos5l_fill_1
XFILLER_506_230 VPWR VGND sg13cmos5l_fill_1
X_1743_ _1743_/Q Tile_X0Y3_FrameData[26] VGND VPWR Tile_X0Y9_FrameStrobe[2] latch
X_4531_ _4531_/X Tile_X0Y9_N4END[15] _0150_/X _4576_/X _4580_/X _2545_/Q _2544_/Q
+ VPWR VGND sg13cmos5l_mux4_1
XFILLER_545_14 VPWR VGND sg13cmos5l_decap_8
XANTENNA__3356__X Tile_X0Y2_FrameData_O[27] VPWR VGND sg13cmos5l_antennanp
XFILLER_7_63 VPWR VGND sg13cmos5l_decap_8
XFILLER_506_252 VPWR VGND sg13cmos5l_fill_2
XFILLER_692_42 VPWR VGND sg13cmos5l_fill_2
XFILLER_317_174 VPWR VGND sg13cmos5l_decap_8
XFILLER_183_180 VPWR VGND sg13cmos5l_decap_8
X_1674_ _1674_/Q Tile_X0Y2_FrameData[31] VGND VPWR Tile_X0Y9_FrameStrobe[0] latch
X_4462_ _4462_/X _4427_/X _0097_/X _4426_/X _0156_/X _2215_/Q _2214_/Q VPWR VGND sg13cmos5l_mux4_1
XFILLER_521_211 VPWR VGND sg13cmos5l_decap_8
XFILLER_116_247 VPWR VGND sg13cmos5l_decap_8
XFILLER_116_269 VPWR VGND sg13cmos5l_decap_4
XFILLER_89_109 VPWR VGND sg13cmos5l_decap_8
XFILLER_332_144 VPWR VGND sg13cmos5l_decap_8
XFILLER_131_206 VPWR VGND sg13cmos5l_decap_8
X_0625_ _0625_/Q Tile_X0Y8_FrameData[14] VGND VPWR Tile_X0Y9_FrameStrobe[6] latch
X_3413_ Tile_X0Y4_FrameData_O[4] Tile_X0Y4_FrameData[4] VPWR VGND sg13cmos5l_buf_1
X_4393_ _4393_/X Tile_X0Y5_WW4END[10] AXI_M_SOC_RLAST _4461_/X _4432_/X _2317_/Q _2316_/Q
+ VPWR VGND sg13cmos5l_mux4_1
XFILLER_625_91 VPWR VGND sg13cmos5l_decap_8
X_3344_ Tile_X0Y2_FrameData_O[15] Tile_X0Y2_FrameData[15] VPWR VGND sg13cmos5l_buf_1
X_0556_ _0556_/Q Tile_X0Y8_FrameData[19] VGND VPWR Tile_X0Y9_FrameStrobe[4] latch
XFILLER_561_35 VPWR VGND sg13cmos5l_decap_8
XFILLER_30_0 VPWR VGND sg13cmos5l_decap_8
XFILLER_285_210 VPWR VGND sg13cmos5l_decap_8
XFILLER_635_112 VPWR VGND sg13cmos5l_decap_8
XFILLER_280_14 VPWR VGND sg13cmos5l_decap_8
X_3275_ Tile_X0Y0_EE4BEG[11] _3831_/X VPWR VGND sg13cmos5l_buf_1
XANTENNA__3091__X Tile_X0Y7_E2BEG[5] VPWR VGND sg13cmos5l_antennanp
X_0487_ _0487_/Q Tile_X0Y8_FrameData[24] VGND VPWR Tile_X0Y9_FrameStrobe[2] latch
X_2226_ _2226_/Q Tile_X0Y5_FrameData[19] VGND VPWR Tile_X0Y9_FrameStrobe[1] latch
XFILLER_434_207 VPWR VGND sg13cmos5l_decap_4
XFILLER_38_220 VPWR VGND sg13cmos5l_fill_2
XFILLER_711_49 VPWR VGND sg13cmos5l_decap_8
XFILLER_635_189 VPWR VGND sg13cmos5l_decap_8
XFILLER_650_126 VPWR VGND sg13cmos5l_decap_8
XFILLER_238_181 VPWR VGND sg13cmos5l_decap_8
XFILLER_588_200 VPWR VGND sg13cmos5l_fill_1
XFILLER_430_28 VPWR VGND sg13cmos5l_decap_8
XFILLER_38_264 VPWR VGND sg13cmos5l_decap_8
XFILLER_213_63 VPWR VGND sg13cmos5l_decap_8
X_2157_ _2157_/Q Tile_X0Y4_FrameData[24] VGND VPWR Tile_X0Y9_FrameStrobe[7] latch
XFILLER_26_28 VPWR VGND sg13cmos5l_decap_8
XFILLER_360_91 VPWR VGND sg13cmos5l_decap_8
X_1108_ _1108_/Q Tile_X0Y0_FrameData[23] VGND VPWR Tile_X0Y9_FrameStrobe[5] latch
XFILLER_53_234 VPWR VGND sg13cmos5l_decap_4
XFILLER_53_245 VPWR VGND sg13cmos5l_decap_8
X_2088_ _2088_/Q Tile_X0Y4_FrameData[29] VGND VPWR Tile_X0Y9_FrameStrobe[5] latch
XFILLER_253_184 VPWR VGND sg13cmos5l_fill_1
XFILLER_53_256 VPWR VGND sg13cmos5l_fill_2
XFILLER_402_126 VPWR VGND sg13cmos5l_decap_8
XFILLER_399_188 VPWR VGND sg13cmos5l_decap_4
XFILLER_289_56 VPWR VGND sg13cmos5l_decap_8
XFILLER_13_109 VPWR VGND sg13cmos5l_decap_8
XFILLER_198_239 VPWR VGND sg13cmos5l_fill_2
X_1039_ _1039_/Q Tile_X0Y0_FrameData[28] VGND VPWR Tile_X0Y9_FrameStrobe[3] latch
XFILLER_586_21 VPWR VGND sg13cmos5l_decap_8
XFILLER_21_142 VPWR VGND sg13cmos5l_fill_1
XFILLER_355_203 VPWR VGND sg13cmos5l_decap_8
XFILLER_166_114 VPWR VGND sg13cmos5l_decap_8
XFILLER_556_163 VPWR VGND sg13cmos5l_decap_8
XFILLER_42_49 VPWR VGND sg13cmos5l_fill_1
XFILLER_586_98 VPWR VGND sg13cmos5l_decap_8
XFILLER_21_197 VPWR VGND sg13cmos5l_decap_8
XFILLER_571_133 VPWR VGND sg13cmos5l_decap_8
X_4729_ _4729_/X Tile_X0Y8_W2MID[6] AXI_M_SOC_RDATA9 _4787_/X _4786_/X _0589_/Q _0588_/Q
+ VPWR VGND sg13cmos5l_mux4_1
XFILLER_455_14 VPWR VGND sg13cmos5l_decap_8
XFILLER_370_206 VPWR VGND sg13cmos5l_decap_8
XFILLER_107_203 VPWR VGND sg13cmos5l_decap_8
XANTENNA__3266__X Tile_X0Y0_EE4BEG[2] VPWR VGND sg13cmos5l_antennanp
XFILLER_181_128 VPWR VGND sg13cmos5l_decap_8
XFILLER_370_228 VPWR VGND sg13cmos5l_decap_8
XFILLER_206_7 VPWR VGND sg13cmos5l_decap_8
XFILLER_658_204 VPWR VGND sg13cmos5l_decap_8
XFILLER_107_258 VPWR VGND sg13cmos5l_decap_8
XFILLER_658_215 VPWR VGND sg13cmos5l_fill_2
XFILLER_107_269 VPWR VGND sg13cmos5l_decap_4
XFILLER_469_137 VPWR VGND sg13cmos5l_decap_4
XFILLER_605_28 VPWR VGND sg13cmos5l_decap_8
XFILLER_122_228 VPWR VGND sg13cmos5l_decap_8
XFILLER_471_35 VPWR VGND sg13cmos5l_decap_8
XFILLER_324_29 VPWR VGND sg13cmos5l_decap_8
XFILLER_67_35 VPWR VGND sg13cmos5l_decap_8
XFILLER_190_14 VPWR VGND sg13cmos5l_decap_8
XFILLER_575_7 VPWR VGND sg13cmos5l_decap_8
XFILLER_626_145 VPWR VGND sg13cmos5l_fill_2
XFILLER_492_140 VPWR VGND sg13cmos5l_decap_8
XFILLER_236_118 VPWR VGND sg13cmos5l_decap_8
XFILLER_621_49 VPWR VGND sg13cmos5l_decap_8
XFILLER_291_224 VPWR VGND sg13cmos5l_decap_8
XFILLER_404_84 VPWR VGND sg13cmos5l_decap_4
XFILLER_641_126 VPWR VGND sg13cmos5l_decap_8
XFILLER_340_28 VPWR VGND sg13cmos5l_decap_8
XFILLER_579_211 VPWR VGND sg13cmos5l_decap_8
XFILLER_270_91 VPWR VGND sg13cmos5l_fill_1
XFILLER_189_206 VPWR VGND sg13cmos5l_fill_1
XFILLER_189_228 VPWR VGND sg13cmos5l_decap_4
XFILLER_199_56 VPWR VGND sg13cmos5l_decap_8
XFILLER_496_21 VPWR VGND sg13cmos5l_decap_8
XFILLER_197_272 VPWR VGND sg13cmos5l_fill_1
XFILLER_232_0 VPWR VGND sg13cmos5l_decap_4
XFILLER_157_125 VPWR VGND sg13cmos5l_decap_8
XFILLER_496_98 VPWR VGND sg13cmos5l_decap_8
XFILLER_346_236 VPWR VGND sg13cmos5l_fill_2
XFILLER_646_35 VPWR VGND sg13cmos5l_decap_8
XFILLER_562_133 VPWR VGND sg13cmos5l_decap_8
XFILLER_429_70 VPWR VGND sg13cmos5l_decap_8
XFILLER_172_106 VPWR VGND sg13cmos5l_decap_8
XFILLER_365_14 VPWR VGND sg13cmos5l_decap_8
XFILLER_172_117 VPWR VGND sg13cmos5l_fill_2
XANTENNA__3176__X Tile_X0Y0_N4BEG[0] VPWR VGND sg13cmos5l_antennanp
XFILLER_361_217 VPWR VGND sg13cmos5l_decap_8
XFILLER_32_93 VPWR VGND sg13cmos5l_decap_8
XFILLER_711_119 VPWR VGND sg13cmos5l_decap_8
XFILLER_503_244 VPWR VGND sg13cmos5l_fill_1
XFILLER_699_0 VPWR VGND sg13cmos5l_decap_4
XFILLER_515_28 VPWR VGND sg13cmos5l_decap_8
XFILLER_503_266 VPWR VGND sg13cmos5l_decap_8
XFILLER_662_56 VPWR VGND sg13cmos5l_decap_8
XFILLER_314_188 VPWR VGND sg13cmos5l_decap_8
X_0410_ _0410_/Q Tile_X0Y7_FrameData[5] VGND VPWR Tile_X0Y9_FrameStrobe[7] latch
X_1390_ _1390_/Q Tile_X0Y1_FrameData[11] VGND VPWR Tile_X0Y9_FrameStrobe[6] latch
X_0341_ _0341_/Q Tile_X0Y7_FrameData[10] VGND VPWR Tile_X0Y9_FrameStrobe[5] latch
XFILLER_79_175 VPWR VGND sg13cmos5l_decap_8
XFILLER_267_265 VPWR VGND sg13cmos5l_decap_8
XFILLER_94_123 VPWR VGND sg13cmos5l_decap_8
X_3060_ Tile_X0Y5_FrameData_O[19] Tile_X0Y5_FrameData[19] VPWR VGND sg13cmos5l_buf_1
XFILLER_416_218 VPWR VGND sg13cmos5l_decap_8
XFILLER_227_129 VPWR VGND sg13cmos5l_fill_1
X_0272_ _0272_/Q Tile_X0Y7_FrameData[15] VGND VPWR Tile_X0Y9_FrameStrobe[3] latch
XFILLER_531_49 VPWR VGND sg13cmos5l_decap_8
XFILLER_617_189 VPWR VGND sg13cmos5l_fill_2
XFILLER_282_224 VPWR VGND sg13cmos5l_decap_8
XFILLER_314_95 VPWR VGND sg13cmos5l_decap_8
X_2011_ _2011_/Q Tile_X0Y4_FrameData[10] VGND VPWR Tile_X0Y9_FrameStrobe[2] latch
XFILLER_632_126 VPWR VGND sg13cmos5l_decap_8
XFILLER_250_28 VPWR VGND sg13cmos5l_decap_8
XFILLER_35_201 VPWR VGND sg13cmos5l_decap_4
XFILLER_180_91 VPWR VGND sg13cmos5l_fill_2
XFILLER_424_251 VPWR VGND sg13cmos5l_decap_8
XFILLER_235_162 VPWR VGND sg13cmos5l_decap_8
X_3962_ _3962_/X Tile_X0Y1_WW4END[1] AXI_M_SOC_ARREADY _4009_/X _3991_/X _1285_/Q
+ _1284_/Q VPWR VGND sg13cmos5l_mux4_1
XFILLER_259_15 VPWR VGND sg13cmos5l_decap_8
XFILLER_585_258 VPWR VGND sg13cmos5l_fill_2
XFILLER_250_176 VPWR VGND sg13cmos5l_decap_8
X_2913_ Tile_X0Y8_E1BEG[1] _4725_/X VPWR VGND sg13cmos5l_buf_1
X_3893_ _3893_/X Tile_X0Y1_W2MID[5] Tile_X0Y1_W2END[5] Tile_X0Y1_W6END[5] _3993_/X
+ _1413_/Q _1412_/Q VPWR VGND sg13cmos5l_mux4_1
XFILLER_337_214 VPWR VGND sg13cmos5l_decap_4
XFILLER_148_147 VPWR VGND sg13cmos5l_decap_8
X_2844_ Tile_X0Y6_E2BEGb[1] _4505_/X VPWR VGND sg13cmos5l_buf_1
XFILLER_556_35 VPWR VGND sg13cmos5l_decap_8
XFILLER_78_0 VPWR VGND sg13cmos5l_decap_8
XFILLER_699_126 VPWR VGND sg13cmos5l_decap_8
XFILLER_275_14 VPWR VGND sg13cmos5l_decap_8
XANTENNA__3086__X Tile_X0Y7_E2BEG[0] VPWR VGND sg13cmos5l_antennanp
X_2775_ Tile_X0Y3_EE4BEG[1] _4165_/X VPWR VGND sg13cmos5l_buf_1
XFILLER_352_217 VPWR VGND sg13cmos5l_decap_8
XFILLER_553_177 VPWR VGND sg13cmos5l_decap_4
X_4514_ _4514_/X Tile_X0Y6_WW4END[13] AXI_M_SOC_RDATA26 _4581_/X _4556_/X _2579_/Q
+ _2578_/Q VPWR VGND sg13cmos5l_mux4_1
X_1726_ _1726_/Q Tile_X0Y3_FrameData[11] VGND VPWR Tile_X0Y9_FrameStrobe[1] latch
XFILLER_706_49 VPWR VGND sg13cmos5l_decap_8
XFILLER_171_161 VPWR VGND sg13cmos5l_fill_2
XFILLER_208_63 VPWR VGND sg13cmos5l_decap_8
X_1657_ _1657_/Q Tile_X0Y2_FrameData[24] VGND VPWR Tile_X0Y9_FrameStrobe[7] latch
X_4445_ _4445_/X Tile_X0Y9_W1END[2] Tile_X0Y9_WW4END[2] Tile_X0Y9_W6END[10] _4918_/X
+ _0897_/Q _0896_/Q VPWR VGND sg13cmos5l_mux4_1
XFILLER_425_28 VPWR VGND sg13cmos5l_decap_8
XFILLER_572_56 VPWR VGND sg13cmos5l_decap_8
XFILLER_355_91 VPWR VGND sg13cmos5l_decap_8
X_0608_ _0608_/Q Tile_X0Y8_FrameData[31] VGND VPWR Tile_X0Y9_FrameStrobe[6] latch
XFILLER_655_218 VPWR VGND sg13cmos5l_decap_4
X_1588_ _1588_/Q Tile_X0Y2_FrameData[29] VGND VPWR Tile_X0Y9_FrameStrobe[5] latch
X_4376_ _4376_/X Tile_X0Y5_W2MID[3] AXI_M_SOC_RVALID _4434_/X _4433_/X _2351_/Q _2350_/Q
+ VPWR VGND sg13cmos5l_mux4_1
XFILLER_655_229 VPWR VGND sg13cmos5l_fill_2
XFILLER_320_147 VPWR VGND sg13cmos5l_decap_8
XFILLER_291_57 VPWR VGND sg13cmos5l_decap_8
X_0539_ _0539_/Q Tile_X0Y8_FrameData[4] VGND VPWR Tile_X0Y9_FrameStrobe[3] latch
X_3327_ Tile_X0Y4_EE4BEG[15] _4287_/X VPWR VGND sg13cmos5l_buf_1
XFILLER_258_254 VPWR VGND sg13cmos5l_decap_8
XFILLER_608_145 VPWR VGND sg13cmos5l_decap_8
XFILLER_85_123 VPWR VGND sg13cmos5l_decap_8
XFILLER_273_202 VPWR VGND sg13cmos5l_fill_2
XFILLER_474_162 VPWR VGND sg13cmos5l_decap_8
XFILLER_218_129 VPWR VGND sg13cmos5l_decap_8
XFILLER_224_84 VPWR VGND sg13cmos5l_decap_8
X_3258_ Tile_X0Y0_FrameData_O[26] Tile_X0Y0_FrameData[26] VPWR VGND sg13cmos5l_buf_1
XFILLER_441_49 VPWR VGND sg13cmos5l_decap_8
XFILLER_623_126 VPWR VGND sg13cmos5l_fill_1
XFILLER_160_28 VPWR VGND sg13cmos5l_decap_8
X_2209_ _2209_/Q Tile_X0Y5_FrameData[4] VGND VPWR Tile_X0Y9_FrameStrobe[0] latch
X_3189_ Tile_X0Y0_N4BEG[13] _3189_/A VPWR VGND sg13cmos5l_buf_1
XFILLER_226_162 VPWR VGND sg13cmos5l_fill_1
XFILLER_226_184 VPWR VGND sg13cmos5l_decap_4
XFILLER_430_210 VPWR VGND sg13cmos5l_decap_8
XFILLER_597_42 VPWR VGND sg13cmos5l_decap_8
XFILLER_631_192 VPWR VGND sg13cmos5l_decap_8
XFILLER_597_53 VPWR VGND sg13cmos5l_fill_2
XFILLER_241_143 VPWR VGND sg13cmos5l_decap_8
XFILLER_576_236 VPWR VGND sg13cmos5l_decap_8
XFILLER_576_247 VPWR VGND sg13cmos5l_fill_1
XFILLER_597_97 VPWR VGND sg13cmos5l_decap_8
XFILLER_179_261 VPWR VGND sg13cmos5l_decap_8
XFILLER_330_8 VPWR VGND sg13cmos5l_decap_8
XFILLER_179_272 VPWR VGND sg13cmos5l_fill_1
XFILLER_139_147 VPWR VGND sg13cmos5l_decap_8
XFILLER_529_196 VPWR VGND sg13cmos5l_decap_8
XFILLER_466_35 VPWR VGND sg13cmos5l_decap_8
XFILLER_328_269 VPWR VGND sg13cmos5l_decap_4
XFILLER_185_14 VPWR VGND sg13cmos5l_decap_8
XFILLER_544_177 VPWR VGND sg13cmos5l_decap_8
XFILLER_343_228 VPWR VGND sg13cmos5l_fill_1
XFILLER_154_139 VPWR VGND sg13cmos5l_decap_8
XFILLER_616_49 VPWR VGND sg13cmos5l_decap_8
XFILLER_698_170 VPWR VGND sg13cmos5l_decap_8
XFILLER_497_210 VPWR VGND sg13cmos5l_decap_8
XANTENNA__0132__Y AXI_M_SOC_AWLEN7 VPWR VGND sg13cmos5l_antennanp
XFILLER_118_63 VPWR VGND sg13cmos5l_decap_4
XFILLER_692_7 VPWR VGND sg13cmos5l_decap_8
XFILLER_335_28 VPWR VGND sg13cmos5l_decap_8
XFILLER_500_203 VPWR VGND sg13cmos5l_decap_8
XFILLER_482_56 VPWR VGND sg13cmos5l_decap_8
XFILLER_265_91 VPWR VGND sg13cmos5l_decap_8
XFILLER_118_96 VPWR VGND sg13cmos5l_decap_8
XFILLER_482_67 VPWR VGND sg13cmos5l_fill_1
XFILLER_311_125 VPWR VGND sg13cmos5l_decap_8
XFILLER_701_185 VPWR VGND sg13cmos5l_fill_2
XFILLER_482_78 VPWR VGND sg13cmos5l_decap_8
XFILLER_457_118 VPWR VGND sg13cmos5l_decap_8
XFILLER_103_261 VPWR VGND sg13cmos5l_fill_1
XFILLER_209_107 VPWR VGND sg13cmos5l_decap_8
XFILLER_264_213 VPWR VGND sg13cmos5l_decap_8
XFILLER_134_84 VPWR VGND sg13cmos5l_decap_8
XFILLER_76_145 VPWR VGND sg13cmos5l_fill_1
XFILLER_351_49 VPWR VGND sg13cmos5l_decap_8
XFILLER_712_70 VPWR VGND sg13cmos5l_decap_8
XFILLER_465_184 VPWR VGND sg13cmos5l_fill_1
XFILLER_182_0 VPWR VGND sg13cmos5l_decap_4
XFILLER_76_167 VPWR VGND sg13cmos5l_decap_4
XFILLER_614_137 VPWR VGND sg13cmos5l_decap_8
XFILLER_17_223 VPWR VGND sg13cmos5l_decap_8
XFILLER_94_88 VPWR VGND sg13cmos5l_decap_8
XFILLER_27_60 VPWR VGND sg13cmos5l_fill_1
XFILLER_91_159 VPWR VGND sg13cmos5l_decap_8
XFILLER_421_210 VPWR VGND sg13cmos5l_fill_1
XFILLER_567_203 VPWR VGND sg13cmos5l_decap_8
XFILLER_447_0 VPWR VGND sg13cmos5l_decap_8
XFILLER_32_204 VPWR VGND sg13cmos5l_decap_8
XFILLER_232_154 VPWR VGND sg13cmos5l_decap_8
XFILLER_567_258 VPWR VGND sg13cmos5l_decap_4
XFILLER_378_158 VPWR VGND sg13cmos5l_decap_4
XFILLER_300_42 VPWR VGND sg13cmos5l_decap_8
XFILLER_709_230 VPWR VGND sg13cmos5l_decap_8
XFILLER_378_169 VPWR VGND sg13cmos5l_decap_8
XFILLER_393_117 VPWR VGND sg13cmos5l_decap_8
XFILLER_614_0 VPWR VGND sg13cmos5l_decap_8
XFILLER_657_56 VPWR VGND sg13cmos5l_decap_4
XFILLER_185_220 VPWR VGND sg13cmos5l_decap_4
XFILLER_582_239 VPWR VGND sg13cmos5l_decap_8
XANTENNA__2803__X Tile_X0Y3_E2BEGb[1] VPWR VGND sg13cmos5l_antennanp
XFILLER_185_231 VPWR VGND sg13cmos5l_decap_8
XFILLER_386_180 VPWR VGND sg13cmos5l_decap_8
XFILLER_185_242 VPWR VGND sg13cmos5l_fill_2
X_0890_ _0890_/Q Tile_X0Y9_FrameData[5] VGND VPWR Tile_X0Y9_FrameStrobe[6] latch
XFILLER_159_81 VPWR VGND sg13cmos5l_decap_8
XFILLER_376_46 VPWR VGND sg13cmos5l_decap_8
XFILLER_71_7 VPWR VGND sg13cmos5l_decap_8
XFILLER_145_117 VPWR VGND sg13cmos5l_decap_8
XFILLER_145_128 VPWR VGND sg13cmos5l_fill_1
XFILLER_590_272 VPWR VGND sg13cmos5l_fill_1
XFILLER_334_239 VPWR VGND sg13cmos5l_decap_8
X_2560_ _2560_/Q Tile_X0Y6_FrameData[7] VGND VPWR Tile_X0Y9_FrameStrobe[3] latch
XFILLER_299_110 VPWR VGND sg13cmos5l_fill_2
X_1511_ _1511_/Q Tile_X0Y2_FrameData[10] VGND VPWR Tile_X0Y9_FrameStrobe[2] latch
XFILLER_550_158 VPWR VGND sg13cmos5l_decap_8
XFILLER_299_143 VPWR VGND sg13cmos5l_decap_8
XFILLER_245_28 VPWR VGND sg13cmos5l_decap_8
X_2491_ _2491_/Q Tile_X0Y6_FrameData[12] VGND VPWR Tile_X0Y9_FrameStrobe[1] latch
XFILLER_99_226 VPWR VGND sg13cmos5l_decap_8
XFILLER_342_272 VPWR VGND sg13cmos5l_fill_1
XFILLER_302_103 VPWR VGND sg13cmos5l_decap_8
XANTENNA__3634__X Tile_X0Y9_S4BEG[12] VPWR VGND sg13cmos5l_antennanp
XFILLER_606_60 VPWR VGND sg13cmos5l_fill_1
XFILLER_4_171 VPWR VGND sg13cmos5l_fill_2
XFILLER_392_67 VPWR VGND sg13cmos5l_decap_8
X_1442_ _1442_/Q Tile_X0Y2_FrameData[15] VGND VPWR Tile_X0Y9_FrameStrobe[0] latch
X_4230_ _4230_/X _4195_/X _0089_/X _4194_/X Tile_X0Y0_S4END[12] _1713_/Q _1712_/Q
+ VPWR VGND sg13cmos5l_mux4_1
XFILLER_4_42 VPWR VGND sg13cmos5l_decap_8
XFILLER_302_147 VPWR VGND sg13cmos5l_fill_1
X_4161_ _4161_/X Tile_X0Y3_W2END[2] AXI_M_SOC_WREADY _4209_/X _4208_/X _1819_/Q _1818_/Q
+ VPWR VGND sg13cmos5l_mux4_1
X_1373_ _1373_/Q Tile_X0Y1_FrameData[28] VGND VPWR Tile_X0Y9_FrameStrobe[6] latch
XFILLER_67_112 VPWR VGND sg13cmos5l_decap_8
X_0324_ _0324_/Q Tile_X0Y7_FrameData[27] VGND VPWR Tile_X0Y9_FrameStrobe[5] latch
X_3112_ Tile_X0Y7_E6BEG[10] _4654_/X VPWR VGND sg13cmos5l_buf_1
X_4092_ _4092_/X Tile_X0Y1_W1END[2] Tile_X0Y1_W6END[10] _3999_/X _3978_/X _1385_/Q
+ _1384_/Q VPWR VGND sg13cmos5l_mux4_1
XFILLER_261_49 VPWR VGND sg13cmos5l_decap_4
XFILLER_191_90 VPWR VGND sg13cmos5l_decap_8
XFILLER_622_70 VPWR VGND sg13cmos5l_decap_8
XFILLER_605_126 VPWR VGND sg13cmos5l_decap_4
X_3043_ Tile_X0Y5_FrameData_O[2] Tile_X0Y5_FrameData[2] VPWR VGND sg13cmos5l_buf_1
X_0255_ _0255_/Q Tile_X0Y7_FrameData[0] VGND VPWR Tile_X0Y9_FrameStrobe[2] latch
XFILLER_67_189 VPWR VGND sg13cmos5l_decap_8
XFILLER_208_140 VPWR VGND sg13cmos5l_decap_8
XFILLER_605_159 VPWR VGND sg13cmos5l_decap_8
XFILLER_270_205 VPWR VGND sg13cmos5l_fill_1
XFILLER_620_107 VPWR VGND sg13cmos5l_decap_8
XFILLER_82_159 VPWR VGND sg13cmos5l_decap_8
XFILLER_698_63 VPWR VGND sg13cmos5l_decap_8
XFILLER_471_187 VPWR VGND sg13cmos5l_decap_8
XFILLER_341_93 VPWR VGND sg13cmos5l_decap_8
X_0186_ _0186_/Q Tile_X0Y7_FrameData[5] VGND VPWR Tile_X0Y9_FrameStrobe[0] latch
XFILLER_613_170 VPWR VGND sg13cmos5l_decap_8
XFILLER_369_114 VPWR VGND sg13cmos5l_decap_8
XFILLER_23_215 VPWR VGND sg13cmos5l_decap_8
XFILLER_23_237 VPWR VGND sg13cmos5l_decap_4
XFILLER_210_42 VPWR VGND sg13cmos5l_decap_8
XFILLER_23_248 VPWR VGND sg13cmos5l_decap_8
X_3945_ _3945_/X Tile_X0Y1_W2END[2] AXI_M_SOC_ARREADY _3993_/X _3992_/X _1319_/Q _1318_/Q
+ VPWR VGND sg13cmos5l_mux4_1
XFILLER_573_217 VPWR VGND sg13cmos5l_decap_8
XFILLER_384_117 VPWR VGND sg13cmos5l_decap_8
XFILLER_176_220 VPWR VGND sg13cmos5l_decap_8
XFILLER_567_56 VPWR VGND sg13cmos5l_decap_8
X_3876_ _3876_/X _3848_/X _0067_/X Tile_X0Y0_S1END[0] Tile_X0Y0_S4END[0] _0979_/Q
+ _0978_/Q VPWR VGND sg13cmos5l_mux4_1
XFILLER_286_35 VPWR VGND sg13cmos5l_decap_8
XFILLER_715_233 VPWR VGND sg13cmos5l_fill_1
XFILLER_176_264 VPWR VGND sg13cmos5l_fill_1
XFILLER_717_26 VPWR VGND sg13cmos5l_fill_1
XFILLER_526_155 VPWR VGND sg13cmos5l_fill_1
X_2827_ Tile_X0Y4_E2BEG[5] _4261_/X VPWR VGND sg13cmos5l_buf_1
XFILLER_392_172 VPWR VGND sg13cmos5l_decap_8
XFILLER_136_128 VPWR VGND sg13cmos5l_decap_8
XFILLER_191_234 VPWR VGND sg13cmos5l_decap_8
XFILLER_687_107 VPWR VGND sg13cmos5l_fill_1
X_2758_ Tile_X0Y3_FrameData_O[16] Tile_X0Y3_FrameData[16] VPWR VGND sg13cmos5l_buf_1
XFILLER_687_129 VPWR VGND sg13cmos5l_fill_2
XFILLER_436_49 VPWR VGND sg13cmos5l_decap_8
XFILLER_366_90 VPWR VGND sg13cmos5l_decap_8
XFILLER_155_28 VPWR VGND sg13cmos5l_decap_8
XFILLER_583_77 VPWR VGND sg13cmos5l_decap_8
X_1709_ _1709_/Q Tile_X0Y3_FrameData[28] VGND VPWR Tile_X0Y9_FrameStrobe[1] latch
XFILLER_2_119 VPWR VGND sg13cmos5l_decap_8
XANTENNA__3544__X Tile_X0Y9_E6BEG[2] VPWR VGND sg13cmos5l_antennanp
X_2689_ _2689_/Q Tile_X0Y6_FrameData[6] VGND VPWR Tile_X0Y9_FrameStrobe[7] latch
XFILLER_333_272 VPWR VGND sg13cmos5l_fill_1
X_4428_ _4428_/X _4367_/X _4483_/X _4482_/X _4366_/X _2191_/Q _2190_/Q VPWR VGND sg13cmos5l_mux4_1
XFILLER_439_118 VPWR VGND sg13cmos5l_decap_8
XFILLER_695_173 VPWR VGND sg13cmos5l_decap_8
XFILLER_439_129 VPWR VGND sg13cmos5l_fill_1
XFILLER_494_235 VPWR VGND sg13cmos5l_decap_8
XFILLER_235_72 VPWR VGND sg13cmos5l_fill_1
X_4359_ _4359_/X Tile_X0Y6_W2MID[4] Tile_X0Y6_W2END[4] Tile_X0Y6_W6END[4] _4559_/X
+ _2681_/Q _2680_/Q VPWR VGND sg13cmos5l_mux4_1
XFILLER_235_94 VPWR VGND sg13cmos5l_decap_8
XFILLER_636_240 VPWR VGND sg13cmos5l_fill_1
XFILLER_48_48 VPWR VGND sg13cmos5l_decap_8
XFILLER_58_123 VPWR VGND sg13cmos5l_decap_8
XFILLER_447_151 VPWR VGND sg13cmos5l_decap_8
XFILLER_100_253 VPWR VGND sg13cmos5l_decap_8
XFILLER_104_21 VPWR VGND sg13cmos5l_decap_8
XFILLER_651_210 VPWR VGND sg13cmos5l_decap_8
XFILLER_462_121 VPWR VGND sg13cmos5l_decap_8
XFILLER_378_8 VPWR VGND sg13cmos5l_decap_8
XFILLER_246_257 VPWR VGND sg13cmos5l_decap_8
XFILLER_273_7 VPWR VGND sg13cmos5l_decap_8
XFILLER_64_14 VPWR VGND sg13cmos5l_decap_8
XFILLER_73_137 VPWR VGND sg13cmos5l_fill_2
XFILLER_403_221 VPWR VGND sg13cmos5l_decap_8
XFILLER_403_232 VPWR VGND sg13cmos5l_fill_1
XFILLER_604_192 VPWR VGND sg13cmos5l_fill_2
XFILLER_440_7 VPWR VGND sg13cmos5l_decap_8
XFILLER_14_226 VPWR VGND sg13cmos5l_decap_8
XFILLER_214_165 VPWR VGND sg13cmos5l_decap_8
XFILLER_538_7 VPWR VGND sg13cmos5l_decap_8
XFILLER_403_254 VPWR VGND sg13cmos5l_decap_8
XFILLER_549_247 VPWR VGND sg13cmos5l_decap_8
XFILLER_120_42 VPWR VGND sg13cmos5l_decap_8
XFILLER_14_259 VPWR VGND sg13cmos5l_fill_1
XFILLER_375_106 VPWR VGND sg13cmos5l_decap_8
XANTENNA__3719__X AXI_M_SOC_WDATA29 VPWR VGND sg13cmos5l_antennanp
XFILLER_477_56 VPWR VGND sg13cmos5l_decap_8
XFILLER_477_67 VPWR VGND sg13cmos5l_fill_2
XFILLER_705_7 VPWR VGND sg13cmos5l_decap_8
XFILLER_196_35 VPWR VGND sg13cmos5l_decap_8
XFILLER_167_253 VPWR VGND sg13cmos5l_decap_8
XFILLER_167_264 VPWR VGND sg13cmos5l_fill_1
XFILLER_706_233 VPWR VGND sg13cmos5l_decap_8
XFILLER_127_106 VPWR VGND sg13cmos5l_decap_8
XFILLER_383_161 VPWR VGND sg13cmos5l_decap_8
XFILLER_572_272 VPWR VGND sg13cmos5l_fill_1
XFILLER_517_177 VPWR VGND sg13cmos5l_decap_8
XFILLER_346_49 VPWR VGND sg13cmos5l_decap_8
XFILLER_129_84 VPWR VGND sg13cmos5l_decap_8
XFILLER_532_147 VPWR VGND sg13cmos5l_fill_1
XFILLER_707_70 VPWR VGND sg13cmos5l_decap_8
XFILLER_532_169 VPWR VGND sg13cmos5l_decap_8
XFILLER_493_77 VPWR VGND sg13cmos5l_decap_8
XFILLER_331_209 VPWR VGND sg13cmos5l_decap_8
XFILLER_643_14 VPWR VGND sg13cmos5l_decap_8
XANTENNA__3454__X Tile_X0Y1_FrameData_O[12] VPWR VGND sg13cmos5l_antennanp
XFILLER_89_77 VPWR VGND sg13cmos5l_decap_8
XFILLER_135_183 VPWR VGND sg13cmos5l_decap_8
XFILLER_8_0 VPWR VGND sg13cmos5l_decap_8
XFILLER_686_184 VPWR VGND sg13cmos5l_decap_8
XFILLER_96_207 VPWR VGND sg13cmos5l_decap_8
XFILLER_397_0 VPWR VGND sg13cmos5l_decap_8
XFILLER_296_157 VPWR VGND sg13cmos5l_decap_8
XFILLER_485_268 VPWR VGND sg13cmos5l_decap_4
XFILLER_438_151 VPWR VGND sg13cmos5l_decap_8
XFILLER_453_110 VPWR VGND sg13cmos5l_decap_8
XFILLER_438_184 VPWR VGND sg13cmos5l_decap_8
XFILLER_642_210 VPWR VGND sg13cmos5l_decap_8
XFILLER_599_114 VPWR VGND sg13cmos5l_decap_4
XFILLER_564_0 VPWR VGND sg13cmos5l_decap_8
XFILLER_237_268 VPWR VGND sg13cmos5l_decap_4
XFILLER_161_60 VPWR VGND sg13cmos5l_decap_8
XFILLER_64_126 VPWR VGND sg13cmos5l_decap_8
XFILLER_453_154 VPWR VGND sg13cmos5l_fill_2
XFILLER_599_158 VPWR VGND sg13cmos5l_fill_2
X_0040_ _0040_/X _4334_/X _4335_/X _0636_/Q VPWR VGND sg13cmos5l_mux2_1
XFILLER_205_176 VPWR VGND sg13cmos5l_decap_8
XFILLER_220_102 VPWR VGND sg13cmos5l_decap_8
XFILLER_72_192 VPWR VGND sg13cmos5l_decap_8
XFILLER_668_77 VPWR VGND sg13cmos5l_decap_8
XFILLER_668_88 VPWR VGND sg13cmos5l_fill_2
XFILLER_20_207 VPWR VGND sg13cmos5l_fill_1
X_1991_ _1991_/Q Tile_X0Y4_FrameData[30] VGND VPWR Tile_X0Y9_FrameStrobe[2] latch
XANTENNA__3629__X Tile_X0Y9_S4BEG[7] VPWR VGND sg13cmos5l_antennanp
XFILLER_366_139 VPWR VGND sg13cmos5l_fill_1
XFILLER_20_229 VPWR VGND sg13cmos5l_decap_8
X_3730_ AXI_M_SOC_ARADDR2 Tile_X0Y9_WW4END[2] Tile_X0Y9_WW4END[10] Tile_X0Y9_W6END[2]
+ _4918_/X _0755_/Q _0754_/Q VPWR VGND sg13cmos5l_mux4_1
X_0942_ _0942_/Q Tile_X0Y0_FrameData[29] VGND VPWR Tile_X0Y9_FrameStrobe[0] latch
XFILLER_684_21 VPWR VGND sg13cmos5l_decap_8
XFILLER_684_32 VPWR VGND sg13cmos5l_fill_1
XFILLER_508_144 VPWR VGND sg13cmos5l_decap_4
XFILLER_118_117 VPWR VGND sg13cmos5l_decap_8
XFILLER_173_212 VPWR VGND sg13cmos5l_decap_8
X_3661_ AXI_M_SOC_AWADDR22 Tile_X0Y4_WW4END[6] Tile_X0Y4_WW4END[14] Tile_X0Y4_W6END[6]
+ _4342_/X _2001_/Q _2000_/Q VPWR VGND sg13cmos5l_mux4_1
XFILLER_684_54 VPWR VGND sg13cmos5l_decap_8
XFILLER_307_217 VPWR VGND sg13cmos5l_decap_8
X_0873_ _0873_/Q Tile_X0Y9_FrameData[22] VGND VPWR Tile_X0Y9_FrameStrobe[6] latch
XFILLER_374_172 VPWR VGND sg13cmos5l_decap_8
XFILLER_712_203 VPWR VGND sg13cmos5l_decap_8
XFILLER_508_188 VPWR VGND sg13cmos5l_fill_2
XFILLER_669_107 VPWR VGND sg13cmos5l_decap_8
X_2612_ _2612_/Q Tile_X0Y6_FrameData[19] VGND VPWR Tile_X0Y9_FrameStrobe[5] latch
X_3592_ Tile_X0Y9_FrameData_O[22] Tile_X0Y9_FrameData[22] VPWR VGND sg13cmos5l_buf_1
XFILLER_617_70 VPWR VGND sg13cmos5l_decap_8
XFILLER_712_258 VPWR VGND sg13cmos5l_decap_4
XFILLER_126_161 VPWR VGND sg13cmos5l_decap_8
XFILLER_523_169 VPWR VGND sg13cmos5l_fill_2
X_2543_ _2543_/Q Tile_X0Y6_FrameData[24] VGND VPWR Tile_X0Y9_FrameStrobe[3] latch
XFILLER_553_14 VPWR VGND sg13cmos5l_decap_8
XFILLER_315_272 VPWR VGND sg13cmos5l_fill_1
XANTENNA__3364__X Tile_X0Y2_EE4BEG[3] VPWR VGND sg13cmos5l_antennanp
XFILLER_126_194 VPWR VGND sg13cmos5l_decap_8
XFILLER_336_82 VPWR VGND sg13cmos5l_decap_8
XFILLER_330_220 VPWR VGND sg13cmos5l_decap_8
XFILLER_476_213 VPWR VGND sg13cmos5l_decap_4
X_2474_ _2474_/Q Tile_X0Y6_FrameData[29] VGND VPWR Tile_X0Y9_FrameStrobe[1] latch
XFILLER_476_224 VPWR VGND sg13cmos5l_decap_8
X_4213_ _4213_/X Tile_X0Y7_W1END[0] Tile_X0Y7_WW4END[0] Tile_X0Y7_W6END[8] _4684_/X
+ _0391_/Q _0390_/Q VPWR VGND sg13cmos5l_mux4_1
XFILLER_330_264 VPWR VGND sg13cmos5l_fill_1
X_1425_ _1425_/Q Tile_X0Y1_FrameData[8] VGND VPWR Tile_X0Y9_FrameStrobe[7] latch
XFILLER_703_28 VPWR VGND sg13cmos5l_decap_8
XFILLER_692_143 VPWR VGND sg13cmos5l_decap_8
XFILLER_287_168 VPWR VGND sg13cmos5l_decap_8
XFILLER_141_186 VPWR VGND sg13cmos5l_decap_8
XFILLER_476_268 VPWR VGND sg13cmos5l_decap_4
XFILLER_429_140 VPWR VGND sg13cmos5l_decap_8
XFILLER_633_91 VPWR VGND sg13cmos5l_decap_8
XFILLER_205_42 VPWR VGND sg13cmos5l_decap_8
X_1356_ _1356_/Q Tile_X0Y1_FrameData[13] VGND VPWR Tile_X0Y9_FrameStrobe[5] latch
X_4144_ _4144_/X _4195_/X Tile_X0Y3_WW4END[6] _4194_/X AXI_M_SOC_BVALID _1853_/Q _1852_/Q
+ VPWR VGND sg13cmos5l_mux4_1
XFILLER_352_70 VPWR VGND sg13cmos5l_decap_8
XFILLER_228_257 VPWR VGND sg13cmos5l_decap_4
X_0307_ _0307_/Q Tile_X0Y7_FrameData[12] VGND VPWR Tile_X0Y9_FrameStrobe[4] latch
XFILLER_55_104 VPWR VGND sg13cmos5l_decap_8
XFILLER_228_268 VPWR VGND sg13cmos5l_decap_4
X_1287_ _1287_/Q Tile_X0Y1_FrameData[18] VGND VPWR Tile_X0Y9_FrameStrobe[3] latch
X_4075_ _4075_/X _0094_/X Tile_X0Y0_S4END[11] _4124_/X _4113_/X _1523_/Q _1522_/Q
+ VPWR VGND sg13cmos5l_mux4_1
XFILLER_444_176 VPWR VGND sg13cmos5l_decap_8
X_0238_ _0238_/Q Tile_X0Y7_FrameData[17] VGND VPWR Tile_X0Y9_FrameStrobe[2] latch
X_3026_ Tile_X0Y5_EE4BEG[1] _4389_/X VPWR VGND sg13cmos5l_buf_1
XFILLER_502_84 VPWR VGND sg13cmos5l_decap_8
XFILLER_243_249 VPWR VGND sg13cmos5l_decap_8
X_0169_ _0169_/Q Tile_X0Y7_FrameData[22] VGND VPWR Tile_X0Y9_FrameStrobe[0] latch
XFILLER_63_181 VPWR VGND sg13cmos5l_decap_8
XFILLER_34_28 VPWR VGND sg13cmos5l_decap_8
XFILLER_397_253 VPWR VGND sg13cmos5l_decap_8
XFILLER_578_77 VPWR VGND sg13cmos5l_decap_8
XANTENNA__3539__X Tile_X0Y9_E2BEGb[5] VPWR VGND sg13cmos5l_antennanp
XFILLER_149_220 VPWR VGND sg13cmos5l_decap_8
XFILLER_400_246 VPWR VGND sg13cmos5l_decap_8
XFILLER_211_168 VPWR VGND sg13cmos5l_decap_8
X_3928_ _3928_/X _3981_/X Tile_X0Y1_WW4END[4] _3980_/X AXI_M_SOC_ARREADY _1353_/Q
+ _1352_/Q VPWR VGND sg13cmos5l_mux4_1
XFILLER_297_78 VPWR VGND sg13cmos5l_decap_8
XFILLER_594_21 VPWR VGND sg13cmos5l_decap_8
X_3859_ _3859_/X _3895_/X _3894_/X Tile_X0Y0_S2MID[3] Tile_X0Y0_S2END[3] _0957_/Q
+ _0956_/Q VPWR VGND sg13cmos5l_mux4_1
XFILLER_554_261 VPWR VGND sg13cmos5l_decap_8
XFILLER_554_272 VPWR VGND sg13cmos5l_fill_1
XFILLER_50_49 VPWR VGND sg13cmos5l_decap_8
XFILLER_164_234 VPWR VGND sg13cmos5l_decap_8
XFILLER_365_183 VPWR VGND sg13cmos5l_decap_8
XFILLER_119_7 VPWR VGND sg13cmos5l_decap_8
XFILLER_514_147 VPWR VGND sg13cmos5l_decap_8
XFILLER_313_209 VPWR VGND sg13cmos5l_decap_8
XFILLER_306_250 VPWR VGND sg13cmos5l_decap_8
XFILLER_463_14 VPWR VGND sg13cmos5l_decap_8
XFILLER_380_175 VPWR VGND sg13cmos5l_decap_8
XFILLER_117_172 VPWR VGND sg13cmos5l_decap_8
XFILLER_306_272 VPWR VGND sg13cmos5l_fill_1
XANTENNA__3274__X Tile_X0Y0_EE4BEG[10] VPWR VGND sg13cmos5l_antennanp
XFILLER_246_82 VPWR VGND sg13cmos5l_decap_8
XFILLER_1_7 VPWR VGND sg13cmos5l_decap_8
XFILLER_522_180 VPWR VGND sg13cmos5l_decap_8
XFILLER_182_15 VPWR VGND sg13cmos5l_decap_8
XFILLER_321_242 VPWR VGND sg13cmos5l_decap_8
XFILLER_278_146 VPWR VGND sg13cmos5l_decap_8
XFILLER_59_69 VPWR VGND sg13cmos5l_decap_8
XFILLER_613_28 VPWR VGND sg13cmos5l_decap_8
XFILLER_390_7 VPWR VGND sg13cmos5l_decap_8
XFILLER_278_168 VPWR VGND sg13cmos5l_decap_8
XFILLER_488_7 VPWR VGND sg13cmos5l_decap_8
XFILLER_115_42 VPWR VGND sg13cmos5l_fill_2
XFILLER_293_127 VPWR VGND sg13cmos5l_decap_8
XFILLER_219_257 VPWR VGND sg13cmos5l_fill_2
XFILLER_115_97 VPWR VGND sg13cmos5l_fill_2
XFILLER_655_7 VPWR VGND sg13cmos5l_decap_8
XFILLER_624_243 VPWR VGND sg13cmos5l_decap_4
XFILLER_435_154 VPWR VGND sg13cmos5l_decap_8
XFILLER_490_260 VPWR VGND sg13cmos5l_fill_1
XFILLER_490_271 VPWR VGND sg13cmos5l_fill_2
XFILLER_596_117 VPWR VGND sg13cmos5l_decap_8
XFILLER_388_220 VPWR VGND sg13cmos5l_decap_8
XFILLER_131_85 VPWR VGND sg13cmos5l_decap_8
XFILLER_131_96 VPWR VGND sg13cmos5l_fill_2
XFILLER_388_253 VPWR VGND sg13cmos5l_decap_4
XFILLER_199_175 VPWR VGND sg13cmos5l_decap_8
XFILLER_638_14 VPWR VGND sg13cmos5l_decap_8
XANTENNA__3449__X Tile_X0Y1_FrameData_O[7] VPWR VGND sg13cmos5l_antennanp
XFILLER_145_0 VPWR VGND sg13cmos5l_decap_8
XFILLER_91_89 VPWR VGND sg13cmos5l_decap_8
XFILLER_356_161 VPWR VGND sg13cmos5l_decap_8
XFILLER_545_272 VPWR VGND sg13cmos5l_fill_1
XFILLER_312_0 VPWR VGND sg13cmos5l_decap_8
XFILLER_654_35 VPWR VGND sg13cmos5l_decap_8
XFILLER_437_70 VPWR VGND sg13cmos5l_decap_8
XFILLER_108_161 VPWR VGND sg13cmos5l_decap_8
XFILLER_520_106 VPWR VGND sg13cmos5l_decap_8
XFILLER_373_14 VPWR VGND sg13cmos5l_decap_8
XANTENNA__3184__X Tile_X0Y0_N4BEG[8] VPWR VGND sg13cmos5l_antennanp
XFILLER_269_102 VPWR VGND sg13cmos5l_decap_4
XFILLER_513_191 VPWR VGND sg13cmos5l_decap_8
XFILLER_312_231 VPWR VGND sg13cmos5l_decap_8
XFILLER_373_69 VPWR VGND sg13cmos5l_decap_8
XFILLER_681_0 VPWR VGND sg13cmos5l_decap_8
XFILLER_659_195 VPWR VGND sg13cmos5l_fill_1
XFILLER_123_175 VPWR VGND sg13cmos5l_decap_8
XFILLER_523_28 VPWR VGND sg13cmos5l_decap_8
XFILLER_34_7 VPWR VGND sg13cmos5l_decap_8
XFILLER_284_105 VPWR VGND sg13cmos5l_decap_8
XFILLER_670_56 VPWR VGND sg13cmos5l_decap_8
X_1210_ _1210_/Q Tile_X0Y1_FrameData[31] VGND VPWR Tile_X0Y9_FrameStrobe[1] latch
XFILLER_473_216 VPWR VGND sg13cmos5l_decap_8
X_2190_ _2190_/Q Tile_X0Y5_FrameData[23] VGND VPWR Tile_X0Y9_FrameStrobe[0] latch
XFILLER_277_190 VPWR VGND sg13cmos5l_fill_2
XFILLER_1_21 VPWR VGND sg13cmos5l_decap_8
XFILLER_615_221 VPWR VGND sg13cmos5l_decap_8
X_1141_ _1141_/Q Tile_X0Y0_FrameData[22] VGND VPWR Tile_X0Y9_FrameStrobe[6] latch
XFILLER_603_94 VPWR VGND sg13cmos5l_decap_4
XFILLER_426_154 VPWR VGND sg13cmos5l_decap_8
XFILLER_679_21 VPWR VGND sg13cmos5l_decap_4
XFILLER_292_171 VPWR VGND sg13cmos5l_decap_8
XFILLER_1_76 VPWR VGND sg13cmos5l_fill_2
XFILLER_92_243 VPWR VGND sg13cmos5l_decap_8
XFILLER_481_271 VPWR VGND sg13cmos5l_fill_2
X_1072_ _1072_/Q Tile_X0Y0_FrameData[27] VGND VPWR Tile_X0Y9_FrameStrobe[4] latch
XFILLER_441_124 VPWR VGND sg13cmos5l_decap_8
XFILLER_679_65 VPWR VGND sg13cmos5l_decap_4
XANTENNA__0048__X AXI_M_SOC_AWCACHE1 VPWR VGND sg13cmos5l_antennanp
X_4900_ _4900_/X Tile_X0Y9_N2MID[7] Tile_X0Y9_N2END[7] _4939_/X _4823_/X _0681_/Q
+ _0680_/Q VPWR VGND sg13cmos5l_mux4_1
XFILLER_679_98 VPWR VGND sg13cmos5l_fill_2
XFILLER_630_268 VPWR VGND sg13cmos5l_decap_4
X_4831_ _4831_/X Tile_X0Y9_W2MID[4] Tile_X0Y9_W2END[4] Tile_X0Y9_W6END[11] _4907_/X
+ _0877_/Q _0876_/Q VPWR VGND sg13cmos5l_mux4_1
XFILLER_398_77 VPWR VGND sg13cmos5l_fill_2
XANTENNA_180 Tile_X0Y9_FrameStrobe[8] VPWR VGND sg13cmos5l_antennanp
XFILLER_548_14 VPWR VGND sg13cmos5l_decap_8
XANTENNA_191 Tile_X0Y9_N2END[0] VPWR VGND sg13cmos5l_antennanp
XFILLER_394_212 VPWR VGND sg13cmos5l_decap_8
XANTENNA__3359__X Tile_X0Y2_FrameData_O[30] VPWR VGND sg13cmos5l_antennanp
XFILLER_695_42 VPWR VGND sg13cmos5l_decap_8
X_4762_ _4762_/X Tile_X0Y9_N4END[6] _0075_/X _4809_/X _4813_/X _0523_/Q _0522_/Q VPWR
+ VGND sg13cmos5l_mux4_1
XFILLER_60_195 VPWR VGND sg13cmos5l_decap_4
X_1974_ _1974_/Q Tile_X0Y4_FrameData[15] VGND VPWR Tile_X0Y9_FrameStrobe[1] latch
X_3713_ AXI_M_SOC_WDATA23 Tile_X0Y6_WW4END[7] Tile_X0Y6_WW4END[15] Tile_X0Y6_W6END[7]
+ _4575_/X _2513_/Q _2512_/Q VPWR VGND sg13cmos5l_mux4_1
X_0925_ _0925_/Q Tile_X0Y9_FrameData[2] VGND VPWR Tile_X0Y9_FrameStrobe[7] latch
XFILLER_536_261 VPWR VGND sg13cmos5l_decap_8
XFILLER_146_223 VPWR VGND sg13cmos5l_fill_2
X_4693_ _4693_/X _4663_/X Tile_X0Y9_N4END[9] _4662_/X _0055_/X _0197_/Q _0196_/Q VPWR
+ VGND sg13cmos5l_mux4_1
XFILLER_536_272 VPWR VGND sg13cmos5l_fill_1
XFILLER_347_194 VPWR VGND sg13cmos5l_decap_8
X_3644_ AXI_M_SOC_AWADDR5 Tile_X0Y5_WW4END[5] Tile_X0Y5_WW4END[13] Tile_X0Y5_W6END[5]
+ _4456_/X _2261_/Q _2260_/Q VPWR VGND sg13cmos5l_mux4_1
X_0856_ _0856_/Q Tile_X0Y9_FrameData[7] VGND VPWR Tile_X0Y9_FrameStrobe[5] latch
XFILLER_60_0 VPWR VGND sg13cmos5l_fill_2
XFILLER_564_35 VPWR VGND sg13cmos5l_decap_8
XFILLER_347_70 VPWR VGND sg13cmos5l_decap_8
XFILLER_697_246 VPWR VGND sg13cmos5l_decap_8
XFILLER_283_14 VPWR VGND sg13cmos5l_decap_8
X_3575_ Tile_X0Y9_FrameData_O[5] Tile_X0Y9_FrameData[5] VPWR VGND sg13cmos5l_buf_1
XFILLER_362_186 VPWR VGND sg13cmos5l_decap_8
XANTENNA__3094__X Tile_X0Y7_E2BEGb[0] VPWR VGND sg13cmos5l_antennanp
X_0787_ _0787_/Q Tile_X0Y9_FrameData[12] VGND VPWR Tile_X0Y9_FrameStrobe[3] latch
X_2526_ _2526_/Q Tile_X0Y6_FrameData[9] VGND VPWR Tile_X0Y9_FrameStrobe[2] latch
XFILLER_714_49 VPWR VGND sg13cmos5l_decap_8
XFILLER_433_28 VPWR VGND sg13cmos5l_decap_8
X_2457_ _2457_/Q Tile_X0Y6_FrameData[14] VGND VPWR Tile_X0Y9_FrameStrobe[0] latch
XFILLER_29_28 VPWR VGND sg13cmos5l_decap_8
XFILLER_665_165 VPWR VGND sg13cmos5l_fill_2
XFILLER_580_56 VPWR VGND sg13cmos5l_decap_8
X_1408_ _1408_/Q Tile_X0Y1_FrameData[25] VGND VPWR Tile_X0Y9_FrameStrobe[7] latch
XFILLER_464_238 VPWR VGND sg13cmos5l_fill_1
XFILLER_275_149 VPWR VGND sg13cmos5l_decap_8
X_2388_ _2388_/Q Tile_X0Y5_FrameData[17] VGND VPWR Tile_X0Y9_FrameStrobe[6] latch
X_4127_ _4127_/X _4095_/X _0094_/X _4094_/X Tile_X0Y0_S4END[11] _1459_/Q _1458_/Q
+ VPWR VGND sg13cmos5l_mux4_1
X_1339_ _1339_/Q Tile_X0Y1_FrameData[30] VGND VPWR Tile_X0Y9_FrameStrobe[5] latch
XFILLER_216_216 VPWR VGND sg13cmos5l_fill_1
XFILLER_606_265 VPWR VGND sg13cmos5l_decap_8
XFILLER_589_21 VPWR VGND sg13cmos5l_decap_8
XFILLER_472_271 VPWR VGND sg13cmos5l_fill_2
XFILLER_216_238 VPWR VGND sg13cmos5l_decap_8
XFILLER_621_213 VPWR VGND sg13cmos5l_fill_2
XFILLER_45_16 VPWR VGND sg13cmos5l_decap_8
XFILLER_28_159 VPWR VGND sg13cmos5l_decap_8
XFILLER_283_182 VPWR VGND sg13cmos5l_decap_8
XFILLER_216_249 VPWR VGND sg13cmos5l_fill_1
X_4058_ _4058_/X Tile_X0Y2_WW4END[13] AXI_M_SOC_AWREADY _4110_/X _4100_/X _1557_/Q
+ _1556_/Q VPWR VGND sg13cmos5l_mux4_1
XFILLER_43_107 VPWR VGND sg13cmos5l_decap_8
X_3009_ Tile_X0Y5_E2BEGb[4] _4384_/X VPWR VGND sg13cmos5l_buf_1
XFILLER_432_168 VPWR VGND sg13cmos5l_decap_8
XFILLER_36_192 VPWR VGND sg13cmos5l_fill_1
XFILLER_224_271 VPWR VGND sg13cmos5l_fill_2
XFILLER_51_140 VPWR VGND sg13cmos5l_decap_8
XFILLER_458_14 VPWR VGND sg13cmos5l_decap_8
XANTENNA__3269__X Tile_X0Y0_EE4BEG[5] VPWR VGND sg13cmos5l_antennanp
XFILLER_101_77 VPWR VGND sg13cmos5l_decap_8
XFILLER_586_194 VPWR VGND sg13cmos5l_decap_8
XFILLER_51_184 VPWR VGND sg13cmos5l_decap_8
XFILLER_196_156 VPWR VGND sg13cmos5l_decap_8
XFILLER_236_7 VPWR VGND sg13cmos5l_decap_8
XFILLER_177_15 VPWR VGND sg13cmos5l_decap_8
XFILLER_608_28 VPWR VGND sg13cmos5l_decap_8
XFILLER_527_261 VPWR VGND sg13cmos5l_fill_2
XFILLER_538_91 VPWR VGND sg13cmos5l_decap_4
XANTENNA__2901__X Tile_X0Y6_FrameData_O[22] VPWR VGND sg13cmos5l_antennanp
XFILLER_327_29 VPWR VGND sg13cmos5l_decap_8
XFILLER_474_35 VPWR VGND sg13cmos5l_decap_8
XFILLER_193_14 VPWR VGND sg13cmos5l_decap_8
XFILLER_353_175 VPWR VGND sg13cmos5l_decap_8
XFILLER_499_168 VPWR VGND sg13cmos5l_decap_8
XFILLER_298_219 VPWR VGND sg13cmos5l_fill_2
XFILLER_3_225 VPWR VGND sg13cmos5l_decap_8
XFILLER_10_63 VPWR VGND sg13cmos5l_decap_8
XFILLER_624_49 VPWR VGND sg13cmos5l_decap_8
XFILLER_407_84 VPWR VGND sg13cmos5l_decap_8
XFILLER_126_63 VPWR VGND sg13cmos5l_decap_8
XFILLER_343_28 VPWR VGND sg13cmos5l_decap_8
XFILLER_455_205 VPWR VGND sg13cmos5l_decap_8
XANTENNA__3732__X AXI_M_SOC_ARADDR4 VPWR VGND sg13cmos5l_antennanp
XFILLER_490_56 VPWR VGND sg13cmos5l_decap_8
XFILLER_86_56 VPWR VGND sg13cmos5l_decap_8
XFILLER_259_190 VPWR VGND sg13cmos5l_decap_8
XFILLER_120_178 VPWR VGND sg13cmos5l_decap_8
XFILLER_671_135 VPWR VGND sg13cmos5l_decap_8
XFILLER_19_115 VPWR VGND sg13cmos5l_decap_8
XFILLER_19_126 VPWR VGND sg13cmos5l_fill_1
XFILLER_281_119 VPWR VGND sg13cmos5l_decap_8
XFILLER_499_21 VPWR VGND sg13cmos5l_decap_8
XFILLER_408_165 VPWR VGND sg13cmos5l_decap_4
XFILLER_19_148 VPWR VGND sg13cmos5l_decap_8
XFILLER_612_202 VPWR VGND sg13cmos5l_decap_8
XFILLER_142_84 VPWR VGND sg13cmos5l_decap_8
XFILLER_262_0 VPWR VGND sg13cmos5l_decap_8
XFILLER_499_98 VPWR VGND sg13cmos5l_decap_8
XFILLER_649_35 VPWR VGND sg13cmos5l_decap_8
XFILLER_577_150 VPWR VGND sg13cmos5l_decap_8
XANTENNA__3179__X Tile_X0Y0_N4BEG[3] VPWR VGND sg13cmos5l_antennanp
XFILLER_230_230 VPWR VGND sg13cmos5l_decap_8
XFILLER_527_0 VPWR VGND sg13cmos5l_decap_8
XFILLER_368_36 VPWR VGND sg13cmos5l_decap_8
XFILLER_187_145 VPWR VGND sg13cmos5l_decap_4
XFILLER_592_120 VPWR VGND sg13cmos5l_decap_8
XFILLER_187_178 VPWR VGND sg13cmos5l_decap_4
XFILLER_518_28 VPWR VGND sg13cmos5l_decap_8
XFILLER_128_234 VPWR VGND sg13cmos5l_decap_8
XFILLER_665_56 VPWR VGND sg13cmos5l_decap_8
XFILLER_448_91 VPWR VGND sg13cmos5l_decap_8
XFILLER_329_194 VPWR VGND sg13cmos5l_decap_8
XANTENNA__2811__X Tile_X0Y3_E2BEG[1] VPWR VGND sg13cmos5l_antennanp
XFILLER_128_245 VPWR VGND sg13cmos5l_fill_1
X_0710_ _0710_/Q Tile_X0Y9_FrameData[25] VGND VPWR Tile_X0Y9_FrameStrobe[1] latch
XFILLER_391_259 VPWR VGND sg13cmos5l_decap_8
XFILLER_167_70 VPWR VGND sg13cmos5l_decap_8
X_1690_ _1690_/Q Tile_X0Y3_FrameData[15] VGND VPWR Tile_X0Y9_FrameStrobe[0] latch
XFILLER_384_35 VPWR VGND sg13cmos5l_decap_8
XFILLER_384_46 VPWR VGND sg13cmos5l_fill_1
XFILLER_533_264 VPWR VGND sg13cmos5l_fill_1
X_0641_ _0641_/Q Tile_X0Y8_FrameData[30] VGND VPWR Tile_X0Y9_FrameStrobe[7] latch
XFILLER_384_79 VPWR VGND sg13cmos5l_decap_4
XFILLER_289_219 VPWR VGND sg13cmos5l_decap_8
XFILLER_694_205 VPWR VGND sg13cmos5l_decap_8
X_0572_ _0572_/Q Tile_X0Y8_FrameData[3] VGND VPWR Tile_X0Y9_FrameStrobe[4] latch
X_3360_ Tile_X0Y2_FrameData_O[31] Tile_X0Y2_FrameData[31] VPWR VGND sg13cmos5l_buf_1
XFILLER_534_49 VPWR VGND sg13cmos5l_decap_8
XANTENNA__0050__Y AXI_M_SOC_AWLOCK VPWR VGND sg13cmos5l_antennanp
XFILLER_111_101 VPWR VGND sg13cmos5l_fill_2
X_2311_ _2311_/Q Tile_X0Y5_FrameData[30] VGND VPWR Tile_X0Y9_FrameStrobe[4] latch
XFILLER_297_252 VPWR VGND sg13cmos5l_fill_2
XFILLER_253_28 VPWR VGND sg13cmos5l_decap_8
XFILLER_501_161 VPWR VGND sg13cmos5l_decap_8
X_3291_ Tile_X0Y0_E6BEG[11] _3847_/X VPWR VGND sg13cmos5l_buf_1
XFILLER_647_154 VPWR VGND sg13cmos5l_decap_8
XANTENNA__3642__X AXI_M_SOC_AWADDR3 VPWR VGND sg13cmos5l_antennanp
XFILLER_446_216 VPWR VGND sg13cmos5l_fill_2
X_2242_ _2242_/Q Tile_X0Y5_FrameData[3] VGND VPWR Tile_X0Y9_FrameStrobe[1] latch
XFILLER_111_167 VPWR VGND sg13cmos5l_decap_8
XFILLER_446_249 VPWR VGND sg13cmos5l_decap_8
XFILLER_333_50 VPWR VGND sg13cmos5l_decap_8
X_2173_ _2173_/Q Tile_X0Y4_FrameData[8] VGND VPWR Tile_X0Y9_FrameStrobe[7] latch
XFILLER_65_210 VPWR VGND sg13cmos5l_decap_8
X_1124_ _1124_/Q Tile_X0Y0_FrameData[7] VGND VPWR Tile_X0Y9_FrameStrobe[5] latch
XFILLER_202_21 VPWR VGND sg13cmos5l_decap_8
XFILLER_630_70 VPWR VGND sg13cmos5l_decap_8
XFILLER_25_107 VPWR VGND sg13cmos5l_fill_1
X_1055_ _1055_/Q Tile_X0Y0_FrameData[12] VGND VPWR Tile_X0Y9_FrameStrobe[3] latch
XFILLER_603_257 VPWR VGND sg13cmos5l_decap_8
XFILLER_206_260 VPWR VGND sg13cmos5l_fill_2
XFILLER_559_35 VPWR VGND sg13cmos5l_decap_8
XFILLER_280_196 VPWR VGND sg13cmos5l_decap_8
XFILLER_202_98 VPWR VGND sg13cmos5l_decap_8
XFILLER_568_161 VPWR VGND sg13cmos5l_decap_8
XFILLER_278_14 VPWR VGND sg13cmos5l_decap_8
XFILLER_367_212 VPWR VGND sg13cmos5l_decap_8
XANTENNA__3089__X Tile_X0Y7_E2BEG[3] VPWR VGND sg13cmos5l_antennanp
X_4814_ _4814_/X _4781_/X Tile_X0Y9_N4END[6] _4780_/X _0075_/X _0443_/Q _0442_/Q VPWR
+ VGND sg13cmos5l_mux4_1
XFILLER_709_49 VPWR VGND sg13cmos5l_decap_8
XFILLER_717_158 VPWR VGND sg13cmos5l_decap_8
XFILLER_717_169 VPWR VGND sg13cmos5l_fill_2
X_4745_ _4745_/X Tile_X0Y8_WW4END[14] AXI_M_SOC_RDATA9 _4814_/X _4786_/X _0557_/Q
+ _0556_/Q VPWR VGND sg13cmos5l_mux4_1
XFILLER_509_261 VPWR VGND sg13cmos5l_fill_1
XFILLER_428_28 VPWR VGND sg13cmos5l_decap_8
X_1957_ _1957_/Q Tile_X0Y4_FrameData[0] VGND VPWR Tile_X0Y9_FrameStrobe[0] latch
XFILLER_509_272 VPWR VGND sg13cmos5l_fill_1
XFILLER_575_56 VPWR VGND sg13cmos5l_decap_8
XFILLER_358_91 VPWR VGND sg13cmos5l_decap_8
XFILLER_119_256 VPWR VGND sg13cmos5l_decap_4
X_0908_ _0908_/Q Tile_X0Y9_FrameData[19] VGND VPWR Tile_X0Y9_FrameStrobe[7] latch
X_4676_ _4676_/X Tile_X0Y3_W1END[0] Tile_X0Y3_WW4END[12] Tile_X0Y3_W6END[4] _4222_/X
+ _1865_/Q _1864_/Q VPWR VGND sg13cmos5l_mux4_1
XFILLER_294_35 VPWR VGND sg13cmos5l_decap_8
X_1888_ _1888_/Q Tile_X0Y3_FrameData[9] VGND VPWR Tile_X0Y9_FrameStrobe[6] latch
XFILLER_524_253 VPWR VGND sg13cmos5l_decap_8
XFILLER_524_264 VPWR VGND sg13cmos5l_fill_1
XFILLER_134_226 VPWR VGND sg13cmos5l_decap_8
X_3627_ Tile_X0Y9_S4BEG[5] _3627_/A VPWR VGND sg13cmos5l_buf_1
X_0839_ _0839_/Q Tile_X0Y9_FrameData[24] VGND VPWR Tile_X0Y9_FrameStrobe[5] latch
XFILLER_350_112 VPWR VGND sg13cmos5l_decap_8
XFILLER_496_105 VPWR VGND sg13cmos5l_decap_8
XFILLER_685_216 VPWR VGND sg13cmos5l_fill_2
X_3558_ Tile_X0Y9_EE4BEG[4] _4868_/X VPWR VGND sg13cmos5l_buf_1
XFILLER_444_49 VPWR VGND sg13cmos5l_decap_8
XFILLER_350_167 VPWR VGND sg13cmos5l_decap_8
XFILLER_0_206 VPWR VGND sg13cmos5l_fill_1
XFILLER_288_241 VPWR VGND sg13cmos5l_decap_8
XFILLER_0_217 VPWR VGND sg13cmos5l_decap_8
XFILLER_102_101 VPWR VGND sg13cmos5l_fill_2
XFILLER_591_77 VPWR VGND sg13cmos5l_decap_8
X_2509_ _2509_/Q Tile_X0Y6_FrameData[26] VGND VPWR Tile_X0Y9_FrameStrobe[2] latch
XFILLER_638_154 VPWR VGND sg13cmos5l_decap_8
XANTENNA__3552__X Tile_X0Y9_E6BEG[10] VPWR VGND sg13cmos5l_antennanp
X_3489_ Tile_X0Y1_EE4BEG[15] _3963_/X VPWR VGND sg13cmos5l_buf_1
XFILLER_693_271 VPWR VGND sg13cmos5l_fill_2
XFILLER_102_156 VPWR VGND sg13cmos5l_decap_8
XFILLER_638_198 VPWR VGND sg13cmos5l_decap_8
XFILLER_243_61 VPWR VGND sg13cmos5l_decap_8
XFILLER_186_7 VPWR VGND sg13cmos5l_decap_8
XFILLER_56_232 VPWR VGND sg13cmos5l_decap_4
XFILLER_445_260 VPWR VGND sg13cmos5l_fill_2
XFILLER_405_102 VPWR VGND sg13cmos5l_decap_8
XFILLER_540_70 VPWR VGND sg13cmos5l_decap_8
XFILLER_112_21 VPWR VGND sg13cmos5l_decap_8
XFILLER_460_241 VPWR VGND sg13cmos5l_decap_8
XFILLER_271_152 VPWR VGND sg13cmos5l_fill_2
XFILLER_460_263 VPWR VGND sg13cmos5l_decap_8
XFILLER_353_7 VPWR VGND sg13cmos5l_decap_8
XFILLER_420_105 VPWR VGND sg13cmos5l_decap_8
XFILLER_405_179 VPWR VGND sg13cmos5l_fill_2
XFILLER_72_14 VPWR VGND sg13cmos5l_decap_8
XFILLER_469_35 VPWR VGND sg13cmos5l_decap_8
XFILLER_469_46 VPWR VGND sg13cmos5l_fill_1
XFILLER_71_268 VPWR VGND sg13cmos5l_decap_4
XFILLER_169_112 VPWR VGND sg13cmos5l_decap_8
XFILLER_188_14 VPWR VGND sg13cmos5l_decap_8
XFILLER_469_68 VPWR VGND sg13cmos5l_fill_1
XFILLER_469_79 VPWR VGND sg13cmos5l_fill_1
XFILLER_212_252 VPWR VGND sg13cmos5l_decap_4
XFILLER_520_7 VPWR VGND sg13cmos5l_decap_8
XFILLER_358_245 VPWR VGND sg13cmos5l_decap_8
XFILLER_708_136 VPWR VGND sg13cmos5l_decap_4
XFILLER_618_7 VPWR VGND sg13cmos5l_decap_8
XFILLER_619_49 VPWR VGND sg13cmos5l_decap_8
XFILLER_549_90 VPWR VGND sg13cmos5l_fill_1
XFILLER_169_189 VPWR VGND sg13cmos5l_decap_8
XFILLER_507_209 VPWR VGND sg13cmos5l_decap_8
XANTENNA__0135__Y AXI_M_SOC_AWLEN5 VPWR VGND sg13cmos5l_antennanp
XFILLER_574_175 VPWR VGND sg13cmos5l_decap_8
XFILLER_338_28 VPWR VGND sg13cmos5l_decap_8
XFILLER_373_226 VPWR VGND sg13cmos5l_fill_2
XANTENNA__3727__X AXI_M_SOC_BREADY VPWR VGND sg13cmos5l_antennanp
XFILLER_184_148 VPWR VGND sg13cmos5l_decap_8
XFILLER_485_56 VPWR VGND sg13cmos5l_decap_8
XFILLER_268_91 VPWR VGND sg13cmos5l_fill_1
XFILLER_716_180 VPWR VGND sg13cmos5l_decap_8
XANTENNA_80 Tile_X0Y0_S4END[14] VPWR VGND sg13cmos5l_antennanp
XFILLER_515_231 VPWR VGND sg13cmos5l_decap_8
XFILLER_401_4 VPWR VGND sg13cmos5l_fill_1
XANTENNA_91 Tile_X0Y1_FrameData[6] VPWR VGND sg13cmos5l_antennanp
XFILLER_326_153 VPWR VGND sg13cmos5l_decap_8
XFILLER_192_170 VPWR VGND sg13cmos5l_decap_8
XFILLER_108_0 VPWR VGND sg13cmos5l_decap_8
XFILLER_137_84 VPWR VGND sg13cmos5l_decap_8
XFILLER_354_49 VPWR VGND sg13cmos5l_decap_8
XFILLER_279_230 VPWR VGND sg13cmos5l_decap_8
XFILLER_715_70 VPWR VGND sg13cmos5l_decap_8
XFILLER_530_267 VPWR VGND sg13cmos5l_decap_4
XFILLER_97_66 VPWR VGND sg13cmos5l_decap_8
XFILLER_651_14 VPWR VGND sg13cmos5l_decap_8
XANTENNA__3462__X Tile_X0Y1_FrameData_O[20] VPWR VGND sg13cmos5l_antennanp
XFILLER_691_219 VPWR VGND sg13cmos5l_decap_8
XFILLER_684_260 VPWR VGND sg13cmos5l_fill_1
XFILLER_495_182 VPWR VGND sg13cmos5l_decap_8
XFILLER_428_238 VPWR VGND sg13cmos5l_decap_8
XFILLER_370_15 VPWR VGND sg13cmos5l_decap_8
XFILLER_477_0 VPWR VGND sg13cmos5l_decap_8
XFILLER_644_168 VPWR VGND sg13cmos5l_decap_8
XFILLER_47_221 VPWR VGND sg13cmos5l_fill_2
XFILLER_303_64 VPWR VGND sg13cmos5l_decap_8
XFILLER_644_0 VPWR VGND sg13cmos5l_decap_8
XFILLER_62_224 VPWR VGND sg13cmos5l_decap_8
XANTENNA__2806__X Tile_X0Y3_E2BEGb[4] VPWR VGND sg13cmos5l_antennanp
XFILLER_597_256 VPWR VGND sg13cmos5l_fill_1
XFILLER_262_174 VPWR VGND sg13cmos5l_decap_8
XFILLER_379_35 VPWR VGND sg13cmos5l_decap_8
XFILLER_349_201 VPWR VGND sg13cmos5l_decap_8
XFILLER_600_84 VPWR VGND sg13cmos5l_fill_2
XFILLER_15_162 VPWR VGND sg13cmos5l_decap_8
XFILLER_203_230 VPWR VGND sg13cmos5l_decap_8
X_2860_ Tile_X0Y6_E6BEG[9] _4537_/X VPWR VGND sg13cmos5l_buf_1
XFILLER_30_121 VPWR VGND sg13cmos5l_decap_8
XFILLER_529_49 VPWR VGND sg13cmos5l_decap_4
X_1811_ _1811_/Q Tile_X0Y3_FrameData[22] VGND VPWR Tile_X0Y9_FrameStrobe[4] latch
XFILLER_676_77 VPWR VGND sg13cmos5l_decap_8
XFILLER_248_28 VPWR VGND sg13cmos5l_decap_8
X_2791_ Tile_X0Y3_E6BEG[1] _4181_/X VPWR VGND sg13cmos5l_buf_1
XFILLER_364_237 VPWR VGND sg13cmos5l_decap_8
XFILLER_30_176 VPWR VGND sg13cmos5l_decap_8
XANTENNA__3637__X Tile_X0Y9_S4BEG[15] VPWR VGND sg13cmos5l_antennanp
XFILLER_175_148 VPWR VGND sg13cmos5l_decap_8
X_4530_ _4530_/X Tile_X0Y9_N4END[14] _0155_/X _4577_/X _4581_/X _2547_/Q _2546_/Q
+ VPWR VGND sg13cmos5l_mux4_1
XFILLER_7_42 VPWR VGND sg13cmos5l_decap_8
X_1742_ _1742_/Q Tile_X0Y3_FrameData[27] VGND VPWR Tile_X0Y9_FrameStrobe[2] latch
XFILLER_395_78 VPWR VGND sg13cmos5l_decap_8
XFILLER_190_107 VPWR VGND sg13cmos5l_decap_8
XFILLER_580_156 VPWR VGND sg13cmos5l_decap_4
XFILLER_190_118 VPWR VGND sg13cmos5l_fill_1
XFILLER_692_21 VPWR VGND sg13cmos5l_decap_8
XFILLER_116_226 VPWR VGND sg13cmos5l_decap_8
X_4461_ _4461_/X _4424_/X _0100_/X _4423_/X _0140_/X _2217_/Q _2216_/Q VPWR VGND sg13cmos5l_mux4_1
X_1673_ _1673_/Q Tile_X0Y2_FrameData[8] VGND VPWR Tile_X0Y9_FrameStrobe[7] latch
XFILLER_667_205 VPWR VGND sg13cmos5l_decap_8
XFILLER_521_223 VPWR VGND sg13cmos5l_fill_2
XFILLER_332_123 VPWR VGND sg13cmos5l_decap_8
X_3412_ Tile_X0Y4_FrameData_O[3] Tile_X0Y4_FrameData[3] VPWR VGND sg13cmos5l_buf_1
XFILLER_692_87 VPWR VGND sg13cmos5l_decap_8
X_0624_ _0624_/Q Tile_X0Y8_FrameData[15] VGND VPWR Tile_X0Y9_FrameStrobe[6] latch
XFILLER_478_138 VPWR VGND sg13cmos5l_fill_2
X_4392_ _4392_/X Tile_X0Y5_WW4END[11] AXI_M_SOC_RVALID _4462_/X _4434_/X _2319_/Q
+ _2318_/Q VPWR VGND sg13cmos5l_mux4_1
XFILLER_264_49 VPWR VGND sg13cmos5l_decap_4
XFILLER_667_249 VPWR VGND sg13cmos5l_decap_8
XFILLER_625_70 VPWR VGND sg13cmos5l_decap_8
X_3343_ Tile_X0Y2_FrameData_O[14] Tile_X0Y2_FrameData[14] VPWR VGND sg13cmos5l_buf_1
XFILLER_561_14 VPWR VGND sg13cmos5l_decap_8
X_0555_ _0555_/Q Tile_X0Y8_FrameData[20] VGND VPWR Tile_X0Y9_FrameStrobe[4] latch
XFILLER_493_119 VPWR VGND sg13cmos5l_decap_8
XANTENNA__3372__X Tile_X0Y2_EE4BEG[11] VPWR VGND sg13cmos5l_antennanp
XFILLER_344_60 VPWR VGND sg13cmos5l_fill_2
XFILLER_97_143 VPWR VGND sg13cmos5l_fill_1
XFILLER_675_260 VPWR VGND sg13cmos5l_decap_8
XFILLER_675_271 VPWR VGND sg13cmos5l_fill_2
XFILLER_419_238 VPWR VGND sg13cmos5l_decap_8
XFILLER_97_165 VPWR VGND sg13cmos5l_decap_8
X_3274_ Tile_X0Y0_EE4BEG[10] _3830_/X VPWR VGND sg13cmos5l_buf_1
X_0486_ _0486_/Q Tile_X0Y8_FrameData[25] VGND VPWR Tile_X0Y9_FrameStrobe[2] latch
XFILLER_23_0 VPWR VGND sg13cmos5l_decap_8
X_2225_ _2225_/Q Tile_X0Y5_FrameData[20] VGND VPWR Tile_X0Y9_FrameStrobe[1] latch
XFILLER_711_28 VPWR VGND sg13cmos5l_decap_8
XFILLER_635_168 VPWR VGND sg13cmos5l_decap_8
XFILLER_650_105 VPWR VGND sg13cmos5l_decap_8
XFILLER_238_160 VPWR VGND sg13cmos5l_decap_8
XFILLER_641_91 VPWR VGND sg13cmos5l_decap_8
XFILLER_38_243 VPWR VGND sg13cmos5l_decap_8
XFILLER_213_42 VPWR VGND sg13cmos5l_decap_8
X_2156_ _2156_/Q Tile_X0Y4_FrameData[25] VGND VPWR Tile_X0Y9_FrameStrobe[7] latch
XFILLER_360_70 VPWR VGND sg13cmos5l_decap_8
XFILLER_253_130 VPWR VGND sg13cmos5l_fill_1
XFILLER_253_152 VPWR VGND sg13cmos5l_decap_8
X_1107_ _1107_/Q Tile_X0Y0_FrameData[24] VGND VPWR Tile_X0Y9_FrameStrobe[5] latch
XFILLER_588_245 VPWR VGND sg13cmos5l_fill_1
XFILLER_442_263 VPWR VGND sg13cmos5l_fill_2
XFILLER_399_156 VPWR VGND sg13cmos5l_decap_4
X_2087_ _2087_/Q Tile_X0Y4_FrameData[30] VGND VPWR Tile_X0Y9_FrameStrobe[5] latch
XFILLER_402_105 VPWR VGND sg13cmos5l_decap_8
XFILLER_399_167 VPWR VGND sg13cmos5l_decap_8
XFILLER_198_218 VPWR VGND sg13cmos5l_decap_8
XFILLER_289_35 VPWR VGND sg13cmos5l_decap_8
XFILLER_253_196 VPWR VGND sg13cmos5l_decap_8
X_1038_ _1038_/Q Tile_X0Y0_FrameData[29] VGND VPWR Tile_X0Y9_FrameStrobe[3] latch
XFILLER_510_84 VPWR VGND sg13cmos5l_decap_8
XFILLER_439_49 VPWR VGND sg13cmos5l_decap_8
XFILLER_42_28 VPWR VGND sg13cmos5l_decap_8
XFILLER_21_154 VPWR VGND sg13cmos5l_decap_8
XFILLER_586_77 VPWR VGND sg13cmos5l_decap_8
XFILLER_410_182 VPWR VGND sg13cmos5l_decap_8
XFILLER_21_176 VPWR VGND sg13cmos5l_decap_8
XFILLER_571_112 VPWR VGND sg13cmos5l_decap_8
XANTENNA__3547__X Tile_X0Y9_E6BEG[5] VPWR VGND sg13cmos5l_antennanp
X_2989_ Tile_X0Y8_FrameData_O[29] Tile_X0Y8_FrameData[29] VPWR VGND sg13cmos5l_buf_1
XFILLER_355_259 VPWR VGND sg13cmos5l_fill_2
X_4728_ _4728_/X Tile_X0Y8_W2MID[7] AXI_M_SOC_RDATA8 _4785_/X _4784_/X _0591_/Q _0590_/Q
+ VPWR VGND sg13cmos5l_mux4_1
XFILLER_308_164 VPWR VGND sg13cmos5l_fill_1
XFILLER_571_189 VPWR VGND sg13cmos5l_decap_8
XFILLER_323_101 VPWR VGND sg13cmos5l_decap_8
X_4659_ _4659_/X _4667_/X Tile_X0Y7_W6END[3] _4666_/X _4659_/A3 _0161_/Q _0416_/Q
+ VPWR VGND sg13cmos5l_mux4_1
XFILLER_238_83 VPWR VGND sg13cmos5l_fill_2
XFILLER_107_248 VPWR VGND sg13cmos5l_fill_2
XFILLER_469_116 VPWR VGND sg13cmos5l_decap_8
XFILLER_101_7 VPWR VGND sg13cmos5l_decap_8
XFILLER_713_194 VPWR VGND sg13cmos5l_decap_8
XFILLER_323_167 VPWR VGND sg13cmos5l_decap_8
XFILLER_107_21 VPWR VGND sg13cmos5l_decap_8
XFILLER_107_32 VPWR VGND sg13cmos5l_fill_2
XFILLER_115_270 VPWR VGND sg13cmos5l_fill_2
XFILLER_471_14 VPWR VGND sg13cmos5l_decap_8
XANTENNA__3282__X Tile_X0Y0_E6BEG[2] VPWR VGND sg13cmos5l_antennanp
XFILLER_477_160 VPWR VGND sg13cmos5l_fill_1
XFILLER_254_60 VPWR VGND sg13cmos5l_fill_1
XFILLER_67_14 VPWR VGND sg13cmos5l_decap_8
XFILLER_88_143 VPWR VGND sg13cmos5l_decap_8
XFILLER_276_222 VPWR VGND sg13cmos5l_fill_2
XFILLER_254_82 VPWR VGND sg13cmos5l_decap_8
XFILLER_477_182 VPWR VGND sg13cmos5l_decap_8
XFILLER_130_251 VPWR VGND sg13cmos5l_decap_4
XFILLER_626_157 VPWR VGND sg13cmos5l_decap_8
XFILLER_621_28 VPWR VGND sg13cmos5l_decap_8
XFILLER_470_7 VPWR VGND sg13cmos5l_decap_8
XFILLER_291_203 VPWR VGND sg13cmos5l_decap_8
XFILLER_190_59 VPWR VGND sg13cmos5l_decap_8
XFILLER_568_7 VPWR VGND sg13cmos5l_decap_8
XFILLER_184_4 VPWR VGND sg13cmos5l_fill_1
XFILLER_641_105 VPWR VGND sg13cmos5l_decap_8
XFILLER_123_42 VPWR VGND sg13cmos5l_decap_8
XFILLER_418_271 VPWR VGND sg13cmos5l_fill_2
XFILLER_29_243 VPWR VGND sg13cmos5l_fill_1
XFILLER_492_196 VPWR VGND sg13cmos5l_decap_4
XFILLER_270_70 VPWR VGND sg13cmos5l_decap_8
XFILLER_244_130 VPWR VGND sg13cmos5l_fill_1
XFILLER_244_152 VPWR VGND sg13cmos5l_decap_8
XFILLER_199_35 VPWR VGND sg13cmos5l_decap_8
XFILLER_244_185 VPWR VGND sg13cmos5l_decap_4
XFILLER_594_204 VPWR VGND sg13cmos5l_decap_4
XFILLER_420_84 VPWR VGND sg13cmos5l_decap_8
XFILLER_349_49 VPWR VGND sg13cmos5l_decap_8
XFILLER_496_77 VPWR VGND sg13cmos5l_decap_8
XFILLER_200_244 VPWR VGND sg13cmos5l_decap_8
XFILLER_646_14 VPWR VGND sg13cmos5l_decap_8
XFILLER_562_112 VPWR VGND sg13cmos5l_decap_8
XANTENNA__3457__X Tile_X0Y1_FrameData_O[15] VPWR VGND sg13cmos5l_antennanp
XFILLER_12_187 VPWR VGND sg13cmos5l_decap_8
XFILLER_225_0 VPWR VGND sg13cmos5l_decap_8
XFILLER_157_159 VPWR VGND sg13cmos5l_decap_4
XFILLER_8_147 VPWR VGND sg13cmos5l_decap_8
XFILLER_562_189 VPWR VGND sg13cmos5l_decap_8
XFILLER_165_181 VPWR VGND sg13cmos5l_decap_4
XFILLER_704_172 VPWR VGND sg13cmos5l_decap_8
XFILLER_503_223 VPWR VGND sg13cmos5l_decap_8
XFILLER_649_227 VPWR VGND sg13cmos5l_fill_1
XFILLER_180_151 VPWR VGND sg13cmos5l_fill_2
XFILLER_662_35 VPWR VGND sg13cmos5l_decap_8
XFILLER_445_70 VPWR VGND sg13cmos5l_decap_8
XFILLER_594_0 VPWR VGND sg13cmos5l_decap_8
XFILLER_445_81 VPWR VGND sg13cmos5l_fill_2
XFILLER_381_14 VPWR VGND sg13cmos5l_decap_8
XANTENNA__3192__X Tile_X0Y0_N2BEGb[0] VPWR VGND sg13cmos5l_antennanp
XFILLER_664_219 VPWR VGND sg13cmos5l_decap_8
XFILLER_267_200 VPWR VGND sg13cmos5l_decap_8
XFILLER_657_260 VPWR VGND sg13cmos5l_fill_2
XFILLER_267_211 VPWR VGND sg13cmos5l_fill_1
XFILLER_164_71 VPWR VGND sg13cmos5l_decap_4
XFILLER_79_154 VPWR VGND sg13cmos5l_decap_8
XFILLER_468_182 VPWR VGND sg13cmos5l_decap_8
X_0340_ _0340_/Q Tile_X0Y7_FrameData[11] VGND VPWR Tile_X0Y9_FrameStrobe[5] latch
XFILLER_267_233 VPWR VGND sg13cmos5l_decap_8
XFILLER_94_102 VPWR VGND sg13cmos5l_decap_8
XFILLER_483_130 VPWR VGND sg13cmos5l_decap_8
X_0271_ _0271_/Q Tile_X0Y7_FrameData[16] VGND VPWR Tile_X0Y9_FrameStrobe[3] latch
XFILLER_531_28 VPWR VGND sg13cmos5l_decap_8
XFILLER_282_203 VPWR VGND sg13cmos5l_decap_8
XFILLER_617_168 VPWR VGND sg13cmos5l_decap_8
XFILLER_632_105 VPWR VGND sg13cmos5l_decap_8
XFILLER_314_85 VPWR VGND sg13cmos5l_fill_2
X_2010_ _2010_/Q Tile_X0Y4_FrameData[11] VGND VPWR Tile_X0Y9_FrameStrobe[2] latch
XFILLER_94_179 VPWR VGND sg13cmos5l_decap_8
XFILLER_180_70 VPWR VGND sg13cmos5l_decap_8
XFILLER_35_213 VPWR VGND sg13cmos5l_decap_8
XFILLER_235_141 VPWR VGND sg13cmos5l_decap_8
XFILLER_330_40 VPWR VGND sg13cmos5l_fill_1
XFILLER_35_246 VPWR VGND sg13cmos5l_decap_8
XFILLER_687_21 VPWR VGND sg13cmos5l_decap_8
XFILLER_640_182 VPWR VGND sg13cmos5l_decap_8
X_3961_ _3961_/X Tile_X0Y1_WW4END[2] AXI_M_SOC_ARREADY _4010_/X _3993_/X _1287_/Q
+ _1286_/Q VPWR VGND sg13cmos5l_mux4_1
XFILLER_585_237 VPWR VGND sg13cmos5l_decap_8
XFILLER_250_155 VPWR VGND sg13cmos5l_decap_8
X_2912_ Tile_X0Y8_E1BEG[0] _4724_/X VPWR VGND sg13cmos5l_buf_1
XFILLER_396_159 VPWR VGND sg13cmos5l_decap_8
X_3892_ _3892_/X Tile_X0Y2_W2MID[5] Tile_X0Y2_W2END[5] Tile_X0Y2_W6END[5] _4101_/X
+ _1661_/Q _1660_/Q VPWR VGND sg13cmos5l_mux4_1
XFILLER_148_126 VPWR VGND sg13cmos5l_decap_8
X_2843_ Tile_X0Y6_E2BEGb[0] _4504_/X VPWR VGND sg13cmos5l_buf_1
XFILLER_556_14 VPWR VGND sg13cmos5l_decap_8
XANTENNA__3367__X Tile_X0Y2_EE4BEG[6] VPWR VGND sg13cmos5l_antennanp
XFILLER_553_145 VPWR VGND sg13cmos5l_decap_8
X_2774_ Tile_X0Y3_EE4BEG[0] _4164_/X VPWR VGND sg13cmos5l_buf_1
XFILLER_156_170 VPWR VGND sg13cmos5l_decap_8
X_4513_ _4513_/X Tile_X0Y6_WW4END[14] AXI_M_SOC_RDATA25 _4582_/X _4554_/X _2581_/Q
+ _2580_/Q VPWR VGND sg13cmos5l_mux4_1
XFILLER_156_181 VPWR VGND sg13cmos5l_fill_1
X_1725_ _1725_/Q Tile_X0Y3_FrameData[12] VGND VPWR Tile_X0Y9_FrameStrobe[1] latch
XFILLER_706_28 VPWR VGND sg13cmos5l_decap_8
XFILLER_305_112 VPWR VGND sg13cmos5l_decap_8
XFILLER_305_123 VPWR VGND sg13cmos5l_fill_1
XFILLER_171_140 VPWR VGND sg13cmos5l_decap_8
XFILLER_208_42 VPWR VGND sg13cmos5l_decap_8
XFILLER_636_91 VPWR VGND sg13cmos5l_decap_8
X_4444_ _4444_/X _4014_/X _4018_/X _3999_/X _3990_/X _1359_/Q _1358_/Q VPWR VGND sg13cmos5l_mux4_1
X_1656_ _1656_/Q Tile_X0Y2_FrameData[25] VGND VPWR Tile_X0Y9_FrameStrobe[7] latch
XFILLER_360_251 VPWR VGND sg13cmos5l_decap_8
XFILLER_572_35 VPWR VGND sg13cmos5l_decap_8
XFILLER_355_70 VPWR VGND sg13cmos5l_decap_8
X_0607_ _0607_/Q Tile_X0Y8_FrameData[0] VGND VPWR Tile_X0Y9_FrameStrobe[5] latch
XFILLER_320_126 VPWR VGND sg13cmos5l_decap_8
X_4375_ _4375_/X Tile_X0Y5_W2MID[4] AXI_M_SOC_RRESP1 _4434_/X _4433_/X _2353_/Q _2352_/Q
+ VPWR VGND sg13cmos5l_mux4_1
X_1587_ _1587_/Q Tile_X0Y2_FrameData[30] VGND VPWR Tile_X0Y9_FrameStrobe[5] latch
XFILLER_710_186 VPWR VGND sg13cmos5l_decap_8
XFILLER_459_171 VPWR VGND sg13cmos5l_fill_2
XFILLER_291_36 VPWR VGND sg13cmos5l_decap_8
XFILLER_648_271 VPWR VGND sg13cmos5l_fill_2
X_3326_ Tile_X0Y4_EE4BEG[14] _4286_/X VPWR VGND sg13cmos5l_buf_1
XFILLER_258_233 VPWR VGND sg13cmos5l_decap_8
X_0538_ _0538_/Q Tile_X0Y8_FrameData[5] VGND VPWR Tile_X0Y9_FrameStrobe[3] latch
XFILLER_608_124 VPWR VGND sg13cmos5l_decap_8
XFILLER_85_102 VPWR VGND sg13cmos5l_decap_8
XFILLER_505_84 VPWR VGND sg13cmos5l_decap_8
XFILLER_224_63 VPWR VGND sg13cmos5l_decap_8
XFILLER_441_28 VPWR VGND sg13cmos5l_decap_8
X_3257_ Tile_X0Y0_FrameData_O[25] Tile_X0Y0_FrameData[25] VPWR VGND sg13cmos5l_buf_1
XFILLER_663_263 VPWR VGND sg13cmos5l_fill_2
X_0469_ _0469_/Q Tile_X0Y8_FrameData[10] VGND VPWR Tile_X0Y9_FrameStrobe[1] latch
XFILLER_623_105 VPWR VGND sg13cmos5l_decap_8
XFILLER_371_91 VPWR VGND sg13cmos5l_fill_1
XFILLER_474_196 VPWR VGND sg13cmos5l_decap_8
XFILLER_37_39 VPWR VGND sg13cmos5l_decap_8
X_2208_ _2208_/Q Tile_X0Y5_FrameData[5] VGND VPWR Tile_X0Y9_FrameStrobe[0] latch
X_3188_ Tile_X0Y0_N4BEG[12] _3188_/A VPWR VGND sg13cmos5l_buf_1
XFILLER_26_202 VPWR VGND sg13cmos5l_fill_2
X_2139_ _2139_/Q Tile_X0Y4_FrameData[10] VGND VPWR Tile_X0Y9_FrameStrobe[6] latch
XFILLER_597_21 VPWR VGND sg13cmos5l_decap_8
XFILLER_387_115 VPWR VGND sg13cmos5l_decap_8
XFILLER_576_215 VPWR VGND sg13cmos5l_decap_8
XFILLER_387_137 VPWR VGND sg13cmos5l_fill_2
XFILLER_240_84 VPWR VGND sg13cmos5l_decap_8
XFILLER_156_8 VPWR VGND sg13cmos5l_decap_8
XFILLER_179_240 VPWR VGND sg13cmos5l_decap_8
XFILLER_430_266 VPWR VGND sg13cmos5l_decap_8
XFILLER_529_131 VPWR VGND sg13cmos5l_decap_8
XFILLER_169_49 VPWR VGND sg13cmos5l_decap_8
XFILLER_149_7 VPWR VGND sg13cmos5l_decap_8
XFILLER_241_199 VPWR VGND sg13cmos5l_fill_2
XFILLER_139_126 VPWR VGND sg13cmos5l_decap_8
XFILLER_584_270 VPWR VGND sg13cmos5l_fill_2
XFILLER_466_14 VPWR VGND sg13cmos5l_decap_8
XFILLER_323_8 VPWR VGND sg13cmos5l_decap_8
XANTENNA__3277__X Tile_X0Y0_EE4BEG[13] VPWR VGND sg13cmos5l_antennanp
XFILLER_395_192 VPWR VGND sg13cmos5l_decap_8
XFILLER_328_248 VPWR VGND sg13cmos5l_decap_8
XFILLER_194_254 VPWR VGND sg13cmos5l_decap_8
XFILLER_544_156 VPWR VGND sg13cmos5l_decap_8
XFILLER_316_7 VPWR VGND sg13cmos5l_decap_8
XFILLER_5_128 VPWR VGND sg13cmos5l_decap_8
XFILLER_185_59 VPWR VGND sg13cmos5l_decap_8
XFILLER_616_28 VPWR VGND sg13cmos5l_decap_8
XFILLER_118_42 VPWR VGND sg13cmos5l_decap_8
XFILLER_546_91 VPWR VGND sg13cmos5l_decap_8
XFILLER_482_35 VPWR VGND sg13cmos5l_decap_8
XFILLER_265_70 VPWR VGND sg13cmos5l_decap_8
XFILLER_162_173 VPWR VGND sg13cmos5l_decap_8
XFILLER_311_104 VPWR VGND sg13cmos5l_decap_8
XFILLER_701_164 VPWR VGND sg13cmos5l_decap_8
XFILLER_685_7 VPWR VGND sg13cmos5l_decap_8
XFILLER_632_49 VPWR VGND sg13cmos5l_decap_8
XFILLER_465_130 VPWR VGND sg13cmos5l_decap_8
XFILLER_415_84 VPWR VGND sg13cmos5l_fill_2
XFILLER_654_241 VPWR VGND sg13cmos5l_decap_8
XFILLER_465_141 VPWR VGND sg13cmos5l_fill_1
XFILLER_351_28 VPWR VGND sg13cmos5l_decap_8
XFILLER_134_63 VPWR VGND sg13cmos5l_decap_8
XANTENNA__3740__X AXI_M_SOC_ARADDR12 VPWR VGND sg13cmos5l_antennanp
XFILLER_614_105 VPWR VGND sg13cmos5l_decap_4
XFILLER_281_91 VPWR VGND sg13cmos5l_decap_8
XFILLER_76_179 VPWR VGND sg13cmos5l_fill_1
XFILLER_480_133 VPWR VGND sg13cmos5l_fill_1
XFILLER_94_67 VPWR VGND sg13cmos5l_decap_8
XFILLER_264_269 VPWR VGND sg13cmos5l_decap_4
XFILLER_175_0 VPWR VGND sg13cmos5l_decap_8
XFILLER_480_155 VPWR VGND sg13cmos5l_decap_8
XFILLER_91_138 VPWR VGND sg13cmos5l_decap_8
XFILLER_406_263 VPWR VGND sg13cmos5l_decap_8
XFILLER_27_72 VPWR VGND sg13cmos5l_fill_2
XFILLER_378_115 VPWR VGND sg13cmos5l_decap_8
XFILLER_232_133 VPWR VGND sg13cmos5l_decap_8
XFILLER_150_95 VPWR VGND sg13cmos5l_decap_8
XFILLER_378_137 VPWR VGND sg13cmos5l_decap_8
XFILLER_300_21 VPWR VGND sg13cmos5l_decap_8
XFILLER_342_0 VPWR VGND sg13cmos5l_decap_8
XFILLER_567_248 VPWR VGND sg13cmos5l_fill_2
XFILLER_657_35 VPWR VGND sg13cmos5l_decap_8
XFILLER_582_218 VPWR VGND sg13cmos5l_decap_8
XFILLER_43_82 VPWR VGND sg13cmos5l_decap_4
XANTENNA__3187__X Tile_X0Y0_N4BEG[11] VPWR VGND sg13cmos5l_antennanp
XFILLER_159_60 VPWR VGND sg13cmos5l_decap_8
XFILLER_376_36 VPWR VGND sg13cmos5l_fill_2
XFILLER_607_0 VPWR VGND sg13cmos5l_decap_8
XFILLER_334_218 VPWR VGND sg13cmos5l_decap_8
XFILLER_550_115 VPWR VGND sg13cmos5l_decap_8
XFILLER_535_189 VPWR VGND sg13cmos5l_decap_8
XFILLER_64_7 VPWR VGND sg13cmos5l_decap_8
XFILLER_526_28 VPWR VGND sg13cmos5l_decap_8
XFILLER_309_74 VPWR VGND sg13cmos5l_fill_2
X_1510_ _1510_/Q Tile_X0Y2_FrameData[11] VGND VPWR Tile_X0Y9_FrameStrobe[2] latch
XFILLER_488_222 VPWR VGND sg13cmos5l_decap_4
XFILLER_99_205 VPWR VGND sg13cmos5l_decap_8
X_2490_ _2490_/Q Tile_X0Y6_FrameData[13] VGND VPWR Tile_X0Y9_FrameStrobe[1] latch
XFILLER_392_35 VPWR VGND sg13cmos5l_decap_8
XFILLER_175_70 VPWR VGND sg13cmos5l_fill_2
XFILLER_299_166 VPWR VGND sg13cmos5l_fill_1
XFILLER_606_72 VPWR VGND sg13cmos5l_fill_2
XFILLER_4_21 VPWR VGND sg13cmos5l_decap_8
X_1441_ _1441_/Q Tile_X0Y2_FrameData[16] VGND VPWR Tile_X0Y9_FrameStrobe[0] latch
XFILLER_302_126 VPWR VGND sg13cmos5l_decap_8
XFILLER_448_119 VPWR VGND sg13cmos5l_decap_8
X_4160_ _4160_/X Tile_X0Y3_W2END[3] AXI_M_SOC_BVALID _4211_/X _4210_/X _1821_/Q _1820_/Q
+ VPWR VGND sg13cmos5l_mux4_1
X_1372_ _1372_/Q Tile_X0Y1_FrameData[29] VGND VPWR Tile_X0Y9_FrameStrobe[6] latch
XFILLER_542_49 VPWR VGND sg13cmos5l_decap_8
XFILLER_4_98 VPWR VGND sg13cmos5l_decap_8
XFILLER_472_90 VPWR VGND sg13cmos5l_decap_8
X_3111_ Tile_X0Y7_E6BEG[9] _4653_/X VPWR VGND sg13cmos5l_buf_1
XFILLER_456_152 VPWR VGND sg13cmos5l_decap_8
X_0323_ _0323_/Q Tile_X0Y7_FrameData[28] VGND VPWR Tile_X0Y9_FrameStrobe[5] latch
XFILLER_645_252 VPWR VGND sg13cmos5l_decap_8
XFILLER_261_28 VPWR VGND sg13cmos5l_decap_8
X_4091_ _4091_/X Tile_X0Y3_W1END[1] Tile_X0Y3_W6END[5] _4235_/X _4201_/X _1923_/Q
+ _1922_/Q VPWR VGND sg13cmos5l_mux4_1
XANTENNA__3650__X AXI_M_SOC_AWADDR11 VPWR VGND sg13cmos5l_antennanp
XFILLER_67_168 VPWR VGND sg13cmos5l_decap_8
X_3042_ Tile_X0Y5_FrameData_O[1] Tile_X0Y5_FrameData[1] VPWR VGND sg13cmos5l_buf_1
XFILLER_660_222 VPWR VGND sg13cmos5l_decap_8
X_0254_ _0254_/Q Tile_X0Y7_FrameData[1] VGND VPWR Tile_X0Y9_FrameStrobe[2] latch
XFILLER_605_138 VPWR VGND sg13cmos5l_decap_8
XFILLER_660_255 VPWR VGND sg13cmos5l_decap_8
XFILLER_82_138 VPWR VGND sg13cmos5l_decap_8
XFILLER_471_166 VPWR VGND sg13cmos5l_decap_8
XFILLER_698_42 VPWR VGND sg13cmos5l_decap_8
X_0185_ _0185_/Q Tile_X0Y7_FrameData[6] VGND VPWR Tile_X0Y9_FrameStrobe[0] latch
XFILLER_223_111 VPWR VGND sg13cmos5l_fill_2
XFILLER_208_196 VPWR VGND sg13cmos5l_decap_8
XFILLER_23_205 VPWR VGND sg13cmos5l_fill_2
XFILLER_613_193 VPWR VGND sg13cmos5l_decap_8
XFILLER_412_233 VPWR VGND sg13cmos5l_fill_2
XFILLER_223_155 VPWR VGND sg13cmos5l_decap_8
XFILLER_210_21 VPWR VGND sg13cmos5l_decap_8
XFILLER_369_159 VPWR VGND sg13cmos5l_decap_8
X_3944_ _3944_/X Tile_X0Y1_W2END[3] AXI_M_SOC_ARREADY _3995_/X _3994_/X _1321_/Q _1320_/Q
+ VPWR VGND sg13cmos5l_mux4_1
XFILLER_90_0 VPWR VGND sg13cmos5l_decap_8
XFILLER_567_35 VPWR VGND sg13cmos5l_decap_8
XFILLER_210_98 VPWR VGND sg13cmos5l_decap_8
XFILLER_286_14 VPWR VGND sg13cmos5l_decap_8
X_3875_ _3875_/X _3848_/X _0067_/X Tile_X0Y0_S1END[0] Tile_X0Y0_S4END[0] _0971_/Q
+ _0970_/Q VPWR VGND sg13cmos5l_mux4_1
XANTENNA__3097__X Tile_X0Y7_E2BEGb[3] VPWR VGND sg13cmos5l_antennanp
XFILLER_526_123 VPWR VGND sg13cmos5l_decap_4
XFILLER_526_134 VPWR VGND sg13cmos5l_decap_8
XFILLER_715_245 VPWR VGND sg13cmos5l_decap_8
X_2826_ Tile_X0Y4_E2BEG[4] _4260_/X VPWR VGND sg13cmos5l_buf_1
XFILLER_392_151 VPWR VGND sg13cmos5l_decap_8
XFILLER_191_213 VPWR VGND sg13cmos5l_decap_8
XFILLER_436_28 VPWR VGND sg13cmos5l_decap_8
XFILLER_129_192 VPWR VGND sg13cmos5l_decap_4
XFILLER_219_63 VPWR VGND sg13cmos5l_decap_8
X_2757_ Tile_X0Y3_FrameData_O[15] Tile_X0Y3_FrameData[15] VPWR VGND sg13cmos5l_buf_1
XFILLER_583_56 VPWR VGND sg13cmos5l_decap_8
X_1708_ _1708_/Q Tile_X0Y3_FrameData[29] VGND VPWR Tile_X0Y9_FrameStrobe[1] latch
XFILLER_333_251 VPWR VGND sg13cmos5l_decap_8
X_2688_ _2688_/Q Tile_X0Y6_FrameData[7] VGND VPWR Tile_X0Y9_FrameStrobe[7] latch
XFILLER_479_244 VPWR VGND sg13cmos5l_decap_8
X_4427_ _4427_/X Tile_X0Y6_W1END[3] Tile_X0Y6_W6END[7] _4583_/X _4543_/X _2689_/Q
+ _2688_/Q VPWR VGND sg13cmos5l_mux4_1
XFILLER_695_152 VPWR VGND sg13cmos5l_decap_8
X_1639_ _1639_/Q Tile_X0Y2_FrameData[10] VGND VPWR Tile_X0Y9_FrameStrobe[6] latch
X_4358_ _4358_/X Tile_X0Y3_W2MID[4] Tile_X0Y3_W2END[4] Tile_X0Y3_W6END[11] _4211_/X
+ _1875_/Q _1874_/Q VPWR VGND sg13cmos5l_mux4_1
XFILLER_48_27 VPWR VGND sg13cmos5l_decap_8
XFILLER_452_49 VPWR VGND sg13cmos5l_decap_8
XFILLER_58_102 VPWR VGND sg13cmos5l_decap_8
XFILLER_171_28 VPWR VGND sg13cmos5l_decap_8
X_3309_ Tile_X0Y0_E1BEG[1] _3801_/X VPWR VGND sg13cmos5l_buf_1
XANTENNA__3560__X Tile_X0Y9_EE4BEG[6] VPWR VGND sg13cmos5l_antennanp
X_4289_ _4289_/X _0158_/X _0111_/X _4346_/X _4350_/X _2035_/Q _2034_/Q VPWR VGND sg13cmos5l_mux4_1
XFILLER_462_100 VPWR VGND sg13cmos5l_decap_8
XFILLER_532_71 VPWR VGND sg13cmos5l_fill_1
XFILLER_246_236 VPWR VGND sg13cmos5l_decap_8
XFILLER_58_179 VPWR VGND sg13cmos5l_decap_8
XFILLER_104_44 VPWR VGND sg13cmos5l_fill_1
XFILLER_462_155 VPWR VGND sg13cmos5l_decap_4
XFILLER_403_200 VPWR VGND sg13cmos5l_decap_8
XFILLER_266_7 VPWR VGND sg13cmos5l_decap_8
XFILLER_261_239 VPWR VGND sg13cmos5l_decap_8
XFILLER_104_99 VPWR VGND sg13cmos5l_decap_8
XFILLER_14_205 VPWR VGND sg13cmos5l_decap_8
XFILLER_401_64 VPWR VGND sg13cmos5l_decap_8
XFILLER_120_21 VPWR VGND sg13cmos5l_decap_8
XFILLER_401_86 VPWR VGND sg13cmos5l_decap_8
XANTENNA__2904__X Tile_X0Y6_FrameData_O[25] VPWR VGND sg13cmos5l_antennanp
XFILLER_433_7 VPWR VGND sg13cmos5l_decap_8
XFILLER_80_14 VPWR VGND sg13cmos5l_decap_8
XFILLER_477_35 VPWR VGND sg13cmos5l_decap_8
XFILLER_196_14 VPWR VGND sg13cmos5l_decap_8
XFILLER_706_212 VPWR VGND sg13cmos5l_decap_8
XFILLER_600_7 VPWR VGND sg13cmos5l_decap_8
XFILLER_383_140 VPWR VGND sg13cmos5l_decap_8
XFILLER_517_156 VPWR VGND sg13cmos5l_decap_8
XFILLER_13_63 VPWR VGND sg13cmos5l_fill_2
XFILLER_627_49 VPWR VGND sg13cmos5l_decap_8
XFILLER_316_218 VPWR VGND sg13cmos5l_fill_1
XFILLER_182_224 VPWR VGND sg13cmos5l_decap_8
XFILLER_532_115 VPWR VGND sg13cmos5l_decap_4
XFILLER_129_63 VPWR VGND sg13cmos5l_decap_8
XFILLER_346_28 VPWR VGND sg13cmos5l_decap_8
XFILLER_532_137 VPWR VGND sg13cmos5l_fill_1
XANTENNA__3735__X AXI_M_SOC_ARADDR7 VPWR VGND sg13cmos5l_antennanp
XFILLER_493_56 VPWR VGND sg13cmos5l_decap_8
XFILLER_182_268 VPWR VGND sg13cmos5l_decap_4
XFILLER_276_91 VPWR VGND sg13cmos5l_decap_8
XFILLER_89_56 VPWR VGND sg13cmos5l_decap_8
XFILLER_135_173 VPWR VGND sg13cmos5l_fill_2
XFILLER_485_203 VPWR VGND sg13cmos5l_fill_1
XFILLER_485_225 VPWR VGND sg13cmos5l_decap_8
XFILLER_150_154 VPWR VGND sg13cmos5l_decap_8
XFILLER_296_136 VPWR VGND sg13cmos5l_decap_8
XFILLER_89_260 VPWR VGND sg13cmos5l_decap_8
XFILLER_89_271 VPWR VGND sg13cmos5l_fill_2
XFILLER_438_130 VPWR VGND sg13cmos5l_decap_8
XFILLER_362_49 VPWR VGND sg13cmos5l_decap_8
XFILLER_1_186 VPWR VGND sg13cmos5l_fill_2
XFILLER_292_0 VPWR VGND sg13cmos5l_decap_8
XFILLER_1_197 VPWR VGND sg13cmos5l_fill_2
XANTENNA__3470__X Tile_X0Y1_FrameData_O[28] VPWR VGND sg13cmos5l_antennanp
XFILLER_49_168 VPWR VGND sg13cmos5l_decap_8
XFILLER_64_105 VPWR VGND sg13cmos5l_decap_8
XFILLER_557_0 VPWR VGND sg13cmos5l_decap_8
XFILLER_453_166 VPWR VGND sg13cmos5l_fill_1
XFILLER_602_108 VPWR VGND sg13cmos5l_fill_2
XFILLER_57_190 VPWR VGND sg13cmos5l_decap_8
XFILLER_453_188 VPWR VGND sg13cmos5l_fill_1
XFILLER_205_155 VPWR VGND sg13cmos5l_decap_8
XFILLER_72_171 VPWR VGND sg13cmos5l_decap_8
XFILLER_668_56 VPWR VGND sg13cmos5l_decap_8
XFILLER_311_86 VPWR VGND sg13cmos5l_decap_4
XANTENNA__2814__X Tile_X0Y3_E2BEG[4] VPWR VGND sg13cmos5l_antennanp
XFILLER_610_152 VPWR VGND sg13cmos5l_decap_8
XFILLER_311_97 VPWR VGND sg13cmos5l_decap_8
XFILLER_260_272 VPWR VGND sg13cmos5l_fill_1
X_1990_ _1990_/Q Tile_X0Y4_FrameData[31] VGND VPWR Tile_X0Y9_FrameStrobe[2] latch
XFILLER_387_35 VPWR VGND sg13cmos5l_fill_2
XFILLER_366_118 VPWR VGND sg13cmos5l_decap_8
XFILLER_555_229 VPWR VGND sg13cmos5l_decap_8
X_0941_ _0941_/Q Tile_X0Y0_FrameData[30] VGND VPWR Tile_X0Y9_FrameStrobe[0] latch
XFILLER_13_271 VPWR VGND sg13cmos5l_fill_2
XFILLER_508_112 VPWR VGND sg13cmos5l_decap_8
XFILLER_9_242 VPWR VGND sg13cmos5l_decap_8
X_3660_ AXI_M_SOC_AWADDR21 Tile_X0Y4_WW4END[5] Tile_X0Y4_WW4END[13] Tile_X0Y4_W6END[5]
+ _4341_/X _2003_/Q _2002_/Q VPWR VGND sg13cmos5l_mux4_1
X_0872_ _0872_/Q Tile_X0Y9_FrameData[23] VGND VPWR Tile_X0Y9_FrameStrobe[6] latch
XFILLER_563_251 VPWR VGND sg13cmos5l_decap_4
XFILLER_537_49 VPWR VGND sg13cmos5l_decap_8
X_2611_ _2611_/Q Tile_X0Y6_FrameData[20] VGND VPWR Tile_X0Y9_FrameStrobe[5] latch
XFILLER_256_28 VPWR VGND sg13cmos5l_decap_8
X_3591_ Tile_X0Y9_FrameData_O[21] Tile_X0Y9_FrameData[21] VPWR VGND sg13cmos5l_buf_1
XANTENNA__3645__X AXI_M_SOC_AWADDR6 VPWR VGND sg13cmos5l_antennanp
XFILLER_523_148 VPWR VGND sg13cmos5l_decap_8
XFILLER_126_140 VPWR VGND sg13cmos5l_decap_8
X_2542_ _2542_/Q Tile_X0Y6_FrameData[25] VGND VPWR Tile_X0Y9_FrameStrobe[3] latch
XFILLER_315_251 VPWR VGND sg13cmos5l_decap_8
XFILLER_336_61 VPWR VGND sg13cmos5l_decap_8
XFILLER_677_152 VPWR VGND sg13cmos5l_decap_4
X_2473_ _2473_/Q Tile_X0Y6_FrameData[30] VGND VPWR Tile_X0Y9_FrameStrobe[1] latch
XFILLER_87_208 VPWR VGND sg13cmos5l_decap_8
X_4212_ _4212_/X _4203_/X _0046_/X _4202_/X Tile_X0Y0_S4END[15] _1699_/Q _1698_/Q
+ VPWR VGND sg13cmos5l_mux4_1
XFILLER_287_147 VPWR VGND sg13cmos5l_decap_8
XFILLER_141_165 VPWR VGND sg13cmos5l_decap_8
X_1424_ _1424_/Q Tile_X0Y1_FrameData[9] VGND VPWR Tile_X0Y9_FrameStrobe[7] latch
XFILLER_692_122 VPWR VGND sg13cmos5l_decap_8
XFILLER_476_247 VPWR VGND sg13cmos5l_fill_1
XFILLER_272_49 VPWR VGND sg13cmos5l_decap_8
XFILLER_633_70 VPWR VGND sg13cmos5l_decap_8
XFILLER_618_230 VPWR VGND sg13cmos5l_decap_8
XFILLER_205_21 VPWR VGND sg13cmos5l_decap_8
XFILLER_228_203 VPWR VGND sg13cmos5l_decap_8
X_4143_ _4143_/X Tile_X0Y4_W2MID[0] Tile_X0Y4_W2END[0] Tile_X0Y4_W6END[0] _4312_/X
+ _2159_/Q _2158_/Q VPWR VGND sg13cmos5l_mux4_1
XFILLER_618_252 VPWR VGND sg13cmos5l_decap_8
X_1355_ _1355_/Q Tile_X0Y1_FrameData[14] VGND VPWR Tile_X0Y9_FrameStrobe[5] latch
XANTENNA__3380__X Tile_X0Y2_E6BEG[3] VPWR VGND sg13cmos5l_antennanp
XFILLER_692_199 VPWR VGND sg13cmos5l_decap_4
XFILLER_429_196 VPWR VGND sg13cmos5l_decap_8
X_0306_ _0306_/Q Tile_X0Y7_FrameData[13] VGND VPWR Tile_X0Y9_FrameStrobe[4] latch
XFILLER_444_133 VPWR VGND sg13cmos5l_fill_1
XFILLER_205_98 VPWR VGND sg13cmos5l_decap_8
X_4074_ _4074_/X _0057_/X Tile_X0Y0_S4END[10] _4125_/X _4110_/X _1525_/Q _1524_/Q
+ VPWR VGND sg13cmos5l_mux4_1
XFILLER_633_233 VPWR VGND sg13cmos5l_decap_4
X_1286_ _1286_/Q Tile_X0Y1_FrameData[19] VGND VPWR Tile_X0Y9_FrameStrobe[3] latch
XFILLER_444_155 VPWR VGND sg13cmos5l_decap_8
X_3025_ Tile_X0Y5_EE4BEG[0] _4388_/X VPWR VGND sg13cmos5l_buf_1
X_0237_ _0237_/Q Tile_X0Y7_FrameData[18] VGND VPWR Tile_X0Y9_FrameStrobe[2] latch
XFILLER_502_63 VPWR VGND sg13cmos5l_decap_8
XFILLER_221_42 VPWR VGND sg13cmos5l_decap_4
XFILLER_63_160 VPWR VGND sg13cmos5l_decap_8
X_0168_ _0168_/Q Tile_X0Y7_FrameData[23] VGND VPWR Tile_X0Y9_FrameStrobe[0] latch
XFILLER_598_192 VPWR VGND sg13cmos5l_decap_8
XFILLER_578_56 VPWR VGND sg13cmos5l_decap_8
XFILLER_251_272 VPWR VGND sg13cmos5l_fill_1
XFILLER_400_203 VPWR VGND sg13cmos5l_decap_4
XFILLER_601_174 VPWR VGND sg13cmos5l_decap_8
X_0099_ _0099_/X _4322_/X _4323_/X _0645_/Q VPWR VGND sg13cmos5l_mux2_1
XFILLER_546_207 VPWR VGND sg13cmos5l_decap_8
XFILLER_211_147 VPWR VGND sg13cmos5l_decap_8
XFILLER_601_196 VPWR VGND sg13cmos5l_fill_2
XFILLER_297_57 VPWR VGND sg13cmos5l_decap_8
XFILLER_539_270 VPWR VGND sg13cmos5l_fill_2
X_3927_ _3927_/X _4226_/X _4230_/X _4234_/X _4205_/X _1901_/Q _1900_/Q VPWR VGND sg13cmos5l_mux4_1
X_3858_ _3858_/X _3897_/X _3896_/X Tile_X0Y0_S2MID[4] Tile_X0Y0_S2END[4] _0955_/Q
+ _0954_/Q VPWR VGND sg13cmos5l_mux4_1
XFILLER_50_28 VPWR VGND sg13cmos5l_decap_8
XFILLER_164_213 VPWR VGND sg13cmos5l_decap_8
XFILLER_447_49 VPWR VGND sg13cmos5l_decap_8
XFILLER_109_129 VPWR VGND sg13cmos5l_decap_8
XFILLER_166_28 VPWR VGND sg13cmos5l_decap_8
X_2809_ Tile_X0Y3_E2BEGb[7] _4163_/X VPWR VGND sg13cmos5l_buf_1
XFILLER_594_77 VPWR VGND sg13cmos5l_fill_2
XFILLER_166_39 VPWR VGND sg13cmos5l_fill_2
XFILLER_164_257 VPWR VGND sg13cmos5l_decap_8
X_3789_ _3789_/X Tile_X0Y0_W2MID[2] Tile_X0Y0_W2END[2] Tile_X0Y0_W6END[2] _3856_/X
+ _1159_/Q _1158_/Q VPWR VGND sg13cmos5l_mux4_1
XANTENNA__3555__X Tile_X0Y9_EE4BEG[1] VPWR VGND sg13cmos5l_antennanp
XFILLER_164_268 VPWR VGND sg13cmos5l_decap_4
XFILLER_527_71 VPWR VGND sg13cmos5l_decap_4
XFILLER_380_154 VPWR VGND sg13cmos5l_decap_8
XFILLER_117_151 VPWR VGND sg13cmos5l_decap_8
XFILLER_321_221 VPWR VGND sg13cmos5l_decap_8
XFILLER_683_122 VPWR VGND sg13cmos5l_decap_8
XFILLER_321_265 VPWR VGND sg13cmos5l_decap_8
XFILLER_132_187 VPWR VGND sg13cmos5l_decap_8
XFILLER_115_21 VPWR VGND sg13cmos5l_decap_8
XFILLER_543_92 VPWR VGND sg13cmos5l_decap_8
XFILLER_383_7 VPWR VGND sg13cmos5l_decap_8
XANTENNA__3290__X Tile_X0Y0_E6BEG[10] VPWR VGND sg13cmos5l_antennanp
XFILLER_75_14 VPWR VGND sg13cmos5l_decap_8
XFILLER_683_199 VPWR VGND sg13cmos5l_decap_8
XFILLER_624_222 VPWR VGND sg13cmos5l_decap_8
XFILLER_435_133 VPWR VGND sg13cmos5l_decap_8
XFILLER_46_127 VPWR VGND sg13cmos5l_decap_4
XFILLER_550_7 VPWR VGND sg13cmos5l_decap_8
XFILLER_39_190 VPWR VGND sg13cmos5l_decap_4
XFILLER_234_228 VPWR VGND sg13cmos5l_fill_1
XFILLER_648_7 VPWR VGND sg13cmos5l_decap_8
XFILLER_61_119 VPWR VGND sg13cmos5l_decap_8
XFILLER_199_121 VPWR VGND sg13cmos5l_decap_8
XANTENNA__0138__Y AXI_M_SOC_AWLEN0 VPWR VGND sg13cmos5l_antennanp
XFILLER_131_64 VPWR VGND sg13cmos5l_decap_8
XFILLER_589_181 VPWR VGND sg13cmos5l_decap_4
XFILLER_91_35 VPWR VGND sg13cmos5l_decap_8
XFILLER_242_261 VPWR VGND sg13cmos5l_decap_8
XFILLER_54_193 VPWR VGND sg13cmos5l_fill_2
XFILLER_488_56 VPWR VGND sg13cmos5l_decap_8
XFILLER_242_272 VPWR VGND sg13cmos5l_fill_1
XFILLER_91_68 VPWR VGND sg13cmos5l_decap_8
XFILLER_199_198 VPWR VGND sg13cmos5l_fill_1
XFILLER_537_218 VPWR VGND sg13cmos5l_decap_8
XFILLER_138_0 VPWR VGND sg13cmos5l_decap_8
XFILLER_356_140 VPWR VGND sg13cmos5l_decap_8
XFILLER_357_49 VPWR VGND sg13cmos5l_decap_8
XFILLER_155_235 VPWR VGND sg13cmos5l_fill_1
XFILLER_560_210 VPWR VGND sg13cmos5l_fill_2
XFILLER_505_115 VPWR VGND sg13cmos5l_decap_8
XFILLER_654_14 VPWR VGND sg13cmos5l_decap_8
XFILLER_155_257 VPWR VGND sg13cmos5l_decap_8
XANTENNA__3465__X Tile_X0Y1_FrameData_O[23] VPWR VGND sg13cmos5l_antennanp
XFILLER_305_0 VPWR VGND sg13cmos5l_decap_8
XFILLER_108_140 VPWR VGND sg13cmos5l_decap_8
XFILLER_155_268 VPWR VGND sg13cmos5l_decap_4
XFILLER_560_254 VPWR VGND sg13cmos5l_fill_2
XFILLER_654_69 VPWR VGND sg13cmos5l_decap_8
XFILLER_312_210 VPWR VGND sg13cmos5l_decap_8
XFILLER_123_154 VPWR VGND sg13cmos5l_decap_8
XFILLER_674_133 VPWR VGND sg13cmos5l_fill_2
XFILLER_306_53 VPWR VGND sg13cmos5l_fill_2
XFILLER_670_35 VPWR VGND sg13cmos5l_decap_8
XFILLER_458_269 VPWR VGND sg13cmos5l_decap_4
XFILLER_674_0 VPWR VGND sg13cmos5l_decap_8
XFILLER_27_7 VPWR VGND sg13cmos5l_decap_8
XANTENNA__2809__X Tile_X0Y3_E2BEGb[7] VPWR VGND sg13cmos5l_antennanp
XFILLER_49_81 VPWR VGND sg13cmos5l_decap_4
XFILLER_92_200 VPWR VGND sg13cmos5l_decap_8
X_1140_ _1140_/Q Tile_X0Y0_FrameData[23] VGND VPWR Tile_X0Y9_FrameStrobe[6] latch
XFILLER_426_133 VPWR VGND sg13cmos5l_decap_8
XFILLER_292_150 VPWR VGND sg13cmos5l_decap_8
XFILLER_441_103 VPWR VGND sg13cmos5l_decap_8
XFILLER_37_149 VPWR VGND sg13cmos5l_fill_2
X_1071_ _1071_/Q Tile_X0Y0_FrameData[28] VGND VPWR Tile_X0Y9_FrameStrobe[4] latch
XFILLER_630_236 VPWR VGND sg13cmos5l_fill_1
XFILLER_679_77 VPWR VGND sg13cmos5l_decap_8
XFILLER_65_91 VPWR VGND sg13cmos5l_decap_8
XFILLER_630_258 VPWR VGND sg13cmos5l_decap_8
XFILLER_379_232 VPWR VGND sg13cmos5l_decap_4
XFILLER_240_209 VPWR VGND sg13cmos5l_fill_2
XFILLER_45_193 VPWR VGND sg13cmos5l_decap_8
XFILLER_398_56 VPWR VGND sg13cmos5l_decap_8
XFILLER_233_261 VPWR VGND sg13cmos5l_fill_1
XFILLER_595_140 VPWR VGND sg13cmos5l_decap_4
XFILLER_233_272 VPWR VGND sg13cmos5l_fill_1
XANTENNA_170 Tile_X0Y9_FrameStrobe[8] VPWR VGND sg13cmos5l_antennanp
X_4830_ _4830_/X Tile_X0Y9_W2MID[5] Tile_X0Y9_W2END[5] Tile_X0Y9_W6END[10] _4905_/X
+ _0879_/Q _0878_/Q VPWR VGND sg13cmos5l_mux4_1
XFILLER_595_151 VPWR VGND sg13cmos5l_decap_8
XANTENNA_181 Tile_X0Y9_FrameStrobe[8] VPWR VGND sg13cmos5l_antennanp
XFILLER_695_21 VPWR VGND sg13cmos5l_decap_8
XANTENNA_192 Tile_X0Y9_N2MID[1] VPWR VGND sg13cmos5l_antennanp
XFILLER_60_174 VPWR VGND sg13cmos5l_decap_8
X_4761_ _4761_/X Tile_X0Y9_N4END[5] _0076_/X _4810_/X _4814_/X _0525_/Q _0524_/Q VPWR
+ VGND sg13cmos5l_mux4_1
X_1973_ _1973_/Q Tile_X0Y4_FrameData[16] VGND VPWR Tile_X0Y9_FrameStrobe[1] latch
XFILLER_394_268 VPWR VGND sg13cmos5l_decap_4
X_3712_ AXI_M_SOC_WDATA22 Tile_X0Y6_WW4END[6] Tile_X0Y6_WW4END[14] Tile_X0Y6_W6END[6]
+ _4574_/X _2515_/Q _2514_/Q VPWR VGND sg13cmos5l_mux4_1
XFILLER_536_240 VPWR VGND sg13cmos5l_decap_8
XFILLER_347_140 VPWR VGND sg13cmos5l_decap_4
X_0924_ _0924_/Q Tile_X0Y9_FrameData[3] VGND VPWR Tile_X0Y9_FrameStrobe[7] latch
X_4692_ _4692_/X _4661_/X Tile_X0Y9_N4END[8] _4660_/X _0056_/X _0199_/Q _0198_/Q VPWR
+ VGND sg13cmos5l_mux4_1
XFILLER_695_98 VPWR VGND sg13cmos5l_decap_8
XFILLER_267_49 VPWR VGND sg13cmos5l_decap_8
XFILLER_347_173 VPWR VGND sg13cmos5l_decap_8
X_3643_ AXI_M_SOC_AWADDR4 Tile_X0Y5_WW4END[4] Tile_X0Y5_WW4END[12] Tile_X0Y5_W6END[4]
+ _4455_/X _2263_/Q _2262_/Q VPWR VGND sg13cmos5l_mux4_1
X_0855_ _0855_/Q Tile_X0Y9_FrameData[8] VGND VPWR Tile_X0Y9_FrameStrobe[5] latch
XFILLER_564_14 VPWR VGND sg13cmos5l_decap_8
XFILLER_362_132 VPWR VGND sg13cmos5l_fill_2
XANTENNA__3375__X Tile_X0Y2_EE4BEG[14] VPWR VGND sg13cmos5l_antennanp
XFILLER_551_232 VPWR VGND sg13cmos5l_fill_1
XFILLER_697_225 VPWR VGND sg13cmos5l_decap_8
XFILLER_362_143 VPWR VGND sg13cmos5l_fill_1
XFILLER_161_216 VPWR VGND sg13cmos5l_decap_8
X_3574_ Tile_X0Y9_FrameData_O[4] Tile_X0Y9_FrameData[4] VPWR VGND sg13cmos5l_buf_1
XFILLER_362_176 VPWR VGND sg13cmos5l_fill_2
X_0786_ _0786_/Q Tile_X0Y9_FrameData[13] VGND VPWR Tile_X0Y9_FrameStrobe[3] latch
X_2525_ _2525_/Q Tile_X0Y6_FrameData[10] VGND VPWR Tile_X0Y9_FrameStrobe[2] latch
XFILLER_714_28 VPWR VGND sg13cmos5l_decap_8
XFILLER_216_42 VPWR VGND sg13cmos5l_decap_8
XFILLER_644_91 VPWR VGND sg13cmos5l_decap_8
XFILLER_449_247 VPWR VGND sg13cmos5l_decap_8
X_2456_ _2456_/Q Tile_X0Y6_FrameData[15] VGND VPWR Tile_X0Y9_FrameStrobe[0] latch
XFILLER_665_144 VPWR VGND sg13cmos5l_decap_8
XFILLER_580_35 VPWR VGND sg13cmos5l_decap_8
XFILLER_449_269 VPWR VGND sg13cmos5l_decap_4
XFILLER_114_198 VPWR VGND sg13cmos5l_decap_8
XFILLER_464_206 VPWR VGND sg13cmos5l_fill_1
X_1407_ _1407_/Q Tile_X0Y1_FrameData[26] VGND VPWR Tile_X0Y9_FrameStrobe[7] latch
X_2387_ _2387_/Q Tile_X0Y5_FrameData[18] VGND VPWR Tile_X0Y9_FrameStrobe[6] latch
XFILLER_68_252 VPWR VGND sg13cmos5l_decap_8
XFILLER_68_263 VPWR VGND sg13cmos5l_fill_2
X_4126_ _4126_/X _4093_/X _0057_/X _4092_/X Tile_X0Y0_S4END[10] _1461_/Q _1460_/Q
+ VPWR VGND sg13cmos5l_mux4_1
X_1338_ _1338_/Q Tile_X0Y1_FrameData[31] VGND VPWR Tile_X0Y9_FrameStrobe[5] latch
XFILLER_513_84 VPWR VGND sg13cmos5l_decap_8
XFILLER_28_138 VPWR VGND sg13cmos5l_decap_8
XFILLER_283_161 VPWR VGND sg13cmos5l_decap_8
XFILLER_83_244 VPWR VGND sg13cmos5l_decap_8
X_4057_ _4057_/X Tile_X0Y2_WW4END[14] AXI_M_SOC_AWREADY _4107_/X _4098_/X _1559_/Q
+ _1558_/Q VPWR VGND sg13cmos5l_mux4_1
X_1269_ _1269_/Q Tile_X0Y1_FrameData[4] VGND VPWR Tile_X0Y9_FrameStrobe[2] latch
X_3008_ Tile_X0Y5_E2BEGb[3] _4383_/X VPWR VGND sg13cmos5l_buf_1
XFILLER_432_147 VPWR VGND sg13cmos5l_decap_8
XFILLER_589_77 VPWR VGND sg13cmos5l_fill_2
XFILLER_586_162 VPWR VGND sg13cmos5l_decap_8
XFILLER_51_163 VPWR VGND sg13cmos5l_decap_8
XFILLER_196_135 VPWR VGND sg13cmos5l_decap_8
XFILLER_586_184 VPWR VGND sg13cmos5l_fill_2
XFILLER_385_246 VPWR VGND sg13cmos5l_decap_8
XFILLER_61_49 VPWR VGND sg13cmos5l_decap_8
XFILLER_385_268 VPWR VGND sg13cmos5l_decap_4
XFILLER_229_7 VPWR VGND sg13cmos5l_decap_8
XFILLER_474_14 VPWR VGND sg13cmos5l_decap_8
XFILLER_403_8 VPWR VGND sg13cmos5l_decap_8
XFILLER_257_60 VPWR VGND sg13cmos5l_decap_8
XANTENNA__3285__X Tile_X0Y0_E6BEG[5] VPWR VGND sg13cmos5l_antennanp
XFILLER_353_154 VPWR VGND sg13cmos5l_decap_8
XFILLER_542_254 VPWR VGND sg13cmos5l_fill_2
XFILLER_499_147 VPWR VGND sg13cmos5l_decap_8
XFILLER_152_227 VPWR VGND sg13cmos5l_decap_8
XFILLER_688_269 VPWR VGND sg13cmos5l_decap_4
XFILLER_105_110 VPWR VGND sg13cmos5l_decap_8
XFILLER_10_42 VPWR VGND sg13cmos5l_decap_8
XFILLER_624_28 VPWR VGND sg13cmos5l_decap_8
XFILLER_407_63 VPWR VGND sg13cmos5l_decap_8
XFILLER_598_7 VPWR VGND sg13cmos5l_decap_8
XFILLER_554_91 VPWR VGND sg13cmos5l_decap_8
XFILLER_126_42 VPWR VGND sg13cmos5l_decap_8
XFILLER_160_260 VPWR VGND sg13cmos5l_fill_2
XFILLER_105_187 VPWR VGND sg13cmos5l_decap_8
XFILLER_490_35 VPWR VGND sg13cmos5l_decap_8
XFILLER_273_70 VPWR VGND sg13cmos5l_decap_8
XFILLER_120_124 VPWR VGND sg13cmos5l_fill_2
XFILLER_510_173 VPWR VGND sg13cmos5l_decap_8
XFILLER_86_35 VPWR VGND sg13cmos5l_decap_8
XFILLER_656_166 VPWR VGND sg13cmos5l_decap_8
XFILLER_640_49 VPWR VGND sg13cmos5l_decap_8
XFILLER_423_84 VPWR VGND sg13cmos5l_decap_8
XFILLER_19_84 VPWR VGND sg13cmos5l_decap_8
XFILLER_142_63 VPWR VGND sg13cmos5l_decap_8
XFILLER_274_194 VPWR VGND sg13cmos5l_decap_8
XFILLER_499_77 VPWR VGND sg13cmos5l_decap_8
XFILLER_423_147 VPWR VGND sg13cmos5l_decap_8
XFILLER_612_258 VPWR VGND sg13cmos5l_decap_8
XFILLER_649_14 VPWR VGND sg13cmos5l_decap_8
XFILLER_215_272 VPWR VGND sg13cmos5l_fill_1
XFILLER_27_193 VPWR VGND sg13cmos5l_fill_2
XFILLER_255_0 VPWR VGND sg13cmos5l_decap_4
XFILLER_368_15 VPWR VGND sg13cmos5l_decap_8
XFILLER_187_124 VPWR VGND sg13cmos5l_decap_8
XFILLER_376_224 VPWR VGND sg13cmos5l_decap_8
XFILLER_422_0 VPWR VGND sg13cmos5l_decap_8
XFILLER_376_268 VPWR VGND sg13cmos5l_decap_4
XFILLER_128_213 VPWR VGND sg13cmos5l_decap_8
XFILLER_665_35 VPWR VGND sg13cmos5l_decap_8
XFILLER_448_70 VPWR VGND sg13cmos5l_decap_8
XFILLER_329_173 VPWR VGND sg13cmos5l_decap_8
XFILLER_592_187 VPWR VGND sg13cmos5l_decap_8
XFILLER_391_238 VPWR VGND sg13cmos5l_decap_8
XFILLER_384_14 VPWR VGND sg13cmos5l_decap_8
XANTENNA__3195__X Tile_X0Y0_N2BEGb[3] VPWR VGND sg13cmos5l_antennanp
XFILLER_679_225 VPWR VGND sg13cmos5l_fill_1
XFILLER_344_154 VPWR VGND sg13cmos5l_decap_8
X_0640_ _0640_/Q Tile_X0Y8_FrameData[31] VGND VPWR Tile_X0Y9_FrameStrobe[7] latch
XFILLER_317_30 VPWR VGND sg13cmos5l_fill_1
XFILLER_317_52 VPWR VGND sg13cmos5l_decap_8
XFILLER_534_28 VPWR VGND sg13cmos5l_decap_8
X_0571_ _0571_/Q Tile_X0Y8_FrameData[4] VGND VPWR Tile_X0Y9_FrameStrobe[4] latch
X_2310_ _2310_/Q Tile_X0Y5_FrameData[31] VGND VPWR Tile_X0Y9_FrameStrobe[4] latch
XFILLER_681_67 VPWR VGND sg13cmos5l_fill_1
XFILLER_647_133 VPWR VGND sg13cmos5l_decap_8
XFILLER_501_140 VPWR VGND sg13cmos5l_decap_8
X_3290_ Tile_X0Y0_E6BEG[10] _3846_/X VPWR VGND sg13cmos5l_buf_1
XFILLER_681_89 VPWR VGND sg13cmos5l_decap_8
X_2241_ _2241_/Q Tile_X0Y5_FrameData[4] VGND VPWR Tile_X0Y9_FrameStrobe[1] latch
XFILLER_300_235 VPWR VGND sg13cmos5l_fill_1
XFILLER_111_146 VPWR VGND sg13cmos5l_decap_8
XFILLER_300_257 VPWR VGND sg13cmos5l_decap_4
XFILLER_300_268 VPWR VGND sg13cmos5l_decap_4
X_2172_ _2172_/Q Tile_X0Y4_FrameData[9] VGND VPWR Tile_X0Y9_FrameStrobe[7] latch
XFILLER_550_49 VPWR VGND sg13cmos5l_decap_8
XFILLER_662_169 VPWR VGND sg13cmos5l_decap_8
XFILLER_454_261 VPWR VGND sg13cmos5l_decap_8
X_1123_ _1123_/Q Tile_X0Y0_FrameData[8] VGND VPWR Tile_X0Y9_FrameStrobe[5] latch
XFILLER_454_272 VPWR VGND sg13cmos5l_fill_1
XFILLER_265_194 VPWR VGND sg13cmos5l_decap_8
XFILLER_80_203 VPWR VGND sg13cmos5l_fill_2
XFILLER_603_236 VPWR VGND sg13cmos5l_decap_8
X_1054_ _1054_/Q Tile_X0Y0_FrameData[13] VGND VPWR Tile_X0Y9_FrameStrobe[3] latch
XFILLER_414_158 VPWR VGND sg13cmos5l_decap_8
XFILLER_559_14 VPWR VGND sg13cmos5l_decap_8
XFILLER_280_175 VPWR VGND sg13cmos5l_decap_8
XFILLER_202_77 VPWR VGND sg13cmos5l_decap_8
XFILLER_206_272 VPWR VGND sg13cmos5l_fill_1
XFILLER_568_140 VPWR VGND sg13cmos5l_decap_8
XFILLER_221_220 VPWR VGND sg13cmos5l_decap_8
XFILLER_422_180 VPWR VGND sg13cmos5l_decap_8
XFILLER_221_231 VPWR VGND sg13cmos5l_fill_2
X_4813_ _4813_/X _4779_/X Tile_X0Y9_N4END[5] _4778_/X _0076_/X _0445_/Q _0444_/Q VPWR
+ VGND sg13cmos5l_mux4_1
XFILLER_709_28 VPWR VGND sg13cmos5l_decap_8
XFILLER_717_137 VPWR VGND sg13cmos5l_decap_8
XFILLER_367_268 VPWR VGND sg13cmos5l_decap_4
XFILLER_639_91 VPWR VGND sg13cmos5l_decap_8
XFILLER_509_240 VPWR VGND sg13cmos5l_decap_8
X_1956_ _1956_/Q Tile_X0Y4_FrameData[1] VGND VPWR Tile_X0Y9_FrameStrobe[0] latch
X_4744_ _4744_/X Tile_X0Y8_WW4END[15] AXI_M_SOC_RDATA8 _4815_/X _4784_/X _0559_/Q
+ _0558_/Q VPWR VGND sg13cmos5l_mux4_1
XFILLER_575_35 VPWR VGND sg13cmos5l_decap_8
XFILLER_358_70 VPWR VGND sg13cmos5l_decap_8
X_0907_ _0907_/Q Tile_X0Y9_FrameData[20] VGND VPWR Tile_X0Y9_FrameStrobe[7] latch
X_4675_ _4675_/X _4591_/X _4707_/X _4706_/X _4590_/X _0177_/Q _0176_/Q VPWR VGND sg13cmos5l_mux4_1
XFILLER_294_14 VPWR VGND sg13cmos5l_decap_8
X_1887_ _1887_/Q Tile_X0Y3_FrameData[10] VGND VPWR Tile_X0Y9_FrameStrobe[6] latch
XFILLER_119_268 VPWR VGND sg13cmos5l_decap_4
XFILLER_134_205 VPWR VGND sg13cmos5l_decap_8
X_3626_ Tile_X0Y9_S4BEG[4] _3626_/A VPWR VGND sg13cmos5l_buf_1
X_0838_ _0838_/Q Tile_X0Y9_FrameData[25] VGND VPWR Tile_X0Y9_FrameStrobe[5] latch
XFILLER_508_84 VPWR VGND sg13cmos5l_decap_8
XFILLER_390_271 VPWR VGND sg13cmos5l_fill_2
XFILLER_444_28 VPWR VGND sg13cmos5l_decap_8
X_3557_ Tile_X0Y9_EE4BEG[3] _4867_/X VPWR VGND sg13cmos5l_buf_1
X_0769_ _0769_/Q Tile_X0Y9_FrameData[30] VGND VPWR Tile_X0Y9_FrameStrobe[3] latch
XFILLER_288_220 VPWR VGND sg13cmos5l_decap_8
XFILLER_685_239 VPWR VGND sg13cmos5l_decap_4
XFILLER_591_56 VPWR VGND sg13cmos5l_decap_8
X_2508_ _2508_/Q Tile_X0Y6_FrameData[27] VGND VPWR Tile_X0Y9_FrameStrobe[2] latch
XFILLER_638_133 VPWR VGND sg13cmos5l_decap_8
X_3488_ Tile_X0Y1_EE4BEG[14] _3962_/X VPWR VGND sg13cmos5l_buf_1
XFILLER_102_146 VPWR VGND sg13cmos5l_fill_2
X_2439_ _2439_/Q Tile_X0Y5_FrameData[30] VGND VPWR Tile_X0Y9_FrameStrobe[8] latch
XFILLER_437_228 VPWR VGND sg13cmos5l_decap_4
XFILLER_263_109 VPWR VGND sg13cmos5l_decap_8
X_4109_ _4109_/X _4573_/X _4577_/X _4581_/X _4555_/X _2668_/Q _2667_/Q VPWR VGND sg13cmos5l_mux4_1
XFILLER_445_272 VPWR VGND sg13cmos5l_fill_1
XFILLER_179_7 VPWR VGND sg13cmos5l_decap_8
XFILLER_460_220 VPWR VGND sg13cmos5l_decap_8
XFILLER_71_203 VPWR VGND sg13cmos5l_decap_8
XFILLER_271_131 VPWR VGND sg13cmos5l_decap_8
XFILLER_405_158 VPWR VGND sg13cmos5l_decap_8
XFILLER_469_14 VPWR VGND sg13cmos5l_decap_8
XFILLER_271_164 VPWR VGND sg13cmos5l_fill_1
XFILLER_271_175 VPWR VGND sg13cmos5l_decap_8
XFILLER_271_186 VPWR VGND sg13cmos5l_fill_2
XFILLER_559_140 VPWR VGND sg13cmos5l_fill_2
XFILLER_346_7 VPWR VGND sg13cmos5l_decap_8
XFILLER_212_231 VPWR VGND sg13cmos5l_decap_8
XFILLER_358_224 VPWR VGND sg13cmos5l_decap_8
XFILLER_24_174 VPWR VGND sg13cmos5l_fill_1
XFILLER_619_28 VPWR VGND sg13cmos5l_decap_8
XFILLER_212_264 VPWR VGND sg13cmos5l_fill_1
XFILLER_169_168 VPWR VGND sg13cmos5l_decap_8
XANTENNA__2912__X Tile_X0Y8_E1BEG[0] VPWR VGND sg13cmos5l_antennanp
XFILLER_574_154 VPWR VGND sg13cmos5l_decap_8
XFILLER_513_7 VPWR VGND sg13cmos5l_decap_8
XFILLER_184_127 VPWR VGND sg13cmos5l_decap_8
XFILLER_485_35 VPWR VGND sg13cmos5l_decap_8
XFILLER_227_4 VPWR VGND sg13cmos5l_fill_1
XFILLER_268_70 VPWR VGND sg13cmos5l_decap_8
XFILLER_515_210 VPWR VGND sg13cmos5l_decap_8
XFILLER_373_249 VPWR VGND sg13cmos5l_decap_8
XANTENNA_70 Tile_X0Y0_S2MID[3] VPWR VGND sg13cmos5l_antennanp
XANTENNA_81 Tile_X0Y0_S4END[14] VPWR VGND sg13cmos5l_antennanp
XANTENNA_92 Tile_X0Y1_FrameData[6] VPWR VGND sg13cmos5l_antennanp
XFILLER_381_260 VPWR VGND sg13cmos5l_decap_4
XFILLER_635_49 VPWR VGND sg13cmos5l_decap_8
XFILLER_381_271 VPWR VGND sg13cmos5l_fill_2
XFILLER_125_249 VPWR VGND sg13cmos5l_decap_4
XFILLER_341_124 VPWR VGND sg13cmos5l_decap_8
XFILLER_341_135 VPWR VGND sg13cmos5l_fill_2
XANTENNA__0151__Y AXI_M_SOC_AWLEN2 VPWR VGND sg13cmos5l_antennanp
XFILLER_137_63 VPWR VGND sg13cmos5l_decap_8
XFILLER_354_28 VPWR VGND sg13cmos5l_decap_8
XFILLER_530_246 VPWR VGND sg13cmos5l_decap_8
XFILLER_487_139 VPWR VGND sg13cmos5l_decap_8
XANTENNA__3743__X AXI_M_SOC_ARADDR15 VPWR VGND sg13cmos5l_antennanp
XFILLER_284_91 VPWR VGND sg13cmos5l_decap_8
XFILLER_341_179 VPWR VGND sg13cmos5l_decap_8
XFILLER_279_253 VPWR VGND sg13cmos5l_fill_2
XFILLER_133_271 VPWR VGND sg13cmos5l_fill_2
XFILLER_495_161 VPWR VGND sg13cmos5l_decap_8
XFILLER_428_217 VPWR VGND sg13cmos5l_decap_8
XFILLER_684_272 VPWR VGND sg13cmos5l_fill_1
XFILLER_294_223 VPWR VGND sg13cmos5l_decap_8
XFILLER_644_147 VPWR VGND sg13cmos5l_decap_8
XFILLER_372_0 VPWR VGND sg13cmos5l_decap_4
XFILLER_436_272 VPWR VGND sg13cmos5l_fill_1
XFILLER_303_43 VPWR VGND sg13cmos5l_decap_8
XFILLER_62_203 VPWR VGND sg13cmos5l_decap_8
XFILLER_379_14 VPWR VGND sg13cmos5l_decap_8
XFILLER_411_106 VPWR VGND sg13cmos5l_decap_8
XFILLER_637_0 VPWR VGND sg13cmos5l_decap_8
XFILLER_597_268 VPWR VGND sg13cmos5l_decap_4
XFILLER_62_258 VPWR VGND sg13cmos5l_fill_1
XFILLER_15_141 VPWR VGND sg13cmos5l_decap_8
XFILLER_203_220 VPWR VGND sg13cmos5l_fill_2
XFILLER_15_185 VPWR VGND sg13cmos5l_decap_8
XFILLER_94_7 VPWR VGND sg13cmos5l_decap_8
XFILLER_529_28 VPWR VGND sg13cmos5l_decap_8
XFILLER_349_257 VPWR VGND sg13cmos5l_decap_4
XFILLER_676_56 VPWR VGND sg13cmos5l_decap_8
X_1810_ _1810_/Q Tile_X0Y3_FrameData[23] VGND VPWR Tile_X0Y9_FrameStrobe[4] latch
XFILLER_565_154 VPWR VGND sg13cmos5l_decap_8
XANTENNA__2822__X Tile_X0Y4_E2BEG[0] VPWR VGND sg13cmos5l_antennanp
X_2790_ Tile_X0Y3_E6BEG[0] _4180_/X VPWR VGND sg13cmos5l_buf_1
XFILLER_364_216 VPWR VGND sg13cmos5l_decap_8
XFILLER_7_21 VPWR VGND sg13cmos5l_decap_8
XFILLER_395_57 VPWR VGND sg13cmos5l_decap_8
X_1741_ _1741_/Q Tile_X0Y3_FrameData[28] VGND VPWR Tile_X0Y9_FrameStrobe[2] latch
XFILLER_506_254 VPWR VGND sg13cmos5l_fill_1
X_4460_ _4460_/X _4421_/X _0159_/X _4420_/X _0145_/X _2219_/Q _2218_/Q VPWR VGND sg13cmos5l_mux4_1
XFILLER_372_260 VPWR VGND sg13cmos5l_fill_2
X_1672_ _1672_/Q Tile_X0Y2_FrameData[9] VGND VPWR Tile_X0Y9_FrameStrobe[7] latch
XFILLER_692_44 VPWR VGND sg13cmos5l_fill_1
XFILLER_332_102 VPWR VGND sg13cmos5l_decap_8
XFILLER_328_73 VPWR VGND sg13cmos5l_fill_1
XFILLER_545_49 VPWR VGND sg13cmos5l_decap_8
XFILLER_7_98 VPWR VGND sg13cmos5l_decap_8
XFILLER_328_95 VPWR VGND sg13cmos5l_decap_8
X_3411_ Tile_X0Y4_FrameData_O[2] Tile_X0Y4_FrameData[2] VPWR VGND sg13cmos5l_buf_1
X_0623_ _0623_/Q Tile_X0Y8_FrameData[16] VGND VPWR Tile_X0Y9_FrameStrobe[6] latch
XFILLER_264_28 VPWR VGND sg13cmos5l_decap_8
X_4391_ _4391_/X Tile_X0Y5_WW4END[12] AXI_M_SOC_RRESP1 _4463_/X _4433_/X _2321_/Q
+ _2320_/Q VPWR VGND sg13cmos5l_mux4_1
XFILLER_667_228 VPWR VGND sg13cmos5l_decap_8
XANTENNA__3653__X AXI_M_SOC_AWADDR14 VPWR VGND sg13cmos5l_antennanp
XFILLER_521_257 VPWR VGND sg13cmos5l_decap_4
XFILLER_124_260 VPWR VGND sg13cmos5l_decap_4
X_3342_ Tile_X0Y2_FrameData_O[13] Tile_X0Y2_FrameData[13] VPWR VGND sg13cmos5l_buf_1
XFILLER_332_179 VPWR VGND sg13cmos5l_decap_8
X_0554_ _0554_/Q Tile_X0Y8_FrameData[21] VGND VPWR Tile_X0Y9_FrameStrobe[4] latch
XFILLER_97_122 VPWR VGND sg13cmos5l_decap_8
XFILLER_419_217 VPWR VGND sg13cmos5l_decap_8
XFILLER_486_172 VPWR VGND sg13cmos5l_decap_8
X_3273_ Tile_X0Y0_EE4BEG[9] _3829_/X VPWR VGND sg13cmos5l_buf_1
X_0485_ _0485_/Q Tile_X0Y8_FrameData[26] VGND VPWR Tile_X0Y9_FrameStrobe[2] latch
XFILLER_285_245 VPWR VGND sg13cmos5l_decap_8
XFILLER_97_188 VPWR VGND sg13cmos5l_decap_8
X_2224_ _2224_/Q Tile_X0Y5_FrameData[21] VGND VPWR Tile_X0Y9_FrameStrobe[1] latch
XFILLER_635_147 VPWR VGND sg13cmos5l_decap_8
XFILLER_280_49 VPWR VGND sg13cmos5l_decap_8
XFILLER_641_70 VPWR VGND sg13cmos5l_decap_8
XFILLER_16_0 VPWR VGND sg13cmos5l_decap_8
XFILLER_213_21 VPWR VGND sg13cmos5l_decap_8
XFILLER_427_272 VPWR VGND sg13cmos5l_fill_1
X_2155_ _2155_/Q Tile_X0Y4_FrameData[26] VGND VPWR Tile_X0Y9_FrameStrobe[7] latch
XFILLER_53_203 VPWR VGND sg13cmos5l_decap_8
XFILLER_399_124 VPWR VGND sg13cmos5l_decap_8
X_1106_ _1106_/Q Tile_X0Y0_FrameData[25] VGND VPWR Tile_X0Y9_FrameStrobe[5] latch
XFILLER_442_242 VPWR VGND sg13cmos5l_decap_8
XFILLER_213_98 VPWR VGND sg13cmos5l_decap_8
X_2086_ _2086_/Q Tile_X0Y4_FrameData[31] VGND VPWR Tile_X0Y9_FrameStrobe[5] latch
XFILLER_289_14 VPWR VGND sg13cmos5l_decap_8
XFILLER_198_208 VPWR VGND sg13cmos5l_fill_2
X_1037_ _1037_/Q Tile_X0Y0_FrameData[30] VGND VPWR Tile_X0Y9_FrameStrobe[3] latch
XFILLER_53_269 VPWR VGND sg13cmos5l_decap_4
XFILLER_510_63 VPWR VGND sg13cmos5l_decap_8
XFILLER_439_28 VPWR VGND sg13cmos5l_decap_8
XFILLER_556_143 VPWR VGND sg13cmos5l_decap_4
XFILLER_410_161 VPWR VGND sg13cmos5l_decap_8
XFILLER_586_56 VPWR VGND sg13cmos5l_decap_8
XFILLER_369_91 VPWR VGND sg13cmos5l_decap_8
XFILLER_158_29 VPWR VGND sg13cmos5l_decap_8
X_2988_ Tile_X0Y8_FrameData_O[28] Tile_X0Y8_FrameData[28] VPWR VGND sg13cmos5l_buf_1
XFILLER_355_238 VPWR VGND sg13cmos5l_decap_8
XFILLER_166_149 VPWR VGND sg13cmos5l_fill_1
X_4727_ _4727_/X _4783_/X _4782_/X AXI_M_SOC_RDATA8 AXI_M_SOC_RDATA12 _0593_/Q _0592_/Q
+ VPWR VGND sg13cmos5l_mux4_1
X_1939_ _1939_/Q Tile_X0Y4_FrameData[18] VGND VPWR Tile_X0Y9_FrameStrobe[0] latch
XFILLER_308_143 VPWR VGND sg13cmos5l_decap_8
XFILLER_571_168 VPWR VGND sg13cmos5l_decap_8
XFILLER_238_51 VPWR VGND sg13cmos5l_fill_1
XFILLER_107_227 VPWR VGND sg13cmos5l_decap_8
XFILLER_174_182 VPWR VGND sg13cmos5l_decap_4
X_4658_ _4658_/X _4665_/X Tile_X0Y7_W6END[2] _4664_/X _4658_/A3 _0163_/Q _0162_/Q
+ VPWR VGND sg13cmos5l_mux4_1
XFILLER_363_271 VPWR VGND sg13cmos5l_fill_2
XFILLER_308_187 VPWR VGND sg13cmos5l_decap_4
XFILLER_713_173 VPWR VGND sg13cmos5l_decap_8
XFILLER_174_28 VPWR VGND sg13cmos5l_decap_8
X_3609_ Tile_X0Y9_S2BEG[3] _4831_/X VPWR VGND sg13cmos5l_buf_1
XFILLER_323_146 VPWR VGND sg13cmos5l_decap_8
XFILLER_174_39 VPWR VGND sg13cmos5l_fill_2
XFILLER_512_246 VPWR VGND sg13cmos5l_decap_8
XANTENNA__3563__X Tile_X0Y9_EE4BEG[9] VPWR VGND sg13cmos5l_antennanp
X_4589_ _4589_/X Tile_X0Y8_W2MID[5] Tile_X0Y8_W2END[5] Tile_X0Y8_W6END[5] _4789_/X
+ _0659_/Q _0658_/Q VPWR VGND sg13cmos5l_mux4_1
XFILLER_512_268 VPWR VGND sg13cmos5l_decap_4
XFILLER_673_209 VPWR VGND sg13cmos5l_decap_8
XFILLER_666_261 VPWR VGND sg13cmos5l_decap_4
XFILLER_666_272 VPWR VGND sg13cmos5l_fill_1
XFILLER_107_88 VPWR VGND sg13cmos5l_decap_8
XFILLER_296_7 VPWR VGND sg13cmos5l_decap_8
XFILLER_404_42 VPWR VGND sg13cmos5l_decap_8
XFILLER_88_199 VPWR VGND sg13cmos5l_decap_8
XFILLER_681_242 VPWR VGND sg13cmos5l_decap_8
XFILLER_229_150 VPWR VGND sg13cmos5l_decap_8
XFILLER_123_21 VPWR VGND sg13cmos5l_decap_8
XFILLER_551_70 VPWR VGND sg13cmos5l_decap_8
XFILLER_29_222 VPWR VGND sg13cmos5l_decap_8
XFILLER_229_161 VPWR VGND sg13cmos5l_fill_1
XFILLER_492_175 VPWR VGND sg13cmos5l_decap_8
XANTENNA__2907__X Tile_X0Y6_FrameData_O[28] VPWR VGND sg13cmos5l_antennanp
XFILLER_463_7 VPWR VGND sg13cmos5l_decap_8
XFILLER_123_65 VPWR VGND sg13cmos5l_fill_2
XFILLER_83_14 VPWR VGND sg13cmos5l_decap_8
XFILLER_433_231 VPWR VGND sg13cmos5l_fill_1
XFILLER_177_4 VPWR VGND sg13cmos5l_fill_1
XFILLER_199_14 VPWR VGND sg13cmos5l_decap_8
XFILLER_433_253 VPWR VGND sg13cmos5l_decap_8
XFILLER_83_58 VPWR VGND sg13cmos5l_decap_8
XFILLER_701_84 VPWR VGND sg13cmos5l_decap_8
XFILLER_579_246 VPWR VGND sg13cmos5l_decap_8
XFILLER_630_7 VPWR VGND sg13cmos5l_decap_8
XFILLER_420_63 VPWR VGND sg13cmos5l_decap_8
XFILLER_16_63 VPWR VGND sg13cmos5l_decap_8
XANTENNA__0146__Y AXI_M_SOC_ARCACHE3 VPWR VGND sg13cmos5l_antennanp
XFILLER_349_28 VPWR VGND sg13cmos5l_decap_8
XFILLER_197_252 VPWR VGND sg13cmos5l_decap_8
XANTENNA__3738__X AXI_M_SOC_ARADDR10 VPWR VGND sg13cmos5l_antennanp
XFILLER_197_263 VPWR VGND sg13cmos5l_fill_2
XFILLER_547_143 VPWR VGND sg13cmos5l_decap_8
XFILLER_496_56 VPWR VGND sg13cmos5l_decap_8
XFILLER_279_91 VPWR VGND sg13cmos5l_decap_8
XFILLER_200_223 VPWR VGND sg13cmos5l_decap_8
XFILLER_12_166 VPWR VGND sg13cmos5l_decap_8
XFILLER_547_176 VPWR VGND sg13cmos5l_fill_2
XFILLER_346_227 VPWR VGND sg13cmos5l_fill_1
XFILLER_157_138 VPWR VGND sg13cmos5l_decap_8
XFILLER_32_51 VPWR VGND sg13cmos5l_decap_8
XFILLER_120_0 VPWR VGND sg13cmos5l_decap_8
XFILLER_218_0 VPWR VGND sg13cmos5l_decap_8
XFILLER_562_168 VPWR VGND sg13cmos5l_decap_8
XFILLER_165_160 VPWR VGND sg13cmos5l_decap_8
XFILLER_503_202 VPWR VGND sg13cmos5l_decap_8
XFILLER_365_49 VPWR VGND sg13cmos5l_decap_8
XFILLER_314_102 VPWR VGND sg13cmos5l_decap_8
XFILLER_148_84 VPWR VGND sg13cmos5l_decap_8
XFILLER_165_193 VPWR VGND sg13cmos5l_fill_2
XFILLER_649_206 VPWR VGND sg13cmos5l_decap_8
XFILLER_180_130 VPWR VGND sg13cmos5l_decap_8
XFILLER_662_14 VPWR VGND sg13cmos5l_decap_8
XANTENNA__3473__X Tile_X0Y1_FrameData_O[31] VPWR VGND sg13cmos5l_antennanp
XFILLER_649_239 VPWR VGND sg13cmos5l_decap_4
XFILLER_180_196 VPWR VGND sg13cmos5l_decap_8
XFILLER_164_50 VPWR VGND sg13cmos5l_decap_8
XFILLER_79_133 VPWR VGND sg13cmos5l_decap_8
XFILLER_587_0 VPWR VGND sg13cmos5l_decap_8
XFILLER_657_272 VPWR VGND sg13cmos5l_fill_1
XFILLER_617_125 VPWR VGND sg13cmos5l_decap_8
X_0270_ _0270_/Q Tile_X0Y7_FrameData[17] VGND VPWR Tile_X0Y9_FrameStrobe[3] latch
XFILLER_461_70 VPWR VGND sg13cmos5l_fill_2
XFILLER_409_250 VPWR VGND sg13cmos5l_fill_1
XFILLER_314_64 VPWR VGND sg13cmos5l_decap_8
XFILLER_94_158 VPWR VGND sg13cmos5l_decap_8
XFILLER_409_272 VPWR VGND sg13cmos5l_fill_1
XANTENNA__2817__X Tile_X0Y3_E2BEG[7] VPWR VGND sg13cmos5l_antennanp
XFILLER_57_81 VPWR VGND sg13cmos5l_decap_8
XFILLER_424_231 VPWR VGND sg13cmos5l_decap_8
XFILLER_611_84 VPWR VGND sg13cmos5l_decap_4
XFILLER_424_264 VPWR VGND sg13cmos5l_decap_8
XFILLER_35_236 VPWR VGND sg13cmos5l_fill_2
XFILLER_611_95 VPWR VGND sg13cmos5l_decap_8
XFILLER_640_161 VPWR VGND sg13cmos5l_decap_8
XFILLER_235_197 VPWR VGND sg13cmos5l_decap_8
X_3960_ _3960_/X Tile_X0Y1_WW4END[3] AXI_M_SOC_ARREADY _4011_/X _3995_/X _1289_/Q
+ _1288_/Q VPWR VGND sg13cmos5l_mux4_1
XFILLER_585_216 VPWR VGND sg13cmos5l_decap_8
XFILLER_250_134 VPWR VGND sg13cmos5l_decap_8
X_2911_ Tile_X0Y6_UserCLKo Tile_X0Y6_UserCLK VPWR VGND sg13cmos5l_buf_1
XFILLER_389_190 VPWR VGND sg13cmos5l_decap_8
X_3891_ _3891_/X Tile_X0Y1_W2MID[6] Tile_X0Y1_W2END[6] Tile_X0Y1_W6END[6] _3991_/X
+ _1415_/Q _1414_/Q VPWR VGND sg13cmos5l_mux4_1
XFILLER_188_252 VPWR VGND sg13cmos5l_decap_8
XFILLER_189_80 VPWR VGND sg13cmos5l_decap_8
XANTENNA__3648__X AXI_M_SOC_AWADDR9 VPWR VGND sg13cmos5l_antennanp
XFILLER_188_263 VPWR VGND sg13cmos5l_fill_2
XFILLER_148_105 VPWR VGND sg13cmos5l_fill_2
X_2842_ Tile_X0Y6_E2BEG[7] _4503_/X VPWR VGND sg13cmos5l_buf_1
XFILLER_337_227 VPWR VGND sg13cmos5l_decap_8
X_2773_ Tile_X0Y3_FrameData_O[31] Tile_X0Y3_FrameData[31] VPWR VGND sg13cmos5l_buf_1
X_1724_ _1724_/Q Tile_X0Y3_FrameData[13] VGND VPWR Tile_X0Y9_FrameStrobe[1] latch
X_4512_ _4512_/X Tile_X0Y6_WW4END[15] AXI_M_SOC_RDATA24 _4583_/X _4552_/X _2583_/Q
+ _2582_/Q VPWR VGND sg13cmos5l_mux4_1
XFILLER_275_49 VPWR VGND sg13cmos5l_decap_8
XFILLER_208_21 VPWR VGND sg13cmos5l_decap_8
XFILLER_636_70 VPWR VGND sg13cmos5l_decap_8
XFILLER_360_230 VPWR VGND sg13cmos5l_decap_8
X_1655_ _1655_/Q Tile_X0Y2_FrameData[26] VGND VPWR Tile_X0Y9_FrameStrobe[7] latch
X_4443_ _4443_/X Tile_X0Y1_W1END[2] Tile_X0Y1_WW4END[14] Tile_X0Y1_W6END[6] _4010_/X
+ _1359_/Q _1358_/Q VPWR VGND sg13cmos5l_mux4_1
XFILLER_572_14 VPWR VGND sg13cmos5l_decap_8
XANTENNA__3383__X Tile_X0Y2_E6BEG[6] VPWR VGND sg13cmos5l_antennanp
XFILLER_171_163 VPWR VGND sg13cmos5l_fill_1
X_0606_ _0606_/Q Tile_X0Y8_FrameData[1] VGND VPWR Tile_X0Y9_FrameStrobe[5] latch
XFILLER_320_105 VPWR VGND sg13cmos5l_decap_8
XFILLER_171_185 VPWR VGND sg13cmos5l_decap_8
X_4374_ _4374_/X Tile_X0Y5_W2MID[5] AXI_M_SOC_RRESP0 _4432_/X _4431_/X _2355_/Q _2354_/Q
+ VPWR VGND sg13cmos5l_mux4_1
XFILLER_208_98 VPWR VGND sg13cmos5l_decap_8
X_1586_ _1586_/Q Tile_X0Y2_FrameData[31] VGND VPWR Tile_X0Y9_FrameStrobe[5] latch
XFILLER_291_15 VPWR VGND sg13cmos5l_decap_8
X_3325_ Tile_X0Y4_EE4BEG[13] _4285_/X VPWR VGND sg13cmos5l_buf_1
XFILLER_608_103 VPWR VGND sg13cmos5l_decap_8
X_0537_ _0537_/Q Tile_X0Y8_FrameData[6] VGND VPWR Tile_X0Y9_FrameStrobe[3] latch
XFILLER_505_63 VPWR VGND sg13cmos5l_decap_8
XFILLER_652_91 VPWR VGND sg13cmos5l_decap_8
XFILLER_224_42 VPWR VGND sg13cmos5l_decap_8
X_3256_ Tile_X0Y0_FrameData_O[24] Tile_X0Y0_FrameData[24] VPWR VGND sg13cmos5l_buf_1
X_0468_ _0468_/Q Tile_X0Y8_FrameData[11] VGND VPWR Tile_X0Y9_FrameStrobe[1] latch
XFILLER_407_209 VPWR VGND sg13cmos5l_decap_8
XFILLER_371_70 VPWR VGND sg13cmos5l_decap_8
XFILLER_37_18 VPWR VGND sg13cmos5l_decap_8
X_2207_ _2207_/Q Tile_X0Y5_FrameData[6] VGND VPWR Tile_X0Y9_FrameStrobe[0] latch
X_3187_ Tile_X0Y0_N4BEG[11] _3187_/A VPWR VGND sg13cmos5l_buf_1
X_0399_ _0399_/Q Tile_X0Y7_FrameData[16] VGND VPWR Tile_X0Y9_FrameStrobe[7] latch
XFILLER_226_153 VPWR VGND sg13cmos5l_decap_8
X_2138_ _2138_/Q Tile_X0Y4_FrameData[11] VGND VPWR Tile_X0Y9_FrameStrobe[6] latch
XFILLER_26_225 VPWR VGND sg13cmos5l_decap_8
XFILLER_415_264 VPWR VGND sg13cmos5l_fill_1
XFILLER_631_161 VPWR VGND sg13cmos5l_decap_8
XFILLER_226_197 VPWR VGND sg13cmos5l_decap_8
XFILLER_240_63 VPWR VGND sg13cmos5l_decap_8
X_2069_ _2069_/Q Tile_X0Y4_FrameData[16] VGND VPWR Tile_X0Y9_FrameStrobe[4] latch
XFILLER_53_39 VPWR VGND sg13cmos5l_decap_8
XFILLER_430_245 VPWR VGND sg13cmos5l_decap_8
XFILLER_529_110 VPWR VGND sg13cmos5l_decap_8
XFILLER_169_28 VPWR VGND sg13cmos5l_decap_8
XFILLER_241_178 VPWR VGND sg13cmos5l_decap_8
XANTENNA__3558__X Tile_X0Y9_EE4BEG[4] VPWR VGND sg13cmos5l_antennanp
XFILLER_139_105 VPWR VGND sg13cmos5l_decap_8
XFILLER_395_171 VPWR VGND sg13cmos5l_decap_8
XFILLER_544_102 VPWR VGND sg13cmos5l_fill_2
XFILLER_328_227 VPWR VGND sg13cmos5l_decap_8
XFILLER_194_233 VPWR VGND sg13cmos5l_decap_8
XFILLER_249_50 VPWR VGND sg13cmos5l_decap_8
XFILLER_544_135 VPWR VGND sg13cmos5l_decap_8
XFILLER_249_72 VPWR VGND sg13cmos5l_decap_4
XFILLER_154_108 VPWR VGND sg13cmos5l_fill_2
XFILLER_147_160 VPWR VGND sg13cmos5l_decap_4
XFILLER_211_7 VPWR VGND sg13cmos5l_decap_8
XFILLER_309_7 VPWR VGND sg13cmos5l_decap_8
XFILLER_147_193 VPWR VGND sg13cmos5l_decap_8
XFILLER_546_70 VPWR VGND sg13cmos5l_decap_8
XFILLER_118_21 VPWR VGND sg13cmos5l_decap_8
XFILLER_482_14 VPWR VGND sg13cmos5l_decap_8
XFILLER_162_152 VPWR VGND sg13cmos5l_decap_8
XANTENNA__3293__X Tile_X0Y0_E2BEGb[1] VPWR VGND sg13cmos5l_antennanp
XFILLER_78_14 VPWR VGND sg13cmos5l_decap_8
XFILLER_497_245 VPWR VGND sg13cmos5l_decap_4
XFILLER_78_58 VPWR VGND sg13cmos5l_decap_4
XFILLER_701_187 VPWR VGND sg13cmos5l_fill_1
XFILLER_500_238 VPWR VGND sg13cmos5l_decap_8
XFILLER_639_272 VPWR VGND sg13cmos5l_fill_1
XFILLER_632_28 VPWR VGND sg13cmos5l_decap_8
XFILLER_580_7 VPWR VGND sg13cmos5l_decap_8
XFILLER_415_63 VPWR VGND sg13cmos5l_decap_8
XFILLER_678_7 VPWR VGND sg13cmos5l_decap_8
XFILLER_654_220 VPWR VGND sg13cmos5l_decap_8
XFILLER_562_91 VPWR VGND sg13cmos5l_decap_8
XFILLER_134_42 VPWR VGND sg13cmos5l_decap_8
XFILLER_76_136 VPWR VGND sg13cmos5l_fill_2
XFILLER_281_70 VPWR VGND sg13cmos5l_decap_8
XFILLER_94_35 VPWR VGND sg13cmos5l_decap_8
XFILLER_480_112 VPWR VGND sg13cmos5l_decap_8
XFILLER_264_248 VPWR VGND sg13cmos5l_decap_8
XFILLER_91_117 VPWR VGND sg13cmos5l_decap_8
XFILLER_217_164 VPWR VGND sg13cmos5l_fill_2
XFILLER_84_191 VPWR VGND sg13cmos5l_fill_1
XFILLER_431_84 VPWR VGND sg13cmos5l_decap_8
XFILLER_232_112 VPWR VGND sg13cmos5l_decap_8
XFILLER_168_0 VPWR VGND sg13cmos5l_decap_8
XFILLER_217_197 VPWR VGND sg13cmos5l_fill_1
XFILLER_150_74 VPWR VGND sg13cmos5l_decap_8
XFILLER_622_194 VPWR VGND sg13cmos5l_decap_4
XFILLER_709_210 VPWR VGND sg13cmos5l_decap_8
XFILLER_657_14 VPWR VGND sg13cmos5l_decap_8
XFILLER_232_189 VPWR VGND sg13cmos5l_decap_8
XANTENNA__3468__X Tile_X0Y1_FrameData_O[26] VPWR VGND sg13cmos5l_antennanp
XFILLER_335_0 VPWR VGND sg13cmos5l_decap_8
XFILLER_40_261 VPWR VGND sg13cmos5l_decap_8
XFILLER_376_15 VPWR VGND sg13cmos5l_decap_8
XFILLER_40_272 VPWR VGND sg13cmos5l_fill_1
XFILLER_502_0 VPWR VGND sg13cmos5l_decap_8
XFILLER_138_182 VPWR VGND sg13cmos5l_decap_8
XFILLER_696_109 VPWR VGND sg13cmos5l_fill_1
XFILLER_673_35 VPWR VGND sg13cmos5l_decap_8
XFILLER_456_70 VPWR VGND sg13cmos5l_decap_8
XFILLER_153_141 VPWR VGND sg13cmos5l_decap_8
XFILLER_392_14 VPWR VGND sg13cmos5l_decap_8
XFILLER_689_183 VPWR VGND sg13cmos5l_decap_8
XFILLER_309_97 VPWR VGND sg13cmos5l_decap_8
XFILLER_673_79 VPWR VGND sg13cmos5l_decap_4
XFILLER_488_234 VPWR VGND sg13cmos5l_decap_8
XFILLER_153_163 VPWR VGND sg13cmos5l_decap_8
XFILLER_488_245 VPWR VGND sg13cmos5l_decap_8
XFILLER_488_256 VPWR VGND sg13cmos5l_fill_1
X_1440_ _1440_/Q Tile_X0Y2_FrameData[17] VGND VPWR Tile_X0Y9_FrameStrobe[0] latch
XFILLER_175_93 VPWR VGND sg13cmos5l_decap_8
XFILLER_637_209 VPWR VGND sg13cmos5l_decap_8
XFILLER_542_28 VPWR VGND sg13cmos5l_decap_8
X_1371_ _1371_/Q Tile_X0Y1_FrameData[30] VGND VPWR Tile_X0Y9_FrameStrobe[6] latch
XFILLER_4_77 VPWR VGND sg13cmos5l_decap_8
X_3110_ Tile_X0Y7_E6BEG[8] _4652_/X VPWR VGND sg13cmos5l_buf_1
XFILLER_645_231 VPWR VGND sg13cmos5l_decap_8
X_0322_ _0322_/Q Tile_X0Y7_FrameData[29] VGND VPWR Tile_X0Y9_FrameStrobe[5] latch
X_4090_ _4090_/X Tile_X0Y1_W1END[1] Tile_X0Y1_W6END[9] _4002_/X _3977_/X _1387_/Q
+ _1386_/Q VPWR VGND sg13cmos5l_mux4_1
XFILLER_68_91 VPWR VGND sg13cmos5l_decap_8
XFILLER_310_182 VPWR VGND sg13cmos5l_decap_8
XFILLER_67_147 VPWR VGND sg13cmos5l_decap_8
XFILLER_255_215 VPWR VGND sg13cmos5l_decap_8
XFILLER_660_201 VPWR VGND sg13cmos5l_decap_8
XFILLER_255_226 VPWR VGND sg13cmos5l_fill_2
X_3041_ Tile_X0Y5_FrameData_O[0] Tile_X0Y5_FrameData[0] VPWR VGND sg13cmos5l_buf_1
X_0253_ _0253_/Q Tile_X0Y7_FrameData[2] VGND VPWR Tile_X0Y9_FrameStrobe[2] latch
XFILLER_456_197 VPWR VGND sg13cmos5l_decap_4
XFILLER_82_117 VPWR VGND sg13cmos5l_decap_8
XFILLER_660_234 VPWR VGND sg13cmos5l_decap_8
XFILLER_698_21 VPWR VGND sg13cmos5l_decap_8
XFILLER_471_156 VPWR VGND sg13cmos5l_fill_2
XFILLER_75_180 VPWR VGND sg13cmos5l_decap_8
X_0184_ _0184_/Q Tile_X0Y7_FrameData[7] VGND VPWR Tile_X0Y9_FrameStrobe[0] latch
XFILLER_208_175 VPWR VGND sg13cmos5l_decap_8
XFILLER_263_270 VPWR VGND sg13cmos5l_fill_2
XFILLER_412_212 VPWR VGND sg13cmos5l_decap_8
XFILLER_369_105 VPWR VGND sg13cmos5l_fill_2
XFILLER_558_205 VPWR VGND sg13cmos5l_fill_1
XFILLER_698_98 VPWR VGND sg13cmos5l_decap_8
XFILLER_412_256 VPWR VGND sg13cmos5l_decap_8
X_3943_ _3943_/X Tile_X0Y1_W2END[4] AXI_M_SOC_ARREADY _3995_/X _3994_/X _1323_/Q _1322_/Q
+ VPWR VGND sg13cmos5l_mux4_1
XFILLER_567_14 VPWR VGND sg13cmos5l_decap_8
XANTENNA__3378__X Tile_X0Y2_E6BEG[1] VPWR VGND sg13cmos5l_antennanp
XFILLER_210_77 VPWR VGND sg13cmos5l_decap_8
XFILLER_31_250 VPWR VGND sg13cmos5l_decap_4
X_3874_ _3874_/X _4342_/X _4346_/X _4350_/X _4317_/X _2151_/Q _2150_/Q VPWR VGND sg13cmos5l_mux4_1
XFILLER_83_0 VPWR VGND sg13cmos5l_decap_8
XFILLER_715_224 VPWR VGND sg13cmos5l_decap_4
X_2825_ Tile_X0Y4_E2BEG[3] _4259_/X VPWR VGND sg13cmos5l_buf_1
XFILLER_647_91 VPWR VGND sg13cmos5l_decap_8
XFILLER_219_42 VPWR VGND sg13cmos5l_decap_8
XFILLER_129_171 VPWR VGND sg13cmos5l_decap_8
X_2756_ Tile_X0Y3_FrameData_O[14] Tile_X0Y3_FrameData[14] VPWR VGND sg13cmos5l_buf_1
XFILLER_583_35 VPWR VGND sg13cmos5l_decap_8
XFILLER_191_269 VPWR VGND sg13cmos5l_decap_4
XFILLER_479_212 VPWR VGND sg13cmos5l_decap_8
XFILLER_333_230 VPWR VGND sg13cmos5l_decap_8
XFILLER_219_97 VPWR VGND sg13cmos5l_decap_8
X_1707_ _1707_/Q Tile_X0Y3_FrameData[30] VGND VPWR Tile_X0Y9_FrameStrobe[1] latch
X_2687_ _2687_/Q Tile_X0Y6_FrameData[8] VGND VPWR Tile_X0Y9_FrameStrobe[7] latch
X_1638_ _1638_/Q Tile_X0Y2_FrameData[11] VGND VPWR Tile_X0Y9_FrameStrobe[6] latch
X_4426_ _4426_/X Tile_X0Y4_W1END[3] Tile_X0Y4_W6END[11] _4351_/X _4309_/X _2139_/Q
+ _2138_/Q VPWR VGND sg13cmos5l_mux4_1
XFILLER_144_196 VPWR VGND sg13cmos5l_decap_8
XFILLER_516_84 VPWR VGND sg13cmos5l_decap_4
XFILLER_452_28 VPWR VGND sg13cmos5l_decap_8
XFILLER_235_63 VPWR VGND sg13cmos5l_decap_8
X_1569_ _1569_/Q Tile_X0Y2_FrameData[16] VGND VPWR Tile_X0Y9_FrameStrobe[4] latch
X_4357_ _4357_/X Tile_X0Y6_W2MID[5] Tile_X0Y6_W2END[5] Tile_X0Y6_W6END[5] _4557_/X
+ _2683_/Q _2682_/Q VPWR VGND sg13cmos5l_mux4_1
XFILLER_98_272 VPWR VGND sg13cmos5l_fill_1
X_3308_ Tile_X0Y0_E1BEG[0] _3800_/X VPWR VGND sg13cmos5l_buf_1
X_4288_ _4288_/X _0099_/X _0112_/X _4347_/X _4351_/X _2037_/Q _2036_/Q VPWR VGND sg13cmos5l_mux4_1
XFILLER_58_158 VPWR VGND sg13cmos5l_decap_8
XFILLER_447_186 VPWR VGND sg13cmos5l_decap_8
X_3239_ Tile_X0Y0_FrameData_O[7] Tile_X0Y0_FrameData[7] VPWR VGND sg13cmos5l_buf_1
XFILLER_104_56 VPWR VGND sg13cmos5l_fill_1
XFILLER_651_245 VPWR VGND sg13cmos5l_decap_8
XFILLER_651_256 VPWR VGND sg13cmos5l_fill_2
XFILLER_73_139 VPWR VGND sg13cmos5l_fill_1
XFILLER_462_167 VPWR VGND sg13cmos5l_decap_4
XFILLER_104_78 VPWR VGND sg13cmos5l_decap_8
XFILLER_251_84 VPWR VGND sg13cmos5l_decap_8
XFILLER_64_49 VPWR VGND sg13cmos5l_decap_8
XFILLER_214_112 VPWR VGND sg13cmos5l_decap_8
XFILLER_401_43 VPWR VGND sg13cmos5l_decap_8
XFILLER_477_14 VPWR VGND sg13cmos5l_decap_8
XANTENNA__3288__X Tile_X0Y0_E6BEG[8] VPWR VGND sg13cmos5l_antennanp
XFILLER_120_66 VPWR VGND sg13cmos5l_fill_2
XFILLER_564_219 VPWR VGND sg13cmos5l_decap_8
XFILLER_557_260 VPWR VGND sg13cmos5l_decap_8
XFILLER_426_7 VPWR VGND sg13cmos5l_decap_8
XFILLER_557_271 VPWR VGND sg13cmos5l_fill_2
XFILLER_517_124 VPWR VGND sg13cmos5l_decap_4
XFILLER_517_135 VPWR VGND sg13cmos5l_decap_8
XFILLER_13_42 VPWR VGND sg13cmos5l_decap_8
XFILLER_627_28 VPWR VGND sg13cmos5l_decap_8
XFILLER_572_252 VPWR VGND sg13cmos5l_decap_8
XFILLER_572_263 VPWR VGND sg13cmos5l_fill_2
XANTENNA__2920__X Tile_X0Y8_E2BEG[4] VPWR VGND sg13cmos5l_antennanp
XFILLER_129_42 VPWR VGND sg13cmos5l_decap_8
XFILLER_383_196 VPWR VGND sg13cmos5l_decap_8
XFILLER_493_35 VPWR VGND sg13cmos5l_decap_8
XFILLER_276_70 VPWR VGND sg13cmos5l_decap_8
XFILLER_89_35 VPWR VGND sg13cmos5l_decap_8
XFILLER_135_141 VPWR VGND sg13cmos5l_decap_8
XFILLER_686_142 VPWR VGND sg13cmos5l_decap_8
XFILLER_643_49 VPWR VGND sg13cmos5l_decap_8
XFILLER_540_182 VPWR VGND sg13cmos5l_decap_8
XFILLER_426_84 VPWR VGND sg13cmos5l_decap_8
XFILLER_145_63 VPWR VGND sg13cmos5l_decap_8
XFILLER_362_28 VPWR VGND sg13cmos5l_decap_8
XFILLER_485_248 VPWR VGND sg13cmos5l_decap_8
XANTENNA__3751__X AXI_M_SOC_ARADDR23 VPWR VGND sg13cmos5l_antennanp
XFILLER_145_74 VPWR VGND sg13cmos5l_fill_1
XFILLER_292_91 VPWR VGND sg13cmos5l_decap_8
XFILLER_145_96 VPWR VGND sg13cmos5l_decap_8
XFILLER_627_253 VPWR VGND sg13cmos5l_decap_4
XFILLER_442_50 VPWR VGND sg13cmos5l_decap_8
XFILLER_285_0 VPWR VGND sg13cmos5l_decap_8
XFILLER_237_248 VPWR VGND sg13cmos5l_decap_8
XFILLER_442_94 VPWR VGND sg13cmos5l_decap_8
XFILLER_38_72 VPWR VGND sg13cmos5l_decap_8
XFILLER_642_245 VPWR VGND sg13cmos5l_decap_8
XFILLER_453_156 VPWR VGND sg13cmos5l_fill_1
XFILLER_642_256 VPWR VGND sg13cmos5l_fill_2
XFILLER_252_229 VPWR VGND sg13cmos5l_decap_4
XFILLER_452_0 VPWR VGND sg13cmos5l_decap_8
XFILLER_245_270 VPWR VGND sg13cmos5l_fill_2
XFILLER_205_112 VPWR VGND sg13cmos5l_decap_8
XFILLER_311_43 VPWR VGND sg13cmos5l_decap_8
XFILLER_72_150 VPWR VGND sg13cmos5l_decap_8
XFILLER_668_35 VPWR VGND sg13cmos5l_decap_8
XFILLER_610_131 VPWR VGND sg13cmos5l_decap_8
XFILLER_387_14 VPWR VGND sg13cmos5l_decap_8
XANTENNA__3198__X Tile_X0Y0_N2BEGb[6] VPWR VGND sg13cmos5l_antennanp
XFILLER_555_208 VPWR VGND sg13cmos5l_decap_8
XFILLER_359_160 VPWR VGND sg13cmos5l_decap_8
XFILLER_13_250 VPWR VGND sg13cmos5l_decap_8
X_0940_ _0940_/Q Tile_X0Y9_FrameData[31] VGND VPWR Tile_X0Y9_FrameStrobe[8] latch
XFILLER_548_271 VPWR VGND sg13cmos5l_fill_2
XFILLER_9_221 VPWR VGND sg13cmos5l_decap_8
XFILLER_359_193 VPWR VGND sg13cmos5l_decap_8
X_0871_ _0871_/Q Tile_X0Y9_FrameData[24] VGND VPWR Tile_X0Y9_FrameStrobe[6] latch
XFILLER_537_28 VPWR VGND sg13cmos5l_decap_8
XANTENNA__2830__X Tile_X0Y4_UserCLKo VPWR VGND sg13cmos5l_antennanp
X_2610_ _2610_/Q Tile_X0Y6_FrameData[21] VGND VPWR Tile_X0Y9_FrameStrobe[5] latch
XFILLER_523_105 VPWR VGND sg13cmos5l_decap_8
XFILLER_173_236 VPWR VGND sg13cmos5l_decap_4
X_3590_ Tile_X0Y9_FrameData_O[20] Tile_X0Y9_FrameData[20] VPWR VGND sg13cmos5l_buf_1
XFILLER_70_92 VPWR VGND sg13cmos5l_decap_8
XFILLER_173_247 VPWR VGND sg13cmos5l_decap_8
XFILLER_684_89 VPWR VGND sg13cmos5l_decap_8
XFILLER_173_258 VPWR VGND sg13cmos5l_fill_1
XFILLER_186_81 VPWR VGND sg13cmos5l_decap_8
XFILLER_712_238 VPWR VGND sg13cmos5l_decap_8
X_2541_ _2541_/Q Tile_X0Y6_FrameData[26] VGND VPWR Tile_X0Y9_FrameStrobe[3] latch
XFILLER_315_230 VPWR VGND sg13cmos5l_decap_8
XFILLER_617_94 VPWR VGND sg13cmos5l_fill_2
XFILLER_677_131 VPWR VGND sg13cmos5l_decap_8
X_2472_ _2472_/Q Tile_X0Y6_FrameData[31] VGND VPWR Tile_X0Y9_FrameStrobe[1] latch
XFILLER_553_49 VPWR VGND sg13cmos5l_decap_8
XFILLER_141_144 VPWR VGND sg13cmos5l_decap_8
XFILLER_692_101 VPWR VGND sg13cmos5l_decap_8
XFILLER_531_193 VPWR VGND sg13cmos5l_decap_8
XFILLER_287_126 VPWR VGND sg13cmos5l_decap_8
X_1423_ _1423_/Q Tile_X0Y1_FrameData[10] VGND VPWR Tile_X0Y9_FrameStrobe[7] latch
X_4211_ _4211_/X _4135_/X _4243_/X _4242_/X _4134_/X _1691_/Q _1690_/Q VPWR VGND sg13cmos5l_mux4_1
XFILLER_272_28 VPWR VGND sg13cmos5l_decap_8
XFILLER_330_255 VPWR VGND sg13cmos5l_decap_8
XANTENNA__3661__X AXI_M_SOC_AWADDR22 VPWR VGND sg13cmos5l_antennanp
XFILLER_476_259 VPWR VGND sg13cmos5l_fill_2
X_4142_ _4142_/X Tile_X0Y1_W1END[3] Tile_X0Y1_W2MID[0] Tile_X0Y1_W2END[0] _3988_/X
+ _1367_/Q _1366_/Q VPWR VGND sg13cmos5l_mux4_1
X_1354_ _1354_/Q Tile_X0Y1_FrameData[15] VGND VPWR Tile_X0Y9_FrameStrobe[5] latch
XFILLER_692_178 VPWR VGND sg13cmos5l_decap_8
XFILLER_491_218 VPWR VGND sg13cmos5l_decap_8
XFILLER_429_175 VPWR VGND sg13cmos5l_decap_8
XFILLER_228_226 VPWR VGND sg13cmos5l_decap_8
X_0305_ _0305_/Q Tile_X0Y7_FrameData[14] VGND VPWR Tile_X0Y9_FrameStrobe[4] latch
XFILLER_205_77 VPWR VGND sg13cmos5l_decap_8
X_4073_ _4073_/X _0064_/X Tile_X0Y0_S4END[9] _4126_/X _4107_/X _1527_/Q _1526_/Q VPWR
+ VGND sg13cmos5l_mux4_1
X_1285_ _1285_/Q Tile_X0Y1_FrameData[20] VGND VPWR Tile_X0Y9_FrameStrobe[3] latch
X_3024_ Tile_X0Y5_E6BEG[11] _4415_/X VPWR VGND sg13cmos5l_buf_1
XFILLER_502_42 VPWR VGND sg13cmos5l_decap_8
XFILLER_243_207 VPWR VGND sg13cmos5l_fill_2
X_0236_ _0236_/Q Tile_X0Y7_FrameData[19] VGND VPWR Tile_X0Y9_FrameStrobe[2] latch
XFILLER_221_21 VPWR VGND sg13cmos5l_decap_8
X_0167_ _0167_/Q Tile_X0Y7_FrameData[24] VGND VPWR Tile_X0Y9_FrameStrobe[0] latch
XFILLER_251_240 VPWR VGND sg13cmos5l_decap_8
XFILLER_221_76 VPWR VGND sg13cmos5l_decap_8
XFILLER_578_35 VPWR VGND sg13cmos5l_decap_8
XFILLER_601_153 VPWR VGND sg13cmos5l_decap_8
X_0098_ _3634_/A _4836_/X _4837_/X _0865_/Q VPWR VGND sg13cmos5l_mux2_1
XFILLER_211_126 VPWR VGND sg13cmos5l_decap_8
XFILLER_297_36 VPWR VGND sg13cmos5l_decap_8
XFILLER_357_119 VPWR VGND sg13cmos5l_decap_8
X_3926_ _3926_/X Tile_X0Y3_W1END[0] Tile_X0Y3_WW4END[0] Tile_X0Y3_W6END[8] _4222_/X
+ _1901_/Q _1900_/Q VPWR VGND sg13cmos5l_mux4_1
XFILLER_447_28 VPWR VGND sg13cmos5l_decap_8
XFILLER_109_108 VPWR VGND sg13cmos5l_decap_8
X_3857_ _3857_/X _3893_/X _3892_/X Tile_X0Y0_S2MID[2] Tile_X0Y0_S2END[2] _0959_/Q
+ _0958_/Q VPWR VGND sg13cmos5l_mux4_1
XFILLER_164_203 VPWR VGND sg13cmos5l_fill_2
XFILLER_594_56 VPWR VGND sg13cmos5l_decap_8
XANTENNA__2740__X Tile_X0Y4_E1BEG[3] VPWR VGND sg13cmos5l_antennanp
XFILLER_514_105 VPWR VGND sg13cmos5l_decap_8
X_2808_ Tile_X0Y3_E2BEGb[6] _4162_/X VPWR VGND sg13cmos5l_buf_1
X_3788_ _3788_/X Tile_X0Y0_W2MID[3] Tile_X0Y0_W2END[3] Tile_X0Y0_W6END[3] _3858_/X
+ _1161_/Q _1160_/Q VPWR VGND sg13cmos5l_mux4_1
XFILLER_703_227 VPWR VGND sg13cmos5l_decap_8
XFILLER_380_133 VPWR VGND sg13cmos5l_decap_8
X_2739_ Tile_X0Y4_E1BEG[2] _4254_/X VPWR VGND sg13cmos5l_buf_1
XFILLER_668_142 VPWR VGND sg13cmos5l_decap_8
XFILLER_321_200 VPWR VGND sg13cmos5l_decap_8
XFILLER_711_271 VPWR VGND sg13cmos5l_fill_2
XFILLER_59_27 VPWR VGND sg13cmos5l_fill_2
XFILLER_132_133 VPWR VGND sg13cmos5l_decap_4
XFILLER_393_90 VPWR VGND sg13cmos5l_decap_8
X_4409_ _4409_/X AXI_M_SOC_RLAST _4457_/X _4461_/X _4430_/X _2285_/Q _2284_/Q VPWR
+ VGND sg13cmos5l_mux4_1
XFILLER_132_166 VPWR VGND sg13cmos5l_decap_8
XANTENNA__3571__X Tile_X0Y9_FrameData_O[1] VPWR VGND sg13cmos5l_antennanp
XFILLER_683_178 VPWR VGND sg13cmos5l_decap_8
XFILLER_86_242 VPWR VGND sg13cmos5l_decap_8
XFILLER_624_201 VPWR VGND sg13cmos5l_decap_8
XFILLER_435_112 VPWR VGND sg13cmos5l_decap_8
XFILLER_624_256 VPWR VGND sg13cmos5l_decap_8
XFILLER_490_251 VPWR VGND sg13cmos5l_decap_8
XFILLER_46_139 VPWR VGND sg13cmos5l_decap_8
XFILLER_412_64 VPWR VGND sg13cmos5l_decap_8
XFILLER_131_43 VPWR VGND sg13cmos5l_decap_8
XANTENNA__2915__X Tile_X0Y8_E1BEG[3] VPWR VGND sg13cmos5l_antennanp
XFILLER_54_150 VPWR VGND sg13cmos5l_fill_1
XFILLER_543_7 VPWR VGND sg13cmos5l_decap_8
XFILLER_91_14 VPWR VGND sg13cmos5l_decap_8
XFILLER_54_172 VPWR VGND sg13cmos5l_decap_8
XFILLER_488_35 VPWR VGND sg13cmos5l_decap_8
XFILLER_242_240 VPWR VGND sg13cmos5l_decap_8
XFILLER_388_266 VPWR VGND sg13cmos5l_decap_8
XFILLER_202_126 VPWR VGND sg13cmos5l_fill_1
XFILLER_348_119 VPWR VGND sg13cmos5l_decap_8
XFILLER_710_7 VPWR VGND sg13cmos5l_decap_8
XFILLER_202_148 VPWR VGND sg13cmos5l_decap_8
XFILLER_638_49 VPWR VGND sg13cmos5l_decap_8
XFILLER_357_28 VPWR VGND sg13cmos5l_decap_8
XFILLER_10_231 VPWR VGND sg13cmos5l_decap_8
XFILLER_10_242 VPWR VGND sg13cmos5l_fill_1
XANTENNA__3746__X AXI_M_SOC_ARADDR18 VPWR VGND sg13cmos5l_antennanp
XFILLER_155_214 VPWR VGND sg13cmos5l_decap_8
XFILLER_545_263 VPWR VGND sg13cmos5l_decap_8
XFILLER_287_91 VPWR VGND sg13cmos5l_decap_8
XFILLER_505_105 VPWR VGND sg13cmos5l_decap_4
XFILLER_6_224 VPWR VGND sg13cmos5l_decap_4
XFILLER_356_196 VPWR VGND sg13cmos5l_decap_8
XFILLER_560_233 VPWR VGND sg13cmos5l_decap_8
XFILLER_654_48 VPWR VGND sg13cmos5l_decap_8
XFILLER_40_62 VPWR VGND sg13cmos5l_decap_4
XFILLER_156_40 VPWR VGND sg13cmos5l_fill_2
XFILLER_200_0 VPWR VGND sg13cmos5l_decap_8
XFILLER_659_131 VPWR VGND sg13cmos5l_fill_1
XFILLER_40_95 VPWR VGND sg13cmos5l_decap_4
XFILLER_123_111 VPWR VGND sg13cmos5l_fill_1
XFILLER_702_260 VPWR VGND sg13cmos5l_fill_1
XFILLER_108_196 VPWR VGND sg13cmos5l_decap_4
XFILLER_458_204 VPWR VGND sg13cmos5l_decap_8
XFILLER_156_84 VPWR VGND sg13cmos5l_decap_8
XFILLER_306_21 VPWR VGND sg13cmos5l_decap_8
XFILLER_458_226 VPWR VGND sg13cmos5l_decap_8
XFILLER_674_112 VPWR VGND sg13cmos5l_decap_8
XFILLER_670_14 VPWR VGND sg13cmos5l_decap_8
XANTENNA__3481__X Tile_X0Y1_EE4BEG[7] VPWR VGND sg13cmos5l_antennanp
XFILLER_269_159 VPWR VGND sg13cmos5l_decap_8
XFILLER_674_156 VPWR VGND sg13cmos5l_decap_8
XFILLER_77_220 VPWR VGND sg13cmos5l_decap_8
XFILLER_674_167 VPWR VGND sg13cmos5l_fill_2
XFILLER_453_93 VPWR VGND sg13cmos5l_fill_2
XFILLER_172_61 VPWR VGND sg13cmos5l_decap_8
XFILLER_667_0 VPWR VGND sg13cmos5l_decap_8
XFILLER_426_112 VPWR VGND sg13cmos5l_decap_8
XFILLER_603_63 VPWR VGND sg13cmos5l_decap_8
XFILLER_1_56 VPWR VGND sg13cmos5l_decap_8
XFILLER_615_256 VPWR VGND sg13cmos5l_decap_8
X_1070_ _1070_/Q Tile_X0Y0_FrameData[29] VGND VPWR Tile_X0Y9_FrameStrobe[4] latch
XFILLER_322_53 VPWR VGND sg13cmos5l_decap_8
XFILLER_426_189 VPWR VGND sg13cmos5l_decap_8
XFILLER_1_89 VPWR VGND sg13cmos5l_fill_2
XFILLER_65_70 VPWR VGND sg13cmos5l_decap_8
XANTENNA__2825__X Tile_X0Y4_E2BEG[3] VPWR VGND sg13cmos5l_antennanp
XFILLER_379_211 VPWR VGND sg13cmos5l_decap_8
XFILLER_45_172 VPWR VGND sg13cmos5l_decap_8
XFILLER_441_159 VPWR VGND sg13cmos5l_decap_8
XFILLER_398_35 VPWR VGND sg13cmos5l_decap_8
XANTENNA_160 Tile_X0Y9_FrameStrobe[8] VPWR VGND sg13cmos5l_antennanp
XANTENNA_171 Tile_X0Y9_FrameStrobe[8] VPWR VGND sg13cmos5l_antennanp
XFILLER_398_79 VPWR VGND sg13cmos5l_fill_1
XANTENNA_182 Tile_X0Y9_FrameStrobe[8] VPWR VGND sg13cmos5l_antennanp
XFILLER_339_119 VPWR VGND sg13cmos5l_decap_8
XANTENNA_193 Tile_X0Y9_N2MID[1] VPWR VGND sg13cmos5l_antennanp
XFILLER_60_153 VPWR VGND sg13cmos5l_decap_8
X_4760_ _4760_/X Tile_X0Y9_N4END[4] _0077_/X _4811_/X _4815_/X _0527_/Q _0526_/Q VPWR
+ VGND sg13cmos5l_mux4_1
X_1972_ _1972_/Q Tile_X0Y4_FrameData[17] VGND VPWR Tile_X0Y9_FrameStrobe[1] latch
XFILLER_595_196 VPWR VGND sg13cmos5l_fill_2
XFILLER_548_49 VPWR VGND sg13cmos5l_decap_8
XFILLER_394_247 VPWR VGND sg13cmos5l_decap_8
X_3711_ AXI_M_SOC_WDATA21 Tile_X0Y6_WW4END[5] Tile_X0Y6_WW4END[13] Tile_X0Y6_W6END[5]
+ _4573_/X _2517_/Q _2516_/Q VPWR VGND sg13cmos5l_mux4_1
XFILLER_695_77 VPWR VGND sg13cmos5l_decap_8
X_0923_ _0923_/Q Tile_X0Y9_FrameData[4] VGND VPWR Tile_X0Y9_FrameStrobe[7] latch
XFILLER_267_28 VPWR VGND sg13cmos5l_decap_8
X_4691_ _4691_/X _4667_/X Tile_X0Y9_N4END[11] _4666_/X _0053_/X _0201_/Q _0200_/Q
+ VPWR VGND sg13cmos5l_mux4_1
XANTENNA__3656__X AXI_M_SOC_AWADDR17 VPWR VGND sg13cmos5l_antennanp
XFILLER_628_71 VPWR VGND sg13cmos5l_decap_8
XFILLER_146_225 VPWR VGND sg13cmos5l_fill_1
X_0854_ _0854_/Q Tile_X0Y9_FrameData[9] VGND VPWR Tile_X0Y9_FrameStrobe[5] latch
X_3642_ AXI_M_SOC_AWADDR3 Tile_X0Y5_WW4END[3] Tile_X0Y5_WW4END[11] Tile_X0Y5_W6END[3]
+ _4454_/X _2265_/Q _2264_/Q VPWR VGND sg13cmos5l_mux4_1
XFILLER_697_204 VPWR VGND sg13cmos5l_decap_8
XFILLER_362_155 VPWR VGND sg13cmos5l_decap_8
X_0785_ _0785_/Q Tile_X0Y9_FrameData[14] VGND VPWR Tile_X0Y9_FrameStrobe[3] latch
X_3573_ Tile_X0Y9_FrameData_O[3] Tile_X0Y9_FrameData[3] VPWR VGND sg13cmos5l_buf_1
XFILLER_161_239 VPWR VGND sg13cmos5l_decap_8
XFILLER_114_122 VPWR VGND sg13cmos5l_decap_4
X_2524_ _2524_/Q Tile_X0Y6_FrameData[11] VGND VPWR Tile_X0Y9_FrameStrobe[2] latch
XFILLER_283_49 VPWR VGND sg13cmos5l_decap_8
XFILLER_644_70 VPWR VGND sg13cmos5l_decap_8
XFILLER_449_215 VPWR VGND sg13cmos5l_decap_8
XFILLER_216_21 VPWR VGND sg13cmos5l_decap_8
XFILLER_46_0 VPWR VGND sg13cmos5l_decap_4
XFILLER_303_244 VPWR VGND sg13cmos5l_decap_8
XFILLER_665_112 VPWR VGND sg13cmos5l_decap_8
X_2455_ _2455_/Q Tile_X0Y6_FrameData[16] VGND VPWR Tile_X0Y9_FrameStrobe[0] latch
XFILLER_580_14 VPWR VGND sg13cmos5l_decap_8
XFILLER_303_255 VPWR VGND sg13cmos5l_decap_8
XFILLER_114_177 VPWR VGND sg13cmos5l_decap_8
XANTENNA__3391__X Tile_X0Y2_E2BEGb[2] VPWR VGND sg13cmos5l_antennanp
XFILLER_275_107 VPWR VGND sg13cmos5l_decap_8
XFILLER_216_87 VPWR VGND sg13cmos5l_fill_2
X_1406_ _1406_/Q Tile_X0Y1_FrameData[27] VGND VPWR Tile_X0Y9_FrameStrobe[7] latch
X_2386_ _2386_/Q Tile_X0Y5_FrameData[19] VGND VPWR Tile_X0Y9_FrameStrobe[6] latch
XFILLER_68_231 VPWR VGND sg13cmos5l_decap_8
XFILLER_680_104 VPWR VGND sg13cmos5l_fill_2
XFILLER_417_112 VPWR VGND sg13cmos5l_decap_8
X_1337_ _1337_/Q Tile_X0Y1_FrameData[0] VGND VPWR Tile_X0Y9_FrameStrobe[4] latch
X_4125_ _4125_/X _4091_/X _0064_/X _4090_/X Tile_X0Y0_S4END[9] _1463_/Q _1462_/Q VPWR
+ VGND sg13cmos5l_mux4_1
XFILLER_513_63 VPWR VGND sg13cmos5l_decap_8
XFILLER_28_117 VPWR VGND sg13cmos5l_decap_8
XFILLER_283_140 VPWR VGND sg13cmos5l_decap_8
XFILLER_660_91 VPWR VGND sg13cmos5l_decap_8
XFILLER_606_245 VPWR VGND sg13cmos5l_decap_8
XFILLER_472_240 VPWR VGND sg13cmos5l_decap_8
XFILLER_216_207 VPWR VGND sg13cmos5l_decap_8
XFILLER_83_223 VPWR VGND sg13cmos5l_decap_8
XFILLER_606_256 VPWR VGND sg13cmos5l_fill_2
X_1268_ _1268_/Q Tile_X0Y1_FrameData[5] VGND VPWR Tile_X0Y9_FrameStrobe[2] latch
X_4056_ _4056_/X Tile_X0Y2_WW4END[15] AXI_M_SOC_AWREADY _4104_/X _4096_/X _1561_/Q
+ _1560_/Q VPWR VGND sg13cmos5l_mux4_1
XFILLER_232_64 VPWR VGND sg13cmos5l_decap_8
XFILLER_417_189 VPWR VGND sg13cmos5l_decap_8
XFILLER_621_215 VPWR VGND sg13cmos5l_fill_1
XFILLER_432_126 VPWR VGND sg13cmos5l_decap_8
XFILLER_589_56 VPWR VGND sg13cmos5l_decap_8
XFILLER_578_119 VPWR VGND sg13cmos5l_decap_8
X_0219_ _0219_/Q Tile_X0Y7_FrameData[4] VGND VPWR Tile_X0Y9_FrameStrobe[1] latch
X_3007_ Tile_X0Y5_E2BEGb[2] _4382_/X VPWR VGND sg13cmos5l_buf_1
XFILLER_621_237 VPWR VGND sg13cmos5l_decap_8
X_1199_ _1199_/Q Tile_X0Y1_FrameData[10] VGND VPWR Tile_X0Y9_FrameStrobe[0] latch
XFILLER_589_89 VPWR VGND sg13cmos5l_decap_8
XFILLER_440_192 VPWR VGND sg13cmos5l_decap_8
XFILLER_385_225 VPWR VGND sg13cmos5l_decap_8
XFILLER_131_8 VPWR VGND sg13cmos5l_decap_8
X_3909_ _3909_/X _4013_/X _4017_/X _4002_/X _3991_/X _1398_/Q _1397_/Q VPWR VGND sg13cmos5l_mux4_1
XANTENNA__3566__X Tile_X0Y9_EE4BEG[12] VPWR VGND sg13cmos5l_antennanp
X_4889_ _4889_/X AXI_M_SOC_RDATA5 _4918_/X _4922_/X _4904_/X _0765_/Q _0764_/Q VPWR
+ VGND sg13cmos5l_mux4_1
XFILLER_527_263 VPWR VGND sg13cmos5l_fill_1
XFILLER_137_225 VPWR VGND sg13cmos5l_decap_8
XFILLER_124_7 VPWR VGND sg13cmos5l_decap_8
XFILLER_353_133 VPWR VGND sg13cmos5l_decap_8
XFILLER_542_233 VPWR VGND sg13cmos5l_decap_8
XFILLER_499_126 VPWR VGND sg13cmos5l_decap_8
XFILLER_152_206 VPWR VGND sg13cmos5l_decap_8
XFILLER_10_21 VPWR VGND sg13cmos5l_decap_8
XFILLER_502_119 VPWR VGND sg13cmos5l_decap_8
XFILLER_407_42 VPWR VGND sg13cmos5l_decap_8
XFILLER_193_49 VPWR VGND sg13cmos5l_decap_8
XFILLER_554_70 VPWR VGND sg13cmos5l_decap_8
XFILLER_126_21 VPWR VGND sg13cmos5l_decap_8
XFILLER_490_14 VPWR VGND sg13cmos5l_decap_8
XFILLER_407_97 VPWR VGND sg13cmos5l_decap_8
XFILLER_105_166 VPWR VGND sg13cmos5l_decap_8
XFILLER_493_7 VPWR VGND sg13cmos5l_decap_8
XFILLER_120_103 VPWR VGND sg13cmos5l_decap_8
XFILLER_160_272 VPWR VGND sg13cmos5l_fill_1
XFILLER_656_134 VPWR VGND sg13cmos5l_decap_4
XFILLER_86_14 VPWR VGND sg13cmos5l_decap_8
XFILLER_126_98 VPWR VGND sg13cmos5l_decap_8
XFILLER_266_129 VPWR VGND sg13cmos5l_decap_8
XFILLER_120_147 VPWR VGND sg13cmos5l_fill_2
XFILLER_704_84 VPWR VGND sg13cmos5l_decap_8
XFILLER_59_242 VPWR VGND sg13cmos5l_decap_8
XFILLER_660_7 VPWR VGND sg13cmos5l_decap_8
XFILLER_640_28 VPWR VGND sg13cmos5l_decap_8
XFILLER_408_123 VPWR VGND sg13cmos5l_decap_8
XFILLER_423_63 VPWR VGND sg13cmos5l_decap_8
XFILLER_74_212 VPWR VGND sg13cmos5l_decap_8
XFILLER_570_91 VPWR VGND sg13cmos5l_decap_8
XFILLER_463_240 VPWR VGND sg13cmos5l_decap_8
XFILLER_374_4 VPWR VGND sg13cmos5l_fill_1
XFILLER_142_42 VPWR VGND sg13cmos5l_decap_8
XFILLER_74_234 VPWR VGND sg13cmos5l_fill_1
XFILLER_463_262 VPWR VGND sg13cmos5l_decap_8
XANTENNA__0149__Y AXI_M_SOC_AWLEN1 VPWR VGND sg13cmos5l_antennanp
XFILLER_274_173 VPWR VGND sg13cmos5l_decap_8
XFILLER_207_229 VPWR VGND sg13cmos5l_decap_8
XFILLER_408_189 VPWR VGND sg13cmos5l_decap_8
XFILLER_499_56 VPWR VGND sg13cmos5l_decap_8
XFILLER_423_126 VPWR VGND sg13cmos5l_decap_8
XFILLER_612_237 VPWR VGND sg13cmos5l_decap_8
XFILLER_569_119 VPWR VGND sg13cmos5l_decap_8
XFILLER_27_150 VPWR VGND sg13cmos5l_fill_1
XFILLER_215_251 VPWR VGND sg13cmos5l_decap_8
XFILLER_150_0 VPWR VGND sg13cmos5l_decap_8
XFILLER_187_103 VPWR VGND sg13cmos5l_decap_8
XFILLER_376_203 VPWR VGND sg13cmos5l_decap_8
XFILLER_230_221 VPWR VGND sg13cmos5l_fill_2
XFILLER_620_270 VPWR VGND sg13cmos5l_fill_2
XFILLER_248_0 VPWR VGND sg13cmos5l_decap_8
XFILLER_577_185 VPWR VGND sg13cmos5l_decap_8
XFILLER_665_14 VPWR VGND sg13cmos5l_decap_8
XFILLER_518_241 VPWR VGND sg13cmos5l_decap_8
XFILLER_329_152 VPWR VGND sg13cmos5l_decap_8
XFILLER_592_166 VPWR VGND sg13cmos5l_decap_8
XFILLER_391_217 VPWR VGND sg13cmos5l_decap_8
XANTENNA__3476__X Tile_X0Y1_EE4BEG[2] VPWR VGND sg13cmos5l_antennanp
XFILLER_415_0 VPWR VGND sg13cmos5l_decap_8
XFILLER_533_200 VPWR VGND sg13cmos5l_decap_8
XFILLER_533_211 VPWR VGND sg13cmos5l_fill_2
XFILLER_679_204 VPWR VGND sg13cmos5l_decap_8
XFILLER_344_133 VPWR VGND sg13cmos5l_decap_8
XFILLER_679_237 VPWR VGND sg13cmos5l_decap_4
XFILLER_344_199 VPWR VGND sg13cmos5l_decap_8
X_0570_ _0570_/Q Tile_X0Y8_FrameData[5] VGND VPWR Tile_X0Y9_FrameStrobe[4] latch
XFILLER_681_35 VPWR VGND sg13cmos5l_decap_8
XFILLER_464_70 VPWR VGND sg13cmos5l_decap_4
XFILLER_647_112 VPWR VGND sg13cmos5l_decap_8
XFILLER_111_103 VPWR VGND sg13cmos5l_fill_1
XFILLER_151_272 VPWR VGND sg13cmos5l_fill_1
XFILLER_300_214 VPWR VGND sg13cmos5l_decap_8
XFILLER_2_271 VPWR VGND sg13cmos5l_fill_2
XFILLER_257_107 VPWR VGND sg13cmos5l_decap_8
XFILLER_111_125 VPWR VGND sg13cmos5l_decap_8
X_2240_ _2240_/Q Tile_X0Y5_FrameData[5] VGND VPWR Tile_X0Y9_FrameStrobe[1] latch
XFILLER_446_218 VPWR VGND sg13cmos5l_fill_1
XFILLER_614_84 VPWR VGND sg13cmos5l_decap_8
XFILLER_501_196 VPWR VGND sg13cmos5l_decap_8
XFILLER_647_189 VPWR VGND sg13cmos5l_decap_8
X_2171_ _2171_/Q Tile_X0Y4_FrameData[10] VGND VPWR Tile_X0Y9_FrameStrobe[7] latch
XFILLER_550_28 VPWR VGND sg13cmos5l_decap_8
XFILLER_662_148 VPWR VGND sg13cmos5l_decap_8
XFILLER_454_240 VPWR VGND sg13cmos5l_decap_8
X_1122_ _1122_/Q Tile_X0Y0_FrameData[9] VGND VPWR Tile_X0Y9_FrameStrobe[5] latch
XFILLER_265_173 VPWR VGND sg13cmos5l_decap_8
XFILLER_65_245 VPWR VGND sg13cmos5l_decap_8
XFILLER_65_256 VPWR VGND sg13cmos5l_fill_2
XFILLER_603_215 VPWR VGND sg13cmos5l_decap_8
XFILLER_414_115 VPWR VGND sg13cmos5l_fill_1
XFILLER_18_150 VPWR VGND sg13cmos5l_fill_1
X_1053_ _1053_/Q Tile_X0Y0_FrameData[14] VGND VPWR Tile_X0Y9_FrameStrobe[3] latch
XFILLER_670_192 VPWR VGND sg13cmos5l_decap_8
XFILLER_280_154 VPWR VGND sg13cmos5l_decap_8
XFILLER_202_56 VPWR VGND sg13cmos5l_decap_8
XFILLER_33_131 VPWR VGND sg13cmos5l_decap_8
XFILLER_178_114 VPWR VGND sg13cmos5l_decap_8
X_4812_ _4812_/X _4777_/X Tile_X0Y9_N4END[4] _4776_/X _0077_/X _0447_/Q _0446_/Q VPWR
+ VGND sg13cmos5l_mux4_1
XFILLER_717_116 VPWR VGND sg13cmos5l_decap_8
XFILLER_568_196 VPWR VGND sg13cmos5l_decap_8
XFILLER_278_49 VPWR VGND sg13cmos5l_decap_8
XFILLER_639_70 VPWR VGND sg13cmos5l_decap_8
XFILLER_178_169 VPWR VGND sg13cmos5l_decap_4
XFILLER_367_258 VPWR VGND sg13cmos5l_decap_4
X_4743_ _4743_/X Tile_X0Y8_W2END[0] AXI_M_SOC_RDATA8 _4785_/X _4784_/X _0561_/Q _0560_/Q
+ VPWR VGND sg13cmos5l_mux4_1
XFILLER_575_14 VPWR VGND sg13cmos5l_decap_8
X_1955_ _1955_/Q Tile_X0Y4_FrameData[2] VGND VPWR Tile_X0Y9_FrameStrobe[0] latch
XANTENNA__3386__X Tile_X0Y2_E6BEG[9] VPWR VGND sg13cmos5l_antennanp
XFILLER_119_214 VPWR VGND sg13cmos5l_decap_8
XFILLER_382_217 VPWR VGND sg13cmos5l_decap_8
XFILLER_193_139 VPWR VGND sg13cmos5l_decap_8
X_0906_ _0906_/Q Tile_X0Y9_FrameData[21] VGND VPWR Tile_X0Y9_FrameStrobe[7] latch
X_4674_ _4674_/X _4593_/X _4709_/X _4708_/X _4592_/X _0175_/Q _0174_/Q VPWR VGND sg13cmos5l_mux4_1
X_1886_ _1886_/Q Tile_X0Y3_FrameData[11] VGND VPWR Tile_X0Y9_FrameStrobe[6] latch
XFILLER_335_133 VPWR VGND sg13cmos5l_decap_8
XFILLER_335_144 VPWR VGND sg13cmos5l_fill_2
X_3625_ Tile_X0Y9_S4BEG[3] _3625_/A VPWR VGND sg13cmos5l_buf_1
X_0837_ _0837_/Q Tile_X0Y9_FrameData[26] VGND VPWR Tile_X0Y9_FrameStrobe[5] latch
XFILLER_508_63 VPWR VGND sg13cmos5l_decap_8
XFILLER_335_188 VPWR VGND sg13cmos5l_decap_8
X_3556_ Tile_X0Y9_EE4BEG[2] _4866_/X VPWR VGND sg13cmos5l_buf_1
X_0768_ _0768_/Q Tile_X0Y9_FrameData[31] VGND VPWR Tile_X0Y9_FrameStrobe[3] latch
XFILLER_591_35 VPWR VGND sg13cmos5l_decap_8
XFILLER_489_170 VPWR VGND sg13cmos5l_decap_8
XFILLER_350_147 VPWR VGND sg13cmos5l_decap_8
XFILLER_350_158 VPWR VGND sg13cmos5l_fill_2
XFILLER_638_112 VPWR VGND sg13cmos5l_decap_8
XFILLER_489_181 VPWR VGND sg13cmos5l_fill_1
X_2507_ _2507_/Q Tile_X0Y6_FrameData[28] VGND VPWR Tile_X0Y9_FrameStrobe[2] latch
XFILLER_142_261 VPWR VGND sg13cmos5l_decap_4
XFILLER_102_103 VPWR VGND sg13cmos5l_fill_1
X_0699_ _0699_/Q Tile_X0Y9_FrameData[4] VGND VPWR Tile_X0Y9_FrameStrobe[0] latch
X_3487_ Tile_X0Y1_EE4BEG[13] _3961_/X VPWR VGND sg13cmos5l_buf_1
XFILLER_524_51 VPWR VGND sg13cmos5l_fill_1
XFILLER_102_125 VPWR VGND sg13cmos5l_decap_8
XFILLER_248_107 VPWR VGND sg13cmos5l_decap_8
X_2438_ _2438_/Q Tile_X0Y5_FrameData[31] VGND VPWR Tile_X0Y9_FrameStrobe[8] latch
XFILLER_653_126 VPWR VGND sg13cmos5l_decap_8
XFILLER_653_137 VPWR VGND sg13cmos5l_fill_2
XFILLER_460_28 VPWR VGND sg13cmos5l_decap_8
X_2369_ _2369_/Q Tile_X0Y5_FrameData[4] VGND VPWR Tile_X0Y9_FrameStrobe[5] latch
XFILLER_256_140 VPWR VGND sg13cmos5l_decap_8
XFILLER_243_96 VPWR VGND sg13cmos5l_decap_8
X_4108_ _4108_/X Tile_X0Y6_W1END[1] Tile_X0Y6_WW4END[1] Tile_X0Y6_W6END[9] _4569_/X
+ _2668_/Q _2667_/Q VPWR VGND sg13cmos5l_mux4_1
XFILLER_56_245 VPWR VGND sg13cmos5l_decap_8
XFILLER_405_137 VPWR VGND sg13cmos5l_decap_8
X_4039_ _4039_/X _4095_/X Tile_X0Y2_WW4END[7] _4094_/X AXI_M_SOC_AWREADY _1595_/Q
+ _1594_/Q VPWR VGND sg13cmos5l_mux4_1
XFILLER_271_154 VPWR VGND sg13cmos5l_fill_1
XFILLER_212_210 VPWR VGND sg13cmos5l_decap_8
XFILLER_358_203 VPWR VGND sg13cmos5l_decap_8
XFILLER_72_49 VPWR VGND sg13cmos5l_decap_8
XFILLER_708_105 VPWR VGND sg13cmos5l_fill_2
XFILLER_559_185 VPWR VGND sg13cmos5l_decap_8
XFILLER_241_7 VPWR VGND sg13cmos5l_decap_8
XFILLER_169_147 VPWR VGND sg13cmos5l_decap_8
XFILLER_188_49 VPWR VGND sg13cmos5l_decap_8
XFILLER_339_7 VPWR VGND sg13cmos5l_decap_8
XFILLER_549_70 VPWR VGND sg13cmos5l_decap_8
XFILLER_574_133 VPWR VGND sg13cmos5l_decap_8
XFILLER_184_106 VPWR VGND sg13cmos5l_decap_8
XFILLER_485_14 VPWR VGND sg13cmos5l_decap_8
XANTENNA__3296__X Tile_X0Y0_E2BEGb[4] VPWR VGND sg13cmos5l_antennanp
XANTENNA_60 Tile_X0Y0_FrameData[25] VPWR VGND sg13cmos5l_antennanp
XFILLER_506_7 VPWR VGND sg13cmos5l_decap_8
XANTENNA_71 Tile_X0Y0_S2MID[3] VPWR VGND sg13cmos5l_antennanp
XANTENNA_82 Tile_X0Y0_S4END[14] VPWR VGND sg13cmos5l_antennanp
XANTENNA_93 Tile_X0Y1_FrameData[6] VPWR VGND sg13cmos5l_antennanp
XFILLER_635_28 VPWR VGND sg13cmos5l_decap_8
XFILLER_21_42 VPWR VGND sg13cmos5l_decap_4
XFILLER_418_63 VPWR VGND sg13cmos5l_decap_8
XFILLER_125_228 VPWR VGND sg13cmos5l_decap_8
XFILLER_326_188 VPWR VGND sg13cmos5l_decap_8
XFILLER_137_42 VPWR VGND sg13cmos5l_decap_8
XFILLER_21_75 VPWR VGND sg13cmos5l_fill_2
XFILLER_565_91 VPWR VGND sg13cmos5l_decap_8
XFILLER_341_114 VPWR VGND sg13cmos5l_fill_2
XFILLER_326_199 VPWR VGND sg13cmos5l_fill_1
XFILLER_676_229 VPWR VGND sg13cmos5l_decap_4
XFILLER_284_70 VPWR VGND sg13cmos5l_decap_8
XFILLER_97_35 VPWR VGND sg13cmos5l_fill_2
XFILLER_629_112 VPWR VGND sg13cmos5l_decap_8
XFILLER_629_123 VPWR VGND sg13cmos5l_fill_1
XFILLER_629_145 VPWR VGND sg13cmos5l_fill_2
XFILLER_495_140 VPWR VGND sg13cmos5l_decap_8
XFILLER_294_202 VPWR VGND sg13cmos5l_decap_8
XFILLER_651_49 VPWR VGND sg13cmos5l_decap_8
XFILLER_434_84 VPWR VGND sg13cmos5l_decap_8
XFILLER_644_126 VPWR VGND sg13cmos5l_decap_8
XFILLER_198_0 VPWR VGND sg13cmos5l_decap_8
XFILLER_153_85 VPWR VGND sg13cmos5l_decap_8
XFILLER_47_223 VPWR VGND sg13cmos5l_fill_1
XFILLER_436_251 VPWR VGND sg13cmos5l_decap_8
XFILLER_303_22 VPWR VGND sg13cmos5l_decap_8
XFILLER_247_195 VPWR VGND sg13cmos5l_fill_2
XFILLER_451_221 VPWR VGND sg13cmos5l_decap_8
XFILLER_365_0 VPWR VGND sg13cmos5l_decap_8
XFILLER_262_132 VPWR VGND sg13cmos5l_decap_8
XFILLER_46_61 VPWR VGND sg13cmos5l_fill_2
XFILLER_597_247 VPWR VGND sg13cmos5l_decap_8
XFILLER_303_99 VPWR VGND sg13cmos5l_fill_2
XFILLER_600_42 VPWR VGND sg13cmos5l_decap_8
XFILLER_600_229 VPWR VGND sg13cmos5l_fill_1
XFILLER_532_0 VPWR VGND sg13cmos5l_decap_8
XFILLER_404_192 VPWR VGND sg13cmos5l_fill_1
XFILLER_349_236 VPWR VGND sg13cmos5l_decap_8
XFILLER_676_35 VPWR VGND sg13cmos5l_decap_8
XFILLER_30_112 VPWR VGND sg13cmos5l_fill_2
XFILLER_565_133 VPWR VGND sg13cmos5l_decap_8
XFILLER_459_70 VPWR VGND sg13cmos5l_decap_8
XFILLER_62_82 VPWR VGND sg13cmos5l_decap_8
XFILLER_178_60 VPWR VGND sg13cmos5l_decap_4
XFILLER_395_36 VPWR VGND sg13cmos5l_decap_8
XFILLER_714_119 VPWR VGND sg13cmos5l_decap_8
XFILLER_580_125 VPWR VGND sg13cmos5l_fill_2
XFILLER_317_111 VPWR VGND sg13cmos5l_fill_1
XFILLER_178_93 VPWR VGND sg13cmos5l_decap_8
X_1740_ _1740_/Q Tile_X0Y3_FrameData[29] VGND VPWR Tile_X0Y9_FrameStrobe[2] latch
XFILLER_317_133 VPWR VGND sg13cmos5l_decap_8
XFILLER_317_144 VPWR VGND sg13cmos5l_fill_2
XFILLER_183_150 VPWR VGND sg13cmos5l_fill_2
XFILLER_545_28 VPWR VGND sg13cmos5l_decap_8
XFILLER_7_77 VPWR VGND sg13cmos5l_decap_8
X_1671_ _1671_/Q Tile_X0Y2_FrameData[10] VGND VPWR Tile_X0Y9_FrameStrobe[7] latch
XFILLER_372_272 VPWR VGND sg13cmos5l_fill_1
XFILLER_317_188 VPWR VGND sg13cmos5l_fill_1
XFILLER_183_194 VPWR VGND sg13cmos5l_decap_8
X_3410_ Tile_X0Y4_FrameData_O[1] Tile_X0Y4_FrameData[1] VPWR VGND sg13cmos5l_buf_1
X_0622_ _0622_/Q Tile_X0Y8_FrameData[17] VGND VPWR Tile_X0Y9_FrameStrobe[6] latch
X_4390_ _4390_/X Tile_X0Y5_WW4END[13] AXI_M_SOC_RRESP0 _4464_/X _4431_/X _2323_/Q
+ _2322_/Q VPWR VGND sg13cmos5l_mux4_1
XFILLER_332_158 VPWR VGND sg13cmos5l_decap_8
X_0553_ _0553_/Q Tile_X0Y8_FrameData[22] VGND VPWR Tile_X0Y9_FrameStrobe[4] latch
X_3341_ Tile_X0Y2_FrameData_O[12] Tile_X0Y2_FrameData[12] VPWR VGND sg13cmos5l_buf_1
XFILLER_124_272 VPWR VGND sg13cmos5l_fill_1
XFILLER_97_101 VPWR VGND sg13cmos5l_decap_8
XFILLER_486_140 VPWR VGND sg13cmos5l_fill_1
X_0484_ _0484_/Q Tile_X0Y8_FrameData[27] VGND VPWR Tile_X0Y9_FrameStrobe[2] latch
X_3272_ Tile_X0Y0_EE4BEG[8] _3828_/X VPWR VGND sg13cmos5l_buf_1
XFILLER_561_49 VPWR VGND sg13cmos5l_decap_8
XFILLER_285_224 VPWR VGND sg13cmos5l_decap_8
XFILLER_635_126 VPWR VGND sg13cmos5l_decap_8
XFILLER_280_28 VPWR VGND sg13cmos5l_decap_8
X_2223_ _2223_/Q Tile_X0Y5_FrameData[22] VGND VPWR Tile_X0Y9_FrameStrobe[1] latch
XFILLER_690_232 VPWR VGND sg13cmos5l_decap_4
XFILLER_690_265 VPWR VGND sg13cmos5l_decap_8
X_2154_ _2154_/Q Tile_X0Y4_FrameData[27] VGND VPWR Tile_X0Y9_FrameStrobe[7] latch
XFILLER_399_103 VPWR VGND sg13cmos5l_decap_8
X_1105_ _1105_/Q Tile_X0Y0_FrameData[26] VGND VPWR Tile_X0Y9_FrameStrobe[5] latch
XFILLER_213_77 VPWR VGND sg13cmos5l_decap_8
X_2085_ _2085_/Q Tile_X0Y4_FrameData[0] VGND VPWR Tile_X0Y9_FrameStrobe[4] latch
XFILLER_588_236 VPWR VGND sg13cmos5l_decap_8
XFILLER_510_42 VPWR VGND sg13cmos5l_decap_8
X_1036_ _1036_/Q Tile_X0Y0_FrameData[31] VGND VPWR Tile_X0Y9_FrameStrobe[3] latch
XFILLER_556_122 VPWR VGND sg13cmos5l_decap_8
XFILLER_410_140 VPWR VGND sg13cmos5l_decap_8
XFILLER_586_35 VPWR VGND sg13cmos5l_decap_8
XFILLER_369_70 VPWR VGND sg13cmos5l_decap_8
XFILLER_355_217 VPWR VGND sg13cmos5l_decap_8
XFILLER_166_128 VPWR VGND sg13cmos5l_decap_8
X_2987_ Tile_X0Y8_FrameData_O[27] Tile_X0Y8_FrameData[27] VPWR VGND sg13cmos5l_buf_1
XFILLER_556_177 VPWR VGND sg13cmos5l_fill_2
XFILLER_159_180 VPWR VGND sg13cmos5l_decap_8
X_4726_ _4726_/X _4781_/X _4780_/X AXI_M_SOC_RDATA9 AXI_M_SOC_RDATA13 _0595_/Q _0594_/Q
+ VPWR VGND sg13cmos5l_mux4_1
X_1938_ _1938_/Q Tile_X0Y4_FrameData[19] VGND VPWR Tile_X0Y9_FrameStrobe[0] latch
XFILLER_308_122 VPWR VGND sg13cmos5l_decap_8
XFILLER_571_147 VPWR VGND sg13cmos5l_decap_8
XFILLER_181_109 VPWR VGND sg13cmos5l_fill_1
XFILLER_174_150 VPWR VGND sg13cmos5l_decap_8
XFILLER_455_28 VPWR VGND sg13cmos5l_decap_8
XFILLER_107_217 VPWR VGND sg13cmos5l_fill_2
X_4657_ _4657_/X _4663_/X Tile_X0Y7_W6END[1] _4662_/X _4657_/A3 _0165_/Q _0164_/Q
+ VPWR VGND sg13cmos5l_mux4_1
XFILLER_174_172 VPWR VGND sg13cmos5l_fill_2
XFILLER_713_152 VPWR VGND sg13cmos5l_decap_8
X_1869_ _1869_/Q Tile_X0Y3_FrameData[28] VGND VPWR Tile_X0Y9_FrameStrobe[6] latch
XFILLER_385_80 VPWR VGND sg13cmos5l_decap_8
XFILLER_512_214 VPWR VGND sg13cmos5l_decap_8
XFILLER_323_125 VPWR VGND sg13cmos5l_decap_8
X_3608_ Tile_X0Y9_S2BEG[2] _4830_/X VPWR VGND sg13cmos5l_buf_1
X_4588_ _4588_/X Tile_X0Y5_W2MID[5] Tile_X0Y5_W2END[5] Tile_X0Y5_W6END[10] _4432_/X
+ _2391_/Q _2390_/Q VPWR VGND sg13cmos5l_mux4_1
XFILLER_122_209 VPWR VGND sg13cmos5l_decap_8
X_3539_ Tile_X0Y9_E2BEGb[5] _4861_/X VPWR VGND sg13cmos5l_buf_1
XFILLER_115_272 VPWR VGND sg13cmos5l_fill_1
XFILLER_107_45 VPWR VGND sg13cmos5l_fill_1
XFILLER_107_67 VPWR VGND sg13cmos5l_decap_8
XFILLER_331_180 VPWR VGND sg13cmos5l_fill_1
XFILLER_130_231 VPWR VGND sg13cmos5l_fill_1
XFILLER_471_49 VPWR VGND sg13cmos5l_decap_8
XFILLER_404_21 VPWR VGND sg13cmos5l_decap_8
XFILLER_130_264 VPWR VGND sg13cmos5l_fill_1
XFILLER_88_178 VPWR VGND sg13cmos5l_decap_8
XFILLER_681_221 VPWR VGND sg13cmos5l_decap_8
XFILLER_67_49 VPWR VGND sg13cmos5l_decap_8
XFILLER_190_28 VPWR VGND sg13cmos5l_fill_2
XFILLER_191_7 VPWR VGND sg13cmos5l_decap_8
XFILLER_492_154 VPWR VGND sg13cmos5l_decap_8
XFILLER_289_7 VPWR VGND sg13cmos5l_decap_8
XFILLER_291_238 VPWR VGND sg13cmos5l_decap_8
XFILLER_123_88 VPWR VGND sg13cmos5l_decap_8
XFILLER_83_37 VPWR VGND sg13cmos5l_decap_8
XFILLER_701_63 VPWR VGND sg13cmos5l_decap_8
XFILLER_579_225 VPWR VGND sg13cmos5l_decap_8
XFILLER_456_7 VPWR VGND sg13cmos5l_decap_8
XFILLER_420_42 VPWR VGND sg13cmos5l_decap_8
XFILLER_16_42 VPWR VGND sg13cmos5l_decap_8
XFILLER_244_198 VPWR VGND sg13cmos5l_decap_8
XANTENNA__2923__X Tile_X0Y8_E2BEG[7] VPWR VGND sg13cmos5l_antennanp
XFILLER_197_231 VPWR VGND sg13cmos5l_decap_8
XFILLER_623_7 VPWR VGND sg13cmos5l_decap_8
XFILLER_547_122 VPWR VGND sg13cmos5l_decap_8
XFILLER_496_35 VPWR VGND sg13cmos5l_decap_8
XFILLER_279_70 VPWR VGND sg13cmos5l_decap_8
XFILLER_401_162 VPWR VGND sg13cmos5l_decap_8
XFILLER_12_145 VPWR VGND sg13cmos5l_decap_8
XFILLER_157_106 VPWR VGND sg13cmos5l_decap_8
XFILLER_157_117 VPWR VGND sg13cmos5l_fill_1
XFILLER_8_105 VPWR VGND sg13cmos5l_decap_8
XFILLER_646_49 VPWR VGND sg13cmos5l_decap_8
XFILLER_429_84 VPWR VGND sg13cmos5l_decap_8
XFILLER_562_147 VPWR VGND sg13cmos5l_decap_8
XFILLER_704_130 VPWR VGND sg13cmos5l_decap_8
XFILLER_365_28 VPWR VGND sg13cmos5l_decap_8
XFILLER_148_63 VPWR VGND sg13cmos5l_decap_8
XFILLER_354_272 VPWR VGND sg13cmos5l_fill_1
XANTENNA__3754__X AXI_M_SOC_ARADDR26 VPWR VGND sg13cmos5l_antennanp
XFILLER_113_0 VPWR VGND sg13cmos5l_decap_8
XFILLER_295_91 VPWR VGND sg13cmos5l_decap_8
XFILLER_106_261 VPWR VGND sg13cmos5l_decap_8
XFILLER_106_272 VPWR VGND sg13cmos5l_fill_1
XFILLER_79_112 VPWR VGND sg13cmos5l_decap_8
XFILLER_381_38 VPWR VGND sg13cmos5l_fill_1
XFILLER_482_0 VPWR VGND sg13cmos5l_decap_8
XFILLER_79_189 VPWR VGND sg13cmos5l_decap_8
XFILLER_672_232 VPWR VGND sg13cmos5l_fill_2
XFILLER_314_43 VPWR VGND sg13cmos5l_decap_8
XFILLER_672_254 VPWR VGND sg13cmos5l_decap_4
XFILLER_94_137 VPWR VGND sg13cmos5l_decap_8
XFILLER_483_165 VPWR VGND sg13cmos5l_decap_8
XFILLER_461_93 VPWR VGND sg13cmos5l_decap_8
XFILLER_314_87 VPWR VGND sg13cmos5l_fill_1
XFILLER_282_238 VPWR VGND sg13cmos5l_decap_8
XFILLER_424_210 VPWR VGND sg13cmos5l_decap_8
XFILLER_282_249 VPWR VGND sg13cmos5l_decap_8
XFILLER_611_63 VPWR VGND sg13cmos5l_decap_8
XFILLER_640_140 VPWR VGND sg13cmos5l_decap_8
XFILLER_290_271 VPWR VGND sg13cmos5l_fill_2
XFILLER_235_176 VPWR VGND sg13cmos5l_decap_8
XFILLER_250_113 VPWR VGND sg13cmos5l_decap_8
XFILLER_396_117 VPWR VGND sg13cmos5l_decap_8
XFILLER_687_56 VPWR VGND sg13cmos5l_decap_4
XANTENNA__2833__X Tile_X0Y6_E1BEG[2] VPWR VGND sg13cmos5l_antennanp
X_2910_ Tile_X0Y6_FrameData_O[31] Tile_X0Y6_FrameData[31] VPWR VGND sg13cmos5l_buf_1
XFILLER_188_231 VPWR VGND sg13cmos5l_decap_8
X_3890_ _3890_/X Tile_X0Y2_W2MID[6] Tile_X0Y2_W2END[6] Tile_X0Y2_W6END[6] _4099_/X
+ _1663_/Q _1662_/Q VPWR VGND sg13cmos5l_mux4_1
XFILLER_538_122 VPWR VGND sg13cmos5l_decap_8
XFILLER_259_29 VPWR VGND sg13cmos5l_decap_8
XFILLER_687_89 VPWR VGND sg13cmos5l_decap_8
X_2841_ Tile_X0Y6_E2BEG[6] _4502_/X VPWR VGND sg13cmos5l_buf_1
XFILLER_337_206 VPWR VGND sg13cmos5l_fill_1
XFILLER_593_261 VPWR VGND sg13cmos5l_fill_1
XFILLER_593_272 VPWR VGND sg13cmos5l_fill_1
XFILLER_339_73 VPWR VGND sg13cmos5l_decap_4
X_2772_ Tile_X0Y3_FrameData_O[30] Tile_X0Y3_FrameData[30] VPWR VGND sg13cmos5l_buf_1
XFILLER_556_49 VPWR VGND sg13cmos5l_decap_8
XFILLER_339_84 VPWR VGND sg13cmos5l_decap_8
XFILLER_163_109 VPWR VGND sg13cmos5l_decap_8
X_4511_ _4511_/X Tile_X0Y6_W2END[0] AXI_M_SOC_RDATA24 _4553_/X _4552_/X _2585_/Q _2584_/Q
+ VPWR VGND sg13cmos5l_mux4_1
XANTENNA__0072__Y AXI_M_SOC_AWCACHE3 VPWR VGND sg13cmos5l_antennanp
X_1723_ _1723_/Q Tile_X0Y3_FrameData[14] VGND VPWR Tile_X0Y9_FrameStrobe[1] latch
XFILLER_275_28 VPWR VGND sg13cmos5l_decap_8
XANTENNA__3664__X AXI_M_SOC_AWADDR25 VPWR VGND sg13cmos5l_antennanp
XFILLER_7_171 VPWR VGND sg13cmos5l_decap_8
X_4442_ _4442_/X _4921_/X _4925_/X _4929_/X _4903_/X _0900_/Q _0899_/Q VPWR VGND sg13cmos5l_mux4_1
XFILLER_710_111 VPWR VGND sg13cmos5l_decap_8
X_1654_ _1654_/Q Tile_X0Y2_FrameData[27] VGND VPWR Tile_X0Y9_FrameStrobe[7] latch
XFILLER_104_209 VPWR VGND sg13cmos5l_decap_4
XFILLER_305_158 VPWR VGND sg13cmos5l_decap_4
XFILLER_208_77 VPWR VGND sg13cmos5l_decap_8
X_0605_ _0605_/Q Tile_X0Y8_FrameData[2] VGND VPWR Tile_X0Y9_FrameStrobe[5] latch
X_4373_ _4373_/X Tile_X0Y5_W2MID[6] AXI_M_SOC_RLAST _4430_/X _4429_/X _2357_/Q _2356_/Q
+ VPWR VGND sg13cmos5l_mux4_1
XFILLER_710_166 VPWR VGND sg13cmos5l_decap_4
X_1585_ _1585_/Q Tile_X0Y2_FrameData[0] VGND VPWR Tile_X0Y9_FrameStrobe[4] latch
XFILLER_648_251 VPWR VGND sg13cmos5l_decap_8
XFILLER_505_42 VPWR VGND sg13cmos5l_decap_8
X_3324_ Tile_X0Y4_EE4BEG[12] _4284_/X VPWR VGND sg13cmos5l_buf_1
XFILLER_313_180 VPWR VGND sg13cmos5l_fill_1
X_0536_ _0536_/Q Tile_X0Y8_FrameData[7] VGND VPWR Tile_X0Y9_FrameStrobe[3] latch
XFILLER_663_210 VPWR VGND sg13cmos5l_decap_8
XFILLER_652_70 VPWR VGND sg13cmos5l_decap_8
XFILLER_224_21 VPWR VGND sg13cmos5l_decap_8
XFILLER_474_121 VPWR VGND sg13cmos5l_decap_8
XFILLER_663_221 VPWR VGND sg13cmos5l_fill_2
XFILLER_474_132 VPWR VGND sg13cmos5l_fill_2
X_0467_ _0467_/Q Tile_X0Y8_FrameData[12] VGND VPWR Tile_X0Y9_FrameStrobe[1] latch
X_3255_ Tile_X0Y0_FrameData_O[23] Tile_X0Y0_FrameData[23] VPWR VGND sg13cmos5l_buf_1
XFILLER_663_254 VPWR VGND sg13cmos5l_fill_1
XFILLER_608_159 VPWR VGND sg13cmos5l_decap_8
XFILLER_85_137 VPWR VGND sg13cmos5l_decap_8
XFILLER_474_176 VPWR VGND sg13cmos5l_decap_4
X_2206_ _2206_/Q Tile_X0Y5_FrameData[7] VGND VPWR Tile_X0Y9_FrameStrobe[0] latch
X_0398_ _0398_/Q Tile_X0Y7_FrameData[17] VGND VPWR Tile_X0Y9_FrameStrobe[7] latch
X_3186_ Tile_X0Y0_N4BEG[10] _3186_/A VPWR VGND sg13cmos5l_buf_1
XFILLER_415_210 VPWR VGND sg13cmos5l_fill_1
XFILLER_226_132 VPWR VGND sg13cmos5l_decap_8
XFILLER_521_63 VPWR VGND sg13cmos5l_decap_8
X_2137_ _2137_/Q Tile_X0Y4_FrameData[12] VGND VPWR Tile_X0Y9_FrameStrobe[6] latch
XFILLER_631_140 VPWR VGND sg13cmos5l_decap_8
XFILLER_281_271 VPWR VGND sg13cmos5l_fill_2
XFILLER_240_42 VPWR VGND sg13cmos5l_decap_8
X_2068_ _2068_/Q Tile_X0Y4_FrameData[17] VGND VPWR Tile_X0Y9_FrameStrobe[4] latch
XFILLER_53_18 VPWR VGND sg13cmos5l_decap_8
XFILLER_430_224 VPWR VGND sg13cmos5l_decap_8
XFILLER_387_139 VPWR VGND sg13cmos5l_fill_1
XFILLER_241_157 VPWR VGND sg13cmos5l_decap_8
XANTENNA__2743__X Tile_X0Y3_FrameData_O[1] VPWR VGND sg13cmos5l_antennanp
X_1019_ _1019_/Q Tile_X0Y0_FrameData[16] VGND VPWR Tile_X0Y9_FrameStrobe[2] latch
XFILLER_328_206 VPWR VGND sg13cmos5l_decap_8
XFILLER_194_212 VPWR VGND sg13cmos5l_decap_8
XFILLER_529_166 VPWR VGND sg13cmos5l_fill_2
XFILLER_584_272 VPWR VGND sg13cmos5l_fill_1
XFILLER_544_114 VPWR VGND sg13cmos5l_decap_8
XFILLER_466_49 VPWR VGND sg13cmos5l_decap_8
XFILLER_185_28 VPWR VGND sg13cmos5l_decap_8
X_4709_ _4709_/X Tile_X0Y9_W2MID[3] Tile_X0Y9_W2END[3] Tile_X0Y9_W6END[3] _4906_/X
+ _0911_/Q _0910_/Q VPWR VGND sg13cmos5l_mux4_1
XANTENNA__3574__X Tile_X0Y9_FrameData_O[4] VPWR VGND sg13cmos5l_antennanp
XFILLER_204_7 VPWR VGND sg13cmos5l_decap_8
XFILLER_351_231 VPWR VGND sg13cmos5l_decap_8
XFILLER_698_184 VPWR VGND sg13cmos5l_decap_8
XFILLER_552_191 VPWR VGND sg13cmos5l_decap_8
XFILLER_497_224 VPWR VGND sg13cmos5l_decap_8
XFILLER_497_257 VPWR VGND sg13cmos5l_fill_1
XFILLER_500_217 VPWR VGND sg13cmos5l_decap_8
XFILLER_103_220 VPWR VGND sg13cmos5l_decap_4
XFILLER_311_139 VPWR VGND sg13cmos5l_fill_2
XFILLER_415_42 VPWR VGND sg13cmos5l_decap_8
XFILLER_562_70 VPWR VGND sg13cmos5l_decap_8
XFILLER_134_21 VPWR VGND sg13cmos5l_decap_8
XANTENNA__2918__X Tile_X0Y8_E2BEG[2] VPWR VGND sg13cmos5l_antennanp
XFILLER_573_7 VPWR VGND sg13cmos5l_decap_8
XFILLER_94_14 VPWR VGND sg13cmos5l_decap_8
XFILLER_264_227 VPWR VGND sg13cmos5l_decap_8
XFILLER_134_98 VPWR VGND sg13cmos5l_fill_2
XFILLER_712_84 VPWR VGND sg13cmos5l_decap_8
XFILLER_607_170 VPWR VGND sg13cmos5l_fill_2
XFILLER_406_221 VPWR VGND sg13cmos5l_decap_8
XFILLER_17_204 VPWR VGND sg13cmos5l_decap_8
XFILLER_217_143 VPWR VGND sg13cmos5l_decap_8
XFILLER_17_215 VPWR VGND sg13cmos5l_fill_1
XFILLER_431_63 VPWR VGND sg13cmos5l_decap_8
XFILLER_17_237 VPWR VGND sg13cmos5l_decap_8
XFILLER_272_260 VPWR VGND sg13cmos5l_fill_1
XFILLER_217_176 VPWR VGND sg13cmos5l_decap_8
XFILLER_272_271 VPWR VGND sg13cmos5l_fill_2
XFILLER_622_173 VPWR VGND sg13cmos5l_decap_8
XFILLER_567_217 VPWR VGND sg13cmos5l_decap_8
XANTENNA__3749__X AXI_M_SOC_ARADDR21 VPWR VGND sg13cmos5l_antennanp
XFILLER_32_218 VPWR VGND sg13cmos5l_decap_8
XFILLER_232_168 VPWR VGND sg13cmos5l_decap_8
XFILLER_300_56 VPWR VGND sg13cmos5l_decap_8
XFILLER_709_244 VPWR VGND sg13cmos5l_decap_8
XFILLER_319_206 VPWR VGND sg13cmos5l_decap_4
XFILLER_40_240 VPWR VGND sg13cmos5l_decap_8
XFILLER_300_78 VPWR VGND sg13cmos5l_decap_8
XFILLER_230_0 VPWR VGND sg13cmos5l_decap_8
XFILLER_328_0 VPWR VGND sg13cmos5l_decap_8
XFILLER_386_194 VPWR VGND sg13cmos5l_decap_8
XFILLER_376_38 VPWR VGND sg13cmos5l_fill_1
XFILLER_159_95 VPWR VGND sg13cmos5l_decap_8
XFILLER_590_253 VPWR VGND sg13cmos5l_decap_4
XFILLER_309_21 VPWR VGND sg13cmos5l_decap_8
XFILLER_138_161 VPWR VGND sg13cmos5l_decap_8
XFILLER_673_14 VPWR VGND sg13cmos5l_decap_8
XFILLER_327_272 VPWR VGND sg13cmos5l_fill_1
XANTENNA__3484__X Tile_X0Y1_EE4BEG[10] VPWR VGND sg13cmos5l_antennanp
XFILLER_689_162 VPWR VGND sg13cmos5l_decap_8
XFILLER_4_130 VPWR VGND sg13cmos5l_fill_2
XFILLER_342_242 VPWR VGND sg13cmos5l_decap_8
XFILLER_697_0 VPWR VGND sg13cmos5l_decap_8
XFILLER_342_264 VPWR VGND sg13cmos5l_fill_1
XFILLER_299_157 VPWR VGND sg13cmos5l_decap_8
XFILLER_153_197 VPWR VGND sg13cmos5l_decap_8
XFILLER_606_85 VPWR VGND sg13cmos5l_decap_8
XFILLER_4_56 VPWR VGND sg13cmos5l_decap_8
XFILLER_325_42 VPWR VGND sg13cmos5l_fill_2
X_1370_ _1370_/Q Tile_X0Y1_FrameData[31] VGND VPWR Tile_X0Y9_FrameStrobe[6] latch
XFILLER_645_210 VPWR VGND sg13cmos5l_decap_8
XFILLER_325_75 VPWR VGND sg13cmos5l_decap_8
X_0321_ _0321_/Q Tile_X0Y7_FrameData[30] VGND VPWR Tile_X0Y9_FrameStrobe[5] latch
XFILLER_68_70 VPWR VGND sg13cmos5l_decap_8
XFILLER_325_86 VPWR VGND sg13cmos5l_fill_2
XANTENNA__2828__X Tile_X0Y4_E2BEG[6] VPWR VGND sg13cmos5l_antennanp
XFILLER_67_126 VPWR VGND sg13cmos5l_decap_8
XFILLER_310_161 VPWR VGND sg13cmos5l_decap_8
XFILLER_191_71 VPWR VGND sg13cmos5l_decap_8
XFILLER_191_82 VPWR VGND sg13cmos5l_fill_1
X_0252_ _0252_/Q Tile_X0Y7_FrameData[3] VGND VPWR Tile_X0Y9_FrameStrobe[2] latch
X_3040_ Tile_X0Y5_EE4BEG[15] _4403_/X VPWR VGND sg13cmos5l_buf_1
XFILLER_471_124 VPWR VGND sg13cmos5l_decap_8
XFILLER_622_84 VPWR VGND sg13cmos5l_decap_8
XFILLER_622_95 VPWR VGND sg13cmos5l_fill_1
XFILLER_471_135 VPWR VGND sg13cmos5l_fill_1
XFILLER_341_63 VPWR VGND sg13cmos5l_decap_8
XFILLER_208_154 VPWR VGND sg13cmos5l_decap_8
X_0183_ _0183_/Q Tile_X0Y7_FrameData[8] VGND VPWR Tile_X0Y9_FrameStrobe[0] latch
XFILLER_660_268 VPWR VGND sg13cmos5l_decap_4
XFILLER_84_91 VPWR VGND sg13cmos5l_decap_8
XFILLER_698_77 VPWR VGND sg13cmos5l_decap_8
XFILLER_613_184 VPWR VGND sg13cmos5l_fill_2
XANTENNA__3659__X AXI_M_SOC_AWADDR20 VPWR VGND sg13cmos5l_antennanp
XFILLER_23_207 VPWR VGND sg13cmos5l_fill_1
XFILLER_90_173 VPWR VGND sg13cmos5l_decap_8
X_3942_ _3942_/X Tile_X0Y1_W2END[5] AXI_M_SOC_ARREADY _3993_/X _3992_/X _1325_/Q _1324_/Q
+ VPWR VGND sg13cmos5l_mux4_1
XFILLER_210_56 VPWR VGND sg13cmos5l_decap_8
X_3873_ _3873_/X Tile_X0Y4_W1END[2] Tile_X0Y4_WW4END[2] Tile_X0Y4_W6END[10] _4338_/X
+ _2151_/Q _2150_/Q VPWR VGND sg13cmos5l_mux4_1
XFILLER_715_203 VPWR VGND sg13cmos5l_decap_8
XFILLER_566_272 VPWR VGND sg13cmos5l_fill_1
X_2824_ Tile_X0Y4_E2BEG[2] _4258_/X VPWR VGND sg13cmos5l_buf_1
XFILLER_286_49 VPWR VGND sg13cmos5l_decap_8
XFILLER_647_70 VPWR VGND sg13cmos5l_decap_8
XFILLER_219_21 VPWR VGND sg13cmos5l_decap_8
XFILLER_76_0 VPWR VGND sg13cmos5l_decap_8
XFILLER_129_150 VPWR VGND sg13cmos5l_decap_8
XFILLER_583_14 VPWR VGND sg13cmos5l_decap_8
X_2755_ Tile_X0Y3_FrameData_O[13] Tile_X0Y3_FrameData[13] VPWR VGND sg13cmos5l_buf_1
XFILLER_541_106 VPWR VGND sg13cmos5l_decap_8
XFILLER_392_186 VPWR VGND sg13cmos5l_decap_8
XANTENNA__3394__X Tile_X0Y2_E2BEGb[5] VPWR VGND sg13cmos5l_antennanp
XFILLER_191_248 VPWR VGND sg13cmos5l_decap_4
XFILLER_144_120 VPWR VGND sg13cmos5l_decap_8
X_1706_ _1706_/Q Tile_X0Y3_FrameData[31] VGND VPWR Tile_X0Y9_FrameStrobe[1] latch
X_2686_ _2686_/Q Tile_X0Y6_FrameData[9] VGND VPWR Tile_X0Y9_FrameStrobe[7] latch
X_4425_ _4425_/X _4427_/X Tile_X0Y5_W6END[3] _4426_/X _4425_/A3 _2183_/Q _2440_/Q
+ VPWR VGND sg13cmos5l_mux4_1
X_1637_ _1637_/Q Tile_X0Y2_FrameData[12] VGND VPWR Tile_X0Y9_FrameStrobe[6] latch
XFILLER_695_143 VPWR VGND sg13cmos5l_fill_2
XFILLER_516_63 VPWR VGND sg13cmos5l_decap_8
XFILLER_479_268 VPWR VGND sg13cmos5l_decap_4
XFILLER_516_96 VPWR VGND sg13cmos5l_fill_1
XFILLER_235_42 VPWR VGND sg13cmos5l_decap_8
X_4356_ _4356_/X Tile_X0Y3_W2MID[5] Tile_X0Y3_W2END[5] Tile_X0Y3_W6END[10] _4209_/X
+ _1877_/Q _1876_/Q VPWR VGND sg13cmos5l_mux4_1
XFILLER_695_187 VPWR VGND sg13cmos5l_fill_2
X_1568_ _1568_/Q Tile_X0Y2_FrameData[17] VGND VPWR Tile_X0Y9_FrameStrobe[4] latch
XFILLER_494_249 VPWR VGND sg13cmos5l_decap_8
XFILLER_100_201 VPWR VGND sg13cmos5l_decap_8
X_3307_ Tile_X0Y0_E2BEG[7] _3811_/X VPWR VGND sg13cmos5l_buf_1
XANTENNA__2738__X Tile_X0Y4_E1BEG[1] VPWR VGND sg13cmos5l_antennanp
X_0519_ _0519_/Q Tile_X0Y8_FrameData[24] VGND VPWR Tile_X0Y9_FrameStrobe[3] latch
XFILLER_301_161 VPWR VGND sg13cmos5l_decap_4
X_4287_ _4287_/X Tile_X0Y4_WW4END[0] AXI_M_SOC_BRESP0 _4336_/X _4313_/X _2039_/Q _2038_/Q
+ VPWR VGND sg13cmos5l_mux4_1
X_1499_ _1499_/Q Tile_X0Y2_FrameData[22] VGND VPWR Tile_X0Y9_FrameStrobe[2] latch
XFILLER_58_137 VPWR VGND sg13cmos5l_decap_8
XFILLER_447_165 VPWR VGND sg13cmos5l_decap_8
X_3238_ Tile_X0Y0_FrameData_O[6] Tile_X0Y0_FrameData[6] VPWR VGND sg13cmos5l_buf_1
XFILLER_651_224 VPWR VGND sg13cmos5l_decap_8
XFILLER_104_35 VPWR VGND sg13cmos5l_decap_8
XFILLER_462_135 VPWR VGND sg13cmos5l_decap_4
XFILLER_251_63 VPWR VGND sg13cmos5l_decap_8
X_3169_ Tile_X0Y4_E6BEG[6] _4294_/X VPWR VGND sg13cmos5l_buf_1
XFILLER_64_28 VPWR VGND sg13cmos5l_decap_8
XFILLER_401_22 VPWR VGND sg13cmos5l_decap_8
XFILLER_604_162 VPWR VGND sg13cmos5l_decap_8
XFILLER_161_8 VPWR VGND sg13cmos5l_decap_8
XFILLER_549_217 VPWR VGND sg13cmos5l_decap_8
XANTENNA__3569__X Tile_X0Y9_EE4BEG[15] VPWR VGND sg13cmos5l_antennanp
XFILLER_259_8 VPWR VGND sg13cmos5l_decap_8
XFILLER_81_173 VPWR VGND sg13cmos5l_decap_8
XFILLER_154_7 VPWR VGND sg13cmos5l_decap_8
XFILLER_214_179 VPWR VGND sg13cmos5l_decap_8
XFILLER_403_268 VPWR VGND sg13cmos5l_decap_4
XFILLER_120_56 VPWR VGND sg13cmos5l_fill_2
XFILLER_167_201 VPWR VGND sg13cmos5l_decap_4
XFILLER_120_89 VPWR VGND sg13cmos5l_decap_8
XFILLER_167_212 VPWR VGND sg13cmos5l_decap_8
XFILLER_167_223 VPWR VGND sg13cmos5l_fill_2
XFILLER_222_190 VPWR VGND sg13cmos5l_decap_8
XFILLER_517_103 VPWR VGND sg13cmos5l_decap_8
XFILLER_13_21 VPWR VGND sg13cmos5l_decap_8
XFILLER_321_7 VPWR VGND sg13cmos5l_decap_8
XFILLER_196_49 VPWR VGND sg13cmos5l_decap_8
XFILLER_572_231 VPWR VGND sg13cmos5l_decap_8
XFILLER_419_7 VPWR VGND sg13cmos5l_decap_8
XFILLER_129_21 VPWR VGND sg13cmos5l_decap_8
XFILLER_557_70 VPWR VGND sg13cmos5l_decap_8
XFILLER_493_14 VPWR VGND sg13cmos5l_decap_8
XFILLER_383_175 VPWR VGND sg13cmos5l_decap_8
XFILLER_309_272 VPWR VGND sg13cmos5l_fill_1
XFILLER_89_14 VPWR VGND sg13cmos5l_decap_8
XFILLER_324_242 VPWR VGND sg13cmos5l_fill_1
XFILLER_707_84 VPWR VGND sg13cmos5l_decap_8
XFILLER_135_175 VPWR VGND sg13cmos5l_fill_1
XFILLER_690_7 VPWR VGND sg13cmos5l_decap_8
XFILLER_643_28 VPWR VGND sg13cmos5l_decap_8
XFILLER_426_63 VPWR VGND sg13cmos5l_decap_8
XFILLER_135_197 VPWR VGND sg13cmos5l_decap_8
XFILLER_150_123 VPWR VGND sg13cmos5l_fill_2
XFILLER_573_91 VPWR VGND sg13cmos5l_decap_8
XFILLER_145_42 VPWR VGND sg13cmos5l_decap_8
XFILLER_686_198 VPWR VGND sg13cmos5l_decap_8
XFILLER_292_70 VPWR VGND sg13cmos5l_decap_8
XFILLER_627_232 VPWR VGND sg13cmos5l_decap_8
XFILLER_1_188 VPWR VGND sg13cmos5l_fill_1
XFILLER_49_126 VPWR VGND sg13cmos5l_decap_8
XFILLER_438_165 VPWR VGND sg13cmos5l_decap_8
XFILLER_493_271 VPWR VGND sg13cmos5l_fill_2
XFILLER_438_198 VPWR VGND sg13cmos5l_decap_8
XFILLER_642_224 VPWR VGND sg13cmos5l_decap_8
XFILLER_180_0 VPWR VGND sg13cmos5l_decap_8
XFILLER_278_0 VPWR VGND sg13cmos5l_decap_8
XFILLER_161_96 VPWR VGND sg13cmos5l_decap_8
XFILLER_311_22 VPWR VGND sg13cmos5l_decap_8
XFILLER_668_14 VPWR VGND sg13cmos5l_decap_8
XANTENNA__3479__X Tile_X0Y1_EE4BEG[5] VPWR VGND sg13cmos5l_antennanp
XFILLER_445_0 VPWR VGND sg13cmos5l_decap_8
XFILLER_260_252 VPWR VGND sg13cmos5l_decap_8
XFILLER_220_116 VPWR VGND sg13cmos5l_decap_8
XFILLER_387_37 VPWR VGND sg13cmos5l_fill_1
XFILLER_610_198 VPWR VGND sg13cmos5l_decap_8
XFILLER_387_59 VPWR VGND sg13cmos5l_decap_8
XFILLER_359_172 VPWR VGND sg13cmos5l_decap_8
XFILLER_158_223 VPWR VGND sg13cmos5l_decap_8
XFILLER_213_190 VPWR VGND sg13cmos5l_decap_8
XFILLER_612_0 VPWR VGND sg13cmos5l_decap_8
X_0870_ _0870_/Q Tile_X0Y9_FrameData[25] VGND VPWR Tile_X0Y9_FrameStrobe[6] latch
XFILLER_70_71 VPWR VGND sg13cmos5l_decap_8
XFILLER_684_68 VPWR VGND sg13cmos5l_decap_8
XFILLER_186_60 VPWR VGND sg13cmos5l_decap_8
XFILLER_523_139 VPWR VGND sg13cmos5l_fill_2
X_2540_ _2540_/Q Tile_X0Y6_FrameData[27] VGND VPWR Tile_X0Y9_FrameStrobe[3] latch
XFILLER_617_84 VPWR VGND sg13cmos5l_fill_2
XFILLER_126_175 VPWR VGND sg13cmos5l_decap_4
XFILLER_553_28 VPWR VGND sg13cmos5l_decap_8
X_2471_ _2471_/Q Tile_X0Y6_FrameData[0] VGND VPWR Tile_X0Y9_FrameStrobe[0] latch
XFILLER_141_123 VPWR VGND sg13cmos5l_fill_2
XFILLER_287_105 VPWR VGND sg13cmos5l_decap_8
XFILLER_677_165 VPWR VGND sg13cmos5l_decap_8
X_4210_ _4210_/X _4137_/X _4245_/X _4244_/X _4136_/X _1689_/Q _1688_/Q VPWR VGND sg13cmos5l_mux4_1
XFILLER_336_96 VPWR VGND sg13cmos5l_decap_8
XFILLER_330_234 VPWR VGND sg13cmos5l_decap_8
X_1422_ _1422_/Q Tile_X0Y1_FrameData[11] VGND VPWR Tile_X0Y9_FrameStrobe[7] latch
XFILLER_79_91 VPWR VGND sg13cmos5l_decap_8
XFILLER_476_238 VPWR VGND sg13cmos5l_decap_8
X_4141_ _4141_/X Tile_X0Y4_W2MID[1] Tile_X0Y4_W2END[1] Tile_X0Y4_W6END[1] _4314_/X
+ _2161_/Q _2160_/Q VPWR VGND sg13cmos5l_mux4_1
XFILLER_692_157 VPWR VGND sg13cmos5l_decap_8
X_1353_ _1353_/Q Tile_X0Y1_FrameData[16] VGND VPWR Tile_X0Y9_FrameStrobe[5] latch
XFILLER_429_154 VPWR VGND sg13cmos5l_decap_8
XFILLER_95_221 VPWR VGND sg13cmos5l_fill_1
XFILLER_205_56 VPWR VGND sg13cmos5l_decap_8
XFILLER_95_243 VPWR VGND sg13cmos5l_fill_2
XFILLER_484_271 VPWR VGND sg13cmos5l_fill_2
XFILLER_444_102 VPWR VGND sg13cmos5l_fill_2
X_0304_ _0304_/Q Tile_X0Y7_FrameData[15] VGND VPWR Tile_X0Y9_FrameStrobe[4] latch
XFILLER_295_182 VPWR VGND sg13cmos5l_decap_8
X_4072_ _4072_/X _0079_/X Tile_X0Y0_S4END[8] _4127_/X _4104_/X _1529_/Q _1528_/Q VPWR
+ VGND sg13cmos5l_mux4_1
X_1284_ _1284_/Q Tile_X0Y1_FrameData[21] VGND VPWR Tile_X0Y9_FrameStrobe[3] latch
XFILLER_352_84 VPWR VGND sg13cmos5l_decap_8
XFILLER_502_21 VPWR VGND sg13cmos5l_decap_8
XFILLER_55_118 VPWR VGND sg13cmos5l_decap_8
X_3023_ Tile_X0Y5_E6BEG[10] _4414_/X VPWR VGND sg13cmos5l_buf_1
X_0235_ _0235_/Q Tile_X0Y7_FrameData[20] VGND VPWR Tile_X0Y9_FrameStrobe[2] latch
XFILLER_48_170 VPWR VGND sg13cmos5l_fill_1
XFILLER_48_192 VPWR VGND sg13cmos5l_decap_8
XFILLER_236_271 VPWR VGND sg13cmos5l_fill_2
X_0166_ _0166_/Q Tile_X0Y7_FrameData[25] VGND VPWR Tile_X0Y9_FrameStrobe[0] latch
XFILLER_502_98 VPWR VGND sg13cmos5l_decap_8
XFILLER_578_14 VPWR VGND sg13cmos5l_decap_8
XANTENNA__3389__X Tile_X0Y2_E2BEGb[0] VPWR VGND sg13cmos5l_antennanp
XFILLER_397_223 VPWR VGND sg13cmos5l_decap_8
XFILLER_601_132 VPWR VGND sg13cmos5l_decap_8
XFILLER_251_263 VPWR VGND sg13cmos5l_decap_8
XFILLER_211_105 VPWR VGND sg13cmos5l_decap_8
X_0097_ _0097_/X _4449_/X _4450_/X _0892_/Q VPWR VGND sg13cmos5l_mux2_1
XFILLER_63_195 VPWR VGND sg13cmos5l_decap_8
XFILLER_397_267 VPWR VGND sg13cmos5l_decap_4
XFILLER_297_15 VPWR VGND sg13cmos5l_decap_8
XFILLER_400_216 VPWR VGND sg13cmos5l_decap_8
X_3925_ _3925_/X _4227_/X _4231_/X _4235_/X _4207_/X _1898_/Q _1897_/Q VPWR VGND sg13cmos5l_mux4_1
XFILLER_601_198 VPWR VGND sg13cmos5l_fill_1
XFILLER_539_272 VPWR VGND sg13cmos5l_fill_1
XFILLER_149_234 VPWR VGND sg13cmos5l_decap_8
XFILLER_658_91 VPWR VGND sg13cmos5l_decap_8
X_3856_ _3856_/X _3899_/X _3898_/X Tile_X0Y0_S2MID[5] Tile_X0Y0_S2END[5] _0953_/Q
+ _0952_/Q VPWR VGND sg13cmos5l_mux4_1
XFILLER_594_35 VPWR VGND sg13cmos5l_decap_8
X_2807_ Tile_X0Y3_E2BEGb[5] _4161_/X VPWR VGND sg13cmos5l_buf_1
X_3787_ _3787_/X Tile_X0Y0_W2MID[4] Tile_X0Y0_W2END[4] Tile_X0Y0_W6END[4] _3859_/X
+ _1163_/Q _1162_/Q VPWR VGND sg13cmos5l_mux4_1
XFILLER_380_112 VPWR VGND sg13cmos5l_decap_8
X_0999_ _0999_/Q Tile_X0Y0_FrameData[4] VGND VPWR Tile_X0Y9_FrameStrobe[1] latch
XFILLER_365_197 VPWR VGND sg13cmos5l_fill_1
X_2738_ Tile_X0Y4_E1BEG[1] _4253_/X VPWR VGND sg13cmos5l_buf_1
XFILLER_527_84 VPWR VGND sg13cmos5l_fill_1
XFILLER_306_264 VPWR VGND sg13cmos5l_fill_1
XFILLER_463_28 VPWR VGND sg13cmos5l_decap_8
XFILLER_380_189 VPWR VGND sg13cmos5l_decap_8
XFILLER_117_186 VPWR VGND sg13cmos5l_decap_8
XFILLER_132_112 VPWR VGND sg13cmos5l_decap_8
XFILLER_711_250 VPWR VGND sg13cmos5l_decap_8
X_2669_ _2669_/Q Tile_X0Y6_FrameData[26] VGND VPWR Tile_X0Y9_FrameStrobe[7] latch
XFILLER_278_105 VPWR VGND sg13cmos5l_decap_8
XFILLER_246_74 VPWR VGND sg13cmos5l_fill_1
XFILLER_668_165 VPWR VGND sg13cmos5l_decap_4
XFILLER_467_205 VPWR VGND sg13cmos5l_fill_2
XFILLER_59_39 VPWR VGND sg13cmos5l_fill_2
XFILLER_132_145 VPWR VGND sg13cmos5l_decap_8
X_4408_ _4408_/X AXI_M_SOC_RVALID _4458_/X _4462_/X _4467_/X _2287_/Q _2286_/Q VPWR
+ VGND sg13cmos5l_mux4_1
XFILLER_522_194 VPWR VGND sg13cmos5l_decap_8
XFILLER_182_29 VPWR VGND sg13cmos5l_decap_8
XFILLER_278_138 VPWR VGND sg13cmos5l_fill_1
XFILLER_321_256 VPWR VGND sg13cmos5l_fill_2
X_4339_ _4339_/X _4311_/X _0040_/X _4310_/X _0109_/X _1975_/Q _1974_/Q VPWR VGND sg13cmos5l_mux4_1
XFILLER_683_157 VPWR VGND sg13cmos5l_decap_8
XFILLER_219_216 VPWR VGND sg13cmos5l_decap_4
XFILLER_219_227 VPWR VGND sg13cmos5l_decap_8
XFILLER_286_182 VPWR VGND sg13cmos5l_decap_8
XFILLER_46_107 VPWR VGND sg13cmos5l_decap_4
XFILLER_376_8 VPWR VGND sg13cmos5l_decap_8
XFILLER_490_241 VPWR VGND sg13cmos5l_fill_2
XFILLER_412_43 VPWR VGND sg13cmos5l_decap_8
XFILLER_271_7 VPWR VGND sg13cmos5l_decap_8
XFILLER_234_208 VPWR VGND sg13cmos5l_decap_4
XFILLER_624_268 VPWR VGND sg13cmos5l_decap_4
XFILLER_435_168 VPWR VGND sg13cmos5l_decap_8
XFILLER_227_260 VPWR VGND sg13cmos5l_fill_1
XFILLER_369_7 VPWR VGND sg13cmos5l_decap_8
XFILLER_131_22 VPWR VGND sg13cmos5l_decap_8
XFILLER_488_14 VPWR VGND sg13cmos5l_decap_8
XFILLER_450_138 VPWR VGND sg13cmos5l_decap_8
XANTENNA__3299__X Tile_X0Y0_E2BEGb[7] VPWR VGND sg13cmos5l_antennanp
XFILLER_388_234 VPWR VGND sg13cmos5l_decap_4
XFILLER_54_195 VPWR VGND sg13cmos5l_fill_1
XFILLER_536_7 VPWR VGND sg13cmos5l_decap_8
XFILLER_202_105 VPWR VGND sg13cmos5l_decap_8
XFILLER_199_189 VPWR VGND sg13cmos5l_decap_8
XFILLER_638_28 VPWR VGND sg13cmos5l_decap_8
XFILLER_24_42 VPWR VGND sg13cmos5l_decap_8
XFILLER_568_91 VPWR VGND sg13cmos5l_decap_8
XANTENNA__2931__X Tile_X0Y8_E2BEGb[7] VPWR VGND sg13cmos5l_antennanp
XFILLER_703_7 VPWR VGND sg13cmos5l_decap_8
XFILLER_545_242 VPWR VGND sg13cmos5l_decap_8
XFILLER_287_70 VPWR VGND sg13cmos5l_decap_8
XFILLER_210_182 VPWR VGND sg13cmos5l_decap_8
XFILLER_6_203 VPWR VGND sg13cmos5l_decap_8
XFILLER_210_193 VPWR VGND sg13cmos5l_fill_1
XFILLER_356_175 VPWR VGND sg13cmos5l_decap_8
XFILLER_40_41 VPWR VGND sg13cmos5l_decap_8
XFILLER_170_207 VPWR VGND sg13cmos5l_decap_8
XFILLER_6_269 VPWR VGND sg13cmos5l_decap_4
XFILLER_560_256 VPWR VGND sg13cmos5l_fill_1
XFILLER_437_84 VPWR VGND sg13cmos5l_decap_8
XFILLER_108_175 VPWR VGND sg13cmos5l_decap_8
XFILLER_156_63 VPWR VGND sg13cmos5l_decap_8
XFILLER_373_28 VPWR VGND sg13cmos5l_decap_8
XFILLER_373_39 VPWR VGND sg13cmos5l_fill_2
XFILLER_702_272 VPWR VGND sg13cmos5l_fill_1
XFILLER_513_172 VPWR VGND sg13cmos5l_decap_8
XFILLER_513_183 VPWR VGND sg13cmos5l_fill_1
XFILLER_269_116 VPWR VGND sg13cmos5l_decap_4
XFILLER_6_0 VPWR VGND sg13cmos5l_decap_8
XFILLER_312_245 VPWR VGND sg13cmos5l_decap_8
XFILLER_269_138 VPWR VGND sg13cmos5l_decap_8
XFILLER_123_189 VPWR VGND sg13cmos5l_decap_8
XFILLER_395_0 VPWR VGND sg13cmos5l_fill_2
XFILLER_284_119 VPWR VGND sg13cmos5l_decap_8
XFILLER_603_42 VPWR VGND sg13cmos5l_decap_8
XFILLER_466_271 VPWR VGND sg13cmos5l_fill_2
XFILLER_1_35 VPWR VGND sg13cmos5l_decap_8
XFILLER_615_235 VPWR VGND sg13cmos5l_decap_8
XFILLER_562_0 VPWR VGND sg13cmos5l_decap_8
XFILLER_481_230 VPWR VGND sg13cmos5l_decap_4
XFILLER_322_21 VPWR VGND sg13cmos5l_decap_8
XFILLER_426_168 VPWR VGND sg13cmos5l_decap_8
XFILLER_218_260 VPWR VGND sg13cmos5l_fill_2
XFILLER_630_205 VPWR VGND sg13cmos5l_fill_1
XFILLER_292_185 VPWR VGND sg13cmos5l_decap_8
XFILLER_92_257 VPWR VGND sg13cmos5l_fill_2
XFILLER_630_227 VPWR VGND sg13cmos5l_decap_8
XFILLER_45_140 VPWR VGND sg13cmos5l_decap_8
XFILLER_441_138 VPWR VGND sg13cmos5l_decap_8
XFILLER_398_14 VPWR VGND sg13cmos5l_decap_8
XANTENNA_150 Tile_X0Y9_FrameStrobe[14] VPWR VGND sg13cmos5l_antennanp
XANTENNA_161 Tile_X0Y9_FrameStrobe[8] VPWR VGND sg13cmos5l_antennanp
XANTENNA__3002__X Tile_X0Y5_E2BEG[5] VPWR VGND sg13cmos5l_antennanp
XANTENNA_172 Tile_X0Y9_FrameStrobe[8] VPWR VGND sg13cmos5l_antennanp
XFILLER_528_209 VPWR VGND sg13cmos5l_decap_8
XANTENNA_183 Tile_X0Y9_FrameStrobe[8] VPWR VGND sg13cmos5l_antennanp
XANTENNA_194 Tile_X0Y9_N2MID[1] VPWR VGND sg13cmos5l_antennanp
XFILLER_548_28 VPWR VGND sg13cmos5l_decap_8
X_1971_ _1971_/Q Tile_X0Y4_FrameData[18] VGND VPWR Tile_X0Y9_FrameStrobe[1] latch
XFILLER_394_226 VPWR VGND sg13cmos5l_decap_8
XFILLER_695_56 VPWR VGND sg13cmos5l_decap_8
XANTENNA__2841__X Tile_X0Y6_E2BEG[6] VPWR VGND sg13cmos5l_antennanp
X_3710_ AXI_M_SOC_WDATA20 Tile_X0Y6_WW4END[4] Tile_X0Y6_WW4END[12] Tile_X0Y6_W6END[4]
+ _4572_/X _2519_/Q _2518_/Q VPWR VGND sg13cmos5l_mux4_1
X_0922_ _0922_/Q Tile_X0Y9_FrameData[5] VGND VPWR Tile_X0Y9_FrameStrobe[7] latch
X_4690_ _4690_/X _4665_/X Tile_X0Y9_N4END[10] _4664_/X _0054_/X _0203_/Q _0202_/Q
+ VPWR VGND sg13cmos5l_mux4_1
XFILLER_197_70 VPWR VGND sg13cmos5l_decap_8
XFILLER_628_50 VPWR VGND sg13cmos5l_decap_8
XFILLER_201_193 VPWR VGND sg13cmos5l_decap_8
X_3641_ AXI_M_SOC_AWADDR2 Tile_X0Y5_WW4END[2] Tile_X0Y5_WW4END[10] Tile_X0Y5_W6END[2]
+ _4453_/X _2267_/Q _2266_/Q VPWR VGND sg13cmos5l_mux4_1
X_0853_ _0853_/Q Tile_X0Y9_FrameData[10] VGND VPWR Tile_X0Y9_FrameStrobe[5] latch
XFILLER_551_201 VPWR VGND sg13cmos5l_fill_1
XFILLER_362_112 VPWR VGND sg13cmos5l_decap_8
X_3572_ Tile_X0Y9_FrameData_O[2] Tile_X0Y9_FrameData[2] VPWR VGND sg13cmos5l_buf_1
XFILLER_564_49 VPWR VGND sg13cmos5l_decap_8
X_0784_ _0784_/Q Tile_X0Y9_FrameData[15] VGND VPWR Tile_X0Y9_FrameStrobe[3] latch
XFILLER_347_84 VPWR VGND sg13cmos5l_decap_8
XFILLER_362_178 VPWR VGND sg13cmos5l_fill_1
X_2523_ _2523_/Q Tile_X0Y6_FrameData[12] VGND VPWR Tile_X0Y9_FrameStrobe[2] latch
XFILLER_283_28 VPWR VGND sg13cmos5l_decap_8
XFILLER_504_172 VPWR VGND sg13cmos5l_decap_8
XFILLER_504_183 VPWR VGND sg13cmos5l_fill_1
XFILLER_114_156 VPWR VGND sg13cmos5l_decap_8
X_2454_ _2454_/Q Tile_X0Y6_FrameData[17] VGND VPWR Tile_X0Y9_FrameStrobe[0] latch
XFILLER_363_50 VPWR VGND sg13cmos5l_decap_8
XFILLER_363_61 VPWR VGND sg13cmos5l_fill_2
X_1405_ _1405_/Q Tile_X0Y1_FrameData[28] VGND VPWR Tile_X0Y9_FrameStrobe[7] latch
XFILLER_68_210 VPWR VGND sg13cmos5l_decap_8
X_2385_ _2385_/Q Tile_X0Y5_FrameData[20] VGND VPWR Tile_X0Y9_FrameStrobe[6] latch
XFILLER_680_116 VPWR VGND sg13cmos5l_decap_8
XFILLER_513_42 VPWR VGND sg13cmos5l_decap_8
X_4124_ _4124_/X _4089_/X _0079_/X _4088_/X Tile_X0Y0_S4END[8] _1465_/Q _1464_/Q VPWR
+ VGND sg13cmos5l_mux4_1
XFILLER_268_182 VPWR VGND sg13cmos5l_decap_8
X_1336_ _1336_/Q Tile_X0Y1_FrameData[1] VGND VPWR Tile_X0Y9_FrameStrobe[4] latch
XFILLER_660_70 VPWR VGND sg13cmos5l_decap_8
XFILLER_606_224 VPWR VGND sg13cmos5l_decap_8
XFILLER_232_43 VPWR VGND sg13cmos5l_decap_8
X_4055_ _4055_/X Tile_X0Y2_W2END[0] AXI_M_SOC_AWREADY _4097_/X _4096_/X _1563_/Q _1562_/Q
+ VPWR VGND sg13cmos5l_mux4_1
X_1267_ _1267_/Q Tile_X0Y1_FrameData[6] VGND VPWR Tile_X0Y9_FrameStrobe[2] latch
XFILLER_589_35 VPWR VGND sg13cmos5l_decap_8
XFILLER_432_105 VPWR VGND sg13cmos5l_decap_8
X_3006_ Tile_X0Y5_E2BEGb[1] _4381_/X VPWR VGND sg13cmos5l_buf_1
XFILLER_283_196 VPWR VGND sg13cmos5l_decap_8
X_0218_ _0218_/Q Tile_X0Y7_FrameData[5] VGND VPWR Tile_X0Y9_FrameStrobe[1] latch
XFILLER_232_98 VPWR VGND sg13cmos5l_decap_8
X_1198_ _1198_/Q Tile_X0Y1_FrameData[11] VGND VPWR Tile_X0Y9_FrameStrobe[0] latch
XFILLER_224_241 VPWR VGND sg13cmos5l_fill_2
XFILLER_586_120 VPWR VGND sg13cmos5l_decap_8
XFILLER_101_14 VPWR VGND sg13cmos5l_decap_8
XFILLER_36_184 VPWR VGND sg13cmos5l_fill_1
X_0149_ AXI_M_SOC_AWLEN1 _0940_/Q _3672_/X VPWR VGND sg13cmos5l_nor2b_1
XFILLER_385_204 VPWR VGND sg13cmos5l_decap_8
XFILLER_458_28 VPWR VGND sg13cmos5l_decap_8
XFILLER_586_186 VPWR VGND sg13cmos5l_fill_1
XFILLER_51_198 VPWR VGND sg13cmos5l_decap_8
XANTENNA__2751__X Tile_X0Y3_FrameData_O[9] VPWR VGND sg13cmos5l_antennanp
X_3908_ _3908_/X Tile_X0Y1_W1END[1] Tile_X0Y1_WW4END[1] Tile_X0Y1_W6END[9] _4009_/X
+ _1398_/Q _1397_/Q VPWR VGND sg13cmos5l_mux4_1
X_4888_ _4888_/X AXI_M_SOC_RDATA4 _4919_/X _4923_/X _4906_/X _0767_/Q _0766_/Q VPWR
+ VGND sg13cmos5l_mux4_1
XFILLER_137_204 VPWR VGND sg13cmos5l_decap_8
X_3839_ _3839_/X _0078_/X Tile_X0Y0_S4END[3] _3876_/X _3875_/X _1027_/Q _1026_/Q VPWR
+ VGND sg13cmos5l_mux4_1
XFILLER_338_186 VPWR VGND sg13cmos5l_fill_1
XFILLER_542_212 VPWR VGND sg13cmos5l_decap_8
XFILLER_499_105 VPWR VGND sg13cmos5l_decap_8
XFILLER_353_112 VPWR VGND sg13cmos5l_decap_8
XFILLER_688_227 VPWR VGND sg13cmos5l_decap_8
XFILLER_117_7 VPWR VGND sg13cmos5l_decap_8
XFILLER_474_49 VPWR VGND sg13cmos5l_decap_8
XFILLER_407_21 VPWR VGND sg13cmos5l_decap_8
XFILLER_193_28 VPWR VGND sg13cmos5l_decap_8
XFILLER_353_189 VPWR VGND sg13cmos5l_decap_8
XFILLER_3_239 VPWR VGND sg13cmos5l_decap_4
XANTENNA__3582__X Tile_X0Y9_FrameData_O[12] VPWR VGND sg13cmos5l_antennanp
XFILLER_105_134 VPWR VGND sg13cmos5l_decap_8
XFILLER_696_271 VPWR VGND sg13cmos5l_fill_2
XFILLER_10_77 VPWR VGND sg13cmos5l_decap_4
XFILLER_126_77 VPWR VGND sg13cmos5l_decap_8
XFILLER_510_164 VPWR VGND sg13cmos5l_fill_2
XFILLER_704_63 VPWR VGND sg13cmos5l_decap_8
XFILLER_59_221 VPWR VGND sg13cmos5l_decap_8
XFILLER_486_7 VPWR VGND sg13cmos5l_decap_8
XFILLER_455_219 VPWR VGND sg13cmos5l_decap_8
XFILLER_448_271 VPWR VGND sg13cmos5l_fill_2
XFILLER_423_42 VPWR VGND sg13cmos5l_decap_8
XFILLER_142_21 VPWR VGND sg13cmos5l_decap_8
XFILLER_570_70 VPWR VGND sg13cmos5l_decap_8
XFILLER_274_152 VPWR VGND sg13cmos5l_decap_8
XANTENNA__2926__X Tile_X0Y8_E2BEGb[2] VPWR VGND sg13cmos5l_antennanp
XFILLER_207_208 VPWR VGND sg13cmos5l_decap_8
XFILLER_653_7 VPWR VGND sg13cmos5l_decap_8
XFILLER_423_105 VPWR VGND sg13cmos5l_decap_8
XFILLER_499_35 VPWR VGND sg13cmos5l_decap_8
XFILLER_367_4 VPWR VGND sg13cmos5l_fill_1
XFILLER_612_216 VPWR VGND sg13cmos5l_decap_8
XFILLER_142_98 VPWR VGND sg13cmos5l_decap_8
XFILLER_416_190 VPWR VGND sg13cmos5l_decap_8
XFILLER_35_30 VPWR VGND sg13cmos5l_fill_1
XFILLER_27_195 VPWR VGND sg13cmos5l_fill_1
XFILLER_230_200 VPWR VGND sg13cmos5l_decap_8
XFILLER_649_49 VPWR VGND sg13cmos5l_decap_8
XFILLER_577_164 VPWR VGND sg13cmos5l_decap_8
XFILLER_431_182 VPWR VGND sg13cmos5l_decap_8
XFILLER_230_244 VPWR VGND sg13cmos5l_fill_1
XANTENNA__3757__X AXI_M_SOC_ARADDR29 VPWR VGND sg13cmos5l_antennanp
XFILLER_143_0 VPWR VGND sg13cmos5l_decap_8
XFILLER_376_259 VPWR VGND sg13cmos5l_decap_4
XFILLER_51_62 VPWR VGND sg13cmos5l_decap_8
XFILLER_310_0 VPWR VGND sg13cmos5l_decap_4
XFILLER_408_0 VPWR VGND sg13cmos5l_decap_8
XFILLER_167_84 VPWR VGND sg13cmos5l_decap_8
XFILLER_143_218 VPWR VGND sg13cmos5l_decap_8
XFILLER_317_21 VPWR VGND sg13cmos5l_decap_8
XFILLER_681_14 VPWR VGND sg13cmos5l_decap_8
XANTENNA__3492__X Tile_X0Y1_E6BEG[2] VPWR VGND sg13cmos5l_antennanp
XFILLER_694_219 VPWR VGND sg13cmos5l_decap_8
XFILLER_297_200 VPWR VGND sg13cmos5l_decap_8
XFILLER_297_222 VPWR VGND sg13cmos5l_decap_8
XFILLER_681_58 VPWR VGND sg13cmos5l_decap_8
XFILLER_498_182 VPWR VGND sg13cmos5l_decap_8
XFILLER_183_83 VPWR VGND sg13cmos5l_decap_8
XFILLER_501_175 VPWR VGND sg13cmos5l_decap_8
XFILLER_32_7 VPWR VGND sg13cmos5l_decap_8
XFILLER_647_168 VPWR VGND sg13cmos5l_decap_8
XFILLER_614_63 VPWR VGND sg13cmos5l_decap_8
XFILLER_662_105 VPWR VGND sg13cmos5l_fill_1
XFILLER_439_260 VPWR VGND sg13cmos5l_fill_2
X_2170_ _2170_/Q Tile_X0Y4_FrameData[11] VGND VPWR Tile_X0Y9_FrameStrobe[7] latch
XFILLER_480_70 VPWR VGND sg13cmos5l_fill_2
XFILLER_333_64 VPWR VGND sg13cmos5l_decap_8
XFILLER_655_190 VPWR VGND sg13cmos5l_decap_8
XFILLER_265_141 VPWR VGND sg13cmos5l_decap_8
X_1121_ _1121_/Q Tile_X0Y0_FrameData[10] VGND VPWR Tile_X0Y9_FrameStrobe[5] latch
XFILLER_65_224 VPWR VGND sg13cmos5l_decap_8
XANTENNA__2836__X Tile_X0Y6_E2BEG[1] VPWR VGND sg13cmos5l_antennanp
XFILLER_670_171 VPWR VGND sg13cmos5l_decap_8
X_1052_ _1052_/Q Tile_X0Y0_FrameData[15] VGND VPWR Tile_X0Y9_FrameStrobe[3] latch
XFILLER_280_133 VPWR VGND sg13cmos5l_decap_8
XFILLER_202_35 VPWR VGND sg13cmos5l_decap_8
XFILLER_80_216 VPWR VGND sg13cmos5l_decap_8
XFILLER_630_84 VPWR VGND sg13cmos5l_decap_8
XFILLER_18_184 VPWR VGND sg13cmos5l_decap_8
XFILLER_80_238 VPWR VGND sg13cmos5l_fill_2
XFILLER_33_110 VPWR VGND sg13cmos5l_decap_8
XFILLER_559_49 VPWR VGND sg13cmos5l_decap_8
X_4811_ _4811_/X _4783_/X Tile_X0Y9_N4END[7] _4782_/X _0074_/X _0449_/Q _0448_/Q VPWR
+ VGND sg13cmos5l_mux4_1
XFILLER_568_175 VPWR VGND sg13cmos5l_decap_8
XFILLER_278_28 VPWR VGND sg13cmos5l_decap_8
XFILLER_367_237 VPWR VGND sg13cmos5l_decap_8
XFILLER_33_176 VPWR VGND sg13cmos5l_decap_8
XANTENNA__3667__X AXI_M_SOC_AWADDR28 VPWR VGND sg13cmos5l_antennanp
XFILLER_178_148 VPWR VGND sg13cmos5l_decap_8
XFILLER_583_123 VPWR VGND sg13cmos5l_decap_8
XFILLER_33_198 VPWR VGND sg13cmos5l_fill_2
X_4742_ _4742_/X Tile_X0Y8_W2END[1] AXI_M_SOC_RDATA9 _4787_/X _4786_/X _0563_/Q _0562_/Q
+ VPWR VGND sg13cmos5l_mux4_1
XFILLER_193_107 VPWR VGND sg13cmos5l_decap_8
X_1954_ _1954_/Q Tile_X0Y4_FrameData[3] VGND VPWR Tile_X0Y9_FrameStrobe[0] latch
XFILLER_583_156 VPWR VGND sg13cmos5l_fill_2
X_0905_ _0905_/Q Tile_X0Y9_FrameData[22] VGND VPWR Tile_X0Y9_FrameStrobe[7] latch
X_4673_ _4673_/X _4589_/X _4705_/X _4704_/X _4588_/X _0179_/Q _0178_/Q VPWR VGND sg13cmos5l_mux4_1
XFILLER_335_112 VPWR VGND sg13cmos5l_decap_8
X_1885_ _1885_/Q Tile_X0Y3_FrameData[12] VGND VPWR Tile_X0Y9_FrameStrobe[6] latch
X_3624_ Tile_X0Y9_S4BEG[2] _3624_/A VPWR VGND sg13cmos5l_buf_1
XFILLER_508_42 VPWR VGND sg13cmos5l_decap_8
X_0836_ _0836_/Q Tile_X0Y9_FrameData[27] VGND VPWR Tile_X0Y9_FrameStrobe[5] latch
XFILLER_294_49 VPWR VGND sg13cmos5l_decap_8
XFILLER_335_167 VPWR VGND sg13cmos5l_decap_8
XFILLER_655_92 VPWR VGND sg13cmos5l_decap_8
XFILLER_227_43 VPWR VGND sg13cmos5l_decap_8
X_3555_ Tile_X0Y9_EE4BEG[1] _4865_/X VPWR VGND sg13cmos5l_buf_1
XFILLER_591_14 VPWR VGND sg13cmos5l_decap_8
XFILLER_350_126 VPWR VGND sg13cmos5l_decap_8
X_0767_ _0767_/Q Tile_X0Y9_FrameData[0] VGND VPWR Tile_X0Y9_FrameStrobe[2] latch
XFILLER_496_119 VPWR VGND sg13cmos5l_decap_8
X_2506_ _2506_/Q Tile_X0Y6_FrameData[29] VGND VPWR Tile_X0Y9_FrameStrobe[2] latch
X_3486_ Tile_X0Y1_EE4BEG[12] _3960_/X VPWR VGND sg13cmos5l_buf_1
X_0698_ _0698_/Q Tile_X0Y9_FrameData[5] VGND VPWR Tile_X0Y9_FrameStrobe[0] latch
XFILLER_288_255 VPWR VGND sg13cmos5l_fill_2
X_2437_ _2437_/Q Tile_X0Y5_FrameData[0] VGND VPWR Tile_X0Y9_FrameStrobe[7] latch
XFILLER_693_252 VPWR VGND sg13cmos5l_decap_8
XFILLER_693_263 VPWR VGND sg13cmos5l_fill_1
XFILLER_638_168 VPWR VGND sg13cmos5l_fill_2
XFILLER_102_148 VPWR VGND sg13cmos5l_fill_1
XFILLER_653_105 VPWR VGND sg13cmos5l_decap_8
XFILLER_671_91 VPWR VGND sg13cmos5l_fill_1
XFILLER_243_42 VPWR VGND sg13cmos5l_decap_8
XFILLER_243_53 VPWR VGND sg13cmos5l_fill_1
X_2368_ _2368_/Q Tile_X0Y5_FrameData[5] VGND VPWR Tile_X0Y9_FrameStrobe[5] latch
XFILLER_445_230 VPWR VGND sg13cmos5l_decap_8
XFILLER_56_29 VPWR VGND sg13cmos5l_decap_8
XFILLER_56_213 VPWR VGND sg13cmos5l_decap_8
XFILLER_110_170 VPWR VGND sg13cmos5l_decap_4
X_4107_ _4107_/X _4093_/X _0057_/X _4092_/X Tile_X0Y0_S4END[10] _1453_/Q _1452_/Q
+ VPWR VGND sg13cmos5l_mux4_1
XFILLER_390_92 VPWR VGND sg13cmos5l_decap_8
XANTENNA__2746__X Tile_X0Y3_FrameData_O[4] VPWR VGND sg13cmos5l_antennanp
X_1319_ _1319_/Q Tile_X0Y1_FrameData[18] VGND VPWR Tile_X0Y9_FrameStrobe[4] latch
XFILLER_271_100 VPWR VGND sg13cmos5l_decap_8
X_2299_ _2299_/Q Tile_X0Y5_FrameData[10] VGND VPWR Tile_X0Y9_FrameStrobe[3] latch
XFILLER_405_116 VPWR VGND sg13cmos5l_decap_8
XFILLER_271_111 VPWR VGND sg13cmos5l_fill_2
X_4038_ _4038_/X _4093_/X Tile_X0Y2_WW4END[6] _4092_/X AXI_M_SOC_AWREADY _1597_/Q
+ _1596_/Q VPWR VGND sg13cmos5l_mux4_1
XFILLER_661_182 VPWR VGND sg13cmos5l_fill_1
XFILLER_112_35 VPWR VGND sg13cmos5l_decap_8
XFILLER_460_255 VPWR VGND sg13cmos5l_fill_1
XFILLER_71_249 VPWR VGND sg13cmos5l_decap_8
XFILLER_420_119 VPWR VGND sg13cmos5l_decap_8
XFILLER_24_121 VPWR VGND sg13cmos5l_decap_4
XFILLER_112_79 VPWR VGND sg13cmos5l_decap_8
XFILLER_72_28 VPWR VGND sg13cmos5l_decap_8
XFILLER_559_142 VPWR VGND sg13cmos5l_fill_1
XFILLER_602_271 VPWR VGND sg13cmos5l_fill_2
XFILLER_169_126 VPWR VGND sg13cmos5l_decap_8
XFILLER_188_28 VPWR VGND sg13cmos5l_decap_8
XFILLER_413_193 VPWR VGND sg13cmos5l_decap_8
XFILLER_574_112 VPWR VGND sg13cmos5l_decap_8
XANTENNA__3577__X Tile_X0Y9_FrameData_O[7] VPWR VGND sg13cmos5l_antennanp
XFILLER_234_7 VPWR VGND sg13cmos5l_decap_8
XFILLER_373_207 VPWR VGND sg13cmos5l_fill_1
XFILLER_574_189 VPWR VGND sg13cmos5l_decap_8
XANTENNA_50 Tile_X0Y0_FrameData[25] VPWR VGND sg13cmos5l_antennanp
XFILLER_326_112 VPWR VGND sg13cmos5l_decap_8
XANTENNA_61 Tile_X0Y0_S2MID[0] VPWR VGND sg13cmos5l_antennanp
XANTENNA_72 Tile_X0Y0_S2MID[3] VPWR VGND sg13cmos5l_antennanp
XANTENNA_83 Tile_X0Y0_S4END[14] VPWR VGND sg13cmos5l_antennanp
XFILLER_21_21 VPWR VGND sg13cmos5l_decap_8
XFILLER_716_194 VPWR VGND sg13cmos5l_decap_4
XFILLER_418_42 VPWR VGND sg13cmos5l_decap_8
XANTENNA_94 Tile_X0Y1_FrameData[6] VPWR VGND sg13cmos5l_antennanp
XFILLER_515_245 VPWR VGND sg13cmos5l_decap_8
XFILLER_137_21 VPWR VGND sg13cmos5l_decap_8
XFILLER_565_70 VPWR VGND sg13cmos5l_decap_8
XFILLER_326_167 VPWR VGND sg13cmos5l_decap_8
XFILLER_530_204 VPWR VGND sg13cmos5l_fill_1
XFILLER_192_184 VPWR VGND sg13cmos5l_decap_8
XFILLER_487_108 VPWR VGND sg13cmos5l_fill_2
XFILLER_676_208 VPWR VGND sg13cmos5l_decap_8
XFILLER_530_226 VPWR VGND sg13cmos5l_decap_8
XFILLER_97_14 VPWR VGND sg13cmos5l_decap_8
XFILLER_530_237 VPWR VGND sg13cmos5l_fill_2
XFILLER_137_98 VPWR VGND sg13cmos5l_decap_8
XFILLER_279_244 VPWR VGND sg13cmos5l_decap_4
XFILLER_715_84 VPWR VGND sg13cmos5l_decap_8
XFILLER_279_255 VPWR VGND sg13cmos5l_fill_1
XFILLER_651_28 VPWR VGND sg13cmos5l_decap_8
XFILLER_434_63 VPWR VGND sg13cmos5l_decap_8
XFILLER_239_108 VPWR VGND sg13cmos5l_decap_8
XFILLER_629_168 VPWR VGND sg13cmos5l_fill_1
XFILLER_644_105 VPWR VGND sg13cmos5l_decap_8
XFILLER_581_91 VPWR VGND sg13cmos5l_decap_8
XFILLER_495_196 VPWR VGND sg13cmos5l_decap_8
XFILLER_153_64 VPWR VGND sg13cmos5l_decap_8
XFILLER_370_29 VPWR VGND sg13cmos5l_decap_8
XFILLER_436_230 VPWR VGND sg13cmos5l_decap_8
XFILLER_262_111 VPWR VGND sg13cmos5l_decap_8
XFILLER_652_171 VPWR VGND sg13cmos5l_decap_8
XFILLER_597_204 VPWR VGND sg13cmos5l_decap_8
XFILLER_600_21 VPWR VGND sg13cmos5l_decap_8
XFILLER_451_255 VPWR VGND sg13cmos5l_decap_8
XFILLER_260_0 VPWR VGND sg13cmos5l_decap_8
XFILLER_62_238 VPWR VGND sg13cmos5l_decap_8
XFILLER_15_110 VPWR VGND sg13cmos5l_decap_8
XFILLER_358_0 VPWR VGND sg13cmos5l_decap_8
XFILLER_600_208 VPWR VGND sg13cmos5l_decap_8
XFILLER_262_188 VPWR VGND sg13cmos5l_decap_8
XFILLER_203_222 VPWR VGND sg13cmos5l_fill_1
XFILLER_349_215 VPWR VGND sg13cmos5l_decap_8
XFILLER_15_176 VPWR VGND sg13cmos5l_fill_2
XFILLER_676_14 VPWR VGND sg13cmos5l_decap_8
XFILLER_565_112 VPWR VGND sg13cmos5l_decap_8
XANTENNA__3487__X Tile_X0Y1_EE4BEG[13] VPWR VGND sg13cmos5l_antennanp
XFILLER_525_0 VPWR VGND sg13cmos5l_decap_8
XFILLER_62_61 VPWR VGND sg13cmos5l_decap_8
XFILLER_30_135 VPWR VGND sg13cmos5l_decap_8
XFILLER_175_107 VPWR VGND sg13cmos5l_decap_8
XFILLER_459_93 VPWR VGND sg13cmos5l_decap_4
XFILLER_87_8 VPWR VGND sg13cmos5l_decap_8
XFILLER_395_15 VPWR VGND sg13cmos5l_decap_8
XFILLER_565_178 VPWR VGND sg13cmos5l_decap_8
XFILLER_178_72 VPWR VGND sg13cmos5l_decap_8
XFILLER_609_63 VPWR VGND sg13cmos5l_decap_8
XFILLER_168_192 VPWR VGND sg13cmos5l_fill_1
XFILLER_506_223 VPWR VGND sg13cmos5l_decap_8
XFILLER_7_56 VPWR VGND sg13cmos5l_decap_8
XFILLER_506_245 VPWR VGND sg13cmos5l_decap_8
X_1670_ _1670_/Q Tile_X0Y2_FrameData[11] VGND VPWR Tile_X0Y9_FrameStrobe[7] latch
XFILLER_692_35 VPWR VGND sg13cmos5l_decap_8
XFILLER_109_270 VPWR VGND sg13cmos5l_fill_2
X_0621_ _0621_/Q Tile_X0Y8_FrameData[18] VGND VPWR Tile_X0Y9_FrameStrobe[6] latch
XFILLER_332_137 VPWR VGND sg13cmos5l_decap_8
XFILLER_194_82 VPWR VGND sg13cmos5l_decap_8
X_3340_ Tile_X0Y2_FrameData_O[11] Tile_X0Y2_FrameData[11] VPWR VGND sg13cmos5l_buf_1
X_0552_ _0552_/Q Tile_X0Y8_FrameData[23] VGND VPWR Tile_X0Y9_FrameStrobe[4] latch
XFILLER_625_84 VPWR VGND sg13cmos5l_decap_8
XFILLER_561_28 VPWR VGND sg13cmos5l_decap_8
XFILLER_285_203 VPWR VGND sg13cmos5l_decap_8
X_3271_ Tile_X0Y0_EE4BEG[7] _3827_/X VPWR VGND sg13cmos5l_buf_1
X_0483_ _0483_/Q Tile_X0Y8_FrameData[28] VGND VPWR Tile_X0Y9_FrameStrobe[2] latch
XFILLER_635_105 VPWR VGND sg13cmos5l_decap_8
XFILLER_491_91 VPWR VGND sg13cmos5l_decap_8
X_2222_ _2222_/Q Tile_X0Y5_FrameData[23] VGND VPWR Tile_X0Y9_FrameStrobe[1] latch
XFILLER_38_202 VPWR VGND sg13cmos5l_decap_8
XFILLER_285_269 VPWR VGND sg13cmos5l_decap_4
XFILLER_427_252 VPWR VGND sg13cmos5l_decap_4
X_2153_ _2153_/Q Tile_X0Y4_FrameData[28] VGND VPWR Tile_X0Y9_FrameStrobe[7] latch
XFILLER_650_119 VPWR VGND sg13cmos5l_decap_8
XFILLER_238_174 VPWR VGND sg13cmos5l_decap_8
XFILLER_213_56 VPWR VGND sg13cmos5l_decap_8
X_1104_ _1104_/Q Tile_X0Y0_FrameData[27] VGND VPWR Tile_X0Y9_FrameStrobe[5] latch
XFILLER_643_182 VPWR VGND sg13cmos5l_decap_8
X_2084_ _2084_/Q Tile_X0Y4_FrameData[1] VGND VPWR Tile_X0Y9_FrameStrobe[4] latch
XFILLER_360_84 VPWR VGND sg13cmos5l_decap_8
XFILLER_510_21 VPWR VGND sg13cmos5l_decap_8
X_1035_ _1035_/Q Tile_X0Y0_FrameData[0] VGND VPWR Tile_X0Y9_FrameStrobe[2] latch
XFILLER_253_177 VPWR VGND sg13cmos5l_decap_8
XFILLER_402_119 VPWR VGND sg13cmos5l_decap_8
XFILLER_289_49 VPWR VGND sg13cmos5l_decap_8
XFILLER_586_14 VPWR VGND sg13cmos5l_decap_8
XFILLER_510_98 VPWR VGND sg13cmos5l_decap_8
XFILLER_61_271 VPWR VGND sg13cmos5l_fill_2
XFILLER_556_112 VPWR VGND sg13cmos5l_fill_2
XANTENNA__3397__X Tile_X0Y2_E2BEG[0] VPWR VGND sg13cmos5l_antennanp
XFILLER_166_107 VPWR VGND sg13cmos5l_decap_8
XFILLER_556_156 VPWR VGND sg13cmos5l_decap_8
X_2986_ Tile_X0Y8_FrameData_O[26] Tile_X0Y8_FrameData[26] VPWR VGND sg13cmos5l_buf_1
XFILLER_410_196 VPWR VGND sg13cmos5l_decap_4
XFILLER_308_101 VPWR VGND sg13cmos5l_decap_8
X_1937_ _1937_/Q Tile_X0Y4_FrameData[20] VGND VPWR Tile_X0Y9_FrameStrobe[0] latch
X_4725_ _4725_/X _4779_/X _4778_/X AXI_M_SOC_RDATA10 AXI_M_SOC_RDATA14 _0597_/Q _0596_/Q
+ VPWR VGND sg13cmos5l_mux4_1
XFILLER_571_126 VPWR VGND sg13cmos5l_decap_8
XFILLER_519_63 VPWR VGND sg13cmos5l_decap_4
XFILLER_238_42 VPWR VGND sg13cmos5l_decap_8
XFILLER_713_131 VPWR VGND sg13cmos5l_decap_8
X_4656_ _4656_/X _4661_/X Tile_X0Y7_W6END[0] _4660_/X _4656_/A3 _0167_/Q _0166_/Q
+ VPWR VGND sg13cmos5l_mux4_1
X_1868_ _1868_/Q Tile_X0Y3_FrameData[29] VGND VPWR Tile_X0Y9_FrameStrobe[6] latch
XFILLER_512_204 VPWR VGND sg13cmos5l_decap_4
X_3607_ Tile_X0Y9_S2BEG[1] _4829_/X VPWR VGND sg13cmos5l_buf_1
XFILLER_174_195 VPWR VGND sg13cmos5l_decap_8
X_0819_ _0819_/Q Tile_X0Y9_FrameData[12] VGND VPWR Tile_X0Y9_FrameStrobe[4] latch
XFILLER_469_108 VPWR VGND sg13cmos5l_fill_1
X_4587_ _4587_/X Tile_X0Y8_W2MID[6] Tile_X0Y8_W2END[6] Tile_X0Y8_W6END[6] _4787_/X
+ _0661_/Q _0660_/Q VPWR VGND sg13cmos5l_mux4_1
X_1799_ _1799_/Q Tile_X0Y3_FrameData[2] VGND VPWR Tile_X0Y9_FrameStrobe[3] latch
XFILLER_115_251 VPWR VGND sg13cmos5l_decap_4
X_3538_ Tile_X0Y9_E2BEGb[4] _4860_/X VPWR VGND sg13cmos5l_buf_1
XFILLER_535_84 VPWR VGND sg13cmos5l_decap_4
XFILLER_666_230 VPWR VGND sg13cmos5l_fill_1
XFILLER_520_270 VPWR VGND sg13cmos5l_fill_2
XFILLER_471_28 VPWR VGND sg13cmos5l_decap_8
X_3469_ Tile_X0Y1_FrameData_O[27] Tile_X0Y1_FrameData[27] VPWR VGND sg13cmos5l_buf_1
XFILLER_130_243 VPWR VGND sg13cmos5l_fill_1
XFILLER_681_200 VPWR VGND sg13cmos5l_decap_8
XFILLER_67_28 VPWR VGND sg13cmos5l_decap_8
XFILLER_492_133 VPWR VGND sg13cmos5l_decap_8
XFILLER_291_217 VPWR VGND sg13cmos5l_decap_8
XFILLER_681_266 VPWR VGND sg13cmos5l_decap_8
XFILLER_404_88 VPWR VGND sg13cmos5l_fill_1
XFILLER_641_119 VPWR VGND sg13cmos5l_decap_8
XFILLER_123_56 VPWR VGND sg13cmos5l_fill_2
XFILLER_701_42 VPWR VGND sg13cmos5l_decap_8
XFILLER_579_204 VPWR VGND sg13cmos5l_decap_8
XFILLER_433_222 VPWR VGND sg13cmos5l_decap_8
XFILLER_29_268 VPWR VGND sg13cmos5l_decap_4
XFILLER_270_84 VPWR VGND sg13cmos5l_decap_8
XFILLER_420_21 VPWR VGND sg13cmos5l_decap_8
XFILLER_244_166 VPWR VGND sg13cmos5l_decap_4
XFILLER_16_21 VPWR VGND sg13cmos5l_decap_8
XFILLER_351_7 VPWR VGND sg13cmos5l_decap_8
XFILLER_199_49 VPWR VGND sg13cmos5l_decap_8
XFILLER_449_7 VPWR VGND sg13cmos5l_decap_8
XFILLER_496_14 VPWR VGND sg13cmos5l_decap_8
XFILLER_420_98 VPWR VGND sg13cmos5l_decap_8
XFILLER_616_7 VPWR VGND sg13cmos5l_decap_8
XFILLER_232_4 VPWR VGND sg13cmos5l_fill_1
XANTENNA__3100__X Tile_X0Y7_E2BEGb[6] VPWR VGND sg13cmos5l_antennanp
XFILLER_200_258 VPWR VGND sg13cmos5l_fill_2
XFILLER_646_28 VPWR VGND sg13cmos5l_decap_8
XFILLER_32_42 VPWR VGND sg13cmos5l_fill_2
XFILLER_562_126 VPWR VGND sg13cmos5l_decap_8
XFILLER_429_63 VPWR VGND sg13cmos5l_decap_8
XFILLER_576_91 VPWR VGND sg13cmos5l_decap_8
XFILLER_148_42 VPWR VGND sg13cmos5l_decap_8
XFILLER_20_190 VPWR VGND sg13cmos5l_fill_1
XFILLER_295_81 VPWR VGND sg13cmos5l_fill_2
XFILLER_180_110 VPWR VGND sg13cmos5l_decap_4
XFILLER_503_237 VPWR VGND sg13cmos5l_decap_8
XFILLER_106_0 VPWR VGND sg13cmos5l_decap_4
XFILLER_704_197 VPWR VGND sg13cmos5l_decap_8
XFILLER_106_240 VPWR VGND sg13cmos5l_decap_8
XFILLER_503_259 VPWR VGND sg13cmos5l_decap_8
XFILLER_662_49 VPWR VGND sg13cmos5l_decap_8
XFILLER_381_28 VPWR VGND sg13cmos5l_fill_2
XFILLER_121_232 VPWR VGND sg13cmos5l_decap_4
XFILLER_483_111 VPWR VGND sg13cmos5l_decap_8
XFILLER_79_168 VPWR VGND sg13cmos5l_decap_8
XFILLER_483_122 VPWR VGND sg13cmos5l_fill_1
XFILLER_314_22 VPWR VGND sg13cmos5l_decap_8
XFILLER_94_116 VPWR VGND sg13cmos5l_decap_8
XFILLER_475_0 VPWR VGND sg13cmos5l_decap_8
XFILLER_282_217 VPWR VGND sg13cmos5l_decap_8
XFILLER_632_119 VPWR VGND sg13cmos5l_decap_8
XFILLER_611_42 VPWR VGND sg13cmos5l_decap_8
XFILLER_180_84 VPWR VGND sg13cmos5l_decap_8
XFILLER_35_205 VPWR VGND sg13cmos5l_fill_1
XFILLER_424_244 VPWR VGND sg13cmos5l_decap_8
XFILLER_642_0 VPWR VGND sg13cmos5l_decap_8
XFILLER_235_155 VPWR VGND sg13cmos5l_decap_8
XFILLER_35_238 VPWR VGND sg13cmos5l_fill_1
XFILLER_188_210 VPWR VGND sg13cmos5l_decap_8
XFILLER_640_196 VPWR VGND sg13cmos5l_decap_8
XFILLER_250_169 VPWR VGND sg13cmos5l_decap_8
X_2840_ Tile_X0Y6_E2BEG[5] _4501_/X VPWR VGND sg13cmos5l_buf_1
XFILLER_593_240 VPWR VGND sg13cmos5l_decap_8
XFILLER_148_107 VPWR VGND sg13cmos5l_fill_1
XANTENNA__3010__X Tile_X0Y5_E2BEGb[5] VPWR VGND sg13cmos5l_antennanp
XFILLER_339_30 VPWR VGND sg13cmos5l_fill_1
XFILLER_337_218 VPWR VGND sg13cmos5l_fill_2
XFILLER_556_28 VPWR VGND sg13cmos5l_decap_8
X_2771_ Tile_X0Y3_FrameData_O[29] Tile_X0Y3_FrameData[29] VPWR VGND sg13cmos5l_buf_1
XFILLER_699_119 VPWR VGND sg13cmos5l_decap_8
X_4510_ _4510_/X Tile_X0Y6_W2END[1] AXI_M_SOC_RDATA25 _4555_/X _4554_/X _2587_/Q _2586_/Q
+ VPWR VGND sg13cmos5l_mux4_1
X_1722_ _1722_/Q Tile_X0Y3_FrameData[15] VGND VPWR Tile_X0Y9_FrameStrobe[1] latch
XFILLER_553_159 VPWR VGND sg13cmos5l_decap_4
XFILLER_7_150 VPWR VGND sg13cmos5l_decap_8
XFILLER_305_104 VPWR VGND sg13cmos5l_fill_1
X_4441_ _4441_/X Tile_X0Y9_W1END[1] Tile_X0Y9_WW4END[1] Tile_X0Y9_W6END[9] _4917_/X
+ _0900_/Q _0899_/Q VPWR VGND sg13cmos5l_mux4_1
X_1653_ _1653_/Q Tile_X0Y2_FrameData[28] VGND VPWR Tile_X0Y9_FrameStrobe[7] latch
XFILLER_561_181 VPWR VGND sg13cmos5l_fill_1
XFILLER_171_154 VPWR VGND sg13cmos5l_decap_8
XFILLER_208_56 VPWR VGND sg13cmos5l_decap_8
X_0604_ _0604_/Q Tile_X0Y8_FrameData[3] VGND VPWR Tile_X0Y9_FrameStrobe[5] latch
X_4372_ _4372_/X Tile_X0Y5_W2MID[7] AXI_M_SOC_RVALID _4467_/X _4428_/X _2359_/Q _2358_/Q
+ VPWR VGND sg13cmos5l_mux4_1
X_1584_ _1584_/Q Tile_X0Y2_FrameData[1] VGND VPWR Tile_X0Y9_FrameStrobe[4] latch
XFILLER_572_49 VPWR VGND sg13cmos5l_decap_8
XFILLER_355_84 VPWR VGND sg13cmos5l_decap_8
XFILLER_648_230 VPWR VGND sg13cmos5l_decap_8
XFILLER_505_21 VPWR VGND sg13cmos5l_decap_8
X_3323_ Tile_X0Y4_EE4BEG[11] _4283_/X VPWR VGND sg13cmos5l_buf_1
X_0535_ _0535_/Q Tile_X0Y8_FrameData[8] VGND VPWR Tile_X0Y9_FrameStrobe[3] latch
XFILLER_258_247 VPWR VGND sg13cmos5l_decap_8
X_3254_ Tile_X0Y0_FrameData_O[22] Tile_X0Y0_FrameData[22] VPWR VGND sg13cmos5l_buf_1
XFILLER_608_138 VPWR VGND sg13cmos5l_decap_8
XFILLER_21_0 VPWR VGND sg13cmos5l_decap_8
XFILLER_85_116 VPWR VGND sg13cmos5l_decap_8
X_0466_ _0466_/Q Tile_X0Y8_FrameData[13] VGND VPWR Tile_X0Y9_FrameStrobe[1] latch
XFILLER_505_98 VPWR VGND sg13cmos5l_decap_8
XFILLER_474_155 VPWR VGND sg13cmos5l_decap_8
XFILLER_224_77 VPWR VGND sg13cmos5l_decap_8
X_2205_ _2205_/Q Tile_X0Y5_FrameData[8] VGND VPWR Tile_X0Y9_FrameStrobe[0] latch
XFILLER_226_100 VPWR VGND sg13cmos5l_decap_4
X_3185_ Tile_X0Y0_N4BEG[9] _3185_/A VPWR VGND sg13cmos5l_buf_1
XFILLER_623_119 VPWR VGND sg13cmos5l_decap_8
XFILLER_226_111 VPWR VGND sg13cmos5l_decap_8
X_0397_ _0397_/Q Tile_X0Y7_FrameData[18] VGND VPWR Tile_X0Y9_FrameStrobe[7] latch
XFILLER_521_42 VPWR VGND sg13cmos5l_decap_8
X_2136_ _2136_/Q Tile_X0Y4_FrameData[13] VGND VPWR Tile_X0Y9_FrameStrobe[6] latch
XFILLER_616_193 VPWR VGND sg13cmos5l_fill_2
XFILLER_240_21 VPWR VGND sg13cmos5l_decap_8
XFILLER_415_255 VPWR VGND sg13cmos5l_decap_4
XFILLER_430_203 VPWR VGND sg13cmos5l_decap_8
XFILLER_226_188 VPWR VGND sg13cmos5l_fill_2
X_2067_ _2067_/Q Tile_X0Y4_FrameData[18] VGND VPWR Tile_X0Y9_FrameStrobe[4] latch
XFILLER_597_35 VPWR VGND sg13cmos5l_decap_8
XFILLER_241_136 VPWR VGND sg13cmos5l_decap_8
XFILLER_387_129 VPWR VGND sg13cmos5l_fill_1
X_1018_ _1018_/Q Tile_X0Y0_FrameData[17] VGND VPWR Tile_X0Y9_FrameStrobe[2] latch
XFILLER_576_229 VPWR VGND sg13cmos5l_decap_8
XFILLER_240_98 VPWR VGND sg13cmos5l_decap_8
XFILLER_179_254 VPWR VGND sg13cmos5l_decap_8
XFILLER_584_262 VPWR VGND sg13cmos5l_fill_1
XFILLER_529_189 VPWR VGND sg13cmos5l_decap_8
XFILLER_466_28 VPWR VGND sg13cmos5l_decap_8
X_2969_ Tile_X0Y8_FrameData_O[9] Tile_X0Y8_FrameData[9] VPWR VGND sg13cmos5l_buf_1
XFILLER_194_268 VPWR VGND sg13cmos5l_decap_4
X_4708_ _4708_/X Tile_X0Y6_W1END[0] Tile_X0Y6_W2MID[3] Tile_X0Y6_W2END[3] _4558_/X
+ _2643_/Q _2642_/Q VPWR VGND sg13cmos5l_mux4_1
XFILLER_336_262 VPWR VGND sg13cmos5l_decap_8
XFILLER_351_210 VPWR VGND sg13cmos5l_decap_8
XFILLER_552_170 VPWR VGND sg13cmos5l_decap_8
XFILLER_497_203 VPWR VGND sg13cmos5l_decap_8
X_4639_ _4639_/X Tile_X0Y7_WW4END[4] AXI_M_SOC_RDATA20 _4688_/X _4674_/X _0281_/Q
+ _0280_/Q VPWR VGND sg13cmos5l_mux4_1
XFILLER_701_112 VPWR VGND sg13cmos5l_decap_8
XFILLER_698_163 VPWR VGND sg13cmos5l_decap_8
XFILLER_118_56 VPWR VGND sg13cmos5l_decap_8
XFILLER_118_67 VPWR VGND sg13cmos5l_fill_1
XFILLER_482_49 VPWR VGND sg13cmos5l_decap_8
XFILLER_265_84 VPWR VGND sg13cmos5l_decap_8
XFILLER_118_89 VPWR VGND sg13cmos5l_decap_8
XFILLER_311_118 VPWR VGND sg13cmos5l_decap_8
XFILLER_415_21 VPWR VGND sg13cmos5l_decap_8
XFILLER_701_178 VPWR VGND sg13cmos5l_decap_8
XFILLER_639_252 VPWR VGND sg13cmos5l_fill_2
XANTENNA__3590__X Tile_X0Y9_FrameData_O[20] VPWR VGND sg13cmos5l_antennanp
XFILLER_399_7 VPWR VGND sg13cmos5l_decap_8
XFILLER_304_192 VPWR VGND sg13cmos5l_decap_8
XFILLER_654_255 VPWR VGND sg13cmos5l_decap_8
XFILLER_134_77 VPWR VGND sg13cmos5l_decap_8
XFILLER_465_177 VPWR VGND sg13cmos5l_decap_8
XFILLER_217_100 VPWR VGND sg13cmos5l_fill_1
XFILLER_712_63 VPWR VGND sg13cmos5l_decap_8
XFILLER_566_7 VPWR VGND sg13cmos5l_decap_8
XFILLER_406_200 VPWR VGND sg13cmos5l_decap_8
XFILLER_182_4 VPWR VGND sg13cmos5l_fill_1
XFILLER_217_122 VPWR VGND sg13cmos5l_decap_8
XFILLER_431_42 VPWR VGND sg13cmos5l_decap_8
XFILLER_607_193 VPWR VGND sg13cmos5l_decap_8
XFILLER_27_42 VPWR VGND sg13cmos5l_decap_4
XFILLER_150_21 VPWR VGND sg13cmos5l_decap_8
XFILLER_84_182 VPWR VGND sg13cmos5l_decap_8
XFILLER_27_53 VPWR VGND sg13cmos5l_decap_8
XFILLER_622_152 VPWR VGND sg13cmos5l_decap_8
XFILLER_421_203 VPWR VGND sg13cmos5l_decap_8
XANTENNA__2934__X Tile_X0Y8_E6BEG[2] VPWR VGND sg13cmos5l_antennanp
XFILLER_378_129 VPWR VGND sg13cmos5l_fill_1
XFILLER_232_147 VPWR VGND sg13cmos5l_decap_8
XFILLER_25_260 VPWR VGND sg13cmos5l_fill_1
XFILLER_300_35 VPWR VGND sg13cmos5l_decap_8
XFILLER_43_41 VPWR VGND sg13cmos5l_decap_8
XFILLER_185_213 VPWR VGND sg13cmos5l_decap_8
XFILLER_657_49 VPWR VGND sg13cmos5l_decap_8
XFILLER_386_173 VPWR VGND sg13cmos5l_decap_8
XFILLER_240_191 VPWR VGND sg13cmos5l_decap_8
XFILLER_159_74 VPWR VGND sg13cmos5l_decap_8
XFILLER_590_232 VPWR VGND sg13cmos5l_decap_8
XFILLER_185_268 VPWR VGND sg13cmos5l_decap_4
XFILLER_223_0 VPWR VGND sg13cmos5l_decap_4
XFILLER_138_140 VPWR VGND sg13cmos5l_decap_8
XFILLER_309_55 VPWR VGND sg13cmos5l_fill_2
XFILLER_689_141 VPWR VGND sg13cmos5l_decap_8
XFILLER_299_103 VPWR VGND sg13cmos5l_decap_8
XFILLER_342_221 VPWR VGND sg13cmos5l_decap_8
XFILLER_4_142 VPWR VGND sg13cmos5l_decap_8
XFILLER_99_219 VPWR VGND sg13cmos5l_decap_8
XFILLER_606_42 VPWR VGND sg13cmos5l_decap_8
XFILLER_592_0 VPWR VGND sg13cmos5l_decap_8
XFILLER_325_21 VPWR VGND sg13cmos5l_decap_8
XFILLER_4_35 VPWR VGND sg13cmos5l_decap_8
XFILLER_472_60 VPWR VGND sg13cmos5l_fill_1
X_0320_ _0320_/Q Tile_X0Y7_FrameData[31] VGND VPWR Tile_X0Y9_FrameStrobe[5] latch
XFILLER_67_105 VPWR VGND sg13cmos5l_decap_8
XFILLER_310_140 VPWR VGND sg13cmos5l_decap_8
XFILLER_191_50 VPWR VGND sg13cmos5l_decap_8
XFILLER_645_266 VPWR VGND sg13cmos5l_decap_8
X_0251_ _0251_/Q Tile_X0Y7_FrameData[4] VGND VPWR Tile_X0Y9_FrameStrobe[2] latch
XFILLER_622_63 VPWR VGND sg13cmos5l_decap_8
XFILLER_605_119 VPWR VGND sg13cmos5l_decap_8
XFILLER_456_188 VPWR VGND sg13cmos5l_fill_2
XANTENNA__3005__X Tile_X0Y5_E2BEGb[0] VPWR VGND sg13cmos5l_antennanp
XFILLER_341_42 VPWR VGND sg13cmos5l_decap_8
XFILLER_208_133 VPWR VGND sg13cmos5l_decap_8
X_0182_ _0182_/Q Tile_X0Y7_FrameData[9] VGND VPWR Tile_X0Y9_FrameStrobe[0] latch
XFILLER_471_158 VPWR VGND sg13cmos5l_fill_1
XFILLER_263_250 VPWR VGND sg13cmos5l_decap_4
XFILLER_341_86 VPWR VGND sg13cmos5l_decap_8
XFILLER_84_70 VPWR VGND sg13cmos5l_decap_8
XFILLER_698_56 VPWR VGND sg13cmos5l_decap_8
XFILLER_263_272 VPWR VGND sg13cmos5l_fill_1
XANTENNA__2844__X Tile_X0Y6_E2BEGb[1] VPWR VGND sg13cmos5l_antennanp
XFILLER_613_163 VPWR VGND sg13cmos5l_decap_8
XFILLER_90_141 VPWR VGND sg13cmos5l_decap_8
X_3941_ _3941_/X Tile_X0Y1_W2END[6] AXI_M_SOC_ARREADY _3991_/X _3990_/X _1327_/Q _1326_/Q
+ VPWR VGND sg13cmos5l_mux4_1
XFILLER_16_271 VPWR VGND sg13cmos5l_fill_2
XFILLER_210_35 VPWR VGND sg13cmos5l_decap_8
X_3872_ _3872_/X _3849_/X _0086_/X Tile_X0Y0_S1END[1] Tile_X0Y0_S4END[1] _0977_/Q
+ _0976_/Q VPWR VGND sg13cmos5l_mux4_1
XFILLER_176_213 VPWR VGND sg13cmos5l_decap_8
XFILLER_567_49 VPWR VGND sg13cmos5l_decap_8
XFILLER_377_173 VPWR VGND sg13cmos5l_decap_4
XFILLER_31_263 VPWR VGND sg13cmos5l_fill_2
X_2823_ Tile_X0Y4_E2BEG[1] _4257_/X VPWR VGND sg13cmos5l_buf_1
XFILLER_286_28 VPWR VGND sg13cmos5l_decap_8
XFILLER_526_148 VPWR VGND sg13cmos5l_decap_8
XFILLER_715_259 VPWR VGND sg13cmos5l_fill_1
X_2754_ Tile_X0Y3_FrameData_O[12] Tile_X0Y3_FrameData[12] VPWR VGND sg13cmos5l_buf_1
XFILLER_392_165 VPWR VGND sg13cmos5l_decap_8
XFILLER_191_227 VPWR VGND sg13cmos5l_decap_8
XFILLER_366_50 VPWR VGND sg13cmos5l_decap_8
XFILLER_69_0 VPWR VGND sg13cmos5l_decap_8
XFILLER_366_61 VPWR VGND sg13cmos5l_fill_1
X_1705_ _1705_/Q Tile_X0Y3_FrameData[0] VGND VPWR Tile_X0Y9_FrameStrobe[0] latch
X_2685_ _2685_/Q Tile_X0Y6_FrameData[10] VGND VPWR Tile_X0Y9_FrameStrobe[7] latch
X_4424_ _4424_/X Tile_X0Y6_W1END[2] Tile_X0Y6_W6END[6] _4582_/X _4542_/X _2691_/Q
+ _2690_/Q VPWR VGND sg13cmos5l_mux4_1
XFILLER_516_42 VPWR VGND sg13cmos5l_decap_8
X_1636_ _1636_/Q Tile_X0Y2_FrameData[13] VGND VPWR Tile_X0Y9_FrameStrobe[6] latch
XFILLER_695_133 VPWR VGND sg13cmos5l_decap_4
XFILLER_479_258 VPWR VGND sg13cmos5l_decap_8
XFILLER_663_70 VPWR VGND sg13cmos5l_decap_8
XFILLER_235_21 VPWR VGND sg13cmos5l_decap_8
XFILLER_695_166 VPWR VGND sg13cmos5l_decap_8
XFILLER_663_92 VPWR VGND sg13cmos5l_decap_8
X_4355_ _4355_/X Tile_X0Y6_W2MID[6] Tile_X0Y6_W2END[6] Tile_X0Y6_W6END[6] _4555_/X
+ _2685_/Q _2684_/Q VPWR VGND sg13cmos5l_mux4_1
X_1567_ _1567_/Q Tile_X0Y2_FrameData[18] VGND VPWR Tile_X0Y9_FrameStrobe[4] latch
XFILLER_494_228 VPWR VGND sg13cmos5l_decap_8
X_3306_ Tile_X0Y0_E2BEG[6] _3810_/X VPWR VGND sg13cmos5l_buf_1
XFILLER_301_140 VPWR VGND sg13cmos5l_decap_8
X_0518_ _0518_/Q Tile_X0Y8_FrameData[25] VGND VPWR Tile_X0Y9_FrameStrobe[3] latch
XFILLER_636_233 VPWR VGND sg13cmos5l_decap_8
X_4286_ _4286_/X Tile_X0Y4_WW4END[1] AXI_M_SOC_BRESP1 _4337_/X _4315_/X _2041_/Q _2040_/Q
+ VPWR VGND sg13cmos5l_mux4_1
XFILLER_58_116 VPWR VGND sg13cmos5l_decap_8
XFILLER_447_144 VPWR VGND sg13cmos5l_decap_8
X_1498_ _1498_/Q Tile_X0Y2_FrameData[23] VGND VPWR Tile_X0Y9_FrameStrobe[2] latch
XFILLER_100_235 VPWR VGND sg13cmos5l_decap_4
X_3237_ Tile_X0Y0_FrameData_O[5] Tile_X0Y0_FrameData[5] VPWR VGND sg13cmos5l_buf_1
XFILLER_651_203 VPWR VGND sg13cmos5l_decap_8
XFILLER_100_246 VPWR VGND sg13cmos5l_decap_8
XFILLER_104_14 VPWR VGND sg13cmos5l_decap_8
X_0449_ _0449_/Q Tile_X0Y8_FrameData[30] VGND VPWR Tile_X0Y9_FrameStrobe[1] latch
XFILLER_462_114 VPWR VGND sg13cmos5l_decap_8
XFILLER_100_268 VPWR VGND sg13cmos5l_decap_4
XFILLER_251_42 VPWR VGND sg13cmos5l_decap_8
X_3168_ Tile_X0Y4_E6BEG[5] _4293_/X VPWR VGND sg13cmos5l_buf_1
XFILLER_604_130 VPWR VGND sg13cmos5l_decap_8
XFILLER_66_182 VPWR VGND sg13cmos5l_decap_8
XANTENNA__2754__X Tile_X0Y3_FrameData_O[12] VPWR VGND sg13cmos5l_antennanp
X_2119_ _2119_/Q Tile_X0Y4_FrameData[30] VGND VPWR Tile_X0Y9_FrameStrobe[6] latch
XFILLER_254_272 VPWR VGND sg13cmos5l_fill_1
XFILLER_403_214 VPWR VGND sg13cmos5l_decap_8
X_3099_ Tile_X0Y7_E2BEGb[5] _4625_/X VPWR VGND sg13cmos5l_buf_1
XFILLER_81_152 VPWR VGND sg13cmos5l_decap_8
XFILLER_604_185 VPWR VGND sg13cmos5l_decap_8
XFILLER_14_219 VPWR VGND sg13cmos5l_decap_8
XFILLER_403_247 VPWR VGND sg13cmos5l_decap_8
XFILLER_214_158 VPWR VGND sg13cmos5l_decap_8
XFILLER_401_78 VPWR VGND sg13cmos5l_fill_1
XFILLER_120_35 VPWR VGND sg13cmos5l_decap_8
XFILLER_368_140 VPWR VGND sg13cmos5l_fill_1
XFILLER_147_7 VPWR VGND sg13cmos5l_decap_8
XFILLER_80_28 VPWR VGND sg13cmos5l_decap_4
XFILLER_477_49 VPWR VGND sg13cmos5l_decap_8
XFILLER_572_210 VPWR VGND sg13cmos5l_decap_8
XFILLER_196_28 VPWR VGND sg13cmos5l_decap_8
XFILLER_368_195 VPWR VGND sg13cmos5l_fill_1
XFILLER_706_226 VPWR VGND sg13cmos5l_decap_8
XANTENNA__3585__X Tile_X0Y9_FrameData_O[15] VPWR VGND sg13cmos5l_antennanp
XFILLER_167_268 VPWR VGND sg13cmos5l_decap_4
XFILLER_383_154 VPWR VGND sg13cmos5l_decap_8
XFILLER_182_238 VPWR VGND sg13cmos5l_fill_2
XFILLER_13_99 VPWR VGND sg13cmos5l_fill_2
XFILLER_129_77 VPWR VGND sg13cmos5l_decap_8
XFILLER_525_170 VPWR VGND sg13cmos5l_decap_8
XFILLER_324_221 VPWR VGND sg13cmos5l_decap_8
XFILLER_707_63 VPWR VGND sg13cmos5l_decap_8
XFILLER_426_42 VPWR VGND sg13cmos5l_decap_8
XFILLER_540_140 VPWR VGND sg13cmos5l_decap_4
XFILLER_150_102 VPWR VGND sg13cmos5l_decap_8
XFILLER_573_70 VPWR VGND sg13cmos5l_decap_8
XFILLER_145_21 VPWR VGND sg13cmos5l_decap_8
XFILLER_686_177 VPWR VGND sg13cmos5l_decap_8
XANTENNA__2929__X Tile_X0Y8_E2BEGb[5] VPWR VGND sg13cmos5l_antennanp
XFILLER_683_7 VPWR VGND sg13cmos5l_decap_8
XFILLER_627_200 VPWR VGND sg13cmos5l_fill_2
XFILLER_485_239 VPWR VGND sg13cmos5l_fill_2
XFILLER_289_191 VPWR VGND sg13cmos5l_decap_8
XFILLER_438_144 VPWR VGND sg13cmos5l_decap_8
XFILLER_627_266 VPWR VGND sg13cmos5l_decap_8
XFILLER_237_217 VPWR VGND sg13cmos5l_fill_2
XFILLER_453_103 VPWR VGND sg13cmos5l_decap_8
XFILLER_642_203 VPWR VGND sg13cmos5l_decap_8
XFILLER_599_107 VPWR VGND sg13cmos5l_decap_8
XFILLER_161_31 VPWR VGND sg13cmos5l_fill_1
XFILLER_599_118 VPWR VGND sg13cmos5l_fill_2
XFILLER_161_53 VPWR VGND sg13cmos5l_decap_8
XFILLER_64_119 VPWR VGND sg13cmos5l_decap_8
XFILLER_453_147 VPWR VGND sg13cmos5l_decap_8
XFILLER_173_0 VPWR VGND sg13cmos5l_decap_8
XFILLER_245_272 VPWR VGND sg13cmos5l_fill_1
XFILLER_610_122 VPWR VGND sg13cmos5l_fill_2
XFILLER_54_51 VPWR VGND sg13cmos5l_fill_1
XFILLER_205_169 VPWR VGND sg13cmos5l_decap_8
XFILLER_72_185 VPWR VGND sg13cmos5l_decap_8
XFILLER_54_62 VPWR VGND sg13cmos5l_decap_8
XFILLER_340_0 VPWR VGND sg13cmos5l_decap_8
XFILLER_438_0 VPWR VGND sg13cmos5l_decap_8
XFILLER_158_202 VPWR VGND sg13cmos5l_decap_8
XFILLER_684_14 VPWR VGND sg13cmos5l_decap_8
XANTENNA__3495__X Tile_X0Y1_E6BEG[5] VPWR VGND sg13cmos5l_antennanp
XFILLER_110_90 VPWR VGND sg13cmos5l_decap_8
XFILLER_70_50 VPWR VGND sg13cmos5l_decap_8
XFILLER_605_0 VPWR VGND sg13cmos5l_decap_8
XFILLER_9_256 VPWR VGND sg13cmos5l_decap_4
XFILLER_173_205 VPWR VGND sg13cmos5l_decap_8
XFILLER_374_165 VPWR VGND sg13cmos5l_decap_8
XFILLER_467_93 VPWR VGND sg13cmos5l_decap_8
XFILLER_62_7 VPWR VGND sg13cmos5l_decap_8
XFILLER_617_63 VPWR VGND sg13cmos5l_decap_8
XFILLER_126_154 VPWR VGND sg13cmos5l_decap_8
XFILLER_617_96 VPWR VGND sg13cmos5l_fill_1
X_2470_ _2470_/Q Tile_X0Y6_FrameData[1] VGND VPWR Tile_X0Y9_FrameStrobe[0] latch
XFILLER_126_187 VPWR VGND sg13cmos5l_decap_8
XFILLER_336_75 VPWR VGND sg13cmos5l_decap_8
XFILLER_330_213 VPWR VGND sg13cmos5l_decap_8
XFILLER_476_206 VPWR VGND sg13cmos5l_decap_8
XFILLER_79_70 VPWR VGND sg13cmos5l_decap_8
X_1421_ _1421_/Q Tile_X0Y1_FrameData[12] VGND VPWR Tile_X0Y9_FrameStrobe[7] latch
XANTENNA__2839__X Tile_X0Y6_E2BEG[4] VPWR VGND sg13cmos5l_antennanp
XFILLER_618_200 VPWR VGND sg13cmos5l_decap_8
XFILLER_141_179 VPWR VGND sg13cmos5l_decap_8
X_4140_ _4140_/X Tile_X0Y1_W1END[2] Tile_X0Y1_W2MID[1] Tile_X0Y1_W2END[1] _3990_/X
+ _1369_/Q _1368_/Q VPWR VGND sg13cmos5l_mux4_1
XFILLER_692_136 VPWR VGND sg13cmos5l_decap_8
X_1352_ _1352_/Q Tile_X0Y1_FrameData[17] VGND VPWR Tile_X0Y9_FrameStrobe[5] latch
XFILLER_429_133 VPWR VGND sg13cmos5l_decap_8
XFILLER_633_84 VPWR VGND sg13cmos5l_decap_8
XFILLER_205_35 VPWR VGND sg13cmos5l_decap_8
XFILLER_491_209 VPWR VGND sg13cmos5l_fill_2
XFILLER_295_161 VPWR VGND sg13cmos5l_decap_8
XFILLER_228_217 VPWR VGND sg13cmos5l_fill_2
X_0303_ _0303_/Q Tile_X0Y7_FrameData[16] VGND VPWR Tile_X0Y9_FrameStrobe[4] latch
XFILLER_618_266 VPWR VGND sg13cmos5l_decap_8
XFILLER_484_261 VPWR VGND sg13cmos5l_fill_1
X_4071_ _4071_/X Tile_X0Y2_WW4END[0] AXI_M_SOC_AWREADY _4116_/X _4097_/X _1531_/Q
+ _1530_/Q VPWR VGND sg13cmos5l_mux4_1
XFILLER_352_63 VPWR VGND sg13cmos5l_decap_8
X_1283_ _1283_/Q Tile_X0Y1_FrameData[22] VGND VPWR Tile_X0Y9_FrameStrobe[3] latch
X_3022_ Tile_X0Y5_E6BEG[9] _4413_/X VPWR VGND sg13cmos5l_buf_1
XFILLER_95_91 VPWR VGND sg13cmos5l_decap_8
X_0234_ _0234_/Q Tile_X0Y7_FrameData[21] VGND VPWR Tile_X0Y9_FrameStrobe[2] latch
XFILLER_243_209 VPWR VGND sg13cmos5l_fill_1
XFILLER_444_169 VPWR VGND sg13cmos5l_decap_8
XFILLER_502_77 VPWR VGND sg13cmos5l_decap_8
X_0165_ _0165_/Q Tile_X0Y7_FrameData[26] VGND VPWR Tile_X0Y9_FrameStrobe[0] latch
XFILLER_601_111 VPWR VGND sg13cmos5l_decap_8
XFILLER_452_191 VPWR VGND sg13cmos5l_decap_8
XFILLER_63_174 VPWR VGND sg13cmos5l_decap_8
XFILLER_397_246 VPWR VGND sg13cmos5l_decap_8
X_0096_ _0096_/X _4000_/X _4001_/X _2410_/Q VPWR VGND sg13cmos5l_mux2_1
X_3924_ _3924_/X Tile_X0Y3_W1END[1] Tile_X0Y3_WW4END[1] Tile_X0Y3_W6END[9] _4223_/X
+ _1898_/Q _1897_/Q VPWR VGND sg13cmos5l_mux4_1
XFILLER_149_213 VPWR VGND sg13cmos5l_decap_8
XFILLER_539_262 VPWR VGND sg13cmos5l_fill_1
XFILLER_658_70 VPWR VGND sg13cmos5l_decap_8
XFILLER_594_14 VPWR VGND sg13cmos5l_decap_8
X_3855_ _3855_/X _3891_/X _3890_/X Tile_X0Y0_S2MID[1] Tile_X0Y0_S2END[1] _0961_/Q
+ _0960_/Q VPWR VGND sg13cmos5l_mux4_1
XFILLER_554_232 VPWR VGND sg13cmos5l_fill_1
XFILLER_164_205 VPWR VGND sg13cmos5l_fill_1
X_2806_ Tile_X0Y3_E2BEGb[4] _4160_/X VPWR VGND sg13cmos5l_buf_1
XFILLER_164_227 VPWR VGND sg13cmos5l_decap_8
X_3786_ _3786_/X Tile_X0Y0_W2MID[5] Tile_X0Y0_W2END[5] Tile_X0Y0_W6END[5] _3857_/X
+ _1165_/Q _1164_/Q VPWR VGND sg13cmos5l_mux4_1
X_0998_ _0998_/Q Tile_X0Y0_FrameData[5] VGND VPWR Tile_X0Y9_FrameStrobe[1] latch
XFILLER_527_63 VPWR VGND sg13cmos5l_fill_1
X_2737_ Tile_X0Y4_E1BEG[0] _4252_/X VPWR VGND sg13cmos5l_buf_1
XFILLER_507_181 VPWR VGND sg13cmos5l_decap_8
XFILLER_306_243 VPWR VGND sg13cmos5l_decap_8
XFILLER_674_91 VPWR VGND sg13cmos5l_decap_8
XFILLER_380_168 VPWR VGND sg13cmos5l_decap_8
XFILLER_117_165 VPWR VGND sg13cmos5l_decap_8
XFILLER_172_271 VPWR VGND sg13cmos5l_fill_2
X_2668_ _2668_/Q Tile_X0Y6_FrameData[27] VGND VPWR Tile_X0Y9_FrameStrobe[7] latch
XFILLER_59_29 VPWR VGND sg13cmos5l_fill_1
XFILLER_522_173 VPWR VGND sg13cmos5l_decap_8
XANTENNA__2749__X Tile_X0Y3_FrameData_O[7] VPWR VGND sg13cmos5l_antennanp
X_1619_ _1619_/Q Tile_X0Y2_FrameData[30] VGND VPWR Tile_X0Y9_FrameStrobe[6] latch
X_4407_ _4407_/X _0097_/X _0156_/X _4459_/X _4463_/X _2289_/Q _2288_/Q VPWR VGND sg13cmos5l_mux4_1
XFILLER_321_235 VPWR VGND sg13cmos5l_decap_8
XFILLER_246_97 VPWR VGND sg13cmos5l_decap_8
XFILLER_467_228 VPWR VGND sg13cmos5l_decap_8
X_2599_ _2599_/Q Tile_X0Y6_FrameData[0] VGND VPWR Tile_X0Y9_FrameStrobe[4] latch
XFILLER_609_222 VPWR VGND sg13cmos5l_decap_8
X_4338_ _4338_/X _4308_/X _0160_/X _4307_/X _0110_/X _1977_/Q _1976_/Q VPWR VGND sg13cmos5l_mux4_1
XFILLER_115_35 VPWR VGND sg13cmos5l_decap_8
XFILLER_543_84 VPWR VGND sg13cmos5l_fill_1
XFILLER_286_161 VPWR VGND sg13cmos5l_decap_8
XFILLER_262_63 VPWR VGND sg13cmos5l_decap_4
X_4269_ _4269_/X Tile_X0Y4_W2END[2] AXI_M_SOC_BRESP0 _4317_/X _4316_/X _2075_/Q _2074_/Q
+ VPWR VGND sg13cmos5l_mux4_1
XFILLER_75_28 VPWR VGND sg13cmos5l_decap_8
XFILLER_490_220 VPWR VGND sg13cmos5l_decap_8
XFILLER_412_22 VPWR VGND sg13cmos5l_decap_8
XFILLER_691_191 VPWR VGND sg13cmos5l_decap_8
XFILLER_624_247 VPWR VGND sg13cmos5l_fill_2
XFILLER_435_147 VPWR VGND sg13cmos5l_decap_8
XFILLER_39_160 VPWR VGND sg13cmos5l_fill_2
XFILLER_490_264 VPWR VGND sg13cmos5l_fill_1
XFILLER_227_272 VPWR VGND sg13cmos5l_fill_1
XFILLER_264_7 VPWR VGND sg13cmos5l_decap_8
XFILLER_388_213 VPWR VGND sg13cmos5l_decap_8
XFILLER_199_135 VPWR VGND sg13cmos5l_decap_4
XFILLER_131_78 VPWR VGND sg13cmos5l_decap_8
XFILLER_388_246 VPWR VGND sg13cmos5l_decap_8
XFILLER_388_257 VPWR VGND sg13cmos5l_fill_2
XFILLER_199_168 VPWR VGND sg13cmos5l_decap_8
XFILLER_431_7 VPWR VGND sg13cmos5l_decap_8
XFILLER_24_21 VPWR VGND sg13cmos5l_decap_8
XFILLER_529_7 VPWR VGND sg13cmos5l_decap_8
XFILLER_568_70 VPWR VGND sg13cmos5l_decap_8
XFILLER_10_222 VPWR VGND sg13cmos5l_fill_2
XFILLER_210_161 VPWR VGND sg13cmos5l_decap_8
XFILLER_356_154 VPWR VGND sg13cmos5l_decap_8
XFILLER_40_20 VPWR VGND sg13cmos5l_decap_8
XFILLER_371_113 VPWR VGND sg13cmos5l_fill_2
XFILLER_6_237 VPWR VGND sg13cmos5l_fill_2
XFILLER_505_129 VPWR VGND sg13cmos5l_decap_8
XFILLER_654_28 VPWR VGND sg13cmos5l_decap_8
XFILLER_437_63 VPWR VGND sg13cmos5l_decap_8
XFILLER_108_154 VPWR VGND sg13cmos5l_decap_8
XFILLER_584_91 VPWR VGND sg13cmos5l_decap_8
XFILLER_123_102 VPWR VGND sg13cmos5l_decap_8
XFILLER_163_271 VPWR VGND sg13cmos5l_fill_2
XFILLER_312_224 VPWR VGND sg13cmos5l_decap_8
XFILLER_123_168 VPWR VGND sg13cmos5l_decap_8
XFILLER_312_268 VPWR VGND sg13cmos5l_decap_4
XFILLER_77_200 VPWR VGND sg13cmos5l_decap_8
XFILLER_306_67 VPWR VGND sg13cmos5l_decap_8
XFILLER_453_73 VPWR VGND sg13cmos5l_decap_4
XFILLER_77_211 VPWR VGND sg13cmos5l_fill_2
XFILLER_670_49 VPWR VGND sg13cmos5l_decap_8
XFILLER_603_21 VPWR VGND sg13cmos5l_decap_8
XFILLER_466_250 VPWR VGND sg13cmos5l_decap_8
XFILLER_453_95 VPWR VGND sg13cmos5l_fill_1
XFILLER_290_0 VPWR VGND sg13cmos5l_decap_4
XFILLER_388_0 VPWR VGND sg13cmos5l_decap_8
XFILLER_277_183 VPWR VGND sg13cmos5l_decap_8
XFILLER_1_14 VPWR VGND sg13cmos5l_decap_8
XFILLER_615_214 VPWR VGND sg13cmos5l_decap_8
XFILLER_37_108 VPWR VGND sg13cmos5l_decap_4
XFILLER_426_147 VPWR VGND sg13cmos5l_decap_8
XFILLER_603_87 VPWR VGND sg13cmos5l_decap_8
XFILLER_679_14 VPWR VGND sg13cmos5l_decap_8
XFILLER_292_164 VPWR VGND sg13cmos5l_decap_8
XFILLER_92_236 VPWR VGND sg13cmos5l_decap_8
XFILLER_679_25 VPWR VGND sg13cmos5l_fill_2
XFILLER_555_0 VPWR VGND sg13cmos5l_decap_4
XFILLER_218_272 VPWR VGND sg13cmos5l_fill_1
XFILLER_441_117 VPWR VGND sg13cmos5l_decap_8
XFILLER_679_58 VPWR VGND sg13cmos5l_decap_8
XFILLER_679_69 VPWR VGND sg13cmos5l_fill_1
XFILLER_233_242 VPWR VGND sg13cmos5l_fill_1
XANTENNA_140 Tile_X0Y6_FrameData[31] VPWR VGND sg13cmos5l_antennanp
XANTENNA_151 Tile_X0Y9_FrameStrobe[15] VPWR VGND sg13cmos5l_antennanp
XANTENNA_162 Tile_X0Y9_FrameStrobe[8] VPWR VGND sg13cmos5l_antennanp
XANTENNA_173 Tile_X0Y9_FrameStrobe[8] VPWR VGND sg13cmos5l_antennanp
XFILLER_379_268 VPWR VGND sg13cmos5l_decap_4
XANTENNA_184 Tile_X0Y9_FrameStrobe[8] VPWR VGND sg13cmos5l_antennanp
XFILLER_394_205 VPWR VGND sg13cmos5l_decap_8
X_1970_ _1970_/Q Tile_X0Y4_FrameData[19] VGND VPWR Tile_X0Y9_FrameStrobe[1] latch
XANTENNA_195 Tile_X0Y9_N2MID[1] VPWR VGND sg13cmos5l_antennanp
XFILLER_695_35 VPWR VGND sg13cmos5l_decap_8
XFILLER_478_70 VPWR VGND sg13cmos5l_fill_2
X_0921_ _0921_/Q Tile_X0Y9_FrameData[6] VGND VPWR Tile_X0Y9_FrameStrobe[7] latch
XFILLER_60_188 VPWR VGND sg13cmos5l_decap_8
XFILLER_81_82 VPWR VGND sg13cmos5l_decap_8
XFILLER_60_199 VPWR VGND sg13cmos5l_fill_1
XFILLER_201_172 VPWR VGND sg13cmos5l_decap_8
X_3640_ AXI_M_SOC_AWADDR1 Tile_X0Y5_WW4END[1] Tile_X0Y5_WW4END[9] Tile_X0Y5_W6END[1]
+ _4452_/X _2269_/Q _2268_/Q VPWR VGND sg13cmos5l_mux4_1
XFILLER_536_254 VPWR VGND sg13cmos5l_decap_8
X_0852_ _0852_/Q Tile_X0Y9_FrameData[11] VGND VPWR Tile_X0Y9_FrameStrobe[5] latch
XFILLER_347_187 VPWR VGND sg13cmos5l_decap_8
X_3571_ Tile_X0Y9_FrameData_O[1] Tile_X0Y9_FrameData[1] VPWR VGND sg13cmos5l_buf_1
XFILLER_564_28 VPWR VGND sg13cmos5l_decap_8
XFILLER_347_63 VPWR VGND sg13cmos5l_decap_8
X_0783_ _0783_/Q Tile_X0Y9_FrameData[16] VGND VPWR Tile_X0Y9_FrameStrobe[3] latch
XFILLER_697_239 VPWR VGND sg13cmos5l_decap_8
XFILLER_551_268 VPWR VGND sg13cmos5l_decap_4
XFILLER_494_91 VPWR VGND sg13cmos5l_decap_8
X_2522_ _2522_/Q Tile_X0Y6_FrameData[13] VGND VPWR Tile_X0Y9_FrameStrobe[2] latch
XFILLER_504_140 VPWR VGND sg13cmos5l_decap_8
XFILLER_154_271 VPWR VGND sg13cmos5l_fill_2
XFILLER_504_151 VPWR VGND sg13cmos5l_decap_8
XFILLER_5_270 VPWR VGND sg13cmos5l_fill_2
XFILLER_303_213 VPWR VGND sg13cmos5l_fill_2
X_2453_ _2453_/Q Tile_X0Y6_FrameData[18] VGND VPWR Tile_X0Y9_FrameStrobe[0] latch
XFILLER_504_195 VPWR VGND sg13cmos5l_decap_8
X_1404_ _1404_/Q Tile_X0Y1_FrameData[29] VGND VPWR Tile_X0Y9_FrameStrobe[7] latch
X_2384_ _2384_/Q Tile_X0Y5_FrameData[21] VGND VPWR Tile_X0Y9_FrameStrobe[6] latch
XFILLER_665_158 VPWR VGND sg13cmos5l_decap_8
XFILLER_580_49 VPWR VGND sg13cmos5l_decap_8
XFILLER_457_250 VPWR VGND sg13cmos5l_decap_8
XFILLER_513_21 VPWR VGND sg13cmos5l_decap_8
X_4123_ _4123_/X _4095_/X _0094_/X _4094_/X Tile_X0Y0_S4END[11] _1467_/Q _1466_/Q
+ VPWR VGND sg13cmos5l_mux4_1
X_1335_ _1335_/Q Tile_X0Y1_FrameData[2] VGND VPWR Tile_X0Y9_FrameStrobe[4] latch
XFILLER_457_272 VPWR VGND sg13cmos5l_fill_1
XFILLER_472_220 VPWR VGND sg13cmos5l_fill_1
XFILLER_232_22 VPWR VGND sg13cmos5l_decap_8
X_4054_ _4054_/X Tile_X0Y2_W2END[1] AXI_M_SOC_AWREADY _4099_/X _4098_/X _1565_/Q _1564_/Q
+ VPWR VGND sg13cmos5l_mux4_1
X_1266_ _1266_/Q Tile_X0Y1_FrameData[7] VGND VPWR Tile_X0Y9_FrameStrobe[2] latch
XFILLER_589_14 VPWR VGND sg13cmos5l_decap_8
XFILLER_513_98 VPWR VGND sg13cmos5l_decap_8
XFILLER_472_264 VPWR VGND sg13cmos5l_decap_8
XFILLER_283_175 VPWR VGND sg13cmos5l_decap_8
XFILLER_209_272 VPWR VGND sg13cmos5l_fill_1
XFILLER_83_258 VPWR VGND sg13cmos5l_decap_4
X_3005_ Tile_X0Y5_E2BEGb[0] _4380_/X VPWR VGND sg13cmos5l_buf_1
XFILLER_621_206 VPWR VGND sg13cmos5l_decap_8
X_0217_ _0217_/Q Tile_X0Y7_FrameData[6] VGND VPWR Tile_X0Y9_FrameStrobe[1] latch
X_1197_ _1197_/Q Tile_X0Y1_FrameData[12] VGND VPWR Tile_X0Y9_FrameStrobe[0] latch
XFILLER_36_163 VPWR VGND sg13cmos5l_decap_8
X_0148_ AXI_M_SOC_ARCACHE2 _0929_/Q _3776_/X VPWR VGND sg13cmos5l_nor2b_1
XFILLER_51_133 VPWR VGND sg13cmos5l_decap_8
X_0079_ _0079_/X _4105_/X _4106_/X _2669_/Q VPWR VGND sg13cmos5l_mux2_1
XFILLER_51_177 VPWR VGND sg13cmos5l_decap_8
XFILLER_196_149 VPWR VGND sg13cmos5l_decap_8
X_3907_ _3907_/X _4014_/X _4018_/X _3999_/X _3993_/X _1395_/Q _1394_/Q VPWR VGND sg13cmos5l_mux4_1
X_4887_ _4887_/X AXI_M_SOC_RDATA3 _4920_/X _4924_/X _4907_/X _0769_/Q _0768_/Q VPWR
+ VGND sg13cmos5l_mux4_1
XFILLER_338_143 VPWR VGND sg13cmos5l_decap_4
XFILLER_527_254 VPWR VGND sg13cmos5l_decap_8
X_3838_ _3838_/X _0085_/X Tile_X0Y0_S4END[2] _3872_/X _3871_/X _1029_/Q _1028_/Q VPWR
+ VGND sg13cmos5l_mux4_1
XFILLER_538_95 VPWR VGND sg13cmos5l_fill_2
XFILLER_474_28 VPWR VGND sg13cmos5l_decap_8
X_3769_ _3769_/X Tile_X0Y1_WW4END[2] Tile_X0Y1_WW4END[10] Tile_X0Y1_W6END[10] _4018_/X
+ _1237_/Q _1236_/Q VPWR VGND sg13cmos5l_mux4_1
XFILLER_257_74 VPWR VGND sg13cmos5l_decap_4
XFILLER_353_168 VPWR VGND sg13cmos5l_decap_8
XFILLER_3_218 VPWR VGND sg13cmos5l_decap_8
XFILLER_105_102 VPWR VGND sg13cmos5l_fill_1
XFILLER_105_124 VPWR VGND sg13cmos5l_fill_2
XFILLER_696_250 VPWR VGND sg13cmos5l_decap_8
XFILLER_10_56 VPWR VGND sg13cmos5l_decap_8
XFILLER_160_230 VPWR VGND sg13cmos5l_decap_8
XFILLER_407_77 VPWR VGND sg13cmos5l_decap_8
XFILLER_126_56 VPWR VGND sg13cmos5l_decap_8
XFILLER_704_42 VPWR VGND sg13cmos5l_decap_8
XFILLER_59_200 VPWR VGND sg13cmos5l_decap_8
XFILLER_490_49 VPWR VGND sg13cmos5l_decap_8
XFILLER_273_84 VPWR VGND sg13cmos5l_decap_4
XFILLER_510_187 VPWR VGND sg13cmos5l_decap_8
XFILLER_423_21 VPWR VGND sg13cmos5l_decap_8
XFILLER_120_149 VPWR VGND sg13cmos5l_fill_1
XFILLER_86_49 VPWR VGND sg13cmos5l_decap_8
XFILLER_671_106 VPWR VGND sg13cmos5l_fill_1
XFILLER_19_21 VPWR VGND sg13cmos5l_decap_8
XFILLER_671_128 VPWR VGND sg13cmos5l_decap_8
XFILLER_381_7 VPWR VGND sg13cmos5l_decap_8
XFILLER_479_7 VPWR VGND sg13cmos5l_decap_8
XFILLER_274_131 VPWR VGND sg13cmos5l_decap_8
XFILLER_664_191 VPWR VGND sg13cmos5l_decap_8
XFILLER_423_98 VPWR VGND sg13cmos5l_decap_8
XFILLER_408_158 VPWR VGND sg13cmos5l_decap_8
XFILLER_499_14 VPWR VGND sg13cmos5l_decap_8
XFILLER_408_169 VPWR VGND sg13cmos5l_fill_2
XFILLER_142_77 VPWR VGND sg13cmos5l_decap_8
XFILLER_74_258 VPWR VGND sg13cmos5l_fill_1
XFILLER_646_7 VPWR VGND sg13cmos5l_decap_8
XANTENNA__3103__X Tile_X0Y7_E6BEG[1] VPWR VGND sg13cmos5l_antennanp
XFILLER_215_264 VPWR VGND sg13cmos5l_fill_1
XFILLER_649_28 VPWR VGND sg13cmos5l_decap_8
XFILLER_42_122 VPWR VGND sg13cmos5l_decap_8
XFILLER_577_143 VPWR VGND sg13cmos5l_decap_8
XFILLER_431_161 VPWR VGND sg13cmos5l_decap_8
XFILLER_35_64 VPWR VGND sg13cmos5l_fill_2
XFILLER_579_91 VPWR VGND sg13cmos5l_decap_8
XANTENNA__2942__X Tile_X0Y8_E6BEG[10] VPWR VGND sg13cmos5l_antennanp
XFILLER_620_272 VPWR VGND sg13cmos5l_fill_1
XFILLER_368_29 VPWR VGND sg13cmos5l_decap_8
XFILLER_592_102 VPWR VGND sg13cmos5l_decap_8
XFILLER_298_70 VPWR VGND sg13cmos5l_decap_4
XFILLER_187_138 VPWR VGND sg13cmos5l_decap_8
XFILLER_187_149 VPWR VGND sg13cmos5l_fill_1
XFILLER_230_256 VPWR VGND sg13cmos5l_fill_2
XFILLER_42_188 VPWR VGND sg13cmos5l_decap_4
XFILLER_329_132 VPWR VGND sg13cmos5l_decap_4
XFILLER_136_0 VPWR VGND sg13cmos5l_decap_8
XFILLER_128_227 VPWR VGND sg13cmos5l_decap_8
XFILLER_665_49 VPWR VGND sg13cmos5l_decap_8
XFILLER_448_84 VPWR VGND sg13cmos5l_decap_8
XFILLER_329_187 VPWR VGND sg13cmos5l_decap_8
XFILLER_595_90 VPWR VGND sg13cmos5l_decap_8
XFILLER_384_28 VPWR VGND sg13cmos5l_decap_8
XFILLER_167_63 VPWR VGND sg13cmos5l_decap_8
XFILLER_303_0 VPWR VGND sg13cmos5l_decap_4
XFILLER_344_168 VPWR VGND sg13cmos5l_decap_8
XFILLER_136_271 VPWR VGND sg13cmos5l_fill_2
XFILLER_498_161 VPWR VGND sg13cmos5l_decap_8
XFILLER_687_261 VPWR VGND sg13cmos5l_decap_8
XFILLER_687_272 VPWR VGND sg13cmos5l_fill_1
XFILLER_183_62 VPWR VGND sg13cmos5l_decap_8
XFILLER_2_251 VPWR VGND sg13cmos5l_decap_8
XFILLER_647_147 VPWR VGND sg13cmos5l_decap_8
XFILLER_614_42 VPWR VGND sg13cmos5l_decap_8
XFILLER_501_154 VPWR VGND sg13cmos5l_decap_8
XFILLER_2_262 VPWR VGND sg13cmos5l_fill_2
XFILLER_446_209 VPWR VGND sg13cmos5l_decap_8
XFILLER_672_0 VPWR VGND sg13cmos5l_decap_8
XFILLER_439_272 VPWR VGND sg13cmos5l_fill_1
XFILLER_333_43 VPWR VGND sg13cmos5l_decap_8
XFILLER_25_7 VPWR VGND sg13cmos5l_decap_8
XFILLER_65_203 VPWR VGND sg13cmos5l_decap_8
X_1120_ _1120_/Q Tile_X0Y0_FrameData[11] VGND VPWR Tile_X0Y9_FrameStrobe[5] latch
XFILLER_480_82 VPWR VGND sg13cmos5l_fill_2
XFILLER_76_93 VPWR VGND sg13cmos5l_decap_8
XFILLER_670_150 VPWR VGND sg13cmos5l_decap_8
XFILLER_65_258 VPWR VGND sg13cmos5l_fill_1
XFILLER_280_112 VPWR VGND sg13cmos5l_decap_8
X_1051_ _1051_/Q Tile_X0Y0_FrameData[16] VGND VPWR Tile_X0Y9_FrameStrobe[3] latch
XFILLER_630_63 VPWR VGND sg13cmos5l_decap_8
XFILLER_202_14 VPWR VGND sg13cmos5l_decap_8
XANTENNA__3013__X Tile_X0Y5_E6BEG[0] VPWR VGND sg13cmos5l_antennanp
XFILLER_206_220 VPWR VGND sg13cmos5l_decap_8
XFILLER_559_28 VPWR VGND sg13cmos5l_decap_8
XFILLER_280_189 VPWR VGND sg13cmos5l_decap_8
XFILLER_92_70 VPWR VGND sg13cmos5l_decap_8
XFILLER_611_261 VPWR VGND sg13cmos5l_decap_4
XFILLER_568_154 VPWR VGND sg13cmos5l_decap_8
XFILLER_489_91 VPWR VGND sg13cmos5l_decap_8
XFILLER_422_161 VPWR VGND sg13cmos5l_decap_8
XANTENNA__2852__X Tile_X0Y6_E6BEG[1] VPWR VGND sg13cmos5l_antennanp
X_4810_ _4810_/X _4781_/X Tile_X0Y9_N4END[6] _4780_/X _0075_/X _0451_/Q _0450_/Q VPWR
+ VGND sg13cmos5l_mux4_1
XFILLER_422_172 VPWR VGND sg13cmos5l_fill_1
XFILLER_367_205 VPWR VGND sg13cmos5l_decap_8
XFILLER_422_194 VPWR VGND sg13cmos5l_decap_8
X_4741_ _4741_/X Tile_X0Y8_W2END[2] AXI_M_SOC_RDATA10 _4789_/X _4788_/X _0565_/Q _0564_/Q
+ VPWR VGND sg13cmos5l_mux4_1
X_1953_ _1953_/Q Tile_X0Y4_FrameData[4] VGND VPWR Tile_X0Y9_FrameStrobe[0] latch
XFILLER_509_254 VPWR VGND sg13cmos5l_decap_8
X_0904_ _0904_/Q Tile_X0Y9_FrameData[23] VGND VPWR Tile_X0Y9_FrameStrobe[7] latch
X_1884_ _1884_/Q Tile_X0Y3_FrameData[13] VGND VPWR Tile_X0Y9_FrameStrobe[6] latch
X_4672_ _4672_/X _4595_/X _4711_/X _4710_/X _4594_/X _0173_/Q _0172_/Q VPWR VGND sg13cmos5l_mux4_1
XFILLER_575_49 VPWR VGND sg13cmos5l_decap_8
XFILLER_358_84 VPWR VGND sg13cmos5l_decap_8
XFILLER_119_249 VPWR VGND sg13cmos5l_decap_8
XFILLER_186_193 VPWR VGND sg13cmos5l_decap_8
XFILLER_508_21 VPWR VGND sg13cmos5l_decap_8
X_0835_ _0835_/Q Tile_X0Y9_FrameData[28] VGND VPWR Tile_X0Y9_FrameStrobe[5] latch
X_3623_ Tile_X0Y9_S4BEG[1] _3623_/A VPWR VGND sg13cmos5l_buf_1
XFILLER_294_28 VPWR VGND sg13cmos5l_decap_8
XFILLER_524_246 VPWR VGND sg13cmos5l_decap_8
XFILLER_390_252 VPWR VGND sg13cmos5l_decap_4
XFILLER_134_219 VPWR VGND sg13cmos5l_decap_8
XFILLER_655_71 VPWR VGND sg13cmos5l_decap_8
XFILLER_524_268 VPWR VGND sg13cmos5l_decap_4
XFILLER_227_22 VPWR VGND sg13cmos5l_decap_8
XFILLER_350_105 VPWR VGND sg13cmos5l_decap_8
X_0766_ _0766_/Q Tile_X0Y9_FrameData[1] VGND VPWR Tile_X0Y9_FrameStrobe[2] latch
X_3554_ Tile_X0Y9_EE4BEG[0] _4864_/X VPWR VGND sg13cmos5l_buf_1
XFILLER_508_98 VPWR VGND sg13cmos5l_decap_8
XFILLER_685_209 VPWR VGND sg13cmos5l_decap_8
XFILLER_51_0 VPWR VGND sg13cmos5l_fill_1
XFILLER_142_230 VPWR VGND sg13cmos5l_decap_8
X_2505_ _2505_/Q Tile_X0Y6_FrameData[30] VGND VPWR Tile_X0Y9_FrameStrobe[2] latch
XFILLER_678_272 VPWR VGND sg13cmos5l_fill_1
X_3485_ Tile_X0Y1_EE4BEG[11] _3959_/X VPWR VGND sg13cmos5l_buf_1
XFILLER_288_234 VPWR VGND sg13cmos5l_decap_8
X_0697_ _0697_/Q Tile_X0Y9_FrameData[6] VGND VPWR Tile_X0Y9_FrameStrobe[0] latch
XFILLER_693_220 VPWR VGND sg13cmos5l_fill_2
XFILLER_524_42 VPWR VGND sg13cmos5l_decap_8
X_2436_ _2436_/Q Tile_X0Y5_FrameData[1] VGND VPWR Tile_X0Y9_FrameStrobe[7] latch
XFILLER_638_147 VPWR VGND sg13cmos5l_decap_8
XFILLER_243_21 VPWR VGND sg13cmos5l_decap_8
X_2367_ _2367_/Q Tile_X0Y5_FrameData[6] VGND VPWR Tile_X0Y9_FrameStrobe[5] latch
XFILLER_390_71 VPWR VGND sg13cmos5l_decap_8
X_1318_ _1318_/Q Tile_X0Y1_FrameData[19] VGND VPWR Tile_X0Y9_FrameStrobe[4] latch
X_4106_ _4106_/X _4572_/X _4576_/X _4580_/X _4553_/X _2671_/Q _2670_/Q VPWR VGND sg13cmos5l_mux4_1
XFILLER_110_182 VPWR VGND sg13cmos5l_decap_8
X_2298_ _2298_/Q Tile_X0Y5_FrameData[11] VGND VPWR Tile_X0Y9_FrameStrobe[3] latch
XFILLER_56_236 VPWR VGND sg13cmos5l_fill_2
X_4037_ _4037_/X _4091_/X Tile_X0Y2_WW4END[5] _4090_/X AXI_M_SOC_AWREADY _1599_/Q
+ _1598_/Q VPWR VGND sg13cmos5l_mux4_1
XFILLER_540_63 VPWR VGND sg13cmos5l_decap_8
XFILLER_271_123 VPWR VGND sg13cmos5l_decap_4
XFILLER_112_14 VPWR VGND sg13cmos5l_decap_8
X_1249_ _1249_/Q Tile_X0Y1_FrameData[24] VGND VPWR Tile_X0Y9_FrameStrobe[2] latch
XFILLER_460_234 VPWR VGND sg13cmos5l_decap_8
XFILLER_271_145 VPWR VGND sg13cmos5l_decap_8
XFILLER_24_100 VPWR VGND sg13cmos5l_decap_8
XFILLER_469_28 VPWR VGND sg13cmos5l_decap_8
XFILLER_413_161 VPWR VGND sg13cmos5l_decap_8
XANTENNA__2762__X Tile_X0Y3_FrameData_O[20] VPWR VGND sg13cmos5l_antennanp
XFILLER_169_105 VPWR VGND sg13cmos5l_decap_8
XFILLER_708_107 VPWR VGND sg13cmos5l_fill_1
XFILLER_212_245 VPWR VGND sg13cmos5l_decap_8
XFILLER_212_256 VPWR VGND sg13cmos5l_fill_1
XFILLER_358_238 VPWR VGND sg13cmos5l_decap_8
X_4939_ _4939_/X Tile_X0Y8_W1END[3] Tile_X0Y8_W2MID[0] Tile_X0Y8_W2END[0] _4784_/X
+ _0613_/Q _0612_/Q VPWR VGND sg13cmos5l_mux4_1
XFILLER_574_168 VPWR VGND sg13cmos5l_decap_8
XFILLER_373_219 VPWR VGND sg13cmos5l_decap_8
XANTENNA_40 AXI_M_SOC_RDATA8 VPWR VGND sg13cmos5l_antennanp
XFILLER_485_49 VPWR VGND sg13cmos5l_decap_8
XANTENNA_51 Tile_X0Y0_FrameData[25] VPWR VGND sg13cmos5l_antennanp
XFILLER_177_182 VPWR VGND sg13cmos5l_fill_2
XFILLER_716_162 VPWR VGND sg13cmos5l_decap_8
XFILLER_268_84 VPWR VGND sg13cmos5l_decap_8
XANTENNA_62 Tile_X0Y0_S2MID[0] VPWR VGND sg13cmos5l_antennanp
XFILLER_418_21 VPWR VGND sg13cmos5l_decap_8
XFILLER_268_95 VPWR VGND sg13cmos5l_decap_4
XANTENNA_73 Tile_X0Y0_S4END[14] VPWR VGND sg13cmos5l_antennanp
XFILLER_515_224 VPWR VGND sg13cmos5l_decap_8
XANTENNA_84 Tile_X0Y0_S4END[14] VPWR VGND sg13cmos5l_antennanp
XFILLER_582_190 VPWR VGND sg13cmos5l_decap_8
XFILLER_401_8 VPWR VGND sg13cmos5l_decap_8
XFILLER_326_146 VPWR VGND sg13cmos5l_decap_8
XANTENNA_95 Tile_X0Y1_FrameData[6] VPWR VGND sg13cmos5l_antennanp
XANTENNA__3593__X Tile_X0Y9_FrameData_O[23] VPWR VGND sg13cmos5l_antennanp
XFILLER_192_163 VPWR VGND sg13cmos5l_decap_8
XFILLER_21_77 VPWR VGND sg13cmos5l_fill_1
XFILLER_341_116 VPWR VGND sg13cmos5l_fill_1
XFILLER_137_77 VPWR VGND sg13cmos5l_decap_8
XFILLER_669_272 VPWR VGND sg13cmos5l_fill_1
XFILLER_334_190 VPWR VGND sg13cmos5l_decap_8
XFILLER_279_223 VPWR VGND sg13cmos5l_decap_8
XFILLER_133_241 VPWR VGND sg13cmos5l_decap_8
XFILLER_715_63 VPWR VGND sg13cmos5l_decap_8
XFILLER_97_37 VPWR VGND sg13cmos5l_fill_1
XFILLER_596_7 VPWR VGND sg13cmos5l_decap_8
XFILLER_684_220 VPWR VGND sg13cmos5l_decap_8
XFILLER_97_59 VPWR VGND sg13cmos5l_decap_8
XFILLER_434_42 VPWR VGND sg13cmos5l_decap_8
XFILLER_684_242 VPWR VGND sg13cmos5l_decap_8
XFILLER_581_70 VPWR VGND sg13cmos5l_decap_8
XFILLER_153_21 VPWR VGND sg13cmos5l_decap_8
XFILLER_495_175 VPWR VGND sg13cmos5l_decap_8
XANTENNA__2937__X Tile_X0Y8_E6BEG[5] VPWR VGND sg13cmos5l_antennanp
XFILLER_637_180 VPWR VGND sg13cmos5l_decap_8
XFILLER_294_259 VPWR VGND sg13cmos5l_fill_2
XFILLER_247_142 VPWR VGND sg13cmos5l_decap_8
XFILLER_101_193 VPWR VGND sg13cmos5l_decap_8
XFILLER_303_57 VPWR VGND sg13cmos5l_decap_8
XFILLER_450_74 VPWR VGND sg13cmos5l_decap_8
XFILLER_652_194 VPWR VGND sg13cmos5l_decap_8
XFILLER_46_63 VPWR VGND sg13cmos5l_fill_1
XFILLER_62_217 VPWR VGND sg13cmos5l_decap_8
XFILLER_46_74 VPWR VGND sg13cmos5l_decap_4
XFILLER_597_238 VPWR VGND sg13cmos5l_decap_4
XFILLER_379_28 VPWR VGND sg13cmos5l_decap_8
XFILLER_253_0 VPWR VGND sg13cmos5l_decap_8
XFILLER_15_155 VPWR VGND sg13cmos5l_decap_8
XFILLER_70_261 VPWR VGND sg13cmos5l_decap_8
XFILLER_203_256 VPWR VGND sg13cmos5l_decap_4
XFILLER_70_272 VPWR VGND sg13cmos5l_fill_1
XFILLER_62_40 VPWR VGND sg13cmos5l_decap_8
XFILLER_15_199 VPWR VGND sg13cmos5l_decap_8
XFILLER_420_0 VPWR VGND sg13cmos5l_decap_8
XFILLER_565_168 VPWR VGND sg13cmos5l_fill_2
XFILLER_518_0 VPWR VGND sg13cmos5l_decap_8
XFILLER_609_42 VPWR VGND sg13cmos5l_decap_8
XFILLER_168_171 VPWR VGND sg13cmos5l_decap_8
XFILLER_580_127 VPWR VGND sg13cmos5l_fill_1
XFILLER_7_35 VPWR VGND sg13cmos5l_decap_8
XFILLER_328_21 VPWR VGND sg13cmos5l_decap_8
XFILLER_692_14 VPWR VGND sg13cmos5l_decap_8
XFILLER_328_65 VPWR VGND sg13cmos5l_fill_1
X_0620_ _0620_/Q Tile_X0Y8_FrameData[19] VGND VPWR Tile_X0Y9_FrameStrobe[6] latch
XFILLER_332_116 VPWR VGND sg13cmos5l_decap_8
XFILLER_194_61 VPWR VGND sg13cmos5l_decap_8
X_0551_ _0551_/Q Tile_X0Y8_FrameData[24] VGND VPWR Tile_X0Y9_FrameStrobe[4] latch
XFILLER_625_63 VPWR VGND sg13cmos5l_decap_8
XANTENNA__3008__X Tile_X0Y5_E2BEGb[3] VPWR VGND sg13cmos5l_antennanp
XFILLER_344_42 VPWR VGND sg13cmos5l_decap_8
X_3270_ Tile_X0Y0_EE4BEG[6] _3826_/X VPWR VGND sg13cmos5l_buf_1
XFILLER_97_136 VPWR VGND sg13cmos5l_decap_8
X_0482_ _0482_/Q Tile_X0Y8_FrameData[29] VGND VPWR Tile_X0Y9_FrameStrobe[2] latch
XFILLER_675_253 VPWR VGND sg13cmos5l_decap_8
XFILLER_491_70 VPWR VGND sg13cmos5l_decap_8
X_2221_ _2221_/Q Tile_X0Y5_FrameData[24] VGND VPWR Tile_X0Y9_FrameStrobe[1] latch
XFILLER_486_186 VPWR VGND sg13cmos5l_decap_4
XANTENNA__2847__X Tile_X0Y6_E2BEGb[4] VPWR VGND sg13cmos5l_antennanp
XFILLER_344_97 VPWR VGND sg13cmos5l_decap_8
XFILLER_238_120 VPWR VGND sg13cmos5l_decap_8
XFILLER_87_92 VPWR VGND sg13cmos5l_decap_8
XFILLER_427_231 VPWR VGND sg13cmos5l_decap_8
X_2152_ _2152_/Q Tile_X0Y4_FrameData[29] VGND VPWR Tile_X0Y9_FrameStrobe[7] latch
XFILLER_238_153 VPWR VGND sg13cmos5l_decap_8
XFILLER_213_35 VPWR VGND sg13cmos5l_decap_8
XFILLER_641_84 VPWR VGND sg13cmos5l_decap_8
XFILLER_38_236 VPWR VGND sg13cmos5l_decap_8
X_1103_ _1103_/Q Tile_X0Y0_FrameData[28] VGND VPWR Tile_X0Y9_FrameStrobe[5] latch
XFILLER_643_161 VPWR VGND sg13cmos5l_decap_8
XFILLER_253_112 VPWR VGND sg13cmos5l_decap_8
XFILLER_360_63 VPWR VGND sg13cmos5l_decap_8
X_2083_ _2083_/Q Tile_X0Y4_FrameData[2] VGND VPWR Tile_X0Y9_FrameStrobe[4] latch
XFILLER_253_145 VPWR VGND sg13cmos5l_decap_8
XFILLER_442_256 VPWR VGND sg13cmos5l_decap_8
X_1034_ _1034_/Q Tile_X0Y0_FrameData[1] VGND VPWR Tile_X0Y9_FrameStrobe[2] latch
XFILLER_399_149 VPWR VGND sg13cmos5l_decap_8
XFILLER_289_28 VPWR VGND sg13cmos5l_decap_8
XFILLER_253_189 VPWR VGND sg13cmos5l_decap_8
XFILLER_510_77 VPWR VGND sg13cmos5l_decap_8
XFILLER_61_250 VPWR VGND sg13cmos5l_fill_1
XFILLER_99_0 VPWR VGND sg13cmos5l_decap_8
XFILLER_21_147 VPWR VGND sg13cmos5l_decap_8
X_2985_ Tile_X0Y8_FrameData_O[25] Tile_X0Y8_FrameData[25] VPWR VGND sg13cmos5l_buf_1
XFILLER_410_175 VPWR VGND sg13cmos5l_decap_8
XFILLER_519_42 VPWR VGND sg13cmos5l_decap_8
XFILLER_21_169 VPWR VGND sg13cmos5l_decap_8
X_4724_ _4724_/X _4777_/X _4776_/X AXI_M_SOC_RDATA11 AXI_M_SOC_RDATA15 _0599_/Q _0598_/Q
+ VPWR VGND sg13cmos5l_mux4_1
XFILLER_571_105 VPWR VGND sg13cmos5l_decap_8
X_1936_ _1936_/Q Tile_X0Y4_FrameData[21] VGND VPWR Tile_X0Y9_FrameStrobe[0] latch
XFILLER_666_81 VPWR VGND sg13cmos5l_fill_1
XFILLER_519_75 VPWR VGND sg13cmos5l_decap_4
XFILLER_238_21 VPWR VGND sg13cmos5l_decap_8
XFILLER_713_110 VPWR VGND sg13cmos5l_decap_8
XFILLER_174_141 VPWR VGND sg13cmos5l_fill_2
X_4655_ _4655_/X AXI_M_SOC_RDATA23 _4684_/X _4688_/X _4668_/X _0249_/Q _0248_/Q VPWR
+ VGND sg13cmos5l_mux4_1
X_1867_ _1867_/Q Tile_X0Y3_FrameData[30] VGND VPWR Tile_X0Y9_FrameStrobe[6] latch
XFILLER_308_157 VPWR VGND sg13cmos5l_decap_8
XFILLER_107_219 VPWR VGND sg13cmos5l_fill_1
XFILLER_174_174 VPWR VGND sg13cmos5l_fill_1
XFILLER_238_76 VPWR VGND sg13cmos5l_decap_8
X_3606_ Tile_X0Y9_S2BEG[0] _4828_/X VPWR VGND sg13cmos5l_buf_1
X_0818_ _0818_/Q Tile_X0Y9_FrameData[13] VGND VPWR Tile_X0Y9_FrameStrobe[4] latch
X_1798_ _1798_/Q Tile_X0Y3_FrameData[3] VGND VPWR Tile_X0Y9_FrameStrobe[3] latch
X_4586_ _4586_/X Tile_X0Y5_W2MID[6] Tile_X0Y5_W2END[6] Tile_X0Y5_W6END[9] _4430_/X
+ _2393_/Q _2392_/Q VPWR VGND sg13cmos5l_mux4_1
XFILLER_713_187 VPWR VGND sg13cmos5l_fill_2
XFILLER_316_190 VPWR VGND sg13cmos5l_decap_8
XFILLER_107_14 VPWR VGND sg13cmos5l_decap_8
X_3537_ Tile_X0Y9_E2BEGb[3] _4859_/X VPWR VGND sg13cmos5l_buf_1
X_0749_ _0749_/Q Tile_X0Y9_FrameData[18] VGND VPWR Tile_X0Y9_FrameStrobe[2] latch
XFILLER_477_120 VPWR VGND sg13cmos5l_fill_1
XFILLER_115_263 VPWR VGND sg13cmos5l_decap_8
XFILLER_88_103 VPWR VGND sg13cmos5l_decap_4
XFILLER_682_91 VPWR VGND sg13cmos5l_decap_8
XFILLER_254_42 VPWR VGND sg13cmos5l_decap_8
XFILLER_477_142 VPWR VGND sg13cmos5l_decap_8
XFILLER_88_136 VPWR VGND sg13cmos5l_decap_8
X_3468_ Tile_X0Y1_FrameData_O[26] Tile_X0Y1_FrameData[26] VPWR VGND sg13cmos5l_buf_1
XFILLER_477_175 VPWR VGND sg13cmos5l_decap_8
XFILLER_130_255 VPWR VGND sg13cmos5l_fill_2
XFILLER_492_112 VPWR VGND sg13cmos5l_decap_8
XFILLER_254_97 VPWR VGND sg13cmos5l_decap_4
XANTENNA__2757__X Tile_X0Y3_FrameData_O[15] VPWR VGND sg13cmos5l_antennanp
X_2419_ _2419_/Q Tile_X0Y5_FrameData[18] VGND VPWR Tile_X0Y9_FrameStrobe[7] latch
XFILLER_477_197 VPWR VGND sg13cmos5l_decap_8
XFILLER_276_259 VPWR VGND sg13cmos5l_fill_2
X_3399_ Tile_X0Y2_E2BEG[2] _4042_/X VPWR VGND sg13cmos5l_buf_1
XFILLER_681_256 VPWR VGND sg13cmos5l_decap_4
XFILLER_123_35 VPWR VGND sg13cmos5l_decap_8
XFILLER_551_84 VPWR VGND sg13cmos5l_decap_4
XFILLER_29_236 VPWR VGND sg13cmos5l_decap_8
XFILLER_184_8 VPWR VGND sg13cmos5l_decap_8
XFILLER_701_21 VPWR VGND sg13cmos5l_decap_8
XFILLER_492_189 VPWR VGND sg13cmos5l_decap_8
XFILLER_229_197 VPWR VGND sg13cmos5l_decap_4
XFILLER_270_63 VPWR VGND sg13cmos5l_decap_8
XFILLER_83_28 VPWR VGND sg13cmos5l_fill_2
XFILLER_634_183 VPWR VGND sg13cmos5l_fill_1
XFILLER_44_217 VPWR VGND sg13cmos5l_decap_8
XFILLER_244_145 VPWR VGND sg13cmos5l_decap_8
XFILLER_199_28 VPWR VGND sg13cmos5l_decap_8
XFILLER_244_178 VPWR VGND sg13cmos5l_decap_8
XFILLER_701_98 VPWR VGND sg13cmos5l_decap_8
XFILLER_244_189 VPWR VGND sg13cmos5l_fill_2
XANTENNA__3588__X Tile_X0Y9_FrameData_O[18] VPWR VGND sg13cmos5l_antennanp
XFILLER_594_208 VPWR VGND sg13cmos5l_fill_2
XFILLER_420_77 VPWR VGND sg13cmos5l_decap_8
XFILLER_587_260 VPWR VGND sg13cmos5l_fill_2
XFILLER_344_7 VPWR VGND sg13cmos5l_decap_8
XFILLER_16_77 VPWR VGND sg13cmos5l_fill_1
XFILLER_52_272 VPWR VGND sg13cmos5l_fill_1
XFILLER_401_142 VPWR VGND sg13cmos5l_decap_4
XFILLER_547_157 VPWR VGND sg13cmos5l_decap_4
XFILLER_200_237 VPWR VGND sg13cmos5l_decap_8
XFILLER_32_21 VPWR VGND sg13cmos5l_decap_8
XFILLER_562_105 VPWR VGND sg13cmos5l_decap_8
XFILLER_511_7 VPWR VGND sg13cmos5l_decap_8
XFILLER_429_42 VPWR VGND sg13cmos5l_decap_8
XFILLER_609_7 VPWR VGND sg13cmos5l_decap_8
XFILLER_339_271 VPWR VGND sg13cmos5l_fill_2
XFILLER_148_21 VPWR VGND sg13cmos5l_decap_8
XFILLER_576_70 VPWR VGND sg13cmos5l_decap_8
XFILLER_32_65 VPWR VGND sg13cmos5l_fill_2
XFILLER_354_252 VPWR VGND sg13cmos5l_decap_4
XFILLER_295_71 VPWR VGND sg13cmos5l_fill_2
XFILLER_165_174 VPWR VGND sg13cmos5l_decap_8
XFILLER_165_185 VPWR VGND sg13cmos5l_fill_1
XFILLER_704_165 VPWR VGND sg13cmos5l_decap_8
XFILLER_503_216 VPWR VGND sg13cmos5l_decap_8
XFILLER_148_98 VPWR VGND sg13cmos5l_decap_8
XFILLER_570_182 VPWR VGND sg13cmos5l_decap_8
XFILLER_180_144 VPWR VGND sg13cmos5l_decap_8
XFILLER_662_28 VPWR VGND sg13cmos5l_decap_8
XFILLER_445_63 VPWR VGND sg13cmos5l_decap_8
XFILLER_468_131 VPWR VGND sg13cmos5l_decap_8
XFILLER_657_242 VPWR VGND sg13cmos5l_decap_8
XFILLER_164_64 VPWR VGND sg13cmos5l_decap_8
XFILLER_511_271 VPWR VGND sg13cmos5l_fill_2
XFILLER_164_75 VPWR VGND sg13cmos5l_fill_2
XFILLER_79_147 VPWR VGND sg13cmos5l_decap_8
XFILLER_468_175 VPWR VGND sg13cmos5l_decap_8
XFILLER_322_182 VPWR VGND sg13cmos5l_decap_8
XFILLER_121_244 VPWR VGND sg13cmos5l_fill_1
XFILLER_267_226 VPWR VGND sg13cmos5l_decap_8
XFILLER_468_197 VPWR VGND sg13cmos5l_decap_4
XFILLER_121_266 VPWR VGND sg13cmos5l_decap_8
XFILLER_57_40 VPWR VGND sg13cmos5l_fill_1
XFILLER_314_78 VPWR VGND sg13cmos5l_decap_8
XFILLER_370_0 VPWR VGND sg13cmos5l_decap_4
XFILLER_235_101 VPWR VGND sg13cmos5l_decap_8
XFILLER_611_21 VPWR VGND sg13cmos5l_decap_8
XFILLER_235_112 VPWR VGND sg13cmos5l_fill_1
XFILLER_468_0 VPWR VGND sg13cmos5l_decap_8
XFILLER_180_63 VPWR VGND sg13cmos5l_decap_8
XFILLER_57_95 VPWR VGND sg13cmos5l_decap_8
XFILLER_625_183 VPWR VGND sg13cmos5l_fill_2
XFILLER_235_134 VPWR VGND sg13cmos5l_decap_8
XFILLER_330_22 VPWR VGND sg13cmos5l_decap_8
XFILLER_687_14 VPWR VGND sg13cmos5l_decap_8
XFILLER_330_55 VPWR VGND sg13cmos5l_decap_4
XANTENNA__3498__X Tile_X0Y1_E6BEG[8] VPWR VGND sg13cmos5l_antennanp
XFILLER_640_175 VPWR VGND sg13cmos5l_decap_8
XFILLER_635_0 VPWR VGND sg13cmos5l_decap_8
XFILLER_330_66 VPWR VGND sg13cmos5l_decap_4
XFILLER_578_260 VPWR VGND sg13cmos5l_fill_1
XFILLER_250_148 VPWR VGND sg13cmos5l_decap_8
XFILLER_578_271 VPWR VGND sg13cmos5l_fill_2
XFILLER_92_7 VPWR VGND sg13cmos5l_decap_8
XFILLER_189_94 VPWR VGND sg13cmos5l_decap_8
XFILLER_148_119 VPWR VGND sg13cmos5l_decap_8
XFILLER_553_116 VPWR VGND sg13cmos5l_fill_1
X_2770_ Tile_X0Y3_FrameData_O[28] Tile_X0Y3_FrameData[28] VPWR VGND sg13cmos5l_buf_1
XFILLER_486_70 VPWR VGND sg13cmos5l_decap_8
X_1721_ _1721_/Q Tile_X0Y3_FrameData[16] VGND VPWR Tile_X0Y9_FrameStrobe[1] latch
XFILLER_156_163 VPWR VGND sg13cmos5l_decap_8
X_1652_ _1652_/Q Tile_X0Y2_FrameData[29] VGND VPWR Tile_X0Y9_FrameStrobe[7] latch
X_4440_ _4440_/X _4013_/X _4017_/X _4002_/X _3992_/X _1362_/Q _1361_/Q VPWR VGND sg13cmos5l_mux4_1
XFILLER_171_133 VPWR VGND sg13cmos5l_decap_8
XFILLER_208_35 VPWR VGND sg13cmos5l_decap_8
XFILLER_636_84 VPWR VGND sg13cmos5l_decap_8
XFILLER_360_244 VPWR VGND sg13cmos5l_decap_8
XFILLER_305_149 VPWR VGND sg13cmos5l_decap_4
X_0603_ _0603_/Q Tile_X0Y8_FrameData[4] VGND VPWR Tile_X0Y9_FrameStrobe[5] latch
XFILLER_572_28 VPWR VGND sg13cmos5l_decap_8
XFILLER_355_63 VPWR VGND sg13cmos5l_decap_8
X_1583_ _1583_/Q Tile_X0Y2_FrameData[2] VGND VPWR Tile_X0Y9_FrameStrobe[4] latch
X_4371_ _4371_/X _4427_/X _4426_/X AXI_M_SOC_RVALID _4425_/X _2361_/Q _2360_/Q VPWR
+ VGND sg13cmos5l_mux4_1
XFILLER_98_80 VPWR VGND sg13cmos5l_decap_8
XFILLER_320_119 VPWR VGND sg13cmos5l_decap_8
XFILLER_112_211 VPWR VGND sg13cmos5l_decap_8
XFILLER_171_199 VPWR VGND sg13cmos5l_decap_8
X_0534_ _0534_/Q Tile_X0Y8_FrameData[9] VGND VPWR Tile_X0Y9_FrameStrobe[3] latch
X_3322_ Tile_X0Y4_EE4BEG[10] _4282_/X VPWR VGND sg13cmos5l_buf_1
XFILLER_710_179 VPWR VGND sg13cmos5l_decap_8
XFILLER_291_29 VPWR VGND sg13cmos5l_decap_8
XFILLER_258_226 VPWR VGND sg13cmos5l_decap_8
XFILLER_608_117 VPWR VGND sg13cmos5l_decap_8
XFILLER_474_112 VPWR VGND sg13cmos5l_fill_2
XFILLER_505_77 VPWR VGND sg13cmos5l_decap_8
X_0465_ _0465_/Q Tile_X0Y8_FrameData[14] VGND VPWR Tile_X0Y9_FrameStrobe[1] latch
X_3253_ Tile_X0Y0_FrameData_O[21] Tile_X0Y0_FrameData[21] VPWR VGND sg13cmos5l_buf_1
XFILLER_224_56 VPWR VGND sg13cmos5l_decap_8
X_2204_ _2204_/Q Tile_X0Y5_FrameData[9] VGND VPWR Tile_X0Y9_FrameStrobe[0] latch
X_3184_ Tile_X0Y0_N4BEG[8] _3184_/A VPWR VGND sg13cmos5l_buf_1
XFILLER_371_84 VPWR VGND sg13cmos5l_decap_8
X_0396_ _0396_/Q Tile_X0Y7_FrameData[19] VGND VPWR Tile_X0Y9_FrameStrobe[7] latch
XFILLER_14_0 VPWR VGND sg13cmos5l_decap_8
XFILLER_521_21 VPWR VGND sg13cmos5l_decap_8
XFILLER_474_189 VPWR VGND sg13cmos5l_decap_8
X_2135_ _2135_/Q Tile_X0Y4_FrameData[14] VGND VPWR Tile_X0Y9_FrameStrobe[6] latch
XFILLER_93_161 VPWR VGND sg13cmos5l_fill_1
XFILLER_415_234 VPWR VGND sg13cmos5l_decap_8
XFILLER_631_120 VPWR VGND sg13cmos5l_fill_2
XFILLER_93_194 VPWR VGND sg13cmos5l_decap_8
X_2066_ _2066_/Q Tile_X0Y4_FrameData[19] VGND VPWR Tile_X0Y9_FrameStrobe[4] latch
XFILLER_521_98 VPWR VGND sg13cmos5l_fill_2
XFILLER_597_14 VPWR VGND sg13cmos5l_decap_8
XFILLER_576_208 VPWR VGND sg13cmos5l_decap_8
X_1017_ _1017_/Q Tile_X0Y0_FrameData[18] VGND VPWR Tile_X0Y9_FrameStrobe[2] latch
XFILLER_240_77 VPWR VGND sg13cmos5l_decap_8
XFILLER_569_271 VPWR VGND sg13cmos5l_fill_2
XANTENNA__3201__X Tile_X0Y0_N2BEG[1] VPWR VGND sg13cmos5l_antennanp
XFILLER_179_233 VPWR VGND sg13cmos5l_decap_8
XFILLER_430_259 VPWR VGND sg13cmos5l_decap_8
XFILLER_529_124 VPWR VGND sg13cmos5l_decap_8
XFILLER_139_119 VPWR VGND sg13cmos5l_decap_8
XFILLER_677_91 VPWR VGND sg13cmos5l_decap_8
XFILLER_395_185 VPWR VGND sg13cmos5l_decap_8
XFILLER_194_247 VPWR VGND sg13cmos5l_decap_8
X_2968_ Tile_X0Y8_FrameData_O[8] Tile_X0Y8_FrameData[8] VPWR VGND sg13cmos5l_buf_1
XFILLER_249_64 VPWR VGND sg13cmos5l_fill_1
XFILLER_396_81 VPWR VGND sg13cmos5l_fill_1
XFILLER_544_149 VPWR VGND sg13cmos5l_decap_8
X_4707_ _4707_/X Tile_X0Y9_W2MID[4] Tile_X0Y9_W2END[4] Tile_X0Y9_W6END[4] _4907_/X
+ _0913_/Q _0912_/Q VPWR VGND sg13cmos5l_mux4_1
X_1919_ _1919_/Q Tile_X0Y3_FrameData[10] VGND VPWR Tile_X0Y9_FrameStrobe[7] latch
XFILLER_336_241 VPWR VGND sg13cmos5l_decap_8
X_2899_ Tile_X0Y6_FrameData_O[20] Tile_X0Y6_FrameData[20] VPWR VGND sg13cmos5l_buf_1
X_4638_ _4638_/X Tile_X0Y7_WW4END[5] AXI_M_SOC_RDATA21 _4689_/X _4672_/X _0283_/Q
+ _0282_/Q VPWR VGND sg13cmos5l_mux4_1
XFILLER_546_84 VPWR VGND sg13cmos5l_decap_8
XFILLER_118_35 VPWR VGND sg13cmos5l_decap_8
XFILLER_482_28 VPWR VGND sg13cmos5l_decap_8
XFILLER_162_166 VPWR VGND sg13cmos5l_decap_8
XFILLER_351_255 VPWR VGND sg13cmos5l_fill_2
XFILLER_265_63 VPWR VGND sg13cmos5l_decap_8
X_4569_ _4569_/X _4547_/X Tile_X0Y9_N4END[13] _4546_/X _0153_/X _2493_/Q _2492_/Q
+ VPWR VGND sg13cmos5l_mux4_1
XFILLER_78_28 VPWR VGND sg13cmos5l_fill_2
XFILLER_701_157 VPWR VGND sg13cmos5l_decap_8
XFILLER_639_231 VPWR VGND sg13cmos5l_decap_8
XFILLER_304_160 VPWR VGND sg13cmos5l_decap_8
XFILLER_249_215 VPWR VGND sg13cmos5l_decap_4
XFILLER_103_233 VPWR VGND sg13cmos5l_fill_2
XFILLER_415_77 VPWR VGND sg13cmos5l_decap_8
XFILLER_465_123 VPWR VGND sg13cmos5l_decap_8
XFILLER_654_234 VPWR VGND sg13cmos5l_decap_8
XFILLER_294_7 VPWR VGND sg13cmos5l_decap_8
XFILLER_134_56 VPWR VGND sg13cmos5l_decap_8
XFILLER_712_42 VPWR VGND sg13cmos5l_decap_8
XFILLER_281_84 VPWR VGND sg13cmos5l_decap_8
XFILLER_431_21 VPWR VGND sg13cmos5l_decap_8
XFILLER_480_126 VPWR VGND sg13cmos5l_decap_8
XFILLER_461_7 VPWR VGND sg13cmos5l_decap_8
XFILLER_27_21 VPWR VGND sg13cmos5l_decap_8
XFILLER_84_161 VPWR VGND sg13cmos5l_decap_8
XFILLER_480_148 VPWR VGND sg13cmos5l_decap_8
XFILLER_559_7 VPWR VGND sg13cmos5l_decap_8
XFILLER_622_131 VPWR VGND sg13cmos5l_decap_8
XFILLER_406_256 VPWR VGND sg13cmos5l_decap_8
XFILLER_272_251 VPWR VGND sg13cmos5l_decap_8
XFILLER_431_98 VPWR VGND sg13cmos5l_decap_8
XFILLER_378_108 VPWR VGND sg13cmos5l_decap_8
XFILLER_232_126 VPWR VGND sg13cmos5l_decap_8
XFILLER_150_88 VPWR VGND sg13cmos5l_decap_8
XFILLER_25_250 VPWR VGND sg13cmos5l_fill_2
XFILLER_300_14 VPWR VGND sg13cmos5l_decap_8
XANTENNA__3111__X Tile_X0Y7_E6BEG[9] VPWR VGND sg13cmos5l_antennanp
XFILLER_25_272 VPWR VGND sg13cmos5l_fill_1
XFILLER_657_28 VPWR VGND sg13cmos5l_decap_8
XFILLER_240_170 VPWR VGND sg13cmos5l_decap_8
XFILLER_575_252 VPWR VGND sg13cmos5l_decap_8
XFILLER_587_91 VPWR VGND sg13cmos5l_decap_4
XANTENNA__2950__X Tile_X0Y8_EE4BEG[6] VPWR VGND sg13cmos5l_antennanp
XFILLER_43_75 VPWR VGND sg13cmos5l_decap_8
XFILLER_590_211 VPWR VGND sg13cmos5l_decap_8
XFILLER_376_29 VPWR VGND sg13cmos5l_decap_8
XFILLER_185_258 VPWR VGND sg13cmos5l_decap_8
XFILLER_689_120 VPWR VGND sg13cmos5l_decap_8
XFILLER_216_0 VPWR VGND sg13cmos5l_decap_8
XFILLER_550_108 VPWR VGND sg13cmos5l_decap_8
XFILLER_342_200 VPWR VGND sg13cmos5l_decap_8
XFILLER_543_160 VPWR VGND sg13cmos5l_decap_8
XFILLER_138_196 VPWR VGND sg13cmos5l_decap_8
XFILLER_153_122 VPWR VGND sg13cmos5l_decap_4
XFILLER_673_49 VPWR VGND sg13cmos5l_fill_2
XFILLER_488_215 VPWR VGND sg13cmos5l_decap_8
XFILLER_606_21 VPWR VGND sg13cmos5l_decap_8
XFILLER_488_226 VPWR VGND sg13cmos5l_fill_1
XFILLER_392_28 VPWR VGND sg13cmos5l_decap_8
XFILLER_175_63 VPWR VGND sg13cmos5l_decap_8
XFILLER_689_197 VPWR VGND sg13cmos5l_decap_8
XFILLER_4_154 VPWR VGND sg13cmos5l_decap_8
XFILLER_4_14 VPWR VGND sg13cmos5l_decap_8
XFILLER_153_188 VPWR VGND sg13cmos5l_fill_2
XFILLER_302_119 VPWR VGND sg13cmos5l_decap_8
XFILLER_4_187 VPWR VGND sg13cmos5l_fill_2
XFILLER_325_44 VPWR VGND sg13cmos5l_fill_1
XFILLER_325_55 VPWR VGND sg13cmos5l_fill_1
XFILLER_585_0 VPWR VGND sg13cmos5l_decap_8
XFILLER_456_112 VPWR VGND sg13cmos5l_decap_4
XFILLER_325_66 VPWR VGND sg13cmos5l_fill_2
XFILLER_325_88 VPWR VGND sg13cmos5l_fill_1
XFILLER_456_145 VPWR VGND sg13cmos5l_decap_8
XFILLER_645_245 VPWR VGND sg13cmos5l_decap_8
XFILLER_622_42 VPWR VGND sg13cmos5l_decap_8
X_0250_ _0250_/Q Tile_X0Y7_FrameData[5] VGND VPWR Tile_X0Y9_FrameStrobe[2] latch
XFILLER_456_167 VPWR VGND sg13cmos5l_decap_8
XFILLER_310_196 VPWR VGND sg13cmos5l_decap_8
XFILLER_341_21 VPWR VGND sg13cmos5l_decap_8
XFILLER_208_112 VPWR VGND sg13cmos5l_decap_8
XFILLER_660_215 VPWR VGND sg13cmos5l_decap_8
X_0181_ _0181_/Q Tile_X0Y7_FrameData[10] VGND VPWR Tile_X0Y9_FrameStrobe[0] latch
XFILLER_660_248 VPWR VGND sg13cmos5l_decap_8
XFILLER_698_35 VPWR VGND sg13cmos5l_decap_8
XFILLER_75_194 VPWR VGND sg13cmos5l_fill_2
XFILLER_613_142 VPWR VGND sg13cmos5l_decap_8
XFILLER_223_104 VPWR VGND sg13cmos5l_decap_8
XFILLER_412_226 VPWR VGND sg13cmos5l_decap_8
XFILLER_210_14 VPWR VGND sg13cmos5l_decap_8
X_3940_ _3940_/X Tile_X0Y1_W2END[7] AXI_M_SOC_ARREADY _3989_/X _3988_/X _1329_/Q _1328_/Q
+ VPWR VGND sg13cmos5l_mux4_1
XANTENNA__3021__X Tile_X0Y5_E6BEG[8] VPWR VGND sg13cmos5l_antennanp
XFILLER_567_28 VPWR VGND sg13cmos5l_decap_8
X_3871_ _3871_/X _3849_/X _0086_/X Tile_X0Y0_S1END[1] Tile_X0Y0_S4END[1] _0969_/Q
+ _0968_/Q VPWR VGND sg13cmos5l_mux4_1
XFILLER_566_241 VPWR VGND sg13cmos5l_decap_4
XFILLER_377_152 VPWR VGND sg13cmos5l_decap_8
XFILLER_497_91 VPWR VGND sg13cmos5l_decap_8
XANTENNA__2860__X Tile_X0Y6_E6BEG[9] VPWR VGND sg13cmos5l_antennanp
X_2822_ Tile_X0Y4_E2BEG[0] _4256_/X VPWR VGND sg13cmos5l_buf_1
XFILLER_526_116 VPWR VGND sg13cmos5l_decap_8
XFILLER_715_238 VPWR VGND sg13cmos5l_decap_8
XFILLER_176_269 VPWR VGND sg13cmos5l_decap_4
XFILLER_392_144 VPWR VGND sg13cmos5l_decap_8
XFILLER_318_241 VPWR VGND sg13cmos5l_decap_8
XFILLER_191_206 VPWR VGND sg13cmos5l_decap_8
X_2753_ Tile_X0Y3_FrameData_O[11] Tile_X0Y3_FrameData[11] VPWR VGND sg13cmos5l_buf_1
XFILLER_219_56 VPWR VGND sg13cmos5l_decap_8
XFILLER_129_185 VPWR VGND sg13cmos5l_decap_8
X_1704_ _1704_/Q Tile_X0Y3_FrameData[1] VGND VPWR Tile_X0Y9_FrameStrobe[0] latch
XFILLER_583_49 VPWR VGND sg13cmos5l_decap_8
XFILLER_534_171 VPWR VGND sg13cmos5l_decap_8
X_2684_ _2684_/Q Tile_X0Y6_FrameData[11] VGND VPWR Tile_X0Y9_FrameStrobe[7] latch
XFILLER_516_21 VPWR VGND sg13cmos5l_decap_8
XFILLER_333_244 VPWR VGND sg13cmos5l_decap_8
X_4423_ _4423_/X Tile_X0Y4_W1END[2] Tile_X0Y4_W6END[10] _4350_/X _4306_/X _2141_/Q
+ _2140_/Q VPWR VGND sg13cmos5l_mux4_1
XFILLER_695_112 VPWR VGND sg13cmos5l_decap_8
XFILLER_479_237 VPWR VGND sg13cmos5l_decap_8
X_1635_ _1635_/Q Tile_X0Y2_FrameData[14] VGND VPWR Tile_X0Y9_FrameStrobe[6] latch
XANTENNA__3691__X AXI_M_SOC_WDATA1 VPWR VGND sg13cmos5l_antennanp
X_4354_ _4354_/X Tile_X0Y3_W2MID[6] Tile_X0Y3_W2END[6] Tile_X0Y3_W6END[9] _4207_/X
+ _1879_/Q _1878_/Q VPWR VGND sg13cmos5l_mux4_1
X_1566_ _1566_/Q Tile_X0Y2_FrameData[19] VGND VPWR Tile_X0Y9_FrameStrobe[4] latch
XFILLER_695_189 VPWR VGND sg13cmos5l_fill_1
XFILLER_98_253 VPWR VGND sg13cmos5l_decap_4
XFILLER_298_181 VPWR VGND sg13cmos5l_decap_8
X_3305_ Tile_X0Y0_E2BEG[5] _3809_/X VPWR VGND sg13cmos5l_buf_1
X_0517_ _0517_/Q Tile_X0Y8_FrameData[26] VGND VPWR Tile_X0Y9_FrameStrobe[3] latch
X_1497_ _1497_/Q Tile_X0Y2_FrameData[24] VGND VPWR Tile_X0Y9_FrameStrobe[2] latch
X_4285_ _4285_/X Tile_X0Y4_WW4END[2] AXI_M_SOC_BRESP0 _4338_/X _4317_/X _2043_/Q _2042_/Q
+ VPWR VGND sg13cmos5l_mux4_1
XFILLER_532_42 VPWR VGND sg13cmos5l_decap_8
XFILLER_301_174 VPWR VGND sg13cmos5l_decap_4
X_0448_ _0448_/Q Tile_X0Y8_FrameData[31] VGND VPWR Tile_X0Y9_FrameStrobe[1] latch
X_3236_ Tile_X0Y0_FrameData_O[4] Tile_X0Y0_FrameData[4] VPWR VGND sg13cmos5l_buf_1
XFILLER_246_229 VPWR VGND sg13cmos5l_decap_8
XFILLER_251_21 VPWR VGND sg13cmos5l_decap_8
XFILLER_532_86 VPWR VGND sg13cmos5l_fill_1
XFILLER_462_148 VPWR VGND sg13cmos5l_decap_8
X_0379_ _0379_/Q Tile_X0Y7_FrameData[4] VGND VPWR Tile_X0Y9_FrameStrobe[6] latch
X_3167_ Tile_X0Y4_E6BEG[4] _4292_/X VPWR VGND sg13cmos5l_buf_1
XFILLER_66_161 VPWR VGND sg13cmos5l_decap_8
XFILLER_462_159 VPWR VGND sg13cmos5l_fill_1
X_2118_ _2118_/Q Tile_X0Y4_FrameData[31] VGND VPWR Tile_X0Y9_FrameStrobe[6] latch
XFILLER_81_131 VPWR VGND sg13cmos5l_decap_8
X_3098_ Tile_X0Y7_E2BEGb[4] _4624_/X VPWR VGND sg13cmos5l_buf_1
XFILLER_401_57 VPWR VGND sg13cmos5l_decap_8
XFILLER_120_14 VPWR VGND sg13cmos5l_decap_8
X_2049_ _2049_/Q Tile_X0Y4_FrameData[4] VGND VPWR Tile_X0Y9_FrameStrobe[3] latch
XFILLER_120_58 VPWR VGND sg13cmos5l_fill_1
XFILLER_477_28 VPWR VGND sg13cmos5l_decap_8
XFILLER_22_253 VPWR VGND sg13cmos5l_decap_4
XFILLER_368_174 VPWR VGND sg13cmos5l_decap_8
XANTENNA__2770__X Tile_X0Y3_FrameData_O[28] VPWR VGND sg13cmos5l_antennanp
XFILLER_706_205 VPWR VGND sg13cmos5l_decap_8
XFILLER_200_91 VPWR VGND sg13cmos5l_decap_8
XFILLER_383_133 VPWR VGND sg13cmos5l_decap_8
XFILLER_517_149 VPWR VGND sg13cmos5l_decap_8
XFILLER_13_56 VPWR VGND sg13cmos5l_decap_8
XFILLER_309_241 VPWR VGND sg13cmos5l_decap_8
XFILLER_182_217 VPWR VGND sg13cmos5l_decap_8
XFILLER_314_8 VPWR VGND sg13cmos5l_decap_8
XFILLER_532_108 VPWR VGND sg13cmos5l_decap_8
XFILLER_129_56 VPWR VGND sg13cmos5l_decap_8
XFILLER_707_42 VPWR VGND sg13cmos5l_decap_8
XFILLER_307_7 VPWR VGND sg13cmos5l_decap_8
XFILLER_714_271 VPWR VGND sg13cmos5l_fill_2
XFILLER_493_49 VPWR VGND sg13cmos5l_decap_8
XFILLER_276_84 VPWR VGND sg13cmos5l_decap_8
XFILLER_426_21 VPWR VGND sg13cmos5l_decap_8
XFILLER_89_49 VPWR VGND sg13cmos5l_decap_8
XFILLER_135_155 VPWR VGND sg13cmos5l_decap_4
XFILLER_135_166 VPWR VGND sg13cmos5l_decap_8
XFILLER_190_272 VPWR VGND sg13cmos5l_fill_1
XFILLER_1_102 VPWR VGND sg13cmos5l_fill_2
XFILLER_540_163 VPWR VGND sg13cmos5l_decap_4
XFILLER_150_125 VPWR VGND sg13cmos5l_fill_1
XFILLER_485_218 VPWR VGND sg13cmos5l_decap_8
XFILLER_150_147 VPWR VGND sg13cmos5l_decap_8
XFILLER_426_98 VPWR VGND sg13cmos5l_decap_8
XFILLER_296_129 VPWR VGND sg13cmos5l_decap_8
XFILLER_1_135 VPWR VGND sg13cmos5l_fill_2
XFILLER_289_170 VPWR VGND sg13cmos5l_fill_2
XFILLER_89_253 VPWR VGND sg13cmos5l_decap_8
XFILLER_438_123 VPWR VGND sg13cmos5l_decap_8
XFILLER_676_7 VPWR VGND sg13cmos5l_decap_8
XANTENNA__3106__X Tile_X0Y7_E6BEG[4] VPWR VGND sg13cmos5l_antennanp
XFILLER_1_179 VPWR VGND sg13cmos5l_decap_8
XANTENNA__2945__X Tile_X0Y8_EE4BEG[1] VPWR VGND sg13cmos5l_antennanp
XFILLER_57_161 VPWR VGND sg13cmos5l_fill_1
XFILLER_57_183 VPWR VGND sg13cmos5l_decap_8
XFILLER_72_120 VPWR VGND sg13cmos5l_fill_1
XFILLER_205_126 VPWR VGND sg13cmos5l_fill_1
XFILLER_72_142 VPWR VGND sg13cmos5l_decap_4
XFILLER_610_101 VPWR VGND sg13cmos5l_decap_8
XFILLER_166_0 VPWR VGND sg13cmos5l_decap_8
XFILLER_461_181 VPWR VGND sg13cmos5l_decap_8
XFILLER_205_148 VPWR VGND sg13cmos5l_decap_8
XFILLER_72_164 VPWR VGND sg13cmos5l_decap_8
XFILLER_260_243 VPWR VGND sg13cmos5l_fill_2
XFILLER_668_49 VPWR VGND sg13cmos5l_decap_8
XFILLER_311_79 VPWR VGND sg13cmos5l_decap_8
XFILLER_610_145 VPWR VGND sg13cmos5l_decap_8
XFILLER_387_28 VPWR VGND sg13cmos5l_decap_8
XFILLER_333_0 VPWR VGND sg13cmos5l_decap_4
XFILLER_9_202 VPWR VGND sg13cmos5l_decap_4
XFILLER_508_105 VPWR VGND sg13cmos5l_decap_8
XFILLER_9_235 VPWR VGND sg13cmos5l_decap_8
XFILLER_563_244 VPWR VGND sg13cmos5l_fill_2
XFILLER_467_72 VPWR VGND sg13cmos5l_decap_8
XFILLER_563_255 VPWR VGND sg13cmos5l_fill_2
XFILLER_500_0 VPWR VGND sg13cmos5l_decap_8
XFILLER_617_42 VPWR VGND sg13cmos5l_decap_8
XFILLER_523_119 VPWR VGND sg13cmos5l_decap_4
XFILLER_186_95 VPWR VGND sg13cmos5l_decap_8
XFILLER_336_21 VPWR VGND sg13cmos5l_decap_8
XFILLER_677_112 VPWR VGND sg13cmos5l_decap_4
XFILLER_617_86 VPWR VGND sg13cmos5l_fill_1
XFILLER_315_244 VPWR VGND sg13cmos5l_decap_8
XFILLER_531_152 VPWR VGND sg13cmos5l_decap_8
XFILLER_677_145 VPWR VGND sg13cmos5l_decap_8
XFILLER_483_71 VPWR VGND sg13cmos5l_decap_4
XFILLER_141_125 VPWR VGND sg13cmos5l_fill_1
XFILLER_677_156 VPWR VGND sg13cmos5l_fill_2
X_1420_ _1420_/Q Tile_X0Y1_FrameData[13] VGND VPWR Tile_X0Y9_FrameStrobe[7] latch
XFILLER_141_158 VPWR VGND sg13cmos5l_decap_8
XFILLER_692_115 VPWR VGND sg13cmos5l_decap_8
XFILLER_429_112 VPWR VGND sg13cmos5l_decap_8
X_1351_ _1351_/Q Tile_X0Y1_FrameData[18] VGND VPWR Tile_X0Y9_FrameStrobe[5] latch
XFILLER_330_269 VPWR VGND sg13cmos5l_decap_4
XFILLER_205_14 VPWR VGND sg13cmos5l_decap_8
XFILLER_633_63 VPWR VGND sg13cmos5l_decap_8
XFILLER_295_140 VPWR VGND sg13cmos5l_decap_8
XANTENNA__3016__X Tile_X0Y5_E6BEG[3] VPWR VGND sg13cmos5l_antennanp
XFILLER_95_212 VPWR VGND sg13cmos5l_decap_8
XFILLER_618_245 VPWR VGND sg13cmos5l_decap_8
X_0302_ _0302_/Q Tile_X0Y7_FrameData[17] VGND VPWR Tile_X0Y9_FrameStrobe[4] latch
XFILLER_484_251 VPWR VGND sg13cmos5l_decap_4
XFILLER_352_42 VPWR VGND sg13cmos5l_decap_8
XFILLER_95_245 VPWR VGND sg13cmos5l_fill_1
X_1282_ _1282_/Q Tile_X0Y1_FrameData[23] VGND VPWR Tile_X0Y9_FrameStrobe[3] latch
X_4070_ _4070_/X Tile_X0Y2_WW4END[1] AXI_M_SOC_AWREADY _4117_/X _4099_/X _1533_/Q
+ _1532_/Q VPWR VGND sg13cmos5l_mux4_1
XFILLER_444_104 VPWR VGND sg13cmos5l_fill_1
XFILLER_429_189 VPWR VGND sg13cmos5l_decap_8
XFILLER_95_70 VPWR VGND sg13cmos5l_decap_8
XFILLER_633_226 VPWR VGND sg13cmos5l_decap_8
XFILLER_444_126 VPWR VGND sg13cmos5l_decap_8
X_0233_ _0233_/Q Tile_X0Y7_FrameData[22] VGND VPWR Tile_X0Y9_FrameStrobe[2] latch
X_3021_ Tile_X0Y5_E6BEG[8] _4412_/X VPWR VGND sg13cmos5l_buf_1
XFILLER_633_237 VPWR VGND sg13cmos5l_fill_1
XANTENNA__2855__X Tile_X0Y6_E6BEG[4] VPWR VGND sg13cmos5l_antennanp
XFILLER_444_148 VPWR VGND sg13cmos5l_decap_8
XFILLER_236_240 VPWR VGND sg13cmos5l_decap_8
XFILLER_502_56 VPWR VGND sg13cmos5l_decap_8
X_0164_ _0164_/Q Tile_X0Y7_FrameData[27] VGND VPWR Tile_X0Y9_FrameStrobe[0] latch
XFILLER_221_35 VPWR VGND sg13cmos5l_decap_8
XFILLER_598_152 VPWR VGND sg13cmos5l_decap_4
XFILLER_452_170 VPWR VGND sg13cmos5l_decap_8
XFILLER_221_46 VPWR VGND sg13cmos5l_fill_2
XFILLER_63_153 VPWR VGND sg13cmos5l_decap_8
XFILLER_598_163 VPWR VGND sg13cmos5l_decap_4
XFILLER_598_185 VPWR VGND sg13cmos5l_decap_8
X_0095_ _0095_/X _4003_/X _4004_/X _2407_/Q VPWR VGND sg13cmos5l_mux2_1
XFILLER_251_254 VPWR VGND sg13cmos5l_fill_2
XFILLER_578_49 VPWR VGND sg13cmos5l_decap_8
XFILLER_400_207 VPWR VGND sg13cmos5l_fill_2
X_3923_ _3923_/X _4228_/X _4232_/X _4215_/X _4209_/X _1895_/Q _1894_/Q VPWR VGND sg13cmos5l_mux4_1
XFILLER_601_167 VPWR VGND sg13cmos5l_decap_8
XFILLER_539_241 VPWR VGND sg13cmos5l_decap_8
XFILLER_601_189 VPWR VGND sg13cmos5l_decap_8
X_3854_ _3854_/X _3901_/X _3900_/X Tile_X0Y0_S2MID[6] Tile_X0Y0_S2END[6] _0951_/Q
+ _0950_/Q VPWR VGND sg13cmos5l_mux4_1
XFILLER_81_0 VPWR VGND sg13cmos5l_decap_8
X_2805_ Tile_X0Y3_E2BEGb[3] _4159_/X VPWR VGND sg13cmos5l_buf_1
XFILLER_365_155 VPWR VGND sg13cmos5l_decap_8
X_3785_ _3785_/X Tile_X0Y0_W2MID[6] Tile_X0Y0_W2END[6] Tile_X0Y0_W6END[6] _3855_/X
+ _1167_/Q _1166_/Q VPWR VGND sg13cmos5l_mux4_1
X_0997_ _0997_/Q Tile_X0Y0_FrameData[6] VGND VPWR Tile_X0Y9_FrameStrobe[1] latch
XFILLER_527_42 VPWR VGND sg13cmos5l_decap_8
X_2736_ _3979_/A3 VPWR VGND sg13cmos5l_tielo
XFILLER_674_70 VPWR VGND sg13cmos5l_decap_8
XFILLER_380_147 VPWR VGND sg13cmos5l_decap_8
XFILLER_117_144 VPWR VGND sg13cmos5l_decap_8
XFILLER_527_75 VPWR VGND sg13cmos5l_fill_2
XFILLER_172_250 VPWR VGND sg13cmos5l_decap_8
XFILLER_246_43 VPWR VGND sg13cmos5l_decap_8
X_2667_ _2667_/Q Tile_X0Y6_FrameData[28] VGND VPWR Tile_X0Y9_FrameStrobe[7] latch
XFILLER_522_152 VPWR VGND sg13cmos5l_decap_8
XFILLER_321_214 VPWR VGND sg13cmos5l_decap_8
X_4406_ _4406_/X _0100_/X _0140_/X _4460_/X _4464_/X _2291_/Q _2290_/Q VPWR VGND sg13cmos5l_mux4_1
X_1618_ _1618_/Q Tile_X0Y2_FrameData[31] VGND VPWR Tile_X0Y9_FrameStrobe[6] latch
X_2598_ _2598_/Q Tile_X0Y6_FrameData[1] VGND VPWR Tile_X0Y9_FrameStrobe[4] latch
XFILLER_683_115 VPWR VGND sg13cmos5l_decap_8
XFILLER_609_201 VPWR VGND sg13cmos5l_decap_8
XFILLER_115_14 VPWR VGND sg13cmos5l_decap_8
X_4337_ _4337_/X _4305_/X _0158_/X _4304_/X _0111_/X _1979_/Q _1978_/Q VPWR VGND sg13cmos5l_mux4_1
XFILLER_543_63 VPWR VGND sg13cmos5l_decap_8
X_1549_ _1549_/Q Tile_X0Y2_FrameData[4] VGND VPWR Tile_X0Y9_FrameStrobe[3] latch
XFILLER_86_212 VPWR VGND sg13cmos5l_decap_8
XFILLER_286_140 VPWR VGND sg13cmos5l_decap_8
XFILLER_262_42 VPWR VGND sg13cmos5l_decap_8
XFILLER_609_267 VPWR VGND sg13cmos5l_decap_4
X_4268_ _4268_/X Tile_X0Y4_W2END[3] AXI_M_SOC_BRESP1 _4319_/X _4318_/X _2077_/Q _2076_/Q
+ VPWR VGND sg13cmos5l_mux4_1
XFILLER_86_256 VPWR VGND sg13cmos5l_decap_4
XFILLER_624_215 VPWR VGND sg13cmos5l_decap_8
XFILLER_435_126 VPWR VGND sg13cmos5l_decap_8
XANTENNA__2765__X Tile_X0Y3_FrameData_O[23] VPWR VGND sg13cmos5l_antennanp
X_3219_ Tile_X0Y0_FrameStrobe_O[7] Tile_X0Y9_FrameStrobe[7] VPWR VGND sg13cmos5l_buf_1
XFILLER_490_243 VPWR VGND sg13cmos5l_fill_1
X_4199_ _4199_/X Tile_X0Y2_W1END[2] Tile_X0Y2_W6END[10] _4107_/X _4086_/X _1633_/Q
+ _1632_/Q VPWR VGND sg13cmos5l_mux4_1
XFILLER_227_251 VPWR VGND sg13cmos5l_decap_8
XFILLER_39_183 VPWR VGND sg13cmos5l_decap_8
XFILLER_39_194 VPWR VGND sg13cmos5l_fill_1
XFILLER_412_78 VPWR VGND sg13cmos5l_fill_2
XFILLER_242_210 VPWR VGND sg13cmos5l_fill_2
XFILLER_131_57 VPWR VGND sg13cmos5l_decap_8
XFILLER_589_174 VPWR VGND sg13cmos5l_decap_8
XFILLER_91_28 VPWR VGND sg13cmos5l_decap_8
XFILLER_54_186 VPWR VGND sg13cmos5l_decap_8
XFILLER_488_49 VPWR VGND sg13cmos5l_decap_8
XFILLER_257_7 VPWR VGND sg13cmos5l_decap_8
XFILLER_242_254 VPWR VGND sg13cmos5l_decap_8
XANTENNA__3596__X Tile_X0Y9_FrameData_O[26] VPWR VGND sg13cmos5l_antennanp
XFILLER_424_7 VPWR VGND sg13cmos5l_decap_8
XFILLER_24_66 VPWR VGND sg13cmos5l_decap_4
XFILLER_210_140 VPWR VGND sg13cmos5l_decap_8
XFILLER_545_222 VPWR VGND sg13cmos5l_decap_8
XFILLER_545_233 VPWR VGND sg13cmos5l_fill_2
XFILLER_356_133 VPWR VGND sg13cmos5l_decap_8
XFILLER_155_228 VPWR VGND sg13cmos5l_decap_8
XFILLER_437_42 VPWR VGND sg13cmos5l_decap_8
XFILLER_108_133 VPWR VGND sg13cmos5l_decap_8
XFILLER_584_70 VPWR VGND sg13cmos5l_decap_8
XFILLER_560_247 VPWR VGND sg13cmos5l_decap_8
XFILLER_699_270 VPWR VGND sg13cmos5l_fill_2
XFILLER_312_203 VPWR VGND sg13cmos5l_decap_8
XFILLER_659_167 VPWR VGND sg13cmos5l_decap_4
XFILLER_458_218 VPWR VGND sg13cmos5l_fill_1
XFILLER_156_98 VPWR VGND sg13cmos5l_fill_2
XFILLER_306_35 VPWR VGND sg13cmos5l_decap_8
XFILLER_674_126 VPWR VGND sg13cmos5l_decap_8
XFILLER_670_28 VPWR VGND sg13cmos5l_decap_8
XFILLER_172_42 VPWR VGND sg13cmos5l_decap_8
XFILLER_49_74 VPWR VGND sg13cmos5l_decap_8
XFILLER_172_53 VPWR VGND sg13cmos5l_fill_1
XFILLER_77_234 VPWR VGND sg13cmos5l_fill_2
XFILLER_49_85 VPWR VGND sg13cmos5l_fill_1
XFILLER_277_173 VPWR VGND sg13cmos5l_fill_2
XFILLER_131_191 VPWR VGND sg13cmos5l_decap_4
XFILLER_615_204 VPWR VGND sg13cmos5l_fill_2
XFILLER_172_75 VPWR VGND sg13cmos5l_fill_2
XFILLER_426_126 VPWR VGND sg13cmos5l_decap_8
XFILLER_283_0 VPWR VGND sg13cmos5l_decap_8
XFILLER_603_77 VPWR VGND sg13cmos5l_fill_2
XFILLER_218_240 VPWR VGND sg13cmos5l_decap_4
XFILLER_105_91 VPWR VGND sg13cmos5l_decap_8
XFILLER_679_37 VPWR VGND sg13cmos5l_decap_8
XFILLER_450_0 VPWR VGND sg13cmos5l_decap_8
XFILLER_65_84 VPWR VGND sg13cmos5l_decap_8
XFILLER_548_0 VPWR VGND sg13cmos5l_decap_8
XFILLER_379_225 VPWR VGND sg13cmos5l_decap_8
XANTENNA_130 Tile_X0Y6_FrameData[31] VPWR VGND sg13cmos5l_antennanp
XFILLER_379_236 VPWR VGND sg13cmos5l_fill_1
XANTENNA_141 Tile_X0Y6_FrameData[31] VPWR VGND sg13cmos5l_antennanp
XFILLER_45_186 VPWR VGND sg13cmos5l_decap_8
XFILLER_398_49 VPWR VGND sg13cmos5l_decap_8
XFILLER_233_254 VPWR VGND sg13cmos5l_decap_8
XANTENNA_152 Tile_X0Y9_FrameStrobe[16] VPWR VGND sg13cmos5l_antennanp
XFILLER_60_123 VPWR VGND sg13cmos5l_decap_4
XFILLER_595_133 VPWR VGND sg13cmos5l_decap_8
XFILLER_379_258 VPWR VGND sg13cmos5l_decap_4
XANTENNA_163 Tile_X0Y9_FrameStrobe[8] VPWR VGND sg13cmos5l_antennanp
XANTENNA_174 Tile_X0Y9_FrameStrobe[8] VPWR VGND sg13cmos5l_antennanp
XFILLER_695_14 VPWR VGND sg13cmos5l_decap_8
XANTENNA_185 Tile_X0Y9_FrameStrobe[8] VPWR VGND sg13cmos5l_antennanp
XANTENNA_196 Tile_X0Y9_N2MID[2] VPWR VGND sg13cmos5l_antennanp
XFILLER_715_0 VPWR VGND sg13cmos5l_decap_8
XFILLER_60_167 VPWR VGND sg13cmos5l_decap_8
XFILLER_81_61 VPWR VGND sg13cmos5l_decap_8
XFILLER_478_82 VPWR VGND sg13cmos5l_decap_8
X_0920_ _0920_/Q Tile_X0Y9_FrameData[7] VGND VPWR Tile_X0Y9_FrameStrobe[7] latch
XFILLER_347_133 VPWR VGND sg13cmos5l_decap_8
XFILLER_201_151 VPWR VGND sg13cmos5l_decap_8
XFILLER_536_233 VPWR VGND sg13cmos5l_decap_8
XFILLER_347_144 VPWR VGND sg13cmos5l_fill_1
X_0851_ _0851_/Q Tile_X0Y9_FrameData[12] VGND VPWR Tile_X0Y9_FrameStrobe[5] latch
XFILLER_347_166 VPWR VGND sg13cmos5l_decap_8
XFILLER_628_85 VPWR VGND sg13cmos5l_decap_8
XFILLER_347_42 VPWR VGND sg13cmos5l_decap_8
X_3570_ Tile_X0Y9_FrameData_O[0] Tile_X0Y9_FrameData[0] VPWR VGND sg13cmos5l_buf_1
XFILLER_697_218 VPWR VGND sg13cmos5l_decap_8
X_0782_ _0782_/Q Tile_X0Y9_FrameData[17] VGND VPWR Tile_X0Y9_FrameStrobe[3] latch
XFILLER_494_70 VPWR VGND sg13cmos5l_decap_8
XFILLER_161_209 VPWR VGND sg13cmos5l_decap_8
X_2521_ _2521_/Q Tile_X0Y6_FrameData[14] VGND VPWR Tile_X0Y9_FrameStrobe[2] latch
XFILLER_362_169 VPWR VGND sg13cmos5l_decap_8
X_2452_ _2452_/Q Tile_X0Y6_FrameData[19] VGND VPWR Tile_X0Y9_FrameStrobe[0] latch
XFILLER_644_84 VPWR VGND sg13cmos5l_decap_8
XFILLER_216_35 VPWR VGND sg13cmos5l_decap_8
X_1403_ _1403_/Q Tile_X0Y1_FrameData[30] VGND VPWR Tile_X0Y9_FrameStrobe[7] latch
XFILLER_665_137 VPWR VGND sg13cmos5l_decap_8
XFILLER_580_28 VPWR VGND sg13cmos5l_decap_8
XFILLER_216_79 VPWR VGND sg13cmos5l_decap_4
X_2383_ _2383_/Q Tile_X0Y5_FrameData[22] VGND VPWR Tile_X0Y9_FrameStrobe[6] latch
X_4122_ _4122_/X _4093_/X _0057_/X _4092_/X Tile_X0Y0_S4END[10] _1469_/Q _1468_/Q
+ VPWR VGND sg13cmos5l_mux4_1
X_1334_ _1334_/Q Tile_X0Y1_FrameData[3] VGND VPWR Tile_X0Y9_FrameStrobe[4] latch
XFILLER_68_245 VPWR VGND sg13cmos5l_decap_8
XFILLER_417_126 VPWR VGND sg13cmos5l_fill_2
XFILLER_673_181 VPWR VGND sg13cmos5l_decap_8
XFILLER_513_77 VPWR VGND sg13cmos5l_decap_8
XFILLER_472_232 VPWR VGND sg13cmos5l_fill_1
X_1265_ _1265_/Q Tile_X0Y1_FrameData[8] VGND VPWR Tile_X0Y9_FrameStrobe[2] latch
X_4053_ _4053_/X Tile_X0Y2_W2END[2] AXI_M_SOC_AWREADY _4101_/X _4100_/X _1567_/Q _1566_/Q
+ VPWR VGND sg13cmos5l_mux4_1
XFILLER_283_154 VPWR VGND sg13cmos5l_decap_8
XFILLER_472_254 VPWR VGND sg13cmos5l_fill_2
XFILLER_83_237 VPWR VGND sg13cmos5l_decap_8
X_3004_ Tile_X0Y5_E2BEG[7] _4379_/X VPWR VGND sg13cmos5l_buf_1
X_0216_ _0216_/Q Tile_X0Y7_FrameData[7] VGND VPWR Tile_X0Y9_FrameStrobe[1] latch
XFILLER_232_78 VPWR VGND sg13cmos5l_decap_4
X_1196_ _1196_/Q Tile_X0Y1_FrameData[13] VGND VPWR Tile_X0Y9_FrameStrobe[0] latch
XFILLER_36_142 VPWR VGND sg13cmos5l_decap_8
XFILLER_224_243 VPWR VGND sg13cmos5l_fill_1
X_0147_ _3184_/A _3910_/X _3911_/X _1399_/Q VPWR VGND sg13cmos5l_mux2_1
XFILLER_440_140 VPWR VGND sg13cmos5l_decap_8
XFILLER_586_155 VPWR VGND sg13cmos5l_decap_8
XFILLER_101_49 VPWR VGND sg13cmos5l_decap_8
X_0078_ _0078_/X _3877_/X _3878_/X _2146_/Q VPWR VGND sg13cmos5l_mux2_1
XFILLER_51_156 VPWR VGND sg13cmos5l_decap_8
XFILLER_388_60 VPWR VGND sg13cmos5l_fill_1
XFILLER_196_128 VPWR VGND sg13cmos5l_decap_8
XFILLER_586_177 VPWR VGND sg13cmos5l_decap_8
XFILLER_385_239 VPWR VGND sg13cmos5l_decap_8
XFILLER_189_180 VPWR VGND sg13cmos5l_decap_8
X_3906_ _3906_/X Tile_X0Y1_W1END[2] Tile_X0Y1_WW4END[2] Tile_X0Y1_W6END[10] _4010_/X
+ _1395_/Q _1394_/Q VPWR VGND sg13cmos5l_mux4_1
X_4886_ _4886_/X AXI_M_SOC_RDATA2 _4921_/X _4925_/X _4905_/X _0771_/Q _0770_/Q VPWR
+ VGND sg13cmos5l_mux4_1
X_3837_ _3837_/X _0086_/X Tile_X0Y0_S4END[1] _3868_/X _3867_/X _1031_/Q _1030_/Q VPWR
+ VGND sg13cmos5l_mux4_1
XFILLER_393_261 VPWR VGND sg13cmos5l_decap_8
XFILLER_393_272 VPWR VGND sg13cmos5l_fill_1
XFILLER_137_239 VPWR VGND sg13cmos5l_decap_8
XFILLER_257_42 VPWR VGND sg13cmos5l_decap_8
X_3768_ _3768_/X Tile_X0Y1_WW4END[1] Tile_X0Y1_WW4END[9] Tile_X0Y1_W6END[9] _4017_/X
+ _1239_/Q _1238_/Q VPWR VGND sg13cmos5l_mux4_1
XFILLER_353_147 VPWR VGND sg13cmos5l_decap_8
XFILLER_542_247 VPWR VGND sg13cmos5l_decap_8
X_2719_ _4656_/A3 VPWR VGND sg13cmos5l_tielo
X_3699_ AXI_M_SOC_WDATA9 Tile_X0Y7_WW4END[1] Tile_X0Y7_WW4END[9] Tile_X0Y7_W6END[9]
+ _4693_/X _0229_/Q _0228_/Q VPWR VGND sg13cmos5l_mux4_1
XFILLER_10_35 VPWR VGND sg13cmos5l_decap_8
XFILLER_407_56 VPWR VGND sg13cmos5l_decap_8
XFILLER_554_84 VPWR VGND sg13cmos5l_decap_8
XFILLER_126_35 VPWR VGND sg13cmos5l_decap_8
XFILLER_160_253 VPWR VGND sg13cmos5l_decap_8
XFILLER_704_21 VPWR VGND sg13cmos5l_decap_8
XFILLER_510_144 VPWR VGND sg13cmos5l_decap_4
XFILLER_490_28 VPWR VGND sg13cmos5l_decap_8
XFILLER_273_63 VPWR VGND sg13cmos5l_decap_8
XFILLER_120_117 VPWR VGND sg13cmos5l_decap_8
XFILLER_86_28 VPWR VGND sg13cmos5l_decap_8
XFILLER_656_159 VPWR VGND sg13cmos5l_decap_8
XFILLER_59_256 VPWR VGND sg13cmos5l_decap_4
XFILLER_664_170 VPWR VGND sg13cmos5l_decap_8
XFILLER_274_121 VPWR VGND sg13cmos5l_decap_8
XFILLER_408_137 VPWR VGND sg13cmos5l_decap_8
XFILLER_423_77 VPWR VGND sg13cmos5l_decap_8
XFILLER_19_77 VPWR VGND sg13cmos5l_decap_8
XFILLER_142_56 VPWR VGND sg13cmos5l_decap_8
XFILLER_274_187 VPWR VGND sg13cmos5l_decap_8
XFILLER_541_7 VPWR VGND sg13cmos5l_decap_8
XFILLER_35_21 VPWR VGND sg13cmos5l_decap_8
XFILLER_82_270 VPWR VGND sg13cmos5l_fill_2
XFILLER_577_111 VPWR VGND sg13cmos5l_fill_1
XFILLER_639_7 VPWR VGND sg13cmos5l_decap_8
XFILLER_577_122 VPWR VGND sg13cmos5l_decap_8
XFILLER_431_140 VPWR VGND sg13cmos5l_decap_8
XFILLER_27_186 VPWR VGND sg13cmos5l_decap_8
XFILLER_579_70 VPWR VGND sg13cmos5l_decap_8
XFILLER_255_4 VPWR VGND sg13cmos5l_fill_1
XFILLER_42_145 VPWR VGND sg13cmos5l_fill_1
XFILLER_187_117 VPWR VGND sg13cmos5l_decap_8
XFILLER_376_217 VPWR VGND sg13cmos5l_decap_8
XFILLER_35_87 VPWR VGND sg13cmos5l_decap_4
XFILLER_329_111 VPWR VGND sg13cmos5l_decap_8
XFILLER_577_199 VPWR VGND sg13cmos5l_decap_8
XFILLER_518_222 VPWR VGND sg13cmos5l_decap_4
XFILLER_128_206 VPWR VGND sg13cmos5l_decap_8
XFILLER_195_161 VPWR VGND sg13cmos5l_decap_8
XFILLER_665_28 VPWR VGND sg13cmos5l_decap_8
XFILLER_518_255 VPWR VGND sg13cmos5l_decap_8
XFILLER_448_63 VPWR VGND sg13cmos5l_decap_8
XFILLER_329_166 VPWR VGND sg13cmos5l_decap_8
XFILLER_51_53 VPWR VGND sg13cmos5l_decap_4
XFILLER_384_261 VPWR VGND sg13cmos5l_fill_1
XFILLER_384_272 VPWR VGND sg13cmos5l_fill_1
XFILLER_129_0 VPWR VGND sg13cmos5l_decap_8
XFILLER_167_42 VPWR VGND sg13cmos5l_decap_8
XFILLER_679_218 VPWR VGND sg13cmos5l_decap_8
XFILLER_344_147 VPWR VGND sg13cmos5l_decap_8
XFILLER_533_269 VPWR VGND sg13cmos5l_decap_4
XFILLER_498_140 VPWR VGND sg13cmos5l_decap_8
XFILLER_687_240 VPWR VGND sg13cmos5l_decap_8
XFILLER_317_45 VPWR VGND sg13cmos5l_decap_4
XFILLER_2_230 VPWR VGND sg13cmos5l_decap_8
XFILLER_614_21 VPWR VGND sg13cmos5l_decap_8
XFILLER_501_133 VPWR VGND sg13cmos5l_decap_8
XFILLER_647_126 VPWR VGND sg13cmos5l_decap_8
XFILLER_498_0 VPWR VGND sg13cmos5l_decap_8
XFILLER_300_228 VPWR VGND sg13cmos5l_decap_8
XFILLER_333_22 VPWR VGND sg13cmos5l_decap_8
XFILLER_614_98 VPWR VGND sg13cmos5l_decap_8
XFILLER_665_0 VPWR VGND sg13cmos5l_decap_8
XFILLER_18_7 VPWR VGND sg13cmos5l_decap_8
XFILLER_76_72 VPWR VGND sg13cmos5l_decap_8
XFILLER_454_254 VPWR VGND sg13cmos5l_decap_8
XFILLER_630_42 VPWR VGND sg13cmos5l_decap_8
XFILLER_18_120 VPWR VGND sg13cmos5l_fill_2
X_1050_ _1050_/Q Tile_X0Y0_FrameData[17] VGND VPWR Tile_X0Y9_FrameStrobe[3] latch
XFILLER_265_187 VPWR VGND sg13cmos5l_decap_8
XFILLER_603_229 VPWR VGND sg13cmos5l_decap_8
XFILLER_280_168 VPWR VGND sg13cmos5l_decap_8
XFILLER_611_240 VPWR VGND sg13cmos5l_decap_8
XFILLER_489_70 VPWR VGND sg13cmos5l_decap_8
XFILLER_422_140 VPWR VGND sg13cmos5l_decap_8
XFILLER_568_133 VPWR VGND sg13cmos5l_decap_8
XFILLER_221_213 VPWR VGND sg13cmos5l_decap_8
XFILLER_33_145 VPWR VGND sg13cmos5l_fill_2
XFILLER_178_128 VPWR VGND sg13cmos5l_decap_4
X_4740_ _4740_/X Tile_X0Y8_W2END[3] AXI_M_SOC_RDATA11 _4791_/X _4790_/X _0567_/Q _0566_/Q
+ VPWR VGND sg13cmos5l_mux4_1
X_1952_ _1952_/Q Tile_X0Y4_FrameData[5] VGND VPWR Tile_X0Y9_FrameStrobe[0] latch
XFILLER_639_84 VPWR VGND sg13cmos5l_decap_8
XFILLER_509_233 VPWR VGND sg13cmos5l_decap_8
XFILLER_583_158 VPWR VGND sg13cmos5l_fill_1
X_0903_ _0903_/Q Tile_X0Y9_FrameData[24] VGND VPWR Tile_X0Y9_FrameStrobe[7] latch
XFILLER_575_28 VPWR VGND sg13cmos5l_decap_8
X_4671_ _4671_/X _4587_/X _4703_/X _4702_/X _4586_/X _0181_/Q _0180_/Q VPWR VGND sg13cmos5l_mux4_1
XFILLER_375_261 VPWR VGND sg13cmos5l_fill_1
XFILLER_358_63 VPWR VGND sg13cmos5l_decap_8
XFILLER_119_228 VPWR VGND sg13cmos5l_decap_8
X_1883_ _1883_/Q Tile_X0Y3_FrameData[14] VGND VPWR Tile_X0Y9_FrameStrobe[6] latch
XFILLER_375_272 VPWR VGND sg13cmos5l_fill_1
X_3622_ Tile_X0Y9_S4BEG[0] _3622_/A VPWR VGND sg13cmos5l_buf_1
X_0834_ _0834_/Q Tile_X0Y9_FrameData[29] VGND VPWR Tile_X0Y9_FrameStrobe[5] latch
XFILLER_390_231 VPWR VGND sg13cmos5l_decap_8
XFILLER_655_50 VPWR VGND sg13cmos5l_decap_8
XFILLER_390_264 VPWR VGND sg13cmos5l_decap_8
X_3553_ Tile_X0Y9_E6BEG[11] _4891_/X VPWR VGND sg13cmos5l_buf_1
XFILLER_508_77 VPWR VGND sg13cmos5l_decap_8
XFILLER_127_272 VPWR VGND sg13cmos5l_fill_1
X_0765_ _0765_/Q Tile_X0Y9_FrameData[2] VGND VPWR Tile_X0Y9_FrameStrobe[2] latch
X_2504_ _2504_/Q Tile_X0Y6_FrameData[31] VGND VPWR Tile_X0Y9_FrameStrobe[2] latch
XFILLER_288_213 VPWR VGND sg13cmos5l_decap_8
XFILLER_227_78 VPWR VGND sg13cmos5l_decap_8
X_3484_ Tile_X0Y1_EE4BEG[10] _3958_/X VPWR VGND sg13cmos5l_buf_1
XFILLER_591_49 VPWR VGND sg13cmos5l_decap_8
X_0696_ _0696_/Q Tile_X0Y9_FrameData[7] VGND VPWR Tile_X0Y9_FrameStrobe[0] latch
XFILLER_524_21 VPWR VGND sg13cmos5l_decap_8
XFILLER_638_126 VPWR VGND sg13cmos5l_decap_8
XFILLER_288_257 VPWR VGND sg13cmos5l_fill_1
X_2435_ _2435_/Q Tile_X0Y5_FrameData[2] VGND VPWR Tile_X0Y9_FrameStrobe[7] latch
XFILLER_102_139 VPWR VGND sg13cmos5l_decap_8
XFILLER_671_82 VPWR VGND sg13cmos5l_decap_8
XFILLER_524_87 VPWR VGND sg13cmos5l_decap_4
X_2366_ _2366_/Q Tile_X0Y5_FrameData[7] VGND VPWR Tile_X0Y9_FrameStrobe[5] latch
X_4105_ _4105_/X Tile_X0Y6_W1END[0] Tile_X0Y6_WW4END[0] Tile_X0Y6_W6END[8] _4568_/X
+ _2671_/Q _2670_/Q VPWR VGND sg13cmos5l_mux4_1
X_1317_ _1317_/Q Tile_X0Y1_FrameData[20] VGND VPWR Tile_X0Y9_FrameStrobe[4] latch
XFILLER_256_154 VPWR VGND sg13cmos5l_decap_8
XANTENNA__3204__X Tile_X0Y0_N2BEG[4] VPWR VGND sg13cmos5l_antennanp
X_2297_ _2297_/Q Tile_X0Y5_FrameData[12] VGND VPWR Tile_X0Y9_FrameStrobe[3] latch
XFILLER_540_42 VPWR VGND sg13cmos5l_decap_8
XFILLER_2_91 VPWR VGND sg13cmos5l_decap_8
X_4036_ _4036_/X _4089_/X Tile_X0Y2_WW4END[4] _4088_/X AXI_M_SOC_AWREADY _1601_/Q
+ _1600_/Q VPWR VGND sg13cmos5l_mux4_1
XFILLER_460_213 VPWR VGND sg13cmos5l_decap_8
X_1248_ _1248_/Q Tile_X0Y1_FrameData[25] VGND VPWR Tile_X0Y9_FrameStrobe[2] latch
X_1179_ _1179_/Q Tile_X0Y1_FrameData[30] VGND VPWR Tile_X0Y9_FrameStrobe[0] latch
XFILLER_413_140 VPWR VGND sg13cmos5l_decap_8
XFILLER_559_133 VPWR VGND sg13cmos5l_decap_8
XFILLER_24_134 VPWR VGND sg13cmos5l_decap_4
XFILLER_212_224 VPWR VGND sg13cmos5l_decap_8
XFILLER_358_217 VPWR VGND sg13cmos5l_decap_8
XFILLER_559_199 VPWR VGND sg13cmos5l_decap_8
XFILLER_212_268 VPWR VGND sg13cmos5l_decap_4
X_4938_ _4938_/X Tile_X0Y8_W1END[2] Tile_X0Y8_W2MID[1] Tile_X0Y8_W2END[1] _4786_/X
+ _0615_/Q _0614_/Q VPWR VGND sg13cmos5l_mux4_1
XFILLER_574_147 VPWR VGND sg13cmos5l_decap_8
XFILLER_716_130 VPWR VGND sg13cmos5l_decap_8
XANTENNA_30 AXI_M_SOC_RDATA26 VPWR VGND sg13cmos5l_antennanp
XFILLER_716_141 VPWR VGND sg13cmos5l_decap_8
XFILLER_485_28 VPWR VGND sg13cmos5l_decap_8
XFILLER_366_261 VPWR VGND sg13cmos5l_fill_1
XFILLER_268_63 VPWR VGND sg13cmos5l_decap_8
XANTENNA_41 AXI_M_SOC_RDATA8 VPWR VGND sg13cmos5l_antennanp
X_4869_ _4869_/X Tile_X0Y9_WW4END[10] AXI_M_SOC_RDATA5 _4926_/X _4905_/X _0805_/Q
+ _0804_/Q VPWR VGND sg13cmos5l_mux4_1
XANTENNA_52 Tile_X0Y0_FrameData[25] VPWR VGND sg13cmos5l_antennanp
XFILLER_227_8 VPWR VGND sg13cmos5l_decap_8
XFILLER_515_203 VPWR VGND sg13cmos5l_decap_8
XANTENNA_63 Tile_X0Y0_S2MID[0] VPWR VGND sg13cmos5l_antennanp
XANTENNA_74 Tile_X0Y0_S4END[14] VPWR VGND sg13cmos5l_antennanp
XFILLER_122_7 VPWR VGND sg13cmos5l_decap_8
XANTENNA_85 Tile_X0Y0_S4END[14] VPWR VGND sg13cmos5l_antennanp
XANTENNA_96 Tile_X0Y3_W1END[3] VPWR VGND sg13cmos5l_antennanp
XFILLER_381_253 VPWR VGND sg13cmos5l_decap_8
XFILLER_515_269 VPWR VGND sg13cmos5l_decap_4
XFILLER_118_261 VPWR VGND sg13cmos5l_decap_8
XFILLER_418_77 VPWR VGND sg13cmos5l_decap_4
XFILLER_118_272 VPWR VGND sg13cmos5l_fill_1
XFILLER_669_240 VPWR VGND sg13cmos5l_decap_8
XFILLER_137_56 VPWR VGND sg13cmos5l_decap_8
XFILLER_133_220 VPWR VGND sg13cmos5l_decap_8
XFILLER_715_42 VPWR VGND sg13cmos5l_decap_8
XFILLER_284_84 VPWR VGND sg13cmos5l_decap_8
XFILLER_434_21 VPWR VGND sg13cmos5l_decap_8
XFILLER_133_264 VPWR VGND sg13cmos5l_fill_1
XFILLER_491_7 VPWR VGND sg13cmos5l_decap_8
XFILLER_589_7 VPWR VGND sg13cmos5l_decap_8
XFILLER_495_154 VPWR VGND sg13cmos5l_decap_8
XFILLER_294_216 VPWR VGND sg13cmos5l_decap_8
XFILLER_434_98 VPWR VGND sg13cmos5l_decap_8
XFILLER_153_55 VPWR VGND sg13cmos5l_fill_2
XFILLER_247_121 VPWR VGND sg13cmos5l_decap_8
XFILLER_101_172 VPWR VGND sg13cmos5l_decap_8
XFILLER_153_99 VPWR VGND sg13cmos5l_decap_8
XFILLER_372_4 VPWR VGND sg13cmos5l_fill_1
XANTENNA__3114__X Tile_X0Y7_EE4BEG[0] VPWR VGND sg13cmos5l_antennanp
XFILLER_303_36 VPWR VGND sg13cmos5l_decap_8
XFILLER_450_42 VPWR VGND sg13cmos5l_decap_4
XFILLER_451_235 VPWR VGND sg13cmos5l_decap_4
XFILLER_262_146 VPWR VGND sg13cmos5l_decap_8
XANTENNA__2953__X Tile_X0Y8_EE4BEG[9] VPWR VGND sg13cmos5l_antennanp
XFILLER_203_213 VPWR VGND sg13cmos5l_decap_8
XFILLER_70_240 VPWR VGND sg13cmos5l_decap_8
XFILLER_246_0 VPWR VGND sg13cmos5l_decap_4
XFILLER_676_49 VPWR VGND sg13cmos5l_decap_8
XFILLER_565_147 VPWR VGND sg13cmos5l_decap_8
XFILLER_609_21 VPWR VGND sg13cmos5l_decap_8
XFILLER_364_209 VPWR VGND sg13cmos5l_decap_8
XFILLER_62_96 VPWR VGND sg13cmos5l_decap_8
XFILLER_7_14 VPWR VGND sg13cmos5l_decap_8
XFILLER_413_0 VPWR VGND sg13cmos5l_decap_8
XFILLER_109_250 VPWR VGND sg13cmos5l_decap_4
XFILLER_109_272 VPWR VGND sg13cmos5l_fill_1
XFILLER_625_42 VPWR VGND sg13cmos5l_decap_8
X_0550_ _0550_/Q Tile_X0Y8_FrameData[25] VGND VPWR Tile_X0Y9_FrameStrobe[4] latch
XFILLER_486_110 VPWR VGND sg13cmos5l_decap_4
XFILLER_124_253 VPWR VGND sg13cmos5l_decap_8
XFILLER_344_21 VPWR VGND sg13cmos5l_decap_8
XFILLER_124_264 VPWR VGND sg13cmos5l_fill_1
XFILLER_675_232 VPWR VGND sg13cmos5l_decap_8
XFILLER_97_115 VPWR VGND sg13cmos5l_decap_8
X_0481_ _0481_/Q Tile_X0Y8_FrameData[30] VGND VPWR Tile_X0Y9_FrameStrobe[2] latch
X_2220_ _2220_/Q Tile_X0Y5_FrameData[25] VGND VPWR Tile_X0Y9_FrameStrobe[1] latch
XFILLER_87_71 VPWR VGND sg13cmos5l_decap_8
XFILLER_285_238 VPWR VGND sg13cmos5l_decap_8
XFILLER_427_210 VPWR VGND sg13cmos5l_decap_8
XFILLER_628_170 VPWR VGND sg13cmos5l_decap_8
XFILLER_213_14 VPWR VGND sg13cmos5l_decap_8
X_2151_ _2151_/Q Tile_X0Y4_FrameData[30] VGND VPWR Tile_X0Y9_FrameStrobe[7] latch
XFILLER_641_63 VPWR VGND sg13cmos5l_decap_8
XANTENNA__3024__X Tile_X0Y5_E6BEG[11] VPWR VGND sg13cmos5l_antennanp
XFILLER_643_140 VPWR VGND sg13cmos5l_decap_8
XFILLER_360_42 VPWR VGND sg13cmos5l_decap_8
X_1102_ _1102_/Q Tile_X0Y0_FrameData[29] VGND VPWR Tile_X0Y9_FrameStrobe[5] latch
XFILLER_442_202 VPWR VGND sg13cmos5l_decap_8
X_2082_ _2082_/Q Tile_X0Y4_FrameData[3] VGND VPWR Tile_X0Y9_FrameStrobe[4] latch
XFILLER_442_224 VPWR VGND sg13cmos5l_decap_4
XFILLER_399_117 VPWR VGND sg13cmos5l_decap_8
XFILLER_442_235 VPWR VGND sg13cmos5l_decap_8
XANTENNA__2863__X Tile_X0Y6_EE4BEG[0] VPWR VGND sg13cmos5l_antennanp
X_1033_ _1033_/Q Tile_X0Y0_FrameData[2] VGND VPWR Tile_X0Y9_FrameStrobe[2] latch
XFILLER_442_268 VPWR VGND sg13cmos5l_decap_4
XFILLER_510_56 VPWR VGND sg13cmos5l_decap_8
XFILLER_596_261 VPWR VGND sg13cmos5l_fill_1
XFILLER_596_272 VPWR VGND sg13cmos5l_fill_1
XFILLER_556_114 VPWR VGND sg13cmos5l_fill_1
X_2984_ Tile_X0Y8_FrameData_O[24] Tile_X0Y8_FrameData[24] VPWR VGND sg13cmos5l_buf_1
XFILLER_586_49 VPWR VGND sg13cmos5l_decap_8
XFILLER_556_147 VPWR VGND sg13cmos5l_fill_2
XFILLER_410_154 VPWR VGND sg13cmos5l_decap_8
XFILLER_369_84 VPWR VGND sg13cmos5l_decap_8
XFILLER_519_21 VPWR VGND sg13cmos5l_decap_8
X_4723_ _4723_/X _4807_/X _4811_/X _4815_/X _4784_/X _0602_/Q _0601_/Q VPWR VGND sg13cmos5l_mux4_1
X_1935_ _1935_/Q Tile_X0Y4_FrameData[22] VGND VPWR Tile_X0Y9_FrameStrobe[0] latch
XANTENNA__3694__X AXI_M_SOC_WDATA4 VPWR VGND sg13cmos5l_antennanp
X_4654_ _4654_/X AXI_M_SOC_RDATA22 _4685_/X _4689_/X _4670_/X _0251_/Q _0250_/Q VPWR
+ VGND sg13cmos5l_mux4_1
XFILLER_308_136 VPWR VGND sg13cmos5l_decap_8
X_1866_ _1866_/Q Tile_X0Y3_FrameData[31] VGND VPWR Tile_X0Y9_FrameStrobe[6] latch
XFILLER_564_191 VPWR VGND sg13cmos5l_decap_8
X_3605_ Tile_X0Y9_S1BEG[3] _4827_/X VPWR VGND sg13cmos5l_buf_1
X_0817_ _0817_/Q Tile_X0Y9_FrameData[14] VGND VPWR Tile_X0Y9_FrameStrobe[4] latch
XFILLER_174_186 VPWR VGND sg13cmos5l_fill_2
XFILLER_713_166 VPWR VGND sg13cmos5l_decap_8
X_4585_ _4585_/X Tile_X0Y8_W2MID[7] Tile_X0Y8_W2END[7] Tile_X0Y8_W6END[7] _4785_/X
+ _0663_/Q _0662_/Q VPWR VGND sg13cmos5l_mux4_1
XFILLER_385_94 VPWR VGND sg13cmos5l_decap_4
X_1797_ _1797_/Q Tile_X0Y3_FrameData[4] VGND VPWR Tile_X0Y9_FrameStrobe[3] latch
XFILLER_512_228 VPWR VGND sg13cmos5l_decap_8
XFILLER_323_139 VPWR VGND sg13cmos5l_decap_8
XFILLER_535_42 VPWR VGND sg13cmos5l_decap_8
XFILLER_512_239 VPWR VGND sg13cmos5l_decap_8
X_3536_ Tile_X0Y9_E2BEGb[2] _4858_/X VPWR VGND sg13cmos5l_buf_1
X_0748_ _0748_/Q Tile_X0Y9_FrameData[19] VGND VPWR Tile_X0Y9_FrameStrobe[2] latch
XFILLER_254_21 VPWR VGND sg13cmos5l_decap_8
X_3467_ Tile_X0Y1_FrameData_O[25] Tile_X0Y1_FrameData[25] VPWR VGND sg13cmos5l_buf_1
X_0679_ _0679_/Q Tile_X0Y9_FrameData[24] VGND VPWR Tile_X0Y9_FrameStrobe[0] latch
XFILLER_520_272 VPWR VGND sg13cmos5l_fill_1
X_2418_ _2418_/Q Tile_X0Y5_FrameData[19] VGND VPWR Tile_X0Y9_FrameStrobe[7] latch
X_3398_ Tile_X0Y2_E2BEG[1] _4041_/X VPWR VGND sg13cmos5l_buf_1
XFILLER_404_35 VPWR VGND sg13cmos5l_decap_8
XFILLER_681_235 VPWR VGND sg13cmos5l_decap_8
XFILLER_229_143 VPWR VGND sg13cmos5l_decap_8
XFILLER_551_63 VPWR VGND sg13cmos5l_decap_8
XFILLER_29_215 VPWR VGND sg13cmos5l_decap_8
XFILLER_123_14 VPWR VGND sg13cmos5l_decap_8
X_2349_ _2349_/Q Tile_X0Y5_FrameData[24] VGND VPWR Tile_X0Y9_FrameStrobe[5] latch
XFILLER_492_168 VPWR VGND sg13cmos5l_decap_8
XFILLER_418_254 VPWR VGND sg13cmos5l_decap_8
XFILLER_634_140 VPWR VGND sg13cmos5l_decap_8
XFILLER_270_42 VPWR VGND sg13cmos5l_decap_8
XFILLER_284_271 VPWR VGND sg13cmos5l_fill_2
XFILLER_177_8 VPWR VGND sg13cmos5l_decap_8
XFILLER_433_246 VPWR VGND sg13cmos5l_decap_8
XANTENNA__2773__X Tile_X0Y3_FrameData_O[31] VPWR VGND sg13cmos5l_antennanp
X_4019_ _4019_/X _3987_/X _0084_/X _3986_/X Tile_X0Y0_S4END[7] _1211_/Q _1210_/Q VPWR
+ VGND sg13cmos5l_mux4_1
XFILLER_701_77 VPWR VGND sg13cmos5l_decap_8
XFILLER_579_239 VPWR VGND sg13cmos5l_decap_8
XFILLER_420_56 VPWR VGND sg13cmos5l_decap_8
XFILLER_203_91 VPWR VGND sg13cmos5l_decap_8
XFILLER_16_56 VPWR VGND sg13cmos5l_decap_8
XFILLER_52_240 VPWR VGND sg13cmos5l_fill_1
XFILLER_587_272 VPWR VGND sg13cmos5l_fill_1
XFILLER_52_262 VPWR VGND sg13cmos5l_fill_2
XFILLER_401_121 VPWR VGND sg13cmos5l_decap_8
XFILLER_197_245 VPWR VGND sg13cmos5l_decap_8
XFILLER_398_194 VPWR VGND sg13cmos5l_decap_8
XFILLER_12_115 VPWR VGND sg13cmos5l_fill_2
XFILLER_547_136 VPWR VGND sg13cmos5l_decap_8
XFILLER_496_49 VPWR VGND sg13cmos5l_decap_8
XFILLER_337_7 VPWR VGND sg13cmos5l_decap_8
XFILLER_279_84 VPWR VGND sg13cmos5l_decap_8
XFILLER_200_216 VPWR VGND sg13cmos5l_decap_8
XFILLER_429_21 VPWR VGND sg13cmos5l_decap_8
XFILLER_12_159 VPWR VGND sg13cmos5l_decap_8
XFILLER_547_169 VPWR VGND sg13cmos5l_decap_8
XFILLER_504_7 VPWR VGND sg13cmos5l_decap_8
XFILLER_354_231 VPWR VGND sg13cmos5l_decap_8
XFILLER_429_98 VPWR VGND sg13cmos5l_decap_8
XFILLER_165_153 VPWR VGND sg13cmos5l_decap_8
XFILLER_295_50 VPWR VGND sg13cmos5l_decap_8
XFILLER_704_144 VPWR VGND sg13cmos5l_decap_8
XFILLER_148_77 VPWR VGND sg13cmos5l_decap_8
XFILLER_295_83 VPWR VGND sg13cmos5l_fill_1
XFILLER_570_161 VPWR VGND sg13cmos5l_decap_8
XFILLER_180_123 VPWR VGND sg13cmos5l_decap_8
XANTENNA__3109__X Tile_X0Y7_E6BEG[7] VPWR VGND sg13cmos5l_antennanp
XFILLER_445_42 VPWR VGND sg13cmos5l_decap_8
XFILLER_314_139 VPWR VGND sg13cmos5l_decap_8
XFILLER_592_81 VPWR VGND sg13cmos5l_decap_8
XFILLER_121_201 VPWR VGND sg13cmos5l_fill_2
XFILLER_164_43 VPWR VGND sg13cmos5l_decap_8
XFILLER_180_189 VPWR VGND sg13cmos5l_decap_8
XFILLER_445_97 VPWR VGND sg13cmos5l_decap_8
XANTENNA__2948__X Tile_X0Y8_EE4BEG[4] VPWR VGND sg13cmos5l_antennanp
XFILLER_79_126 VPWR VGND sg13cmos5l_decap_8
XFILLER_672_202 VPWR VGND sg13cmos5l_decap_4
XFILLER_164_98 VPWR VGND sg13cmos5l_decap_8
XFILLER_617_118 VPWR VGND sg13cmos5l_decap_8
XFILLER_267_249 VPWR VGND sg13cmos5l_decap_4
XFILLER_196_0 VPWR VGND sg13cmos5l_decap_8
XFILLER_461_63 VPWR VGND sg13cmos5l_decap_8
XFILLER_314_57 VPWR VGND sg13cmos5l_decap_8
XFILLER_409_243 VPWR VGND sg13cmos5l_decap_8
XFILLER_409_265 VPWR VGND sg13cmos5l_decap_8
XFILLER_180_42 VPWR VGND sg13cmos5l_decap_8
XFILLER_57_74 VPWR VGND sg13cmos5l_decap_8
XFILLER_275_271 VPWR VGND sg13cmos5l_fill_2
XFILLER_625_162 VPWR VGND sg13cmos5l_decap_8
XFILLER_424_224 VPWR VGND sg13cmos5l_decap_8
XANTENNA__3779__X AXI_M_SOC_RREADY VPWR VGND sg13cmos5l_antennanp
XFILLER_363_0 VPWR VGND sg13cmos5l_decap_4
XFILLER_290_241 VPWR VGND sg13cmos5l_decap_8
XFILLER_611_77 VPWR VGND sg13cmos5l_decap_8
XFILLER_35_229 VPWR VGND sg13cmos5l_decap_8
XFILLER_640_154 VPWR VGND sg13cmos5l_decap_8
XFILLER_585_209 VPWR VGND sg13cmos5l_decap_8
XFILLER_250_127 VPWR VGND sg13cmos5l_decap_8
XFILLER_43_240 VPWR VGND sg13cmos5l_decap_4
XFILLER_189_40 VPWR VGND sg13cmos5l_decap_4
XFILLER_530_0 VPWR VGND sg13cmos5l_decap_8
XFILLER_389_183 VPWR VGND sg13cmos5l_decap_8
XFILLER_628_0 VPWR VGND sg13cmos5l_decap_4
XFILLER_188_245 VPWR VGND sg13cmos5l_decap_8
XFILLER_189_73 VPWR VGND sg13cmos5l_decap_8
XFILLER_538_136 VPWR VGND sg13cmos5l_fill_1
XFILLER_538_158 VPWR VGND sg13cmos5l_decap_8
XFILLER_339_21 VPWR VGND sg13cmos5l_decap_8
XFILLER_538_169 VPWR VGND sg13cmos5l_decap_4
XFILLER_85_7 VPWR VGND sg13cmos5l_decap_8
X_1720_ _1720_/Q Tile_X0Y3_FrameData[17] VGND VPWR Tile_X0Y9_FrameStrobe[1] latch
XFILLER_546_180 VPWR VGND sg13cmos5l_fill_2
XFILLER_156_142 VPWR VGND sg13cmos5l_decap_8
XFILLER_345_231 VPWR VGND sg13cmos5l_decap_8
XFILLER_339_98 VPWR VGND sg13cmos5l_decap_8
X_1651_ _1651_/Q Tile_X0Y2_FrameData[30] VGND VPWR Tile_X0Y9_FrameStrobe[7] latch
XFILLER_636_63 VPWR VGND sg13cmos5l_decap_8
XFILLER_360_201 VPWR VGND sg13cmos5l_fill_1
XFILLER_171_112 VPWR VGND sg13cmos5l_decap_8
XFILLER_208_14 VPWR VGND sg13cmos5l_decap_8
XANTENNA__3019__X Tile_X0Y5_E6BEG[6] VPWR VGND sg13cmos5l_antennanp
XFILLER_7_185 VPWR VGND sg13cmos5l_decap_8
XFILLER_360_223 VPWR VGND sg13cmos5l_decap_8
XFILLER_355_42 VPWR VGND sg13cmos5l_decap_8
X_0602_ _0602_/Q Tile_X0Y8_FrameData[5] VGND VPWR Tile_X0Y9_FrameStrobe[5] latch
XFILLER_710_125 VPWR VGND sg13cmos5l_decap_4
X_4370_ _4370_/X _4424_/X _4423_/X AXI_M_SOC_RLAST _4422_/X _2363_/Q _2362_/Q VPWR
+ VGND sg13cmos5l_mux4_1
X_1582_ _1582_/Q Tile_X0Y2_FrameData[3] VGND VPWR Tile_X0Y9_FrameStrobe[4] latch
XFILLER_171_178 VPWR VGND sg13cmos5l_decap_8
X_3321_ Tile_X0Y4_EE4BEG[9] _4281_/X VPWR VGND sg13cmos5l_buf_1
XANTENNA__2858__X Tile_X0Y6_E6BEG[7] VPWR VGND sg13cmos5l_antennanp
X_0533_ _0533_/Q Tile_X0Y8_FrameData[10] VGND VPWR Tile_X0Y9_FrameStrobe[3] latch
XFILLER_258_205 VPWR VGND sg13cmos5l_decap_8
XFILLER_112_234 VPWR VGND sg13cmos5l_fill_1
XFILLER_505_56 VPWR VGND sg13cmos5l_decap_8
XFILLER_112_256 VPWR VGND sg13cmos5l_decap_4
X_3252_ Tile_X0Y0_FrameData_O[20] Tile_X0Y0_FrameData[20] VPWR VGND sg13cmos5l_buf_1
X_0464_ _0464_/Q Tile_X0Y8_FrameData[15] VGND VPWR Tile_X0Y9_FrameStrobe[1] latch
XFILLER_652_84 VPWR VGND sg13cmos5l_decap_8
XFILLER_224_35 VPWR VGND sg13cmos5l_decap_8
X_2203_ _2203_/Q Tile_X0Y5_FrameData[10] VGND VPWR Tile_X0Y9_FrameStrobe[0] latch
XFILLER_371_63 VPWR VGND sg13cmos5l_decap_8
X_3183_ Tile_X0Y0_N4BEG[7] _3183_/A VPWR VGND sg13cmos5l_buf_1
XFILLER_663_268 VPWR VGND sg13cmos5l_decap_4
X_0395_ _0395_/Q Tile_X0Y7_FrameData[20] VGND VPWR Tile_X0Y9_FrameStrobe[7] latch
XFILLER_616_162 VPWR VGND sg13cmos5l_fill_2
X_2134_ _2134_/Q Tile_X0Y4_FrameData[15] VGND VPWR Tile_X0Y9_FrameStrobe[6] latch
XANTENNA__3689__X AXI_M_SOC_AWVALID VPWR VGND sg13cmos5l_antennanp
XFILLER_226_146 VPWR VGND sg13cmos5l_decap_8
XFILLER_616_195 VPWR VGND sg13cmos5l_fill_1
XFILLER_281_241 VPWR VGND sg13cmos5l_decap_8
XFILLER_521_77 VPWR VGND sg13cmos5l_decap_8
X_2065_ _2065_/Q Tile_X0Y4_FrameData[20] VGND VPWR Tile_X0Y9_FrameStrobe[4] latch
XFILLER_631_154 VPWR VGND sg13cmos5l_decap_8
XFILLER_240_56 VPWR VGND sg13cmos5l_decap_8
XFILLER_631_176 VPWR VGND sg13cmos5l_decap_4
X_1016_ _1016_/Q Tile_X0Y0_FrameData[19] VGND VPWR Tile_X0Y9_FrameStrobe[2] latch
XFILLER_430_238 VPWR VGND sg13cmos5l_decap_8
XFILLER_529_103 VPWR VGND sg13cmos5l_decap_8
XFILLER_395_164 VPWR VGND sg13cmos5l_decap_8
XFILLER_194_226 VPWR VGND sg13cmos5l_decap_8
XFILLER_249_43 VPWR VGND sg13cmos5l_decap_8
X_2967_ Tile_X0Y8_FrameData_O[7] Tile_X0Y8_FrameData[7] VPWR VGND sg13cmos5l_buf_1
XFILLER_544_128 VPWR VGND sg13cmos5l_decap_8
XFILLER_336_220 VPWR VGND sg13cmos5l_decap_8
X_1918_ _1918_/Q Tile_X0Y3_FrameData[11] VGND VPWR Tile_X0Y9_FrameStrobe[7] latch
X_4706_ _4706_/X Tile_X0Y6_W2MID[4] Tile_X0Y6_W2END[4] Tile_X0Y6_W6END[11] _4559_/X
+ _2645_/Q _2644_/Q VPWR VGND sg13cmos5l_mux4_1
XFILLER_147_153 VPWR VGND sg13cmos5l_decap_8
X_2898_ Tile_X0Y6_FrameData_O[19] Tile_X0Y6_FrameData[19] VPWR VGND sg13cmos5l_buf_1
XFILLER_147_164 VPWR VGND sg13cmos5l_fill_1
XFILLER_162_101 VPWR VGND sg13cmos5l_fill_2
X_4637_ _4637_/X Tile_X0Y7_WW4END[6] AXI_M_SOC_RDATA22 _4690_/X _4670_/X _0285_/Q
+ _0284_/Q VPWR VGND sg13cmos5l_mux4_1
XFILLER_546_63 VPWR VGND sg13cmos5l_decap_8
XFILLER_118_14 VPWR VGND sg13cmos5l_decap_8
XFILLER_147_186 VPWR VGND sg13cmos5l_decap_8
X_1849_ _1849_/Q Tile_X0Y3_FrameData[16] VGND VPWR Tile_X0Y9_FrameStrobe[5] latch
XFILLER_162_145 VPWR VGND sg13cmos5l_decap_8
XFILLER_265_42 VPWR VGND sg13cmos5l_decap_8
X_4568_ _4568_/X _4545_/X Tile_X0Y9_N4END[12] _4544_/X _0152_/X _2495_/Q _2494_/Q
+ VPWR VGND sg13cmos5l_mux4_1
XFILLER_497_238 VPWR VGND sg13cmos5l_decap_8
XFILLER_698_198 VPWR VGND sg13cmos5l_fill_1
XFILLER_639_210 VPWR VGND sg13cmos5l_decap_8
XFILLER_497_249 VPWR VGND sg13cmos5l_fill_1
XANTENNA__2768__X Tile_X0Y3_FrameData_O[26] VPWR VGND sg13cmos5l_antennanp
X_3519_ Tile_X0Y1_E1BEG[1] _3929_/X VPWR VGND sg13cmos5l_buf_1
X_4499_ _4499_/X Tile_X0Y6_W2MID[4] AXI_M_SOC_RDATA27 _4559_/X _4558_/X _2609_/Q _2608_/Q
+ VPWR VGND sg13cmos5l_mux4_1
XFILLER_465_102 VPWR VGND sg13cmos5l_decap_8
XFILLER_415_56 VPWR VGND sg13cmos5l_decap_8
XFILLER_134_35 VPWR VGND sg13cmos5l_decap_8
XFILLER_562_84 VPWR VGND sg13cmos5l_decap_8
XFILLER_712_21 VPWR VGND sg13cmos5l_decap_8
XFILLER_76_129 VPWR VGND sg13cmos5l_decap_8
XFILLER_281_63 VPWR VGND sg13cmos5l_decap_8
XFILLER_94_28 VPWR VGND sg13cmos5l_decap_8
XFILLER_287_7 VPWR VGND sg13cmos5l_decap_8
XFILLER_480_105 VPWR VGND sg13cmos5l_decap_8
XFILLER_84_140 VPWR VGND sg13cmos5l_decap_8
XFILLER_712_98 VPWR VGND sg13cmos5l_decap_8
XANTENNA__3599__X Tile_X0Y9_FrameData_O[29] VPWR VGND sg13cmos5l_antennanp
XFILLER_217_157 VPWR VGND sg13cmos5l_decap_8
XFILLER_431_77 VPWR VGND sg13cmos5l_decap_8
XFILLER_454_7 VPWR VGND sg13cmos5l_decap_8
XFILLER_232_105 VPWR VGND sg13cmos5l_decap_8
XFILLER_150_67 VPWR VGND sg13cmos5l_decap_8
XFILLER_622_187 VPWR VGND sg13cmos5l_decap_8
XFILLER_622_198 VPWR VGND sg13cmos5l_fill_2
XFILLER_709_203 VPWR VGND sg13cmos5l_decap_8
XFILLER_421_249 VPWR VGND sg13cmos5l_decap_4
XFILLER_621_7 VPWR VGND sg13cmos5l_decap_8
XFILLER_386_131 VPWR VGND sg13cmos5l_decap_8
XFILLER_575_231 VPWR VGND sg13cmos5l_decap_8
XFILLER_587_70 VPWR VGND sg13cmos5l_decap_8
XFILLER_159_21 VPWR VGND sg13cmos5l_decap_8
XFILLER_40_254 VPWR VGND sg13cmos5l_decap_8
XFILLER_535_117 VPWR VGND sg13cmos5l_fill_2
XFILLER_327_264 VPWR VGND sg13cmos5l_fill_1
XFILLER_138_175 VPWR VGND sg13cmos5l_decap_8
XFILLER_673_28 VPWR VGND sg13cmos5l_decap_8
XFILLER_456_63 VPWR VGND sg13cmos5l_decap_8
XFILLER_111_0 VPWR VGND sg13cmos5l_decap_8
XFILLER_153_134 VPWR VGND sg13cmos5l_decap_8
XFILLER_175_42 VPWR VGND sg13cmos5l_decap_8
XFILLER_209_0 VPWR VGND sg13cmos5l_decap_8
XFILLER_689_176 VPWR VGND sg13cmos5l_decap_8
XFILLER_153_156 VPWR VGND sg13cmos5l_decap_8
XFILLER_342_256 VPWR VGND sg13cmos5l_fill_1
XFILLER_175_86 VPWR VGND sg13cmos5l_decap_8
XFILLER_606_99 VPWR VGND sg13cmos5l_decap_8
XFILLER_108_91 VPWR VGND sg13cmos5l_decap_8
XFILLER_645_224 VPWR VGND sg13cmos5l_decap_8
XFILLER_622_21 VPWR VGND sg13cmos5l_decap_8
XFILLER_480_0 VPWR VGND sg13cmos5l_decap_8
XFILLER_68_84 VPWR VGND sg13cmos5l_decap_8
XFILLER_578_0 VPWR VGND sg13cmos5l_decap_8
XFILLER_310_175 VPWR VGND sg13cmos5l_decap_8
XFILLER_255_208 VPWR VGND sg13cmos5l_decap_8
X_0180_ _0180_/Q Tile_X0Y7_FrameData[11] VGND VPWR Tile_X0Y9_FrameStrobe[0] latch
XFILLER_698_14 VPWR VGND sg13cmos5l_decap_8
XFILLER_471_149 VPWR VGND sg13cmos5l_decap_8
XFILLER_613_121 VPWR VGND sg13cmos5l_decap_8
XFILLER_341_77 VPWR VGND sg13cmos5l_fill_2
XFILLER_208_168 VPWR VGND sg13cmos5l_decap_8
XFILLER_263_263 VPWR VGND sg13cmos5l_decap_8
XANTENNA__3302__X Tile_X0Y0_E2BEG[2] VPWR VGND sg13cmos5l_antennanp
XFILLER_412_205 VPWR VGND sg13cmos5l_decap_8
XFILLER_90_187 VPWR VGND sg13cmos5l_decap_4
XFILLER_566_220 VPWR VGND sg13cmos5l_decap_8
X_3870_ _3870_/X _4341_/X _4345_/X _4349_/X _4315_/X _2154_/Q _2153_/Q VPWR VGND sg13cmos5l_mux4_1
XFILLER_497_70 VPWR VGND sg13cmos5l_decap_8
XFILLER_31_243 VPWR VGND sg13cmos5l_decap_8
X_2821_ Tile_X0Y3_E1BEG[3] _4147_/X VPWR VGND sg13cmos5l_buf_1
XFILLER_31_254 VPWR VGND sg13cmos5l_fill_2
XFILLER_715_217 VPWR VGND sg13cmos5l_decap_8
X_2752_ Tile_X0Y3_FrameData_O[10] Tile_X0Y3_FrameData[10] VPWR VGND sg13cmos5l_buf_1
XFILLER_647_84 VPWR VGND sg13cmos5l_decap_8
XFILLER_219_35 VPWR VGND sg13cmos5l_decap_8
XFILLER_129_164 VPWR VGND sg13cmos5l_decap_8
X_1703_ _1703_/Q Tile_X0Y3_FrameData[2] VGND VPWR Tile_X0Y9_FrameStrobe[0] latch
XFILLER_534_150 VPWR VGND sg13cmos5l_decap_8
XFILLER_583_28 VPWR VGND sg13cmos5l_decap_8
X_2683_ _2683_/Q Tile_X0Y6_FrameData[12] VGND VPWR Tile_X0Y9_FrameStrobe[7] latch
XFILLER_479_205 VPWR VGND sg13cmos5l_decap_8
X_4422_ _4422_/X _4424_/X Tile_X0Y5_W6END[2] _4423_/X _4422_/A3 _2185_/Q _2184_/Q
+ VPWR VGND sg13cmos5l_mux4_1
XFILLER_144_156 VPWR VGND sg13cmos5l_decap_4
X_1634_ _1634_/Q Tile_X0Y2_FrameData[15] VGND VPWR Tile_X0Y9_FrameStrobe[6] latch
XFILLER_144_189 VPWR VGND sg13cmos5l_decap_8
X_4353_ _4353_/X Tile_X0Y6_W2MID[7] Tile_X0Y6_W2END[7] Tile_X0Y6_W6END[7] _4553_/X
+ _2687_/Q _2686_/Q VPWR VGND sg13cmos5l_mux4_1
XFILLER_516_77 VPWR VGND sg13cmos5l_decap_8
X_1565_ _1565_/Q Tile_X0Y2_FrameData[20] VGND VPWR Tile_X0Y9_FrameStrobe[4] latch
XFILLER_516_88 VPWR VGND sg13cmos5l_fill_1
XFILLER_98_232 VPWR VGND sg13cmos5l_decap_8
XFILLER_298_160 VPWR VGND sg13cmos5l_decap_8
XFILLER_235_56 VPWR VGND sg13cmos5l_decap_8
X_3304_ Tile_X0Y0_E2BEG[4] _3808_/X VPWR VGND sg13cmos5l_buf_1
X_0516_ _0516_/Q Tile_X0Y8_FrameData[27] VGND VPWR Tile_X0Y9_FrameStrobe[3] latch
XFILLER_98_265 VPWR VGND sg13cmos5l_decap_8
X_4284_ _4284_/X Tile_X0Y4_WW4END[3] AXI_M_SOC_BRESP1 _4339_/X _4319_/X _2045_/Q _2044_/Q
+ VPWR VGND sg13cmos5l_mux4_1
X_1496_ _1496_/Q Tile_X0Y2_FrameData[25] VGND VPWR Tile_X0Y9_FrameStrobe[2] latch
XFILLER_532_21 VPWR VGND sg13cmos5l_decap_8
XFILLER_100_215 VPWR VGND sg13cmos5l_decap_4
X_3235_ Tile_X0Y0_FrameData_O[3] Tile_X0Y0_FrameData[3] VPWR VGND sg13cmos5l_buf_1
XFILLER_246_208 VPWR VGND sg13cmos5l_decap_8
X_0447_ _0447_/Q Tile_X0Y8_FrameData[0] VGND VPWR Tile_X0Y9_FrameStrobe[0] latch
XFILLER_447_179 VPWR VGND sg13cmos5l_decap_8
XFILLER_239_271 VPWR VGND sg13cmos5l_fill_2
XFILLER_66_140 VPWR VGND sg13cmos5l_decap_8
X_3166_ Tile_X0Y4_E6BEG[3] _4291_/X VPWR VGND sg13cmos5l_buf_1
XFILLER_651_238 VPWR VGND sg13cmos5l_decap_8
X_0378_ _0378_/Q Tile_X0Y7_FrameData[5] VGND VPWR Tile_X0Y9_FrameStrobe[6] latch
XFILLER_251_77 VPWR VGND sg13cmos5l_decap_8
XFILLER_81_110 VPWR VGND sg13cmos5l_decap_8
X_2117_ _2117_/Q Tile_X0Y4_FrameData[0] VGND VPWR Tile_X0Y9_FrameStrobe[5] latch
XFILLER_254_263 VPWR VGND sg13cmos5l_fill_2
XFILLER_214_105 VPWR VGND sg13cmos5l_decap_8
X_3097_ Tile_X0Y7_E2BEGb[3] _4623_/X VPWR VGND sg13cmos5l_buf_1
XANTENNA__3212__X Tile_X0Y0_FrameStrobe_O[0] VPWR VGND sg13cmos5l_antennanp
XFILLER_401_36 VPWR VGND sg13cmos5l_decap_8
X_2048_ _2048_/Q Tile_X0Y4_FrameData[5] VGND VPWR Tile_X0Y9_FrameStrobe[3] latch
XFILLER_368_131 VPWR VGND sg13cmos5l_decap_8
XFILLER_22_232 VPWR VGND sg13cmos5l_decap_8
XFILLER_557_253 VPWR VGND sg13cmos5l_decap_8
XFILLER_200_70 VPWR VGND sg13cmos5l_decap_8
XFILLER_517_117 VPWR VGND sg13cmos5l_decap_8
XFILLER_383_112 VPWR VGND sg13cmos5l_decap_8
X_3999_ _3999_/X _3985_/X _0095_/X _3984_/X Tile_X0Y0_S4END[6] _1205_/Q _1204_/Q VPWR
+ VGND sg13cmos5l_mux4_1
XFILLER_13_35 VPWR VGND sg13cmos5l_decap_8
XFILLER_309_220 VPWR VGND sg13cmos5l_decap_8
XFILLER_572_245 VPWR VGND sg13cmos5l_decap_8
XFILLER_129_35 VPWR VGND sg13cmos5l_decap_8
XFILLER_557_84 VPWR VGND sg13cmos5l_decap_4
XFILLER_13_79 VPWR VGND sg13cmos5l_decap_4
XFILLER_707_21 VPWR VGND sg13cmos5l_decap_8
XFILLER_309_264 VPWR VGND sg13cmos5l_fill_1
XFILLER_493_28 VPWR VGND sg13cmos5l_decap_8
XFILLER_383_189 VPWR VGND sg13cmos5l_decap_8
XFILLER_276_63 VPWR VGND sg13cmos5l_decap_8
XFILLER_135_112 VPWR VGND sg13cmos5l_decap_8
XFILLER_89_28 VPWR VGND sg13cmos5l_decap_8
XFILLER_135_134 VPWR VGND sg13cmos5l_decap_8
XFILLER_202_7 VPWR VGND sg13cmos5l_decap_8
XFILLER_707_98 VPWR VGND sg13cmos5l_decap_8
XFILLER_686_135 VPWR VGND sg13cmos5l_decap_8
XFILLER_426_77 VPWR VGND sg13cmos5l_decap_8
XFILLER_540_175 VPWR VGND sg13cmos5l_decap_8
XFILLER_145_56 VPWR VGND sg13cmos5l_decap_8
XFILLER_89_243 VPWR VGND sg13cmos5l_fill_2
XFILLER_478_271 VPWR VGND sg13cmos5l_fill_2
XFILLER_438_102 VPWR VGND sg13cmos5l_decap_8
XFILLER_292_84 VPWR VGND sg13cmos5l_decap_8
XFILLER_627_246 VPWR VGND sg13cmos5l_decap_8
XFILLER_493_241 VPWR VGND sg13cmos5l_decap_4
XFILLER_627_257 VPWR VGND sg13cmos5l_fill_2
XFILLER_442_43 VPWR VGND sg13cmos5l_decap_8
XFILLER_38_21 VPWR VGND sg13cmos5l_decap_8
XFILLER_571_7 VPWR VGND sg13cmos5l_decap_8
XFILLER_669_7 VPWR VGND sg13cmos5l_decap_8
XFILLER_438_179 VPWR VGND sg13cmos5l_fill_1
XFILLER_237_219 VPWR VGND sg13cmos5l_fill_1
XFILLER_161_22 VPWR VGND sg13cmos5l_decap_8
XFILLER_442_87 VPWR VGND sg13cmos5l_decap_8
XFILLER_642_238 VPWR VGND sg13cmos5l_decap_8
XFILLER_245_230 VPWR VGND sg13cmos5l_fill_1
XFILLER_205_105 VPWR VGND sg13cmos5l_decap_8
XANTENNA__3122__X Tile_X0Y7_EE4BEG[8] VPWR VGND sg13cmos5l_antennanp
XFILLER_311_36 VPWR VGND sg13cmos5l_decap_8
XFILLER_260_222 VPWR VGND sg13cmos5l_decap_8
XFILLER_668_28 VPWR VGND sg13cmos5l_decap_8
XFILLER_159_0 VPWR VGND sg13cmos5l_decap_8
XANTENNA__2961__X Tile_X0Y8_FrameData_O[1] VPWR VGND sg13cmos5l_antennanp
XFILLER_13_210 VPWR VGND sg13cmos5l_decap_4
XFILLER_359_142 VPWR VGND sg13cmos5l_decap_8
XFILLER_548_264 VPWR VGND sg13cmos5l_decap_8
XFILLER_9_214 VPWR VGND sg13cmos5l_decap_8
XFILLER_563_201 VPWR VGND sg13cmos5l_decap_8
XFILLER_359_186 VPWR VGND sg13cmos5l_decap_8
XFILLER_158_248 VPWR VGND sg13cmos5l_decap_8
XFILLER_158_259 VPWR VGND sg13cmos5l_fill_2
XFILLER_326_0 VPWR VGND sg13cmos5l_decap_8
XFILLER_9_269 VPWR VGND sg13cmos5l_decap_4
XFILLER_617_21 VPWR VGND sg13cmos5l_decap_8
XFILLER_173_229 VPWR VGND sg13cmos5l_decap_8
XFILLER_70_85 VPWR VGND sg13cmos5l_decap_8
XFILLER_315_201 VPWR VGND sg13cmos5l_fill_1
XFILLER_186_74 VPWR VGND sg13cmos5l_decap_8
XFILLER_315_223 VPWR VGND sg13cmos5l_decap_8
XFILLER_531_131 VPWR VGND sg13cmos5l_decap_8
XFILLER_677_124 VPWR VGND sg13cmos5l_decap_8
XFILLER_483_50 VPWR VGND sg13cmos5l_decap_8
XFILLER_181_262 VPWR VGND sg13cmos5l_decap_8
XFILLER_695_0 VPWR VGND sg13cmos5l_decap_8
XFILLER_531_175 VPWR VGND sg13cmos5l_decap_8
XFILLER_141_137 VPWR VGND sg13cmos5l_decap_8
XFILLER_531_186 VPWR VGND sg13cmos5l_decap_8
XFILLER_287_119 VPWR VGND sg13cmos5l_decap_8
XFILLER_677_179 VPWR VGND sg13cmos5l_decap_4
XFILLER_330_248 VPWR VGND sg13cmos5l_decap_8
XFILLER_633_42 VPWR VGND sg13cmos5l_decap_8
X_1350_ _1350_/Q Tile_X0Y1_FrameData[19] VGND VPWR Tile_X0Y9_FrameStrobe[5] latch
XFILLER_484_230 VPWR VGND sg13cmos5l_decap_8
XFILLER_352_21 VPWR VGND sg13cmos5l_decap_8
X_0301_ _0301_/Q Tile_X0Y7_FrameData[18] VGND VPWR Tile_X0Y9_FrameStrobe[4] latch
XFILLER_429_168 VPWR VGND sg13cmos5l_decap_8
X_1281_ _1281_/Q Tile_X0Y1_FrameData[24] VGND VPWR Tile_X0Y9_FrameStrobe[3] latch
X_3020_ Tile_X0Y5_E6BEG[7] _4411_/X VPWR VGND sg13cmos5l_buf_1
XFILLER_295_196 VPWR VGND sg13cmos5l_decap_8
X_0232_ _0232_/Q Tile_X0Y7_FrameData[23] VGND VPWR Tile_X0Y9_FrameStrobe[2] latch
XFILLER_352_98 VPWR VGND sg13cmos5l_decap_8
XFILLER_633_249 VPWR VGND sg13cmos5l_decap_4
XFILLER_502_35 VPWR VGND sg13cmos5l_decap_8
XFILLER_236_230 VPWR VGND sg13cmos5l_fill_2
XFILLER_221_14 VPWR VGND sg13cmos5l_decap_8
X_0163_ _0163_/Q Tile_X0Y7_FrameData[28] VGND VPWR Tile_X0Y9_FrameStrobe[0] latch
XFILLER_598_131 VPWR VGND sg13cmos5l_decap_8
XANTENNA__3032__X Tile_X0Y5_EE4BEG[7] VPWR VGND sg13cmos5l_antennanp
XFILLER_63_132 VPWR VGND sg13cmos5l_decap_8
XFILLER_641_271 VPWR VGND sg13cmos5l_fill_2
XFILLER_601_102 VPWR VGND sg13cmos5l_fill_2
XFILLER_251_233 VPWR VGND sg13cmos5l_decap_8
XFILLER_578_28 VPWR VGND sg13cmos5l_decap_8
X_0094_ _0094_/X _4114_/X _4115_/X _2660_/Q VPWR VGND sg13cmos5l_mux2_1
XFILLER_397_237 VPWR VGND sg13cmos5l_fill_2
XFILLER_601_146 VPWR VGND sg13cmos5l_decap_8
XANTENNA__2871__X Tile_X0Y6_EE4BEG[8] VPWR VGND sg13cmos5l_antennanp
XFILLER_211_119 VPWR VGND sg13cmos5l_decap_8
X_3922_ _3922_/X Tile_X0Y3_W1END[2] Tile_X0Y3_WW4END[2] Tile_X0Y3_W6END[10] _4224_/X
+ _1895_/Q _1894_/Q VPWR VGND sg13cmos5l_mux4_1
XFILLER_297_29 VPWR VGND sg13cmos5l_decap_8
XFILLER_204_193 VPWR VGND sg13cmos5l_decap_8
X_3853_ _3853_/X _3889_/X _3888_/X Tile_X0Y0_S2MID[0] Tile_X0Y0_S2END[0] _0963_/Q
+ _0962_/Q VPWR VGND sg13cmos5l_mux4_1
XFILLER_149_248 VPWR VGND sg13cmos5l_decap_8
XFILLER_149_259 VPWR VGND sg13cmos5l_fill_2
X_2804_ Tile_X0Y3_E2BEGb[2] _4158_/X VPWR VGND sg13cmos5l_buf_1
XFILLER_377_73 VPWR VGND sg13cmos5l_fill_2
X_3784_ _3784_/X Tile_X0Y0_W2MID[7] Tile_X0Y0_W2END[7] Tile_X0Y0_W6END[7] _3853_/X
+ _1169_/Q _1168_/Q VPWR VGND sg13cmos5l_mux4_1
XFILLER_594_49 VPWR VGND sg13cmos5l_decap_8
X_0996_ _0996_/Q Tile_X0Y0_FrameData[7] VGND VPWR Tile_X0Y9_FrameStrobe[1] latch
XFILLER_74_0 VPWR VGND sg13cmos5l_decap_8
XFILLER_527_21 VPWR VGND sg13cmos5l_decap_8
XFILLER_117_112 VPWR VGND sg13cmos5l_decap_4
X_2735_ _3978_/A3 VPWR VGND sg13cmos5l_tielo
XFILLER_380_126 VPWR VGND sg13cmos5l_decap_8
XFILLER_306_234 VPWR VGND sg13cmos5l_fill_2
XFILLER_246_22 VPWR VGND sg13cmos5l_decap_8
XFILLER_711_220 VPWR VGND sg13cmos5l_decap_8
XFILLER_522_131 VPWR VGND sg13cmos5l_decap_8
X_2666_ _2666_/Q Tile_X0Y6_FrameData[29] VGND VPWR Tile_X0Y9_FrameStrobe[7] latch
XFILLER_668_135 VPWR VGND sg13cmos5l_decap_8
XFILLER_393_61 VPWR VGND sg13cmos5l_fill_1
X_4405_ _4405_/X _0159_/X _0145_/X _4461_/X _4465_/X _2293_/Q _2292_/Q VPWR VGND sg13cmos5l_mux4_1
XFILLER_132_126 VPWR VGND sg13cmos5l_decap_8
X_1617_ _1617_/Q Tile_X0Y2_FrameData[0] VGND VPWR Tile_X0Y9_FrameStrobe[5] latch
XFILLER_711_264 VPWR VGND sg13cmos5l_fill_1
XFILLER_393_83 VPWR VGND sg13cmos5l_decap_8
XFILLER_132_137 VPWR VGND sg13cmos5l_fill_1
XFILLER_278_119 VPWR VGND sg13cmos5l_fill_2
X_2597_ _2597_/Q Tile_X0Y6_FrameData[2] VGND VPWR Tile_X0Y9_FrameStrobe[4] latch
XANTENNA__3207__X Tile_X0Y0_N2BEG[7] VPWR VGND sg13cmos5l_antennanp
XFILLER_132_159 VPWR VGND sg13cmos5l_decap_8
XFILLER_543_42 VPWR VGND sg13cmos5l_decap_8
X_4336_ _4336_/X _4302_/X _0099_/X _4301_/X _0112_/X _1981_/Q _1980_/Q VPWR VGND sg13cmos5l_mux4_1
XFILLER_5_91 VPWR VGND sg13cmos5l_fill_2
X_1548_ _1548_/Q Tile_X0Y2_FrameData[5] VGND VPWR Tile_X0Y9_FrameStrobe[3] latch
XFILLER_262_21 VPWR VGND sg13cmos5l_decap_8
XFILLER_690_92 VPWR VGND sg13cmos5l_decap_8
X_4267_ _4267_/X Tile_X0Y4_W2END[4] AXI_M_SOC_BRESP0 _4319_/X _4318_/X _2079_/Q _2078_/Q
+ VPWR VGND sg13cmos5l_mux4_1
X_1479_ _1479_/Q Tile_X0Y2_FrameData[10] VGND VPWR Tile_X0Y9_FrameStrobe[1] latch
XFILLER_435_105 VPWR VGND sg13cmos5l_decap_8
XFILLER_286_196 VPWR VGND sg13cmos5l_decap_8
XFILLER_262_76 VPWR VGND sg13cmos5l_decap_8
X_3218_ Tile_X0Y0_FrameStrobe_O[6] Tile_X0Y9_FrameStrobe[6] VPWR VGND sg13cmos5l_buf_1
X_4198_ _4198_/X _4195_/X Tile_X0Y3_W6END[0] _4194_/X _4198_/A3 _1681_/Q _1680_/Q
+ VPWR VGND sg13cmos5l_mux4_1
XFILLER_412_57 VPWR VGND sg13cmos5l_decap_8
X_3149_ Tile_X0Y7_FrameData_O[19] Tile_X0Y7_FrameData[19] VPWR VGND sg13cmos5l_buf_1
XFILLER_131_36 VPWR VGND sg13cmos5l_decap_8
XFILLER_632_260 VPWR VGND sg13cmos5l_fill_1
XFILLER_54_143 VPWR VGND sg13cmos5l_decap_8
XFILLER_632_271 VPWR VGND sg13cmos5l_fill_2
XFILLER_54_165 VPWR VGND sg13cmos5l_decap_8
XFILLER_488_28 VPWR VGND sg13cmos5l_decap_8
XFILLER_242_233 VPWR VGND sg13cmos5l_decap_8
XANTENNA__2781__X Tile_X0Y3_EE4BEG[7] VPWR VGND sg13cmos5l_antennanp
XFILLER_152_7 VPWR VGND sg13cmos5l_decap_8
XFILLER_202_119 VPWR VGND sg13cmos5l_decap_8
XFILLER_211_91 VPWR VGND sg13cmos5l_decap_8
XFILLER_24_56 VPWR VGND sg13cmos5l_fill_2
XFILLER_356_112 VPWR VGND sg13cmos5l_decap_8
XFILLER_155_207 VPWR VGND sg13cmos5l_decap_8
XFILLER_545_256 VPWR VGND sg13cmos5l_decap_8
XFILLER_417_7 VPWR VGND sg13cmos5l_decap_8
XFILLER_287_84 VPWR VGND sg13cmos5l_decap_8
XFILLER_10_257 VPWR VGND sg13cmos5l_decap_4
XFILLER_437_21 VPWR VGND sg13cmos5l_decap_8
XFILLER_6_217 VPWR VGND sg13cmos5l_decap_8
XFILLER_505_109 VPWR VGND sg13cmos5l_fill_2
XFILLER_6_228 VPWR VGND sg13cmos5l_fill_2
XFILLER_356_189 VPWR VGND sg13cmos5l_decap_8
XFILLER_108_112 VPWR VGND sg13cmos5l_decap_8
XFILLER_560_226 VPWR VGND sg13cmos5l_decap_8
XFILLER_371_148 VPWR VGND sg13cmos5l_decap_4
XFILLER_156_22 VPWR VGND sg13cmos5l_decap_8
XFILLER_659_102 VPWR VGND sg13cmos5l_decap_4
XFILLER_40_55 VPWR VGND sg13cmos5l_decap_8
XFILLER_40_66 VPWR VGND sg13cmos5l_fill_1
XFILLER_371_159 VPWR VGND sg13cmos5l_fill_2
XFILLER_702_242 VPWR VGND sg13cmos5l_decap_8
XFILLER_437_98 VPWR VGND sg13cmos5l_decap_8
XFILLER_108_189 VPWR VGND sg13cmos5l_decap_8
XFILLER_40_99 VPWR VGND sg13cmos5l_fill_2
XFILLER_156_77 VPWR VGND sg13cmos5l_decap_8
XFILLER_306_14 VPWR VGND sg13cmos5l_decap_8
XANTENNA__3117__X Tile_X0Y7_EE4BEG[3] VPWR VGND sg13cmos5l_antennanp
XFILLER_674_105 VPWR VGND sg13cmos5l_decap_8
XFILLER_453_42 VPWR VGND sg13cmos5l_fill_2
XFILLER_312_259 VPWR VGND sg13cmos5l_decap_4
XFILLER_172_21 VPWR VGND sg13cmos5l_decap_8
XFILLER_453_86 VPWR VGND sg13cmos5l_decap_8
XFILLER_277_152 VPWR VGND sg13cmos5l_decap_8
XANTENNA__2956__X Tile_X0Y8_EE4BEG[12] VPWR VGND sg13cmos5l_antennanp
XFILLER_426_105 VPWR VGND sg13cmos5l_decap_8
XFILLER_49_97 VPWR VGND sg13cmos5l_fill_1
XFILLER_481_200 VPWR VGND sg13cmos5l_decap_8
XFILLER_77_257 VPWR VGND sg13cmos5l_fill_1
XFILLER_603_56 VPWR VGND sg13cmos5l_decap_8
XFILLER_292_111 VPWR VGND sg13cmos5l_decap_8
XFILLER_105_70 VPWR VGND sg13cmos5l_decap_8
XFILLER_1_49 VPWR VGND sg13cmos5l_decap_8
XFILLER_615_249 VPWR VGND sg13cmos5l_decap_8
XFILLER_322_35 VPWR VGND sg13cmos5l_fill_2
XFILLER_276_0 VPWR VGND sg13cmos5l_decap_8
XFILLER_322_68 VPWR VGND sg13cmos5l_decap_4
XFILLER_65_63 VPWR VGND sg13cmos5l_decap_8
XFILLER_292_199 VPWR VGND sg13cmos5l_fill_2
XFILLER_623_260 VPWR VGND sg13cmos5l_decap_4
XFILLER_434_171 VPWR VGND sg13cmos5l_decap_8
XFILLER_379_204 VPWR VGND sg13cmos5l_decap_8
XFILLER_233_211 VPWR VGND sg13cmos5l_decap_4
XANTENNA_120 Tile_X0Y6_FrameData[30] VPWR VGND sg13cmos5l_antennanp
XFILLER_434_182 VPWR VGND sg13cmos5l_fill_1
XFILLER_398_28 VPWR VGND sg13cmos5l_decap_8
XFILLER_595_101 VPWR VGND sg13cmos5l_fill_1
XFILLER_45_165 VPWR VGND sg13cmos5l_decap_8
XANTENNA_131 Tile_X0Y6_FrameData[31] VPWR VGND sg13cmos5l_antennanp
XFILLER_60_102 VPWR VGND sg13cmos5l_decap_8
XANTENNA_142 Tile_X0Y6_FrameData[31] VPWR VGND sg13cmos5l_antennanp
XFILLER_443_0 VPWR VGND sg13cmos5l_decap_8
XANTENNA_153 Tile_X0Y9_FrameStrobe[17] VPWR VGND sg13cmos5l_antennanp
XANTENNA_164 Tile_X0Y9_FrameStrobe[8] VPWR VGND sg13cmos5l_antennanp
XANTENNA_175 Tile_X0Y9_FrameStrobe[8] VPWR VGND sg13cmos5l_antennanp
XFILLER_60_146 VPWR VGND sg13cmos5l_decap_8
XANTENNA_186 Tile_X0Y9_FrameStrobe[8] VPWR VGND sg13cmos5l_antennanp
XFILLER_121_91 VPWR VGND sg13cmos5l_decap_8
XFILLER_81_40 VPWR VGND sg13cmos5l_decap_8
XANTENNA_197 Tile_X0Y9_N2MID[2] VPWR VGND sg13cmos5l_antennanp
XFILLER_595_189 VPWR VGND sg13cmos5l_decap_8
XFILLER_347_112 VPWR VGND sg13cmos5l_decap_8
XFILLER_610_0 VPWR VGND sg13cmos5l_decap_8
XFILLER_708_0 VPWR VGND sg13cmos5l_decap_8
X_0850_ _0850_/Q Tile_X0Y9_FrameData[13] VGND VPWR Tile_X0Y9_FrameStrobe[5] latch
XFILLER_197_84 VPWR VGND sg13cmos5l_decap_4
XFILLER_628_64 VPWR VGND sg13cmos5l_decap_8
XFILLER_197_95 VPWR VGND sg13cmos5l_decap_8
XFILLER_347_21 VPWR VGND sg13cmos5l_decap_8
X_0781_ _0781_/Q Tile_X0Y9_FrameData[18] VGND VPWR Tile_X0Y9_FrameStrobe[3] latch
X_2520_ _2520_/Q Tile_X0Y6_FrameData[15] VGND VPWR Tile_X0Y9_FrameStrobe[2] latch
XFILLER_154_262 VPWR VGND sg13cmos5l_fill_1
XFILLER_347_98 VPWR VGND sg13cmos5l_decap_8
XFILLER_114_115 VPWR VGND sg13cmos5l_decap_8
XFILLER_5_272 VPWR VGND sg13cmos5l_fill_1
XFILLER_303_215 VPWR VGND sg13cmos5l_fill_1
XFILLER_114_126 VPWR VGND sg13cmos5l_fill_2
X_2451_ _2451_/Q Tile_X0Y6_FrameData[20] VGND VPWR Tile_X0Y9_FrameStrobe[0] latch
XFILLER_644_63 VPWR VGND sg13cmos5l_decap_8
XFILLER_449_208 VPWR VGND sg13cmos5l_decap_8
XFILLER_216_14 VPWR VGND sg13cmos5l_decap_8
XANTENNA__3027__X Tile_X0Y5_EE4BEG[2] VPWR VGND sg13cmos5l_antennanp
XFILLER_665_105 VPWR VGND sg13cmos5l_decap_8
XFILLER_370_192 VPWR VGND sg13cmos5l_decap_8
X_1402_ _1402_/Q Tile_X0Y1_FrameData[31] VGND VPWR Tile_X0Y9_FrameStrobe[7] latch
X_2382_ _2382_/Q Tile_X0Y5_FrameData[23] VGND VPWR Tile_X0Y9_FrameStrobe[6] latch
XFILLER_658_190 VPWR VGND sg13cmos5l_decap_8
X_4121_ _4121_/X _4091_/X _0064_/X _4090_/X Tile_X0Y0_S4END[9] _1471_/Q _1470_/Q VPWR
+ VGND sg13cmos5l_mux4_1
XFILLER_68_224 VPWR VGND sg13cmos5l_decap_8
XANTENNA__2866__X Tile_X0Y6_EE4BEG[3] VPWR VGND sg13cmos5l_antennanp
X_1333_ _1333_/Q Tile_X0Y1_FrameData[4] VGND VPWR Tile_X0Y9_FrameStrobe[4] latch
XFILLER_472_200 VPWR VGND sg13cmos5l_decap_4
XFILLER_417_105 VPWR VGND sg13cmos5l_decap_8
XFILLER_673_160 VPWR VGND sg13cmos5l_decap_8
XFILLER_472_211 VPWR VGND sg13cmos5l_decap_8
XFILLER_68_268 VPWR VGND sg13cmos5l_decap_4
XFILLER_513_56 VPWR VGND sg13cmos5l_decap_8
X_4052_ _4052_/X Tile_X0Y2_W2END[3] AXI_M_SOC_AWREADY _4103_/X _4102_/X _1569_/Q _1568_/Q
+ VPWR VGND sg13cmos5l_mux4_1
XFILLER_283_133 VPWR VGND sg13cmos5l_decap_8
X_1264_ _1264_/Q Tile_X0Y1_FrameData[9] VGND VPWR Tile_X0Y9_FrameStrobe[2] latch
XFILLER_660_84 VPWR VGND sg13cmos5l_decap_8
XFILLER_606_238 VPWR VGND sg13cmos5l_decap_8
XFILLER_83_216 VPWR VGND sg13cmos5l_decap_8
XFILLER_417_149 VPWR VGND sg13cmos5l_decap_4
X_3003_ Tile_X0Y5_E2BEG[6] _4378_/X VPWR VGND sg13cmos5l_buf_1
XFILLER_232_57 VPWR VGND sg13cmos5l_decap_8
X_0215_ _0215_/Q Tile_X0Y7_FrameData[8] VGND VPWR Tile_X0Y9_FrameStrobe[1] latch
XFILLER_36_121 VPWR VGND sg13cmos5l_decap_8
X_1195_ _1195_/Q Tile_X0Y1_FrameData[14] VGND VPWR Tile_X0Y9_FrameStrobe[0] latch
XFILLER_589_49 VPWR VGND sg13cmos5l_decap_8
XFILLER_432_119 VPWR VGND sg13cmos5l_decap_8
XFILLER_614_271 VPWR VGND sg13cmos5l_fill_2
XFILLER_224_233 VPWR VGND sg13cmos5l_fill_1
XFILLER_425_182 VPWR VGND sg13cmos5l_decap_8
X_0146_ AXI_M_SOC_ARCACHE3 _0929_/Q _3777_/X VPWR VGND sg13cmos5l_nor2b_1
XFILLER_586_112 VPWR VGND sg13cmos5l_fill_1
XANTENNA__3697__X AXI_M_SOC_WDATA7 VPWR VGND sg13cmos5l_antennanp
XFILLER_224_255 VPWR VGND sg13cmos5l_fill_2
XFILLER_669_60 VPWR VGND sg13cmos5l_decap_8
XFILLER_669_71 VPWR VGND sg13cmos5l_fill_1
XFILLER_101_28 VPWR VGND sg13cmos5l_decap_8
XFILLER_440_152 VPWR VGND sg13cmos5l_decap_4
X_0077_ _0077_/X _4792_/X _4793_/X _2119_/Q VPWR VGND sg13cmos5l_mux2_1
XFILLER_669_93 VPWR VGND sg13cmos5l_decap_8
XFILLER_440_185 VPWR VGND sg13cmos5l_decap_8
XFILLER_385_218 VPWR VGND sg13cmos5l_decap_8
X_3905_ _3905_/X _4015_/X _4019_/X _3996_/X _3995_/X _1392_/Q _1391_/Q VPWR VGND sg13cmos5l_mux4_1
X_4885_ _4885_/X AXI_M_SOC_RDATA1 _4922_/X _4926_/X _4903_/X _0773_/Q _0772_/Q VPWR
+ VGND sg13cmos5l_mux4_1
XFILLER_538_42 VPWR VGND sg13cmos5l_decap_8
XFILLER_393_240 VPWR VGND sg13cmos5l_decap_8
X_3836_ _3836_/X _0067_/X Tile_X0Y0_S4END[0] _3864_/X _3863_/X _1033_/Q _1032_/Q VPWR
+ VGND sg13cmos5l_mux4_1
XFILLER_137_218 VPWR VGND sg13cmos5l_decap_8
XFILLER_257_21 VPWR VGND sg13cmos5l_decap_8
X_3767_ _3767_/X Tile_X0Y1_WW4END[0] Tile_X0Y1_WW4END[8] Tile_X0Y1_W6END[8] _4016_/X
+ _1241_/Q _1240_/Q VPWR VGND sg13cmos5l_mux4_1
XFILLER_542_226 VPWR VGND sg13cmos5l_decap_8
XFILLER_499_119 VPWR VGND sg13cmos5l_decap_8
XFILLER_353_126 VPWR VGND sg13cmos5l_decap_8
X_0979_ _0979_/Q Tile_X0Y0_FrameData[24] VGND VPWR Tile_X0Y9_FrameStrobe[1] latch
X_2718_ _4774_/A3 VPWR VGND sg13cmos5l_tielo
XFILLER_10_14 VPWR VGND sg13cmos5l_decap_8
X_3698_ AXI_M_SOC_WDATA8 Tile_X0Y7_WW4END[0] Tile_X0Y7_WW4END[8] Tile_X0Y7_W6END[8]
+ _4692_/X _0231_/Q _0230_/Q VPWR VGND sg13cmos5l_mux4_1
XFILLER_407_35 VPWR VGND sg13cmos5l_decap_8
XFILLER_105_126 VPWR VGND sg13cmos5l_fill_1
XFILLER_554_63 VPWR VGND sg13cmos5l_decap_8
XFILLER_126_14 VPWR VGND sg13cmos5l_decap_8
X_2649_ _2649_/Q Tile_X0Y6_FrameData[14] VGND VPWR Tile_X0Y9_FrameStrobe[6] latch
XFILLER_510_112 VPWR VGND sg13cmos5l_decap_8
XFILLER_273_42 VPWR VGND sg13cmos5l_decap_8
XFILLER_656_127 VPWR VGND sg13cmos5l_decap_8
XANTENNA__2776__X Tile_X0Y3_EE4BEG[2] VPWR VGND sg13cmos5l_antennanp
XFILLER_704_77 VPWR VGND sg13cmos5l_decap_8
X_4319_ _4319_/X _4243_/X _4359_/X _4358_/X _4242_/X _1943_/Q _1942_/Q VPWR VGND sg13cmos5l_mux4_1
XFILLER_59_235 VPWR VGND sg13cmos5l_fill_2
XFILLER_448_263 VPWR VGND sg13cmos5l_fill_2
XFILLER_259_163 VPWR VGND sg13cmos5l_decap_4
XFILLER_274_100 VPWR VGND sg13cmos5l_decap_8
XFILLER_408_116 VPWR VGND sg13cmos5l_decap_8
XFILLER_206_91 VPWR VGND sg13cmos5l_decap_8
XFILLER_423_56 VPWR VGND sg13cmos5l_decap_8
XFILLER_19_45 VPWR VGND sg13cmos5l_decap_4
XFILLER_463_233 VPWR VGND sg13cmos5l_decap_8
XFILLER_142_35 VPWR VGND sg13cmos5l_decap_8
XFILLER_570_84 VPWR VGND sg13cmos5l_decap_8
XFILLER_374_8 VPWR VGND sg13cmos5l_decap_8
XFILLER_463_255 VPWR VGND sg13cmos5l_decap_8
XFILLER_274_166 VPWR VGND sg13cmos5l_decap_8
XFILLER_74_249 VPWR VGND sg13cmos5l_fill_2
XFILLER_423_119 VPWR VGND sg13cmos5l_decap_8
XFILLER_499_49 VPWR VGND sg13cmos5l_decap_8
XFILLER_42_113 VPWR VGND sg13cmos5l_fill_2
XFILLER_534_7 VPWR VGND sg13cmos5l_decap_8
XFILLER_230_214 VPWR VGND sg13cmos5l_decap_8
XFILLER_620_263 VPWR VGND sg13cmos5l_decap_8
XANTENNA__3400__X Tile_X0Y2_E2BEG[3] VPWR VGND sg13cmos5l_antennanp
XFILLER_577_178 VPWR VGND sg13cmos5l_decap_8
XFILLER_431_196 VPWR VGND sg13cmos5l_fill_2
XFILLER_35_99 VPWR VGND sg13cmos5l_decap_4
XFILLER_518_201 VPWR VGND sg13cmos5l_decap_8
XFILLER_230_258 VPWR VGND sg13cmos5l_fill_1
XFILLER_701_7 VPWR VGND sg13cmos5l_decap_8
XFILLER_518_234 VPWR VGND sg13cmos5l_decap_8
XFILLER_51_32 VPWR VGND sg13cmos5l_decap_8
XFILLER_448_42 VPWR VGND sg13cmos5l_decap_8
XFILLER_329_145 VPWR VGND sg13cmos5l_decap_8
XFILLER_167_21 VPWR VGND sg13cmos5l_decap_8
XFILLER_344_104 VPWR VGND sg13cmos5l_decap_4
XFILLER_51_76 VPWR VGND sg13cmos5l_fill_2
XFILLER_344_126 VPWR VGND sg13cmos5l_decap_8
XFILLER_533_248 VPWR VGND sg13cmos5l_decap_8
XFILLER_167_98 VPWR VGND sg13cmos5l_decap_8
XFILLER_681_28 VPWR VGND sg13cmos5l_decap_8
XFILLER_464_63 VPWR VGND sg13cmos5l_decap_8
XFILLER_501_112 VPWR VGND sg13cmos5l_decap_8
XFILLER_464_74 VPWR VGND sg13cmos5l_fill_2
XFILLER_297_214 VPWR VGND sg13cmos5l_fill_1
XFILLER_647_105 VPWR VGND sg13cmos5l_decap_8
XFILLER_4_0 VPWR VGND sg13cmos5l_decap_8
XFILLER_297_236 VPWR VGND sg13cmos5l_decap_4
XFILLER_498_196 VPWR VGND sg13cmos5l_decap_8
XFILLER_300_207 VPWR VGND sg13cmos5l_decap_8
XFILLER_297_258 VPWR VGND sg13cmos5l_fill_2
XFILLER_111_118 VPWR VGND sg13cmos5l_decap_8
XFILLER_393_0 VPWR VGND sg13cmos5l_decap_4
XFILLER_183_97 VPWR VGND sg13cmos5l_decap_8
XFILLER_501_189 VPWR VGND sg13cmos5l_decap_8
XFILLER_614_77 VPWR VGND sg13cmos5l_decap_8
XFILLER_454_222 VPWR VGND sg13cmos5l_decap_8
XFILLER_454_233 VPWR VGND sg13cmos5l_decap_8
XFILLER_333_78 VPWR VGND sg13cmos5l_decap_4
XFILLER_630_21 VPWR VGND sg13cmos5l_decap_8
XFILLER_560_0 VPWR VGND sg13cmos5l_decap_8
XFILLER_333_89 VPWR VGND sg13cmos5l_fill_2
XFILLER_65_238 VPWR VGND sg13cmos5l_decap_8
XFILLER_658_0 VPWR VGND sg13cmos5l_decap_8
XFILLER_414_108 VPWR VGND sg13cmos5l_decap_8
XFILLER_603_208 VPWR VGND sg13cmos5l_decap_8
XFILLER_18_143 VPWR VGND sg13cmos5l_decap_8
XFILLER_670_185 VPWR VGND sg13cmos5l_decap_8
XFILLER_280_147 VPWR VGND sg13cmos5l_decap_8
XFILLER_18_165 VPWR VGND sg13cmos5l_decap_4
XFILLER_202_49 VPWR VGND sg13cmos5l_decap_8
XFILLER_73_260 VPWR VGND sg13cmos5l_fill_2
XFILLER_630_98 VPWR VGND sg13cmos5l_decap_8
XFILLER_73_271 VPWR VGND sg13cmos5l_fill_2
XFILLER_568_112 VPWR VGND sg13cmos5l_decap_8
XFILLER_18_198 VPWR VGND sg13cmos5l_decap_8
XFILLER_33_124 VPWR VGND sg13cmos5l_decap_8
XANTENNA__3310__X Tile_X0Y0_E1BEG[2] VPWR VGND sg13cmos5l_antennanp
XFILLER_178_107 VPWR VGND sg13cmos5l_decap_8
XFILLER_717_109 VPWR VGND sg13cmos5l_decap_4
XFILLER_568_189 VPWR VGND sg13cmos5l_decap_8
X_1951_ _1951_/Q Tile_X0Y4_FrameData[6] VGND VPWR Tile_X0Y9_FrameStrobe[0] latch
XFILLER_639_63 VPWR VGND sg13cmos5l_decap_8
XFILLER_583_137 VPWR VGND sg13cmos5l_decap_4
X_0902_ _0902_/Q Tile_X0Y9_FrameData[25] VGND VPWR Tile_X0Y9_FrameStrobe[7] latch
XFILLER_375_240 VPWR VGND sg13cmos5l_decap_8
XFILLER_358_42 VPWR VGND sg13cmos5l_decap_8
XFILLER_186_151 VPWR VGND sg13cmos5l_decap_8
X_4670_ _4670_/X _4597_/X _4713_/X _4712_/X _4596_/X _0171_/Q _0170_/Q VPWR VGND sg13cmos5l_mux4_1
XFILLER_119_207 VPWR VGND sg13cmos5l_decap_8
X_1882_ _1882_/Q Tile_X0Y3_FrameData[15] VGND VPWR Tile_X0Y9_FrameStrobe[6] latch
X_3621_ Tile_X0Y9_S2BEGb[7] _4939_/X VPWR VGND sg13cmos5l_buf_1
X_0833_ _0833_/Q Tile_X0Y9_FrameData[30] VGND VPWR Tile_X0Y9_FrameStrobe[5] latch
XFILLER_335_126 VPWR VGND sg13cmos5l_decap_8
XFILLER_390_221 VPWR VGND sg13cmos5l_fill_2
XFILLER_508_56 VPWR VGND sg13cmos5l_decap_8
X_3552_ Tile_X0Y9_E6BEG[10] _4890_/X VPWR VGND sg13cmos5l_buf_1
X_0764_ _0764_/Q Tile_X0Y9_FrameData[3] VGND VPWR Tile_X0Y9_FrameStrobe[2] latch
X_2503_ _2503_/Q Tile_X0Y6_FrameData[0] VGND VPWR Tile_X0Y9_FrameStrobe[1] latch
XFILLER_227_57 VPWR VGND sg13cmos5l_decap_8
XFILLER_678_252 VPWR VGND sg13cmos5l_decap_4
XFILLER_591_28 VPWR VGND sg13cmos5l_decap_8
XFILLER_374_63 VPWR VGND sg13cmos5l_decap_4
X_3483_ Tile_X0Y1_EE4BEG[9] _3957_/X VPWR VGND sg13cmos5l_buf_1
XFILLER_489_163 VPWR VGND sg13cmos5l_decap_8
X_0695_ _0695_/Q Tile_X0Y9_FrameData[8] VGND VPWR Tile_X0Y9_FrameStrobe[0] latch
XFILLER_638_105 VPWR VGND sg13cmos5l_decap_8
XFILLER_142_254 VPWR VGND sg13cmos5l_decap_8
X_2434_ _2434_/Q Tile_X0Y5_FrameData[3] VGND VPWR Tile_X0Y9_FrameStrobe[7] latch
XFILLER_671_61 VPWR VGND sg13cmos5l_decap_8
XFILLER_37_0 VPWR VGND sg13cmos5l_fill_2
XFILLER_307_90 VPWR VGND sg13cmos5l_decap_8
X_2365_ _2365_/Q Tile_X0Y5_FrameData[8] VGND VPWR Tile_X0Y9_FrameStrobe[5] latch
XFILLER_653_119 VPWR VGND sg13cmos5l_decap_8
X_4104_ _4104_/X _4095_/X _0094_/X _4094_/X Tile_X0Y0_S4END[11] _1451_/Q _1450_/Q
+ VPWR VGND sg13cmos5l_mux4_1
X_1316_ _1316_/Q Tile_X0Y1_FrameData[21] VGND VPWR Tile_X0Y9_FrameStrobe[4] latch
XFILLER_646_182 VPWR VGND sg13cmos5l_decap_8
XFILLER_256_133 VPWR VGND sg13cmos5l_decap_8
X_2296_ _2296_/Q Tile_X0Y5_FrameData[13] VGND VPWR Tile_X0Y9_FrameStrobe[3] latch
XFILLER_243_89 VPWR VGND sg13cmos5l_decap_8
XFILLER_56_227 VPWR VGND sg13cmos5l_fill_1
XFILLER_540_21 VPWR VGND sg13cmos5l_decap_8
XFILLER_2_70 VPWR VGND sg13cmos5l_decap_8
X_4035_ _4035_/X Tile_X0Y3_W2MID[0] Tile_X0Y3_W2END[0] Tile_X0Y3_W6END[0] _4204_/X
+ _1903_/Q _1902_/Q VPWR VGND sg13cmos5l_mux4_1
X_1247_ _1247_/Q Tile_X0Y1_FrameData[26] VGND VPWR Tile_X0Y9_FrameStrobe[2] latch
XFILLER_540_87 VPWR VGND sg13cmos5l_fill_2
XFILLER_112_49 VPWR VGND sg13cmos5l_fill_2
X_1178_ _1178_/Q Tile_X0Y0_FrameData[31] VGND VPWR Tile_X0Y9_FrameStrobe[0] latch
XFILLER_559_112 VPWR VGND sg13cmos5l_decap_8
XFILLER_64_271 VPWR VGND sg13cmos5l_fill_2
XFILLER_399_60 VPWR VGND sg13cmos5l_fill_1
XFILLER_602_241 VPWR VGND sg13cmos5l_decap_8
XFILLER_212_203 VPWR VGND sg13cmos5l_decap_8
X_0129_ _3636_/A _4840_/X _4841_/X _0859_/Q VPWR VGND sg13cmos5l_mux2_1
XANTENNA__3220__X Tile_X0Y0_FrameStrobe_O[8] VPWR VGND sg13cmos5l_antennanp
XFILLER_559_178 VPWR VGND sg13cmos5l_decap_8
X_4937_ _4937_/X Tile_X0Y8_W1END[1] Tile_X0Y8_W2MID[2] Tile_X0Y8_W2END[2] _4788_/X
+ _0617_/Q _0616_/Q VPWR VGND sg13cmos5l_mux4_1
XFILLER_574_126 VPWR VGND sg13cmos5l_decap_8
XFILLER_549_63 VPWR VGND sg13cmos5l_decap_8
XFILLER_696_91 VPWR VGND sg13cmos5l_decap_8
XFILLER_268_42 VPWR VGND sg13cmos5l_decap_8
XANTENNA_20 AXI_M_SOC_RDATA26 VPWR VGND sg13cmos5l_antennanp
XANTENNA_31 AXI_M_SOC_RDATA26 VPWR VGND sg13cmos5l_antennanp
X_4868_ _4868_/X Tile_X0Y9_WW4END[11] AXI_M_SOC_RDATA4 _4927_/X _4907_/X _0807_/Q
+ _0806_/Q VPWR VGND sg13cmos5l_mux4_1
XANTENNA_42 AXI_M_SOC_RDATA8 VPWR VGND sg13cmos5l_antennanp
XANTENNA_53 Tile_X0Y0_FrameData[25] VPWR VGND sg13cmos5l_antennanp
XANTENNA_64 Tile_X0Y0_S2MID[0] VPWR VGND sg13cmos5l_antennanp
XANTENNA_75 Tile_X0Y0_S4END[14] VPWR VGND sg13cmos5l_antennanp
X_3819_ _3819_/X Tile_X0Y0_W2END[0] _3853_/X _3852_/X _3861_/X _1067_/Q _1066_/Q VPWR
+ VGND sg13cmos5l_mux4_1
XFILLER_326_126 VPWR VGND sg13cmos5l_decap_4
XFILLER_381_232 VPWR VGND sg13cmos5l_decap_8
XANTENNA_86 Tile_X0Y0_S4END[14] VPWR VGND sg13cmos5l_antennanp
X_4799_ _4799_/X _4343_/X _4347_/X _4351_/X _4312_/X _2112_/Q _2111_/Q VPWR VGND sg13cmos5l_mux4_1
XANTENNA_97 Tile_X0Y3_W1END[3] VPWR VGND sg13cmos5l_antennanp
XFILLER_21_35 VPWR VGND sg13cmos5l_decap_8
XFILLER_418_56 VPWR VGND sg13cmos5l_decap_8
XFILLER_21_46 VPWR VGND sg13cmos5l_fill_1
XFILLER_515_259 VPWR VGND sg13cmos5l_fill_2
XFILLER_115_7 VPWR VGND sg13cmos5l_decap_8
XFILLER_21_68 VPWR VGND sg13cmos5l_decap_8
XFILLER_565_84 VPWR VGND sg13cmos5l_decap_8
XFILLER_341_107 VPWR VGND sg13cmos5l_decap_8
XFILLER_137_35 VPWR VGND sg13cmos5l_decap_8
XFILLER_715_21 VPWR VGND sg13cmos5l_decap_8
XFILLER_192_198 VPWR VGND sg13cmos5l_fill_2
XFILLER_284_63 VPWR VGND sg13cmos5l_decap_8
XFILLER_629_105 VPWR VGND sg13cmos5l_decap_8
XFILLER_97_28 VPWR VGND sg13cmos5l_decap_8
XFILLER_629_138 VPWR VGND sg13cmos5l_decap_8
XFILLER_495_133 VPWR VGND sg13cmos5l_decap_8
XFILLER_715_98 VPWR VGND sg13cmos5l_decap_8
XFILLER_434_77 VPWR VGND sg13cmos5l_decap_8
XFILLER_644_119 VPWR VGND sg13cmos5l_decap_8
XFILLER_484_7 VPWR VGND sg13cmos5l_decap_8
XFILLER_247_100 VPWR VGND sg13cmos5l_decap_8
XFILLER_153_78 VPWR VGND sg13cmos5l_decap_8
XFILLER_436_244 VPWR VGND sg13cmos5l_decap_8
XFILLER_652_130 VPWR VGND sg13cmos5l_fill_2
XFILLER_450_21 VPWR VGND sg13cmos5l_decap_8
XFILLER_303_15 VPWR VGND sg13cmos5l_decap_8
XFILLER_47_238 VPWR VGND sg13cmos5l_decap_4
XFILLER_651_7 VPWR VGND sg13cmos5l_decap_8
XFILLER_451_214 VPWR VGND sg13cmos5l_decap_8
XFILLER_46_43 VPWR VGND sg13cmos5l_decap_4
XFILLER_262_125 VPWR VGND sg13cmos5l_decap_8
XFILLER_652_185 VPWR VGND sg13cmos5l_fill_2
XFILLER_597_218 VPWR VGND sg13cmos5l_decap_4
XFILLER_46_54 VPWR VGND sg13cmos5l_decap_8
XFILLER_55_260 VPWR VGND sg13cmos5l_fill_1
XFILLER_600_35 VPWR VGND sg13cmos5l_decap_8
XFILLER_55_271 VPWR VGND sg13cmos5l_fill_2
XFILLER_451_269 VPWR VGND sg13cmos5l_decap_4
XANTENNA__3130__X Tile_X0Y7_FrameData_O[0] VPWR VGND sg13cmos5l_antennanp
XFILLER_349_229 VPWR VGND sg13cmos5l_decap_8
XFILLER_270_191 VPWR VGND sg13cmos5l_decap_8
XFILLER_30_105 VPWR VGND sg13cmos5l_decap_8
XFILLER_676_28 VPWR VGND sg13cmos5l_decap_8
XFILLER_565_126 VPWR VGND sg13cmos5l_decap_8
XFILLER_459_63 VPWR VGND sg13cmos5l_decap_8
XFILLER_141_0 VPWR VGND sg13cmos5l_decap_8
XFILLER_62_75 VPWR VGND sg13cmos5l_decap_8
XFILLER_30_149 VPWR VGND sg13cmos5l_decap_4
XFILLER_239_0 VPWR VGND sg13cmos5l_decap_8
XFILLER_178_53 VPWR VGND sg13cmos5l_decap_8
XFILLER_707_131 VPWR VGND sg13cmos5l_decap_4
XFILLER_23_190 VPWR VGND sg13cmos5l_fill_1
XFILLER_178_64 VPWR VGND sg13cmos5l_fill_1
XFILLER_395_29 VPWR VGND sg13cmos5l_decap_8
XFILLER_317_104 VPWR VGND sg13cmos5l_decap_8
XFILLER_178_86 VPWR VGND sg13cmos5l_decap_8
XFILLER_372_221 VPWR VGND sg13cmos5l_decap_8
XFILLER_317_126 VPWR VGND sg13cmos5l_decap_8
XFILLER_183_132 VPWR VGND sg13cmos5l_decap_8
XFILLER_707_197 VPWR VGND sg13cmos5l_decap_8
XFILLER_406_0 VPWR VGND sg13cmos5l_decap_8
XFILLER_475_73 VPWR VGND sg13cmos5l_decap_8
XFILLER_183_187 VPWR VGND sg13cmos5l_decap_8
XFILLER_625_21 VPWR VGND sg13cmos5l_decap_8
XFILLER_521_218 VPWR VGND sg13cmos5l_fill_1
XFILLER_124_210 VPWR VGND sg13cmos5l_decap_8
XFILLER_124_232 VPWR VGND sg13cmos5l_decap_8
XFILLER_675_200 VPWR VGND sg13cmos5l_decap_8
XFILLER_194_96 VPWR VGND sg13cmos5l_decap_8
X_0480_ _0480_/Q Tile_X0Y8_FrameData[31] VGND VPWR Tile_X0Y9_FrameStrobe[2] latch
XFILLER_625_98 VPWR VGND sg13cmos5l_decap_8
XFILLER_340_162 VPWR VGND sg13cmos5l_decap_8
XFILLER_87_50 VPWR VGND sg13cmos5l_decap_8
XFILLER_30_7 VPWR VGND sg13cmos5l_decap_8
XFILLER_285_217 VPWR VGND sg13cmos5l_decap_8
XFILLER_635_119 VPWR VGND sg13cmos5l_decap_8
XANTENNA__3305__X Tile_X0Y0_E2BEG[5] VPWR VGND sg13cmos5l_antennanp
XFILLER_690_225 VPWR VGND sg13cmos5l_decap_8
XFILLER_690_236 VPWR VGND sg13cmos5l_fill_1
XFILLER_641_42 VPWR VGND sg13cmos5l_decap_8
X_2150_ _2150_/Q Tile_X0Y4_FrameData[31] VGND VPWR Tile_X0Y9_FrameStrobe[7] latch
XFILLER_628_193 VPWR VGND sg13cmos5l_decap_4
XFILLER_38_216 VPWR VGND sg13cmos5l_decap_4
XFILLER_690_258 VPWR VGND sg13cmos5l_decap_8
XFILLER_360_21 VPWR VGND sg13cmos5l_decap_8
X_1101_ _1101_/Q Tile_X0Y0_FrameData[30] VGND VPWR Tile_X0Y9_FrameStrobe[5] latch
XFILLER_293_272 VPWR VGND sg13cmos5l_fill_1
X_2081_ _2081_/Q Tile_X0Y4_FrameData[4] VGND VPWR Tile_X0Y9_FrameStrobe[4] latch
XFILLER_238_188 VPWR VGND sg13cmos5l_decap_4
XFILLER_238_199 VPWR VGND sg13cmos5l_decap_8
X_1032_ _1032_/Q Tile_X0Y0_FrameData[3] VGND VPWR Tile_X0Y9_FrameStrobe[2] latch
XFILLER_643_196 VPWR VGND sg13cmos5l_decap_8
XFILLER_588_229 VPWR VGND sg13cmos5l_decap_8
XFILLER_46_260 VPWR VGND sg13cmos5l_decap_8
XFILLER_510_35 VPWR VGND sg13cmos5l_decap_8
XFILLER_46_271 VPWR VGND sg13cmos5l_fill_2
XFILLER_596_240 VPWR VGND sg13cmos5l_decap_8
XANTENNA__3040__X Tile_X0Y5_EE4BEG[15] VPWR VGND sg13cmos5l_antennanp
XFILLER_261_191 VPWR VGND sg13cmos5l_decap_4
XFILLER_586_28 VPWR VGND sg13cmos5l_decap_8
XFILLER_410_133 VPWR VGND sg13cmos5l_decap_8
XFILLER_369_63 VPWR VGND sg13cmos5l_decap_8
X_2983_ Tile_X0Y8_FrameData_O[23] Tile_X0Y8_FrameData[23] VPWR VGND sg13cmos5l_buf_1
X_4722_ _4722_/X Tile_X0Y8_W1END[3] Tile_X0Y8_WW4END[15] Tile_X0Y8_W6END[7] _4803_/X
+ _0602_/Q _0601_/Q VPWR VGND sg13cmos5l_mux4_1
X_1934_ _1934_/Q Tile_X0Y4_FrameData[23] VGND VPWR Tile_X0Y9_FrameStrobe[0] latch
XFILLER_159_173 VPWR VGND sg13cmos5l_decap_8
XFILLER_308_115 VPWR VGND sg13cmos5l_decap_8
X_1865_ _1865_/Q Tile_X0Y3_FrameData[0] VGND VPWR Tile_X0Y9_FrameStrobe[5] latch
X_4653_ _4653_/X AXI_M_SOC_RDATA21 _4686_/X _4690_/X _4672_/X _0253_/Q _0252_/Q VPWR
+ VGND sg13cmos5l_mux4_1
XFILLER_564_181 VPWR VGND sg13cmos5l_fill_2
XFILLER_174_165 VPWR VGND sg13cmos5l_decap_8
XFILLER_713_145 VPWR VGND sg13cmos5l_decap_8
X_0816_ _0816_/Q Tile_X0Y9_FrameData[15] VGND VPWR Tile_X0Y9_FrameStrobe[4] latch
X_3604_ Tile_X0Y9_S1BEG[2] _4826_/X VPWR VGND sg13cmos5l_buf_1
X_1796_ _1796_/Q Tile_X0Y3_FrameData[5] VGND VPWR Tile_X0Y9_FrameStrobe[3] latch
X_4584_ _4584_/X Tile_X0Y5_W2MID[7] Tile_X0Y5_W2END[7] Tile_X0Y5_W6END[8] _4467_/X
+ _2395_/Q _2394_/Q VPWR VGND sg13cmos5l_mux4_1
XFILLER_535_21 VPWR VGND sg13cmos5l_decap_8
XFILLER_323_118 VPWR VGND sg13cmos5l_decap_8
XFILLER_713_189 VPWR VGND sg13cmos5l_fill_1
X_0747_ _0747_/Q Tile_X0Y9_FrameData[20] VGND VPWR Tile_X0Y9_FrameStrobe[2] latch
X_3535_ Tile_X0Y9_E2BEGb[1] _4857_/X VPWR VGND sg13cmos5l_buf_1
XFILLER_477_100 VPWR VGND sg13cmos5l_decap_4
XFILLER_477_111 VPWR VGND sg13cmos5l_decap_8
X_3466_ Tile_X0Y1_FrameData_O[24] Tile_X0Y1_FrameData[24] VPWR VGND sg13cmos5l_buf_1
X_0678_ _0678_/Q Tile_X0Y9_FrameData[25] VGND VPWR Tile_X0Y9_FrameStrobe[0] latch
XFILLER_331_173 VPWR VGND sg13cmos5l_decap_8
XFILLER_130_224 VPWR VGND sg13cmos5l_decap_8
X_2417_ _2417_/Q Tile_X0Y5_FrameData[20] VGND VPWR Tile_X0Y9_FrameStrobe[7] latch
XFILLER_404_14 VPWR VGND sg13cmos5l_decap_8
XFILLER_331_195 VPWR VGND sg13cmos5l_decap_8
X_3397_ Tile_X0Y2_E2BEG[0] _4040_/X VPWR VGND sg13cmos5l_buf_1
XFILLER_681_214 VPWR VGND sg13cmos5l_decap_8
XANTENNA__3215__X Tile_X0Y0_FrameStrobe_O[3] VPWR VGND sg13cmos5l_antennanp
XFILLER_551_42 VPWR VGND sg13cmos5l_decap_8
XFILLER_492_147 VPWR VGND sg13cmos5l_decap_8
X_2348_ _2348_/Q Tile_X0Y5_FrameData[25] VGND VPWR Tile_X0Y9_FrameStrobe[5] latch
XFILLER_270_21 VPWR VGND sg13cmos5l_decap_8
XFILLER_96_193 VPWR VGND sg13cmos5l_decap_8
X_2279_ _2279_/Q Tile_X0Y5_FrameData[30] VGND VPWR Tile_X0Y9_FrameStrobe[3] latch
XFILLER_701_56 VPWR VGND sg13cmos5l_decap_8
XFILLER_579_218 VPWR VGND sg13cmos5l_decap_8
X_4018_ _4018_/X _3985_/X _0095_/X _3984_/X Tile_X0Y0_S4END[6] _1213_/Q _1212_/Q VPWR
+ VGND sg13cmos5l_mux4_1
XFILLER_37_271 VPWR VGND sg13cmos5l_fill_2
XFILLER_203_70 VPWR VGND sg13cmos5l_decap_8
XFILLER_420_35 VPWR VGND sg13cmos5l_decap_8
XFILLER_16_35 VPWR VGND sg13cmos5l_decap_8
XFILLER_398_162 VPWR VGND sg13cmos5l_decap_4
XFILLER_197_224 VPWR VGND sg13cmos5l_decap_8
XFILLER_547_115 VPWR VGND sg13cmos5l_decap_8
XFILLER_496_28 VPWR VGND sg13cmos5l_decap_8
XFILLER_279_63 VPWR VGND sg13cmos5l_decap_8
XFILLER_401_155 VPWR VGND sg13cmos5l_decap_8
XFILLER_197_268 VPWR VGND sg13cmos5l_decap_4
XFILLER_401_199 VPWR VGND sg13cmos5l_decap_8
XFILLER_354_210 VPWR VGND sg13cmos5l_decap_8
XFILLER_429_77 VPWR VGND sg13cmos5l_decap_8
XFILLER_32_67 VPWR VGND sg13cmos5l_fill_1
XFILLER_704_112 VPWR VGND sg13cmos5l_decap_4
XFILLER_704_123 VPWR VGND sg13cmos5l_decap_8
XFILLER_148_56 VPWR VGND sg13cmos5l_decap_8
XFILLER_570_140 VPWR VGND sg13cmos5l_decap_8
XFILLER_295_73 VPWR VGND sg13cmos5l_fill_1
XFILLER_445_21 VPWR VGND sg13cmos5l_decap_8
XFILLER_468_100 VPWR VGND sg13cmos5l_fill_2
XFILLER_106_254 VPWR VGND sg13cmos5l_decap_8
XFILLER_164_22 VPWR VGND sg13cmos5l_decap_8
XFILLER_657_222 VPWR VGND sg13cmos5l_decap_8
XFILLER_79_105 VPWR VGND sg13cmos5l_decap_8
XFILLER_657_233 VPWR VGND sg13cmos5l_fill_2
XANTENNA__3125__X Tile_X0Y7_EE4BEG[11] VPWR VGND sg13cmos5l_antennanp
XFILLER_314_36 VPWR VGND sg13cmos5l_decap_8
XFILLER_461_42 VPWR VGND sg13cmos5l_decap_8
XFILLER_672_258 VPWR VGND sg13cmos5l_fill_2
XFILLER_180_21 VPWR VGND sg13cmos5l_decap_8
XFILLER_275_250 VPWR VGND sg13cmos5l_fill_2
XFILLER_275_261 VPWR VGND sg13cmos5l_fill_1
XFILLER_87_193 VPWR VGND sg13cmos5l_decap_8
XANTENNA__2964__X Tile_X0Y8_FrameData_O[4] VPWR VGND sg13cmos5l_antennanp
XFILLER_189_0 VPWR VGND sg13cmos5l_decap_8
XFILLER_424_203 VPWR VGND sg13cmos5l_decap_8
XFILLER_611_56 VPWR VGND sg13cmos5l_decap_8
XFILLER_640_133 VPWR VGND sg13cmos5l_decap_8
XFILLER_424_258 VPWR VGND sg13cmos5l_fill_2
XFILLER_113_70 VPWR VGND sg13cmos5l_decap_8
XFILLER_235_169 VPWR VGND sg13cmos5l_decap_8
XFILLER_250_106 VPWR VGND sg13cmos5l_decap_8
XFILLER_356_0 VPWR VGND sg13cmos5l_decap_8
XFILLER_73_63 VPWR VGND sg13cmos5l_decap_4
XFILLER_389_162 VPWR VGND sg13cmos5l_decap_8
XFILLER_43_252 VPWR VGND sg13cmos5l_decap_8
XFILLER_188_224 VPWR VGND sg13cmos5l_decap_8
XFILLER_189_52 VPWR VGND sg13cmos5l_decap_8
XFILLER_523_0 VPWR VGND sg13cmos5l_decap_8
XFILLER_593_254 VPWR VGND sg13cmos5l_decap_8
XFILLER_339_66 VPWR VGND sg13cmos5l_decap_8
XFILLER_78_7 VPWR VGND sg13cmos5l_decap_8
XFILLER_636_42 VPWR VGND sg13cmos5l_decap_8
X_1650_ _1650_/Q Tile_X0Y2_FrameData[31] VGND VPWR Tile_X0Y9_FrameStrobe[7] latch
XFILLER_561_140 VPWR VGND sg13cmos5l_decap_4
XFILLER_7_164 VPWR VGND sg13cmos5l_decap_8
XFILLER_355_21 VPWR VGND sg13cmos5l_decap_8
X_0601_ _0601_/Q Tile_X0Y8_FrameData[6] VGND VPWR Tile_X0Y9_FrameStrobe[5] latch
XFILLER_710_104 VPWR VGND sg13cmos5l_decap_8
X_1581_ _1581_/Q Tile_X0Y2_FrameData[4] VGND VPWR Tile_X0Y9_FrameStrobe[4] latch
XFILLER_459_111 VPWR VGND sg13cmos5l_decap_8
X_3320_ Tile_X0Y4_EE4BEG[8] _4280_/X VPWR VGND sg13cmos5l_buf_1
X_0532_ _0532_/Q Tile_X0Y8_FrameData[11] VGND VPWR Tile_X0Y9_FrameStrobe[3] latch
XFILLER_710_159 VPWR VGND sg13cmos5l_decap_8
XFILLER_355_98 VPWR VGND sg13cmos5l_decap_8
XFILLER_648_244 VPWR VGND sg13cmos5l_decap_8
XFILLER_505_35 VPWR VGND sg13cmos5l_decap_8
XFILLER_313_173 VPWR VGND sg13cmos5l_decap_8
X_3251_ Tile_X0Y0_FrameData_O[19] Tile_X0Y0_FrameData[19] VPWR VGND sg13cmos5l_buf_1
XFILLER_652_63 VPWR VGND sg13cmos5l_decap_8
XFILLER_224_14 VPWR VGND sg13cmos5l_decap_8
X_0463_ _0463_/Q Tile_X0Y8_FrameData[16] VGND VPWR Tile_X0Y9_FrameStrobe[1] latch
XANTENNA__3035__X Tile_X0Y5_EE4BEG[10] VPWR VGND sg13cmos5l_antennanp
X_2202_ _2202_/Q Tile_X0Y5_FrameData[11] VGND VPWR Tile_X0Y9_FrameStrobe[0] latch
XFILLER_371_42 VPWR VGND sg13cmos5l_decap_8
X_3182_ Tile_X0Y0_N4BEG[6] _3182_/A VPWR VGND sg13cmos5l_buf_1
XFILLER_663_247 VPWR VGND sg13cmos5l_decap_8
X_0394_ _0394_/Q Tile_X0Y7_FrameData[21] VGND VPWR Tile_X0Y9_FrameStrobe[7] latch
XFILLER_474_169 VPWR VGND sg13cmos5l_decap_8
XFILLER_616_141 VPWR VGND sg13cmos5l_decap_8
XFILLER_266_261 VPWR VGND sg13cmos5l_decap_8
XANTENNA__2874__X Tile_X0Y6_EE4BEG[11] VPWR VGND sg13cmos5l_antennanp
X_2133_ _2133_/Q Tile_X0Y4_FrameData[16] VGND VPWR Tile_X0Y9_FrameStrobe[6] latch
XFILLER_266_272 VPWR VGND sg13cmos5l_fill_1
XFILLER_226_125 VPWR VGND sg13cmos5l_decap_8
XFILLER_93_152 VPWR VGND sg13cmos5l_decap_8
XFILLER_415_225 VPWR VGND sg13cmos5l_decap_4
XFILLER_521_56 VPWR VGND sg13cmos5l_decap_8
XFILLER_304_91 VPWR VGND sg13cmos5l_fill_2
XFILLER_19_260 VPWR VGND sg13cmos5l_fill_1
X_2064_ _2064_/Q Tile_X0Y4_FrameData[21] VGND VPWR Tile_X0Y9_FrameStrobe[4] latch
XFILLER_631_133 VPWR VGND sg13cmos5l_decap_8
XFILLER_240_35 VPWR VGND sg13cmos5l_decap_8
X_1015_ _1015_/Q Tile_X0Y0_FrameData[20] VGND VPWR Tile_X0Y9_FrameStrobe[2] latch
XFILLER_430_217 VPWR VGND sg13cmos5l_decap_8
XFILLER_597_49 VPWR VGND sg13cmos5l_decap_4
XFILLER_584_221 VPWR VGND sg13cmos5l_decap_8
XFILLER_584_232 VPWR VGND sg13cmos5l_fill_2
XFILLER_320_90 VPWR VGND sg13cmos5l_fill_1
XFILLER_179_268 VPWR VGND sg13cmos5l_decap_4
XFILLER_395_143 VPWR VGND sg13cmos5l_decap_8
XFILLER_194_205 VPWR VGND sg13cmos5l_decap_8
XFILLER_249_22 VPWR VGND sg13cmos5l_decap_8
XFILLER_677_82 VPWR VGND sg13cmos5l_fill_2
X_2966_ Tile_X0Y8_FrameData_O[6] Tile_X0Y8_FrameData[6] VPWR VGND sg13cmos5l_buf_1
XFILLER_147_121 VPWR VGND sg13cmos5l_decap_8
X_4705_ _4705_/X Tile_X0Y9_W2MID[5] Tile_X0Y9_W2END[5] Tile_X0Y9_W6END[5] _4905_/X
+ _0915_/Q _0914_/Q VPWR VGND sg13cmos5l_mux4_1
X_1917_ _1917_/Q Tile_X0Y3_FrameData[12] VGND VPWR Tile_X0Y9_FrameStrobe[7] latch
X_2897_ Tile_X0Y6_FrameData_O[18] Tile_X0Y6_FrameData[18] VPWR VGND sg13cmos5l_buf_1
XFILLER_546_42 VPWR VGND sg13cmos5l_decap_8
XFILLER_8_91 VPWR VGND sg13cmos5l_decap_8
X_4636_ _4636_/X Tile_X0Y7_WW4END[7] AXI_M_SOC_RDATA23 _4691_/X _4668_/X _0287_/Q
+ _0286_/Q VPWR VGND sg13cmos5l_mux4_1
X_1848_ _1848_/Q Tile_X0Y3_FrameData[17] VGND VPWR Tile_X0Y9_FrameStrobe[5] latch
XFILLER_265_21 VPWR VGND sg13cmos5l_decap_8
XFILLER_351_224 VPWR VGND sg13cmos5l_decap_8
XFILLER_693_92 VPWR VGND sg13cmos5l_decap_8
XFILLER_552_184 VPWR VGND sg13cmos5l_decap_8
XFILLER_497_217 VPWR VGND sg13cmos5l_decap_8
XFILLER_701_126 VPWR VGND sg13cmos5l_fill_2
XFILLER_698_177 VPWR VGND sg13cmos5l_decap_8
X_1779_ _1779_/Q Tile_X0Y3_FrameData[22] VGND VPWR Tile_X0Y9_FrameStrobe[3] latch
X_4567_ _4567_/X _4123_/X _4127_/X _4104_/X _4096_/X _1604_/Q _1603_/Q VPWR VGND sg13cmos5l_mux4_1
XFILLER_351_257 VPWR VGND sg13cmos5l_fill_1
X_3518_ Tile_X0Y1_E1BEG[0] _3928_/X VPWR VGND sg13cmos5l_buf_1
XFILLER_265_98 VPWR VGND sg13cmos5l_decap_8
XFILLER_103_213 VPWR VGND sg13cmos5l_decap_8
X_4498_ _4498_/X Tile_X0Y6_W2MID[5] AXI_M_SOC_RDATA26 _4557_/X _4556_/X _2611_/Q _2610_/Q
+ VPWR VGND sg13cmos5l_mux4_1
XFILLER_415_35 VPWR VGND sg13cmos5l_decap_8
XFILLER_103_224 VPWR VGND sg13cmos5l_fill_2
XFILLER_103_235 VPWR VGND sg13cmos5l_fill_1
XFILLER_134_14 VPWR VGND sg13cmos5l_decap_8
XFILLER_562_63 VPWR VGND sg13cmos5l_decap_8
XFILLER_103_257 VPWR VGND sg13cmos5l_decap_4
X_3449_ Tile_X0Y1_FrameData_O[7] Tile_X0Y1_FrameData[7] VPWR VGND sg13cmos5l_buf_1
XFILLER_281_42 VPWR VGND sg13cmos5l_decap_8
XFILLER_69_182 VPWR VGND sg13cmos5l_decap_8
XFILLER_257_272 VPWR VGND sg13cmos5l_fill_1
XANTENNA__2784__X Tile_X0Y3_EE4BEG[10] VPWR VGND sg13cmos5l_antennanp
XFILLER_712_77 VPWR VGND sg13cmos5l_decap_8
XFILLER_607_163 VPWR VGND sg13cmos5l_decap_8
XFILLER_406_214 VPWR VGND sg13cmos5l_decap_8
XFILLER_272_220 VPWR VGND sg13cmos5l_fill_1
XFILLER_214_91 VPWR VGND sg13cmos5l_decap_8
XFILLER_217_136 VPWR VGND sg13cmos5l_decap_8
XFILLER_431_56 VPWR VGND sg13cmos5l_decap_8
XFILLER_150_35 VPWR VGND sg13cmos5l_decap_4
XFILLER_622_166 VPWR VGND sg13cmos5l_decap_8
XFILLER_447_7 VPWR VGND sg13cmos5l_decap_8
XFILLER_25_252 VPWR VGND sg13cmos5l_fill_1
XFILLER_575_210 VPWR VGND sg13cmos5l_decap_8
XFILLER_300_49 VPWR VGND sg13cmos5l_decap_8
XFILLER_709_237 VPWR VGND sg13cmos5l_decap_8
XFILLER_43_55 VPWR VGND sg13cmos5l_decap_4
XFILLER_40_233 VPWR VGND sg13cmos5l_decap_8
XFILLER_614_7 VPWR VGND sg13cmos5l_decap_8
XFILLER_185_238 VPWR VGND sg13cmos5l_decap_4
XFILLER_386_187 VPWR VGND sg13cmos5l_decap_8
XFILLER_159_88 VPWR VGND sg13cmos5l_decap_8
XFILLER_590_246 VPWR VGND sg13cmos5l_decap_8
XFILLER_528_181 VPWR VGND sg13cmos5l_decap_8
XFILLER_327_232 VPWR VGND sg13cmos5l_decap_4
XFILLER_309_14 VPWR VGND sg13cmos5l_decap_8
XFILLER_138_154 VPWR VGND sg13cmos5l_decap_8
XFILLER_590_257 VPWR VGND sg13cmos5l_fill_1
XFILLER_456_42 VPWR VGND sg13cmos5l_decap_8
XFILLER_193_271 VPWR VGND sg13cmos5l_fill_2
XFILLER_175_21 VPWR VGND sg13cmos5l_decap_8
XFILLER_689_155 VPWR VGND sg13cmos5l_decap_8
XFILLER_4_112 VPWR VGND sg13cmos5l_decap_8
XANTENNA__2959__X Tile_X0Y8_EE4BEG[15] VPWR VGND sg13cmos5l_antennanp
XFILLER_543_195 VPWR VGND sg13cmos5l_decap_8
XFILLER_342_235 VPWR VGND sg13cmos5l_decap_8
XFILLER_104_0 VPWR VGND sg13cmos5l_decap_8
XFILLER_342_268 VPWR VGND sg13cmos5l_decap_4
XFILLER_606_56 VPWR VGND sg13cmos5l_decap_4
XFILLER_108_70 VPWR VGND sg13cmos5l_decap_8
XFILLER_4_189 VPWR VGND sg13cmos5l_fill_1
XFILLER_325_35 VPWR VGND sg13cmos5l_decap_8
XFILLER_4_49 VPWR VGND sg13cmos5l_decap_8
XFILLER_496_250 VPWR VGND sg13cmos5l_decap_8
XFILLER_645_203 VPWR VGND sg13cmos5l_decap_8
XFILLER_496_272 VPWR VGND sg13cmos5l_fill_1
XFILLER_68_63 VPWR VGND sg13cmos5l_decap_8
XFILLER_191_42 VPWR VGND sg13cmos5l_fill_1
XFILLER_700_192 VPWR VGND sg13cmos5l_decap_8
XFILLER_310_154 VPWR VGND sg13cmos5l_decap_8
XFILLER_67_119 VPWR VGND sg13cmos5l_decap_8
XFILLER_191_64 VPWR VGND sg13cmos5l_decap_8
XFILLER_473_0 VPWR VGND sg13cmos5l_decap_8
XFILLER_191_97 VPWR VGND sg13cmos5l_decap_8
XFILLER_622_77 VPWR VGND sg13cmos5l_decap_8
XFILLER_471_117 VPWR VGND sg13cmos5l_decap_8
XFILLER_75_141 VPWR VGND sg13cmos5l_decap_8
XFILLER_613_100 VPWR VGND sg13cmos5l_decap_8
XFILLER_341_56 VPWR VGND sg13cmos5l_decap_8
XFILLER_124_91 VPWR VGND sg13cmos5l_decap_8
XFILLER_208_147 VPWR VGND sg13cmos5l_decap_8
XFILLER_640_0 VPWR VGND sg13cmos5l_decap_8
XFILLER_75_196 VPWR VGND sg13cmos5l_fill_1
XFILLER_84_84 VPWR VGND sg13cmos5l_decap_8
XFILLER_613_177 VPWR VGND sg13cmos5l_decap_8
XFILLER_16_252 VPWR VGND sg13cmos5l_fill_2
XFILLER_566_210 VPWR VGND sg13cmos5l_fill_2
XFILLER_210_49 VPWR VGND sg13cmos5l_decap_8
XFILLER_231_150 VPWR VGND sg13cmos5l_decap_8
X_2820_ Tile_X0Y3_E1BEG[2] _4146_/X VPWR VGND sg13cmos5l_buf_1
XFILLER_420_272 VPWR VGND sg13cmos5l_fill_1
XFILLER_231_194 VPWR VGND sg13cmos5l_decap_8
XFILLER_176_227 VPWR VGND sg13cmos5l_fill_2
XFILLER_581_202 VPWR VGND sg13cmos5l_decap_8
XFILLER_581_224 VPWR VGND sg13cmos5l_fill_2
XFILLER_318_210 VPWR VGND sg13cmos5l_decap_8
XFILLER_219_14 VPWR VGND sg13cmos5l_decap_8
X_2751_ Tile_X0Y3_FrameData_O[9] Tile_X0Y3_FrameData[9] VPWR VGND sg13cmos5l_buf_1
XFILLER_647_63 VPWR VGND sg13cmos5l_decap_8
XFILLER_129_143 VPWR VGND sg13cmos5l_decap_8
X_1702_ _1702_/Q Tile_X0Y3_FrameData[3] VGND VPWR Tile_X0Y9_FrameStrobe[0] latch
XFILLER_392_179 VPWR VGND sg13cmos5l_decap_8
X_2682_ _2682_/Q Tile_X0Y6_FrameData[13] VGND VPWR Tile_X0Y9_FrameStrobe[7] latch
X_1633_ _1633_/Q Tile_X0Y2_FrameData[16] VGND VPWR Tile_X0Y9_FrameStrobe[6] latch
X_4421_ _4421_/X Tile_X0Y6_W1END[1] Tile_X0Y6_W6END[5] _4581_/X _4541_/X _2693_/Q
+ _2692_/Q VPWR VGND sg13cmos5l_mux4_1
XFILLER_366_97 VPWR VGND sg13cmos5l_decap_8
XANTENNA__2869__X Tile_X0Y6_EE4BEG[6] VPWR VGND sg13cmos5l_antennanp
XFILLER_516_56 VPWR VGND sg13cmos5l_decap_8
XFILLER_333_268 VPWR VGND sg13cmos5l_decap_4
X_1564_ _1564_/Q Tile_X0Y2_FrameData[21] VGND VPWR Tile_X0Y9_FrameStrobe[4] latch
X_4352_ _4352_/X Tile_X0Y3_W2MID[7] Tile_X0Y3_W2END[7] Tile_X0Y3_W6END[8] _4205_/X
+ _1881_/Q _1880_/Q VPWR VGND sg13cmos5l_mux4_1
XFILLER_663_84 VPWR VGND sg13cmos5l_fill_1
XFILLER_235_35 VPWR VGND sg13cmos5l_decap_8
X_0515_ _0515_/Q Tile_X0Y8_FrameData[28] VGND VPWR Tile_X0Y9_FrameStrobe[3] latch
X_3303_ Tile_X0Y0_E2BEG[3] _3807_/X VPWR VGND sg13cmos5l_buf_1
XFILLER_487_272 VPWR VGND sg13cmos5l_fill_1
XFILLER_382_63 VPWR VGND sg13cmos5l_decap_4
X_4283_ _4283_/X Tile_X0Y4_WW4END[4] AXI_M_SOC_BRESP0 _4340_/X _4318_/X _2047_/Q _2046_/Q
+ VPWR VGND sg13cmos5l_mux4_1
X_1495_ _1495_/Q Tile_X0Y2_FrameData[26] VGND VPWR Tile_X0Y9_FrameStrobe[2] latch
XFILLER_301_154 VPWR VGND sg13cmos5l_decap_8
X_3234_ Tile_X0Y0_FrameData_O[2] Tile_X0Y0_FrameData[2] VPWR VGND sg13cmos5l_buf_1
XFILLER_301_165 VPWR VGND sg13cmos5l_fill_2
X_0446_ _0446_/Q Tile_X0Y8_FrameData[1] VGND VPWR Tile_X0Y9_FrameStrobe[0] latch
XFILLER_447_158 VPWR VGND sg13cmos5l_decap_8
XFILLER_104_28 VPWR VGND sg13cmos5l_decap_8
X_3165_ Tile_X0Y4_E6BEG[2] _4290_/X VPWR VGND sg13cmos5l_buf_1
XFILLER_651_217 VPWR VGND sg13cmos5l_decap_8
XFILLER_462_128 VPWR VGND sg13cmos5l_decap_8
X_0377_ _0377_/Q Tile_X0Y7_FrameData[6] VGND VPWR Tile_X0Y9_FrameStrobe[6] latch
XFILLER_462_139 VPWR VGND sg13cmos5l_fill_2
XFILLER_455_191 VPWR VGND sg13cmos5l_decap_8
XFILLER_251_56 VPWR VGND sg13cmos5l_decap_8
X_2116_ _2116_/Q Tile_X0Y4_FrameData[1] VGND VPWR Tile_X0Y9_FrameStrobe[5] latch
XFILLER_254_242 VPWR VGND sg13cmos5l_decap_4
X_3096_ Tile_X0Y7_E2BEGb[2] _4622_/X VPWR VGND sg13cmos5l_buf_1
XFILLER_401_15 VPWR VGND sg13cmos5l_decap_8
XFILLER_66_196 VPWR VGND sg13cmos5l_decap_8
X_2047_ _2047_/Q Tile_X0Y4_FrameData[6] VGND VPWR Tile_X0Y9_FrameStrobe[3] latch
XFILLER_403_228 VPWR VGND sg13cmos5l_decap_4
XFILLER_207_180 VPWR VGND sg13cmos5l_decap_8
XFILLER_81_166 VPWR VGND sg13cmos5l_decap_8
XFILLER_688_92 VPWR VGND sg13cmos5l_decap_4
XFILLER_120_49 VPWR VGND sg13cmos5l_decap_8
XFILLER_557_221 VPWR VGND sg13cmos5l_decap_8
XFILLER_411_272 VPWR VGND sg13cmos5l_fill_1
XFILLER_222_183 VPWR VGND sg13cmos5l_decap_8
XFILLER_13_14 VPWR VGND sg13cmos5l_decap_8
X_3998_ _3998_/X _4455_/X _4459_/X _4463_/X _4467_/X _2415_/Q _2414_/Q VPWR VGND sg13cmos5l_mux4_1
XFILLER_572_224 VPWR VGND sg13cmos5l_decap_8
XFILLER_557_63 VPWR VGND sg13cmos5l_decap_8
XFILLER_129_14 VPWR VGND sg13cmos5l_decap_8
X_2949_ Tile_X0Y8_EE4BEG[5] _4749_/X VPWR VGND sg13cmos5l_buf_1
XFILLER_572_268 VPWR VGND sg13cmos5l_decap_4
XFILLER_383_168 VPWR VGND sg13cmos5l_decap_8
XFILLER_276_42 VPWR VGND sg13cmos5l_decap_8
XFILLER_175_271 VPWR VGND sg13cmos5l_fill_2
XFILLER_525_184 VPWR VGND sg13cmos5l_decap_4
XFILLER_324_235 VPWR VGND sg13cmos5l_decap_8
XANTENNA__2779__X Tile_X0Y3_EE4BEG[5] VPWR VGND sg13cmos5l_antennanp
X_4619_ _4619_/X Tile_X0Y7_W2MID[0] AXI_M_SOC_RDATA23 _4669_/X _4668_/X _0321_/Q _0320_/Q
+ VPWR VGND sg13cmos5l_mux4_1
XFILLER_707_77 VPWR VGND sg13cmos5l_decap_8
XFILLER_540_132 VPWR VGND sg13cmos5l_fill_1
XFILLER_190_263 VPWR VGND sg13cmos5l_fill_2
XFILLER_426_56 VPWR VGND sg13cmos5l_decap_8
XFILLER_209_91 VPWR VGND sg13cmos5l_decap_8
XFILLER_150_116 VPWR VGND sg13cmos5l_decap_8
XFILLER_89_200 VPWR VGND sg13cmos5l_fill_1
XFILLER_573_84 VPWR VGND sg13cmos5l_decap_8
XFILLER_145_35 VPWR VGND sg13cmos5l_decap_8
XFILLER_89_222 VPWR VGND sg13cmos5l_decap_8
XFILLER_8_7 VPWR VGND sg13cmos5l_decap_8
XFILLER_1_137 VPWR VGND sg13cmos5l_fill_1
XFILLER_289_172 VPWR VGND sg13cmos5l_fill_1
XFILLER_292_63 VPWR VGND sg13cmos5l_decap_8
XFILLER_627_225 VPWR VGND sg13cmos5l_decap_8
XFILLER_397_7 VPWR VGND sg13cmos5l_decap_8
XFILLER_442_22 VPWR VGND sg13cmos5l_decap_8
XFILLER_694_191 VPWR VGND sg13cmos5l_decap_8
XFILLER_438_158 VPWR VGND sg13cmos5l_decap_8
XFILLER_38_44 VPWR VGND sg13cmos5l_decap_8
XFILLER_453_117 VPWR VGND sg13cmos5l_fill_2
XFILLER_642_217 VPWR VGND sg13cmos5l_decap_8
XFILLER_564_7 VPWR VGND sg13cmos5l_decap_8
XANTENNA__3403__X Tile_X0Y2_E2BEG[6] VPWR VGND sg13cmos5l_antennanp
XFILLER_161_67 VPWR VGND sg13cmos5l_fill_1
XFILLER_311_15 VPWR VGND sg13cmos5l_decap_8
XFILLER_650_250 VPWR VGND sg13cmos5l_decap_8
XFILLER_260_201 VPWR VGND sg13cmos5l_decap_8
XFILLER_650_261 VPWR VGND sg13cmos5l_fill_1
XFILLER_650_272 VPWR VGND sg13cmos5l_fill_1
XFILLER_598_70 VPWR VGND sg13cmos5l_fill_1
XFILLER_220_109 VPWR VGND sg13cmos5l_decap_8
XFILLER_72_199 VPWR VGND sg13cmos5l_decap_8
XFILLER_54_76 VPWR VGND sg13cmos5l_decap_4
XFILLER_610_169 VPWR VGND sg13cmos5l_decap_8
XFILLER_402_261 VPWR VGND sg13cmos5l_decap_8
XFILLER_13_244 VPWR VGND sg13cmos5l_fill_2
XFILLER_213_172 VPWR VGND sg13cmos5l_decap_8
XFILLER_402_272 VPWR VGND sg13cmos5l_fill_1
XFILLER_158_216 VPWR VGND sg13cmos5l_decap_8
XFILLER_213_183 VPWR VGND sg13cmos5l_decap_8
XFILLER_684_28 VPWR VGND sg13cmos5l_decap_4
XFILLER_563_246 VPWR VGND sg13cmos5l_fill_1
XFILLER_221_0 VPWR VGND sg13cmos5l_decap_8
XFILLER_70_64 VPWR VGND sg13cmos5l_decap_8
XFILLER_173_219 VPWR VGND sg13cmos5l_fill_2
XFILLER_516_140 VPWR VGND sg13cmos5l_fill_1
XFILLER_374_179 VPWR VGND sg13cmos5l_fill_1
XFILLER_319_0 VPWR VGND sg13cmos5l_decap_8
XFILLER_186_53 VPWR VGND sg13cmos5l_decap_8
XFILLER_516_162 VPWR VGND sg13cmos5l_decap_8
XFILLER_531_110 VPWR VGND sg13cmos5l_decap_8
XFILLER_617_77 VPWR VGND sg13cmos5l_decap_8
XFILLER_181_241 VPWR VGND sg13cmos5l_decap_8
XFILLER_126_168 VPWR VGND sg13cmos5l_decap_8
XFILLER_315_268 VPWR VGND sg13cmos5l_decap_4
XFILLER_126_179 VPWR VGND sg13cmos5l_fill_1
XFILLER_336_56 VPWR VGND sg13cmos5l_fill_1
XFILLER_336_89 VPWR VGND sg13cmos5l_decap_8
XFILLER_330_227 VPWR VGND sg13cmos5l_decap_8
XFILLER_633_21 VPWR VGND sg13cmos5l_decap_8
XFILLER_590_0 VPWR VGND sg13cmos5l_decap_8
XFILLER_79_84 VPWR VGND sg13cmos5l_decap_8
XFILLER_688_0 VPWR VGND sg13cmos5l_decap_8
XFILLER_469_272 VPWR VGND sg13cmos5l_fill_1
X_0300_ _0300_/Q Tile_X0Y7_FrameData[19] VGND VPWR Tile_X0Y9_FrameStrobe[4] latch
XFILLER_429_147 VPWR VGND sg13cmos5l_decap_8
X_1280_ _1280_/Q Tile_X0Y1_FrameData[25] VGND VPWR Tile_X0Y9_FrameStrobe[3] latch
XFILLER_633_98 VPWR VGND sg13cmos5l_decap_8
XFILLER_205_49 VPWR VGND sg13cmos5l_decap_8
XFILLER_95_236 VPWR VGND sg13cmos5l_decap_8
XFILLER_295_175 VPWR VGND sg13cmos5l_decap_8
X_0231_ _0231_/Q Tile_X0Y7_FrameData[24] VGND VPWR Tile_X0Y9_FrameStrobe[2] latch
XFILLER_352_77 VPWR VGND sg13cmos5l_decap_8
XFILLER_502_14 VPWR VGND sg13cmos5l_decap_8
XANTENNA__3313__X Tile_X0Y4_EE4BEG[1] VPWR VGND sg13cmos5l_antennanp
XFILLER_48_152 VPWR VGND sg13cmos5l_decap_8
XFILLER_437_191 VPWR VGND sg13cmos5l_fill_2
XFILLER_63_100 VPWR VGND sg13cmos5l_fill_1
X_0162_ _0162_/Q Tile_X0Y7_FrameData[29] VGND VPWR Tile_X0Y9_FrameStrobe[0] latch
XFILLER_48_185 VPWR VGND sg13cmos5l_decap_8
XFILLER_63_111 VPWR VGND sg13cmos5l_decap_8
XFILLER_397_205 VPWR VGND sg13cmos5l_decap_4
XFILLER_251_212 VPWR VGND sg13cmos5l_decap_8
X_0093_ _3622_/A _4484_/X _4485_/X _2633_/Q VPWR VGND sg13cmos5l_mux2_1
XFILLER_397_216 VPWR VGND sg13cmos5l_decap_8
XFILLER_601_125 VPWR VGND sg13cmos5l_decap_8
XFILLER_63_188 VPWR VGND sg13cmos5l_decap_8
X_3921_ _3921_/X _4229_/X _4233_/X _4212_/X _4211_/X _1892_/Q _1891_/Q VPWR VGND sg13cmos5l_mux4_1
XFILLER_204_150 VPWR VGND sg13cmos5l_decap_8
XFILLER_149_227 VPWR VGND sg13cmos5l_decap_8
X_3852_ _3852_/X _3903_/X _3902_/X Tile_X0Y0_S2MID[7] Tile_X0Y0_S2END[7] _0949_/Q
+ _0948_/Q VPWR VGND sg13cmos5l_mux4_1
XFILLER_658_84 VPWR VGND sg13cmos5l_decap_8
X_2803_ Tile_X0Y3_E2BEGb[1] _4157_/X VPWR VGND sg13cmos5l_buf_1
XFILLER_594_28 VPWR VGND sg13cmos5l_decap_8
XFILLER_365_146 VPWR VGND sg13cmos5l_fill_2
X_0995_ _0995_/Q Tile_X0Y0_FrameData[8] VGND VPWR Tile_X0Y9_FrameStrobe[1] latch
X_3783_ _3783_/X Tile_X0Y0_W1END[3] Tile_X0Y0_W6END[7] _3863_/X _3880_/X _1171_/Q
+ _1170_/Q VPWR VGND sg13cmos5l_mux4_1
XFILLER_554_268 VPWR VGND sg13cmos5l_decap_4
XFILLER_380_105 VPWR VGND sg13cmos5l_decap_8
XFILLER_157_271 VPWR VGND sg13cmos5l_fill_2
X_2734_ _3977_/A3 VPWR VGND sg13cmos5l_tielo
XFILLER_67_0 VPWR VGND sg13cmos5l_decap_8
XFILLER_522_110 VPWR VGND sg13cmos5l_decap_8
XFILLER_507_195 VPWR VGND sg13cmos5l_decap_8
XFILLER_373_190 VPWR VGND sg13cmos5l_fill_2
X_2665_ _2665_/Q Tile_X0Y6_FrameData[30] VGND VPWR Tile_X0Y9_FrameStrobe[7] latch
XFILLER_306_257 VPWR VGND sg13cmos5l_decap_8
XFILLER_117_179 VPWR VGND sg13cmos5l_decap_8
XFILLER_132_105 VPWR VGND sg13cmos5l_decap_8
XFILLER_711_243 VPWR VGND sg13cmos5l_fill_2
XFILLER_306_268 VPWR VGND sg13cmos5l_decap_4
X_4404_ _4404_/X _0157_/X _0143_/X _4462_/X _4466_/X _2295_/Q _2294_/Q VPWR VGND sg13cmos5l_mux4_1
XFILLER_246_67 VPWR VGND sg13cmos5l_decap_8
X_1616_ _1616_/Q Tile_X0Y2_FrameData[1] VGND VPWR Tile_X0Y9_FrameStrobe[5] latch
X_2596_ _2596_/Q Tile_X0Y6_FrameData[3] VGND VPWR Tile_X0Y9_FrameStrobe[4] latch
XFILLER_668_158 VPWR VGND sg13cmos5l_decap_8
XFILLER_668_169 VPWR VGND sg13cmos5l_fill_2
XFILLER_543_21 VPWR VGND sg13cmos5l_decap_8
XFILLER_522_187 VPWR VGND sg13cmos5l_decap_8
XFILLER_246_89 VPWR VGND sg13cmos5l_fill_1
XFILLER_5_70 VPWR VGND sg13cmos5l_decap_8
XFILLER_125_190 VPWR VGND sg13cmos5l_decap_8
XFILLER_321_249 VPWR VGND sg13cmos5l_decap_8
X_4335_ _4335_/X _4807_/X _4811_/X _4815_/X _4791_/X _0638_/Q _0637_/Q VPWR VGND sg13cmos5l_mux4_1
X_1547_ _1547_/Q Tile_X0Y2_FrameData[6] VGND VPWR Tile_X0Y9_FrameStrobe[3] latch
XFILLER_690_71 VPWR VGND sg13cmos5l_decap_8
XFILLER_609_236 VPWR VGND sg13cmos5l_fill_2
XFILLER_676_191 VPWR VGND sg13cmos5l_decap_8
XFILLER_219_209 VPWR VGND sg13cmos5l_decap_8
X_1478_ _1478_/Q Tile_X0Y2_FrameData[11] VGND VPWR Tile_X0Y9_FrameStrobe[1] latch
X_4266_ _4266_/X Tile_X0Y4_W2END[5] AXI_M_SOC_BRESP1 _4317_/X _4316_/X _2081_/Q _2080_/Q
+ VPWR VGND sg13cmos5l_mux4_1
XFILLER_140_182 VPWR VGND sg13cmos5l_decap_8
XFILLER_286_175 VPWR VGND sg13cmos5l_decap_8
X_0429_ _0429_/Q Tile_X0Y8_FrameData[18] VGND VPWR Tile_X0Y9_FrameStrobe[0] latch
X_3217_ Tile_X0Y0_FrameStrobe_O[5] Tile_X0Y9_FrameStrobe[5] VPWR VGND sg13cmos5l_buf_1
XANTENNA__3223__X Tile_X0Y0_FrameStrobe_O[11] VPWR VGND sg13cmos5l_antennanp
X_4197_ _4197_/X Tile_X0Y4_W1END[1] Tile_X0Y4_W6END[5] _4349_/X _4303_/X _2179_/Q
+ _2178_/Q VPWR VGND sg13cmos5l_mux4_1
XFILLER_490_234 VPWR VGND sg13cmos5l_decap_8
XFILLER_412_36 VPWR VGND sg13cmos5l_decap_8
XFILLER_131_15 VPWR VGND sg13cmos5l_decap_8
X_3148_ Tile_X0Y7_FrameData_O[18] Tile_X0Y7_FrameData[18] VPWR VGND sg13cmos5l_buf_1
XFILLER_54_111 VPWR VGND sg13cmos5l_decap_4
XFILLER_450_109 VPWR VGND sg13cmos5l_decap_8
XFILLER_589_165 VPWR VGND sg13cmos5l_fill_2
X_3079_ Tile_X0Y4_E2BEGb[5] _4269_/X VPWR VGND sg13cmos5l_buf_1
XFILLER_388_227 VPWR VGND sg13cmos5l_decap_8
XFILLER_388_238 VPWR VGND sg13cmos5l_fill_1
XFILLER_211_70 VPWR VGND sg13cmos5l_decap_8
XFILLER_24_35 VPWR VGND sg13cmos5l_decap_8
XFILLER_145_7 VPWR VGND sg13cmos5l_decap_8
XFILLER_568_84 VPWR VGND sg13cmos5l_decap_8
XFILLER_396_271 VPWR VGND sg13cmos5l_fill_2
XFILLER_287_63 VPWR VGND sg13cmos5l_decap_8
XFILLER_210_175 VPWR VGND sg13cmos5l_decap_8
XFILLER_356_168 VPWR VGND sg13cmos5l_decap_8
XFILLER_210_197 VPWR VGND sg13cmos5l_decap_8
XFILLER_312_7 VPWR VGND sg13cmos5l_decap_8
XFILLER_10_269 VPWR VGND sg13cmos5l_decap_4
XFILLER_148_271 VPWR VGND sg13cmos5l_fill_2
XFILLER_40_34 VPWR VGND sg13cmos5l_decap_8
XFILLER_699_261 VPWR VGND sg13cmos5l_fill_2
XFILLER_699_272 VPWR VGND sg13cmos5l_fill_1
XFILLER_437_77 VPWR VGND sg13cmos5l_decap_8
XFILLER_702_221 VPWR VGND sg13cmos5l_decap_8
XFILLER_108_168 VPWR VGND sg13cmos5l_decap_8
XFILLER_163_263 VPWR VGND sg13cmos5l_fill_2
XFILLER_513_165 VPWR VGND sg13cmos5l_decap_8
XFILLER_453_21 VPWR VGND sg13cmos5l_decap_8
XFILLER_312_238 VPWR VGND sg13cmos5l_decap_8
XFILLER_513_198 VPWR VGND sg13cmos5l_decap_4
XFILLER_681_7 VPWR VGND sg13cmos5l_decap_8
XFILLER_306_59 VPWR VGND sg13cmos5l_fill_1
XFILLER_277_131 VPWR VGND sg13cmos5l_decap_8
XFILLER_667_191 VPWR VGND sg13cmos5l_decap_8
XFILLER_320_271 VPWR VGND sg13cmos5l_fill_2
XFILLER_603_35 VPWR VGND sg13cmos5l_decap_8
XFILLER_466_264 VPWR VGND sg13cmos5l_decap_8
XFILLER_277_175 VPWR VGND sg13cmos5l_fill_1
XFILLER_172_77 VPWR VGND sg13cmos5l_fill_1
XFILLER_682_161 VPWR VGND sg13cmos5l_decap_8
XFILLER_615_206 VPWR VGND sg13cmos5l_fill_1
XFILLER_1_28 VPWR VGND sg13cmos5l_decap_8
XFILLER_615_228 VPWR VGND sg13cmos5l_decap_8
XFILLER_481_223 VPWR VGND sg13cmos5l_decap_8
XFILLER_322_14 VPWR VGND sg13cmos5l_decap_8
XANTENNA__3133__X Tile_X0Y7_FrameData_O[3] VPWR VGND sg13cmos5l_antennanp
XFILLER_172_99 VPWR VGND sg13cmos5l_decap_8
XFILLER_603_79 VPWR VGND sg13cmos5l_fill_1
XFILLER_481_234 VPWR VGND sg13cmos5l_fill_2
XFILLER_65_42 VPWR VGND sg13cmos5l_decap_8
XFILLER_45_111 VPWR VGND sg13cmos5l_fill_1
XFILLER_292_178 VPWR VGND sg13cmos5l_decap_8
XFILLER_171_0 VPWR VGND sg13cmos5l_decap_8
XFILLER_434_150 VPWR VGND sg13cmos5l_decap_8
XANTENNA__2972__X Tile_X0Y8_FrameData_O[12] VPWR VGND sg13cmos5l_antennanp
XFILLER_623_272 VPWR VGND sg13cmos5l_fill_1
XFILLER_269_0 VPWR VGND sg13cmos5l_decap_8
XANTENNA_110 _0157_/X VPWR VGND sg13cmos5l_antennanp
XANTENNA_121 Tile_X0Y6_FrameData[30] VPWR VGND sg13cmos5l_antennanp
XANTENNA_132 Tile_X0Y6_FrameData[31] VPWR VGND sg13cmos5l_antennanp
XANTENNA_143 Tile_X0Y6_FrameData[31] VPWR VGND sg13cmos5l_antennanp
XFILLER_402_91 VPWR VGND sg13cmos5l_decap_8
XANTENNA_154 Tile_X0Y9_FrameStrobe[18] VPWR VGND sg13cmos5l_antennanp
XANTENNA_165 Tile_X0Y9_FrameStrobe[8] VPWR VGND sg13cmos5l_antennanp
XFILLER_121_70 VPWR VGND sg13cmos5l_decap_8
XANTENNA_176 Tile_X0Y9_FrameStrobe[8] VPWR VGND sg13cmos5l_antennanp
XANTENNA_187 Tile_X0Y9_FrameStrobe[8] VPWR VGND sg13cmos5l_antennanp
XFILLER_436_0 VPWR VGND sg13cmos5l_decap_8
XANTENNA_198 Tile_X0Y9_N2MID[2] VPWR VGND sg13cmos5l_antennanp
XFILLER_394_219 VPWR VGND sg13cmos5l_decap_8
XFILLER_198_171 VPWR VGND sg13cmos5l_fill_1
XFILLER_695_49 VPWR VGND sg13cmos5l_decap_8
XFILLER_201_131 VPWR VGND sg13cmos5l_decap_4
XFILLER_81_96 VPWR VGND sg13cmos5l_decap_8
XFILLER_628_43 VPWR VGND sg13cmos5l_decap_8
XFILLER_603_0 VPWR VGND sg13cmos5l_decap_8
XFILLER_201_186 VPWR VGND sg13cmos5l_decap_8
XFILLER_536_268 VPWR VGND sg13cmos5l_decap_4
XFILLER_362_105 VPWR VGND sg13cmos5l_decap_8
X_0780_ _0780_/Q Tile_X0Y9_FrameData[19] VGND VPWR Tile_X0Y9_FrameStrobe[3] latch
XFILLER_347_77 VPWR VGND sg13cmos5l_decap_8
XFILLER_154_252 VPWR VGND sg13cmos5l_fill_2
XANTENNA__3308__X Tile_X0Y0_E1BEG[0] VPWR VGND sg13cmos5l_antennanp
XFILLER_644_42 VPWR VGND sg13cmos5l_decap_8
XFILLER_53_6 VPWR VGND sg13cmos5l_fill_2
X_2450_ _2450_/Q Tile_X0Y6_FrameData[21] VGND VPWR Tile_X0Y9_FrameStrobe[0] latch
XFILLER_504_165 VPWR VGND sg13cmos5l_decap_8
XFILLER_370_171 VPWR VGND sg13cmos5l_decap_8
XFILLER_114_149 VPWR VGND sg13cmos5l_decap_8
X_1401_ _1401_/Q Tile_X0Y1_FrameData[0] VGND VPWR Tile_X0Y9_FrameStrobe[6] latch
XFILLER_363_43 VPWR VGND sg13cmos5l_decap_8
X_2381_ _2381_/Q Tile_X0Y5_FrameData[24] VGND VPWR Tile_X0Y9_FrameStrobe[6] latch
XFILLER_68_203 VPWR VGND sg13cmos5l_decap_8
X_1332_ _1332_/Q Tile_X0Y1_FrameData[5] VGND VPWR Tile_X0Y9_FrameStrobe[4] latch
X_4120_ _4120_/X _4089_/X _0079_/X _4088_/X Tile_X0Y0_S4END[8] _1473_/Q _1472_/Q VPWR
+ VGND sg13cmos5l_mux4_1
XFILLER_363_98 VPWR VGND sg13cmos5l_decap_8
XFILLER_122_182 VPWR VGND sg13cmos5l_fill_2
XFILLER_457_264 VPWR VGND sg13cmos5l_fill_1
XFILLER_513_35 VPWR VGND sg13cmos5l_decap_8
XFILLER_268_175 VPWR VGND sg13cmos5l_decap_8
XFILLER_283_112 VPWR VGND sg13cmos5l_decap_8
X_1263_ _1263_/Q Tile_X0Y1_FrameData[10] VGND VPWR Tile_X0Y9_FrameStrobe[2] latch
X_4051_ _4051_/X Tile_X0Y2_W2END[4] AXI_M_SOC_AWREADY _4103_/X _4102_/X _1571_/Q _1570_/Q
+ VPWR VGND sg13cmos5l_mux4_1
XFILLER_660_63 VPWR VGND sg13cmos5l_decap_8
XANTENNA__3043__X Tile_X0Y5_FrameData_O[2] VPWR VGND sg13cmos5l_antennanp
XFILLER_232_36 VPWR VGND sg13cmos5l_decap_8
X_0214_ _0214_/Q Tile_X0Y7_FrameData[9] VGND VPWR Tile_X0Y9_FrameStrobe[1] latch
X_3002_ Tile_X0Y5_E2BEG[5] _4377_/X VPWR VGND sg13cmos5l_buf_1
XFILLER_472_256 VPWR VGND sg13cmos5l_fill_1
XFILLER_36_100 VPWR VGND sg13cmos5l_decap_8
XFILLER_589_28 VPWR VGND sg13cmos5l_decap_8
X_1194_ _1194_/Q Tile_X0Y1_FrameData[15] VGND VPWR Tile_X0Y9_FrameStrobe[0] latch
XFILLER_224_201 VPWR VGND sg13cmos5l_decap_8
XFILLER_283_189 VPWR VGND sg13cmos5l_decap_8
XFILLER_425_161 VPWR VGND sg13cmos5l_decap_8
XANTENNA__2882__X Tile_X0Y6_FrameData_O[3] VPWR VGND sg13cmos5l_antennanp
X_0145_ _0145_/X _4439_/X _4440_/X _1360_/Q VPWR VGND sg13cmos5l_mux2_1
XFILLER_91_272 VPWR VGND sg13cmos5l_fill_1
XFILLER_51_103 VPWR VGND sg13cmos5l_fill_2
XFILLER_36_177 VPWR VGND sg13cmos5l_decap_8
X_0076_ _0076_/X _4794_/X _4795_/X _2116_/Q VPWR VGND sg13cmos5l_mux2_1
XFILLER_51_147 VPWR VGND sg13cmos5l_fill_2
X_3904_ _3904_/X Tile_X0Y1_W1END[3] Tile_X0Y1_WW4END[3] Tile_X0Y1_W6END[11] _4011_/X
+ _1392_/Q _1391_/Q VPWR VGND sg13cmos5l_mux4_1
XFILLER_189_171 VPWR VGND sg13cmos5l_fill_2
X_4884_ _4884_/X AXI_M_SOC_RDATA0 _4923_/X _4927_/X _4901_/X _0775_/Q _0774_/Q VPWR
+ VGND sg13cmos5l_mux4_1
XFILLER_538_21 VPWR VGND sg13cmos5l_decap_8
X_3835_ _3835_/X Tile_X0Y0_WW4END[0] Tile_X0Y0_WW4END[9] _3881_/X _3853_/X _1035_/Q
+ _1034_/Q VPWR VGND sg13cmos5l_mux4_1
XFILLER_594_190 VPWR VGND sg13cmos5l_decap_8
XFILLER_542_205 VPWR VGND sg13cmos5l_decap_8
XFILLER_353_105 VPWR VGND sg13cmos5l_decap_8
X_3766_ _3766_/X Tile_X0Y1_WW4END[7] Tile_X0Y1_WW4END[15] Tile_X0Y1_W6END[7] _4015_/X
+ _1243_/Q _1242_/Q VPWR VGND sg13cmos5l_mux4_1
X_0978_ _0978_/Q Tile_X0Y0_FrameData[25] VGND VPWR Tile_X0Y9_FrameStrobe[1] latch
X_2717_ _4773_/A3 VPWR VGND sg13cmos5l_tielo
XFILLER_145_252 VPWR VGND sg13cmos5l_decap_8
XFILLER_407_14 VPWR VGND sg13cmos5l_decap_8
XANTENNA__3218__X Tile_X0Y0_FrameStrobe_O[6] VPWR VGND sg13cmos5l_antennanp
X_3697_ AXI_M_SOC_WDATA7 Tile_X0Y7_WW4END[7] Tile_X0Y7_WW4END[15] Tile_X0Y7_W6END[7]
+ _4691_/X _0233_/Q _0232_/Q VPWR VGND sg13cmos5l_mux4_1
XFILLER_696_220 VPWR VGND sg13cmos5l_decap_8
XFILLER_554_42 VPWR VGND sg13cmos5l_decap_8
XFILLER_696_242 VPWR VGND sg13cmos5l_fill_1
X_2648_ _2648_/Q Tile_X0Y6_FrameData[15] VGND VPWR Tile_X0Y9_FrameStrobe[6] latch
XFILLER_696_264 VPWR VGND sg13cmos5l_decap_8
XFILLER_273_21 VPWR VGND sg13cmos5l_decap_8
XFILLER_160_244 VPWR VGND sg13cmos5l_decap_4
X_2579_ _2579_/Q Tile_X0Y6_FrameData[20] VGND VPWR Tile_X0Y9_FrameStrobe[4] latch
XFILLER_510_157 VPWR VGND sg13cmos5l_decap_8
XFILLER_704_56 VPWR VGND sg13cmos5l_decap_8
XFILLER_59_214 VPWR VGND sg13cmos5l_decap_8
XFILLER_259_142 VPWR VGND sg13cmos5l_decap_8
X_4318_ _4318_/X _4245_/X _4361_/X _4360_/X _4244_/X _1941_/Q _1940_/Q VPWR VGND sg13cmos5l_mux4_1
XFILLER_448_253 VPWR VGND sg13cmos5l_decap_4
XFILLER_206_70 VPWR VGND sg13cmos5l_decap_8
XFILLER_423_35 VPWR VGND sg13cmos5l_decap_8
XFILLER_19_35 VPWR VGND sg13cmos5l_fill_2
XFILLER_463_212 VPWR VGND sg13cmos5l_decap_8
XFILLER_142_14 VPWR VGND sg13cmos5l_decap_8
XFILLER_570_63 VPWR VGND sg13cmos5l_decap_8
XFILLER_259_197 VPWR VGND sg13cmos5l_decap_8
X_4249_ _4249_/X Tile_X0Y5_W2MID[1] Tile_X0Y5_W2END[1] Tile_X0Y5_W6END[1] _4429_/X
+ _2419_/Q _2418_/Q VPWR VGND sg13cmos5l_mux4_1
XFILLER_274_145 VPWR VGND sg13cmos5l_decap_8
XFILLER_499_28 VPWR VGND sg13cmos5l_decap_8
XFILLER_612_209 VPWR VGND sg13cmos5l_decap_8
XFILLER_367_8 VPWR VGND sg13cmos5l_decap_8
XANTENNA__2792__X Tile_X0Y3_E6BEG[2] VPWR VGND sg13cmos5l_antennanp
XFILLER_605_272 VPWR VGND sg13cmos5l_fill_1
XFILLER_416_183 VPWR VGND sg13cmos5l_decap_8
XFILLER_262_7 VPWR VGND sg13cmos5l_decap_8
XFILLER_82_272 VPWR VGND sg13cmos5l_fill_1
XFILLER_577_157 VPWR VGND sg13cmos5l_decap_8
XFILLER_431_175 VPWR VGND sg13cmos5l_decap_8
XFILLER_230_237 VPWR VGND sg13cmos5l_decap_8
XFILLER_527_7 VPWR VGND sg13cmos5l_decap_8
XFILLER_592_127 VPWR VGND sg13cmos5l_decap_4
XFILLER_448_21 VPWR VGND sg13cmos5l_decap_8
XFILLER_195_130 VPWR VGND sg13cmos5l_decap_8
XFILLER_595_60 VPWR VGND sg13cmos5l_fill_2
XFILLER_448_98 VPWR VGND sg13cmos5l_decap_8
XFILLER_310_4 VPWR VGND sg13cmos5l_fill_1
XFILLER_51_99 VPWR VGND sg13cmos5l_decap_4
XFILLER_167_77 VPWR VGND sg13cmos5l_decap_8
XFILLER_317_14 VPWR VGND sg13cmos5l_decap_8
XANTENNA__3128__X Tile_X0Y7_EE4BEG[14] VPWR VGND sg13cmos5l_antennanp
XFILLER_151_200 VPWR VGND sg13cmos5l_decap_8
XFILLER_464_42 VPWR VGND sg13cmos5l_decap_8
XFILLER_352_182 VPWR VGND sg13cmos5l_decap_8
XFILLER_317_69 VPWR VGND sg13cmos5l_decap_8
XFILLER_498_175 VPWR VGND sg13cmos5l_decap_8
XANTENNA__2967__X Tile_X0Y8_FrameData_O[7] VPWR VGND sg13cmos5l_antennanp
XFILLER_297_248 VPWR VGND sg13cmos5l_decap_4
XFILLER_183_76 VPWR VGND sg13cmos5l_decap_8
XFILLER_439_231 VPWR VGND sg13cmos5l_decap_8
XFILLER_104_160 VPWR VGND sg13cmos5l_decap_8
XFILLER_614_56 VPWR VGND sg13cmos5l_decap_8
XFILLER_501_168 VPWR VGND sg13cmos5l_decap_8
XFILLER_116_70 VPWR VGND sg13cmos5l_decap_8
XFILLER_386_0 VPWR VGND sg13cmos5l_decap_8
XFILLER_265_112 VPWR VGND sg13cmos5l_decap_4
XFILLER_480_63 VPWR VGND sg13cmos5l_decap_8
XFILLER_333_57 VPWR VGND sg13cmos5l_decap_8
XFILLER_265_134 VPWR VGND sg13cmos5l_decap_8
XFILLER_655_183 VPWR VGND sg13cmos5l_decap_8
XFILLER_76_63 VPWR VGND sg13cmos5l_fill_2
XFILLER_65_217 VPWR VGND sg13cmos5l_decap_8
XFILLER_670_131 VPWR VGND sg13cmos5l_fill_1
XFILLER_670_164 VPWR VGND sg13cmos5l_decap_8
XFILLER_553_0 VPWR VGND sg13cmos5l_decap_8
XFILLER_407_161 VPWR VGND sg13cmos5l_decap_8
XFILLER_280_126 VPWR VGND sg13cmos5l_decap_8
XFILLER_630_77 VPWR VGND sg13cmos5l_decap_8
XFILLER_202_28 VPWR VGND sg13cmos5l_decap_8
XFILLER_80_209 VPWR VGND sg13cmos5l_decap_8
XFILLER_18_177 VPWR VGND sg13cmos5l_decap_8
XFILLER_132_91 VPWR VGND sg13cmos5l_decap_8
XFILLER_206_256 VPWR VGND sg13cmos5l_decap_4
XFILLER_33_103 VPWR VGND sg13cmos5l_decap_8
XFILLER_33_147 VPWR VGND sg13cmos5l_fill_1
XFILLER_568_168 VPWR VGND sg13cmos5l_decap_8
XFILLER_92_95 VPWR VGND sg13cmos5l_decap_8
XFILLER_367_219 VPWR VGND sg13cmos5l_decap_4
XFILLER_639_42 VPWR VGND sg13cmos5l_decap_8
XFILLER_33_169 VPWR VGND sg13cmos5l_decap_8
X_1950_ _1950_/Q Tile_X0Y4_FrameData[7] VGND VPWR Tile_X0Y9_FrameStrobe[0] latch
XFILLER_358_21 VPWR VGND sg13cmos5l_decap_8
X_0901_ _0901_/Q Tile_X0Y9_FrameData[26] VGND VPWR Tile_X0Y9_FrameStrobe[7] latch
XFILLER_583_149 VPWR VGND sg13cmos5l_decap_8
X_1881_ _1881_/Q Tile_X0Y3_FrameData[16] VGND VPWR Tile_X0Y9_FrameStrobe[6] latch
XFILLER_335_105 VPWR VGND sg13cmos5l_decap_8
X_3620_ Tile_X0Y9_S2BEGb[6] _4938_/X VPWR VGND sg13cmos5l_buf_1
X_0832_ _0832_/Q Tile_X0Y9_FrameData[31] VGND VPWR Tile_X0Y9_FrameStrobe[5] latch
XFILLER_358_98 VPWR VGND sg13cmos5l_decap_8
XFILLER_508_35 VPWR VGND sg13cmos5l_decap_8
XFILLER_591_193 VPWR VGND sg13cmos5l_decap_4
XFILLER_524_238 VPWR VGND sg13cmos5l_fill_1
X_3551_ Tile_X0Y9_E6BEG[9] _4889_/X VPWR VGND sg13cmos5l_buf_1
X_0763_ _0763_/Q Tile_X0Y9_FrameData[4] VGND VPWR Tile_X0Y9_FrameStrobe[2] latch
XANTENNA__3038__X Tile_X0Y5_EE4BEG[13] VPWR VGND sg13cmos5l_antennanp
XFILLER_655_85 VPWR VGND sg13cmos5l_decap_8
XFILLER_227_36 VPWR VGND sg13cmos5l_decap_8
XFILLER_678_231 VPWR VGND sg13cmos5l_decap_8
XFILLER_350_119 VPWR VGND sg13cmos5l_decap_8
X_2502_ _2502_/Q Tile_X0Y6_FrameData[1] VGND VPWR Tile_X0Y9_FrameStrobe[1] latch
XFILLER_489_142 VPWR VGND sg13cmos5l_decap_8
XFILLER_374_53 VPWR VGND sg13cmos5l_fill_2
X_0694_ _0694_/Q Tile_X0Y9_FrameData[9] VGND VPWR Tile_X0Y9_FrameStrobe[0] latch
X_3482_ Tile_X0Y1_EE4BEG[8] _3956_/X VPWR VGND sg13cmos5l_buf_1
XFILLER_142_244 VPWR VGND sg13cmos5l_fill_2
XFILLER_343_193 VPWR VGND sg13cmos5l_decap_8
XANTENNA__2877__X Tile_X0Y6_EE4BEG[14] VPWR VGND sg13cmos5l_antennanp
X_2433_ _2433_/Q Tile_X0Y5_FrameData[4] VGND VPWR Tile_X0Y9_FrameStrobe[7] latch
XFILLER_288_248 VPWR VGND sg13cmos5l_decap_8
X_2364_ _2364_/Q Tile_X0Y5_FrameData[9] VGND VPWR Tile_X0Y9_FrameStrobe[5] latch
XFILLER_243_35 VPWR VGND sg13cmos5l_decap_8
XFILLER_646_161 VPWR VGND sg13cmos5l_decap_8
XFILLER_256_112 VPWR VGND sg13cmos5l_decap_8
X_4103_ _4103_/X _4027_/X _4135_/X _4134_/X _4026_/X _1443_/Q _1442_/Q VPWR VGND sg13cmos5l_mux4_1
XFILLER_110_141 VPWR VGND sg13cmos5l_decap_8
X_1315_ _1315_/Q Tile_X0Y1_FrameData[22] VGND VPWR Tile_X0Y9_FrameStrobe[4] latch
XFILLER_243_68 VPWR VGND sg13cmos5l_decap_4
X_2295_ _2295_/Q Tile_X0Y5_FrameData[14] VGND VPWR Tile_X0Y9_FrameStrobe[3] latch
XFILLER_56_206 VPWR VGND sg13cmos5l_decap_8
XFILLER_243_79 VPWR VGND sg13cmos5l_fill_2
XFILLER_110_163 VPWR VGND sg13cmos5l_decap_8
XFILLER_390_85 VPWR VGND sg13cmos5l_decap_8
XFILLER_110_174 VPWR VGND sg13cmos5l_fill_1
X_1246_ _1246_/Q Tile_X0Y1_FrameData[27] VGND VPWR Tile_X0Y9_FrameStrobe[2] latch
X_4034_ _4034_/X Tile_X0Y0_W1END[3] Tile_X0Y0_W2MID[0] Tile_X0Y0_W2END[0] _3852_/X
+ _1119_/Q _1118_/Q VPWR VGND sg13cmos5l_mux4_1
XFILLER_110_196 VPWR VGND sg13cmos5l_fill_2
XFILLER_405_109 VPWR VGND sg13cmos5l_decap_8
XFILLER_661_175 VPWR VGND sg13cmos5l_decap_8
XFILLER_540_77 VPWR VGND sg13cmos5l_fill_2
XFILLER_112_28 VPWR VGND sg13cmos5l_decap_8
X_1177_ _1177_/Q Tile_X0Y0_FrameData[18] VGND VPWR Tile_X0Y9_FrameStrobe[7] latch
XFILLER_460_248 VPWR VGND sg13cmos5l_decap_8
XANTENNA__3501__X Tile_X0Y1_E6BEG[11] VPWR VGND sg13cmos5l_antennanp
XFILLER_24_114 VPWR VGND sg13cmos5l_decap_8
X_0128_ _3637_/A _4842_/X _4843_/X _0856_/Q VPWR VGND sg13cmos5l_mux2_1
XFILLER_24_125 VPWR VGND sg13cmos5l_fill_2
XFILLER_602_264 VPWR VGND sg13cmos5l_decap_8
XFILLER_413_175 VPWR VGND sg13cmos5l_fill_1
XFILLER_169_119 VPWR VGND sg13cmos5l_decap_8
XFILLER_413_186 VPWR VGND sg13cmos5l_decap_8
XFILLER_574_105 VPWR VGND sg13cmos5l_decap_8
XFILLER_549_42 VPWR VGND sg13cmos5l_decap_8
X_0059_ _3178_/A _3922_/X _3923_/X _1893_/Q VPWR VGND sg13cmos5l_mux2_1
X_4936_ _4936_/X Tile_X0Y8_W1END[0] Tile_X0Y8_W2MID[3] Tile_X0Y8_W2END[3] _4790_/X
+ _0619_/Q _0618_/Q VPWR VGND sg13cmos5l_mux4_1
XFILLER_696_70 VPWR VGND sg13cmos5l_decap_8
XFILLER_268_21 VPWR VGND sg13cmos5l_decap_8
XFILLER_549_86 VPWR VGND sg13cmos5l_decap_4
XANTENNA_10 AXI_M_SOC_RDATA26 VPWR VGND sg13cmos5l_antennanp
XANTENNA_21 AXI_M_SOC_RDATA26 VPWR VGND sg13cmos5l_antennanp
X_4867_ _4867_/X Tile_X0Y9_WW4END[12] AXI_M_SOC_RDATA3 _4928_/X _4906_/X _0809_/Q
+ _0808_/Q VPWR VGND sg13cmos5l_mux4_1
XANTENNA_32 AXI_M_SOC_RDATA26 VPWR VGND sg13cmos5l_antennanp
XFILLER_220_270 VPWR VGND sg13cmos5l_fill_2
XANTENNA_43 AXI_M_SOC_RDATA8 VPWR VGND sg13cmos5l_antennanp
XANTENNA_54 Tile_X0Y0_FrameData[25] VPWR VGND sg13cmos5l_antennanp
XFILLER_326_105 VPWR VGND sg13cmos5l_decap_8
X_3818_ _3818_/X Tile_X0Y0_W2END[1] Tile_X0Y0_W6END[8] _3855_/X _3854_/X _1069_/Q
+ _1068_/Q VPWR VGND sg13cmos5l_mux4_1
XANTENNA_65 Tile_X0Y0_S2MID[1] VPWR VGND sg13cmos5l_antennanp
XANTENNA_76 Tile_X0Y0_S4END[14] VPWR VGND sg13cmos5l_antennanp
XFILLER_21_14 VPWR VGND sg13cmos5l_decap_8
XFILLER_716_187 VPWR VGND sg13cmos5l_decap_8
X_4798_ _4798_/X Tile_X0Y4_W1END[3] Tile_X0Y4_WW4END[15] Tile_X0Y4_W6END[7] _4339_/X
+ _2112_/Q _2111_/Q VPWR VGND sg13cmos5l_mux4_1
XFILLER_418_35 VPWR VGND sg13cmos5l_decap_8
XANTENNA_87 Tile_X0Y0_S4END[14] VPWR VGND sg13cmos5l_antennanp
XFILLER_515_238 VPWR VGND sg13cmos5l_decap_8
XANTENNA_98 Tile_X0Y3_W1END[3] VPWR VGND sg13cmos5l_antennanp
XFILLER_565_63 VPWR VGND sg13cmos5l_decap_8
XFILLER_118_252 VPWR VGND sg13cmos5l_fill_2
XFILLER_137_14 VPWR VGND sg13cmos5l_decap_8
X_3749_ AXI_M_SOC_ARADDR21 Tile_X0Y8_WW4END[5] Tile_X0Y8_WW4END[13] Tile_X0Y8_W6END[5]
+ _4805_/X _0493_/Q _0492_/Q VPWR VGND sg13cmos5l_mux4_1
XFILLER_192_177 VPWR VGND sg13cmos5l_decap_8
XFILLER_284_42 VPWR VGND sg13cmos5l_decap_8
XFILLER_108_7 VPWR VGND sg13cmos5l_decap_8
XFILLER_495_112 VPWR VGND sg13cmos5l_decap_8
XFILLER_279_237 VPWR VGND sg13cmos5l_decap_8
XANTENNA__2787__X Tile_X0Y3_EE4BEG[13] VPWR VGND sg13cmos5l_antennanp
XFILLER_133_255 VPWR VGND sg13cmos5l_fill_1
XFILLER_715_77 VPWR VGND sg13cmos5l_decap_8
XFILLER_279_248 VPWR VGND sg13cmos5l_fill_1
XFILLER_434_56 VPWR VGND sg13cmos5l_decap_8
XFILLER_217_91 VPWR VGND sg13cmos5l_decap_8
XFILLER_684_256 VPWR VGND sg13cmos5l_decap_4
XFILLER_581_84 VPWR VGND sg13cmos5l_decap_8
XFILLER_153_35 VPWR VGND sg13cmos5l_decap_4
XFILLER_495_189 VPWR VGND sg13cmos5l_decap_8
XFILLER_436_223 VPWR VGND sg13cmos5l_decap_8
XFILLER_477_7 VPWR VGND sg13cmos5l_decap_8
XFILLER_652_142 VPWR VGND sg13cmos5l_decap_8
XFILLER_46_22 VPWR VGND sg13cmos5l_decap_8
XFILLER_262_104 VPWR VGND sg13cmos5l_decap_8
XFILLER_652_164 VPWR VGND sg13cmos5l_decap_8
XFILLER_644_7 VPWR VGND sg13cmos5l_decap_8
XFILLER_600_14 VPWR VGND sg13cmos5l_decap_8
XFILLER_451_248 VPWR VGND sg13cmos5l_decap_8
XANTENNA__3411__X Tile_X0Y4_FrameData_O[2] VPWR VGND sg13cmos5l_antennanp
XFILLER_15_103 VPWR VGND sg13cmos5l_decap_8
XFILLER_70_231 VPWR VGND sg13cmos5l_fill_2
XFILLER_349_208 VPWR VGND sg13cmos5l_decap_8
XFILLER_270_170 VPWR VGND sg13cmos5l_decap_8
XFILLER_102_72 VPWR VGND sg13cmos5l_decap_8
XFILLER_15_169 VPWR VGND sg13cmos5l_decap_8
XFILLER_203_237 VPWR VGND sg13cmos5l_decap_4
XFILLER_62_21 VPWR VGND sg13cmos5l_decap_8
XFILLER_565_105 VPWR VGND sg13cmos5l_decap_8
XFILLER_459_42 VPWR VGND sg13cmos5l_decap_8
XFILLER_203_248 VPWR VGND sg13cmos5l_decap_4
XFILLER_102_94 VPWR VGND sg13cmos5l_decap_8
XFILLER_62_54 VPWR VGND sg13cmos5l_decap_8
XFILLER_30_128 VPWR VGND sg13cmos5l_decap_8
XFILLER_178_32 VPWR VGND sg13cmos5l_decap_8
XFILLER_459_86 VPWR VGND sg13cmos5l_decap_8
XFILLER_357_252 VPWR VGND sg13cmos5l_decap_8
XFILLER_134_0 VPWR VGND sg13cmos5l_decap_8
XFILLER_609_56 VPWR VGND sg13cmos5l_decap_8
XFILLER_372_200 VPWR VGND sg13cmos5l_decap_8
XFILLER_168_185 VPWR VGND sg13cmos5l_decap_8
XFILLER_183_111 VPWR VGND sg13cmos5l_decap_8
XFILLER_506_216 VPWR VGND sg13cmos5l_decap_8
XFILLER_7_49 VPWR VGND sg13cmos5l_decap_8
XFILLER_573_182 VPWR VGND sg13cmos5l_decap_8
XFILLER_506_238 VPWR VGND sg13cmos5l_decap_8
XFILLER_692_28 VPWR VGND sg13cmos5l_decap_8
XFILLER_475_63 VPWR VGND sg13cmos5l_decap_8
XFILLER_301_0 VPWR VGND sg13cmos5l_decap_4
XFILLER_109_263 VPWR VGND sg13cmos5l_decap_8
XFILLER_194_42 VPWR VGND sg13cmos5l_decap_4
XFILLER_194_75 VPWR VGND sg13cmos5l_decap_8
XFILLER_325_193 VPWR VGND sg13cmos5l_decap_4
XFILLER_11_91 VPWR VGND sg13cmos5l_decap_8
XFILLER_625_77 VPWR VGND sg13cmos5l_decap_8
XFILLER_340_152 VPWR VGND sg13cmos5l_fill_2
XFILLER_344_56 VPWR VGND sg13cmos5l_decap_4
XFILLER_675_267 VPWR VGND sg13cmos5l_decap_4
XFILLER_491_84 VPWR VGND sg13cmos5l_decap_8
XFILLER_670_0 VPWR VGND sg13cmos5l_decap_8
XFILLER_641_21 VPWR VGND sg13cmos5l_decap_8
XFILLER_23_7 VPWR VGND sg13cmos5l_decap_8
XFILLER_238_134 VPWR VGND sg13cmos5l_decap_4
XFILLER_427_245 VPWR VGND sg13cmos5l_decap_8
X_1100_ _1100_/Q Tile_X0Y0_FrameData[31] VGND VPWR Tile_X0Y9_FrameStrobe[5] latch
XFILLER_427_256 VPWR VGND sg13cmos5l_fill_2
XFILLER_238_167 VPWR VGND sg13cmos5l_decap_8
X_2080_ _2080_/Q Tile_X0Y4_FrameData[5] VGND VPWR Tile_X0Y9_FrameStrobe[4] latch
XFILLER_213_49 VPWR VGND sg13cmos5l_decap_8
XFILLER_641_98 VPWR VGND sg13cmos5l_decap_8
XFILLER_643_175 VPWR VGND sg13cmos5l_decap_8
XFILLER_253_126 VPWR VGND sg13cmos5l_decap_4
X_1031_ _1031_/Q Tile_X0Y0_FrameData[4] VGND VPWR Tile_X0Y9_FrameStrobe[2] latch
XFILLER_360_77 VPWR VGND sg13cmos5l_decap_8
XFILLER_510_14 VPWR VGND sg13cmos5l_decap_8
XANTENNA__3321__X Tile_X0Y4_EE4BEG[9] VPWR VGND sg13cmos5l_antennanp
XFILLER_253_159 VPWR VGND sg13cmos5l_decap_4
XFILLER_261_170 VPWR VGND sg13cmos5l_decap_8
XFILLER_410_112 VPWR VGND sg13cmos5l_decap_8
XFILLER_556_105 VPWR VGND sg13cmos5l_decap_8
XFILLER_369_42 VPWR VGND sg13cmos5l_decap_8
XFILLER_21_106 VPWR VGND sg13cmos5l_fill_2
X_2982_ Tile_X0Y8_FrameData_O[22] Tile_X0Y8_FrameData[22] VPWR VGND sg13cmos5l_buf_1
X_4721_ _4721_/X _4806_/X _4810_/X _4814_/X _4786_/X _0605_/Q _0604_/Q VPWR VGND sg13cmos5l_mux4_1
XFILLER_549_190 VPWR VGND sg13cmos5l_decap_8
X_1933_ _1933_/Q Tile_X0Y4_FrameData[24] VGND VPWR Tile_X0Y9_FrameStrobe[0] latch
XFILLER_348_241 VPWR VGND sg13cmos5l_decap_8
XFILLER_159_152 VPWR VGND sg13cmos5l_decap_8
XFILLER_410_189 VPWR VGND sg13cmos5l_decap_8
XFILLER_202_270 VPWR VGND sg13cmos5l_fill_2
XFILLER_519_56 VPWR VGND sg13cmos5l_decap_8
XFILLER_571_119 VPWR VGND sg13cmos5l_decap_8
X_4652_ _4652_/X AXI_M_SOC_RDATA20 _4687_/X _4691_/X _4674_/X _0255_/Q _0254_/Q VPWR
+ VGND sg13cmos5l_mux4_1
XFILLER_519_67 VPWR VGND sg13cmos5l_fill_1
X_1864_ _1864_/Q Tile_X0Y3_FrameData[1] VGND VPWR Tile_X0Y9_FrameStrobe[5] latch
XFILLER_385_30 VPWR VGND sg13cmos5l_fill_1
XFILLER_363_222 VPWR VGND sg13cmos5l_fill_2
XFILLER_238_35 VPWR VGND sg13cmos5l_decap_8
XFILLER_713_124 VPWR VGND sg13cmos5l_decap_8
X_3603_ Tile_X0Y9_S1BEG[1] _4825_/X VPWR VGND sg13cmos5l_buf_1
X_0815_ _0815_/Q Tile_X0Y9_FrameData[16] VGND VPWR Tile_X0Y9_FrameStrobe[4] latch
X_4583_ _4583_/X _4551_/X Tile_X0Y9_N4END[15] _4550_/X _0150_/X _2465_/Q _2464_/Q
+ VPWR VGND sg13cmos5l_mux4_1
X_1795_ _1795_/Q Tile_X0Y3_FrameData[6] VGND VPWR Tile_X0Y9_FrameStrobe[3] latch
XFILLER_323_108 VPWR VGND sg13cmos5l_fill_2
XFILLER_512_208 VPWR VGND sg13cmos5l_fill_2
X_3534_ Tile_X0Y9_E2BEGb[0] _4856_/X VPWR VGND sg13cmos5l_buf_1
XFILLER_505_260 VPWR VGND sg13cmos5l_fill_2
XFILLER_316_171 VPWR VGND sg13cmos5l_decap_8
X_0746_ _0746_/Q Tile_X0Y9_FrameData[21] VGND VPWR Tile_X0Y9_FrameStrobe[2] latch
XFILLER_316_182 VPWR VGND sg13cmos5l_fill_1
XFILLER_115_244 VPWR VGND sg13cmos5l_decap_8
XFILLER_115_255 VPWR VGND sg13cmos5l_fill_1
XFILLER_682_72 VPWR VGND sg13cmos5l_decap_4
XFILLER_666_212 VPWR VGND sg13cmos5l_decap_8
XFILLER_331_130 VPWR VGND sg13cmos5l_decap_8
XFILLER_107_28 VPWR VGND sg13cmos5l_decap_4
X_3465_ Tile_X0Y1_FrameData_O[23] Tile_X0Y1_FrameData[23] VPWR VGND sg13cmos5l_buf_1
XFILLER_535_88 VPWR VGND sg13cmos5l_fill_1
X_0677_ _0677_/Q Tile_X0Y9_FrameData[26] VGND VPWR Tile_X0Y9_FrameStrobe[0] latch
XFILLER_520_263 VPWR VGND sg13cmos5l_decap_8
XFILLER_477_156 VPWR VGND sg13cmos5l_decap_4
X_2416_ _2416_/Q Tile_X0Y5_FrameData[21] VGND VPWR Tile_X0Y9_FrameStrobe[7] latch
XFILLER_276_218 VPWR VGND sg13cmos5l_decap_4
X_3396_ Tile_X0Y2_E2BEGb[7] _4055_/X VPWR VGND sg13cmos5l_buf_1
XFILLER_551_21 VPWR VGND sg13cmos5l_decap_8
XFILLER_477_189 VPWR VGND sg13cmos5l_fill_1
XFILLER_254_89 VPWR VGND sg13cmos5l_fill_1
XFILLER_619_161 VPWR VGND sg13cmos5l_decap_8
XFILLER_492_126 VPWR VGND sg13cmos5l_decap_8
XFILLER_619_172 VPWR VGND sg13cmos5l_fill_1
X_2347_ _2347_/Q Tile_X0Y5_FrameData[26] VGND VPWR Tile_X0Y9_FrameStrobe[5] latch
XFILLER_619_194 VPWR VGND sg13cmos5l_decap_8
XFILLER_96_172 VPWR VGND sg13cmos5l_decap_8
XFILLER_123_49 VPWR VGND sg13cmos5l_decap_8
X_2278_ _2278_/Q Tile_X0Y5_FrameData[31] VGND VPWR Tile_X0Y9_FrameStrobe[3] latch
XFILLER_701_35 VPWR VGND sg13cmos5l_decap_8
XFILLER_433_215 VPWR VGND sg13cmos5l_decap_8
XFILLER_244_126 VPWR VGND sg13cmos5l_decap_4
XFILLER_270_77 VPWR VGND sg13cmos5l_decap_8
X_4017_ _4017_/X _3983_/X _0096_/X _3982_/X Tile_X0Y0_S4END[5] _1215_/Q _1214_/Q VPWR
+ VGND sg13cmos5l_mux4_1
X_1229_ _1229_/Q Tile_X0Y1_FrameData[12] VGND VPWR Tile_X0Y9_FrameStrobe[1] latch
XFILLER_420_14 VPWR VGND sg13cmos5l_decap_8
XFILLER_37_250 VPWR VGND sg13cmos5l_decap_8
XANTENNA__3231__X Tile_X0Y0_FrameStrobe_O[19] VPWR VGND sg13cmos5l_antennanp
XFILLER_244_159 VPWR VGND sg13cmos5l_decap_8
XFILLER_16_14 VPWR VGND sg13cmos5l_decap_8
XFILLER_279_42 VPWR VGND sg13cmos5l_decap_8
XFILLER_52_264 VPWR VGND sg13cmos5l_fill_1
XFILLER_500_91 VPWR VGND sg13cmos5l_decap_8
X_4919_ _4919_/X Tile_X0Y9_N1END[3] Tile_X0Y9_N4END[3] _4899_/X _0080_/X _0721_/Q
+ _0720_/Q VPWR VGND sg13cmos5l_mux4_1
XFILLER_339_241 VPWR VGND sg13cmos5l_decap_8
XFILLER_232_8 VPWR VGND sg13cmos5l_decap_8
XFILLER_32_35 VPWR VGND sg13cmos5l_decap_8
XFILLER_562_119 VPWR VGND sg13cmos5l_decap_8
XFILLER_429_56 VPWR VGND sg13cmos5l_decap_8
XFILLER_20_150 VPWR VGND sg13cmos5l_decap_8
XFILLER_225_7 VPWR VGND sg13cmos5l_decap_8
XFILLER_148_35 VPWR VGND sg13cmos5l_decap_8
XFILLER_165_133 VPWR VGND sg13cmos5l_fill_2
XFILLER_576_84 VPWR VGND sg13cmos5l_decap_8
XFILLER_555_182 VPWR VGND sg13cmos5l_decap_8
XFILLER_180_103 VPWR VGND sg13cmos5l_decap_8
XFILLER_180_114 VPWR VGND sg13cmos5l_fill_2
XFILLER_704_179 VPWR VGND sg13cmos5l_decap_4
XFILLER_106_233 VPWR VGND sg13cmos5l_decap_8
XFILLER_570_196 VPWR VGND sg13cmos5l_decap_8
XFILLER_307_182 VPWR VGND sg13cmos5l_decap_8
XFILLER_106_4 VPWR VGND sg13cmos5l_fill_1
XFILLER_699_8 VPWR VGND sg13cmos5l_decap_8
XFILLER_445_77 VPWR VGND sg13cmos5l_decap_4
XFILLER_594_7 VPWR VGND sg13cmos5l_decap_8
XFILLER_121_203 VPWR VGND sg13cmos5l_fill_1
XANTENNA__3406__X Tile_X0Y2_E1BEG[1] VPWR VGND sg13cmos5l_antennanp
XFILLER_267_207 VPWR VGND sg13cmos5l_decap_4
XFILLER_121_236 VPWR VGND sg13cmos5l_fill_1
XFILLER_483_104 VPWR VGND sg13cmos5l_decap_8
XFILLER_314_15 VPWR VGND sg13cmos5l_decap_8
XFILLER_468_189 VPWR VGND sg13cmos5l_fill_1
XFILLER_461_21 VPWR VGND sg13cmos5l_decap_8
XFILLER_409_212 VPWR VGND sg13cmos5l_fill_2
XFILLER_94_109 VPWR VGND sg13cmos5l_decap_8
XFILLER_483_137 VPWR VGND sg13cmos5l_decap_8
XFILLER_275_240 VPWR VGND sg13cmos5l_fill_2
XFILLER_611_35 VPWR VGND sg13cmos5l_decap_8
XFILLER_180_77 VPWR VGND sg13cmos5l_decap_8
XFILLER_640_112 VPWR VGND sg13cmos5l_decap_8
XFILLER_235_148 VPWR VGND sg13cmos5l_decap_8
XFILLER_28_261 VPWR VGND sg13cmos5l_decap_8
XANTENNA__3141__X Tile_X0Y7_FrameData_O[11] VPWR VGND sg13cmos5l_antennanp
XFILLER_330_36 VPWR VGND sg13cmos5l_decap_4
XFILLER_28_272 VPWR VGND sg13cmos5l_fill_1
XFILLER_73_42 VPWR VGND sg13cmos5l_decap_8
XFILLER_389_141 VPWR VGND sg13cmos5l_decap_8
XFILLER_188_203 VPWR VGND sg13cmos5l_decap_8
XFILLER_640_189 VPWR VGND sg13cmos5l_decap_8
XFILLER_251_0 VPWR VGND sg13cmos5l_decap_8
XANTENNA__2980__X Tile_X0Y8_FrameData_O[20] VPWR VGND sg13cmos5l_antennanp
XFILLER_349_0 VPWR VGND sg13cmos5l_decap_8
XFILLER_593_222 VPWR VGND sg13cmos5l_decap_8
XFILLER_410_91 VPWR VGND sg13cmos5l_decap_8
XFILLER_188_269 VPWR VGND sg13cmos5l_decap_4
XFILLER_516_0 VPWR VGND sg13cmos5l_decap_8
XFILLER_11_150 VPWR VGND sg13cmos5l_fill_1
XFILLER_486_84 VPWR VGND sg13cmos5l_decap_4
XFILLER_11_172 VPWR VGND sg13cmos5l_decap_8
XFILLER_636_21 VPWR VGND sg13cmos5l_decap_8
XFILLER_156_177 VPWR VGND sg13cmos5l_decap_4
XFILLER_171_103 VPWR VGND sg13cmos5l_fill_2
XFILLER_305_119 VPWR VGND sg13cmos5l_decap_4
X_0600_ _0600_/Q Tile_X0Y8_FrameData[7] VGND VPWR Tile_X0Y9_FrameStrobe[5] latch
XFILLER_561_174 VPWR VGND sg13cmos5l_decap_8
XFILLER_171_147 VPWR VGND sg13cmos5l_decap_8
XFILLER_208_49 VPWR VGND sg13cmos5l_decap_8
X_1580_ _1580_/Q Tile_X0Y2_FrameData[5] VGND VPWR Tile_X0Y9_FrameStrobe[4] latch
XFILLER_636_98 VPWR VGND sg13cmos5l_decap_8
XFILLER_360_258 VPWR VGND sg13cmos5l_fill_2
XFILLER_355_77 VPWR VGND sg13cmos5l_decap_8
X_0531_ _0531_/Q Tile_X0Y8_FrameData[12] VGND VPWR Tile_X0Y9_FrameStrobe[3] latch
XFILLER_648_223 VPWR VGND sg13cmos5l_decap_8
XFILLER_505_14 VPWR VGND sg13cmos5l_decap_8
XFILLER_313_152 VPWR VGND sg13cmos5l_decap_8
XANTENNA__3316__X Tile_X0Y4_EE4BEG[4] VPWR VGND sg13cmos5l_antennanp
XFILLER_502_252 VPWR VGND sg13cmos5l_decap_8
XFILLER_98_94 VPWR VGND sg13cmos5l_decap_8
XFILLER_112_225 VPWR VGND sg13cmos5l_fill_2
XFILLER_652_42 VPWR VGND sg13cmos5l_decap_8
X_0462_ _0462_/Q Tile_X0Y8_FrameData[17] VGND VPWR Tile_X0Y9_FrameStrobe[1] latch
X_3250_ Tile_X0Y0_FrameData_O[18] Tile_X0Y0_FrameData[18] VPWR VGND sg13cmos5l_buf_1
XFILLER_371_21 VPWR VGND sg13cmos5l_decap_8
XFILLER_112_269 VPWR VGND sg13cmos5l_decap_4
XFILLER_85_109 VPWR VGND sg13cmos5l_decap_8
X_2201_ _2201_/Q Tile_X0Y5_FrameData[12] VGND VPWR Tile_X0Y9_FrameStrobe[0] latch
X_0393_ _0393_/Q Tile_X0Y7_FrameData[22] VGND VPWR Tile_X0Y9_FrameStrobe[7] latch
X_3181_ Tile_X0Y0_N4BEG[5] _3181_/A VPWR VGND sg13cmos5l_buf_1
XFILLER_663_259 VPWR VGND sg13cmos5l_decap_4
XFILLER_616_120 VPWR VGND sg13cmos5l_decap_8
XFILLER_266_240 VPWR VGND sg13cmos5l_decap_8
X_2132_ _2132_/Q Tile_X0Y4_FrameData[17] VGND VPWR Tile_X0Y9_FrameStrobe[6] latch
XFILLER_93_131 VPWR VGND sg13cmos5l_decap_8
XFILLER_616_164 VPWR VGND sg13cmos5l_fill_1
XFILLER_521_35 VPWR VGND sg13cmos5l_decap_8
XFILLER_304_70 VPWR VGND sg13cmos5l_decap_8
XFILLER_281_210 VPWR VGND sg13cmos5l_decap_4
XFILLER_616_186 VPWR VGND sg13cmos5l_decap_8
XFILLER_240_14 VPWR VGND sg13cmos5l_decap_8
X_2063_ _2063_/Q Tile_X0Y4_FrameData[22] VGND VPWR Tile_X0Y9_FrameStrobe[4] latch
XFILLER_415_248 VPWR VGND sg13cmos5l_decap_8
XANTENNA__3051__X Tile_X0Y5_FrameData_O[10] VPWR VGND sg13cmos5l_antennanp
XFILLER_415_259 VPWR VGND sg13cmos5l_fill_1
X_1014_ _1014_/Q Tile_X0Y0_FrameData[21] VGND VPWR Tile_X0Y9_FrameStrobe[2] latch
XFILLER_241_118 VPWR VGND sg13cmos5l_fill_1
XFILLER_597_28 VPWR VGND sg13cmos5l_decap_8
XFILLER_34_231 VPWR VGND sg13cmos5l_decap_8
XFILLER_234_170 VPWR VGND sg13cmos5l_fill_1
XANTENNA__2890__X Tile_X0Y6_FrameData_O[11] VPWR VGND sg13cmos5l_antennanp
XFILLER_584_200 VPWR VGND sg13cmos5l_decap_8
XFILLER_179_247 VPWR VGND sg13cmos5l_decap_8
XFILLER_677_50 VPWR VGND sg13cmos5l_decap_8
XFILLER_97_0 VPWR VGND sg13cmos5l_decap_8
X_2965_ Tile_X0Y8_FrameData_O[5] Tile_X0Y8_FrameData[5] VPWR VGND sg13cmos5l_buf_1
X_4704_ _4704_/X Tile_X0Y6_W2MID[5] Tile_X0Y6_W2END[5] Tile_X0Y6_W6END[10] _4557_/X
+ _2647_/Q _2646_/Q VPWR VGND sg13cmos5l_mux4_1
XFILLER_395_199 VPWR VGND sg13cmos5l_decap_8
X_1916_ _1916_/Q Tile_X0Y3_FrameData[13] VGND VPWR Tile_X0Y9_FrameStrobe[7] latch
X_2896_ Tile_X0Y6_FrameData_O[17] Tile_X0Y6_FrameData[17] VPWR VGND sg13cmos5l_buf_1
XFILLER_537_182 VPWR VGND sg13cmos5l_decap_8
XFILLER_546_21 VPWR VGND sg13cmos5l_decap_8
XFILLER_8_70 VPWR VGND sg13cmos5l_decap_8
XFILLER_698_112 VPWR VGND sg13cmos5l_decap_8
X_4635_ _4635_/X Tile_X0Y7_WW4END[8] AXI_M_SOC_RDATA23 _4692_/X _4669_/X _0289_/Q
+ _0288_/Q VPWR VGND sg13cmos5l_mux4_1
XFILLER_336_255 VPWR VGND sg13cmos5l_decap_8
X_1847_ _1847_/Q Tile_X0Y3_FrameData[18] VGND VPWR Tile_X0Y9_FrameStrobe[5] latch
XFILLER_351_203 VPWR VGND sg13cmos5l_decap_8
XFILLER_693_71 VPWR VGND sg13cmos5l_decap_8
XFILLER_552_163 VPWR VGND sg13cmos5l_decap_8
XFILLER_698_156 VPWR VGND sg13cmos5l_decap_8
XFILLER_701_105 VPWR VGND sg13cmos5l_decap_8
X_4566_ _4566_/X Tile_X0Y2_W1END[3] Tile_X0Y2_WW4END[15] Tile_X0Y2_W6END[7] _4119_/X
+ _1604_/Q _1603_/Q VPWR VGND sg13cmos5l_mux4_1
XFILLER_546_98 VPWR VGND sg13cmos5l_decap_8
XFILLER_118_49 VPWR VGND sg13cmos5l_decap_8
X_1778_ _1778_/Q Tile_X0Y3_FrameData[23] VGND VPWR Tile_X0Y9_FrameStrobe[3] latch
X_3517_ Tile_X0Y1_E2BEG[7] _3939_/X VPWR VGND sg13cmos5l_buf_1
XFILLER_265_77 VPWR VGND sg13cmos5l_decap_8
X_0729_ _0729_/Q Tile_X0Y9_FrameData[6] VGND VPWR Tile_X0Y9_FrameStrobe[1] latch
XFILLER_415_14 VPWR VGND sg13cmos5l_decap_8
X_4497_ _4497_/X Tile_X0Y6_W2MID[6] AXI_M_SOC_RDATA25 _4555_/X _4554_/X _2613_/Q _2612_/Q
+ VPWR VGND sg13cmos5l_mux4_1
XANTENNA__3226__X Tile_X0Y0_FrameStrobe_O[14] VPWR VGND sg13cmos5l_antennanp
XFILLER_639_245 VPWR VGND sg13cmos5l_decap_8
XFILLER_562_42 VPWR VGND sg13cmos5l_decap_8
XFILLER_304_174 VPWR VGND sg13cmos5l_fill_1
X_3448_ Tile_X0Y1_FrameData_O[6] Tile_X0Y1_FrameData[6] VPWR VGND sg13cmos5l_buf_1
XFILLER_281_21 VPWR VGND sg13cmos5l_decap_8
XFILLER_654_215 VPWR VGND sg13cmos5l_fill_1
XFILLER_103_269 VPWR VGND sg13cmos5l_decap_4
XFILLER_465_137 VPWR VGND sg13cmos5l_decap_4
XFILLER_654_248 VPWR VGND sg13cmos5l_decap_8
X_3379_ Tile_X0Y2_E6BEG[2] _4074_/X VPWR VGND sg13cmos5l_buf_1
XFILLER_69_161 VPWR VGND sg13cmos5l_decap_8
XFILLER_257_251 VPWR VGND sg13cmos5l_decap_8
XFILLER_712_56 VPWR VGND sg13cmos5l_decap_8
XFILLER_281_98 VPWR VGND sg13cmos5l_decap_8
XFILLER_182_8 VPWR VGND sg13cmos5l_decap_8
XFILLER_217_115 VPWR VGND sg13cmos5l_decap_8
XFILLER_431_35 VPWR VGND sg13cmos5l_decap_8
XFILLER_214_70 VPWR VGND sg13cmos5l_decap_8
XFILLER_473_181 VPWR VGND sg13cmos5l_decap_8
XFILLER_27_35 VPWR VGND sg13cmos5l_decap_8
XFILLER_150_14 VPWR VGND sg13cmos5l_decap_8
XFILLER_175_7 VPWR VGND sg13cmos5l_decap_8
XFILLER_84_175 VPWR VGND sg13cmos5l_decap_8
XFILLER_622_145 VPWR VGND sg13cmos5l_decap_8
XFILLER_27_68 VPWR VGND sg13cmos5l_decap_4
XFILLER_421_218 VPWR VGND sg13cmos5l_fill_2
XFILLER_386_111 VPWR VGND sg13cmos5l_decap_4
XFILLER_342_7 VPWR VGND sg13cmos5l_decap_8
XFILLER_300_28 VPWR VGND sg13cmos5l_decap_8
XFILLER_40_212 VPWR VGND sg13cmos5l_decap_8
XFILLER_43_34 VPWR VGND sg13cmos5l_decap_8
XFILLER_386_166 VPWR VGND sg13cmos5l_decap_8
XFILLER_575_266 VPWR VGND sg13cmos5l_decap_8
XFILLER_240_184 VPWR VGND sg13cmos5l_decap_8
XFILLER_535_119 VPWR VGND sg13cmos5l_fill_1
XFILLER_159_67 VPWR VGND sg13cmos5l_decap_8
XFILLER_590_225 VPWR VGND sg13cmos5l_decap_8
XFILLER_327_211 VPWR VGND sg13cmos5l_decap_8
XFILLER_607_7 VPWR VGND sg13cmos5l_decap_8
XFILLER_138_133 VPWR VGND sg13cmos5l_decap_8
XFILLER_223_4 VPWR VGND sg13cmos5l_fill_1
XFILLER_456_21 VPWR VGND sg13cmos5l_decap_8
XFILLER_689_134 VPWR VGND sg13cmos5l_decap_8
XFILLER_342_214 VPWR VGND sg13cmos5l_decap_8
XFILLER_4_135 VPWR VGND sg13cmos5l_decap_8
XFILLER_606_35 VPWR VGND sg13cmos5l_decap_8
XFILLER_606_68 VPWR VGND sg13cmos5l_decap_4
XFILLER_325_14 VPWR VGND sg13cmos5l_decap_8
XFILLER_4_28 VPWR VGND sg13cmos5l_decap_8
XANTENNA__3136__X Tile_X0Y7_FrameData_O[6] VPWR VGND sg13cmos5l_antennanp
XFILLER_472_42 VPWR VGND sg13cmos5l_decap_8
XFILLER_310_100 VPWR VGND sg13cmos5l_decap_4
XFILLER_310_111 VPWR VGND sg13cmos5l_fill_1
XFILLER_68_42 VPWR VGND sg13cmos5l_decap_8
XFILLER_191_21 VPWR VGND sg13cmos5l_decap_8
XFILLER_310_133 VPWR VGND sg13cmos5l_decap_8
XFILLER_472_97 VPWR VGND sg13cmos5l_decap_4
XFILLER_299_0 VPWR VGND sg13cmos5l_decap_8
XANTENNA__2975__X Tile_X0Y8_FrameData_O[15] VPWR VGND sg13cmos5l_antennanp
XFILLER_456_159 VPWR VGND sg13cmos5l_fill_1
XFILLER_645_259 VPWR VGND sg13cmos5l_decap_8
XFILLER_622_56 VPWR VGND sg13cmos5l_decap_8
XFILLER_405_91 VPWR VGND sg13cmos5l_decap_4
XFILLER_124_70 VPWR VGND sg13cmos5l_decap_8
XFILLER_208_126 VPWR VGND sg13cmos5l_decap_8
XFILLER_660_229 VPWR VGND sg13cmos5l_fill_1
XFILLER_341_35 VPWR VGND sg13cmos5l_decap_8
XFILLER_466_0 VPWR VGND sg13cmos5l_decap_8
XFILLER_464_192 VPWR VGND sg13cmos5l_decap_8
XFILLER_263_243 VPWR VGND sg13cmos5l_decap_8
XFILLER_263_254 VPWR VGND sg13cmos5l_fill_2
XFILLER_84_63 VPWR VGND sg13cmos5l_decap_8
XFILLER_698_49 VPWR VGND sg13cmos5l_decap_8
XFILLER_613_156 VPWR VGND sg13cmos5l_decap_8
XFILLER_90_134 VPWR VGND sg13cmos5l_decap_8
XFILLER_633_0 VPWR VGND sg13cmos5l_decap_8
XFILLER_210_28 VPWR VGND sg13cmos5l_decap_8
XFILLER_377_111 VPWR VGND sg13cmos5l_decap_4
XFILLER_31_201 VPWR VGND sg13cmos5l_decap_8
XFILLER_140_91 VPWR VGND sg13cmos5l_decap_8
XFILLER_90_7 VPWR VGND sg13cmos5l_decap_8
XFILLER_176_206 VPWR VGND sg13cmos5l_decap_8
XFILLER_566_255 VPWR VGND sg13cmos5l_fill_2
XFILLER_377_166 VPWR VGND sg13cmos5l_decap_8
XFILLER_377_177 VPWR VGND sg13cmos5l_fill_1
XFILLER_647_42 VPWR VGND sg13cmos5l_decap_8
XFILLER_377_199 VPWR VGND sg13cmos5l_decap_8
X_2750_ Tile_X0Y3_FrameData_O[8] Tile_X0Y3_FrameData[8] VPWR VGND sg13cmos5l_buf_1
XFILLER_129_133 VPWR VGND sg13cmos5l_fill_2
XFILLER_708_271 VPWR VGND sg13cmos5l_fill_2
XFILLER_519_193 VPWR VGND sg13cmos5l_fill_2
XFILLER_392_158 VPWR VGND sg13cmos5l_decap_8
X_1701_ _1701_/Q Tile_X0Y3_FrameData[4] VGND VPWR Tile_X0Y9_FrameStrobe[0] latch
XFILLER_318_255 VPWR VGND sg13cmos5l_decap_8
XFILLER_366_43 VPWR VGND sg13cmos5l_decap_8
X_2681_ _2681_/Q Tile_X0Y6_FrameData[14] VGND VPWR Tile_X0Y9_FrameStrobe[7] latch
XFILLER_184_272 VPWR VGND sg13cmos5l_fill_1
XFILLER_333_203 VPWR VGND sg13cmos5l_decap_4
XFILLER_129_199 VPWR VGND sg13cmos5l_decap_8
X_4420_ _4420_/X Tile_X0Y4_W1END[1] Tile_X0Y4_W6END[9] _4349_/X _4303_/X _2143_/Q
+ _2142_/Q VPWR VGND sg13cmos5l_mux4_1
X_1632_ _1632_/Q Tile_X0Y2_FrameData[17] VGND VPWR Tile_X0Y9_FrameStrobe[6] latch
XFILLER_534_185 VPWR VGND sg13cmos5l_fill_1
XFILLER_516_35 VPWR VGND sg13cmos5l_decap_8
XFILLER_333_258 VPWR VGND sg13cmos5l_fill_2
XFILLER_695_126 VPWR VGND sg13cmos5l_decap_8
X_4351_ _4351_/X _4311_/X _0040_/X _4310_/X _0109_/X _1951_/Q _1950_/Q VPWR VGND sg13cmos5l_mux4_1
XFILLER_695_137 VPWR VGND sg13cmos5l_fill_2
XFILLER_663_63 VPWR VGND sg13cmos5l_decap_8
X_1563_ _1563_/Q Tile_X0Y2_FrameData[22] VGND VPWR Tile_X0Y9_FrameStrobe[4] latch
XFILLER_235_14 VPWR VGND sg13cmos5l_decap_8
XANTENNA__3046__X Tile_X0Y5_FrameData_O[5] VPWR VGND sg13cmos5l_antennanp
XFILLER_695_159 VPWR VGND sg13cmos5l_decap_8
XFILLER_487_240 VPWR VGND sg13cmos5l_decap_8
XFILLER_98_223 VPWR VGND sg13cmos5l_fill_2
XFILLER_382_42 VPWR VGND sg13cmos5l_decap_8
X_3302_ Tile_X0Y0_E2BEG[2] _3806_/X VPWR VGND sg13cmos5l_buf_1
X_0514_ _0514_/Q Tile_X0Y8_FrameData[29] VGND VPWR Tile_X0Y9_FrameStrobe[3] latch
X_4282_ _4282_/X Tile_X0Y4_WW4END[5] AXI_M_SOC_BRESP1 _4341_/X _4316_/X _2049_/Q _2048_/Q
+ VPWR VGND sg13cmos5l_mux4_1
XFILLER_636_204 VPWR VGND sg13cmos5l_fill_1
X_1494_ _1494_/Q Tile_X0Y2_FrameData[27] VGND VPWR Tile_X0Y9_FrameStrobe[2] latch
XFILLER_301_133 VPWR VGND sg13cmos5l_decap_8
XFILLER_298_195 VPWR VGND sg13cmos5l_decap_4
XFILLER_58_109 VPWR VGND sg13cmos5l_decap_8
XFILLER_447_137 VPWR VGND sg13cmos5l_decap_8
XANTENNA__2885__X Tile_X0Y6_FrameData_O[6] VPWR VGND sg13cmos5l_antennanp
X_3233_ Tile_X0Y0_FrameData_O[1] Tile_X0Y0_FrameData[1] VPWR VGND sg13cmos5l_buf_1
X_0445_ _0445_/Q Tile_X0Y8_FrameData[2] VGND VPWR Tile_X0Y9_FrameStrobe[0] latch
XFILLER_636_248 VPWR VGND sg13cmos5l_decap_4
XFILLER_100_228 VPWR VGND sg13cmos5l_decap_8
XFILLER_532_56 VPWR VGND sg13cmos5l_decap_4
XFILLER_462_107 VPWR VGND sg13cmos5l_decap_8
XFILLER_532_67 VPWR VGND sg13cmos5l_decap_4
X_3164_ Tile_X0Y4_E6BEG[1] _4289_/X VPWR VGND sg13cmos5l_buf_1
XFILLER_12_0 VPWR VGND sg13cmos5l_decap_8
X_0376_ _0376_/Q Tile_X0Y7_FrameData[7] VGND VPWR Tile_X0Y9_FrameStrobe[6] latch
XFILLER_251_35 VPWR VGND sg13cmos5l_decap_8
XFILLER_455_170 VPWR VGND sg13cmos5l_decap_8
XFILLER_254_221 VPWR VGND sg13cmos5l_decap_8
X_2115_ _2115_/Q Tile_X0Y4_FrameData[2] VGND VPWR Tile_X0Y9_FrameStrobe[5] latch
XFILLER_604_123 VPWR VGND sg13cmos5l_decap_8
XFILLER_66_175 VPWR VGND sg13cmos5l_decap_8
X_3095_ Tile_X0Y7_E2BEGb[1] _4621_/X VPWR VGND sg13cmos5l_buf_1
XFILLER_403_207 VPWR VGND sg13cmos5l_decap_8
XFILLER_81_145 VPWR VGND sg13cmos5l_decap_8
X_2046_ _2046_/Q Tile_X0Y4_FrameData[7] VGND VPWR Tile_X0Y9_FrameStrobe[3] latch
XFILLER_604_178 VPWR VGND sg13cmos5l_decap_8
XFILLER_688_71 VPWR VGND sg13cmos5l_decap_4
XFILLER_120_28 VPWR VGND sg13cmos5l_decap_8
XFILLER_222_140 VPWR VGND sg13cmos5l_decap_8
XFILLER_222_162 VPWR VGND sg13cmos5l_decap_8
XFILLER_368_155 VPWR VGND sg13cmos5l_decap_4
X_3997_ _3997_/X Tile_X0Y5_W1END[0] Tile_X0Y5_WW4END[0] Tile_X0Y5_W6END[8] _4451_/X
+ _2415_/Q _2414_/Q VPWR VGND sg13cmos5l_mux4_1
XFILLER_572_203 VPWR VGND sg13cmos5l_decap_8
XFILLER_368_188 VPWR VGND sg13cmos5l_decap_8
XFILLER_706_219 VPWR VGND sg13cmos5l_decap_8
XFILLER_557_42 VPWR VGND sg13cmos5l_decap_8
X_2948_ Tile_X0Y8_EE4BEG[4] _4748_/X VPWR VGND sg13cmos5l_buf_1
XFILLER_383_147 VPWR VGND sg13cmos5l_decap_8
XFILLER_276_21 VPWR VGND sg13cmos5l_decap_8
XFILLER_175_250 VPWR VGND sg13cmos5l_decap_8
XFILLER_309_255 VPWR VGND sg13cmos5l_decap_4
X_2879_ Tile_X0Y6_FrameData_O[0] Tile_X0Y6_FrameData[0] VPWR VGND sg13cmos5l_buf_1
XFILLER_324_203 VPWR VGND sg13cmos5l_fill_1
XFILLER_525_163 VPWR VGND sg13cmos5l_decap_8
XFILLER_324_214 VPWR VGND sg13cmos5l_decap_8
XFILLER_707_56 VPWR VGND sg13cmos5l_decap_8
X_4618_ _4618_/X Tile_X0Y7_W2MID[1] AXI_M_SOC_RDATA22 _4671_/X _4670_/X _0323_/Q _0322_/Q
+ VPWR VGND sg13cmos5l_mux4_1
XFILLER_540_111 VPWR VGND sg13cmos5l_decap_8
XFILLER_276_98 VPWR VGND sg13cmos5l_decap_8
XFILLER_190_242 VPWR VGND sg13cmos5l_decap_8
XFILLER_525_196 VPWR VGND sg13cmos5l_decap_8
XFILLER_426_35 VPWR VGND sg13cmos5l_decap_8
XFILLER_209_70 VPWR VGND sg13cmos5l_decap_8
XFILLER_540_144 VPWR VGND sg13cmos5l_fill_1
XFILLER_573_63 VPWR VGND sg13cmos5l_decap_8
XFILLER_145_14 VPWR VGND sg13cmos5l_decap_8
X_4549_ _4549_/X Tile_X0Y7_W1END[2] Tile_X0Y7_W6END[6] _4698_/X _4658_/X _0411_/Q
+ _0410_/Q VPWR VGND sg13cmos5l_mux4_1
XFILLER_292_42 VPWR VGND sg13cmos5l_decap_8
XFILLER_89_245 VPWR VGND sg13cmos5l_fill_1
XFILLER_289_184 VPWR VGND sg13cmos5l_decap_8
XFILLER_89_267 VPWR VGND sg13cmos5l_decap_4
XANTENNA__2795__X Tile_X0Y3_E6BEG[5] VPWR VGND sg13cmos5l_antennanp
XFILLER_438_137 VPWR VGND sg13cmos5l_decap_8
XFILLER_292_7 VPWR VGND sg13cmos5l_decap_8
XFILLER_57_142 VPWR VGND sg13cmos5l_decap_8
XFILLER_57_153 VPWR VGND sg13cmos5l_fill_1
XFILLER_557_7 VPWR VGND sg13cmos5l_decap_8
XFILLER_461_140 VPWR VGND sg13cmos5l_decap_4
XFILLER_57_197 VPWR VGND sg13cmos5l_decap_4
XFILLER_610_115 VPWR VGND sg13cmos5l_decap_8
XFILLER_54_44 VPWR VGND sg13cmos5l_decap_8
XFILLER_72_178 VPWR VGND sg13cmos5l_decap_8
XFILLER_54_55 VPWR VGND sg13cmos5l_decap_8
XFILLER_610_159 VPWR VGND sg13cmos5l_fill_2
XFILLER_402_240 VPWR VGND sg13cmos5l_decap_8
XFILLER_213_151 VPWR VGND sg13cmos5l_decap_8
XFILLER_110_61 VPWR VGND sg13cmos5l_fill_1
XFILLER_508_119 VPWR VGND sg13cmos5l_decap_4
XFILLER_467_42 VPWR VGND sg13cmos5l_decap_4
XFILLER_110_83 VPWR VGND sg13cmos5l_decap_8
XFILLER_9_249 VPWR VGND sg13cmos5l_decap_8
XFILLER_70_43 VPWR VGND sg13cmos5l_decap_8
XFILLER_186_21 VPWR VGND sg13cmos5l_decap_8
XFILLER_467_86 VPWR VGND sg13cmos5l_decap_8
XFILLER_214_0 VPWR VGND sg13cmos5l_decap_8
XFILLER_617_56 VPWR VGND sg13cmos5l_decap_8
XFILLER_181_220 VPWR VGND sg13cmos5l_decap_8
XFILLER_126_147 VPWR VGND sg13cmos5l_decap_8
XFILLER_119_70 VPWR VGND sg13cmos5l_decap_8
XFILLER_336_35 VPWR VGND sg13cmos5l_decap_8
XFILLER_315_258 VPWR VGND sg13cmos5l_decap_8
XFILLER_119_92 VPWR VGND sg13cmos5l_decap_8
XFILLER_336_68 VPWR VGND sg13cmos5l_decap_8
XFILLER_79_63 VPWR VGND sg13cmos5l_decap_8
XFILLER_469_251 VPWR VGND sg13cmos5l_decap_8
XFILLER_134_191 VPWR VGND sg13cmos5l_decap_8
XFILLER_692_129 VPWR VGND sg13cmos5l_decap_8
XFILLER_583_0 VPWR VGND sg13cmos5l_decap_8
XFILLER_429_126 VPWR VGND sg13cmos5l_decap_8
XFILLER_205_28 VPWR VGND sg13cmos5l_decap_8
XFILLER_633_77 VPWR VGND sg13cmos5l_decap_8
XFILLER_618_237 VPWR VGND sg13cmos5l_fill_1
XFILLER_295_154 VPWR VGND sg13cmos5l_decap_8
XFILLER_618_259 VPWR VGND sg13cmos5l_decap_8
XFILLER_135_91 VPWR VGND sg13cmos5l_decap_8
XFILLER_352_56 VPWR VGND sg13cmos5l_decap_8
XFILLER_0_182 VPWR VGND sg13cmos5l_fill_1
X_0230_ _0230_/Q Tile_X0Y7_FrameData[25] VGND VPWR Tile_X0Y9_FrameStrobe[2] latch
XFILLER_48_142 VPWR VGND sg13cmos5l_fill_2
XFILLER_95_84 VPWR VGND sg13cmos5l_decap_8
XFILLER_236_232 VPWR VGND sg13cmos5l_fill_1
X_0161_ _0161_/Q Tile_X0Y7_FrameData[30] VGND VPWR Tile_X0Y9_FrameStrobe[0] latch
X_0092_ _3623_/A _4486_/X _4487_/X _2630_/Q VPWR VGND sg13cmos5l_mux2_1
XFILLER_452_184 VPWR VGND sg13cmos5l_decap_8
XFILLER_63_167 VPWR VGND sg13cmos5l_decap_8
X_3920_ _3920_/X Tile_X0Y3_W1END[3] Tile_X0Y3_WW4END[3] Tile_X0Y3_W6END[11] _4225_/X
+ _1892_/Q _1891_/Q VPWR VGND sg13cmos5l_mux4_1
XFILLER_598_199 VPWR VGND sg13cmos5l_fill_1
XFILLER_539_211 VPWR VGND sg13cmos5l_decap_8
XFILLER_204_140 VPWR VGND sg13cmos5l_fill_2
XFILLER_301_71 VPWR VGND sg13cmos5l_decap_4
XFILLER_149_206 VPWR VGND sg13cmos5l_decap_8
X_3851_ _3851_/X Tile_X0Y1_W1END[3] Tile_X0Y1_W6END[7] _3996_/X _3979_/X _1419_/Q
+ _1418_/Q VPWR VGND sg13cmos5l_mux4_1
XFILLER_658_63 VPWR VGND sg13cmos5l_decap_8
XFILLER_539_255 VPWR VGND sg13cmos5l_decap_8
X_2802_ Tile_X0Y3_E2BEGb[0] _4156_/X VPWR VGND sg13cmos5l_buf_1
XFILLER_377_42 VPWR VGND sg13cmos5l_fill_2
X_3782_ _3782_/X Tile_X0Y0_W1END[2] Tile_X0Y0_W6END[6] _3867_/X _3861_/X _1173_/Q
+ _1172_/Q VPWR VGND sg13cmos5l_mux4_1
X_0994_ _0994_/Q Tile_X0Y0_FrameData[9] VGND VPWR Tile_X0Y9_FrameStrobe[1] latch
X_2733_ _4892_/A3 VPWR VGND sg13cmos5l_tielo
XFILLER_507_163 VPWR VGND sg13cmos5l_decap_4
XFILLER_527_56 VPWR VGND sg13cmos5l_decap_8
XFILLER_507_174 VPWR VGND sg13cmos5l_decap_8
X_2664_ _2664_/Q Tile_X0Y6_FrameData[31] VGND VPWR Tile_X0Y9_FrameStrobe[7] latch
XFILLER_668_104 VPWR VGND sg13cmos5l_fill_2
XFILLER_117_158 VPWR VGND sg13cmos5l_decap_8
XFILLER_674_84 VPWR VGND sg13cmos5l_decap_8
XFILLER_172_264 VPWR VGND sg13cmos5l_decap_8
X_4403_ _4403_/X Tile_X0Y5_WW4END[0] AXI_M_SOC_RVALID _4451_/X _4467_/X _2297_/Q _2296_/Q
+ VPWR VGND sg13cmos5l_mux4_1
X_1615_ _1615_/Q Tile_X0Y2_FrameData[2] VGND VPWR Tile_X0Y9_FrameStrobe[5] latch
XFILLER_246_57 VPWR VGND sg13cmos5l_fill_2
XFILLER_522_166 VPWR VGND sg13cmos5l_decap_8
X_2595_ _2595_/Q Tile_X0Y6_FrameData[4] VGND VPWR Tile_X0Y9_FrameStrobe[4] latch
XFILLER_321_228 VPWR VGND sg13cmos5l_decap_8
X_4334_ _4334_/X Tile_X0Y8_W1END[3] Tile_X0Y8_WW4END[3] Tile_X0Y8_W6END[11] _4803_/X
+ _0638_/Q _0637_/Q VPWR VGND sg13cmos5l_mux4_1
X_1546_ _1546_/Q Tile_X0Y2_FrameData[7] VGND VPWR Tile_X0Y9_FrameStrobe[3] latch
XFILLER_609_215 VPWR VGND sg13cmos5l_decap_8
XFILLER_676_170 VPWR VGND sg13cmos5l_decap_8
XFILLER_115_28 VPWR VGND sg13cmos5l_decap_8
XFILLER_543_77 VPWR VGND sg13cmos5l_decap_8
XFILLER_140_161 VPWR VGND sg13cmos5l_decap_8
X_4265_ _4265_/X Tile_X0Y4_W2END[6] AXI_M_SOC_BRESP0 _4315_/X _4314_/X _2083_/Q _2082_/Q
+ VPWR VGND sg13cmos5l_mux4_1
X_1477_ _1477_/Q Tile_X0Y2_FrameData[12] VGND VPWR Tile_X0Y9_FrameStrobe[1] latch
XFILLER_543_99 VPWR VGND sg13cmos5l_decap_8
XFILLER_286_154 VPWR VGND sg13cmos5l_decap_8
XANTENNA__3504__X Tile_X0Y1_E2BEGb[2] VPWR VGND sg13cmos5l_antennanp
XFILLER_262_56 VPWR VGND sg13cmos5l_decap_8
X_3216_ Tile_X0Y0_FrameStrobe_O[4] Tile_X0Y9_FrameStrobe[4] VPWR VGND sg13cmos5l_buf_1
XFILLER_691_162 VPWR VGND sg13cmos5l_fill_1
XFILLER_262_67 VPWR VGND sg13cmos5l_fill_2
X_0428_ _0428_/Q Tile_X0Y8_FrameData[19] VGND VPWR Tile_X0Y9_FrameStrobe[0] latch
XFILLER_490_213 VPWR VGND sg13cmos5l_decap_8
X_4196_ _4196_/X Tile_X0Y2_W1END[1] Tile_X0Y2_W6END[9] _4110_/X _4085_/X _1635_/Q
+ _1634_/Q VPWR VGND sg13cmos5l_mux4_1
XFILLER_624_229 VPWR VGND sg13cmos5l_decap_8
XFILLER_412_15 VPWR VGND sg13cmos5l_decap_8
XFILLER_39_142 VPWR VGND sg13cmos5l_decap_8
X_3147_ Tile_X0Y7_FrameData_O[17] Tile_X0Y7_FrameData[17] VPWR VGND sg13cmos5l_buf_1
X_0359_ _0359_/Q Tile_X0Y7_FrameData[24] VGND VPWR Tile_X0Y9_FrameStrobe[6] latch
XFILLER_388_206 VPWR VGND sg13cmos5l_decap_8
X_3078_ Tile_X0Y4_E2BEGb[4] _4268_/X VPWR VGND sg13cmos5l_buf_1
XFILLER_199_128 VPWR VGND sg13cmos5l_decap_8
XFILLER_199_139 VPWR VGND sg13cmos5l_fill_1
X_2029_ _2029_/Q Tile_X0Y4_FrameData[24] VGND VPWR Tile_X0Y9_FrameStrobe[3] latch
XFILLER_242_268 VPWR VGND sg13cmos5l_decap_4
XFILLER_24_14 VPWR VGND sg13cmos5l_decap_8
XFILLER_568_63 VPWR VGND sg13cmos5l_decap_8
XFILLER_24_58 VPWR VGND sg13cmos5l_fill_1
XFILLER_287_42 VPWR VGND sg13cmos5l_decap_8
XFILLER_10_215 VPWR VGND sg13cmos5l_fill_2
XFILLER_210_154 VPWR VGND sg13cmos5l_decap_8
XFILLER_138_7 VPWR VGND sg13cmos5l_decap_8
XFILLER_356_147 VPWR VGND sg13cmos5l_decap_8
XFILLER_699_240 VPWR VGND sg13cmos5l_decap_8
XFILLER_699_251 VPWR VGND sg13cmos5l_fill_2
XFILLER_437_56 VPWR VGND sg13cmos5l_decap_8
XFILLER_305_7 VPWR VGND sg13cmos5l_decap_8
XFILLER_108_147 VPWR VGND sg13cmos5l_decap_8
XFILLER_163_242 VPWR VGND sg13cmos5l_decap_8
XFILLER_584_84 VPWR VGND sg13cmos5l_decap_8
XFILLER_312_217 VPWR VGND sg13cmos5l_decap_8
XFILLER_49_22 VPWR VGND sg13cmos5l_decap_8
XFILLER_453_44 VPWR VGND sg13cmos5l_fill_1
XFILLER_306_49 VPWR VGND sg13cmos5l_decap_4
XFILLER_667_170 VPWR VGND sg13cmos5l_decap_8
XFILLER_49_33 VPWR VGND sg13cmos5l_fill_1
XFILLER_453_77 VPWR VGND sg13cmos5l_fill_2
XFILLER_320_250 VPWR VGND sg13cmos5l_decap_8
XFILLER_131_161 VPWR VGND sg13cmos5l_fill_2
XFILLER_674_7 VPWR VGND sg13cmos5l_decap_8
XFILLER_466_243 VPWR VGND sg13cmos5l_decap_8
XFILLER_603_14 VPWR VGND sg13cmos5l_decap_8
XANTENNA__3414__X Tile_X0Y4_FrameData_O[5] VPWR VGND sg13cmos5l_antennanp
XFILLER_682_140 VPWR VGND sg13cmos5l_decap_8
XFILLER_290_4 VPWR VGND sg13cmos5l_fill_1
XFILLER_608_270 VPWR VGND sg13cmos5l_fill_2
XFILLER_92_207 VPWR VGND sg13cmos5l_fill_1
XFILLER_65_21 VPWR VGND sg13cmos5l_decap_8
XFILLER_322_37 VPWR VGND sg13cmos5l_fill_1
XFILLER_322_48 VPWR VGND sg13cmos5l_fill_2
XFILLER_555_4 VPWR VGND sg13cmos5l_fill_1
XANTENNA_100 Tile_X0Y3_W1END[3] VPWR VGND sg13cmos5l_antennanp
XANTENNA_111 _0157_/X VPWR VGND sg13cmos5l_antennanp
XFILLER_402_70 VPWR VGND sg13cmos5l_decap_8
XANTENNA_122 Tile_X0Y6_FrameData[30] VPWR VGND sg13cmos5l_antennanp
XFILLER_164_0 VPWR VGND sg13cmos5l_decap_4
XFILLER_65_98 VPWR VGND sg13cmos5l_decap_8
XANTENNA_133 Tile_X0Y6_FrameData[31] VPWR VGND sg13cmos5l_antennanp
XANTENNA_144 Tile_X0Y6_UserCLK VPWR VGND sg13cmos5l_antennanp
XANTENNA_155 Tile_X0Y9_FrameStrobe[19] VPWR VGND sg13cmos5l_antennanp
XANTENNA_166 Tile_X0Y9_FrameStrobe[8] VPWR VGND sg13cmos5l_antennanp
XANTENNA_177 Tile_X0Y9_FrameStrobe[8] VPWR VGND sg13cmos5l_antennanp
XFILLER_595_158 VPWR VGND sg13cmos5l_fill_2
XANTENNA_188 Tile_X0Y9_FrameStrobe[8] VPWR VGND sg13cmos5l_antennanp
XANTENNA_199 Tile_X0Y9_N2MID[2] VPWR VGND sg13cmos5l_antennanp
XFILLER_695_28 VPWR VGND sg13cmos5l_decap_8
XFILLER_478_63 VPWR VGND sg13cmos5l_decap_8
XFILLER_387_261 VPWR VGND sg13cmos5l_decap_8
XFILLER_387_272 VPWR VGND sg13cmos5l_fill_1
XFILLER_331_0 VPWR VGND sg13cmos5l_decap_8
XFILLER_197_42 VPWR VGND sg13cmos5l_decap_8
XFILLER_81_75 VPWR VGND sg13cmos5l_decap_8
XFILLER_429_0 VPWR VGND sg13cmos5l_decap_8
XFILLER_198_194 VPWR VGND sg13cmos5l_decap_8
XFILLER_628_22 VPWR VGND sg13cmos5l_decap_8
XFILLER_478_96 VPWR VGND sg13cmos5l_decap_8
XFILLER_201_165 VPWR VGND sg13cmos5l_decap_8
XFILLER_536_247 VPWR VGND sg13cmos5l_decap_8
XFILLER_139_261 VPWR VGND sg13cmos5l_fill_1
XFILLER_139_272 VPWR VGND sg13cmos5l_fill_1
XFILLER_362_128 VPWR VGND sg13cmos5l_decap_4
XFILLER_347_56 VPWR VGND sg13cmos5l_decap_8
XFILLER_494_84 VPWR VGND sg13cmos5l_decap_8
XFILLER_504_133 VPWR VGND sg13cmos5l_decap_8
XFILLER_644_21 VPWR VGND sg13cmos5l_decap_8
XFILLER_370_150 VPWR VGND sg13cmos5l_decap_8
XFILLER_504_188 VPWR VGND sg13cmos5l_decap_8
XFILLER_363_22 VPWR VGND sg13cmos5l_decap_8
X_1400_ _1400_/Q Tile_X0Y1_FrameData[1] VGND VPWR Tile_X0Y9_FrameStrobe[6] latch
X_2380_ _2380_/Q Tile_X0Y5_FrameData[25] VGND VPWR Tile_X0Y9_FrameStrobe[6] latch
XFILLER_644_98 VPWR VGND sg13cmos5l_decap_8
XFILLER_216_49 VPWR VGND sg13cmos5l_fill_2
XFILLER_658_181 VPWR VGND sg13cmos5l_fill_2
X_1331_ _1331_/Q Tile_X0Y1_FrameData[6] VGND VPWR Tile_X0Y9_FrameStrobe[4] latch
XFILLER_513_14 VPWR VGND sg13cmos5l_decap_8
XFILLER_457_243 VPWR VGND sg13cmos5l_decap_8
XFILLER_311_261 VPWR VGND sg13cmos5l_fill_2
XANTENNA__3324__X Tile_X0Y4_EE4BEG[12] VPWR VGND sg13cmos5l_antennanp
XFILLER_660_42 VPWR VGND sg13cmos5l_decap_8
X_4050_ _4050_/X Tile_X0Y2_W2END[5] AXI_M_SOC_AWREADY _4101_/X _4100_/X _1573_/Q _1572_/Q
+ VPWR VGND sg13cmos5l_mux4_1
XFILLER_68_259 VPWR VGND sg13cmos5l_decap_4
X_1262_ _1262_/Q Tile_X0Y1_FrameData[11] VGND VPWR Tile_X0Y9_FrameStrobe[2] latch
XFILLER_232_15 VPWR VGND sg13cmos5l_decap_8
XFILLER_209_232 VPWR VGND sg13cmos5l_decap_8
X_3001_ Tile_X0Y5_E2BEG[4] _4376_/X VPWR VGND sg13cmos5l_buf_1
XFILLER_673_195 VPWR VGND sg13cmos5l_decap_8
X_0213_ _0213_/Q Tile_X0Y7_FrameData[10] VGND VPWR Tile_X0Y9_FrameStrobe[1] latch
XFILLER_209_254 VPWR VGND sg13cmos5l_fill_1
XFILLER_283_168 VPWR VGND sg13cmos5l_decap_8
X_1193_ _1193_/Q Tile_X0Y1_FrameData[16] VGND VPWR Tile_X0Y9_FrameStrobe[0] latch
XFILLER_425_140 VPWR VGND sg13cmos5l_decap_8
X_0144_ _3186_/A _3906_/X _3907_/X _1393_/Q VPWR VGND sg13cmos5l_mux2_1
XFILLER_91_251 VPWR VGND sg13cmos5l_decap_8
XFILLER_36_156 VPWR VGND sg13cmos5l_decap_8
XFILLER_224_257 VPWR VGND sg13cmos5l_fill_1
X_0075_ _0075_/X _4796_/X _4797_/X _2113_/Q VPWR VGND sg13cmos5l_mux2_1
XFILLER_51_126 VPWR VGND sg13cmos5l_decap_8
XFILLER_586_169 VPWR VGND sg13cmos5l_fill_1
X_3903_ _3903_/X Tile_X0Y1_W2MID[0] Tile_X0Y1_W2END[0] Tile_X0Y1_W6END[0] _3988_/X
+ _1403_/Q _1402_/Q VPWR VGND sg13cmos5l_mux4_1
X_4883_ _4883_/X Tile_X0Y9_N4END[3] _0080_/X _4924_/X _4928_/X _0777_/Q _0776_/Q VPWR
+ VGND sg13cmos5l_mux4_1
XFILLER_378_261 VPWR VGND sg13cmos5l_decap_4
XFILLER_378_272 VPWR VGND sg13cmos5l_fill_1
XFILLER_388_96 VPWR VGND sg13cmos5l_decap_8
X_3834_ _3834_/X Tile_X0Y0_WW4END[1] Tile_X0Y0_WW4END[2] _3882_/X _3855_/X _1037_/Q
+ _1036_/Q VPWR VGND sg13cmos5l_mux4_1
XFILLER_594_180 VPWR VGND sg13cmos5l_fill_2
XFILLER_338_136 VPWR VGND sg13cmos5l_decap_8
XFILLER_527_247 VPWR VGND sg13cmos5l_decap_8
X_3765_ _3765_/X Tile_X0Y1_WW4END[6] Tile_X0Y1_WW4END[14] Tile_X0Y1_W6END[6] _4014_/X
+ _1245_/Q _1244_/Q VPWR VGND sg13cmos5l_mux4_1
X_0977_ _0977_/Q Tile_X0Y0_FrameData[26] VGND VPWR Tile_X0Y9_FrameStrobe[1] latch
X_2716_ _4543_/A3 VPWR VGND sg13cmos5l_tielo
XFILLER_257_67 VPWR VGND sg13cmos5l_decap_8
XFILLER_257_78 VPWR VGND sg13cmos5l_fill_1
X_3696_ AXI_M_SOC_WDATA6 Tile_X0Y7_WW4END[6] Tile_X0Y7_WW4END[14] Tile_X0Y7_W6END[6]
+ _4690_/X _0235_/Q _0234_/Q VPWR VGND sg13cmos5l_mux4_1
XFILLER_554_21 VPWR VGND sg13cmos5l_decap_8
XFILLER_105_117 VPWR VGND sg13cmos5l_decap_8
X_2647_ _2647_/Q Tile_X0Y6_FrameData[16] VGND VPWR Tile_X0Y9_FrameStrobe[6] latch
XFILLER_550_261 VPWR VGND sg13cmos5l_decap_4
XFILLER_10_49 VPWR VGND sg13cmos5l_decap_8
XFILLER_160_223 VPWR VGND sg13cmos5l_decap_8
XFILLER_361_183 VPWR VGND sg13cmos5l_decap_8
XFILLER_361_194 VPWR VGND sg13cmos5l_fill_2
XFILLER_554_98 VPWR VGND sg13cmos5l_fill_2
XFILLER_126_49 VPWR VGND sg13cmos5l_decap_8
X_2578_ _2578_/Q Tile_X0Y6_FrameData[21] VGND VPWR Tile_X0Y9_FrameStrobe[4] latch
XFILLER_704_35 VPWR VGND sg13cmos5l_decap_8
X_4317_ _4317_/X _4241_/X _4357_/X _4356_/X _4240_/X _1945_/Q _1944_/Q VPWR VGND sg13cmos5l_mux4_1
XFILLER_649_192 VPWR VGND sg13cmos5l_decap_8
XFILLER_273_77 VPWR VGND sg13cmos5l_decap_8
X_1529_ _1529_/Q Tile_X0Y2_FrameData[24] VGND VPWR Tile_X0Y9_FrameStrobe[3] latch
XFILLER_423_14 VPWR VGND sg13cmos5l_decap_8
XFILLER_273_88 VPWR VGND sg13cmos5l_fill_2
XFILLER_302_272 VPWR VGND sg13cmos5l_fill_1
XANTENNA__3234__X Tile_X0Y0_FrameData_O[2] VPWR VGND sg13cmos5l_antennanp
XFILLER_664_140 VPWR VGND sg13cmos5l_decap_8
XFILLER_59_237 VPWR VGND sg13cmos5l_fill_1
XFILLER_113_194 VPWR VGND sg13cmos5l_fill_1
XFILLER_19_14 VPWR VGND sg13cmos5l_decap_8
XFILLER_664_151 VPWR VGND sg13cmos5l_fill_2
XFILLER_570_42 VPWR VGND sg13cmos5l_decap_8
X_4248_ _4248_/X Tile_X0Y2_W1END[2] Tile_X0Y2_W2MID[1] Tile_X0Y2_W2END[1] _4098_/X
+ _1617_/Q _1616_/Q VPWR VGND sg13cmos5l_mux4_1
XFILLER_664_184 VPWR VGND sg13cmos5l_decap_8
X_4179_ _4179_/X Tile_X0Y3_WW4END[0] AXI_M_SOC_WREADY _4222_/X _4205_/X _1783_/Q _1782_/Q
+ VPWR VGND sg13cmos5l_mux4_1
XFILLER_605_251 VPWR VGND sg13cmos5l_decap_8
XFILLER_503_91 VPWR VGND sg13cmos5l_decap_8
XFILLER_416_162 VPWR VGND sg13cmos5l_decap_8
XFILLER_222_70 VPWR VGND sg13cmos5l_decap_4
XFILLER_222_81 VPWR VGND sg13cmos5l_decap_8
XFILLER_35_46 VPWR VGND sg13cmos5l_decap_4
XFILLER_215_268 VPWR VGND sg13cmos5l_decap_4
XFILLER_577_136 VPWR VGND sg13cmos5l_decap_8
XFILLER_431_154 VPWR VGND sg13cmos5l_decap_8
XFILLER_35_57 VPWR VGND sg13cmos5l_decap_8
XFILLER_579_84 VPWR VGND sg13cmos5l_decap_8
XFILLER_298_63 VPWR VGND sg13cmos5l_decap_8
XFILLER_230_249 VPWR VGND sg13cmos5l_decap_8
XFILLER_298_74 VPWR VGND sg13cmos5l_fill_1
XFILLER_329_125 VPWR VGND sg13cmos5l_decap_8
XFILLER_298_96 VPWR VGND sg13cmos5l_decap_8
XFILLER_422_7 VPWR VGND sg13cmos5l_decap_8
XFILLER_329_136 VPWR VGND sg13cmos5l_fill_2
XFILLER_195_175 VPWR VGND sg13cmos5l_decap_4
XFILLER_448_77 VPWR VGND sg13cmos5l_decap_8
XANTENNA__3409__X Tile_X0Y4_FrameData_O[0] VPWR VGND sg13cmos5l_antennanp
XFILLER_167_56 VPWR VGND sg13cmos5l_decap_8
XFILLER_136_242 VPWR VGND sg13cmos5l_decap_8
XFILLER_303_4 VPWR VGND sg13cmos5l_fill_1
XFILLER_687_210 VPWR VGND sg13cmos5l_fill_1
XFILLER_464_21 VPWR VGND sg13cmos5l_decap_8
XFILLER_352_161 VPWR VGND sg13cmos5l_decap_8
XFILLER_498_154 VPWR VGND sg13cmos5l_decap_8
XFILLER_2_200 VPWR VGND sg13cmos5l_decap_8
XFILLER_687_254 VPWR VGND sg13cmos5l_decap_8
XFILLER_541_272 VPWR VGND sg13cmos5l_fill_1
XFILLER_317_59 VPWR VGND sg13cmos5l_fill_2
XFILLER_2_244 VPWR VGND sg13cmos5l_decap_8
XFILLER_183_55 VPWR VGND sg13cmos5l_decap_8
XFILLER_614_35 VPWR VGND sg13cmos5l_decap_8
XFILLER_501_147 VPWR VGND sg13cmos5l_decap_8
XANTENNA__3144__X Tile_X0Y7_FrameData_O[14] VPWR VGND sg13cmos5l_antennanp
XFILLER_480_42 VPWR VGND sg13cmos5l_decap_8
XFILLER_333_36 VPWR VGND sg13cmos5l_decap_8
XFILLER_76_42 VPWR VGND sg13cmos5l_decap_8
XFILLER_480_75 VPWR VGND sg13cmos5l_decap_8
XFILLER_281_0 VPWR VGND sg13cmos5l_decap_8
XANTENNA__2983__X Tile_X0Y8_FrameData_O[23] VPWR VGND sg13cmos5l_antennanp
XFILLER_379_0 VPWR VGND sg13cmos5l_decap_8
XFILLER_18_101 VPWR VGND sg13cmos5l_decap_4
XFILLER_76_86 VPWR VGND sg13cmos5l_decap_8
XFILLER_670_143 VPWR VGND sg13cmos5l_decap_8
XFILLER_454_268 VPWR VGND sg13cmos5l_decap_4
XFILLER_280_105 VPWR VGND sg13cmos5l_decap_8
XFILLER_630_56 VPWR VGND sg13cmos5l_decap_8
XFILLER_413_91 VPWR VGND sg13cmos5l_decap_8
XFILLER_206_213 VPWR VGND sg13cmos5l_decap_8
XFILLER_132_70 VPWR VGND sg13cmos5l_decap_8
XFILLER_73_251 VPWR VGND sg13cmos5l_decap_4
XFILLER_546_0 VPWR VGND sg13cmos5l_decap_8
XFILLER_206_268 VPWR VGND sg13cmos5l_decap_4
XFILLER_92_63 VPWR VGND sg13cmos5l_decap_8
XFILLER_611_254 VPWR VGND sg13cmos5l_decap_8
XFILLER_489_84 VPWR VGND sg13cmos5l_decap_8
XFILLER_422_154 VPWR VGND sg13cmos5l_decap_8
XFILLER_568_147 VPWR VGND sg13cmos5l_decap_8
XFILLER_639_21 VPWR VGND sg13cmos5l_decap_8
XFILLER_221_227 VPWR VGND sg13cmos5l_decap_4
XFILLER_422_187 VPWR VGND sg13cmos5l_decap_8
XFILLER_713_0 VPWR VGND sg13cmos5l_decap_8
X_0900_ _0900_/Q Tile_X0Y9_FrameData[27] VGND VPWR Tile_X0Y9_FrameStrobe[7] latch
X_1880_ _1880_/Q Tile_X0Y3_FrameData[17] VGND VPWR Tile_X0Y9_FrameStrobe[6] latch
XFILLER_639_98 VPWR VGND sg13cmos5l_decap_8
XFILLER_509_247 VPWR VGND sg13cmos5l_decap_8
X_0831_ _0831_/Q Tile_X0Y9_FrameData[0] VGND VPWR Tile_X0Y9_FrameStrobe[4] latch
XFILLER_390_201 VPWR VGND sg13cmos5l_decap_4
XFILLER_358_77 VPWR VGND sg13cmos5l_decap_8
XFILLER_186_186 VPWR VGND sg13cmos5l_decap_8
XFILLER_508_14 VPWR VGND sg13cmos5l_decap_8
XANTENNA__3319__X Tile_X0Y4_EE4BEG[7] VPWR VGND sg13cmos5l_antennanp
XFILLER_390_223 VPWR VGND sg13cmos5l_fill_1
XFILLER_127_231 VPWR VGND sg13cmos5l_fill_2
X_3550_ Tile_X0Y9_E6BEG[8] _4888_/X VPWR VGND sg13cmos5l_buf_1
XFILLER_390_245 VPWR VGND sg13cmos5l_decap_8
X_0762_ _0762_/Q Tile_X0Y9_FrameData[5] VGND VPWR Tile_X0Y9_FrameStrobe[2] latch
XFILLER_655_64 VPWR VGND sg13cmos5l_decap_8
XFILLER_390_256 VPWR VGND sg13cmos5l_fill_1
XFILLER_227_15 VPWR VGND sg13cmos5l_decap_8
X_2501_ _2501_/Q Tile_X0Y6_FrameData[2] VGND VPWR Tile_X0Y9_FrameStrobe[1] latch
X_3481_ Tile_X0Y1_EE4BEG[7] _3955_/X VPWR VGND sg13cmos5l_buf_1
XFILLER_142_223 VPWR VGND sg13cmos5l_decap_8
X_0693_ _0693_/Q Tile_X0Y9_FrameData[10] VGND VPWR Tile_X0Y9_FrameStrobe[0] latch
XFILLER_343_172 VPWR VGND sg13cmos5l_decap_8
XFILLER_678_265 VPWR VGND sg13cmos5l_decap_8
XFILLER_288_227 VPWR VGND sg13cmos5l_decap_8
X_2432_ _2432_/Q Tile_X0Y5_FrameData[5] VGND VPWR Tile_X0Y9_FrameStrobe[7] latch
XFILLER_524_35 VPWR VGND sg13cmos5l_decap_8
X_2363_ _2363_/Q Tile_X0Y5_FrameData[10] VGND VPWR Tile_X0Y9_FrameStrobe[5] latch
XFILLER_243_14 VPWR VGND sg13cmos5l_decap_8
XANTENNA__3054__X Tile_X0Y5_FrameData_O[13] VPWR VGND sg13cmos5l_antennanp
XFILLER_646_140 VPWR VGND sg13cmos5l_decap_8
X_4102_ _4102_/X _4029_/X _4137_/X _4136_/X _4028_/X _1441_/Q _1440_/Q VPWR VGND sg13cmos5l_mux4_1
XFILLER_390_42 VPWR VGND sg13cmos5l_decap_8
X_1314_ _1314_/Q Tile_X0Y1_FrameData[23] VGND VPWR Tile_X0Y9_FrameStrobe[4] latch
X_2294_ _2294_/Q Tile_X0Y5_FrameData[15] VGND VPWR Tile_X0Y9_FrameStrobe[3] latch
XFILLER_661_110 VPWR VGND sg13cmos5l_decap_4
XANTENNA__2893__X Tile_X0Y6_FrameData_O[14] VPWR VGND sg13cmos5l_antennanp
X_4033_ _4033_/X Tile_X0Y3_W2MID[1] Tile_X0Y3_W2END[1] Tile_X0Y3_W6END[1] _4206_/X
+ _1905_/Q _1904_/Q VPWR VGND sg13cmos5l_mux4_1
X_1245_ _1245_/Q Tile_X0Y1_FrameData[28] VGND VPWR Tile_X0Y9_FrameStrobe[2] latch
XFILLER_49_270 VPWR VGND sg13cmos5l_fill_2
XFILLER_256_168 VPWR VGND sg13cmos5l_fill_1
XFILLER_445_268 VPWR VGND sg13cmos5l_decap_4
XFILLER_540_56 VPWR VGND sg13cmos5l_decap_8
XFILLER_271_116 VPWR VGND sg13cmos5l_decap_8
XFILLER_460_227 VPWR VGND sg13cmos5l_decap_8
XFILLER_271_127 VPWR VGND sg13cmos5l_fill_1
XFILLER_271_138 VPWR VGND sg13cmos5l_decap_8
X_1176_ _1176_/Q Tile_X0Y0_FrameData[19] VGND VPWR Tile_X0Y9_FrameStrobe[7] latch
XFILLER_599_261 VPWR VGND sg13cmos5l_fill_1
XFILLER_540_89 VPWR VGND sg13cmos5l_fill_1
XFILLER_602_210 VPWR VGND sg13cmos5l_fill_2
XFILLER_599_272 VPWR VGND sg13cmos5l_fill_1
X_0127_ AXI_M_SOC_WLAST _4940_/X _0934_/Q VPWR VGND sg13cmos5l_or2_1
XFILLER_413_154 VPWR VGND sg13cmos5l_decap_8
XFILLER_549_21 VPWR VGND sg13cmos5l_decap_8
XFILLER_212_238 VPWR VGND sg13cmos5l_decap_8
X_0058_ _3179_/A _3920_/X _3921_/X _1890_/Q VPWR VGND sg13cmos5l_mux2_1
X_4935_ _4935_/X Tile_X0Y8_W2MID[4] Tile_X0Y8_W2END[4] Tile_X0Y8_W6END[11] _4791_/X
+ _0621_/Q _0620_/Q VPWR VGND sg13cmos5l_mux4_1
XFILLER_177_131 VPWR VGND sg13cmos5l_decap_8
XANTENNA_11 AXI_M_SOC_RDATA26 VPWR VGND sg13cmos5l_antennanp
XANTENNA_22 AXI_M_SOC_RDATA26 VPWR VGND sg13cmos5l_antennanp
X_4866_ _4866_/X Tile_X0Y9_WW4END[13] AXI_M_SOC_RDATA2 _4929_/X _4904_/X _0811_/Q
+ _0810_/Q VPWR VGND sg13cmos5l_mux4_1
XANTENNA_33 AXI_M_SOC_RDATA26 VPWR VGND sg13cmos5l_antennanp
XANTENNA_44 AXI_M_SOC_RDATA8 VPWR VGND sg13cmos5l_antennanp
XFILLER_716_155 VPWR VGND sg13cmos5l_decap_8
XFILLER_268_77 VPWR VGND sg13cmos5l_decap_8
XANTENNA_55 Tile_X0Y0_FrameData[25] VPWR VGND sg13cmos5l_antennanp
X_3817_ _3817_/X Tile_X0Y0_W2END[2] Tile_X0Y0_W6END[0] _3857_/X _3856_/X _1071_/Q
+ _1070_/Q VPWR VGND sg13cmos5l_mux4_1
XFILLER_418_14 VPWR VGND sg13cmos5l_decap_8
XANTENNA_66 Tile_X0Y0_S2MID[1] VPWR VGND sg13cmos5l_antennanp
X_4797_ _4797_/X _4342_/X _4346_/X _4350_/X _4314_/X _2115_/Q _2114_/Q VPWR VGND sg13cmos5l_mux4_1
XFILLER_515_217 VPWR VGND sg13cmos5l_decap_8
XFILLER_381_212 VPWR VGND sg13cmos5l_decap_8
XANTENNA__3229__X Tile_X0Y0_FrameStrobe_O[17] VPWR VGND sg13cmos5l_antennanp
XANTENNA_77 Tile_X0Y0_S4END[14] VPWR VGND sg13cmos5l_antennanp
XFILLER_582_183 VPWR VGND sg13cmos5l_decap_8
XFILLER_565_42 VPWR VGND sg13cmos5l_decap_8
XFILLER_326_139 VPWR VGND sg13cmos5l_decap_8
XANTENNA_88 Tile_X0Y1_FrameData[6] VPWR VGND sg13cmos5l_antennanp
XANTENNA_99 Tile_X0Y3_W1END[3] VPWR VGND sg13cmos5l_antennanp
XFILLER_192_156 VPWR VGND sg13cmos5l_decap_8
X_3748_ AXI_M_SOC_ARADDR20 Tile_X0Y8_WW4END[4] Tile_X0Y8_WW4END[12] Tile_X0Y8_W6END[4]
+ _4804_/X _0495_/Q _0494_/Q VPWR VGND sg13cmos5l_mux4_1
XFILLER_284_21 VPWR VGND sg13cmos5l_decap_8
X_3679_ _3679_/X Tile_X0Y2_WW4END[1] Tile_X0Y2_WW4END[9] Tile_X0Y2_W6END[9] _4125_/X
+ _1487_/Q _1486_/Q VPWR VGND sg13cmos5l_mux4_1
XFILLER_279_205 VPWR VGND sg13cmos5l_decap_8
XFILLER_334_183 VPWR VGND sg13cmos5l_decap_8
XFILLER_133_234 VPWR VGND sg13cmos5l_decap_8
XFILLER_715_56 VPWR VGND sg13cmos5l_decap_8
XFILLER_279_216 VPWR VGND sg13cmos5l_decap_8
XFILLER_284_98 VPWR VGND sg13cmos5l_decap_8
XFILLER_434_35 VPWR VGND sg13cmos5l_decap_8
XFILLER_684_235 VPWR VGND sg13cmos5l_decap_8
XFILLER_153_14 VPWR VGND sg13cmos5l_decap_8
XFILLER_99_170 VPWR VGND sg13cmos5l_decap_8
XFILLER_581_63 VPWR VGND sg13cmos5l_decap_8
XFILLER_684_268 VPWR VGND sg13cmos5l_decap_4
XFILLER_495_168 VPWR VGND sg13cmos5l_decap_8
XFILLER_436_202 VPWR VGND sg13cmos5l_decap_8
XFILLER_637_173 VPWR VGND sg13cmos5l_decap_8
XFILLER_247_135 VPWR VGND sg13cmos5l_decap_8
XFILLER_637_195 VPWR VGND sg13cmos5l_decap_8
XFILLER_101_186 VPWR VGND sg13cmos5l_decap_8
XFILLER_46_78 VPWR VGND sg13cmos5l_fill_1
XFILLER_70_210 VPWR VGND sg13cmos5l_decap_8
XFILLER_637_7 VPWR VGND sg13cmos5l_decap_8
XFILLER_459_21 VPWR VGND sg13cmos5l_decap_8
XFILLER_15_148 VPWR VGND sg13cmos5l_decap_8
XFILLER_70_254 VPWR VGND sg13cmos5l_decap_8
XFILLER_62_33 VPWR VGND sg13cmos5l_decap_8
XFILLER_168_131 VPWR VGND sg13cmos5l_decap_8
XFILLER_357_231 VPWR VGND sg13cmos5l_decap_8
XFILLER_23_181 VPWR VGND sg13cmos5l_decap_8
XFILLER_609_35 VPWR VGND sg13cmos5l_decap_8
XFILLER_7_28 VPWR VGND sg13cmos5l_decap_8
XFILLER_573_161 VPWR VGND sg13cmos5l_decap_8
XFILLER_328_14 VPWR VGND sg13cmos5l_decap_8
XANTENNA__3139__X Tile_X0Y7_FrameData_O[9] VPWR VGND sg13cmos5l_antennanp
XFILLER_127_0 VPWR VGND sg13cmos5l_decap_8
XFILLER_475_42 VPWR VGND sg13cmos5l_decap_8
XFILLER_328_58 VPWR VGND sg13cmos5l_decap_8
XFILLER_194_21 VPWR VGND sg13cmos5l_decap_8
XFILLER_332_109 VPWR VGND sg13cmos5l_decap_8
XANTENNA__2978__X Tile_X0Y8_FrameData_O[18] VPWR VGND sg13cmos5l_antennanp
XFILLER_194_54 VPWR VGND sg13cmos5l_decap_8
XFILLER_11_70 VPWR VGND sg13cmos5l_decap_8
XFILLER_625_56 VPWR VGND sg13cmos5l_decap_8
XFILLER_408_91 VPWR VGND sg13cmos5l_decap_4
XFILLER_340_131 VPWR VGND sg13cmos5l_decap_8
XFILLER_344_35 VPWR VGND sg13cmos5l_decap_8
XFILLER_675_246 VPWR VGND sg13cmos5l_decap_8
XFILLER_496_0 VPWR VGND sg13cmos5l_decap_8
XFILLER_127_92 VPWR VGND sg13cmos5l_decap_8
XFILLER_97_129 VPWR VGND sg13cmos5l_decap_8
XFILLER_491_63 VPWR VGND sg13cmos5l_decap_8
XFILLER_486_179 VPWR VGND sg13cmos5l_decap_8
XFILLER_628_151 VPWR VGND sg13cmos5l_decap_4
XFILLER_87_85 VPWR VGND sg13cmos5l_decap_8
XFILLER_238_113 VPWR VGND sg13cmos5l_decap_8
XFILLER_427_224 VPWR VGND sg13cmos5l_decap_8
XFILLER_628_184 VPWR VGND sg13cmos5l_fill_2
XFILLER_663_0 VPWR VGND sg13cmos5l_decap_8
XFILLER_238_146 VPWR VGND sg13cmos5l_decap_8
XFILLER_213_28 VPWR VGND sg13cmos5l_decap_8
XFILLER_641_77 VPWR VGND sg13cmos5l_decap_8
XFILLER_38_229 VPWR VGND sg13cmos5l_decap_8
XFILLER_293_252 VPWR VGND sg13cmos5l_decap_8
XFILLER_16_7 VPWR VGND sg13cmos5l_decap_8
XFILLER_643_154 VPWR VGND sg13cmos5l_decap_8
XFILLER_253_105 VPWR VGND sg13cmos5l_decap_8
XANTENNA__3602__X Tile_X0Y9_S1BEG[0] VPWR VGND sg13cmos5l_antennanp
XFILLER_360_56 VPWR VGND sg13cmos5l_decap_8
XFILLER_143_91 VPWR VGND sg13cmos5l_decap_8
X_1030_ _1030_/Q Tile_X0Y0_FrameData[5] VGND VPWR Tile_X0Y9_FrameStrobe[2] latch
XFILLER_253_138 VPWR VGND sg13cmos5l_decap_8
XFILLER_61_232 VPWR VGND sg13cmos5l_decap_8
XFILLER_369_21 VPWR VGND sg13cmos5l_decap_8
X_2981_ Tile_X0Y8_FrameData_O[21] Tile_X0Y8_FrameData[21] VPWR VGND sg13cmos5l_buf_1
XFILLER_348_220 VPWR VGND sg13cmos5l_decap_8
X_1932_ _1932_/Q Tile_X0Y4_FrameData[25] VGND VPWR Tile_X0Y9_FrameStrobe[0] latch
X_4720_ _4720_/X Tile_X0Y8_W1END[2] Tile_X0Y8_WW4END[14] Tile_X0Y8_W6END[6] _4802_/X
+ _0605_/Q _0604_/Q VPWR VGND sg13cmos5l_mux4_1
XFILLER_410_168 VPWR VGND sg13cmos5l_decap_8
XFILLER_369_98 VPWR VGND sg13cmos5l_decap_8
XFILLER_519_35 VPWR VGND sg13cmos5l_decap_8
XFILLER_174_101 VPWR VGND sg13cmos5l_fill_1
X_4651_ _4651_/X AXI_M_SOC_RDATA19 _4688_/X _4692_/X _4675_/X _0257_/Q _0256_/Q VPWR
+ VGND sg13cmos5l_mux4_1
XFILLER_666_63 VPWR VGND sg13cmos5l_decap_8
X_1863_ _1863_/Q Tile_X0Y3_FrameData[2] VGND VPWR Tile_X0Y9_FrameStrobe[5] latch
XFILLER_238_14 VPWR VGND sg13cmos5l_decap_8
XFILLER_519_79 VPWR VGND sg13cmos5l_fill_2
XANTENNA__3049__X Tile_X0Y5_FrameData_O[8] VPWR VGND sg13cmos5l_antennanp
XFILLER_174_134 VPWR VGND sg13cmos5l_decap_8
XFILLER_713_103 VPWR VGND sg13cmos5l_decap_8
XFILLER_564_183 VPWR VGND sg13cmos5l_fill_1
X_3602_ Tile_X0Y9_S1BEG[0] _4824_/X VPWR VGND sg13cmos5l_buf_1
X_0814_ _0814_/Q Tile_X0Y9_FrameData[17] VGND VPWR Tile_X0Y9_FrameStrobe[4] latch
X_4582_ _4582_/X _4549_/X Tile_X0Y9_N4END[14] _4548_/X _0155_/X _2467_/Q _2466_/Q
+ VPWR VGND sg13cmos5l_mux4_1
XFILLER_363_256 VPWR VGND sg13cmos5l_fill_2
X_1794_ _1794_/Q Tile_X0Y3_FrameData[7] VGND VPWR Tile_X0Y9_FrameStrobe[3] latch
X_3533_ Tile_X0Y9_E2BEG[7] _4855_/X VPWR VGND sg13cmos5l_buf_1
XANTENNA__2888__X Tile_X0Y6_FrameData_O[9] VPWR VGND sg13cmos5l_antennanp
X_0745_ _0745_/Q Tile_X0Y9_FrameData[22] VGND VPWR Tile_X0Y9_FrameStrobe[2] latch
XFILLER_115_223 VPWR VGND sg13cmos5l_decap_8
XFILLER_505_272 VPWR VGND sg13cmos5l_fill_1
XFILLER_682_62 VPWR VGND sg13cmos5l_fill_2
XFILLER_318_91 VPWR VGND sg13cmos5l_decap_8
X_3464_ Tile_X0Y1_FrameData_O[22] Tile_X0Y1_FrameData[22] VPWR VGND sg13cmos5l_buf_1
X_0676_ _0676_/Q Tile_X0Y9_FrameData[27] VGND VPWR Tile_X0Y9_FrameStrobe[0] latch
XFILLER_682_84 VPWR VGND sg13cmos5l_decap_8
XFILLER_42_0 VPWR VGND sg13cmos5l_fill_1
XFILLER_254_35 VPWR VGND sg13cmos5l_decap_8
XFILLER_88_107 VPWR VGND sg13cmos5l_fill_1
XFILLER_477_135 VPWR VGND sg13cmos5l_decap_8
X_2415_ _2415_/Q Tile_X0Y5_FrameData[22] VGND VPWR Tile_X0Y9_FrameStrobe[7] latch
XFILLER_477_168 VPWR VGND sg13cmos5l_decap_8
X_3395_ Tile_X0Y2_E2BEGb[6] _4054_/X VPWR VGND sg13cmos5l_buf_1
XFILLER_666_268 VPWR VGND sg13cmos5l_decap_4
XFILLER_492_105 VPWR VGND sg13cmos5l_decap_8
X_2346_ _2346_/Q Tile_X0Y5_FrameData[27] VGND VPWR Tile_X0Y9_FrameStrobe[5] latch
XFILLER_96_151 VPWR VGND sg13cmos5l_decap_8
XFILLER_404_49 VPWR VGND sg13cmos5l_decap_8
XFILLER_681_249 VPWR VGND sg13cmos5l_decap_8
XFILLER_229_157 VPWR VGND sg13cmos5l_decap_4
XFILLER_551_77 VPWR VGND sg13cmos5l_decap_8
XFILLER_29_229 VPWR VGND sg13cmos5l_decap_8
XFILLER_284_252 VPWR VGND sg13cmos5l_decap_4
XFILLER_123_28 VPWR VGND sg13cmos5l_decap_8
XFILLER_701_14 VPWR VGND sg13cmos5l_decap_8
XFILLER_551_88 VPWR VGND sg13cmos5l_fill_1
X_2277_ _2277_/Q Tile_X0Y5_FrameData[0] VGND VPWR Tile_X0Y9_FrameStrobe[2] latch
XANTENNA__3512__X Tile_X0Y1_E2BEG[2] VPWR VGND sg13cmos5l_antennanp
XFILLER_270_56 VPWR VGND sg13cmos5l_decap_8
X_4016_ _4016_/X _3981_/X _0073_/X _3980_/X Tile_X0Y0_S4END[4] _1217_/Q _1216_/Q VPWR
+ VGND sg13cmos5l_mux4_1
X_1228_ _1228_/Q Tile_X0Y1_FrameData[13] VGND VPWR Tile_X0Y9_FrameStrobe[1] latch
XFILLER_244_138 VPWR VGND sg13cmos5l_decap_8
XFILLER_587_220 VPWR VGND sg13cmos5l_decap_8
X_1159_ _1159_/Q Tile_X0Y0_FrameData[4] VGND VPWR Tile_X0Y9_FrameStrobe[6] latch
XFILLER_279_21 VPWR VGND sg13cmos5l_decap_8
XFILLER_252_193 VPWR VGND sg13cmos5l_fill_1
XFILLER_500_70 VPWR VGND sg13cmos5l_decap_8
XFILLER_401_135 VPWR VGND sg13cmos5l_decap_8
XFILLER_401_146 VPWR VGND sg13cmos5l_fill_2
XFILLER_197_259 VPWR VGND sg13cmos5l_decap_4
X_4918_ _4918_/X Tile_X0Y9_N1END[2] Tile_X0Y9_N4END[2] _4898_/X _0081_/X _0723_/Q
+ _0722_/Q VPWR VGND sg13cmos5l_mux4_1
XFILLER_279_98 VPWR VGND sg13cmos5l_decap_8
XFILLER_429_35 VPWR VGND sg13cmos5l_decap_8
XFILLER_32_14 VPWR VGND sg13cmos5l_decap_8
XFILLER_339_264 VPWR VGND sg13cmos5l_decap_8
XFILLER_148_14 VPWR VGND sg13cmos5l_decap_8
XFILLER_576_63 VPWR VGND sg13cmos5l_decap_8
XFILLER_555_161 VPWR VGND sg13cmos5l_decap_8
X_4849_ _4849_/X Tile_X0Y9_W2MID[6] AXI_M_SOC_RDATA1 _4903_/X _4902_/X _0845_/Q _0844_/Q
+ VPWR VGND sg13cmos5l_mux4_1
XFILLER_120_7 VPWR VGND sg13cmos5l_decap_8
XFILLER_354_245 VPWR VGND sg13cmos5l_decap_8
XFILLER_165_167 VPWR VGND sg13cmos5l_decap_8
XFILLER_218_7 VPWR VGND sg13cmos5l_decap_8
XFILLER_354_256 VPWR VGND sg13cmos5l_fill_2
XFILLER_295_64 VPWR VGND sg13cmos5l_decap_8
XFILLER_704_158 VPWR VGND sg13cmos5l_decap_8
XFILLER_503_209 VPWR VGND sg13cmos5l_decap_8
XFILLER_314_109 VPWR VGND sg13cmos5l_fill_2
XANTENNA__2798__X Tile_X0Y3_E6BEG[8] VPWR VGND sg13cmos5l_antennanp
XFILLER_106_212 VPWR VGND sg13cmos5l_decap_8
XFILLER_570_175 VPWR VGND sg13cmos5l_decap_8
XFILLER_180_137 VPWR VGND sg13cmos5l_decap_8
XFILLER_228_80 VPWR VGND sg13cmos5l_decap_8
XFILLER_468_102 VPWR VGND sg13cmos5l_fill_1
XFILLER_445_56 VPWR VGND sg13cmos5l_decap_8
XFILLER_592_73 VPWR VGND sg13cmos5l_fill_1
XFILLER_468_124 VPWR VGND sg13cmos5l_decap_8
XFILLER_592_95 VPWR VGND sg13cmos5l_decap_8
XFILLER_511_253 VPWR VGND sg13cmos5l_decap_8
XFILLER_164_57 VPWR VGND sg13cmos5l_decap_8
XFILLER_322_175 VPWR VGND sg13cmos5l_decap_8
XFILLER_468_168 VPWR VGND sg13cmos5l_decap_8
XFILLER_267_219 VPWR VGND sg13cmos5l_decap_8
XFILLER_587_7 VPWR VGND sg13cmos5l_decap_8
XFILLER_672_238 VPWR VGND sg13cmos5l_decap_8
XFILLER_672_249 VPWR VGND sg13cmos5l_fill_1
XFILLER_57_33 VPWR VGND sg13cmos5l_decap_4
XFILLER_87_162 VPWR VGND sg13cmos5l_decap_8
XFILLER_275_252 VPWR VGND sg13cmos5l_fill_1
XFILLER_611_14 VPWR VGND sg13cmos5l_decap_8
XANTENNA__3422__X Tile_X0Y4_FrameData_O[13] VPWR VGND sg13cmos5l_antennanp
XFILLER_370_4 VPWR VGND sg13cmos5l_fill_1
XFILLER_290_200 VPWR VGND sg13cmos5l_decap_8
XFILLER_180_56 VPWR VGND sg13cmos5l_decap_8
XFILLER_57_88 VPWR VGND sg13cmos5l_decap_8
XFILLER_290_211 VPWR VGND sg13cmos5l_fill_2
XFILLER_625_176 VPWR VGND sg13cmos5l_decap_8
XFILLER_491_182 VPWR VGND sg13cmos5l_decap_8
XFILLER_491_193 VPWR VGND sg13cmos5l_fill_2
XFILLER_330_15 VPWR VGND sg13cmos5l_decap_8
XFILLER_290_255 VPWR VGND sg13cmos5l_decap_4
XFILLER_73_21 VPWR VGND sg13cmos5l_decap_8
XFILLER_389_120 VPWR VGND sg13cmos5l_decap_8
XFILLER_330_48 VPWR VGND sg13cmos5l_decap_8
XFILLER_113_94 VPWR VGND sg13cmos5l_decap_8
XFILLER_640_168 VPWR VGND sg13cmos5l_decap_8
XFILLER_189_21 VPWR VGND sg13cmos5l_decap_4
XFILLER_432_271 VPWR VGND sg13cmos5l_fill_2
XFILLER_243_193 VPWR VGND sg13cmos5l_decap_8
XFILLER_410_70 VPWR VGND sg13cmos5l_decap_8
XFILLER_389_197 VPWR VGND sg13cmos5l_decap_8
XFILLER_244_0 VPWR VGND sg13cmos5l_decap_8
XFILLER_188_259 VPWR VGND sg13cmos5l_decap_4
XFILLER_189_87 VPWR VGND sg13cmos5l_decap_8
XFILLER_553_109 VPWR VGND sg13cmos5l_decap_8
XFILLER_486_63 VPWR VGND sg13cmos5l_decap_8
XFILLER_345_212 VPWR VGND sg13cmos5l_decap_4
XFILLER_411_0 VPWR VGND sg13cmos5l_decap_8
XFILLER_509_0 VPWR VGND sg13cmos5l_decap_8
XFILLER_345_245 VPWR VGND sg13cmos5l_decap_8
XFILLER_156_156 VPWR VGND sg13cmos5l_decap_8
XFILLER_345_256 VPWR VGND sg13cmos5l_fill_2
XFILLER_22_91 VPWR VGND sg13cmos5l_decap_8
XFILLER_636_77 VPWR VGND sg13cmos5l_decap_8
XFILLER_171_126 VPWR VGND sg13cmos5l_decap_8
XFILLER_208_28 VPWR VGND sg13cmos5l_decap_8
XFILLER_7_199 VPWR VGND sg13cmos5l_fill_2
XFILLER_360_237 VPWR VGND sg13cmos5l_decap_8
XFILLER_355_56 VPWR VGND sg13cmos5l_decap_8
XFILLER_138_91 VPWR VGND sg13cmos5l_decap_8
XFILLER_648_202 VPWR VGND sg13cmos5l_decap_8
X_0530_ _0530_/Q Tile_X0Y8_FrameData[13] VGND VPWR Tile_X0Y9_FrameStrobe[3] latch
XFILLER_98_62 VPWR VGND sg13cmos5l_decap_4
XFILLER_502_231 VPWR VGND sg13cmos5l_decap_8
XFILLER_112_204 VPWR VGND sg13cmos5l_decap_8
XFILLER_98_73 VPWR VGND sg13cmos5l_decap_8
XFILLER_652_21 VPWR VGND sg13cmos5l_decap_8
X_0461_ _0461_/Q Tile_X0Y8_FrameData[18] VGND VPWR Tile_X0Y9_FrameStrobe[1] latch
XFILLER_258_219 VPWR VGND sg13cmos5l_decap_8
XFILLER_474_105 VPWR VGND sg13cmos5l_decap_8
X_2200_ _2200_/Q Tile_X0Y5_FrameData[13] VGND VPWR Tile_X0Y9_FrameStrobe[0] latch
X_3180_ Tile_X0Y0_N4BEG[4] _3180_/A VPWR VGND sg13cmos5l_buf_1
XFILLER_652_98 VPWR VGND sg13cmos5l_decap_8
XFILLER_224_49 VPWR VGND sg13cmos5l_decap_8
X_0392_ _0392_/Q Tile_X0Y7_FrameData[23] VGND VPWR Tile_X0Y9_FrameStrobe[7] latch
X_2131_ _2131_/Q Tile_X0Y4_FrameData[18] VGND VPWR Tile_X0Y9_FrameStrobe[6] latch
XFILLER_371_77 VPWR VGND sg13cmos5l_decap_8
XFILLER_521_14 VPWR VGND sg13cmos5l_decap_8
XANTENNA__3332__X Tile_X0Y2_FrameData_O[3] VPWR VGND sg13cmos5l_antennanp
XFILLER_671_271 VPWR VGND sg13cmos5l_fill_2
X_2062_ _2062_/Q Tile_X0Y4_FrameData[23] VGND VPWR Tile_X0Y9_FrameStrobe[4] latch
XFILLER_304_93 VPWR VGND sg13cmos5l_fill_1
XFILLER_219_190 VPWR VGND sg13cmos5l_decap_8
XFILLER_281_255 VPWR VGND sg13cmos5l_decap_4
X_1013_ _1013_/Q Tile_X0Y0_FrameData[22] VGND VPWR Tile_X0Y9_FrameStrobe[2] latch
XFILLER_34_210 VPWR VGND sg13cmos5l_decap_8
XFILLER_631_168 VPWR VGND sg13cmos5l_fill_1
XFILLER_569_231 VPWR VGND sg13cmos5l_decap_8
XFILLER_569_242 VPWR VGND sg13cmos5l_fill_2
XFILLER_601_91 VPWR VGND sg13cmos5l_decap_8
XFILLER_423_271 VPWR VGND sg13cmos5l_fill_2
XFILLER_569_264 VPWR VGND sg13cmos5l_fill_1
XFILLER_179_226 VPWR VGND sg13cmos5l_decap_8
XFILLER_529_117 VPWR VGND sg13cmos5l_decap_8
XFILLER_395_112 VPWR VGND sg13cmos5l_decap_8
X_2964_ Tile_X0Y8_FrameData_O[4] Tile_X0Y8_FrameData[4] VPWR VGND sg13cmos5l_buf_1
XFILLER_395_178 VPWR VGND sg13cmos5l_decap_8
X_1915_ _1915_/Q Tile_X0Y3_FrameData[14] VGND VPWR Tile_X0Y9_FrameStrobe[7] latch
X_4703_ _4703_/X Tile_X0Y9_W2MID[6] Tile_X0Y9_W2END[6] Tile_X0Y9_W6END[6] _4903_/X
+ _0917_/Q _0916_/Q VPWR VGND sg13cmos5l_mux4_1
XFILLER_249_57 VPWR VGND sg13cmos5l_decap_8
XFILLER_537_161 VPWR VGND sg13cmos5l_decap_8
X_2895_ Tile_X0Y6_FrameData_O[16] Tile_X0Y6_FrameData[16] VPWR VGND sg13cmos5l_buf_1
XFILLER_336_234 VPWR VGND sg13cmos5l_decap_8
X_1846_ _1846_/Q Tile_X0Y3_FrameData[19] VGND VPWR Tile_X0Y9_FrameStrobe[5] latch
X_4634_ _4634_/X Tile_X0Y7_WW4END[9] AXI_M_SOC_RDATA22 _4693_/X _4671_/X _0291_/Q
+ _0290_/Q VPWR VGND sg13cmos5l_mux4_1
XFILLER_552_131 VPWR VGND sg13cmos5l_decap_4
XFILLER_552_142 VPWR VGND sg13cmos5l_decap_8
XFILLER_329_90 VPWR VGND sg13cmos5l_decap_8
XFILLER_546_77 VPWR VGND sg13cmos5l_decap_4
XFILLER_118_28 VPWR VGND sg13cmos5l_decap_8
X_4565_ _4565_/X _4122_/X _4126_/X _4107_/X _4098_/X _1607_/Q _1606_/Q VPWR VGND sg13cmos5l_mux4_1
X_1777_ _1777_/Q Tile_X0Y3_FrameData[24] VGND VPWR Tile_X0Y9_FrameStrobe[3] latch
XANTENNA__3507__X Tile_X0Y1_E2BEGb[5] VPWR VGND sg13cmos5l_antennanp
XFILLER_701_128 VPWR VGND sg13cmos5l_fill_1
XFILLER_351_248 VPWR VGND sg13cmos5l_decap_8
XFILLER_265_56 VPWR VGND sg13cmos5l_decap_8
XFILLER_162_159 VPWR VGND sg13cmos5l_decap_8
X_0728_ _0728_/Q Tile_X0Y9_FrameData[7] VGND VPWR Tile_X0Y9_FrameStrobe[1] latch
X_3516_ Tile_X0Y1_E2BEG[6] _3938_/X VPWR VGND sg13cmos5l_buf_1
X_4496_ _4496_/X Tile_X0Y6_W2MID[7] AXI_M_SOC_RDATA24 _4553_/X _4552_/X _2615_/Q _2614_/Q
+ VPWR VGND sg13cmos5l_mux4_1
XFILLER_639_224 VPWR VGND sg13cmos5l_decap_8
XFILLER_562_21 VPWR VGND sg13cmos5l_decap_8
XFILLER_304_153 VPWR VGND sg13cmos5l_decap_8
X_3447_ Tile_X0Y1_FrameData_O[5] Tile_X0Y1_FrameData[5] VPWR VGND sg13cmos5l_buf_1
XFILLER_249_208 VPWR VGND sg13cmos5l_decap_8
X_0659_ _0659_/Q Tile_X0Y8_FrameData[12] VGND VPWR Tile_X0Y9_FrameStrobe[7] latch
XFILLER_249_219 VPWR VGND sg13cmos5l_fill_1
XFILLER_465_116 VPWR VGND sg13cmos5l_decap_8
XFILLER_69_140 VPWR VGND sg13cmos5l_decap_8
XFILLER_654_227 VPWR VGND sg13cmos5l_decap_8
XFILLER_134_49 VPWR VGND sg13cmos5l_decap_8
X_3378_ Tile_X0Y2_E6BEG[1] _4073_/X VPWR VGND sg13cmos5l_buf_1
XFILLER_562_98 VPWR VGND sg13cmos5l_decap_8
XFILLER_712_35 VPWR VGND sg13cmos5l_decap_8
XFILLER_111_270 VPWR VGND sg13cmos5l_fill_2
XFILLER_281_77 VPWR VGND sg13cmos5l_decap_8
X_2329_ _2329_/Q Tile_X0Y5_FrameData[12] VGND VPWR Tile_X0Y9_FrameStrobe[4] latch
XFILLER_431_14 VPWR VGND sg13cmos5l_decap_8
XANTENNA__3242__X Tile_X0Y0_FrameData_O[10] VPWR VGND sg13cmos5l_antennanp
XFILLER_480_119 VPWR VGND sg13cmos5l_decap_8
XFILLER_27_14 VPWR VGND sg13cmos5l_decap_8
XFILLER_662_271 VPWR VGND sg13cmos5l_fill_2
XFILLER_84_154 VPWR VGND sg13cmos5l_decap_8
XFILLER_622_124 VPWR VGND sg13cmos5l_decap_8
XFILLER_272_244 VPWR VGND sg13cmos5l_decap_8
XFILLER_232_119 VPWR VGND sg13cmos5l_decap_8
XFILLER_168_7 VPWR VGND sg13cmos5l_decap_8
XFILLER_511_91 VPWR VGND sg13cmos5l_decap_8
XFILLER_414_271 VPWR VGND sg13cmos5l_fill_2
XFILLER_25_243 VPWR VGND sg13cmos5l_decap_8
XFILLER_225_193 VPWR VGND sg13cmos5l_fill_2
XFILLER_25_265 VPWR VGND sg13cmos5l_decap_8
XFILLER_709_217 VPWR VGND sg13cmos5l_fill_2
XFILLER_240_130 VPWR VGND sg13cmos5l_decap_8
XFILLER_240_141 VPWR VGND sg13cmos5l_fill_1
XFILLER_386_145 VPWR VGND sg13cmos5l_decap_4
XFILLER_575_245 VPWR VGND sg13cmos5l_decap_8
XFILLER_335_7 VPWR VGND sg13cmos5l_decap_8
XFILLER_587_84 VPWR VGND sg13cmos5l_decap_8
XFILLER_159_35 VPWR VGND sg13cmos5l_decap_4
XFILLER_43_68 VPWR VGND sg13cmos5l_decap_8
XFILLER_590_204 VPWR VGND sg13cmos5l_decap_8
XFILLER_40_268 VPWR VGND sg13cmos5l_decap_4
XFILLER_138_112 VPWR VGND sg13cmos5l_decap_8
XFILLER_528_161 VPWR VGND sg13cmos5l_decap_4
XFILLER_717_261 VPWR VGND sg13cmos5l_decap_8
XFILLER_717_272 VPWR VGND sg13cmos5l_fill_1
XFILLER_193_240 VPWR VGND sg13cmos5l_fill_1
XFILLER_502_7 VPWR VGND sg13cmos5l_decap_8
XFILLER_689_113 VPWR VGND sg13cmos5l_decap_8
XFILLER_193_262 VPWR VGND sg13cmos5l_fill_1
XFILLER_239_90 VPWR VGND sg13cmos5l_decap_8
XFILLER_138_189 VPWR VGND sg13cmos5l_decap_8
XFILLER_153_115 VPWR VGND sg13cmos5l_decap_8
XFILLER_153_126 VPWR VGND sg13cmos5l_fill_1
XFILLER_488_208 VPWR VGND sg13cmos5l_decap_8
XFILLER_606_14 VPWR VGND sg13cmos5l_decap_8
XANTENNA__3417__X Tile_X0Y4_FrameData_O[8] VPWR VGND sg13cmos5l_antennanp
XFILLER_153_148 VPWR VGND sg13cmos5l_fill_1
XFILLER_175_56 VPWR VGND sg13cmos5l_decap_8
XFILLER_472_21 VPWR VGND sg13cmos5l_decap_8
XFILLER_697_190 VPWR VGND sg13cmos5l_decap_8
XFILLER_68_21 VPWR VGND sg13cmos5l_decap_8
XFILLER_161_181 VPWR VGND sg13cmos5l_decap_8
XFILLER_325_48 VPWR VGND sg13cmos5l_decap_8
XFILLER_456_105 VPWR VGND sg13cmos5l_decap_8
XFILLER_325_59 VPWR VGND sg13cmos5l_decap_8
XFILLER_456_116 VPWR VGND sg13cmos5l_fill_1
XFILLER_645_238 VPWR VGND sg13cmos5l_decap_8
XFILLER_456_138 VPWR VGND sg13cmos5l_decap_8
XFILLER_622_35 VPWR VGND sg13cmos5l_decap_8
XFILLER_68_98 VPWR VGND sg13cmos5l_decap_8
XFILLER_405_70 VPWR VGND sg13cmos5l_decap_8
XFILLER_194_0 VPWR VGND sg13cmos5l_decap_8
XFILLER_310_189 VPWR VGND sg13cmos5l_decap_8
XFILLER_660_208 VPWR VGND sg13cmos5l_decap_8
XFILLER_341_14 VPWR VGND sg13cmos5l_decap_8
XANTENNA__3152__X Tile_X0Y7_FrameData_O[22] VPWR VGND sg13cmos5l_antennanp
XFILLER_208_105 VPWR VGND sg13cmos5l_decap_8
XFILLER_464_171 VPWR VGND sg13cmos5l_decap_8
XFILLER_263_222 VPWR VGND sg13cmos5l_decap_8
XFILLER_84_42 VPWR VGND sg13cmos5l_decap_8
XFILLER_698_28 VPWR VGND sg13cmos5l_decap_8
XFILLER_613_135 VPWR VGND sg13cmos5l_decap_8
XFILLER_361_0 VPWR VGND sg13cmos5l_decap_8
XFILLER_75_187 VPWR VGND sg13cmos5l_decap_8
XANTENNA__2991__X Tile_X0Y8_FrameData_O[31] VPWR VGND sg13cmos5l_antennanp
XFILLER_459_0 VPWR VGND sg13cmos5l_decap_8
XFILLER_216_160 VPWR VGND sg13cmos5l_decap_4
XFILLER_412_219 VPWR VGND sg13cmos5l_decap_8
XFILLER_16_232 VPWR VGND sg13cmos5l_decap_8
XFILLER_421_91 VPWR VGND sg13cmos5l_decap_8
XFILLER_405_271 VPWR VGND sg13cmos5l_fill_2
XFILLER_16_254 VPWR VGND sg13cmos5l_fill_1
XFILLER_17_80 VPWR VGND sg13cmos5l_decap_8
XFILLER_216_193 VPWR VGND sg13cmos5l_decap_8
XFILLER_140_70 VPWR VGND sg13cmos5l_decap_8
XFILLER_566_212 VPWR VGND sg13cmos5l_fill_1
XFILLER_626_0 VPWR VGND sg13cmos5l_decap_8
XFILLER_566_234 VPWR VGND sg13cmos5l_decap_8
XFILLER_377_145 VPWR VGND sg13cmos5l_decap_8
XFILLER_497_84 VPWR VGND sg13cmos5l_decap_8
XFILLER_647_21 VPWR VGND sg13cmos5l_decap_8
XFILLER_83_7 VPWR VGND sg13cmos5l_decap_8
XFILLER_392_115 VPWR VGND sg13cmos5l_fill_1
XFILLER_519_172 VPWR VGND sg13cmos5l_decap_8
X_1700_ _1700_/Q Tile_X0Y3_FrameData[5] VGND VPWR Tile_X0Y9_FrameStrobe[0] latch
XFILLER_366_22 VPWR VGND sg13cmos5l_decap_8
XFILLER_318_234 VPWR VGND sg13cmos5l_decap_8
XFILLER_184_251 VPWR VGND sg13cmos5l_decap_8
X_2680_ _2680_/Q Tile_X0Y6_FrameData[15] VGND VPWR Tile_X0Y9_FrameStrobe[7] latch
XFILLER_647_98 VPWR VGND sg13cmos5l_decap_8
XFILLER_219_49 VPWR VGND sg13cmos5l_decap_8
XFILLER_129_178 VPWR VGND sg13cmos5l_decap_8
XFILLER_534_164 VPWR VGND sg13cmos5l_decap_8
X_1631_ _1631_/Q Tile_X0Y2_FrameData[18] VGND VPWR Tile_X0Y9_FrameStrobe[6] latch
XFILLER_516_14 VPWR VGND sg13cmos5l_decap_8
XFILLER_479_219 VPWR VGND sg13cmos5l_decap_4
XFILLER_333_237 VPWR VGND sg13cmos5l_decap_8
XANTENNA__3327__X Tile_X0Y4_EE4BEG[15] VPWR VGND sg13cmos5l_antennanp
XFILLER_695_105 VPWR VGND sg13cmos5l_decap_8
XFILLER_663_42 VPWR VGND sg13cmos5l_decap_8
X_4350_ _4350_/X _4308_/X _0160_/X _4307_/X _0110_/X _1953_/Q _1952_/Q VPWR VGND sg13cmos5l_mux4_1
X_1562_ _1562_/Q Tile_X0Y2_FrameData[23] VGND VPWR Tile_X0Y9_FrameStrobe[4] latch
XFILLER_382_21 VPWR VGND sg13cmos5l_decap_8
X_3301_ Tile_X0Y0_E2BEG[1] _3805_/X VPWR VGND sg13cmos5l_buf_1
X_0513_ _0513_/Q Tile_X0Y8_FrameData[30] VGND VPWR Tile_X0Y9_FrameStrobe[3] latch
X_4281_ _4281_/X Tile_X0Y4_WW4END[6] AXI_M_SOC_BRESP0 _4342_/X _4314_/X _2051_/Q _2050_/Q
+ VPWR VGND sg13cmos5l_mux4_1
XFILLER_152_192 VPWR VGND sg13cmos5l_decap_8
XFILLER_98_246 VPWR VGND sg13cmos5l_decap_8
X_1493_ _1493_/Q Tile_X0Y2_FrameData[28] VGND VPWR Tile_X0Y9_FrameStrobe[2] latch
XFILLER_298_174 VPWR VGND sg13cmos5l_decap_8
XFILLER_98_257 VPWR VGND sg13cmos5l_fill_1
XFILLER_382_76 VPWR VGND sg13cmos5l_fill_1
X_3232_ Tile_X0Y0_FrameData_O[0] Tile_X0Y0_FrameData[0] VPWR VGND sg13cmos5l_buf_1
X_0444_ _0444_/Q Tile_X0Y8_FrameData[3] VGND VPWR Tile_X0Y9_FrameStrobe[0] latch
XFILLER_382_98 VPWR VGND sg13cmos5l_decap_8
XFILLER_532_35 VPWR VGND sg13cmos5l_decap_8
XFILLER_301_178 VPWR VGND sg13cmos5l_fill_2
X_3163_ Tile_X0Y4_E6BEG[0] _4288_/X VPWR VGND sg13cmos5l_buf_1
XFILLER_251_14 VPWR VGND sg13cmos5l_decap_8
X_0375_ _0375_/Q Tile_X0Y7_FrameData[8] VGND VPWR Tile_X0Y9_FrameStrobe[6] latch
XFILLER_532_79 VPWR VGND sg13cmos5l_decap_8
XANTENNA__3062__X Tile_X0Y5_FrameData_O[21] VPWR VGND sg13cmos5l_antennanp
X_2114_ _2114_/Q Tile_X0Y4_FrameData[3] VGND VPWR Tile_X0Y9_FrameStrobe[5] latch
XFILLER_66_154 VPWR VGND sg13cmos5l_decap_8
XFILLER_604_102 VPWR VGND sg13cmos5l_decap_8
X_3094_ Tile_X0Y7_E2BEGb[0] _4620_/X VPWR VGND sg13cmos5l_buf_1
XFILLER_81_124 VPWR VGND sg13cmos5l_decap_8
X_2045_ _2045_/Q Tile_X0Y4_FrameData[8] VGND VPWR Tile_X0Y9_FrameStrobe[3] latch
XFILLER_214_119 VPWR VGND sg13cmos5l_decap_4
XFILLER_557_201 VPWR VGND sg13cmos5l_decap_4
XFILLER_22_224 VPWR VGND sg13cmos5l_fill_1
XFILLER_22_246 VPWR VGND sg13cmos5l_decap_8
XFILLER_368_167 VPWR VGND sg13cmos5l_decap_8
XFILLER_22_257 VPWR VGND sg13cmos5l_fill_2
X_3996_ _3996_/X _3987_/X _0084_/X _3986_/X Tile_X0Y0_S4END[7] _1203_/Q _1202_/Q VPWR
+ VGND sg13cmos5l_mux4_1
XFILLER_557_267 VPWR VGND sg13cmos5l_decap_4
XFILLER_557_21 VPWR VGND sg13cmos5l_decap_8
XFILLER_383_126 VPWR VGND sg13cmos5l_decap_8
XFILLER_200_84 VPWR VGND sg13cmos5l_decap_8
X_2947_ Tile_X0Y8_EE4BEG[3] _4747_/X VPWR VGND sg13cmos5l_buf_1
XFILLER_13_49 VPWR VGND sg13cmos5l_decap_8
XFILLER_309_234 VPWR VGND sg13cmos5l_decap_8
XFILLER_714_220 VPWR VGND sg13cmos5l_decap_8
XFILLER_572_259 VPWR VGND sg13cmos5l_decap_4
XFILLER_129_49 VPWR VGND sg13cmos5l_decap_8
XFILLER_525_142 VPWR VGND sg13cmos5l_decap_8
X_2878_ Tile_X0Y6_EE4BEG[15] _4527_/X VPWR VGND sg13cmos5l_buf_1
XFILLER_707_35 VPWR VGND sg13cmos5l_decap_8
XFILLER_276_77 VPWR VGND sg13cmos5l_decap_8
X_4617_ _4617_/X Tile_X0Y7_W2MID[2] AXI_M_SOC_RDATA21 _4673_/X _4672_/X _0325_/Q _0324_/Q
+ VPWR VGND sg13cmos5l_mux4_1
X_1829_ _1829_/Q Tile_X0Y3_FrameData[4] VGND VPWR Tile_X0Y9_FrameStrobe[4] latch
XFILLER_426_14 VPWR VGND sg13cmos5l_decap_8
XANTENNA__3237__X Tile_X0Y0_FrameData_O[5] VPWR VGND sg13cmos5l_antennanp
XFILLER_135_148 VPWR VGND sg13cmos5l_decap_8
XFILLER_573_42 VPWR VGND sg13cmos5l_decap_8
X_4548_ _4548_/X Tile_X0Y5_W1END[2] Tile_X0Y5_W6END[10] _4465_/X _4422_/X _2399_/Q
+ _2398_/Q VPWR VGND sg13cmos5l_mux4_1
XFILLER_540_156 VPWR VGND sg13cmos5l_decap_8
XFILLER_540_167 VPWR VGND sg13cmos5l_fill_1
XFILLER_292_21 VPWR VGND sg13cmos5l_decap_8
XFILLER_540_189 VPWR VGND sg13cmos5l_fill_2
XFILLER_289_163 VPWR VGND sg13cmos5l_decap_8
X_4479_ _4479_/X Tile_X0Y7_W2MID[2] Tile_X0Y7_W2END[2] Tile_X0Y7_W6END[2] _4672_/X
+ _0397_/Q _0396_/Q VPWR VGND sg13cmos5l_mux4_1
XFILLER_627_216 VPWR VGND sg13cmos5l_fill_2
XFILLER_438_116 VPWR VGND sg13cmos5l_decap_8
XFILLER_506_91 VPWR VGND sg13cmos5l_decap_8
XFILLER_292_98 VPWR VGND sg13cmos5l_decap_8
XFILLER_493_255 VPWR VGND sg13cmos5l_fill_2
XFILLER_442_57 VPWR VGND sg13cmos5l_fill_2
XFILLER_38_35 VPWR VGND sg13cmos5l_fill_2
XFILLER_285_7 VPWR VGND sg13cmos5l_decap_8
XFILLER_446_160 VPWR VGND sg13cmos5l_decap_8
XFILLER_635_260 VPWR VGND sg13cmos5l_fill_2
XFILLER_635_271 VPWR VGND sg13cmos5l_fill_2
XFILLER_38_79 VPWR VGND sg13cmos5l_decap_4
XFILLER_72_102 VPWR VGND sg13cmos5l_decap_8
XFILLER_205_119 VPWR VGND sg13cmos5l_decap_8
XFILLER_72_135 VPWR VGND sg13cmos5l_decap_8
XFILLER_452_7 VPWR VGND sg13cmos5l_decap_8
XFILLER_72_146 VPWR VGND sg13cmos5l_fill_1
XFILLER_461_174 VPWR VGND sg13cmos5l_decap_8
XANTENNA__3700__X AXI_M_SOC_WDATA10 VPWR VGND sg13cmos5l_antennanp
XFILLER_72_157 VPWR VGND sg13cmos5l_decap_8
XFILLER_260_236 VPWR VGND sg13cmos5l_decap_8
XFILLER_610_138 VPWR VGND sg13cmos5l_decap_8
XFILLER_213_130 VPWR VGND sg13cmos5l_decap_8
XFILLER_359_112 VPWR VGND sg13cmos5l_decap_8
XFILLER_359_123 VPWR VGND sg13cmos5l_fill_2
XFILLER_13_257 VPWR VGND sg13cmos5l_fill_2
XFILLER_359_167 VPWR VGND sg13cmos5l_fill_2
XFILLER_333_4 VPWR VGND sg13cmos5l_fill_1
XFILLER_9_206 VPWR VGND sg13cmos5l_fill_1
XFILLER_467_21 VPWR VGND sg13cmos5l_decap_8
XFILLER_9_228 VPWR VGND sg13cmos5l_decap_8
XFILLER_70_22 VPWR VGND sg13cmos5l_decap_8
XFILLER_563_237 VPWR VGND sg13cmos5l_decap_8
XFILLER_705_242 VPWR VGND sg13cmos5l_decap_8
XFILLER_70_99 VPWR VGND sg13cmos5l_decap_8
XFILLER_617_35 VPWR VGND sg13cmos5l_decap_8
XFILLER_186_88 VPWR VGND sg13cmos5l_decap_8
XFILLER_336_14 VPWR VGND sg13cmos5l_decap_8
XFILLER_677_105 VPWR VGND sg13cmos5l_decap_8
XANTENNA__3147__X Tile_X0Y7_FrameData_O[17] VPWR VGND sg13cmos5l_antennanp
XFILLER_207_0 VPWR VGND sg13cmos5l_decap_8
XFILLER_677_116 VPWR VGND sg13cmos5l_fill_1
XFILLER_531_145 VPWR VGND sg13cmos5l_decap_8
XFILLER_79_42 VPWR VGND sg13cmos5l_decap_8
XFILLER_677_138 VPWR VGND sg13cmos5l_decap_8
XFILLER_483_64 VPWR VGND sg13cmos5l_decap_8
XFILLER_483_75 VPWR VGND sg13cmos5l_fill_1
XFILLER_469_230 VPWR VGND sg13cmos5l_decap_8
XANTENNA__2986__X Tile_X0Y8_FrameData_O[26] VPWR VGND sg13cmos5l_antennanp
XFILLER_134_170 VPWR VGND sg13cmos5l_decap_8
XFILLER_692_108 VPWR VGND sg13cmos5l_decap_8
XFILLER_429_105 VPWR VGND sg13cmos5l_decap_8
XFILLER_685_171 VPWR VGND sg13cmos5l_fill_2
XFILLER_633_56 VPWR VGND sg13cmos5l_decap_8
XFILLER_416_91 VPWR VGND sg13cmos5l_fill_1
XFILLER_295_133 VPWR VGND sg13cmos5l_decap_8
XFILLER_95_205 VPWR VGND sg13cmos5l_decap_8
XFILLER_484_244 VPWR VGND sg13cmos5l_decap_8
XFILLER_352_35 VPWR VGND sg13cmos5l_decap_8
XFILLER_135_70 VPWR VGND sg13cmos5l_decap_8
XFILLER_576_0 VPWR VGND sg13cmos5l_decap_8
XFILLER_48_121 VPWR VGND sg13cmos5l_decap_8
XFILLER_0_194 VPWR VGND sg13cmos5l_fill_1
XFILLER_95_63 VPWR VGND sg13cmos5l_decap_8
XFILLER_626_260 VPWR VGND sg13cmos5l_decap_8
XFILLER_626_271 VPWR VGND sg13cmos5l_fill_2
X_0160_ _0160_/X _4330_/X _4331_/X _0639_/Q VPWR VGND sg13cmos5l_mux2_1
XFILLER_502_49 VPWR VGND sg13cmos5l_decap_8
XFILLER_236_255 VPWR VGND sg13cmos5l_decap_8
XFILLER_221_28 VPWR VGND sg13cmos5l_decap_8
XFILLER_641_252 VPWR VGND sg13cmos5l_decap_4
XFILLER_598_145 VPWR VGND sg13cmos5l_decap_8
X_0091_ _3624_/A _4488_/X _4489_/X _2627_/Q VPWR VGND sg13cmos5l_mux2_1
XFILLER_63_146 VPWR VGND sg13cmos5l_decap_8
XANTENNA__3610__X Tile_X0Y9_S2BEG[4] VPWR VGND sg13cmos5l_antennanp
XFILLER_598_167 VPWR VGND sg13cmos5l_fill_1
XFILLER_251_247 VPWR VGND sg13cmos5l_decap_8
XFILLER_301_50 VPWR VGND sg13cmos5l_decap_8
XFILLER_658_42 VPWR VGND sg13cmos5l_decap_8
XFILLER_539_234 VPWR VGND sg13cmos5l_decap_8
X_3850_ _3850_/X Tile_X0Y1_W1END[2] Tile_X0Y1_W6END[6] _3999_/X _3978_/X _1421_/Q
+ _1420_/Q VPWR VGND sg13cmos5l_mux4_1
XFILLER_377_21 VPWR VGND sg13cmos5l_decap_8
X_2801_ Tile_X0Y3_E6BEG[11] _4191_/X VPWR VGND sg13cmos5l_buf_1
X_3781_ _3781_/X Tile_X0Y0_W1END[1] Tile_X0Y0_W6END[5] _3871_/X _3860_/X _1175_/Q
+ _1174_/Q VPWR VGND sg13cmos5l_mux4_1
X_0993_ _0993_/Q Tile_X0Y0_FrameData[10] VGND VPWR Tile_X0Y9_FrameStrobe[1] latch
X_2732_ _3880_/A3 VPWR VGND sg13cmos5l_tielo
XFILLER_507_131 VPWR VGND sg13cmos5l_decap_4
XFILLER_157_262 VPWR VGND sg13cmos5l_fill_1
XFILLER_507_142 VPWR VGND sg13cmos5l_decap_8
XFILLER_527_35 VPWR VGND sg13cmos5l_decap_8
X_2663_ _2663_/Q Tile_X0Y6_FrameData[0] VGND VPWR Tile_X0Y9_FrameStrobe[6] latch
XFILLER_674_63 VPWR VGND sg13cmos5l_decap_8
XFILLER_117_137 VPWR VGND sg13cmos5l_decap_8
XANTENNA__3057__X Tile_X0Y5_FrameData_O[16] VPWR VGND sg13cmos5l_antennanp
XFILLER_172_243 VPWR VGND sg13cmos5l_decap_8
XFILLER_373_192 VPWR VGND sg13cmos5l_fill_1
XFILLER_246_36 VPWR VGND sg13cmos5l_decap_8
X_1614_ _1614_/Q Tile_X0Y2_FrameData[3] VGND VPWR Tile_X0Y9_FrameStrobe[5] latch
X_4402_ _4402_/X Tile_X0Y5_WW4END[1] AXI_M_SOC_RLAST _4452_/X _4430_/X _2299_/Q _2298_/Q
+ VPWR VGND sg13cmos5l_mux4_1
XFILLER_522_145 VPWR VGND sg13cmos5l_decap_8
XFILLER_711_245 VPWR VGND sg13cmos5l_fill_1
X_2594_ _2594_/Q Tile_X0Y6_FrameData[5] VGND VPWR Tile_X0Y9_FrameStrobe[4] latch
XFILLER_321_207 VPWR VGND sg13cmos5l_decap_8
XFILLER_668_149 VPWR VGND sg13cmos5l_fill_2
XFILLER_393_97 VPWR VGND sg13cmos5l_decap_4
XANTENNA__2896__X Tile_X0Y6_FrameData_O[17] VPWR VGND sg13cmos5l_antennanp
X_1545_ _1545_/Q Tile_X0Y2_FrameData[8] VGND VPWR Tile_X0Y9_FrameStrobe[3] latch
X_4333_ _4333_/X _3879_/X _3864_/X _3863_/X _3852_/X _1108_/Q _1107_/Q VPWR VGND sg13cmos5l_mux4_1
XFILLER_543_56 VPWR VGND sg13cmos5l_decap_8
XFILLER_326_91 VPWR VGND sg13cmos5l_decap_8
XFILLER_140_140 VPWR VGND sg13cmos5l_decap_8
X_4264_ _4264_/X Tile_X0Y4_W2END[7] AXI_M_SOC_BRESP1 _4313_/X _4312_/X _2085_/Q _2084_/Q
+ VPWR VGND sg13cmos5l_mux4_1
XFILLER_609_238 VPWR VGND sg13cmos5l_fill_1
XFILLER_286_133 VPWR VGND sg13cmos5l_decap_8
X_1476_ _1476_/Q Tile_X0Y2_FrameData[13] VGND VPWR Tile_X0Y9_FrameStrobe[1] latch
XFILLER_691_130 VPWR VGND sg13cmos5l_decap_4
XFILLER_262_35 VPWR VGND sg13cmos5l_decap_8
X_3215_ Tile_X0Y0_FrameStrobe_O[3] Tile_X0Y9_FrameStrobe[3] VPWR VGND sg13cmos5l_buf_1
XFILLER_475_266 VPWR VGND sg13cmos5l_decap_8
XFILLER_86_249 VPWR VGND sg13cmos5l_decap_8
X_0427_ _0427_/Q Tile_X0Y8_FrameData[20] VGND VPWR Tile_X0Y9_FrameStrobe[0] latch
XFILLER_624_208 VPWR VGND sg13cmos5l_decap_8
XFILLER_227_200 VPWR VGND sg13cmos5l_decap_8
X_4195_ _4195_/X Tile_X0Y4_W1END[0] Tile_X0Y4_W6END[4] _4348_/X _4300_/X _2181_/Q
+ _2180_/Q VPWR VGND sg13cmos5l_mux4_1
XFILLER_435_119 VPWR VGND sg13cmos5l_decap_8
XFILLER_39_121 VPWR VGND sg13cmos5l_decap_8
XFILLER_428_182 VPWR VGND sg13cmos5l_decap_8
X_3146_ Tile_X0Y7_FrameData_O[16] Tile_X0Y7_FrameData[16] VPWR VGND sg13cmos5l_buf_1
XFILLER_227_244 VPWR VGND sg13cmos5l_decap_8
X_0358_ _0358_/Q Tile_X0Y7_FrameData[25] VGND VPWR Tile_X0Y9_FrameStrobe[6] latch
XFILLER_490_258 VPWR VGND sg13cmos5l_fill_2
XFILLER_699_71 VPWR VGND sg13cmos5l_decap_8
XFILLER_589_145 VPWR VGND sg13cmos5l_fill_2
XFILLER_242_203 VPWR VGND sg13cmos5l_decap_8
X_3077_ Tile_X0Y4_E2BEGb[3] _4267_/X VPWR VGND sg13cmos5l_buf_1
XANTENNA__3520__X Tile_X0Y1_E1BEG[2] VPWR VGND sg13cmos5l_antennanp
X_0289_ _0289_/Q Tile_X0Y7_FrameData[30] VGND VPWR Tile_X0Y9_FrameStrobe[4] latch
X_2028_ _2028_/Q Tile_X0Y4_FrameData[25] VGND VPWR Tile_X0Y9_FrameStrobe[3] latch
XFILLER_589_189 VPWR VGND sg13cmos5l_decap_8
XFILLER_54_179 VPWR VGND sg13cmos5l_decap_8
XFILLER_242_247 VPWR VGND sg13cmos5l_decap_8
XFILLER_568_42 VPWR VGND sg13cmos5l_decap_8
XFILLER_287_21 VPWR VGND sg13cmos5l_decap_8
XFILLER_210_133 VPWR VGND sg13cmos5l_decap_8
XFILLER_545_215 VPWR VGND sg13cmos5l_decap_8
XFILLER_356_126 VPWR VGND sg13cmos5l_decap_8
X_3979_ _3979_/X _3987_/X Tile_X0Y1_W6END[3] _3986_/X _3979_/A3 _1179_/Q _1426_/Q
+ VPWR VGND sg13cmos5l_mux4_1
XFILLER_10_238 VPWR VGND sg13cmos5l_decap_4
XFILLER_287_98 VPWR VGND sg13cmos5l_decap_8
XFILLER_437_35 VPWR VGND sg13cmos5l_decap_8
XFILLER_108_126 VPWR VGND sg13cmos5l_decap_8
XFILLER_163_221 VPWR VGND sg13cmos5l_decap_8
XFILLER_584_63 VPWR VGND sg13cmos5l_decap_8
XFILLER_513_112 VPWR VGND sg13cmos5l_decap_8
XFILLER_364_181 VPWR VGND sg13cmos5l_decap_8
XFILLER_156_36 VPWR VGND sg13cmos5l_decap_4
XFILLER_200_7 VPWR VGND sg13cmos5l_decap_8
XFILLER_659_127 VPWR VGND sg13cmos5l_decap_4
XFILLER_513_134 VPWR VGND sg13cmos5l_decap_8
XFILLER_702_256 VPWR VGND sg13cmos5l_decap_4
XFILLER_306_28 VPWR VGND sg13cmos5l_decap_8
XFILLER_674_119 VPWR VGND sg13cmos5l_decap_8
XFILLER_131_140 VPWR VGND sg13cmos5l_decap_8
XFILLER_466_222 VPWR VGND sg13cmos5l_decap_8
XFILLER_172_35 VPWR VGND sg13cmos5l_decap_8
XFILLER_49_67 VPWR VGND sg13cmos5l_decap_8
XFILLER_131_184 VPWR VGND sg13cmos5l_decap_8
XFILLER_277_166 VPWR VGND sg13cmos5l_decap_8
XFILLER_131_195 VPWR VGND sg13cmos5l_fill_1
XFILLER_172_68 VPWR VGND sg13cmos5l_decap_8
XFILLER_426_119 VPWR VGND sg13cmos5l_decap_8
XFILLER_667_7 VPWR VGND sg13cmos5l_decap_8
XFILLER_277_199 VPWR VGND sg13cmos5l_decap_8
XFILLER_218_233 VPWR VGND sg13cmos5l_decap_8
XFILLER_419_182 VPWR VGND sg13cmos5l_decap_8
XFILLER_218_244 VPWR VGND sg13cmos5l_fill_2
XFILLER_105_84 VPWR VGND sg13cmos5l_decap_8
XANTENNA_101 _0157_/X VPWR VGND sg13cmos5l_antennanp
XFILLER_65_77 VPWR VGND sg13cmos5l_decap_8
XANTENNA_112 _0157_/X VPWR VGND sg13cmos5l_antennanp
XANTENNA__3430__X Tile_X0Y4_FrameData_O[21] VPWR VGND sg13cmos5l_antennanp
XANTENNA_123 Tile_X0Y6_FrameData[30] VPWR VGND sg13cmos5l_antennanp
XFILLER_379_218 VPWR VGND sg13cmos5l_decap_8
XANTENNA_134 Tile_X0Y6_FrameData[31] VPWR VGND sg13cmos5l_antennanp
XFILLER_233_247 VPWR VGND sg13cmos5l_decap_8
XFILLER_45_179 VPWR VGND sg13cmos5l_decap_8
XANTENNA_145 _4817_/X VPWR VGND sg13cmos5l_antennanp
XFILLER_60_116 VPWR VGND sg13cmos5l_decap_8
XFILLER_595_126 VPWR VGND sg13cmos5l_decap_8
XANTENNA_156 Tile_X0Y9_FrameStrobe[8] VPWR VGND sg13cmos5l_antennanp
XFILLER_60_127 VPWR VGND sg13cmos5l_fill_2
XANTENNA_167 Tile_X0Y9_FrameStrobe[8] VPWR VGND sg13cmos5l_antennanp
XANTENNA_178 Tile_X0Y9_FrameStrobe[8] VPWR VGND sg13cmos5l_antennanp
XFILLER_157_0 VPWR VGND sg13cmos5l_decap_8
XFILLER_81_21 VPWR VGND sg13cmos5l_decap_4
XFILLER_478_42 VPWR VGND sg13cmos5l_decap_8
XANTENNA_189 Tile_X0Y9_FrameStrobe[8] VPWR VGND sg13cmos5l_antennanp
XFILLER_198_162 VPWR VGND sg13cmos5l_decap_8
XFILLER_81_54 VPWR VGND sg13cmos5l_decap_8
XFILLER_197_21 VPWR VGND sg13cmos5l_decap_8
XFILLER_478_75 VPWR VGND sg13cmos5l_decap_8
XFILLER_347_126 VPWR VGND sg13cmos5l_decap_8
XFILLER_201_144 VPWR VGND sg13cmos5l_decap_8
XFILLER_536_226 VPWR VGND sg13cmos5l_decap_8
XFILLER_324_0 VPWR VGND sg13cmos5l_decap_4
XFILLER_14_70 VPWR VGND sg13cmos5l_decap_8
XFILLER_628_78 VPWR VGND sg13cmos5l_decap_8
XFILLER_347_35 VPWR VGND sg13cmos5l_decap_8
XFILLER_494_63 VPWR VGND sg13cmos5l_decap_8
XFILLER_504_112 VPWR VGND sg13cmos5l_decap_8
XFILLER_5_242 VPWR VGND sg13cmos5l_decap_8
XFILLER_693_0 VPWR VGND sg13cmos5l_decap_8
XFILLER_644_77 VPWR VGND sg13cmos5l_decap_8
XFILLER_216_28 VPWR VGND sg13cmos5l_decap_8
XFILLER_665_119 VPWR VGND sg13cmos5l_decap_4
XANTENNA__3605__X Tile_X0Y9_S1BEG[3] VPWR VGND sg13cmos5l_antennanp
XFILLER_146_91 VPWR VGND sg13cmos5l_decap_8
X_1330_ _1330_/Q Tile_X0Y1_FrameData[7] VGND VPWR Tile_X0Y9_FrameStrobe[4] latch
XFILLER_660_21 VPWR VGND sg13cmos5l_decap_8
XFILLER_122_184 VPWR VGND sg13cmos5l_fill_1
XFILLER_68_238 VPWR VGND sg13cmos5l_decap_8
XFILLER_673_141 VPWR VGND sg13cmos5l_decap_4
XFILLER_122_195 VPWR VGND sg13cmos5l_decap_8
X_1261_ _1261_/Q Tile_X0Y1_FrameData[12] VGND VPWR Tile_X0Y9_FrameStrobe[2] latch
XFILLER_417_119 VPWR VGND sg13cmos5l_decap_8
XFILLER_673_174 VPWR VGND sg13cmos5l_decap_8
X_3000_ Tile_X0Y5_E2BEG[3] _4375_/X VPWR VGND sg13cmos5l_buf_1
X_0212_ _0212_/Q Tile_X0Y7_FrameData[11] VGND VPWR Tile_X0Y9_FrameStrobe[1] latch
XFILLER_283_147 VPWR VGND sg13cmos5l_decap_8
XFILLER_660_98 VPWR VGND sg13cmos5l_decap_8
XFILLER_472_247 VPWR VGND sg13cmos5l_decap_8
X_1192_ _1192_/Q Tile_X0Y1_FrameData[17] VGND VPWR Tile_X0Y9_FrameStrobe[0] latch
XFILLER_76_271 VPWR VGND sg13cmos5l_fill_2
X_0143_ _0143_/X _4435_/X _4436_/X _1363_/Q VPWR VGND sg13cmos5l_mux2_1
XFILLER_614_252 VPWR VGND sg13cmos5l_decap_4
XFILLER_36_135 VPWR VGND sg13cmos5l_decap_8
XANTENNA__3340__X Tile_X0Y2_FrameData_O[11] VPWR VGND sg13cmos5l_antennanp
XFILLER_425_196 VPWR VGND sg13cmos5l_decap_8
X_0074_ _0074_/X _4798_/X _4799_/X _2110_/Q VPWR VGND sg13cmos5l_mux2_1
X_3902_ _3902_/X Tile_X0Y2_W2MID[0] Tile_X0Y2_W2END[0] Tile_X0Y2_W6END[0] _4096_/X
+ _1651_/Q _1650_/Q VPWR VGND sg13cmos5l_mux4_1
XFILLER_378_240 VPWR VGND sg13cmos5l_decap_8
XFILLER_388_53 VPWR VGND sg13cmos5l_decap_8
X_4882_ _4882_/X Tile_X0Y9_N4END[2] _0081_/X _4925_/X _4929_/X _0779_/Q _0778_/Q VPWR
+ VGND sg13cmos5l_mux4_1
XFILLER_440_199 VPWR VGND sg13cmos5l_decap_8
XFILLER_189_195 VPWR VGND sg13cmos5l_decap_8
X_3833_ _3833_/X Tile_X0Y0_WW4END[2] _3883_/X _3857_/X _3880_/X _1039_/Q _1038_/Q
+ VPWR VGND sg13cmos5l_mux4_1
XFILLER_338_126 VPWR VGND sg13cmos5l_fill_2
XFILLER_538_56 VPWR VGND sg13cmos5l_decap_8
XFILLER_685_62 VPWR VGND sg13cmos5l_decap_4
XFILLER_393_254 VPWR VGND sg13cmos5l_decap_8
X_0976_ _0976_/Q Tile_X0Y0_FrameData[27] VGND VPWR Tile_X0Y9_FrameStrobe[1] latch
X_3764_ _3764_/X Tile_X0Y1_WW4END[5] Tile_X0Y1_WW4END[13] Tile_X0Y1_W6END[5] _4013_/X
+ _1247_/Q _1246_/Q VPWR VGND sg13cmos5l_mux4_1
XFILLER_72_0 VPWR VGND sg13cmos5l_decap_8
XFILLER_685_95 VPWR VGND sg13cmos5l_decap_8
XFILLER_257_35 VPWR VGND sg13cmos5l_decap_8
X_2715_ _4416_/A3 VPWR VGND sg13cmos5l_tielo
XFILLER_145_243 VPWR VGND sg13cmos5l_fill_2
X_3695_ AXI_M_SOC_WDATA5 Tile_X0Y7_WW4END[5] Tile_X0Y7_WW4END[13] Tile_X0Y7_W6END[5]
+ _4689_/X _0237_/Q _0236_/Q VPWR VGND sg13cmos5l_mux4_1
XFILLER_696_211 VPWR VGND sg13cmos5l_fill_2
XFILLER_550_240 VPWR VGND sg13cmos5l_decap_8
XFILLER_10_28 VPWR VGND sg13cmos5l_decap_8
X_2646_ _2646_/Q Tile_X0Y6_FrameData[17] VGND VPWR Tile_X0Y9_FrameStrobe[6] latch
XFILLER_407_49 VPWR VGND sg13cmos5l_decap_8
XFILLER_126_28 VPWR VGND sg13cmos5l_decap_8
XFILLER_554_77 VPWR VGND sg13cmos5l_decap_8
X_2577_ _2577_/Q Tile_X0Y6_FrameData[22] VGND VPWR Tile_X0Y9_FrameStrobe[4] latch
XFILLER_704_14 VPWR VGND sg13cmos5l_decap_8
XFILLER_510_126 VPWR VGND sg13cmos5l_decap_4
XFILLER_510_137 VPWR VGND sg13cmos5l_decap_8
XFILLER_259_111 VPWR VGND sg13cmos5l_decap_8
XANTENNA__3515__X Tile_X0Y1_E2BEG[5] VPWR VGND sg13cmos5l_antennanp
XFILLER_510_148 VPWR VGND sg13cmos5l_fill_2
XFILLER_273_56 VPWR VGND sg13cmos5l_decap_8
XFILLER_649_171 VPWR VGND sg13cmos5l_decap_8
X_4316_ _4316_/X _4247_/X _4363_/X _4362_/X _4246_/X _1939_/Q _1938_/Q VPWR VGND sg13cmos5l_mux4_1
X_1528_ _1528_/Q Tile_X0Y2_FrameData[25] VGND VPWR Tile_X0Y9_FrameStrobe[3] latch
XFILLER_570_21 VPWR VGND sg13cmos5l_decap_8
XFILLER_302_262 VPWR VGND sg13cmos5l_fill_2
XFILLER_59_249 VPWR VGND sg13cmos5l_decap_8
X_1459_ _1459_/Q Tile_X0Y2_FrameData[30] VGND VPWR Tile_X0Y9_FrameStrobe[1] latch
X_4247_ _4247_/X Tile_X0Y5_W2MID[2] Tile_X0Y5_W2END[2] Tile_X0Y5_W6END[2] _4431_/X
+ _2421_/Q _2420_/Q VPWR VGND sg13cmos5l_mux4_1
XFILLER_664_163 VPWR VGND sg13cmos5l_decap_8
XFILLER_274_114 VPWR VGND sg13cmos5l_decap_8
XFILLER_19_37 VPWR VGND sg13cmos5l_fill_1
XFILLER_74_219 VPWR VGND sg13cmos5l_decap_4
XFILLER_463_247 VPWR VGND sg13cmos5l_fill_1
XFILLER_142_49 VPWR VGND sg13cmos5l_decap_8
X_4178_ _4178_/X Tile_X0Y3_WW4END[1] AXI_M_SOC_BVALID _4223_/X _4207_/X _1785_/Q _1784_/Q
+ VPWR VGND sg13cmos5l_mux4_1
XFILLER_570_98 VPWR VGND sg13cmos5l_decap_8
XFILLER_605_230 VPWR VGND sg13cmos5l_decap_8
XFILLER_27_102 VPWR VGND sg13cmos5l_decap_8
XFILLER_503_70 VPWR VGND sg13cmos5l_decap_8
XFILLER_463_269 VPWR VGND sg13cmos5l_decap_4
XFILLER_416_141 VPWR VGND sg13cmos5l_decap_8
X_3129_ Tile_X0Y7_EE4BEG[15] _4643_/X VPWR VGND sg13cmos5l_buf_1
XANTENNA__3250__X Tile_X0Y0_FrameData_O[18] VPWR VGND sg13cmos5l_antennanp
XFILLER_27_146 VPWR VGND sg13cmos5l_decap_4
XFILLER_35_14 VPWR VGND sg13cmos5l_decap_8
XFILLER_577_115 VPWR VGND sg13cmos5l_decap_8
XFILLER_27_179 VPWR VGND sg13cmos5l_decap_8
XFILLER_215_258 VPWR VGND sg13cmos5l_fill_2
XFILLER_579_63 VPWR VGND sg13cmos5l_decap_8
XFILLER_431_133 VPWR VGND sg13cmos5l_decap_8
XFILLER_255_8 VPWR VGND sg13cmos5l_decap_8
XFILLER_42_138 VPWR VGND sg13cmos5l_decap_8
XFILLER_150_7 VPWR VGND sg13cmos5l_decap_8
XFILLER_42_149 VPWR VGND sg13cmos5l_fill_1
XFILLER_369_240 VPWR VGND sg13cmos5l_decap_8
XFILLER_298_42 VPWR VGND sg13cmos5l_decap_8
XFILLER_248_7 VPWR VGND sg13cmos5l_decap_8
XFILLER_329_104 VPWR VGND sg13cmos5l_decap_8
XFILLER_518_215 VPWR VGND sg13cmos5l_decap_8
XFILLER_50_160 VPWR VGND sg13cmos5l_decap_4
XFILLER_585_181 VPWR VGND sg13cmos5l_decap_8
XFILLER_518_226 VPWR VGND sg13cmos5l_fill_1
XFILLER_518_248 VPWR VGND sg13cmos5l_decap_8
XFILLER_448_56 VPWR VGND sg13cmos5l_decap_8
XFILLER_384_254 VPWR VGND sg13cmos5l_decap_8
XFILLER_329_159 VPWR VGND sg13cmos5l_decap_8
XFILLER_51_46 VPWR VGND sg13cmos5l_decap_8
XFILLER_415_7 VPWR VGND sg13cmos5l_decap_8
XFILLER_51_57 VPWR VGND sg13cmos5l_fill_2
XFILLER_167_35 VPWR VGND sg13cmos5l_decap_8
XFILLER_533_207 VPWR VGND sg13cmos5l_decap_4
XFILLER_136_221 VPWR VGND sg13cmos5l_decap_8
XFILLER_337_181 VPWR VGND sg13cmos5l_decap_8
XFILLER_498_133 VPWR VGND sg13cmos5l_decap_8
XFILLER_352_140 VPWR VGND sg13cmos5l_decap_8
XFILLER_687_233 VPWR VGND sg13cmos5l_decap_8
XFILLER_317_38 VPWR VGND sg13cmos5l_decap_8
XFILLER_2_223 VPWR VGND sg13cmos5l_decap_8
XFILLER_614_14 VPWR VGND sg13cmos5l_decap_8
XFILLER_501_126 VPWR VGND sg13cmos5l_decap_8
XFILLER_647_119 VPWR VGND sg13cmos5l_decap_8
XANTENNA__3425__X Tile_X0Y4_FrameData_O[16] VPWR VGND sg13cmos5l_antennanp
XFILLER_333_15 VPWR VGND sg13cmos5l_decap_8
XFILLER_655_130 VPWR VGND sg13cmos5l_fill_1
XFILLER_480_21 VPWR VGND sg13cmos5l_decap_8
XFILLER_104_195 VPWR VGND sg13cmos5l_decap_8
XFILLER_76_21 VPWR VGND sg13cmos5l_decap_8
XFILLER_670_122 VPWR VGND sg13cmos5l_decap_8
XFILLER_454_247 VPWR VGND sg13cmos5l_decap_8
XFILLER_630_35 VPWR VGND sg13cmos5l_decap_8
XFILLER_58_271 VPWR VGND sg13cmos5l_fill_2
XFILLER_18_113 VPWR VGND sg13cmos5l_decap_8
XFILLER_413_70 VPWR VGND sg13cmos5l_decap_8
XFILLER_274_0 VPWR VGND sg13cmos5l_decap_8
XANTENNA__3160__X Tile_X0Y7_FrameData_O[30] VPWR VGND sg13cmos5l_antennanp
XFILLER_670_199 VPWR VGND sg13cmos5l_fill_1
XFILLER_92_42 VPWR VGND sg13cmos5l_decap_8
XFILLER_611_233 VPWR VGND sg13cmos5l_decap_8
XFILLER_422_133 VPWR VGND sg13cmos5l_decap_8
XFILLER_568_126 VPWR VGND sg13cmos5l_decap_8
XFILLER_489_63 VPWR VGND sg13cmos5l_decap_8
XFILLER_441_0 VPWR VGND sg13cmos5l_decap_8
XFILLER_221_206 VPWR VGND sg13cmos5l_decap_8
XFILLER_33_138 VPWR VGND sg13cmos5l_decap_8
XFILLER_539_0 VPWR VGND sg13cmos5l_decap_8
XFILLER_639_77 VPWR VGND sg13cmos5l_decap_8
XFILLER_576_181 VPWR VGND sg13cmos5l_fill_2
XFILLER_41_160 VPWR VGND sg13cmos5l_fill_1
XFILLER_706_0 VPWR VGND sg13cmos5l_decap_8
XFILLER_41_182 VPWR VGND sg13cmos5l_decap_8
XFILLER_375_254 VPWR VGND sg13cmos5l_decap_8
XFILLER_358_56 VPWR VGND sg13cmos5l_decap_8
XFILLER_186_165 VPWR VGND sg13cmos5l_decap_4
X_0830_ _0830_/Q Tile_X0Y9_FrameData[1] VGND VPWR Tile_X0Y9_FrameStrobe[4] latch
XFILLER_591_140 VPWR VGND sg13cmos5l_decap_8
XFILLER_655_21 VPWR VGND sg13cmos5l_decap_8
X_0761_ _0761_/Q Tile_X0Y9_FrameData[6] VGND VPWR Tile_X0Y9_FrameStrobe[2] latch
XFILLER_655_43 VPWR VGND sg13cmos5l_decap_8
XFILLER_489_100 VPWR VGND sg13cmos5l_fill_1
XFILLER_328_192 VPWR VGND sg13cmos5l_decap_8
XFILLER_374_22 VPWR VGND sg13cmos5l_decap_8
X_2500_ _2500_/Q Tile_X0Y6_FrameData[3] VGND VPWR Tile_X0Y9_FrameStrobe[1] latch
X_3480_ Tile_X0Y1_EE4BEG[6] _3954_/X VPWR VGND sg13cmos5l_buf_1
X_0692_ _0692_/Q Tile_X0Y9_FrameData[11] VGND VPWR Tile_X0Y9_FrameStrobe[0] latch
XFILLER_374_55 VPWR VGND sg13cmos5l_fill_1
XFILLER_288_206 VPWR VGND sg13cmos5l_decap_8
X_2431_ _2431_/Q Tile_X0Y5_FrameData[6] VGND VPWR Tile_X0Y9_FrameStrobe[7] latch
XFILLER_142_246 VPWR VGND sg13cmos5l_fill_1
XFILLER_489_177 VPWR VGND sg13cmos5l_decap_4
XFILLER_638_119 VPWR VGND sg13cmos5l_decap_8
XFILLER_524_14 VPWR VGND sg13cmos5l_decap_8
XANTENNA__3335__X Tile_X0Y2_FrameData_O[6] VPWR VGND sg13cmos5l_antennanp
XFILLER_671_42 VPWR VGND sg13cmos5l_decap_8
X_2362_ _2362_/Q Tile_X0Y5_FrameData[11] VGND VPWR Tile_X0Y9_FrameStrobe[5] latch
XFILLER_671_75 VPWR VGND sg13cmos5l_decap_8
XFILLER_390_21 VPWR VGND sg13cmos5l_decap_8
X_1313_ _1313_/Q Tile_X0Y1_FrameData[24] VGND VPWR Tile_X0Y9_FrameStrobe[4] latch
X_4101_ _4101_/X _4025_/X _4133_/X _4132_/X _4024_/X _1445_/Q _1444_/Q VPWR VGND sg13cmos5l_mux4_1
XFILLER_296_272 VPWR VGND sg13cmos5l_fill_1
X_2293_ _2293_/Q Tile_X0Y5_FrameData[16] VGND VPWR Tile_X0Y9_FrameStrobe[3] latch
X_4032_ _4032_/X Tile_X0Y0_W1END[2] Tile_X0Y0_W2MID[1] Tile_X0Y0_W2END[1] _3854_/X
+ _1121_/Q _1120_/Q VPWR VGND sg13cmos5l_mux4_1
XFILLER_646_196 VPWR VGND sg13cmos5l_decap_8
XFILLER_256_147 VPWR VGND sg13cmos5l_decap_8
X_1244_ _1244_/Q Tile_X0Y1_FrameData[29] VGND VPWR Tile_X0Y9_FrameStrobe[2] latch
XFILLER_661_144 VPWR VGND sg13cmos5l_fill_2
XFILLER_540_35 VPWR VGND sg13cmos5l_decap_8
XFILLER_110_198 VPWR VGND sg13cmos5l_fill_1
XFILLER_2_84 VPWR VGND sg13cmos5l_decap_8
XFILLER_460_206 VPWR VGND sg13cmos5l_decap_8
XFILLER_599_240 VPWR VGND sg13cmos5l_decap_4
X_1175_ _1175_/Q Tile_X0Y0_FrameData[20] VGND VPWR Tile_X0Y9_FrameStrobe[7] latch
XANTENNA__3070__X Tile_X0Y5_FrameData_O[29] VPWR VGND sg13cmos5l_antennanp
XFILLER_602_200 VPWR VGND sg13cmos5l_fill_2
XFILLER_540_79 VPWR VGND sg13cmos5l_fill_1
XFILLER_64_252 VPWR VGND sg13cmos5l_fill_2
XFILLER_64_263 VPWR VGND sg13cmos5l_fill_2
X_0126_ _3188_/A _3792_/X _3793_/X _1151_/Q VPWR VGND sg13cmos5l_mux2_1
XFILLER_413_133 VPWR VGND sg13cmos5l_decap_8
XFILLER_559_126 VPWR VGND sg13cmos5l_decap_8
XFILLER_602_255 VPWR VGND sg13cmos5l_fill_2
XFILLER_212_217 VPWR VGND sg13cmos5l_decap_8
XFILLER_399_96 VPWR VGND sg13cmos5l_decap_8
XFILLER_17_190 VPWR VGND sg13cmos5l_decap_8
X_0057_ _0057_/X _4111_/X _4112_/X _2663_/Q VPWR VGND sg13cmos5l_mux2_1
X_4934_ _4934_/X Tile_X0Y8_W2MID[5] Tile_X0Y8_W2END[5] Tile_X0Y8_W6END[10] _4789_/X
+ _0623_/Q _0622_/Q VPWR VGND sg13cmos5l_mux4_1
XFILLER_549_77 VPWR VGND sg13cmos5l_fill_2
X_4865_ _4865_/X Tile_X0Y9_WW4END[14] AXI_M_SOC_RDATA1 _4930_/X _4902_/X _0813_/Q
+ _0812_/Q VPWR VGND sg13cmos5l_mux4_1
XFILLER_366_232 VPWR VGND sg13cmos5l_fill_1
XANTENNA_12 AXI_M_SOC_RDATA26 VPWR VGND sg13cmos5l_antennanp
XFILLER_716_123 VPWR VGND sg13cmos5l_decap_8
XANTENNA_23 AXI_M_SOC_RDATA26 VPWR VGND sg13cmos5l_antennanp
XFILLER_268_56 VPWR VGND sg13cmos5l_decap_8
XANTENNA_34 AXI_M_SOC_RDATA26 VPWR VGND sg13cmos5l_antennanp
XFILLER_220_272 VPWR VGND sg13cmos5l_fill_1
X_3816_ _3816_/X Tile_X0Y0_W2END[3] Tile_X0Y0_WW4END[10] _3859_/X _3858_/X _1073_/Q
+ _1072_/Q VPWR VGND sg13cmos5l_mux4_1
XANTENNA_45 AXI_M_SOC_RDATA8 VPWR VGND sg13cmos5l_antennanp
XANTENNA_56 Tile_X0Y0_FrameData[25] VPWR VGND sg13cmos5l_antennanp
X_4796_ _4796_/X Tile_X0Y4_W1END[2] Tile_X0Y4_WW4END[14] Tile_X0Y4_W6END[6] _4338_/X
+ _2115_/Q _2114_/Q VPWR VGND sg13cmos5l_mux4_1
XANTENNA_67 Tile_X0Y0_S2MID[2] VPWR VGND sg13cmos5l_antennanp
XFILLER_565_21 VPWR VGND sg13cmos5l_decap_8
XANTENNA_78 Tile_X0Y0_S4END[14] VPWR VGND sg13cmos5l_antennanp
XFILLER_192_135 VPWR VGND sg13cmos5l_decap_8
XANTENNA_89 Tile_X0Y1_FrameData[6] VPWR VGND sg13cmos5l_antennanp
XFILLER_118_221 VPWR VGND sg13cmos5l_fill_2
X_3747_ AXI_M_SOC_ARADDR19 Tile_X0Y8_WW4END[3] Tile_X0Y8_WW4END[11] Tile_X0Y8_W6END[3]
+ _4803_/X _0497_/Q _0496_/Q VPWR VGND sg13cmos5l_mux4_1
XFILLER_381_246 VPWR VGND sg13cmos5l_decap_8
X_0959_ _0959_/Q Tile_X0Y0_FrameData[12] VGND VPWR Tile_X0Y9_FrameStrobe[0] latch
XFILLER_669_211 VPWR VGND sg13cmos5l_decap_8
XFILLER_669_233 VPWR VGND sg13cmos5l_decap_8
XFILLER_565_98 VPWR VGND sg13cmos5l_decap_8
XFILLER_133_213 VPWR VGND sg13cmos5l_decap_8
XFILLER_137_49 VPWR VGND sg13cmos5l_decap_8
XFILLER_715_35 VPWR VGND sg13cmos5l_decap_8
X_3678_ _3678_/X Tile_X0Y2_WW4END[0] Tile_X0Y2_WW4END[8] Tile_X0Y2_W6END[8] _4124_/X
+ _1489_/Q _1488_/Q VPWR VGND sg13cmos5l_mux4_1
XFILLER_334_162 VPWR VGND sg13cmos5l_decap_8
XFILLER_669_255 VPWR VGND sg13cmos5l_decap_8
XFILLER_284_77 VPWR VGND sg13cmos5l_decap_8
X_2629_ _2629_/Q Tile_X0Y6_FrameData[2] VGND VPWR Tile_X0Y9_FrameStrobe[5] latch
XFILLER_629_119 VPWR VGND sg13cmos5l_decap_4
XFILLER_434_14 VPWR VGND sg13cmos5l_decap_8
XANTENNA__3245__X Tile_X0Y0_FrameData_O[13] VPWR VGND sg13cmos5l_antennanp
XFILLER_581_42 VPWR VGND sg13cmos5l_decap_8
XFILLER_495_147 VPWR VGND sg13cmos5l_decap_8
XFILLER_294_209 VPWR VGND sg13cmos5l_decap_8
XFILLER_287_261 VPWR VGND sg13cmos5l_fill_1
XFILLER_101_121 VPWR VGND sg13cmos5l_decap_8
XFILLER_153_48 VPWR VGND sg13cmos5l_decap_8
XFILLER_637_152 VPWR VGND sg13cmos5l_decap_8
XFILLER_247_114 VPWR VGND sg13cmos5l_decap_8
XFILLER_198_7 VPWR VGND sg13cmos5l_decap_8
XFILLER_101_143 VPWR VGND sg13cmos5l_fill_1
XFILLER_514_91 VPWR VGND sg13cmos5l_decap_8
XFILLER_101_165 VPWR VGND sg13cmos5l_decap_8
XFILLER_450_35 VPWR VGND sg13cmos5l_decap_8
XFILLER_372_8 VPWR VGND sg13cmos5l_decap_8
XFILLER_303_29 VPWR VGND sg13cmos5l_decap_8
XFILLER_233_70 VPWR VGND sg13cmos5l_decap_4
XFILLER_451_228 VPWR VGND sg13cmos5l_decap_8
XFILLER_365_7 VPWR VGND sg13cmos5l_decap_8
XFILLER_262_139 VPWR VGND sg13cmos5l_decap_8
XFILLER_451_239 VPWR VGND sg13cmos5l_fill_2
XFILLER_600_49 VPWR VGND sg13cmos5l_decap_8
XFILLER_404_155 VPWR VGND sg13cmos5l_decap_4
XFILLER_532_7 VPWR VGND sg13cmos5l_decap_8
XFILLER_404_188 VPWR VGND sg13cmos5l_decap_4
XFILLER_246_4 VPWR VGND sg13cmos5l_fill_1
XFILLER_357_210 VPWR VGND sg13cmos5l_decap_8
XFILLER_459_77 VPWR VGND sg13cmos5l_fill_2
XFILLER_707_112 VPWR VGND sg13cmos5l_decap_8
XFILLER_609_14 VPWR VGND sg13cmos5l_decap_8
XFILLER_707_123 VPWR VGND sg13cmos5l_fill_1
XFILLER_62_89 VPWR VGND sg13cmos5l_decap_8
XFILLER_707_145 VPWR VGND sg13cmos5l_decap_8
XFILLER_573_140 VPWR VGND sg13cmos5l_decap_8
XFILLER_475_21 VPWR VGND sg13cmos5l_decap_8
XFILLER_183_146 VPWR VGND sg13cmos5l_decap_4
XFILLER_109_243 VPWR VGND sg13cmos5l_decap_8
XFILLER_109_254 VPWR VGND sg13cmos5l_fill_2
XFILLER_372_268 VPWR VGND sg13cmos5l_decap_4
XFILLER_475_87 VPWR VGND sg13cmos5l_decap_8
XFILLER_625_35 VPWR VGND sg13cmos5l_decap_8
XFILLER_408_70 VPWR VGND sg13cmos5l_decap_8
XFILLER_124_246 VPWR VGND sg13cmos5l_decap_8
XFILLER_344_14 VPWR VGND sg13cmos5l_decap_8
XFILLER_675_214 VPWR VGND sg13cmos5l_decap_4
XANTENNA__3155__X Tile_X0Y7_FrameData_O[25] VPWR VGND sg13cmos5l_antennanp
XFILLER_675_225 VPWR VGND sg13cmos5l_decap_8
XFILLER_2_0 VPWR VGND sg13cmos5l_decap_8
XFILLER_124_268 VPWR VGND sg13cmos5l_decap_4
XFILLER_97_108 VPWR VGND sg13cmos5l_decap_8
XFILLER_491_42 VPWR VGND sg13cmos5l_decap_8
XFILLER_340_154 VPWR VGND sg13cmos5l_fill_1
XFILLER_340_176 VPWR VGND sg13cmos5l_fill_2
XFILLER_87_64 VPWR VGND sg13cmos5l_decap_8
XFILLER_391_0 VPWR VGND sg13cmos5l_decap_8
XFILLER_489_0 VPWR VGND sg13cmos5l_decap_8
XFILLER_278_272 VPWR VGND sg13cmos5l_fill_1
XANTENNA__2994__X Tile_X0Y5_E1BEG[1] VPWR VGND sg13cmos5l_antennanp
XFILLER_628_163 VPWR VGND sg13cmos5l_decap_8
XFILLER_427_203 VPWR VGND sg13cmos5l_decap_8
XFILLER_641_56 VPWR VGND sg13cmos5l_decap_8
XFILLER_424_91 VPWR VGND sg13cmos5l_decap_8
XFILLER_293_231 VPWR VGND sg13cmos5l_decap_8
XFILLER_643_133 VPWR VGND sg13cmos5l_decap_8
XFILLER_360_35 VPWR VGND sg13cmos5l_decap_8
XFILLER_143_70 VPWR VGND sg13cmos5l_decap_8
XFILLER_293_264 VPWR VGND sg13cmos5l_fill_1
XFILLER_656_0 VPWR VGND sg13cmos5l_decap_8
XFILLER_442_217 VPWR VGND sg13cmos5l_decap_8
XFILLER_510_49 VPWR VGND sg13cmos5l_decap_8
XFILLER_596_254 VPWR VGND sg13cmos5l_decap_8
XFILLER_61_255 VPWR VGND sg13cmos5l_fill_2
X_2980_ Tile_X0Y8_FrameData_O[20] Tile_X0Y8_FrameData[20] VPWR VGND sg13cmos5l_buf_1
XFILLER_556_129 VPWR VGND sg13cmos5l_decap_8
XFILLER_410_147 VPWR VGND sg13cmos5l_decap_8
XFILLER_369_77 VPWR VGND sg13cmos5l_decap_8
X_1931_ _1931_/Q Tile_X0Y4_FrameData[26] VGND VPWR Tile_X0Y9_FrameStrobe[0] latch
XFILLER_202_250 VPWR VGND sg13cmos5l_decap_4
XFILLER_519_14 VPWR VGND sg13cmos5l_decap_8
XFILLER_14_182 VPWR VGND sg13cmos5l_decap_8
XFILLER_202_272 VPWR VGND sg13cmos5l_fill_1
XFILLER_666_42 VPWR VGND sg13cmos5l_decap_8
XFILLER_564_140 VPWR VGND sg13cmos5l_decap_4
X_4650_ _4650_/X AXI_M_SOC_RDATA18 _4689_/X _4693_/X _4673_/X _0259_/Q _0258_/Q VPWR
+ VGND sg13cmos5l_mux4_1
XFILLER_159_187 VPWR VGND sg13cmos5l_decap_4
X_1862_ _1862_/Q Tile_X0Y3_FrameData[3] VGND VPWR Tile_X0Y9_FrameStrobe[5] latch
XFILLER_385_21 VPWR VGND sg13cmos5l_decap_8
XFILLER_159_198 VPWR VGND sg13cmos5l_decap_4
X_3601_ Tile_X0Y9_FrameData_O[31] Tile_X0Y9_FrameData[31] VPWR VGND sg13cmos5l_buf_1
X_0813_ _0813_/Q Tile_X0Y9_FrameData[18] VGND VPWR Tile_X0Y9_FrameStrobe[4] latch
X_1793_ _1793_/Q Tile_X0Y3_FrameData[8] VGND VPWR Tile_X0Y9_FrameStrobe[3] latch
X_4581_ _4581_/X _4547_/X Tile_X0Y9_N4END[13] _4546_/X _0153_/X _2469_/Q _2468_/Q
+ VPWR VGND sg13cmos5l_mux4_1
XFILLER_174_157 VPWR VGND sg13cmos5l_fill_1
XFILLER_713_159 VPWR VGND sg13cmos5l_decap_8
XFILLER_385_87 VPWR VGND sg13cmos5l_decap_8
X_3532_ Tile_X0Y9_E2BEG[6] _4854_/X VPWR VGND sg13cmos5l_buf_1
XFILLER_316_151 VPWR VGND sg13cmos5l_decap_8
XFILLER_115_202 VPWR VGND sg13cmos5l_decap_8
X_0744_ _0744_/Q Tile_X0Y9_FrameData[23] VGND VPWR Tile_X0Y9_FrameStrobe[2] latch
XFILLER_385_98 VPWR VGND sg13cmos5l_fill_1
XFILLER_316_162 VPWR VGND sg13cmos5l_fill_2
XFILLER_535_35 VPWR VGND sg13cmos5l_decap_8
XFILLER_318_70 VPWR VGND sg13cmos5l_decap_8
XFILLER_254_14 VPWR VGND sg13cmos5l_decap_8
X_0675_ _0675_/Q Tile_X0Y9_FrameData[28] VGND VPWR Tile_X0Y9_FrameStrobe[0] latch
X_3463_ Tile_X0Y1_FrameData_O[21] Tile_X0Y1_FrameData[21] VPWR VGND sg13cmos5l_buf_1
XFILLER_520_221 VPWR VGND sg13cmos5l_decap_8
XANTENNA__3065__X Tile_X0Y5_FrameData_O[24] VPWR VGND sg13cmos5l_antennanp
X_2414_ _2414_/Q Tile_X0Y5_FrameData[23] VGND VPWR Tile_X0Y9_FrameStrobe[7] latch
X_3394_ Tile_X0Y2_E2BEGb[5] _4053_/X VPWR VGND sg13cmos5l_buf_1
XFILLER_35_0 VPWR VGND sg13cmos5l_decap_8
XFILLER_96_130 VPWR VGND sg13cmos5l_decap_8
XFILLER_404_28 VPWR VGND sg13cmos5l_decap_8
XFILLER_269_272 VPWR VGND sg13cmos5l_fill_1
X_2345_ _2345_/Q Tile_X0Y5_FrameData[28] VGND VPWR Tile_X0Y9_FrameStrobe[5] latch
XFILLER_681_228 VPWR VGND sg13cmos5l_decap_8
XFILLER_229_125 VPWR VGND sg13cmos5l_fill_1
XFILLER_229_136 VPWR VGND sg13cmos5l_decap_8
XFILLER_551_56 VPWR VGND sg13cmos5l_decap_8
XFILLER_485_180 VPWR VGND sg13cmos5l_fill_2
XFILLER_29_208 VPWR VGND sg13cmos5l_decap_8
XFILLER_284_231 VPWR VGND sg13cmos5l_decap_8
X_2276_ _2276_/Q Tile_X0Y5_FrameData[1] VGND VPWR Tile_X0Y9_FrameStrobe[2] latch
XFILLER_634_133 VPWR VGND sg13cmos5l_decap_8
XFILLER_284_264 VPWR VGND sg13cmos5l_fill_1
XFILLER_270_35 VPWR VGND sg13cmos5l_decap_8
X_1227_ _1227_/Q Tile_X0Y1_FrameData[14] VGND VPWR Tile_X0Y9_FrameStrobe[1] latch
X_4015_ _4015_/X _3987_/X _0084_/X _3986_/X Tile_X0Y0_S4END[7] _1219_/Q _1218_/Q VPWR
+ VGND sg13cmos5l_mux4_1
XFILLER_433_239 VPWR VGND sg13cmos5l_decap_8
XFILLER_237_180 VPWR VGND sg13cmos5l_fill_2
X_1158_ _1158_/Q Tile_X0Y0_FrameData[5] VGND VPWR Tile_X0Y9_FrameStrobe[6] latch
XFILLER_203_84 VPWR VGND sg13cmos5l_decap_8
XFILLER_420_49 VPWR VGND sg13cmos5l_decap_8
XFILLER_16_49 VPWR VGND sg13cmos5l_decap_8
XFILLER_52_233 VPWR VGND sg13cmos5l_decap_8
XFILLER_252_161 VPWR VGND sg13cmos5l_decap_4
X_0109_ _0109_/X _4332_/X _4333_/X _1106_/Q VPWR VGND sg13cmos5l_mux2_1
XFILLER_441_272 VPWR VGND sg13cmos5l_fill_1
XFILLER_401_114 VPWR VGND sg13cmos5l_decap_8
X_1089_ _1089_/Q Tile_X0Y0_FrameData[10] VGND VPWR Tile_X0Y9_FrameStrobe[4] latch
XFILLER_398_187 VPWR VGND sg13cmos5l_decap_8
XFILLER_12_108 VPWR VGND sg13cmos5l_decap_8
XFILLER_197_238 VPWR VGND sg13cmos5l_decap_8
XFILLER_547_129 VPWR VGND sg13cmos5l_decap_8
XFILLER_339_210 VPWR VGND sg13cmos5l_decap_8
X_4917_ _4917_/X Tile_X0Y9_N1END[1] Tile_X0Y9_N4END[1] _4897_/X _0082_/X _0725_/Q
+ _0724_/Q VPWR VGND sg13cmos5l_mux4_1
XFILLER_279_77 VPWR VGND sg13cmos5l_decap_8
XFILLER_200_209 VPWR VGND sg13cmos5l_decap_8
XFILLER_429_14 VPWR VGND sg13cmos5l_decap_8
XFILLER_401_169 VPWR VGND sg13cmos5l_fill_2
XFILLER_576_42 VPWR VGND sg13cmos5l_decap_8
XFILLER_555_140 VPWR VGND sg13cmos5l_decap_8
X_4848_ _4848_/X Tile_X0Y9_W2MID[7] AXI_M_SOC_RDATA0 _4901_/X _4900_/X _0847_/Q _0846_/Q
+ VPWR VGND sg13cmos5l_mux4_1
XFILLER_354_224 VPWR VGND sg13cmos5l_decap_8
XFILLER_295_43 VPWR VGND sg13cmos5l_decap_8
XFILLER_165_146 VPWR VGND sg13cmos5l_decap_8
X_4779_ _4779_/X Tile_X0Y9_W1END[1] Tile_X0Y9_W6END[5] _4929_/X _4893_/X _0925_/Q
+ _0924_/Q VPWR VGND sg13cmos5l_mux4_1
XFILLER_704_137 VPWR VGND sg13cmos5l_decap_4
XFILLER_570_154 VPWR VGND sg13cmos5l_decap_8
XFILLER_509_91 VPWR VGND sg13cmos5l_decap_8
XFILLER_113_7 VPWR VGND sg13cmos5l_decap_8
XFILLER_295_98 VPWR VGND sg13cmos5l_decap_8
XFILLER_445_35 VPWR VGND sg13cmos5l_decap_8
XFILLER_307_162 VPWR VGND sg13cmos5l_decap_8
XFILLER_307_173 VPWR VGND sg13cmos5l_fill_2
XFILLER_106_268 VPWR VGND sg13cmos5l_decap_4
XFILLER_164_36 VPWR VGND sg13cmos5l_decap_8
XFILLER_79_119 VPWR VGND sg13cmos5l_decap_8
XFILLER_672_206 VPWR VGND sg13cmos5l_fill_1
XFILLER_482_7 VPWR VGND sg13cmos5l_decap_8
XFILLER_409_214 VPWR VGND sg13cmos5l_fill_1
XFILLER_87_141 VPWR VGND sg13cmos5l_decap_8
XFILLER_672_228 VPWR VGND sg13cmos5l_decap_4
XFILLER_275_220 VPWR VGND sg13cmos5l_decap_8
XANTENNA__3703__X AXI_M_SOC_WDATA13 VPWR VGND sg13cmos5l_antennanp
XFILLER_476_180 VPWR VGND sg13cmos5l_fill_1
XFILLER_461_56 VPWR VGND sg13cmos5l_decap_8
XFILLER_275_242 VPWR VGND sg13cmos5l_fill_1
XFILLER_409_258 VPWR VGND sg13cmos5l_decap_8
XFILLER_180_35 VPWR VGND sg13cmos5l_decap_8
XFILLER_87_185 VPWR VGND sg13cmos5l_fill_1
XFILLER_625_144 VPWR VGND sg13cmos5l_decap_4
XFILLER_57_67 VPWR VGND sg13cmos5l_decap_8
XFILLER_625_155 VPWR VGND sg13cmos5l_decap_8
XFILLER_491_161 VPWR VGND sg13cmos5l_decap_8
XFILLER_424_217 VPWR VGND sg13cmos5l_decap_8
XFILLER_363_4 VPWR VGND sg13cmos5l_fill_1
XFILLER_28_252 VPWR VGND sg13cmos5l_fill_2
XFILLER_640_147 VPWR VGND sg13cmos5l_decap_8
XFILLER_113_84 VPWR VGND sg13cmos5l_fill_2
XFILLER_43_233 VPWR VGND sg13cmos5l_decap_8
XFILLER_243_172 VPWR VGND sg13cmos5l_decap_8
XFILLER_189_33 VPWR VGND sg13cmos5l_decap_8
XFILLER_43_244 VPWR VGND sg13cmos5l_fill_1
XFILLER_189_44 VPWR VGND sg13cmos5l_fill_1
XFILLER_389_176 VPWR VGND sg13cmos5l_decap_8
XFILLER_43_266 VPWR VGND sg13cmos5l_decap_8
XFILLER_188_238 VPWR VGND sg13cmos5l_decap_8
XFILLER_189_66 VPWR VGND sg13cmos5l_decap_8
XFILLER_538_129 VPWR VGND sg13cmos5l_decap_8
XFILLER_339_14 VPWR VGND sg13cmos5l_decap_8
XFILLER_593_268 VPWR VGND sg13cmos5l_decap_4
XFILLER_486_42 VPWR VGND sg13cmos5l_decap_8
XFILLER_237_0 VPWR VGND sg13cmos5l_decap_8
XFILLER_546_140 VPWR VGND sg13cmos5l_decap_8
XFILLER_11_141 VPWR VGND sg13cmos5l_decap_8
XFILLER_546_151 VPWR VGND sg13cmos5l_fill_1
XFILLER_7_112 VPWR VGND sg13cmos5l_decap_8
XFILLER_345_224 VPWR VGND sg13cmos5l_decap_8
XFILLER_156_135 VPWR VGND sg13cmos5l_decap_4
XANTENNA__2989__X Tile_X0Y8_FrameData_O[29] VPWR VGND sg13cmos5l_antennanp
XFILLER_11_196 VPWR VGND sg13cmos5l_decap_8
XFILLER_404_0 VPWR VGND sg13cmos5l_decap_8
XFILLER_22_70 VPWR VGND sg13cmos5l_decap_8
XFILLER_636_56 VPWR VGND sg13cmos5l_decap_8
XFILLER_419_91 VPWR VGND sg13cmos5l_decap_8
XFILLER_138_70 VPWR VGND sg13cmos5l_decap_8
XFILLER_355_35 VPWR VGND sg13cmos5l_decap_8
XFILLER_710_118 VPWR VGND sg13cmos5l_decap_8
XFILLER_710_129 VPWR VGND sg13cmos5l_fill_2
XFILLER_502_210 VPWR VGND sg13cmos5l_decap_8
XFILLER_703_170 VPWR VGND sg13cmos5l_decap_8
XFILLER_459_125 VPWR VGND sg13cmos5l_decap_4
XFILLER_459_136 VPWR VGND sg13cmos5l_decap_8
X_0460_ _0460_/Q Tile_X0Y8_FrameData[19] VGND VPWR Tile_X0Y9_FrameStrobe[1] latch
XFILLER_648_258 VPWR VGND sg13cmos5l_decap_4
XFILLER_505_49 VPWR VGND sg13cmos5l_decap_8
XFILLER_652_77 VPWR VGND sg13cmos5l_decap_8
XFILLER_224_28 VPWR VGND sg13cmos5l_decap_8
XFILLER_663_217 VPWR VGND sg13cmos5l_decap_4
XFILLER_474_128 VPWR VGND sg13cmos5l_decap_4
X_0391_ _0391_/Q Tile_X0Y7_FrameData[24] VGND VPWR Tile_X0Y9_FrameStrobe[7] latch
XANTENNA__3613__X Tile_X0Y9_S2BEG[7] VPWR VGND sg13cmos5l_antennanp
XFILLER_371_56 VPWR VGND sg13cmos5l_decap_8
X_2130_ _2130_/Q Tile_X0Y4_FrameData[19] VGND VPWR Tile_X0Y9_FrameStrobe[6] latch
XFILLER_616_155 VPWR VGND sg13cmos5l_decap_8
XFILLER_415_206 VPWR VGND sg13cmos5l_decap_4
XFILLER_482_161 VPWR VGND sg13cmos5l_decap_8
X_2061_ _2061_/Q Tile_X0Y4_FrameData[24] VGND VPWR Tile_X0Y9_FrameStrobe[4] latch
XFILLER_226_139 VPWR VGND sg13cmos5l_decap_8
XFILLER_281_234 VPWR VGND sg13cmos5l_decap_4
X_1012_ _1012_/Q Tile_X0Y0_FrameData[23] VGND VPWR Tile_X0Y9_FrameStrobe[2] latch
XFILLER_631_147 VPWR VGND sg13cmos5l_decap_8
XFILLER_569_210 VPWR VGND sg13cmos5l_decap_8
XFILLER_281_267 VPWR VGND sg13cmos5l_decap_4
XFILLER_240_49 VPWR VGND sg13cmos5l_decap_8
XFILLER_601_70 VPWR VGND sg13cmos5l_decap_8
XFILLER_179_216 VPWR VGND sg13cmos5l_fill_2
X_2963_ Tile_X0Y8_FrameData_O[3] Tile_X0Y8_FrameData[3] VPWR VGND sg13cmos5l_buf_1
XFILLER_395_157 VPWR VGND sg13cmos5l_decap_8
XFILLER_249_36 VPWR VGND sg13cmos5l_decap_8
XFILLER_194_219 VPWR VGND sg13cmos5l_decap_8
X_4702_ _4702_/X Tile_X0Y6_W2MID[6] Tile_X0Y6_W2END[6] Tile_X0Y6_W6END[9] _4555_/X
+ _2649_/Q _2648_/Q VPWR VGND sg13cmos5l_mux4_1
XFILLER_396_42 VPWR VGND sg13cmos5l_decap_8
X_1914_ _1914_/Q Tile_X0Y3_FrameData[15] VGND VPWR Tile_X0Y9_FrameStrobe[7] latch
X_2894_ Tile_X0Y6_FrameData_O[15] Tile_X0Y6_FrameData[15] VPWR VGND sg13cmos5l_buf_1
XFILLER_336_213 VPWR VGND sg13cmos5l_decap_8
XFILLER_147_135 VPWR VGND sg13cmos5l_decap_4
XFILLER_552_110 VPWR VGND sg13cmos5l_decap_8
XANTENNA__2899__X Tile_X0Y6_FrameData_O[20] VPWR VGND sg13cmos5l_antennanp
XFILLER_147_146 VPWR VGND sg13cmos5l_decap_8
X_4633_ _4633_/X Tile_X0Y7_WW4END[10] AXI_M_SOC_RDATA21 _4694_/X _4673_/X _0293_/Q
+ _0292_/Q VPWR VGND sg13cmos5l_mux4_1
X_1845_ _1845_/Q Tile_X0Y3_FrameData[20] VGND VPWR Tile_X0Y9_FrameStrobe[5] latch
XFILLER_546_56 VPWR VGND sg13cmos5l_decap_8
X_4564_ _4564_/X Tile_X0Y2_W1END[2] Tile_X0Y2_WW4END[14] Tile_X0Y2_W6END[6] _4118_/X
+ _1607_/Q _1606_/Q VPWR VGND sg13cmos5l_mux4_1
X_1776_ _1776_/Q Tile_X0Y3_FrameData[25] VGND VPWR Tile_X0Y9_FrameStrobe[3] latch
XFILLER_265_35 VPWR VGND sg13cmos5l_decap_8
XFILLER_162_138 VPWR VGND sg13cmos5l_decap_8
XFILLER_351_238 VPWR VGND sg13cmos5l_fill_2
XFILLER_552_198 VPWR VGND sg13cmos5l_fill_2
X_3515_ Tile_X0Y1_E2BEG[5] _3937_/X VPWR VGND sg13cmos5l_buf_1
XFILLER_639_203 VPWR VGND sg13cmos5l_decap_8
X_0727_ _0727_/Q Tile_X0Y9_FrameData[8] VGND VPWR Tile_X0Y9_FrameStrobe[1] latch
X_4495_ _4495_/X _4551_/X _4550_/X AXI_M_SOC_RDATA24 AXI_M_SOC_RDATA28 _2617_/Q _2616_/Q
+ VPWR VGND sg13cmos5l_mux4_1
XFILLER_170_171 VPWR VGND sg13cmos5l_decap_8
X_3446_ Tile_X0Y1_FrameData_O[4] Tile_X0Y1_FrameData[4] VPWR VGND sg13cmos5l_buf_1
X_0658_ _0658_/Q Tile_X0Y8_FrameData[13] VGND VPWR Tile_X0Y9_FrameStrobe[7] latch
XFILLER_415_49 VPWR VGND sg13cmos5l_decap_8
XFILLER_134_28 VPWR VGND sg13cmos5l_decap_8
XFILLER_562_77 VPWR VGND sg13cmos5l_decap_8
XFILLER_712_14 VPWR VGND sg13cmos5l_decap_8
X_0589_ _0589_/Q Tile_X0Y8_FrameData[18] VGND VPWR Tile_X0Y9_FrameStrobe[5] latch
X_3377_ Tile_X0Y2_E6BEG[0] _4072_/X VPWR VGND sg13cmos5l_buf_1
XANTENNA__3523__X Tile_X0Y9_E1BEG[1] VPWR VGND sg13cmos5l_antennanp
XFILLER_281_56 VPWR VGND sg13cmos5l_decap_8
XFILLER_257_231 VPWR VGND sg13cmos5l_decap_8
XFILLER_257_242 VPWR VGND sg13cmos5l_fill_2
X_2328_ _2328_/Q Tile_X0Y5_FrameData[13] VGND VPWR Tile_X0Y9_FrameStrobe[4] latch
XFILLER_84_122 VPWR VGND sg13cmos5l_decap_4
XFILLER_69_196 VPWR VGND sg13cmos5l_decap_8
XFILLER_662_250 VPWR VGND sg13cmos5l_decap_4
XFILLER_84_133 VPWR VGND sg13cmos5l_decap_8
XFILLER_662_261 VPWR VGND sg13cmos5l_fill_1
X_2259_ _2259_/Q Tile_X0Y5_FrameData[18] VGND VPWR Tile_X0Y9_FrameStrobe[2] latch
XFILLER_84_199 VPWR VGND sg13cmos5l_decap_8
XFILLER_511_70 VPWR VGND sg13cmos5l_decap_8
XFILLER_414_250 VPWR VGND sg13cmos5l_decap_8
XFILLER_25_222 VPWR VGND sg13cmos5l_decap_8
XFILLER_575_224 VPWR VGND sg13cmos5l_decap_8
XFILLER_386_124 VPWR VGND sg13cmos5l_decap_8
XFILLER_587_63 VPWR VGND sg13cmos5l_decap_8
XFILLER_159_14 VPWR VGND sg13cmos5l_decap_8
XFILLER_40_247 VPWR VGND sg13cmos5l_decap_8
XFILLER_230_7 VPWR VGND sg13cmos5l_decap_8
XFILLER_178_271 VPWR VGND sg13cmos5l_fill_2
XFILLER_328_7 VPWR VGND sg13cmos5l_decap_8
XANTENNA__0106__Y AXI_M_SOC_ARLEN3 VPWR VGND sg13cmos5l_antennanp
XFILLER_528_195 VPWR VGND sg13cmos5l_decap_8
XFILLER_309_28 VPWR VGND sg13cmos5l_decap_8
XFILLER_138_168 VPWR VGND sg13cmos5l_decap_8
XFILLER_327_268 VPWR VGND sg13cmos5l_decap_4
XFILLER_456_56 VPWR VGND sg13cmos5l_decap_8
XFILLER_175_35 VPWR VGND sg13cmos5l_decap_8
XFILLER_689_169 VPWR VGND sg13cmos5l_decap_8
XFILLER_4_126 VPWR VGND sg13cmos5l_decap_4
XFILLER_342_249 VPWR VGND sg13cmos5l_decap_8
XFILLER_175_79 VPWR VGND sg13cmos5l_decap_8
XFILLER_697_7 VPWR VGND sg13cmos5l_decap_8
XFILLER_108_84 VPWR VGND sg13cmos5l_decap_8
XFILLER_700_162 VPWR VGND sg13cmos5l_fill_2
XFILLER_496_264 VPWR VGND sg13cmos5l_fill_1
XFILLER_645_217 VPWR VGND sg13cmos5l_decap_8
XFILLER_622_14 VPWR VGND sg13cmos5l_decap_8
XANTENNA__3433__X Tile_X0Y4_FrameData_O[24] VPWR VGND sg13cmos5l_antennanp
XFILLER_68_77 VPWR VGND sg13cmos5l_decap_8
XFILLER_449_180 VPWR VGND sg13cmos5l_decap_8
XFILLER_310_168 VPWR VGND sg13cmos5l_decap_8
XFILLER_248_231 VPWR VGND sg13cmos5l_fill_1
XFILLER_191_78 VPWR VGND sg13cmos5l_decap_4
XFILLER_187_0 VPWR VGND sg13cmos5l_decap_8
XFILLER_84_21 VPWR VGND sg13cmos5l_decap_8
XFILLER_653_272 VPWR VGND sg13cmos5l_fill_1
XFILLER_613_114 VPWR VGND sg13cmos5l_decap_8
XFILLER_702_91 VPWR VGND sg13cmos5l_decap_8
XFILLER_421_70 VPWR VGND sg13cmos5l_decap_8
XFILLER_405_250 VPWR VGND sg13cmos5l_decap_8
XFILLER_84_98 VPWR VGND sg13cmos5l_decap_8
XFILLER_354_0 VPWR VGND sg13cmos5l_decap_8
XFILLER_420_231 VPWR VGND sg13cmos5l_fill_1
XFILLER_497_63 VPWR VGND sg13cmos5l_decap_8
XFILLER_231_164 VPWR VGND sg13cmos5l_fill_2
XFILLER_521_0 VPWR VGND sg13cmos5l_decap_8
XFILLER_31_236 VPWR VGND sg13cmos5l_decap_8
XFILLER_566_257 VPWR VGND sg13cmos5l_fill_1
XFILLER_619_0 VPWR VGND sg13cmos5l_decap_8
XFILLER_169_271 VPWR VGND sg13cmos5l_fill_2
XFILLER_519_151 VPWR VGND sg13cmos5l_decap_8
XFILLER_31_269 VPWR VGND sg13cmos5l_decap_4
XFILLER_708_251 VPWR VGND sg13cmos5l_decap_4
XFILLER_581_216 VPWR VGND sg13cmos5l_fill_1
XFILLER_318_224 VPWR VGND sg13cmos5l_fill_2
XFILLER_129_135 VPWR VGND sg13cmos5l_fill_1
XFILLER_219_28 VPWR VGND sg13cmos5l_decap_8
XFILLER_76_7 VPWR VGND sg13cmos5l_decap_8
XFILLER_647_77 VPWR VGND sg13cmos5l_decap_8
XFILLER_534_121 VPWR VGND sg13cmos5l_decap_8
XFILLER_519_195 VPWR VGND sg13cmos5l_fill_1
XFILLER_129_157 VPWR VGND sg13cmos5l_decap_8
XFILLER_534_143 VPWR VGND sg13cmos5l_decap_8
XANTENNA__3608__X Tile_X0Y9_S2BEG[2] VPWR VGND sg13cmos5l_antennanp
X_1630_ _1630_/Q Tile_X0Y2_FrameData[19] VGND VPWR Tile_X0Y9_FrameStrobe[6] latch
XFILLER_144_127 VPWR VGND sg13cmos5l_fill_1
XFILLER_663_21 VPWR VGND sg13cmos5l_decap_8
XFILLER_137_190 VPWR VGND sg13cmos5l_decap_8
XFILLER_144_149 VPWR VGND sg13cmos5l_decap_8
X_1561_ _1561_/Q Tile_X0Y2_FrameData[24] VGND VPWR Tile_X0Y9_FrameStrobe[4] latch
XFILLER_298_131 VPWR VGND sg13cmos5l_decap_8
XFILLER_152_160 VPWR VGND sg13cmos5l_decap_4
X_3300_ Tile_X0Y0_E2BEG[0] _3804_/X VPWR VGND sg13cmos5l_buf_1
X_0512_ _0512_/Q Tile_X0Y8_FrameData[31] VGND VPWR Tile_X0Y9_FrameStrobe[3] latch
XFILLER_298_153 VPWR VGND sg13cmos5l_decap_8
X_1492_ _1492_/Q Tile_X0Y2_FrameData[29] VGND VPWR Tile_X0Y9_FrameStrobe[2] latch
X_4280_ _4280_/X Tile_X0Y4_WW4END[7] AXI_M_SOC_BRESP1 _4343_/X _4312_/X _2053_/Q _2052_/Q
+ VPWR VGND sg13cmos5l_mux4_1
XFILLER_235_49 VPWR VGND sg13cmos5l_decap_8
X_0443_ _0443_/Q Tile_X0Y8_FrameData[4] VGND VPWR Tile_X0Y9_FrameStrobe[0] latch
X_3231_ Tile_X0Y0_FrameStrobe_O[19] Tile_X0Y9_FrameStrobe[19] VPWR VGND sg13cmos5l_buf_1
XFILLER_532_14 VPWR VGND sg13cmos5l_decap_8
XANTENNA__3343__X Tile_X0Y2_FrameData_O[14] VPWR VGND sg13cmos5l_antennanp
XFILLER_100_208 VPWR VGND sg13cmos5l_decap_8
XFILLER_100_219 VPWR VGND sg13cmos5l_fill_2
X_0374_ _0374_/Q Tile_X0Y7_FrameData[9] VGND VPWR Tile_X0Y9_FrameStrobe[6] latch
X_3162_ Tile_X0Y7_UserCLKo Tile_X0Y7_UserCLK VPWR VGND sg13cmos5l_buf_1
XFILLER_239_264 VPWR VGND sg13cmos5l_decap_8
XFILLER_66_133 VPWR VGND sg13cmos5l_decap_8
XFILLER_644_261 VPWR VGND sg13cmos5l_fill_1
X_2113_ _2113_/Q Tile_X0Y4_FrameData[4] VGND VPWR Tile_X0Y9_FrameStrobe[5] latch
XFILLER_644_272 VPWR VGND sg13cmos5l_fill_1
X_3093_ Tile_X0Y7_E2BEG[7] _4619_/X VPWR VGND sg13cmos5l_buf_1
XFILLER_81_103 VPWR VGND sg13cmos5l_decap_8
XFILLER_254_256 VPWR VGND sg13cmos5l_decap_8
X_2044_ _2044_/Q Tile_X0Y4_FrameData[9] VGND VPWR Tile_X0Y9_FrameStrobe[3] latch
XFILLER_604_169 VPWR VGND sg13cmos5l_fill_2
XFILLER_401_29 VPWR VGND sg13cmos5l_decap_8
XFILLER_470_175 VPWR VGND sg13cmos5l_fill_1
XFILLER_331_92 VPWR VGND sg13cmos5l_decap_8
XFILLER_470_197 VPWR VGND sg13cmos5l_fill_2
XFILLER_207_194 VPWR VGND sg13cmos5l_decap_8
XFILLER_368_124 VPWR VGND sg13cmos5l_decap_8
XFILLER_411_242 VPWR VGND sg13cmos5l_decap_8
XFILLER_411_264 VPWR VGND sg13cmos5l_fill_1
X_3995_ _3995_/X _3894_/X _4027_/X _4026_/X Tile_X0Y0_S2MID[3] _1195_/Q _1194_/Q VPWR
+ VGND sg13cmos5l_mux4_1
XFILLER_167_219 VPWR VGND sg13cmos5l_decap_4
XFILLER_383_105 VPWR VGND sg13cmos5l_decap_8
XFILLER_200_63 VPWR VGND sg13cmos5l_decap_8
XFILLER_222_197 VPWR VGND sg13cmos5l_decap_8
X_2946_ Tile_X0Y8_EE4BEG[2] _4746_/X VPWR VGND sg13cmos5l_buf_1
XFILLER_13_28 VPWR VGND sg13cmos5l_decap_8
XFILLER_572_238 VPWR VGND sg13cmos5l_decap_8
XFILLER_557_77 VPWR VGND sg13cmos5l_decap_8
XFILLER_525_121 VPWR VGND sg13cmos5l_decap_8
XFILLER_129_28 VPWR VGND sg13cmos5l_decap_8
XFILLER_707_14 VPWR VGND sg13cmos5l_decap_8
XFILLER_557_88 VPWR VGND sg13cmos5l_fill_2
XFILLER_714_232 VPWR VGND sg13cmos5l_decap_8
X_2877_ Tile_X0Y6_EE4BEG[14] _4526_/X VPWR VGND sg13cmos5l_buf_1
XANTENNA__3518__X Tile_X0Y1_E1BEG[0] VPWR VGND sg13cmos5l_antennanp
XFILLER_309_268 VPWR VGND sg13cmos5l_decap_4
XFILLER_276_56 VPWR VGND sg13cmos5l_decap_8
XFILLER_135_105 VPWR VGND sg13cmos5l_decap_8
XFILLER_714_254 VPWR VGND sg13cmos5l_fill_2
X_4616_ _4616_/X Tile_X0Y7_W2MID[3] AXI_M_SOC_RDATA20 _4675_/X _4674_/X _0327_/Q _0326_/Q
+ VPWR VGND sg13cmos5l_mux4_1
XFILLER_135_127 VPWR VGND sg13cmos5l_decap_8
X_1828_ _1828_/Q Tile_X0Y3_FrameData[5] VGND VPWR Tile_X0Y9_FrameStrobe[4] latch
XFILLER_580_271 VPWR VGND sg13cmos5l_fill_2
XFILLER_573_21 VPWR VGND sg13cmos5l_decap_8
XFILLER_686_106 VPWR VGND sg13cmos5l_fill_1
X_4547_ _4547_/X Tile_X0Y7_W1END[1] Tile_X0Y7_W6END[5] _4697_/X _4657_/X _0413_/Q
+ _0412_/Q VPWR VGND sg13cmos5l_mux4_1
XFILLER_686_128 VPWR VGND sg13cmos5l_decap_8
X_1759_ _1759_/Q Tile_X0Y3_FrameData[10] VGND VPWR Tile_X0Y9_FrameStrobe[2] latch
XFILLER_289_131 VPWR VGND sg13cmos5l_decap_8
XFILLER_478_231 VPWR VGND sg13cmos5l_fill_1
XFILLER_143_171 VPWR VGND sg13cmos5l_fill_1
XFILLER_573_98 VPWR VGND sg13cmos5l_decap_8
XFILLER_332_271 VPWR VGND sg13cmos5l_fill_2
XFILLER_145_49 VPWR VGND sg13cmos5l_decap_8
XFILLER_89_236 VPWR VGND sg13cmos5l_decap_8
X_4478_ _4478_/X Tile_X0Y4_W1END[1] Tile_X0Y4_W2MID[2] Tile_X0Y4_W2END[2] _4316_/X
+ _2127_/Q _2126_/Q VPWR VGND sg13cmos5l_mux4_1
XFILLER_506_70 VPWR VGND sg13cmos5l_decap_8
XFILLER_292_77 VPWR VGND sg13cmos5l_decap_8
X_3429_ Tile_X0Y4_FrameData_O[20] Tile_X0Y4_FrameData[20] VPWR VGND sg13cmos5l_buf_1
XFILLER_627_239 VPWR VGND sg13cmos5l_decap_8
XFILLER_493_234 VPWR VGND sg13cmos5l_decap_8
XANTENNA__3253__X Tile_X0Y0_FrameData_O[21] VPWR VGND sg13cmos5l_antennanp
XFILLER_225_60 VPWR VGND sg13cmos5l_decap_8
XFILLER_493_245 VPWR VGND sg13cmos5l_fill_2
XFILLER_442_36 VPWR VGND sg13cmos5l_decap_8
XFILLER_38_14 VPWR VGND sg13cmos5l_decap_8
XFILLER_225_93 VPWR VGND sg13cmos5l_decap_8
XFILLER_161_15 VPWR VGND sg13cmos5l_decap_8
XFILLER_180_7 VPWR VGND sg13cmos5l_decap_8
XFILLER_245_223 VPWR VGND sg13cmos5l_decap_8
XFILLER_446_194 VPWR VGND sg13cmos5l_decap_4
XFILLER_278_7 VPWR VGND sg13cmos5l_decap_8
XFILLER_311_29 VPWR VGND sg13cmos5l_decap_8
XFILLER_260_215 VPWR VGND sg13cmos5l_decap_8
XFILLER_461_197 VPWR VGND sg13cmos5l_decap_8
XFILLER_445_7 VPWR VGND sg13cmos5l_decap_8
XFILLER_13_203 VPWR VGND sg13cmos5l_decap_8
XFILLER_603_180 VPWR VGND sg13cmos5l_decap_8
XFILLER_13_214 VPWR VGND sg13cmos5l_fill_2
XFILLER_359_135 VPWR VGND sg13cmos5l_decap_8
XFILLER_110_52 VPWR VGND sg13cmos5l_decap_8
XANTENNA__0117__X AXI_M_SOC_ARCACHE0 VPWR VGND sg13cmos5l_antennanp
XFILLER_213_197 VPWR VGND sg13cmos5l_decap_8
XFILLER_612_7 VPWR VGND sg13cmos5l_decap_8
XFILLER_359_179 VPWR VGND sg13cmos5l_decap_8
XFILLER_166_241 VPWR VGND sg13cmos5l_decap_8
XFILLER_70_78 VPWR VGND sg13cmos5l_decap_8
XFILLER_617_14 VPWR VGND sg13cmos5l_decap_8
XANTENNA__3428__X Tile_X0Y4_FrameData_O[19] VPWR VGND sg13cmos5l_antennanp
XFILLER_126_105 VPWR VGND sg13cmos5l_decap_4
XFILLER_186_67 VPWR VGND sg13cmos5l_decap_8
XFILLER_126_116 VPWR VGND sg13cmos5l_fill_2
XFILLER_315_216 VPWR VGND sg13cmos5l_decap_8
XFILLER_531_124 VPWR VGND sg13cmos5l_decap_8
XFILLER_382_193 VPWR VGND sg13cmos5l_fill_2
XFILLER_483_43 VPWR VGND sg13cmos5l_decap_8
XFILLER_181_255 VPWR VGND sg13cmos5l_decap_8
XFILLER_79_21 VPWR VGND sg13cmos5l_decap_8
XFILLER_102_0 VPWR VGND sg13cmos5l_decap_8
XFILLER_531_168 VPWR VGND sg13cmos5l_decap_8
XFILLER_633_35 VPWR VGND sg13cmos5l_decap_8
XFILLER_416_70 VPWR VGND sg13cmos5l_decap_8
XFILLER_79_98 VPWR VGND sg13cmos5l_decap_8
XFILLER_295_112 VPWR VGND sg13cmos5l_decap_8
XFILLER_484_223 VPWR VGND sg13cmos5l_decap_8
XFILLER_352_14 VPWR VGND sg13cmos5l_decap_8
XANTENNA__3163__X Tile_X0Y4_E6BEG[0] VPWR VGND sg13cmos5l_antennanp
XFILLER_95_42 VPWR VGND sg13cmos5l_decap_8
XFILLER_295_189 VPWR VGND sg13cmos5l_decap_8
XFILLER_471_0 VPWR VGND sg13cmos5l_decap_8
XFILLER_48_144 VPWR VGND sg13cmos5l_fill_1
XFILLER_569_0 VPWR VGND sg13cmos5l_decap_8
XFILLER_502_28 VPWR VGND sg13cmos5l_decap_8
XFILLER_236_223 VPWR VGND sg13cmos5l_decap_8
XFILLER_48_166 VPWR VGND sg13cmos5l_decap_4
XFILLER_641_231 VPWR VGND sg13cmos5l_decap_8
XFILLER_598_124 VPWR VGND sg13cmos5l_decap_8
XFILLER_432_91 VPWR VGND sg13cmos5l_decap_8
XFILLER_48_199 VPWR VGND sg13cmos5l_decap_8
X_0090_ _3625_/A _4490_/X _4491_/X _2624_/Q VPWR VGND sg13cmos5l_mux2_1
XFILLER_63_125 VPWR VGND sg13cmos5l_decap_8
XFILLER_151_70 VPWR VGND sg13cmos5l_decap_8
XFILLER_251_226 VPWR VGND sg13cmos5l_decap_8
XFILLER_601_139 VPWR VGND sg13cmos5l_decap_8
XFILLER_204_131 VPWR VGND sg13cmos5l_decap_4
XFILLER_204_142 VPWR VGND sg13cmos5l_fill_1
XFILLER_658_21 VPWR VGND sg13cmos5l_decap_8
XFILLER_204_186 VPWR VGND sg13cmos5l_decap_8
X_2800_ Tile_X0Y3_E6BEG[10] _4190_/X VPWR VGND sg13cmos5l_buf_1
XFILLER_365_105 VPWR VGND sg13cmos5l_decap_4
X_3780_ _3780_/X Tile_X0Y0_W1END[0] Tile_X0Y0_W6END[4] _3875_/X _3862_/X _1177_/Q
+ _1176_/Q VPWR VGND sg13cmos5l_mux4_1
XFILLER_658_98 VPWR VGND sg13cmos5l_decap_4
XFILLER_377_44 VPWR VGND sg13cmos5l_fill_1
X_0992_ _0992_/Q Tile_X0Y0_FrameData[11] VGND VPWR Tile_X0Y9_FrameStrobe[1] latch
XFILLER_377_66 VPWR VGND sg13cmos5l_decap_8
XFILLER_157_241 VPWR VGND sg13cmos5l_decap_8
X_2731_ _3862_/A3 VPWR VGND sg13cmos5l_tielo
XFILLER_527_14 VPWR VGND sg13cmos5l_decap_8
XANTENNA__3338__X Tile_X0Y2_FrameData_O[9] VPWR VGND sg13cmos5l_antennanp
XFILLER_117_105 VPWR VGND sg13cmos5l_decap_8
XFILLER_674_42 VPWR VGND sg13cmos5l_decap_8
XFILLER_380_119 VPWR VGND sg13cmos5l_decap_8
X_2662_ _2662_/Q Tile_X0Y6_FrameData[1] VGND VPWR Tile_X0Y9_FrameStrobe[6] latch
XFILLER_562_271 VPWR VGND sg13cmos5l_fill_2
XFILLER_306_227 VPWR VGND sg13cmos5l_decap_8
XFILLER_246_15 VPWR VGND sg13cmos5l_decap_8
XFILLER_711_213 VPWR VGND sg13cmos5l_decap_8
XFILLER_668_106 VPWR VGND sg13cmos5l_fill_1
X_4401_ _4401_/X Tile_X0Y5_WW4END[2] AXI_M_SOC_RRESP0 _4453_/X _4432_/X _2301_/Q _2300_/Q
+ VPWR VGND sg13cmos5l_mux4_1
XFILLER_522_124 VPWR VGND sg13cmos5l_decap_8
X_1613_ _1613_/Q Tile_X0Y2_FrameData[4] VGND VPWR Tile_X0Y9_FrameStrobe[5] latch
X_2593_ _2593_/Q Tile_X0Y6_FrameData[6] VGND VPWR Tile_X0Y9_FrameStrobe[4] latch
XFILLER_246_59 VPWR VGND sg13cmos5l_fill_1
XFILLER_132_119 VPWR VGND sg13cmos5l_decap_8
X_4332_ _4332_/X Tile_X0Y0_W1END[3] Tile_X0Y0_WW4END[15] Tile_X0Y0_W6END[7] _3884_/X
+ _1108_/Q _1107_/Q VPWR VGND sg13cmos5l_mux4_1
X_1544_ _1544_/Q Tile_X0Y2_FrameData[9] VGND VPWR Tile_X0Y9_FrameStrobe[3] latch
XFILLER_314_271 VPWR VGND sg13cmos5l_fill_2
XFILLER_543_35 VPWR VGND sg13cmos5l_decap_8
XFILLER_5_84 VPWR VGND sg13cmos5l_decap_8
XFILLER_286_112 VPWR VGND sg13cmos5l_decap_8
X_4263_ _4263_/X Tile_X0Y4_W2MID[0] AXI_M_SOC_BRESP1 _4313_/X _4312_/X _2087_/Q _2086_/Q
+ VPWR VGND sg13cmos5l_mux4_1
XFILLER_262_14 VPWR VGND sg13cmos5l_decap_8
XANTENNA__3073__X Tile_X0Y5_UserCLKo VPWR VGND sg13cmos5l_antennanp
X_1475_ _1475_/Q Tile_X0Y2_FrameData[14] VGND VPWR Tile_X0Y9_FrameStrobe[1] latch
XFILLER_690_85 VPWR VGND sg13cmos5l_decap_8
X_3214_ Tile_X0Y0_FrameStrobe_O[2] Tile_X0Y9_FrameStrobe[2] VPWR VGND sg13cmos5l_buf_1
XFILLER_39_100 VPWR VGND sg13cmos5l_decap_8
X_0426_ _0426_/Q Tile_X0Y8_FrameData[21] VGND VPWR Tile_X0Y9_FrameStrobe[0] latch
XFILLER_140_196 VPWR VGND sg13cmos5l_decap_8
X_4194_ _4194_/X Tile_X0Y2_W1END[0] Tile_X0Y2_W6END[8] _4113_/X _4084_/X _1637_/Q
+ _1636_/Q VPWR VGND sg13cmos5l_mux4_1
XFILLER_286_189 VPWR VGND sg13cmos5l_decap_8
XFILLER_428_161 VPWR VGND sg13cmos5l_decap_8
X_3145_ Tile_X0Y7_FrameData_O[15] Tile_X0Y7_FrameData[15] VPWR VGND sg13cmos5l_buf_1
X_0357_ _0357_/Q Tile_X0Y7_FrameData[26] VGND VPWR Tile_X0Y9_FrameStrobe[6] latch
XFILLER_699_50 VPWR VGND sg13cmos5l_decap_8
XFILLER_632_220 VPWR VGND sg13cmos5l_decap_8
XFILLER_632_231 VPWR VGND sg13cmos5l_fill_1
XFILLER_131_29 VPWR VGND sg13cmos5l_decap_8
X_0288_ _0288_/Q Tile_X0Y7_FrameData[31] VGND VPWR Tile_X0Y9_FrameStrobe[4] latch
X_3076_ Tile_X0Y4_E2BEGb[2] _4266_/X VPWR VGND sg13cmos5l_buf_1
XFILLER_54_136 VPWR VGND sg13cmos5l_decap_8
XFILLER_443_164 VPWR VGND sg13cmos5l_fill_2
XFILLER_242_226 VPWR VGND sg13cmos5l_decap_8
XFILLER_54_158 VPWR VGND sg13cmos5l_decap_8
X_2027_ _2027_/Q Tile_X0Y4_FrameData[26] VGND VPWR Tile_X0Y9_FrameStrobe[3] latch
XFILLER_568_21 VPWR VGND sg13cmos5l_decap_8
XFILLER_211_84 VPWR VGND sg13cmos5l_decap_8
XFILLER_62_180 VPWR VGND sg13cmos5l_decap_4
XFILLER_396_241 VPWR VGND sg13cmos5l_decap_8
XFILLER_250_270 VPWR VGND sg13cmos5l_fill_2
XFILLER_210_112 VPWR VGND sg13cmos5l_decap_8
XFILLER_24_49 VPWR VGND sg13cmos5l_decap_8
XFILLER_356_105 VPWR VGND sg13cmos5l_decap_8
XFILLER_568_98 VPWR VGND sg13cmos5l_decap_8
X_3978_ _3978_/X _3985_/X Tile_X0Y1_W6END[2] _3984_/X _3978_/A3 _1181_/Q _1180_/Q
+ VPWR VGND sg13cmos5l_mux4_1
XFILLER_10_217 VPWR VGND sg13cmos5l_fill_1
XFILLER_545_249 VPWR VGND sg13cmos5l_decap_8
XFILLER_287_77 VPWR VGND sg13cmos5l_decap_8
X_2929_ Tile_X0Y8_E2BEGb[5] _4741_/X VPWR VGND sg13cmos5l_buf_1
XFILLER_437_14 VPWR VGND sg13cmos5l_decap_8
XFILLER_210_189 VPWR VGND sg13cmos5l_decap_4
XANTENNA__3248__X Tile_X0Y0_FrameData_O[16] VPWR VGND sg13cmos5l_antennanp
XFILLER_108_105 VPWR VGND sg13cmos5l_decap_8
XFILLER_163_200 VPWR VGND sg13cmos5l_decap_8
XFILLER_584_42 VPWR VGND sg13cmos5l_decap_8
XFILLER_371_119 VPWR VGND sg13cmos5l_fill_1
XFILLER_560_219 VPWR VGND sg13cmos5l_decap_8
XFILLER_364_160 VPWR VGND sg13cmos5l_decap_8
XFILLER_156_15 VPWR VGND sg13cmos5l_decap_8
XFILLER_40_48 VPWR VGND sg13cmos5l_decap_8
XFILLER_702_213 VPWR VGND sg13cmos5l_fill_1
XFILLER_702_235 VPWR VGND sg13cmos5l_decap_8
XFILLER_123_119 VPWR VGND sg13cmos5l_decap_8
XFILLER_702_268 VPWR VGND sg13cmos5l_decap_4
XFILLER_513_179 VPWR VGND sg13cmos5l_decap_4
XFILLER_6_7 VPWR VGND sg13cmos5l_decap_8
XFILLER_453_35 VPWR VGND sg13cmos5l_decap_8
XFILLER_236_70 VPWR VGND sg13cmos5l_decap_8
XFILLER_466_201 VPWR VGND sg13cmos5l_decap_8
XFILLER_277_112 VPWR VGND sg13cmos5l_decap_8
XFILLER_172_14 VPWR VGND sg13cmos5l_decap_8
XFILLER_277_145 VPWR VGND sg13cmos5l_decap_8
XFILLER_603_49 VPWR VGND sg13cmos5l_decap_8
XFILLER_218_212 VPWR VGND sg13cmos5l_decap_8
XFILLER_105_63 VPWR VGND sg13cmos5l_decap_8
XFILLER_608_272 VPWR VGND sg13cmos5l_fill_1
XFILLER_562_7 VPWR VGND sg13cmos5l_decap_8
XFILLER_322_28 VPWR VGND sg13cmos5l_decap_8
XANTENNA__3711__X AXI_M_SOC_WDATA21 VPWR VGND sg13cmos5l_antennanp
XFILLER_85_261 VPWR VGND sg13cmos5l_fill_1
XFILLER_218_256 VPWR VGND sg13cmos5l_decap_4
XFILLER_65_56 VPWR VGND sg13cmos5l_decap_8
XFILLER_623_253 VPWR VGND sg13cmos5l_decap_8
XFILLER_233_204 VPWR VGND sg13cmos5l_decap_8
XANTENNA_102 _0157_/X VPWR VGND sg13cmos5l_antennanp
XFILLER_434_164 VPWR VGND sg13cmos5l_decap_8
XFILLER_233_215 VPWR VGND sg13cmos5l_fill_2
XFILLER_45_147 VPWR VGND sg13cmos5l_decap_4
XANTENNA_113 _0157_/X VPWR VGND sg13cmos5l_antennanp
XFILLER_45_158 VPWR VGND sg13cmos5l_decap_8
XANTENNA_124 Tile_X0Y6_FrameData[30] VPWR VGND sg13cmos5l_antennanp
XANTENNA_135 Tile_X0Y6_FrameData[31] VPWR VGND sg13cmos5l_antennanp
XANTENNA_146 Tile_X0Y9_FrameStrobe[10] VPWR VGND sg13cmos5l_antennanp
XANTENNA_157 Tile_X0Y9_FrameStrobe[8] VPWR VGND sg13cmos5l_antennanp
XFILLER_478_21 VPWR VGND sg13cmos5l_decap_8
XANTENNA_168 Tile_X0Y9_FrameStrobe[8] VPWR VGND sg13cmos5l_antennanp
XFILLER_60_139 VPWR VGND sg13cmos5l_decap_8
XANTENNA_179 Tile_X0Y9_FrameStrobe[8] VPWR VGND sg13cmos5l_antennanp
XFILLER_198_141 VPWR VGND sg13cmos5l_decap_8
XFILLER_121_84 VPWR VGND sg13cmos5l_decap_8
XFILLER_81_33 VPWR VGND sg13cmos5l_decap_8
XFILLER_347_105 VPWR VGND sg13cmos5l_decap_8
XFILLER_197_77 VPWR VGND sg13cmos5l_decap_8
XFILLER_139_241 VPWR VGND sg13cmos5l_decap_8
XFILLER_628_57 VPWR VGND sg13cmos5l_decap_8
XFILLER_347_14 VPWR VGND sg13cmos5l_decap_8
XANTENNA__3158__X Tile_X0Y7_FrameData_O[28] VPWR VGND sg13cmos5l_antennanp
XFILLER_317_0 VPWR VGND sg13cmos5l_decap_8
XFILLER_494_42 VPWR VGND sg13cmos5l_decap_8
XFILLER_362_119 VPWR VGND sg13cmos5l_fill_2
XFILLER_355_182 VPWR VGND sg13cmos5l_decap_8
XFILLER_5_221 VPWR VGND sg13cmos5l_decap_8
XANTENNA__2997__X Tile_X0Y5_E2BEG[0] VPWR VGND sg13cmos5l_antennanp
XFILLER_644_56 VPWR VGND sg13cmos5l_decap_8
XFILLER_107_160 VPWR VGND sg13cmos5l_decap_8
XFILLER_504_179 VPWR VGND sg13cmos5l_decap_4
XFILLER_427_91 VPWR VGND sg13cmos5l_decap_8
XFILLER_370_185 VPWR VGND sg13cmos5l_decap_8
XFILLER_686_0 VPWR VGND sg13cmos5l_decap_8
XFILLER_363_57 VPWR VGND sg13cmos5l_decap_4
XFILLER_512_190 VPWR VGND sg13cmos5l_decap_8
XFILLER_268_123 VPWR VGND sg13cmos5l_decap_4
XFILLER_673_120 VPWR VGND sg13cmos5l_decap_8
XFILLER_268_145 VPWR VGND sg13cmos5l_fill_2
XFILLER_68_217 VPWR VGND sg13cmos5l_decap_8
X_1260_ _1260_/Q Tile_X0Y1_FrameData[13] VGND VPWR Tile_X0Y9_FrameStrobe[2] latch
XFILLER_673_153 VPWR VGND sg13cmos5l_decap_8
XFILLER_513_49 VPWR VGND sg13cmos5l_decap_8
XFILLER_268_189 VPWR VGND sg13cmos5l_decap_8
XFILLER_283_126 VPWR VGND sg13cmos5l_decap_8
X_0211_ _0211_/Q Tile_X0Y7_FrameData[12] VGND VPWR Tile_X0Y9_FrameStrobe[1] latch
XFILLER_660_77 VPWR VGND sg13cmos5l_decap_8
X_1191_ _1191_/Q Tile_X0Y1_FrameData[18] VGND VPWR Tile_X0Y9_FrameStrobe[0] latch
XFILLER_162_80 VPWR VGND sg13cmos5l_decap_8
XANTENNA__3621__X Tile_X0Y9_S2BEGb[7] VPWR VGND sg13cmos5l_antennanp
XFILLER_614_231 VPWR VGND sg13cmos5l_decap_8
XFILLER_36_114 VPWR VGND sg13cmos5l_decap_8
X_0142_ _3187_/A _3904_/X _3905_/X _1390_/Q VPWR VGND sg13cmos5l_mux2_1
XFILLER_614_264 VPWR VGND sg13cmos5l_decap_8
XFILLER_425_175 VPWR VGND sg13cmos5l_decap_8
XFILLER_224_226 VPWR VGND sg13cmos5l_decap_8
XFILLER_669_42 VPWR VGND sg13cmos5l_decap_8
XFILLER_586_105 VPWR VGND sg13cmos5l_decap_8
XFILLER_312_72 VPWR VGND sg13cmos5l_decap_8
XFILLER_224_248 VPWR VGND sg13cmos5l_decap_8
X_0073_ _0073_/X _3997_/X _3998_/X _2413_/Q VPWR VGND sg13cmos5l_mux2_1
XFILLER_586_127 VPWR VGND sg13cmos5l_decap_8
XFILLER_440_156 VPWR VGND sg13cmos5l_fill_1
XFILLER_388_21 VPWR VGND sg13cmos5l_decap_8
XFILLER_189_130 VPWR VGND sg13cmos5l_decap_8
X_3901_ _3901_/X Tile_X0Y1_W2MID[1] Tile_X0Y1_W2END[1] Tile_X0Y1_W6END[1] _3990_/X
+ _1405_/Q _1404_/Q VPWR VGND sg13cmos5l_mux4_1
XFILLER_669_86 VPWR VGND sg13cmos5l_decap_8
XFILLER_579_190 VPWR VGND sg13cmos5l_decap_8
X_4881_ _4881_/X Tile_X0Y9_N4END[1] _0082_/X _4926_/X _4930_/X _0781_/Q _0780_/Q VPWR
+ VGND sg13cmos5l_mux4_1
XFILLER_527_205 VPWR VGND sg13cmos5l_decap_4
XFILLER_338_105 VPWR VGND sg13cmos5l_decap_8
X_3832_ _3832_/X Tile_X0Y0_WW4END[3] _3884_/X _3859_/X _3861_/X _1041_/Q _1040_/Q
+ VPWR VGND sg13cmos5l_mux4_1
XFILLER_594_182 VPWR VGND sg13cmos5l_fill_1
XFILLER_538_35 VPWR VGND sg13cmos5l_decap_8
XFILLER_685_41 VPWR VGND sg13cmos5l_decap_8
XFILLER_393_233 VPWR VGND sg13cmos5l_decap_8
X_3763_ _3763_/X Tile_X0Y1_WW4END[4] Tile_X0Y1_WW4END[12] Tile_X0Y1_W6END[4] _4012_/X
+ _1249_/Q _1248_/Q VPWR VGND sg13cmos5l_mux4_1
XFILLER_257_14 VPWR VGND sg13cmos5l_decap_8
X_0975_ _0975_/Q Tile_X0Y0_FrameData[28] VGND VPWR Tile_X0Y9_FrameStrobe[1] latch
XANTENNA__3068__X Tile_X0Y5_FrameData_O[27] VPWR VGND sg13cmos5l_antennanp
XFILLER_542_219 VPWR VGND sg13cmos5l_decap_8
XFILLER_353_119 VPWR VGND sg13cmos5l_decap_8
X_2714_ _4541_/A3 VPWR VGND sg13cmos5l_tielo
XFILLER_535_271 VPWR VGND sg13cmos5l_fill_2
X_3694_ AXI_M_SOC_WDATA4 Tile_X0Y7_WW4END[4] Tile_X0Y7_WW4END[12] Tile_X0Y7_W6END[4]
+ _4688_/X _0239_/Q _0238_/Q VPWR VGND sg13cmos5l_mux4_1
XFILLER_346_182 VPWR VGND sg13cmos5l_decap_8
XFILLER_65_0 VPWR VGND sg13cmos5l_decap_8
X_2645_ _2645_/Q Tile_X0Y6_FrameData[18] VGND VPWR Tile_X0Y9_FrameStrobe[6] latch
XFILLER_407_28 VPWR VGND sg13cmos5l_decap_8
XFILLER_361_163 VPWR VGND sg13cmos5l_decap_4
XFILLER_337_80 VPWR VGND sg13cmos5l_fill_1
XFILLER_554_56 VPWR VGND sg13cmos5l_decap_8
XFILLER_510_105 VPWR VGND sg13cmos5l_decap_8
X_2576_ _2576_/Q Tile_X0Y6_FrameData[23] VGND VPWR Tile_X0Y9_FrameStrobe[4] latch
XFILLER_273_35 VPWR VGND sg13cmos5l_decap_8
XFILLER_649_150 VPWR VGND sg13cmos5l_decap_8
X_4315_ _4315_/X _4239_/X _4355_/X _4354_/X _4238_/X _1947_/Q _1946_/Q VPWR VGND sg13cmos5l_mux4_1
XFILLER_113_141 VPWR VGND sg13cmos5l_decap_8
X_1527_ _1527_/Q Tile_X0Y2_FrameData[26] VGND VPWR Tile_X0Y9_FrameStrobe[3] latch
XFILLER_302_241 VPWR VGND sg13cmos5l_decap_8
XFILLER_448_245 VPWR VGND sg13cmos5l_decap_4
XFILLER_59_228 VPWR VGND sg13cmos5l_decap_8
XFILLER_259_156 VPWR VGND sg13cmos5l_decap_8
XFILLER_259_167 VPWR VGND sg13cmos5l_fill_2
X_4246_ _4246_/X Tile_X0Y2_W1END[1] Tile_X0Y2_W2MID[2] Tile_X0Y2_W2END[2] _4100_/X
+ _1619_/Q _1618_/Q VPWR VGND sg13cmos5l_mux4_1
XFILLER_206_84 VPWR VGND sg13cmos5l_decap_8
X_1458_ _1458_/Q Tile_X0Y2_FrameData[31] VGND VPWR Tile_X0Y9_FrameStrobe[1] latch
XFILLER_423_49 VPWR VGND sg13cmos5l_decap_8
XFILLER_463_226 VPWR VGND sg13cmos5l_decap_8
XFILLER_570_77 VPWR VGND sg13cmos5l_decap_8
XFILLER_142_28 VPWR VGND sg13cmos5l_decap_8
X_0409_ _0409_/Q Tile_X0Y7_FrameData[6] VGND VPWR Tile_X0Y9_FrameStrobe[7] latch
X_4177_ _4177_/X Tile_X0Y3_WW4END[2] AXI_M_SOC_WREADY _4224_/X _4209_/X _1787_/Q _1786_/Q
+ VPWR VGND sg13cmos5l_mux4_1
XFILLER_416_120 VPWR VGND sg13cmos5l_decap_8
XFILLER_274_159 VPWR VGND sg13cmos5l_decap_8
XANTENNA__3531__X Tile_X0Y9_E2BEG[5] VPWR VGND sg13cmos5l_antennanp
X_1389_ _1389_/Q Tile_X0Y1_FrameData[12] VGND VPWR Tile_X0Y9_FrameStrobe[6] latch
X_3128_ Tile_X0Y7_EE4BEG[14] _4642_/X VPWR VGND sg13cmos5l_buf_1
XFILLER_579_42 VPWR VGND sg13cmos5l_decap_8
XFILLER_431_112 VPWR VGND sg13cmos5l_decap_8
XFILLER_577_105 VPWR VGND sg13cmos5l_fill_2
XFILLER_416_197 VPWR VGND sg13cmos5l_decap_8
X_3059_ Tile_X0Y5_FrameData_O[18] Tile_X0Y5_FrameData[18] VPWR VGND sg13cmos5l_buf_1
XFILLER_42_106 VPWR VGND sg13cmos5l_decap_8
XFILLER_298_21 VPWR VGND sg13cmos5l_decap_8
XFILLER_230_207 VPWR VGND sg13cmos5l_decap_8
XFILLER_620_256 VPWR VGND sg13cmos5l_decap_8
XFILLER_35_180 VPWR VGND sg13cmos5l_decap_8
XFILLER_431_189 VPWR VGND sg13cmos5l_decap_8
XFILLER_384_200 VPWR VGND sg13cmos5l_decap_4
XFILLER_143_7 VPWR VGND sg13cmos5l_decap_8
XFILLER_50_172 VPWR VGND sg13cmos5l_fill_2
XFILLER_448_35 VPWR VGND sg13cmos5l_decap_8
XFILLER_51_25 VPWR VGND sg13cmos5l_decap_8
XFILLER_167_14 VPWR VGND sg13cmos5l_decap_8
XFILLER_344_108 VPWR VGND sg13cmos5l_fill_1
XFILLER_136_200 VPWR VGND sg13cmos5l_decap_8
XFILLER_51_69 VPWR VGND sg13cmos5l_decap_8
XFILLER_337_160 VPWR VGND sg13cmos5l_decap_8
XFILLER_526_271 VPWR VGND sg13cmos5l_fill_2
XFILLER_408_7 VPWR VGND sg13cmos5l_decap_8
XFILLER_687_201 VPWR VGND sg13cmos5l_decap_8
XFILLER_498_112 VPWR VGND sg13cmos5l_decap_8
XANTENNA__0114__Y AXI_M_SOC_ARLOCK VPWR VGND sg13cmos5l_antennanp
XFILLER_317_28 VPWR VGND sg13cmos5l_fill_2
XANTENNA__3706__X AXI_M_SOC_WDATA16 VPWR VGND sg13cmos5l_antennanp
XFILLER_464_56 VPWR VGND sg13cmos5l_decap_8
XFILLER_501_105 VPWR VGND sg13cmos5l_decap_8
XFILLER_297_207 VPWR VGND sg13cmos5l_decap_8
XFILLER_352_196 VPWR VGND sg13cmos5l_decap_8
XFILLER_297_229 VPWR VGND sg13cmos5l_decap_8
XFILLER_498_189 VPWR VGND sg13cmos5l_decap_8
XFILLER_104_174 VPWR VGND sg13cmos5l_decap_8
XFILLER_393_4 VPWR VGND sg13cmos5l_fill_1
XFILLER_439_256 VPWR VGND sg13cmos5l_decap_4
XFILLER_116_84 VPWR VGND sg13cmos5l_decap_4
XFILLER_454_215 VPWR VGND sg13cmos5l_decap_8
XFILLER_670_112 VPWR VGND sg13cmos5l_fill_2
XFILLER_655_197 VPWR VGND sg13cmos5l_decap_8
XFILLER_630_14 VPWR VGND sg13cmos5l_decap_8
XFILLER_265_148 VPWR VGND sg13cmos5l_decap_4
XANTENNA__3441__X Tile_X0Y1_UserCLKo VPWR VGND sg13cmos5l_antennanp
XFILLER_407_120 VPWR VGND sg13cmos5l_decap_8
XFILLER_670_178 VPWR VGND sg13cmos5l_decap_8
XFILLER_407_175 VPWR VGND sg13cmos5l_decap_4
XFILLER_18_158 VPWR VGND sg13cmos5l_decap_8
XFILLER_92_21 VPWR VGND sg13cmos5l_decap_8
XFILLER_422_112 VPWR VGND sg13cmos5l_decap_8
XFILLER_267_0 VPWR VGND sg13cmos5l_decap_8
XFILLER_18_169 VPWR VGND sg13cmos5l_fill_1
XFILLER_568_105 VPWR VGND sg13cmos5l_decap_8
XFILLER_489_42 VPWR VGND sg13cmos5l_decap_8
XFILLER_611_223 VPWR VGND sg13cmos5l_fill_2
XFILLER_710_91 VPWR VGND sg13cmos5l_decap_8
XFILLER_26_191 VPWR VGND sg13cmos5l_decap_8
XFILLER_434_0 VPWR VGND sg13cmos5l_decap_8
XFILLER_639_56 VPWR VGND sg13cmos5l_decap_8
XFILLER_25_70 VPWR VGND sg13cmos5l_decap_8
XFILLER_576_160 VPWR VGND sg13cmos5l_decap_8
XFILLER_358_35 VPWR VGND sg13cmos5l_decap_8
XFILLER_186_144 VPWR VGND sg13cmos5l_decap_8
XFILLER_375_233 VPWR VGND sg13cmos5l_decap_8
XFILLER_601_0 VPWR VGND sg13cmos5l_decap_8
XFILLER_335_119 VPWR VGND sg13cmos5l_decap_8
XFILLER_390_214 VPWR VGND sg13cmos5l_decap_8
X_0760_ _0760_/Q Tile_X0Y9_FrameData[7] VGND VPWR Tile_X0Y9_FrameStrobe[2] latch
XFILLER_127_233 VPWR VGND sg13cmos5l_fill_1
XFILLER_508_49 VPWR VGND sg13cmos5l_decap_8
XFILLER_678_201 VPWR VGND sg13cmos5l_fill_2
XFILLER_343_130 VPWR VGND sg13cmos5l_decap_4
XFILLER_127_255 VPWR VGND sg13cmos5l_decap_8
X_0691_ _0691_/Q Tile_X0Y9_FrameData[12] VGND VPWR Tile_X0Y9_FrameStrobe[0] latch
XFILLER_655_99 VPWR VGND sg13cmos5l_decap_8
XFILLER_532_252 VPWR VGND sg13cmos5l_decap_8
XANTENNA__3616__X Tile_X0Y9_S2BEGb[2] VPWR VGND sg13cmos5l_antennanp
XFILLER_678_245 VPWR VGND sg13cmos5l_decap_8
XFILLER_678_256 VPWR VGND sg13cmos5l_fill_2
XFILLER_489_156 VPWR VGND sg13cmos5l_decap_8
X_2430_ _2430_/Q Tile_X0Y5_FrameData[7] VGND VPWR Tile_X0Y9_FrameStrobe[7] latch
XFILLER_374_67 VPWR VGND sg13cmos5l_fill_1
XFILLER_671_21 VPWR VGND sg13cmos5l_decap_8
XFILLER_142_269 VPWR VGND sg13cmos5l_decap_4
X_2361_ _2361_/Q Tile_X0Y5_FrameData[12] VGND VPWR Tile_X0Y9_FrameStrobe[5] latch
XFILLER_671_54 VPWR VGND sg13cmos5l_decap_8
XFILLER_693_259 VPWR VGND sg13cmos5l_decap_4
X_4100_ _4100_/X _4031_/X _4139_/X _4138_/X _4030_/X _1439_/Q _1438_/Q VPWR VGND sg13cmos5l_mux4_1
XFILLER_110_111 VPWR VGND sg13cmos5l_fill_2
X_1312_ _1312_/Q Tile_X0Y1_FrameData[25] VGND VPWR Tile_X0Y9_FrameStrobe[4] latch
X_2292_ _2292_/Q Tile_X0Y5_FrameData[17] VGND VPWR Tile_X0Y9_FrameStrobe[3] latch
XFILLER_243_49 VPWR VGND sg13cmos5l_decap_4
XFILLER_646_175 VPWR VGND sg13cmos5l_decap_8
XFILLER_604_70 VPWR VGND sg13cmos5l_decap_4
XFILLER_500_182 VPWR VGND sg13cmos5l_decap_8
XFILLER_256_126 VPWR VGND sg13cmos5l_decap_8
XFILLER_604_81 VPWR VGND sg13cmos5l_decap_8
XFILLER_110_155 VPWR VGND sg13cmos5l_fill_1
X_4031_ _4031_/X Tile_X0Y3_W2MID[2] Tile_X0Y3_W2END[2] Tile_X0Y3_W6END[2] _4208_/X
+ _1907_/Q _1906_/Q VPWR VGND sg13cmos5l_mux4_1
XFILLER_445_237 VPWR VGND sg13cmos5l_fill_2
X_1243_ _1243_/Q Tile_X0Y1_FrameData[30] VGND VPWR Tile_X0Y9_FrameStrobe[2] latch
XFILLER_540_14 VPWR VGND sg13cmos5l_decap_8
XFILLER_390_99 VPWR VGND sg13cmos5l_decap_8
XFILLER_2_63 VPWR VGND sg13cmos5l_decap_8
XANTENNA__3351__X Tile_X0Y2_FrameData_O[22] VPWR VGND sg13cmos5l_antennanp
XFILLER_49_272 VPWR VGND sg13cmos5l_fill_1
XFILLER_271_107 VPWR VGND sg13cmos5l_decap_4
X_1174_ _1174_/Q Tile_X0Y0_FrameData[21] VGND VPWR Tile_X0Y9_FrameStrobe[7] latch
XFILLER_64_231 VPWR VGND sg13cmos5l_decap_8
XFILLER_599_252 VPWR VGND sg13cmos5l_fill_1
XFILLER_453_270 VPWR VGND sg13cmos5l_fill_2
XFILLER_413_112 VPWR VGND sg13cmos5l_decap_8
XFILLER_602_212 VPWR VGND sg13cmos5l_fill_1
XFILLER_399_42 VPWR VGND sg13cmos5l_decap_8
X_0125_ _3189_/A _3794_/X _3795_/X _1148_/Q VPWR VGND sg13cmos5l_mux2_1
X_0056_ _0056_/X _4676_/X _4677_/X _1863_/Q VPWR VGND sg13cmos5l_mux2_1
X_4933_ _4933_/X Tile_X0Y8_W2MID[6] Tile_X0Y8_W2END[6] Tile_X0Y8_W6END[9] _4787_/X
+ _0625_/Q _0624_/Q VPWR VGND sg13cmos5l_mux4_1
XFILLER_574_119 VPWR VGND sg13cmos5l_decap_8
XFILLER_549_56 VPWR VGND sg13cmos5l_decap_8
X_4864_ _4864_/X Tile_X0Y9_WW4END[15] AXI_M_SOC_RDATA0 _4931_/X _4900_/X _0815_/Q
+ _0814_/Q VPWR VGND sg13cmos5l_mux4_1
XFILLER_696_84 VPWR VGND sg13cmos5l_decap_8
XFILLER_567_182 VPWR VGND sg13cmos5l_decap_8
XFILLER_268_35 VPWR VGND sg13cmos5l_decap_8
XANTENNA_13 AXI_M_SOC_RDATA26 VPWR VGND sg13cmos5l_antennanp
XFILLER_716_113 VPWR VGND sg13cmos5l_fill_2
XANTENNA_24 AXI_M_SOC_RDATA26 VPWR VGND sg13cmos5l_antennanp
X_3815_ _3815_/X Tile_X0Y0_W2END[4] Tile_X0Y0_WW4END[3] _3859_/X _3858_/X _1075_/Q
+ _1074_/Q VPWR VGND sg13cmos5l_mux4_1
XANTENNA_35 AXI_M_SOC_RDATA26 VPWR VGND sg13cmos5l_antennanp
XANTENNA_46 Tile_X0Y0_FrameData[25] VPWR VGND sg13cmos5l_antennanp
X_4795_ _4795_/X _4341_/X _4345_/X _4349_/X _4316_/X _2118_/Q _2117_/Q VPWR VGND sg13cmos5l_mux4_1
XANTENNA_57 Tile_X0Y0_FrameData[25] VPWR VGND sg13cmos5l_antennanp
XFILLER_326_119 VPWR VGND sg13cmos5l_decap_8
XANTENNA_68 Tile_X0Y0_S2MID[2] VPWR VGND sg13cmos5l_antennanp
XFILLER_118_211 VPWR VGND sg13cmos5l_fill_2
XFILLER_381_225 VPWR VGND sg13cmos5l_decap_8
XANTENNA_79 Tile_X0Y0_S4END[14] VPWR VGND sg13cmos5l_antennanp
X_3746_ AXI_M_SOC_ARADDR18 Tile_X0Y8_WW4END[2] Tile_X0Y8_WW4END[10] Tile_X0Y8_W6END[2]
+ _4802_/X _0499_/Q _0498_/Q VPWR VGND sg13cmos5l_mux4_1
XFILLER_319_171 VPWR VGND sg13cmos5l_decap_8
XFILLER_21_28 VPWR VGND sg13cmos5l_decap_8
X_0958_ _0958_/Q Tile_X0Y0_FrameData[13] VGND VPWR Tile_X0Y9_FrameStrobe[0] latch
XFILLER_418_49 VPWR VGND sg13cmos5l_decap_8
XFILLER_565_77 VPWR VGND sg13cmos5l_decap_8
XFILLER_137_28 VPWR VGND sg13cmos5l_decap_8
XFILLER_715_14 VPWR VGND sg13cmos5l_decap_8
X_3677_ _3677_/X Tile_X0Y2_WW4END[7] Tile_X0Y2_WW4END[15] Tile_X0Y2_W6END[7] _4123_/X
+ _1491_/Q _1490_/Q VPWR VGND sg13cmos5l_mux4_1
XANTENNA__3526__X Tile_X0Y9_E2BEG[0] VPWR VGND sg13cmos5l_antennanp
X_0889_ _0889_/Q Tile_X0Y9_FrameData[6] VGND VPWR Tile_X0Y9_FrameStrobe[6] latch
XFILLER_523_263 VPWR VGND sg13cmos5l_fill_2
XFILLER_284_56 VPWR VGND sg13cmos5l_decap_8
X_2628_ _2628_/Q Tile_X0Y6_FrameData[3] VGND VPWR Tile_X0Y9_FrameStrobe[5] latch
XFILLER_581_21 VPWR VGND sg13cmos5l_decap_8
XFILLER_495_126 VPWR VGND sg13cmos5l_decap_8
X_2559_ _2559_/Q Tile_X0Y6_FrameData[8] VGND VPWR Tile_X0Y9_FrameStrobe[3] latch
XFILLER_637_131 VPWR VGND sg13cmos5l_decap_8
XFILLER_581_98 VPWR VGND sg13cmos5l_decap_8
XFILLER_514_70 VPWR VGND sg13cmos5l_decap_8
XFILLER_652_112 VPWR VGND sg13cmos5l_decap_8
XFILLER_436_237 VPWR VGND sg13cmos5l_decap_8
X_4229_ _4229_/X _4203_/X _0046_/X _4202_/X Tile_X0Y0_S4END[15] _1715_/Q _1714_/Q
+ VPWR VGND sg13cmos5l_mux4_1
XFILLER_450_14 VPWR VGND sg13cmos5l_decap_8
XANTENNA__3261__X Tile_X0Y0_FrameData_O[29] VPWR VGND sg13cmos5l_antennanp
XFILLER_46_36 VPWR VGND sg13cmos5l_decap_8
XFILLER_262_118 VPWR VGND sg13cmos5l_decap_8
XFILLER_652_178 VPWR VGND sg13cmos5l_decap_8
XFILLER_600_28 VPWR VGND sg13cmos5l_decap_8
XFILLER_260_7 VPWR VGND sg13cmos5l_decap_8
XFILLER_15_117 VPWR VGND sg13cmos5l_fill_2
XFILLER_358_7 VPWR VGND sg13cmos5l_decap_8
XFILLER_102_42 VPWR VGND sg13cmos5l_decap_8
XFILLER_270_184 VPWR VGND sg13cmos5l_decap_8
XFILLER_102_86 VPWR VGND sg13cmos5l_fill_1
XFILLER_565_119 VPWR VGND sg13cmos5l_decap_8
XFILLER_459_56 VPWR VGND sg13cmos5l_decap_8
XFILLER_525_7 VPWR VGND sg13cmos5l_decap_8
XFILLER_558_171 VPWR VGND sg13cmos5l_fill_1
XFILLER_62_68 VPWR VGND sg13cmos5l_decap_8
XFILLER_178_46 VPWR VGND sg13cmos5l_decap_8
XFILLER_357_266 VPWR VGND sg13cmos5l_decap_8
XFILLER_178_79 VPWR VGND sg13cmos5l_decap_8
XFILLER_707_168 VPWR VGND sg13cmos5l_fill_1
XFILLER_372_214 VPWR VGND sg13cmos5l_decap_8
XFILLER_317_119 VPWR VGND sg13cmos5l_decap_8
XFILLER_183_125 VPWR VGND sg13cmos5l_decap_8
XFILLER_109_222 VPWR VGND sg13cmos5l_decap_8
XFILLER_573_196 VPWR VGND sg13cmos5l_decap_8
XFILLER_625_14 VPWR VGND sg13cmos5l_decap_8
XANTENNA__3436__X Tile_X0Y4_FrameData_O[27] VPWR VGND sg13cmos5l_antennanp
XFILLER_124_225 VPWR VGND sg13cmos5l_decap_8
XFILLER_194_89 VPWR VGND sg13cmos5l_decap_8
XFILLER_491_21 VPWR VGND sg13cmos5l_decap_8
XFILLER_127_72 VPWR VGND sg13cmos5l_decap_8
XFILLER_127_83 VPWR VGND sg13cmos5l_fill_2
XFILLER_87_43 VPWR VGND sg13cmos5l_decap_8
XFILLER_628_120 VPWR VGND sg13cmos5l_fill_2
XFILLER_278_240 VPWR VGND sg13cmos5l_fill_1
XFILLER_705_91 VPWR VGND sg13cmos5l_decap_8
XFILLER_278_262 VPWR VGND sg13cmos5l_fill_1
XFILLER_491_98 VPWR VGND sg13cmos5l_decap_8
XFILLER_641_35 VPWR VGND sg13cmos5l_decap_8
XFILLER_424_70 VPWR VGND sg13cmos5l_decap_8
XFILLER_643_112 VPWR VGND sg13cmos5l_decap_8
XFILLER_384_0 VPWR VGND sg13cmos5l_decap_8
XFILLER_628_197 VPWR VGND sg13cmos5l_fill_2
XFILLER_38_209 VPWR VGND sg13cmos5l_decap_8
XFILLER_360_14 VPWR VGND sg13cmos5l_decap_8
XANTENNA__3171__X Tile_X0Y4_E6BEG[8] VPWR VGND sg13cmos5l_antennanp
XFILLER_643_189 VPWR VGND sg13cmos5l_decap_8
XFILLER_551_0 VPWR VGND sg13cmos5l_decap_8
XFILLER_46_253 VPWR VGND sg13cmos5l_decap_8
XFILLER_649_0 VPWR VGND sg13cmos5l_decap_8
XFILLER_510_28 VPWR VGND sg13cmos5l_decap_8
XFILLER_596_233 VPWR VGND sg13cmos5l_decap_8
XFILLER_440_91 VPWR VGND sg13cmos5l_decap_8
XFILLER_261_184 VPWR VGND sg13cmos5l_decap_8
XFILLER_410_126 VPWR VGND sg13cmos5l_decap_8
XFILLER_369_56 VPWR VGND sg13cmos5l_decap_8
XFILLER_14_150 VPWR VGND sg13cmos5l_decap_4
X_1930_ _1930_/Q Tile_X0Y4_FrameData[27] VGND VPWR Tile_X0Y9_FrameStrobe[0] latch
XFILLER_14_161 VPWR VGND sg13cmos5l_decap_8
XFILLER_666_21 VPWR VGND sg13cmos5l_decap_8
XFILLER_348_255 VPWR VGND sg13cmos5l_decap_4
XFILLER_159_166 VPWR VGND sg13cmos5l_decap_8
X_1861_ _1861_/Q Tile_X0Y3_FrameData[4] VGND VPWR Tile_X0Y9_FrameStrobe[5] latch
XFILLER_308_108 VPWR VGND sg13cmos5l_decap_8
X_3600_ Tile_X0Y9_FrameData_O[30] Tile_X0Y9_FrameData[30] VPWR VGND sg13cmos5l_buf_1
X_0812_ _0812_/Q Tile_X0Y9_FrameData[19] VGND VPWR Tile_X0Y9_FrameStrobe[4] latch
XFILLER_564_174 VPWR VGND sg13cmos5l_decap_8
X_4580_ _4580_/X _4545_/X Tile_X0Y9_N4END[12] _4544_/X _0152_/X _2471_/Q _2470_/Q
+ VPWR VGND sg13cmos5l_mux4_1
X_1792_ _1792_/Q Tile_X0Y3_FrameData[9] VGND VPWR Tile_X0Y9_FrameStrobe[3] latch
XFILLER_238_49 VPWR VGND sg13cmos5l_fill_2
XFILLER_713_138 VPWR VGND sg13cmos5l_decap_8
XFILLER_385_66 VPWR VGND sg13cmos5l_decap_8
X_3531_ Tile_X0Y9_E2BEG[5] _4853_/X VPWR VGND sg13cmos5l_buf_1
X_0743_ _0743_/Q Tile_X0Y9_FrameData[24] VGND VPWR Tile_X0Y9_FrameStrobe[2] latch
XFILLER_535_14 VPWR VGND sg13cmos5l_decap_8
XANTENNA__3346__X Tile_X0Y2_FrameData_O[17] VPWR VGND sg13cmos5l_antennanp
X_3462_ Tile_X0Y1_FrameData_O[20] Tile_X0Y1_FrameData[20] VPWR VGND sg13cmos5l_buf_1
X_0674_ _0674_/Q Tile_X0Y9_FrameData[29] VGND VPWR Tile_X0Y9_FrameStrobe[0] latch
XFILLER_682_64 VPWR VGND sg13cmos5l_fill_1
XFILLER_666_226 VPWR VGND sg13cmos5l_decap_4
XFILLER_331_144 VPWR VGND sg13cmos5l_fill_1
X_2413_ _2413_/Q Tile_X0Y5_FrameData[24] VGND VPWR Tile_X0Y9_FrameStrobe[7] latch
XFILLER_130_217 VPWR VGND sg13cmos5l_decap_8
X_3393_ Tile_X0Y2_E2BEGb[4] _4052_/X VPWR VGND sg13cmos5l_buf_1
XFILLER_331_166 VPWR VGND sg13cmos5l_decap_8
XFILLER_130_239 VPWR VGND sg13cmos5l_decap_4
XFILLER_331_188 VPWR VGND sg13cmos5l_decap_8
XFILLER_269_251 VPWR VGND sg13cmos5l_decap_8
X_2344_ _2344_/Q Tile_X0Y5_FrameData[29] VGND VPWR Tile_X0Y9_FrameStrobe[5] latch
XFILLER_681_207 VPWR VGND sg13cmos5l_decap_8
XFILLER_551_35 VPWR VGND sg13cmos5l_decap_8
XFILLER_284_210 VPWR VGND sg13cmos5l_decap_8
XFILLER_28_0 VPWR VGND sg13cmos5l_decap_8
XFILLER_634_112 VPWR VGND sg13cmos5l_decap_8
XFILLER_270_14 VPWR VGND sg13cmos5l_decap_8
X_2275_ _2275_/Q Tile_X0Y5_FrameData[2] VGND VPWR Tile_X0Y9_FrameStrobe[2] latch
XANTENNA__3081__X Tile_X0Y4_E2BEGb[7] VPWR VGND sg13cmos5l_antennanp
X_4014_ _4014_/X _3985_/X _0095_/X _3984_/X Tile_X0Y0_S4END[6] _1221_/Q _1220_/Q VPWR
+ VGND sg13cmos5l_mux4_1
X_1226_ _1226_/Q Tile_X0Y1_FrameData[15] VGND VPWR Tile_X0Y9_FrameStrobe[1] latch
XFILLER_701_49 VPWR VGND sg13cmos5l_decap_8
XFILLER_433_229 VPWR VGND sg13cmos5l_fill_2
XFILLER_203_63 VPWR VGND sg13cmos5l_decap_8
XFILLER_420_28 VPWR VGND sg13cmos5l_decap_8
XFILLER_37_264 VPWR VGND sg13cmos5l_decap_8
X_1157_ _1157_/Q Tile_X0Y0_FrameData[6] VGND VPWR Tile_X0Y9_FrameStrobe[6] latch
XFILLER_16_28 VPWR VGND sg13cmos5l_decap_8
XFILLER_252_140 VPWR VGND sg13cmos5l_decap_8
XFILLER_350_91 VPWR VGND sg13cmos5l_decap_8
XFILLER_441_251 VPWR VGND sg13cmos5l_decap_8
X_0108_ AXI_M_SOC_ARBURST0 _3771_/X _0931_/Q VPWR VGND sg13cmos5l_or2_1
XFILLER_398_155 VPWR VGND sg13cmos5l_decap_8
XFILLER_197_217 VPWR VGND sg13cmos5l_decap_8
X_1088_ _1088_/Q Tile_X0Y0_FrameData[11] VGND VPWR Tile_X0Y9_FrameStrobe[4] latch
XFILLER_547_108 VPWR VGND sg13cmos5l_decap_8
XFILLER_279_56 VPWR VGND sg13cmos5l_decap_8
X_4916_ _4916_/X Tile_X0Y9_N1END[0] Tile_X0Y9_N4END[0] _4896_/X _0083_/X _0727_/Q
+ _0726_/Q VPWR VGND sg13cmos5l_mux4_1
XFILLER_576_21 VPWR VGND sg13cmos5l_decap_8
XFILLER_339_255 VPWR VGND sg13cmos5l_fill_2
X_4847_ _4847_/X Tile_X0Y9_N1END[3] _4899_/X AXI_M_SOC_RDATA0 AXI_M_SOC_RDATA4 _0849_/Q
+ _0848_/Q VPWR VGND sg13cmos5l_mux4_1
XFILLER_354_203 VPWR VGND sg13cmos5l_decap_8
XFILLER_295_22 VPWR VGND sg13cmos5l_decap_8
XFILLER_704_105 VPWR VGND sg13cmos5l_decap_8
XFILLER_148_49 VPWR VGND sg13cmos5l_decap_8
X_4778_ _4778_/X Tile_X0Y7_W1END[1] Tile_X0Y7_W6END[9] _4697_/X _4657_/X _0377_/Q
+ _0376_/Q VPWR VGND sg13cmos5l_mux4_1
XFILLER_576_98 VPWR VGND sg13cmos5l_decap_8
XFILLER_20_186 VPWR VGND sg13cmos5l_decap_4
XFILLER_509_70 VPWR VGND sg13cmos5l_decap_8
XFILLER_570_133 VPWR VGND sg13cmos5l_decap_8
X_3729_ AXI_M_SOC_ARADDR1 Tile_X0Y9_WW4END[1] Tile_X0Y9_WW4END[9] Tile_X0Y9_W6END[1]
+ _4917_/X _0757_/Q _0756_/Q VPWR VGND sg13cmos5l_mux4_1
XFILLER_445_14 VPWR VGND sg13cmos5l_decap_8
XANTENNA__3256__X Tile_X0Y0_FrameData_O[24] VPWR VGND sg13cmos5l_antennanp
XFILLER_592_42 VPWR VGND sg13cmos5l_decap_8
XFILLER_106_247 VPWR VGND sg13cmos5l_decap_8
XFILLER_164_15 VPWR VGND sg13cmos5l_decap_8
XFILLER_173_191 VPWR VGND sg13cmos5l_decap_8
XFILLER_307_196 VPWR VGND sg13cmos5l_decap_8
XFILLER_712_182 VPWR VGND sg13cmos5l_decap_8
XFILLER_322_144 VPWR VGND sg13cmos5l_fill_2
XFILLER_525_91 VPWR VGND sg13cmos5l_fill_2
XFILLER_87_120 VPWR VGND sg13cmos5l_decap_8
XFILLER_483_118 VPWR VGND sg13cmos5l_decap_4
XFILLER_461_35 VPWR VGND sg13cmos5l_decap_8
XFILLER_244_70 VPWR VGND sg13cmos5l_decap_8
XFILLER_625_112 VPWR VGND sg13cmos5l_decap_8
XFILLER_275_232 VPWR VGND sg13cmos5l_decap_4
XFILLER_180_14 VPWR VGND sg13cmos5l_decap_8
XFILLER_57_46 VPWR VGND sg13cmos5l_fill_2
XFILLER_476_192 VPWR VGND sg13cmos5l_decap_8
XFILLER_475_7 VPWR VGND sg13cmos5l_decap_8
XFILLER_491_140 VPWR VGND sg13cmos5l_decap_8
XFILLER_680_262 VPWR VGND sg13cmos5l_decap_8
XFILLER_611_49 VPWR VGND sg13cmos5l_decap_8
XFILLER_640_126 VPWR VGND sg13cmos5l_decap_8
XFILLER_113_63 VPWR VGND sg13cmos5l_decap_8
XFILLER_642_7 VPWR VGND sg13cmos5l_decap_8
XFILLER_578_222 VPWR VGND sg13cmos5l_decap_8
XFILLER_43_212 VPWR VGND sg13cmos5l_decap_8
XFILLER_73_56 VPWR VGND sg13cmos5l_decap_8
XFILLER_389_155 VPWR VGND sg13cmos5l_decap_8
XFILLER_188_217 VPWR VGND sg13cmos5l_decap_8
XFILLER_593_247 VPWR VGND sg13cmos5l_decap_8
XFILLER_486_21 VPWR VGND sg13cmos5l_decap_8
XFILLER_11_120 VPWR VGND sg13cmos5l_decap_8
XFILLER_132_0 VPWR VGND sg13cmos5l_decap_8
XFILLER_196_272 VPWR VGND sg13cmos5l_fill_1
XFILLER_339_59 VPWR VGND sg13cmos5l_decap_8
XFILLER_11_186 VPWR VGND sg13cmos5l_fill_2
XFILLER_636_35 VPWR VGND sg13cmos5l_decap_8
XFILLER_546_196 VPWR VGND sg13cmos5l_decap_4
XFILLER_561_133 VPWR VGND sg13cmos5l_decap_8
XFILLER_419_70 VPWR VGND sg13cmos5l_decap_8
XFILLER_345_258 VPWR VGND sg13cmos5l_fill_1
XFILLER_7_157 VPWR VGND sg13cmos5l_decap_8
XFILLER_561_144 VPWR VGND sg13cmos5l_fill_2
XFILLER_355_14 VPWR VGND sg13cmos5l_decap_8
XANTENNA__3166__X Tile_X0Y4_E6BEG[3] VPWR VGND sg13cmos5l_antennanp
XFILLER_98_42 VPWR VGND sg13cmos5l_decap_4
XFILLER_459_104 VPWR VGND sg13cmos5l_decap_8
XFILLER_648_237 VPWR VGND sg13cmos5l_decap_8
XFILLER_599_0 VPWR VGND sg13cmos5l_decap_8
XFILLER_505_28 VPWR VGND sg13cmos5l_decap_8
XFILLER_502_266 VPWR VGND sg13cmos5l_decap_8
XFILLER_652_56 VPWR VGND sg13cmos5l_decap_8
XFILLER_435_91 VPWR VGND sg13cmos5l_decap_8
XFILLER_154_70 VPWR VGND sg13cmos5l_decap_8
X_0390_ _0390_/Q Tile_X0Y7_FrameData[25] VGND VPWR Tile_X0Y9_FrameStrobe[7] latch
XFILLER_371_35 VPWR VGND sg13cmos5l_decap_8
XFILLER_78_142 VPWR VGND sg13cmos5l_decap_4
XFILLER_21_7 VPWR VGND sg13cmos5l_decap_8
XFILLER_78_175 VPWR VGND sg13cmos5l_decap_4
XFILLER_616_134 VPWR VGND sg13cmos5l_decap_8
XFILLER_266_254 VPWR VGND sg13cmos5l_decap_8
XFILLER_671_240 VPWR VGND sg13cmos5l_decap_4
XFILLER_482_140 VPWR VGND sg13cmos5l_decap_8
XFILLER_226_118 VPWR VGND sg13cmos5l_decap_8
XFILLER_93_145 VPWR VGND sg13cmos5l_decap_8
X_2060_ _2060_/Q Tile_X0Y4_FrameData[25] VGND VPWR Tile_X0Y9_FrameStrobe[4] latch
XFILLER_415_218 VPWR VGND sg13cmos5l_decap_8
XFILLER_521_49 VPWR VGND sg13cmos5l_decap_8
XFILLER_415_229 VPWR VGND sg13cmos5l_fill_1
XFILLER_304_84 VPWR VGND sg13cmos5l_decap_8
XFILLER_281_224 VPWR VGND sg13cmos5l_decap_4
XFILLER_19_253 VPWR VGND sg13cmos5l_decap_8
XFILLER_631_126 VPWR VGND sg13cmos5l_decap_8
X_1011_ _1011_/Q Tile_X0Y0_FrameData[24] VGND VPWR Tile_X0Y9_FrameStrobe[2] latch
XFILLER_240_28 VPWR VGND sg13cmos5l_decap_8
XFILLER_170_91 VPWR VGND sg13cmos5l_decap_8
XFILLER_569_255 VPWR VGND sg13cmos5l_decap_4
XFILLER_34_245 VPWR VGND sg13cmos5l_fill_2
XFILLER_677_42 VPWR VGND sg13cmos5l_fill_1
XFILLER_584_214 VPWR VGND sg13cmos5l_decap_8
X_2962_ Tile_X0Y8_FrameData_O[2] Tile_X0Y8_FrameData[2] VPWR VGND sg13cmos5l_buf_1
XFILLER_395_136 VPWR VGND sg13cmos5l_decap_8
XFILLER_249_15 VPWR VGND sg13cmos5l_decap_8
XFILLER_677_75 VPWR VGND sg13cmos5l_decap_8
XFILLER_396_21 VPWR VGND sg13cmos5l_decap_8
X_1913_ _1913_/Q Tile_X0Y3_FrameData[16] VGND VPWR Tile_X0Y9_FrameStrobe[7] latch
X_4701_ _4701_/X Tile_X0Y9_W2MID[7] Tile_X0Y9_W2END[7] Tile_X0Y9_W6END[7] _4901_/X
+ _0919_/Q _0918_/Q VPWR VGND sg13cmos5l_mux4_1
X_2893_ Tile_X0Y6_FrameData_O[14] Tile_X0Y6_FrameData[14] VPWR VGND sg13cmos5l_buf_1
X_4632_ _4632_/X Tile_X0Y7_WW4END[11] AXI_M_SOC_RDATA20 _4695_/X _4675_/X _0295_/Q
+ _0294_/Q VPWR VGND sg13cmos5l_mux4_1
X_1844_ _1844_/Q Tile_X0Y3_FrameData[21] VGND VPWR Tile_X0Y9_FrameStrobe[5] latch
XFILLER_546_35 VPWR VGND sg13cmos5l_decap_8
XFILLER_8_84 VPWR VGND sg13cmos5l_decap_8
XFILLER_698_126 VPWR VGND sg13cmos5l_fill_2
XFILLER_336_269 VPWR VGND sg13cmos5l_decap_4
X_4563_ _4563_/X _4121_/X _4125_/X _4110_/X _4100_/X _1610_/Q _1609_/Q VPWR VGND sg13cmos5l_mux4_1
XFILLER_265_14 VPWR VGND sg13cmos5l_decap_8
X_1775_ _1775_/Q Tile_X0Y3_FrameData[26] VGND VPWR Tile_X0Y9_FrameStrobe[3] latch
XFILLER_351_217 VPWR VGND sg13cmos5l_decap_8
XANTENNA__3076__X Tile_X0Y4_E2BEGb[2] VPWR VGND sg13cmos5l_antennanp
XFILLER_693_85 VPWR VGND sg13cmos5l_decap_8
XFILLER_552_177 VPWR VGND sg13cmos5l_decap_8
X_3514_ Tile_X0Y1_E2BEG[4] _3936_/X VPWR VGND sg13cmos5l_buf_1
XFILLER_701_119 VPWR VGND sg13cmos5l_decap_8
X_0726_ _0726_/Q Tile_X0Y9_FrameData[9] VGND VPWR Tile_X0Y9_FrameStrobe[1] latch
X_4494_ _4494_/X _4549_/X _4548_/X AXI_M_SOC_RDATA25 AXI_M_SOC_RDATA29 _2619_/Q _2618_/Q
+ VPWR VGND sg13cmos5l_mux4_1
XFILLER_304_122 VPWR VGND sg13cmos5l_decap_8
XFILLER_103_206 VPWR VGND sg13cmos5l_decap_8
X_3445_ Tile_X0Y1_FrameData_O[3] Tile_X0Y1_FrameData[3] VPWR VGND sg13cmos5l_buf_1
XFILLER_415_28 VPWR VGND sg13cmos5l_decap_8
X_0657_ _0657_/Q Tile_X0Y8_FrameData[14] VGND VPWR Tile_X0Y9_FrameStrobe[7] latch
XFILLER_562_56 VPWR VGND sg13cmos5l_decap_8
XFILLER_304_199 VPWR VGND sg13cmos5l_decap_8
X_3376_ Tile_X0Y2_EE4BEG[15] _4071_/X VPWR VGND sg13cmos5l_buf_1
XFILLER_281_35 VPWR VGND sg13cmos5l_decap_8
X_0588_ _0588_/Q Tile_X0Y8_FrameData[19] VGND VPWR Tile_X0Y9_FrameStrobe[5] latch
XFILLER_458_181 VPWR VGND sg13cmos5l_decap_8
X_2327_ _2327_/Q Tile_X0Y5_FrameData[14] VGND VPWR Tile_X0Y9_FrameStrobe[4] latch
XFILLER_69_175 VPWR VGND sg13cmos5l_decap_8
XFILLER_111_272 VPWR VGND sg13cmos5l_fill_1
XFILLER_607_156 VPWR VGND sg13cmos5l_decap_8
XFILLER_406_207 VPWR VGND sg13cmos5l_decap_8
XFILLER_272_202 VPWR VGND sg13cmos5l_decap_8
XFILLER_217_129 VPWR VGND sg13cmos5l_decap_8
X_2258_ _2258_/Q Tile_X0Y5_FrameData[19] VGND VPWR Tile_X0Y9_FrameStrobe[2] latch
XFILLER_431_49 VPWR VGND sg13cmos5l_decap_8
XFILLER_214_84 VPWR VGND sg13cmos5l_decap_8
XFILLER_272_235 VPWR VGND sg13cmos5l_decap_4
XFILLER_150_28 VPWR VGND sg13cmos5l_decap_8
X_1209_ _1209_/Q Tile_X0Y1_FrameData[0] VGND VPWR Tile_X0Y9_FrameStrobe[0] latch
XFILLER_84_189 VPWR VGND sg13cmos5l_fill_2
XFILLER_25_201 VPWR VGND sg13cmos5l_decap_8
X_2189_ _2189_/Q Tile_X0Y5_FrameData[24] VGND VPWR Tile_X0Y9_FrameStrobe[0] latch
XFILLER_622_159 VPWR VGND sg13cmos5l_decap_8
XFILLER_225_162 VPWR VGND sg13cmos5l_fill_2
XFILLER_575_203 VPWR VGND sg13cmos5l_decap_8
XFILLER_230_72 VPWR VGND sg13cmos5l_decap_8
XFILLER_709_219 VPWR VGND sg13cmos5l_fill_1
XFILLER_587_42 VPWR VGND sg13cmos5l_decap_8
XFILLER_40_226 VPWR VGND sg13cmos5l_decap_8
XFILLER_43_48 VPWR VGND sg13cmos5l_decap_8
XFILLER_43_59 VPWR VGND sg13cmos5l_fill_2
XFILLER_386_158 VPWR VGND sg13cmos5l_decap_4
XFILLER_528_141 VPWR VGND sg13cmos5l_decap_8
XFILLER_528_152 VPWR VGND sg13cmos5l_fill_2
XFILLER_240_198 VPWR VGND sg13cmos5l_decap_8
XFILLER_528_174 VPWR VGND sg13cmos5l_decap_8
XFILLER_327_225 VPWR VGND sg13cmos5l_decap_8
XFILLER_590_239 VPWR VGND sg13cmos5l_decap_8
XFILLER_138_147 VPWR VGND sg13cmos5l_decap_8
XFILLER_394_191 VPWR VGND sg13cmos5l_decap_8
XFILLER_456_35 VPWR VGND sg13cmos5l_decap_8
XFILLER_543_133 VPWR VGND sg13cmos5l_decap_4
XFILLER_153_106 VPWR VGND sg13cmos5l_fill_2
XFILLER_175_14 VPWR VGND sg13cmos5l_decap_8
XFILLER_689_148 VPWR VGND sg13cmos5l_decap_8
XFILLER_4_105 VPWR VGND sg13cmos5l_decap_8
XFILLER_342_228 VPWR VGND sg13cmos5l_decap_8
XFILLER_4_149 VPWR VGND sg13cmos5l_fill_2
XFILLER_606_49 VPWR VGND sg13cmos5l_decap_8
XFILLER_496_210 VPWR VGND sg13cmos5l_fill_2
XFILLER_325_28 VPWR VGND sg13cmos5l_decap_8
XFILLER_108_63 VPWR VGND sg13cmos5l_decap_8
XFILLER_700_141 VPWR VGND sg13cmos5l_decap_8
XFILLER_592_7 VPWR VGND sg13cmos5l_decap_8
XFILLER_496_243 VPWR VGND sg13cmos5l_decap_8
XFILLER_350_272 VPWR VGND sg13cmos5l_fill_1
XANTENNA__3714__X AXI_M_SOC_WDATA24 VPWR VGND sg13cmos5l_antennanp
XFILLER_472_56 VPWR VGND sg13cmos5l_decap_4
XFILLER_68_56 VPWR VGND sg13cmos5l_decap_8
XFILLER_191_35 VPWR VGND sg13cmos5l_decap_8
XFILLER_310_147 VPWR VGND sg13cmos5l_decap_8
XFILLER_248_210 VPWR VGND sg13cmos5l_decap_8
XFILLER_191_57 VPWR VGND sg13cmos5l_decap_8
XFILLER_102_261 VPWR VGND sg13cmos5l_decap_4
XFILLER_102_272 VPWR VGND sg13cmos5l_fill_1
XFILLER_464_140 VPWR VGND sg13cmos5l_decap_8
XFILLER_75_134 VPWR VGND sg13cmos5l_decap_8
XFILLER_124_84 VPWR VGND sg13cmos5l_decap_8
XFILLER_341_49 VPWR VGND sg13cmos5l_decap_8
XFILLER_702_70 VPWR VGND sg13cmos5l_decap_8
XFILLER_90_104 VPWR VGND sg13cmos5l_fill_2
XFILLER_84_77 VPWR VGND sg13cmos5l_decap_8
XFILLER_90_148 VPWR VGND sg13cmos5l_decap_4
XFILLER_621_170 VPWR VGND sg13cmos5l_fill_1
XFILLER_377_103 VPWR VGND sg13cmos5l_decap_4
XFILLER_566_203 VPWR VGND sg13cmos5l_decap_8
XFILLER_497_42 VPWR VGND sg13cmos5l_decap_8
XFILLER_347_0 VPWR VGND sg13cmos5l_decap_8
XFILLER_621_192 VPWR VGND sg13cmos5l_decap_8
XFILLER_420_254 VPWR VGND sg13cmos5l_decap_4
XFILLER_519_130 VPWR VGND sg13cmos5l_decap_8
XFILLER_318_203 VPWR VGND sg13cmos5l_decap_8
XFILLER_514_0 VPWR VGND sg13cmos5l_decap_8
XFILLER_647_56 VPWR VGND sg13cmos5l_decap_8
XFILLER_318_269 VPWR VGND sg13cmos5l_decap_4
XFILLER_366_57 VPWR VGND sg13cmos5l_decap_4
XFILLER_69_7 VPWR VGND sg13cmos5l_decap_8
X_1560_ _1560_/Q Tile_X0Y2_FrameData[25] VGND VPWR Tile_X0Y9_FrameStrobe[4] latch
XFILLER_516_49 VPWR VGND sg13cmos5l_decap_8
XFILLER_298_110 VPWR VGND sg13cmos5l_decap_8
X_0511_ _0511_/Q Tile_X0Y8_FrameData[0] VGND VPWR Tile_X0Y9_FrameStrobe[2] latch
XFILLER_663_77 VPWR VGND sg13cmos5l_decap_8
XFILLER_235_28 VPWR VGND sg13cmos5l_decap_8
X_1491_ _1491_/Q Tile_X0Y2_FrameData[30] VGND VPWR Tile_X0Y9_FrameStrobe[2] latch
XFILLER_487_254 VPWR VGND sg13cmos5l_decap_4
XFILLER_341_261 VPWR VGND sg13cmos5l_fill_1
XANTENNA__3624__X Tile_X0Y9_S4BEG[2] VPWR VGND sg13cmos5l_antennanp
XFILLER_663_99 VPWR VGND sg13cmos5l_decap_8
XFILLER_165_91 VPWR VGND sg13cmos5l_decap_8
XFILLER_382_56 VPWR VGND sg13cmos5l_decap_8
X_3230_ Tile_X0Y0_FrameStrobe_O[18] Tile_X0Y9_FrameStrobe[18] VPWR VGND sg13cmos5l_buf_1
XFILLER_447_107 VPWR VGND sg13cmos5l_fill_2
XFILLER_3_182 VPWR VGND sg13cmos5l_decap_8
XFILLER_382_67 VPWR VGND sg13cmos5l_fill_2
X_0442_ _0442_/Q Tile_X0Y8_FrameData[5] VGND VPWR Tile_X0Y9_FrameStrobe[0] latch
XFILLER_301_147 VPWR VGND sg13cmos5l_decap_8
X_3161_ Tile_X0Y7_FrameData_O[31] Tile_X0Y7_FrameData[31] VPWR VGND sg13cmos5l_buf_1
X_0373_ _0373_/Q Tile_X0Y7_FrameData[10] VGND VPWR Tile_X0Y9_FrameStrobe[6] latch
XFILLER_66_112 VPWR VGND sg13cmos5l_decap_8
XFILLER_455_151 VPWR VGND sg13cmos5l_decap_8
X_2112_ _2112_/Q Tile_X0Y4_FrameData[5] VGND VPWR Tile_X0Y9_FrameStrobe[5] latch
X_3092_ Tile_X0Y7_E2BEG[6] _4618_/X VPWR VGND sg13cmos5l_buf_1
XFILLER_251_49 VPWR VGND sg13cmos5l_decap_8
XFILLER_612_70 VPWR VGND sg13cmos5l_fill_1
XFILLER_455_184 VPWR VGND sg13cmos5l_decap_8
XFILLER_254_235 VPWR VGND sg13cmos5l_decap_8
XFILLER_604_137 VPWR VGND sg13cmos5l_decap_4
X_2043_ _2043_/Q Tile_X0Y4_FrameData[10] VGND VPWR Tile_X0Y9_FrameStrobe[3] latch
XFILLER_66_189 VPWR VGND sg13cmos5l_decap_8
XFILLER_612_92 VPWR VGND sg13cmos5l_decap_8
XFILLER_207_140 VPWR VGND sg13cmos5l_decap_8
XFILLER_254_268 VPWR VGND sg13cmos5l_decap_4
XFILLER_207_151 VPWR VGND sg13cmos5l_fill_1
XFILLER_331_71 VPWR VGND sg13cmos5l_decap_8
XFILLER_207_173 VPWR VGND sg13cmos5l_decap_8
XFILLER_81_159 VPWR VGND sg13cmos5l_decap_8
XFILLER_411_221 VPWR VGND sg13cmos5l_decap_8
XFILLER_612_181 VPWR VGND sg13cmos5l_decap_8
XFILLER_557_214 VPWR VGND sg13cmos5l_decap_8
X_3994_ _3994_/X _3896_/X _4029_/X _4028_/X Tile_X0Y0_S2MID[4] _1193_/Q _1192_/Q VPWR
+ VGND sg13cmos5l_mux4_1
XFILLER_200_42 VPWR VGND sg13cmos5l_decap_8
XFILLER_222_176 VPWR VGND sg13cmos5l_decap_8
XFILLER_95_0 VPWR VGND sg13cmos5l_decap_8
X_2945_ Tile_X0Y8_EE4BEG[1] _4745_/X VPWR VGND sg13cmos5l_buf_1
XFILLER_572_217 VPWR VGND sg13cmos5l_decap_8
XFILLER_557_56 VPWR VGND sg13cmos5l_decap_8
XFILLER_714_200 VPWR VGND sg13cmos5l_decap_8
XFILLER_525_100 VPWR VGND sg13cmos5l_decap_8
XFILLER_376_180 VPWR VGND sg13cmos5l_decap_8
X_2876_ Tile_X0Y6_EE4BEG[13] _4525_/X VPWR VGND sg13cmos5l_buf_1
XFILLER_276_35 VPWR VGND sg13cmos5l_decap_8
XFILLER_175_264 VPWR VGND sg13cmos5l_decap_8
X_1827_ _1827_/Q Tile_X0Y3_FrameData[6] VGND VPWR Tile_X0Y9_FrameStrobe[4] latch
X_4615_ _4615_/X Tile_X0Y7_W2MID[4] AXI_M_SOC_RDATA19 _4675_/X _4674_/X _0329_/Q _0328_/Q
+ VPWR VGND sg13cmos5l_mux4_1
XFILLER_391_161 VPWR VGND sg13cmos5l_decap_8
XFILLER_190_223 VPWR VGND sg13cmos5l_decap_4
XFILLER_525_177 VPWR VGND sg13cmos5l_decap_8
XFILLER_525_188 VPWR VGND sg13cmos5l_fill_1
XFILLER_391_183 VPWR VGND sg13cmos5l_decap_4
XFILLER_324_228 VPWR VGND sg13cmos5l_decap_8
X_4546_ _4546_/X Tile_X0Y5_W1END[1] Tile_X0Y5_W6END[9] _4464_/X _4419_/X _2401_/Q
+ _2400_/Q VPWR VGND sg13cmos5l_mux4_1
XFILLER_540_125 VPWR VGND sg13cmos5l_decap_8
XFILLER_190_256 VPWR VGND sg13cmos5l_decap_8
X_1758_ _1758_/Q Tile_X0Y3_FrameData[11] VGND VPWR Tile_X0Y9_FrameStrobe[2] latch
XFILLER_209_84 VPWR VGND sg13cmos5l_decap_8
XFILLER_426_49 VPWR VGND sg13cmos5l_decap_8
XFILLER_150_109 VPWR VGND sg13cmos5l_decap_8
XFILLER_573_77 VPWR VGND sg13cmos5l_decap_8
XFILLER_145_28 VPWR VGND sg13cmos5l_decap_8
X_0709_ _0709_/Q Tile_X0Y9_FrameData[26] VGND VPWR Tile_X0Y9_FrameStrobe[1] latch
X_4477_ _4477_/X Tile_X0Y7_W2MID[3] Tile_X0Y7_W2END[3] Tile_X0Y7_W6END[3] _4674_/X
+ _0399_/Q _0398_/Q VPWR VGND sg13cmos5l_mux4_1
XANTENNA__3534__X Tile_X0Y9_E2BEGb[0] VPWR VGND sg13cmos5l_antennanp
X_1689_ _1689_/Q Tile_X0Y3_FrameData[16] VGND VPWR Tile_X0Y9_FrameStrobe[0] latch
XFILLER_292_56 VPWR VGND sg13cmos5l_decap_8
XFILLER_694_151 VPWR VGND sg13cmos5l_decap_4
XFILLER_493_202 VPWR VGND sg13cmos5l_decap_8
X_3428_ Tile_X0Y4_FrameData_O[19] Tile_X0Y4_FrameData[19] VPWR VGND sg13cmos5l_buf_1
XFILLER_289_198 VPWR VGND sg13cmos5l_decap_8
XFILLER_694_184 VPWR VGND sg13cmos5l_decap_8
XFILLER_442_15 VPWR VGND sg13cmos5l_decap_8
XFILLER_493_257 VPWR VGND sg13cmos5l_fill_1
X_3359_ Tile_X0Y2_FrameData_O[30] Tile_X0Y2_FrameData[30] VPWR VGND sg13cmos5l_buf_1
XFILLER_635_240 VPWR VGND sg13cmos5l_fill_1
XFILLER_245_202 VPWR VGND sg13cmos5l_decap_8
XFILLER_300_191 VPWR VGND sg13cmos5l_decap_8
XFILLER_650_210 VPWR VGND sg13cmos5l_decap_8
XFILLER_173_7 VPWR VGND sg13cmos5l_decap_8
XFILLER_650_243 VPWR VGND sg13cmos5l_decap_8
XFILLER_598_63 VPWR VGND sg13cmos5l_decap_8
XFILLER_241_93 VPWR VGND sg13cmos5l_decap_4
XFILLER_399_272 VPWR VGND sg13cmos5l_fill_1
XFILLER_598_85 VPWR VGND sg13cmos5l_decap_4
XFILLER_54_69 VPWR VGND sg13cmos5l_decap_8
XFILLER_340_7 VPWR VGND sg13cmos5l_decap_8
XFILLER_438_7 VPWR VGND sg13cmos5l_decap_8
XFILLER_402_254 VPWR VGND sg13cmos5l_decap_8
XFILLER_13_237 VPWR VGND sg13cmos5l_decap_8
XFILLER_213_165 VPWR VGND sg13cmos5l_decap_8
XFILLER_158_209 VPWR VGND sg13cmos5l_decap_8
XFILLER_13_259 VPWR VGND sg13cmos5l_fill_1
XFILLER_374_106 VPWR VGND sg13cmos5l_fill_2
XANTENNA__3709__X AXI_M_SOC_WDATA19 VPWR VGND sg13cmos5l_antennanp
XFILLER_110_97 VPWR VGND sg13cmos5l_decap_8
XFILLER_166_220 VPWR VGND sg13cmos5l_decap_8
XFILLER_705_200 VPWR VGND sg13cmos5l_decap_8
XFILLER_605_7 VPWR VGND sg13cmos5l_decap_8
XFILLER_70_57 VPWR VGND sg13cmos5l_decap_8
XFILLER_367_191 VPWR VGND sg13cmos5l_decap_8
XFILLER_516_133 VPWR VGND sg13cmos5l_decap_8
XFILLER_571_272 VPWR VGND sg13cmos5l_fill_1
XFILLER_181_234 VPWR VGND sg13cmos5l_decap_8
XFILLER_483_22 VPWR VGND sg13cmos5l_decap_8
XFILLER_336_49 VPWR VGND sg13cmos5l_decap_8
XFILLER_633_14 VPWR VGND sg13cmos5l_decap_8
XFILLER_79_77 VPWR VGND sg13cmos5l_decap_8
XANTENNA__3444__X Tile_X0Y1_FrameData_O[2] VPWR VGND sg13cmos5l_antennanp
XFILLER_469_265 VPWR VGND sg13cmos5l_decap_8
XFILLER_618_207 VPWR VGND sg13cmos5l_fill_2
XFILLER_484_202 VPWR VGND sg13cmos5l_decap_8
XFILLER_95_21 VPWR VGND sg13cmos5l_decap_8
XFILLER_297_0 VPWR VGND sg13cmos5l_decap_4
XFILLER_95_229 VPWR VGND sg13cmos5l_decap_8
XFILLER_295_168 VPWR VGND sg13cmos5l_decap_8
XFILLER_0_174 VPWR VGND sg13cmos5l_fill_2
XFILLER_437_140 VPWR VGND sg13cmos5l_decap_8
XFILLER_437_184 VPWR VGND sg13cmos5l_decap_8
XFILLER_95_98 VPWR VGND sg13cmos5l_decap_8
XFILLER_641_210 VPWR VGND sg13cmos5l_decap_8
XFILLER_432_70 VPWR VGND sg13cmos5l_decap_8
XFILLER_464_0 VPWR VGND sg13cmos5l_decap_8
XFILLER_452_121 VPWR VGND sg13cmos5l_decap_8
XFILLER_63_104 VPWR VGND sg13cmos5l_decap_8
XFILLER_48_178 VPWR VGND sg13cmos5l_decap_8
XFILLER_251_205 VPWR VGND sg13cmos5l_decap_8
XFILLER_601_118 VPWR VGND sg13cmos5l_decap_8
XFILLER_452_198 VPWR VGND sg13cmos5l_fill_2
XFILLER_631_0 VPWR VGND sg13cmos5l_decap_8
XFILLER_658_77 VPWR VGND sg13cmos5l_decap_8
XFILLER_554_206 VPWR VGND sg13cmos5l_fill_1
X_0991_ _0991_/Q Tile_X0Y0_FrameData[12] VGND VPWR Tile_X0Y9_FrameStrobe[1] latch
XANTENNA__3619__X Tile_X0Y9_S2BEGb[5] VPWR VGND sg13cmos5l_antennanp
XFILLER_157_220 VPWR VGND sg13cmos5l_decap_8
XFILLER_554_228 VPWR VGND sg13cmos5l_decap_4
X_2730_ _3860_/A3 VPWR VGND sg13cmos5l_tielo
XFILLER_674_21 VPWR VGND sg13cmos5l_decap_8
X_2661_ _2661_/Q Tile_X0Y6_FrameData[2] VGND VPWR Tile_X0Y9_FrameStrobe[6] latch
XFILLER_306_217 VPWR VGND sg13cmos5l_fill_2
X_4400_ _4400_/X Tile_X0Y5_WW4END[3] AXI_M_SOC_RRESP1 _4454_/X _4434_/X _2303_/Q _2302_/Q
+ VPWR VGND sg13cmos5l_mux4_1
XFILLER_60_90 VPWR VGND sg13cmos5l_decap_8
XFILLER_507_188 VPWR VGND sg13cmos5l_decap_8
XFILLER_393_22 VPWR VGND sg13cmos5l_decap_8
XFILLER_373_183 VPWR VGND sg13cmos5l_decap_8
X_1612_ _1612_/Q Tile_X0Y2_FrameData[5] VGND VPWR Tile_X0Y9_FrameStrobe[5] latch
X_2592_ _2592_/Q Tile_X0Y6_FrameData[7] VGND VPWR Tile_X0Y9_FrameStrobe[4] latch
XFILLER_711_236 VPWR VGND sg13cmos5l_decap_8
XFILLER_674_98 VPWR VGND sg13cmos5l_decap_8
X_4331_ _4331_/X _4806_/X _4810_/X _4814_/X _4789_/X _0641_/Q _0640_/Q VPWR VGND sg13cmos5l_mux4_1
X_1543_ _1543_/Q Tile_X0Y2_FrameData[10] VGND VPWR Tile_X0Y9_FrameStrobe[3] latch
XFILLER_607_92 VPWR VGND sg13cmos5l_fill_1
XFILLER_543_14 VPWR VGND sg13cmos5l_decap_8
XFILLER_314_261 VPWR VGND sg13cmos5l_fill_1
XFILLER_5_63 VPWR VGND sg13cmos5l_decap_8
XANTENNA__3354__X Tile_X0Y2_FrameData_O[25] VPWR VGND sg13cmos5l_antennanp
XFILLER_125_183 VPWR VGND sg13cmos5l_decap_8
XFILLER_690_42 VPWR VGND sg13cmos5l_decap_8
X_4262_ _4262_/X Tile_X0Y4_W2MID[1] AXI_M_SOC_BRESP0 _4315_/X _4314_/X _2089_/Q _2088_/Q
+ VPWR VGND sg13cmos5l_mux4_1
X_1474_ _1474_/Q Tile_X0Y2_FrameData[15] VGND VPWR Tile_X0Y9_FrameStrobe[1] latch
XFILLER_609_229 VPWR VGND sg13cmos5l_decap_8
XFILLER_676_184 VPWR VGND sg13cmos5l_decap_8
X_3213_ Tile_X0Y0_FrameStrobe_O[1] Tile_X0Y9_FrameStrobe[1] VPWR VGND sg13cmos5l_buf_1
XFILLER_140_175 VPWR VGND sg13cmos5l_decap_8
X_0425_ _0425_/Q Tile_X0Y8_FrameData[22] VGND VPWR Tile_X0Y9_FrameStrobe[0] latch
X_4193_ _4193_/X _4203_/X Tile_X0Y3_W6END[3] _4202_/X _4193_/A3 _1675_/Q _1926_/Q
+ VPWR VGND sg13cmos5l_mux4_1
XFILLER_286_168 VPWR VGND sg13cmos5l_decap_8
XFILLER_428_140 VPWR VGND sg13cmos5l_decap_8
XFILLER_623_91 VPWR VGND sg13cmos5l_decap_8
X_3144_ Tile_X0Y7_FrameData_O[14] Tile_X0Y7_FrameData[14] VPWR VGND sg13cmos5l_buf_1
XFILLER_490_227 VPWR VGND sg13cmos5l_decap_8
XFILLER_10_0 VPWR VGND sg13cmos5l_decap_8
X_0356_ _0356_/Q Tile_X0Y7_FrameData[27] VGND VPWR Tile_X0Y9_FrameStrobe[6] latch
XFILLER_412_29 VPWR VGND sg13cmos5l_decap_8
XFILLER_691_198 VPWR VGND sg13cmos5l_decap_8
XFILLER_589_125 VPWR VGND sg13cmos5l_decap_4
XFILLER_227_268 VPWR VGND sg13cmos5l_decap_4
X_3075_ Tile_X0Y4_E2BEGb[1] _4265_/X VPWR VGND sg13cmos5l_buf_1
X_0287_ _0287_/Q Tile_X0Y7_FrameData[0] VGND VPWR Tile_X0Y9_FrameStrobe[3] latch
XFILLER_589_147 VPWR VGND sg13cmos5l_fill_1
XFILLER_589_158 VPWR VGND sg13cmos5l_decap_8
X_2026_ _2026_/Q Tile_X0Y4_FrameData[27] VGND VPWR Tile_X0Y9_FrameStrobe[3] latch
XFILLER_211_63 VPWR VGND sg13cmos5l_decap_8
XFILLER_396_220 VPWR VGND sg13cmos5l_decap_8
XFILLER_24_28 VPWR VGND sg13cmos5l_decap_8
XFILLER_396_264 VPWR VGND sg13cmos5l_decap_8
XFILLER_568_77 VPWR VGND sg13cmos5l_decap_8
X_3977_ _3977_/X _3983_/X Tile_X0Y1_W6END[1] _3982_/X _3977_/A3 _1183_/Q _1182_/Q
+ VPWR VGND sg13cmos5l_mux4_1
XANTENNA__3529__X Tile_X0Y9_E2BEG[3] VPWR VGND sg13cmos5l_antennanp
XFILLER_287_56 VPWR VGND sg13cmos5l_decap_8
XFILLER_210_168 VPWR VGND sg13cmos5l_decap_8
X_2928_ Tile_X0Y8_E2BEGb[4] _4740_/X VPWR VGND sg13cmos5l_buf_1
XFILLER_584_21 VPWR VGND sg13cmos5l_decap_8
XFILLER_40_27 VPWR VGND sg13cmos5l_decap_8
X_2859_ Tile_X0Y6_E6BEG[8] _4536_/X VPWR VGND sg13cmos5l_buf_1
XFILLER_553_272 VPWR VGND sg13cmos5l_fill_1
XFILLER_702_203 VPWR VGND sg13cmos5l_fill_2
XFILLER_163_256 VPWR VGND sg13cmos5l_fill_2
XFILLER_584_98 VPWR VGND sg13cmos5l_decap_8
XFILLER_123_109 VPWR VGND sg13cmos5l_fill_2
XFILLER_517_70 VPWR VGND sg13cmos5l_decap_4
XFILLER_513_158 VPWR VGND sg13cmos5l_decap_8
XFILLER_116_150 VPWR VGND sg13cmos5l_fill_1
X_4529_ _4529_/X Tile_X0Y9_N4END[13] _0153_/X _4578_/X _4582_/X _2549_/Q _2548_/Q
+ VPWR VGND sg13cmos5l_mux4_1
XFILLER_453_14 VPWR VGND sg13cmos5l_decap_8
XFILLER_305_261 VPWR VGND sg13cmos5l_decap_4
XANTENNA__3264__X Tile_X0Y0_EE4BEG[0] VPWR VGND sg13cmos5l_antennanp
XFILLER_305_272 VPWR VGND sg13cmos5l_fill_1
XFILLER_667_184 VPWR VGND sg13cmos5l_decap_8
XFILLER_77_207 VPWR VGND sg13cmos5l_decap_4
XFILLER_395_8 VPWR VGND sg13cmos5l_decap_8
XFILLER_320_264 VPWR VGND sg13cmos5l_decap_8
XFILLER_466_257 VPWR VGND sg13cmos5l_decap_8
XFILLER_603_28 VPWR VGND sg13cmos5l_decap_8
XFILLER_682_154 VPWR VGND sg13cmos5l_decap_8
XFILLER_388_7 VPWR VGND sg13cmos5l_decap_8
XFILLER_292_105 VPWR VGND sg13cmos5l_fill_2
XFILLER_419_151 VPWR VGND sg13cmos5l_decap_8
XFILLER_105_42 VPWR VGND sg13cmos5l_decap_8
XFILLER_481_216 VPWR VGND sg13cmos5l_decap_8
XFILLER_252_70 VPWR VGND sg13cmos5l_decap_4
XFILLER_65_35 VPWR VGND sg13cmos5l_decap_8
XFILLER_45_104 VPWR VGND sg13cmos5l_decap_8
XFILLER_218_268 VPWR VGND sg13cmos5l_decap_4
XFILLER_434_143 VPWR VGND sg13cmos5l_decap_8
XANTENNA_103 _0157_/X VPWR VGND sg13cmos5l_antennanp
XANTENNA_114 _0157_/X VPWR VGND sg13cmos5l_antennanp
XANTENNA_125 Tile_X0Y6_FrameData[31] VPWR VGND sg13cmos5l_antennanp
XFILLER_233_238 VPWR VGND sg13cmos5l_decap_4
XFILLER_402_84 VPWR VGND sg13cmos5l_decap_8
XANTENNA_136 Tile_X0Y6_FrameData[31] VPWR VGND sg13cmos5l_antennanp
XANTENNA_147 Tile_X0Y9_FrameStrobe[11] VPWR VGND sg13cmos5l_antennanp
XANTENNA_158 Tile_X0Y9_FrameStrobe[8] VPWR VGND sg13cmos5l_antennanp
XANTENNA_169 Tile_X0Y9_FrameStrobe[8] VPWR VGND sg13cmos5l_antennanp
XFILLER_121_63 VPWR VGND sg13cmos5l_decap_8
XFILLER_387_231 VPWR VGND sg13cmos5l_fill_2
XFILLER_198_186 VPWR VGND sg13cmos5l_fill_1
XFILLER_201_124 VPWR VGND sg13cmos5l_decap_8
XFILLER_201_135 VPWR VGND sg13cmos5l_fill_2
XANTENNA__3439__X Tile_X0Y4_FrameData_O[30] VPWR VGND sg13cmos5l_antennanp
XFILLER_81_89 VPWR VGND sg13cmos5l_decap_8
XFILLER_628_36 VPWR VGND sg13cmos5l_decap_8
XFILLER_139_231 VPWR VGND sg13cmos5l_fill_1
XFILLER_201_179 VPWR VGND sg13cmos5l_decap_8
XFILLER_494_21 VPWR VGND sg13cmos5l_decap_8
XFILLER_355_161 VPWR VGND sg13cmos5l_decap_8
XFILLER_212_0 VPWR VGND sg13cmos5l_decap_8
XFILLER_708_91 VPWR VGND sg13cmos5l_decap_8
XFILLER_494_98 VPWR VGND sg13cmos5l_decap_8
XFILLER_370_131 VPWR VGND sg13cmos5l_decap_4
XFILLER_154_267 VPWR VGND sg13cmos5l_decap_4
XFILLER_644_35 VPWR VGND sg13cmos5l_decap_8
XFILLER_427_70 VPWR VGND sg13cmos5l_decap_8
XFILLER_504_158 VPWR VGND sg13cmos5l_decap_8
XFILLER_370_164 VPWR VGND sg13cmos5l_decap_8
XANTENNA__3174__X Tile_X0Y4_E6BEG[11] VPWR VGND sg13cmos5l_antennanp
XFILLER_363_36 VPWR VGND sg13cmos5l_decap_8
XFILLER_311_220 VPWR VGND sg13cmos5l_decap_8
XFILLER_122_153 VPWR VGND sg13cmos5l_decap_4
XFILLER_581_0 VPWR VGND sg13cmos5l_decap_8
XFILLER_39_8 VPWR VGND sg13cmos5l_fill_1
XFILLER_122_175 VPWR VGND sg13cmos5l_decap_8
XFILLER_679_0 VPWR VGND sg13cmos5l_decap_8
XFILLER_513_28 VPWR VGND sg13cmos5l_decap_8
XFILLER_457_257 VPWR VGND sg13cmos5l_fill_2
XFILLER_268_168 VPWR VGND sg13cmos5l_decap_8
XFILLER_457_268 VPWR VGND sg13cmos5l_decap_4
XFILLER_283_105 VPWR VGND sg13cmos5l_decap_8
XFILLER_660_56 VPWR VGND sg13cmos5l_decap_8
XFILLER_443_91 VPWR VGND sg13cmos5l_decap_8
X_0210_ _0210_/Q Tile_X0Y7_FrameData[13] VGND VPWR Tile_X0Y9_FrameStrobe[1] latch
X_1190_ _1190_/Q Tile_X0Y1_FrameData[19] VGND VPWR Tile_X0Y9_FrameStrobe[0] latch
XFILLER_232_29 VPWR VGND sg13cmos5l_decap_8
X_0141_ AXI_M_SOC_ARLEN1 _0933_/Q _3761_/X VPWR VGND sg13cmos5l_nor2b_1
XFILLER_425_154 VPWR VGND sg13cmos5l_decap_8
XFILLER_91_221 VPWR VGND sg13cmos5l_decap_4
XFILLER_91_232 VPWR VGND sg13cmos5l_decap_8
XFILLER_669_21 VPWR VGND sg13cmos5l_decap_8
X_0072_ AXI_M_SOC_AWCACHE3 _0936_/Q _3688_/X VPWR VGND sg13cmos5l_nor2b_1
XFILLER_55_90 VPWR VGND sg13cmos5l_decap_8
X_3900_ _3900_/X Tile_X0Y2_W2MID[1] Tile_X0Y2_W2END[1] Tile_X0Y2_W6END[1] _4098_/X
+ _1653_/Q _1652_/Q VPWR VGND sg13cmos5l_mux4_1
X_4880_ _4880_/X Tile_X0Y9_N4END[0] _0083_/X _4927_/X _4931_/X _0783_/Q _0782_/Q VPWR
+ VGND sg13cmos5l_mux4_1
XFILLER_388_44 VPWR VGND sg13cmos5l_fill_2
XFILLER_232_271 VPWR VGND sg13cmos5l_fill_2
X_3831_ _3831_/X Tile_X0Y0_WW4END[4] Tile_X0Y0_WW4END[11] _3885_/X _3858_/X _1043_/Q
+ _1042_/Q VPWR VGND sg13cmos5l_mux4_1
XFILLER_538_14 VPWR VGND sg13cmos5l_decap_8
XANTENNA__3349__X Tile_X0Y2_FrameData_O[20] VPWR VGND sg13cmos5l_antennanp
XFILLER_338_128 VPWR VGND sg13cmos5l_fill_1
XFILLER_527_239 VPWR VGND sg13cmos5l_decap_4
X_3762_ _3762_/X Tile_X0Y1_WW4END[3] Tile_X0Y1_WW4END[11] Tile_X0Y1_W6END[3] _4011_/X
+ _1251_/Q _1250_/Q VPWR VGND sg13cmos5l_mux4_1
X_0974_ _0974_/Q Tile_X0Y0_FrameData[29] VGND VPWR Tile_X0Y9_FrameStrobe[1] latch
X_2713_ _4542_/A3 VPWR VGND sg13cmos5l_tielo
X_3693_ AXI_M_SOC_WDATA3 Tile_X0Y7_WW4END[3] Tile_X0Y7_WW4END[11] Tile_X0Y7_W6END[3]
+ _4687_/X _0241_/Q _0240_/Q VPWR VGND sg13cmos5l_mux4_1
XFILLER_618_91 VPWR VGND sg13cmos5l_decap_8
X_2644_ _2644_/Q Tile_X0Y6_FrameData[19] VGND VPWR Tile_X0Y9_FrameStrobe[6] latch
XFILLER_554_35 VPWR VGND sg13cmos5l_decap_8
XFILLER_361_142 VPWR VGND sg13cmos5l_decap_8
XFILLER_696_235 VPWR VGND sg13cmos5l_decap_8
XFILLER_58_0 VPWR VGND sg13cmos5l_fill_2
XFILLER_696_257 VPWR VGND sg13cmos5l_decap_8
XFILLER_273_14 VPWR VGND sg13cmos5l_decap_8
X_2575_ _2575_/Q Tile_X0Y6_FrameData[24] VGND VPWR Tile_X0Y9_FrameStrobe[4] latch
XANTENNA__3084__X Tile_X0Y7_E1BEG[2] VPWR VGND sg13cmos5l_antennanp
XFILLER_160_237 VPWR VGND sg13cmos5l_decap_8
XFILLER_160_248 VPWR VGND sg13cmos5l_fill_1
XFILLER_113_120 VPWR VGND sg13cmos5l_decap_8
XFILLER_302_220 VPWR VGND sg13cmos5l_decap_8
X_1526_ _1526_/Q Tile_X0Y2_FrameData[27] VGND VPWR Tile_X0Y9_FrameStrobe[3] latch
X_4314_ _4314_/X _4249_/X _4365_/X _4364_/X _4248_/X _1937_/Q _1936_/Q VPWR VGND sg13cmos5l_mux4_1
XFILLER_503_191 VPWR VGND sg13cmos5l_fill_1
XFILLER_704_49 VPWR VGND sg13cmos5l_decap_8
XFILLER_59_207 VPWR VGND sg13cmos5l_decap_8
XFILLER_259_135 VPWR VGND sg13cmos5l_decap_8
XFILLER_302_264 VPWR VGND sg13cmos5l_fill_1
X_4245_ _4245_/X Tile_X0Y5_W2MID[3] Tile_X0Y5_W2END[3] Tile_X0Y5_W6END[3] _4433_/X
+ _2423_/Q _2422_/Q VPWR VGND sg13cmos5l_mux4_1
XFILLER_448_257 VPWR VGND sg13cmos5l_fill_2
XFILLER_423_28 VPWR VGND sg13cmos5l_decap_8
XFILLER_206_63 VPWR VGND sg13cmos5l_decap_8
X_1457_ _1457_/Q Tile_X0Y2_FrameData[0] VGND VPWR Tile_X0Y9_FrameStrobe[0] latch
XFILLER_19_28 VPWR VGND sg13cmos5l_decap_8
XFILLER_570_56 VPWR VGND sg13cmos5l_decap_8
XFILLER_463_205 VPWR VGND sg13cmos5l_decap_8
XFILLER_353_91 VPWR VGND sg13cmos5l_decap_8
X_0408_ _0408_/Q Tile_X0Y7_FrameData[7] VGND VPWR Tile_X0Y9_FrameStrobe[7] latch
X_4176_ _4176_/X Tile_X0Y3_WW4END[3] AXI_M_SOC_BVALID _4225_/X _4211_/X _1789_/Q _1788_/Q
+ VPWR VGND sg13cmos5l_mux4_1
XFILLER_274_138 VPWR VGND sg13cmos5l_decap_8
X_1388_ _1388_/Q Tile_X0Y1_FrameData[13] VGND VPWR Tile_X0Y9_FrameStrobe[6] latch
XFILLER_664_198 VPWR VGND sg13cmos5l_decap_8
X_3127_ Tile_X0Y7_EE4BEG[13] _4641_/X VPWR VGND sg13cmos5l_buf_1
X_0339_ _0339_/Q Tile_X0Y7_FrameData[12] VGND VPWR Tile_X0Y9_FrameStrobe[5] latch
XFILLER_82_221 VPWR VGND sg13cmos5l_fill_1
XFILLER_605_265 VPWR VGND sg13cmos5l_decap_8
XFILLER_579_21 VPWR VGND sg13cmos5l_decap_8
XFILLER_471_271 VPWR VGND sg13cmos5l_fill_2
XFILLER_416_176 VPWR VGND sg13cmos5l_decap_8
XFILLER_282_182 VPWR VGND sg13cmos5l_decap_8
X_3058_ Tile_X0Y5_FrameData_O[17] Tile_X0Y5_FrameData[17] VPWR VGND sg13cmos5l_buf_1
XFILLER_222_95 VPWR VGND sg13cmos5l_decap_4
XFILLER_35_38 VPWR VGND sg13cmos5l_decap_4
X_2009_ _2009_/Q Tile_X0Y4_FrameData[12] VGND VPWR Tile_X0Y9_FrameStrobe[2] latch
XFILLER_42_129 VPWR VGND sg13cmos5l_fill_2
XFILLER_579_98 VPWR VGND sg13cmos5l_decap_8
XFILLER_431_168 VPWR VGND sg13cmos5l_decap_8
XFILLER_592_109 VPWR VGND sg13cmos5l_decap_4
XFILLER_448_14 VPWR VGND sg13cmos5l_decap_8
XFILLER_195_123 VPWR VGND sg13cmos5l_decap_8
XANTENNA__3259__X Tile_X0Y0_FrameData_O[27] VPWR VGND sg13cmos5l_antennanp
XFILLER_595_42 VPWR VGND sg13cmos5l_decap_8
XFILLER_136_7 VPWR VGND sg13cmos5l_decap_8
XFILLER_50_195 VPWR VGND sg13cmos5l_decap_4
XFILLER_595_97 VPWR VGND sg13cmos5l_decap_4
XFILLER_310_8 VPWR VGND sg13cmos5l_decap_8
XFILLER_136_256 VPWR VGND sg13cmos5l_fill_1
XFILLER_464_35 VPWR VGND sg13cmos5l_decap_8
XFILLER_247_70 VPWR VGND sg13cmos5l_decap_8
XFILLER_352_175 VPWR VGND sg13cmos5l_decap_8
XFILLER_183_14 VPWR VGND sg13cmos5l_decap_4
XFILLER_498_168 VPWR VGND sg13cmos5l_decap_8
XFILLER_687_268 VPWR VGND sg13cmos5l_decap_4
XFILLER_104_120 VPWR VGND sg13cmos5l_decap_8
XFILLER_2_258 VPWR VGND sg13cmos5l_decap_4
XFILLER_183_69 VPWR VGND sg13cmos5l_decap_8
XFILLER_655_110 VPWR VGND sg13cmos5l_fill_2
XFILLER_614_49 VPWR VGND sg13cmos5l_decap_8
XFILLER_439_224 VPWR VGND sg13cmos5l_decap_8
XFILLER_104_153 VPWR VGND sg13cmos5l_decap_8
XANTENNA__0130__Y AXI_M_SOC_AWSIZE0 VPWR VGND sg13cmos5l_antennanp
XFILLER_116_63 VPWR VGND sg13cmos5l_decap_8
XFILLER_672_7 VPWR VGND sg13cmos5l_decap_8
XFILLER_265_105 VPWR VGND sg13cmos5l_decap_8
XFILLER_480_56 VPWR VGND sg13cmos5l_decap_8
XFILLER_655_165 VPWR VGND sg13cmos5l_decap_4
XFILLER_655_176 VPWR VGND sg13cmos5l_decap_8
XFILLER_265_127 VPWR VGND sg13cmos5l_decap_8
XFILLER_76_56 VPWR VGND sg13cmos5l_decap_8
XFILLER_670_157 VPWR VGND sg13cmos5l_decap_8
XFILLER_280_119 VPWR VGND sg13cmos5l_decap_8
XFILLER_489_21 VPWR VGND sg13cmos5l_decap_8
XFILLER_206_227 VPWR VGND sg13cmos5l_fill_1
XFILLER_611_202 VPWR VGND sg13cmos5l_decap_8
XFILLER_132_84 VPWR VGND sg13cmos5l_decap_8
XFILLER_206_249 VPWR VGND sg13cmos5l_decap_8
XFILLER_710_70 VPWR VGND sg13cmos5l_decap_8
XFILLER_162_0 VPWR VGND sg13cmos5l_decap_8
XFILLER_92_77 VPWR VGND sg13cmos5l_decap_4
XFILLER_489_98 VPWR VGND sg13cmos5l_fill_2
XFILLER_422_168 VPWR VGND sg13cmos5l_decap_4
XFILLER_92_88 VPWR VGND sg13cmos5l_decap_8
XFILLER_214_271 VPWR VGND sg13cmos5l_fill_2
XFILLER_639_35 VPWR VGND sg13cmos5l_decap_8
XFILLER_41_140 VPWR VGND sg13cmos5l_fill_2
XFILLER_358_14 VPWR VGND sg13cmos5l_decap_8
XFILLER_186_123 VPWR VGND sg13cmos5l_decap_8
XFILLER_375_212 VPWR VGND sg13cmos5l_decap_8
XANTENNA__3169__X Tile_X0Y4_E6BEG[6] VPWR VGND sg13cmos5l_antennanp
XFILLER_427_0 VPWR VGND sg13cmos5l_decap_8
XFILLER_576_194 VPWR VGND sg13cmos5l_decap_8
XFILLER_517_261 VPWR VGND sg13cmos5l_fill_1
XFILLER_508_28 VPWR VGND sg13cmos5l_decap_8
XFILLER_517_272 VPWR VGND sg13cmos5l_fill_1
XFILLER_591_197 VPWR VGND sg13cmos5l_fill_1
XFILLER_438_91 VPWR VGND sg13cmos5l_decap_4
XANTENNA__2801__X Tile_X0Y3_E6BEG[11] VPWR VGND sg13cmos5l_antennanp
XFILLER_655_78 VPWR VGND sg13cmos5l_decap_8
XFILLER_532_231 VPWR VGND sg13cmos5l_decap_8
XFILLER_227_29 VPWR VGND sg13cmos5l_decap_8
X_0690_ _0690_/Q Tile_X0Y9_FrameData[13] VGND VPWR Tile_X0Y9_FrameStrobe[0] latch
XFILLER_678_224 VPWR VGND sg13cmos5l_decap_8
XFILLER_374_46 VPWR VGND sg13cmos5l_decap_8
XFILLER_157_92 VPWR VGND sg13cmos5l_decap_8
XFILLER_142_237 VPWR VGND sg13cmos5l_decap_8
XFILLER_343_186 VPWR VGND sg13cmos5l_decap_8
XFILLER_693_216 VPWR VGND sg13cmos5l_decap_4
X_2360_ _2360_/Q Tile_X0Y5_FrameData[13] VGND VPWR Tile_X0Y9_FrameStrobe[5] latch
XFILLER_524_49 VPWR VGND sg13cmos5l_fill_2
XFILLER_296_241 VPWR VGND sg13cmos5l_decap_8
X_1311_ _1311_/Q Tile_X0Y1_FrameData[26] VGND VPWR Tile_X0Y9_FrameStrobe[4] latch
XFILLER_243_28 VPWR VGND sg13cmos5l_decap_8
X_2291_ _2291_/Q Tile_X0Y5_FrameData[18] VGND VPWR Tile_X0Y9_FrameStrobe[3] latch
XFILLER_500_161 VPWR VGND sg13cmos5l_decap_8
XANTENNA__3632__X Tile_X0Y9_S4BEG[10] VPWR VGND sg13cmos5l_antennanp
XFILLER_671_99 VPWR VGND sg13cmos5l_decap_8
XFILLER_646_154 VPWR VGND sg13cmos5l_decap_8
XFILLER_445_205 VPWR VGND sg13cmos5l_decap_4
XFILLER_256_105 VPWR VGND sg13cmos5l_decap_8
X_4030_ _4030_/X Tile_X0Y0_W1END[1] Tile_X0Y0_W2MID[2] Tile_X0Y0_W2END[2] _3856_/X
+ _1123_/Q _1122_/Q VPWR VGND sg13cmos5l_mux4_1
X_1242_ _1242_/Q Tile_X0Y1_FrameData[31] VGND VPWR Tile_X0Y9_FrameStrobe[2] latch
XFILLER_390_78 VPWR VGND sg13cmos5l_decap_8
XFILLER_2_42 VPWR VGND sg13cmos5l_decap_8
XFILLER_110_189 VPWR VGND sg13cmos5l_decap_8
XFILLER_661_146 VPWR VGND sg13cmos5l_fill_1
XFILLER_64_210 VPWR VGND sg13cmos5l_decap_8
X_1173_ _1173_/Q Tile_X0Y0_FrameData[22] VGND VPWR Tile_X0Y9_FrameStrobe[7] latch
XFILLER_399_21 VPWR VGND sg13cmos5l_decap_8
XFILLER_602_202 VPWR VGND sg13cmos5l_fill_1
X_0124_ AXI_M_SOC_ARSIZE1 _0932_/Q _3769_/X VPWR VGND sg13cmos5l_or2_1
XFILLER_620_70 VPWR VGND sg13cmos5l_decap_8
XFILLER_24_107 VPWR VGND sg13cmos5l_decap_8
XFILLER_620_81 VPWR VGND sg13cmos5l_fill_1
X_0055_ _0055_/X _4678_/X _4679_/X _1860_/Q VPWR VGND sg13cmos5l_mux2_1
X_4932_ _4932_/X Tile_X0Y8_W2MID[7] Tile_X0Y8_W2END[7] Tile_X0Y8_W6END[8] _4785_/X
+ _0627_/Q _0626_/Q VPWR VGND sg13cmos5l_mux4_1
XFILLER_413_168 VPWR VGND sg13cmos5l_decap_8
XFILLER_549_35 VPWR VGND sg13cmos5l_decap_8
XFILLER_696_63 VPWR VGND sg13cmos5l_decap_8
X_4863_ _4863_/X Tile_X0Y9_W2END[0] AXI_M_SOC_RDATA0 _4901_/X _4900_/X _0817_/Q _0816_/Q
+ VPWR VGND sg13cmos5l_mux4_1
XFILLER_567_161 VPWR VGND sg13cmos5l_decap_8
XFILLER_268_14 VPWR VGND sg13cmos5l_decap_8
XANTENNA__3079__X Tile_X0Y4_E2BEGb[5] VPWR VGND sg13cmos5l_antennanp
XANTENNA_14 AXI_M_SOC_RDATA26 VPWR VGND sg13cmos5l_antennanp
XFILLER_177_145 VPWR VGND sg13cmos5l_decap_8
XANTENNA_25 AXI_M_SOC_RDATA26 VPWR VGND sg13cmos5l_antennanp
X_3814_ _3814_/X Tile_X0Y0_W2END[3] Tile_X0Y0_W2END[5] _3857_/X _3856_/X _1077_/Q
+ _1076_/Q VPWR VGND sg13cmos5l_mux4_1
XANTENNA_36 AXI_M_SOC_RDATA26 VPWR VGND sg13cmos5l_antennanp
X_4794_ _4794_/X Tile_X0Y4_W1END[1] Tile_X0Y4_WW4END[13] Tile_X0Y4_W6END[5] _4337_/X
+ _2118_/Q _2117_/Q VPWR VGND sg13cmos5l_mux4_1
XANTENNA_47 Tile_X0Y0_FrameData[25] VPWR VGND sg13cmos5l_antennanp
XFILLER_582_153 VPWR VGND sg13cmos5l_decap_4
XANTENNA_58 Tile_X0Y0_FrameData[25] VPWR VGND sg13cmos5l_antennanp
XFILLER_716_169 VPWR VGND sg13cmos5l_decap_8
XFILLER_582_164 VPWR VGND sg13cmos5l_decap_4
XANTENNA_69 Tile_X0Y0_S2MID[3] VPWR VGND sg13cmos5l_antennanp
X_0957_ _0957_/Q Tile_X0Y0_FrameData[14] VGND VPWR Tile_X0Y9_FrameStrobe[0] latch
X_3745_ AXI_M_SOC_ARADDR17 Tile_X0Y8_WW4END[1] Tile_X0Y8_WW4END[9] Tile_X0Y8_W6END[1]
+ _4801_/X _0501_/Q _0500_/Q VPWR VGND sg13cmos5l_mux4_1
XFILLER_418_28 VPWR VGND sg13cmos5l_decap_8
XFILLER_118_223 VPWR VGND sg13cmos5l_fill_1
XFILLER_508_272 VPWR VGND sg13cmos5l_fill_1
XFILLER_582_197 VPWR VGND sg13cmos5l_decap_8
XFILLER_565_56 VPWR VGND sg13cmos5l_decap_8
XFILLER_118_245 VPWR VGND sg13cmos5l_decap_8
XFILLER_348_91 VPWR VGND sg13cmos5l_decap_8
X_0888_ _0888_/Q Tile_X0Y9_FrameData[7] VGND VPWR Tile_X0Y9_FrameStrobe[6] latch
X_3676_ _3676_/X Tile_X0Y2_WW4END[6] Tile_X0Y2_WW4END[14] Tile_X0Y2_W6END[6] _4122_/X
+ _1493_/Q _1492_/Q VPWR VGND sg13cmos5l_mux4_1
XFILLER_284_35 VPWR VGND sg13cmos5l_decap_8
XFILLER_334_153 VPWR VGND sg13cmos5l_fill_2
X_2627_ _2627_/Q Tile_X0Y6_FrameData[4] VGND VPWR Tile_X0Y9_FrameStrobe[5] latch
XFILLER_669_268 VPWR VGND sg13cmos5l_decap_4
XFILLER_495_105 VPWR VGND sg13cmos5l_decap_8
XFILLER_133_248 VPWR VGND sg13cmos5l_decap_8
XFILLER_334_197 VPWR VGND sg13cmos5l_decap_8
XFILLER_684_227 VPWR VGND sg13cmos5l_fill_1
X_2558_ _2558_/Q Tile_X0Y6_FrameData[9] VGND VPWR Tile_X0Y9_FrameStrobe[3] latch
XFILLER_217_84 VPWR VGND sg13cmos5l_decap_8
XFILLER_637_110 VPWR VGND sg13cmos5l_decap_8
XFILLER_434_49 VPWR VGND sg13cmos5l_decap_8
XFILLER_684_249 VPWR VGND sg13cmos5l_decap_8
XFILLER_153_28 VPWR VGND sg13cmos5l_decap_8
XFILLER_99_184 VPWR VGND sg13cmos5l_decap_8
X_1509_ _1509_/Q Tile_X0Y2_FrameData[12] VGND VPWR Tile_X0Y9_FrameStrobe[2] latch
XFILLER_581_77 VPWR VGND sg13cmos5l_decap_8
XFILLER_287_252 VPWR VGND sg13cmos5l_fill_2
XFILLER_101_112 VPWR VGND sg13cmos5l_fill_2
XFILLER_153_39 VPWR VGND sg13cmos5l_fill_2
X_2489_ _2489_/Q Tile_X0Y6_FrameData[14] VGND VPWR Tile_X0Y9_FrameStrobe[1] latch
XANTENNA__3542__X Tile_X0Y9_E6BEG[0] VPWR VGND sg13cmos5l_antennanp
XFILLER_436_216 VPWR VGND sg13cmos5l_decap_8
X_4228_ _4228_/X _4200_/X _0087_/X _4199_/X Tile_X0Y0_S4END[14] _1717_/Q _1716_/Q
+ VPWR VGND sg13cmos5l_mux4_1
XFILLER_637_187 VPWR VGND sg13cmos5l_fill_1
XFILLER_247_149 VPWR VGND sg13cmos5l_decap_8
X_4159_ _4159_/X Tile_X0Y3_W2END[4] AXI_M_SOC_WREADY _4211_/X _4210_/X _1823_/Q _1822_/Q
+ VPWR VGND sg13cmos5l_mux4_1
XFILLER_652_157 VPWR VGND sg13cmos5l_decap_8
XFILLER_255_171 VPWR VGND sg13cmos5l_decap_8
XFILLER_404_124 VPWR VGND sg13cmos5l_fill_2
XFILLER_102_21 VPWR VGND sg13cmos5l_decap_8
XFILLER_530_70 VPWR VGND sg13cmos5l_decap_8
XFILLER_70_224 VPWR VGND sg13cmos5l_decap_8
XFILLER_253_7 VPWR VGND sg13cmos5l_decap_8
XFILLER_102_65 VPWR VGND sg13cmos5l_decap_8
XFILLER_62_14 VPWR VGND sg13cmos5l_decap_8
XFILLER_459_35 VPWR VGND sg13cmos5l_decap_8
XFILLER_70_268 VPWR VGND sg13cmos5l_decap_4
XFILLER_62_47 VPWR VGND sg13cmos5l_decap_8
XFILLER_23_151 VPWR VGND sg13cmos5l_decap_8
XFILLER_178_25 VPWR VGND sg13cmos5l_decap_8
XFILLER_558_183 VPWR VGND sg13cmos5l_fill_1
XFILLER_420_7 VPWR VGND sg13cmos5l_decap_8
XFILLER_168_145 VPWR VGND sg13cmos5l_decap_4
XFILLER_357_245 VPWR VGND sg13cmos5l_decap_8
XFILLER_518_7 VPWR VGND sg13cmos5l_decap_8
XFILLER_609_49 VPWR VGND sg13cmos5l_decap_8
XFILLER_168_178 VPWR VGND sg13cmos5l_decap_8
XFILLER_183_104 VPWR VGND sg13cmos5l_decap_8
XFILLER_109_201 VPWR VGND sg13cmos5l_decap_8
XFILLER_573_175 VPWR VGND sg13cmos5l_decap_8
XFILLER_328_28 VPWR VGND sg13cmos5l_fill_2
XANTENNA__3717__X AXI_M_SOC_WDATA27 VPWR VGND sg13cmos5l_antennanp
XFILLER_475_56 VPWR VGND sg13cmos5l_decap_8
XFILLER_194_35 VPWR VGND sg13cmos5l_decap_8
XFILLER_301_4 VPWR VGND sg13cmos5l_fill_1
XFILLER_124_204 VPWR VGND sg13cmos5l_fill_2
XFILLER_194_46 VPWR VGND sg13cmos5l_fill_1
XFILLER_194_68 VPWR VGND sg13cmos5l_decap_8
XFILLER_191_192 VPWR VGND sg13cmos5l_decap_8
XFILLER_11_84 VPWR VGND sg13cmos5l_decap_8
XFILLER_340_145 VPWR VGND sg13cmos5l_decap_8
XFILLER_87_22 VPWR VGND sg13cmos5l_decap_8
XFILLER_486_138 VPWR VGND sg13cmos5l_fill_2
XFILLER_344_49 VPWR VGND sg13cmos5l_decap_8
XFILLER_705_70 VPWR VGND sg13cmos5l_decap_8
XFILLER_340_178 VPWR VGND sg13cmos5l_fill_1
XFILLER_491_77 VPWR VGND sg13cmos5l_decap_8
XFILLER_278_252 VPWR VGND sg13cmos5l_decap_4
XFILLER_641_14 VPWR VGND sg13cmos5l_decap_8
XANTENNA__3452__X Tile_X0Y1_FrameData_O[10] VPWR VGND sg13cmos5l_antennanp
XFILLER_87_99 VPWR VGND sg13cmos5l_decap_8
XFILLER_238_127 VPWR VGND sg13cmos5l_decap_8
XFILLER_494_182 VPWR VGND sg13cmos5l_decap_8
XFILLER_427_238 VPWR VGND sg13cmos5l_decap_8
XFILLER_238_138 VPWR VGND sg13cmos5l_fill_1
XFILLER_377_0 VPWR VGND sg13cmos5l_decap_8
XFILLER_46_210 VPWR VGND sg13cmos5l_fill_1
XFILLER_643_168 VPWR VGND sg13cmos5l_decap_8
XFILLER_253_119 VPWR VGND sg13cmos5l_decap_8
XFILLER_46_232 VPWR VGND sg13cmos5l_decap_8
XFILLER_435_271 VPWR VGND sg13cmos5l_fill_2
XFILLER_440_70 VPWR VGND sg13cmos5l_decap_8
XFILLER_544_0 VPWR VGND sg13cmos5l_decap_8
XFILLER_450_241 VPWR VGND sg13cmos5l_decap_4
XFILLER_261_152 VPWR VGND sg13cmos5l_decap_8
XFILLER_61_246 VPWR VGND sg13cmos5l_decap_4
XFILLER_410_105 VPWR VGND sg13cmos5l_decap_8
XFILLER_61_257 VPWR VGND sg13cmos5l_fill_1
XFILLER_369_35 VPWR VGND sg13cmos5l_decap_8
XFILLER_99_7 VPWR VGND sg13cmos5l_decap_8
XFILLER_711_0 VPWR VGND sg13cmos5l_decap_8
XFILLER_549_183 VPWR VGND sg13cmos5l_decap_8
XFILLER_348_234 VPWR VGND sg13cmos5l_decap_8
XFILLER_159_145 VPWR VGND sg13cmos5l_decap_8
X_1860_ _1860_/Q Tile_X0Y3_FrameData[5] VGND VPWR Tile_X0Y9_FrameStrobe[5] latch
XFILLER_519_49 VPWR VGND sg13cmos5l_decap_8
XFILLER_564_153 VPWR VGND sg13cmos5l_decap_8
X_0811_ _0811_/Q Tile_X0Y9_FrameData[20] VGND VPWR Tile_X0Y9_FrameStrobe[4] latch
XFILLER_666_77 VPWR VGND sg13cmos5l_decap_4
XFILLER_238_28 VPWR VGND sg13cmos5l_decap_8
X_1791_ _1791_/Q Tile_X0Y3_FrameData[10] VGND VPWR Tile_X0Y9_FrameStrobe[3] latch
XFILLER_713_117 VPWR VGND sg13cmos5l_decap_8
XANTENNA__3627__X Tile_X0Y9_S4BEG[5] VPWR VGND sg13cmos5l_antennanp
XFILLER_505_220 VPWR VGND sg13cmos5l_decap_8
X_0742_ _0742_/Q Tile_X0Y9_FrameData[25] VGND VPWR Tile_X0Y9_FrameStrobe[2] latch
X_3530_ Tile_X0Y9_E2BEG[4] _4852_/X VPWR VGND sg13cmos5l_buf_1
XFILLER_682_21 VPWR VGND sg13cmos5l_decap_4
X_3461_ Tile_X0Y1_FrameData_O[19] Tile_X0Y1_FrameData[19] VPWR VGND sg13cmos5l_buf_1
XFILLER_115_237 VPWR VGND sg13cmos5l_decap_8
X_0673_ _0673_/Q Tile_X0Y9_FrameData[30] VGND VPWR Tile_X0Y9_FrameStrobe[0] latch
XFILLER_316_197 VPWR VGND sg13cmos5l_decap_8
XFILLER_682_76 VPWR VGND sg13cmos5l_fill_1
X_2412_ _2412_/Q Tile_X0Y5_FrameData[25] VGND VPWR Tile_X0Y9_FrameStrobe[7] latch
X_3392_ Tile_X0Y2_E2BEGb[3] _4051_/X VPWR VGND sg13cmos5l_buf_1
XFILLER_682_98 VPWR VGND sg13cmos5l_decap_8
XFILLER_666_238 VPWR VGND sg13cmos5l_fill_2
XFILLER_254_49 VPWR VGND sg13cmos5l_decap_4
XFILLER_477_149 VPWR VGND sg13cmos5l_decap_8
XFILLER_269_230 VPWR VGND sg13cmos5l_decap_8
XFILLER_619_121 VPWR VGND sg13cmos5l_decap_8
XFILLER_615_70 VPWR VGND sg13cmos5l_decap_8
XFILLER_619_132 VPWR VGND sg13cmos5l_fill_1
X_2343_ _2343_/Q Tile_X0Y5_FrameData[30] VGND VPWR Tile_X0Y9_FrameStrobe[5] latch
XFILLER_551_14 VPWR VGND sg13cmos5l_decap_8
XANTENNA__3362__X Tile_X0Y2_EE4BEG[1] VPWR VGND sg13cmos5l_antennanp
XFILLER_229_105 VPWR VGND sg13cmos5l_decap_4
XFILLER_619_154 VPWR VGND sg13cmos5l_decap_8
XFILLER_492_119 VPWR VGND sg13cmos5l_decap_8
XFILLER_674_271 VPWR VGND sg13cmos5l_fill_2
XFILLER_96_165 VPWR VGND sg13cmos5l_decap_8
X_2274_ _2274_/Q Tile_X0Y5_FrameData[3] VGND VPWR Tile_X0Y9_FrameStrobe[2] latch
XFILLER_334_93 VPWR VGND sg13cmos5l_decap_8
X_4013_ _4013_/X _3983_/X _0096_/X _3982_/X Tile_X0Y0_S4END[5] _1223_/Q _1222_/Q VPWR
+ VGND sg13cmos5l_mux4_1
X_1225_ _1225_/Q Tile_X0Y1_FrameData[16] VGND VPWR Tile_X0Y9_FrameStrobe[1] latch
XFILLER_701_28 VPWR VGND sg13cmos5l_decap_8
XFILLER_433_208 VPWR VGND sg13cmos5l_decap_8
XFILLER_244_119 VPWR VGND sg13cmos5l_decap_8
XFILLER_634_179 VPWR VGND sg13cmos5l_decap_4
XFILLER_237_171 VPWR VGND sg13cmos5l_fill_1
XFILLER_203_42 VPWR VGND sg13cmos5l_decap_8
XFILLER_631_91 VPWR VGND sg13cmos5l_decap_8
XFILLER_426_271 VPWR VGND sg13cmos5l_fill_2
XFILLER_37_243 VPWR VGND sg13cmos5l_decap_8
X_1156_ _1156_/Q Tile_X0Y0_FrameData[7] VGND VPWR Tile_X0Y9_FrameStrobe[6] latch
XFILLER_350_70 VPWR VGND sg13cmos5l_decap_8
XFILLER_441_230 VPWR VGND sg13cmos5l_decap_8
X_0107_ AXI_M_SOC_ARLEN2 _0933_/Q _3762_/X VPWR VGND sg13cmos5l_nor2b_1
XFILLER_587_234 VPWR VGND sg13cmos5l_fill_1
X_1087_ _1087_/Q Tile_X0Y0_FrameData[12] VGND VPWR Tile_X0Y9_FrameStrobe[4] latch
XFILLER_587_256 VPWR VGND sg13cmos5l_decap_4
XFILLER_279_35 VPWR VGND sg13cmos5l_decap_8
XFILLER_52_268 VPWR VGND sg13cmos5l_decap_4
X_4915_ _4915_/X _4458_/X _4462_/X _4466_/X _4428_/X _2370_/Q _2369_/Q VPWR VGND sg13cmos5l_mux4_1
XFILLER_500_84 VPWR VGND sg13cmos5l_decap_8
XFILLER_339_234 VPWR VGND sg13cmos5l_decap_8
X_4846_ _4846_/X Tile_X0Y9_N1END[2] _4898_/X AXI_M_SOC_RDATA1 AXI_M_SOC_RDATA5 _0851_/Q
+ _0850_/Q VPWR VGND sg13cmos5l_mux4_1
XFILLER_555_131 VPWR VGND sg13cmos5l_fill_2
XFILLER_429_49 VPWR VGND sg13cmos5l_decap_8
XFILLER_32_28 VPWR VGND sg13cmos5l_decap_8
XFILLER_20_143 VPWR VGND sg13cmos5l_decap_8
XFILLER_148_28 VPWR VGND sg13cmos5l_decap_8
XFILLER_576_77 VPWR VGND sg13cmos5l_decap_8
XFILLER_555_175 VPWR VGND sg13cmos5l_decap_8
X_4777_ _4777_/X Tile_X0Y9_W1END[0] Tile_X0Y9_W6END[4] _4928_/X _4892_/X _0927_/Q
+ _0926_/Q VPWR VGND sg13cmos5l_mux4_1
XFILLER_570_112 VPWR VGND sg13cmos5l_decap_8
XANTENNA__3537__X Tile_X0Y9_E2BEGb[3] VPWR VGND sg13cmos5l_antennanp
X_1989_ _1989_/Q Tile_X0Y4_FrameData[0] VGND VPWR Tile_X0Y9_FrameStrobe[1] latch
XFILLER_20_198 VPWR VGND sg13cmos5l_decap_8
X_3728_ AXI_M_SOC_ARADDR0 Tile_X0Y9_WW4END[0] Tile_X0Y9_WW4END[8] Tile_X0Y9_W6END[0]
+ _4916_/X _0759_/Q _0758_/Q VPWR VGND sg13cmos5l_mux4_1
XFILLER_592_21 VPWR VGND sg13cmos5l_decap_8
XFILLER_173_170 VPWR VGND sg13cmos5l_decap_8
XFILLER_570_189 VPWR VGND sg13cmos5l_decap_8
XFILLER_106_226 VPWR VGND sg13cmos5l_decap_8
XFILLER_712_161 VPWR VGND sg13cmos5l_decap_8
XFILLER_106_8 VPWR VGND sg13cmos5l_decap_8
X_3659_ AXI_M_SOC_AWADDR20 Tile_X0Y4_WW4END[4] Tile_X0Y4_WW4END[12] Tile_X0Y4_W6END[4]
+ _4340_/X _2005_/Q _2004_/Q VPWR VGND sg13cmos5l_mux4_1
XFILLER_511_245 VPWR VGND sg13cmos5l_fill_1
XFILLER_468_138 VPWR VGND sg13cmos5l_fill_2
XFILLER_657_249 VPWR VGND sg13cmos5l_decap_8
XFILLER_525_70 VPWR VGND sg13cmos5l_decap_8
XFILLER_114_270 VPWR VGND sg13cmos5l_fill_2
XFILLER_322_189 VPWR VGND sg13cmos5l_fill_2
XFILLER_461_14 VPWR VGND sg13cmos5l_decap_8
XFILLER_409_205 VPWR VGND sg13cmos5l_decap_8
XANTENNA__3272__X Tile_X0Y0_EE4BEG[8] VPWR VGND sg13cmos5l_antennanp
XFILLER_680_241 VPWR VGND sg13cmos5l_decap_8
XFILLER_611_28 VPWR VGND sg13cmos5l_decap_8
XFILLER_235_108 VPWR VGND sg13cmos5l_decap_4
XFILLER_228_160 VPWR VGND sg13cmos5l_decap_8
XFILLER_640_105 VPWR VGND sg13cmos5l_decap_8
XFILLER_468_7 VPWR VGND sg13cmos5l_decap_8
XFILLER_28_232 VPWR VGND sg13cmos5l_decap_4
XFILLER_417_271 VPWR VGND sg13cmos5l_fill_2
XFILLER_113_42 VPWR VGND sg13cmos5l_decap_8
XFILLER_330_29 VPWR VGND sg13cmos5l_decap_8
XFILLER_260_70 VPWR VGND sg13cmos5l_decap_8
XFILLER_113_86 VPWR VGND sg13cmos5l_fill_1
XFILLER_73_35 VPWR VGND sg13cmos5l_decap_8
XFILLER_389_134 VPWR VGND sg13cmos5l_decap_8
XFILLER_635_7 VPWR VGND sg13cmos5l_decap_8
XFILLER_593_215 VPWR VGND sg13cmos5l_decap_8
XFILLER_410_84 VPWR VGND sg13cmos5l_decap_8
XFILLER_486_77 VPWR VGND sg13cmos5l_decap_8
XFILLER_400_182 VPWR VGND sg13cmos5l_decap_8
XFILLER_11_165 VPWR VGND sg13cmos5l_decap_8
XFILLER_486_88 VPWR VGND sg13cmos5l_fill_1
XFILLER_636_14 VPWR VGND sg13cmos5l_decap_8
XFILLER_561_112 VPWR VGND sg13cmos5l_decap_8
XANTENNA__3447__X Tile_X0Y1_FrameData_O[5] VPWR VGND sg13cmos5l_antennanp
XFILLER_125_0 VPWR VGND sg13cmos5l_decap_8
XFILLER_7_136 VPWR VGND sg13cmos5l_decap_8
XFILLER_98_21 VPWR VGND sg13cmos5l_decap_8
XFILLER_499_252 VPWR VGND sg13cmos5l_decap_4
XFILLER_648_216 VPWR VGND sg13cmos5l_decap_8
XFILLER_313_145 VPWR VGND sg13cmos5l_decap_8
XFILLER_502_245 VPWR VGND sg13cmos5l_decap_8
XFILLER_112_218 VPWR VGND sg13cmos5l_decap_8
XFILLER_652_35 VPWR VGND sg13cmos5l_decap_8
XFILLER_435_70 VPWR VGND sg13cmos5l_decap_8
XFILLER_494_0 VPWR VGND sg13cmos5l_decap_8
XFILLER_371_14 VPWR VGND sg13cmos5l_decap_8
XANTENNA__3182__X Tile_X0Y0_N4BEG[6] VPWR VGND sg13cmos5l_antennanp
XFILLER_656_271 VPWR VGND sg13cmos5l_fill_2
XFILLER_616_113 VPWR VGND sg13cmos5l_decap_8
XFILLER_266_233 VPWR VGND sg13cmos5l_decap_8
XFILLER_78_187 VPWR VGND sg13cmos5l_fill_2
XFILLER_661_0 VPWR VGND sg13cmos5l_decap_8
XFILLER_14_7 VPWR VGND sg13cmos5l_decap_8
XFILLER_521_28 VPWR VGND sg13cmos5l_decap_8
XFILLER_281_203 VPWR VGND sg13cmos5l_decap_8
XFILLER_304_63 VPWR VGND sg13cmos5l_decap_8
XFILLER_631_105 VPWR VGND sg13cmos5l_decap_4
XFILLER_408_260 VPWR VGND sg13cmos5l_decap_8
XFILLER_451_91 VPWR VGND sg13cmos5l_decap_8
X_1010_ _1010_/Q Tile_X0Y0_FrameData[25] VGND VPWR Tile_X0Y9_FrameStrobe[2] latch
XFILLER_631_116 VPWR VGND sg13cmos5l_decap_4
XFILLER_408_271 VPWR VGND sg13cmos5l_fill_2
XFILLER_482_196 VPWR VGND sg13cmos5l_decap_8
XFILLER_47_91 VPWR VGND sg13cmos5l_decap_8
XFILLER_170_70 VPWR VGND sg13cmos5l_decap_8
XFILLER_234_141 VPWR VGND sg13cmos5l_decap_8
XFILLER_34_224 VPWR VGND sg13cmos5l_decap_8
XFILLER_179_218 VPWR VGND sg13cmos5l_fill_1
XFILLER_677_21 VPWR VGND sg13cmos5l_decap_8
XFILLER_395_126 VPWR VGND sg13cmos5l_fill_2
X_2961_ Tile_X0Y8_FrameData_O[1] Tile_X0Y8_FrameData[1] VPWR VGND sg13cmos5l_buf_1
X_4700_ _4700_/X Tile_X0Y6_W2MID[7] Tile_X0Y6_W2END[7] Tile_X0Y6_W6END[8] _4553_/X
+ _2651_/Q _2650_/Q VPWR VGND sg13cmos5l_mux4_1
X_1912_ _1912_/Q Tile_X0Y3_FrameData[17] VGND VPWR Tile_X0Y9_FrameStrobe[7] latch
XFILLER_677_98 VPWR VGND sg13cmos5l_decap_8
XFILLER_537_142 VPWR VGND sg13cmos5l_decap_4
X_2892_ Tile_X0Y6_FrameData_O[13] Tile_X0Y6_FrameData[13] VPWR VGND sg13cmos5l_buf_1
XFILLER_396_77 VPWR VGND sg13cmos5l_decap_4
X_4631_ _4631_/X Tile_X0Y7_WW4END[12] AXI_M_SOC_RDATA19 _4696_/X _4674_/X _0297_/Q
+ _0296_/Q VPWR VGND sg13cmos5l_mux4_1
XFILLER_537_175 VPWR VGND sg13cmos5l_decap_8
X_1843_ _1843_/Q Tile_X0Y3_FrameData[22] VGND VPWR Tile_X0Y9_FrameStrobe[5] latch
XFILLER_546_14 VPWR VGND sg13cmos5l_decap_8
XFILLER_8_63 VPWR VGND sg13cmos5l_decap_8
XFILLER_698_105 VPWR VGND sg13cmos5l_decap_8
XANTENNA__3357__X Tile_X0Y2_FrameData_O[28] VPWR VGND sg13cmos5l_antennanp
XFILLER_336_248 VPWR VGND sg13cmos5l_decap_8
XFILLER_693_42 VPWR VGND sg13cmos5l_decap_8
XFILLER_329_71 VPWR VGND sg13cmos5l_decap_8
XFILLER_329_82 VPWR VGND sg13cmos5l_fill_1
X_1774_ _1774_/Q Tile_X0Y3_FrameData[27] VGND VPWR Tile_X0Y9_FrameStrobe[3] latch
X_4562_ _4562_/X Tile_X0Y2_W1END[1] Tile_X0Y2_WW4END[13] Tile_X0Y2_W6END[5] _4117_/X
+ _1610_/Q _1609_/Q VPWR VGND sg13cmos5l_mux4_1
XFILLER_552_156 VPWR VGND sg13cmos5l_decap_8
X_0725_ _0725_/Q Tile_X0Y9_FrameData[10] VGND VPWR Tile_X0Y9_FrameStrobe[1] latch
X_3513_ Tile_X0Y1_E2BEG[3] _3935_/X VPWR VGND sg13cmos5l_buf_1
XFILLER_304_101 VPWR VGND sg13cmos5l_decap_8
X_4493_ _4493_/X _4547_/X _4546_/X AXI_M_SOC_RDATA26 AXI_M_SOC_RDATA30 _2621_/Q _2620_/Q
+ VPWR VGND sg13cmos5l_mux4_1
X_0656_ _0656_/Q Tile_X0Y8_FrameData[15] VGND VPWR Tile_X0Y9_FrameStrobe[7] latch
X_3444_ Tile_X0Y1_FrameData_O[2] Tile_X0Y1_FrameData[2] VPWR VGND sg13cmos5l_buf_1
XFILLER_639_238 VPWR VGND sg13cmos5l_decap_8
XFILLER_562_35 VPWR VGND sg13cmos5l_decap_8
XFILLER_40_0 VPWR VGND sg13cmos5l_fill_2
XFILLER_345_70 VPWR VGND sg13cmos5l_decap_8
XFILLER_304_167 VPWR VGND sg13cmos5l_decap_8
XFILLER_345_92 VPWR VGND sg13cmos5l_decap_8
X_3375_ Tile_X0Y2_EE4BEG[14] _4070_/X VPWR VGND sg13cmos5l_buf_1
XFILLER_281_14 VPWR VGND sg13cmos5l_decap_8
XANTENNA__3092__X Tile_X0Y7_E2BEG[6] VPWR VGND sg13cmos5l_antennanp
X_0587_ _0587_/Q Tile_X0Y8_FrameData[20] VGND VPWR Tile_X0Y9_FrameStrobe[5] latch
XFILLER_257_200 VPWR VGND sg13cmos5l_fill_2
XFILLER_69_154 VPWR VGND sg13cmos5l_decap_8
X_2326_ _2326_/Q Tile_X0Y5_FrameData[15] VGND VPWR Tile_X0Y9_FrameStrobe[4] latch
XFILLER_712_49 VPWR VGND sg13cmos5l_decap_8
XFILLER_217_108 VPWR VGND sg13cmos5l_decap_8
XFILLER_431_28 VPWR VGND sg13cmos5l_decap_8
XFILLER_214_63 VPWR VGND sg13cmos5l_decap_8
X_2257_ _2257_/Q Tile_X0Y5_FrameData[20] VGND VPWR Tile_X0Y9_FrameStrobe[2] latch
XFILLER_27_28 VPWR VGND sg13cmos5l_decap_8
XFILLER_84_168 VPWR VGND sg13cmos5l_decap_8
X_1208_ _1208_/Q Tile_X0Y1_FrameData[1] VGND VPWR Tile_X0Y9_FrameStrobe[0] latch
XFILLER_622_138 VPWR VGND sg13cmos5l_decap_8
XFILLER_225_130 VPWR VGND sg13cmos5l_decap_8
X_2188_ _2188_/Q Tile_X0Y5_FrameData[25] VGND VPWR Tile_X0Y9_FrameStrobe[0] latch
XFILLER_272_258 VPWR VGND sg13cmos5l_fill_2
XFILLER_225_141 VPWR VGND sg13cmos5l_fill_1
X_1139_ _1139_/Q Tile_X0Y0_FrameData[24] VGND VPWR Tile_X0Y9_FrameStrobe[6] latch
XFILLER_587_21 VPWR VGND sg13cmos5l_decap_8
XFILLER_386_104 VPWR VGND sg13cmos5l_decap_8
XFILLER_40_205 VPWR VGND sg13cmos5l_decap_8
XFILLER_386_115 VPWR VGND sg13cmos5l_fill_2
XFILLER_43_27 VPWR VGND sg13cmos5l_decap_8
XFILLER_230_95 VPWR VGND sg13cmos5l_decap_4
XFILLER_528_120 VPWR VGND sg13cmos5l_decap_8
XFILLER_575_259 VPWR VGND sg13cmos5l_decap_8
XFILLER_240_177 VPWR VGND sg13cmos5l_decap_8
XFILLER_138_126 VPWR VGND sg13cmos5l_decap_8
XFILLER_223_8 VPWR VGND sg13cmos5l_decap_8
X_4829_ _4829_/X Tile_X0Y9_W2MID[6] Tile_X0Y9_W2END[6] Tile_X0Y9_W6END[9] _4903_/X
+ _0881_/Q _0880_/Q VPWR VGND sg13cmos5l_mux4_1
XFILLER_456_14 VPWR VGND sg13cmos5l_decap_8
XANTENNA__3267__X Tile_X0Y0_EE4BEG[3] VPWR VGND sg13cmos5l_antennanp
XFILLER_543_123 VPWR VGND sg13cmos5l_fill_2
XFILLER_689_127 VPWR VGND sg13cmos5l_decap_8
XFILLER_216_7 VPWR VGND sg13cmos5l_decap_8
XFILLER_342_207 VPWR VGND sg13cmos5l_decap_8
XFILLER_606_28 VPWR VGND sg13cmos5l_decap_8
XFILLER_146_192 VPWR VGND sg13cmos5l_fill_2
XFILLER_108_42 VPWR VGND sg13cmos5l_decap_8
XFILLER_700_120 VPWR VGND sg13cmos5l_decap_8
XFILLER_496_222 VPWR VGND sg13cmos5l_decap_8
XFILLER_472_35 VPWR VGND sg13cmos5l_decap_8
XFILLER_350_251 VPWR VGND sg13cmos5l_fill_2
XFILLER_68_35 VPWR VGND sg13cmos5l_decap_8
XFILLER_255_92 VPWR VGND sg13cmos5l_decap_8
XFILLER_161_195 VPWR VGND sg13cmos5l_decap_8
XFILLER_191_14 VPWR VGND sg13cmos5l_decap_8
XFILLER_472_68 VPWR VGND sg13cmos5l_fill_1
XFILLER_585_7 VPWR VGND sg13cmos5l_decap_8
XFILLER_102_240 VPWR VGND sg13cmos5l_decap_8
XFILLER_622_49 VPWR VGND sg13cmos5l_decap_8
XFILLER_653_230 VPWR VGND sg13cmos5l_fill_2
XFILLER_405_84 VPWR VGND sg13cmos5l_decap_8
XFILLER_75_113 VPWR VGND sg13cmos5l_decap_8
XFILLER_124_63 VPWR VGND sg13cmos5l_decap_8
XFILLER_341_28 VPWR VGND sg13cmos5l_decap_8
XFILLER_208_119 VPWR VGND sg13cmos5l_decap_8
XANTENNA__3730__X AXI_M_SOC_ARADDR2 VPWR VGND sg13cmos5l_antennanp
XFILLER_75_157 VPWR VGND sg13cmos5l_fill_2
XFILLER_464_185 VPWR VGND sg13cmos5l_decap_8
XFILLER_263_236 VPWR VGND sg13cmos5l_decap_8
XFILLER_84_56 VPWR VGND sg13cmos5l_decap_8
XFILLER_613_149 VPWR VGND sg13cmos5l_decap_8
XFILLER_497_21 VPWR VGND sg13cmos5l_decap_8
XFILLER_17_94 VPWR VGND sg13cmos5l_decap_8
XFILLER_377_115 VPWR VGND sg13cmos5l_fill_2
XFILLER_140_84 VPWR VGND sg13cmos5l_decap_8
XFILLER_242_0 VPWR VGND sg13cmos5l_decap_8
XFILLER_566_248 VPWR VGND sg13cmos5l_decap_8
XFILLER_377_159 VPWR VGND sg13cmos5l_decap_8
XFILLER_497_98 VPWR VGND sg13cmos5l_decap_8
XFILLER_647_35 VPWR VGND sg13cmos5l_decap_8
XFILLER_129_126 VPWR VGND sg13cmos5l_decap_8
XFILLER_318_226 VPWR VGND sg13cmos5l_fill_1
XFILLER_519_186 VPWR VGND sg13cmos5l_decap_8
XANTENNA__3177__X Tile_X0Y0_N4BEG[1] VPWR VGND sg13cmos5l_antennanp
XFILLER_507_0 VPWR VGND sg13cmos5l_decap_8
XFILLER_366_36 VPWR VGND sg13cmos5l_decap_8
XFILLER_318_248 VPWR VGND sg13cmos5l_decap_8
XFILLER_184_265 VPWR VGND sg13cmos5l_decap_8
XFILLER_333_207 VPWR VGND sg13cmos5l_fill_2
XFILLER_534_178 VPWR VGND sg13cmos5l_decap_8
XFILLER_516_28 VPWR VGND sg13cmos5l_decap_8
XFILLER_695_119 VPWR VGND sg13cmos5l_decap_8
XFILLER_663_56 VPWR VGND sg13cmos5l_decap_8
X_0510_ _0510_/Q Tile_X0Y8_FrameData[1] VGND VPWR Tile_X0Y9_FrameStrobe[2] latch
X_1490_ _1490_/Q Tile_X0Y2_FrameData[31] VGND VPWR Tile_X0Y9_FrameStrobe[2] latch
XFILLER_487_233 VPWR VGND sg13cmos5l_decap_8
XFILLER_382_35 VPWR VGND sg13cmos5l_decap_8
X_0441_ _0441_/Q Tile_X0Y8_FrameData[6] VGND VPWR Tile_X0Y9_FrameStrobe[0] latch
XFILLER_298_188 VPWR VGND sg13cmos5l_decap_8
XFILLER_298_199 VPWR VGND sg13cmos5l_fill_2
XFILLER_629_260 VPWR VGND sg13cmos5l_decap_8
XFILLER_629_271 VPWR VGND sg13cmos5l_fill_2
X_3160_ Tile_X0Y7_FrameData_O[30] Tile_X0Y7_FrameData[30] VPWR VGND sg13cmos5l_buf_1
X_0372_ _0372_/Q Tile_X0Y7_FrameData[11] VGND VPWR Tile_X0Y9_FrameStrobe[6] latch
XFILLER_239_244 VPWR VGND sg13cmos5l_decap_4
XFILLER_532_49 VPWR VGND sg13cmos5l_decap_8
X_2111_ _2111_/Q Tile_X0Y4_FrameData[6] VGND VPWR Tile_X0Y9_FrameStrobe[5] latch
XFILLER_644_252 VPWR VGND sg13cmos5l_decap_8
XFILLER_251_28 VPWR VGND sg13cmos5l_decap_8
X_3091_ Tile_X0Y7_E2BEG[5] _4617_/X VPWR VGND sg13cmos5l_buf_1
XANTENNA__3640__X AXI_M_SOC_AWADDR1 VPWR VGND sg13cmos5l_antennanp
XFILLER_181_91 VPWR VGND sg13cmos5l_decap_8
XFILLER_66_168 VPWR VGND sg13cmos5l_decap_8
XFILLER_604_116 VPWR VGND sg13cmos5l_decap_8
X_2042_ _2042_/Q Tile_X0Y4_FrameData[11] VGND VPWR Tile_X0Y9_FrameStrobe[3] latch
XFILLER_331_50 VPWR VGND sg13cmos5l_decap_8
XFILLER_81_138 VPWR VGND sg13cmos5l_decap_8
XFILLER_688_42 VPWR VGND sg13cmos5l_decap_8
XFILLER_74_190 VPWR VGND sg13cmos5l_fill_1
XFILLER_612_160 VPWR VGND sg13cmos5l_decap_8
XFILLER_222_133 VPWR VGND sg13cmos5l_decap_8
XFILLER_200_21 VPWR VGND sg13cmos5l_decap_8
XFILLER_222_155 VPWR VGND sg13cmos5l_decap_8
X_3993_ _3993_/X _3892_/X _4025_/X _4024_/X Tile_X0Y0_S2MID[2] _1197_/Q _1196_/Q VPWR
+ VGND sg13cmos5l_mux4_1
XFILLER_368_148 VPWR VGND sg13cmos5l_decap_8
XFILLER_368_159 VPWR VGND sg13cmos5l_fill_1
X_2944_ Tile_X0Y8_EE4BEG[0] _4744_/X VPWR VGND sg13cmos5l_buf_1
XFILLER_557_35 VPWR VGND sg13cmos5l_decap_8
XFILLER_88_0 VPWR VGND sg13cmos5l_decap_8
XFILLER_309_215 VPWR VGND sg13cmos5l_fill_1
XFILLER_200_98 VPWR VGND sg13cmos5l_decap_8
XFILLER_276_14 VPWR VGND sg13cmos5l_decap_8
XANTENNA__3087__X Tile_X0Y7_E2BEG[1] VPWR VGND sg13cmos5l_antennanp
X_2875_ Tile_X0Y6_EE4BEG[12] _4524_/X VPWR VGND sg13cmos5l_buf_1
XFILLER_30_271 VPWR VGND sg13cmos5l_fill_2
XFILLER_175_243 VPWR VGND sg13cmos5l_decap_8
XFILLER_309_248 VPWR VGND sg13cmos5l_decap_8
XFILLER_309_259 VPWR VGND sg13cmos5l_fill_1
X_4614_ _4614_/X Tile_X0Y7_W2MID[5] AXI_M_SOC_RDATA18 _4673_/X _4672_/X _0331_/Q _0330_/Q
+ VPWR VGND sg13cmos5l_mux4_1
XFILLER_580_240 VPWR VGND sg13cmos5l_decap_8
XFILLER_391_140 VPWR VGND sg13cmos5l_decap_8
X_1826_ _1826_/Q Tile_X0Y3_FrameData[7] VGND VPWR Tile_X0Y9_FrameStrobe[4] latch
XFILLER_525_156 VPWR VGND sg13cmos5l_decap_8
XFILLER_714_256 VPWR VGND sg13cmos5l_fill_1
XFILLER_707_49 VPWR VGND sg13cmos5l_decap_8
XFILLER_324_207 VPWR VGND sg13cmos5l_decap_8
XFILLER_637_90 VPWR VGND sg13cmos5l_fill_2
XFILLER_190_235 VPWR VGND sg13cmos5l_decap_8
XFILLER_209_63 VPWR VGND sg13cmos5l_decap_8
X_4545_ _4545_/X Tile_X0Y7_W1END[0] Tile_X0Y7_W6END[4] _4696_/X _4656_/X _0415_/Q
+ _0414_/Q VPWR VGND sg13cmos5l_mux4_1
XFILLER_426_28 VPWR VGND sg13cmos5l_decap_8
X_1757_ _1757_/Q Tile_X0Y3_FrameData[12] VGND VPWR Tile_X0Y9_FrameStrobe[2] latch
XFILLER_478_200 VPWR VGND sg13cmos5l_fill_1
XFILLER_143_140 VPWR VGND sg13cmos5l_fill_1
XFILLER_190_268 VPWR VGND sg13cmos5l_decap_4
XFILLER_573_56 VPWR VGND sg13cmos5l_decap_8
XFILLER_356_91 VPWR VGND sg13cmos5l_decap_8
X_0708_ _0708_/Q Tile_X0Y9_FrameData[27] VGND VPWR Tile_X0Y9_FrameStrobe[1] latch
XFILLER_143_162 VPWR VGND sg13cmos5l_decap_8
X_4476_ _4476_/X Tile_X0Y4_W1END[0] Tile_X0Y4_W2MID[3] Tile_X0Y4_W2END[3] _4318_/X
+ _2129_/Q _2128_/Q VPWR VGND sg13cmos5l_mux4_1
XFILLER_679_193 VPWR VGND sg13cmos5l_decap_4
XFILLER_292_35 VPWR VGND sg13cmos5l_decap_8
X_1688_ _1688_/Q Tile_X0Y3_FrameData[17] VGND VPWR Tile_X0Y9_FrameStrobe[0] latch
XFILLER_289_177 VPWR VGND sg13cmos5l_decap_8
X_3427_ Tile_X0Y4_FrameData_O[18] Tile_X0Y4_FrameData[18] VPWR VGND sg13cmos5l_buf_1
X_0639_ _0639_/Q Tile_X0Y8_FrameData[0] VGND VPWR Tile_X0Y9_FrameStrobe[6] latch
XFILLER_493_225 VPWR VGND sg13cmos5l_decap_4
XFILLER_225_84 VPWR VGND sg13cmos5l_fill_2
X_3358_ Tile_X0Y2_FrameData_O[29] Tile_X0Y2_FrameData[29] VPWR VGND sg13cmos5l_buf_1
XFILLER_57_102 VPWR VGND sg13cmos5l_decap_4
X_2309_ _2309_/Q Tile_X0Y5_FrameData[0] VGND VPWR Tile_X0Y9_FrameStrobe[3] latch
XFILLER_57_135 VPWR VGND sg13cmos5l_decap_8
XFILLER_446_174 VPWR VGND sg13cmos5l_decap_4
XANTENNA__3550__X Tile_X0Y9_E6BEG[8] VPWR VGND sg13cmos5l_antennanp
X_3289_ Tile_X0Y0_E6BEG[9] _3845_/X VPWR VGND sg13cmos5l_buf_1
XFILLER_461_100 VPWR VGND sg13cmos5l_decap_4
XFILLER_522_82 VPWR VGND sg13cmos5l_decap_8
XFILLER_72_116 VPWR VGND sg13cmos5l_decap_4
XFILLER_461_144 VPWR VGND sg13cmos5l_fill_2
XFILLER_598_42 VPWR VGND sg13cmos5l_decap_8
XFILLER_610_108 VPWR VGND sg13cmos5l_decap_8
XFILLER_166_7 VPWR VGND sg13cmos5l_decap_8
XFILLER_54_37 VPWR VGND sg13cmos5l_decap_8
XFILLER_461_188 VPWR VGND sg13cmos5l_fill_2
XFILLER_399_262 VPWR VGND sg13cmos5l_fill_2
XFILLER_402_211 VPWR VGND sg13cmos5l_fill_1
XFILLER_402_233 VPWR VGND sg13cmos5l_decap_8
XFILLER_213_144 VPWR VGND sg13cmos5l_decap_8
XFILLER_110_21 VPWR VGND sg13cmos5l_decap_8
XFILLER_80_182 VPWR VGND sg13cmos5l_decap_8
XFILLER_110_76 VPWR VGND sg13cmos5l_decap_8
XFILLER_467_35 VPWR VGND sg13cmos5l_decap_8
XFILLER_467_46 VPWR VGND sg13cmos5l_fill_2
XFILLER_70_36 VPWR VGND sg13cmos5l_decap_8
XFILLER_367_170 VPWR VGND sg13cmos5l_decap_8
XFILLER_186_14 VPWR VGND sg13cmos5l_decap_8
XFILLER_467_79 VPWR VGND sg13cmos5l_decap_8
XFILLER_500_7 VPWR VGND sg13cmos5l_decap_8
XFILLER_571_240 VPWR VGND sg13cmos5l_decap_8
XFILLER_126_118 VPWR VGND sg13cmos5l_fill_1
XFILLER_181_213 VPWR VGND sg13cmos5l_decap_8
XFILLER_617_49 VPWR VGND sg13cmos5l_decap_8
XANTENNA__0133__Y AXI_M_SOC_AWSIZE2 VPWR VGND sg13cmos5l_antennanp
XFILLER_119_63 VPWR VGND sg13cmos5l_decap_8
XFILLER_382_195 VPWR VGND sg13cmos5l_fill_1
XFILLER_336_28 VPWR VGND sg13cmos5l_decap_8
XFILLER_119_85 VPWR VGND sg13cmos5l_decap_8
XFILLER_531_159 VPWR VGND sg13cmos5l_fill_2
XFILLER_79_56 VPWR VGND sg13cmos5l_decap_8
XFILLER_469_244 VPWR VGND sg13cmos5l_decap_8
XFILLER_685_141 VPWR VGND sg13cmos5l_fill_1
XFILLER_134_184 VPWR VGND sg13cmos5l_decap_8
XFILLER_429_119 VPWR VGND sg13cmos5l_decap_8
XFILLER_95_219 VPWR VGND sg13cmos5l_fill_2
XFILLER_295_147 VPWR VGND sg13cmos5l_decap_8
XFILLER_352_49 VPWR VGND sg13cmos5l_decap_8
XFILLER_135_84 VPWR VGND sg13cmos5l_decap_8
XFILLER_88_271 VPWR VGND sg13cmos5l_fill_2
XFILLER_48_102 VPWR VGND sg13cmos5l_decap_8
XFILLER_192_0 VPWR VGND sg13cmos5l_decap_8
XFILLER_48_113 VPWR VGND sg13cmos5l_fill_1
XFILLER_48_135 VPWR VGND sg13cmos5l_decap_8
XANTENNA__3460__X Tile_X0Y1_FrameData_O[18] VPWR VGND sg13cmos5l_antennanp
XFILLER_95_77 VPWR VGND sg13cmos5l_decap_8
XFILLER_236_247 VPWR VGND sg13cmos5l_decap_4
XFILLER_457_0 VPWR VGND sg13cmos5l_decap_8
XFILLER_452_177 VPWR VGND sg13cmos5l_decap_8
XFILLER_204_122 VPWR VGND sg13cmos5l_fill_2
XFILLER_539_204 VPWR VGND sg13cmos5l_decap_8
XFILLER_301_64 VPWR VGND sg13cmos5l_decap_8
XFILLER_624_0 VPWR VGND sg13cmos5l_decap_8
XFILLER_301_75 VPWR VGND sg13cmos5l_fill_2
XFILLER_71_182 VPWR VGND sg13cmos5l_decap_8
XFILLER_539_248 VPWR VGND sg13cmos5l_decap_8
XFILLER_658_56 VPWR VGND sg13cmos5l_decap_8
XFILLER_44_70 VPWR VGND sg13cmos5l_decap_8
XANTENNA__2804__X Tile_X0Y3_E2BEGb[2] VPWR VGND sg13cmos5l_antennanp
X_0990_ _0990_/Q Tile_X0Y0_FrameData[13] VGND VPWR Tile_X0Y9_FrameStrobe[1] latch
XFILLER_377_35 VPWR VGND sg13cmos5l_decap_8
XFILLER_81_7 VPWR VGND sg13cmos5l_decap_8
XFILLER_507_112 VPWR VGND sg13cmos5l_decap_4
X_2660_ _2660_/Q Tile_X0Y6_FrameData[3] VGND VPWR Tile_X0Y9_FrameStrobe[6] latch
XFILLER_562_251 VPWR VGND sg13cmos5l_decap_4
XFILLER_507_156 VPWR VGND sg13cmos5l_decap_8
XFILLER_527_49 VPWR VGND sg13cmos5l_decap_8
XFILLER_373_162 VPWR VGND sg13cmos5l_decap_8
X_1611_ _1611_/Q Tile_X0Y2_FrameData[6] VGND VPWR Tile_X0Y9_FrameStrobe[5] latch
XFILLER_674_77 VPWR VGND sg13cmos5l_decap_8
X_2591_ _2591_/Q Tile_X0Y6_FrameData[8] VGND VPWR Tile_X0Y9_FrameStrobe[4] latch
XFILLER_172_257 VPWR VGND sg13cmos5l_decap_8
XFILLER_176_80 VPWR VGND sg13cmos5l_decap_8
XANTENNA__3635__X Tile_X0Y9_S4BEG[13] VPWR VGND sg13cmos5l_antennanp
X_4330_ _4330_/X Tile_X0Y8_W1END[2] Tile_X0Y8_WW4END[2] Tile_X0Y8_W6END[10] _4802_/X
+ _0641_/Q _0640_/Q VPWR VGND sg13cmos5l_mux4_1
XFILLER_522_159 VPWR VGND sg13cmos5l_decap_8
X_1542_ _1542_/Q Tile_X0Y2_FrameData[11] VGND VPWR Tile_X0Y9_FrameStrobe[3] latch
XFILLER_5_42 VPWR VGND sg13cmos5l_decap_8
XFILLER_125_162 VPWR VGND sg13cmos5l_decap_8
XFILLER_690_21 VPWR VGND sg13cmos5l_decap_8
X_1473_ _1473_/Q Tile_X0Y2_FrameData[16] VGND VPWR Tile_X0Y9_FrameStrobe[1] latch
X_4261_ _4261_/X Tile_X0Y4_W2MID[2] AXI_M_SOC_BRESP1 _4317_/X _4316_/X _2091_/Q _2090_/Q
+ VPWR VGND sg13cmos5l_mux4_1
XFILLER_676_163 VPWR VGND sg13cmos5l_decap_8
XFILLER_609_208 VPWR VGND sg13cmos5l_decap_8
XFILLER_140_154 VPWR VGND sg13cmos5l_decap_8
XFILLER_86_219 VPWR VGND sg13cmos5l_fill_2
X_0424_ _0424_/Q Tile_X0Y8_FrameData[23] VGND VPWR Tile_X0Y9_FrameStrobe[0] latch
X_3212_ Tile_X0Y0_FrameStrobe_O[0] Tile_X0Y9_FrameStrobe[0] VPWR VGND sg13cmos5l_buf_1
XFILLER_286_147 VPWR VGND sg13cmos5l_decap_8
XFILLER_79_271 VPWR VGND sg13cmos5l_fill_2
X_4192_ _4192_/X _4200_/X Tile_X0Y3_W6END[2] _4199_/X _4192_/A3 _1677_/Q _1676_/Q
+ VPWR VGND sg13cmos5l_mux4_1
XFILLER_262_49 VPWR VGND sg13cmos5l_decap_8
XFILLER_623_70 VPWR VGND sg13cmos5l_decap_8
XFILLER_490_206 VPWR VGND sg13cmos5l_decap_8
X_0355_ _0355_/Q Tile_X0Y7_FrameData[28] VGND VPWR Tile_X0Y9_FrameStrobe[6] latch
X_3143_ Tile_X0Y7_FrameData_O[13] Tile_X0Y7_FrameData[13] VPWR VGND sg13cmos5l_buf_1
XFILLER_39_135 VPWR VGND sg13cmos5l_decap_8
XANTENNA__3370__X Tile_X0Y2_EE4BEG[9] VPWR VGND sg13cmos5l_antennanp
XFILLER_294_180 VPWR VGND sg13cmos5l_fill_1
XFILLER_428_196 VPWR VGND sg13cmos5l_decap_8
XFILLER_227_258 VPWR VGND sg13cmos5l_fill_2
X_3074_ Tile_X0Y4_E2BEGb[0] _4264_/X VPWR VGND sg13cmos5l_buf_1
X_0286_ _0286_/Q Tile_X0Y7_FrameData[1] VGND VPWR Tile_X0Y9_FrameStrobe[3] latch
XFILLER_699_85 VPWR VGND sg13cmos5l_decap_4
X_2025_ _2025_/Q Tile_X0Y4_FrameData[28] VGND VPWR Tile_X0Y9_FrameStrobe[3] latch
XFILLER_443_166 VPWR VGND sg13cmos5l_fill_1
XFILLER_47_190 VPWR VGND sg13cmos5l_fill_2
XFILLER_443_199 VPWR VGND sg13cmos5l_fill_1
XFILLER_211_42 VPWR VGND sg13cmos5l_decap_8
XFILLER_568_56 VPWR VGND sg13cmos5l_decap_8
XFILLER_600_152 VPWR VGND sg13cmos5l_decap_8
XFILLER_250_272 VPWR VGND sg13cmos5l_fill_1
X_3976_ _3976_/X _3981_/X Tile_X0Y1_W6END[0] _3980_/X _3976_/A3 _1185_/Q _1184_/Q
+ VPWR VGND sg13cmos5l_mux4_1
XFILLER_287_35 VPWR VGND sg13cmos5l_decap_8
XFILLER_210_147 VPWR VGND sg13cmos5l_decap_8
XFILLER_545_229 VPWR VGND sg13cmos5l_decap_4
X_2927_ Tile_X0Y8_E2BEGb[3] _4739_/X VPWR VGND sg13cmos5l_buf_1
XFILLER_699_233 VPWR VGND sg13cmos5l_decap_8
X_2858_ Tile_X0Y6_E6BEG[7] _4535_/X VPWR VGND sg13cmos5l_buf_1
XFILLER_437_49 VPWR VGND sg13cmos5l_decap_8
XFILLER_163_235 VPWR VGND sg13cmos5l_decap_8
XFILLER_584_77 VPWR VGND sg13cmos5l_decap_8
X_1809_ _1809_/Q Tile_X0Y3_FrameData[24] VGND VPWR Tile_X0Y9_FrameStrobe[4] latch
XFILLER_513_126 VPWR VGND sg13cmos5l_fill_1
XFILLER_364_195 VPWR VGND sg13cmos5l_decap_8
XANTENNA__3545__X Tile_X0Y9_E6BEG[3] VPWR VGND sg13cmos5l_antennanp
X_2789_ Tile_X0Y3_EE4BEG[15] _4179_/X VPWR VGND sg13cmos5l_buf_1
XFILLER_517_82 VPWR VGND sg13cmos5l_decap_8
X_4528_ _4528_/X Tile_X0Y9_N4END[12] _0152_/X _4579_/X _4583_/X _2551_/Q _2550_/Q
+ VPWR VGND sg13cmos5l_mux4_1
XFILLER_49_15 VPWR VGND sg13cmos5l_decap_8
X_4459_ _4459_/X _4418_/X _0157_/X _4417_/X _0143_/X _2221_/Q _2220_/Q VPWR VGND sg13cmos5l_mux4_1
XFILLER_667_163 VPWR VGND sg13cmos5l_decap_8
XFILLER_49_37 VPWR VGND sg13cmos5l_fill_2
XFILLER_131_154 VPWR VGND sg13cmos5l_decap_8
XFILLER_466_236 VPWR VGND sg13cmos5l_decap_8
XFILLER_320_243 VPWR VGND sg13cmos5l_decap_8
XFILLER_172_49 VPWR VGND sg13cmos5l_decap_4
XFILLER_682_133 VPWR VGND sg13cmos5l_decap_8
XFILLER_290_8 VPWR VGND sg13cmos5l_decap_8
XFILLER_105_21 VPWR VGND sg13cmos5l_decap_8
XFILLER_533_81 VPWR VGND sg13cmos5l_decap_8
XFILLER_85_230 VPWR VGND sg13cmos5l_fill_2
XFILLER_608_263 VPWR VGND sg13cmos5l_decap_8
XFILLER_283_7 VPWR VGND sg13cmos5l_decap_8
XANTENNA__3280__X Tile_X0Y0_E6BEG[0] VPWR VGND sg13cmos5l_antennanp
XFILLER_65_14 VPWR VGND sg13cmos5l_decap_8
XFILLER_434_122 VPWR VGND sg13cmos5l_decap_8
XFILLER_419_196 VPWR VGND sg13cmos5l_decap_8
XFILLER_105_98 VPWR VGND sg13cmos5l_decap_4
XANTENNA_104 _0157_/X VPWR VGND sg13cmos5l_antennanp
XFILLER_450_7 VPWR VGND sg13cmos5l_decap_8
XFILLER_402_63 VPWR VGND sg13cmos5l_decap_8
XANTENNA_115 _0157_/X VPWR VGND sg13cmos5l_antennanp
XANTENNA_126 Tile_X0Y6_FrameData[31] VPWR VGND sg13cmos5l_antennanp
XFILLER_548_7 VPWR VGND sg13cmos5l_decap_8
XANTENNA_137 Tile_X0Y6_FrameData[31] VPWR VGND sg13cmos5l_antennanp
XFILLER_164_4 VPWR VGND sg13cmos5l_fill_1
XANTENNA_148 Tile_X0Y9_FrameStrobe[12] VPWR VGND sg13cmos5l_antennanp
XFILLER_121_42 VPWR VGND sg13cmos5l_decap_8
XFILLER_198_110 VPWR VGND sg13cmos5l_fill_1
XANTENNA_159 Tile_X0Y9_FrameStrobe[8] VPWR VGND sg13cmos5l_antennanp
XFILLER_198_132 VPWR VGND sg13cmos5l_fill_2
XFILLER_478_56 VPWR VGND sg13cmos5l_decap_8
XFILLER_241_272 VPWR VGND sg13cmos5l_fill_1
XFILLER_715_7 VPWR VGND sg13cmos5l_decap_8
XFILLER_197_35 VPWR VGND sg13cmos5l_decap_8
XFILLER_81_68 VPWR VGND sg13cmos5l_decap_8
XFILLER_628_15 VPWR VGND sg13cmos5l_decap_8
XFILLER_478_89 VPWR VGND sg13cmos5l_decap_8
XFILLER_139_210 VPWR VGND sg13cmos5l_decap_8
XFILLER_201_158 VPWR VGND sg13cmos5l_decap_8
XFILLER_14_84 VPWR VGND sg13cmos5l_decap_8
XFILLER_355_140 VPWR VGND sg13cmos5l_decap_8
XFILLER_347_49 VPWR VGND sg13cmos5l_decap_8
XFILLER_154_224 VPWR VGND sg13cmos5l_fill_2
XFILLER_708_70 VPWR VGND sg13cmos5l_decap_8
XFILLER_494_77 VPWR VGND sg13cmos5l_decap_8
XFILLER_644_14 VPWR VGND sg13cmos5l_decap_8
XFILLER_504_126 VPWR VGND sg13cmos5l_decap_8
XANTENNA__3455__X Tile_X0Y1_FrameData_O[13] VPWR VGND sg13cmos5l_antennanp
XFILLER_205_0 VPWR VGND sg13cmos5l_decap_8
XFILLER_370_143 VPWR VGND sg13cmos5l_decap_8
XFILLER_5_256 VPWR VGND sg13cmos5l_decap_4
XFILLER_30_61 VPWR VGND sg13cmos5l_fill_2
XFILLER_363_15 VPWR VGND sg13cmos5l_decap_8
XFILLER_122_132 VPWR VGND sg13cmos5l_decap_8
XFILLER_658_174 VPWR VGND sg13cmos5l_decap_8
XFILLER_457_236 VPWR VGND sg13cmos5l_decap_8
XFILLER_660_35 VPWR VGND sg13cmos5l_decap_8
XFILLER_574_0 VPWR VGND sg13cmos5l_decap_8
XFILLER_472_228 VPWR VGND sg13cmos5l_decap_4
XANTENNA__3190__X Tile_X0Y0_N4BEG[14] VPWR VGND sg13cmos5l_antennanp
XFILLER_673_188 VPWR VGND sg13cmos5l_decap_8
XFILLER_276_180 VPWR VGND sg13cmos5l_decap_8
XFILLER_209_247 VPWR VGND sg13cmos5l_decap_8
X_0140_ _0140_/X _4443_/X _4444_/X _1357_/Q VPWR VGND sg13cmos5l_mux2_1
XFILLER_425_133 VPWR VGND sg13cmos5l_decap_8
XFILLER_36_149 VPWR VGND sg13cmos5l_decap_8
X_0071_ AXI_M_SOC_WSTRB0 _0935_/Q _3722_/X VPWR VGND sg13cmos5l_or2_1
XFILLER_440_147 VPWR VGND sg13cmos5l_fill_1
XFILLER_378_254 VPWR VGND sg13cmos5l_decap_8
X_3830_ _3830_/X Tile_X0Y0_WW4END[5] Tile_X0Y0_WW4END[10] _3886_/X _3856_/X _1045_/Q
+ _1044_/Q VPWR VGND sg13cmos5l_mux4_1
XFILLER_189_187 VPWR VGND sg13cmos5l_fill_1
XFILLER_388_89 VPWR VGND sg13cmos5l_decap_8
XFILLER_685_21 VPWR VGND sg13cmos5l_decap_4
XFILLER_594_173 VPWR VGND sg13cmos5l_decap_8
X_3761_ _3761_/X Tile_X0Y1_WW4END[2] Tile_X0Y1_WW4END[10] Tile_X0Y1_W6END[2] _4010_/X
+ _1253_/Q _1252_/Q VPWR VGND sg13cmos5l_mux4_1
X_0973_ _0973_/Q Tile_X0Y0_FrameData[30] VGND VPWR Tile_X0Y9_FrameStrobe[1] latch
XFILLER_393_268 VPWR VGND sg13cmos5l_decap_4
X_2712_ _4425_/A3 VPWR VGND sg13cmos5l_tielo
X_3692_ AXI_M_SOC_WDATA2 Tile_X0Y7_WW4END[2] Tile_X0Y7_WW4END[10] Tile_X0Y7_W6END[2]
+ _4686_/X _0243_/Q _0242_/Q VPWR VGND sg13cmos5l_mux4_1
XFILLER_257_49 VPWR VGND sg13cmos5l_decap_4
XFILLER_618_70 VPWR VGND sg13cmos5l_decap_8
XFILLER_346_173 VPWR VGND sg13cmos5l_fill_2
X_2643_ _2643_/Q Tile_X0Y6_FrameData[20] VGND VPWR Tile_X0Y9_FrameStrobe[6] latch
XFILLER_554_14 VPWR VGND sg13cmos5l_decap_8
XANTENNA__3365__X Tile_X0Y2_EE4BEG[4] VPWR VGND sg13cmos5l_antennanp
XFILLER_550_254 VPWR VGND sg13cmos5l_decap_8
XFILLER_160_216 VPWR VGND sg13cmos5l_decap_8
X_2574_ _2574_/Q Tile_X0Y6_FrameData[25] VGND VPWR Tile_X0Y9_FrameStrobe[4] latch
XFILLER_361_176 VPWR VGND sg13cmos5l_decap_8
XFILLER_649_130 VPWR VGND sg13cmos5l_fill_2
XFILLER_299_261 VPWR VGND sg13cmos5l_decap_4
X_4313_ _4313_/X _4237_/X _4353_/X _4352_/X _4236_/X _1949_/Q _1948_/Q VPWR VGND sg13cmos5l_mux4_1
XFILLER_302_210 VPWR VGND sg13cmos5l_decap_4
XFILLER_299_272 VPWR VGND sg13cmos5l_fill_1
X_1525_ _1525_/Q Tile_X0Y2_FrameData[28] VGND VPWR Tile_X0Y9_FrameStrobe[3] latch
XFILLER_704_28 VPWR VGND sg13cmos5l_decap_8
XFILLER_259_125 VPWR VGND sg13cmos5l_fill_2
XFILLER_649_185 VPWR VGND sg13cmos5l_decap_8
XFILLER_634_91 VPWR VGND sg13cmos5l_decap_8
XFILLER_206_42 VPWR VGND sg13cmos5l_decap_8
X_4244_ _4244_/X Tile_X0Y2_W1END[0] Tile_X0Y2_W2MID[3] Tile_X0Y2_W2END[3] _4102_/X
+ _1621_/Q _1620_/Q VPWR VGND sg13cmos5l_mux4_1
XFILLER_664_133 VPWR VGND sg13cmos5l_decap_8
X_1456_ _1456_/Q Tile_X0Y2_FrameData[1] VGND VPWR Tile_X0Y9_FrameStrobe[0] latch
XFILLER_570_35 VPWR VGND sg13cmos5l_decap_8
XFILLER_353_70 VPWR VGND sg13cmos5l_decap_8
X_0407_ _0407_/Q Tile_X0Y7_FrameData[8] VGND VPWR Tile_X0Y9_FrameStrobe[7] latch
XFILLER_664_177 VPWR VGND sg13cmos5l_decap_8
X_1387_ _1387_/Q Tile_X0Y1_FrameData[14] VGND VPWR Tile_X0Y9_FrameStrobe[6] latch
X_4175_ _4175_/X Tile_X0Y3_WW4END[4] AXI_M_SOC_WREADY _4226_/X _4210_/X _1791_/Q _1790_/Q
+ VPWR VGND sg13cmos5l_mux4_1
X_3126_ Tile_X0Y7_EE4BEG[12] _4640_/X VPWR VGND sg13cmos5l_buf_1
X_0338_ _0338_/Q Tile_X0Y7_FrameData[13] VGND VPWR Tile_X0Y9_FrameStrobe[5] latch
XFILLER_605_244 VPWR VGND sg13cmos5l_decap_8
XFILLER_503_84 VPWR VGND sg13cmos5l_decap_8
XFILLER_416_155 VPWR VGND sg13cmos5l_decap_8
XFILLER_471_250 VPWR VGND sg13cmos5l_decap_8
XFILLER_282_161 VPWR VGND sg13cmos5l_decap_8
XFILLER_222_63 VPWR VGND sg13cmos5l_decap_8
X_0269_ _0269_/Q Tile_X0Y7_FrameData[18] VGND VPWR Tile_X0Y9_FrameStrobe[3] latch
X_3057_ Tile_X0Y5_FrameData_O[16] Tile_X0Y5_FrameData[16] VPWR VGND sg13cmos5l_buf_1
XFILLER_35_28 VPWR VGND sg13cmos5l_fill_2
XFILLER_620_225 VPWR VGND sg13cmos5l_fill_2
XFILLER_577_129 VPWR VGND sg13cmos5l_decap_8
X_2008_ _2008_/Q Tile_X0Y4_FrameData[13] VGND VPWR Tile_X0Y9_FrameStrobe[2] latch
XFILLER_579_77 VPWR VGND sg13cmos5l_decap_8
XFILLER_431_147 VPWR VGND sg13cmos5l_decap_8
XFILLER_369_221 VPWR VGND sg13cmos5l_decap_4
XFILLER_223_261 VPWR VGND sg13cmos5l_fill_1
XFILLER_298_56 VPWR VGND sg13cmos5l_decap_8
XFILLER_223_272 VPWR VGND sg13cmos5l_fill_1
XFILLER_50_141 VPWR VGND sg13cmos5l_fill_1
XFILLER_595_21 VPWR VGND sg13cmos5l_decap_8
XFILLER_329_118 VPWR VGND sg13cmos5l_decap_8
XFILLER_585_195 VPWR VGND sg13cmos5l_decap_8
X_3959_ _3959_/X Tile_X0Y1_WW4END[4] AXI_M_SOC_ARREADY _4012_/X _3994_/X _1291_/Q
+ _1290_/Q VPWR VGND sg13cmos5l_mux4_1
XFILLER_195_168 VPWR VGND sg13cmos5l_decap_8
XFILLER_384_268 VPWR VGND sg13cmos5l_decap_4
XFILLER_195_179 VPWR VGND sg13cmos5l_fill_1
XFILLER_526_251 VPWR VGND sg13cmos5l_decap_8
XFILLER_129_7 VPWR VGND sg13cmos5l_decap_8
XFILLER_167_49 VPWR VGND sg13cmos5l_decap_8
XFILLER_528_70 VPWR VGND sg13cmos5l_fill_1
XFILLER_136_235 VPWR VGND sg13cmos5l_decap_8
XFILLER_541_210 VPWR VGND sg13cmos5l_decap_8
XFILLER_528_92 VPWR VGND sg13cmos5l_decap_8
XFILLER_464_14 VPWR VGND sg13cmos5l_decap_8
XFILLER_337_195 VPWR VGND sg13cmos5l_decap_8
XFILLER_303_8 VPWR VGND sg13cmos5l_decap_8
XANTENNA__3275__X Tile_X0Y0_EE4BEG[11] VPWR VGND sg13cmos5l_antennanp
XFILLER_687_225 VPWR VGND sg13cmos5l_fill_1
XFILLER_498_147 VPWR VGND sg13cmos5l_decap_8
XFILLER_352_154 VPWR VGND sg13cmos5l_decap_8
XFILLER_687_247 VPWR VGND sg13cmos5l_decap_8
XFILLER_541_265 VPWR VGND sg13cmos5l_decap_8
XFILLER_183_26 VPWR VGND sg13cmos5l_fill_1
XFILLER_2_237 VPWR VGND sg13cmos5l_decap_8
XFILLER_183_48 VPWR VGND sg13cmos5l_decap_8
XFILLER_614_28 VPWR VGND sg13cmos5l_decap_8
XFILLER_498_7 VPWR VGND sg13cmos5l_decap_8
XFILLER_116_42 VPWR VGND sg13cmos5l_decap_8
XFILLER_333_29 VPWR VGND sg13cmos5l_decap_8
XFILLER_480_35 VPWR VGND sg13cmos5l_decap_8
XFILLER_263_81 VPWR VGND sg13cmos5l_decap_8
XFILLER_76_35 VPWR VGND sg13cmos5l_decap_8
XFILLER_665_7 VPWR VGND sg13cmos5l_decap_8
XFILLER_670_114 VPWR VGND sg13cmos5l_fill_1
XFILLER_407_111 VPWR VGND sg13cmos5l_fill_2
XFILLER_76_79 VPWR VGND sg13cmos5l_decap_8
XFILLER_670_136 VPWR VGND sg13cmos5l_decap_8
XFILLER_258_191 VPWR VGND sg13cmos5l_decap_8
XFILLER_18_105 VPWR VGND sg13cmos5l_fill_1
XFILLER_630_49 VPWR VGND sg13cmos5l_decap_8
XFILLER_413_84 VPWR VGND sg13cmos5l_decap_8
XFILLER_206_206 VPWR VGND sg13cmos5l_decap_8
XFILLER_132_63 VPWR VGND sg13cmos5l_decap_8
XFILLER_462_272 VPWR VGND sg13cmos5l_fill_1
XFILLER_73_255 VPWR VGND sg13cmos5l_fill_1
XFILLER_611_225 VPWR VGND sg13cmos5l_fill_1
XFILLER_92_56 VPWR VGND sg13cmos5l_decap_8
XFILLER_422_147 VPWR VGND sg13cmos5l_decap_8
XFILLER_611_247 VPWR VGND sg13cmos5l_decap_8
XFILLER_489_77 VPWR VGND sg13cmos5l_decap_8
XFILLER_639_14 VPWR VGND sg13cmos5l_decap_8
XFILLER_611_269 VPWR VGND sg13cmos5l_decap_4
XFILLER_155_0 VPWR VGND sg13cmos5l_decap_8
XFILLER_186_102 VPWR VGND sg13cmos5l_decap_8
XFILLER_375_202 VPWR VGND sg13cmos5l_decap_4
XFILLER_41_196 VPWR VGND sg13cmos5l_decap_8
XFILLER_322_0 VPWR VGND sg13cmos5l_decap_8
XFILLER_375_268 VPWR VGND sg13cmos5l_decap_4
XFILLER_186_179 VPWR VGND sg13cmos5l_decap_8
XFILLER_591_154 VPWR VGND sg13cmos5l_fill_1
XFILLER_517_240 VPWR VGND sg13cmos5l_fill_1
XFILLER_390_205 VPWR VGND sg13cmos5l_fill_2
XFILLER_591_165 VPWR VGND sg13cmos5l_decap_4
XFILLER_655_35 VPWR VGND sg13cmos5l_decap_4
XFILLER_127_224 VPWR VGND sg13cmos5l_decap_8
XFILLER_438_70 VPWR VGND sg13cmos5l_decap_8
XFILLER_390_238 VPWR VGND sg13cmos5l_decap_8
XFILLER_655_57 VPWR VGND sg13cmos5l_decap_8
XFILLER_532_210 VPWR VGND sg13cmos5l_decap_8
XFILLER_41_82 VPWR VGND sg13cmos5l_decap_4
XANTENNA__3185__X Tile_X0Y0_N4BEG[9] VPWR VGND sg13cmos5l_antennanp
XFILLER_127_268 VPWR VGND sg13cmos5l_decap_4
XFILLER_374_36 VPWR VGND sg13cmos5l_fill_2
XFILLER_343_143 VPWR VGND sg13cmos5l_fill_1
XFILLER_343_165 VPWR VGND sg13cmos5l_decap_8
XFILLER_142_216 VPWR VGND sg13cmos5l_decap_8
XFILLER_51_8 VPWR VGND sg13cmos5l_fill_1
XFILLER_691_0 VPWR VGND sg13cmos5l_decap_8
XFILLER_524_28 VPWR VGND sg13cmos5l_decap_8
X_1310_ _1310_/Q Tile_X0Y1_FrameData[27] VGND VPWR Tile_X0Y9_FrameStrobe[4] latch
XFILLER_500_140 VPWR VGND sg13cmos5l_decap_8
XFILLER_150_271 VPWR VGND sg13cmos5l_fill_2
X_2290_ _2290_/Q Tile_X0Y5_FrameData[19] VGND VPWR Tile_X0Y9_FrameStrobe[3] latch
XFILLER_646_133 VPWR VGND sg13cmos5l_decap_8
XFILLER_671_89 VPWR VGND sg13cmos5l_fill_2
XFILLER_390_35 VPWR VGND sg13cmos5l_decap_8
XFILLER_173_81 VPWR VGND sg13cmos5l_decap_4
XFILLER_2_21 VPWR VGND sg13cmos5l_decap_8
X_1241_ _1241_/Q Tile_X0Y1_FrameData[0] VGND VPWR Tile_X0Y9_FrameStrobe[1] latch
XFILLER_661_103 VPWR VGND sg13cmos5l_decap_8
XFILLER_661_114 VPWR VGND sg13cmos5l_fill_2
XFILLER_49_263 VPWR VGND sg13cmos5l_decap_8
X_1172_ _1172_/Q Tile_X0Y0_FrameData[23] VGND VPWR Tile_X0Y9_FrameStrobe[7] latch
XFILLER_323_73 VPWR VGND sg13cmos5l_decap_8
XFILLER_540_49 VPWR VGND sg13cmos5l_decap_8
XFILLER_453_250 VPWR VGND sg13cmos5l_decap_8
XFILLER_2_98 VPWR VGND sg13cmos5l_decap_8
X_0123_ AXI_M_SOC_ARSIZE2 _0932_/Q _3770_/X VPWR VGND sg13cmos5l_nor2b_1
XANTENNA__0049__X AXI_M_SOC_AWCACHE0 VPWR VGND sg13cmos5l_antennanp
XFILLER_453_272 VPWR VGND sg13cmos5l_fill_1
XFILLER_264_183 VPWR VGND sg13cmos5l_fill_2
XFILLER_413_147 VPWR VGND sg13cmos5l_decap_8
X_0054_ _0054_/X _4680_/X _4681_/X _1857_/Q VPWR VGND sg13cmos5l_mux2_1
X_4931_ _4931_/X Tile_X0Y9_N1END[3] Tile_X0Y9_N4END[3] _4899_/X _0080_/X _0697_/Q
+ _0696_/Q VPWR VGND sg13cmos5l_mux4_1
XFILLER_549_14 VPWR VGND sg13cmos5l_decap_8
XFILLER_696_42 VPWR VGND sg13cmos5l_decap_8
XFILLER_567_140 VPWR VGND sg13cmos5l_decap_8
XFILLER_32_130 VPWR VGND sg13cmos5l_fill_1
X_4862_ _4862_/X Tile_X0Y9_W2END[1] AXI_M_SOC_RDATA1 _4903_/X _4902_/X _0819_/Q _0818_/Q
+ VPWR VGND sg13cmos5l_mux4_1
XFILLER_32_152 VPWR VGND sg13cmos5l_decap_8
XFILLER_177_124 VPWR VGND sg13cmos5l_decap_8
X_3813_ _3813_/X Tile_X0Y0_W2MID[4] Tile_X0Y0_W2END[6] _3855_/X _3854_/X _1079_/Q
+ _1078_/Q VPWR VGND sg13cmos5l_mux4_1
XANTENNA_15 AXI_M_SOC_RDATA26 VPWR VGND sg13cmos5l_antennanp
XANTENNA_26 AXI_M_SOC_RDATA26 VPWR VGND sg13cmos5l_antennanp
X_4793_ _4793_/X _4340_/X _4344_/X _4348_/X _4318_/X _2121_/Q _2120_/Q VPWR VGND sg13cmos5l_mux4_1
XANTENNA_37 AXI_M_SOC_RDATA26 VPWR VGND sg13cmos5l_antennanp
XANTENNA_48 Tile_X0Y0_FrameData[25] VPWR VGND sg13cmos5l_antennanp
XFILLER_716_148 VPWR VGND sg13cmos5l_decap_8
XFILLER_629_91 VPWR VGND sg13cmos5l_decap_8
XFILLER_381_205 VPWR VGND sg13cmos5l_decap_8
XANTENNA_59 Tile_X0Y0_FrameData[25] VPWR VGND sg13cmos5l_antennanp
X_3744_ AXI_M_SOC_ARADDR16 Tile_X0Y8_WW4END[0] Tile_X0Y8_WW4END[8] Tile_X0Y8_W6END[0]
+ _4800_/X _0503_/Q _0502_/Q VPWR VGND sg13cmos5l_mux4_1
XFILLER_118_213 VPWR VGND sg13cmos5l_fill_1
X_0956_ _0956_/Q Tile_X0Y0_FrameData[15] VGND VPWR Tile_X0Y9_FrameStrobe[0] latch
XFILLER_70_0 VPWR VGND sg13cmos5l_decap_4
XFILLER_582_176 VPWR VGND sg13cmos5l_decap_8
XFILLER_565_35 VPWR VGND sg13cmos5l_decap_8
XFILLER_348_70 VPWR VGND sg13cmos5l_decap_8
XFILLER_192_149 VPWR VGND sg13cmos5l_decap_8
XFILLER_523_221 VPWR VGND sg13cmos5l_decap_8
XFILLER_284_14 VPWR VGND sg13cmos5l_decap_8
X_3675_ _3675_/X Tile_X0Y2_WW4END[5] Tile_X0Y2_WW4END[13] Tile_X0Y2_W6END[5] _4121_/X
+ _1495_/Q _1494_/Q VPWR VGND sg13cmos5l_mux4_1
XANTENNA__3095__X Tile_X0Y7_E2BEGb[1] VPWR VGND sg13cmos5l_antennanp
XFILLER_118_268 VPWR VGND sg13cmos5l_decap_4
X_0887_ _0887_/Q Tile_X0Y9_FrameData[8] VGND VPWR Tile_X0Y9_FrameStrobe[6] latch
XFILLER_669_225 VPWR VGND sg13cmos5l_fill_1
X_2626_ _2626_/Q Tile_X0Y6_FrameData[5] VGND VPWR Tile_X0Y9_FrameStrobe[5] latch
XFILLER_669_247 VPWR VGND sg13cmos5l_fill_1
XFILLER_133_227 VPWR VGND sg13cmos5l_decap_8
XFILLER_715_49 VPWR VGND sg13cmos5l_decap_8
XFILLER_334_176 VPWR VGND sg13cmos5l_decap_8
XFILLER_684_206 VPWR VGND sg13cmos5l_decap_8
XFILLER_434_28 VPWR VGND sg13cmos5l_decap_8
X_2557_ _2557_/Q Tile_X0Y6_FrameData[10] VGND VPWR Tile_X0Y9_FrameStrobe[3] latch
XFILLER_488_180 VPWR VGND sg13cmos5l_decap_8
XFILLER_99_163 VPWR VGND sg13cmos5l_decap_8
XFILLER_581_56 VPWR VGND sg13cmos5l_decap_8
XFILLER_364_91 VPWR VGND sg13cmos5l_decap_4
XFILLER_287_231 VPWR VGND sg13cmos5l_decap_8
X_1508_ _1508_/Q Tile_X0Y2_FrameData[13] VGND VPWR Tile_X0Y9_FrameStrobe[2] latch
X_2488_ _2488_/Q Tile_X0Y6_FrameData[15] VGND VPWR Tile_X0Y9_FrameStrobe[1] latch
XFILLER_101_135 VPWR VGND sg13cmos5l_fill_1
XFILLER_637_166 VPWR VGND sg13cmos5l_decap_8
X_4227_ _4227_/X _4197_/X _0088_/X _4196_/X Tile_X0Y0_S4END[13] _1719_/Q _1718_/Q
+ VPWR VGND sg13cmos5l_mux4_1
XFILLER_692_272 VPWR VGND sg13cmos5l_fill_1
XFILLER_247_128 VPWR VGND sg13cmos5l_decap_8
X_1439_ _1439_/Q Tile_X0Y2_FrameData[18] VGND VPWR Tile_X0Y9_FrameStrobe[0] latch
XFILLER_101_179 VPWR VGND sg13cmos5l_decap_8
XFILLER_55_200 VPWR VGND sg13cmos5l_fill_1
X_4158_ _4158_/X Tile_X0Y3_W2END[5] AXI_M_SOC_BVALID _4209_/X _4208_/X _1825_/Q _1824_/Q
+ VPWR VGND sg13cmos5l_mux4_1
XFILLER_55_222 VPWR VGND sg13cmos5l_decap_8
XFILLER_255_150 VPWR VGND sg13cmos5l_decap_8
X_3109_ Tile_X0Y7_E6BEG[7] _4651_/X VPWR VGND sg13cmos5l_buf_1
X_4089_ _4089_/X Tile_X0Y3_W1END[0] Tile_X0Y3_W6END[4] _4234_/X _4198_/X _1925_/Q
+ _1924_/Q VPWR VGND sg13cmos5l_mux4_1
XFILLER_255_194 VPWR VGND sg13cmos5l_decap_8
XFILLER_660_180 VPWR VGND sg13cmos5l_decap_8
XFILLER_15_119 VPWR VGND sg13cmos5l_fill_1
XFILLER_70_203 VPWR VGND sg13cmos5l_decap_8
XFILLER_459_14 VPWR VGND sg13cmos5l_decap_8
XFILLER_70_247 VPWR VGND sg13cmos5l_decap_8
XFILLER_23_130 VPWR VGND sg13cmos5l_decap_8
XFILLER_178_15 VPWR VGND sg13cmos5l_fill_2
XFILLER_412_191 VPWR VGND sg13cmos5l_decap_8
XFILLER_357_224 VPWR VGND sg13cmos5l_decap_8
XFILLER_23_174 VPWR VGND sg13cmos5l_decap_8
XFILLER_211_253 VPWR VGND sg13cmos5l_fill_2
XFILLER_609_28 VPWR VGND sg13cmos5l_decap_8
XFILLER_707_159 VPWR VGND sg13cmos5l_fill_2
XFILLER_573_154 VPWR VGND sg13cmos5l_decap_8
XANTENNA__2902__X Tile_X0Y6_FrameData_O[23] VPWR VGND sg13cmos5l_antennanp
XFILLER_413_7 VPWR VGND sg13cmos5l_decap_8
XFILLER_475_35 VPWR VGND sg13cmos5l_decap_8
XFILLER_258_70 VPWR VGND sg13cmos5l_decap_8
XFILLER_514_210 VPWR VGND sg13cmos5l_fill_1
XFILLER_194_14 VPWR VGND sg13cmos5l_decap_8
XFILLER_514_232 VPWR VGND sg13cmos5l_decap_8
XFILLER_325_143 VPWR VGND sg13cmos5l_decap_8
XFILLER_514_254 VPWR VGND sg13cmos5l_fill_1
XFILLER_325_154 VPWR VGND sg13cmos5l_decap_4
XFILLER_191_160 VPWR VGND sg13cmos5l_decap_4
XFILLER_340_102 VPWR VGND sg13cmos5l_fill_1
XFILLER_11_63 VPWR VGND sg13cmos5l_decap_8
XFILLER_625_49 VPWR VGND sg13cmos5l_decap_8
XFILLER_408_84 VPWR VGND sg13cmos5l_decap_8
XFILLER_340_124 VPWR VGND sg13cmos5l_decap_8
XANTENNA__0141__Y AXI_M_SOC_ARLEN1 VPWR VGND sg13cmos5l_antennanp
XFILLER_344_28 VPWR VGND sg13cmos5l_decap_8
XFILLER_127_63 VPWR VGND sg13cmos5l_fill_2
XFILLER_675_239 VPWR VGND sg13cmos5l_decap_8
XANTENNA__3733__X AXI_M_SOC_ARADDR5 VPWR VGND sg13cmos5l_antennanp
XFILLER_491_56 VPWR VGND sg13cmos5l_decap_8
XFILLER_278_231 VPWR VGND sg13cmos5l_decap_8
XFILLER_274_91 VPWR VGND sg13cmos5l_decap_4
XFILLER_628_122 VPWR VGND sg13cmos5l_fill_1
XFILLER_479_191 VPWR VGND sg13cmos5l_decap_8
XFILLER_132_271 VPWR VGND sg13cmos5l_fill_2
XFILLER_628_144 VPWR VGND sg13cmos5l_decap_8
XFILLER_87_78 VPWR VGND sg13cmos5l_decap_8
XFILLER_628_155 VPWR VGND sg13cmos5l_fill_1
XFILLER_494_161 VPWR VGND sg13cmos5l_decap_8
XFILLER_628_177 VPWR VGND sg13cmos5l_decap_8
XFILLER_427_217 VPWR VGND sg13cmos5l_decap_8
XFILLER_683_272 VPWR VGND sg13cmos5l_fill_1
XFILLER_293_245 VPWR VGND sg13cmos5l_decap_8
XFILLER_643_147 VPWR VGND sg13cmos5l_decap_8
XFILLER_360_49 VPWR VGND sg13cmos5l_decap_8
XFILLER_143_84 VPWR VGND sg13cmos5l_decap_8
XFILLER_442_209 VPWR VGND sg13cmos5l_fill_1
XFILLER_272_0 VPWR VGND sg13cmos5l_decap_8
XFILLER_246_172 VPWR VGND sg13cmos5l_decap_4
XFILLER_246_183 VPWR VGND sg13cmos5l_decap_8
XFILLER_246_194 VPWR VGND sg13cmos5l_decap_8
XFILLER_450_220 VPWR VGND sg13cmos5l_decap_8
XFILLER_261_131 VPWR VGND sg13cmos5l_decap_8
XFILLER_61_225 VPWR VGND sg13cmos5l_decap_8
XFILLER_369_14 VPWR VGND sg13cmos5l_decap_8
XFILLER_36_93 VPWR VGND sg13cmos5l_decap_8
XFILLER_537_0 VPWR VGND sg13cmos5l_decap_8
XFILLER_596_268 VPWR VGND sg13cmos5l_decap_4
XFILLER_159_102 VPWR VGND sg13cmos5l_fill_1
XFILLER_199_271 VPWR VGND sg13cmos5l_fill_2
XFILLER_549_162 VPWR VGND sg13cmos5l_decap_8
XFILLER_348_213 VPWR VGND sg13cmos5l_decap_8
XFILLER_519_28 VPWR VGND sg13cmos5l_decap_8
XFILLER_14_196 VPWR VGND sg13cmos5l_fill_2
XFILLER_704_0 VPWR VGND sg13cmos5l_decap_8
XFILLER_666_56 VPWR VGND sg13cmos5l_decap_8
XFILLER_449_91 VPWR VGND sg13cmos5l_decap_8
XANTENNA__2812__X Tile_X0Y3_E2BEG[2] VPWR VGND sg13cmos5l_antennanp
X_0810_ _0810_/Q Tile_X0Y9_FrameData[21] VGND VPWR Tile_X0Y9_FrameStrobe[4] latch
X_1790_ _1790_/Q Tile_X0Y3_FrameData[11] VGND VPWR Tile_X0Y9_FrameStrobe[3] latch
XFILLER_564_198 VPWR VGND sg13cmos5l_decap_8
XFILLER_316_110 VPWR VGND sg13cmos5l_decap_8
XFILLER_168_92 VPWR VGND sg13cmos5l_decap_8
X_0741_ _0741_/Q Tile_X0Y9_FrameData[26] VGND VPWR Tile_X0Y9_FrameStrobe[2] latch
XFILLER_115_216 VPWR VGND sg13cmos5l_decap_8
X_3460_ Tile_X0Y1_FrameData_O[18] Tile_X0Y1_FrameData[18] VPWR VGND sg13cmos5l_buf_1
X_0672_ _0672_/Q Tile_X0Y8_FrameData[31] VGND VPWR Tile_X0Y9_FrameStrobe[0] latch
XFILLER_535_49 VPWR VGND sg13cmos5l_decap_8
XFILLER_318_84 VPWR VGND sg13cmos5l_decap_8
XFILLER_682_55 VPWR VGND sg13cmos5l_decap_8
XANTENNA__0051__Y AXI_M_SOC_AWBURST1 VPWR VGND sg13cmos5l_antennanp
X_2411_ _2411_/Q Tile_X0Y5_FrameData[26] VGND VPWR Tile_X0Y9_FrameStrobe[7] latch
XFILLER_520_235 VPWR VGND sg13cmos5l_decap_8
XFILLER_477_128 VPWR VGND sg13cmos5l_decap_8
XFILLER_254_28 VPWR VGND sg13cmos5l_decap_8
X_3391_ Tile_X0Y2_E2BEGb[2] _4050_/X VPWR VGND sg13cmos5l_buf_1
XFILLER_42_4 VPWR VGND sg13cmos5l_fill_1
XANTENNA__3643__X AXI_M_SOC_AWADDR4 VPWR VGND sg13cmos5l_antennanp
X_2342_ _2342_/Q Tile_X0Y5_FrameData[31] VGND VPWR Tile_X0Y9_FrameStrobe[5] latch
XFILLER_615_93 VPWR VGND sg13cmos5l_decap_8
XFILLER_96_144 VPWR VGND sg13cmos5l_decap_8
XFILLER_334_72 VPWR VGND sg13cmos5l_decap_8
X_2273_ _2273_/Q Tile_X0Y5_FrameData[4] VGND VPWR Tile_X0Y9_FrameStrobe[2] latch
XFILLER_284_245 VPWR VGND sg13cmos5l_decap_8
X_4012_ _4012_/X _3981_/X _0073_/X _3980_/X Tile_X0Y0_S4END[4] _1225_/Q _1224_/Q VPWR
+ VGND sg13cmos5l_mux4_1
XFILLER_284_256 VPWR VGND sg13cmos5l_fill_1
X_1224_ _1224_/Q Tile_X0Y1_FrameData[17] VGND VPWR Tile_X0Y9_FrameStrobe[1] latch
XFILLER_634_147 VPWR VGND sg13cmos5l_decap_4
XFILLER_270_49 VPWR VGND sg13cmos5l_decap_8
XFILLER_631_70 VPWR VGND sg13cmos5l_decap_8
XFILLER_37_222 VPWR VGND sg13cmos5l_decap_8
XFILLER_203_21 VPWR VGND sg13cmos5l_decap_8
X_1155_ _1155_/Q Tile_X0Y0_FrameData[8] VGND VPWR Tile_X0Y9_FrameStrobe[6] latch
XFILLER_441_220 VPWR VGND sg13cmos5l_fill_2
XFILLER_587_213 VPWR VGND sg13cmos5l_decap_8
X_0106_ AXI_M_SOC_ARLEN3 _0933_/Q _3763_/X VPWR VGND sg13cmos5l_nor2b_1
XFILLER_203_98 VPWR VGND sg13cmos5l_decap_8
X_1086_ _1086_/Q Tile_X0Y0_FrameData[13] VGND VPWR Tile_X0Y9_FrameStrobe[4] latch
XFILLER_279_14 VPWR VGND sg13cmos5l_decap_8
XFILLER_587_268 VPWR VGND sg13cmos5l_decap_4
XFILLER_252_186 VPWR VGND sg13cmos5l_decap_8
X_4914_ _4914_/X Tile_X0Y5_W1END[3] Tile_X0Y5_WW4END[15] Tile_X0Y5_W6END[7] _4454_/X
+ _2370_/Q _2369_/Q VPWR VGND sg13cmos5l_mux4_1
XFILLER_500_63 VPWR VGND sg13cmos5l_decap_8
XFILLER_555_110 VPWR VGND sg13cmos5l_decap_8
X_4845_ _4845_/X Tile_X0Y9_N1END[1] _4897_/X AXI_M_SOC_RDATA2 AXI_M_SOC_RDATA6 _0853_/Q
+ _0852_/Q VPWR VGND sg13cmos5l_mux4_1
XFILLER_429_28 VPWR VGND sg13cmos5l_decap_8
XFILLER_576_56 VPWR VGND sg13cmos5l_decap_8
XFILLER_359_91 VPWR VGND sg13cmos5l_decap_8
XFILLER_555_154 VPWR VGND sg13cmos5l_decap_8
X_4776_ _4776_/X Tile_X0Y7_W1END[0] Tile_X0Y7_W6END[8] _4696_/X _4656_/X _0379_/Q
+ _0378_/Q VPWR VGND sg13cmos5l_mux4_1
X_1988_ _1988_/Q Tile_X0Y4_FrameData[1] VGND VPWR Tile_X0Y9_FrameStrobe[1] latch
XFILLER_555_198 VPWR VGND sg13cmos5l_fill_2
XFILLER_354_238 VPWR VGND sg13cmos5l_decap_8
XFILLER_295_57 VPWR VGND sg13cmos5l_decap_8
X_3727_ AXI_M_SOC_BREADY Tile_X0Y3_W1END[1] Tile_X0Y3_WW4END[5] Tile_X0Y3_WW4END[13]
+ _4235_/X _1731_/Q _1730_/Q VPWR VGND sg13cmos5l_mux4_1
X_0939_ _0939_/Q Tile_X0Y9_FrameData[30] VGND VPWR Tile_X0Y9_FrameStrobe[8] latch
XFILLER_106_205 VPWR VGND sg13cmos5l_decap_8
XFILLER_570_168 VPWR VGND sg13cmos5l_decap_8
XFILLER_712_140 VPWR VGND sg13cmos5l_decap_8
XFILLER_228_73 VPWR VGND sg13cmos5l_decap_8
X_3658_ AXI_M_SOC_AWADDR19 Tile_X0Y4_WW4END[3] Tile_X0Y4_WW4END[11] Tile_X0Y4_W6END[3]
+ _4339_/X _2007_/Q _2006_/Q VPWR VGND sg13cmos5l_mux4_1
XFILLER_445_49 VPWR VGND sg13cmos5l_decap_8
XFILLER_362_271 VPWR VGND sg13cmos5l_fill_2
XFILLER_322_102 VPWR VGND sg13cmos5l_decap_8
XFILLER_322_113 VPWR VGND sg13cmos5l_fill_2
XFILLER_592_66 VPWR VGND sg13cmos5l_decap_8
X_2609_ _2609_/Q Tile_X0Y6_FrameData[22] VGND VPWR Tile_X0Y9_FrameStrobe[5] latch
XFILLER_592_88 VPWR VGND sg13cmos5l_decap_8
XFILLER_322_146 VPWR VGND sg13cmos5l_fill_1
XANTENNA__3553__X Tile_X0Y9_E6BEG[11] VPWR VGND sg13cmos5l_antennanp
X_3589_ Tile_X0Y9_FrameData_O[19] Tile_X0Y9_FrameData[19] VPWR VGND sg13cmos5l_buf_1
XFILLER_665_261 VPWR VGND sg13cmos5l_fill_1
XFILLER_665_272 VPWR VGND sg13cmos5l_fill_1
XFILLER_57_26 VPWR VGND sg13cmos5l_decap_8
XFILLER_87_155 VPWR VGND sg13cmos5l_decap_8
XFILLER_196_7 VPWR VGND sg13cmos5l_decap_8
XFILLER_57_48 VPWR VGND sg13cmos5l_fill_1
XFILLER_680_231 VPWR VGND sg13cmos5l_fill_2
XFILLER_180_49 VPWR VGND sg13cmos5l_decap_8
XFILLER_370_8 VPWR VGND sg13cmos5l_decap_8
XFILLER_625_169 VPWR VGND sg13cmos5l_decap_8
XFILLER_541_70 VPWR VGND sg13cmos5l_decap_8
XFILLER_417_250 VPWR VGND sg13cmos5l_decap_4
XFILLER_113_21 VPWR VGND sg13cmos5l_decap_8
XFILLER_541_81 VPWR VGND sg13cmos5l_fill_2
XFILLER_491_175 VPWR VGND sg13cmos5l_decap_8
XFILLER_290_248 VPWR VGND sg13cmos5l_decap_8
XFILLER_228_194 VPWR VGND sg13cmos5l_fill_2
XFILLER_73_14 VPWR VGND sg13cmos5l_decap_8
XFILLER_389_113 VPWR VGND sg13cmos5l_decap_8
XFILLER_432_231 VPWR VGND sg13cmos5l_decap_8
XFILLER_189_14 VPWR VGND sg13cmos5l_decap_8
XFILLER_432_264 VPWR VGND sg13cmos5l_decap_8
XFILLER_189_25 VPWR VGND sg13cmos5l_fill_1
XFILLER_243_186 VPWR VGND sg13cmos5l_decap_8
XFILLER_530_7 VPWR VGND sg13cmos5l_decap_8
XFILLER_410_63 VPWR VGND sg13cmos5l_decap_8
XANTENNA__0136__Y AXI_M_SOC_AWLEN3 VPWR VGND sg13cmos5l_antennanp
XFILLER_339_28 VPWR VGND sg13cmos5l_fill_2
XFILLER_546_132 VPWR VGND sg13cmos5l_fill_1
XFILLER_196_252 VPWR VGND sg13cmos5l_decap_4
XANTENNA__3728__X AXI_M_SOC_ARADDR0 VPWR VGND sg13cmos5l_antennanp
XFILLER_486_56 VPWR VGND sg13cmos5l_decap_8
XFILLER_400_161 VPWR VGND sg13cmos5l_decap_8
XFILLER_345_205 VPWR VGND sg13cmos5l_decap_8
XFILLER_269_91 VPWR VGND sg13cmos5l_fill_1
XFILLER_345_216 VPWR VGND sg13cmos5l_fill_1
XFILLER_7_126 VPWR VGND sg13cmos5l_fill_2
XFILLER_345_238 VPWR VGND sg13cmos5l_decap_8
XFILLER_11_188 VPWR VGND sg13cmos5l_fill_1
XFILLER_156_149 VPWR VGND sg13cmos5l_decap_8
XFILLER_22_84 VPWR VGND sg13cmos5l_decap_8
XFILLER_118_0 VPWR VGND sg13cmos5l_decap_8
XFILLER_171_119 VPWR VGND sg13cmos5l_decap_8
XFILLER_499_231 VPWR VGND sg13cmos5l_decap_8
XFILLER_353_260 VPWR VGND sg13cmos5l_fill_2
XFILLER_353_271 VPWR VGND sg13cmos5l_fill_2
XFILLER_313_102 VPWR VGND sg13cmos5l_decap_8
XFILLER_138_84 VPWR VGND sg13cmos5l_decap_8
XFILLER_164_182 VPWR VGND sg13cmos5l_decap_8
XFILLER_355_49 VPWR VGND sg13cmos5l_decap_8
XFILLER_716_70 VPWR VGND sg13cmos5l_decap_8
XFILLER_716_81 VPWR VGND sg13cmos5l_fill_1
XFILLER_502_224 VPWR VGND sg13cmos5l_decap_8
XFILLER_98_55 VPWR VGND sg13cmos5l_decap_8
XFILLER_703_195 VPWR VGND sg13cmos5l_decap_8
XFILLER_652_14 VPWR VGND sg13cmos5l_decap_8
XANTENNA__3463__X Tile_X0Y1_FrameData_O[21] VPWR VGND sg13cmos5l_antennanp
XFILLER_0_0 VPWR VGND sg13cmos5l_decap_8
XFILLER_487_0 VPWR VGND sg13cmos5l_decap_8
XFILLER_154_94 VPWR VGND sg13cmos5l_decap_8
XFILLER_120_263 VPWR VGND sg13cmos5l_fill_2
XFILLER_304_42 VPWR VGND sg13cmos5l_decap_8
XFILLER_451_70 VPWR VGND sg13cmos5l_decap_8
XFILLER_654_0 VPWR VGND sg13cmos5l_decap_8
XANTENNA__2807__X Tile_X0Y3_E2BEGb[5] VPWR VGND sg13cmos5l_antennanp
XFILLER_219_183 VPWR VGND sg13cmos5l_decap_8
XFILLER_93_169 VPWR VGND sg13cmos5l_decap_4
XFILLER_281_248 VPWR VGND sg13cmos5l_decap_8
XFILLER_234_120 VPWR VGND sg13cmos5l_decap_8
XFILLER_34_203 VPWR VGND sg13cmos5l_decap_8
XFILLER_569_224 VPWR VGND sg13cmos5l_decap_8
XFILLER_423_253 VPWR VGND sg13cmos5l_fill_2
XFILLER_601_84 VPWR VGND sg13cmos5l_decap_8
XFILLER_423_264 VPWR VGND sg13cmos5l_fill_1
XFILLER_234_175 VPWR VGND sg13cmos5l_decap_4
XFILLER_34_247 VPWR VGND sg13cmos5l_fill_1
XFILLER_234_186 VPWR VGND sg13cmos5l_fill_1
XFILLER_34_269 VPWR VGND sg13cmos5l_decap_4
X_2960_ Tile_X0Y8_FrameData_O[0] Tile_X0Y8_FrameData[0] VPWR VGND sg13cmos5l_buf_1
XFILLER_187_230 VPWR VGND sg13cmos5l_fill_1
X_1911_ _1911_/Q Tile_X0Y3_FrameData[18] VGND VPWR Tile_X0Y9_FrameStrobe[7] latch
XFILLER_63_91 VPWR VGND sg13cmos5l_decap_8
XFILLER_187_252 VPWR VGND sg13cmos5l_decap_8
X_2891_ Tile_X0Y6_FrameData_O[12] Tile_X0Y6_FrameData[12] VPWR VGND sg13cmos5l_buf_1
XANTENNA__3638__X Tile_X0Y9_UserCLKo VPWR VGND sg13cmos5l_antennanp
XFILLER_537_154 VPWR VGND sg13cmos5l_decap_8
X_4630_ _4630_/X Tile_X0Y7_WW4END[13] AXI_M_SOC_RDATA18 _4697_/X _4672_/X _0299_/Q
+ _0298_/Q VPWR VGND sg13cmos5l_mux4_1
XFILLER_8_42 VPWR VGND sg13cmos5l_decap_8
X_1842_ _1842_/Q Tile_X0Y3_FrameData[23] VGND VPWR Tile_X0Y9_FrameStrobe[5] latch
XFILLER_336_227 VPWR VGND sg13cmos5l_decap_8
XFILLER_693_21 VPWR VGND sg13cmos5l_decap_8
XFILLER_329_50 VPWR VGND sg13cmos5l_decap_8
XFILLER_552_124 VPWR VGND sg13cmos5l_decap_8
X_4561_ _4561_/X _4120_/X _4124_/X _4113_/X _4102_/X _1613_/Q _1612_/Q VPWR VGND sg13cmos5l_mux4_1
X_1773_ _1773_/Q Tile_X0Y3_FrameData[28] VGND VPWR Tile_X0Y9_FrameStrobe[3] latch
X_3512_ Tile_X0Y1_E2BEG[2] _3934_/X VPWR VGND sg13cmos5l_buf_1
XFILLER_155_171 VPWR VGND sg13cmos5l_decap_4
X_0724_ _0724_/Q Tile_X0Y9_FrameData[11] VGND VPWR Tile_X0Y9_FrameStrobe[1] latch
X_4492_ _4492_/X _4545_/X _4544_/X AXI_M_SOC_RDATA27 AXI_M_SOC_RDATA31 _2623_/Q _2622_/Q
+ VPWR VGND sg13cmos5l_mux4_1
XFILLER_265_49 VPWR VGND sg13cmos5l_decap_8
XFILLER_626_70 VPWR VGND sg13cmos5l_decap_8
XFILLER_155_193 VPWR VGND sg13cmos5l_decap_8
XFILLER_639_217 VPWR VGND sg13cmos5l_decap_8
X_3443_ Tile_X0Y1_FrameData_O[1] Tile_X0Y1_FrameData[1] VPWR VGND sg13cmos5l_buf_1
XFILLER_562_14 VPWR VGND sg13cmos5l_decap_8
XFILLER_304_146 VPWR VGND sg13cmos5l_decap_8
X_0655_ _0655_/Q Tile_X0Y8_FrameData[16] VGND VPWR Tile_X0Y9_FrameStrobe[7] latch
XANTENNA__3373__X Tile_X0Y2_EE4BEG[12] VPWR VGND sg13cmos5l_antennanp
XFILLER_170_185 VPWR VGND sg13cmos5l_fill_1
X_3374_ Tile_X0Y2_EE4BEG[13] _4069_/X VPWR VGND sg13cmos5l_buf_1
XFILLER_465_109 VPWR VGND sg13cmos5l_decap_8
X_0586_ _0586_/Q Tile_X0Y8_FrameData[21] VGND VPWR Tile_X0Y9_FrameStrobe[5] latch
XFILLER_33_0 VPWR VGND sg13cmos5l_decap_8
XFILLER_69_133 VPWR VGND sg13cmos5l_decap_8
X_2325_ _2325_/Q Tile_X0Y5_FrameData[16] VGND VPWR Tile_X0Y9_FrameStrobe[4] latch
XFILLER_712_28 VPWR VGND sg13cmos5l_decap_8
XFILLER_607_103 VPWR VGND sg13cmos5l_decap_4
XFILLER_607_125 VPWR VGND sg13cmos5l_fill_2
XFILLER_111_263 VPWR VGND sg13cmos5l_decap_8
XFILLER_642_91 VPWR VGND sg13cmos5l_decap_8
XFILLER_214_42 VPWR VGND sg13cmos5l_decap_8
X_2256_ _2256_/Q Tile_X0Y5_FrameData[21] VGND VPWR Tile_X0Y9_FrameStrobe[2] latch
XFILLER_473_153 VPWR VGND sg13cmos5l_decap_8
XFILLER_361_70 VPWR VGND sg13cmos5l_decap_8
XFILLER_84_147 VPWR VGND sg13cmos5l_decap_8
X_1207_ _1207_/Q Tile_X0Y1_FrameData[2] VGND VPWR Tile_X0Y9_FrameStrobe[0] latch
X_2187_ _2187_/Q Tile_X0Y5_FrameData[26] VGND VPWR Tile_X0Y9_FrameStrobe[0] latch
XFILLER_225_153 VPWR VGND sg13cmos5l_fill_2
XFILLER_225_164 VPWR VGND sg13cmos5l_fill_1
XFILLER_92_180 VPWR VGND sg13cmos5l_decap_4
X_1138_ _1138_/Q Tile_X0Y0_FrameData[25] VGND VPWR Tile_X0Y9_FrameStrobe[6] latch
XFILLER_511_84 VPWR VGND sg13cmos5l_decap_8
XFILLER_25_236 VPWR VGND sg13cmos5l_decap_8
XFILLER_225_186 VPWR VGND sg13cmos5l_decap_8
XFILLER_240_123 VPWR VGND sg13cmos5l_decap_8
X_1069_ _1069_/Q Tile_X0Y0_FrameData[30] VGND VPWR Tile_X0Y9_FrameStrobe[4] latch
XFILLER_630_194 VPWR VGND sg13cmos5l_decap_8
XFILLER_575_238 VPWR VGND sg13cmos5l_decap_8
XFILLER_386_138 VPWR VGND sg13cmos5l_decap_8
XFILLER_717_210 VPWR VGND sg13cmos5l_decap_8
XFILLER_386_149 VPWR VGND sg13cmos5l_fill_2
XFILLER_159_28 VPWR VGND sg13cmos5l_decap_8
XFILLER_587_77 VPWR VGND sg13cmos5l_decap_8
XFILLER_379_190 VPWR VGND sg13cmos5l_decap_8
XANTENNA__3548__X Tile_X0Y9_E6BEG[6] VPWR VGND sg13cmos5l_antennanp
XFILLER_138_105 VPWR VGND sg13cmos5l_decap_8
XFILLER_717_254 VPWR VGND sg13cmos5l_decap_8
X_4828_ _4828_/X Tile_X0Y9_W2MID[7] Tile_X0Y9_W2END[7] Tile_X0Y9_W6END[8] _4901_/X
+ _0883_/Q _0882_/Q VPWR VGND sg13cmos5l_mux4_1
XFILLER_528_165 VPWR VGND sg13cmos5l_fill_2
XFILLER_583_271 VPWR VGND sg13cmos5l_fill_2
XFILLER_193_233 VPWR VGND sg13cmos5l_decap_8
XFILLER_689_106 VPWR VGND sg13cmos5l_decap_8
X_4759_ _4759_/X Tile_X0Y8_WW4END[0] AXI_M_SOC_RDATA8 _4800_/X _4785_/X _0529_/Q _0528_/Q
+ VPWR VGND sg13cmos5l_mux4_1
XFILLER_239_83 VPWR VGND sg13cmos5l_decap_8
XFILLER_111_7 VPWR VGND sg13cmos5l_decap_8
XFILLER_146_171 VPWR VGND sg13cmos5l_decap_8
XFILLER_175_49 VPWR VGND sg13cmos5l_decap_8
XFILLER_209_7 VPWR VGND sg13cmos5l_decap_8
XFILLER_108_21 VPWR VGND sg13cmos5l_decap_8
XFILLER_536_70 VPWR VGND sg13cmos5l_fill_2
XFILLER_697_161 VPWR VGND sg13cmos5l_fill_1
XFILLER_536_81 VPWR VGND sg13cmos5l_fill_1
XFILLER_350_230 VPWR VGND sg13cmos5l_decap_8
XFILLER_472_14 VPWR VGND sg13cmos5l_decap_8
XANTENNA__3283__X Tile_X0Y0_E6BEG[3] VPWR VGND sg13cmos5l_antennanp
XFILLER_161_152 VPWR VGND sg13cmos5l_fill_1
XFILLER_68_14 VPWR VGND sg13cmos5l_decap_8
XFILLER_255_71 VPWR VGND sg13cmos5l_decap_8
XFILLER_161_174 VPWR VGND sg13cmos5l_decap_8
XFILLER_638_272 VPWR VGND sg13cmos5l_fill_1
XFILLER_480_7 VPWR VGND sg13cmos5l_decap_8
XFILLER_622_28 VPWR VGND sg13cmos5l_decap_8
XFILLER_405_63 VPWR VGND sg13cmos5l_decap_8
XFILLER_578_7 VPWR VGND sg13cmos5l_decap_8
XFILLER_449_194 VPWR VGND sg13cmos5l_decap_8
XFILLER_124_42 VPWR VGND sg13cmos5l_decap_8
XFILLER_653_253 VPWR VGND sg13cmos5l_decap_4
XFILLER_271_70 VPWR VGND sg13cmos5l_decap_4
XFILLER_263_215 VPWR VGND sg13cmos5l_decap_8
XFILLER_84_35 VPWR VGND sg13cmos5l_decap_8
XFILLER_613_128 VPWR VGND sg13cmos5l_decap_8
XFILLER_16_203 VPWR VGND sg13cmos5l_fill_1
XFILLER_16_225 VPWR VGND sg13cmos5l_decap_8
XFILLER_216_153 VPWR VGND sg13cmos5l_decap_8
XFILLER_216_164 VPWR VGND sg13cmos5l_fill_1
XFILLER_421_84 VPWR VGND sg13cmos5l_decap_8
XFILLER_405_264 VPWR VGND sg13cmos5l_decap_8
XFILLER_16_247 VPWR VGND sg13cmos5l_fill_1
XFILLER_17_73 VPWR VGND sg13cmos5l_decap_8
XFILLER_83_191 VPWR VGND sg13cmos5l_fill_1
XFILLER_621_150 VPWR VGND sg13cmos5l_decap_8
XFILLER_216_186 VPWR VGND sg13cmos5l_fill_2
XFILLER_231_112 VPWR VGND sg13cmos5l_decap_8
XFILLER_621_161 VPWR VGND sg13cmos5l_fill_2
XFILLER_140_63 VPWR VGND sg13cmos5l_decap_8
XFILLER_566_227 VPWR VGND sg13cmos5l_decap_8
XFILLER_377_138 VPWR VGND sg13cmos5l_decap_8
XFILLER_497_77 VPWR VGND sg13cmos5l_decap_8
XFILLER_647_14 VPWR VGND sg13cmos5l_decap_8
XFILLER_169_252 VPWR VGND sg13cmos5l_decap_8
XANTENNA__3458__X Tile_X0Y1_FrameData_O[16] VPWR VGND sg13cmos5l_antennanp
XFILLER_235_0 VPWR VGND sg13cmos5l_decap_8
XFILLER_184_211 VPWR VGND sg13cmos5l_decap_8
XFILLER_519_165 VPWR VGND sg13cmos5l_decap_8
XFILLER_534_102 VPWR VGND sg13cmos5l_decap_8
XFILLER_385_171 VPWR VGND sg13cmos5l_decap_4
XFILLER_366_15 VPWR VGND sg13cmos5l_decap_8
XFILLER_534_113 VPWR VGND sg13cmos5l_fill_1
XFILLER_184_244 VPWR VGND sg13cmos5l_decap_8
XFILLER_149_72 VPWR VGND sg13cmos5l_decap_8
XFILLER_402_0 VPWR VGND sg13cmos5l_decap_8
XFILLER_534_157 VPWR VGND sg13cmos5l_decap_8
XFILLER_663_35 VPWR VGND sg13cmos5l_decap_8
XFILLER_487_212 VPWR VGND sg13cmos5l_decap_8
XFILLER_382_14 VPWR VGND sg13cmos5l_decap_8
XANTENNA__3193__X Tile_X0Y0_N2BEGb[1] VPWR VGND sg13cmos5l_antennanp
XFILLER_165_60 VPWR VGND sg13cmos5l_decap_8
XFILLER_341_252 VPWR VGND sg13cmos5l_decap_8
XFILLER_298_145 VPWR VGND sg13cmos5l_fill_1
XFILLER_301_105 VPWR VGND sg13cmos5l_decap_8
XFILLER_298_167 VPWR VGND sg13cmos5l_decap_8
XFILLER_152_185 VPWR VGND sg13cmos5l_decap_8
XFILLER_98_239 VPWR VGND sg13cmos5l_decap_8
X_0440_ _0440_/Q Tile_X0Y8_FrameData[7] VGND VPWR Tile_X0Y9_FrameStrobe[0] latch
XFILLER_315_52 VPWR VGND sg13cmos5l_decap_8
XFILLER_532_28 VPWR VGND sg13cmos5l_decap_8
X_0371_ _0371_/Q Tile_X0Y7_FrameData[12] VGND VPWR Tile_X0Y9_FrameStrobe[6] latch
XFILLER_644_231 VPWR VGND sg13cmos5l_decap_8
X_2110_ _2110_/Q Tile_X0Y4_FrameData[7] VGND VPWR Tile_X0Y9_FrameStrobe[5] latch
XFILLER_315_96 VPWR VGND sg13cmos5l_decap_8
X_3090_ Tile_X0Y7_E2BEG[4] _4616_/X VPWR VGND sg13cmos5l_buf_1
XFILLER_181_70 VPWR VGND sg13cmos5l_decap_8
XFILLER_66_147 VPWR VGND sg13cmos5l_decap_8
X_2041_ _2041_/Q Tile_X0Y4_FrameData[12] VGND VPWR Tile_X0Y9_FrameStrobe[3] latch
XFILLER_688_21 VPWR VGND sg13cmos5l_decap_8
XFILLER_557_205 VPWR VGND sg13cmos5l_fill_2
X_3992_ _3992_/X _3898_/X _4031_/X _4030_/X Tile_X0Y0_S2MID[5] _1191_/Q _1190_/Q VPWR
+ VGND sg13cmos5l_mux4_1
XFILLER_22_217 VPWR VGND sg13cmos5l_decap_8
XFILLER_368_138 VPWR VGND sg13cmos5l_fill_2
XFILLER_411_256 VPWR VGND sg13cmos5l_decap_4
XFILLER_22_239 VPWR VGND sg13cmos5l_decap_8
X_2943_ Tile_X0Y8_E6BEG[11] _4771_/X VPWR VGND sg13cmos5l_buf_1
XFILLER_557_14 VPWR VGND sg13cmos5l_decap_8
XANTENNA__3368__X Tile_X0Y2_EE4BEG[7] VPWR VGND sg13cmos5l_antennanp
XFILLER_383_119 VPWR VGND sg13cmos5l_decap_8
XFILLER_200_77 VPWR VGND sg13cmos5l_decap_8
XFILLER_376_160 VPWR VGND sg13cmos5l_decap_4
X_2874_ Tile_X0Y6_EE4BEG[11] _4523_/X VPWR VGND sg13cmos5l_buf_1
XFILLER_565_271 VPWR VGND sg13cmos5l_fill_2
XFILLER_309_227 VPWR VGND sg13cmos5l_decap_8
X_4613_ _4613_/X Tile_X0Y7_W2MID[6] AXI_M_SOC_RDATA17 _4671_/X _4670_/X _0333_/Q _0332_/Q
+ VPWR VGND sg13cmos5l_mux4_1
XFILLER_525_135 VPWR VGND sg13cmos5l_decap_8
X_1825_ _1825_/Q Tile_X0Y3_FrameData[8] VGND VPWR Tile_X0Y9_FrameStrobe[4] latch
XFILLER_707_28 VPWR VGND sg13cmos5l_decap_8
XFILLER_135_119 VPWR VGND sg13cmos5l_fill_1
XFILLER_128_160 VPWR VGND sg13cmos5l_fill_1
XFILLER_209_42 VPWR VGND sg13cmos5l_decap_8
X_4544_ _4544_/X Tile_X0Y5_W1END[0] Tile_X0Y5_W6END[8] _4463_/X _4416_/X _2403_/Q
+ _2402_/Q VPWR VGND sg13cmos5l_mux4_1
X_1756_ _1756_/Q Tile_X0Y3_FrameData[13] VGND VPWR Tile_X0Y9_FrameStrobe[2] latch
XFILLER_573_35 VPWR VGND sg13cmos5l_decap_8
XFILLER_356_70 VPWR VGND sg13cmos5l_decap_8
XFILLER_540_149 VPWR VGND sg13cmos5l_decap_8
X_0707_ _0707_/Q Tile_X0Y9_FrameData[28] VGND VPWR Tile_X0Y9_FrameStrobe[1] latch
XFILLER_679_172 VPWR VGND sg13cmos5l_decap_8
XFILLER_292_14 VPWR VGND sg13cmos5l_decap_8
X_4475_ _4475_/X Tile_X0Y7_W2MID[4] Tile_X0Y7_W2END[4] Tile_X0Y7_W6END[4] _4675_/X
+ _0401_/Q _0400_/Q VPWR VGND sg13cmos5l_mux4_1
X_1687_ _1687_/Q Tile_X0Y3_FrameData[18] VGND VPWR Tile_X0Y9_FrameStrobe[0] latch
XFILLER_289_145 VPWR VGND sg13cmos5l_decap_4
XFILLER_289_156 VPWR VGND sg13cmos5l_decap_8
X_3426_ Tile_X0Y4_FrameData_O[17] Tile_X0Y4_FrameData[17] VPWR VGND sg13cmos5l_buf_1
X_0638_ _0638_/Q Tile_X0Y8_FrameData[1] VGND VPWR Tile_X0Y9_FrameStrobe[6] latch
XFILLER_438_109 VPWR VGND sg13cmos5l_decap_8
XFILLER_627_209 VPWR VGND sg13cmos5l_decap_8
XFILLER_506_84 VPWR VGND sg13cmos5l_decap_8
X_3357_ Tile_X0Y2_FrameData_O[28] Tile_X0Y2_FrameData[28] VPWR VGND sg13cmos5l_buf_1
X_0569_ _0569_/Q Tile_X0Y8_FrameData[6] VGND VPWR Tile_X0Y9_FrameStrobe[4] latch
XFILLER_38_28 VPWR VGND sg13cmos5l_decap_8
XFILLER_635_231 VPWR VGND sg13cmos5l_decap_8
XFILLER_446_142 VPWR VGND sg13cmos5l_decap_8
X_2308_ _2308_/Q Tile_X0Y5_FrameData[1] VGND VPWR Tile_X0Y9_FrameStrobe[3] latch
XFILLER_161_29 VPWR VGND sg13cmos5l_fill_2
XFILLER_635_253 VPWR VGND sg13cmos5l_decap_8
X_3288_ Tile_X0Y0_E6BEG[8] _3844_/X VPWR VGND sg13cmos5l_buf_1
XFILLER_461_112 VPWR VGND sg13cmos5l_decap_8
X_2239_ _2239_/Q Tile_X0Y5_FrameData[6] VGND VPWR Tile_X0Y9_FrameStrobe[1] latch
XFILLER_72_128 VPWR VGND sg13cmos5l_decap_8
XFILLER_598_21 VPWR VGND sg13cmos5l_decap_8
XFILLER_461_167 VPWR VGND sg13cmos5l_decap_8
XFILLER_399_241 VPWR VGND sg13cmos5l_decap_8
XFILLER_260_229 VPWR VGND sg13cmos5l_decap_8
XFILLER_213_123 VPWR VGND sg13cmos5l_decap_8
XFILLER_359_105 VPWR VGND sg13cmos5l_decap_8
XFILLER_159_7 VPWR VGND sg13cmos5l_decap_8
XFILLER_603_194 VPWR VGND sg13cmos5l_decap_8
XFILLER_359_149 VPWR VGND sg13cmos5l_decap_4
XFILLER_467_14 VPWR VGND sg13cmos5l_decap_8
XFILLER_333_8 VPWR VGND sg13cmos5l_decap_8
XANTENNA__3278__X Tile_X0Y0_EE4BEG[14] VPWR VGND sg13cmos5l_antennanp
XFILLER_70_15 VPWR VGND sg13cmos5l_decap_8
XFILLER_563_208 VPWR VGND sg13cmos5l_fill_1
XFILLER_374_108 VPWR VGND sg13cmos5l_fill_1
XFILLER_326_7 VPWR VGND sg13cmos5l_decap_8
XFILLER_21_261 VPWR VGND sg13cmos5l_fill_1
XFILLER_21_272 VPWR VGND sg13cmos5l_fill_1
XFILLER_166_255 VPWR VGND sg13cmos5l_decap_8
XFILLER_705_235 VPWR VGND sg13cmos5l_decap_8
XFILLER_617_28 VPWR VGND sg13cmos5l_decap_8
XFILLER_119_160 VPWR VGND sg13cmos5l_fill_2
XFILLER_382_174 VPWR VGND sg13cmos5l_decap_4
XANTENNA__2910__X Tile_X0Y6_FrameData_O[31] VPWR VGND sg13cmos5l_antennanp
XFILLER_119_42 VPWR VGND sg13cmos5l_decap_8
XFILLER_308_260 VPWR VGND sg13cmos5l_decap_4
XFILLER_531_138 VPWR VGND sg13cmos5l_decap_8
XFILLER_469_201 VPWR VGND sg13cmos5l_decap_8
XFILLER_181_269 VPWR VGND sg13cmos5l_decap_4
XFILLER_79_35 VPWR VGND sg13cmos5l_decap_8
XFILLER_483_57 VPWR VGND sg13cmos5l_decap_8
XFILLER_469_223 VPWR VGND sg13cmos5l_decap_8
XFILLER_695_7 VPWR VGND sg13cmos5l_decap_8
XFILLER_134_163 VPWR VGND sg13cmos5l_decap_8
XFILLER_323_263 VPWR VGND sg13cmos5l_fill_2
XFILLER_633_49 VPWR VGND sg13cmos5l_decap_8
XFILLER_416_84 VPWR VGND sg13cmos5l_decap_8
XFILLER_295_126 VPWR VGND sg13cmos5l_decap_8
XFILLER_484_237 VPWR VGND sg13cmos5l_decap_8
XFILLER_352_28 VPWR VGND sg13cmos5l_decap_8
XFILLER_0_143 VPWR VGND sg13cmos5l_fill_2
XFILLER_135_63 VPWR VGND sg13cmos5l_decap_8
XANTENNA__3741__X AXI_M_SOC_ARADDR13 VPWR VGND sg13cmos5l_antennanp
XFILLER_626_220 VPWR VGND sg13cmos5l_decap_4
XFILLER_484_259 VPWR VGND sg13cmos5l_fill_2
XFILLER_282_91 VPWR VGND sg13cmos5l_decap_8
XFILLER_713_82 VPWR VGND sg13cmos5l_decap_8
XFILLER_95_56 VPWR VGND sg13cmos5l_decap_8
XFILLER_626_253 VPWR VGND sg13cmos5l_decap_8
XFILLER_236_215 VPWR VGND sg13cmos5l_fill_1
XFILLER_185_0 VPWR VGND sg13cmos5l_decap_8
XFILLER_641_245 VPWR VGND sg13cmos5l_decap_8
XFILLER_598_138 VPWR VGND sg13cmos5l_decap_8
XFILLER_63_139 VPWR VGND sg13cmos5l_decap_8
XFILLER_151_84 VPWR VGND sg13cmos5l_fill_2
XFILLER_352_0 VPWR VGND sg13cmos5l_decap_8
XFILLER_301_43 VPWR VGND sg13cmos5l_decap_8
XFILLER_71_161 VPWR VGND sg13cmos5l_decap_8
XFILLER_539_227 VPWR VGND sg13cmos5l_decap_8
XFILLER_658_35 VPWR VGND sg13cmos5l_decap_8
XFILLER_377_14 VPWR VGND sg13cmos5l_decap_8
XFILLER_301_98 VPWR VGND sg13cmos5l_decap_8
XANTENNA__3188__X Tile_X0Y0_N4BEG[12] VPWR VGND sg13cmos5l_antennanp
XFILLER_617_0 VPWR VGND sg13cmos5l_decap_8
XFILLER_547_271 VPWR VGND sg13cmos5l_fill_2
XFILLER_358_182 VPWR VGND sg13cmos5l_decap_8
XFILLER_12_272 VPWR VGND sg13cmos5l_fill_1
XFILLER_507_124 VPWR VGND sg13cmos5l_decap_8
XFILLER_157_255 VPWR VGND sg13cmos5l_decap_8
XFILLER_74_7 VPWR VGND sg13cmos5l_decap_8
XFILLER_527_28 VPWR VGND sg13cmos5l_decap_8
XFILLER_373_141 VPWR VGND sg13cmos5l_decap_8
XFILLER_674_56 VPWR VGND sg13cmos5l_decap_8
XFILLER_457_91 VPWR VGND sg13cmos5l_fill_2
XFILLER_306_219 VPWR VGND sg13cmos5l_fill_1
XANTENNA__2820__X Tile_X0Y3_E1BEG[2] VPWR VGND sg13cmos5l_antennanp
X_1610_ _1610_/Q Tile_X0Y2_FrameData[7] VGND VPWR Tile_X0Y9_FrameStrobe[5] latch
XFILLER_172_236 VPWR VGND sg13cmos5l_decap_8
X_2590_ _2590_/Q Tile_X0Y6_FrameData[9] VGND VPWR Tile_X0Y9_FrameStrobe[4] latch
XFILLER_246_29 VPWR VGND sg13cmos5l_decap_8
XFILLER_711_227 VPWR VGND sg13cmos5l_fill_2
XFILLER_522_138 VPWR VGND sg13cmos5l_decap_8
XFILLER_5_21 VPWR VGND sg13cmos5l_decap_8
XFILLER_125_141 VPWR VGND sg13cmos5l_decap_8
X_1541_ _1541_/Q Tile_X0Y2_FrameData[12] VGND VPWR Tile_X0Y9_FrameStrobe[3] latch
XFILLER_676_120 VPWR VGND sg13cmos5l_decap_8
X_4260_ _4260_/X Tile_X0Y4_W2MID[3] AXI_M_SOC_BRESP0 _4319_/X _4318_/X _2093_/Q _2092_/Q
+ VPWR VGND sg13cmos5l_mux4_1
X_1472_ _1472_/Q Tile_X0Y2_FrameData[17] VGND VPWR Tile_X0Y9_FrameStrobe[1] latch
XFILLER_543_49 VPWR VGND sg13cmos5l_decap_8
XFILLER_140_133 VPWR VGND sg13cmos5l_decap_8
XFILLER_326_84 VPWR VGND sg13cmos5l_decap_8
XFILLER_286_126 VPWR VGND sg13cmos5l_decap_8
X_3211_ Tile_X0Y0_N1BEG[3] _3783_/X VPWR VGND sg13cmos5l_buf_1
XFILLER_79_250 VPWR VGND sg13cmos5l_fill_2
X_0423_ _0423_/Q Tile_X0Y8_FrameData[24] VGND VPWR Tile_X0Y9_FrameStrobe[0] latch
XFILLER_262_28 VPWR VGND sg13cmos5l_decap_8
X_4191_ _4191_/X AXI_M_SOC_BVALID _4222_/X _4226_/X _4204_/X _1759_/Q _1758_/Q VPWR
+ VGND sg13cmos5l_mux4_1
XANTENNA__3651__X AXI_M_SOC_AWADDR12 VPWR VGND sg13cmos5l_antennanp
XFILLER_79_261 VPWR VGND sg13cmos5l_fill_1
XFILLER_690_99 VPWR VGND sg13cmos5l_decap_8
XFILLER_475_259 VPWR VGND sg13cmos5l_decap_8
XFILLER_39_114 VPWR VGND sg13cmos5l_decap_8
X_3142_ Tile_X0Y7_FrameData_O[12] Tile_X0Y7_FrameData[12] VPWR VGND sg13cmos5l_buf_1
XFILLER_617_242 VPWR VGND sg13cmos5l_decap_8
X_0354_ _0354_/Q Tile_X0Y7_FrameData[29] VGND VPWR Tile_X0Y9_FrameStrobe[6] latch
XFILLER_227_215 VPWR VGND sg13cmos5l_fill_1
XFILLER_483_270 VPWR VGND sg13cmos5l_fill_2
XFILLER_428_175 VPWR VGND sg13cmos5l_decap_8
XFILLER_227_237 VPWR VGND sg13cmos5l_decap_8
XFILLER_94_253 VPWR VGND sg13cmos5l_decap_4
XFILLER_443_112 VPWR VGND sg13cmos5l_decap_4
X_3073_ Tile_X0Y5_UserCLKo Tile_X0Y5_UserCLK VPWR VGND sg13cmos5l_buf_1
XFILLER_443_134 VPWR VGND sg13cmos5l_fill_2
X_0285_ _0285_/Q Tile_X0Y7_FrameData[2] VGND VPWR Tile_X0Y9_FrameStrobe[3] latch
XFILLER_699_64 VPWR VGND sg13cmos5l_decap_8
XFILLER_632_256 VPWR VGND sg13cmos5l_decap_4
XFILLER_589_138 VPWR VGND sg13cmos5l_decap_8
X_2024_ _2024_/Q Tile_X0Y4_FrameData[29] VGND VPWR Tile_X0Y9_FrameStrobe[3] latch
XFILLER_699_97 VPWR VGND sg13cmos5l_fill_1
XFILLER_211_21 VPWR VGND sg13cmos5l_decap_8
XFILLER_568_35 VPWR VGND sg13cmos5l_decap_8
XFILLER_211_98 VPWR VGND sg13cmos5l_decap_8
XFILLER_396_255 VPWR VGND sg13cmos5l_fill_2
XFILLER_287_14 VPWR VGND sg13cmos5l_decap_8
X_3975_ _3975_/X AXI_M_SOC_ARREADY _4008_/X _4012_/X _3988_/X _1259_/Q _1258_/Q VPWR
+ VGND sg13cmos5l_mux4_1
XANTENNA__3098__X Tile_X0Y7_E2BEGb[4] VPWR VGND sg13cmos5l_antennanp
XFILLER_210_126 VPWR VGND sg13cmos5l_decap_8
XFILLER_545_208 VPWR VGND sg13cmos5l_decap_8
XFILLER_356_119 VPWR VGND sg13cmos5l_decap_8
XFILLER_148_211 VPWR VGND sg13cmos5l_decap_4
X_2926_ Tile_X0Y8_E2BEGb[2] _4738_/X VPWR VGND sg13cmos5l_buf_1
XFILLER_538_260 VPWR VGND sg13cmos5l_decap_4
XFILLER_148_255 VPWR VGND sg13cmos5l_decap_8
XFILLER_437_28 VPWR VGND sg13cmos5l_decap_8
X_2857_ Tile_X0Y6_E6BEG[6] _4534_/X VPWR VGND sg13cmos5l_buf_1
XFILLER_108_119 VPWR VGND sg13cmos5l_decap_8
XFILLER_163_214 VPWR VGND sg13cmos5l_decap_8
XFILLER_584_56 VPWR VGND sg13cmos5l_decap_8
XFILLER_513_105 VPWR VGND sg13cmos5l_decap_8
XFILLER_364_174 VPWR VGND sg13cmos5l_decap_8
X_1808_ _1808_/Q Tile_X0Y3_FrameData[25] VGND VPWR Tile_X0Y9_FrameStrobe[4] latch
XFILLER_156_29 VPWR VGND sg13cmos5l_decap_8
X_2788_ Tile_X0Y3_EE4BEG[14] _4178_/X VPWR VGND sg13cmos5l_buf_1
XFILLER_163_258 VPWR VGND sg13cmos5l_fill_1
XFILLER_116_141 VPWR VGND sg13cmos5l_decap_8
X_4527_ _4527_/X Tile_X0Y6_WW4END[0] AXI_M_SOC_RDATA24 _4568_/X _4553_/X _2553_/Q
+ _2552_/Q VPWR VGND sg13cmos5l_mux4_1
XFILLER_702_249 VPWR VGND sg13cmos5l_decap_8
X_1739_ _1739_/Q Tile_X0Y3_FrameData[30] VGND VPWR Tile_X0Y9_FrameStrobe[2] latch
XFILLER_667_142 VPWR VGND sg13cmos5l_decap_8
XFILLER_116_196 VPWR VGND sg13cmos5l_fill_2
X_4458_ _4458_/X _4427_/X _0097_/X _4426_/X _0156_/X _2223_/Q _2222_/Q VPWR VGND sg13cmos5l_mux4_1
XFILLER_320_222 VPWR VGND sg13cmos5l_decap_8
XFILLER_236_84 VPWR VGND sg13cmos5l_fill_2
XFILLER_131_133 VPWR VGND sg13cmos5l_decap_8
XFILLER_466_215 VPWR VGND sg13cmos5l_decap_8
XFILLER_277_126 VPWR VGND sg13cmos5l_fill_2
XFILLER_172_28 VPWR VGND sg13cmos5l_decap_8
X_3409_ Tile_X0Y4_FrameData_O[0] Tile_X0Y4_FrameData[0] VPWR VGND sg13cmos5l_buf_1
XFILLER_682_112 VPWR VGND sg13cmos5l_decap_8
X_4389_ _4389_/X Tile_X0Y5_WW4END[14] AXI_M_SOC_RLAST _4465_/X _4429_/X _2325_/Q _2324_/Q
+ VPWR VGND sg13cmos5l_mux4_1
XFILLER_277_159 VPWR VGND sg13cmos5l_decap_8
XANTENNA__3561__X Tile_X0Y9_EE4BEG[7] VPWR VGND sg13cmos5l_antennanp
XFILLER_131_199 VPWR VGND sg13cmos5l_decap_8
XFILLER_608_242 VPWR VGND sg13cmos5l_decap_8
XFILLER_481_207 VPWR VGND sg13cmos5l_fill_2
XFILLER_292_118 VPWR VGND sg13cmos5l_decap_4
XFILLER_218_226 VPWR VGND sg13cmos5l_decap_8
XFILLER_682_189 VPWR VGND sg13cmos5l_decap_8
XFILLER_419_175 VPWR VGND sg13cmos5l_decap_8
XFILLER_105_77 VPWR VGND sg13cmos5l_decap_8
XFILLER_276_7 VPWR VGND sg13cmos5l_decap_8
XFILLER_555_9 VPWR VGND sg13cmos5l_decap_8
XFILLER_402_42 VPWR VGND sg13cmos5l_decap_8
XANTENNA_105 _0157_/X VPWR VGND sg13cmos5l_antennanp
XANTENNA_116 Tile_X0Y6_FrameData[30] VPWR VGND sg13cmos5l_antennanp
XFILLER_434_178 VPWR VGND sg13cmos5l_decap_4
XFILLER_121_21 VPWR VGND sg13cmos5l_decap_8
XANTENNA_127 Tile_X0Y6_FrameData[31] VPWR VGND sg13cmos5l_antennanp
XANTENNA_138 Tile_X0Y6_FrameData[31] VPWR VGND sg13cmos5l_antennanp
XFILLER_60_109 VPWR VGND sg13cmos5l_decap_8
XFILLER_595_119 VPWR VGND sg13cmos5l_decap_8
XANTENNA_149 Tile_X0Y9_FrameStrobe[13] VPWR VGND sg13cmos5l_antennanp
XANTENNA__2905__X Tile_X0Y6_FrameData_O[26] VPWR VGND sg13cmos5l_antennanp
XFILLER_443_7 VPWR VGND sg13cmos5l_decap_8
XFILLER_81_14 VPWR VGND sg13cmos5l_decap_8
XFILLER_478_35 VPWR VGND sg13cmos5l_decap_8
XFILLER_241_240 VPWR VGND sg13cmos5l_fill_1
XFILLER_81_25 VPWR VGND sg13cmos5l_fill_1
XFILLER_241_262 VPWR VGND sg13cmos5l_fill_2
XFILLER_198_155 VPWR VGND sg13cmos5l_decap_8
XFILLER_121_98 VPWR VGND sg13cmos5l_decap_8
XFILLER_197_14 VPWR VGND sg13cmos5l_decap_8
XFILLER_81_47 VPWR VGND sg13cmos5l_decap_8
XFILLER_610_7 VPWR VGND sg13cmos5l_decap_8
XFILLER_347_119 VPWR VGND sg13cmos5l_decap_8
XFILLER_708_7 VPWR VGND sg13cmos5l_decap_8
XFILLER_529_271 VPWR VGND sg13cmos5l_fill_2
XFILLER_14_63 VPWR VGND sg13cmos5l_decap_8
XFILLER_324_4 VPWR VGND sg13cmos5l_fill_1
XFILLER_139_255 VPWR VGND sg13cmos5l_fill_2
XFILLER_347_28 VPWR VGND sg13cmos5l_decap_8
XANTENNA__3736__X AXI_M_SOC_ARADDR8 VPWR VGND sg13cmos5l_antennanp
XFILLER_494_56 VPWR VGND sg13cmos5l_decap_8
XFILLER_277_91 VPWR VGND sg13cmos5l_decap_8
XFILLER_504_105 VPWR VGND sg13cmos5l_decap_8
XFILLER_355_196 VPWR VGND sg13cmos5l_decap_8
XFILLER_5_235 VPWR VGND sg13cmos5l_decap_8
XFILLER_154_258 VPWR VGND sg13cmos5l_decap_4
XFILLER_100_0 VPWR VGND sg13cmos5l_decap_8
XFILLER_658_131 VPWR VGND sg13cmos5l_decap_8
XFILLER_122_111 VPWR VGND sg13cmos5l_decap_8
XFILLER_107_196 VPWR VGND sg13cmos5l_decap_8
XFILLER_370_199 VPWR VGND sg13cmos5l_decap_8
XFILLER_146_84 VPWR VGND sg13cmos5l_decap_8
XFILLER_658_164 VPWR VGND sg13cmos5l_fill_2
XFILLER_457_215 VPWR VGND sg13cmos5l_decap_8
XFILLER_660_14 VPWR VGND sg13cmos5l_decap_8
XFILLER_658_197 VPWR VGND sg13cmos5l_decap_8
XANTENNA__3471__X Tile_X0Y1_FrameData_O[29] VPWR VGND sg13cmos5l_antennanp
XFILLER_673_134 VPWR VGND sg13cmos5l_decap_8
XFILLER_457_259 VPWR VGND sg13cmos5l_fill_1
XFILLER_673_145 VPWR VGND sg13cmos5l_fill_1
XFILLER_673_167 VPWR VGND sg13cmos5l_decap_8
XFILLER_76_231 VPWR VGND sg13cmos5l_decap_8
XFILLER_472_218 VPWR VGND sg13cmos5l_fill_2
XFILLER_209_215 VPWR VGND sg13cmos5l_decap_4
XFILLER_465_270 VPWR VGND sg13cmos5l_fill_2
XFILLER_39_93 VPWR VGND sg13cmos5l_decap_8
XFILLER_567_0 VPWR VGND sg13cmos5l_decap_8
XFILLER_425_112 VPWR VGND sg13cmos5l_decap_8
XFILLER_162_94 VPWR VGND sg13cmos5l_decap_8
XFILLER_209_259 VPWR VGND sg13cmos5l_fill_2
XFILLER_614_245 VPWR VGND sg13cmos5l_decap_8
XFILLER_36_128 VPWR VGND sg13cmos5l_decap_8
XFILLER_614_256 VPWR VGND sg13cmos5l_fill_1
XFILLER_312_42 VPWR VGND sg13cmos5l_decap_4
X_0070_ AXI_M_SOC_WSTRB1 _0935_/Q _3723_/X VPWR VGND sg13cmos5l_or2_1
XFILLER_480_262 VPWR VGND sg13cmos5l_decap_8
XFILLER_291_162 VPWR VGND sg13cmos5l_decap_8
XFILLER_425_189 VPWR VGND sg13cmos5l_decap_8
XANTENNA__2815__X Tile_X0Y3_E2BEG[5] VPWR VGND sg13cmos5l_antennanp
XFILLER_669_67 VPWR VGND sg13cmos5l_decap_4
XFILLER_579_160 VPWR VGND sg13cmos5l_decap_8
XFILLER_378_233 VPWR VGND sg13cmos5l_decap_8
XFILLER_189_144 VPWR VGND sg13cmos5l_decap_4
XFILLER_594_130 VPWR VGND sg13cmos5l_fill_1
XFILLER_338_119 VPWR VGND sg13cmos5l_decap_8
X_3760_ _3760_/X Tile_X0Y1_WW4END[1] Tile_X0Y1_WW4END[9] Tile_X0Y1_W6END[1] _4009_/X
+ _1255_/Q _1254_/Q VPWR VGND sg13cmos5l_mux4_1
X_0972_ _0972_/Q Tile_X0Y0_FrameData[31] VGND VPWR Tile_X0Y9_FrameStrobe[1] latch
XFILLER_685_55 VPWR VGND sg13cmos5l_decap_8
XFILLER_538_49 VPWR VGND sg13cmos5l_decap_8
XFILLER_393_247 VPWR VGND sg13cmos5l_decap_8
XFILLER_685_66 VPWR VGND sg13cmos5l_fill_1
X_2711_ _4300_/A3 VPWR VGND sg13cmos5l_tielo
XFILLER_71_91 VPWR VGND sg13cmos5l_decap_8
XFILLER_257_28 VPWR VGND sg13cmos5l_decap_8
X_3691_ AXI_M_SOC_WDATA1 Tile_X0Y7_WW4END[1] Tile_X0Y7_WW4END[9] Tile_X0Y7_W6END[1]
+ _4685_/X _0245_/Q _0244_/Q VPWR VGND sg13cmos5l_mux4_1
XFILLER_685_88 VPWR VGND sg13cmos5l_decap_8
XANTENNA__3646__X AXI_M_SOC_AWADDR7 VPWR VGND sg13cmos5l_antennanp
XFILLER_145_225 VPWR VGND sg13cmos5l_decap_4
XFILLER_145_236 VPWR VGND sg13cmos5l_decap_8
X_2642_ _2642_/Q Tile_X0Y6_FrameData[21] VGND VPWR Tile_X0Y9_FrameStrobe[6] latch
XFILLER_696_204 VPWR VGND sg13cmos5l_decap_8
XFILLER_346_196 VPWR VGND sg13cmos5l_fill_2
XFILLER_550_233 VPWR VGND sg13cmos5l_decap_8
X_2573_ _2573_/Q Tile_X0Y6_FrameData[26] VGND VPWR Tile_X0Y9_FrameStrobe[4] latch
XANTENNA__0070__X AXI_M_SOC_WSTRB1 VPWR VGND sg13cmos5l_antennanp
X_4312_ _4312_/X _4251_/X _4367_/X _4366_/X _4250_/X _1935_/Q _1934_/Q VPWR VGND sg13cmos5l_mux4_1
XFILLER_510_119 VPWR VGND sg13cmos5l_decap_8
X_1524_ _1524_/Q Tile_X0Y2_FrameData[29] VGND VPWR Tile_X0Y9_FrameStrobe[3] latch
XFILLER_448_204 VPWR VGND sg13cmos5l_decap_4
XFILLER_273_49 VPWR VGND sg13cmos5l_decap_8
XFILLER_259_104 VPWR VGND sg13cmos5l_decap_8
XFILLER_649_164 VPWR VGND sg13cmos5l_decap_8
XFILLER_634_70 VPWR VGND sg13cmos5l_decap_8
XFILLER_503_182 VPWR VGND sg13cmos5l_decap_8
XFILLER_206_21 VPWR VGND sg13cmos5l_decap_8
XFILLER_113_155 VPWR VGND sg13cmos5l_decap_4
X_4243_ _4243_/X Tile_X0Y5_W2MID[4] Tile_X0Y5_W2END[4] Tile_X0Y5_W6END[4] _4434_/X
+ _2425_/Q _2424_/Q VPWR VGND sg13cmos5l_mux4_1
XFILLER_302_255 VPWR VGND sg13cmos5l_decap_8
X_1455_ _1455_/Q Tile_X0Y2_FrameData[2] VGND VPWR Tile_X0Y9_FrameStrobe[0] latch
XFILLER_570_14 VPWR VGND sg13cmos5l_decap_8
XANTENNA__3381__X Tile_X0Y2_E6BEG[4] VPWR VGND sg13cmos5l_antennanp
XFILLER_274_107 VPWR VGND sg13cmos5l_decap_8
X_0406_ _0406_/Q Tile_X0Y7_FrameData[9] VGND VPWR Tile_X0Y9_FrameStrobe[7] latch
XFILLER_206_98 VPWR VGND sg13cmos5l_decap_8
X_4174_ _4174_/X Tile_X0Y3_WW4END[5] AXI_M_SOC_BVALID _4227_/X _4208_/X _1793_/Q _1792_/Q
+ VPWR VGND sg13cmos5l_mux4_1
X_1386_ _1386_/Q Tile_X0Y1_FrameData[15] VGND VPWR Tile_X0Y9_FrameStrobe[6] latch
XFILLER_67_231 VPWR VGND sg13cmos5l_decap_8
XFILLER_605_201 VPWR VGND sg13cmos5l_decap_8
XFILLER_67_253 VPWR VGND sg13cmos5l_fill_2
X_3125_ Tile_X0Y7_EE4BEG[11] _4639_/X VPWR VGND sg13cmos5l_buf_1
X_0337_ _0337_/Q Tile_X0Y7_FrameData[14] VGND VPWR Tile_X0Y9_FrameStrobe[5] latch
XFILLER_605_223 VPWR VGND sg13cmos5l_decap_8
XFILLER_503_63 VPWR VGND sg13cmos5l_decap_8
XFILLER_416_134 VPWR VGND sg13cmos5l_decap_8
XFILLER_282_140 VPWR VGND sg13cmos5l_decap_8
XFILLER_222_42 VPWR VGND sg13cmos5l_decap_8
XFILLER_650_91 VPWR VGND sg13cmos5l_decap_8
XFILLER_27_139 VPWR VGND sg13cmos5l_decap_8
X_3056_ Tile_X0Y5_FrameData_O[15] Tile_X0Y5_FrameData[15] VPWR VGND sg13cmos5l_buf_1
X_0268_ _0268_/Q Tile_X0Y7_FrameData[19] VGND VPWR Tile_X0Y9_FrameStrobe[3] latch
XFILLER_579_56 VPWR VGND sg13cmos5l_decap_8
XFILLER_431_126 VPWR VGND sg13cmos5l_decap_8
X_2007_ _2007_/Q Tile_X0Y4_FrameData[14] VGND VPWR Tile_X0Y9_FrameStrobe[2] latch
X_0199_ _0199_/Q Tile_X0Y7_FrameData[24] VGND VPWR Tile_X0Y9_FrameStrobe[1] latch
XFILLER_369_233 VPWR VGND sg13cmos5l_decap_8
XFILLER_298_35 VPWR VGND sg13cmos5l_decap_8
XFILLER_50_120 VPWR VGND sg13cmos5l_decap_8
XFILLER_35_194 VPWR VGND sg13cmos5l_decap_8
XFILLER_585_152 VPWR VGND sg13cmos5l_fill_1
XFILLER_518_208 VPWR VGND sg13cmos5l_decap_8
XFILLER_50_153 VPWR VGND sg13cmos5l_decap_8
XFILLER_50_164 VPWR VGND sg13cmos5l_fill_1
X_3958_ _3958_/X Tile_X0Y1_WW4END[5] AXI_M_SOC_ARREADY _4013_/X _3992_/X _1293_/Q
+ _1292_/Q VPWR VGND sg13cmos5l_mux4_1
XFILLER_448_49 VPWR VGND sg13cmos5l_decap_8
XFILLER_384_247 VPWR VGND sg13cmos5l_decap_8
XFILLER_51_39 VPWR VGND sg13cmos5l_decap_8
XFILLER_167_28 VPWR VGND sg13cmos5l_decap_8
XFILLER_526_230 VPWR VGND sg13cmos5l_decap_8
X_2909_ Tile_X0Y6_FrameData_O[30] Tile_X0Y6_FrameData[30] VPWR VGND sg13cmos5l_buf_1
X_3889_ _3889_/X Tile_X0Y1_W2MID[7] Tile_X0Y1_W2END[7] Tile_X0Y1_W6END[7] _3989_/X
+ _1417_/Q _1416_/Q VPWR VGND sg13cmos5l_mux4_1
XANTENNA__3556__X Tile_X0Y9_EE4BEG[2] VPWR VGND sg13cmos5l_antennanp
XFILLER_136_214 VPWR VGND sg13cmos5l_decap_8
XFILLER_337_174 VPWR VGND sg13cmos5l_decap_8
XFILLER_352_133 VPWR VGND sg13cmos5l_decap_8
XFILLER_498_126 VPWR VGND sg13cmos5l_decap_8
XFILLER_501_119 VPWR VGND sg13cmos5l_decap_8
XFILLER_2_216 VPWR VGND sg13cmos5l_decap_8
XFILLER_4_7 VPWR VGND sg13cmos5l_decap_8
XFILLER_116_21 VPWR VGND sg13cmos5l_decap_8
XFILLER_544_70 VPWR VGND sg13cmos5l_decap_8
XFILLER_480_14 VPWR VGND sg13cmos5l_decap_8
XANTENNA__3291__X Tile_X0Y0_E6BEG[11] VPWR VGND sg13cmos5l_antennanp
XFILLER_263_60 VPWR VGND sg13cmos5l_decap_8
XFILLER_76_14 VPWR VGND sg13cmos5l_decap_8
XFILLER_655_145 VPWR VGND sg13cmos5l_decap_4
XFILLER_104_188 VPWR VGND sg13cmos5l_decap_8
XFILLER_258_170 VPWR VGND sg13cmos5l_decap_8
XFILLER_58_253 VPWR VGND sg13cmos5l_fill_2
XFILLER_630_28 VPWR VGND sg13cmos5l_decap_8
XFILLER_560_7 VPWR VGND sg13cmos5l_decap_8
XFILLER_413_63 VPWR VGND sg13cmos5l_decap_8
XFILLER_73_201 VPWR VGND sg13cmos5l_fill_1
XFILLER_658_7 VPWR VGND sg13cmos5l_decap_8
XFILLER_407_134 VPWR VGND sg13cmos5l_decap_4
XFILLER_560_91 VPWR VGND sg13cmos5l_decap_8
XFILLER_132_42 VPWR VGND sg13cmos5l_decap_8
XFILLER_462_251 VPWR VGND sg13cmos5l_decap_8
XANTENNA__0139__Y AXI_M_SOC_ARLEN0 VPWR VGND sg13cmos5l_antennanp
XFILLER_422_126 VPWR VGND sg13cmos5l_decap_8
XFILLER_273_195 VPWR VGND sg13cmos5l_decap_8
XFILLER_92_35 VPWR VGND sg13cmos5l_decap_8
XFILLER_568_119 VPWR VGND sg13cmos5l_decap_8
XFILLER_489_56 VPWR VGND sg13cmos5l_decap_8
XFILLER_41_142 VPWR VGND sg13cmos5l_fill_1
XFILLER_148_0 VPWR VGND sg13cmos5l_decap_8
XFILLER_41_153 VPWR VGND sg13cmos5l_decap_8
XFILLER_25_84 VPWR VGND sg13cmos5l_decap_4
XFILLER_576_174 VPWR VGND sg13cmos5l_decap_8
XFILLER_41_175 VPWR VGND sg13cmos5l_decap_8
XFILLER_358_49 VPWR VGND sg13cmos5l_decap_8
XFILLER_186_158 VPWR VGND sg13cmos5l_decap_8
XFILLER_375_247 VPWR VGND sg13cmos5l_decap_8
XFILLER_591_133 VPWR VGND sg13cmos5l_decap_8
XFILLER_328_130 VPWR VGND sg13cmos5l_decap_8
XFILLER_655_14 VPWR VGND sg13cmos5l_decap_8
XANTENNA__3466__X Tile_X0Y1_FrameData_O[24] VPWR VGND sg13cmos5l_antennanp
XFILLER_315_0 VPWR VGND sg13cmos5l_decap_8
XFILLER_328_185 VPWR VGND sg13cmos5l_decap_8
XFILLER_194_191 VPWR VGND sg13cmos5l_decap_8
XFILLER_374_15 VPWR VGND sg13cmos5l_decap_8
XFILLER_157_50 VPWR VGND sg13cmos5l_fill_1
XFILLER_157_72 VPWR VGND sg13cmos5l_decap_8
XFILLER_142_206 VPWR VGND sg13cmos5l_fill_2
XFILLER_157_83 VPWR VGND sg13cmos5l_fill_2
XFILLER_532_266 VPWR VGND sg13cmos5l_decap_8
XFILLER_307_42 VPWR VGND sg13cmos5l_decap_4
XFILLER_693_229 VPWR VGND sg13cmos5l_fill_2
XFILLER_671_35 VPWR VGND sg13cmos5l_decap_8
XFILLER_684_0 VPWR VGND sg13cmos5l_decap_8
XFILLER_646_112 VPWR VGND sg13cmos5l_decap_8
XFILLER_671_68 VPWR VGND sg13cmos5l_decap_8
XFILLER_390_14 VPWR VGND sg13cmos5l_decap_8
XFILLER_307_97 VPWR VGND sg13cmos5l_decap_4
XFILLER_173_71 VPWR VGND sg13cmos5l_fill_2
XFILLER_173_93 VPWR VGND sg13cmos5l_decap_8
X_1240_ _1240_/Q Tile_X0Y1_FrameData[1] VGND VPWR Tile_X0Y9_FrameStrobe[1] latch
XFILLER_500_196 VPWR VGND sg13cmos5l_decap_8
XFILLER_646_189 VPWR VGND sg13cmos5l_decap_8
XFILLER_604_95 VPWR VGND sg13cmos5l_decap_8
XFILLER_249_181 VPWR VGND sg13cmos5l_decap_4
XFILLER_49_253 VPWR VGND sg13cmos5l_fill_2
XFILLER_540_28 VPWR VGND sg13cmos5l_decap_8
X_1171_ _1171_/Q Tile_X0Y0_FrameData[24] VGND VPWR Tile_X0Y9_FrameStrobe[7] latch
XFILLER_599_211 VPWR VGND sg13cmos5l_fill_1
XFILLER_2_77 VPWR VGND sg13cmos5l_decap_8
X_0122_ _3180_/A _3918_/X _3919_/X _1647_/Q VPWR VGND sg13cmos5l_mux2_1
XFILLER_264_162 VPWR VGND sg13cmos5l_decap_8
XFILLER_66_91 VPWR VGND sg13cmos5l_decap_8
XFILLER_64_245 VPWR VGND sg13cmos5l_decap_8
XFILLER_559_119 VPWR VGND sg13cmos5l_decap_8
XFILLER_413_126 VPWR VGND sg13cmos5l_decap_8
XFILLER_399_56 VPWR VGND sg13cmos5l_decap_4
X_0053_ _0053_/X _4682_/X _4683_/X _1854_/Q VPWR VGND sg13cmos5l_mux2_1
X_4930_ _4930_/X Tile_X0Y9_N1END[2] Tile_X0Y9_N4END[2] _4898_/X _0081_/X _0699_/Q
+ _0698_/Q VPWR VGND sg13cmos5l_mux4_1
XFILLER_602_248 VPWR VGND sg13cmos5l_decap_8
XFILLER_696_21 VPWR VGND sg13cmos5l_decap_8
XFILLER_399_89 VPWR VGND sg13cmos5l_decap_8
XFILLER_17_183 VPWR VGND sg13cmos5l_decap_8
X_4861_ _4861_/X Tile_X0Y9_W2END[2] AXI_M_SOC_RDATA2 _4905_/X _4904_/X _0821_/Q _0820_/Q
+ VPWR VGND sg13cmos5l_mux4_1
XFILLER_220_232 VPWR VGND sg13cmos5l_decap_8
X_3812_ _3812_/X Tile_X0Y0_W2MID[1] Tile_X0Y0_W2END[7] _3853_/X _3852_/X _1081_/Q
+ _1080_/Q VPWR VGND sg13cmos5l_mux4_1
XFILLER_366_225 VPWR VGND sg13cmos5l_decap_8
XANTENNA_16 AXI_M_SOC_RDATA26 VPWR VGND sg13cmos5l_antennanp
X_4792_ _4792_/X Tile_X0Y4_W1END[0] Tile_X0Y4_WW4END[12] Tile_X0Y4_W6END[4] _4336_/X
+ _2121_/Q _2120_/Q VPWR VGND sg13cmos5l_mux4_1
XFILLER_696_98 VPWR VGND sg13cmos5l_decap_8
XFILLER_567_196 VPWR VGND sg13cmos5l_decap_8
XFILLER_268_49 VPWR VGND sg13cmos5l_decap_8
XANTENNA_27 AXI_M_SOC_RDATA26 VPWR VGND sg13cmos5l_antennanp
XFILLER_629_70 VPWR VGND sg13cmos5l_decap_8
XFILLER_32_197 VPWR VGND sg13cmos5l_decap_8
XANTENNA_38 AXI_M_SOC_RDATA8 VPWR VGND sg13cmos5l_antennanp
XANTENNA_49 Tile_X0Y0_FrameData[25] VPWR VGND sg13cmos5l_antennanp
X_3743_ AXI_M_SOC_ARADDR15 Tile_X0Y9_W1END[3] Tile_X0Y9_WW4END[7] Tile_X0Y9_WW4END[15]
+ _4931_/X _0729_/Q _0728_/Q VPWR VGND sg13cmos5l_mux4_1
XFILLER_319_141 VPWR VGND sg13cmos5l_fill_2
X_0955_ _0955_/Q Tile_X0Y0_FrameData[16] VGND VPWR Tile_X0Y9_FrameStrobe[0] latch
XFILLER_565_14 VPWR VGND sg13cmos5l_decap_8
XANTENNA__3376__X Tile_X0Y2_EE4BEG[15] VPWR VGND sg13cmos5l_antennanp
XFILLER_192_128 VPWR VGND sg13cmos5l_decap_8
XFILLER_381_239 VPWR VGND sg13cmos5l_decap_8
XFILLER_334_100 VPWR VGND sg13cmos5l_decap_8
XFILLER_185_191 VPWR VGND sg13cmos5l_fill_1
X_3674_ _3674_/X Tile_X0Y2_WW4END[4] Tile_X0Y2_WW4END[12] Tile_X0Y2_W6END[4] _4120_/X
+ _1497_/Q _1496_/Q VPWR VGND sg13cmos5l_mux4_1
XFILLER_669_204 VPWR VGND sg13cmos5l_decap_8
X_0886_ _0886_/Q Tile_X0Y9_FrameData[9] VGND VPWR Tile_X0Y9_FrameStrobe[6] latch
XFILLER_63_0 VPWR VGND sg13cmos5l_decap_8
XFILLER_133_206 VPWR VGND sg13cmos5l_decap_8
X_2625_ _2625_/Q Tile_X0Y6_FrameData[6] VGND VPWR Tile_X0Y9_FrameStrobe[5] latch
XFILLER_715_28 VPWR VGND sg13cmos5l_decap_8
XFILLER_217_42 VPWR VGND sg13cmos5l_decap_8
XFILLER_645_91 VPWR VGND sg13cmos5l_decap_8
X_2556_ _2556_/Q Tile_X0Y6_FrameData[11] VGND VPWR Tile_X0Y9_FrameStrobe[3] latch
XFILLER_581_35 VPWR VGND sg13cmos5l_decap_8
XFILLER_364_70 VPWR VGND sg13cmos5l_decap_8
XFILLER_287_210 VPWR VGND sg13cmos5l_decap_8
XFILLER_99_153 VPWR VGND sg13cmos5l_fill_2
X_1507_ _1507_/Q Tile_X0Y2_FrameData[14] VGND VPWR Tile_X0Y9_FrameStrobe[2] latch
X_2487_ _2487_/Q Tile_X0Y6_FrameData[16] VGND VPWR Tile_X0Y9_FrameStrobe[1] latch
XFILLER_287_254 VPWR VGND sg13cmos5l_fill_1
XFILLER_692_240 VPWR VGND sg13cmos5l_decap_4
XFILLER_637_145 VPWR VGND sg13cmos5l_decap_8
XFILLER_247_107 VPWR VGND sg13cmos5l_decap_8
X_4226_ _4226_/X _4195_/X _0089_/X _4194_/X Tile_X0Y0_S4END[12] _1721_/Q _1720_/Q
+ VPWR VGND sg13cmos5l_mux4_1
XFILLER_692_251 VPWR VGND sg13cmos5l_decap_8
X_1438_ _1438_/Q Tile_X0Y2_FrameData[19] VGND VPWR Tile_X0Y9_FrameStrobe[0] latch
XFILLER_514_84 VPWR VGND sg13cmos5l_decap_8
XFILLER_652_126 VPWR VGND sg13cmos5l_decap_4
XFILLER_450_28 VPWR VGND sg13cmos5l_decap_8
X_4157_ _4157_/X Tile_X0Y3_W2END[6] AXI_M_SOC_WREADY _4207_/X _4206_/X _1827_/Q _1826_/Q
+ VPWR VGND sg13cmos5l_mux4_1
X_1369_ _1369_/Q Tile_X0Y1_FrameData[0] VGND VPWR Tile_X0Y9_FrameStrobe[5] latch
XFILLER_233_74 VPWR VGND sg13cmos5l_fill_2
XFILLER_380_91 VPWR VGND sg13cmos5l_decap_8
X_3108_ Tile_X0Y7_E6BEG[6] _4650_/X VPWR VGND sg13cmos5l_buf_1
X_4088_ _4088_/X Tile_X0Y1_W1END[0] Tile_X0Y1_W6END[8] _4005_/X _3976_/X _1389_/Q
+ _1388_/Q VPWR VGND sg13cmos5l_mux4_1
XFILLER_404_126 VPWR VGND sg13cmos5l_fill_1
X_3039_ Tile_X0Y5_EE4BEG[14] _4402_/X VPWR VGND sg13cmos5l_buf_1
XFILLER_404_159 VPWR VGND sg13cmos5l_fill_1
XFILLER_102_56 VPWR VGND sg13cmos5l_fill_2
XFILLER_270_198 VPWR VGND sg13cmos5l_decap_8
XFILLER_558_152 VPWR VGND sg13cmos5l_decap_4
XFILLER_357_203 VPWR VGND sg13cmos5l_decap_8
XFILLER_246_8 VPWR VGND sg13cmos5l_decap_8
XFILLER_141_7 VPWR VGND sg13cmos5l_decap_8
XFILLER_211_243 VPWR VGND sg13cmos5l_fill_2
XFILLER_707_105 VPWR VGND sg13cmos5l_decap_8
XFILLER_239_7 VPWR VGND sg13cmos5l_decap_8
XFILLER_573_133 VPWR VGND sg13cmos5l_decap_8
XFILLER_539_92 VPWR VGND sg13cmos5l_decap_4
XFILLER_475_14 VPWR VGND sg13cmos5l_decap_8
XANTENNA__3286__X Tile_X0Y0_E6BEG[6] VPWR VGND sg13cmos5l_antennanp
XFILLER_183_139 VPWR VGND sg13cmos5l_decap_8
XFILLER_372_228 VPWR VGND sg13cmos5l_decap_4
XFILLER_109_236 VPWR VGND sg13cmos5l_decap_8
XFILLER_406_7 VPWR VGND sg13cmos5l_decap_8
XFILLER_715_182 VPWR VGND sg13cmos5l_decap_8
XFILLER_11_42 VPWR VGND sg13cmos5l_decap_8
XFILLER_124_206 VPWR VGND sg13cmos5l_fill_1
XFILLER_625_28 VPWR VGND sg13cmos5l_decap_8
XFILLER_408_63 VPWR VGND sg13cmos5l_decap_8
XFILLER_124_217 VPWR VGND sg13cmos5l_fill_1
XFILLER_124_239 VPWR VGND sg13cmos5l_decap_8
XFILLER_127_42 VPWR VGND sg13cmos5l_decap_8
XFILLER_675_207 VPWR VGND sg13cmos5l_decap_8
XFILLER_491_35 VPWR VGND sg13cmos5l_decap_8
XFILLER_278_210 VPWR VGND sg13cmos5l_decap_8
XFILLER_479_170 VPWR VGND sg13cmos5l_decap_8
XFILLER_274_70 VPWR VGND sg13cmos5l_decap_8
XFILLER_340_169 VPWR VGND sg13cmos5l_decap_8
XFILLER_87_57 VPWR VGND sg13cmos5l_decap_8
XFILLER_494_140 VPWR VGND sg13cmos5l_decap_8
XFILLER_293_213 VPWR VGND sg13cmos5l_decap_4
XFILLER_641_49 VPWR VGND sg13cmos5l_decap_8
XFILLER_293_224 VPWR VGND sg13cmos5l_decap_8
XFILLER_424_84 VPWR VGND sg13cmos5l_decap_8
XFILLER_643_126 VPWR VGND sg13cmos5l_decap_8
XFILLER_143_63 VPWR VGND sg13cmos5l_decap_8
XFILLER_360_28 VPWR VGND sg13cmos5l_decap_8
XFILLER_46_201 VPWR VGND sg13cmos5l_decap_8
XFILLER_293_268 VPWR VGND sg13cmos5l_decap_4
XFILLER_261_110 VPWR VGND sg13cmos5l_decap_8
XFILLER_46_267 VPWR VGND sg13cmos5l_decap_4
XFILLER_265_0 VPWR VGND sg13cmos5l_decap_8
XFILLER_36_72 VPWR VGND sg13cmos5l_decap_8
XFILLER_596_247 VPWR VGND sg13cmos5l_decap_8
XFILLER_549_141 VPWR VGND sg13cmos5l_decap_8
XFILLER_432_0 VPWR VGND sg13cmos5l_decap_8
XFILLER_14_175 VPWR VGND sg13cmos5l_decap_8
XFILLER_202_243 VPWR VGND sg13cmos5l_decap_8
XFILLER_202_254 VPWR VGND sg13cmos5l_fill_2
XFILLER_666_35 VPWR VGND sg13cmos5l_decap_8
XFILLER_564_133 VPWR VGND sg13cmos5l_decap_8
XFILLER_449_70 VPWR VGND sg13cmos5l_decap_8
XFILLER_564_144 VPWR VGND sg13cmos5l_fill_2
XFILLER_385_14 VPWR VGND sg13cmos5l_decap_8
XANTENNA__3196__X Tile_X0Y0_N2BEGb[4] VPWR VGND sg13cmos5l_antennanp
XFILLER_168_71 VPWR VGND sg13cmos5l_decap_8
XFILLER_505_200 VPWR VGND sg13cmos5l_decap_4
X_0740_ _0740_/Q Tile_X0Y9_FrameData[27] VGND VPWR Tile_X0Y9_FrameStrobe[2] latch
XFILLER_706_193 VPWR VGND sg13cmos5l_decap_4
XFILLER_316_144 VPWR VGND sg13cmos5l_decap_8
XFILLER_182_150 VPWR VGND sg13cmos5l_decap_8
XFILLER_535_28 VPWR VGND sg13cmos5l_decap_8
X_0671_ _0671_/Q Tile_X0Y8_FrameData[0] VGND VPWR Tile_X0Y9_FrameStrobe[7] latch
X_2410_ _2410_/Q Tile_X0Y5_FrameData[27] VGND VPWR Tile_X0Y9_FrameStrobe[7] latch
XFILLER_520_214 VPWR VGND sg13cmos5l_decap_8
XFILLER_477_118 VPWR VGND sg13cmos5l_fill_2
X_3390_ Tile_X0Y2_E2BEGb[1] _4049_/X VPWR VGND sg13cmos5l_buf_1
XFILLER_184_92 VPWR VGND sg13cmos5l_decap_8
X_2341_ _2341_/Q Tile_X0Y5_FrameData[0] VGND VPWR Tile_X0Y9_FrameStrobe[4] latch
XFILLER_269_265 VPWR VGND sg13cmos5l_decap_8
XFILLER_674_251 VPWR VGND sg13cmos5l_decap_4
XFILLER_229_118 VPWR VGND sg13cmos5l_decap_8
X_2272_ _2272_/Q Tile_X0Y5_FrameData[5] VGND VPWR Tile_X0Y9_FrameStrobe[2] latch
XFILLER_485_173 VPWR VGND sg13cmos5l_decap_8
XFILLER_551_49 VPWR VGND sg13cmos5l_decap_8
XFILLER_284_224 VPWR VGND sg13cmos5l_decap_8
X_4011_ _4011_/X _3987_/X _0084_/X _3986_/X Tile_X0Y0_S4END[7] _1227_/Q _1226_/Q VPWR
+ VGND sg13cmos5l_mux4_1
XFILLER_634_126 VPWR VGND sg13cmos5l_decap_8
X_1223_ _1223_/Q Tile_X0Y1_FrameData[18] VGND VPWR Tile_X0Y9_FrameStrobe[1] latch
XFILLER_270_28 VPWR VGND sg13cmos5l_decap_8
XFILLER_37_201 VPWR VGND sg13cmos5l_decap_8
XFILLER_237_140 VPWR VGND sg13cmos5l_decap_4
XFILLER_237_162 VPWR VGND sg13cmos5l_decap_8
XFILLER_426_262 VPWR VGND sg13cmos5l_fill_2
X_1154_ _1154_/Q Tile_X0Y0_FrameData[9] VGND VPWR Tile_X0Y9_FrameStrobe[6] latch
XFILLER_398_103 VPWR VGND sg13cmos5l_fill_1
XFILLER_398_114 VPWR VGND sg13cmos5l_decap_4
XFILLER_203_77 VPWR VGND sg13cmos5l_decap_8
X_0105_ AXI_M_SOC_ARLEN4 _0933_/Q _3764_/X VPWR VGND sg13cmos5l_nor2b_1
X_1085_ _1085_/Q Tile_X0Y0_FrameData[14] VGND VPWR Tile_X0Y9_FrameStrobe[4] latch
XFILLER_52_226 VPWR VGND sg13cmos5l_decap_8
XFILLER_398_147 VPWR VGND sg13cmos5l_decap_4
XFILLER_500_42 VPWR VGND sg13cmos5l_decap_8
X_4913_ _4913_/X _4457_/X _4461_/X _4465_/X _4429_/X _2373_/Q _2372_/Q VPWR VGND sg13cmos5l_mux4_1
XFILLER_339_203 VPWR VGND sg13cmos5l_decap_8
X_4844_ _4844_/X Tile_X0Y9_N1END[0] _4896_/X AXI_M_SOC_RDATA3 AXI_M_SOC_RDATA7 _0855_/Q
+ _0854_/Q VPWR VGND sg13cmos5l_mux4_1
XFILLER_20_112 VPWR VGND sg13cmos5l_decap_8
XFILLER_576_35 VPWR VGND sg13cmos5l_decap_8
XFILLER_359_70 VPWR VGND sg13cmos5l_decap_8
X_1987_ _1987_/Q Tile_X0Y4_FrameData[2] VGND VPWR Tile_X0Y9_FrameStrobe[1] latch
X_4775_ _4775_/X _4783_/X Tile_X0Y8_W6END[3] _4782_/X _4775_/A3 _0417_/Q _0672_/Q
+ VPWR VGND sg13cmos5l_mux4_1
XFILLER_354_217 VPWR VGND sg13cmos5l_decap_8
XFILLER_295_36 VPWR VGND sg13cmos5l_decap_8
XFILLER_165_139 VPWR VGND sg13cmos5l_decap_8
XFILLER_158_180 VPWR VGND sg13cmos5l_decap_4
X_0938_ _0938_/Q Tile_X0Y9_FrameData[29] VGND VPWR Tile_X0Y9_FrameStrobe[8] latch
X_3726_ AXI_M_SOC_WVALID Tile_X0Y3_W1END[0] Tile_X0Y3_WW4END[4] Tile_X0Y3_WW4END[12]
+ _4234_/X _1733_/Q _1732_/Q VPWR VGND sg13cmos5l_mux4_1
XFILLER_307_122 VPWR VGND sg13cmos5l_decap_8
XFILLER_509_84 VPWR VGND sg13cmos5l_decap_8
XFILLER_307_133 VPWR VGND sg13cmos5l_fill_1
XFILLER_656_90 VPWR VGND sg13cmos5l_fill_2
XFILLER_570_147 VPWR VGND sg13cmos5l_decap_8
XFILLER_307_155 VPWR VGND sg13cmos5l_decap_8
XFILLER_445_28 VPWR VGND sg13cmos5l_decap_8
X_0869_ _0869_/Q Tile_X0Y9_FrameData[26] VGND VPWR Tile_X0Y9_FrameStrobe[6] latch
X_3657_ AXI_M_SOC_AWADDR18 Tile_X0Y4_WW4END[2] Tile_X0Y4_WW4END[10] Tile_X0Y4_W6END[2]
+ _4338_/X _2009_/Q _2008_/Q VPWR VGND sg13cmos5l_mux4_1
XFILLER_164_29 VPWR VGND sg13cmos5l_decap_8
X_2608_ _2608_/Q Tile_X0Y6_FrameData[23] VGND VPWR Tile_X0Y9_FrameStrobe[5] latch
XFILLER_322_136 VPWR VGND sg13cmos5l_decap_4
X_3588_ Tile_X0Y9_FrameData_O[18] Tile_X0Y9_FrameData[18] VPWR VGND sg13cmos5l_buf_1
XFILLER_712_196 VPWR VGND sg13cmos5l_decap_8
XFILLER_657_229 VPWR VGND sg13cmos5l_decap_4
X_2539_ _2539_/Q Tile_X0Y6_FrameData[28] VGND VPWR Tile_X0Y9_FrameStrobe[3] latch
XFILLER_114_272 VPWR VGND sg13cmos5l_fill_1
XFILLER_665_240 VPWR VGND sg13cmos5l_decap_8
XFILLER_275_202 VPWR VGND sg13cmos5l_decap_4
XFILLER_87_134 VPWR VGND sg13cmos5l_decap_8
XFILLER_275_213 VPWR VGND sg13cmos5l_decap_8
XFILLER_461_49 VPWR VGND sg13cmos5l_decap_8
XFILLER_625_126 VPWR VGND sg13cmos5l_decap_4
XFILLER_180_28 VPWR VGND sg13cmos5l_decap_8
XFILLER_87_178 VPWR VGND sg13cmos5l_decap_8
XFILLER_625_137 VPWR VGND sg13cmos5l_decap_8
X_4209_ _4209_/X _4133_/X _4241_/X _4240_/X _4132_/X _1693_/Q _1692_/Q VPWR VGND sg13cmos5l_mux4_1
XFILLER_275_257 VPWR VGND sg13cmos5l_decap_4
XFILLER_228_140 VPWR VGND sg13cmos5l_fill_2
XFILLER_28_201 VPWR VGND sg13cmos5l_decap_8
XFILLER_189_7 VPWR VGND sg13cmos5l_decap_8
XFILLER_491_154 VPWR VGND sg13cmos5l_decap_8
XFILLER_28_245 VPWR VGND sg13cmos5l_decap_8
XFILLER_363_8 VPWR VGND sg13cmos5l_decap_8
XFILLER_113_77 VPWR VGND sg13cmos5l_decap_8
XFILLER_356_7 VPWR VGND sg13cmos5l_decap_8
XFILLER_243_154 VPWR VGND sg13cmos5l_decap_4
XFILLER_43_226 VPWR VGND sg13cmos5l_decap_8
XFILLER_243_165 VPWR VGND sg13cmos5l_decap_8
XFILLER_578_258 VPWR VGND sg13cmos5l_fill_2
XFILLER_410_42 VPWR VGND sg13cmos5l_decap_8
XFILLER_43_259 VPWR VGND sg13cmos5l_decap_8
XFILLER_389_169 VPWR VGND sg13cmos5l_decap_8
XFILLER_189_59 VPWR VGND sg13cmos5l_decap_8
XFILLER_628_8 VPWR VGND sg13cmos5l_decap_8
XANTENNA__2913__X Tile_X0Y8_E1BEG[1] VPWR VGND sg13cmos5l_antennanp
XFILLER_523_7 VPWR VGND sg13cmos5l_decap_8
XFILLER_51_270 VPWR VGND sg13cmos5l_fill_2
XFILLER_400_140 VPWR VGND sg13cmos5l_decap_8
XFILLER_397_191 VPWR VGND sg13cmos5l_decap_8
XFILLER_486_35 VPWR VGND sg13cmos5l_decap_8
XFILLER_7_105 VPWR VGND sg13cmos5l_decap_8
XFILLER_156_128 VPWR VGND sg13cmos5l_decap_8
XFILLER_636_49 VPWR VGND sg13cmos5l_decap_8
XFILLER_22_63 VPWR VGND sg13cmos5l_decap_8
XFILLER_499_210 VPWR VGND sg13cmos5l_decap_8
XFILLER_419_84 VPWR VGND sg13cmos5l_decap_8
XFILLER_138_63 VPWR VGND sg13cmos5l_decap_8
XFILLER_164_161 VPWR VGND sg13cmos5l_decap_4
XFILLER_355_28 VPWR VGND sg13cmos5l_decap_8
XFILLER_353_250 VPWR VGND sg13cmos5l_fill_2
XANTENNA__3744__X AXI_M_SOC_ARADDR16 VPWR VGND sg13cmos5l_antennanp
XFILLER_502_203 VPWR VGND sg13cmos5l_decap_8
XFILLER_703_163 VPWR VGND sg13cmos5l_decap_8
XFILLER_285_91 VPWR VGND sg13cmos5l_decap_8
XFILLER_459_118 VPWR VGND sg13cmos5l_decap_8
XFILLER_105_272 VPWR VGND sg13cmos5l_fill_1
XFILLER_154_84 VPWR VGND sg13cmos5l_fill_2
XFILLER_371_49 VPWR VGND sg13cmos5l_decap_8
XFILLER_120_242 VPWR VGND sg13cmos5l_decap_8
XFILLER_382_0 VPWR VGND sg13cmos5l_decap_8
XFILLER_304_21 VPWR VGND sg13cmos5l_decap_8
XFILLER_78_189 VPWR VGND sg13cmos5l_fill_1
XFILLER_616_148 VPWR VGND sg13cmos5l_decap_8
XFILLER_266_268 VPWR VGND sg13cmos5l_decap_4
XFILLER_482_154 VPWR VGND sg13cmos5l_decap_8
XFILLER_19_223 VPWR VGND sg13cmos5l_fill_2
XFILLER_219_162 VPWR VGND sg13cmos5l_decap_8
XFILLER_93_159 VPWR VGND sg13cmos5l_fill_2
XFILLER_569_203 VPWR VGND sg13cmos5l_decap_8
XFILLER_647_0 VPWR VGND sg13cmos5l_decap_8
XFILLER_601_63 VPWR VGND sg13cmos5l_decap_8
XFILLER_179_209 VPWR VGND sg13cmos5l_decap_8
XFILLER_63_70 VPWR VGND sg13cmos5l_decap_8
XFILLER_584_228 VPWR VGND sg13cmos5l_decap_4
XFILLER_395_128 VPWR VGND sg13cmos5l_fill_1
XFILLER_320_86 VPWR VGND sg13cmos5l_decap_4
X_1910_ _1910_/Q Tile_X0Y3_FrameData[19] VGND VPWR Tile_X0Y9_FrameStrobe[7] latch
XANTENNA__2823__X Tile_X0Y4_E2BEG[1] VPWR VGND sg13cmos5l_antennanp
X_2890_ Tile_X0Y6_FrameData_O[11] Tile_X0Y6_FrameData[11] VPWR VGND sg13cmos5l_buf_1
XFILLER_249_29 VPWR VGND sg13cmos5l_decap_8
XFILLER_396_35 VPWR VGND sg13cmos5l_decap_8
XFILLER_179_81 VPWR VGND sg13cmos5l_decap_4
XFILLER_8_21 VPWR VGND sg13cmos5l_decap_8
X_1841_ _1841_/Q Tile_X0Y3_FrameData[24] VGND VPWR Tile_X0Y9_FrameStrobe[5] latch
XFILLER_336_206 VPWR VGND sg13cmos5l_decap_8
XFILLER_147_128 VPWR VGND sg13cmos5l_decap_8
XFILLER_552_103 VPWR VGND sg13cmos5l_decap_8
X_4560_ _4560_/X Tile_X0Y2_W1END[0] Tile_X0Y2_WW4END[12] Tile_X0Y2_W6END[4] _4116_/X
+ _1613_/Q _1612_/Q VPWR VGND sg13cmos5l_mux4_1
X_1772_ _1772_/Q Tile_X0Y3_FrameData[29] VGND VPWR Tile_X0Y9_FrameStrobe[3] latch
XFILLER_546_49 VPWR VGND sg13cmos5l_decap_8
XFILLER_8_98 VPWR VGND sg13cmos5l_decap_8
X_0723_ _0723_/Q Tile_X0Y9_FrameData[12] VGND VPWR Tile_X0Y9_FrameStrobe[1] latch
X_3511_ Tile_X0Y1_E2BEG[1] _3933_/X VPWR VGND sg13cmos5l_buf_1
XFILLER_265_28 VPWR VGND sg13cmos5l_decap_8
X_4491_ _4491_/X _4575_/X _4579_/X _4583_/X _4552_/X _2626_/Q _2625_/Q VPWR VGND sg13cmos5l_mux4_1
XFILLER_693_99 VPWR VGND sg13cmos5l_fill_1
XFILLER_344_272 VPWR VGND sg13cmos5l_fill_1
XANTENNA__3654__X AXI_M_SOC_AWADDR15 VPWR VGND sg13cmos5l_antennanp
X_3442_ Tile_X0Y1_FrameData_O[0] Tile_X0Y1_FrameData[0] VPWR VGND sg13cmos5l_buf_1
XFILLER_6_182 VPWR VGND sg13cmos5l_decap_8
X_0654_ _0654_/Q Tile_X0Y8_FrameData[17] VGND VPWR Tile_X0Y9_FrameStrobe[7] latch
XFILLER_304_136 VPWR VGND sg13cmos5l_decap_8
X_3373_ Tile_X0Y2_EE4BEG[12] _4068_/X VPWR VGND sg13cmos5l_buf_1
X_0585_ _0585_/Q Tile_X0Y8_FrameData[22] VGND VPWR Tile_X0Y9_FrameStrobe[5] latch
XFILLER_69_112 VPWR VGND sg13cmos5l_decap_8
XFILLER_458_140 VPWR VGND sg13cmos5l_decap_8
XFILLER_257_202 VPWR VGND sg13cmos5l_fill_1
X_2324_ _2324_/Q Tile_X0Y5_FrameData[17] VGND VPWR Tile_X0Y9_FrameStrobe[4] latch
XFILLER_281_49 VPWR VGND sg13cmos5l_decap_8
XFILLER_111_242 VPWR VGND sg13cmos5l_decap_8
XFILLER_257_224 VPWR VGND sg13cmos5l_decap_8
XFILLER_214_21 VPWR VGND sg13cmos5l_decap_8
XFILLER_642_70 VPWR VGND sg13cmos5l_decap_8
XFILLER_26_0 VPWR VGND sg13cmos5l_decap_8
XFILLER_84_115 VPWR VGND sg13cmos5l_decap_8
X_2255_ _2255_/Q Tile_X0Y5_FrameData[22] VGND VPWR Tile_X0Y9_FrameStrobe[2] latch
XFILLER_69_189 VPWR VGND sg13cmos5l_decap_8
XFILLER_257_268 VPWR VGND sg13cmos5l_decap_4
XFILLER_662_243 VPWR VGND sg13cmos5l_decap_8
XFILLER_662_254 VPWR VGND sg13cmos5l_fill_1
XFILLER_272_216 VPWR VGND sg13cmos5l_decap_4
X_1206_ _1206_/Q Tile_X0Y1_FrameData[3] VGND VPWR Tile_X0Y9_FrameStrobe[0] latch
XFILLER_214_98 VPWR VGND sg13cmos5l_decap_8
X_2186_ _2186_/Q Tile_X0Y5_FrameData[27] VGND VPWR Tile_X0Y9_FrameStrobe[0] latch
XFILLER_615_181 VPWR VGND sg13cmos5l_decap_8
X_1137_ _1137_/Q Tile_X0Y0_FrameData[26] VGND VPWR Tile_X0Y9_FrameStrobe[6] latch
XFILLER_615_192 VPWR VGND sg13cmos5l_fill_1
XFILLER_511_63 VPWR VGND sg13cmos5l_decap_8
XFILLER_414_243 VPWR VGND sg13cmos5l_decap_8
XFILLER_25_215 VPWR VGND sg13cmos5l_decap_8
XFILLER_630_140 VPWR VGND sg13cmos5l_fill_1
X_1068_ _1068_/Q Tile_X0Y0_FrameData[31] VGND VPWR Tile_X0Y9_FrameStrobe[4] latch
XFILLER_575_217 VPWR VGND sg13cmos5l_decap_8
XFILLER_587_56 VPWR VGND sg13cmos5l_decap_8
XFILLER_178_264 VPWR VGND sg13cmos5l_decap_8
X_4827_ _4827_/X Tile_X0Y9_W1END[3] Tile_X0Y9_W6END[11] _4931_/X _4895_/X _0885_/Q
+ _0884_/Q VPWR VGND sg13cmos5l_mux4_1
XFILLER_583_250 VPWR VGND sg13cmos5l_decap_8
XFILLER_528_188 VPWR VGND sg13cmos5l_decap_8
XFILLER_543_125 VPWR VGND sg13cmos5l_fill_1
X_4758_ _4758_/X Tile_X0Y8_WW4END[1] AXI_M_SOC_RDATA9 _4801_/X _4787_/X _0531_/Q _0530_/Q
+ VPWR VGND sg13cmos5l_mux4_1
XFILLER_456_49 VPWR VGND sg13cmos5l_decap_8
XFILLER_193_267 VPWR VGND sg13cmos5l_decap_4
XFILLER_386_90 VPWR VGND sg13cmos5l_decap_8
XFILLER_175_28 VPWR VGND sg13cmos5l_decap_8
X_3709_ AXI_M_SOC_WDATA19 Tile_X0Y6_WW4END[3] Tile_X0Y6_WW4END[11] Tile_X0Y6_W6END[3]
+ _4571_/X _2521_/Q _2520_/Q VPWR VGND sg13cmos5l_mux4_1
XFILLER_4_119 VPWR VGND sg13cmos5l_decap_8
XANTENNA__3564__X Tile_X0Y9_EE4BEG[10] VPWR VGND sg13cmos5l_antennanp
X_4689_ _4689_/X _4663_/X Tile_X0Y9_N4END[9] _4662_/X _0055_/X _0205_/Q _0204_/Q VPWR
+ VGND sg13cmos5l_mux4_1
XFILLER_146_194 VPWR VGND sg13cmos5l_fill_1
XFILLER_104_7 VPWR VGND sg13cmos5l_decap_8
XFILLER_161_131 VPWR VGND sg13cmos5l_decap_8
XFILLER_255_50 VPWR VGND sg13cmos5l_decap_8
XFILLER_108_77 VPWR VGND sg13cmos5l_decap_8
XFILLER_700_155 VPWR VGND sg13cmos5l_decap_8
XFILLER_496_257 VPWR VGND sg13cmos5l_fill_2
XFILLER_496_268 VPWR VGND sg13cmos5l_decap_4
XFILLER_449_151 VPWR VGND sg13cmos5l_fill_1
XFILLER_405_42 VPWR VGND sg13cmos5l_decap_8
XFILLER_700_199 VPWR VGND sg13cmos5l_decap_8
XFILLER_449_173 VPWR VGND sg13cmos5l_decap_8
XFILLER_303_180 VPWR VGND sg13cmos5l_decap_4
XFILLER_248_224 VPWR VGND sg13cmos5l_decap_8
XFILLER_552_70 VPWR VGND sg13cmos5l_decap_8
XFILLER_124_21 VPWR VGND sg13cmos5l_decap_8
XFILLER_552_81 VPWR VGND sg13cmos5l_fill_1
XANTENNA__2908__X Tile_X0Y6_FrameData_O[29] VPWR VGND sg13cmos5l_antennanp
XFILLER_473_7 VPWR VGND sg13cmos5l_decap_8
XFILLER_84_14 VPWR VGND sg13cmos5l_decap_8
XFILLER_75_148 VPWR VGND sg13cmos5l_fill_2
XFILLER_613_107 VPWR VGND sg13cmos5l_decap_8
XFILLER_124_98 VPWR VGND sg13cmos5l_decap_8
XFILLER_702_84 VPWR VGND sg13cmos5l_decap_8
XFILLER_640_7 VPWR VGND sg13cmos5l_decap_8
XFILLER_421_63 VPWR VGND sg13cmos5l_decap_8
XFILLER_405_243 VPWR VGND sg13cmos5l_decap_8
XFILLER_140_42 VPWR VGND sg13cmos5l_decap_8
XFILLER_16_259 VPWR VGND sg13cmos5l_fill_2
XANTENNA__3739__X AXI_M_SOC_ARADDR11 VPWR VGND sg13cmos5l_antennanp
XFILLER_497_56 VPWR VGND sg13cmos5l_decap_8
XFILLER_420_246 VPWR VGND sg13cmos5l_decap_4
XFILLER_231_157 VPWR VGND sg13cmos5l_decap_8
XFILLER_169_231 VPWR VGND sg13cmos5l_decap_8
XFILLER_519_144 VPWR VGND sg13cmos5l_decap_8
XFILLER_581_209 VPWR VGND sg13cmos5l_decap_8
XFILLER_708_255 VPWR VGND sg13cmos5l_fill_1
XFILLER_33_62 VPWR VGND sg13cmos5l_decap_8
XFILLER_318_217 VPWR VGND sg13cmos5l_decap_8
XFILLER_130_0 VPWR VGND sg13cmos5l_decap_8
XFILLER_33_73 VPWR VGND sg13cmos5l_fill_2
XFILLER_228_0 VPWR VGND sg13cmos5l_decap_8
XFILLER_534_136 VPWR VGND sg13cmos5l_decap_8
XFILLER_137_161 VPWR VGND sg13cmos5l_decap_8
XFILLER_663_14 VPWR VGND sg13cmos5l_decap_8
XFILLER_326_261 VPWR VGND sg13cmos5l_decap_4
XANTENNA__3474__X Tile_X0Y1_EE4BEG[0] VPWR VGND sg13cmos5l_antennanp
XFILLER_137_183 VPWR VGND sg13cmos5l_decap_8
XFILLER_542_191 VPWR VGND sg13cmos5l_decap_8
XFILLER_298_124 VPWR VGND sg13cmos5l_decap_8
XFILLER_152_153 VPWR VGND sg13cmos5l_decap_8
XFILLER_597_0 VPWR VGND sg13cmos5l_decap_8
XFILLER_487_268 VPWR VGND sg13cmos5l_decap_4
XFILLER_3_196 VPWR VGND sg13cmos5l_fill_1
XFILLER_239_202 VPWR VGND sg13cmos5l_decap_8
X_0370_ _0370_/Q Tile_X0Y7_FrameData[13] VGND VPWR Tile_X0Y9_FrameStrobe[6] latch
XFILLER_455_110 VPWR VGND sg13cmos5l_fill_1
XFILLER_644_210 VPWR VGND sg13cmos5l_decap_8
XFILLER_239_257 VPWR VGND sg13cmos5l_decap_8
XANTENNA__2818__X Tile_X0Y3_E1BEG[0] VPWR VGND sg13cmos5l_antennanp
XFILLER_58_81 VPWR VGND sg13cmos5l_decap_8
XFILLER_455_143 VPWR VGND sg13cmos5l_decap_4
XFILLER_66_126 VPWR VGND sg13cmos5l_decap_8
X_2040_ _2040_/Q Tile_X0Y4_FrameData[13] VGND VPWR Tile_X0Y9_FrameStrobe[3] latch
XFILLER_455_198 VPWR VGND sg13cmos5l_decap_8
XFILLER_254_249 VPWR VGND sg13cmos5l_decap_8
XFILLER_331_85 VPWR VGND sg13cmos5l_decap_8
XFILLER_207_187 VPWR VGND sg13cmos5l_decap_8
XFILLER_368_117 VPWR VGND sg13cmos5l_decap_8
X_3991_ _3991_/X _3890_/X _4023_/X _4022_/X Tile_X0Y0_S2MID[1] _1199_/Q _1198_/Q VPWR
+ VGND sg13cmos5l_mux4_1
XFILLER_411_235 VPWR VGND sg13cmos5l_decap_8
XANTENNA__3649__X AXI_M_SOC_AWADDR10 VPWR VGND sg13cmos5l_antennanp
XFILLER_612_195 VPWR VGND sg13cmos5l_decap_8
XFILLER_557_228 VPWR VGND sg13cmos5l_decap_4
X_2942_ Tile_X0Y8_E6BEG[10] _4770_/X VPWR VGND sg13cmos5l_buf_1
XFILLER_411_268 VPWR VGND sg13cmos5l_decap_4
XFILLER_200_56 VPWR VGND sg13cmos5l_decap_8
XFILLER_175_201 VPWR VGND sg13cmos5l_decap_8
XFILLER_565_250 VPWR VGND sg13cmos5l_decap_4
X_2873_ Tile_X0Y6_EE4BEG[10] _4522_/X VPWR VGND sg13cmos5l_buf_1
XFILLER_376_172 VPWR VGND sg13cmos5l_fill_1
XFILLER_714_214 VPWR VGND sg13cmos5l_fill_2
XFILLER_525_114 VPWR VGND sg13cmos5l_decap_8
X_4612_ _4612_/X Tile_X0Y7_W2MID[7] AXI_M_SOC_RDATA16 _4669_/X _4668_/X _0335_/Q _0334_/Q
+ VPWR VGND sg13cmos5l_mux4_1
X_1824_ _1824_/Q Tile_X0Y3_FrameData[9] VGND VPWR Tile_X0Y9_FrameStrobe[4] latch
XFILLER_276_49 VPWR VGND sg13cmos5l_decap_8
XFILLER_209_21 VPWR VGND sg13cmos5l_decap_8
XFILLER_714_247 VPWR VGND sg13cmos5l_decap_8
XFILLER_637_70 VPWR VGND sg13cmos5l_decap_8
X_1755_ _1755_/Q Tile_X0Y3_FrameData[14] VGND VPWR Tile_X0Y9_FrameStrobe[2] latch
X_4543_ _4543_/X _4551_/X Tile_X0Y6_W6END[3] _4550_/X _4543_/A3 _2441_/Q _2696_/Q
+ VPWR VGND sg13cmos5l_mux4_1
XFILLER_573_14 VPWR VGND sg13cmos5l_decap_8
XANTENNA__3384__X Tile_X0Y2_E6BEG[7] VPWR VGND sg13cmos5l_antennanp
XFILLER_679_151 VPWR VGND sg13cmos5l_decap_8
X_0706_ _0706_/Q Tile_X0Y9_FrameData[29] VGND VPWR Tile_X0Y9_FrameStrobe[1] latch
XFILLER_332_220 VPWR VGND sg13cmos5l_decap_8
XFILLER_143_131 VPWR VGND sg13cmos5l_decap_8
XFILLER_289_124 VPWR VGND sg13cmos5l_decap_8
XFILLER_209_98 VPWR VGND sg13cmos5l_decap_4
X_1686_ _1686_/Q Tile_X0Y3_FrameData[19] VGND VPWR Tile_X0Y9_FrameStrobe[0] latch
X_4474_ _4474_/X Tile_X0Y4_W2MID[4] Tile_X0Y4_W2END[4] Tile_X0Y4_W6END[11] _4319_/X
+ _2131_/Q _2130_/Q VPWR VGND sg13cmos5l_mux4_1
XFILLER_694_110 VPWR VGND sg13cmos5l_decap_4
XFILLER_332_264 VPWR VGND sg13cmos5l_decap_8
X_0637_ _0637_/Q Tile_X0Y8_FrameData[2] VGND VPWR Tile_X0Y9_FrameStrobe[6] latch
X_3425_ Tile_X0Y4_FrameData_O[16] Tile_X0Y4_FrameData[16] VPWR VGND sg13cmos5l_buf_1
XFILLER_506_63 VPWR VGND sg13cmos5l_decap_8
XFILLER_143_186 VPWR VGND sg13cmos5l_decap_4
XFILLER_653_91 VPWR VGND sg13cmos5l_decap_8
XFILLER_225_42 VPWR VGND sg13cmos5l_decap_8
X_3356_ Tile_X0Y2_FrameData_O[27] Tile_X0Y2_FrameData[27] VPWR VGND sg13cmos5l_buf_1
X_0568_ _0568_/Q Tile_X0Y8_FrameData[7] VGND VPWR Tile_X0Y9_FrameStrobe[4] latch
XFILLER_694_198 VPWR VGND sg13cmos5l_decap_8
XFILLER_442_29 VPWR VGND sg13cmos5l_decap_8
XFILLER_635_210 VPWR VGND sg13cmos5l_fill_2
X_2307_ _2307_/Q Tile_X0Y5_FrameData[2] VGND VPWR Tile_X0Y9_FrameStrobe[3] latch
X_3287_ Tile_X0Y0_E6BEG[7] _3843_/X VPWR VGND sg13cmos5l_buf_1
X_0499_ _0499_/Q Tile_X0Y8_FrameData[12] VGND VPWR Tile_X0Y9_FrameStrobe[2] latch
XFILLER_245_216 VPWR VGND sg13cmos5l_decap_8
X_2238_ _2238_/Q Tile_X0Y5_FrameData[7] VGND VPWR Tile_X0Y9_FrameStrobe[1] latch
XFILLER_446_187 VPWR VGND sg13cmos5l_decap_8
XFILLER_650_224 VPWR VGND sg13cmos5l_fill_1
XFILLER_241_52 VPWR VGND sg13cmos5l_decap_4
XFILLER_650_257 VPWR VGND sg13cmos5l_decap_4
XFILLER_399_220 VPWR VGND sg13cmos5l_decap_8
XFILLER_260_208 VPWR VGND sg13cmos5l_decap_8
X_2169_ _2169_/Q Tile_X0Y4_FrameData[12] VGND VPWR Tile_X0Y9_FrameStrobe[7] latch
XFILLER_650_268 VPWR VGND sg13cmos5l_decap_4
XFILLER_253_260 VPWR VGND sg13cmos5l_decap_8
XFILLER_402_202 VPWR VGND sg13cmos5l_decap_8
XFILLER_399_264 VPWR VGND sg13cmos5l_fill_1
XFILLER_253_271 VPWR VGND sg13cmos5l_fill_2
XFILLER_603_173 VPWR VGND sg13cmos5l_decap_8
XFILLER_548_206 VPWR VGND sg13cmos5l_fill_2
XANTENNA__3559__X Tile_X0Y9_EE4BEG[5] VPWR VGND sg13cmos5l_antennanp
XFILLER_359_128 VPWR VGND sg13cmos5l_decap_8
XFILLER_402_268 VPWR VGND sg13cmos5l_decap_4
XFILLER_110_45 VPWR VGND sg13cmos5l_decap_8
XFILLER_556_250 VPWR VGND sg13cmos5l_decap_8
XFILLER_556_272 VPWR VGND sg13cmos5l_fill_1
XFILLER_166_234 VPWR VGND sg13cmos5l_decap_8
XFILLER_221_7 VPWR VGND sg13cmos5l_decap_8
XFILLER_319_7 VPWR VGND sg13cmos5l_decap_8
XFILLER_547_70 VPWR VGND sg13cmos5l_decap_8
XFILLER_119_21 VPWR VGND sg13cmos5l_decap_8
XFILLER_705_258 VPWR VGND sg13cmos5l_fill_2
XFILLER_315_209 VPWR VGND sg13cmos5l_decap_8
XFILLER_516_169 VPWR VGND sg13cmos5l_decap_4
XFILLER_382_186 VPWR VGND sg13cmos5l_decap_8
XANTENNA__3294__X Tile_X0Y0_E2BEGb[2] VPWR VGND sg13cmos5l_antennanp
XFILLER_119_183 VPWR VGND sg13cmos5l_fill_2
XFILLER_531_117 VPWR VGND sg13cmos5l_decap_8
XFILLER_308_272 VPWR VGND sg13cmos5l_fill_1
XFILLER_181_248 VPWR VGND sg13cmos5l_decap_8
XFILLER_79_14 VPWR VGND sg13cmos5l_decap_8
XFILLER_483_36 VPWR VGND sg13cmos5l_decap_8
XFILLER_134_142 VPWR VGND sg13cmos5l_decap_8
XFILLER_323_242 VPWR VGND sg13cmos5l_decap_8
XFILLER_633_28 VPWR VGND sg13cmos5l_decap_8
XFILLER_590_7 VPWR VGND sg13cmos5l_decap_8
XFILLER_416_63 VPWR VGND sg13cmos5l_decap_8
XFILLER_688_7 VPWR VGND sg13cmos5l_decap_8
XFILLER_295_105 VPWR VGND sg13cmos5l_decap_8
XFILLER_563_91 VPWR VGND sg13cmos5l_decap_8
XFILLER_135_42 VPWR VGND sg13cmos5l_decap_8
XFILLER_484_216 VPWR VGND sg13cmos5l_decap_8
XFILLER_282_70 VPWR VGND sg13cmos5l_decap_8
XFILLER_713_61 VPWR VGND sg13cmos5l_decap_8
XFILLER_95_35 VPWR VGND sg13cmos5l_decap_8
XFILLER_626_232 VPWR VGND sg13cmos5l_decap_8
XFILLER_492_271 VPWR VGND sg13cmos5l_fill_2
XFILLER_48_159 VPWR VGND sg13cmos5l_decap_8
XFILLER_452_113 VPWR VGND sg13cmos5l_fill_1
XFILLER_641_224 VPWR VGND sg13cmos5l_decap_8
XFILLER_598_117 VPWR VGND sg13cmos5l_decap_8
XFILLER_432_84 VPWR VGND sg13cmos5l_decap_8
XFILLER_28_62 VPWR VGND sg13cmos5l_decap_8
XFILLER_28_73 VPWR VGND sg13cmos5l_fill_2
XFILLER_63_118 VPWR VGND sg13cmos5l_decap_8
XFILLER_151_63 VPWR VGND sg13cmos5l_decap_8
XFILLER_178_0 VPWR VGND sg13cmos5l_decap_4
XFILLER_251_219 VPWR VGND sg13cmos5l_decap_8
XFILLER_56_192 VPWR VGND sg13cmos5l_decap_8
XFILLER_301_22 VPWR VGND sg13cmos5l_decap_8
XFILLER_244_271 VPWR VGND sg13cmos5l_fill_2
XFILLER_71_140 VPWR VGND sg13cmos5l_decap_8
XFILLER_204_135 VPWR VGND sg13cmos5l_fill_1
XFILLER_658_14 VPWR VGND sg13cmos5l_decap_8
XANTENNA__3469__X Tile_X0Y1_FrameData_O[27] VPWR VGND sg13cmos5l_antennanp
XFILLER_345_0 VPWR VGND sg13cmos5l_decap_8
XFILLER_204_157 VPWR VGND sg13cmos5l_fill_1
XFILLER_204_179 VPWR VGND sg13cmos5l_decap_8
XFILLER_44_94 VPWR VGND sg13cmos5l_decap_8
XFILLER_365_109 VPWR VGND sg13cmos5l_fill_2
XFILLER_358_161 VPWR VGND sg13cmos5l_decap_8
XFILLER_512_0 VPWR VGND sg13cmos5l_decap_8
XFILLER_157_234 VPWR VGND sg13cmos5l_decap_8
XFILLER_562_220 VPWR VGND sg13cmos5l_decap_8
XFILLER_157_267 VPWR VGND sg13cmos5l_decap_4
XFILLER_674_35 VPWR VGND sg13cmos5l_decap_8
XFILLER_457_70 VPWR VGND sg13cmos5l_decap_8
XFILLER_67_7 VPWR VGND sg13cmos5l_decap_8
XFILLER_522_117 VPWR VGND sg13cmos5l_decap_8
X_1540_ _1540_/Q Tile_X0Y2_FrameData[13] VGND VPWR Tile_X0Y9_FrameStrobe[3] latch
XFILLER_314_253 VPWR VGND sg13cmos5l_fill_2
XFILLER_543_28 VPWR VGND sg13cmos5l_decap_8
XFILLER_326_52 VPWR VGND sg13cmos5l_decap_4
X_1471_ _1471_/Q Tile_X0Y2_FrameData[18] VGND VPWR Tile_X0Y9_FrameStrobe[1] latch
XFILLER_5_77 VPWR VGND sg13cmos5l_decap_8
XFILLER_125_197 VPWR VGND sg13cmos5l_fill_2
XFILLER_286_105 VPWR VGND sg13cmos5l_decap_8
XFILLER_690_56 VPWR VGND sg13cmos5l_fill_2
XFILLER_530_172 VPWR VGND sg13cmos5l_decap_8
XFILLER_473_80 VPWR VGND sg13cmos5l_decap_8
X_3210_ Tile_X0Y0_N1BEG[2] _3782_/X VPWR VGND sg13cmos5l_buf_1
X_0422_ _0422_/Q Tile_X0Y8_FrameData[25] VGND VPWR Tile_X0Y9_FrameStrobe[0] latch
XFILLER_530_194 VPWR VGND sg13cmos5l_fill_2
XFILLER_475_227 VPWR VGND sg13cmos5l_decap_4
X_4190_ _4190_/X AXI_M_SOC_WREADY _4223_/X _4227_/X _4206_/X _1761_/Q _1760_/Q VPWR
+ VGND sg13cmos5l_mux4_1
XFILLER_69_91 VPWR VGND sg13cmos5l_decap_8
XFILLER_676_198 VPWR VGND sg13cmos5l_fill_2
XFILLER_192_81 VPWR VGND sg13cmos5l_decap_8
XFILLER_140_189 VPWR VGND sg13cmos5l_decap_8
X_3141_ Tile_X0Y7_FrameData_O[11] Tile_X0Y7_FrameData[11] VPWR VGND sg13cmos5l_buf_1
X_0353_ _0353_/Q Tile_X0Y7_FrameData[30] VGND VPWR Tile_X0Y9_FrameStrobe[6] latch
XFILLER_428_154 VPWR VGND sg13cmos5l_decap_8
XFILLER_94_232 VPWR VGND sg13cmos5l_decap_8
X_3072_ Tile_X0Y5_FrameData_O[31] Tile_X0Y5_FrameData[31] VPWR VGND sg13cmos5l_buf_1
XFILLER_699_43 VPWR VGND sg13cmos5l_decap_8
X_0284_ _0284_/Q Tile_X0Y7_FrameData[3] VGND VPWR Tile_X0Y9_FrameStrobe[3] latch
XFILLER_342_95 VPWR VGND sg13cmos5l_fill_2
XANTENNA__0068__X AXI_M_SOC_WSTRB3 VPWR VGND sg13cmos5l_antennanp
X_2023_ _2023_/Q Tile_X0Y4_FrameData[30] VGND VPWR Tile_X0Y9_FrameStrobe[3] latch
XFILLER_632_246 VPWR VGND sg13cmos5l_fill_2
XFILLER_242_219 VPWR VGND sg13cmos5l_decap_8
XFILLER_235_260 VPWR VGND sg13cmos5l_fill_2
XFILLER_47_192 VPWR VGND sg13cmos5l_fill_1
XFILLER_568_14 VPWR VGND sg13cmos5l_decap_8
XANTENNA__3379__X Tile_X0Y2_E6BEG[2] VPWR VGND sg13cmos5l_antennanp
XFILLER_211_77 VPWR VGND sg13cmos5l_decap_8
XFILLER_62_173 VPWR VGND sg13cmos5l_decap_8
XFILLER_396_234 VPWR VGND sg13cmos5l_decap_8
XFILLER_62_184 VPWR VGND sg13cmos5l_fill_1
XFILLER_250_263 VPWR VGND sg13cmos5l_decap_8
XFILLER_210_105 VPWR VGND sg13cmos5l_decap_8
X_3974_ _3974_/X AXI_M_SOC_ARREADY _4009_/X _4013_/X _3990_/X _1261_/Q _1260_/Q VPWR
+ VGND sg13cmos5l_mux4_1
XFILLER_93_0 VPWR VGND sg13cmos5l_decap_8
X_2925_ Tile_X0Y8_E2BEGb[1] _4737_/X VPWR VGND sg13cmos5l_buf_1
XFILLER_349_161 VPWR VGND sg13cmos5l_decap_4
XFILLER_538_272 VPWR VGND sg13cmos5l_fill_1
XFILLER_648_91 VPWR VGND sg13cmos5l_decap_8
XFILLER_349_194 VPWR VGND sg13cmos5l_decap_8
XFILLER_699_202 VPWR VGND sg13cmos5l_fill_2
X_2856_ Tile_X0Y6_E6BEG[5] _4533_/X VPWR VGND sg13cmos5l_buf_1
XFILLER_584_35 VPWR VGND sg13cmos5l_decap_8
XFILLER_364_153 VPWR VGND sg13cmos5l_decap_8
XFILLER_553_253 VPWR VGND sg13cmos5l_decap_8
X_1807_ _1807_/Q Tile_X0Y3_FrameData[26] VGND VPWR Tile_X0Y9_FrameStrobe[4] latch
XFILLER_699_257 VPWR VGND sg13cmos5l_decap_4
X_2787_ Tile_X0Y3_EE4BEG[13] _4177_/X VPWR VGND sg13cmos5l_buf_1
XFILLER_702_228 VPWR VGND sg13cmos5l_decap_8
X_4526_ _4526_/X Tile_X0Y6_WW4END[1] AXI_M_SOC_RDATA25 _4569_/X _4555_/X _2555_/Q
+ _2554_/Q VPWR VGND sg13cmos5l_mux4_1
X_1738_ _1738_/Q Tile_X0Y3_FrameData[31] VGND VPWR Tile_X0Y9_FrameStrobe[2] latch
XFILLER_305_253 VPWR VGND sg13cmos5l_decap_4
XFILLER_171_270 VPWR VGND sg13cmos5l_fill_2
XFILLER_521_150 VPWR VGND sg13cmos5l_decap_4
XFILLER_453_28 VPWR VGND sg13cmos5l_decap_8
XFILLER_320_201 VPWR VGND sg13cmos5l_decap_8
XFILLER_116_186 VPWR VGND sg13cmos5l_fill_2
X_4457_ _4457_/X _4424_/X _0100_/X _4423_/X _0140_/X _2225_/Q _2224_/Q VPWR VGND sg13cmos5l_mux4_1
X_1669_ _1669_/Q Tile_X0Y2_FrameData[12] VGND VPWR Tile_X0Y9_FrameStrobe[7] latch
XFILLER_277_105 VPWR VGND sg13cmos5l_decap_8
XFILLER_383_91 VPWR VGND sg13cmos5l_decap_8
X_3408_ Tile_X0Y2_E1BEG[3] _4039_/X VPWR VGND sg13cmos5l_buf_1
XFILLER_277_138 VPWR VGND sg13cmos5l_decap_8
XFILLER_667_198 VPWR VGND sg13cmos5l_decap_8
X_4388_ _4388_/X Tile_X0Y5_WW4END[15] AXI_M_SOC_RVALID _4466_/X _4428_/X _2327_/Q
+ _2326_/Q VPWR VGND sg13cmos5l_mux4_1
XFILLER_608_221 VPWR VGND sg13cmos5l_decap_8
X_3339_ Tile_X0Y2_FrameData_O[10] Tile_X0Y2_FrameData[10] VPWR VGND sg13cmos5l_buf_1
XFILLER_218_205 VPWR VGND sg13cmos5l_decap_8
XFILLER_419_165 VPWR VGND sg13cmos5l_fill_2
XFILLER_105_56 VPWR VGND sg13cmos5l_decap_8
XFILLER_85_254 VPWR VGND sg13cmos5l_decap_8
XFILLER_285_182 VPWR VGND sg13cmos5l_decap_8
XFILLER_65_49 VPWR VGND sg13cmos5l_decap_8
XFILLER_623_235 VPWR VGND sg13cmos5l_decap_4
XFILLER_402_21 VPWR VGND sg13cmos5l_decap_8
XFILLER_623_246 VPWR VGND sg13cmos5l_decap_8
XFILLER_171_7 VPWR VGND sg13cmos5l_decap_8
XFILLER_434_157 VPWR VGND sg13cmos5l_decap_8
XANTENNA_106 _0157_/X VPWR VGND sg13cmos5l_antennanp
XFILLER_623_268 VPWR VGND sg13cmos5l_decap_4
XFILLER_38_181 VPWR VGND sg13cmos5l_decap_8
XFILLER_269_7 VPWR VGND sg13cmos5l_decap_8
XANTENNA_117 Tile_X0Y6_FrameData[30] VPWR VGND sg13cmos5l_antennanp
XANTENNA_128 Tile_X0Y6_FrameData[31] VPWR VGND sg13cmos5l_antennanp
XANTENNA_139 Tile_X0Y6_FrameData[31] VPWR VGND sg13cmos5l_antennanp
XFILLER_402_98 VPWR VGND sg13cmos5l_decap_8
XFILLER_53_151 VPWR VGND sg13cmos5l_decap_8
XFILLER_478_14 VPWR VGND sg13cmos5l_decap_8
XANTENNA__3289__X Tile_X0Y0_E6BEG[9] VPWR VGND sg13cmos5l_antennanp
XFILLER_121_77 VPWR VGND sg13cmos5l_decap_8
XFILLER_436_7 VPWR VGND sg13cmos5l_decap_8
XFILLER_529_250 VPWR VGND sg13cmos5l_decap_8
XFILLER_14_42 VPWR VGND sg13cmos5l_decap_8
XANTENNA__2921__X Tile_X0Y8_E2BEG[5] VPWR VGND sg13cmos5l_antennanp
XFILLER_603_7 VPWR VGND sg13cmos5l_decap_8
XFILLER_494_35 VPWR VGND sg13cmos5l_decap_8
XFILLER_277_70 VPWR VGND sg13cmos5l_decap_8
XFILLER_544_264 VPWR VGND sg13cmos5l_fill_1
XFILLER_355_175 VPWR VGND sg13cmos5l_decap_8
XFILLER_154_226 VPWR VGND sg13cmos5l_fill_1
XFILLER_370_112 VPWR VGND sg13cmos5l_decap_8
XFILLER_154_248 VPWR VGND sg13cmos5l_decap_4
XFILLER_107_153 VPWR VGND sg13cmos5l_decap_8
XFILLER_644_49 VPWR VGND sg13cmos5l_decap_8
XFILLER_427_84 VPWR VGND sg13cmos5l_decap_8
XFILLER_370_178 VPWR VGND sg13cmos5l_decap_8
XFILLER_146_63 VPWR VGND sg13cmos5l_decap_8
XFILLER_701_261 VPWR VGND sg13cmos5l_decap_8
XANTENNA__3752__X AXI_M_SOC_ARADDR24 VPWR VGND sg13cmos5l_antennanp
XFILLER_701_272 VPWR VGND sg13cmos5l_fill_1
XFILLER_512_183 VPWR VGND sg13cmos5l_decap_8
XFILLER_293_91 VPWR VGND sg13cmos5l_fill_1
XFILLER_268_116 VPWR VGND sg13cmos5l_decap_8
XFILLER_268_127 VPWR VGND sg13cmos5l_fill_1
XFILLER_268_138 VPWR VGND sg13cmos5l_decap_8
XFILLER_673_113 VPWR VGND sg13cmos5l_decap_8
XFILLER_311_256 VPWR VGND sg13cmos5l_fill_1
XFILLER_295_0 VPWR VGND sg13cmos5l_decap_4
XFILLER_283_119 VPWR VGND sg13cmos5l_decap_8
XFILLER_39_83 VPWR VGND sg13cmos5l_fill_2
XFILLER_162_73 VPWR VGND sg13cmos5l_decap_8
XFILLER_76_254 VPWR VGND sg13cmos5l_decap_8
XFILLER_462_0 VPWR VGND sg13cmos5l_decap_8
XFILLER_36_107 VPWR VGND sg13cmos5l_decap_8
XFILLER_312_21 VPWR VGND sg13cmos5l_decap_8
XFILLER_480_241 VPWR VGND sg13cmos5l_decap_8
XFILLER_224_208 VPWR VGND sg13cmos5l_decap_4
XFILLER_425_168 VPWR VGND sg13cmos5l_decap_8
XFILLER_29_170 VPWR VGND sg13cmos5l_decap_8
XFILLER_224_219 VPWR VGND sg13cmos5l_decap_8
XFILLER_217_260 VPWR VGND sg13cmos5l_fill_2
XFILLER_91_246 VPWR VGND sg13cmos5l_fill_1
XFILLER_669_35 VPWR VGND sg13cmos5l_decap_8
XFILLER_440_105 VPWR VGND sg13cmos5l_decap_4
XFILLER_312_65 VPWR VGND sg13cmos5l_decap_8
XFILLER_189_101 VPWR VGND sg13cmos5l_decap_8
XFILLER_388_14 VPWR VGND sg13cmos5l_decap_8
XANTENNA__3199__X Tile_X0Y0_N2BEGb[7] VPWR VGND sg13cmos5l_antennanp
XFILLER_189_123 VPWR VGND sg13cmos5l_decap_8
XFILLER_669_79 VPWR VGND sg13cmos5l_decap_8
XFILLER_527_209 VPWR VGND sg13cmos5l_fill_2
X_0971_ _0971_/Q Tile_X0Y0_FrameData[0] VGND VPWR Tile_X0Y9_FrameStrobe[0] latch
XFILLER_685_34 VPWR VGND sg13cmos5l_decap_8
XFILLER_538_28 VPWR VGND sg13cmos5l_decap_8
XFILLER_393_226 VPWR VGND sg13cmos5l_decap_8
XFILLER_594_197 VPWR VGND sg13cmos5l_decap_8
XFILLER_71_70 VPWR VGND sg13cmos5l_decap_8
XANTENNA__2831__X Tile_X0Y6_E1BEG[0] VPWR VGND sg13cmos5l_antennanp
X_2710_ _4419_/A3 VPWR VGND sg13cmos5l_tielo
XFILLER_346_131 VPWR VGND sg13cmos5l_decap_8
X_3690_ AXI_M_SOC_WDATA0 Tile_X0Y7_WW4END[0] Tile_X0Y7_WW4END[8] Tile_X0Y7_W6END[0]
+ _4684_/X _0247_/Q _0246_/Q VPWR VGND sg13cmos5l_mux4_1
XFILLER_145_204 VPWR VGND sg13cmos5l_decap_8
XFILLER_535_264 VPWR VGND sg13cmos5l_decap_8
X_2641_ _2641_/Q Tile_X0Y6_FrameData[22] VGND VPWR Tile_X0Y9_FrameStrobe[6] latch
XFILLER_550_212 VPWR VGND sg13cmos5l_decap_8
XFILLER_696_227 VPWR VGND sg13cmos5l_fill_1
X_2572_ _2572_/Q Tile_X0Y6_FrameData[27] VGND VPWR Tile_X0Y9_FrameStrobe[4] latch
XFILLER_554_49 VPWR VGND sg13cmos5l_decap_8
XFILLER_361_156 VPWR VGND sg13cmos5l_decap_8
XFILLER_361_167 VPWR VGND sg13cmos5l_fill_2
XFILLER_113_101 VPWR VGND sg13cmos5l_decap_4
X_4311_ _4311_/X Tile_X0Y5_W1END[3] Tile_X0Y5_W6END[7] _4466_/X _4425_/X _2433_/Q
+ _2432_/Q VPWR VGND sg13cmos5l_mux4_1
XFILLER_273_28 VPWR VGND sg13cmos5l_decap_8
X_1523_ _1523_/Q Tile_X0Y2_FrameData[30] VGND VPWR Tile_X0Y9_FrameStrobe[3] latch
XFILLER_649_143 VPWR VGND sg13cmos5l_decap_8
XFILLER_503_161 VPWR VGND sg13cmos5l_decap_8
XFILLER_302_201 VPWR VGND sg13cmos5l_fill_2
XANTENNA__3662__X AXI_M_SOC_AWADDR23 VPWR VGND sg13cmos5l_antennanp
XFILLER_113_134 VPWR VGND sg13cmos5l_decap_8
XFILLER_448_216 VPWR VGND sg13cmos5l_fill_1
XFILLER_259_127 VPWR VGND sg13cmos5l_fill_1
X_1454_ _1454_/Q Tile_X0Y2_FrameData[3] VGND VPWR Tile_X0Y9_FrameStrobe[0] latch
X_4242_ _4242_/X Tile_X0Y2_W2MID[4] Tile_X0Y2_W2END[4] Tile_X0Y2_W6END[11] _4103_/X
+ _1623_/Q _1622_/Q VPWR VGND sg13cmos5l_mux4_1
XFILLER_448_238 VPWR VGND sg13cmos5l_decap_8
XFILLER_259_149 VPWR VGND sg13cmos5l_decap_8
X_0405_ _0405_/Q Tile_X0Y7_FrameData[10] VGND VPWR Tile_X0Y9_FrameStrobe[7] latch
XFILLER_206_77 VPWR VGND sg13cmos5l_decap_8
X_4173_ _4173_/X Tile_X0Y3_WW4END[6] AXI_M_SOC_WREADY _4228_/X _4206_/X _1795_/Q _1794_/Q
+ VPWR VGND sg13cmos5l_mux4_1
XFILLER_67_210 VPWR VGND sg13cmos5l_decap_8
X_1385_ _1385_/Q Tile_X0Y1_FrameData[16] VGND VPWR Tile_X0Y9_FrameStrobe[6] latch
XFILLER_463_219 VPWR VGND sg13cmos5l_decap_8
XFILLER_267_171 VPWR VGND sg13cmos5l_fill_1
XFILLER_503_42 VPWR VGND sg13cmos5l_decap_8
XFILLER_267_182 VPWR VGND sg13cmos5l_decap_8
X_0336_ _0336_/Q Tile_X0Y7_FrameData[15] VGND VPWR Tile_X0Y9_FrameStrobe[5] latch
X_3124_ Tile_X0Y7_EE4BEG[10] _4638_/X VPWR VGND sg13cmos5l_buf_1
XFILLER_222_21 VPWR VGND sg13cmos5l_decap_8
XFILLER_650_70 VPWR VGND sg13cmos5l_decap_8
X_3055_ Tile_X0Y5_FrameData_O[14] Tile_X0Y5_FrameData[14] VPWR VGND sg13cmos5l_buf_1
X_0267_ _0267_/Q Tile_X0Y7_FrameData[20] VGND VPWR Tile_X0Y9_FrameStrobe[3] latch
XFILLER_208_260 VPWR VGND sg13cmos5l_fill_2
XFILLER_431_105 VPWR VGND sg13cmos5l_decap_8
XFILLER_208_271 VPWR VGND sg13cmos5l_fill_2
XFILLER_579_35 VPWR VGND sg13cmos5l_decap_8
X_2006_ _2006_/Q Tile_X0Y4_FrameData[15] VGND VPWR Tile_X0Y9_FrameStrobe[2] latch
XFILLER_282_196 VPWR VGND sg13cmos5l_decap_8
XFILLER_620_227 VPWR VGND sg13cmos5l_fill_1
XFILLER_298_14 VPWR VGND sg13cmos5l_decap_8
X_0198_ _0198_/Q Tile_X0Y7_FrameData[25] VGND VPWR Tile_X0Y9_FrameStrobe[1] latch
XFILLER_35_173 VPWR VGND sg13cmos5l_decap_8
XFILLER_585_131 VPWR VGND sg13cmos5l_decap_4
XFILLER_369_256 VPWR VGND sg13cmos5l_fill_2
XFILLER_384_215 VPWR VGND sg13cmos5l_decap_4
XFILLER_448_28 VPWR VGND sg13cmos5l_decap_8
XFILLER_195_137 VPWR VGND sg13cmos5l_fill_2
X_3957_ _3957_/X Tile_X0Y1_WW4END[6] AXI_M_SOC_ARREADY _4014_/X _3990_/X _1295_/Q
+ _1294_/Q VPWR VGND sg13cmos5l_mux4_1
XFILLER_51_18 VPWR VGND sg13cmos5l_fill_2
XFILLER_595_56 VPWR VGND sg13cmos5l_decap_4
XANTENNA__2741__X Tile_X0Y3_UserCLKo VPWR VGND sg13cmos5l_antennanp
X_2908_ Tile_X0Y6_FrameData_O[29] Tile_X0Y6_FrameData[29] VPWR VGND sg13cmos5l_buf_1
X_3888_ _3888_/X Tile_X0Y2_W2MID[7] Tile_X0Y2_W2END[7] Tile_X0Y2_W6END[7] _4097_/X
+ _1665_/Q _1664_/Q VPWR VGND sg13cmos5l_mux4_1
XFILLER_337_153 VPWR VGND sg13cmos5l_decap_8
X_2839_ Tile_X0Y6_E2BEG[4] _4500_/X VPWR VGND sg13cmos5l_buf_1
XFILLER_352_112 VPWR VGND sg13cmos5l_decap_8
XFILLER_498_105 VPWR VGND sg13cmos5l_decap_8
XFILLER_151_207 VPWR VGND sg13cmos5l_fill_2
XFILLER_464_49 VPWR VGND sg13cmos5l_decap_8
X_4509_ _4509_/X Tile_X0Y6_W2END[2] AXI_M_SOC_RDATA26 _4557_/X _4556_/X _2589_/Q _2588_/Q
+ VPWR VGND sg13cmos5l_mux4_1
XFILLER_352_189 VPWR VGND sg13cmos5l_decap_8
XANTENNA__3572__X Tile_X0Y9_FrameData_O[2] VPWR VGND sg13cmos5l_antennanp
XFILLER_104_134 VPWR VGND sg13cmos5l_decap_4
XFILLER_695_271 VPWR VGND sg13cmos5l_fill_2
XFILLER_439_238 VPWR VGND sg13cmos5l_decap_4
XFILLER_104_167 VPWR VGND sg13cmos5l_decap_8
XFILLER_439_249 VPWR VGND sg13cmos5l_decap_8
XFILLER_393_8 VPWR VGND sg13cmos5l_decap_8
XFILLER_116_77 VPWR VGND sg13cmos5l_decap_8
XFILLER_116_88 VPWR VGND sg13cmos5l_fill_2
XFILLER_386_7 VPWR VGND sg13cmos5l_decap_8
XFILLER_670_105 VPWR VGND sg13cmos5l_decap_8
XFILLER_58_232 VPWR VGND sg13cmos5l_decap_8
XFILLER_447_260 VPWR VGND sg13cmos5l_fill_2
XFILLER_413_42 VPWR VGND sg13cmos5l_decap_8
XFILLER_560_70 VPWR VGND sg13cmos5l_decap_8
XFILLER_132_21 VPWR VGND sg13cmos5l_decap_8
XFILLER_462_230 VPWR VGND sg13cmos5l_decap_8
XFILLER_18_129 VPWR VGND sg13cmos5l_decap_8
XANTENNA__2916__X Tile_X0Y8_E2BEG[0] VPWR VGND sg13cmos5l_antennanp
XFILLER_553_7 VPWR VGND sg13cmos5l_decap_8
XFILLER_407_168 VPWR VGND sg13cmos5l_decap_8
XFILLER_273_163 VPWR VGND sg13cmos5l_decap_4
XFILLER_422_105 VPWR VGND sg13cmos5l_decap_8
XFILLER_407_179 VPWR VGND sg13cmos5l_fill_2
XFILLER_92_14 VPWR VGND sg13cmos5l_decap_8
XFILLER_489_35 VPWR VGND sg13cmos5l_decap_8
XFILLER_611_216 VPWR VGND sg13cmos5l_decap_8
XFILLER_132_98 VPWR VGND sg13cmos5l_decap_8
XFILLER_710_84 VPWR VGND sg13cmos5l_decap_8
XFILLER_214_241 VPWR VGND sg13cmos5l_fill_1
XFILLER_26_184 VPWR VGND sg13cmos5l_decap_8
XFILLER_639_49 VPWR VGND sg13cmos5l_decap_8
XFILLER_576_153 VPWR VGND sg13cmos5l_decap_8
XFILLER_430_182 VPWR VGND sg13cmos5l_decap_8
XFILLER_358_28 VPWR VGND sg13cmos5l_decap_8
XFILLER_375_226 VPWR VGND sg13cmos5l_decap_8
XFILLER_25_96 VPWR VGND sg13cmos5l_decap_8
XFILLER_186_137 VPWR VGND sg13cmos5l_decap_8
XFILLER_591_112 VPWR VGND sg13cmos5l_decap_8
XANTENNA__3747__X AXI_M_SOC_ARADDR19 VPWR VGND sg13cmos5l_antennanp
XFILLER_328_142 VPWR VGND sg13cmos5l_decap_8
XFILLER_194_170 VPWR VGND sg13cmos5l_decap_8
XFILLER_210_0 VPWR VGND sg13cmos5l_decap_8
XFILLER_343_123 VPWR VGND sg13cmos5l_decap_8
XFILLER_343_134 VPWR VGND sg13cmos5l_fill_2
XFILLER_308_0 VPWR VGND sg13cmos5l_decap_8
XFILLER_374_38 VPWR VGND sg13cmos5l_fill_1
XFILLER_678_238 VPWR VGND sg13cmos5l_decap_8
XFILLER_532_245 VPWR VGND sg13cmos5l_decap_8
XFILLER_489_149 VPWR VGND sg13cmos5l_decap_8
XFILLER_307_21 VPWR VGND sg13cmos5l_decap_8
XFILLER_671_14 VPWR VGND sg13cmos5l_decap_8
XFILLER_454_60 VPWR VGND sg13cmos5l_fill_2
XANTENNA__3482__X Tile_X0Y1_EE4BEG[8] VPWR VGND sg13cmos5l_antennanp
XFILLER_307_76 VPWR VGND sg13cmos5l_decap_8
XFILLER_150_240 VPWR VGND sg13cmos5l_decap_8
XFILLER_497_182 VPWR VGND sg13cmos5l_decap_8
XFILLER_110_104 VPWR VGND sg13cmos5l_decap_8
XFILLER_296_255 VPWR VGND sg13cmos5l_fill_2
XFILLER_1_272 VPWR VGND sg13cmos5l_fill_1
XFILLER_677_0 VPWR VGND sg13cmos5l_decap_8
XFILLER_604_63 VPWR VGND sg13cmos5l_decap_8
XFILLER_500_175 VPWR VGND sg13cmos5l_decap_8
XFILLER_646_168 VPWR VGND sg13cmos5l_decap_8
XFILLER_256_119 VPWR VGND sg13cmos5l_decap_8
XFILLER_110_148 VPWR VGND sg13cmos5l_decap_8
XFILLER_49_232 VPWR VGND sg13cmos5l_decap_8
XFILLER_438_260 VPWR VGND sg13cmos5l_fill_1
XFILLER_2_56 VPWR VGND sg13cmos5l_decap_8
X_1170_ _1170_/Q Tile_X0Y0_FrameData[25] VGND VPWR Tile_X0Y9_FrameStrobe[7] latch
XFILLER_453_241 VPWR VGND sg13cmos5l_decap_4
XFILLER_264_141 VPWR VGND sg13cmos5l_decap_8
X_0121_ _3181_/A _3916_/X _3917_/X _1644_/Q VPWR VGND sg13cmos5l_mux2_1
XFILLER_66_70 VPWR VGND sg13cmos5l_decap_8
XFILLER_64_224 VPWR VGND sg13cmos5l_decap_8
XANTENNA__2826__X Tile_X0Y4_E2BEG[4] VPWR VGND sg13cmos5l_antennanp
XFILLER_413_105 VPWR VGND sg13cmos5l_decap_8
XFILLER_399_35 VPWR VGND sg13cmos5l_decap_8
X_0052_ AXI_M_SOC_AWBURST0 _0938_/Q _3682_/X VPWR VGND sg13cmos5l_or2_1
XFILLER_17_162 VPWR VGND sg13cmos5l_decap_8
XFILLER_205_252 VPWR VGND sg13cmos5l_decap_4
X_4860_ _4860_/X Tile_X0Y9_W2END[3] AXI_M_SOC_RDATA3 _4907_/X _4906_/X _0823_/Q _0822_/Q
+ VPWR VGND sg13cmos5l_mux4_1
XFILLER_32_121 VPWR VGND sg13cmos5l_decap_8
XFILLER_549_49 VPWR VGND sg13cmos5l_decap_8
X_3811_ _3811_/X Tile_X0Y0_W2MID[0] _3853_/X _3852_/X _3860_/X _1083_/Q _1082_/Q VPWR
+ VGND sg13cmos5l_mux4_1
XFILLER_696_77 VPWR VGND sg13cmos5l_decap_8
XFILLER_421_182 VPWR VGND sg13cmos5l_decap_8
XFILLER_567_175 VPWR VGND sg13cmos5l_decap_8
XFILLER_268_28 VPWR VGND sg13cmos5l_decap_8
X_4791_ _4791_/X _4707_/X Tile_X0Y9_N2MID[3] _4819_/X _4706_/X _0433_/Q _0432_/Q VPWR
+ VGND sg13cmos5l_mux4_1
XANTENNA_17 AXI_M_SOC_RDATA26 VPWR VGND sg13cmos5l_antennanp
XANTENNA__3657__X AXI_M_SOC_AWADDR18 VPWR VGND sg13cmos5l_antennanp
XANTENNA_28 AXI_M_SOC_RDATA26 VPWR VGND sg13cmos5l_antennanp
XFILLER_177_159 VPWR VGND sg13cmos5l_fill_2
XANTENNA_39 AXI_M_SOC_RDATA8 VPWR VGND sg13cmos5l_antennanp
X_3742_ AXI_M_SOC_ARADDR14 Tile_X0Y9_W1END[2] Tile_X0Y9_WW4END[6] Tile_X0Y9_WW4END[14]
+ _4930_/X _0731_/Q _0730_/Q VPWR VGND sg13cmos5l_mux4_1
X_0954_ _0954_/Q Tile_X0Y0_FrameData[17] VGND VPWR Tile_X0Y9_FrameStrobe[0] latch
XFILLER_118_204 VPWR VGND sg13cmos5l_decap_8
X_3673_ _3673_/X Tile_X0Y2_WW4END[3] Tile_X0Y2_WW4END[11] Tile_X0Y2_W6END[3] _4119_/X
+ _1499_/Q _1498_/Q VPWR VGND sg13cmos5l_mux4_1
X_0885_ _0885_/Q Tile_X0Y9_FrameData[10] VGND VPWR Tile_X0Y9_FrameStrobe[6] latch
X_2624_ _2624_/Q Tile_X0Y6_FrameData[7] VGND VPWR Tile_X0Y9_FrameStrobe[5] latch
XFILLER_284_49 VPWR VGND sg13cmos5l_decap_8
XFILLER_645_70 VPWR VGND sg13cmos5l_decap_8
XFILLER_217_21 VPWR VGND sg13cmos5l_decap_8
XFILLER_56_0 VPWR VGND sg13cmos5l_fill_1
XFILLER_581_14 VPWR VGND sg13cmos5l_decap_8
XFILLER_99_121 VPWR VGND sg13cmos5l_decap_8
X_2555_ _2555_/Q Tile_X0Y6_FrameData[12] VGND VPWR Tile_X0Y9_FrameStrobe[3] latch
XFILLER_495_119 VPWR VGND sg13cmos5l_decap_8
XANTENNA__3392__X Tile_X0Y2_E2BEGb[3] VPWR VGND sg13cmos5l_antennanp
X_1506_ _1506_/Q Tile_X0Y2_FrameData[15] VGND VPWR Tile_X0Y9_FrameStrobe[2] latch
XFILLER_217_98 VPWR VGND sg13cmos5l_fill_2
XFILLER_637_124 VPWR VGND sg13cmos5l_decap_8
XFILLER_141_262 VPWR VGND sg13cmos5l_decap_8
X_2486_ _2486_/Q Tile_X0Y6_FrameData[17] VGND VPWR Tile_X0Y9_FrameStrobe[1] latch
XFILLER_99_198 VPWR VGND sg13cmos5l_decap_8
X_4225_ _4225_/X _4203_/X _0046_/X _4202_/X Tile_X0Y0_S4END[15] _1723_/Q _1722_/Q
+ VPWR VGND sg13cmos5l_mux4_1
XFILLER_514_63 VPWR VGND sg13cmos5l_decap_8
X_1437_ _1437_/Q Tile_X0Y2_FrameData[20] VGND VPWR Tile_X0Y9_FrameStrobe[0] latch
XFILLER_652_105 VPWR VGND sg13cmos5l_decap_8
X_1368_ _1368_/Q Tile_X0Y1_FrameData[1] VGND VPWR Tile_X0Y9_FrameStrobe[5] latch
X_4156_ _4156_/X Tile_X0Y3_W2END[7] AXI_M_SOC_BVALID _4205_/X _4204_/X _1829_/Q _1828_/Q
+ VPWR VGND sg13cmos5l_mux4_1
XFILLER_652_149 VPWR VGND sg13cmos5l_fill_1
XFILLER_46_29 VPWR VGND sg13cmos5l_decap_8
XFILLER_255_141 VPWR VGND sg13cmos5l_fill_2
X_0319_ _0319_/Q Tile_X0Y7_FrameData[0] VGND VPWR Tile_X0Y9_FrameStrobe[4] latch
X_3107_ Tile_X0Y7_E6BEG[5] _4649_/X VPWR VGND sg13cmos5l_buf_1
XFILLER_233_97 VPWR VGND sg13cmos5l_decap_8
X_1299_ _1299_/Q Tile_X0Y1_FrameData[6] VGND VPWR Tile_X0Y9_FrameStrobe[3] latch
X_4087_ _4087_/X _4095_/X Tile_X0Y2_W6END[3] _4094_/X _4087_/A3 _1427_/Q _1674_/Q
+ VPWR VGND sg13cmos5l_mux4_1
X_3038_ Tile_X0Y5_EE4BEG[13] _4401_/X VPWR VGND sg13cmos5l_buf_1
XFILLER_102_35 VPWR VGND sg13cmos5l_decap_8
XFILLER_270_177 VPWR VGND sg13cmos5l_decap_8
XFILLER_102_79 VPWR VGND sg13cmos5l_decap_8
XFILLER_459_49 VPWR VGND sg13cmos5l_decap_8
XFILLER_412_160 VPWR VGND sg13cmos5l_fill_2
XFILLER_211_222 VPWR VGND sg13cmos5l_decap_8
XFILLER_601_271 VPWR VGND sg13cmos5l_fill_2
XFILLER_178_17 VPWR VGND sg13cmos5l_fill_1
XFILLER_558_164 VPWR VGND sg13cmos5l_decap_8
XFILLER_178_39 VPWR VGND sg13cmos5l_decap_8
XFILLER_573_112 VPWR VGND sg13cmos5l_decap_8
XANTENNA__3567__X Tile_X0Y9_EE4BEG[13] VPWR VGND sg13cmos5l_antennanp
XFILLER_539_71 VPWR VGND sg13cmos5l_decap_8
XFILLER_357_259 VPWR VGND sg13cmos5l_decap_8
XFILLER_23_198 VPWR VGND sg13cmos5l_decap_8
XFILLER_134_7 VPWR VGND sg13cmos5l_decap_8
XFILLER_183_118 VPWR VGND sg13cmos5l_decap_8
XFILLER_372_207 VPWR VGND sg13cmos5l_decap_8
XFILLER_109_215 VPWR VGND sg13cmos5l_decap_8
XFILLER_573_189 VPWR VGND sg13cmos5l_decap_8
XFILLER_715_161 VPWR VGND sg13cmos5l_decap_8
XFILLER_176_192 VPWR VGND sg13cmos5l_decap_8
XFILLER_258_94 VPWR VGND sg13cmos5l_decap_8
XFILLER_11_21 VPWR VGND sg13cmos5l_decap_8
XFILLER_408_42 VPWR VGND sg13cmos5l_decap_8
XFILLER_380_262 VPWR VGND sg13cmos5l_decap_8
XFILLER_127_21 VPWR VGND sg13cmos5l_decap_8
XFILLER_491_14 VPWR VGND sg13cmos5l_decap_8
XFILLER_11_98 VPWR VGND sg13cmos5l_fill_1
XFILLER_668_271 VPWR VGND sg13cmos5l_fill_2
XFILLER_87_36 VPWR VGND sg13cmos5l_decap_8
XFILLER_705_84 VPWR VGND sg13cmos5l_decap_8
XFILLER_683_241 VPWR VGND sg13cmos5l_decap_8
XFILLER_670_7 VPWR VGND sg13cmos5l_decap_8
XFILLER_641_28 VPWR VGND sg13cmos5l_decap_8
XFILLER_424_63 VPWR VGND sg13cmos5l_decap_8
XFILLER_643_105 VPWR VGND sg13cmos5l_decap_8
XFILLER_143_42 VPWR VGND sg13cmos5l_decap_8
XFILLER_571_91 VPWR VGND sg13cmos5l_decap_8
XFILLER_494_196 VPWR VGND sg13cmos5l_decap_4
XFILLER_435_241 VPWR VGND sg13cmos5l_decap_8
XFILLER_290_92 VPWR VGND sg13cmos5l_decap_8
XFILLER_435_263 VPWR VGND sg13cmos5l_fill_1
XFILLER_46_246 VPWR VGND sg13cmos5l_decap_8
XFILLER_651_182 VPWR VGND sg13cmos5l_decap_8
XFILLER_440_84 VPWR VGND sg13cmos5l_decap_8
XFILLER_160_0 VPWR VGND sg13cmos5l_decap_8
XFILLER_450_266 VPWR VGND sg13cmos5l_decap_8
XFILLER_258_0 VPWR VGND sg13cmos5l_decap_8
XFILLER_261_177 VPWR VGND sg13cmos5l_decap_8
XFILLER_410_119 VPWR VGND sg13cmos5l_decap_8
XFILLER_369_49 VPWR VGND sg13cmos5l_decap_8
XFILLER_14_143 VPWR VGND sg13cmos5l_decap_8
XFILLER_202_222 VPWR VGND sg13cmos5l_decap_8
XFILLER_666_14 VPWR VGND sg13cmos5l_decap_8
XFILLER_403_193 VPWR VGND sg13cmos5l_decap_8
XFILLER_564_112 VPWR VGND sg13cmos5l_decap_8
XANTENNA__3477__X Tile_X0Y1_EE4BEG[3] VPWR VGND sg13cmos5l_antennanp
XFILLER_549_197 VPWR VGND sg13cmos5l_fill_2
XFILLER_425_0 VPWR VGND sg13cmos5l_decap_8
XFILLER_348_248 VPWR VGND sg13cmos5l_decap_8
XFILLER_159_159 VPWR VGND sg13cmos5l_decap_8
XFILLER_348_259 VPWR VGND sg13cmos5l_fill_2
XFILLER_52_61 VPWR VGND sg13cmos5l_decap_8
XFILLER_564_167 VPWR VGND sg13cmos5l_decap_8
XFILLER_52_94 VPWR VGND sg13cmos5l_decap_8
XFILLER_385_59 VPWR VGND sg13cmos5l_decap_8
XFILLER_706_172 VPWR VGND sg13cmos5l_decap_8
XFILLER_505_234 VPWR VGND sg13cmos5l_fill_1
X_0670_ _0670_/Q Tile_X0Y8_FrameData[1] VGND VPWR Tile_X0Y9_FrameStrobe[7] latch
XFILLER_505_256 VPWR VGND sg13cmos5l_decap_4
XFILLER_465_81 VPWR VGND sg13cmos5l_decap_4
XFILLER_316_178 VPWR VGND sg13cmos5l_decap_4
XFILLER_182_184 VPWR VGND sg13cmos5l_decap_4
XFILLER_331_137 VPWR VGND sg13cmos5l_decap_8
XFILLER_666_219 VPWR VGND sg13cmos5l_decap_8
X_2340_ _2340_/Q Tile_X0Y5_FrameData[1] VGND VPWR Tile_X0Y9_FrameStrobe[4] latch
XFILLER_269_244 VPWR VGND sg13cmos5l_decap_8
XFILLER_674_230 VPWR VGND sg13cmos5l_decap_8
XFILLER_615_84 VPWR VGND sg13cmos5l_fill_2
XFILLER_485_130 VPWR VGND sg13cmos5l_fill_1
XFILLER_485_152 VPWR VGND sg13cmos5l_decap_8
X_2271_ _2271_/Q Tile_X0Y5_FrameData[6] VGND VPWR Tile_X0Y9_FrameStrobe[2] latch
XFILLER_551_28 VPWR VGND sg13cmos5l_decap_8
XFILLER_418_208 VPWR VGND sg13cmos5l_decap_8
XFILLER_284_203 VPWR VGND sg13cmos5l_decap_8
XFILLER_619_168 VPWR VGND sg13cmos5l_decap_4
XFILLER_418_219 VPWR VGND sg13cmos5l_decap_4
XFILLER_634_105 VPWR VGND sg13cmos5l_decap_8
XFILLER_77_80 VPWR VGND sg13cmos5l_decap_8
X_1222_ _1222_/Q Tile_X0Y1_FrameData[19] VGND VPWR Tile_X0Y9_FrameStrobe[1] latch
X_4010_ _4010_/X _3985_/X _0095_/X _3984_/X Tile_X0Y0_S4END[6] _1229_/Q _1228_/Q VPWR
+ VGND sg13cmos5l_mux4_1
XFILLER_485_196 VPWR VGND sg13cmos5l_decap_8
XFILLER_96_179 VPWR VGND sg13cmos5l_decap_8
X_1153_ _1153_/Q Tile_X0Y0_FrameData[10] VGND VPWR Tile_X0Y9_FrameStrobe[6] latch
XFILLER_203_56 VPWR VGND sg13cmos5l_decap_8
XFILLER_37_257 VPWR VGND sg13cmos5l_decap_8
X_0104_ _3190_/A _3796_/X _3797_/X _1145_/Q VPWR VGND sg13cmos5l_mux2_1
XFILLER_441_222 VPWR VGND sg13cmos5l_fill_1
XFILLER_237_196 VPWR VGND sg13cmos5l_decap_8
XFILLER_642_182 VPWR VGND sg13cmos5l_decap_8
X_1084_ _1084_/Q Tile_X0Y0_FrameData[15] VGND VPWR Tile_X0Y9_FrameStrobe[4] latch
XFILLER_350_84 VPWR VGND sg13cmos5l_decap_8
XFILLER_441_244 VPWR VGND sg13cmos5l_decap_8
XFILLER_500_21 VPWR VGND sg13cmos5l_decap_8
X_4912_ _4912_/X Tile_X0Y5_W1END[2] Tile_X0Y5_WW4END[14] Tile_X0Y5_W6END[6] _4453_/X
+ _2373_/Q _2372_/Q VPWR VGND sg13cmos5l_mux4_1
XFILLER_279_49 VPWR VGND sg13cmos5l_decap_8
X_4843_ _4843_/X _4923_/X _4927_/X _4931_/X _4900_/X _0858_/Q _0857_/Q VPWR VGND sg13cmos5l_mux4_1
XFILLER_576_14 VPWR VGND sg13cmos5l_decap_8
XFILLER_500_98 VPWR VGND sg13cmos5l_decap_8
XANTENNA__3387__X Tile_X0Y2_E6BEG[10] VPWR VGND sg13cmos5l_antennanp
XFILLER_339_248 VPWR VGND sg13cmos5l_decap_8
XFILLER_165_107 VPWR VGND sg13cmos5l_fill_1
X_4774_ _4774_/X _4781_/X Tile_X0Y8_W6END[2] _4780_/X _4774_/A3 _0419_/Q _0418_/Q
+ VPWR VGND sg13cmos5l_mux4_1
XFILLER_295_15 VPWR VGND sg13cmos5l_decap_8
XFILLER_20_157 VPWR VGND sg13cmos5l_fill_1
X_1986_ _1986_/Q Tile_X0Y4_FrameData[3] VGND VPWR Tile_X0Y9_FrameStrobe[1] latch
XFILLER_165_129 VPWR VGND sg13cmos5l_decap_4
XFILLER_555_189 VPWR VGND sg13cmos5l_fill_2
XFILLER_20_179 VPWR VGND sg13cmos5l_decap_8
X_3725_ _3725_/X Tile_X0Y3_WW4END[2] Tile_X0Y3_WW4END[10] Tile_X0Y3_W6END[10] _4232_/X
+ _1737_/Q _1736_/Q VPWR VGND sg13cmos5l_mux4_1
X_0937_ _0937_/Q Tile_X0Y9_FrameData[28] VGND VPWR Tile_X0Y9_FrameStrobe[8] latch
XFILLER_570_126 VPWR VGND sg13cmos5l_decap_8
XFILLER_509_63 VPWR VGND sg13cmos5l_decap_8
XFILLER_228_42 VPWR VGND sg13cmos5l_fill_2
XFILLER_362_240 VPWR VGND sg13cmos5l_decap_4
X_3656_ AXI_M_SOC_AWADDR17 Tile_X0Y4_WW4END[1] Tile_X0Y4_WW4END[9] Tile_X0Y4_W6END[1]
+ _4337_/X _2011_/Q _2010_/Q VPWR VGND sg13cmos5l_mux4_1
X_0868_ _0868_/Q Tile_X0Y9_FrameData[27] VGND VPWR Tile_X0Y9_FrameStrobe[6] latch
XFILLER_592_35 VPWR VGND sg13cmos5l_decap_8
XFILLER_173_184 VPWR VGND sg13cmos5l_decap_8
XFILLER_307_189 VPWR VGND sg13cmos5l_decap_8
X_2607_ _2607_/Q Tile_X0Y6_FrameData[24] VGND VPWR Tile_X0Y9_FrameStrobe[5] latch
XFILLER_712_175 VPWR VGND sg13cmos5l_decap_8
X_3587_ Tile_X0Y9_FrameData_O[17] Tile_X0Y9_FrameData[17] VPWR VGND sg13cmos5l_buf_1
X_0799_ _0799_/Q Tile_X0Y9_FrameData[0] VGND VPWR Tile_X0Y9_FrameStrobe[3] latch
X_2538_ _2538_/Q Tile_X0Y6_FrameData[29] VGND VPWR Tile_X0Y9_FrameStrobe[3] latch
XFILLER_525_84 VPWR VGND sg13cmos5l_decap_8
XFILLER_87_113 VPWR VGND sg13cmos5l_decap_8
XFILLER_461_28 VPWR VGND sg13cmos5l_decap_8
XFILLER_244_63 VPWR VGND sg13cmos5l_decap_8
X_2469_ _2469_/Q Tile_X0Y6_FrameData[2] VGND VPWR Tile_X0Y9_FrameStrobe[0] latch
XFILLER_625_105 VPWR VGND sg13cmos5l_decap_8
XFILLER_476_185 VPWR VGND sg13cmos5l_decap_8
XFILLER_391_91 VPWR VGND sg13cmos5l_decap_8
X_4208_ _4208_/X _4139_/X _4247_/X _4246_/X _4138_/X _1687_/Q _1686_/Q VPWR VGND sg13cmos5l_mux4_1
XFILLER_680_233 VPWR VGND sg13cmos5l_fill_1
XFILLER_491_133 VPWR VGND sg13cmos5l_decap_8
XFILLER_680_255 VPWR VGND sg13cmos5l_decap_8
X_4139_ _4139_/X Tile_X0Y4_W2MID[2] Tile_X0Y4_W2END[2] Tile_X0Y4_W6END[2] _4316_/X
+ _2163_/Q _2162_/Q VPWR VGND sg13cmos5l_mux4_1
XFILLER_228_174 VPWR VGND sg13cmos5l_decap_4
XFILLER_640_119 VPWR VGND sg13cmos5l_decap_8
XFILLER_541_94 VPWR VGND sg13cmos5l_decap_4
XFILLER_113_56 VPWR VGND sg13cmos5l_decap_8
XFILLER_28_268 VPWR VGND sg13cmos5l_decap_4
XFILLER_43_205 VPWR VGND sg13cmos5l_decap_8
XFILLER_410_21 VPWR VGND sg13cmos5l_decap_8
XFILLER_260_95 VPWR VGND sg13cmos5l_decap_8
XFILLER_73_49 VPWR VGND sg13cmos5l_decap_8
XFILLER_389_148 VPWR VGND sg13cmos5l_decap_8
XFILLER_251_7 VPWR VGND sg13cmos5l_decap_8
XFILLER_349_7 VPWR VGND sg13cmos5l_decap_8
XFILLER_593_229 VPWR VGND sg13cmos5l_decap_4
XFILLER_410_98 VPWR VGND sg13cmos5l_decap_8
XFILLER_397_170 VPWR VGND sg13cmos5l_decap_8
XFILLER_546_112 VPWR VGND sg13cmos5l_decap_4
XFILLER_486_14 VPWR VGND sg13cmos5l_decap_8
XANTENNA__3297__X Tile_X0Y0_E2BEGb[5] VPWR VGND sg13cmos5l_antennanp
XFILLER_11_113 VPWR VGND sg13cmos5l_decap_8
XFILLER_516_7 VPWR VGND sg13cmos5l_decap_8
XFILLER_400_196 VPWR VGND sg13cmos5l_decap_8
XFILLER_11_179 VPWR VGND sg13cmos5l_decap_8
XFILLER_7_128 VPWR VGND sg13cmos5l_fill_1
XFILLER_546_189 VPWR VGND sg13cmos5l_decap_8
XFILLER_22_42 VPWR VGND sg13cmos5l_decap_8
XFILLER_636_28 VPWR VGND sg13cmos5l_decap_8
XFILLER_561_126 VPWR VGND sg13cmos5l_decap_8
XFILLER_419_63 VPWR VGND sg13cmos5l_decap_8
XFILLER_149_192 VPWR VGND sg13cmos5l_decap_8
XFILLER_138_42 VPWR VGND sg13cmos5l_decap_8
XFILLER_164_140 VPWR VGND sg13cmos5l_decap_8
XFILLER_566_91 VPWR VGND sg13cmos5l_decap_8
XFILLER_285_70 VPWR VGND sg13cmos5l_decap_8
XFILLER_716_61 VPWR VGND sg13cmos5l_fill_1
XFILLER_98_35 VPWR VGND sg13cmos5l_decap_8
XFILLER_98_46 VPWR VGND sg13cmos5l_fill_2
XFILLER_313_159 VPWR VGND sg13cmos5l_decap_8
XFILLER_502_259 VPWR VGND sg13cmos5l_decap_8
XFILLER_652_49 VPWR VGND sg13cmos5l_decap_8
XFILLER_435_84 VPWR VGND sg13cmos5l_decap_8
XFILLER_120_210 VPWR VGND sg13cmos5l_decap_8
XFILLER_371_28 VPWR VGND sg13cmos5l_decap_8
XFILLER_154_63 VPWR VGND sg13cmos5l_decap_8
XFILLER_78_135 VPWR VGND sg13cmos5l_decap_8
XFILLER_78_146 VPWR VGND sg13cmos5l_fill_1
XFILLER_616_105 VPWR VGND sg13cmos5l_fill_1
XFILLER_78_168 VPWR VGND sg13cmos5l_decap_8
XFILLER_616_127 VPWR VGND sg13cmos5l_decap_8
XFILLER_266_247 VPWR VGND sg13cmos5l_decap_8
XFILLER_78_179 VPWR VGND sg13cmos5l_fill_1
XFILLER_482_133 VPWR VGND sg13cmos5l_decap_8
XFILLER_671_233 VPWR VGND sg13cmos5l_decap_8
XFILLER_671_255 VPWR VGND sg13cmos5l_decap_4
XFILLER_375_0 VPWR VGND sg13cmos5l_decap_8
XFILLER_93_138 VPWR VGND sg13cmos5l_decap_8
XFILLER_281_217 VPWR VGND sg13cmos5l_decap_8
XFILLER_304_77 VPWR VGND sg13cmos5l_decap_8
XFILLER_281_228 VPWR VGND sg13cmos5l_fill_2
XFILLER_423_211 VPWR VGND sg13cmos5l_decap_8
XFILLER_601_42 VPWR VGND sg13cmos5l_decap_8
XFILLER_170_84 VPWR VGND sg13cmos5l_decap_8
XFILLER_234_155 VPWR VGND sg13cmos5l_decap_4
XFILLER_542_0 VPWR VGND sg13cmos5l_decap_8
XFILLER_423_255 VPWR VGND sg13cmos5l_fill_1
XFILLER_569_248 VPWR VGND sg13cmos5l_decap_8
XFILLER_34_238 VPWR VGND sg13cmos5l_decap_8
XFILLER_569_259 VPWR VGND sg13cmos5l_fill_1
XFILLER_584_207 VPWR VGND sg13cmos5l_decap_8
XFILLER_677_35 VPWR VGND sg13cmos5l_decap_8
XFILLER_320_76 VPWR VGND sg13cmos5l_fill_2
XFILLER_677_57 VPWR VGND sg13cmos5l_decap_4
XFILLER_677_68 VPWR VGND sg13cmos5l_decap_8
XFILLER_396_14 VPWR VGND sg13cmos5l_decap_8
XFILLER_320_98 VPWR VGND sg13cmos5l_decap_8
XFILLER_97_7 VPWR VGND sg13cmos5l_decap_8
XFILLER_537_112 VPWR VGND sg13cmos5l_decap_8
XFILLER_179_93 VPWR VGND sg13cmos5l_decap_8
X_1840_ _1840_/Q Tile_X0Y3_FrameData[25] VGND VPWR Tile_X0Y9_FrameStrobe[5] latch
XFILLER_592_240 VPWR VGND sg13cmos5l_decap_8
XANTENNA__3000__X Tile_X0Y5_E2BEG[3] VPWR VGND sg13cmos5l_antennanp
XFILLER_537_189 VPWR VGND sg13cmos5l_fill_1
XFILLER_546_28 VPWR VGND sg13cmos5l_decap_8
XFILLER_8_77 VPWR VGND sg13cmos5l_decap_8
X_1771_ _1771_/Q Tile_X0Y3_FrameData[30] VGND VPWR Tile_X0Y9_FrameStrobe[3] latch
XFILLER_698_119 VPWR VGND sg13cmos5l_decap_8
XFILLER_693_56 VPWR VGND sg13cmos5l_decap_4
XFILLER_476_91 VPWR VGND sg13cmos5l_decap_8
X_3510_ Tile_X0Y1_E2BEG[0] _3932_/X VPWR VGND sg13cmos5l_buf_1
X_0722_ _0722_/Q Tile_X0Y9_FrameData[13] VGND VPWR Tile_X0Y9_FrameStrobe[1] latch
XFILLER_693_78 VPWR VGND sg13cmos5l_decap_8
XFILLER_344_251 VPWR VGND sg13cmos5l_decap_8
X_4490_ _4490_/X Tile_X0Y6_W1END[3] Tile_X0Y6_WW4END[15] Tile_X0Y6_W6END[7] _4571_/X
+ _2626_/Q _2625_/Q VPWR VGND sg13cmos5l_mux4_1
XFILLER_195_70 VPWR VGND sg13cmos5l_fill_2
XFILLER_195_81 VPWR VGND sg13cmos5l_fill_1
XFILLER_6_161 VPWR VGND sg13cmos5l_decap_8
XFILLER_195_92 VPWR VGND sg13cmos5l_decap_8
XFILLER_304_115 VPWR VGND sg13cmos5l_decap_8
X_3441_ Tile_X0Y1_UserCLKo Tile_X0Y1_UserCLK VPWR VGND sg13cmos5l_buf_1
XFILLER_170_132 VPWR VGND sg13cmos5l_decap_8
X_0653_ _0653_/Q Tile_X0Y8_FrameData[18] VGND VPWR Tile_X0Y9_FrameStrobe[7] latch
X_0584_ _0584_/Q Tile_X0Y8_FrameData[23] VGND VPWR Tile_X0Y9_FrameStrobe[5] latch
X_3372_ Tile_X0Y2_EE4BEG[11] _4067_/X VPWR VGND sg13cmos5l_buf_1
XFILLER_562_49 VPWR VGND sg13cmos5l_decap_8
X_2323_ _2323_/Q Tile_X0Y5_FrameData[18] VGND VPWR Tile_X0Y9_FrameStrobe[4] latch
XFILLER_647_252 VPWR VGND sg13cmos5l_decap_8
XFILLER_281_28 VPWR VGND sg13cmos5l_decap_8
XANTENNA__3670__X AXI_M_SOC_AWADDR31 VPWR VGND sg13cmos5l_antennanp
XFILLER_458_174 VPWR VGND sg13cmos5l_decap_8
XFILLER_69_168 VPWR VGND sg13cmos5l_decap_8
XFILLER_607_127 VPWR VGND sg13cmos5l_fill_1
XFILLER_473_122 VPWR VGND sg13cmos5l_decap_8
XFILLER_84_105 VPWR VGND sg13cmos5l_fill_2
XFILLER_662_222 VPWR VGND sg13cmos5l_decap_8
X_2254_ _2254_/Q Tile_X0Y5_FrameData[23] VGND VPWR Tile_X0Y9_FrameStrobe[2] latch
XFILLER_257_258 VPWR VGND sg13cmos5l_decap_8
XFILLER_607_149 VPWR VGND sg13cmos5l_decap_8
XFILLER_19_0 VPWR VGND sg13cmos5l_decap_8
XFILLER_214_77 VPWR VGND sg13cmos5l_decap_8
X_1205_ _1205_/Q Tile_X0Y1_FrameData[4] VGND VPWR Tile_X0Y9_FrameStrobe[0] latch
XFILLER_225_100 VPWR VGND sg13cmos5l_fill_2
X_2185_ _2185_/Q Tile_X0Y5_FrameData[28] VGND VPWR Tile_X0Y9_FrameStrobe[0] latch
XFILLER_272_228 VPWR VGND sg13cmos5l_decap_8
XFILLER_272_239 VPWR VGND sg13cmos5l_fill_1
XFILLER_511_42 VPWR VGND sg13cmos5l_decap_8
XFILLER_414_222 VPWR VGND sg13cmos5l_decap_8
X_1136_ _1136_/Q Tile_X0Y0_FrameData[27] VGND VPWR Tile_X0Y9_FrameStrobe[6] latch
XFILLER_230_21 VPWR VGND sg13cmos5l_decap_8
XFILLER_92_193 VPWR VGND sg13cmos5l_decap_8
XFILLER_280_272 VPWR VGND sg13cmos5l_fill_1
X_1067_ _1067_/Q Tile_X0Y0_FrameData[0] VGND VPWR Tile_X0Y9_FrameStrobe[3] latch
XFILLER_630_163 VPWR VGND sg13cmos5l_fill_2
XFILLER_587_35 VPWR VGND sg13cmos5l_decap_8
XFILLER_40_219 VPWR VGND sg13cmos5l_decap_8
XFILLER_33_271 VPWR VGND sg13cmos5l_fill_2
XFILLER_528_134 VPWR VGND sg13cmos5l_decap_8
X_4826_ _4826_/X Tile_X0Y9_W1END[2] Tile_X0Y9_W6END[10] _4930_/X _4894_/X _0887_/Q
+ _0886_/Q VPWR VGND sg13cmos5l_mux4_1
XFILLER_327_218 VPWR VGND sg13cmos5l_decap_8
XFILLER_239_52 VPWR VGND sg13cmos5l_decap_8
XFILLER_456_28 VPWR VGND sg13cmos5l_decap_8
X_4757_ _4757_/X Tile_X0Y8_WW4END[2] AXI_M_SOC_RDATA10 _4802_/X _4789_/X _0533_/Q
+ _0532_/Q VPWR VGND sg13cmos5l_mux4_1
X_1969_ _1969_/Q Tile_X0Y4_FrameData[20] VGND VPWR Tile_X0Y9_FrameStrobe[1] latch
XFILLER_543_137 VPWR VGND sg13cmos5l_fill_2
X_3708_ AXI_M_SOC_WDATA18 Tile_X0Y6_WW4END[2] Tile_X0Y6_WW4END[10] Tile_X0Y6_W6END[2]
+ _4570_/X _2523_/Q _2522_/Q VPWR VGND sg13cmos5l_mux4_1
X_4688_ _4688_/X _4661_/X Tile_X0Y9_N4END[8] _4660_/X _0056_/X _0207_/Q _0206_/Q VPWR
+ VGND sg13cmos5l_mux4_1
XFILLER_161_110 VPWR VGND sg13cmos5l_decap_8
XFILLER_536_72 VPWR VGND sg13cmos5l_fill_1
XFILLER_496_203 VPWR VGND sg13cmos5l_decap_8
X_3639_ AXI_M_SOC_AWADDR0 Tile_X0Y5_WW4END[0] Tile_X0Y5_WW4END[8] Tile_X0Y5_W6END[0]
+ _4451_/X _2271_/Q _2270_/Q VPWR VGND sg13cmos5l_mux4_1
XFILLER_108_56 VPWR VGND sg13cmos5l_decap_8
XFILLER_700_134 VPWR VGND sg13cmos5l_decap_8
XFILLER_496_236 VPWR VGND sg13cmos5l_decap_8
XFILLER_472_49 VPWR VGND sg13cmos5l_decap_8
XFILLER_405_21 VPWR VGND sg13cmos5l_decap_8
XFILLER_68_49 VPWR VGND sg13cmos5l_decap_8
XFILLER_191_28 VPWR VGND sg13cmos5l_decap_8
XFILLER_638_252 VPWR VGND sg13cmos5l_fill_2
XFILLER_248_203 VPWR VGND sg13cmos5l_decap_8
XANTENNA__3580__X Tile_X0Y9_FrameData_O[10] VPWR VGND sg13cmos5l_antennanp
XFILLER_299_7 VPWR VGND sg13cmos5l_decap_8
XFILLER_102_254 VPWR VGND sg13cmos5l_decap_8
XFILLER_464_133 VPWR VGND sg13cmos5l_decap_8
XFILLER_248_269 VPWR VGND sg13cmos5l_decap_4
XFILLER_75_127 VPWR VGND sg13cmos5l_decap_8
XFILLER_124_77 VPWR VGND sg13cmos5l_decap_8
XFILLER_702_63 VPWR VGND sg13cmos5l_decap_8
XFILLER_271_83 VPWR VGND sg13cmos5l_fill_2
XFILLER_466_7 VPWR VGND sg13cmos5l_decap_8
XFILLER_464_199 VPWR VGND sg13cmos5l_decap_8
XFILLER_421_42 VPWR VGND sg13cmos5l_decap_8
XFILLER_405_222 VPWR VGND sg13cmos5l_decap_8
XFILLER_83_160 VPWR VGND sg13cmos5l_fill_2
XFILLER_17_42 VPWR VGND sg13cmos5l_decap_8
XFILLER_140_21 VPWR VGND sg13cmos5l_decap_8
XFILLER_83_171 VPWR VGND sg13cmos5l_fill_1
XFILLER_83_182 VPWR VGND sg13cmos5l_decap_8
XANTENNA__2924__X Tile_X0Y8_E2BEGb[0] VPWR VGND sg13cmos5l_antennanp
XFILLER_216_188 VPWR VGND sg13cmos5l_fill_1
XFILLER_633_7 VPWR VGND sg13cmos5l_decap_8
XFILLER_271_272 VPWR VGND sg13cmos5l_fill_1
XFILLER_497_35 VPWR VGND sg13cmos5l_decap_8
XFILLER_169_210 VPWR VGND sg13cmos5l_decap_8
XFILLER_140_98 VPWR VGND sg13cmos5l_decap_8
XFILLER_519_123 VPWR VGND sg13cmos5l_decap_8
XFILLER_385_151 VPWR VGND sg13cmos5l_decap_8
XFILLER_647_49 VPWR VGND sg13cmos5l_decap_8
XFILLER_33_96 VPWR VGND sg13cmos5l_decap_8
XANTENNA__3755__X AXI_M_SOC_ARADDR27 VPWR VGND sg13cmos5l_antennanp
XFILLER_123_0 VPWR VGND sg13cmos5l_decap_8
XFILLER_137_140 VPWR VGND sg13cmos5l_decap_8
XFILLER_446_50 VPWR VGND sg13cmos5l_decap_8
XFILLER_298_103 VPWR VGND sg13cmos5l_decap_8
XFILLER_152_132 VPWR VGND sg13cmos5l_decap_8
XFILLER_446_94 VPWR VGND sg13cmos5l_fill_2
XFILLER_98_219 VPWR VGND sg13cmos5l_decap_4
XFILLER_487_247 VPWR VGND sg13cmos5l_decap_8
XFILLER_3_153 VPWR VGND sg13cmos5l_fill_1
XFILLER_165_84 VPWR VGND sg13cmos5l_decap_8
XFILLER_382_49 VPWR VGND sg13cmos5l_decap_8
XFILLER_492_0 VPWR VGND sg13cmos5l_decap_8
XFILLER_315_21 VPWR VGND sg13cmos5l_decap_8
XANTENNA__3490__X Tile_X0Y1_E6BEG[0] VPWR VGND sg13cmos5l_antennanp
XFILLER_58_60 VPWR VGND sg13cmos5l_decap_8
XFILLER_66_105 VPWR VGND sg13cmos5l_decap_8
XFILLER_462_93 VPWR VGND sg13cmos5l_decap_8
XFILLER_12_7 VPWR VGND sg13cmos5l_decap_8
XFILLER_612_63 VPWR VGND sg13cmos5l_decap_8
XFILLER_455_177 VPWR VGND sg13cmos5l_decap_8
XFILLER_254_228 VPWR VGND sg13cmos5l_decap_8
XFILLER_612_85 VPWR VGND sg13cmos5l_decap_8
XFILLER_470_125 VPWR VGND sg13cmos5l_fill_1
XFILLER_207_133 VPWR VGND sg13cmos5l_decap_8
XFILLER_207_166 VPWR VGND sg13cmos5l_decap_8
XFILLER_612_141 VPWR VGND sg13cmos5l_decap_4
XANTENNA__2834__X Tile_X0Y6_E1BEG[3] VPWR VGND sg13cmos5l_antennanp
XFILLER_222_114 VPWR VGND sg13cmos5l_decap_4
XFILLER_411_214 VPWR VGND sg13cmos5l_decap_8
XFILLER_74_92 VPWR VGND sg13cmos5l_decap_8
X_3990_ _3990_/X _3900_/X _4033_/X _4032_/X Tile_X0Y0_S2MID[6] _1189_/Q _1188_/Q VPWR
+ VGND sg13cmos5l_mux4_1
XFILLER_612_174 VPWR VGND sg13cmos5l_decap_8
XFILLER_222_147 VPWR VGND sg13cmos5l_fill_1
X_2941_ Tile_X0Y8_E6BEG[9] _4769_/X VPWR VGND sg13cmos5l_buf_1
XFILLER_15_271 VPWR VGND sg13cmos5l_fill_2
XFILLER_200_35 VPWR VGND sg13cmos5l_decap_8
XFILLER_222_169 VPWR VGND sg13cmos5l_decap_8
X_2872_ Tile_X0Y6_EE4BEG[9] _4521_/X VPWR VGND sg13cmos5l_buf_1
XFILLER_557_49 VPWR VGND sg13cmos5l_decap_8
X_4611_ _4611_/X _4667_/X _4666_/X AXI_M_SOC_RDATA16 AXI_M_SOC_RDATA20 _0337_/Q _0336_/Q
+ VPWR VGND sg13cmos5l_mux4_1
X_1823_ _1823_/Q Tile_X0Y3_FrameData[10] VGND VPWR Tile_X0Y9_FrameStrobe[4] latch
XFILLER_276_28 VPWR VGND sg13cmos5l_decap_8
XANTENNA__3665__X AXI_M_SOC_AWADDR26 VPWR VGND sg13cmos5l_antennanp
XFILLER_175_257 VPWR VGND sg13cmos5l_decap_8
XFILLER_580_254 VPWR VGND sg13cmos5l_decap_8
XFILLER_391_154 VPWR VGND sg13cmos5l_decap_8
X_4542_ _4542_/X _4549_/X Tile_X0Y6_W6END[2] _4548_/X _4542_/A3 _2443_/Q _2442_/Q
+ VPWR VGND sg13cmos5l_mux4_1
XFILLER_190_216 VPWR VGND sg13cmos5l_decap_8
X_1754_ _1754_/Q Tile_X0Y3_FrameData[15] VGND VPWR Tile_X0Y9_FrameStrobe[2] latch
XFILLER_391_176 VPWR VGND sg13cmos5l_decap_8
XFILLER_190_227 VPWR VGND sg13cmos5l_fill_1
XFILLER_317_262 VPWR VGND sg13cmos5l_decap_8
XFILLER_540_118 VPWR VGND sg13cmos5l_decap_8
XFILLER_391_187 VPWR VGND sg13cmos5l_fill_2
XFILLER_190_249 VPWR VGND sg13cmos5l_decap_8
XFILLER_209_77 VPWR VGND sg13cmos5l_decap_8
X_0705_ _0705_/Q Tile_X0Y9_FrameData[30] VGND VPWR Tile_X0Y9_FrameStrobe[1] latch
X_4473_ _4473_/X Tile_X0Y7_W2MID[5] Tile_X0Y7_W2END[5] Tile_X0Y7_W6END[5] _4673_/X
+ _0403_/Q _0402_/Q VPWR VGND sg13cmos5l_mux4_1
X_1685_ _1685_/Q Tile_X0Y3_FrameData[20] VGND VPWR Tile_X0Y9_FrameStrobe[0] latch
XFILLER_506_42 VPWR VGND sg13cmos5l_decap_8
X_3424_ Tile_X0Y4_FrameData_O[15] Tile_X0Y4_FrameData[15] VPWR VGND sg13cmos5l_buf_1
X_0636_ _0636_/Q Tile_X0Y8_FrameData[3] VGND VPWR Tile_X0Y9_FrameStrobe[6] latch
XFILLER_292_49 VPWR VGND sg13cmos5l_decap_8
XFILLER_653_70 VPWR VGND sg13cmos5l_decap_8
XFILLER_225_21 VPWR VGND sg13cmos5l_decap_8
XFILLER_694_155 VPWR VGND sg13cmos5l_fill_1
X_3355_ Tile_X0Y2_FrameData_O[26] Tile_X0Y2_FrameData[26] VPWR VGND sg13cmos5l_buf_1
X_0567_ _0567_/Q Tile_X0Y8_FrameData[8] VGND VPWR Tile_X0Y9_FrameStrobe[4] latch
XFILLER_446_111 VPWR VGND sg13cmos5l_decap_8
X_2306_ _2306_/Q Tile_X0Y5_FrameData[3] VGND VPWR Tile_X0Y9_FrameStrobe[3] latch
XFILLER_635_222 VPWR VGND sg13cmos5l_fill_2
X_3286_ Tile_X0Y0_E6BEG[6] _3842_/X VPWR VGND sg13cmos5l_buf_1
X_0498_ _0498_/Q Tile_X0Y8_FrameData[13] VGND VPWR Tile_X0Y9_FrameStrobe[2] latch
XFILLER_300_184 VPWR VGND sg13cmos5l_decap_8
XFILLER_57_149 VPWR VGND sg13cmos5l_decap_4
X_2237_ _2237_/Q Tile_X0Y5_FrameData[8] VGND VPWR Tile_X0Y9_FrameStrobe[1] latch
XFILLER_650_203 VPWR VGND sg13cmos5l_decap_8
XFILLER_241_42 VPWR VGND sg13cmos5l_fill_2
XFILLER_650_236 VPWR VGND sg13cmos5l_decap_8
X_2168_ _2168_/Q Tile_X0Y4_FrameData[13] VGND VPWR Tile_X0Y9_FrameStrobe[7] latch
XFILLER_54_18 VPWR VGND sg13cmos5l_fill_1
XFILLER_65_182 VPWR VGND sg13cmos5l_decap_8
XFILLER_598_56 VPWR VGND sg13cmos5l_decap_8
XFILLER_603_152 VPWR VGND sg13cmos5l_decap_8
XANTENNA__2744__X Tile_X0Y3_FrameData_O[2] VPWR VGND sg13cmos5l_antennanp
X_1119_ _1119_/Q Tile_X0Y0_FrameData[12] VGND VPWR Tile_X0Y9_FrameStrobe[5] latch
XFILLER_80_141 VPWR VGND sg13cmos5l_decap_4
XFILLER_598_78 VPWR VGND sg13cmos5l_decap_8
X_2099_ _2099_/Q Tile_X0Y4_FrameData[18] VGND VPWR Tile_X0Y9_FrameStrobe[5] latch
XFILLER_402_247 VPWR VGND sg13cmos5l_decap_8
XFILLER_213_158 VPWR VGND sg13cmos5l_decap_8
XFILLER_110_35 VPWR VGND sg13cmos5l_fill_2
XFILLER_80_196 VPWR VGND sg13cmos5l_decap_8
XFILLER_166_213 VPWR VGND sg13cmos5l_decap_8
XFILLER_21_252 VPWR VGND sg13cmos5l_decap_8
XFILLER_367_184 VPWR VGND sg13cmos5l_decap_8
X_4809_ _4809_/X _4779_/X Tile_X0Y9_N4END[5] _4778_/X _0076_/X _0453_/Q _0452_/Q VPWR
+ VGND sg13cmos5l_mux4_1
XFILLER_571_210 VPWR VGND sg13cmos5l_decap_8
XFILLER_571_221 VPWR VGND sg13cmos5l_fill_1
XFILLER_516_126 VPWR VGND sg13cmos5l_decap_8
XANTENNA__3575__X Tile_X0Y9_FrameData_O[5] VPWR VGND sg13cmos5l_antennanp
XFILLER_382_143 VPWR VGND sg13cmos5l_fill_2
XFILLER_571_254 VPWR VGND sg13cmos5l_decap_4
XFILLER_214_7 VPWR VGND sg13cmos5l_decap_8
XFILLER_181_227 VPWR VGND sg13cmos5l_decap_8
XFILLER_483_15 VPWR VGND sg13cmos5l_decap_8
XFILLER_119_77 VPWR VGND sg13cmos5l_fill_1
XFILLER_323_221 VPWR VGND sg13cmos5l_decap_8
XFILLER_266_94 VPWR VGND sg13cmos5l_decap_8
XFILLER_119_99 VPWR VGND sg13cmos5l_fill_2
XFILLER_416_42 VPWR VGND sg13cmos5l_decap_8
XFILLER_469_258 VPWR VGND sg13cmos5l_decap_8
XFILLER_135_21 VPWR VGND sg13cmos5l_decap_8
XFILLER_563_70 VPWR VGND sg13cmos5l_decap_8
XFILLER_134_198 VPWR VGND sg13cmos5l_decap_8
XANTENNA__2919__X Tile_X0Y8_E2BEG[3] VPWR VGND sg13cmos5l_antennanp
XFILLER_685_177 VPWR VGND sg13cmos5l_decap_4
XFILLER_583_7 VPWR VGND sg13cmos5l_decap_8
XFILLER_0_145 VPWR VGND sg13cmos5l_fill_1
XFILLER_713_40 VPWR VGND sg13cmos5l_decap_8
XFILLER_95_14 VPWR VGND sg13cmos5l_decap_8
XFILLER_297_4 VPWR VGND sg13cmos5l_fill_1
XFILLER_437_133 VPWR VGND sg13cmos5l_decap_8
XFILLER_135_98 VPWR VGND sg13cmos5l_decap_8
XFILLER_0_189 VPWR VGND sg13cmos5l_fill_2
XFILLER_492_250 VPWR VGND sg13cmos5l_decap_8
XFILLER_641_203 VPWR VGND sg13cmos5l_decap_8
XFILLER_437_177 VPWR VGND sg13cmos5l_decap_8
XFILLER_432_63 VPWR VGND sg13cmos5l_decap_8
XFILLER_151_42 VPWR VGND sg13cmos5l_decap_8
XFILLER_244_261 VPWR VGND sg13cmos5l_fill_2
XFILLER_539_218 VPWR VGND sg13cmos5l_fill_2
XFILLER_240_0 VPWR VGND sg13cmos5l_decap_8
XFILLER_71_196 VPWR VGND sg13cmos5l_decap_8
XFILLER_338_0 VPWR VGND sg13cmos5l_decap_8
XFILLER_358_140 VPWR VGND sg13cmos5l_decap_8
XFILLER_12_241 VPWR VGND sg13cmos5l_decap_8
XFILLER_157_213 VPWR VGND sg13cmos5l_decap_8
XFILLER_674_14 VPWR VGND sg13cmos5l_decap_8
XANTENNA__3485__X Tile_X0Y1_EE4BEG[11] VPWR VGND sg13cmos5l_antennanp
XFILLER_505_0 VPWR VGND sg13cmos5l_decap_8
XFILLER_562_243 VPWR VGND sg13cmos5l_fill_1
XFILLER_60_83 VPWR VGND sg13cmos5l_decap_8
XFILLER_393_15 VPWR VGND sg13cmos5l_decap_8
XFILLER_373_176 VPWR VGND sg13cmos5l_decap_8
XFILLER_607_63 VPWR VGND sg13cmos5l_decap_4
XFILLER_393_59 VPWR VGND sg13cmos5l_fill_2
XFILLER_607_96 VPWR VGND sg13cmos5l_decap_8
XFILLER_5_56 VPWR VGND sg13cmos5l_decap_8
XFILLER_125_176 VPWR VGND sg13cmos5l_decap_8
X_1470_ _1470_/Q Tile_X0Y2_FrameData[19] VGND VPWR Tile_X0Y9_FrameStrobe[1] latch
XFILLER_530_151 VPWR VGND sg13cmos5l_decap_8
XFILLER_690_35 VPWR VGND sg13cmos5l_decap_8
XFILLER_69_70 VPWR VGND sg13cmos5l_decap_8
X_0421_ _0421_/Q Tile_X0Y8_FrameData[26] VGND VPWR Tile_X0Y9_FrameStrobe[0] latch
XFILLER_676_177 VPWR VGND sg13cmos5l_decap_8
XANTENNA__2829__X Tile_X0Y4_E2BEG[7] VPWR VGND sg13cmos5l_antennanp
XFILLER_140_168 VPWR VGND sg13cmos5l_decap_8
XFILLER_279_191 VPWR VGND sg13cmos5l_decap_8
XFILLER_94_200 VPWR VGND sg13cmos5l_decap_4
X_3140_ Tile_X0Y7_FrameData_O[10] Tile_X0Y7_FrameData[10] VPWR VGND sg13cmos5l_buf_1
XFILLER_428_133 VPWR VGND sg13cmos5l_decap_8
X_0352_ _0352_/Q Tile_X0Y7_FrameData[31] VGND VPWR Tile_X0Y9_FrameStrobe[6] latch
XFILLER_623_84 VPWR VGND sg13cmos5l_decap_8
XFILLER_699_22 VPWR VGND sg13cmos5l_decap_8
XFILLER_617_266 VPWR VGND sg13cmos5l_decap_8
XFILLER_483_272 VPWR VGND sg13cmos5l_fill_1
XFILLER_39_149 VPWR VGND sg13cmos5l_decap_4
X_0283_ _0283_/Q Tile_X0Y7_FrameData[4] VGND VPWR Tile_X0Y9_FrameStrobe[3] latch
X_3071_ Tile_X0Y5_FrameData_O[30] Tile_X0Y5_FrameData[30] VPWR VGND sg13cmos5l_buf_1
XFILLER_589_118 VPWR VGND sg13cmos5l_decap_8
X_2022_ _2022_/Q Tile_X0Y4_FrameData[31] VGND VPWR Tile_X0Y9_FrameStrobe[3] latch
XFILLER_589_129 VPWR VGND sg13cmos5l_fill_2
XFILLER_235_272 VPWR VGND sg13cmos5l_fill_1
XFILLER_62_152 VPWR VGND sg13cmos5l_decap_8
XFILLER_211_56 VPWR VGND sg13cmos5l_decap_8
XFILLER_250_242 VPWR VGND sg13cmos5l_decap_8
X_3973_ _3973_/X AXI_M_SOC_ARREADY _4010_/X _4014_/X _3992_/X _1263_/Q _1262_/Q VPWR
+ VGND sg13cmos5l_mux4_1
XFILLER_600_144 VPWR VGND sg13cmos5l_fill_1
XFILLER_62_196 VPWR VGND sg13cmos5l_decap_8
XFILLER_600_166 VPWR VGND sg13cmos5l_decap_4
XFILLER_349_140 VPWR VGND sg13cmos5l_decap_8
X_2924_ Tile_X0Y8_E2BEGb[0] _4736_/X VPWR VGND sg13cmos5l_buf_1
XFILLER_600_177 VPWR VGND sg13cmos5l_fill_2
XFILLER_287_49 VPWR VGND sg13cmos5l_decap_8
XFILLER_203_180 VPWR VGND sg13cmos5l_decap_4
XFILLER_86_0 VPWR VGND sg13cmos5l_decap_8
XFILLER_648_70 VPWR VGND sg13cmos5l_decap_8
X_2855_ Tile_X0Y6_E6BEG[4] _4532_/X VPWR VGND sg13cmos5l_buf_1
XFILLER_584_14 VPWR VGND sg13cmos5l_decap_8
XFILLER_364_132 VPWR VGND sg13cmos5l_decap_8
XANTENNA__3395__X Tile_X0Y2_E2BEGb[6] VPWR VGND sg13cmos5l_antennanp
XFILLER_553_232 VPWR VGND sg13cmos5l_decap_8
XFILLER_367_71 VPWR VGND sg13cmos5l_decap_8
X_1806_ _1806_/Q Tile_X0Y3_FrameData[27] VGND VPWR Tile_X0Y9_FrameStrobe[4] latch
XFILLER_699_247 VPWR VGND sg13cmos5l_decap_4
X_2786_ Tile_X0Y3_EE4BEG[12] _4176_/X VPWR VGND sg13cmos5l_buf_1
XFILLER_163_249 VPWR VGND sg13cmos5l_decap_8
X_4525_ _4525_/X Tile_X0Y6_WW4END[2] AXI_M_SOC_RDATA26 _4570_/X _4557_/X _2557_/Q
+ _2556_/Q VPWR VGND sg13cmos5l_mux4_1
XFILLER_305_221 VPWR VGND sg13cmos5l_decap_4
X_1737_ _1737_/Q Tile_X0Y3_FrameData[0] VGND VPWR Tile_X0Y9_FrameStrobe[1] latch
XFILLER_517_63 VPWR VGND sg13cmos5l_decap_8
XFILLER_517_74 VPWR VGND sg13cmos5l_fill_1
XFILLER_517_96 VPWR VGND sg13cmos5l_decap_8
X_4456_ _4456_/X _4421_/X _0159_/X _4420_/X _0145_/X _2227_/Q _2226_/Q VPWR VGND sg13cmos5l_mux4_1
X_1668_ _1668_/Q Tile_X0Y2_FrameData[13] VGND VPWR Tile_X0Y9_FrameStrobe[7] latch
XFILLER_383_70 VPWR VGND sg13cmos5l_decap_8
XFILLER_49_29 VPWR VGND sg13cmos5l_decap_4
XFILLER_236_86 VPWR VGND sg13cmos5l_fill_1
X_3407_ Tile_X0Y2_E1BEG[2] _4038_/X VPWR VGND sg13cmos5l_buf_1
XFILLER_236_97 VPWR VGND sg13cmos5l_decap_8
XANTENNA__2739__X Tile_X0Y4_E1BEG[2] VPWR VGND sg13cmos5l_antennanp
X_0619_ _0619_/Q Tile_X0Y8_FrameData[20] VGND VPWR Tile_X0Y9_FrameStrobe[6] latch
XFILLER_667_177 VPWR VGND sg13cmos5l_decap_8
X_4387_ _4387_/X Tile_X0Y5_W2END[0] AXI_M_SOC_RVALID _4467_/X _4428_/X _2329_/Q _2328_/Q
+ VPWR VGND sg13cmos5l_mux4_1
XFILLER_419_100 VPWR VGND sg13cmos5l_fill_1
X_1599_ _1599_/Q Tile_X0Y2_FrameData[18] VGND VPWR Tile_X0Y9_FrameStrobe[5] latch
XFILLER_320_257 VPWR VGND sg13cmos5l_decap_8
XFILLER_419_122 VPWR VGND sg13cmos5l_decap_8
X_3338_ Tile_X0Y2_FrameData_O[9] Tile_X0Y2_FrameData[9] VPWR VGND sg13cmos5l_buf_1
XFILLER_419_144 VPWR VGND sg13cmos5l_decap_8
XFILLER_105_35 VPWR VGND sg13cmos5l_decap_8
XFILLER_680_90 VPWR VGND sg13cmos5l_decap_8
XFILLER_533_95 VPWR VGND sg13cmos5l_decap_8
XFILLER_285_161 VPWR VGND sg13cmos5l_decap_8
XFILLER_252_63 VPWR VGND sg13cmos5l_decap_8
X_3269_ Tile_X0Y0_EE4BEG[5] _3825_/X VPWR VGND sg13cmos5l_buf_1
XFILLER_65_28 VPWR VGND sg13cmos5l_decap_8
XFILLER_434_136 VPWR VGND sg13cmos5l_decap_8
XFILLER_38_171 VPWR VGND sg13cmos5l_fill_2
XANTENNA_107 _0157_/X VPWR VGND sg13cmos5l_antennanp
XANTENNA_118 Tile_X0Y6_FrameData[30] VPWR VGND sg13cmos5l_antennanp
XFILLER_226_272 VPWR VGND sg13cmos5l_fill_1
XFILLER_402_77 VPWR VGND sg13cmos5l_decap_8
XANTENNA_129 Tile_X0Y6_FrameData[31] VPWR VGND sg13cmos5l_antennanp
XFILLER_53_130 VPWR VGND sg13cmos5l_decap_8
XFILLER_588_162 VPWR VGND sg13cmos5l_decap_4
XFILLER_121_56 VPWR VGND sg13cmos5l_decap_8
XFILLER_53_196 VPWR VGND sg13cmos5l_decap_8
XFILLER_241_264 VPWR VGND sg13cmos5l_fill_1
XFILLER_198_179 VPWR VGND sg13cmos5l_decap_8
XFILLER_201_117 VPWR VGND sg13cmos5l_decap_8
XFILLER_387_268 VPWR VGND sg13cmos5l_decap_4
XFILLER_14_21 VPWR VGND sg13cmos5l_decap_8
XFILLER_331_7 VPWR VGND sg13cmos5l_decap_8
XFILLER_628_29 VPWR VGND sg13cmos5l_decap_8
XFILLER_429_7 VPWR VGND sg13cmos5l_decap_8
XFILLER_139_224 VPWR VGND sg13cmos5l_decap_8
XFILLER_558_70 VPWR VGND sg13cmos5l_decap_8
XFILLER_544_221 VPWR VGND sg13cmos5l_decap_8
XFILLER_494_14 VPWR VGND sg13cmos5l_decap_8
XFILLER_139_268 VPWR VGND sg13cmos5l_decap_4
XFILLER_355_154 VPWR VGND sg13cmos5l_decap_8
XFILLER_708_84 VPWR VGND sg13cmos5l_decap_8
XFILLER_370_124 VPWR VGND sg13cmos5l_decap_8
XFILLER_370_135 VPWR VGND sg13cmos5l_fill_1
XFILLER_644_28 VPWR VGND sg13cmos5l_decap_8
XFILLER_427_63 VPWR VGND sg13cmos5l_decap_8
XFILLER_370_157 VPWR VGND sg13cmos5l_decap_8
XFILLER_574_91 VPWR VGND sg13cmos5l_decap_8
XFILLER_146_42 VPWR VGND sg13cmos5l_decap_8
XFILLER_363_29 VPWR VGND sg13cmos5l_decap_8
XFILLER_512_162 VPWR VGND sg13cmos5l_decap_8
XFILLER_311_213 VPWR VGND sg13cmos5l_decap_8
XFILLER_293_70 VPWR VGND sg13cmos5l_decap_8
XFILLER_457_206 VPWR VGND sg13cmos5l_fill_2
XFILLER_658_166 VPWR VGND sg13cmos5l_fill_1
XFILLER_122_146 VPWR VGND sg13cmos5l_decap_8
XFILLER_122_157 VPWR VGND sg13cmos5l_fill_1
XFILLER_660_49 VPWR VGND sg13cmos5l_decap_8
XFILLER_190_0 VPWR VGND sg13cmos5l_decap_8
XFILLER_465_272 VPWR VGND sg13cmos5l_fill_1
XFILLER_288_0 VPWR VGND sg13cmos5l_decap_4
XFILLER_209_239 VPWR VGND sg13cmos5l_fill_1
XFILLER_291_120 VPWR VGND sg13cmos5l_decap_8
XFILLER_91_214 VPWR VGND sg13cmos5l_decap_8
XFILLER_425_147 VPWR VGND sg13cmos5l_decap_8
XFILLER_669_14 VPWR VGND sg13cmos5l_decap_8
XFILLER_455_0 VPWR VGND sg13cmos5l_decap_8
XFILLER_55_61 VPWR VGND sg13cmos5l_decap_4
XFILLER_291_197 VPWR VGND sg13cmos5l_fill_2
XFILLER_55_83 VPWR VGND sg13cmos5l_decap_8
XFILLER_44_152 VPWR VGND sg13cmos5l_decap_4
XFILLER_232_231 VPWR VGND sg13cmos5l_decap_8
XFILLER_388_37 VPWR VGND sg13cmos5l_decap_8
XFILLER_594_121 VPWR VGND sg13cmos5l_decap_4
XFILLER_622_0 VPWR VGND sg13cmos5l_decap_8
XFILLER_378_268 VPWR VGND sg13cmos5l_decap_4
X_0970_ _0970_/Q Tile_X0Y0_FrameData[1] VGND VPWR Tile_X0Y9_FrameStrobe[0] latch
XFILLER_346_110 VPWR VGND sg13cmos5l_decap_8
XFILLER_535_232 VPWR VGND sg13cmos5l_decap_4
XFILLER_187_93 VPWR VGND sg13cmos5l_fill_2
X_2640_ _2640_/Q Tile_X0Y6_FrameData[23] VGND VPWR Tile_X0Y9_FrameStrobe[6] latch
XFILLER_618_84 VPWR VGND sg13cmos5l_decap_8
XFILLER_346_198 VPWR VGND sg13cmos5l_fill_1
XFILLER_554_28 VPWR VGND sg13cmos5l_decap_8
XFILLER_361_135 VPWR VGND sg13cmos5l_decap_8
X_2571_ _2571_/Q Tile_X0Y6_FrameData[28] VGND VPWR Tile_X0Y9_FrameStrobe[4] latch
XFILLER_484_91 VPWR VGND sg13cmos5l_fill_1
X_4310_ _4310_/X Tile_X0Y3_W1END[3] Tile_X0Y3_W6END[11] _4212_/X _4193_/X _1883_/Q
+ _1882_/Q VPWR VGND sg13cmos5l_mux4_1
XFILLER_299_242 VPWR VGND sg13cmos5l_decap_8
X_1522_ _1522_/Q Tile_X0Y2_FrameData[31] VGND VPWR Tile_X0Y9_FrameStrobe[3] latch
XFILLER_503_140 VPWR VGND sg13cmos5l_decap_8
XFILLER_113_113 VPWR VGND sg13cmos5l_decap_8
X_4241_ _4241_/X Tile_X0Y5_W2MID[5] Tile_X0Y5_W2END[5] Tile_X0Y5_W6END[5] _4432_/X
+ _2427_/Q _2426_/Q VPWR VGND sg13cmos5l_mux4_1
X_1453_ _1453_/Q Tile_X0Y2_FrameData[4] VGND VPWR Tile_X0Y9_FrameStrobe[0] latch
XFILLER_503_195 VPWR VGND sg13cmos5l_decap_8
XFILLER_649_199 VPWR VGND sg13cmos5l_decap_8
XFILLER_206_56 VPWR VGND sg13cmos5l_decap_8
XFILLER_302_268 VPWR VGND sg13cmos5l_decap_4
X_0404_ _0404_/Q Tile_X0Y7_FrameData[11] VGND VPWR Tile_X0Y9_FrameStrobe[7] latch
XFILLER_664_147 VPWR VGND sg13cmos5l_decap_4
X_4172_ _4172_/X Tile_X0Y3_WW4END[7] AXI_M_SOC_BVALID _4229_/X _4204_/X _1797_/Q _1796_/Q
+ VPWR VGND sg13cmos5l_mux4_1
XFILLER_570_49 VPWR VGND sg13cmos5l_decap_8
X_1384_ _1384_/Q Tile_X0Y1_FrameData[17] VGND VPWR Tile_X0Y9_FrameStrobe[6] latch
XFILLER_353_84 VPWR VGND sg13cmos5l_decap_8
XFILLER_503_21 VPWR VGND sg13cmos5l_decap_8
XFILLER_96_90 VPWR VGND sg13cmos5l_decap_8
X_3123_ Tile_X0Y7_EE4BEG[9] _4637_/X VPWR VGND sg13cmos5l_buf_1
XFILLER_456_272 VPWR VGND sg13cmos5l_fill_1
X_0335_ _0335_/Q Tile_X0Y7_FrameData[16] VGND VPWR Tile_X0Y9_FrameStrobe[5] latch
XFILLER_67_255 VPWR VGND sg13cmos5l_fill_1
XFILLER_672_180 VPWR VGND sg13cmos5l_fill_1
XFILLER_82_214 VPWR VGND sg13cmos5l_decap_8
X_3054_ Tile_X0Y5_FrameData_O[13] Tile_X0Y5_FrameData[13] VPWR VGND sg13cmos5l_buf_1
X_0266_ _0266_/Q Tile_X0Y7_FrameData[21] VGND VPWR Tile_X0Y9_FrameStrobe[3] latch
XFILLER_605_258 VPWR VGND sg13cmos5l_decap_8
XFILLER_579_14 VPWR VGND sg13cmos5l_decap_8
XFILLER_503_98 VPWR VGND sg13cmos5l_decap_8
XFILLER_416_169 VPWR VGND sg13cmos5l_decap_8
XFILLER_471_264 VPWR VGND sg13cmos5l_decap_8
XFILLER_282_175 VPWR VGND sg13cmos5l_decap_8
XFILLER_82_258 VPWR VGND sg13cmos5l_fill_1
X_2005_ _2005_/Q Tile_X0Y4_FrameData[16] VGND VPWR Tile_X0Y9_FrameStrobe[2] latch
XFILLER_222_88 VPWR VGND sg13cmos5l_decap_8
X_0197_ _0197_/Q Tile_X0Y7_FrameData[26] VGND VPWR Tile_X0Y9_FrameStrobe[1] latch
XFILLER_222_99 VPWR VGND sg13cmos5l_fill_1
XFILLER_195_116 VPWR VGND sg13cmos5l_decap_8
X_3956_ _3956_/X Tile_X0Y1_WW4END[7] AXI_M_SOC_ARREADY _4015_/X _3988_/X _1297_/Q
+ _1296_/Q VPWR VGND sg13cmos5l_mux4_1
XFILLER_595_35 VPWR VGND sg13cmos5l_decap_8
X_2907_ Tile_X0Y6_FrameData_O[28] Tile_X0Y6_FrameData[28] VPWR VGND sg13cmos5l_buf_1
X_3887_ _3887_/X _3850_/X _0085_/X Tile_X0Y0_S1END[2] Tile_X0Y0_S4END[2] _0983_/Q
+ _0982_/Q VPWR VGND sg13cmos5l_mux4_1
X_2838_ Tile_X0Y6_E2BEG[3] _4499_/X VPWR VGND sg13cmos5l_buf_1
XFILLER_136_249 VPWR VGND sg13cmos5l_decap_8
XFILLER_464_28 VPWR VGND sg13cmos5l_decap_8
XFILLER_541_235 VPWR VGND sg13cmos5l_fill_2
X_2769_ Tile_X0Y3_FrameData_O[27] Tile_X0Y3_FrameData[27] VPWR VGND sg13cmos5l_buf_1
XFILLER_394_80 VPWR VGND sg13cmos5l_fill_1
XFILLER_352_168 VPWR VGND sg13cmos5l_decap_8
XFILLER_183_18 VPWR VGND sg13cmos5l_fill_1
X_4508_ _4508_/X Tile_X0Y6_W2END[3] AXI_M_SOC_RDATA27 _4559_/X _4558_/X _2591_/Q _2590_/Q
+ VPWR VGND sg13cmos5l_mux4_1
XFILLER_2_207 VPWR VGND sg13cmos5l_fill_2
XFILLER_104_113 VPWR VGND sg13cmos5l_decap_8
XFILLER_439_217 VPWR VGND sg13cmos5l_decap_8
XFILLER_104_146 VPWR VGND sg13cmos5l_decap_8
X_4439_ _4439_/X Tile_X0Y1_W1END[1] Tile_X0Y1_WW4END[13] Tile_X0Y1_W6END[5] _4009_/X
+ _1362_/Q _1361_/Q VPWR VGND sg13cmos5l_mux4_1
XFILLER_116_56 VPWR VGND sg13cmos5l_decap_8
XFILLER_58_200 VPWR VGND sg13cmos5l_decap_8
XFILLER_655_158 VPWR VGND sg13cmos5l_decap_8
XFILLER_480_49 VPWR VGND sg13cmos5l_decap_8
XFILLER_413_21 VPWR VGND sg13cmos5l_decap_8
XFILLER_263_95 VPWR VGND sg13cmos5l_decap_8
XFILLER_76_49 VPWR VGND sg13cmos5l_decap_8
XFILLER_112_190 VPWR VGND sg13cmos5l_decap_8
XFILLER_447_272 VPWR VGND sg13cmos5l_fill_1
XFILLER_281_7 VPWR VGND sg13cmos5l_decap_8
XFILLER_58_255 VPWR VGND sg13cmos5l_fill_1
XFILLER_379_7 VPWR VGND sg13cmos5l_decap_8
XFILLER_273_120 VPWR VGND sg13cmos5l_fill_1
XFILLER_489_14 VPWR VGND sg13cmos5l_decap_8
XFILLER_132_77 VPWR VGND sg13cmos5l_decap_8
XFILLER_710_63 VPWR VGND sg13cmos5l_decap_8
XFILLER_546_7 VPWR VGND sg13cmos5l_decap_8
XFILLER_214_220 VPWR VGND sg13cmos5l_decap_8
XFILLER_26_163 VPWR VGND sg13cmos5l_decap_8
XFILLER_639_28 VPWR VGND sg13cmos5l_decap_8
XFILLER_576_121 VPWR VGND sg13cmos5l_fill_1
XFILLER_214_264 VPWR VGND sg13cmos5l_decap_8
XFILLER_576_132 VPWR VGND sg13cmos5l_decap_8
XFILLER_569_91 VPWR VGND sg13cmos5l_decap_8
XFILLER_430_161 VPWR VGND sg13cmos5l_decap_8
XANTENNA__2932__X Tile_X0Y8_E6BEG[0] VPWR VGND sg13cmos5l_antennanp
XFILLER_713_7 VPWR VGND sg13cmos5l_decap_8
XFILLER_186_116 VPWR VGND sg13cmos5l_decap_8
XFILLER_576_187 VPWR VGND sg13cmos5l_decap_8
XFILLER_288_92 VPWR VGND sg13cmos5l_decap_8
XFILLER_591_179 VPWR VGND sg13cmos5l_decap_8
XFILLER_343_102 VPWR VGND sg13cmos5l_decap_8
XFILLER_438_84 VPWR VGND sg13cmos5l_decap_8
XFILLER_532_224 VPWR VGND sg13cmos5l_decap_8
XFILLER_142_208 VPWR VGND sg13cmos5l_fill_1
XFILLER_203_0 VPWR VGND sg13cmos5l_decap_8
XFILLER_343_179 VPWR VGND sg13cmos5l_decap_8
XFILLER_135_271 VPWR VGND sg13cmos5l_fill_2
XFILLER_497_161 VPWR VGND sg13cmos5l_decap_8
XFILLER_686_272 VPWR VGND sg13cmos5l_fill_1
XFILLER_454_83 VPWR VGND sg13cmos5l_fill_1
XFILLER_604_42 VPWR VGND sg13cmos5l_decap_8
XFILLER_500_154 VPWR VGND sg13cmos5l_decap_8
XFILLER_173_73 VPWR VGND sg13cmos5l_fill_1
XFILLER_646_147 VPWR VGND sg13cmos5l_decap_8
XFILLER_390_49 VPWR VGND sg13cmos5l_fill_1
XFILLER_572_0 VPWR VGND sg13cmos5l_decap_8
XFILLER_2_35 VPWR VGND sg13cmos5l_decap_8
XFILLER_438_272 VPWR VGND sg13cmos5l_fill_1
XFILLER_49_255 VPWR VGND sg13cmos5l_fill_1
XFILLER_470_60 VPWR VGND sg13cmos5l_fill_2
XFILLER_654_191 VPWR VGND sg13cmos5l_fill_2
XFILLER_64_203 VPWR VGND sg13cmos5l_decap_8
X_0120_ _3182_/A _3914_/X _3915_/X _1641_/Q VPWR VGND sg13cmos5l_mux2_1
XFILLER_399_14 VPWR VGND sg13cmos5l_decap_8
XFILLER_599_257 VPWR VGND sg13cmos5l_decap_4
X_0051_ AXI_M_SOC_AWBURST1 _0938_/Q _3683_/X VPWR VGND sg13cmos5l_nor2b_1
XFILLER_64_258 VPWR VGND sg13cmos5l_fill_1
XFILLER_17_141 VPWR VGND sg13cmos5l_decap_8
XFILLER_620_63 VPWR VGND sg13cmos5l_decap_8
XANTENNA__3003__X Tile_X0Y5_E2BEG[6] VPWR VGND sg13cmos5l_antennanp
XFILLER_205_231 VPWR VGND sg13cmos5l_decap_8
XFILLER_620_96 VPWR VGND sg13cmos5l_decap_4
XFILLER_32_100 VPWR VGND sg13cmos5l_decap_8
XFILLER_549_28 VPWR VGND sg13cmos5l_decap_8
XFILLER_610_250 VPWR VGND sg13cmos5l_decap_8
XFILLER_696_56 VPWR VGND sg13cmos5l_decap_8
XFILLER_421_161 VPWR VGND sg13cmos5l_decap_8
X_3810_ _3810_/X Tile_X0Y0_W2MID[1] Tile_X0Y0_W6END[7] _3855_/X _3854_/X _1085_/Q
+ _1084_/Q VPWR VGND sg13cmos5l_mux4_1
XFILLER_567_154 VPWR VGND sg13cmos5l_decap_8
XANTENNA__2842__X Tile_X0Y6_E2BEG[7] VPWR VGND sg13cmos5l_antennanp
XFILLER_610_272 VPWR VGND sg13cmos5l_fill_1
X_4790_ _4790_/X _4709_/X Tile_X0Y9_N2MID[4] _4820_/X _4708_/X _0431_/Q _0430_/Q VPWR
+ VGND sg13cmos5l_mux4_1
XFILLER_177_138 VPWR VGND sg13cmos5l_decap_8
XFILLER_32_166 VPWR VGND sg13cmos5l_fill_2
XANTENNA_18 AXI_M_SOC_RDATA26 VPWR VGND sg13cmos5l_antennanp
XANTENNA_29 AXI_M_SOC_RDATA26 VPWR VGND sg13cmos5l_antennanp
X_3741_ AXI_M_SOC_ARADDR13 Tile_X0Y9_W1END[1] Tile_X0Y9_WW4END[5] Tile_X0Y9_WW4END[13]
+ _4929_/X _0733_/Q _0732_/Q VPWR VGND sg13cmos5l_mux4_1
X_0953_ _0953_/Q Tile_X0Y0_FrameData[18] VGND VPWR Tile_X0Y9_FrameStrobe[0] latch
XFILLER_582_168 VPWR VGND sg13cmos5l_fill_1
XFILLER_381_219 VPWR VGND sg13cmos5l_fill_2
X_3672_ _3672_/X Tile_X0Y2_WW4END[2] Tile_X0Y2_WW4END[10] Tile_X0Y2_W6END[2] _4118_/X
+ _1501_/Q _1500_/Q VPWR VGND sg13cmos5l_mux4_1
XFILLER_374_271 VPWR VGND sg13cmos5l_fill_2
XFILLER_185_182 VPWR VGND sg13cmos5l_decap_8
X_0884_ _0884_/Q Tile_X0Y9_FrameData[11] VGND VPWR Tile_X0Y9_FrameStrobe[6] latch
XFILLER_565_49 VPWR VGND sg13cmos5l_decap_8
XFILLER_348_84 VPWR VGND sg13cmos5l_decap_8
X_2623_ _2623_/Q Tile_X0Y6_FrameData[8] VGND VPWR Tile_X0Y9_FrameStrobe[5] latch
XFILLER_523_235 VPWR VGND sg13cmos5l_decap_8
XFILLER_284_28 VPWR VGND sg13cmos5l_decap_8
XFILLER_334_146 VPWR VGND sg13cmos5l_decap_8
X_2554_ _2554_/Q Tile_X0Y6_FrameData[13] VGND VPWR Tile_X0Y9_FrameStrobe[3] latch
XFILLER_49_0 VPWR VGND sg13cmos5l_fill_2
XFILLER_217_77 VPWR VGND sg13cmos5l_decap_8
X_1505_ _1505_/Q Tile_X0Y2_FrameData[16] VGND VPWR Tile_X0Y9_FrameStrobe[2] latch
XFILLER_637_103 VPWR VGND sg13cmos5l_decap_8
XFILLER_99_155 VPWR VGND sg13cmos5l_fill_1
XFILLER_677_272 VPWR VGND sg13cmos5l_fill_1
X_2485_ _2485_/Q Tile_X0Y6_FrameData[18] VGND VPWR Tile_X0Y9_FrameStrobe[1] latch
XFILLER_287_245 VPWR VGND sg13cmos5l_decap_8
XFILLER_101_105 VPWR VGND sg13cmos5l_decap_8
XFILLER_99_177 VPWR VGND sg13cmos5l_decap_8
X_4224_ _4224_/X _4200_/X _0087_/X _4199_/X Tile_X0Y0_S4END[14] _1725_/Q _1724_/Q
+ VPWR VGND sg13cmos5l_mux4_1
XFILLER_514_42 VPWR VGND sg13cmos5l_decap_8
X_1436_ _1436_/Q Tile_X0Y2_FrameData[21] VGND VPWR Tile_X0Y9_FrameStrobe[0] latch
XFILLER_436_209 VPWR VGND sg13cmos5l_decap_8
XFILLER_661_70 VPWR VGND sg13cmos5l_fill_1
XFILLER_233_21 VPWR VGND sg13cmos5l_decap_8
XFILLER_429_272 VPWR VGND sg13cmos5l_fill_1
X_4155_ _4155_/X Tile_X0Y3_W2MID[0] AXI_M_SOC_BVALID _4205_/X _4204_/X _1831_/Q _1830_/Q
+ VPWR VGND sg13cmos5l_mux4_1
X_1367_ _1367_/Q Tile_X0Y1_FrameData[2] VGND VPWR Tile_X0Y9_FrameStrobe[5] latch
XFILLER_380_71 VPWR VGND sg13cmos5l_decap_8
X_3106_ Tile_X0Y7_E6BEG[4] _4648_/X VPWR VGND sg13cmos5l_buf_1
XFILLER_380_82 VPWR VGND sg13cmos5l_fill_2
X_0318_ _0318_/Q Tile_X0Y7_FrameData[1] VGND VPWR Tile_X0Y9_FrameStrobe[4] latch
X_4086_ _4086_/X _4093_/X Tile_X0Y2_W6END[2] _4092_/X _4086_/A3 _1429_/Q _1428_/Q
+ VPWR VGND sg13cmos5l_mux4_1
XFILLER_55_236 VPWR VGND sg13cmos5l_fill_2
XFILLER_255_164 VPWR VGND sg13cmos5l_decap_8
X_1298_ _1298_/Q Tile_X0Y1_FrameData[7] VGND VPWR Tile_X0Y9_FrameStrobe[3] latch
XFILLER_660_150 VPWR VGND sg13cmos5l_decap_8
XFILLER_102_14 VPWR VGND sg13cmos5l_decap_8
X_3037_ Tile_X0Y5_EE4BEG[12] _4400_/X VPWR VGND sg13cmos5l_buf_1
XFILLER_530_63 VPWR VGND sg13cmos5l_decap_8
X_0249_ _0249_/Q Tile_X0Y7_FrameData[6] VGND VPWR Tile_X0Y9_FrameStrobe[2] latch
XFILLER_270_134 VPWR VGND sg13cmos5l_fill_1
XFILLER_660_194 VPWR VGND sg13cmos5l_decap_8
XFILLER_270_145 VPWR VGND sg13cmos5l_decap_4
XFILLER_70_217 VPWR VGND sg13cmos5l_decap_8
XFILLER_459_28 VPWR VGND sg13cmos5l_decap_8
XFILLER_211_201 VPWR VGND sg13cmos5l_decap_8
XFILLER_389_91 VPWR VGND sg13cmos5l_fill_1
XFILLER_23_144 VPWR VGND sg13cmos5l_decap_8
XANTENNA__2752__X Tile_X0Y3_FrameData_O[10] VPWR VGND sg13cmos5l_antennanp
XFILLER_168_138 VPWR VGND sg13cmos5l_decap_8
XFILLER_357_238 VPWR VGND sg13cmos5l_decap_8
XFILLER_168_149 VPWR VGND sg13cmos5l_fill_1
XFILLER_23_188 VPWR VGND sg13cmos5l_fill_2
X_3939_ _3939_/X Tile_X0Y1_W2MID[0] AXI_M_SOC_ARREADY _3989_/X _3988_/X _1331_/Q _1330_/Q
+ VPWR VGND sg13cmos5l_mux4_1
XFILLER_573_168 VPWR VGND sg13cmos5l_decap_8
XFILLER_715_140 VPWR VGND sg13cmos5l_decap_8
XFILLER_176_171 VPWR VGND sg13cmos5l_decap_8
XFILLER_127_7 VPWR VGND sg13cmos5l_decap_8
XFILLER_475_49 VPWR VGND sg13cmos5l_decap_8
XFILLER_365_271 VPWR VGND sg13cmos5l_fill_2
XFILLER_258_84 VPWR VGND sg13cmos5l_fill_2
XFILLER_325_113 VPWR VGND sg13cmos5l_fill_2
XFILLER_408_21 VPWR VGND sg13cmos5l_decap_8
XFILLER_194_28 VPWR VGND sg13cmos5l_decap_8
XFILLER_301_8 VPWR VGND sg13cmos5l_decap_8
XANTENNA__3583__X Tile_X0Y9_FrameData_O[13] VPWR VGND sg13cmos5l_antennanp
XFILLER_191_185 VPWR VGND sg13cmos5l_decap_8
XFILLER_11_77 VPWR VGND sg13cmos5l_decap_8
XFILLER_668_250 VPWR VGND sg13cmos5l_decap_8
XFILLER_340_138 VPWR VGND sg13cmos5l_decap_8
XFILLER_132_230 VPWR VGND sg13cmos5l_fill_2
XFILLER_87_15 VPWR VGND sg13cmos5l_decap_8
XFILLER_705_63 VPWR VGND sg13cmos5l_decap_8
XFILLER_496_7 VPWR VGND sg13cmos5l_decap_8
XFILLER_127_99 VPWR VGND sg13cmos5l_decap_8
XFILLER_683_220 VPWR VGND sg13cmos5l_decap_8
XFILLER_132_263 VPWR VGND sg13cmos5l_fill_2
XFILLER_278_256 VPWR VGND sg13cmos5l_fill_2
XFILLER_424_42 VPWR VGND sg13cmos5l_decap_8
XFILLER_143_21 VPWR VGND sg13cmos5l_decap_8
XFILLER_571_70 VPWR VGND sg13cmos5l_decap_8
XFILLER_494_175 VPWR VGND sg13cmos5l_decap_8
XANTENNA__2927__X Tile_X0Y8_E2BEGb[3] VPWR VGND sg13cmos5l_antennanp
XFILLER_663_7 VPWR VGND sg13cmos5l_decap_8
XFILLER_293_259 VPWR VGND sg13cmos5l_fill_1
XFILLER_290_71 VPWR VGND sg13cmos5l_decap_8
XFILLER_246_153 VPWR VGND sg13cmos5l_decap_4
XFILLER_143_98 VPWR VGND sg13cmos5l_fill_2
XFILLER_46_225 VPWR VGND sg13cmos5l_decap_8
XFILLER_651_161 VPWR VGND sg13cmos5l_decap_8
XFILLER_440_63 VPWR VGND sg13cmos5l_decap_8
XFILLER_450_234 VPWR VGND sg13cmos5l_decap_8
XFILLER_261_145 VPWR VGND sg13cmos5l_decap_8
XFILLER_61_239 VPWR VGND sg13cmos5l_decap_8
XFILLER_369_28 VPWR VGND sg13cmos5l_decap_8
XFILLER_14_122 VPWR VGND sg13cmos5l_decap_8
XANTENNA__3758__X AXI_M_SOC_ARADDR30 VPWR VGND sg13cmos5l_antennanp
XFILLER_153_0 VPWR VGND sg13cmos5l_decap_8
XFILLER_403_172 VPWR VGND sg13cmos5l_decap_8
XFILLER_549_176 VPWR VGND sg13cmos5l_decap_8
XFILLER_348_227 VPWR VGND sg13cmos5l_decap_8
XFILLER_159_138 VPWR VGND sg13cmos5l_decap_8
XFILLER_52_40 VPWR VGND sg13cmos5l_decap_8
XFILLER_320_0 VPWR VGND sg13cmos5l_decap_4
XFILLER_418_0 VPWR VGND sg13cmos5l_decap_8
XFILLER_706_140 VPWR VGND sg13cmos5l_fill_1
XFILLER_706_151 VPWR VGND sg13cmos5l_decap_8
XFILLER_167_182 VPWR VGND sg13cmos5l_decap_4
XFILLER_505_213 VPWR VGND sg13cmos5l_decap_8
XFILLER_682_14 VPWR VGND sg13cmos5l_decap_8
XANTENNA__3493__X Tile_X0Y1_E6BEG[3] VPWR VGND sg13cmos5l_antennanp
XFILLER_682_25 VPWR VGND sg13cmos5l_fill_2
XFILLER_371_252 VPWR VGND sg13cmos5l_decap_8
XFILLER_505_268 VPWR VGND sg13cmos5l_decap_4
XFILLER_184_50 VPWR VGND sg13cmos5l_decap_8
XFILLER_318_98 VPWR VGND sg13cmos5l_decap_8
XFILLER_659_250 VPWR VGND sg13cmos5l_decap_8
XFILLER_123_230 VPWR VGND sg13cmos5l_decap_8
XFILLER_659_272 VPWR VGND sg13cmos5l_fill_1
XFILLER_269_223 VPWR VGND sg13cmos5l_decap_8
XFILLER_619_114 VPWR VGND sg13cmos5l_decap_8
XFILLER_615_63 VPWR VGND sg13cmos5l_decap_8
XFILLER_229_109 VPWR VGND sg13cmos5l_fill_2
X_2270_ _2270_/Q Tile_X0Y5_FrameData[7] VGND VPWR Tile_X0Y9_FrameStrobe[2] latch
XFILLER_481_70 VPWR VGND sg13cmos5l_fill_2
XFILLER_674_264 VPWR VGND sg13cmos5l_decap_8
XFILLER_96_158 VPWR VGND sg13cmos5l_decap_8
XFILLER_334_86 VPWR VGND sg13cmos5l_decap_8
X_1221_ _1221_/Q Tile_X0Y1_FrameData[20] VGND VPWR Tile_X0Y9_FrameStrobe[1] latch
XANTENNA__2837__X Tile_X0Y6_E2BEG[2] VPWR VGND sg13cmos5l_antennanp
XFILLER_426_231 VPWR VGND sg13cmos5l_decap_8
X_1152_ _1152_/Q Tile_X0Y0_FrameData[11] VGND VPWR Tile_X0Y9_FrameStrobe[6] latch
XFILLER_631_84 VPWR VGND sg13cmos5l_decap_8
XFILLER_37_236 VPWR VGND sg13cmos5l_decap_8
XFILLER_203_35 VPWR VGND sg13cmos5l_decap_8
XFILLER_642_161 VPWR VGND sg13cmos5l_decap_8
X_0103_ _3191_/A _3798_/X _3799_/X _1142_/Q VPWR VGND sg13cmos5l_mux2_1
XFILLER_350_63 VPWR VGND sg13cmos5l_decap_8
X_1083_ _1083_/Q Tile_X0Y0_FrameData[16] VGND VPWR Tile_X0Y9_FrameStrobe[4] latch
XFILLER_587_227 VPWR VGND sg13cmos5l_decap_8
X_4911_ _4911_/X _4456_/X _4460_/X _4464_/X _4431_/X _2376_/Q _2375_/Q VPWR VGND sg13cmos5l_mux4_1
XFILLER_279_28 VPWR VGND sg13cmos5l_decap_8
XANTENNA__3668__X AXI_M_SOC_AWADDR29 VPWR VGND sg13cmos5l_antennanp
XFILLER_500_77 VPWR VGND sg13cmos5l_decap_8
X_4842_ _4842_/X Tile_X0Y9_W1END[3] Tile_X0Y9_WW4END[15] Tile_X0Y9_W6END[7] _4919_/X
+ _0858_/Q _0857_/Q VPWR VGND sg13cmos5l_mux4_1
XFILLER_60_250 VPWR VGND sg13cmos5l_decap_8
XFILLER_60_261 VPWR VGND sg13cmos5l_fill_1
XFILLER_339_227 VPWR VGND sg13cmos5l_decap_8
XFILLER_60_272 VPWR VGND sg13cmos5l_fill_1
XFILLER_555_124 VPWR VGND sg13cmos5l_decap_8
X_4773_ _4773_/X _4779_/X Tile_X0Y8_W6END[1] _4778_/X _4773_/A3 _0421_/Q _0420_/Q
+ VPWR VGND sg13cmos5l_mux4_1
XFILLER_20_136 VPWR VGND sg13cmos5l_decap_8
X_1985_ _1985_/Q Tile_X0Y4_FrameData[4] VGND VPWR Tile_X0Y9_FrameStrobe[1] latch
XFILLER_555_168 VPWR VGND sg13cmos5l_decap_8
X_3724_ _3724_/X Tile_X0Y3_WW4END[1] Tile_X0Y3_WW4END[9] Tile_X0Y3_W6END[9] _4231_/X
+ _1739_/Q _1738_/Q VPWR VGND sg13cmos5l_mux4_1
XFILLER_570_105 VPWR VGND sg13cmos5l_decap_8
XFILLER_509_42 VPWR VGND sg13cmos5l_decap_8
X_0936_ _0936_/Q Tile_X0Y9_FrameData[27] VGND VPWR Tile_X0Y9_FrameStrobe[8] latch
XFILLER_228_21 VPWR VGND sg13cmos5l_decap_8
XFILLER_656_70 VPWR VGND sg13cmos5l_fill_2
X_3655_ AXI_M_SOC_AWADDR16 Tile_X0Y4_WW4END[0] Tile_X0Y4_WW4END[8] Tile_X0Y4_W6END[0]
+ _4336_/X _2013_/Q _2012_/Q VPWR VGND sg13cmos5l_mux4_1
XFILLER_592_14 VPWR VGND sg13cmos5l_decap_8
X_0867_ _0867_/Q Tile_X0Y9_FrameData[28] VGND VPWR Tile_X0Y9_FrameStrobe[6] latch
XFILLER_362_252 VPWR VGND sg13cmos5l_decap_8
XFILLER_173_163 VPWR VGND sg13cmos5l_decap_8
XFILLER_106_219 VPWR VGND sg13cmos5l_decap_8
X_2606_ _2606_/Q Tile_X0Y6_FrameData[25] VGND VPWR Tile_X0Y9_FrameStrobe[5] latch
XFILLER_712_154 VPWR VGND sg13cmos5l_decap_8
XFILLER_511_205 VPWR VGND sg13cmos5l_decap_4
XFILLER_228_87 VPWR VGND sg13cmos5l_decap_4
X_3586_ Tile_X0Y9_FrameData_O[16] Tile_X0Y9_FrameData[16] VPWR VGND sg13cmos5l_buf_1
X_0798_ _0798_/Q Tile_X0Y9_FrameData[1] VGND VPWR Tile_X0Y9_FrameStrobe[3] latch
XFILLER_511_238 VPWR VGND sg13cmos5l_decap_8
XFILLER_315_190 VPWR VGND sg13cmos5l_decap_8
XFILLER_114_241 VPWR VGND sg13cmos5l_fill_1
X_2537_ _2537_/Q Tile_X0Y6_FrameData[30] VGND VPWR Tile_X0Y9_FrameStrobe[3] latch
XFILLER_525_63 VPWR VGND sg13cmos5l_decap_8
XFILLER_114_263 VPWR VGND sg13cmos5l_decap_8
XFILLER_665_220 VPWR VGND sg13cmos5l_fill_2
XFILLER_244_42 VPWR VGND sg13cmos5l_decap_8
X_2468_ _2468_/Q Tile_X0Y6_FrameData[3] VGND VPWR Tile_X0Y9_FrameStrobe[0] latch
XFILLER_680_201 VPWR VGND sg13cmos5l_fill_2
X_4207_ _4207_/X _4131_/X _4239_/X _4238_/X _4130_/X _1695_/Q _1694_/Q VPWR VGND sg13cmos5l_mux4_1
XFILLER_491_112 VPWR VGND sg13cmos5l_decap_8
XANTENNA__2747__X Tile_X0Y3_FrameData_O[5] VPWR VGND sg13cmos5l_antennanp
XFILLER_87_169 VPWR VGND sg13cmos5l_fill_2
X_1419_ _1419_/Q Tile_X0Y1_FrameData[14] VGND VPWR Tile_X0Y9_FrameStrobe[7] latch
X_2399_ _2399_/Q Tile_X0Y5_FrameData[6] VGND VPWR Tile_X0Y9_FrameStrobe[6] latch
XFILLER_618_180 VPWR VGND sg13cmos5l_decap_4
XFILLER_417_231 VPWR VGND sg13cmos5l_decap_8
XFILLER_228_142 VPWR VGND sg13cmos5l_fill_1
XFILLER_290_207 VPWR VGND sg13cmos5l_decap_4
XFILLER_228_153 VPWR VGND sg13cmos5l_decap_8
X_4138_ _4138_/X Tile_X0Y1_W1END[1] Tile_X0Y1_W2MID[2] Tile_X0Y1_W2END[2] _3992_/X
+ _1371_/Q _1370_/Q VPWR VGND sg13cmos5l_mux4_1
XFILLER_28_225 VPWR VGND sg13cmos5l_decap_8
XFILLER_28_236 VPWR VGND sg13cmos5l_fill_2
XFILLER_113_35 VPWR VGND sg13cmos5l_decap_8
XFILLER_417_264 VPWR VGND sg13cmos5l_fill_1
XFILLER_491_189 VPWR VGND sg13cmos5l_decap_4
XFILLER_633_161 VPWR VGND sg13cmos5l_decap_4
XFILLER_260_63 VPWR VGND sg13cmos5l_decap_8
X_4069_ _4069_/X Tile_X0Y2_WW4END[2] AXI_M_SOC_AWREADY _4118_/X _4101_/X _1535_/Q
+ _1534_/Q VPWR VGND sg13cmos5l_mux4_1
XFILLER_73_28 VPWR VGND sg13cmos5l_decap_8
XFILLER_389_127 VPWR VGND sg13cmos5l_decap_8
XFILLER_432_245 VPWR VGND sg13cmos5l_decap_4
XANTENNA__3578__X Tile_X0Y9_FrameData_O[8] VPWR VGND sg13cmos5l_antennanp
XFILLER_593_208 VPWR VGND sg13cmos5l_decap_8
XFILLER_410_77 VPWR VGND sg13cmos5l_decap_8
XFILLER_244_7 VPWR VGND sg13cmos5l_decap_8
XFILLER_196_222 VPWR VGND sg13cmos5l_fill_2
XFILLER_51_272 VPWR VGND sg13cmos5l_fill_1
XFILLER_400_175 VPWR VGND sg13cmos5l_decap_8
XFILLER_11_158 VPWR VGND sg13cmos5l_decap_8
XFILLER_22_21 VPWR VGND sg13cmos5l_decap_8
XFILLER_561_105 VPWR VGND sg13cmos5l_decap_8
XFILLER_419_42 VPWR VGND sg13cmos5l_decap_8
XFILLER_411_7 VPWR VGND sg13cmos5l_decap_8
XFILLER_149_171 VPWR VGND sg13cmos5l_decap_8
XFILLER_509_7 VPWR VGND sg13cmos5l_decap_8
XFILLER_566_70 VPWR VGND sg13cmos5l_decap_8
XFILLER_138_21 VPWR VGND sg13cmos5l_decap_8
XFILLER_22_98 VPWR VGND sg13cmos5l_fill_2
XFILLER_98_14 VPWR VGND sg13cmos5l_decap_8
XFILLER_499_245 VPWR VGND sg13cmos5l_decap_8
XFILLER_499_256 VPWR VGND sg13cmos5l_fill_2
XFILLER_313_116 VPWR VGND sg13cmos5l_decap_4
XFILLER_138_98 VPWR VGND sg13cmos5l_decap_8
XFILLER_164_196 VPWR VGND sg13cmos5l_decap_8
XFILLER_313_127 VPWR VGND sg13cmos5l_decap_8
XFILLER_648_209 VPWR VGND sg13cmos5l_decap_8
XFILLER_502_238 VPWR VGND sg13cmos5l_decap_8
XFILLER_313_138 VPWR VGND sg13cmos5l_decap_8
XFILLER_105_230 VPWR VGND sg13cmos5l_decap_4
XFILLER_105_241 VPWR VGND sg13cmos5l_fill_2
XFILLER_652_28 VPWR VGND sg13cmos5l_decap_8
XFILLER_435_63 VPWR VGND sg13cmos5l_decap_8
XFILLER_582_91 VPWR VGND sg13cmos5l_decap_8
XFILLER_154_42 VPWR VGND sg13cmos5l_decap_8
XFILLER_656_253 VPWR VGND sg13cmos5l_decap_4
XFILLER_467_153 VPWR VGND sg13cmos5l_decap_8
XFILLER_321_193 VPWR VGND sg13cmos5l_decap_8
XFILLER_266_226 VPWR VGND sg13cmos5l_decap_8
XFILLER_154_86 VPWR VGND sg13cmos5l_fill_1
XFILLER_482_112 VPWR VGND sg13cmos5l_decap_8
XFILLER_671_212 VPWR VGND sg13cmos5l_decap_8
XFILLER_93_106 VPWR VGND sg13cmos5l_decap_4
XFILLER_408_231 VPWR VGND sg13cmos5l_fill_1
XFILLER_304_56 VPWR VGND sg13cmos5l_decap_8
XFILLER_408_253 VPWR VGND sg13cmos5l_decap_8
XFILLER_451_84 VPWR VGND sg13cmos5l_decap_8
XFILLER_601_21 VPWR VGND sg13cmos5l_decap_8
XFILLER_270_0 VPWR VGND sg13cmos5l_decap_8
XFILLER_47_84 VPWR VGND sg13cmos5l_decap_8
XFILLER_170_63 VPWR VGND sg13cmos5l_decap_8
XFILLER_19_269 VPWR VGND sg13cmos5l_decap_4
XFILLER_219_197 VPWR VGND sg13cmos5l_decap_4
XFILLER_368_0 VPWR VGND sg13cmos5l_decap_4
XFILLER_234_134 VPWR VGND sg13cmos5l_decap_8
XFILLER_624_194 VPWR VGND sg13cmos5l_decap_8
XFILLER_34_217 VPWR VGND sg13cmos5l_decap_8
XFILLER_569_238 VPWR VGND sg13cmos5l_decap_4
XFILLER_320_22 VPWR VGND sg13cmos5l_decap_8
XFILLER_677_14 VPWR VGND sg13cmos5l_decap_8
XFILLER_601_98 VPWR VGND sg13cmos5l_decap_4
XANTENNA__3488__X Tile_X0Y1_EE4BEG[14] VPWR VGND sg13cmos5l_antennanp
XFILLER_535_0 VPWR VGND sg13cmos5l_decap_8
XFILLER_320_66 VPWR VGND sg13cmos5l_fill_2
XFILLER_395_119 VPWR VGND sg13cmos5l_decap_8
XFILLER_537_135 VPWR VGND sg13cmos5l_decap_8
XFILLER_187_266 VPWR VGND sg13cmos5l_decap_8
XFILLER_537_146 VPWR VGND sg13cmos5l_fill_1
XFILLER_702_0 VPWR VGND sg13cmos5l_decap_8
XFILLER_537_168 VPWR VGND sg13cmos5l_decap_8
XFILLER_8_56 VPWR VGND sg13cmos5l_decap_8
X_1770_ _1770_/Q Tile_X0Y3_FrameData[31] VGND VPWR Tile_X0Y9_FrameStrobe[3] latch
XFILLER_693_35 VPWR VGND sg13cmos5l_decap_8
XFILLER_329_64 VPWR VGND sg13cmos5l_decap_8
X_0721_ _0721_/Q Tile_X0Y9_FrameData[14] VGND VPWR Tile_X0Y9_FrameStrobe[1] latch
XFILLER_552_149 VPWR VGND sg13cmos5l_decap_8
XFILLER_344_241 VPWR VGND sg13cmos5l_fill_2
XFILLER_329_97 VPWR VGND sg13cmos5l_decap_8
X_3440_ Tile_X0Y4_FrameData_O[31] Tile_X0Y4_FrameData[31] VPWR VGND sg13cmos5l_buf_1
X_0652_ _0652_/Q Tile_X0Y8_FrameData[19] VGND VPWR Tile_X0Y9_FrameStrobe[7] latch
XFILLER_626_84 VPWR VGND sg13cmos5l_decap_4
XFILLER_560_171 VPWR VGND sg13cmos5l_decap_8
XFILLER_562_28 VPWR VGND sg13cmos5l_decap_8
X_3371_ Tile_X0Y2_EE4BEG[10] _4066_/X VPWR VGND sg13cmos5l_buf_1
XFILLER_345_63 VPWR VGND sg13cmos5l_decap_8
X_0583_ _0583_/Q Tile_X0Y8_FrameData[24] VGND VPWR Tile_X0Y9_FrameStrobe[5] latch
XFILLER_345_85 VPWR VGND sg13cmos5l_decap_8
XFILLER_647_231 VPWR VGND sg13cmos5l_decap_8
XFILLER_492_91 VPWR VGND sg13cmos5l_decap_8
X_2322_ _2322_/Q Tile_X0Y5_FrameData[19] VGND VPWR Tile_X0Y9_FrameStrobe[4] latch
XFILLER_312_160 VPWR VGND sg13cmos5l_fill_1
XFILLER_312_182 VPWR VGND sg13cmos5l_decap_8
XFILLER_69_147 VPWR VGND sg13cmos5l_decap_8
XFILLER_473_101 VPWR VGND sg13cmos5l_decap_8
X_2253_ _2253_/Q Tile_X0Y5_FrameData[24] VGND VPWR Tile_X0Y9_FrameStrobe[2] latch
XFILLER_458_197 VPWR VGND sg13cmos5l_decap_8
XFILLER_214_56 VPWR VGND sg13cmos5l_decap_8
X_1204_ _1204_/Q Tile_X0Y1_FrameData[5] VGND VPWR Tile_X0Y9_FrameStrobe[0] latch
X_2184_ _2184_/Q Tile_X0Y5_FrameData[29] VGND VPWR Tile_X0Y9_FrameStrobe[0] latch
XFILLER_511_21 VPWR VGND sg13cmos5l_decap_8
XFILLER_225_123 VPWR VGND sg13cmos5l_decap_8
XFILLER_615_172 VPWR VGND sg13cmos5l_fill_2
X_1135_ _1135_/Q Tile_X0Y0_FrameData[28] VGND VPWR Tile_X0Y9_FrameStrobe[6] latch
X_1066_ _1066_/Q Tile_X0Y0_FrameData[1] VGND VPWR Tile_X0Y9_FrameStrobe[3] latch
XFILLER_587_14 VPWR VGND sg13cmos5l_decap_8
XFILLER_511_98 VPWR VGND sg13cmos5l_decap_8
XANTENNA__3398__X Tile_X0Y2_E2BEG[1] VPWR VGND sg13cmos5l_antennanp
XFILLER_240_137 VPWR VGND sg13cmos5l_decap_4
XFILLER_178_222 VPWR VGND sg13cmos5l_decap_8
XFILLER_230_88 VPWR VGND sg13cmos5l_decap_8
XFILLER_230_99 VPWR VGND sg13cmos5l_fill_2
XFILLER_528_113 VPWR VGND sg13cmos5l_decap_8
XFILLER_717_224 VPWR VGND sg13cmos5l_decap_4
X_4825_ _4825_/X Tile_X0Y9_W1END[1] Tile_X0Y9_W6END[9] _4929_/X _4893_/X _0889_/Q
+ _0888_/Q VPWR VGND sg13cmos5l_mux4_1
XFILLER_394_152 VPWR VGND sg13cmos5l_decap_8
XFILLER_138_119 VPWR VGND sg13cmos5l_decap_8
XFILLER_717_268 VPWR VGND sg13cmos5l_decap_4
XFILLER_543_116 VPWR VGND sg13cmos5l_decap_8
X_1968_ _1968_/Q Tile_X0Y4_FrameData[21] VGND VPWR Tile_X0Y9_FrameStrobe[1] latch
X_4756_ _4756_/X Tile_X0Y8_WW4END[3] AXI_M_SOC_RDATA11 _4803_/X _4791_/X _0535_/Q
+ _0534_/Q VPWR VGND sg13cmos5l_mux4_1
XFILLER_239_64 VPWR VGND sg13cmos5l_decap_4
XFILLER_335_230 VPWR VGND sg13cmos5l_decap_8
X_0919_ _0919_/Q Tile_X0Y9_FrameData[8] VGND VPWR Tile_X0Y9_FrameStrobe[7] latch
X_3707_ AXI_M_SOC_WDATA17 Tile_X0Y6_WW4END[1] Tile_X0Y6_WW4END[9] Tile_X0Y6_W6END[1]
+ _4569_/X _2525_/Q _2524_/Q VPWR VGND sg13cmos5l_mux4_1
XFILLER_536_190 VPWR VGND sg13cmos5l_fill_1
XFILLER_239_97 VPWR VGND sg13cmos5l_decap_4
X_4687_ _4687_/X _4667_/X Tile_X0Y9_N4END[11] _4666_/X _0053_/X _0209_/Q _0208_/Q
+ VPWR VGND sg13cmos5l_mux4_1
X_1899_ _1899_/Q Tile_X0Y3_FrameData[30] VGND VPWR Tile_X0Y9_FrameStrobe[7] latch
XFILLER_146_185 VPWR VGND sg13cmos5l_decap_8
X_3638_ Tile_X0Y9_UserCLKo Tile_X0Y9_UserCLK VPWR VGND sg13cmos5l_buf_1
XFILLER_108_35 VPWR VGND sg13cmos5l_decap_8
XFILLER_496_215 VPWR VGND sg13cmos5l_decap_8
XFILLER_551_193 VPWR VGND sg13cmos5l_fill_1
XFILLER_350_244 VPWR VGND sg13cmos5l_decap_8
XFILLER_697_197 VPWR VGND sg13cmos5l_decap_8
XFILLER_472_28 VPWR VGND sg13cmos5l_decap_8
X_3569_ Tile_X0Y9_EE4BEG[15] _4879_/X VPWR VGND sg13cmos5l_buf_1
XFILLER_68_28 VPWR VGND sg13cmos5l_decap_8
XFILLER_496_259 VPWR VGND sg13cmos5l_fill_1
XFILLER_255_85 VPWR VGND sg13cmos5l_decap_8
XFILLER_161_188 VPWR VGND sg13cmos5l_decap_8
XFILLER_449_142 VPWR VGND sg13cmos5l_decap_8
XFILLER_102_233 VPWR VGND sg13cmos5l_decap_8
XFILLER_405_77 VPWR VGND sg13cmos5l_decap_8
XFILLER_194_7 VPWR VGND sg13cmos5l_decap_8
XFILLER_75_106 VPWR VGND sg13cmos5l_decap_8
XFILLER_653_223 VPWR VGND sg13cmos5l_decap_8
XFILLER_124_56 VPWR VGND sg13cmos5l_decap_8
XFILLER_702_42 VPWR VGND sg13cmos5l_decap_8
XFILLER_464_178 VPWR VGND sg13cmos5l_decap_8
XFILLER_271_95 VPWR VGND sg13cmos5l_fill_2
XFILLER_263_229 VPWR VGND sg13cmos5l_decap_8
XFILLER_84_49 VPWR VGND sg13cmos5l_decap_8
XFILLER_421_21 VPWR VGND sg13cmos5l_decap_8
XFILLER_17_21 VPWR VGND sg13cmos5l_decap_8
XFILLER_606_172 VPWR VGND sg13cmos5l_decap_8
XFILLER_361_7 VPWR VGND sg13cmos5l_decap_8
XFILLER_459_7 VPWR VGND sg13cmos5l_decap_8
XFILLER_16_239 VPWR VGND sg13cmos5l_decap_4
XFILLER_497_14 VPWR VGND sg13cmos5l_decap_8
XFILLER_421_98 VPWR VGND sg13cmos5l_decap_8
XFILLER_17_87 VPWR VGND sg13cmos5l_decap_8
XFILLER_231_126 VPWR VGND sg13cmos5l_fill_2
XFILLER_140_77 VPWR VGND sg13cmos5l_decap_8
XFILLER_626_7 VPWR VGND sg13cmos5l_decap_8
XFILLER_24_250 VPWR VGND sg13cmos5l_decap_8
XFILLER_559_271 VPWR VGND sg13cmos5l_fill_2
XANTENNA__3101__X Tile_X0Y7_E2BEGb[7] VPWR VGND sg13cmos5l_antennanp
XFILLER_24_272 VPWR VGND sg13cmos5l_fill_1
XFILLER_647_28 VPWR VGND sg13cmos5l_decap_8
XFILLER_574_252 VPWR VGND sg13cmos5l_decap_8
XFILLER_129_119 VPWR VGND sg13cmos5l_decap_8
XANTENNA__2940__X Tile_X0Y8_E6BEG[8] VPWR VGND sg13cmos5l_antennanp
XFILLER_149_42 VPWR VGND sg13cmos5l_decap_8
XFILLER_184_225 VPWR VGND sg13cmos5l_decap_4
XFILLER_577_91 VPWR VGND sg13cmos5l_decap_8
XFILLER_519_179 VPWR VGND sg13cmos5l_decap_8
XFILLER_366_29 VPWR VGND sg13cmos5l_decap_8
XFILLER_296_70 VPWR VGND sg13cmos5l_fill_2
XFILLER_149_86 VPWR VGND sg13cmos5l_decap_8
XFILLER_116_0 VPWR VGND sg13cmos5l_decap_8
XFILLER_341_200 VPWR VGND sg13cmos5l_decap_4
XFILLER_663_49 VPWR VGND sg13cmos5l_decap_8
XFILLER_487_226 VPWR VGND sg13cmos5l_decap_8
XFILLER_382_28 VPWR VGND sg13cmos5l_decap_8
XFILLER_165_74 VPWR VGND sg13cmos5l_decap_4
XFILLER_341_266 VPWR VGND sg13cmos5l_decap_8
XFILLER_152_199 VPWR VGND sg13cmos5l_decap_8
XFILLER_629_253 VPWR VGND sg13cmos5l_decap_8
XFILLER_485_0 VPWR VGND sg13cmos5l_decap_8
XFILLER_462_72 VPWR VGND sg13cmos5l_decap_8
XFILLER_315_66 VPWR VGND sg13cmos5l_fill_2
XFILLER_239_237 VPWR VGND sg13cmos5l_decap_8
XFILLER_239_248 VPWR VGND sg13cmos5l_fill_2
XFILLER_644_245 VPWR VGND sg13cmos5l_decap_8
XFILLER_612_42 VPWR VGND sg13cmos5l_decap_8
XFILLER_181_84 VPWR VGND sg13cmos5l_decap_8
XFILLER_604_109 VPWR VGND sg13cmos5l_decap_8
XFILLER_652_0 VPWR VGND sg13cmos5l_decap_8
XFILLER_331_21 VPWR VGND sg13cmos5l_fill_1
XFILLER_688_35 VPWR VGND sg13cmos5l_decap_8
XFILLER_612_120 VPWR VGND sg13cmos5l_decap_8
XFILLER_74_183 VPWR VGND sg13cmos5l_decap_8
XFILLER_74_60 VPWR VGND sg13cmos5l_decap_8
XFILLER_262_262 VPWR VGND sg13cmos5l_decap_8
XFILLER_612_153 VPWR VGND sg13cmos5l_decap_8
XFILLER_222_126 VPWR VGND sg13cmos5l_decap_8
XFILLER_200_14 VPWR VGND sg13cmos5l_decap_8
X_2940_ Tile_X0Y8_E6BEG[8] _4768_/X VPWR VGND sg13cmos5l_buf_1
XANTENNA__3011__X Tile_X0Y5_E2BEGb[6] VPWR VGND sg13cmos5l_antennanp
X_2871_ Tile_X0Y6_EE4BEG[8] _4520_/X VPWR VGND sg13cmos5l_buf_1
XFILLER_557_28 VPWR VGND sg13cmos5l_decap_8
XFILLER_309_208 VPWR VGND sg13cmos5l_decap_8
XFILLER_487_91 VPWR VGND sg13cmos5l_fill_2
XFILLER_30_253 VPWR VGND sg13cmos5l_decap_8
XANTENNA__2850__X Tile_X0Y6_E2BEGb[7] VPWR VGND sg13cmos5l_antennanp
X_1822_ _1822_/Q Tile_X0Y3_FrameData[11] VGND VPWR Tile_X0Y9_FrameStrobe[4] latch
X_4610_ _4610_/X _4665_/X _4664_/X AXI_M_SOC_RDATA17 AXI_M_SOC_RDATA21 _0339_/Q _0338_/Q
+ VPWR VGND sg13cmos5l_mux4_1
XFILLER_30_264 VPWR VGND sg13cmos5l_decap_8
XFILLER_175_236 VPWR VGND sg13cmos5l_decap_8
XFILLER_714_216 VPWR VGND sg13cmos5l_fill_1
XFILLER_376_196 VPWR VGND sg13cmos5l_decap_8
XFILLER_714_227 VPWR VGND sg13cmos5l_fill_1
XFILLER_391_133 VPWR VGND sg13cmos5l_decap_8
XFILLER_580_233 VPWR VGND sg13cmos5l_decap_8
XFILLER_525_149 VPWR VGND sg13cmos5l_decap_8
X_4541_ _4541_/X _4547_/X Tile_X0Y6_W6END[1] _4546_/X _4541_/A3 _2445_/Q _2444_/Q
+ VPWR VGND sg13cmos5l_mux4_1
X_1753_ _1753_/Q Tile_X0Y3_FrameData[16] VGND VPWR Tile_X0Y9_FrameStrobe[2] latch
XFILLER_317_252 VPWR VGND sg13cmos5l_fill_2
XFILLER_143_100 VPWR VGND sg13cmos5l_fill_1
XFILLER_209_56 VPWR VGND sg13cmos5l_decap_8
X_0704_ _0704_/Q Tile_X0Y9_FrameData[31] VGND VPWR Tile_X0Y9_FrameStrobe[1] latch
XFILLER_332_200 VPWR VGND sg13cmos5l_decap_4
XFILLER_128_196 VPWR VGND sg13cmos5l_decap_8
X_4472_ _4472_/X Tile_X0Y4_W2MID[5] Tile_X0Y4_W2END[5] Tile_X0Y4_W6END[10] _4317_/X
+ _2133_/Q _2132_/Q VPWR VGND sg13cmos5l_mux4_1
X_1684_ _1684_/Q Tile_X0Y3_FrameData[21] VGND VPWR Tile_X0Y9_FrameStrobe[0] latch
XFILLER_573_49 VPWR VGND sg13cmos5l_decap_8
XFILLER_356_84 VPWR VGND sg13cmos5l_decap_8
XFILLER_533_193 VPWR VGND sg13cmos5l_decap_8
XFILLER_506_21 VPWR VGND sg13cmos5l_decap_8
X_3423_ Tile_X0Y4_FrameData_O[14] Tile_X0Y4_FrameData[14] VPWR VGND sg13cmos5l_buf_1
XFILLER_679_186 VPWR VGND sg13cmos5l_decap_8
XFILLER_292_28 VPWR VGND sg13cmos5l_decap_8
X_0635_ _0635_/Q Tile_X0Y8_FrameData[4] VGND VPWR Tile_X0Y9_FrameStrobe[6] latch
X_3354_ Tile_X0Y2_FrameData_O[25] Tile_X0Y2_FrameData[25] VPWR VGND sg13cmos5l_buf_1
XFILLER_97_231 VPWR VGND sg13cmos5l_decap_4
X_0566_ _0566_/Q Tile_X0Y8_FrameData[9] VGND VPWR Tile_X0Y9_FrameStrobe[4] latch
XFILLER_506_98 VPWR VGND sg13cmos5l_decap_8
XFILLER_493_218 VPWR VGND sg13cmos5l_decap_8
XFILLER_372_50 VPWR VGND sg13cmos5l_decap_8
XFILLER_31_0 VPWR VGND sg13cmos5l_decap_8
XFILLER_493_229 VPWR VGND sg13cmos5l_fill_1
X_2305_ _2305_/Q Tile_X0Y5_FrameData[4] VGND VPWR Tile_X0Y9_FrameStrobe[3] latch
XFILLER_372_72 VPWR VGND sg13cmos5l_decap_8
XFILLER_225_77 VPWR VGND sg13cmos5l_decap_8
X_3285_ Tile_X0Y0_E6BEG[5] _3841_/X VPWR VGND sg13cmos5l_buf_1
XFILLER_57_106 VPWR VGND sg13cmos5l_fill_1
XFILLER_372_94 VPWR VGND sg13cmos5l_decap_8
X_0497_ _0497_/Q Tile_X0Y8_FrameData[14] VGND VPWR Tile_X0Y9_FrameStrobe[2] latch
XFILLER_635_245 VPWR VGND sg13cmos5l_fill_1
XFILLER_522_42 VPWR VGND sg13cmos5l_decap_8
X_2236_ _2236_/Q Tile_X0Y5_FrameData[9] VGND VPWR Tile_X0Y9_FrameStrobe[1] latch
XFILLER_522_53 VPWR VGND sg13cmos5l_fill_1
XFILLER_446_167 VPWR VGND sg13cmos5l_decap_8
XFILLER_461_104 VPWR VGND sg13cmos5l_fill_1
XFILLER_446_178 VPWR VGND sg13cmos5l_fill_2
XFILLER_241_21 VPWR VGND sg13cmos5l_decap_8
XFILLER_72_109 VPWR VGND sg13cmos5l_decap_8
X_2167_ _2167_/Q Tile_X0Y4_FrameData[14] VGND VPWR Tile_X0Y9_FrameStrobe[7] latch
XFILLER_65_161 VPWR VGND sg13cmos5l_decap_8
XFILLER_598_35 VPWR VGND sg13cmos5l_decap_8
X_1118_ _1118_/Q Tile_X0Y0_FrameData[13] VGND VPWR Tile_X0Y9_FrameStrobe[5] latch
XFILLER_399_255 VPWR VGND sg13cmos5l_decap_8
X_2098_ _2098_/Q Tile_X0Y4_FrameData[19] VGND VPWR Tile_X0Y9_FrameStrobe[5] latch
XFILLER_213_137 VPWR VGND sg13cmos5l_decap_8
XFILLER_402_226 VPWR VGND sg13cmos5l_decap_8
XFILLER_359_119 VPWR VGND sg13cmos5l_decap_4
XFILLER_110_14 VPWR VGND sg13cmos5l_decap_8
X_1049_ _1049_/Q Tile_X0Y0_FrameData[18] VGND VPWR Tile_X0Y9_FrameStrobe[3] latch
XFILLER_80_175 VPWR VGND sg13cmos5l_decap_8
XFILLER_467_28 VPWR VGND sg13cmos5l_decap_8
XFILLER_110_69 VPWR VGND sg13cmos5l_decap_8
XFILLER_70_29 VPWR VGND sg13cmos5l_decap_8
XFILLER_367_163 VPWR VGND sg13cmos5l_decap_8
XANTENNA__2760__X Tile_X0Y3_FrameData_O[18] VPWR VGND sg13cmos5l_antennanp
XFILLER_221_192 VPWR VGND sg13cmos5l_decap_8
X_4808_ _4808_/X _4777_/X Tile_X0Y9_N4END[4] _4776_/X _0077_/X _0455_/Q _0454_/Q VPWR
+ VGND sg13cmos5l_mux4_1
XFILLER_119_130 VPWR VGND sg13cmos5l_decap_8
XFILLER_571_233 VPWR VGND sg13cmos5l_decap_8
XFILLER_166_269 VPWR VGND sg13cmos5l_decap_4
XFILLER_705_249 VPWR VGND sg13cmos5l_fill_2
XFILLER_119_141 VPWR VGND sg13cmos5l_fill_1
XFILLER_181_206 VPWR VGND sg13cmos5l_decap_8
X_4739_ _4739_/X Tile_X0Y8_W2END[4] AXI_M_SOC_RDATA12 _4791_/X _4790_/X _0569_/Q _0568_/Q
+ VPWR VGND sg13cmos5l_mux4_1
XFILLER_119_185 VPWR VGND sg13cmos5l_fill_1
XFILLER_119_56 VPWR VGND sg13cmos5l_decap_8
XFILLER_323_200 VPWR VGND sg13cmos5l_decap_8
XFILLER_207_7 VPWR VGND sg13cmos5l_decap_8
XFILLER_713_271 VPWR VGND sg13cmos5l_fill_2
XFILLER_469_215 VPWR VGND sg13cmos5l_fill_1
XFILLER_416_21 VPWR VGND sg13cmos5l_decap_8
XFILLER_79_49 VPWR VGND sg13cmos5l_decap_8
XFILLER_469_237 VPWR VGND sg13cmos5l_decap_8
XANTENNA__3591__X Tile_X0Y9_FrameData_O[21] VPWR VGND sg13cmos5l_antennanp
XFILLER_134_177 VPWR VGND sg13cmos5l_decap_8
XFILLER_685_134 VPWR VGND sg13cmos5l_decap_8
XFILLER_685_156 VPWR VGND sg13cmos5l_decap_4
XFILLER_685_167 VPWR VGND sg13cmos5l_decap_4
XFILLER_437_112 VPWR VGND sg13cmos5l_decap_8
XFILLER_135_77 VPWR VGND sg13cmos5l_decap_8
XFILLER_288_192 VPWR VGND sg13cmos5l_decap_8
XFILLER_576_7 VPWR VGND sg13cmos5l_decap_8
XFILLER_713_96 VPWR VGND sg13cmos5l_decap_8
XFILLER_48_128 VPWR VGND sg13cmos5l_decap_8
XFILLER_432_42 VPWR VGND sg13cmos5l_decap_8
XFILLER_626_267 VPWR VGND sg13cmos5l_decap_4
XFILLER_151_21 VPWR VGND sg13cmos5l_decap_8
XFILLER_452_137 VPWR VGND sg13cmos5l_fill_2
XANTENNA__2935__X Tile_X0Y8_E6BEG[3] VPWR VGND sg13cmos5l_antennanp
XFILLER_56_172 VPWR VGND sg13cmos5l_fill_2
XFILLER_244_240 VPWR VGND sg13cmos5l_decap_8
XFILLER_301_57 VPWR VGND sg13cmos5l_decap_8
XFILLER_460_192 VPWR VGND sg13cmos5l_decap_8
XFILLER_71_175 VPWR VGND sg13cmos5l_decap_8
XFILLER_658_49 VPWR VGND sg13cmos5l_decap_8
XFILLER_377_28 VPWR VGND sg13cmos5l_decap_8
XFILLER_547_241 VPWR VGND sg13cmos5l_decap_8
XFILLER_233_0 VPWR VGND sg13cmos5l_decap_8
XFILLER_507_105 VPWR VGND sg13cmos5l_decap_8
XFILLER_373_100 VPWR VGND sg13cmos5l_decap_4
XFILLER_507_116 VPWR VGND sg13cmos5l_fill_1
XFILLER_358_196 VPWR VGND sg13cmos5l_decap_8
XFILLER_100_91 VPWR VGND sg13cmos5l_decap_8
XFILLER_507_149 VPWR VGND sg13cmos5l_decap_8
XFILLER_373_155 VPWR VGND sg13cmos5l_decap_8
XFILLER_60_62 VPWR VGND sg13cmos5l_decap_8
XFILLER_562_255 VPWR VGND sg13cmos5l_fill_2
XFILLER_400_0 VPWR VGND sg13cmos5l_decap_8
XFILLER_607_42 VPWR VGND sg13cmos5l_decap_8
XFILLER_515_171 VPWR VGND sg13cmos5l_decap_8
XFILLER_704_271 VPWR VGND sg13cmos5l_fill_2
XFILLER_176_95 VPWR VGND sg13cmos5l_decap_8
XFILLER_326_21 VPWR VGND sg13cmos5l_decap_8
XFILLER_5_35 VPWR VGND sg13cmos5l_decap_8
XFILLER_125_155 VPWR VGND sg13cmos5l_decap_8
XFILLER_690_14 VPWR VGND sg13cmos5l_decap_8
XFILLER_180_272 VPWR VGND sg13cmos5l_fill_1
XFILLER_676_156 VPWR VGND sg13cmos5l_decap_8
XFILLER_125_199 VPWR VGND sg13cmos5l_fill_1
X_0420_ _0420_/Q Tile_X0Y8_FrameData[27] VGND VPWR Tile_X0Y9_FrameStrobe[0] latch
XFILLER_140_147 VPWR VGND sg13cmos5l_decap_8
XFILLER_691_104 VPWR VGND sg13cmos5l_decap_4
XFILLER_530_196 VPWR VGND sg13cmos5l_fill_1
XFILLER_326_98 VPWR VGND sg13cmos5l_decap_8
XFILLER_468_270 VPWR VGND sg13cmos5l_fill_2
XFILLER_428_112 VPWR VGND sg13cmos5l_decap_8
XFILLER_617_212 VPWR VGND sg13cmos5l_decap_8
X_0351_ _0351_/Q Tile_X0Y7_FrameData[0] VGND VPWR Tile_X0Y9_FrameStrobe[5] latch
XFILLER_623_63 VPWR VGND sg13cmos5l_decap_8
XANTENNA__3006__X Tile_X0Y5_E2BEGb[1] VPWR VGND sg13cmos5l_antennanp
XFILLER_483_251 VPWR VGND sg13cmos5l_decap_8
XFILLER_39_128 VPWR VGND sg13cmos5l_decap_8
XFILLER_342_42 VPWR VGND sg13cmos5l_decap_8
XFILLER_227_207 VPWR VGND sg13cmos5l_fill_1
XFILLER_617_256 VPWR VGND sg13cmos5l_fill_2
X_3070_ Tile_X0Y5_FrameData_O[29] Tile_X0Y5_FrameData[29] VPWR VGND sg13cmos5l_buf_1
XFILLER_294_173 VPWR VGND sg13cmos5l_decap_8
X_0282_ _0282_/Q Tile_X0Y7_FrameData[5] VGND VPWR Tile_X0Y9_FrameStrobe[3] latch
XFILLER_342_64 VPWR VGND sg13cmos5l_fill_2
XFILLER_428_189 VPWR VGND sg13cmos5l_decap_8
XFILLER_85_70 VPWR VGND sg13cmos5l_decap_8
X_2021_ _2021_/Q Tile_X0Y4_FrameData[0] VGND VPWR Tile_X0Y9_FrameStrobe[2] latch
XANTENNA__2845__X Tile_X0Y6_E2BEGb[2] VPWR VGND sg13cmos5l_antennanp
XFILLER_85_81 VPWR VGND sg13cmos5l_fill_1
XFILLER_699_78 VPWR VGND sg13cmos5l_decap_8
XFILLER_632_248 VPWR VGND sg13cmos5l_fill_1
XFILLER_699_89 VPWR VGND sg13cmos5l_fill_1
XFILLER_47_183 VPWR VGND sg13cmos5l_decap_8
XFILLER_62_131 VPWR VGND sg13cmos5l_decap_8
XFILLER_211_35 VPWR VGND sg13cmos5l_decap_8
XFILLER_250_221 VPWR VGND sg13cmos5l_decap_8
XFILLER_600_123 VPWR VGND sg13cmos5l_decap_8
X_3972_ _3972_/X AXI_M_SOC_ARREADY _4011_/X _4015_/X _3994_/X _1265_/Q _1264_/Q VPWR
+ VGND sg13cmos5l_mux4_1
XFILLER_568_49 VPWR VGND sg13cmos5l_decap_8
X_2923_ Tile_X0Y8_E2BEG[7] _4735_/X VPWR VGND sg13cmos5l_buf_1
XFILLER_287_28 VPWR VGND sg13cmos5l_decap_8
XFILLER_148_203 VPWR VGND sg13cmos5l_fill_1
XFILLER_553_211 VPWR VGND sg13cmos5l_decap_8
XFILLER_364_111 VPWR VGND sg13cmos5l_decap_8
X_2854_ Tile_X0Y6_E6BEG[3] _4531_/X VPWR VGND sg13cmos5l_buf_1
XFILLER_699_204 VPWR VGND sg13cmos5l_fill_1
XFILLER_367_50 VPWR VGND sg13cmos5l_decap_8
XFILLER_699_226 VPWR VGND sg13cmos5l_decap_8
XFILLER_79_0 VPWR VGND sg13cmos5l_decap_8
X_1805_ _1805_/Q Tile_X0Y3_FrameData[28] VGND VPWR Tile_X0Y9_FrameStrobe[4] latch
X_2785_ Tile_X0Y3_EE4BEG[11] _4175_/X VPWR VGND sg13cmos5l_buf_1
XFILLER_163_228 VPWR VGND sg13cmos5l_decap_8
XFILLER_513_119 VPWR VGND sg13cmos5l_decap_8
XFILLER_364_188 VPWR VGND sg13cmos5l_decap_8
XFILLER_116_111 VPWR VGND sg13cmos5l_decap_8
XFILLER_517_42 VPWR VGND sg13cmos5l_decap_8
X_1736_ _1736_/Q Tile_X0Y3_FrameData[1] VGND VPWR Tile_X0Y9_FrameStrobe[1] latch
X_4524_ _4524_/X Tile_X0Y6_WW4END[3] AXI_M_SOC_RDATA27 _4571_/X _4559_/X _2559_/Q
+ _2558_/Q VPWR VGND sg13cmos5l_mux4_1
XFILLER_236_21 VPWR VGND sg13cmos5l_decap_8
XFILLER_667_112 VPWR VGND sg13cmos5l_decap_8
XFILLER_667_123 VPWR VGND sg13cmos5l_fill_2
X_1667_ _1667_/Q Tile_X0Y2_FrameData[14] VGND VPWR Tile_X0Y9_FrameStrobe[7] latch
X_4455_ _4455_/X _4418_/X _0157_/X _4417_/X _0143_/X _2229_/Q _2228_/Q VPWR VGND sg13cmos5l_mux4_1
XFILLER_710_241 VPWR VGND sg13cmos5l_decap_8
XFILLER_171_272 VPWR VGND sg13cmos5l_fill_1
XFILLER_116_188 VPWR VGND sg13cmos5l_fill_1
XFILLER_667_156 VPWR VGND sg13cmos5l_decap_8
X_0618_ _0618_/Q Tile_X0Y8_FrameData[21] VGND VPWR Tile_X0Y9_FrameStrobe[6] latch
X_3406_ Tile_X0Y2_E1BEG[1] _4037_/X VPWR VGND sg13cmos5l_buf_1
X_4386_ _4386_/X Tile_X0Y5_W2END[1] AXI_M_SOC_RLAST _4430_/X _4429_/X _2331_/Q _2330_/Q
+ VPWR VGND sg13cmos5l_mux4_1
XFILLER_320_236 VPWR VGND sg13cmos5l_decap_8
XFILLER_131_147 VPWR VGND sg13cmos5l_decap_8
X_1598_ _1598_/Q Tile_X0Y2_FrameData[19] VGND VPWR Tile_X0Y9_FrameStrobe[5] latch
XFILLER_466_229 VPWR VGND sg13cmos5l_decap_8
XFILLER_682_126 VPWR VGND sg13cmos5l_decap_8
X_3337_ Tile_X0Y2_FrameData_O[8] Tile_X0Y2_FrameData[8] VPWR VGND sg13cmos5l_buf_1
XFILLER_105_14 VPWR VGND sg13cmos5l_decap_8
X_0549_ _0549_/Q Tile_X0Y8_FrameData[26] VGND VPWR Tile_X0Y9_FrameStrobe[4] latch
XFILLER_285_140 VPWR VGND sg13cmos5l_decap_8
XFILLER_608_256 VPWR VGND sg13cmos5l_decap_8
XFILLER_252_42 VPWR VGND sg13cmos5l_decap_8
XFILLER_419_167 VPWR VGND sg13cmos5l_fill_1
X_3268_ Tile_X0Y0_EE4BEG[4] _3824_/X VPWR VGND sg13cmos5l_buf_1
XFILLER_434_115 VPWR VGND sg13cmos5l_decap_8
XFILLER_419_189 VPWR VGND sg13cmos5l_decap_8
XANTENNA__2755__X Tile_X0Y3_FrameData_O[13] VPWR VGND sg13cmos5l_antennanp
X_2219_ _2219_/Q Tile_X0Y5_FrameData[26] VGND VPWR Tile_X0Y9_FrameStrobe[1] latch
XFILLER_38_150 VPWR VGND sg13cmos5l_decap_8
X_3199_ Tile_X0Y0_N2BEGb[7] _3903_/X VPWR VGND sg13cmos5l_buf_1
XANTENNA_108 _0157_/X VPWR VGND sg13cmos5l_antennanp
XFILLER_402_56 VPWR VGND sg13cmos5l_decap_8
XANTENNA_119 Tile_X0Y6_FrameData[30] VPWR VGND sg13cmos5l_antennanp
XFILLER_121_35 VPWR VGND sg13cmos5l_decap_8
XFILLER_164_8 VPWR VGND sg13cmos5l_decap_8
XFILLER_198_103 VPWR VGND sg13cmos5l_decap_8
XFILLER_198_125 VPWR VGND sg13cmos5l_decap_8
XFILLER_53_175 VPWR VGND sg13cmos5l_decap_8
XFILLER_157_7 VPWR VGND sg13cmos5l_decap_8
XFILLER_588_196 VPWR VGND sg13cmos5l_decap_4
XFILLER_478_49 VPWR VGND sg13cmos5l_decap_8
XFILLER_198_169 VPWR VGND sg13cmos5l_fill_2
XFILLER_529_230 VPWR VGND sg13cmos5l_decap_8
XFILLER_197_28 VPWR VGND sg13cmos5l_decap_8
XANTENNA__3586__X Tile_X0Y9_FrameData_O[16] VPWR VGND sg13cmos5l_antennanp
XFILLER_139_203 VPWR VGND sg13cmos5l_decap_8
XFILLER_529_263 VPWR VGND sg13cmos5l_fill_2
XFILLER_139_236 VPWR VGND sg13cmos5l_fill_2
XFILLER_14_77 VPWR VGND sg13cmos5l_decap_8
XFILLER_355_133 VPWR VGND sg13cmos5l_decap_8
XFILLER_708_63 VPWR VGND sg13cmos5l_decap_8
XFILLER_154_217 VPWR VGND sg13cmos5l_decap_8
XFILLER_370_103 VPWR VGND sg13cmos5l_fill_2
XFILLER_504_119 VPWR VGND sg13cmos5l_decap_8
XFILLER_427_42 VPWR VGND sg13cmos5l_decap_8
XFILLER_30_21 VPWR VGND sg13cmos5l_decap_4
XFILLER_574_70 VPWR VGND sg13cmos5l_decap_8
XFILLER_146_21 VPWR VGND sg13cmos5l_decap_8
XFILLER_30_54 VPWR VGND sg13cmos5l_decap_8
XFILLER_162_261 VPWR VGND sg13cmos5l_fill_1
XFILLER_693_7 VPWR VGND sg13cmos5l_decap_8
XFILLER_512_141 VPWR VGND sg13cmos5l_decap_8
XFILLER_162_272 VPWR VGND sg13cmos5l_fill_1
XFILLER_658_145 VPWR VGND sg13cmos5l_decap_4
XFILLER_122_125 VPWR VGND sg13cmos5l_decap_8
XFILLER_146_98 VPWR VGND sg13cmos5l_fill_2
XFILLER_457_229 VPWR VGND sg13cmos5l_decap_8
XFILLER_660_28 VPWR VGND sg13cmos5l_decap_8
XFILLER_311_269 VPWR VGND sg13cmos5l_decap_4
XFILLER_443_63 VPWR VGND sg13cmos5l_decap_8
XFILLER_590_91 VPWR VGND sg13cmos5l_fill_2
XFILLER_162_42 VPWR VGND sg13cmos5l_decap_8
XFILLER_76_245 VPWR VGND sg13cmos5l_fill_2
XFILLER_39_85 VPWR VGND sg13cmos5l_fill_1
XFILLER_276_173 VPWR VGND sg13cmos5l_decap_8
XFILLER_614_204 VPWR VGND sg13cmos5l_decap_4
XFILLER_183_0 VPWR VGND sg13cmos5l_decap_8
XFILLER_425_126 VPWR VGND sg13cmos5l_decap_8
XFILLER_440_118 VPWR VGND sg13cmos5l_fill_1
XFILLER_350_0 VPWR VGND sg13cmos5l_decap_8
XFILLER_232_210 VPWR VGND sg13cmos5l_decap_8
XFILLER_433_181 VPWR VGND sg13cmos5l_decap_8
XFILLER_594_100 VPWR VGND sg13cmos5l_decap_8
XFILLER_448_0 VPWR VGND sg13cmos5l_decap_8
XFILLER_44_186 VPWR VGND sg13cmos5l_fill_2
XFILLER_378_247 VPWR VGND sg13cmos5l_decap_8
XFILLER_685_14 VPWR VGND sg13cmos5l_decap_8
XFILLER_685_25 VPWR VGND sg13cmos5l_fill_2
XFILLER_594_166 VPWR VGND sg13cmos5l_decap_8
XANTENNA__3496__X Tile_X0Y1_E6BEG[6] VPWR VGND sg13cmos5l_antennanp
XFILLER_615_0 VPWR VGND sg13cmos5l_decap_8
XFILLER_468_93 VPWR VGND sg13cmos5l_decap_8
XFILLER_187_50 VPWR VGND sg13cmos5l_fill_1
XFILLER_200_151 VPWR VGND sg13cmos5l_decap_8
XFILLER_72_7 VPWR VGND sg13cmos5l_decap_8
XFILLER_618_63 VPWR VGND sg13cmos5l_decap_8
XFILLER_337_42 VPWR VGND sg13cmos5l_decap_4
X_2570_ _2570_/Q Tile_X0Y6_FrameData[29] VGND VPWR Tile_X0Y9_FrameStrobe[4] latch
XFILLER_550_247 VPWR VGND sg13cmos5l_decap_8
XFILLER_484_70 VPWR VGND sg13cmos5l_decap_8
XFILLER_299_221 VPWR VGND sg13cmos5l_decap_8
X_1521_ _1521_/Q Tile_X0Y2_FrameData[0] VGND VPWR Tile_X0Y9_FrameStrobe[2] latch
XFILLER_649_112 VPWR VGND sg13cmos5l_decap_8
XFILLER_153_261 VPWR VGND sg13cmos5l_fill_1
XFILLER_550_269 VPWR VGND sg13cmos5l_decap_4
XFILLER_153_272 VPWR VGND sg13cmos5l_fill_1
XFILLER_4_260 VPWR VGND sg13cmos5l_fill_1
XFILLER_4_271 VPWR VGND sg13cmos5l_fill_2
XFILLER_302_214 VPWR VGND sg13cmos5l_fill_2
X_4240_ _4240_/X Tile_X0Y2_W2MID[5] Tile_X0Y2_W2END[5] Tile_X0Y2_W6END[10] _4101_/X
+ _1625_/Q _1624_/Q VPWR VGND sg13cmos5l_mux4_1
X_1452_ _1452_/Q Tile_X0Y2_FrameData[5] VGND VPWR Tile_X0Y9_FrameStrobe[0] latch
XFILLER_259_118 VPWR VGND sg13cmos5l_decap_8
XFILLER_649_178 VPWR VGND sg13cmos5l_decap_8
XFILLER_634_84 VPWR VGND sg13cmos5l_decap_8
XFILLER_206_35 VPWR VGND sg13cmos5l_decap_8
X_0403_ _0403_/Q Tile_X0Y7_FrameData[12] VGND VPWR Tile_X0Y9_FrameStrobe[7] latch
X_4171_ _4171_/X Tile_X0Y3_WW4END[8] AXI_M_SOC_BVALID _4230_/X _4205_/X _1799_/Q _1798_/Q
+ VPWR VGND sg13cmos5l_mux4_1
XFILLER_570_28 VPWR VGND sg13cmos5l_decap_8
XFILLER_353_63 VPWR VGND sg13cmos5l_decap_8
X_1383_ _1383_/Q Tile_X0Y1_FrameData[18] VGND VPWR Tile_X0Y9_FrameStrobe[6] latch
X_3122_ Tile_X0Y7_EE4BEG[8] _4636_/X VPWR VGND sg13cmos5l_buf_1
X_0334_ _0334_/Q Tile_X0Y7_FrameData[17] VGND VPWR Tile_X0Y9_FrameStrobe[5] latch
XFILLER_121_191 VPWR VGND sg13cmos5l_fill_2
XFILLER_67_245 VPWR VGND sg13cmos5l_decap_4
XFILLER_605_215 VPWR VGND sg13cmos5l_fill_1
XFILLER_27_109 VPWR VGND sg13cmos5l_fill_2
XFILLER_82_204 VPWR VGND sg13cmos5l_fill_2
X_3053_ Tile_X0Y5_FrameData_O[12] Tile_X0Y5_FrameData[12] VPWR VGND sg13cmos5l_buf_1
XFILLER_605_237 VPWR VGND sg13cmos5l_decap_8
XFILLER_503_77 VPWR VGND sg13cmos5l_decap_8
XFILLER_416_148 VPWR VGND sg13cmos5l_decap_8
X_0265_ _0265_/Q Tile_X0Y7_FrameData[22] VGND VPWR Tile_X0Y9_FrameStrobe[3] latch
XFILLER_471_243 VPWR VGND sg13cmos5l_decap_8
XFILLER_282_154 VPWR VGND sg13cmos5l_decap_8
XFILLER_208_251 VPWR VGND sg13cmos5l_decap_4
XFILLER_222_56 VPWR VGND sg13cmos5l_decap_8
X_2004_ _2004_/Q Tile_X0Y4_FrameData[17] VGND VPWR Tile_X0Y9_FrameStrobe[2] latch
X_0196_ _0196_/Q Tile_X0Y7_FrameData[27] VGND VPWR Tile_X0Y9_FrameStrobe[1] latch
XFILLER_223_232 VPWR VGND sg13cmos5l_decap_4
XFILLER_369_225 VPWR VGND sg13cmos5l_fill_1
XFILLER_369_247 VPWR VGND sg13cmos5l_fill_2
XFILLER_298_49 VPWR VGND sg13cmos5l_decap_8
XFILLER_369_258 VPWR VGND sg13cmos5l_fill_1
XFILLER_50_134 VPWR VGND sg13cmos5l_decap_8
XFILLER_195_106 VPWR VGND sg13cmos5l_fill_2
XFILLER_595_14 VPWR VGND sg13cmos5l_decap_8
X_3955_ _3955_/X Tile_X0Y1_WW4END[8] AXI_M_SOC_ARREADY _4016_/X _3989_/X _1299_/Q
+ _1298_/Q VPWR VGND sg13cmos5l_mux4_1
XFILLER_195_139 VPWR VGND sg13cmos5l_fill_1
XFILLER_585_188 VPWR VGND sg13cmos5l_decap_8
XFILLER_378_82 VPWR VGND sg13cmos5l_decap_8
X_2906_ Tile_X0Y6_FrameData_O[27] Tile_X0Y6_FrameData[27] VPWR VGND sg13cmos5l_buf_1
XFILLER_378_93 VPWR VGND sg13cmos5l_fill_1
X_3886_ _3886_/X _3849_/X _0086_/X Tile_X0Y0_S1END[1] Tile_X0Y0_S4END[1] _0985_/Q
+ _0984_/Q VPWR VGND sg13cmos5l_mux4_1
XFILLER_526_244 VPWR VGND sg13cmos5l_decap_8
X_2837_ Tile_X0Y6_E2BEG[2] _4498_/X VPWR VGND sg13cmos5l_buf_1
XFILLER_528_63 VPWR VGND sg13cmos5l_decap_8
XFILLER_136_228 VPWR VGND sg13cmos5l_decap_8
XFILLER_528_85 VPWR VGND sg13cmos5l_decap_8
XFILLER_247_42 VPWR VGND sg13cmos5l_decap_8
XFILLER_687_218 VPWR VGND sg13cmos5l_decap_8
X_2768_ Tile_X0Y3_FrameData_O[26] Tile_X0Y3_FrameData[26] VPWR VGND sg13cmos5l_buf_1
XFILLER_352_147 VPWR VGND sg13cmos5l_decap_8
X_4507_ _4507_/X Tile_X0Y6_W2END[4] AXI_M_SOC_RDATA28 _4559_/X _4558_/X _2593_/Q _2592_/Q
+ VPWR VGND sg13cmos5l_mux4_1
X_1719_ _1719_/Q Tile_X0Y3_FrameData[18] VGND VPWR Tile_X0Y9_FrameStrobe[1] latch
XFILLER_144_272 VPWR VGND sg13cmos5l_fill_1
X_2699_ _4085_/A3 VPWR VGND sg13cmos5l_tielo
X_4438_ _4438_/X _4920_/X _4924_/X _4928_/X _4901_/X _0903_/Q _0902_/Q VPWR VGND sg13cmos5l_mux4_1
XFILLER_116_35 VPWR VGND sg13cmos5l_decap_8
XFILLER_655_126 VPWR VGND sg13cmos5l_decap_4
XFILLER_480_28 VPWR VGND sg13cmos5l_decap_8
XFILLER_263_74 VPWR VGND sg13cmos5l_decap_8
XFILLER_76_28 VPWR VGND sg13cmos5l_decap_8
X_4369_ _4369_/X _4421_/X _4420_/X AXI_M_SOC_RRESP0 _4419_/X _2365_/Q _2364_/Q VPWR
+ VGND sg13cmos5l_mux4_1
XFILLER_407_104 VPWR VGND sg13cmos5l_decap_8
XFILLER_670_129 VPWR VGND sg13cmos5l_fill_2
XFILLER_258_184 VPWR VGND sg13cmos5l_decap_8
XFILLER_663_181 VPWR VGND sg13cmos5l_fill_1
XFILLER_413_77 VPWR VGND sg13cmos5l_decap_8
XFILLER_274_7 VPWR VGND sg13cmos5l_decap_8
XFILLER_132_56 VPWR VGND sg13cmos5l_decap_8
XFILLER_710_42 VPWR VGND sg13cmos5l_decap_8
XFILLER_462_265 VPWR VGND sg13cmos5l_decap_8
XFILLER_26_142 VPWR VGND sg13cmos5l_decap_8
XFILLER_92_49 VPWR VGND sg13cmos5l_decap_8
XFILLER_415_192 VPWR VGND sg13cmos5l_decap_8
XFILLER_25_21 VPWR VGND sg13cmos5l_decap_8
XFILLER_441_7 VPWR VGND sg13cmos5l_decap_8
XFILLER_539_7 VPWR VGND sg13cmos5l_decap_8
XFILLER_430_140 VPWR VGND sg13cmos5l_decap_8
XFILLER_25_43 VPWR VGND sg13cmos5l_decap_4
XFILLER_569_70 VPWR VGND sg13cmos5l_decap_8
XFILLER_375_206 VPWR VGND sg13cmos5l_fill_2
XFILLER_288_71 VPWR VGND sg13cmos5l_decap_8
XFILLER_41_189 VPWR VGND sg13cmos5l_decap_8
XFILLER_706_7 VPWR VGND sg13cmos5l_decap_8
XFILLER_591_147 VPWR VGND sg13cmos5l_decap_8
XFILLER_591_158 VPWR VGND sg13cmos5l_decap_8
XFILLER_655_28 VPWR VGND sg13cmos5l_decap_8
XFILLER_438_63 VPWR VGND sg13cmos5l_decap_8
XFILLER_383_261 VPWR VGND sg13cmos5l_fill_1
XFILLER_655_39 VPWR VGND sg13cmos5l_fill_1
XFILLER_532_203 VPWR VGND sg13cmos5l_decap_8
XFILLER_383_272 VPWR VGND sg13cmos5l_fill_1
XFILLER_585_91 VPWR VGND sg13cmos5l_decap_4
XFILLER_41_75 VPWR VGND sg13cmos5l_decap_8
XFILLER_41_86 VPWR VGND sg13cmos5l_fill_2
XFILLER_328_199 VPWR VGND sg13cmos5l_decap_8
XFILLER_374_29 VPWR VGND sg13cmos5l_decap_8
XFILLER_686_240 VPWR VGND sg13cmos5l_decap_4
XFILLER_497_140 VPWR VGND sg13cmos5l_decap_8
XFILLER_9_0 VPWR VGND sg13cmos5l_decap_8
XFILLER_671_49 VPWR VGND sg13cmos5l_fill_2
XFILLER_500_133 VPWR VGND sg13cmos5l_decap_8
XFILLER_646_126 VPWR VGND sg13cmos5l_decap_8
XFILLER_604_21 VPWR VGND sg13cmos5l_decap_8
XFILLER_398_0 VPWR VGND sg13cmos5l_decap_8
XFILLER_390_28 VPWR VGND sg13cmos5l_decap_8
XFILLER_296_257 VPWR VGND sg13cmos5l_fill_1
XFILLER_49_201 VPWR VGND sg13cmos5l_decap_8
XFILLER_173_85 VPWR VGND sg13cmos5l_fill_1
XFILLER_2_14 VPWR VGND sg13cmos5l_decap_8
XFILLER_323_22 VPWR VGND sg13cmos5l_decap_8
XFILLER_453_210 VPWR VGND sg13cmos5l_decap_8
XFILLER_654_170 VPWR VGND sg13cmos5l_decap_8
XFILLER_565_0 VPWR VGND sg13cmos5l_decap_8
XFILLER_323_66 VPWR VGND sg13cmos5l_decap_8
XFILLER_620_42 VPWR VGND sg13cmos5l_decap_8
XFILLER_264_176 VPWR VGND sg13cmos5l_decap_8
X_0050_ AXI_M_SOC_AWLOCK _0937_/Q _3684_/X VPWR VGND sg13cmos5l_nor2b_1
XFILLER_205_210 VPWR VGND sg13cmos5l_decap_8
XFILLER_696_35 VPWR VGND sg13cmos5l_decap_8
XFILLER_421_140 VPWR VGND sg13cmos5l_decap_8
XFILLER_17_197 VPWR VGND sg13cmos5l_decap_8
XFILLER_567_133 VPWR VGND sg13cmos5l_decap_8
XFILLER_82_82 VPWR VGND sg13cmos5l_decap_8
XFILLER_32_145 VPWR VGND sg13cmos5l_decap_8
XFILLER_177_117 VPWR VGND sg13cmos5l_decap_8
XFILLER_198_60 VPWR VGND sg13cmos5l_fill_1
XANTENNA_19 AXI_M_SOC_RDATA26 VPWR VGND sg13cmos5l_antennanp
XFILLER_198_82 VPWR VGND sg13cmos5l_decap_8
X_0952_ _0952_/Q Tile_X0Y0_FrameData[19] VGND VPWR Tile_X0Y9_FrameStrobe[0] latch
X_3740_ AXI_M_SOC_ARADDR12 Tile_X0Y9_W1END[0] Tile_X0Y9_WW4END[4] Tile_X0Y9_WW4END[12]
+ _4928_/X _0735_/Q _0734_/Q VPWR VGND sg13cmos5l_mux4_1
XFILLER_508_211 VPWR VGND sg13cmos5l_decap_8
XFILLER_629_84 VPWR VGND sg13cmos5l_decap_8
XFILLER_508_233 VPWR VGND sg13cmos5l_fill_1
XFILLER_565_28 VPWR VGND sg13cmos5l_decap_8
XFILLER_348_63 VPWR VGND sg13cmos5l_decap_8
X_0883_ _0883_/Q Tile_X0Y9_FrameData[12] VGND VPWR Tile_X0Y9_FrameStrobe[6] latch
X_3671_ _3671_/X Tile_X0Y2_WW4END[1] Tile_X0Y2_WW4END[9] Tile_X0Y2_W6END[1] _4117_/X
+ _1503_/Q _1502_/Q VPWR VGND sg13cmos5l_mux4_1
XFILLER_70_4 VPWR VGND sg13cmos5l_fill_1
XFILLER_523_214 VPWR VGND sg13cmos5l_decap_8
XFILLER_495_91 VPWR VGND sg13cmos5l_decap_8
X_2622_ _2622_/Q Tile_X0Y6_FrameData[9] VGND VPWR Tile_X0Y9_FrameStrobe[5] latch
XFILLER_669_218 VPWR VGND sg13cmos5l_decap_8
XFILLER_523_269 VPWR VGND sg13cmos5l_decap_4
XFILLER_334_169 VPWR VGND sg13cmos5l_decap_8
X_2553_ _2553_/Q Tile_X0Y6_FrameData[14] VGND VPWR Tile_X0Y9_FrameStrobe[3] latch
X_1504_ _1504_/Q Tile_X0Y2_FrameData[17] VGND VPWR Tile_X0Y9_FrameStrobe[2] latch
XFILLER_677_251 VPWR VGND sg13cmos5l_decap_8
X_2484_ _2484_/Q Tile_X0Y6_FrameData[19] VGND VPWR Tile_X0Y9_FrameStrobe[1] latch
XFILLER_581_49 VPWR VGND sg13cmos5l_decap_8
XFILLER_488_173 VPWR VGND sg13cmos5l_decap_8
XFILLER_364_84 VPWR VGND sg13cmos5l_decap_8
XFILLER_287_224 VPWR VGND sg13cmos5l_decap_8
XFILLER_514_21 VPWR VGND sg13cmos5l_decap_8
XFILLER_488_195 VPWR VGND sg13cmos5l_decap_4
XFILLER_364_95 VPWR VGND sg13cmos5l_fill_2
X_1435_ _1435_/Q Tile_X0Y2_FrameData[22] VGND VPWR Tile_X0Y9_FrameStrobe[0] latch
X_4223_ _4223_/X _4197_/X _0088_/X _4196_/X Tile_X0Y0_S4END[13] _1727_/Q _1726_/Q
+ VPWR VGND sg13cmos5l_mux4_1
XFILLER_101_128 VPWR VGND sg13cmos5l_decap_8
XFILLER_637_159 VPWR VGND sg13cmos5l_decap_8
XFILLER_692_265 VPWR VGND sg13cmos5l_decap_8
X_4154_ _4154_/X Tile_X0Y3_W2MID[1] AXI_M_SOC_WREADY _4207_/X _4206_/X _1833_/Q _1832_/Q
+ VPWR VGND sg13cmos5l_mux4_1
X_1366_ _1366_/Q Tile_X0Y1_FrameData[3] VGND VPWR Tile_X0Y9_FrameStrobe[5] latch
XFILLER_514_98 VPWR VGND sg13cmos5l_decap_8
X_3105_ Tile_X0Y7_E6BEG[3] _4647_/X VPWR VGND sg13cmos5l_buf_1
X_0317_ _0317_/Q Tile_X0Y7_FrameData[2] VGND VPWR Tile_X0Y9_FrameStrobe[4] latch
XFILLER_444_232 VPWR VGND sg13cmos5l_fill_2
X_4085_ _4085_/X _4091_/X Tile_X0Y2_W6END[1] _4090_/X _4085_/A3 _1431_/Q _1430_/Q
+ VPWR VGND sg13cmos5l_mux4_1
X_1297_ _1297_/Q Tile_X0Y1_FrameData[8] VGND VPWR Tile_X0Y9_FrameStrobe[3] latch
XFILLER_530_42 VPWR VGND sg13cmos5l_decap_8
X_3036_ Tile_X0Y5_EE4BEG[11] _4399_/X VPWR VGND sg13cmos5l_buf_1
XFILLER_255_187 VPWR VGND sg13cmos5l_decap_8
X_0248_ _0248_/Q Tile_X0Y7_FrameData[7] VGND VPWR Tile_X0Y9_FrameStrobe[2] latch
XFILLER_660_173 VPWR VGND sg13cmos5l_decap_8
X_0179_ _0179_/Q Tile_X0Y7_FrameData[12] VGND VPWR Tile_X0Y9_FrameStrobe[0] latch
XFILLER_558_133 VPWR VGND sg13cmos5l_fill_1
XFILLER_389_70 VPWR VGND sg13cmos5l_decap_8
XFILLER_601_251 VPWR VGND sg13cmos5l_decap_8
XFILLER_23_123 VPWR VGND sg13cmos5l_decap_8
XFILLER_601_262 VPWR VGND sg13cmos5l_fill_1
XFILLER_412_162 VPWR VGND sg13cmos5l_fill_1
XFILLER_168_106 VPWR VGND sg13cmos5l_decap_4
XFILLER_357_217 VPWR VGND sg13cmos5l_decap_8
XFILLER_23_167 VPWR VGND sg13cmos5l_decap_8
XFILLER_707_119 VPWR VGND sg13cmos5l_decap_4
X_3938_ _3938_/X Tile_X0Y1_W2MID[1] AXI_M_SOC_ARREADY _3991_/X _3990_/X _1333_/Q _1332_/Q
+ VPWR VGND sg13cmos5l_mux4_1
XFILLER_573_147 VPWR VGND sg13cmos5l_decap_8
XFILLER_176_150 VPWR VGND sg13cmos5l_decap_8
XFILLER_475_28 VPWR VGND sg13cmos5l_decap_8
XFILLER_258_63 VPWR VGND sg13cmos5l_decap_8
X_3869_ _3869_/X Tile_X0Y4_W1END[1] Tile_X0Y4_WW4END[1] Tile_X0Y4_W6END[9] _4337_/X
+ _2154_/Q _2153_/Q VPWR VGND sg13cmos5l_mux4_1
XFILLER_715_196 VPWR VGND sg13cmos5l_decap_8
XFILLER_514_247 VPWR VGND sg13cmos5l_decap_8
XFILLER_191_153 VPWR VGND sg13cmos5l_decap_8
XFILLER_11_56 VPWR VGND sg13cmos5l_decap_8
XFILLER_555_72 VPWR VGND sg13cmos5l_decap_8
XFILLER_514_269 VPWR VGND sg13cmos5l_decap_4
XFILLER_408_77 VPWR VGND sg13cmos5l_decap_8
XFILLER_555_83 VPWR VGND sg13cmos5l_fill_1
XFILLER_117_272 VPWR VGND sg13cmos5l_fill_1
XFILLER_127_56 VPWR VGND sg13cmos5l_decap_8
XFILLER_705_42 VPWR VGND sg13cmos5l_decap_8
XFILLER_491_49 VPWR VGND sg13cmos5l_decap_8
XFILLER_2_7 VPWR VGND sg13cmos5l_decap_8
XFILLER_278_224 VPWR VGND sg13cmos5l_decap_8
XFILLER_132_242 VPWR VGND sg13cmos5l_decap_8
XFILLER_479_184 VPWR VGND sg13cmos5l_decap_8
XFILLER_274_84 VPWR VGND sg13cmos5l_decap_8
XFILLER_424_21 VPWR VGND sg13cmos5l_decap_8
XFILLER_274_95 VPWR VGND sg13cmos5l_fill_2
XFILLER_391_7 VPWR VGND sg13cmos5l_decap_8
XFILLER_494_154 VPWR VGND sg13cmos5l_decap_8
XFILLER_489_7 VPWR VGND sg13cmos5l_decap_8
XFILLER_683_265 VPWR VGND sg13cmos5l_decap_8
XFILLER_293_238 VPWR VGND sg13cmos5l_decap_8
XFILLER_424_98 VPWR VGND sg13cmos5l_decap_8
XFILLER_290_50 VPWR VGND sg13cmos5l_decap_8
XFILLER_435_221 VPWR VGND sg13cmos5l_fill_2
XFILLER_143_77 VPWR VGND sg13cmos5l_decap_8
XFILLER_656_7 VPWR VGND sg13cmos5l_decap_8
XANTENNA__3104__X Tile_X0Y7_E6BEG[2] VPWR VGND sg13cmos5l_antennanp
XFILLER_651_140 VPWR VGND sg13cmos5l_decap_8
XFILLER_246_165 VPWR VGND sg13cmos5l_decap_8
XFILLER_440_42 VPWR VGND sg13cmos5l_decap_8
XFILLER_450_213 VPWR VGND sg13cmos5l_decap_8
XFILLER_261_124 VPWR VGND sg13cmos5l_decap_8
XFILLER_199_220 VPWR VGND sg13cmos5l_decap_8
XFILLER_61_218 VPWR VGND sg13cmos5l_decap_8
XANTENNA__2943__X Tile_X0Y8_E6BEG[11] VPWR VGND sg13cmos5l_antennanp
XFILLER_36_86 VPWR VGND sg13cmos5l_decap_8
XFILLER_14_112 VPWR VGND sg13cmos5l_fill_2
XFILLER_299_70 VPWR VGND sg13cmos5l_decap_4
XFILLER_403_151 VPWR VGND sg13cmos5l_decap_8
XFILLER_549_155 VPWR VGND sg13cmos5l_decap_8
XFILLER_348_206 VPWR VGND sg13cmos5l_decap_8
XFILLER_146_0 VPWR VGND sg13cmos5l_decap_8
XFILLER_14_189 VPWR VGND sg13cmos5l_decap_8
XFILLER_549_199 VPWR VGND sg13cmos5l_fill_1
XFILLER_666_49 VPWR VGND sg13cmos5l_decap_8
XFILLER_449_84 VPWR VGND sg13cmos5l_decap_8
XFILLER_174_109 VPWR VGND sg13cmos5l_decap_4
XFILLER_385_28 VPWR VGND sg13cmos5l_fill_2
XFILLER_167_161 VPWR VGND sg13cmos5l_decap_8
XFILLER_356_272 VPWR VGND sg13cmos5l_fill_1
XFILLER_316_103 VPWR VGND sg13cmos5l_decap_8
XFILLER_168_85 VPWR VGND sg13cmos5l_decap_8
XFILLER_313_0 VPWR VGND sg13cmos5l_decap_8
XFILLER_167_194 VPWR VGND sg13cmos5l_decap_8
XFILLER_318_22 VPWR VGND sg13cmos5l_decap_8
XFILLER_371_231 VPWR VGND sg13cmos5l_decap_8
XFILLER_316_158 VPWR VGND sg13cmos5l_decap_4
XFILLER_115_209 VPWR VGND sg13cmos5l_decap_8
XFILLER_182_164 VPWR VGND sg13cmos5l_decap_4
XFILLER_108_261 VPWR VGND sg13cmos5l_fill_1
XFILLER_331_106 VPWR VGND sg13cmos5l_fill_2
XFILLER_318_77 VPWR VGND sg13cmos5l_decap_8
XFILLER_520_228 VPWR VGND sg13cmos5l_decap_8
XFILLER_269_202 VPWR VGND sg13cmos5l_decap_8
XFILLER_615_42 VPWR VGND sg13cmos5l_decap_8
XFILLER_334_21 VPWR VGND sg13cmos5l_decap_8
XFILLER_682_0 VPWR VGND sg13cmos5l_decap_8
XFILLER_485_121 VPWR VGND sg13cmos5l_decap_8
XFILLER_96_104 VPWR VGND sg13cmos5l_decap_4
XFILLER_35_7 VPWR VGND sg13cmos5l_decap_8
XFILLER_334_65 VPWR VGND sg13cmos5l_decap_8
XFILLER_96_137 VPWR VGND sg13cmos5l_decap_8
X_1220_ _1220_/Q Tile_X0Y1_FrameData[21] VGND VPWR Tile_X0Y9_FrameStrobe[1] latch
XFILLER_284_238 VPWR VGND sg13cmos5l_decap_8
XFILLER_237_110 VPWR VGND sg13cmos5l_fill_2
XFILLER_426_210 VPWR VGND sg13cmos5l_decap_8
X_1151_ _1151_/Q Tile_X0Y0_FrameData[12] VGND VPWR Tile_X0Y9_FrameStrobe[6] latch
XFILLER_631_63 VPWR VGND sg13cmos5l_decap_8
XFILLER_37_215 VPWR VGND sg13cmos5l_decap_8
XFILLER_203_14 VPWR VGND sg13cmos5l_decap_8
XANTENNA__3014__X Tile_X0Y5_E6BEG[1] VPWR VGND sg13cmos5l_antennanp
XFILLER_642_140 VPWR VGND sg13cmos5l_decap_8
X_0102_ AXI_M_SOC_ARLEN5 _0933_/Q _3765_/X VPWR VGND sg13cmos5l_nor2b_1
XFILLER_350_42 VPWR VGND sg13cmos5l_decap_8
XFILLER_252_102 VPWR VGND sg13cmos5l_decap_8
XFILLER_237_176 VPWR VGND sg13cmos5l_decap_4
X_1082_ _1082_/Q Tile_X0Y0_FrameData[17] VGND VPWR Tile_X0Y9_FrameStrobe[4] latch
XFILLER_587_206 VPWR VGND sg13cmos5l_decap_8
XANTENNA__2853__X Tile_X0Y6_E6BEG[2] VPWR VGND sg13cmos5l_antennanp
X_4910_ _4910_/X Tile_X0Y5_W1END[1] Tile_X0Y5_WW4END[13] Tile_X0Y5_W6END[5] _4452_/X
+ _2376_/Q _2375_/Q VPWR VGND sg13cmos5l_mux4_1
XFILLER_93_92 VPWR VGND sg13cmos5l_decap_8
XFILLER_500_56 VPWR VGND sg13cmos5l_decap_8
X_4841_ _4841_/X _4922_/X _4926_/X _4930_/X _4902_/X _0861_/Q _0860_/Q VPWR VGND sg13cmos5l_mux4_1
XFILLER_595_250 VPWR VGND sg13cmos5l_decap_8
XFILLER_339_217 VPWR VGND sg13cmos5l_fill_2
XFILLER_595_272 VPWR VGND sg13cmos5l_fill_1
XFILLER_20_126 VPWR VGND sg13cmos5l_fill_2
X_4772_ _4772_/X _4777_/X Tile_X0Y8_W6END[0] _4776_/X _4772_/A3 _0423_/Q _0422_/Q
+ VPWR VGND sg13cmos5l_mux4_1
XFILLER_576_49 VPWR VGND sg13cmos5l_decap_8
X_1984_ _1984_/Q Tile_X0Y4_FrameData[5] VGND VPWR Tile_X0Y9_FrameStrobe[1] latch
XFILLER_555_147 VPWR VGND sg13cmos5l_decap_8
XFILLER_359_84 VPWR VGND sg13cmos5l_decap_8
XFILLER_509_21 VPWR VGND sg13cmos5l_decap_8
X_3723_ _3723_/X Tile_X0Y3_WW4END[0] Tile_X0Y3_WW4END[8] Tile_X0Y3_W6END[8] _4230_/X
+ _1741_/Q _1740_/Q VPWR VGND sg13cmos5l_mux4_1
X_0935_ _0935_/Q Tile_X0Y9_FrameData[26] VGND VPWR Tile_X0Y9_FrameStrobe[8] latch
XFILLER_347_261 VPWR VGND sg13cmos5l_fill_1
XFILLER_9_182 VPWR VGND sg13cmos5l_decap_4
XFILLER_173_142 VPWR VGND sg13cmos5l_decap_8
XFILLER_228_44 VPWR VGND sg13cmos5l_fill_1
X_0866_ _0866_/Q Tile_X0Y9_FrameData[29] VGND VPWR Tile_X0Y9_FrameStrobe[6] latch
X_3654_ AXI_M_SOC_AWADDR15 Tile_X0Y5_W1END[3] Tile_X0Y5_WW4END[7] Tile_X0Y5_WW4END[15]
+ _4466_/X _2241_/Q _2240_/Q VPWR VGND sg13cmos5l_mux4_1
XFILLER_61_0 VPWR VGND sg13cmos5l_fill_2
XFILLER_509_98 VPWR VGND sg13cmos5l_decap_8
XFILLER_712_133 VPWR VGND sg13cmos5l_decap_8
XFILLER_362_264 VPWR VGND sg13cmos5l_fill_1
XFILLER_307_169 VPWR VGND sg13cmos5l_decap_4
X_2605_ _2605_/Q Tile_X0Y6_FrameData[26] VGND VPWR Tile_X0Y9_FrameStrobe[5] latch
X_0797_ _0797_/Q Tile_X0Y9_FrameData[2] VGND VPWR Tile_X0Y9_FrameStrobe[3] latch
X_3585_ Tile_X0Y9_FrameData_O[15] Tile_X0Y9_FrameData[15] VPWR VGND sg13cmos5l_buf_1
XFILLER_114_220 VPWR VGND sg13cmos5l_decap_8
XFILLER_525_42 VPWR VGND sg13cmos5l_decap_8
X_2536_ _2536_/Q Tile_X0Y6_FrameData[31] VGND VPWR Tile_X0Y9_FrameStrobe[3] latch
XFILLER_244_21 VPWR VGND sg13cmos5l_decap_8
X_2467_ _2467_/Q Tile_X0Y6_FrameData[4] VGND VPWR Tile_X0Y9_FrameStrobe[0] latch
XFILLER_665_254 VPWR VGND sg13cmos5l_decap_8
XFILLER_391_60 VPWR VGND sg13cmos5l_fill_1
XFILLER_57_19 VPWR VGND sg13cmos5l_decap_8
XFILLER_330_183 VPWR VGND sg13cmos5l_fill_2
XFILLER_476_176 VPWR VGND sg13cmos5l_decap_4
X_4206_ _4206_/X _4141_/X _4249_/X _4248_/X _4140_/X _1685_/Q _1684_/Q VPWR VGND sg13cmos5l_mux4_1
XFILLER_275_227 VPWR VGND sg13cmos5l_fill_1
X_1418_ _1418_/Q Tile_X0Y1_FrameData[15] VGND VPWR Tile_X0Y9_FrameStrobe[7] latch
X_2398_ _2398_/Q Tile_X0Y5_FrameData[7] VGND VPWR Tile_X0Y9_FrameStrobe[6] latch
XFILLER_680_224 VPWR VGND sg13cmos5l_decap_8
XFILLER_113_14 VPWR VGND sg13cmos5l_decap_8
X_1349_ _1349_/Q Tile_X0Y1_FrameData[20] VGND VPWR Tile_X0Y9_FrameStrobe[5] latch
X_4137_ _4137_/X Tile_X0Y4_W2MID[3] Tile_X0Y4_W2END[3] Tile_X0Y4_W6END[3] _4318_/X
+ _2165_/Q _2164_/Q VPWR VGND sg13cmos5l_mux4_1
XFILLER_541_63 VPWR VGND sg13cmos5l_decap_8
XFILLER_417_243 VPWR VGND sg13cmos5l_decap_8
XFILLER_28_215 VPWR VGND sg13cmos5l_fill_2
XFILLER_491_168 VPWR VGND sg13cmos5l_decap_8
XFILLER_417_254 VPWR VGND sg13cmos5l_fill_2
XFILLER_633_140 VPWR VGND sg13cmos5l_decap_8
XFILLER_260_42 VPWR VGND sg13cmos5l_decap_8
XFILLER_228_187 VPWR VGND sg13cmos5l_decap_8
X_4068_ _4068_/X Tile_X0Y2_WW4END[3] AXI_M_SOC_AWREADY _4119_/X _4103_/X _1537_/Q
+ _1536_/Q VPWR VGND sg13cmos5l_mux4_1
XFILLER_432_224 VPWR VGND sg13cmos5l_decap_8
XFILLER_243_135 VPWR VGND sg13cmos5l_decap_4
XANTENNA__2763__X Tile_X0Y3_FrameData_O[21] VPWR VGND sg13cmos5l_antennanp
X_3019_ Tile_X0Y5_E6BEG[6] _4410_/X VPWR VGND sg13cmos5l_buf_1
XFILLER_432_257 VPWR VGND sg13cmos5l_decap_8
XFILLER_243_179 VPWR VGND sg13cmos5l_decap_8
XFILLER_410_56 VPWR VGND sg13cmos5l_decap_8
XFILLER_196_201 VPWR VGND sg13cmos5l_decap_8
XFILLER_586_272 VPWR VGND sg13cmos5l_fill_1
XFILLER_546_125 VPWR VGND sg13cmos5l_decap_8
XFILLER_196_256 VPWR VGND sg13cmos5l_fill_2
XFILLER_400_154 VPWR VGND sg13cmos5l_decap_8
XFILLER_237_7 VPWR VGND sg13cmos5l_decap_8
XFILLER_546_147 VPWR VGND sg13cmos5l_decap_4
XFILLER_486_49 VPWR VGND sg13cmos5l_decap_8
XFILLER_419_21 VPWR VGND sg13cmos5l_decap_8
XFILLER_269_95 VPWR VGND sg13cmos5l_decap_8
XFILLER_11_148 VPWR VGND sg13cmos5l_fill_2
XFILLER_7_119 VPWR VGND sg13cmos5l_decap_8
XANTENNA__3594__X Tile_X0Y9_FrameData_O[24] VPWR VGND sg13cmos5l_antennanp
XFILLER_404_7 VPWR VGND sg13cmos5l_decap_8
XFILLER_353_231 VPWR VGND sg13cmos5l_decap_8
XFILLER_22_77 VPWR VGND sg13cmos5l_decap_8
XFILLER_499_224 VPWR VGND sg13cmos5l_decap_8
XFILLER_419_98 VPWR VGND sg13cmos5l_fill_2
XFILLER_703_133 VPWR VGND sg13cmos5l_fill_2
XFILLER_138_77 VPWR VGND sg13cmos5l_decap_8
XFILLER_164_175 VPWR VGND sg13cmos5l_decap_8
XFILLER_502_217 VPWR VGND sg13cmos5l_decap_8
XFILLER_703_177 VPWR VGND sg13cmos5l_decap_4
XFILLER_703_188 VPWR VGND sg13cmos5l_decap_8
XFILLER_435_42 VPWR VGND sg13cmos5l_decap_8
XFILLER_582_70 VPWR VGND sg13cmos5l_decap_8
XFILLER_154_21 VPWR VGND sg13cmos5l_decap_8
XFILLER_467_121 VPWR VGND sg13cmos5l_decap_8
XFILLER_656_232 VPWR VGND sg13cmos5l_decap_8
XANTENNA__2938__X Tile_X0Y8_E6BEG[6] VPWR VGND sg13cmos5l_antennanp
XFILLER_321_161 VPWR VGND sg13cmos5l_decap_4
XFILLER_510_272 VPWR VGND sg13cmos5l_fill_1
XFILLER_321_172 VPWR VGND sg13cmos5l_decap_8
XFILLER_467_198 VPWR VGND sg13cmos5l_decap_8
XFILLER_408_210 VPWR VGND sg13cmos5l_decap_8
XFILLER_304_35 VPWR VGND sg13cmos5l_decap_8
XFILLER_451_63 VPWR VGND sg13cmos5l_decap_8
XFILLER_170_42 VPWR VGND sg13cmos5l_decap_8
XFILLER_219_176 VPWR VGND sg13cmos5l_decap_8
XFILLER_234_102 VPWR VGND sg13cmos5l_decap_4
XFILLER_274_271 VPWR VGND sg13cmos5l_fill_2
XFILLER_234_113 VPWR VGND sg13cmos5l_decap_8
XFILLER_569_217 VPWR VGND sg13cmos5l_decap_8
XFILLER_263_0 VPWR VGND sg13cmos5l_decap_8
XFILLER_423_246 VPWR VGND sg13cmos5l_decap_8
XFILLER_601_77 VPWR VGND sg13cmos5l_decap_8
XFILLER_103_91 VPWR VGND sg13cmos5l_decap_8
XFILLER_320_78 VPWR VGND sg13cmos5l_fill_1
XFILLER_187_212 VPWR VGND sg13cmos5l_decap_8
XFILLER_430_0 VPWR VGND sg13cmos5l_decap_8
XFILLER_63_84 VPWR VGND sg13cmos5l_decap_8
XFILLER_528_0 VPWR VGND sg13cmos5l_decap_8
XFILLER_396_49 VPWR VGND sg13cmos5l_decap_8
XFILLER_8_35 VPWR VGND sg13cmos5l_decap_8
XFILLER_693_14 VPWR VGND sg13cmos5l_decap_8
XFILLER_329_43 VPWR VGND sg13cmos5l_decap_8
XFILLER_329_261 VPWR VGND sg13cmos5l_decap_8
XFILLER_329_272 VPWR VGND sg13cmos5l_fill_1
XFILLER_552_117 VPWR VGND sg13cmos5l_decap_8
XFILLER_476_60 VPWR VGND sg13cmos5l_fill_2
X_0720_ _0720_/Q Tile_X0Y9_FrameData[15] VGND VPWR Tile_X0Y9_FrameStrobe[1] latch
XFILLER_476_82 VPWR VGND sg13cmos5l_fill_2
XFILLER_10_192 VPWR VGND sg13cmos5l_fill_2
X_0651_ _0651_/Q Tile_X0Y8_FrameData[20] VGND VPWR Tile_X0Y9_FrameStrobe[7] latch
XFILLER_626_63 VPWR VGND sg13cmos5l_decap_8
XFILLER_155_186 VPWR VGND sg13cmos5l_decap_8
XFILLER_560_161 VPWR VGND sg13cmos5l_fill_2
XANTENNA__3009__X Tile_X0Y5_E2BEGb[4] VPWR VGND sg13cmos5l_antennanp
XFILLER_6_196 VPWR VGND sg13cmos5l_decap_8
XFILLER_345_42 VPWR VGND sg13cmos5l_decap_8
X_3370_ Tile_X0Y2_EE4BEG[9] _4065_/X VPWR VGND sg13cmos5l_buf_1
X_0582_ _0582_/Q Tile_X0Y8_FrameData[25] VGND VPWR Tile_X0Y9_FrameStrobe[5] latch
XFILLER_647_210 VPWR VGND sg13cmos5l_decap_8
XFILLER_492_70 VPWR VGND sg13cmos5l_decap_8
XFILLER_170_178 VPWR VGND sg13cmos5l_decap_8
XFILLER_88_70 VPWR VGND sg13cmos5l_decap_4
XANTENNA__2848__X Tile_X0Y6_E2BEGb[5] VPWR VGND sg13cmos5l_antennanp
X_2321_ _2321_/Q Tile_X0Y5_FrameData[20] VGND VPWR Tile_X0Y9_FrameStrobe[4] latch
XFILLER_69_126 VPWR VGND sg13cmos5l_decap_8
XFILLER_458_154 VPWR VGND sg13cmos5l_fill_2
XFILLER_607_107 VPWR VGND sg13cmos5l_fill_1
X_2252_ _2252_/Q Tile_X0Y5_FrameData[25] VGND VPWR Tile_X0Y9_FrameStrobe[2] latch
XFILLER_607_118 VPWR VGND sg13cmos5l_decap_8
XFILLER_111_256 VPWR VGND sg13cmos5l_decap_8
XFILLER_257_238 VPWR VGND sg13cmos5l_decap_4
XFILLER_214_35 VPWR VGND sg13cmos5l_decap_8
XFILLER_642_84 VPWR VGND sg13cmos5l_decap_8
XFILLER_84_107 VPWR VGND sg13cmos5l_fill_1
X_1203_ _1203_/Q Tile_X0Y1_FrameData[6] VGND VPWR Tile_X0Y9_FrameStrobe[0] latch
XFILLER_473_146 VPWR VGND sg13cmos5l_decap_8
XFILLER_361_63 VPWR VGND sg13cmos5l_decap_8
X_2183_ _2183_/Q Tile_X0Y5_FrameData[30] VGND VPWR Tile_X0Y9_FrameStrobe[0] latch
X_1134_ _1134_/Q Tile_X0Y0_FrameData[29] VGND VPWR Tile_X0Y9_FrameStrobe[6] latch
XFILLER_280_241 VPWR VGND sg13cmos5l_decap_8
XFILLER_92_173 VPWR VGND sg13cmos5l_decap_8
XFILLER_511_77 VPWR VGND sg13cmos5l_decap_8
XFILLER_280_252 VPWR VGND sg13cmos5l_decap_8
XFILLER_25_229 VPWR VGND sg13cmos5l_decap_8
XFILLER_92_184 VPWR VGND sg13cmos5l_fill_2
X_1065_ _1065_/Q Tile_X0Y0_FrameData[2] VGND VPWR Tile_X0Y9_FrameStrobe[3] latch
XFILLER_280_263 VPWR VGND sg13cmos5l_fill_2
XFILLER_240_105 VPWR VGND sg13cmos5l_decap_4
XFILLER_630_165 VPWR VGND sg13cmos5l_fill_1
XFILLER_240_116 VPWR VGND sg13cmos5l_decap_8
XFILLER_178_201 VPWR VGND sg13cmos5l_decap_8
XFILLER_717_203 VPWR VGND sg13cmos5l_decap_8
XFILLER_568_272 VPWR VGND sg13cmos5l_fill_1
XFILLER_379_172 VPWR VGND sg13cmos5l_decap_8
XFILLER_233_190 VPWR VGND sg13cmos5l_decap_8
X_4824_ _4824_/X Tile_X0Y9_W1END[0] Tile_X0Y9_W6END[8] _4928_/X _4892_/X _0891_/Q
+ _0890_/Q VPWR VGND sg13cmos5l_mux4_1
XFILLER_394_131 VPWR VGND sg13cmos5l_decap_8
XFILLER_717_247 VPWR VGND sg13cmos5l_decap_8
XFILLER_667_70 VPWR VGND sg13cmos5l_decap_8
XFILLER_239_21 VPWR VGND sg13cmos5l_decap_8
XFILLER_193_226 VPWR VGND sg13cmos5l_decap_8
X_4755_ _4755_/X Tile_X0Y8_WW4END[4] AXI_M_SOC_RDATA12 _4804_/X _4790_/X _0537_/Q
+ _0536_/Q VPWR VGND sg13cmos5l_mux4_1
XFILLER_543_106 VPWR VGND sg13cmos5l_fill_2
X_1967_ _1967_/Q Tile_X0Y4_FrameData[22] VGND VPWR Tile_X0Y9_FrameStrobe[1] latch
X_3706_ AXI_M_SOC_WDATA16 Tile_X0Y6_WW4END[0] Tile_X0Y6_WW4END[8] Tile_X0Y6_W6END[0]
+ _4568_/X _2527_/Q _2526_/Q VPWR VGND sg13cmos5l_mux4_1
XFILLER_536_180 VPWR VGND sg13cmos5l_fill_2
X_0918_ _0918_/Q Tile_X0Y9_FrameData[9] VGND VPWR Tile_X0Y9_FrameStrobe[7] latch
X_4686_ _4686_/X _4665_/X Tile_X0Y9_N4END[10] _4664_/X _0054_/X _0211_/Q _0210_/Q
+ VPWR VGND sg13cmos5l_mux4_1
X_1898_ _1898_/Q Tile_X0Y3_FrameData[31] VGND VPWR Tile_X0Y9_FrameStrobe[7] latch
XFILLER_146_164 VPWR VGND sg13cmos5l_decap_8
XFILLER_697_132 VPWR VGND sg13cmos5l_decap_8
XFILLER_108_14 VPWR VGND sg13cmos5l_decap_8
X_3637_ Tile_X0Y9_S4BEG[15] _3637_/A VPWR VGND sg13cmos5l_buf_1
XFILLER_536_63 VPWR VGND sg13cmos5l_decap_8
X_0849_ _0849_/Q Tile_X0Y9_FrameData[14] VGND VPWR Tile_X0Y9_FrameStrobe[5] latch
XFILLER_697_154 VPWR VGND sg13cmos5l_decap_8
XFILLER_350_223 VPWR VGND sg13cmos5l_decap_8
XFILLER_536_96 VPWR VGND sg13cmos5l_decap_8
X_3568_ Tile_X0Y9_EE4BEG[14] _4878_/X VPWR VGND sg13cmos5l_buf_1
XFILLER_255_64 VPWR VGND sg13cmos5l_decap_8
XFILLER_638_232 VPWR VGND sg13cmos5l_decap_8
XANTENNA__2758__X Tile_X0Y3_FrameData_O[16] VPWR VGND sg13cmos5l_antennanp
XFILLER_102_212 VPWR VGND sg13cmos5l_decap_8
X_2519_ _2519_/Q Tile_X0Y6_FrameData[16] VGND VPWR Tile_X0Y9_FrameStrobe[2] latch
X_3499_ Tile_X0Y1_E6BEG[9] _3973_/X VPWR VGND sg13cmos5l_buf_1
XFILLER_405_56 VPWR VGND sg13cmos5l_decap_8
XFILLER_653_202 VPWR VGND sg13cmos5l_decap_8
XFILLER_449_187 VPWR VGND sg13cmos5l_decap_8
XFILLER_124_35 VPWR VGND sg13cmos5l_decap_8
XFILLER_702_21 VPWR VGND sg13cmos5l_decap_8
XFILLER_271_63 VPWR VGND sg13cmos5l_decap_8
XFILLER_653_257 VPWR VGND sg13cmos5l_fill_1
XFILLER_263_208 VPWR VGND sg13cmos5l_decap_8
XFILLER_187_7 VPWR VGND sg13cmos5l_decap_8
XFILLER_271_74 VPWR VGND sg13cmos5l_fill_2
XFILLER_84_28 VPWR VGND sg13cmos5l_decap_8
XFILLER_256_260 VPWR VGND sg13cmos5l_decap_8
XFILLER_606_151 VPWR VGND sg13cmos5l_fill_1
XFILLER_405_202 VPWR VGND sg13cmos5l_decap_4
XFILLER_256_271 VPWR VGND sg13cmos5l_fill_2
XFILLER_702_98 VPWR VGND sg13cmos5l_fill_2
XANTENNA__3589__X Tile_X0Y9_FrameData_O[19] VPWR VGND sg13cmos5l_antennanp
XFILLER_216_146 VPWR VGND sg13cmos5l_decap_8
XFILLER_606_195 VPWR VGND sg13cmos5l_fill_1
XFILLER_421_77 VPWR VGND sg13cmos5l_decap_8
XFILLER_621_143 VPWR VGND sg13cmos5l_decap_8
XFILLER_405_257 VPWR VGND sg13cmos5l_decap_8
XFILLER_17_66 VPWR VGND sg13cmos5l_decap_8
XFILLER_354_7 VPWR VGND sg13cmos5l_decap_8
XFILLER_140_56 VPWR VGND sg13cmos5l_decap_8
XFILLER_169_245 VPWR VGND sg13cmos5l_decap_8
XFILLER_521_7 VPWR VGND sg13cmos5l_decap_8
XFILLER_385_120 VPWR VGND sg13cmos5l_fill_2
XFILLER_33_21 VPWR VGND sg13cmos5l_decap_4
XFILLER_708_236 VPWR VGND sg13cmos5l_decap_4
XFILLER_574_231 VPWR VGND sg13cmos5l_decap_8
XFILLER_169_267 VPWR VGND sg13cmos5l_decap_4
XFILLER_619_7 VPWR VGND sg13cmos5l_decap_8
XFILLER_149_21 VPWR VGND sg13cmos5l_decap_8
XFILLER_577_70 VPWR VGND sg13cmos5l_decap_8
XFILLER_519_158 VPWR VGND sg13cmos5l_decap_8
XFILLER_385_164 VPWR VGND sg13cmos5l_decap_8
XFILLER_385_175 VPWR VGND sg13cmos5l_fill_1
XFILLER_184_237 VPWR VGND sg13cmos5l_decap_8
XFILLER_149_65 VPWR VGND sg13cmos5l_decap_8
XFILLER_534_128 VPWR VGND sg13cmos5l_fill_1
XFILLER_385_197 VPWR VGND sg13cmos5l_decap_8
XFILLER_326_242 VPWR VGND sg13cmos5l_decap_8
XFILLER_326_253 VPWR VGND sg13cmos5l_fill_1
XFILLER_192_270 VPWR VGND sg13cmos5l_fill_2
XFILLER_663_28 VPWR VGND sg13cmos5l_decap_8
XFILLER_341_212 VPWR VGND sg13cmos5l_decap_8
XFILLER_137_197 VPWR VGND sg13cmos5l_decap_8
XFILLER_165_31 VPWR VGND sg13cmos5l_fill_1
XFILLER_542_172 VPWR VGND sg13cmos5l_decap_8
XFILLER_487_205 VPWR VGND sg13cmos5l_decap_8
XFILLER_341_223 VPWR VGND sg13cmos5l_fill_1
XFILLER_542_183 VPWR VGND sg13cmos5l_fill_1
XFILLER_109_0 VPWR VGND sg13cmos5l_decap_4
XFILLER_446_96 VPWR VGND sg13cmos5l_fill_1
XFILLER_165_53 VPWR VGND sg13cmos5l_decap_8
XFILLER_298_138 VPWR VGND sg13cmos5l_decap_8
XFILLER_629_232 VPWR VGND sg13cmos5l_decap_8
XFILLER_495_271 VPWR VGND sg13cmos5l_fill_2
XFILLER_644_224 VPWR VGND sg13cmos5l_decap_8
XFILLER_612_21 VPWR VGND sg13cmos5l_decap_8
XFILLER_380_0 VPWR VGND sg13cmos5l_decap_8
XFILLER_478_0 VPWR VGND sg13cmos5l_decap_8
XFILLER_181_63 VPWR VGND sg13cmos5l_decap_8
XFILLER_58_95 VPWR VGND sg13cmos5l_decap_8
XFILLER_644_268 VPWR VGND sg13cmos5l_decap_4
XFILLER_247_260 VPWR VGND sg13cmos5l_decap_4
XFILLER_688_14 VPWR VGND sg13cmos5l_decap_8
XANTENNA__3499__X Tile_X0Y1_E6BEG[9] VPWR VGND sg13cmos5l_antennanp
XFILLER_74_162 VPWR VGND sg13cmos5l_decap_8
XFILLER_645_0 VPWR VGND sg13cmos5l_decap_8
XFILLER_331_99 VPWR VGND sg13cmos5l_decap_8
XFILLER_411_249 VPWR VGND sg13cmos5l_decap_8
XFILLER_215_190 VPWR VGND sg13cmos5l_decap_4
X_2870_ Tile_X0Y6_EE4BEG[7] _4519_/X VPWR VGND sg13cmos5l_buf_1
XFILLER_487_70 VPWR VGND sg13cmos5l_decap_8
XFILLER_376_153 VPWR VGND sg13cmos5l_decap_8
XFILLER_30_232 VPWR VGND sg13cmos5l_decap_8
XFILLER_230_171 VPWR VGND sg13cmos5l_decap_8
XFILLER_90_60 VPWR VGND sg13cmos5l_decap_8
XFILLER_565_264 VPWR VGND sg13cmos5l_fill_1
XFILLER_230_193 VPWR VGND sg13cmos5l_decap_8
X_1821_ _1821_/Q Tile_X0Y3_FrameData[12] VGND VPWR Tile_X0Y9_FrameStrobe[4] latch
XFILLER_391_112 VPWR VGND sg13cmos5l_decap_8
XFILLER_580_212 VPWR VGND sg13cmos5l_decap_8
XFILLER_128_120 VPWR VGND sg13cmos5l_fill_2
XFILLER_525_128 VPWR VGND sg13cmos5l_decap_8
XFILLER_714_239 VPWR VGND sg13cmos5l_fill_1
X_4540_ _4540_/X _4545_/X Tile_X0Y6_W6END[0] _4544_/X _4540_/A3 _2447_/Q _2446_/Q
+ VPWR VGND sg13cmos5l_mux4_1
XFILLER_317_231 VPWR VGND sg13cmos5l_decap_8
X_1752_ _1752_/Q Tile_X0Y3_FrameData[17] VGND VPWR Tile_X0Y9_FrameStrobe[2] latch
XFILLER_637_84 VPWR VGND sg13cmos5l_fill_2
XFILLER_209_35 VPWR VGND sg13cmos5l_decap_8
XFILLER_679_121 VPWR VGND sg13cmos5l_decap_8
X_0703_ _0703_/Q Tile_X0Y9_FrameData[0] VGND VPWR Tile_X0Y9_FrameStrobe[0] latch
XFILLER_573_28 VPWR VGND sg13cmos5l_decap_8
XFILLER_356_63 VPWR VGND sg13cmos5l_decap_8
X_4471_ _4471_/X Tile_X0Y7_W2MID[6] Tile_X0Y7_W2END[6] Tile_X0Y7_W6END[6] _4671_/X
+ _0405_/Q _0404_/Q VPWR VGND sg13cmos5l_mux4_1
XFILLER_143_123 VPWR VGND sg13cmos5l_fill_1
X_1683_ _1683_/Q Tile_X0Y3_FrameData[22] VGND VPWR Tile_X0Y9_FrameStrobe[0] latch
XFILLER_533_172 VPWR VGND sg13cmos5l_decap_8
XFILLER_679_165 VPWR VGND sg13cmos5l_decap_8
XFILLER_332_234 VPWR VGND sg13cmos5l_fill_2
X_3422_ Tile_X0Y4_FrameData_O[13] Tile_X0Y4_FrameData[13] VPWR VGND sg13cmos5l_buf_1
XFILLER_289_138 VPWR VGND sg13cmos5l_decap_8
X_0634_ _0634_/Q Tile_X0Y8_FrameData[5] VGND VPWR Tile_X0Y9_FrameStrobe[6] latch
XFILLER_506_77 VPWR VGND sg13cmos5l_decap_8
X_0565_ _0565_/Q Tile_X0Y8_FrameData[10] VGND VPWR Tile_X0Y9_FrameStrobe[4] latch
X_3353_ Tile_X0Y2_FrameData_O[24] Tile_X0Y2_FrameData[24] VPWR VGND sg13cmos5l_buf_1
XFILLER_97_243 VPWR VGND sg13cmos5l_fill_2
XFILLER_297_171 VPWR VGND sg13cmos5l_fill_1
XFILLER_225_67 VPWR VGND sg13cmos5l_fill_2
X_2304_ _2304_/Q Tile_X0Y5_FrameData[5] VGND VPWR Tile_X0Y9_FrameStrobe[3] latch
XFILLER_297_193 VPWR VGND sg13cmos5l_decap_8
X_0496_ _0496_/Q Tile_X0Y8_FrameData[15] VGND VPWR Tile_X0Y9_FrameStrobe[2] latch
X_3284_ Tile_X0Y0_E6BEG[4] _3840_/X VPWR VGND sg13cmos5l_buf_1
XFILLER_300_142 VPWR VGND sg13cmos5l_decap_8
XFILLER_522_21 VPWR VGND sg13cmos5l_decap_8
XFILLER_446_135 VPWR VGND sg13cmos5l_decap_8
XFILLER_24_0 VPWR VGND sg13cmos5l_decap_8
X_2235_ _2235_/Q Tile_X0Y5_FrameData[10] VGND VPWR Tile_X0Y9_FrameStrobe[1] latch
XFILLER_238_271 VPWR VGND sg13cmos5l_fill_2
X_2166_ _2166_/Q Tile_X0Y4_FrameData[15] VGND VPWR Tile_X0Y9_FrameStrobe[7] latch
XFILLER_65_140 VPWR VGND sg13cmos5l_decap_8
XFILLER_241_44 VPWR VGND sg13cmos5l_fill_1
XFILLER_598_14 VPWR VGND sg13cmos5l_decap_8
X_1117_ _1117_/Q Tile_X0Y0_FrameData[14] VGND VPWR Tile_X0Y9_FrameStrobe[5] latch
XFILLER_399_234 VPWR VGND sg13cmos5l_decap_8
XFILLER_213_105 VPWR VGND sg13cmos5l_fill_1
X_2097_ _2097_/Q Tile_X0Y4_FrameData[20] VGND VPWR Tile_X0Y9_FrameStrobe[5] latch
XANTENNA__3202__X Tile_X0Y0_N2BEG[2] VPWR VGND sg13cmos5l_antennanp
XFILLER_213_116 VPWR VGND sg13cmos5l_decap_8
X_1048_ _1048_/Q Tile_X0Y0_FrameData[19] VGND VPWR Tile_X0Y9_FrameStrobe[3] latch
XFILLER_110_37 VPWR VGND sg13cmos5l_fill_1
XFILLER_110_59 VPWR VGND sg13cmos5l_fill_2
XFILLER_221_160 VPWR VGND sg13cmos5l_decap_8
XFILLER_367_142 VPWR VGND sg13cmos5l_decap_8
XFILLER_221_171 VPWR VGND sg13cmos5l_fill_1
XFILLER_410_271 VPWR VGND sg13cmos5l_fill_2
X_4807_ _4807_/X _4783_/X Tile_X0Y9_N4END[7] _4782_/X _0074_/X _0457_/Q _0456_/Q VPWR
+ VGND sg13cmos5l_mux4_1
XFILLER_382_112 VPWR VGND sg13cmos5l_fill_2
XFILLER_166_248 VPWR VGND sg13cmos5l_decap_8
X_2999_ Tile_X0Y5_E2BEG[2] _4374_/X VPWR VGND sg13cmos5l_buf_1
XFILLER_705_228 VPWR VGND sg13cmos5l_decap_8
XFILLER_308_220 VPWR VGND sg13cmos5l_decap_4
XFILLER_382_145 VPWR VGND sg13cmos5l_fill_1
X_4738_ _4738_/X Tile_X0Y8_W2END[5] AXI_M_SOC_RDATA13 _4789_/X _4788_/X _0571_/Q _0570_/Q
+ VPWR VGND sg13cmos5l_mux4_1
XFILLER_547_84 VPWR VGND sg13cmos5l_fill_2
XFILLER_119_35 VPWR VGND sg13cmos5l_decap_8
XFILLER_308_253 VPWR VGND sg13cmos5l_decap_8
XFILLER_382_178 VPWR VGND sg13cmos5l_fill_1
XFILLER_308_264 VPWR VGND sg13cmos5l_fill_1
XFILLER_266_63 VPWR VGND sg13cmos5l_fill_2
X_4669_ _4669_/X _4585_/X _4701_/X _4700_/X _4584_/X _0183_/Q _0182_/Q VPWR VGND sg13cmos5l_mux4_1
XFILLER_79_28 VPWR VGND sg13cmos5l_decap_8
XFILLER_102_7 VPWR VGND sg13cmos5l_decap_8
XFILLER_685_102 VPWR VGND sg13cmos5l_decap_8
XFILLER_134_156 VPWR VGND sg13cmos5l_decap_8
XFILLER_323_256 VPWR VGND sg13cmos5l_decap_8
XFILLER_0_103 VPWR VGND sg13cmos5l_fill_2
XFILLER_416_77 VPWR VGND sg13cmos5l_decap_8
XFILLER_0_114 VPWR VGND sg13cmos5l_fill_2
XFILLER_88_221 VPWR VGND sg13cmos5l_decap_4
XFILLER_295_119 VPWR VGND sg13cmos5l_decap_8
XFILLER_135_56 VPWR VGND sg13cmos5l_decap_8
XFILLER_288_171 VPWR VGND sg13cmos5l_decap_8
XFILLER_626_213 VPWR VGND sg13cmos5l_decap_8
XFILLER_626_224 VPWR VGND sg13cmos5l_fill_1
XFILLER_282_84 VPWR VGND sg13cmos5l_decap_8
XFILLER_432_21 VPWR VGND sg13cmos5l_decap_8
XFILLER_713_75 VPWR VGND sg13cmos5l_decap_8
XFILLER_95_49 VPWR VGND sg13cmos5l_decap_8
XFILLER_626_246 VPWR VGND sg13cmos5l_decap_8
XFILLER_471_7 VPWR VGND sg13cmos5l_decap_8
XFILLER_28_21 VPWR VGND sg13cmos5l_decap_4
XFILLER_236_208 VPWR VGND sg13cmos5l_decap_8
XFILLER_569_7 VPWR VGND sg13cmos5l_decap_8
XFILLER_641_238 VPWR VGND sg13cmos5l_decap_8
XFILLER_56_151 VPWR VGND sg13cmos5l_decap_8
XFILLER_432_98 VPWR VGND sg13cmos5l_decap_8
XFILLER_151_77 VPWR VGND sg13cmos5l_decap_8
XANTENNA__3112__X Tile_X0Y7_E6BEG[10] VPWR VGND sg13cmos5l_antennanp
XFILLER_301_36 VPWR VGND sg13cmos5l_decap_8
XFILLER_460_171 VPWR VGND sg13cmos5l_decap_8
XFILLER_71_154 VPWR VGND sg13cmos5l_decap_8
XFILLER_658_28 VPWR VGND sg13cmos5l_decap_8
XANTENNA__2951__X Tile_X0Y8_EE4BEG[7] VPWR VGND sg13cmos5l_antennanp
XFILLER_547_220 VPWR VGND sg13cmos5l_decap_8
XFILLER_401_271 VPWR VGND sg13cmos5l_fill_2
XFILLER_212_182 VPWR VGND sg13cmos5l_decap_8
XFILLER_358_175 VPWR VGND sg13cmos5l_decap_8
XFILLER_100_70 VPWR VGND sg13cmos5l_decap_8
XFILLER_373_112 VPWR VGND sg13cmos5l_decap_4
XFILLER_157_248 VPWR VGND sg13cmos5l_decap_8
XFILLER_226_0 VPWR VGND sg13cmos5l_decap_8
XFILLER_373_134 VPWR VGND sg13cmos5l_decap_8
XFILLER_172_207 VPWR VGND sg13cmos5l_fill_1
XFILLER_674_49 VPWR VGND sg13cmos5l_decap_8
XFILLER_457_84 VPWR VGND sg13cmos5l_decap_8
XFILLER_607_21 VPWR VGND sg13cmos5l_decap_8
XFILLER_172_229 VPWR VGND sg13cmos5l_decap_8
XFILLER_704_250 VPWR VGND sg13cmos5l_fill_1
XFILLER_125_123 VPWR VGND sg13cmos5l_decap_8
XFILLER_5_14 VPWR VGND sg13cmos5l_decap_8
XFILLER_125_134 VPWR VGND sg13cmos5l_decap_8
XFILLER_314_234 VPWR VGND sg13cmos5l_decap_4
XFILLER_676_113 VPWR VGND sg13cmos5l_decap_8
XFILLER_180_251 VPWR VGND sg13cmos5l_decap_8
XFILLER_595_0 VPWR VGND sg13cmos5l_decap_8
XFILLER_140_126 VPWR VGND sg13cmos5l_decap_8
XFILLER_79_210 VPWR VGND sg13cmos5l_decap_8
XFILLER_326_77 VPWR VGND sg13cmos5l_decap_8
XFILLER_286_119 VPWR VGND sg13cmos5l_decap_8
XFILLER_473_94 VPWR VGND sg13cmos5l_decap_8
XFILLER_192_62 VPWR VGND sg13cmos5l_decap_4
XFILLER_79_243 VPWR VGND sg13cmos5l_decap_8
XFILLER_623_42 VPWR VGND sg13cmos5l_decap_8
X_0350_ _0350_/Q Tile_X0Y7_FrameData[1] VGND VPWR Tile_X0Y9_FrameStrobe[5] latch
XFILLER_192_95 VPWR VGND sg13cmos5l_decap_4
XFILLER_39_107 VPWR VGND sg13cmos5l_decap_8
XFILLER_617_235 VPWR VGND sg13cmos5l_decap_8
XFILLER_342_21 VPWR VGND sg13cmos5l_decap_8
X_0281_ _0281_/Q Tile_X0Y7_FrameData[6] VGND VPWR Tile_X0Y9_FrameStrobe[3] latch
XFILLER_483_263 VPWR VGND sg13cmos5l_decap_8
XFILLER_428_168 VPWR VGND sg13cmos5l_decap_8
XFILLER_94_246 VPWR VGND sg13cmos5l_decap_8
XFILLER_443_105 VPWR VGND sg13cmos5l_decap_8
XFILLER_94_257 VPWR VGND sg13cmos5l_fill_2
X_2020_ _2020_/Q Tile_X0Y4_FrameData[1] VGND VPWR Tile_X0Y9_FrameStrobe[2] latch
XFILLER_443_116 VPWR VGND sg13cmos5l_fill_1
XFILLER_699_57 VPWR VGND sg13cmos5l_decap_8
XFILLER_632_227 VPWR VGND sg13cmos5l_decap_4
XFILLER_85_93 VPWR VGND sg13cmos5l_fill_2
XFILLER_47_162 VPWR VGND sg13cmos5l_decap_8
XFILLER_62_110 VPWR VGND sg13cmos5l_decap_8
XFILLER_211_14 VPWR VGND sg13cmos5l_decap_8
XANTENNA__3022__X Tile_X0Y5_E6BEG[9] VPWR VGND sg13cmos5l_antennanp
XFILLER_597_153 VPWR VGND sg13cmos5l_decap_4
XFILLER_250_211 VPWR VGND sg13cmos5l_fill_2
XFILLER_568_28 VPWR VGND sg13cmos5l_decap_8
X_3971_ _3971_/X AXI_M_SOC_ARREADY _4012_/X _4016_/X _3995_/X _1267_/Q _1266_/Q VPWR
+ VGND sg13cmos5l_mux4_1
XFILLER_597_186 VPWR VGND sg13cmos5l_decap_4
XFILLER_597_197 VPWR VGND sg13cmos5l_decap_8
XFILLER_396_248 VPWR VGND sg13cmos5l_decap_8
XANTENNA__2861__X Tile_X0Y6_E6BEG[10] VPWR VGND sg13cmos5l_antennanp
XFILLER_498_91 VPWR VGND sg13cmos5l_decap_8
X_2922_ Tile_X0Y8_E2BEG[6] _4734_/X VPWR VGND sg13cmos5l_buf_1
XFILLER_210_119 VPWR VGND sg13cmos5l_decap_8
XFILLER_600_179 VPWR VGND sg13cmos5l_fill_1
XFILLER_538_253 VPWR VGND sg13cmos5l_decap_8
XFILLER_538_264 VPWR VGND sg13cmos5l_fill_1
X_2853_ Tile_X0Y6_E6BEG[2] _4530_/X VPWR VGND sg13cmos5l_buf_1
X_1804_ _1804_/Q Tile_X0Y3_FrameData[29] VGND VPWR Tile_X0Y9_FrameStrobe[4] latch
XFILLER_584_49 VPWR VGND sg13cmos5l_decap_8
XFILLER_163_207 VPWR VGND sg13cmos5l_decap_8
X_2784_ Tile_X0Y3_EE4BEG[10] _4174_/X VPWR VGND sg13cmos5l_buf_1
XFILLER_364_167 VPWR VGND sg13cmos5l_decap_8
XFILLER_517_21 VPWR VGND sg13cmos5l_decap_8
XFILLER_702_209 VPWR VGND sg13cmos5l_decap_4
X_4523_ _4523_/X Tile_X0Y6_WW4END[4] AXI_M_SOC_RDATA28 _4572_/X _4558_/X _2561_/Q
+ _2560_/Q VPWR VGND sg13cmos5l_mux4_1
X_1735_ _1735_/Q Tile_X0Y3_FrameData[2] VGND VPWR Tile_X0Y9_FrameStrobe[1] latch
XANTENNA__3692__X AXI_M_SOC_WDATA2 VPWR VGND sg13cmos5l_antennanp
XFILLER_116_134 VPWR VGND sg13cmos5l_decap_8
X_4454_ _4454_/X _4427_/X _0097_/X _4426_/X _0156_/X _2231_/Q _2230_/Q VPWR VGND sg13cmos5l_mux4_1
X_1666_ _1666_/Q Tile_X0Y2_FrameData[15] VGND VPWR Tile_X0Y9_FrameStrobe[7] latch
XFILLER_667_135 VPWR VGND sg13cmos5l_decap_8
X_3405_ Tile_X0Y2_E1BEG[0] _4036_/X VPWR VGND sg13cmos5l_buf_1
XFILLER_320_215 VPWR VGND sg13cmos5l_decap_8
XFILLER_236_77 VPWR VGND sg13cmos5l_decap_8
XFILLER_131_126 VPWR VGND sg13cmos5l_decap_8
X_0617_ _0617_/Q Tile_X0Y8_FrameData[22] VGND VPWR Tile_X0Y9_FrameStrobe[6] latch
XFILLER_466_208 VPWR VGND sg13cmos5l_decap_8
X_4385_ _4385_/X Tile_X0Y5_W2END[2] AXI_M_SOC_RRESP0 _4432_/X _4431_/X _2333_/Q _2332_/Q
+ VPWR VGND sg13cmos5l_mux4_1
XFILLER_277_119 VPWR VGND sg13cmos5l_decap_8
X_1597_ _1597_/Q Tile_X0Y2_FrameData[20] VGND VPWR Tile_X0Y9_FrameStrobe[5] latch
XFILLER_682_105 VPWR VGND sg13cmos5l_decap_8
XFILLER_533_42 VPWR VGND sg13cmos5l_decap_8
X_3336_ Tile_X0Y2_FrameData_O[7] Tile_X0Y2_FrameData[7] VPWR VGND sg13cmos5l_buf_1
X_0548_ _0548_/Q Tile_X0Y8_FrameData[27] VGND VPWR Tile_X0Y9_FrameStrobe[4] latch
XFILLER_608_235 VPWR VGND sg13cmos5l_decap_8
XFILLER_252_21 VPWR VGND sg13cmos5l_decap_8
XFILLER_474_252 VPWR VGND sg13cmos5l_decap_8
XFILLER_218_219 VPWR VGND sg13cmos5l_decap_8
X_3267_ Tile_X0Y0_EE4BEG[3] _3823_/X VPWR VGND sg13cmos5l_buf_1
XFILLER_85_246 VPWR VGND sg13cmos5l_fill_1
X_0479_ _0479_/Q Tile_X0Y8_FrameData[0] VGND VPWR Tile_X0Y9_FrameStrobe[1] latch
XFILLER_434_105 VPWR VGND sg13cmos5l_decap_4
XFILLER_690_171 VPWR VGND sg13cmos5l_decap_8
XFILLER_285_196 VPWR VGND sg13cmos5l_decap_8
X_2218_ _2218_/Q Tile_X0Y5_FrameData[27] VGND VPWR Tile_X0Y9_FrameStrobe[1] latch
X_3198_ Tile_X0Y0_N2BEGb[6] _3901_/X VPWR VGND sg13cmos5l_buf_1
XFILLER_402_35 VPWR VGND sg13cmos5l_decap_8
XFILLER_38_173 VPWR VGND sg13cmos5l_fill_1
XANTENNA_109 _0157_/X VPWR VGND sg13cmos5l_antennanp
XFILLER_121_14 VPWR VGND sg13cmos5l_decap_8
X_2149_ _2149_/Q Tile_X0Y4_FrameData[0] VGND VPWR Tile_X0Y9_FrameStrobe[6] latch
XFILLER_53_121 VPWR VGND sg13cmos5l_fill_2
XFILLER_38_195 VPWR VGND sg13cmos5l_decap_8
XFILLER_241_222 VPWR VGND sg13cmos5l_decap_8
XFILLER_442_182 VPWR VGND sg13cmos5l_decap_4
XFILLER_53_165 VPWR VGND sg13cmos5l_fill_2
XFILLER_478_28 VPWR VGND sg13cmos5l_decap_8
XFILLER_198_148 VPWR VGND sg13cmos5l_decap_8
XANTENNA__2771__X Tile_X0Y3_FrameData_O[29] VPWR VGND sg13cmos5l_antennanp
XFILLER_14_56 VPWR VGND sg13cmos5l_decap_8
XFILLER_395_270 VPWR VGND sg13cmos5l_fill_2
XFILLER_355_112 VPWR VGND sg13cmos5l_decap_8
XFILLER_324_8 VPWR VGND sg13cmos5l_decap_8
XFILLER_139_248 VPWR VGND sg13cmos5l_decap_8
XFILLER_708_42 VPWR VGND sg13cmos5l_decap_8
XFILLER_317_7 VPWR VGND sg13cmos5l_decap_8
XFILLER_494_49 VPWR VGND sg13cmos5l_decap_8
XFILLER_277_84 VPWR VGND sg13cmos5l_decap_8
XFILLER_427_21 VPWR VGND sg13cmos5l_decap_8
XFILLER_355_189 VPWR VGND sg13cmos5l_decap_8
XFILLER_5_228 VPWR VGND sg13cmos5l_decap_8
XFILLER_698_271 VPWR VGND sg13cmos5l_fill_2
XFILLER_658_113 VPWR VGND sg13cmos5l_fill_1
XFILLER_107_167 VPWR VGND sg13cmos5l_fill_1
XFILLER_701_231 VPWR VGND sg13cmos5l_fill_2
XFILLER_658_124 VPWR VGND sg13cmos5l_decap_8
XFILLER_427_98 VPWR VGND sg13cmos5l_decap_8
XFILLER_122_104 VPWR VGND sg13cmos5l_decap_8
XFILLER_146_77 VPWR VGND sg13cmos5l_decap_8
XFILLER_658_157 VPWR VGND sg13cmos5l_decap_8
XFILLER_686_7 VPWR VGND sg13cmos5l_decap_8
XANTENNA__3107__X Tile_X0Y7_E6BEG[5] VPWR VGND sg13cmos5l_antennanp
XFILLER_512_197 VPWR VGND sg13cmos5l_decap_8
XFILLER_443_42 VPWR VGND sg13cmos5l_decap_8
XFILLER_673_127 VPWR VGND sg13cmos5l_decap_8
XFILLER_162_21 VPWR VGND sg13cmos5l_decap_8
XFILLER_590_70 VPWR VGND sg13cmos5l_decap_8
XFILLER_666_190 VPWR VGND sg13cmos5l_fill_1
XFILLER_276_152 VPWR VGND sg13cmos5l_decap_8
XANTENNA__2946__X Tile_X0Y8_EE4BEG[2] VPWR VGND sg13cmos5l_antennanp
XFILLER_76_224 VPWR VGND sg13cmos5l_decap_8
XFILLER_209_219 VPWR VGND sg13cmos5l_fill_2
XFILLER_465_263 VPWR VGND sg13cmos5l_decap_8
XFILLER_425_105 VPWR VGND sg13cmos5l_decap_8
XFILLER_681_171 VPWR VGND sg13cmos5l_decap_8
XFILLER_162_87 VPWR VGND sg13cmos5l_decap_8
XFILLER_614_238 VPWR VGND sg13cmos5l_decap_8
XFILLER_217_230 VPWR VGND sg13cmos5l_fill_2
XFILLER_681_193 VPWR VGND sg13cmos5l_decap_8
XFILLER_312_35 VPWR VGND sg13cmos5l_decap_8
XFILLER_480_255 VPWR VGND sg13cmos5l_decap_8
XFILLER_312_46 VPWR VGND sg13cmos5l_fill_2
XFILLER_291_155 VPWR VGND sg13cmos5l_decap_8
XFILLER_176_0 VPWR VGND sg13cmos5l_decap_8
XFILLER_669_49 VPWR VGND sg13cmos5l_decap_4
XFILLER_579_153 VPWR VGND sg13cmos5l_decap_8
XFILLER_433_160 VPWR VGND sg13cmos5l_decap_8
XFILLER_388_28 VPWR VGND sg13cmos5l_fill_2
XFILLER_378_226 VPWR VGND sg13cmos5l_decap_8
XFILLER_189_137 VPWR VGND sg13cmos5l_decap_8
XFILLER_189_148 VPWR VGND sg13cmos5l_fill_2
XFILLER_579_197 VPWR VGND sg13cmos5l_decap_8
XFILLER_343_0 VPWR VGND sg13cmos5l_decap_8
XFILLER_232_255 VPWR VGND sg13cmos5l_decap_8
XFILLER_468_72 VPWR VGND sg13cmos5l_decap_8
XFILLER_685_48 VPWR VGND sg13cmos5l_decap_8
XFILLER_197_181 VPWR VGND sg13cmos5l_decap_8
XFILLER_200_130 VPWR VGND sg13cmos5l_decap_8
XFILLER_510_0 VPWR VGND sg13cmos5l_decap_8
XFILLER_71_84 VPWR VGND sg13cmos5l_decap_8
XFILLER_608_0 VPWR VGND sg13cmos5l_decap_8
XFILLER_618_42 VPWR VGND sg13cmos5l_decap_8
XFILLER_346_145 VPWR VGND sg13cmos5l_fill_2
XFILLER_145_218 VPWR VGND sg13cmos5l_decap_8
XFILLER_200_185 VPWR VGND sg13cmos5l_fill_2
XFILLER_187_95 VPWR VGND sg13cmos5l_fill_1
XFILLER_337_21 VPWR VGND sg13cmos5l_decap_8
XFILLER_346_189 VPWR VGND sg13cmos5l_decap_8
XFILLER_65_7 VPWR VGND sg13cmos5l_decap_8
XFILLER_550_226 VPWR VGND sg13cmos5l_decap_8
X_1520_ _1520_/Q Tile_X0Y2_FrameData[1] VGND VPWR Tile_X0Y9_FrameStrobe[2] latch
XFILLER_649_157 VPWR VGND sg13cmos5l_decap_8
XFILLER_503_175 VPWR VGND sg13cmos5l_decap_8
XFILLER_448_208 VPWR VGND sg13cmos5l_fill_1
XFILLER_206_14 VPWR VGND sg13cmos5l_decap_8
X_1451_ _1451_/Q Tile_X0Y2_FrameData[6] VGND VPWR Tile_X0Y9_FrameStrobe[0] latch
XFILLER_634_63 VPWR VGND sg13cmos5l_decap_8
XANTENNA__3017__X Tile_X0Y5_E6BEG[4] VPWR VGND sg13cmos5l_antennanp
XFILLER_113_148 VPWR VGND sg13cmos5l_decap_8
XFILLER_302_248 VPWR VGND sg13cmos5l_decap_8
XFILLER_353_42 VPWR VGND sg13cmos5l_decap_8
X_0402_ _0402_/Q Tile_X0Y7_FrameData[13] VGND VPWR Tile_X0Y9_FrameStrobe[7] latch
X_1382_ _1382_/Q Tile_X0Y1_FrameData[19] VGND VPWR Tile_X0Y9_FrameStrobe[6] latch
X_4170_ _4170_/X Tile_X0Y3_WW4END[9] AXI_M_SOC_WREADY _4231_/X _4207_/X _1801_/Q _1800_/Q
+ VPWR VGND sg13cmos5l_mux4_1
XFILLER_657_190 VPWR VGND sg13cmos5l_decap_4
X_3121_ Tile_X0Y7_EE4BEG[7] _4635_/X VPWR VGND sg13cmos5l_buf_1
XFILLER_67_224 VPWR VGND sg13cmos5l_decap_8
XANTENNA__2856__X Tile_X0Y6_E6BEG[5] VPWR VGND sg13cmos5l_antennanp
X_0333_ _0333_/Q Tile_X0Y7_FrameData[18] VGND VPWR Tile_X0Y9_FrameStrobe[5] latch
XFILLER_456_263 VPWR VGND sg13cmos5l_fill_2
XFILLER_503_56 VPWR VGND sg13cmos5l_decap_8
XFILLER_471_222 VPWR VGND sg13cmos5l_decap_8
XFILLER_416_127 VPWR VGND sg13cmos5l_decap_8
X_0264_ _0264_/Q Tile_X0Y7_FrameData[23] VGND VPWR Tile_X0Y9_FrameStrobe[3] latch
X_3052_ Tile_X0Y5_FrameData_O[11] Tile_X0Y5_FrameData[11] VPWR VGND sg13cmos5l_buf_1
XFILLER_282_133 VPWR VGND sg13cmos5l_decap_8
XFILLER_222_35 VPWR VGND sg13cmos5l_decap_8
XFILLER_650_84 VPWR VGND sg13cmos5l_decap_8
XFILLER_409_190 VPWR VGND sg13cmos5l_decap_8
X_2003_ _2003_/Q Tile_X0Y4_FrameData[18] VGND VPWR Tile_X0Y9_FrameStrobe[2] latch
X_0195_ _0195_/Q Tile_X0Y7_FrameData[28] VGND VPWR Tile_X0Y9_FrameStrobe[1] latch
XFILLER_431_119 VPWR VGND sg13cmos5l_decap_8
XFILLER_579_49 VPWR VGND sg13cmos5l_decap_8
XFILLER_35_132 VPWR VGND sg13cmos5l_decap_4
XFILLER_223_222 VPWR VGND sg13cmos5l_fill_2
XFILLER_424_182 VPWR VGND sg13cmos5l_decap_8
XFILLER_298_28 VPWR VGND sg13cmos5l_decap_8
XFILLER_659_60 VPWR VGND sg13cmos5l_fill_1
XFILLER_50_113 VPWR VGND sg13cmos5l_decap_8
XFILLER_35_187 VPWR VGND sg13cmos5l_decap_8
XFILLER_659_82 VPWR VGND sg13cmos5l_decap_4
X_3954_ _3954_/X Tile_X0Y1_WW4END[9] AXI_M_SOC_ARREADY _4017_/X _3991_/X _1301_/Q
+ _1300_/Q VPWR VGND sg13cmos5l_mux4_1
XFILLER_91_0 VPWR VGND sg13cmos5l_decap_8
XFILLER_50_146 VPWR VGND sg13cmos5l_decap_8
XFILLER_378_50 VPWR VGND sg13cmos5l_decap_8
X_2905_ Tile_X0Y6_FrameData_O[26] Tile_X0Y6_FrameData[26] VPWR VGND sg13cmos5l_buf_1
X_3885_ _3885_/X _3848_/X _0067_/X Tile_X0Y0_S1END[0] Tile_X0Y0_S4END[0] _0987_/Q
+ _0986_/Q VPWR VGND sg13cmos5l_mux4_1
XFILLER_526_223 VPWR VGND sg13cmos5l_decap_8
XFILLER_528_42 VPWR VGND sg13cmos5l_decap_8
X_2836_ Tile_X0Y6_E2BEG[1] _4497_/X VPWR VGND sg13cmos5l_buf_1
XFILLER_136_207 VPWR VGND sg13cmos5l_decap_8
XFILLER_337_167 VPWR VGND sg13cmos5l_decap_8
XFILLER_392_262 VPWR VGND sg13cmos5l_decap_8
XFILLER_247_21 VPWR VGND sg13cmos5l_decap_8
XFILLER_687_208 VPWR VGND sg13cmos5l_fill_2
XFILLER_352_126 VPWR VGND sg13cmos5l_decap_8
X_2767_ Tile_X0Y3_FrameData_O[25] Tile_X0Y3_FrameData[25] VPWR VGND sg13cmos5l_buf_1
XFILLER_498_119 VPWR VGND sg13cmos5l_decap_8
X_4506_ _4506_/X Tile_X0Y6_W2END[5] AXI_M_SOC_RDATA29 _4557_/X _4556_/X _2595_/Q _2594_/Q
+ VPWR VGND sg13cmos5l_mux4_1
X_1718_ _1718_/Q Tile_X0Y3_FrameData[19] VGND VPWR Tile_X0Y9_FrameStrobe[1] latch
X_2698_ _4086_/A3 VPWR VGND sg13cmos5l_tielo
XFILLER_695_230 VPWR VGND sg13cmos5l_fill_2
X_4437_ _4437_/X Tile_X0Y9_W1END[0] Tile_X0Y9_WW4END[0] Tile_X0Y9_W6END[8] _4916_/X
+ _0903_/Q _0902_/Q VPWR VGND sg13cmos5l_mux4_1
XFILLER_544_63 VPWR VGND sg13cmos5l_decap_8
XFILLER_116_14 VPWR VGND sg13cmos5l_decap_8
X_1649_ _1649_/Q Tile_X0Y2_FrameData[0] VGND VPWR Tile_X0Y9_FrameStrobe[6] latch
XFILLER_360_192 VPWR VGND sg13cmos5l_decap_8
XFILLER_263_42 VPWR VGND sg13cmos5l_decap_8
X_4368_ _4368_/X _4418_/X _4417_/X AXI_M_SOC_RRESP1 _4416_/X _2367_/Q _2366_/Q VPWR
+ VGND sg13cmos5l_mux4_1
XFILLER_655_138 VPWR VGND sg13cmos5l_decap_8
XFILLER_655_149 VPWR VGND sg13cmos5l_fill_2
XANTENNA__2766__X Tile_X0Y3_FrameData_O[24] VPWR VGND sg13cmos5l_antennanp
X_3319_ Tile_X0Y4_EE4BEG[7] _4279_/X VPWR VGND sg13cmos5l_buf_1
XFILLER_258_163 VPWR VGND sg13cmos5l_decap_8
X_4299_ _4299_/X AXI_M_SOC_BRESP1 _4336_/X _4340_/X _4312_/X _2015_/Q _2014_/Q VPWR
+ VGND sg13cmos5l_mux4_1
XFILLER_58_246 VPWR VGND sg13cmos5l_decap_8
XFILLER_462_200 VPWR VGND sg13cmos5l_fill_2
XFILLER_413_56 VPWR VGND sg13cmos5l_decap_8
XFILLER_407_127 VPWR VGND sg13cmos5l_decap_8
XFILLER_407_138 VPWR VGND sg13cmos5l_fill_2
XFILLER_560_84 VPWR VGND sg13cmos5l_decap_8
XFILLER_132_35 VPWR VGND sg13cmos5l_decap_8
XFILLER_462_244 VPWR VGND sg13cmos5l_decap_8
XFILLER_710_21 VPWR VGND sg13cmos5l_decap_8
XFILLER_422_119 VPWR VGND sg13cmos5l_decap_8
XFILLER_273_188 VPWR VGND sg13cmos5l_decap_8
XFILLER_26_121 VPWR VGND sg13cmos5l_decap_8
XFILLER_214_200 VPWR VGND sg13cmos5l_decap_8
XFILLER_92_28 VPWR VGND sg13cmos5l_decap_8
XFILLER_489_49 VPWR VGND sg13cmos5l_decap_8
XFILLER_415_160 VPWR VGND sg13cmos5l_decap_4
XFILLER_267_7 VPWR VGND sg13cmos5l_decap_8
XFILLER_214_211 VPWR VGND sg13cmos5l_fill_2
XFILLER_710_98 VPWR VGND sg13cmos5l_fill_2
XFILLER_576_112 VPWR VGND sg13cmos5l_fill_2
XANTENNA__3597__X Tile_X0Y9_FrameData_O[27] VPWR VGND sg13cmos5l_antennanp
XFILLER_26_198 VPWR VGND sg13cmos5l_decap_4
XFILLER_434_7 VPWR VGND sg13cmos5l_decap_8
XFILLER_25_77 VPWR VGND sg13cmos5l_decap_8
XFILLER_576_167 VPWR VGND sg13cmos5l_decap_8
XFILLER_288_50 VPWR VGND sg13cmos5l_decap_8
XFILLER_25_88 VPWR VGND sg13cmos5l_fill_1
XFILLER_41_168 VPWR VGND sg13cmos5l_decap_8
XFILLER_430_196 VPWR VGND sg13cmos5l_decap_8
XFILLER_591_126 VPWR VGND sg13cmos5l_decap_8
XFILLER_601_7 VPWR VGND sg13cmos5l_decap_8
XFILLER_438_42 VPWR VGND sg13cmos5l_decap_8
XFILLER_517_245 VPWR VGND sg13cmos5l_decap_4
XFILLER_585_70 VPWR VGND sg13cmos5l_decap_8
XFILLER_157_21 VPWR VGND sg13cmos5l_decap_8
XFILLER_328_178 VPWR VGND sg13cmos5l_decap_8
XFILLER_194_184 VPWR VGND sg13cmos5l_decap_8
XFILLER_157_43 VPWR VGND sg13cmos5l_decap_8
XFILLER_157_65 VPWR VGND sg13cmos5l_decap_8
XFILLER_532_259 VPWR VGND sg13cmos5l_decap_8
XFILLER_307_35 VPWR VGND sg13cmos5l_decap_8
XFILLER_307_46 VPWR VGND sg13cmos5l_fill_2
XFILLER_671_28 VPWR VGND sg13cmos5l_decap_8
XFILLER_500_112 VPWR VGND sg13cmos5l_decap_8
XFILLER_646_105 VPWR VGND sg13cmos5l_decap_8
XFILLER_150_254 VPWR VGND sg13cmos5l_decap_8
XFILLER_173_42 VPWR VGND sg13cmos5l_decap_8
XFILLER_497_196 VPWR VGND sg13cmos5l_decap_8
XFILLER_173_64 VPWR VGND sg13cmos5l_decap_8
XFILLER_249_141 VPWR VGND sg13cmos5l_fill_1
XFILLER_103_170 VPWR VGND sg13cmos5l_fill_1
XFILLER_293_0 VPWR VGND sg13cmos5l_decap_8
XFILLER_500_189 VPWR VGND sg13cmos5l_decap_8
XFILLER_604_88 VPWR VGND sg13cmos5l_decap_8
XFILLER_103_192 VPWR VGND sg13cmos5l_decap_8
XFILLER_49_246 VPWR VGND sg13cmos5l_decap_8
XFILLER_249_185 VPWR VGND sg13cmos5l_fill_2
XFILLER_654_193 VPWR VGND sg13cmos5l_fill_1
XFILLER_620_21 VPWR VGND sg13cmos5l_decap_8
XFILLER_460_0 VPWR VGND sg13cmos5l_decap_8
XFILLER_264_155 VPWR VGND sg13cmos5l_decap_8
XFILLER_66_84 VPWR VGND sg13cmos5l_decap_8
XFILLER_64_238 VPWR VGND sg13cmos5l_decap_8
XFILLER_558_0 VPWR VGND sg13cmos5l_decap_8
XFILLER_413_119 VPWR VGND sg13cmos5l_decap_8
XFILLER_399_49 VPWR VGND sg13cmos5l_decap_8
XFILLER_406_193 VPWR VGND sg13cmos5l_decap_8
XFILLER_17_176 VPWR VGND sg13cmos5l_decap_8
XFILLER_696_14 VPWR VGND sg13cmos5l_decap_8
XFILLER_567_112 VPWR VGND sg13cmos5l_decap_8
XFILLER_122_90 VPWR VGND sg13cmos5l_decap_8
XFILLER_82_61 VPWR VGND sg13cmos5l_decap_8
XANTENNA__3300__X Tile_X0Y0_E2BEG[0] VPWR VGND sg13cmos5l_antennanp
XFILLER_366_218 VPWR VGND sg13cmos5l_decap_8
XFILLER_421_196 VPWR VGND sg13cmos5l_decap_8
XFILLER_32_168 VPWR VGND sg13cmos5l_fill_1
XFILLER_567_189 VPWR VGND sg13cmos5l_decap_8
X_0951_ _0951_/Q Tile_X0Y0_FrameData[20] VGND VPWR Tile_X0Y9_FrameStrobe[0] latch
XFILLER_709_161 VPWR VGND sg13cmos5l_decap_8
XFILLER_629_63 VPWR VGND sg13cmos5l_decap_8
XFILLER_319_134 VPWR VGND sg13cmos5l_fill_2
XFILLER_348_42 VPWR VGND sg13cmos5l_decap_8
X_3670_ AXI_M_SOC_AWADDR31 Tile_X0Y4_W1END[3] Tile_X0Y4_WW4END[7] Tile_X0Y4_WW4END[15]
+ _4351_/X _1983_/Q _1982_/Q VPWR VGND sg13cmos5l_mux4_1
X_0882_ _0882_/Q Tile_X0Y9_FrameData[13] VGND VPWR Tile_X0Y9_FrameStrobe[6] latch
XFILLER_495_70 VPWR VGND sg13cmos5l_decap_8
X_2621_ _2621_/Q Tile_X0Y6_FrameData[10] VGND VPWR Tile_X0Y9_FrameStrobe[5] latch
X_2552_ _2552_/Q Tile_X0Y6_FrameData[15] VGND VPWR Tile_X0Y9_FrameStrobe[3] latch
XFILLER_99_102 VPWR VGND sg13cmos5l_decap_8
XFILLER_645_84 VPWR VGND sg13cmos5l_decap_8
XFILLER_217_35 VPWR VGND sg13cmos5l_decap_8
XFILLER_99_113 VPWR VGND sg13cmos5l_fill_1
XFILLER_677_230 VPWR VGND sg13cmos5l_decap_8
XFILLER_488_141 VPWR VGND sg13cmos5l_decap_8
X_1503_ _1503_/Q Tile_X0Y2_FrameData[18] VGND VPWR Tile_X0Y9_FrameStrobe[2] latch
XFILLER_581_28 VPWR VGND sg13cmos5l_decap_8
XFILLER_342_170 VPWR VGND sg13cmos5l_decap_8
XFILLER_287_203 VPWR VGND sg13cmos5l_decap_8
XFILLER_99_135 VPWR VGND sg13cmos5l_decap_4
XFILLER_364_63 VPWR VGND sg13cmos5l_decap_8
XFILLER_99_146 VPWR VGND sg13cmos5l_decap_8
X_2483_ _2483_/Q Tile_X0Y6_FrameData[20] VGND VPWR Tile_X0Y9_FrameStrobe[1] latch
X_4222_ _4222_/X _4195_/X _0089_/X _4194_/X Tile_X0Y0_S4END[12] _1729_/Q _1728_/Q
+ VPWR VGND sg13cmos5l_mux4_1
X_1434_ _1434_/Q Tile_X0Y2_FrameData[23] VGND VPWR Tile_X0Y9_FrameStrobe[0] latch
XFILLER_637_138 VPWR VGND sg13cmos5l_decap_8
XFILLER_692_233 VPWR VGND sg13cmos5l_decap_8
XFILLER_287_269 VPWR VGND sg13cmos5l_decap_4
XFILLER_514_77 VPWR VGND sg13cmos5l_decap_8
XFILLER_429_252 VPWR VGND sg13cmos5l_decap_8
X_4153_ _4153_/X Tile_X0Y3_W2MID[2] AXI_M_SOC_BVALID _4209_/X _4208_/X _1835_/Q _1834_/Q
+ VPWR VGND sg13cmos5l_mux4_1
XFILLER_429_263 VPWR VGND sg13cmos5l_fill_2
X_1365_ _1365_/Q Tile_X0Y1_FrameData[4] VGND VPWR Tile_X0Y9_FrameStrobe[5] latch
XFILLER_652_119 VPWR VGND sg13cmos5l_decap_8
XFILLER_444_211 VPWR VGND sg13cmos5l_decap_8
XFILLER_255_122 VPWR VGND sg13cmos5l_decap_8
X_3104_ Tile_X0Y7_E6BEG[2] _4646_/X VPWR VGND sg13cmos5l_buf_1
X_0316_ _0316_/Q Tile_X0Y7_FrameData[3] VGND VPWR Tile_X0Y9_FrameStrobe[4] latch
XFILLER_645_182 VPWR VGND sg13cmos5l_decap_8
X_4084_ _4084_/X _4089_/X Tile_X0Y2_W6END[0] _4088_/X _4084_/A3 _1433_/Q _1432_/Q
+ VPWR VGND sg13cmos5l_mux4_1
X_1296_ _1296_/Q Tile_X0Y1_FrameData[9] VGND VPWR Tile_X0Y9_FrameStrobe[3] latch
XFILLER_530_21 VPWR VGND sg13cmos5l_decap_8
XFILLER_444_255 VPWR VGND sg13cmos5l_decap_4
XFILLER_55_238 VPWR VGND sg13cmos5l_fill_1
X_3035_ Tile_X0Y5_EE4BEG[10] _4398_/X VPWR VGND sg13cmos5l_buf_1
X_0247_ _0247_/Q Tile_X0Y7_FrameData[8] VGND VPWR Tile_X0Y9_FrameStrobe[2] latch
XFILLER_102_49 VPWR VGND sg13cmos5l_decap_8
X_0178_ _0178_/Q Tile_X0Y7_FrameData[13] VGND VPWR Tile_X0Y9_FrameStrobe[0] latch
XFILLER_601_230 VPWR VGND sg13cmos5l_fill_1
XFILLER_412_130 VPWR VGND sg13cmos5l_fill_2
XFILLER_558_145 VPWR VGND sg13cmos5l_decap_8
XFILLER_558_156 VPWR VGND sg13cmos5l_fill_1
XANTENNA__3210__X Tile_X0Y0_N1BEG[2] VPWR VGND sg13cmos5l_antennanp
XFILLER_211_236 VPWR VGND sg13cmos5l_decap_8
X_3937_ _3937_/X Tile_X0Y1_W2MID[2] AXI_M_SOC_ARREADY _3993_/X _3992_/X _1335_/Q _1334_/Q
+ VPWR VGND sg13cmos5l_mux4_1
XFILLER_573_126 VPWR VGND sg13cmos5l_decap_8
XFILLER_539_63 VPWR VGND sg13cmos5l_fill_1
XFILLER_686_80 VPWR VGND sg13cmos5l_decap_8
XFILLER_539_85 VPWR VGND sg13cmos5l_decap_8
XFILLER_539_96 VPWR VGND sg13cmos5l_fill_1
XFILLER_258_42 VPWR VGND sg13cmos5l_decap_8
X_3868_ _3868_/X _3850_/X _0085_/X Tile_X0Y0_S1END[2] Tile_X0Y0_S4END[2] _0975_/Q
+ _0974_/Q VPWR VGND sg13cmos5l_mux4_1
XFILLER_109_229 VPWR VGND sg13cmos5l_decap_8
XFILLER_380_210 VPWR VGND sg13cmos5l_decap_4
XFILLER_258_86 VPWR VGND sg13cmos5l_fill_1
XFILLER_715_175 VPWR VGND sg13cmos5l_decap_8
X_2819_ Tile_X0Y3_E1BEG[1] _4145_/X VPWR VGND sg13cmos5l_buf_1
XFILLER_191_132 VPWR VGND sg13cmos5l_decap_8
X_3799_ _3799_/X _3879_/X _3864_/X _3863_/X _3859_/X _1144_/Q _1143_/Q VPWR VGND sg13cmos5l_mux4_1
XFILLER_11_35 VPWR VGND sg13cmos5l_decap_8
XFILLER_555_51 VPWR VGND sg13cmos5l_decap_8
XFILLER_408_56 VPWR VGND sg13cmos5l_decap_8
XFILLER_127_35 VPWR VGND sg13cmos5l_decap_8
XFILLER_705_21 VPWR VGND sg13cmos5l_decap_8
XFILLER_555_95 VPWR VGND sg13cmos5l_decap_4
XFILLER_479_141 VPWR VGND sg13cmos5l_decap_8
XFILLER_491_28 VPWR VGND sg13cmos5l_decap_8
XFILLER_278_203 VPWR VGND sg13cmos5l_decap_8
XFILLER_274_63 VPWR VGND sg13cmos5l_decap_8
XFILLER_127_79 VPWR VGND sg13cmos5l_decap_4
XFILLER_494_133 VPWR VGND sg13cmos5l_decap_8
XFILLER_705_98 VPWR VGND sg13cmos5l_decap_8
XFILLER_683_255 VPWR VGND sg13cmos5l_fill_2
XFILLER_293_206 VPWR VGND sg13cmos5l_decap_8
XFILLER_424_77 VPWR VGND sg13cmos5l_decap_8
XFILLER_98_190 VPWR VGND sg13cmos5l_fill_1
XFILLER_384_7 VPWR VGND sg13cmos5l_decap_8
XFILLER_643_119 VPWR VGND sg13cmos5l_decap_8
XFILLER_435_200 VPWR VGND sg13cmos5l_decap_8
XFILLER_143_56 VPWR VGND sg13cmos5l_decap_8
XFILLER_100_162 VPWR VGND sg13cmos5l_decap_8
XFILLER_440_21 VPWR VGND sg13cmos5l_decap_8
XFILLER_551_7 VPWR VGND sg13cmos5l_decap_8
XFILLER_36_21 VPWR VGND sg13cmos5l_decap_8
XFILLER_261_103 VPWR VGND sg13cmos5l_decap_8
XFILLER_649_7 VPWR VGND sg13cmos5l_decap_8
XFILLER_651_196 VPWR VGND sg13cmos5l_decap_8
XFILLER_36_65 VPWR VGND sg13cmos5l_decap_8
XFILLER_54_260 VPWR VGND sg13cmos5l_fill_1
XFILLER_440_98 VPWR VGND sg13cmos5l_decap_8
XFILLER_54_271 VPWR VGND sg13cmos5l_fill_2
XFILLER_549_112 VPWR VGND sg13cmos5l_fill_1
XFILLER_299_82 VPWR VGND sg13cmos5l_decap_8
XANTENNA__3120__X Tile_X0Y7_EE4BEG[6] VPWR VGND sg13cmos5l_antennanp
XFILLER_14_168 VPWR VGND sg13cmos5l_decap_8
XFILLER_202_236 VPWR VGND sg13cmos5l_decap_8
XFILLER_52_20 VPWR VGND sg13cmos5l_fill_1
XFILLER_666_28 VPWR VGND sg13cmos5l_decap_8
XFILLER_564_126 VPWR VGND sg13cmos5l_decap_8
XFILLER_596_91 VPWR VGND sg13cmos5l_decap_4
XFILLER_139_0 VPWR VGND sg13cmos5l_decap_8
XFILLER_167_140 VPWR VGND sg13cmos5l_decap_8
XFILLER_52_86 VPWR VGND sg13cmos5l_fill_1
XFILLER_505_204 VPWR VGND sg13cmos5l_fill_2
XFILLER_706_186 VPWR VGND sg13cmos5l_decap_8
XFILLER_182_143 VPWR VGND sg13cmos5l_decap_8
XFILLER_706_197 VPWR VGND sg13cmos5l_fill_1
XFILLER_306_0 VPWR VGND sg13cmos5l_decap_8
XFILLER_520_207 VPWR VGND sg13cmos5l_decap_8
XFILLER_615_21 VPWR VGND sg13cmos5l_decap_8
XFILLER_465_95 VPWR VGND sg13cmos5l_decap_8
XFILLER_324_192 VPWR VGND sg13cmos5l_decap_8
XFILLER_269_258 VPWR VGND sg13cmos5l_decap_8
XFILLER_674_244 VPWR VGND sg13cmos5l_decap_8
XFILLER_675_0 VPWR VGND sg13cmos5l_decap_8
XFILLER_674_255 VPWR VGND sg13cmos5l_fill_2
XFILLER_485_166 VPWR VGND sg13cmos5l_decap_8
XFILLER_284_217 VPWR VGND sg13cmos5l_decap_8
XFILLER_28_7 VPWR VGND sg13cmos5l_decap_8
XFILLER_77_72 VPWR VGND sg13cmos5l_fill_1
XFILLER_634_119 VPWR VGND sg13cmos5l_decap_8
XFILLER_77_94 VPWR VGND sg13cmos5l_decap_8
XFILLER_631_42 VPWR VGND sg13cmos5l_decap_8
XFILLER_627_182 VPWR VGND sg13cmos5l_decap_8
XFILLER_237_133 VPWR VGND sg13cmos5l_decap_8
X_1150_ _1150_/Q Tile_X0Y0_FrameData[13] VGND VPWR Tile_X0Y9_FrameStrobe[6] latch
XFILLER_237_144 VPWR VGND sg13cmos5l_fill_1
XFILLER_350_21 VPWR VGND sg13cmos5l_decap_8
XFILLER_237_155 VPWR VGND sg13cmos5l_decap_8
X_0101_ AXI_M_SOC_ARLEN6 _0933_/Q _3766_/X VPWR VGND sg13cmos5l_nor2b_1
X_1081_ _1081_/Q Tile_X0Y0_FrameData[18] VGND VPWR Tile_X0Y9_FrameStrobe[4] latch
XFILLER_398_118 VPWR VGND sg13cmos5l_fill_1
XFILLER_642_196 VPWR VGND sg13cmos5l_decap_8
XFILLER_252_147 VPWR VGND sg13cmos5l_decap_8
XFILLER_52_219 VPWR VGND sg13cmos5l_decap_8
XFILLER_350_98 VPWR VGND sg13cmos5l_decap_8
XFILLER_441_258 VPWR VGND sg13cmos5l_fill_1
XFILLER_500_35 VPWR VGND sg13cmos5l_decap_8
X_4840_ _4840_/X Tile_X0Y9_W1END[2] Tile_X0Y9_WW4END[14] Tile_X0Y9_W6END[6] _4918_/X
+ _0861_/Q _0860_/Q VPWR VGND sg13cmos5l_mux4_1
XANTENNA__3030__X Tile_X0Y5_EE4BEG[5] VPWR VGND sg13cmos5l_antennanp
XFILLER_595_262 VPWR VGND sg13cmos5l_fill_2
XFILLER_20_105 VPWR VGND sg13cmos5l_decap_8
XFILLER_576_28 VPWR VGND sg13cmos5l_decap_8
X_4771_ _4771_/X AXI_M_SOC_RDATA15 _4800_/X _4804_/X _4784_/X _0505_/Q _0504_/Q VPWR
+ VGND sg13cmos5l_mux4_1
XFILLER_359_63 VPWR VGND sg13cmos5l_decap_8
X_1983_ _1983_/Q Tile_X0Y4_FrameData[6] VGND VPWR Tile_X0Y9_FrameStrobe[1] latch
X_3722_ _3722_/X Tile_X0Y3_WW4END[7] Tile_X0Y3_WW4END[15] Tile_X0Y3_W6END[7] _4229_/X
+ _1743_/Q _1742_/Q VPWR VGND sg13cmos5l_mux4_1
X_0934_ _0934_/Q Tile_X0Y9_FrameData[25] VGND VPWR Tile_X0Y9_FrameStrobe[8] latch
XFILLER_295_29 VPWR VGND sg13cmos5l_decap_8
XFILLER_158_173 VPWR VGND sg13cmos5l_decap_8
XFILLER_158_195 VPWR VGND sg13cmos5l_decap_8
XFILLER_173_121 VPWR VGND sg13cmos5l_decap_8
X_3653_ AXI_M_SOC_AWADDR14 Tile_X0Y5_W1END[2] Tile_X0Y5_WW4END[6] Tile_X0Y5_WW4END[14]
+ _4465_/X _2243_/Q _2242_/Q VPWR VGND sg13cmos5l_mux4_1
XFILLER_509_77 VPWR VGND sg13cmos5l_decap_8
X_0865_ _0865_/Q Tile_X0Y9_FrameData[30] VGND VPWR Tile_X0Y9_FrameStrobe[6] latch
XFILLER_712_112 VPWR VGND sg13cmos5l_decap_8
X_2604_ _2604_/Q Tile_X0Y6_FrameData[27] VGND VPWR Tile_X0Y9_FrameStrobe[5] latch
X_3584_ Tile_X0Y9_FrameData_O[14] Tile_X0Y9_FrameData[14] VPWR VGND sg13cmos5l_buf_1
XFILLER_592_49 VPWR VGND sg13cmos5l_decap_8
X_0796_ _0796_/Q Tile_X0Y9_FrameData[3] VGND VPWR Tile_X0Y9_FrameStrobe[3] latch
XFILLER_525_21 VPWR VGND sg13cmos5l_decap_8
XFILLER_375_95 VPWR VGND sg13cmos5l_decap_4
XFILLER_173_198 VPWR VGND sg13cmos5l_decap_8
X_2535_ _2535_/Q Tile_X0Y6_FrameData[0] VGND VPWR Tile_X0Y9_FrameStrobe[2] latch
XFILLER_712_189 VPWR VGND sg13cmos5l_decap_8
XFILLER_672_82 VPWR VGND sg13cmos5l_decap_8
XFILLER_476_133 VPWR VGND sg13cmos5l_decap_8
X_2466_ _2466_/Q Tile_X0Y6_FrameData[5] VGND VPWR Tile_X0Y9_FrameStrobe[0] latch
XFILLER_665_233 VPWR VGND sg13cmos5l_decap_8
XFILLER_330_162 VPWR VGND sg13cmos5l_decap_8
X_4205_ _4205_/X _4129_/X _4237_/X _4236_/X _4128_/X _1697_/Q _1696_/Q VPWR VGND sg13cmos5l_mux4_1
XFILLER_391_72 VPWR VGND sg13cmos5l_fill_2
XFILLER_244_77 VPWR VGND sg13cmos5l_fill_2
X_1417_ _1417_/Q Tile_X0Y1_FrameData[16] VGND VPWR Tile_X0Y9_FrameStrobe[7] latch
XFILLER_625_119 VPWR VGND sg13cmos5l_decap_8
XFILLER_417_200 VPWR VGND sg13cmos5l_fill_2
XANTENNA__3205__X Tile_X0Y0_N2BEG[5] VPWR VGND sg13cmos5l_antennanp
X_2397_ _2397_/Q Tile_X0Y5_FrameData[8] VGND VPWR Tile_X0Y9_FrameStrobe[6] latch
XFILLER_541_42 VPWR VGND sg13cmos5l_decap_8
XFILLER_228_133 VPWR VGND sg13cmos5l_decap_8
X_4136_ _4136_/X Tile_X0Y1_W1END[0] Tile_X0Y1_W2MID[3] Tile_X0Y1_W2END[3] _3994_/X
+ _1373_/Q _1372_/Q VPWR VGND sg13cmos5l_mux4_1
XFILLER_491_147 VPWR VGND sg13cmos5l_decap_8
XFILLER_3_91 VPWR VGND sg13cmos5l_decap_8
X_1348_ _1348_/Q Tile_X0Y1_FrameData[21] VGND VPWR Tile_X0Y9_FrameStrobe[5] latch
XFILLER_618_193 VPWR VGND sg13cmos5l_decap_8
XFILLER_95_171 VPWR VGND sg13cmos5l_decap_4
XFILLER_283_250 VPWR VGND sg13cmos5l_decap_8
XFILLER_260_21 VPWR VGND sg13cmos5l_decap_8
XFILLER_680_269 VPWR VGND sg13cmos5l_decap_4
XFILLER_283_272 VPWR VGND sg13cmos5l_fill_1
XFILLER_243_103 VPWR VGND sg13cmos5l_decap_8
X_4067_ _4067_/X Tile_X0Y2_WW4END[4] AXI_M_SOC_AWREADY _4120_/X _4102_/X _1539_/Q
+ _1538_/Q VPWR VGND sg13cmos5l_mux4_1
X_1279_ _1279_/Q Tile_X0Y1_FrameData[26] VGND VPWR Tile_X0Y9_FrameStrobe[3] latch
XFILLER_633_174 VPWR VGND sg13cmos5l_decap_4
XFILLER_633_185 VPWR VGND sg13cmos5l_fill_1
XFILLER_243_147 VPWR VGND sg13cmos5l_decap_8
X_3018_ Tile_X0Y5_E6BEG[5] _4409_/X VPWR VGND sg13cmos5l_buf_1
XFILLER_633_196 VPWR VGND sg13cmos5l_fill_2
XFILLER_578_229 VPWR VGND sg13cmos5l_fill_1
XFILLER_43_219 VPWR VGND sg13cmos5l_decap_8
XFILLER_410_35 VPWR VGND sg13cmos5l_decap_8
XFILLER_51_263 VPWR VGND sg13cmos5l_decap_8
XFILLER_251_191 VPWR VGND sg13cmos5l_decap_8
XFILLER_397_184 VPWR VGND sg13cmos5l_decap_8
XFILLER_486_28 VPWR VGND sg13cmos5l_decap_8
XFILLER_400_133 VPWR VGND sg13cmos5l_decap_8
XFILLER_269_63 VPWR VGND sg13cmos5l_fill_2
XFILLER_11_127 VPWR VGND sg13cmos5l_decap_8
XFILLER_132_7 VPWR VGND sg13cmos5l_decap_8
XFILLER_149_151 VPWR VGND sg13cmos5l_decap_4
XFILLER_338_262 VPWR VGND sg13cmos5l_decap_8
XFILLER_353_210 VPWR VGND sg13cmos5l_decap_8
XFILLER_22_56 VPWR VGND sg13cmos5l_decap_8
XFILLER_499_203 VPWR VGND sg13cmos5l_decap_8
XFILLER_419_77 VPWR VGND sg13cmos5l_decap_8
XFILLER_703_112 VPWR VGND sg13cmos5l_decap_8
XFILLER_554_192 VPWR VGND sg13cmos5l_decap_8
XFILLER_138_56 VPWR VGND sg13cmos5l_decap_8
XFILLER_164_154 VPWR VGND sg13cmos5l_decap_8
XFILLER_703_156 VPWR VGND sg13cmos5l_decap_8
XFILLER_285_84 VPWR VGND sg13cmos5l_decap_8
XFILLER_499_269 VPWR VGND sg13cmos5l_decap_4
XFILLER_435_21 VPWR VGND sg13cmos5l_decap_8
XFILLER_105_243 VPWR VGND sg13cmos5l_fill_1
XFILLER_599_7 VPWR VGND sg13cmos5l_decap_8
XFILLER_467_100 VPWR VGND sg13cmos5l_decap_8
XFILLER_321_140 VPWR VGND sg13cmos5l_decap_8
XFILLER_435_98 VPWR VGND sg13cmos5l_decap_8
XFILLER_120_235 VPWR VGND sg13cmos5l_decap_8
XFILLER_154_77 VPWR VGND sg13cmos5l_decap_8
XFILLER_304_14 VPWR VGND sg13cmos5l_decap_8
XFILLER_219_111 VPWR VGND sg13cmos5l_decap_8
XANTENNA__3115__X Tile_X0Y7_EE4BEG[1] VPWR VGND sg13cmos5l_antennanp
XFILLER_451_42 VPWR VGND sg13cmos5l_decap_8
XFILLER_482_147 VPWR VGND sg13cmos5l_decap_8
XFILLER_170_21 VPWR VGND sg13cmos5l_decap_8
XFILLER_219_155 VPWR VGND sg13cmos5l_decap_8
XFILLER_86_182 VPWR VGND sg13cmos5l_decap_8
XANTENNA__2954__X Tile_X0Y8_EE4BEG[10] VPWR VGND sg13cmos5l_antennanp
XFILLER_423_225 VPWR VGND sg13cmos5l_decap_4
XFILLER_601_56 VPWR VGND sg13cmos5l_decap_8
XFILLER_170_98 VPWR VGND sg13cmos5l_decap_8
XFILLER_256_0 VPWR VGND sg13cmos5l_decap_8
XFILLER_320_68 VPWR VGND sg13cmos5l_fill_1
XFILLER_63_63 VPWR VGND sg13cmos5l_decap_8
XFILLER_388_173 VPWR VGND sg13cmos5l_decap_4
XFILLER_396_28 VPWR VGND sg13cmos5l_decap_8
XFILLER_537_126 VPWR VGND sg13cmos5l_fill_2
XFILLER_179_74 VPWR VGND sg13cmos5l_decap_8
XFILLER_8_14 VPWR VGND sg13cmos5l_decap_8
XFILLER_179_85 VPWR VGND sg13cmos5l_fill_1
XFILLER_423_0 VPWR VGND sg13cmos5l_decap_8
XFILLER_329_22 VPWR VGND sg13cmos5l_decap_8
XFILLER_592_254 VPWR VGND sg13cmos5l_decap_8
XFILLER_626_42 VPWR VGND sg13cmos5l_decap_8
XFILLER_560_140 VPWR VGND sg13cmos5l_decap_8
X_0650_ _0650_/Q Tile_X0Y8_FrameData[21] VGND VPWR Tile_X0Y9_FrameStrobe[7] latch
XFILLER_6_175 VPWR VGND sg13cmos5l_decap_8
XFILLER_345_21 VPWR VGND sg13cmos5l_decap_8
XFILLER_304_129 VPWR VGND sg13cmos5l_decap_8
XFILLER_170_146 VPWR VGND sg13cmos5l_decap_4
XFILLER_626_97 VPWR VGND sg13cmos5l_decap_8
X_0581_ _0581_/Q Tile_X0Y8_FrameData[26] VGND VPWR Tile_X0Y9_FrameStrobe[5] latch
XFILLER_458_111 VPWR VGND sg13cmos5l_fill_1
X_2320_ _2320_/Q Tile_X0Y5_FrameData[21] VGND VPWR Tile_X0Y9_FrameStrobe[4] latch
XFILLER_69_105 VPWR VGND sg13cmos5l_decap_8
XFILLER_111_202 VPWR VGND sg13cmos5l_decap_4
XFILLER_111_235 VPWR VGND sg13cmos5l_decap_8
XFILLER_647_266 VPWR VGND sg13cmos5l_decap_8
XFILLER_214_14 VPWR VGND sg13cmos5l_decap_8
X_2251_ _2251_/Q Tile_X0Y5_FrameData[26] VGND VPWR Tile_X0Y9_FrameStrobe[2] latch
XFILLER_642_63 VPWR VGND sg13cmos5l_decap_8
XFILLER_458_188 VPWR VGND sg13cmos5l_fill_2
XANTENNA__3025__X Tile_X0Y5_EE4BEG[0] VPWR VGND sg13cmos5l_antennanp
XFILLER_473_136 VPWR VGND sg13cmos5l_fill_2
XFILLER_361_42 VPWR VGND sg13cmos5l_decap_8
X_1202_ _1202_/Q Tile_X0Y1_FrameData[7] VGND VPWR Tile_X0Y9_FrameStrobe[0] latch
XFILLER_662_236 VPWR VGND sg13cmos5l_decap_8
X_2182_ _2182_/Q Tile_X0Y4_FrameData[31] VGND VPWR Tile_X0Y9_FrameStrobe[0] latch
XFILLER_272_209 VPWR VGND sg13cmos5l_decap_8
XFILLER_77_193 VPWR VGND sg13cmos5l_decap_8
XANTENNA__2864__X Tile_X0Y6_EE4BEG[1] VPWR VGND sg13cmos5l_antennanp
X_1133_ _1133_/Q Tile_X0Y0_FrameData[30] VGND VPWR Tile_X0Y9_FrameStrobe[6] latch
XFILLER_92_141 VPWR VGND sg13cmos5l_decap_4
XFILLER_92_152 VPWR VGND sg13cmos5l_decap_8
XFILLER_511_56 VPWR VGND sg13cmos5l_decap_8
XFILLER_414_236 VPWR VGND sg13cmos5l_decap_8
XFILLER_25_208 VPWR VGND sg13cmos5l_decap_8
X_1064_ _1064_/Q Tile_X0Y0_FrameData[3] VGND VPWR Tile_X0Y9_FrameStrobe[3] latch
XFILLER_630_133 VPWR VGND sg13cmos5l_decap_8
XFILLER_230_35 VPWR VGND sg13cmos5l_decap_4
XFILLER_630_155 VPWR VGND sg13cmos5l_fill_1
XFILLER_379_140 VPWR VGND sg13cmos5l_decap_4
XFILLER_230_79 VPWR VGND sg13cmos5l_fill_2
XFILLER_587_49 VPWR VGND sg13cmos5l_decap_8
X_4823_ _4823_/X Tile_X0Y7_W1END[3] Tile_X0Y7_W2MID[0] Tile_X0Y7_W2END[0] _4668_/X
+ _0357_/Q _0356_/Q VPWR VGND sg13cmos5l_mux4_1
XANTENNA__3695__X AXI_M_SOC_WDATA5 VPWR VGND sg13cmos5l_antennanp
XFILLER_528_148 VPWR VGND sg13cmos5l_decap_4
XFILLER_583_243 VPWR VGND sg13cmos5l_decap_8
X_4754_ _4754_/X Tile_X0Y8_WW4END[5] AXI_M_SOC_RDATA13 _4805_/X _4788_/X _0539_/Q
+ _0538_/Q VPWR VGND sg13cmos5l_mux4_1
X_1966_ _1966_/Q Tile_X0Y4_FrameData[23] VGND VPWR Tile_X0Y9_FrameStrobe[1] latch
XFILLER_394_198 VPWR VGND sg13cmos5l_decap_8
X_3705_ AXI_M_SOC_WDATA15 Tile_X0Y7_W1END[3] Tile_X0Y7_WW4END[7] Tile_X0Y7_WW4END[15]
+ _4699_/X _0217_/Q _0216_/Q VPWR VGND sg13cmos5l_mux4_1
X_0917_ _0917_/Q Tile_X0Y9_FrameData[10] VGND VPWR Tile_X0Y9_FrameStrobe[7] latch
X_4685_ _4685_/X _4663_/X Tile_X0Y9_N4END[9] _4662_/X _0055_/X _0213_/Q _0212_/Q VPWR
+ VGND sg13cmos5l_mux4_1
X_1897_ _1897_/Q Tile_X0Y3_FrameData[0] VGND VPWR Tile_X0Y9_FrameStrobe[6] latch
XFILLER_536_42 VPWR VGND sg13cmos5l_decap_8
X_3636_ Tile_X0Y9_S4BEG[14] _3636_/A VPWR VGND sg13cmos5l_buf_1
X_0848_ _0848_/Q Tile_X0Y9_FrameData[15] VGND VPWR Tile_X0Y9_FrameStrobe[5] latch
XFILLER_350_202 VPWR VGND sg13cmos5l_decap_8
XFILLER_161_124 VPWR VGND sg13cmos5l_decap_8
XFILLER_255_43 VPWR VGND sg13cmos5l_decap_8
X_3567_ Tile_X0Y9_EE4BEG[13] _4877_/X VPWR VGND sg13cmos5l_buf_1
X_0779_ _0779_/Q Tile_X0Y9_FrameData[20] VGND VPWR Tile_X0Y9_FrameStrobe[3] latch
X_2518_ _2518_/Q Tile_X0Y6_FrameData[17] VGND VPWR Tile_X0Y9_FrameStrobe[2] latch
X_3498_ Tile_X0Y1_E6BEG[8] _3972_/X VPWR VGND sg13cmos5l_buf_1
XFILLER_405_35 VPWR VGND sg13cmos5l_decap_8
XFILLER_449_166 VPWR VGND sg13cmos5l_decap_8
XFILLER_303_184 VPWR VGND sg13cmos5l_fill_1
XFILLER_248_217 VPWR VGND sg13cmos5l_decap_8
XFILLER_552_63 VPWR VGND sg13cmos5l_decap_8
XFILLER_124_14 VPWR VGND sg13cmos5l_decap_8
X_2449_ _2449_/Q Tile_X0Y6_FrameData[22] VGND VPWR Tile_X0Y9_FrameStrobe[0] latch
XFILLER_248_239 VPWR VGND sg13cmos5l_fill_2
XFILLER_102_268 VPWR VGND sg13cmos5l_decap_4
XFILLER_552_96 VPWR VGND sg13cmos5l_decap_8
XFILLER_271_42 VPWR VGND sg13cmos5l_decap_8
XFILLER_464_147 VPWR VGND sg13cmos5l_fill_2
XFILLER_606_130 VPWR VGND sg13cmos5l_decap_8
XFILLER_68_182 VPWR VGND sg13cmos5l_decap_8
XANTENNA__2774__X Tile_X0Y3_EE4BEG[0] VPWR VGND sg13cmos5l_antennanp
X_4119_ _4119_/X _4095_/X _0094_/X _4094_/X Tile_X0Y0_S4END[11] _1475_/Q _1474_/Q
+ VPWR VGND sg13cmos5l_mux4_1
XFILLER_702_77 VPWR VGND sg13cmos5l_decap_8
XFILLER_216_114 VPWR VGND sg13cmos5l_decap_4
XFILLER_606_163 VPWR VGND sg13cmos5l_fill_2
XFILLER_421_56 VPWR VGND sg13cmos5l_decap_8
XFILLER_405_236 VPWR VGND sg13cmos5l_decap_8
XFILLER_621_122 VPWR VGND sg13cmos5l_decap_8
XFILLER_17_56 VPWR VGND sg13cmos5l_fill_2
XFILLER_140_35 VPWR VGND sg13cmos5l_decap_8
XFILLER_231_128 VPWR VGND sg13cmos5l_fill_1
XFILLER_497_49 VPWR VGND sg13cmos5l_decap_8
XFILLER_420_239 VPWR VGND sg13cmos5l_decap_8
XFILLER_347_7 VPWR VGND sg13cmos5l_decap_8
XFILLER_621_199 VPWR VGND sg13cmos5l_decap_8
XFILLER_169_224 VPWR VGND sg13cmos5l_decap_8
XFILLER_574_210 VPWR VGND sg13cmos5l_decap_8
XFILLER_519_137 VPWR VGND sg13cmos5l_decap_8
XFILLER_33_55 VPWR VGND sg13cmos5l_decap_8
XFILLER_514_7 VPWR VGND sg13cmos5l_decap_8
XFILLER_296_72 VPWR VGND sg13cmos5l_fill_1
XFILLER_326_221 VPWR VGND sg13cmos5l_decap_8
XFILLER_137_154 VPWR VGND sg13cmos5l_decap_8
XFILLER_542_140 VPWR VGND sg13cmos5l_decap_8
XFILLER_137_176 VPWR VGND sg13cmos5l_decap_8
XFILLER_446_64 VPWR VGND sg13cmos5l_decap_8
XFILLER_165_21 VPWR VGND sg13cmos5l_fill_2
XFILLER_3_112 VPWR VGND sg13cmos5l_decap_8
XFILLER_298_117 VPWR VGND sg13cmos5l_decap_8
XFILLER_593_92 VPWR VGND sg13cmos5l_fill_2
XFILLER_3_123 VPWR VGND sg13cmos5l_fill_2
XANTENNA__2949__X Tile_X0Y8_EE4BEG[5] VPWR VGND sg13cmos5l_antennanp
XFILLER_152_146 VPWR VGND sg13cmos5l_decap_8
XFILLER_629_211 VPWR VGND sg13cmos5l_decap_8
XFILLER_165_98 VPWR VGND sg13cmos5l_fill_2
XFILLER_3_189 VPWR VGND sg13cmos5l_decap_8
XFILLER_315_35 VPWR VGND sg13cmos5l_decap_8
XFILLER_58_30 VPWR VGND sg13cmos5l_decap_8
XFILLER_462_63 VPWR VGND sg13cmos5l_fill_2
XFILLER_455_103 VPWR VGND sg13cmos5l_decap_8
XFILLER_644_203 VPWR VGND sg13cmos5l_decap_8
XFILLER_455_125 VPWR VGND sg13cmos5l_decap_4
XFILLER_181_42 VPWR VGND sg13cmos5l_decap_8
XFILLER_58_74 VPWR VGND sg13cmos5l_decap_8
XFILLER_455_136 VPWR VGND sg13cmos5l_decap_8
XFILLER_66_119 VPWR VGND sg13cmos5l_decap_8
XFILLER_455_158 VPWR VGND sg13cmos5l_fill_2
XFILLER_59_193 VPWR VGND sg13cmos5l_decap_8
XFILLER_373_0 VPWR VGND sg13cmos5l_decap_8
XFILLER_74_141 VPWR VGND sg13cmos5l_decap_8
XFILLER_612_99 VPWR VGND sg13cmos5l_decap_8
XFILLER_262_231 VPWR VGND sg13cmos5l_fill_2
XFILLER_207_147 VPWR VGND sg13cmos5l_decap_4
XFILLER_463_191 VPWR VGND sg13cmos5l_decap_8
XFILLER_331_78 VPWR VGND sg13cmos5l_decap_8
XFILLER_540_0 VPWR VGND sg13cmos5l_decap_8
XFILLER_638_0 VPWR VGND sg13cmos5l_decap_8
XFILLER_15_241 VPWR VGND sg13cmos5l_decap_8
XFILLER_612_188 VPWR VGND sg13cmos5l_decap_8
XFILLER_411_228 VPWR VGND sg13cmos5l_decap_8
XFILLER_200_49 VPWR VGND sg13cmos5l_decap_8
XFILLER_95_7 VPWR VGND sg13cmos5l_decap_8
XFILLER_230_150 VPWR VGND sg13cmos5l_decap_8
XFILLER_565_232 VPWR VGND sg13cmos5l_decap_8
XFILLER_376_143 VPWR VGND sg13cmos5l_decap_4
X_1820_ _1820_/Q Tile_X0Y3_FrameData[13] VGND VPWR Tile_X0Y9_FrameStrobe[4] latch
XFILLER_565_254 VPWR VGND sg13cmos5l_fill_2
XFILLER_487_93 VPWR VGND sg13cmos5l_fill_1
XFILLER_714_207 VPWR VGND sg13cmos5l_fill_2
XFILLER_525_107 VPWR VGND sg13cmos5l_decap_8
XFILLER_376_187 VPWR VGND sg13cmos5l_fill_2
XFILLER_317_210 VPWR VGND sg13cmos5l_decap_8
X_1751_ _1751_/Q Tile_X0Y3_FrameData[18] VGND VPWR Tile_X0Y9_FrameStrobe[2] latch
XFILLER_637_63 VPWR VGND sg13cmos5l_decap_8
XFILLER_209_14 VPWR VGND sg13cmos5l_decap_8
XFILLER_391_168 VPWR VGND sg13cmos5l_fill_1
XFILLER_317_254 VPWR VGND sg13cmos5l_fill_1
X_0702_ _0702_/Q Tile_X0Y9_FrameData[1] VGND VPWR Tile_X0Y9_FrameStrobe[0] latch
XFILLER_637_96 VPWR VGND sg13cmos5l_decap_8
XFILLER_356_42 VPWR VGND sg13cmos5l_decap_8
X_4470_ _4470_/X Tile_X0Y4_W2MID[6] Tile_X0Y4_W2END[6] Tile_X0Y4_W6END[9] _4315_/X
+ _2135_/Q _2134_/Q VPWR VGND sg13cmos5l_mux4_1
XFILLER_533_151 VPWR VGND sg13cmos5l_decap_8
XFILLER_183_271 VPWR VGND sg13cmos5l_fill_2
X_1682_ _1682_/Q Tile_X0Y3_FrameData[23] VGND VPWR Tile_X0Y9_FrameStrobe[0] latch
XFILLER_679_144 VPWR VGND sg13cmos5l_decap_8
XFILLER_332_213 VPWR VGND sg13cmos5l_decap_8
XFILLER_99_70 VPWR VGND sg13cmos5l_decap_4
X_3421_ Tile_X0Y4_FrameData_O[12] Tile_X0Y4_FrameData[12] VPWR VGND sg13cmos5l_buf_1
XANTENNA__2859__X Tile_X0Y6_E6BEG[8] VPWR VGND sg13cmos5l_antennanp
X_0633_ _0633_/Q Tile_X0Y8_FrameData[6] VGND VPWR Tile_X0Y9_FrameStrobe[6] latch
XFILLER_694_114 VPWR VGND sg13cmos5l_fill_2
XFILLER_506_56 VPWR VGND sg13cmos5l_decap_8
XFILLER_143_179 VPWR VGND sg13cmos5l_decap_8
X_3352_ Tile_X0Y2_FrameData_O[23] Tile_X0Y2_FrameData[23] VPWR VGND sg13cmos5l_buf_1
X_0564_ _0564_/Q Tile_X0Y8_FrameData[11] VGND VPWR Tile_X0Y9_FrameStrobe[4] latch
XFILLER_653_84 VPWR VGND sg13cmos5l_decap_8
XFILLER_225_35 VPWR VGND sg13cmos5l_decap_8
XFILLER_493_209 VPWR VGND sg13cmos5l_fill_2
X_2303_ _2303_/Q Tile_X0Y5_FrameData[6] VGND VPWR Tile_X0Y9_FrameStrobe[3] latch
XFILLER_635_203 VPWR VGND sg13cmos5l_decap_8
XFILLER_300_121 VPWR VGND sg13cmos5l_decap_8
X_3283_ Tile_X0Y0_E6BEG[3] _3839_/X VPWR VGND sg13cmos5l_buf_1
X_0495_ _0495_/Q Tile_X0Y8_FrameData[16] VGND VPWR Tile_X0Y9_FrameStrobe[2] latch
XFILLER_446_125 VPWR VGND sg13cmos5l_fill_2
X_2234_ _2234_/Q Tile_X0Y5_FrameData[11] VGND VPWR Tile_X0Y9_FrameStrobe[1] latch
XFILLER_245_209 VPWR VGND sg13cmos5l_decap_8
XFILLER_17_0 VPWR VGND sg13cmos5l_decap_8
XFILLER_305_90 VPWR VGND sg13cmos5l_decap_8
XFILLER_300_198 VPWR VGND sg13cmos5l_fill_2
XFILLER_650_217 VPWR VGND sg13cmos5l_decap_8
X_2165_ _2165_/Q Tile_X0Y4_FrameData[16] VGND VPWR Tile_X0Y9_FrameStrobe[7] latch
XFILLER_241_56 VPWR VGND sg13cmos5l_fill_2
X_1116_ _1116_/Q Tile_X0Y0_FrameData[15] VGND VPWR Tile_X0Y9_FrameStrobe[5] latch
XFILLER_253_253 VPWR VGND sg13cmos5l_decap_8
X_2096_ _2096_/Q Tile_X0Y4_FrameData[21] VGND VPWR Tile_X0Y9_FrameStrobe[5] latch
XFILLER_65_196 VPWR VGND sg13cmos5l_decap_8
XFILLER_0_70 VPWR VGND sg13cmos5l_decap_8
XFILLER_603_166 VPWR VGND sg13cmos5l_decap_8
XFILLER_399_268 VPWR VGND sg13cmos5l_decap_4
X_1047_ _1047_/Q Tile_X0Y0_FrameData[20] VGND VPWR Tile_X0Y9_FrameStrobe[3] latch
XFILLER_367_121 VPWR VGND sg13cmos5l_decap_8
XFILLER_21_211 VPWR VGND sg13cmos5l_decap_8
XFILLER_221_183 VPWR VGND sg13cmos5l_fill_2
X_4806_ _4806_/X _4781_/X Tile_X0Y9_N4END[6] _4780_/X _0075_/X _0459_/Q _0458_/Q VPWR
+ VGND sg13cmos5l_mux4_1
XFILLER_397_93 VPWR VGND sg13cmos5l_decap_8
XFILLER_166_227 VPWR VGND sg13cmos5l_decap_8
X_2998_ Tile_X0Y5_E2BEG[1] _4373_/X VPWR VGND sg13cmos5l_buf_1
XFILLER_516_118 VPWR VGND sg13cmos5l_decap_4
XFILLER_367_198 VPWR VGND sg13cmos5l_decap_8
XFILLER_547_63 VPWR VGND sg13cmos5l_decap_8
XFILLER_119_14 VPWR VGND sg13cmos5l_decap_8
X_1949_ _1949_/Q Tile_X0Y4_FrameData[8] VGND VPWR Tile_X0Y9_FrameStrobe[0] latch
X_4737_ _4737_/X Tile_X0Y8_W2END[6] AXI_M_SOC_RDATA14 _4787_/X _4786_/X _0573_/Q _0572_/Q
+ VPWR VGND sg13cmos5l_mux4_1
XFILLER_524_140 VPWR VGND sg13cmos5l_fill_1
XFILLER_266_42 VPWR VGND sg13cmos5l_decap_8
XFILLER_119_176 VPWR VGND sg13cmos5l_decap_8
X_4668_ _4668_/X _4599_/X _4715_/X _4714_/X _4598_/X _0169_/Q _0168_/Q VPWR VGND sg13cmos5l_mux4_1
XFILLER_483_29 VPWR VGND sg13cmos5l_decap_8
XFILLER_524_173 VPWR VGND sg13cmos5l_fill_2
XFILLER_134_135 VPWR VGND sg13cmos5l_decap_8
XANTENNA__2769__X Tile_X0Y3_FrameData_O[27] VPWR VGND sg13cmos5l_antennanp
X_3619_ Tile_X0Y9_S2BEGb[5] _4937_/X VPWR VGND sg13cmos5l_buf_1
XFILLER_323_235 VPWR VGND sg13cmos5l_decap_8
X_4599_ _4599_/X Tile_X0Y8_W2MID[0] Tile_X0Y8_W2END[0] Tile_X0Y8_W6END[0] _4784_/X
+ _0649_/Q _0648_/Q VPWR VGND sg13cmos5l_mux4_1
XFILLER_416_56 VPWR VGND sg13cmos5l_decap_8
XFILLER_135_35 VPWR VGND sg13cmos5l_decap_8
XFILLER_563_84 VPWR VGND sg13cmos5l_decap_8
XFILLER_484_209 VPWR VGND sg13cmos5l_decap_8
XFILLER_288_150 VPWR VGND sg13cmos5l_decap_8
XFILLER_713_21 VPWR VGND sg13cmos5l_fill_1
XFILLER_88_233 VPWR VGND sg13cmos5l_fill_1
XFILLER_282_63 VPWR VGND sg13cmos5l_decap_8
XFILLER_88_255 VPWR VGND sg13cmos5l_decap_4
XFILLER_713_54 VPWR VGND sg13cmos5l_decap_8
XFILLER_95_28 VPWR VGND sg13cmos5l_decap_8
XFILLER_437_147 VPWR VGND sg13cmos5l_fill_2
XFILLER_452_106 VPWR VGND sg13cmos5l_decap_8
XFILLER_229_272 VPWR VGND sg13cmos5l_fill_1
XFILLER_641_217 VPWR VGND sg13cmos5l_decap_8
XFILLER_56_130 VPWR VGND sg13cmos5l_decap_8
XFILLER_432_77 VPWR VGND sg13cmos5l_decap_8
XFILLER_28_55 VPWR VGND sg13cmos5l_decap_8
XFILLER_464_7 VPWR VGND sg13cmos5l_decap_8
XFILLER_452_128 VPWR VGND sg13cmos5l_fill_2
XFILLER_151_56 VPWR VGND sg13cmos5l_decap_8
XFILLER_178_4 VPWR VGND sg13cmos5l_fill_1
XFILLER_56_174 VPWR VGND sg13cmos5l_fill_1
XFILLER_56_185 VPWR VGND sg13cmos5l_decap_8
XFILLER_301_15 VPWR VGND sg13cmos5l_decap_8
XFILLER_71_133 VPWR VGND sg13cmos5l_decap_8
XFILLER_631_7 VPWR VGND sg13cmos5l_decap_8
XFILLER_588_70 VPWR VGND sg13cmos5l_decap_8
XFILLER_44_87 VPWR VGND sg13cmos5l_decap_8
XFILLER_212_161 VPWR VGND sg13cmos5l_decap_8
XFILLER_358_154 VPWR VGND sg13cmos5l_decap_8
XFILLER_12_255 VPWR VGND sg13cmos5l_decap_8
XFILLER_157_227 VPWR VGND sg13cmos5l_decap_8
XFILLER_8_226 VPWR VGND sg13cmos5l_fill_1
XFILLER_562_213 VPWR VGND sg13cmos5l_decap_8
XFILLER_674_28 VPWR VGND sg13cmos5l_decap_8
XFILLER_121_0 VPWR VGND sg13cmos5l_decap_8
XFILLER_8_259 VPWR VGND sg13cmos5l_fill_1
XFILLER_176_42 VPWR VGND sg13cmos5l_decap_4
XFILLER_219_0 VPWR VGND sg13cmos5l_decap_8
XFILLER_125_102 VPWR VGND sg13cmos5l_decap_8
XFILLER_393_29 VPWR VGND sg13cmos5l_fill_2
XFILLER_314_202 VPWR VGND sg13cmos5l_decap_8
XFILLER_60_97 VPWR VGND sg13cmos5l_fill_2
XFILLER_314_246 VPWR VGND sg13cmos5l_decap_8
XFILLER_607_88 VPWR VGND sg13cmos5l_decap_4
XFILLER_326_45 VPWR VGND sg13cmos5l_decap_8
XFILLER_140_105 VPWR VGND sg13cmos5l_decap_8
XFILLER_530_165 VPWR VGND sg13cmos5l_decap_8
XFILLER_473_73 VPWR VGND sg13cmos5l_decap_8
XFILLER_690_49 VPWR VGND sg13cmos5l_decap_8
XFILLER_623_21 VPWR VGND sg13cmos5l_decap_8
XFILLER_530_187 VPWR VGND sg13cmos5l_decap_8
XFILLER_490_0 VPWR VGND sg13cmos5l_decap_8
XFILLER_69_84 VPWR VGND sg13cmos5l_decap_8
XFILLER_279_161 VPWR VGND sg13cmos5l_decap_8
XFILLER_588_0 VPWR VGND sg13cmos5l_decap_8
XFILLER_468_272 VPWR VGND sg13cmos5l_fill_1
XFILLER_279_172 VPWR VGND sg13cmos5l_fill_2
XFILLER_192_74 VPWR VGND sg13cmos5l_decap_8
XFILLER_428_147 VPWR VGND sg13cmos5l_decap_8
X_0280_ _0280_/Q Tile_X0Y7_FrameData[7] VGND VPWR Tile_X0Y9_FrameStrobe[3] latch
XFILLER_623_98 VPWR VGND sg13cmos5l_decap_8
XFILLER_617_258 VPWR VGND sg13cmos5l_fill_1
XFILLER_342_66 VPWR VGND sg13cmos5l_fill_1
XFILLER_10_7 VPWR VGND sg13cmos5l_decap_8
XFILLER_699_36 VPWR VGND sg13cmos5l_decap_8
XFILLER_94_269 VPWR VGND sg13cmos5l_decap_4
XFILLER_47_141 VPWR VGND sg13cmos5l_decap_8
XFILLER_342_88 VPWR VGND sg13cmos5l_decap_8
XANTENNA__3303__X Tile_X0Y0_E2BEG[3] VPWR VGND sg13cmos5l_antennanp
XFILLER_632_239 VPWR VGND sg13cmos5l_decap_8
XFILLER_235_253 VPWR VGND sg13cmos5l_decap_8
XFILLER_451_161 VPWR VGND sg13cmos5l_decap_8
X_3970_ _3970_/X AXI_M_SOC_ARREADY _4013_/X _4017_/X _3993_/X _1269_/Q _1268_/Q VPWR
+ VGND sg13cmos5l_mux4_1
XFILLER_600_114 VPWR VGND sg13cmos5l_fill_2
XFILLER_62_166 VPWR VGND sg13cmos5l_decap_8
XFILLER_396_227 VPWR VGND sg13cmos5l_decap_8
XFILLER_498_70 VPWR VGND sg13cmos5l_decap_8
XFILLER_250_256 VPWR VGND sg13cmos5l_decap_8
X_2921_ Tile_X0Y8_E2BEG[5] _4733_/X VPWR VGND sg13cmos5l_buf_1
XFILLER_349_154 VPWR VGND sg13cmos5l_decap_8
XFILLER_349_165 VPWR VGND sg13cmos5l_fill_1
X_2852_ Tile_X0Y6_E6BEG[1] _4529_/X VPWR VGND sg13cmos5l_buf_1
XFILLER_648_84 VPWR VGND sg13cmos5l_decap_8
XFILLER_349_187 VPWR VGND sg13cmos5l_decap_8
X_1803_ _1803_/Q Tile_X0Y3_FrameData[30] VGND VPWR Tile_X0Y9_FrameStrobe[4] latch
XFILLER_584_28 VPWR VGND sg13cmos5l_decap_8
X_2783_ Tile_X0Y3_EE4BEG[9] _4173_/X VPWR VGND sg13cmos5l_buf_1
XFILLER_553_246 VPWR VGND sg13cmos5l_decap_8
XFILLER_364_146 VPWR VGND sg13cmos5l_decap_8
XFILLER_553_268 VPWR VGND sg13cmos5l_decap_4
XFILLER_156_260 VPWR VGND sg13cmos5l_fill_2
X_4522_ _4522_/X Tile_X0Y6_WW4END[5] AXI_M_SOC_RDATA29 _4573_/X _4556_/X _2563_/Q
+ _2562_/Q VPWR VGND sg13cmos5l_mux4_1
X_1734_ _1734_/Q Tile_X0Y3_FrameData[3] VGND VPWR Tile_X0Y9_FrameStrobe[1] latch
X_4453_ _4453_/X _4424_/X _0100_/X _4423_/X _0140_/X _2233_/Q _2232_/Q VPWR VGND sg13cmos5l_mux4_1
XFILLER_710_210 VPWR VGND sg13cmos5l_decap_8
XFILLER_171_241 VPWR VGND sg13cmos5l_decap_4
X_1665_ _1665_/Q Tile_X0Y2_FrameData[16] VGND VPWR Tile_X0Y9_FrameStrobe[7] latch
XFILLER_710_221 VPWR VGND sg13cmos5l_fill_2
XFILLER_305_246 VPWR VGND sg13cmos5l_decap_8
XFILLER_171_252 VPWR VGND sg13cmos5l_decap_8
XFILLER_664_94 VPWR VGND sg13cmos5l_fill_2
XFILLER_305_268 VPWR VGND sg13cmos5l_decap_4
XFILLER_116_179 VPWR VGND sg13cmos5l_decap_8
X_3404_ Tile_X0Y2_E2BEG[7] _4047_/X VPWR VGND sg13cmos5l_buf_1
XFILLER_521_154 VPWR VGND sg13cmos5l_fill_1
X_0616_ _0616_/Q Tile_X0Y8_FrameData[23] VGND VPWR Tile_X0Y9_FrameStrobe[6] latch
X_4384_ _4384_/X Tile_X0Y5_W2END[3] AXI_M_SOC_RRESP1 _4434_/X _4433_/X _2335_/Q _2334_/Q
+ VPWR VGND sg13cmos5l_mux4_1
XFILLER_383_84 VPWR VGND sg13cmos5l_decap_8
X_1596_ _1596_/Q Tile_X0Y2_FrameData[21] VGND VPWR Tile_X0Y9_FrameStrobe[5] latch
XFILLER_533_21 VPWR VGND sg13cmos5l_decap_8
XFILLER_124_190 VPWR VGND sg13cmos5l_decap_8
X_3335_ Tile_X0Y2_FrameData_O[6] Tile_X0Y2_FrameData[6] VPWR VGND sg13cmos5l_buf_1
XFILLER_459_272 VPWR VGND sg13cmos5l_fill_1
X_0547_ _0547_/Q Tile_X0Y8_FrameData[28] VGND VPWR Tile_X0Y9_FrameStrobe[4] latch
XFILLER_419_136 VPWR VGND sg13cmos5l_fill_1
XFILLER_474_231 VPWR VGND sg13cmos5l_decap_8
X_3266_ Tile_X0Y0_EE4BEG[2] _3822_/X VPWR VGND sg13cmos5l_buf_1
XFILLER_419_158 VPWR VGND sg13cmos5l_decap_8
XFILLER_105_49 VPWR VGND sg13cmos5l_decap_8
X_0478_ _0478_/Q Tile_X0Y8_FrameData[1] VGND VPWR Tile_X0Y9_FrameStrobe[1] latch
XFILLER_285_175 VPWR VGND sg13cmos5l_decap_8
X_2217_ _2217_/Q Tile_X0Y5_FrameData[28] VGND VPWR Tile_X0Y9_FrameStrobe[1] latch
XFILLER_402_14 VPWR VGND sg13cmos5l_decap_8
X_3197_ Tile_X0Y0_N2BEGb[5] _3899_/X VPWR VGND sg13cmos5l_buf_1
XANTENNA__3213__X Tile_X0Y0_FrameStrobe_O[1] VPWR VGND sg13cmos5l_antennanp
XFILLER_690_194 VPWR VGND sg13cmos5l_fill_2
X_2148_ _2148_/Q Tile_X0Y4_FrameData[1] VGND VPWR Tile_X0Y9_FrameStrobe[6] latch
XFILLER_588_132 VPWR VGND sg13cmos5l_decap_8
XFILLER_588_143 VPWR VGND sg13cmos5l_fill_2
XFILLER_442_161 VPWR VGND sg13cmos5l_decap_8
XFILLER_53_144 VPWR VGND sg13cmos5l_decap_8
XFILLER_631_272 VPWR VGND sg13cmos5l_fill_1
X_2079_ _2079_/Q Tile_X0Y4_FrameData[6] VGND VPWR Tile_X0Y9_FrameStrobe[4] latch
XFILLER_387_227 VPWR VGND sg13cmos5l_decap_4
XFILLER_529_210 VPWR VGND sg13cmos5l_decap_4
XFILLER_201_70 VPWR VGND sg13cmos5l_decap_8
XFILLER_14_35 VPWR VGND sg13cmos5l_decap_8
XFILLER_558_84 VPWR VGND sg13cmos5l_fill_2
XFILLER_708_21 VPWR VGND sg13cmos5l_decap_8
XFILLER_544_235 VPWR VGND sg13cmos5l_fill_1
XFILLER_494_28 VPWR VGND sg13cmos5l_decap_8
XFILLER_277_63 VPWR VGND sg13cmos5l_decap_8
XFILLER_355_168 VPWR VGND sg13cmos5l_decap_8
XFILLER_5_207 VPWR VGND sg13cmos5l_decap_8
XFILLER_212_7 VPWR VGND sg13cmos5l_decap_8
XFILLER_107_102 VPWR VGND sg13cmos5l_decap_8
XFILLER_147_271 VPWR VGND sg13cmos5l_fill_2
XFILLER_708_98 VPWR VGND sg13cmos5l_decap_8
XFILLER_107_146 VPWR VGND sg13cmos5l_decap_8
XFILLER_427_77 VPWR VGND sg13cmos5l_decap_8
XFILLER_146_56 VPWR VGND sg13cmos5l_decap_8
XFILLER_512_176 VPWR VGND sg13cmos5l_decap_8
XFILLER_311_227 VPWR VGND sg13cmos5l_fill_1
XFILLER_293_84 VPWR VGND sg13cmos5l_decap_8
XFILLER_443_21 VPWR VGND sg13cmos5l_decap_8
XFILLER_311_249 VPWR VGND sg13cmos5l_decap_8
XFILLER_581_7 VPWR VGND sg13cmos5l_decap_8
XFILLER_679_7 VPWR VGND sg13cmos5l_decap_8
XFILLER_276_131 VPWR VGND sg13cmos5l_decap_8
XFILLER_295_4 VPWR VGND sg13cmos5l_fill_1
XFILLER_465_242 VPWR VGND sg13cmos5l_decap_8
XFILLER_590_93 VPWR VGND sg13cmos5l_fill_1
XFILLER_443_98 VPWR VGND sg13cmos5l_decap_8
XFILLER_130_182 VPWR VGND sg13cmos5l_decap_8
XFILLER_39_76 VPWR VGND sg13cmos5l_decap_8
XFILLER_681_150 VPWR VGND sg13cmos5l_decap_8
XFILLER_162_66 VPWR VGND sg13cmos5l_decap_8
XFILLER_312_14 VPWR VGND sg13cmos5l_decap_8
XFILLER_291_134 VPWR VGND sg13cmos5l_decap_8
XANTENNA__3123__X Tile_X0Y7_EE4BEG[9] VPWR VGND sg13cmos5l_antennanp
XFILLER_480_234 VPWR VGND sg13cmos5l_decap_8
XFILLER_217_242 VPWR VGND sg13cmos5l_decap_8
XFILLER_55_31 VPWR VGND sg13cmos5l_decap_8
XFILLER_91_239 VPWR VGND sg13cmos5l_decap_8
XFILLER_312_58 VPWR VGND sg13cmos5l_decap_8
XFILLER_669_28 VPWR VGND sg13cmos5l_decap_8
XFILLER_440_109 VPWR VGND sg13cmos5l_fill_2
XFILLER_44_122 VPWR VGND sg13cmos5l_decap_8
XFILLER_579_143 VPWR VGND sg13cmos5l_fill_2
XANTENNA__2962__X Tile_X0Y8_FrameData_O[2] VPWR VGND sg13cmos5l_antennanp
XFILLER_169_0 VPWR VGND sg13cmos5l_decap_8
XFILLER_189_116 VPWR VGND sg13cmos5l_decap_8
XFILLER_622_272 VPWR VGND sg13cmos5l_fill_1
XFILLER_55_97 VPWR VGND sg13cmos5l_decap_8
XFILLER_232_245 VPWR VGND sg13cmos5l_decap_4
XFILLER_44_188 VPWR VGND sg13cmos5l_fill_1
XFILLER_111_70 VPWR VGND sg13cmos5l_decap_8
XFILLER_336_0 VPWR VGND sg13cmos5l_decap_8
XFILLER_197_160 VPWR VGND sg13cmos5l_decap_8
XFILLER_71_63 VPWR VGND sg13cmos5l_decap_8
XFILLER_187_41 VPWR VGND sg13cmos5l_decap_8
XFILLER_535_213 VPWR VGND sg13cmos5l_decap_4
XFILLER_618_21 VPWR VGND sg13cmos5l_decap_8
XFILLER_346_124 VPWR VGND sg13cmos5l_decap_8
XFILLER_503_0 VPWR VGND sg13cmos5l_decap_8
XFILLER_138_260 VPWR VGND sg13cmos5l_fill_1
XFILLER_550_205 VPWR VGND sg13cmos5l_decap_8
XFILLER_618_98 VPWR VGND sg13cmos5l_decap_8
XFILLER_361_149 VPWR VGND sg13cmos5l_decap_8
XFILLER_153_252 VPWR VGND sg13cmos5l_decap_8
XFILLER_649_136 VPWR VGND sg13cmos5l_decap_8
XFILLER_299_256 VPWR VGND sg13cmos5l_fill_1
XFILLER_113_105 VPWR VGND sg13cmos5l_fill_1
XFILLER_634_42 VPWR VGND sg13cmos5l_decap_8
XFILLER_503_154 VPWR VGND sg13cmos5l_decap_8
X_1450_ _1450_/Q Tile_X0Y2_FrameData[7] VGND VPWR Tile_X0Y9_FrameStrobe[0] latch
XFILLER_113_127 VPWR VGND sg13cmos5l_decap_8
XFILLER_353_21 VPWR VGND sg13cmos5l_decap_8
XFILLER_302_227 VPWR VGND sg13cmos5l_decap_8
XFILLER_664_106 VPWR VGND sg13cmos5l_fill_2
X_0401_ _0401_/Q Tile_X0Y7_FrameData[14] VGND VPWR Tile_X0Y9_FrameStrobe[7] latch
X_1381_ _1381_/Q Tile_X0Y1_FrameData[20] VGND VPWR Tile_X0Y9_FrameStrobe[6] latch
XFILLER_67_203 VPWR VGND sg13cmos5l_decap_8
X_3120_ Tile_X0Y7_EE4BEG[6] _4634_/X VPWR VGND sg13cmos5l_buf_1
X_0332_ _0332_/Q Tile_X0Y7_FrameData[19] VGND VPWR Tile_X0Y9_FrameStrobe[5] latch
XFILLER_267_153 VPWR VGND sg13cmos5l_fill_2
XFILLER_353_98 VPWR VGND sg13cmos5l_decap_8
XFILLER_503_35 VPWR VGND sg13cmos5l_decap_8
XFILLER_121_193 VPWR VGND sg13cmos5l_fill_1
XFILLER_471_201 VPWR VGND sg13cmos5l_decap_8
XFILLER_282_112 VPWR VGND sg13cmos5l_decap_8
X_3051_ Tile_X0Y5_FrameData_O[10] Tile_X0Y5_FrameData[10] VPWR VGND sg13cmos5l_buf_1
XFILLER_650_63 VPWR VGND sg13cmos5l_decap_8
XFILLER_222_14 VPWR VGND sg13cmos5l_decap_8
X_0263_ _0263_/Q Tile_X0Y7_FrameData[24] VGND VPWR Tile_X0Y9_FrameStrobe[3] latch
XANTENNA__3033__X Tile_X0Y5_EE4BEG[8] VPWR VGND sg13cmos5l_antennanp
XFILLER_82_206 VPWR VGND sg13cmos5l_fill_1
XFILLER_208_231 VPWR VGND sg13cmos5l_decap_8
X_2002_ _2002_/Q Tile_X0Y4_FrameData[19] VGND VPWR Tile_X0Y9_FrameStrobe[2] latch
XFILLER_579_28 VPWR VGND sg13cmos5l_decap_8
X_0194_ _0194_/Q Tile_X0Y7_FrameData[29] VGND VPWR Tile_X0Y9_FrameStrobe[1] latch
XFILLER_282_189 VPWR VGND sg13cmos5l_decap_8
XFILLER_223_201 VPWR VGND sg13cmos5l_decap_8
XFILLER_424_161 VPWR VGND sg13cmos5l_decap_8
XANTENNA__2872__X Tile_X0Y6_EE4BEG[9] VPWR VGND sg13cmos5l_antennanp
XFILLER_35_166 VPWR VGND sg13cmos5l_decap_8
XFILLER_90_272 VPWR VGND sg13cmos5l_fill_1
XFILLER_585_124 VPWR VGND sg13cmos5l_decap_8
XFILLER_585_135 VPWR VGND sg13cmos5l_fill_2
X_3953_ _3953_/X Tile_X0Y1_WW4END[10] AXI_M_SOC_ARREADY _4018_/X _3993_/X _1303_/Q
+ _1302_/Q VPWR VGND sg13cmos5l_mux4_1
XFILLER_195_108 VPWR VGND sg13cmos5l_fill_1
XFILLER_384_208 VPWR VGND sg13cmos5l_decap_8
X_2904_ Tile_X0Y6_FrameData_O[25] Tile_X0Y6_FrameData[25] VPWR VGND sg13cmos5l_buf_1
XFILLER_188_182 VPWR VGND sg13cmos5l_decap_8
X_3884_ _3884_/X _3851_/X _0078_/X Tile_X0Y0_S1END[3] Tile_X0Y0_S4END[3] _0989_/Q
+ _0988_/Q VPWR VGND sg13cmos5l_mux4_1
XFILLER_595_49 VPWR VGND sg13cmos5l_decap_8
XFILLER_526_202 VPWR VGND sg13cmos5l_decap_8
XFILLER_377_271 VPWR VGND sg13cmos5l_fill_2
XFILLER_337_102 VPWR VGND sg13cmos5l_decap_8
XFILLER_84_0 VPWR VGND sg13cmos5l_decap_8
XFILLER_528_21 VPWR VGND sg13cmos5l_decap_8
X_2835_ Tile_X0Y6_E2BEG[0] _4496_/X VPWR VGND sg13cmos5l_buf_1
XFILLER_392_230 VPWR VGND sg13cmos5l_decap_4
XFILLER_337_146 VPWR VGND sg13cmos5l_decap_8
XFILLER_352_105 VPWR VGND sg13cmos5l_decap_8
XFILLER_129_271 VPWR VGND sg13cmos5l_fill_2
X_2766_ Tile_X0Y3_FrameData_O[24] Tile_X0Y3_FrameData[24] VPWR VGND sg13cmos5l_buf_1
XFILLER_675_93 VPWR VGND sg13cmos5l_decap_8
XFILLER_394_50 VPWR VGND sg13cmos5l_decap_8
X_1717_ _1717_/Q Tile_X0Y3_FrameData[20] VGND VPWR Tile_X0Y9_FrameStrobe[1] latch
X_4505_ _4505_/X Tile_X0Y6_W2END[6] AXI_M_SOC_RDATA30 _4555_/X _4554_/X _2597_/Q _2596_/Q
+ VPWR VGND sg13cmos5l_mux4_1
XFILLER_345_190 VPWR VGND sg13cmos5l_fill_1
XFILLER_247_77 VPWR VGND sg13cmos5l_fill_2
X_2697_ _4087_/A3 VPWR VGND sg13cmos5l_tielo
XANTENNA__3208__X Tile_X0Y0_N1BEG[0] VPWR VGND sg13cmos5l_antennanp
XFILLER_144_263 VPWR VGND sg13cmos5l_fill_2
XFILLER_544_42 VPWR VGND sg13cmos5l_decap_8
X_4436_ _4436_/X _4012_/X _4016_/X _4005_/X _3994_/X _1365_/Q _1364_/Q VPWR VGND sg13cmos5l_mux4_1
XFILLER_6_91 VPWR VGND sg13cmos5l_decap_8
XFILLER_104_127 VPWR VGND sg13cmos5l_decap_8
X_1648_ _1648_/Q Tile_X0Y2_FrameData[1] VGND VPWR Tile_X0Y9_FrameStrobe[6] latch
XFILLER_695_253 VPWR VGND sg13cmos5l_decap_8
XFILLER_691_70 VPWR VGND sg13cmos5l_decap_8
XFILLER_104_138 VPWR VGND sg13cmos5l_fill_1
XFILLER_263_21 VPWR VGND sg13cmos5l_decap_8
XFILLER_655_106 VPWR VGND sg13cmos5l_decap_4
X_4367_ _4367_/X Tile_X0Y6_W2MID[0] Tile_X0Y6_W2END[0] Tile_X0Y6_W6END[0] _4552_/X
+ _2673_/Q _2672_/Q VPWR VGND sg13cmos5l_mux4_1
X_1579_ _1579_/Q Tile_X0Y2_FrameData[6] VGND VPWR Tile_X0Y9_FrameStrobe[4] latch
X_3318_ Tile_X0Y4_EE4BEG[6] _4278_/X VPWR VGND sg13cmos5l_buf_1
XFILLER_58_225 VPWR VGND sg13cmos5l_decap_8
XFILLER_447_253 VPWR VGND sg13cmos5l_decap_8
X_4298_ _4298_/X AXI_M_SOC_BRESP0 _4337_/X _4341_/X _4314_/X _2017_/Q _2016_/Q VPWR
+ VGND sg13cmos5l_mux4_1
XFILLER_413_35 VPWR VGND sg13cmos5l_decap_8
XFILLER_560_63 VPWR VGND sg13cmos5l_decap_8
XFILLER_132_14 VPWR VGND sg13cmos5l_decap_8
X_3249_ Tile_X0Y0_FrameData_O[17] Tile_X0Y0_FrameData[17] VPWR VGND sg13cmos5l_buf_1
XFILLER_273_156 VPWR VGND sg13cmos5l_decap_8
XFILLER_26_100 VPWR VGND sg13cmos5l_decap_8
XFILLER_489_28 VPWR VGND sg13cmos5l_decap_8
XFILLER_611_209 VPWR VGND sg13cmos5l_decap_8
XANTENNA__2782__X Tile_X0Y3_EE4BEG[8] VPWR VGND sg13cmos5l_antennanp
XFILLER_710_77 VPWR VGND sg13cmos5l_decap_8
XFILLER_162_7 VPWR VGND sg13cmos5l_decap_8
XFILLER_604_272 VPWR VGND sg13cmos5l_fill_1
XFILLER_214_234 VPWR VGND sg13cmos5l_decap_8
XFILLER_212_91 VPWR VGND sg13cmos5l_decap_8
XFILLER_81_272 VPWR VGND sg13cmos5l_fill_1
XFILLER_26_177 VPWR VGND sg13cmos5l_decap_8
XFILLER_576_146 VPWR VGND sg13cmos5l_decap_8
XFILLER_430_175 VPWR VGND sg13cmos5l_decap_8
XFILLER_375_219 VPWR VGND sg13cmos5l_decap_8
XFILLER_591_105 VPWR VGND sg13cmos5l_decap_8
XFILLER_427_7 VPWR VGND sg13cmos5l_decap_8
XFILLER_179_193 VPWR VGND sg13cmos5l_fill_2
XFILLER_438_21 VPWR VGND sg13cmos5l_decap_8
XFILLER_41_22 VPWR VGND sg13cmos5l_decap_8
XFILLER_517_257 VPWR VGND sg13cmos5l_decap_4
XFILLER_383_252 VPWR VGND sg13cmos5l_decap_8
XFILLER_194_163 VPWR VGND sg13cmos5l_decap_8
XFILLER_343_116 VPWR VGND sg13cmos5l_decap_8
XFILLER_532_238 VPWR VGND sg13cmos5l_decap_8
XFILLER_307_14 VPWR VGND sg13cmos5l_decap_8
XANTENNA__3118__X Tile_X0Y7_EE4BEG[4] VPWR VGND sg13cmos5l_antennanp
XFILLER_157_99 VPWR VGND sg13cmos5l_decap_8
XFILLER_454_42 VPWR VGND sg13cmos5l_decap_8
XFILLER_1_210 VPWR VGND sg13cmos5l_fill_1
XFILLER_173_21 VPWR VGND sg13cmos5l_decap_8
XFILLER_351_182 VPWR VGND sg13cmos5l_decap_8
XFILLER_307_69 VPWR VGND sg13cmos5l_decap_8
XFILLER_497_175 VPWR VGND sg13cmos5l_decap_8
XANTENNA__2957__X Tile_X0Y8_EE4BEG[13] VPWR VGND sg13cmos5l_antennanp
XFILLER_296_248 VPWR VGND sg13cmos5l_decap_8
XFILLER_438_220 VPWR VGND sg13cmos5l_decap_8
XFILLER_604_56 VPWR VGND sg13cmos5l_decap_8
XFILLER_500_168 VPWR VGND sg13cmos5l_decap_8
XFILLER_49_225 VPWR VGND sg13cmos5l_decap_8
XFILLER_438_253 VPWR VGND sg13cmos5l_decap_8
XFILLER_2_49 VPWR VGND sg13cmos5l_decap_8
XFILLER_286_0 VPWR VGND sg13cmos5l_decap_8
XFILLER_264_134 VPWR VGND sg13cmos5l_decap_8
XFILLER_66_63 VPWR VGND sg13cmos5l_decap_8
XFILLER_64_217 VPWR VGND sg13cmos5l_decap_8
XFILLER_453_245 VPWR VGND sg13cmos5l_fill_1
XFILLER_399_28 VPWR VGND sg13cmos5l_decap_8
XFILLER_17_122 VPWR VGND sg13cmos5l_decap_8
XFILLER_17_133 VPWR VGND sg13cmos5l_fill_1
XFILLER_453_0 VPWR VGND sg13cmos5l_decap_8
XFILLER_406_172 VPWR VGND sg13cmos5l_decap_8
XFILLER_17_155 VPWR VGND sg13cmos5l_decap_8
XFILLER_620_77 VPWR VGND sg13cmos5l_decap_4
XFILLER_205_245 VPWR VGND sg13cmos5l_decap_8
XFILLER_72_272 VPWR VGND sg13cmos5l_fill_1
XFILLER_32_114 VPWR VGND sg13cmos5l_decap_8
XFILLER_620_0 VPWR VGND sg13cmos5l_decap_8
XFILLER_198_51 VPWR VGND sg13cmos5l_decap_8
XFILLER_421_175 VPWR VGND sg13cmos5l_decap_8
XFILLER_567_168 VPWR VGND sg13cmos5l_decap_8
XFILLER_629_42 VPWR VGND sg13cmos5l_decap_8
XFILLER_582_105 VPWR VGND sg13cmos5l_decap_4
X_0950_ _0950_/Q Tile_X0Y0_FrameData[21] VGND VPWR Tile_X0Y9_FrameStrobe[0] latch
XFILLER_348_21 VPWR VGND sg13cmos5l_decap_8
XFILLER_185_141 VPWR VGND sg13cmos5l_decap_8
X_0881_ _0881_/Q Tile_X0Y9_FrameData[14] VGND VPWR Tile_X0Y9_FrameStrobe[6] latch
XFILLER_40_191 VPWR VGND sg13cmos5l_decap_8
XFILLER_508_268 VPWR VGND sg13cmos5l_decap_4
X_2620_ _2620_/Q Tile_X0Y6_FrameData[11] VGND VPWR Tile_X0Y9_FrameStrobe[5] latch
XFILLER_348_98 VPWR VGND sg13cmos5l_decap_8
XFILLER_126_241 VPWR VGND sg13cmos5l_decap_4
X_2551_ _2551_/Q Tile_X0Y6_FrameData[16] VGND VPWR Tile_X0Y9_FrameStrobe[3] latch
XFILLER_645_63 VPWR VGND sg13cmos5l_decap_8
XFILLER_217_14 VPWR VGND sg13cmos5l_decap_8
XFILLER_56_4 VPWR VGND sg13cmos5l_fill_2
XANTENNA__3028__X Tile_X0Y5_EE4BEG[3] VPWR VGND sg13cmos5l_antennanp
XFILLER_141_200 VPWR VGND sg13cmos5l_decap_8
X_1502_ _1502_/Q Tile_X0Y2_FrameData[19] VGND VPWR Tile_X0Y9_FrameStrobe[2] latch
XFILLER_364_42 VPWR VGND sg13cmos5l_decap_8
X_2482_ _2482_/Q Tile_X0Y6_FrameData[21] VGND VPWR Tile_X0Y9_FrameStrobe[1] latch
X_4221_ _4221_/X _4691_/X _4695_/X _4699_/X _4675_/X _0382_/Q _0381_/Q VPWR VGND sg13cmos5l_mux4_1
XFILLER_637_117 VPWR VGND sg13cmos5l_decap_8
XANTENNA__2867__X Tile_X0Y6_EE4BEG[4] VPWR VGND sg13cmos5l_antennanp
XFILLER_141_255 VPWR VGND sg13cmos5l_decap_8
X_1433_ _1433_/Q Tile_X0Y2_FrameData[24] VGND VPWR Tile_X0Y9_FrameStrobe[0] latch
XFILLER_692_212 VPWR VGND sg13cmos5l_decap_8
XFILLER_287_259 VPWR VGND sg13cmos5l_fill_2
XFILLER_429_231 VPWR VGND sg13cmos5l_decap_8
XFILLER_514_56 VPWR VGND sg13cmos5l_decap_8
X_4152_ _4152_/X Tile_X0Y3_W2MID[3] AXI_M_SOC_WREADY _4211_/X _4210_/X _1837_/Q _1836_/Q
+ VPWR VGND sg13cmos5l_mux4_1
X_1364_ _1364_/Q Tile_X0Y1_FrameData[5] VGND VPWR Tile_X0Y9_FrameStrobe[5] latch
XFILLER_233_35 VPWR VGND sg13cmos5l_fill_2
X_3103_ Tile_X0Y7_E6BEG[1] _4645_/X VPWR VGND sg13cmos5l_buf_1
XFILLER_645_161 VPWR VGND sg13cmos5l_decap_8
X_0315_ _0315_/Q Tile_X0Y7_FrameData[4] VGND VPWR Tile_X0Y9_FrameStrobe[4] latch
X_4083_ _4083_/X AXI_M_SOC_AWREADY _4116_/X _4120_/X _4096_/X _1507_/Q _1506_/Q VPWR
+ VGND sg13cmos5l_mux4_1
X_1295_ _1295_/Q Tile_X0Y1_FrameData[10] VGND VPWR Tile_X0Y9_FrameStrobe[3] latch
XFILLER_660_120 VPWR VGND sg13cmos5l_decap_8
XFILLER_444_245 VPWR VGND sg13cmos5l_fill_2
X_3034_ Tile_X0Y5_EE4BEG[9] _4397_/X VPWR VGND sg13cmos5l_buf_1
X_0246_ _0246_/Q Tile_X0Y7_FrameData[9] VGND VPWR Tile_X0Y9_FrameStrobe[2] latch
XFILLER_255_178 VPWR VGND sg13cmos5l_fill_2
XANTENNA__3698__X AXI_M_SOC_WDATA8 VPWR VGND sg13cmos5l_antennanp
XFILLER_660_164 VPWR VGND sg13cmos5l_fill_2
XFILLER_102_28 VPWR VGND sg13cmos5l_decap_8
XFILLER_530_77 VPWR VGND sg13cmos5l_fill_2
X_0177_ _0177_/Q Tile_X0Y7_FrameData[14] VGND VPWR Tile_X0Y9_FrameStrobe[0] latch
XFILLER_598_271 VPWR VGND sg13cmos5l_fill_2
XFILLER_211_215 VPWR VGND sg13cmos5l_decap_8
XFILLER_23_158 VPWR VGND sg13cmos5l_fill_2
XFILLER_539_42 VPWR VGND sg13cmos5l_decap_8
XFILLER_573_105 VPWR VGND sg13cmos5l_decap_8
X_3936_ _3936_/X Tile_X0Y1_W2MID[3] AXI_M_SOC_ARREADY _3995_/X _3994_/X _1337_/Q _1336_/Q
+ VPWR VGND sg13cmos5l_mux4_1
XFILLER_258_21 VPWR VGND sg13cmos5l_decap_8
XFILLER_109_208 VPWR VGND sg13cmos5l_decap_8
X_3867_ _3867_/X _3850_/X _0085_/X Tile_X0Y0_S1END[2] Tile_X0Y0_S4END[2] _0967_/Q
+ _0966_/Q VPWR VGND sg13cmos5l_mux4_1
XFILLER_715_154 VPWR VGND sg13cmos5l_decap_8
XFILLER_176_185 VPWR VGND sg13cmos5l_decap_8
XFILLER_191_111 VPWR VGND sg13cmos5l_decap_8
X_2818_ Tile_X0Y3_E1BEG[0] _4144_/X VPWR VGND sg13cmos5l_buf_1
XFILLER_11_14 VPWR VGND sg13cmos5l_decap_8
XFILLER_555_30 VPWR VGND sg13cmos5l_decap_8
X_3798_ _3798_/X Tile_X0Y0_W1END[3] Tile_X0Y0_WW4END[3] Tile_X0Y0_W6END[11] _3884_/X
+ _1144_/Q _1143_/Q VPWR VGND sg13cmos5l_mux4_1
XFILLER_408_35 VPWR VGND sg13cmos5l_decap_8
XFILLER_380_244 VPWR VGND sg13cmos5l_decap_4
XFILLER_127_14 VPWR VGND sg13cmos5l_decap_8
XFILLER_380_255 VPWR VGND sg13cmos5l_decap_8
X_2749_ Tile_X0Y3_FrameData_O[7] Tile_X0Y3_FrameData[7] VPWR VGND sg13cmos5l_buf_1
XFILLER_479_120 VPWR VGND sg13cmos5l_decap_8
XFILLER_117_263 VPWR VGND sg13cmos5l_fill_2
XFILLER_274_42 VPWR VGND sg13cmos5l_decap_8
XFILLER_191_199 VPWR VGND sg13cmos5l_decap_8
XFILLER_668_264 VPWR VGND sg13cmos5l_decap_8
XFILLER_87_29 VPWR VGND sg13cmos5l_decap_8
XFILLER_494_112 VPWR VGND sg13cmos5l_decap_8
XANTENNA__2777__X Tile_X0Y3_EE4BEG[3] VPWR VGND sg13cmos5l_antennanp
X_4419_ _4419_/X _4421_/X Tile_X0Y5_W6END[1] _4420_/X _4419_/A3 _2187_/Q _2186_/Q
+ VPWR VGND sg13cmos5l_mux4_1
XFILLER_705_77 VPWR VGND sg13cmos5l_decap_8
XFILLER_683_234 VPWR VGND sg13cmos5l_decap_8
XFILLER_207_91 VPWR VGND sg13cmos5l_decap_8
XFILLER_424_56 VPWR VGND sg13cmos5l_decap_8
XFILLER_143_35 VPWR VGND sg13cmos5l_decap_8
XFILLER_571_84 VPWR VGND sg13cmos5l_decap_8
XFILLER_494_189 VPWR VGND sg13cmos5l_decap_8
XFILLER_246_123 VPWR VGND sg13cmos5l_fill_2
XFILLER_100_141 VPWR VGND sg13cmos5l_decap_8
XFILLER_435_234 VPWR VGND sg13cmos5l_decap_8
XFILLER_377_7 VPWR VGND sg13cmos5l_decap_8
XFILLER_290_85 VPWR VGND sg13cmos5l_decap_8
XFILLER_435_256 VPWR VGND sg13cmos5l_fill_2
XFILLER_46_239 VPWR VGND sg13cmos5l_decap_8
XFILLER_223_90 VPWR VGND sg13cmos5l_decap_8
XFILLER_651_175 VPWR VGND sg13cmos5l_decap_8
XFILLER_440_77 VPWR VGND sg13cmos5l_decap_8
XFILLER_589_271 VPWR VGND sg13cmos5l_fill_2
XFILLER_544_7 VPWR VGND sg13cmos5l_decap_8
XANTENNA__3401__X Tile_X0Y2_E2BEG[4] VPWR VGND sg13cmos5l_antennanp
XFILLER_261_159 VPWR VGND sg13cmos5l_decap_4
XFILLER_14_114 VPWR VGND sg13cmos5l_fill_1
XFILLER_202_215 VPWR VGND sg13cmos5l_decap_8
XFILLER_403_186 VPWR VGND sg13cmos5l_decap_8
XFILLER_711_7 VPWR VGND sg13cmos5l_decap_8
XFILLER_564_105 VPWR VGND sg13cmos5l_decap_8
XFILLER_449_42 VPWR VGND sg13cmos5l_decap_8
XFILLER_168_21 VPWR VGND sg13cmos5l_decap_8
XFILLER_596_70 VPWR VGND sg13cmos5l_decap_8
XFILLER_52_54 VPWR VGND sg13cmos5l_decap_8
XFILLER_356_252 VPWR VGND sg13cmos5l_decap_8
XFILLER_356_263 VPWR VGND sg13cmos5l_fill_2
XFILLER_706_165 VPWR VGND sg13cmos5l_decap_8
XFILLER_505_227 VPWR VGND sg13cmos5l_decap_8
XFILLER_572_182 VPWR VGND sg13cmos5l_decap_8
XFILLER_316_138 VPWR VGND sg13cmos5l_fill_2
XFILLER_108_230 VPWR VGND sg13cmos5l_decap_8
XFILLER_465_74 VPWR VGND sg13cmos5l_decap_8
XFILLER_371_266 VPWR VGND sg13cmos5l_decap_8
XFILLER_182_177 VPWR VGND sg13cmos5l_decap_8
XFILLER_201_0 VPWR VGND sg13cmos5l_decap_8
XFILLER_331_108 VPWR VGND sg13cmos5l_fill_1
XFILLER_182_188 VPWR VGND sg13cmos5l_fill_1
XFILLER_123_200 VPWR VGND sg13cmos5l_fill_2
XFILLER_324_171 VPWR VGND sg13cmos5l_decap_8
XFILLER_184_64 VPWR VGND sg13cmos5l_decap_8
XFILLER_659_264 VPWR VGND sg13cmos5l_fill_1
XFILLER_674_201 VPWR VGND sg13cmos5l_fill_1
XFILLER_269_237 VPWR VGND sg13cmos5l_decap_8
XFILLER_619_128 VPWR VGND sg13cmos5l_decap_4
XFILLER_615_77 VPWR VGND sg13cmos5l_decap_8
XFILLER_674_223 VPWR VGND sg13cmos5l_decap_8
XFILLER_485_145 VPWR VGND sg13cmos5l_decap_8
XFILLER_117_91 VPWR VGND sg13cmos5l_decap_8
XFILLER_77_40 VPWR VGND sg13cmos5l_fill_1
XFILLER_570_0 VPWR VGND sg13cmos5l_decap_8
XFILLER_485_189 VPWR VGND sg13cmos5l_decap_8
XFILLER_631_21 VPWR VGND sg13cmos5l_decap_8
XFILLER_668_0 VPWR VGND sg13cmos5l_decap_8
X_0100_ _0100_/X _4445_/X _4446_/X _0895_/Q VPWR VGND sg13cmos5l_mux2_1
XFILLER_292_262 VPWR VGND sg13cmos5l_fill_1
X_1080_ _1080_/Q Tile_X0Y0_FrameData[19] VGND VPWR Tile_X0Y9_FrameStrobe[4] latch
XFILLER_631_98 VPWR VGND sg13cmos5l_decap_8
XFILLER_203_49 VPWR VGND sg13cmos5l_decap_8
XFILLER_237_189 VPWR VGND sg13cmos5l_decap_8
XFILLER_642_175 VPWR VGND sg13cmos5l_decap_8
XFILLER_441_237 VPWR VGND sg13cmos5l_decap_8
XFILLER_350_77 VPWR VGND sg13cmos5l_decap_8
XFILLER_500_14 VPWR VGND sg13cmos5l_decap_8
XANTENNA__3311__X Tile_X0Y0_E1BEG[3] VPWR VGND sg13cmos5l_antennanp
XFILLER_45_272 VPWR VGND sg13cmos5l_fill_1
XFILLER_60_231 VPWR VGND sg13cmos5l_decap_8
XFILLER_339_219 VPWR VGND sg13cmos5l_fill_1
XFILLER_359_42 VPWR VGND sg13cmos5l_decap_8
X_1982_ _1982_/Q Tile_X0Y4_FrameData[7] VGND VPWR Tile_X0Y9_FrameStrobe[1] latch
X_4770_ _4770_/X AXI_M_SOC_RDATA14 _4801_/X _4805_/X _4786_/X _0507_/Q _0506_/Q VPWR
+ VGND sg13cmos5l_mux4_1
XFILLER_20_128 VPWR VGND sg13cmos5l_fill_1
X_0933_ _0933_/Q Tile_X0Y9_FrameData[24] VGND VPWR Tile_X0Y9_FrameStrobe[8] latch
X_3721_ AXI_M_SOC_WDATA31 Tile_X0Y6_W1END[3] Tile_X0Y6_WW4END[7] Tile_X0Y6_WW4END[15]
+ _4583_/X _2497_/Q _2496_/Q VPWR VGND sg13cmos5l_mux4_1
XFILLER_347_241 VPWR VGND sg13cmos5l_decap_8
XFILLER_347_252 VPWR VGND sg13cmos5l_fill_1
XFILLER_173_100 VPWR VGND sg13cmos5l_decap_8
XFILLER_570_119 VPWR VGND sg13cmos5l_decap_8
XFILLER_509_56 VPWR VGND sg13cmos5l_decap_8
XFILLER_362_200 VPWR VGND sg13cmos5l_decap_8
XFILLER_362_211 VPWR VGND sg13cmos5l_fill_1
X_0864_ _0864_/Q Tile_X0Y9_FrameData[31] VGND VPWR Tile_X0Y9_FrameStrobe[6] latch
X_3652_ AXI_M_SOC_AWADDR13 Tile_X0Y5_W1END[1] Tile_X0Y5_WW4END[5] Tile_X0Y5_WW4END[13]
+ _4464_/X _2245_/Q _2244_/Q VPWR VGND sg13cmos5l_mux4_1
XFILLER_228_35 VPWR VGND sg13cmos5l_decap_8
XFILLER_9_195 VPWR VGND sg13cmos5l_decap_8
XFILLER_362_233 VPWR VGND sg13cmos5l_decap_8
XFILLER_362_244 VPWR VGND sg13cmos5l_fill_1
X_2603_ _2603_/Q Tile_X0Y6_FrameData[28] VGND VPWR Tile_X0Y9_FrameStrobe[5] latch
XFILLER_592_28 VPWR VGND sg13cmos5l_decap_8
X_3583_ Tile_X0Y9_FrameData_O[13] Tile_X0Y9_FrameData[13] VPWR VGND sg13cmos5l_buf_1
XFILLER_173_177 VPWR VGND sg13cmos5l_decap_8
X_0795_ _0795_/Q Tile_X0Y9_FrameData[4] VGND VPWR Tile_X0Y9_FrameStrobe[3] latch
XFILLER_712_168 VPWR VGND sg13cmos5l_decap_8
X_2534_ _2534_/Q Tile_X0Y6_FrameData[1] VGND VPWR Tile_X0Y9_FrameStrobe[2] latch
XFILLER_672_61 VPWR VGND sg13cmos5l_decap_4
XFILLER_47_0 VPWR VGND sg13cmos5l_fill_2
XFILLER_476_112 VPWR VGND sg13cmos5l_decap_8
XFILLER_525_77 VPWR VGND sg13cmos5l_decap_8
XFILLER_87_106 VPWR VGND sg13cmos5l_decap_8
X_2465_ _2465_/Q Tile_X0Y6_FrameData[6] VGND VPWR Tile_X0Y9_FrameStrobe[0] latch
XFILLER_330_141 VPWR VGND sg13cmos5l_decap_8
XFILLER_391_51 VPWR VGND sg13cmos5l_decap_8
XFILLER_244_56 VPWR VGND sg13cmos5l_decap_8
X_1416_ _1416_/Q Tile_X0Y1_FrameData[17] VGND VPWR Tile_X0Y9_FrameStrobe[7] latch
X_4204_ _4204_/X _4143_/X _4251_/X _4250_/X _4142_/X _1683_/Q _1682_/Q VPWR VGND sg13cmos5l_mux4_1
X_2396_ _2396_/Q Tile_X0Y5_FrameData[9] VGND VPWR Tile_X0Y9_FrameStrobe[6] latch
XFILLER_541_21 VPWR VGND sg13cmos5l_decap_8
XFILLER_618_161 VPWR VGND sg13cmos5l_decap_4
XFILLER_491_126 VPWR VGND sg13cmos5l_decap_8
XFILLER_3_70 VPWR VGND sg13cmos5l_decap_8
X_4135_ _4135_/X Tile_X0Y4_W2MID[4] Tile_X0Y4_W2END[4] Tile_X0Y4_W6END[4] _4319_/X
+ _2167_/Q _2166_/Q VPWR VGND sg13cmos5l_mux4_1
X_1347_ _1347_/Q Tile_X0Y1_FrameData[22] VGND VPWR Tile_X0Y9_FrameStrobe[5] latch
XFILLER_680_248 VPWR VGND sg13cmos5l_decap_8
XFILLER_28_217 VPWR VGND sg13cmos5l_fill_1
XFILLER_228_167 VPWR VGND sg13cmos5l_decap_8
XFILLER_228_178 VPWR VGND sg13cmos5l_fill_2
X_4066_ _4066_/X Tile_X0Y2_WW4END[5] AXI_M_SOC_AWREADY _4121_/X _4100_/X _1541_/Q
+ _1540_/Q VPWR VGND sg13cmos5l_mux4_1
XFILLER_541_98 VPWR VGND sg13cmos5l_fill_1
XFILLER_113_49 VPWR VGND sg13cmos5l_decap_8
X_1278_ _1278_/Q Tile_X0Y1_FrameData[27] VGND VPWR Tile_X0Y9_FrameStrobe[3] latch
X_3017_ Tile_X0Y5_E6BEG[4] _4408_/X VPWR VGND sg13cmos5l_buf_1
XFILLER_260_77 VPWR VGND sg13cmos5l_decap_8
X_0229_ _0229_/Q Tile_X0Y7_FrameData[26] VGND VPWR Tile_X0Y9_FrameStrobe[2] latch
XFILLER_410_14 VPWR VGND sg13cmos5l_decap_8
XFILLER_260_88 VPWR VGND sg13cmos5l_decap_8
XANTENNA__3221__X Tile_X0Y0_FrameStrobe_O[9] VPWR VGND sg13cmos5l_antennanp
XFILLER_251_170 VPWR VGND sg13cmos5l_decap_8
XFILLER_51_242 VPWR VGND sg13cmos5l_decap_8
XFILLER_440_270 VPWR VGND sg13cmos5l_fill_2
XFILLER_397_163 VPWR VGND sg13cmos5l_decap_8
XFILLER_400_112 VPWR VGND sg13cmos5l_decap_8
XFILLER_269_42 VPWR VGND sg13cmos5l_decap_8
XFILLER_546_105 VPWR VGND sg13cmos5l_decap_8
XFILLER_11_106 VPWR VGND sg13cmos5l_decap_8
XFILLER_546_116 VPWR VGND sg13cmos5l_fill_2
XFILLER_539_190 VPWR VGND sg13cmos5l_decap_8
X_3919_ _3919_/X _4120_/X _4124_/X _4113_/X _4097_/X _1649_/Q _1648_/Q VPWR VGND sg13cmos5l_mux4_1
XFILLER_338_241 VPWR VGND sg13cmos5l_decap_8
XFILLER_400_189 VPWR VGND sg13cmos5l_decap_8
X_4899_ _4899_/X Tile_X0Y8_W1END[3] Tile_X0Y8_W6END[11] _4815_/X _4775_/X _0629_/Q
+ _0628_/Q VPWR VGND sg13cmos5l_mux4_1
XFILLER_22_35 VPWR VGND sg13cmos5l_decap_8
XFILLER_561_119 VPWR VGND sg13cmos5l_decap_8
XFILLER_419_56 VPWR VGND sg13cmos5l_decap_8
XFILLER_149_185 VPWR VGND sg13cmos5l_decap_8
XFILLER_125_7 VPWR VGND sg13cmos5l_decap_8
XFILLER_566_84 VPWR VGND sg13cmos5l_decap_8
XFILLER_138_35 VPWR VGND sg13cmos5l_decap_8
XFILLER_164_133 VPWR VGND sg13cmos5l_decap_8
XFILLER_285_63 VPWR VGND sg13cmos5l_decap_8
XFILLER_98_28 VPWR VGND sg13cmos5l_decap_8
XFILLER_656_201 VPWR VGND sg13cmos5l_fill_2
XFILLER_435_77 VPWR VGND sg13cmos5l_decap_8
XFILLER_494_7 VPWR VGND sg13cmos5l_decap_8
XFILLER_120_203 VPWR VGND sg13cmos5l_decap_8
XFILLER_154_56 VPWR VGND sg13cmos5l_decap_8
XFILLER_78_128 VPWR VGND sg13cmos5l_decap_8
XFILLER_467_167 VPWR VGND sg13cmos5l_fill_2
XFILLER_451_21 VPWR VGND sg13cmos5l_decap_8
XFILLER_482_126 VPWR VGND sg13cmos5l_decap_8
XFILLER_671_226 VPWR VGND sg13cmos5l_decap_8
XFILLER_661_7 VPWR VGND sg13cmos5l_decap_8
XFILLER_671_248 VPWR VGND sg13cmos5l_decap_8
XFILLER_86_161 VPWR VGND sg13cmos5l_decap_8
XFILLER_609_194 VPWR VGND sg13cmos5l_decap_8
XFILLER_274_240 VPWR VGND sg13cmos5l_decap_8
XFILLER_671_259 VPWR VGND sg13cmos5l_fill_2
XFILLER_408_267 VPWR VGND sg13cmos5l_decap_4
XFILLER_423_204 VPWR VGND sg13cmos5l_decap_8
XFILLER_601_35 VPWR VGND sg13cmos5l_decap_8
XFILLER_47_98 VPWR VGND sg13cmos5l_decap_8
XFILLER_170_77 VPWR VGND sg13cmos5l_decap_8
XFILLER_490_192 VPWR VGND sg13cmos5l_decap_8
XFILLER_234_148 VPWR VGND sg13cmos5l_decap_8
XANTENNA__3131__X Tile_X0Y7_FrameData_O[1] VPWR VGND sg13cmos5l_antennanp
XFILLER_234_159 VPWR VGND sg13cmos5l_fill_1
XFILLER_320_36 VPWR VGND sg13cmos5l_fill_2
XFILLER_677_28 VPWR VGND sg13cmos5l_decap_8
XFILLER_63_42 VPWR VGND sg13cmos5l_decap_8
XFILLER_577_241 VPWR VGND sg13cmos5l_decap_8
XFILLER_388_152 VPWR VGND sg13cmos5l_decap_8
XFILLER_151_0 VPWR VGND sg13cmos5l_decap_8
XFILLER_42_242 VPWR VGND sg13cmos5l_decap_8
XANTENNA__2970__X Tile_X0Y8_FrameData_O[10] VPWR VGND sg13cmos5l_antennanp
XFILLER_537_105 VPWR VGND sg13cmos5l_decap_8
XFILLER_249_0 VPWR VGND sg13cmos5l_decap_4
XFILLER_592_233 VPWR VGND sg13cmos5l_decap_8
XFILLER_416_0 VPWR VGND sg13cmos5l_decap_8
XFILLER_693_49 VPWR VGND sg13cmos5l_decap_8
XFILLER_329_78 VPWR VGND sg13cmos5l_decap_4
XFILLER_155_133 VPWR VGND sg13cmos5l_decap_8
XFILLER_626_21 VPWR VGND sg13cmos5l_decap_8
XFILLER_195_63 VPWR VGND sg13cmos5l_decap_8
XFILLER_6_154 VPWR VGND sg13cmos5l_decap_8
XFILLER_304_108 VPWR VGND sg13cmos5l_decap_8
XFILLER_560_163 VPWR VGND sg13cmos5l_fill_1
X_0580_ _0580_/Q Tile_X0Y8_FrameData[27] VGND VPWR Tile_X0Y9_FrameStrobe[5] latch
XFILLER_345_77 VPWR VGND sg13cmos5l_fill_1
XFILLER_501_252 VPWR VGND sg13cmos5l_decap_8
XFILLER_345_99 VPWR VGND sg13cmos5l_decap_8
XANTENNA__3306__X Tile_X0Y0_E2BEG[6] VPWR VGND sg13cmos5l_antennanp
XFILLER_647_245 VPWR VGND sg13cmos5l_decap_8
XFILLER_642_42 VPWR VGND sg13cmos5l_decap_8
X_2250_ _2250_/Q Tile_X0Y5_FrameData[27] VGND VPWR Tile_X0Y9_FrameStrobe[2] latch
XFILLER_458_167 VPWR VGND sg13cmos5l_decap_8
XFILLER_312_196 VPWR VGND sg13cmos5l_decap_8
XFILLER_473_115 VPWR VGND sg13cmos5l_decap_8
XFILLER_662_215 VPWR VGND sg13cmos5l_decap_8
XFILLER_361_21 VPWR VGND sg13cmos5l_decap_8
X_1201_ _1201_/Q Tile_X0Y1_FrameData[8] VGND VPWR Tile_X0Y9_FrameStrobe[0] latch
X_2181_ _2181_/Q Tile_X0Y4_FrameData[0] VGND VPWR Tile_X0Y9_FrameStrobe[7] latch
XFILLER_77_172 VPWR VGND sg13cmos5l_decap_8
XFILLER_662_259 VPWR VGND sg13cmos5l_fill_2
X_1132_ _1132_/Q Tile_X0Y0_FrameData[31] VGND VPWR Tile_X0Y9_FrameStrobe[6] latch
XFILLER_615_142 VPWR VGND sg13cmos5l_decap_4
XFILLER_511_35 VPWR VGND sg13cmos5l_decap_8
XFILLER_225_137 VPWR VGND sg13cmos5l_decap_4
XFILLER_230_14 VPWR VGND sg13cmos5l_decap_8
X_1063_ _1063_/Q Tile_X0Y0_FrameData[4] VGND VPWR Tile_X0Y9_FrameStrobe[3] latch
XFILLER_615_197 VPWR VGND sg13cmos5l_decap_8
XANTENNA__3041__X Tile_X0Y5_FrameData_O[0] VPWR VGND sg13cmos5l_antennanp
XFILLER_18_261 VPWR VGND sg13cmos5l_fill_1
XFILLER_18_272 VPWR VGND sg13cmos5l_fill_1
XFILLER_587_28 VPWR VGND sg13cmos5l_decap_8
XFILLER_33_242 VPWR VGND sg13cmos5l_decap_8
XANTENNA__2880__X Tile_X0Y6_FrameData_O[1] VPWR VGND sg13cmos5l_antennanp
X_4822_ _4822_/X Tile_X0Y7_W1END[2] Tile_X0Y7_W2MID[1] Tile_X0Y7_W2END[1] _4670_/X
+ _0359_/Q _0358_/Q VPWR VGND sg13cmos5l_mux4_1
XFILLER_178_236 VPWR VGND sg13cmos5l_decap_8
XFILLER_528_127 VPWR VGND sg13cmos5l_decap_8
X_4753_ _4753_/X Tile_X0Y8_WW4END[6] AXI_M_SOC_RDATA14 _4806_/X _4786_/X _0541_/Q
+ _0540_/Q VPWR VGND sg13cmos5l_mux4_1
XFILLER_394_166 VPWR VGND sg13cmos5l_decap_4
X_1965_ _1965_/Q Tile_X0Y4_FrameData[24] VGND VPWR Tile_X0Y9_FrameStrobe[1] latch
XFILLER_543_108 VPWR VGND sg13cmos5l_fill_1
XFILLER_146_100 VPWR VGND sg13cmos5l_fill_1
X_3704_ AXI_M_SOC_WDATA14 Tile_X0Y7_W1END[2] Tile_X0Y7_WW4END[6] Tile_X0Y7_WW4END[14]
+ _4698_/X _0219_/Q _0218_/Q VPWR VGND sg13cmos5l_mux4_1
X_0916_ _0916_/Q Tile_X0Y9_FrameData[11] VGND VPWR Tile_X0Y9_FrameStrobe[7] latch
X_1896_ _1896_/Q Tile_X0Y3_FrameData[1] VGND VPWR Tile_X0Y9_FrameStrobe[6] latch
X_4684_ _4684_/X _4661_/X Tile_X0Y9_N4END[8] _4660_/X _0056_/X _0215_/Q _0214_/Q VPWR
+ VGND sg13cmos5l_mux4_1
XFILLER_536_21 VPWR VGND sg13cmos5l_decap_8
X_0847_ _0847_/Q Tile_X0Y9_FrameData[16] VGND VPWR Tile_X0Y9_FrameStrobe[5] latch
X_3635_ Tile_X0Y9_S4BEG[13] _3635_/A VPWR VGND sg13cmos5l_buf_1
XFILLER_335_266 VPWR VGND sg13cmos5l_decap_8
XFILLER_161_103 VPWR VGND sg13cmos5l_decap_8
XFILLER_683_71 VPWR VGND sg13cmos5l_decap_8
XFILLER_255_22 VPWR VGND sg13cmos5l_decap_8
XFILLER_683_82 VPWR VGND sg13cmos5l_fill_2
XFILLER_108_49 VPWR VGND sg13cmos5l_decap_8
X_0778_ _0778_/Q Tile_X0Y9_FrameData[21] VGND VPWR Tile_X0Y9_FrameStrobe[3] latch
X_3566_ Tile_X0Y9_EE4BEG[12] _4876_/X VPWR VGND sg13cmos5l_buf_1
XFILLER_496_229 VPWR VGND sg13cmos5l_decap_8
XFILLER_700_127 VPWR VGND sg13cmos5l_decap_8
XFILLER_449_112 VPWR VGND sg13cmos5l_decap_8
XFILLER_638_212 VPWR VGND sg13cmos5l_decap_8
X_2517_ _2517_/Q Tile_X0Y6_FrameData[18] VGND VPWR Tile_X0Y9_FrameStrobe[2] latch
XFILLER_405_14 VPWR VGND sg13cmos5l_decap_8
X_3497_ Tile_X0Y1_E6BEG[7] _3971_/X VPWR VGND sg13cmos5l_buf_1
XANTENNA__3216__X Tile_X0Y0_FrameStrobe_O[4] VPWR VGND sg13cmos5l_antennanp
XFILLER_255_99 VPWR VGND sg13cmos5l_decap_8
XFILLER_552_42 VPWR VGND sg13cmos5l_decap_8
X_2448_ _2448_/Q Tile_X0Y6_FrameData[23] VGND VPWR Tile_X0Y9_FrameStrobe[0] latch
XFILLER_464_104 VPWR VGND sg13cmos5l_decap_4
XFILLER_464_115 VPWR VGND sg13cmos5l_fill_1
XFILLER_271_21 VPWR VGND sg13cmos5l_decap_8
XFILLER_464_126 VPWR VGND sg13cmos5l_decap_8
X_2379_ _2379_/Q Tile_X0Y5_FrameData[26] VGND VPWR Tile_X0Y9_FrameStrobe[6] latch
XFILLER_68_161 VPWR VGND sg13cmos5l_decap_8
XFILLER_702_56 VPWR VGND sg13cmos5l_decap_8
X_4118_ _4118_/X _4093_/X _0057_/X _4092_/X Tile_X0Y0_S4END[10] _1477_/Q _1476_/Q
+ VPWR VGND sg13cmos5l_mux4_1
XFILLER_204_70 VPWR VGND sg13cmos5l_decap_8
XFILLER_83_142 VPWR VGND sg13cmos5l_fill_2
XFILLER_421_35 VPWR VGND sg13cmos5l_decap_8
XFILLER_405_215 VPWR VGND sg13cmos5l_decap_8
XFILLER_472_170 VPWR VGND sg13cmos5l_fill_2
XFILLER_17_35 VPWR VGND sg13cmos5l_decap_8
XFILLER_621_112 VPWR VGND sg13cmos5l_fill_2
XFILLER_271_232 VPWR VGND sg13cmos5l_decap_8
XFILLER_140_14 VPWR VGND sg13cmos5l_decap_8
X_4049_ _4049_/X Tile_X0Y2_W2END[6] AXI_M_SOC_AWREADY _4099_/X _4098_/X _1575_/Q _1574_/Q
+ VPWR VGND sg13cmos5l_mux4_1
XFILLER_559_230 VPWR VGND sg13cmos5l_fill_2
XFILLER_497_28 VPWR VGND sg13cmos5l_decap_8
XFILLER_169_203 VPWR VGND sg13cmos5l_decap_8
XFILLER_420_229 VPWR VGND sg13cmos5l_fill_2
XANTENNA__2790__X Tile_X0Y3_E6BEG[0] VPWR VGND sg13cmos5l_antennanp
XFILLER_242_7 VPWR VGND sg13cmos5l_decap_8
XFILLER_519_116 VPWR VGND sg13cmos5l_decap_8
XFILLER_385_122 VPWR VGND sg13cmos5l_fill_1
XFILLER_385_144 VPWR VGND sg13cmos5l_decap_8
XFILLER_574_266 VPWR VGND sg13cmos5l_decap_8
XFILLER_149_56 VPWR VGND sg13cmos5l_fill_2
XFILLER_507_7 VPWR VGND sg13cmos5l_decap_8
XFILLER_137_133 VPWR VGND sg13cmos5l_decap_8
XFILLER_446_43 VPWR VGND sg13cmos5l_decap_8
XFILLER_192_272 VPWR VGND sg13cmos5l_fill_1
XFILLER_152_125 VPWR VGND sg13cmos5l_decap_8
XFILLER_446_87 VPWR VGND sg13cmos5l_decap_8
XFILLER_315_14 VPWR VGND sg13cmos5l_decap_8
XANTENNA__3126__X Tile_X0Y7_EE4BEG[12] VPWR VGND sg13cmos5l_antennanp
XFILLER_462_42 VPWR VGND sg13cmos5l_decap_8
XFILLER_629_267 VPWR VGND sg13cmos5l_decap_4
XFILLER_181_21 VPWR VGND sg13cmos5l_decap_8
XFILLER_58_53 VPWR VGND sg13cmos5l_decap_8
XFILLER_462_86 VPWR VGND sg13cmos5l_decap_8
XANTENNA__2965__X Tile_X0Y8_FrameData_O[5] VPWR VGND sg13cmos5l_antennanp
XFILLER_199_0 VPWR VGND sg13cmos5l_decap_8
XFILLER_644_259 VPWR VGND sg13cmos5l_fill_2
XFILLER_59_172 VPWR VGND sg13cmos5l_decap_8
XFILLER_612_56 VPWR VGND sg13cmos5l_decap_8
XFILLER_74_120 VPWR VGND sg13cmos5l_decap_8
XFILLER_181_98 VPWR VGND sg13cmos5l_decap_8
XFILLER_612_78 VPWR VGND sg13cmos5l_decap_8
XFILLER_470_118 VPWR VGND sg13cmos5l_decap_8
XFILLER_207_126 VPWR VGND sg13cmos5l_decap_8
XFILLER_463_170 VPWR VGND sg13cmos5l_decap_8
XFILLER_366_0 VPWR VGND sg13cmos5l_decap_4
XFILLER_331_57 VPWR VGND sg13cmos5l_decap_8
XFILLER_114_92 VPWR VGND sg13cmos5l_fill_2
XFILLER_74_41 VPWR VGND sg13cmos5l_decap_4
XFILLER_207_159 VPWR VGND sg13cmos5l_decap_8
XFILLER_688_49 VPWR VGND sg13cmos5l_fill_1
XFILLER_612_134 VPWR VGND sg13cmos5l_decap_8
XFILLER_612_145 VPWR VGND sg13cmos5l_fill_1
XFILLER_222_107 VPWR VGND sg13cmos5l_decap_8
XFILLER_74_74 VPWR VGND sg13cmos5l_decap_8
XFILLER_15_220 VPWR VGND sg13cmos5l_decap_8
XFILLER_222_118 VPWR VGND sg13cmos5l_fill_1
XFILLER_74_85 VPWR VGND sg13cmos5l_decap_8
XFILLER_612_167 VPWR VGND sg13cmos5l_decap_8
XFILLER_533_0 VPWR VGND sg13cmos5l_decap_8
XFILLER_200_28 VPWR VGND sg13cmos5l_decap_8
XFILLER_30_212 VPWR VGND sg13cmos5l_decap_8
XFILLER_130_91 VPWR VGND sg13cmos5l_decap_8
XFILLER_30_223 VPWR VGND sg13cmos5l_fill_2
XFILLER_88_7 VPWR VGND sg13cmos5l_decap_8
XFILLER_700_0 VPWR VGND sg13cmos5l_decap_8
XFILLER_128_100 VPWR VGND sg13cmos5l_decap_4
XFILLER_637_42 VPWR VGND sg13cmos5l_decap_8
X_1750_ _1750_/Q Tile_X0Y3_FrameData[19] VGND VPWR Tile_X0Y9_FrameStrobe[2] latch
XFILLER_128_122 VPWR VGND sg13cmos5l_fill_1
XFILLER_707_271 VPWR VGND sg13cmos5l_fill_2
XFILLER_391_147 VPWR VGND sg13cmos5l_decap_8
XFILLER_356_21 VPWR VGND sg13cmos5l_decap_8
X_0701_ _0701_/Q Tile_X0Y9_FrameData[2] VGND VPWR Tile_X0Y9_FrameStrobe[0] latch
XFILLER_637_86 VPWR VGND sg13cmos5l_fill_1
XFILLER_183_250 VPWR VGND sg13cmos5l_decap_8
XFILLER_533_130 VPWR VGND sg13cmos5l_decap_8
X_1681_ _1681_/Q Tile_X0Y3_FrameData[24] VGND VPWR Tile_X0Y9_FrameStrobe[0] latch
X_0632_ _0632_/Q Tile_X0Y8_FrameData[7] VGND VPWR Tile_X0Y9_FrameStrobe[6] latch
X_3420_ Tile_X0Y4_FrameData_O[11] Tile_X0Y4_FrameData[11] VPWR VGND sg13cmos5l_buf_1
XFILLER_356_98 VPWR VGND sg13cmos5l_decap_8
XFILLER_478_229 VPWR VGND sg13cmos5l_fill_2
XFILLER_506_35 VPWR VGND sg13cmos5l_decap_8
XFILLER_143_169 VPWR VGND sg13cmos5l_fill_2
X_3351_ Tile_X0Y2_FrameData_O[22] Tile_X0Y2_FrameData[22] VPWR VGND sg13cmos5l_buf_1
XFILLER_225_14 VPWR VGND sg13cmos5l_decap_8
X_0563_ _0563_/Q Tile_X0Y8_FrameData[12] VGND VPWR Tile_X0Y9_FrameStrobe[4] latch
XFILLER_653_63 VPWR VGND sg13cmos5l_decap_8
XANTENNA__3036__X Tile_X0Y5_EE4BEG[11] VPWR VGND sg13cmos5l_antennanp
X_2302_ _2302_/Q Tile_X0Y5_FrameData[7] VGND VPWR Tile_X0Y9_FrameStrobe[3] latch
XFILLER_300_100 VPWR VGND sg13cmos5l_decap_8
XFILLER_151_180 VPWR VGND sg13cmos5l_decap_8
XFILLER_151_191 VPWR VGND sg13cmos5l_fill_2
X_3282_ Tile_X0Y0_E6BEG[2] _3838_/X VPWR VGND sg13cmos5l_buf_1
XFILLER_446_104 VPWR VGND sg13cmos5l_decap_8
XFILLER_225_69 VPWR VGND sg13cmos5l_fill_1
X_0494_ _0494_/Q Tile_X0Y8_FrameData[17] VGND VPWR Tile_X0Y9_FrameStrobe[2] latch
XFILLER_2_190 VPWR VGND sg13cmos5l_decap_8
X_2233_ _2233_/Q Tile_X0Y5_FrameData[12] VGND VPWR Tile_X0Y9_FrameStrobe[1] latch
XANTENNA__2875__X Tile_X0Y6_EE4BEG[12] VPWR VGND sg13cmos5l_antennanp
XFILLER_300_177 VPWR VGND sg13cmos5l_decap_8
X_2164_ _2164_/Q Tile_X0Y4_FrameData[17] VGND VPWR Tile_X0Y9_FrameStrobe[7] latch
XFILLER_253_210 VPWR VGND sg13cmos5l_fill_1
XFILLER_241_35 VPWR VGND sg13cmos5l_decap_8
XFILLER_650_229 VPWR VGND sg13cmos5l_decap_8
X_1115_ _1115_/Q Tile_X0Y0_FrameData[16] VGND VPWR Tile_X0Y9_FrameStrobe[5] latch
XFILLER_253_232 VPWR VGND sg13cmos5l_decap_8
XFILLER_603_123 VPWR VGND sg13cmos5l_fill_1
XFILLER_454_192 VPWR VGND sg13cmos5l_fill_2
X_2095_ _2095_/Q Tile_X0Y4_FrameData[22] VGND VPWR Tile_X0Y9_FrameStrobe[5] latch
XFILLER_65_175 VPWR VGND sg13cmos5l_decap_8
XFILLER_241_79 VPWR VGND sg13cmos5l_decap_8
XFILLER_598_49 VPWR VGND sg13cmos5l_decap_8
XFILLER_80_134 VPWR VGND sg13cmos5l_decap_8
XFILLER_0_82 VPWR VGND sg13cmos5l_fill_2
X_1046_ _1046_/Q Tile_X0Y0_FrameData[21] VGND VPWR Tile_X0Y9_FrameStrobe[3] latch
XFILLER_80_145 VPWR VGND sg13cmos5l_fill_2
XFILLER_556_200 VPWR VGND sg13cmos5l_decap_8
XFILLER_110_28 VPWR VGND sg13cmos5l_decap_8
XFILLER_80_189 VPWR VGND sg13cmos5l_decap_8
XFILLER_556_222 VPWR VGND sg13cmos5l_decap_8
XFILLER_410_251 VPWR VGND sg13cmos5l_decap_8
X_4805_ _4805_/X _4779_/X Tile_X0Y9_N4END[5] _4778_/X _0076_/X _0461_/Q _0460_/Q VPWR
+ VGND sg13cmos5l_mux4_1
XFILLER_410_262 VPWR VGND sg13cmos5l_fill_1
XFILLER_397_72 VPWR VGND sg13cmos5l_decap_8
XFILLER_166_206 VPWR VGND sg13cmos5l_decap_8
XFILLER_367_177 VPWR VGND sg13cmos5l_decap_8
X_2997_ Tile_X0Y5_E2BEG[0] _4372_/X VPWR VGND sg13cmos5l_buf_1
XFILLER_571_203 VPWR VGND sg13cmos5l_decap_8
XFILLER_382_114 VPWR VGND sg13cmos5l_fill_1
XFILLER_547_42 VPWR VGND sg13cmos5l_decap_8
XFILLER_9_91 VPWR VGND sg13cmos5l_decap_8
X_4736_ _4736_/X Tile_X0Y8_W2END[7] AXI_M_SOC_RDATA15 _4785_/X _4784_/X _0575_/Q _0574_/Q
+ VPWR VGND sg13cmos5l_mux4_1
XFILLER_382_136 VPWR VGND sg13cmos5l_fill_2
X_1948_ _1948_/Q Tile_X0Y4_FrameData[9] VGND VPWR Tile_X0Y9_FrameStrobe[0] latch
XFILLER_694_70 VPWR VGND sg13cmos5l_decap_8
XFILLER_571_247 VPWR VGND sg13cmos5l_decap_8
XFILLER_266_21 VPWR VGND sg13cmos5l_decap_8
XFILLER_547_86 VPWR VGND sg13cmos5l_fill_1
X_4667_ _4667_/X Tile_X0Y8_W1END[3] Tile_X0Y8_W6END[7] _4815_/X _4775_/X _0665_/Q
+ _0664_/Q VPWR VGND sg13cmos5l_mux4_1
X_1879_ _1879_/Q Tile_X0Y3_FrameData[18] VGND VPWR Tile_X0Y9_FrameStrobe[6] latch
XFILLER_266_65 VPWR VGND sg13cmos5l_fill_1
XFILLER_323_214 VPWR VGND sg13cmos5l_decap_8
XFILLER_266_87 VPWR VGND sg13cmos5l_decap_8
X_3618_ Tile_X0Y9_S2BEGb[4] _4936_/X VPWR VGND sg13cmos5l_buf_1
XFILLER_390_180 VPWR VGND sg13cmos5l_decap_8
X_4598_ _4598_/X Tile_X0Y5_W1END[3] Tile_X0Y5_W2MID[0] Tile_X0Y5_W2END[0] _4428_/X
+ _2381_/Q _2380_/Q VPWR VGND sg13cmos5l_mux4_1
XFILLER_416_35 VPWR VGND sg13cmos5l_decap_8
XFILLER_323_269 VPWR VGND sg13cmos5l_decap_4
XFILLER_135_14 VPWR VGND sg13cmos5l_decap_8
XFILLER_563_63 VPWR VGND sg13cmos5l_decap_8
X_3549_ Tile_X0Y9_E6BEG[7] _4887_/X VPWR VGND sg13cmos5l_buf_1
XFILLER_282_42 VPWR VGND sg13cmos5l_decap_8
XFILLER_713_33 VPWR VGND sg13cmos5l_decap_8
XFILLER_477_262 VPWR VGND sg13cmos5l_decap_8
XFILLER_437_126 VPWR VGND sg13cmos5l_decap_8
XFILLER_297_8 VPWR VGND sg13cmos5l_decap_8
XFILLER_693_181 VPWR VGND sg13cmos5l_decap_8
XFILLER_48_109 VPWR VGND sg13cmos5l_decap_4
XANTENNA__2785__X Tile_X0Y3_EE4BEG[11] VPWR VGND sg13cmos5l_antennanp
XFILLER_192_7 VPWR VGND sg13cmos5l_decap_8
XFILLER_492_243 VPWR VGND sg13cmos5l_decap_8
XFILLER_432_56 VPWR VGND sg13cmos5l_decap_8
XFILLER_151_35 VPWR VGND sg13cmos5l_decap_8
XFILLER_457_7 VPWR VGND sg13cmos5l_decap_8
XFILLER_244_254 VPWR VGND sg13cmos5l_decap_8
XFILLER_460_151 VPWR VGND sg13cmos5l_decap_4
XFILLER_204_118 VPWR VGND sg13cmos5l_decap_4
XFILLER_44_11 VPWR VGND sg13cmos5l_fill_2
XFILLER_231_90 VPWR VGND sg13cmos5l_fill_1
XFILLER_12_201 VPWR VGND sg13cmos5l_decap_8
XFILLER_71_189 VPWR VGND sg13cmos5l_decap_8
XFILLER_624_7 VPWR VGND sg13cmos5l_decap_8
XFILLER_212_140 VPWR VGND sg13cmos5l_decap_8
XFILLER_44_77 VPWR VGND sg13cmos5l_fill_2
XFILLER_358_133 VPWR VGND sg13cmos5l_decap_8
XFILLER_12_234 VPWR VGND sg13cmos5l_decap_8
XFILLER_157_206 VPWR VGND sg13cmos5l_decap_8
XFILLER_60_21 VPWR VGND sg13cmos5l_fill_1
XFILLER_457_42 VPWR VGND sg13cmos5l_decap_8
XFILLER_373_125 VPWR VGND sg13cmos5l_decap_4
XFILLER_60_43 VPWR VGND sg13cmos5l_fill_1
XFILLER_562_236 VPWR VGND sg13cmos5l_decap_8
XFILLER_176_21 VPWR VGND sg13cmos5l_decap_8
XFILLER_373_169 VPWR VGND sg13cmos5l_decap_8
XFILLER_60_76 VPWR VGND sg13cmos5l_decap_8
XFILLER_457_97 VPWR VGND sg13cmos5l_decap_8
XFILLER_165_272 VPWR VGND sg13cmos5l_fill_1
XFILLER_114_0 VPWR VGND sg13cmos5l_decap_8
XFILLER_180_220 VPWR VGND sg13cmos5l_decap_8
XFILLER_607_56 VPWR VGND sg13cmos5l_decap_8
XFILLER_176_87 VPWR VGND sg13cmos5l_fill_1
XFILLER_515_185 VPWR VGND sg13cmos5l_fill_1
XFILLER_515_196 VPWR VGND sg13cmos5l_decap_8
XFILLER_326_35 VPWR VGND sg13cmos5l_fill_2
XFILLER_5_49 VPWR VGND sg13cmos5l_decap_8
XFILLER_125_169 VPWR VGND sg13cmos5l_decap_8
XFILLER_530_144 VPWR VGND sg13cmos5l_decap_8
XFILLER_690_28 VPWR VGND sg13cmos5l_decap_8
XFILLER_473_63 VPWR VGND sg13cmos5l_decap_8
XFILLER_279_140 VPWR VGND sg13cmos5l_decap_8
XFILLER_69_63 VPWR VGND sg13cmos5l_decap_8
XFILLER_468_251 VPWR VGND sg13cmos5l_decap_4
XFILLER_483_0 VPWR VGND sg13cmos5l_decap_4
XFILLER_428_126 VPWR VGND sg13cmos5l_decap_8
XFILLER_623_77 VPWR VGND sg13cmos5l_decap_8
XFILLER_684_192 VPWR VGND sg13cmos5l_decap_8
XFILLER_699_15 VPWR VGND sg13cmos5l_decap_8
XFILLER_342_56 VPWR VGND sg13cmos5l_fill_1
XFILLER_650_0 VPWR VGND sg13cmos5l_decap_8
XFILLER_436_181 VPWR VGND sg13cmos5l_decap_8
XFILLER_235_232 VPWR VGND sg13cmos5l_decap_8
XFILLER_451_140 VPWR VGND sg13cmos5l_decap_8
XFILLER_62_145 VPWR VGND sg13cmos5l_decap_8
XFILLER_250_213 VPWR VGND sg13cmos5l_fill_1
XFILLER_211_49 VPWR VGND sg13cmos5l_decap_8
XFILLER_451_184 VPWR VGND sg13cmos5l_fill_2
XFILLER_250_235 VPWR VGND sg13cmos5l_decap_8
XFILLER_600_137 VPWR VGND sg13cmos5l_decap_8
X_2920_ Tile_X0Y8_E2BEG[4] _4732_/X VPWR VGND sg13cmos5l_buf_1
XFILLER_62_189 VPWR VGND sg13cmos5l_decap_8
XFILLER_600_159 VPWR VGND sg13cmos5l_decap_8
XFILLER_538_222 VPWR VGND sg13cmos5l_fill_2
XFILLER_349_133 VPWR VGND sg13cmos5l_decap_8
XFILLER_203_184 VPWR VGND sg13cmos5l_fill_1
X_2851_ Tile_X0Y6_E6BEG[0] _4528_/X VPWR VGND sg13cmos5l_buf_1
XFILLER_648_63 VPWR VGND sg13cmos5l_decap_8
X_1802_ _1802_/Q Tile_X0Y3_FrameData[31] VGND VPWR Tile_X0Y9_FrameStrobe[4] latch
XFILLER_553_225 VPWR VGND sg13cmos5l_decap_8
XFILLER_364_125 VPWR VGND sg13cmos5l_decap_8
X_2782_ Tile_X0Y3_EE4BEG[8] _4172_/X VPWR VGND sg13cmos5l_buf_1
XFILLER_367_64 VPWR VGND sg13cmos5l_decap_8
XFILLER_367_86 VPWR VGND sg13cmos5l_decap_8
X_4521_ _4521_/X Tile_X0Y6_WW4END[6] AXI_M_SOC_RDATA30 _4574_/X _4554_/X _2565_/Q
+ _2564_/Q VPWR VGND sg13cmos5l_mux4_1
X_1733_ _1733_/Q Tile_X0Y3_FrameData[4] VGND VPWR Tile_X0Y9_FrameStrobe[1] latch
XFILLER_156_272 VPWR VGND sg13cmos5l_fill_1
XFILLER_7_260 VPWR VGND sg13cmos5l_fill_2
XFILLER_116_125 VPWR VGND sg13cmos5l_fill_2
XFILLER_517_56 VPWR VGND sg13cmos5l_decap_8
XFILLER_305_214 VPWR VGND sg13cmos5l_decap_8
XFILLER_171_220 VPWR VGND sg13cmos5l_decap_8
XFILLER_710_200 VPWR VGND sg13cmos5l_fill_2
XFILLER_521_100 VPWR VGND sg13cmos5l_fill_1
X_4452_ _4452_/X _4421_/X _0159_/X _4420_/X _0145_/X _2235_/Q _2234_/Q VPWR VGND sg13cmos5l_mux4_1
X_1664_ _1664_/Q Tile_X0Y2_FrameData[17] VGND VPWR Tile_X0Y9_FrameStrobe[7] latch
XFILLER_517_89 VPWR VGND sg13cmos5l_decap_8
XFILLER_383_41 VPWR VGND sg13cmos5l_fill_1
XFILLER_236_35 VPWR VGND sg13cmos5l_decap_8
X_3403_ Tile_X0Y2_E2BEG[6] _4046_/X VPWR VGND sg13cmos5l_buf_1
XFILLER_383_63 VPWR VGND sg13cmos5l_decap_8
X_0615_ _0615_/Q Tile_X0Y8_FrameData[24] VGND VPWR Tile_X0Y9_FrameStrobe[6] latch
X_1595_ _1595_/Q Tile_X0Y2_FrameData[22] VGND VPWR Tile_X0Y9_FrameStrobe[5] latch
X_4383_ _4383_/X Tile_X0Y5_W2END[4] AXI_M_SOC_RVALID _4434_/X _4433_/X _2337_/Q _2336_/Q
+ VPWR VGND sg13cmos5l_mux4_1
X_0546_ _0546_/Q Tile_X0Y8_FrameData[29] VGND VPWR Tile_X0Y9_FrameStrobe[4] latch
X_3334_ Tile_X0Y2_FrameData_O[5] Tile_X0Y2_FrameData[5] VPWR VGND sg13cmos5l_buf_1
XFILLER_419_115 VPWR VGND sg13cmos5l_decap_8
XFILLER_474_210 VPWR VGND sg13cmos5l_decap_8
XFILLER_105_28 VPWR VGND sg13cmos5l_decap_8
XFILLER_680_83 VPWR VGND sg13cmos5l_decap_8
XFILLER_85_226 VPWR VGND sg13cmos5l_decap_4
X_0477_ _0477_/Q Tile_X0Y8_FrameData[2] VGND VPWR Tile_X0Y9_FrameStrobe[1] latch
X_3265_ Tile_X0Y0_EE4BEG[1] _3821_/X VPWR VGND sg13cmos5l_buf_1
XFILLER_533_88 VPWR VGND sg13cmos5l_decap_8
XFILLER_285_154 VPWR VGND sg13cmos5l_decap_8
XFILLER_252_56 VPWR VGND sg13cmos5l_decap_8
X_2216_ _2216_/Q Tile_X0Y5_FrameData[29] VGND VPWR Tile_X0Y9_FrameStrobe[1] latch
X_3196_ Tile_X0Y0_N2BEGb[4] _3897_/X VPWR VGND sg13cmos5l_buf_1
XFILLER_434_129 VPWR VGND sg13cmos5l_decap_8
XFILLER_38_164 VPWR VGND sg13cmos5l_decap_8
X_2147_ _2147_/Q Tile_X0Y4_FrameData[2] VGND VPWR Tile_X0Y9_FrameStrobe[6] latch
XFILLER_226_265 VPWR VGND sg13cmos5l_decap_8
XFILLER_689_92 VPWR VGND sg13cmos5l_decap_8
XFILLER_588_155 VPWR VGND sg13cmos5l_decap_8
XFILLER_121_49 VPWR VGND sg13cmos5l_decap_8
X_2078_ _2078_/Q Tile_X0Y4_FrameData[7] VGND VPWR Tile_X0Y9_FrameStrobe[4] latch
XFILLER_588_166 VPWR VGND sg13cmos5l_fill_2
XFILLER_53_167 VPWR VGND sg13cmos5l_fill_1
XFILLER_442_195 VPWR VGND sg13cmos5l_decap_8
X_1029_ _1029_/Q Tile_X0Y0_FrameData[6] VGND VPWR Tile_X0Y9_FrameStrobe[2] latch
XFILLER_53_189 VPWR VGND sg13cmos5l_decap_8
XFILLER_241_268 VPWR VGND sg13cmos5l_decap_4
XFILLER_14_14 VPWR VGND sg13cmos5l_decap_8
XFILLER_529_244 VPWR VGND sg13cmos5l_fill_2
XFILLER_558_63 VPWR VGND sg13cmos5l_decap_8
XFILLER_139_217 VPWR VGND sg13cmos5l_decap_8
XFILLER_395_272 VPWR VGND sg13cmos5l_fill_1
XFILLER_544_214 VPWR VGND sg13cmos5l_decap_8
XFILLER_277_42 VPWR VGND sg13cmos5l_decap_8
XFILLER_355_147 VPWR VGND sg13cmos5l_decap_8
XFILLER_544_269 VPWR VGND sg13cmos5l_decap_4
X_4719_ _4719_/X _4805_/X _4809_/X _4813_/X _4788_/X _0608_/Q _0607_/Q VPWR VGND sg13cmos5l_mux4_1
XFILLER_708_77 VPWR VGND sg13cmos5l_decap_8
XFILLER_427_56 VPWR VGND sg13cmos5l_decap_8
XFILLER_205_7 VPWR VGND sg13cmos5l_decap_8
XFILLER_574_84 VPWR VGND sg13cmos5l_decap_8
XFILLER_146_35 VPWR VGND sg13cmos5l_decap_8
XFILLER_512_133 VPWR VGND sg13cmos5l_fill_1
XFILLER_512_155 VPWR VGND sg13cmos5l_decap_8
XFILLER_311_206 VPWR VGND sg13cmos5l_decap_8
XFILLER_293_63 VPWR VGND sg13cmos5l_decap_8
XFILLER_122_139 VPWR VGND sg13cmos5l_decap_8
XFILLER_465_221 VPWR VGND sg13cmos5l_decap_8
XFILLER_666_181 VPWR VGND sg13cmos5l_decap_8
XFILLER_130_161 VPWR VGND sg13cmos5l_decap_8
XFILLER_574_7 VPWR VGND sg13cmos5l_decap_8
XANTENNA__3404__X Tile_X0Y2_E2BEG[7] VPWR VGND sg13cmos5l_antennanp
XFILLER_162_56 VPWR VGND sg13cmos5l_fill_2
XFILLER_276_187 VPWR VGND sg13cmos5l_decap_8
XFILLER_91_207 VPWR VGND sg13cmos5l_decap_8
XFILLER_44_101 VPWR VGND sg13cmos5l_decap_8
XFILLER_579_122 VPWR VGND sg13cmos5l_decap_8
XFILLER_433_140 VPWR VGND sg13cmos5l_fill_2
XFILLER_599_70 VPWR VGND sg13cmos5l_fill_2
XFILLER_55_54 VPWR VGND sg13cmos5l_decap_8
XFILLER_55_65 VPWR VGND sg13cmos5l_fill_1
XFILLER_55_76 VPWR VGND sg13cmos5l_decap_8
XFILLER_44_145 VPWR VGND sg13cmos5l_decap_8
XFILLER_44_156 VPWR VGND sg13cmos5l_fill_2
XFILLER_232_224 VPWR VGND sg13cmos5l_decap_8
XFILLER_433_195 VPWR VGND sg13cmos5l_fill_2
XFILLER_594_114 VPWR VGND sg13cmos5l_decap_8
XFILLER_594_125 VPWR VGND sg13cmos5l_fill_1
XFILLER_71_42 VPWR VGND sg13cmos5l_decap_8
XFILLER_468_63 VPWR VGND sg13cmos5l_decap_4
XFILLER_231_0 VPWR VGND sg13cmos5l_decap_8
XFILLER_346_103 VPWR VGND sg13cmos5l_decap_8
XFILLER_329_0 VPWR VGND sg13cmos5l_decap_4
XFILLER_535_225 VPWR VGND sg13cmos5l_decap_8
XFILLER_346_147 VPWR VGND sg13cmos5l_fill_1
XFILLER_200_176 VPWR VGND sg13cmos5l_fill_2
XFILLER_187_86 VPWR VGND sg13cmos5l_decap_8
XFILLER_346_169 VPWR VGND sg13cmos5l_decap_4
XFILLER_200_187 VPWR VGND sg13cmos5l_fill_1
XFILLER_618_77 VPWR VGND sg13cmos5l_decap_8
XFILLER_138_272 VPWR VGND sg13cmos5l_fill_1
XFILLER_153_220 VPWR VGND sg13cmos5l_fill_1
XFILLER_689_262 VPWR VGND sg13cmos5l_decap_8
XFILLER_484_84 VPWR VGND sg13cmos5l_decap_8
XFILLER_634_21 VPWR VGND sg13cmos5l_decap_8
XFILLER_503_133 VPWR VGND sg13cmos5l_decap_8
XFILLER_299_235 VPWR VGND sg13cmos5l_decap_8
XFILLER_649_126 VPWR VGND sg13cmos5l_decap_4
XFILLER_698_0 VPWR VGND sg13cmos5l_decap_8
XFILLER_299_268 VPWR VGND sg13cmos5l_decap_4
X_0400_ _0400_/Q Tile_X0Y7_FrameData[15] VGND VPWR Tile_X0Y9_FrameStrobe[7] latch
XFILLER_106_191 VPWR VGND sg13cmos5l_decap_8
X_1380_ _1380_/Q Tile_X0Y1_FrameData[21] VGND VPWR Tile_X0Y9_FrameStrobe[6] latch
XFILLER_206_49 VPWR VGND sg13cmos5l_decap_8
XFILLER_634_98 VPWR VGND sg13cmos5l_decap_8
XFILLER_96_61 VPWR VGND sg13cmos5l_fill_1
X_0331_ _0331_/Q Tile_X0Y7_FrameData[20] VGND VPWR Tile_X0Y9_FrameStrobe[5] latch
XFILLER_353_77 VPWR VGND sg13cmos5l_decap_8
XFILLER_121_161 VPWR VGND sg13cmos5l_decap_8
XFILLER_503_14 VPWR VGND sg13cmos5l_decap_8
XFILLER_310_261 VPWR VGND sg13cmos5l_fill_1
XANTENNA__3314__X Tile_X0Y4_EE4BEG[2] VPWR VGND sg13cmos5l_antennanp
XFILLER_310_272 VPWR VGND sg13cmos5l_fill_1
XFILLER_650_42 VPWR VGND sg13cmos5l_decap_8
X_3050_ Tile_X0Y5_FrameData_O[9] Tile_X0Y5_FrameData[9] VPWR VGND sg13cmos5l_buf_1
X_0262_ _0262_/Q Tile_X0Y7_FrameData[25] VGND VPWR Tile_X0Y9_FrameStrobe[3] latch
XFILLER_672_173 VPWR VGND sg13cmos5l_decap_8
X_2001_ _2001_/Q Tile_X0Y4_FrameData[20] VGND VPWR Tile_X0Y9_FrameStrobe[2] latch
XFILLER_672_195 VPWR VGND sg13cmos5l_decap_8
XFILLER_82_229 VPWR VGND sg13cmos5l_fill_1
XFILLER_471_257 VPWR VGND sg13cmos5l_decap_8
X_0193_ _0193_/Q Tile_X0Y7_FrameData[30] VGND VPWR Tile_X0Y9_FrameStrobe[1] latch
XFILLER_282_168 VPWR VGND sg13cmos5l_decap_8
XFILLER_424_140 VPWR VGND sg13cmos5l_decap_8
XFILLER_223_224 VPWR VGND sg13cmos5l_fill_1
X_3952_ _3952_/X Tile_X0Y1_WW4END[11] AXI_M_SOC_ARREADY _4019_/X _3995_/X _1305_/Q
+ _1304_/Q VPWR VGND sg13cmos5l_mux4_1
XFILLER_659_95 VPWR VGND sg13cmos5l_decap_8
X_2903_ Tile_X0Y6_FrameData_O[24] Tile_X0Y6_FrameData[24] VPWR VGND sg13cmos5l_buf_1
XFILLER_595_28 VPWR VGND sg13cmos5l_decap_8
XFILLER_377_250 VPWR VGND sg13cmos5l_decap_8
XFILLER_188_161 VPWR VGND sg13cmos5l_decap_8
X_3883_ _3883_/X _3850_/X _0085_/X Tile_X0Y0_S1END[2] Tile_X0Y0_S4END[2] _0991_/Q
+ _0990_/Q VPWR VGND sg13cmos5l_mux4_1
X_2834_ Tile_X0Y6_E1BEG[3] _4495_/X VPWR VGND sg13cmos5l_buf_1
XFILLER_77_0 VPWR VGND sg13cmos5l_fill_2
XFILLER_526_258 VPWR VGND sg13cmos5l_decap_4
XFILLER_675_72 VPWR VGND sg13cmos5l_decap_8
X_2765_ Tile_X0Y3_FrameData_O[23] Tile_X0Y3_FrameData[23] VPWR VGND sg13cmos5l_buf_1
XFILLER_541_217 VPWR VGND sg13cmos5l_decap_4
XFILLER_528_99 VPWR VGND sg13cmos5l_decap_8
XFILLER_541_228 VPWR VGND sg13cmos5l_decap_8
X_4504_ _4504_/X Tile_X0Y6_W2END[7] AXI_M_SOC_RDATA31 _4553_/X _4552_/X _2599_/Q _2598_/Q
+ VPWR VGND sg13cmos5l_mux4_1
XFILLER_144_231 VPWR VGND sg13cmos5l_decap_4
X_1716_ _1716_/Q Tile_X0Y3_FrameData[21] VGND VPWR Tile_X0Y9_FrameStrobe[1] latch
XFILLER_394_73 VPWR VGND sg13cmos5l_decap_8
X_2696_ _2696_/Q Tile_X0Y6_FrameData[31] VGND VPWR Tile_X0Y9_FrameStrobe[0] latch
XFILLER_544_21 VPWR VGND sg13cmos5l_decap_8
XFILLER_6_70 VPWR VGND sg13cmos5l_decap_8
XFILLER_104_106 VPWR VGND sg13cmos5l_decap_8
X_4435_ _4435_/X Tile_X0Y1_W1END[0] Tile_X0Y1_WW4END[12] Tile_X0Y1_W6END[4] _4008_/X
+ _1365_/Q _1364_/Q VPWR VGND sg13cmos5l_mux4_1
X_1647_ _1647_/Q Tile_X0Y2_FrameData[2] VGND VPWR Tile_X0Y9_FrameStrobe[6] latch
XFILLER_116_49 VPWR VGND sg13cmos5l_decap_8
X_4366_ _4366_/X Tile_X0Y3_W1END[3] Tile_X0Y3_W2MID[0] Tile_X0Y3_W2END[0] _4204_/X
+ _1867_/Q _1866_/Q VPWR VGND sg13cmos5l_mux4_1
XFILLER_544_98 VPWR VGND sg13cmos5l_decap_4
XFILLER_258_110 VPWR VGND sg13cmos5l_fill_1
X_1578_ _1578_/Q Tile_X0Y2_FrameData[7] VGND VPWR Tile_X0Y9_FrameStrobe[4] latch
XFILLER_447_221 VPWR VGND sg13cmos5l_decap_8
XFILLER_648_181 VPWR VGND sg13cmos5l_decap_8
XFILLER_258_132 VPWR VGND sg13cmos5l_decap_8
X_3317_ Tile_X0Y4_EE4BEG[5] _4277_/X VPWR VGND sg13cmos5l_buf_1
X_0529_ _0529_/Q Tile_X0Y8_FrameData[14] VGND VPWR Tile_X0Y9_FrameStrobe[3] latch
XFILLER_413_14 VPWR VGND sg13cmos5l_decap_8
XFILLER_301_261 VPWR VGND sg13cmos5l_fill_1
XFILLER_263_88 VPWR VGND sg13cmos5l_decap_8
XANTENNA__3224__X Tile_X0Y0_FrameStrobe_O[12] VPWR VGND sg13cmos5l_antennanp
X_4297_ _4297_/X AXI_M_SOC_BRESP1 _4338_/X _4342_/X _4316_/X _2019_/Q _2018_/Q VPWR
+ VGND sg13cmos5l_mux4_1
XFILLER_301_272 VPWR VGND sg13cmos5l_fill_1
XFILLER_112_183 VPWR VGND sg13cmos5l_decap_8
XFILLER_560_42 VPWR VGND sg13cmos5l_decap_8
X_3248_ Tile_X0Y0_FrameData_O[16] Tile_X0Y0_FrameData[16] VPWR VGND sg13cmos5l_buf_1
XFILLER_663_173 VPWR VGND sg13cmos5l_fill_2
XFILLER_258_198 VPWR VGND sg13cmos5l_decap_8
X_3179_ Tile_X0Y0_N4BEG[3] _3179_/A VPWR VGND sg13cmos5l_buf_1
XFILLER_710_56 VPWR VGND sg13cmos5l_decap_8
XFILLER_212_70 VPWR VGND sg13cmos5l_decap_8
XFILLER_26_156 VPWR VGND sg13cmos5l_decap_8
XFILLER_576_114 VPWR VGND sg13cmos5l_fill_1
XFILLER_25_35 VPWR VGND sg13cmos5l_fill_1
XFILLER_214_257 VPWR VGND sg13cmos5l_decap_8
XFILLER_576_125 VPWR VGND sg13cmos5l_decap_8
XFILLER_155_7 VPWR VGND sg13cmos5l_decap_8
XFILLER_430_154 VPWR VGND sg13cmos5l_decap_8
XFILLER_569_84 VPWR VGND sg13cmos5l_decap_8
XFILLER_186_109 VPWR VGND sg13cmos5l_decap_8
XFILLER_288_85 VPWR VGND sg13cmos5l_decap_8
XFILLER_194_131 VPWR VGND sg13cmos5l_decap_4
XFILLER_322_7 VPWR VGND sg13cmos5l_decap_8
XFILLER_194_142 VPWR VGND sg13cmos5l_decap_8
XFILLER_383_231 VPWR VGND sg13cmos5l_decap_8
XFILLER_438_77 VPWR VGND sg13cmos5l_decap_8
XFILLER_532_217 VPWR VGND sg13cmos5l_decap_8
XFILLER_135_253 VPWR VGND sg13cmos5l_decap_4
XFILLER_454_21 VPWR VGND sg13cmos5l_decap_8
XFILLER_691_7 VPWR VGND sg13cmos5l_decap_8
XFILLER_540_261 VPWR VGND sg13cmos5l_decap_8
XFILLER_351_161 VPWR VGND sg13cmos5l_decap_8
XFILLER_497_154 VPWR VGND sg13cmos5l_decap_8
XFILLER_540_272 VPWR VGND sg13cmos5l_fill_1
XFILLER_1_222 VPWR VGND sg13cmos5l_decap_8
XFILLER_454_76 VPWR VGND sg13cmos5l_decap_8
XFILLER_500_147 VPWR VGND sg13cmos5l_decap_8
XFILLER_604_35 VPWR VGND sg13cmos5l_decap_8
XFILLER_438_232 VPWR VGND sg13cmos5l_decap_8
XFILLER_103_161 VPWR VGND sg13cmos5l_fill_2
XFILLER_49_215 VPWR VGND sg13cmos5l_fill_2
XFILLER_2_28 VPWR VGND sg13cmos5l_decap_8
XANTENNA__3134__X Tile_X0Y7_FrameData_O[4] VPWR VGND sg13cmos5l_antennanp
XFILLER_106_60 VPWR VGND sg13cmos5l_decap_8
XFILLER_470_42 VPWR VGND sg13cmos5l_decap_8
XFILLER_66_42 VPWR VGND sg13cmos5l_decap_8
XFILLER_181_0 VPWR VGND sg13cmos5l_decap_8
XANTENNA__2973__X Tile_X0Y8_FrameData_O[13] VPWR VGND sg13cmos5l_antennanp
XFILLER_279_0 VPWR VGND sg13cmos5l_decap_8
XFILLER_17_101 VPWR VGND sg13cmos5l_decap_8
XFILLER_453_257 VPWR VGND sg13cmos5l_fill_2
XFILLER_620_56 VPWR VGND sg13cmos5l_decap_8
XFILLER_205_224 VPWR VGND sg13cmos5l_decap_8
XFILLER_620_89 VPWR VGND sg13cmos5l_decap_8
XFILLER_122_70 VPWR VGND sg13cmos5l_decap_4
XFILLER_446_0 VPWR VGND sg13cmos5l_decap_4
XFILLER_610_243 VPWR VGND sg13cmos5l_decap_8
XFILLER_479_73 VPWR VGND sg13cmos5l_decap_4
XFILLER_421_154 VPWR VGND sg13cmos5l_decap_8
XFILLER_696_49 VPWR VGND sg13cmos5l_decap_8
XFILLER_567_147 VPWR VGND sg13cmos5l_decap_8
XFILLER_629_21 VPWR VGND sg13cmos5l_decap_8
XFILLER_610_265 VPWR VGND sg13cmos5l_decap_8
XFILLER_82_96 VPWR VGND sg13cmos5l_decap_8
XFILLER_709_141 VPWR VGND sg13cmos5l_decap_4
XFILLER_359_261 VPWR VGND sg13cmos5l_decap_8
XFILLER_613_0 VPWR VGND sg13cmos5l_decap_8
XFILLER_359_272 VPWR VGND sg13cmos5l_fill_1
XFILLER_319_103 VPWR VGND sg13cmos5l_fill_2
XFILLER_198_96 VPWR VGND sg13cmos5l_decap_8
XFILLER_319_136 VPWR VGND sg13cmos5l_fill_1
XFILLER_40_170 VPWR VGND sg13cmos5l_decap_8
X_0880_ _0880_/Q Tile_X0Y9_FrameData[15] VGND VPWR Tile_X0Y9_FrameStrobe[6] latch
XFILLER_709_196 VPWR VGND sg13cmos5l_decap_8
XFILLER_629_98 VPWR VGND sg13cmos5l_decap_8
XFILLER_185_175 VPWR VGND sg13cmos5l_decap_8
XFILLER_348_77 VPWR VGND sg13cmos5l_decap_8
XFILLER_523_206 VPWR VGND sg13cmos5l_fill_1
XANTENNA__3309__X Tile_X0Y0_E1BEG[1] VPWR VGND sg13cmos5l_antennanp
XFILLER_523_228 VPWR VGND sg13cmos5l_decap_8
XFILLER_126_220 VPWR VGND sg13cmos5l_decap_8
XFILLER_334_139 VPWR VGND sg13cmos5l_decap_8
XFILLER_645_42 VPWR VGND sg13cmos5l_decap_8
X_2550_ _2550_/Q Tile_X0Y6_FrameData[17] VGND VPWR Tile_X0Y9_FrameStrobe[3] latch
XFILLER_126_253 VPWR VGND sg13cmos5l_decap_4
XFILLER_364_21 VPWR VGND sg13cmos5l_decap_8
X_1501_ _1501_/Q Tile_X0Y2_FrameData[20] VGND VPWR Tile_X0Y9_FrameStrobe[2] latch
XFILLER_488_132 VPWR VGND sg13cmos5l_fill_2
X_2481_ _2481_/Q Tile_X0Y6_FrameData[22] VGND VPWR Tile_X0Y9_FrameStrobe[1] latch
XFILLER_531_272 VPWR VGND sg13cmos5l_fill_1
XFILLER_677_265 VPWR VGND sg13cmos5l_decap_8
X_4220_ _4220_/X Tile_X0Y7_W1END[3] Tile_X0Y7_WW4END[3] Tile_X0Y7_W6END[11] _4687_/X
+ _0382_/Q _0381_/Q VPWR VGND sg13cmos5l_mux4_1
X_1432_ _1432_/Q Tile_X0Y2_FrameData[25] VGND VPWR Tile_X0Y9_FrameStrobe[0] latch
XFILLER_488_187 VPWR VGND sg13cmos5l_fill_1
XFILLER_287_238 VPWR VGND sg13cmos5l_decap_8
XFILLER_429_210 VPWR VGND sg13cmos5l_decap_8
XFILLER_514_35 VPWR VGND sg13cmos5l_decap_8
X_1363_ _1363_/Q Tile_X0Y1_FrameData[6] VGND VPWR Tile_X0Y9_FrameStrobe[5] latch
X_4151_ _4151_/X Tile_X0Y3_W2MID[4] AXI_M_SOC_BVALID _4211_/X _4210_/X _1839_/Q _1838_/Q
+ VPWR VGND sg13cmos5l_mux4_1
XFILLER_661_63 VPWR VGND sg13cmos5l_decap_8
XFILLER_233_14 VPWR VGND sg13cmos5l_decap_8
XANTENNA__3044__X Tile_X0Y5_FrameData_O[3] VPWR VGND sg13cmos5l_antennanp
XFILLER_645_140 VPWR VGND sg13cmos5l_decap_8
XFILLER_380_42 VPWR VGND sg13cmos5l_decap_8
X_0314_ _0314_/Q Tile_X0Y7_FrameData[5] VGND VPWR Tile_X0Y9_FrameStrobe[4] latch
X_3102_ Tile_X0Y7_E6BEG[0] _4644_/X VPWR VGND sg13cmos5l_buf_1
XFILLER_255_113 VPWR VGND sg13cmos5l_fill_2
XFILLER_233_47 VPWR VGND sg13cmos5l_fill_2
X_1294_ _1294_/Q Tile_X0Y1_FrameData[11] VGND VPWR Tile_X0Y9_FrameStrobe[3] latch
X_4082_ _4082_/X AXI_M_SOC_AWREADY _4117_/X _4121_/X _4098_/X _1509_/Q _1508_/Q VPWR
+ VGND sg13cmos5l_mux4_1
XFILLER_380_64 VPWR VGND sg13cmos5l_decap_8
XFILLER_255_157 VPWR VGND sg13cmos5l_decap_8
XANTENNA__2883__X Tile_X0Y6_FrameData_O[4] VPWR VGND sg13cmos5l_antennanp
X_0245_ _0245_/Q Tile_X0Y7_FrameData[10] VGND VPWR Tile_X0Y9_FrameStrobe[2] latch
X_3033_ Tile_X0Y5_EE4BEG[8] _4396_/X VPWR VGND sg13cmos5l_buf_1
XFILLER_55_229 VPWR VGND sg13cmos5l_decap_8
XFILLER_660_143 VPWR VGND sg13cmos5l_decap_8
XFILLER_530_56 VPWR VGND sg13cmos5l_decap_8
X_0176_ _0176_/Q Tile_X0Y7_FrameData[15] VGND VPWR Tile_X0Y9_FrameStrobe[0] latch
XFILLER_660_187 VPWR VGND sg13cmos5l_decap_8
XFILLER_63_251 VPWR VGND sg13cmos5l_decap_4
XFILLER_389_84 VPWR VGND sg13cmos5l_decap_8
XFILLER_23_137 VPWR VGND sg13cmos5l_decap_8
XFILLER_539_21 VPWR VGND sg13cmos5l_decap_8
X_3935_ _3935_/X Tile_X0Y1_W2MID[4] AXI_M_SOC_ARREADY _3995_/X _3994_/X _1339_/Q _1338_/Q
+ VPWR VGND sg13cmos5l_mux4_1
XFILLER_412_198 VPWR VGND sg13cmos5l_decap_8
XFILLER_211_249 VPWR VGND sg13cmos5l_decap_4
XFILLER_31_170 VPWR VGND sg13cmos5l_decap_8
XFILLER_176_142 VPWR VGND sg13cmos5l_fill_1
X_3866_ _3866_/X _4340_/X _4344_/X _4348_/X _4313_/X _2157_/Q _2156_/Q VPWR VGND sg13cmos5l_mux4_1
XFILLER_365_242 VPWR VGND sg13cmos5l_decap_8
XFILLER_715_133 VPWR VGND sg13cmos5l_decap_8
XFILLER_176_164 VPWR VGND sg13cmos5l_decap_8
X_2817_ Tile_X0Y3_E2BEG[7] _4155_/X VPWR VGND sg13cmos5l_buf_1
XFILLER_514_206 VPWR VGND sg13cmos5l_decap_4
XFILLER_325_106 VPWR VGND sg13cmos5l_decap_8
XFILLER_258_77 VPWR VGND sg13cmos5l_decap_8
XFILLER_581_161 VPWR VGND sg13cmos5l_decap_8
XFILLER_408_14 VPWR VGND sg13cmos5l_decap_8
X_3797_ _3797_/X _3887_/X _3868_/X _3867_/X _3857_/X _1147_/Q _1146_/Q VPWR VGND sg13cmos5l_mux4_1
XANTENNA__3219__X Tile_X0Y0_FrameStrobe_O[7] VPWR VGND sg13cmos5l_antennanp
XFILLER_514_239 VPWR VGND sg13cmos5l_fill_1
X_2748_ Tile_X0Y3_FrameData_O[6] Tile_X0Y3_FrameData[6] VPWR VGND sg13cmos5l_buf_1
XFILLER_274_21 VPWR VGND sg13cmos5l_decap_8
XFILLER_132_201 VPWR VGND sg13cmos5l_decap_8
XFILLER_668_243 VPWR VGND sg13cmos5l_decap_8
X_2679_ _2679_/Q Tile_X0Y6_FrameData[16] VGND VPWR Tile_X0Y9_FrameStrobe[7] latch
XFILLER_522_272 VPWR VGND sg13cmos5l_fill_1
XFILLER_705_56 VPWR VGND sg13cmos5l_decap_8
X_4418_ _4418_/X Tile_X0Y6_W1END[0] Tile_X0Y6_W6END[4] _4580_/X _4540_/X _2695_/Q
+ _2694_/Q VPWR VGND sg13cmos5l_mux4_1
XFILLER_278_238 VPWR VGND sg13cmos5l_fill_2
XFILLER_683_213 VPWR VGND sg13cmos5l_decap_8
XFILLER_479_198 VPWR VGND sg13cmos5l_decap_8
XFILLER_424_35 VPWR VGND sg13cmos5l_decap_8
XFILLER_207_70 VPWR VGND sg13cmos5l_decap_8
XFILLER_571_63 VPWR VGND sg13cmos5l_decap_8
XFILLER_143_14 VPWR VGND sg13cmos5l_decap_8
X_4349_ _4349_/X _4305_/X _0158_/X _4304_/X _0111_/X _1955_/Q _1954_/Q VPWR VGND sg13cmos5l_mux4_1
XFILLER_683_257 VPWR VGND sg13cmos5l_fill_1
XFILLER_494_168 VPWR VGND sg13cmos5l_decap_8
XFILLER_636_140 VPWR VGND sg13cmos5l_decap_8
XFILLER_100_120 VPWR VGND sg13cmos5l_decap_8
XFILLER_290_64 VPWR VGND sg13cmos5l_decap_8
XFILLER_246_146 VPWR VGND sg13cmos5l_decap_8
XFILLER_46_218 VPWR VGND sg13cmos5l_decap_8
XANTENNA__2793__X Tile_X0Y3_E6BEG[3] VPWR VGND sg13cmos5l_antennanp
XFILLER_246_157 VPWR VGND sg13cmos5l_fill_1
XFILLER_272_7 VPWR VGND sg13cmos5l_decap_8
XFILLER_651_154 VPWR VGND sg13cmos5l_decap_8
XFILLER_440_56 VPWR VGND sg13cmos5l_decap_8
XFILLER_450_227 VPWR VGND sg13cmos5l_decap_8
XFILLER_261_138 VPWR VGND sg13cmos5l_decap_8
XFILLER_403_132 VPWR VGND sg13cmos5l_decap_8
XFILLER_403_143 VPWR VGND sg13cmos5l_fill_1
XFILLER_199_256 VPWR VGND sg13cmos5l_fill_1
XFILLER_537_7 VPWR VGND sg13cmos5l_decap_8
XFILLER_403_165 VPWR VGND sg13cmos5l_decap_8
XFILLER_449_21 VPWR VGND sg13cmos5l_decap_8
XFILLER_549_169 VPWR VGND sg13cmos5l_decap_8
XFILLER_52_11 VPWR VGND sg13cmos5l_decap_8
XFILLER_52_33 VPWR VGND sg13cmos5l_decap_8
XFILLER_704_7 VPWR VGND sg13cmos5l_decap_8
XFILLER_356_231 VPWR VGND sg13cmos5l_decap_8
XFILLER_320_4 VPWR VGND sg13cmos5l_fill_1
XFILLER_210_271 VPWR VGND sg13cmos5l_fill_2
XFILLER_706_133 VPWR VGND sg13cmos5l_decap_8
XFILLER_706_144 VPWR VGND sg13cmos5l_decap_8
XFILLER_167_175 VPWR VGND sg13cmos5l_decap_8
XFILLER_167_186 VPWR VGND sg13cmos5l_fill_1
XFILLER_182_112 VPWR VGND sg13cmos5l_fill_2
XFILLER_572_161 VPWR VGND sg13cmos5l_decap_8
XFILLER_168_99 VPWR VGND sg13cmos5l_decap_8
XANTENNA__3129__X Tile_X0Y7_EE4BEG[15] VPWR VGND sg13cmos5l_antennanp
XFILLER_465_42 VPWR VGND sg13cmos5l_decap_8
XFILLER_318_36 VPWR VGND sg13cmos5l_fill_2
XFILLER_371_245 VPWR VGND sg13cmos5l_decap_8
XFILLER_184_43 VPWR VGND sg13cmos5l_decap_8
XFILLER_324_150 VPWR VGND sg13cmos5l_decap_8
XANTENNA__2968__X Tile_X0Y8_FrameData_O[8] VPWR VGND sg13cmos5l_antennanp
XFILLER_659_243 VPWR VGND sg13cmos5l_decap_8
XFILLER_513_272 VPWR VGND sg13cmos5l_fill_1
XFILLER_269_216 VPWR VGND sg13cmos5l_decap_8
XFILLER_7_0 VPWR VGND sg13cmos5l_decap_8
XFILLER_615_56 VPWR VGND sg13cmos5l_decap_8
XFILLER_481_63 VPWR VGND sg13cmos5l_decap_8
XFILLER_396_0 VPWR VGND sg13cmos5l_decap_8
XFILLER_334_79 VPWR VGND sg13cmos5l_decap_8
XFILLER_426_224 VPWR VGND sg13cmos5l_decap_8
XFILLER_563_0 VPWR VGND sg13cmos5l_decap_8
XFILLER_631_77 VPWR VGND sg13cmos5l_decap_8
XFILLER_37_229 VPWR VGND sg13cmos5l_decap_8
XFILLER_203_28 VPWR VGND sg13cmos5l_decap_8
XFILLER_642_154 VPWR VGND sg13cmos5l_decap_8
XFILLER_133_91 VPWR VGND sg13cmos5l_decap_8
XFILLER_350_56 VPWR VGND sg13cmos5l_decap_8
XFILLER_93_62 VPWR VGND sg13cmos5l_fill_2
XFILLER_45_251 VPWR VGND sg13cmos5l_decap_8
XFILLER_60_210 VPWR VGND sg13cmos5l_decap_8
XFILLER_595_231 VPWR VGND sg13cmos5l_decap_8
XFILLER_359_21 VPWR VGND sg13cmos5l_decap_8
XFILLER_595_264 VPWR VGND sg13cmos5l_fill_1
X_1981_ _1981_/Q Tile_X0Y4_FrameData[8] VGND VPWR Tile_X0Y9_FrameStrobe[1] latch
XFILLER_158_131 VPWR VGND sg13cmos5l_decap_8
X_3720_ AXI_M_SOC_WDATA30 Tile_X0Y6_W1END[2] Tile_X0Y6_WW4END[6] Tile_X0Y6_WW4END[14]
+ _4582_/X _2499_/Q _2498_/Q VPWR VGND sg13cmos5l_mux4_1
XFILLER_548_180 VPWR VGND sg13cmos5l_decap_4
X_0932_ _0932_/Q Tile_X0Y9_FrameData[23] VGND VPWR Tile_X0Y9_FrameStrobe[8] latch
XFILLER_359_98 VPWR VGND sg13cmos5l_decap_8
XFILLER_509_35 VPWR VGND sg13cmos5l_decap_8
XFILLER_9_163 VPWR VGND sg13cmos5l_decap_4
X_3651_ AXI_M_SOC_AWADDR12 Tile_X0Y5_W1END[0] Tile_X0Y5_WW4END[4] Tile_X0Y5_WW4END[12]
+ _4463_/X _2247_/Q _2246_/Q VPWR VGND sg13cmos5l_mux4_1
XFILLER_656_63 VPWR VGND sg13cmos5l_decap_8
XFILLER_228_14 VPWR VGND sg13cmos5l_decap_8
X_0863_ _0863_/Q Tile_X0Y9_FrameData[0] VGND VPWR Tile_X0Y9_FrameStrobe[5] latch
XANTENNA__3039__X Tile_X0Y5_EE4BEG[14] VPWR VGND sg13cmos5l_antennanp
XFILLER_375_42 VPWR VGND sg13cmos5l_decap_4
X_2602_ _2602_/Q Tile_X0Y6_FrameData[29] VGND VPWR Tile_X0Y9_FrameStrobe[5] latch
XFILLER_563_194 VPWR VGND sg13cmos5l_decap_8
XFILLER_173_156 VPWR VGND sg13cmos5l_decap_8
X_3582_ Tile_X0Y9_FrameData_O[12] Tile_X0Y9_FrameData[12] VPWR VGND sg13cmos5l_buf_1
X_0794_ _0794_/Q Tile_X0Y9_FrameData[5] VGND VPWR Tile_X0Y9_FrameStrobe[3] latch
XFILLER_712_147 VPWR VGND sg13cmos5l_decap_8
XFILLER_322_109 VPWR VGND sg13cmos5l_decap_4
XFILLER_511_209 VPWR VGND sg13cmos5l_fill_1
XANTENNA__2878__X Tile_X0Y6_EE4BEG[15] VPWR VGND sg13cmos5l_antennanp
X_2533_ _2533_/Q Tile_X0Y6_FrameData[2] VGND VPWR Tile_X0Y9_FrameStrobe[2] latch
XFILLER_114_212 VPWR VGND sg13cmos5l_fill_1
XFILLER_504_272 VPWR VGND sg13cmos5l_fill_1
XFILLER_114_234 VPWR VGND sg13cmos5l_decap_8
XFILLER_525_56 VPWR VGND sg13cmos5l_decap_8
XFILLER_315_183 VPWR VGND sg13cmos5l_decap_8
X_2464_ _2464_/Q Tile_X0Y6_FrameData[7] VGND VPWR Tile_X0Y9_FrameStrobe[0] latch
XFILLER_244_35 VPWR VGND sg13cmos5l_decap_8
X_4203_ _4203_/X Tile_X0Y4_W1END[3] Tile_X0Y4_W6END[7] _4351_/X _4309_/X _2175_/Q
+ _2174_/Q VPWR VGND sg13cmos5l_mux4_1
X_1415_ _1415_/Q Tile_X0Y1_FrameData[18] VGND VPWR Tile_X0Y9_FrameStrobe[7] latch
XFILLER_665_268 VPWR VGND sg13cmos5l_decap_4
X_2395_ _2395_/Q Tile_X0Y5_FrameData[10] VGND VPWR Tile_X0Y9_FrameStrobe[6] latch
XFILLER_618_140 VPWR VGND sg13cmos5l_decap_8
XFILLER_491_105 VPWR VGND sg13cmos5l_decap_8
XFILLER_244_79 VPWR VGND sg13cmos5l_fill_1
XFILLER_95_140 VPWR VGND sg13cmos5l_decap_8
X_4134_ _4134_/X Tile_X0Y1_W2MID[4] Tile_X0Y1_W2END[4] Tile_X0Y1_W6END[11] _3995_/X
+ _1375_/Q _1374_/Q VPWR VGND sg13cmos5l_mux4_1
X_1346_ _1346_/Q Tile_X0Y1_FrameData[23] VGND VPWR Tile_X0Y9_FrameStrobe[5] latch
XFILLER_618_173 VPWR VGND sg13cmos5l_decap_8
XFILLER_618_184 VPWR VGND sg13cmos5l_fill_2
XFILLER_113_28 VPWR VGND sg13cmos5l_decap_8
XFILLER_541_77 VPWR VGND sg13cmos5l_decap_4
X_4065_ _4065_/X Tile_X0Y2_WW4END[6] AXI_M_SOC_AWREADY _4122_/X _4098_/X _1543_/Q
+ _1542_/Q VPWR VGND sg13cmos5l_mux4_1
X_1277_ _1277_/Q Tile_X0Y1_FrameData[28] VGND VPWR Tile_X0Y9_FrameStrobe[3] latch
XFILLER_633_154 VPWR VGND sg13cmos5l_decap_8
XANTENNA__3502__X Tile_X0Y1_E2BEGb[0] VPWR VGND sg13cmos5l_antennanp
XFILLER_633_165 VPWR VGND sg13cmos5l_fill_2
XFILLER_260_56 VPWR VGND sg13cmos5l_decap_8
X_3016_ Tile_X0Y5_E6BEG[3] _4407_/X VPWR VGND sg13cmos5l_buf_1
X_0228_ _0228_/Q Tile_X0Y7_FrameData[27] VGND VPWR Tile_X0Y9_FrameStrobe[2] latch
XFILLER_432_238 VPWR VGND sg13cmos5l_decap_8
XFILLER_432_249 VPWR VGND sg13cmos5l_fill_1
X_0159_ _0159_/X _4441_/X _4442_/X _0898_/Q VPWR VGND sg13cmos5l_mux2_1
XFILLER_51_221 VPWR VGND sg13cmos5l_decap_8
XFILLER_397_142 VPWR VGND sg13cmos5l_decap_8
XFILLER_697_70 VPWR VGND sg13cmos5l_decap_8
XFILLER_586_253 VPWR VGND sg13cmos5l_decap_4
XFILLER_269_21 VPWR VGND sg13cmos5l_decap_8
XFILLER_196_215 VPWR VGND sg13cmos5l_decap_8
XFILLER_269_65 VPWR VGND sg13cmos5l_fill_1
X_3918_ _3918_/X Tile_X0Y2_W1END[0] Tile_X0Y2_WW4END[0] Tile_X0Y2_W6END[8] _4116_/X
+ _1649_/Q _1648_/Q VPWR VGND sg13cmos5l_mux4_1
XFILLER_400_168 VPWR VGND sg13cmos5l_decap_8
XFILLER_269_87 VPWR VGND sg13cmos5l_decap_4
XFILLER_22_14 VPWR VGND sg13cmos5l_decap_8
X_4898_ _4898_/X Tile_X0Y8_W1END[2] Tile_X0Y8_W6END[10] _4814_/X _4774_/X _0631_/Q
+ _0630_/Q VPWR VGND sg13cmos5l_mux4_1
XFILLER_419_35 VPWR VGND sg13cmos5l_decap_8
XFILLER_149_164 VPWR VGND sg13cmos5l_decap_8
XFILLER_566_63 VPWR VGND sg13cmos5l_decap_8
XFILLER_138_14 VPWR VGND sg13cmos5l_decap_8
XFILLER_164_112 VPWR VGND sg13cmos5l_decap_8
X_3849_ _3849_/X Tile_X0Y1_W1END[1] Tile_X0Y1_W6END[5] _4002_/X _3977_/X _1423_/Q
+ _1422_/Q VPWR VGND sg13cmos5l_mux4_1
XFILLER_285_42 VPWR VGND sg13cmos5l_decap_8
XFILLER_353_245 VPWR VGND sg13cmos5l_fill_1
XFILLER_118_7 VPWR VGND sg13cmos5l_decap_8
XFILLER_499_238 VPWR VGND sg13cmos5l_decap_8
XFILLER_353_256 VPWR VGND sg13cmos5l_decap_4
XFILLER_313_109 VPWR VGND sg13cmos5l_decap_8
XFILLER_164_189 VPWR VGND sg13cmos5l_decap_8
XANTENNA__2788__X Tile_X0Y3_EE4BEG[14] VPWR VGND sg13cmos5l_antennanp
XFILLER_716_77 VPWR VGND sg13cmos5l_decap_4
XFILLER_105_223 VPWR VGND sg13cmos5l_decap_8
XFILLER_306_183 VPWR VGND sg13cmos5l_decap_4
XFILLER_435_56 VPWR VGND sg13cmos5l_decap_8
XFILLER_321_120 VPWR VGND sg13cmos5l_decap_4
XFILLER_0_7 VPWR VGND sg13cmos5l_decap_8
XFILLER_154_35 VPWR VGND sg13cmos5l_decap_8
XFILLER_582_84 VPWR VGND sg13cmos5l_decap_8
XFILLER_656_246 VPWR VGND sg13cmos5l_decap_8
XFILLER_467_146 VPWR VGND sg13cmos5l_decap_8
XFILLER_656_257 VPWR VGND sg13cmos5l_fill_2
XFILLER_487_7 VPWR VGND sg13cmos5l_decap_8
XFILLER_321_186 VPWR VGND sg13cmos5l_decap_8
XFILLER_266_219 VPWR VGND sg13cmos5l_decap_8
XFILLER_671_205 VPWR VGND sg13cmos5l_decap_8
XFILLER_482_105 VPWR VGND sg13cmos5l_decap_8
XFILLER_86_140 VPWR VGND sg13cmos5l_decap_8
XFILLER_47_22 VPWR VGND sg13cmos5l_decap_8
XFILLER_408_224 VPWR VGND sg13cmos5l_decap_8
XFILLER_304_49 VPWR VGND sg13cmos5l_decap_8
XFILLER_408_246 VPWR VGND sg13cmos5l_decap_8
XFILLER_451_77 VPWR VGND sg13cmos5l_decap_8
XFILLER_654_7 VPWR VGND sg13cmos5l_decap_8
XFILLER_601_14 VPWR VGND sg13cmos5l_decap_8
XFILLER_47_66 VPWR VGND sg13cmos5l_decap_4
XFILLER_47_77 VPWR VGND sg13cmos5l_decap_8
XANTENNA__3412__X Tile_X0Y4_FrameData_O[3] VPWR VGND sg13cmos5l_antennanp
XFILLER_170_56 VPWR VGND sg13cmos5l_decap_8
XFILLER_368_4 VPWR VGND sg13cmos5l_fill_1
XFILLER_234_127 VPWR VGND sg13cmos5l_decap_8
XFILLER_624_187 VPWR VGND sg13cmos5l_decap_8
XFILLER_320_15 VPWR VGND sg13cmos5l_decap_8
XFILLER_63_21 VPWR VGND sg13cmos5l_decap_8
XFILLER_577_220 VPWR VGND sg13cmos5l_decap_8
XFILLER_388_131 VPWR VGND sg13cmos5l_decap_8
XFILLER_42_221 VPWR VGND sg13cmos5l_decap_8
XFILLER_431_260 VPWR VGND sg13cmos5l_fill_2
XFILLER_179_21 VPWR VGND sg13cmos5l_decap_8
XFILLER_431_271 VPWR VGND sg13cmos5l_fill_2
XFILLER_187_226 VPWR VGND sg13cmos5l_decap_4
XFILLER_592_212 VPWR VGND sg13cmos5l_decap_8
XFILLER_400_70 VPWR VGND sg13cmos5l_decap_8
XFILLER_144_0 VPWR VGND sg13cmos5l_decap_8
XFILLER_63_98 VPWR VGND sg13cmos5l_fill_2
XFILLER_187_259 VPWR VGND sg13cmos5l_decap_8
XFILLER_8_49 VPWR VGND sg13cmos5l_decap_8
XFILLER_693_28 VPWR VGND sg13cmos5l_decap_8
XFILLER_329_57 VPWR VGND sg13cmos5l_decap_8
XFILLER_155_112 VPWR VGND sg13cmos5l_decap_8
XFILLER_311_0 VPWR VGND sg13cmos5l_decap_4
XFILLER_409_0 VPWR VGND sg13cmos5l_decap_8
XFILLER_344_234 VPWR VGND sg13cmos5l_decap_8
XFILLER_626_77 VPWR VGND sg13cmos5l_decap_8
XFILLER_626_88 VPWR VGND sg13cmos5l_fill_2
XFILLER_560_186 VPWR VGND sg13cmos5l_fill_2
XFILLER_128_91 VPWR VGND sg13cmos5l_fill_2
XFILLER_498_271 VPWR VGND sg13cmos5l_fill_2
XFILLER_345_56 VPWR VGND sg13cmos5l_decap_8
XFILLER_501_231 VPWR VGND sg13cmos5l_decap_8
XFILLER_647_224 VPWR VGND sg13cmos5l_decap_8
XFILLER_492_84 VPWR VGND sg13cmos5l_decap_8
XFILLER_312_142 VPWR VGND sg13cmos5l_decap_8
XFILLER_680_0 VPWR VGND sg13cmos5l_decap_8
XFILLER_642_21 VPWR VGND sg13cmos5l_decap_8
XFILLER_33_7 VPWR VGND sg13cmos5l_decap_8
XFILLER_312_175 VPWR VGND sg13cmos5l_decap_8
X_1200_ _1200_/Q Tile_X0Y1_FrameData[9] VGND VPWR Tile_X0Y9_FrameStrobe[0] latch
XFILLER_77_140 VPWR VGND sg13cmos5l_decap_8
X_2180_ _2180_/Q Tile_X0Y4_FrameData[1] VGND VPWR Tile_X0Y9_FrameStrobe[7] latch
XFILLER_214_49 VPWR VGND sg13cmos5l_decap_8
XFILLER_642_98 VPWR VGND sg13cmos5l_decap_8
XFILLER_473_138 VPWR VGND sg13cmos5l_fill_1
XFILLER_615_121 VPWR VGND sg13cmos5l_decap_8
XFILLER_361_77 VPWR VGND sg13cmos5l_fill_2
XFILLER_92_110 VPWR VGND sg13cmos5l_decap_8
X_1131_ _1131_/Q Tile_X0Y0_FrameData[0] VGND VPWR Tile_X0Y9_FrameStrobe[5] latch
XFILLER_265_263 VPWR VGND sg13cmos5l_fill_2
XFILLER_511_14 VPWR VGND sg13cmos5l_decap_8
XANTENNA__3322__X Tile_X0Y4_EE4BEG[10] VPWR VGND sg13cmos5l_antennanp
XFILLER_225_116 VPWR VGND sg13cmos5l_decap_8
XFILLER_280_211 VPWR VGND sg13cmos5l_decap_8
XFILLER_280_222 VPWR VGND sg13cmos5l_decap_8
XFILLER_18_240 VPWR VGND sg13cmos5l_fill_1
X_1062_ _1062_/Q Tile_X0Y0_FrameData[5] VGND VPWR Tile_X0Y9_FrameStrobe[3] latch
XFILLER_225_149 VPWR VGND sg13cmos5l_decap_4
XFILLER_481_193 VPWR VGND sg13cmos5l_decap_8
XFILLER_568_231 VPWR VGND sg13cmos5l_decap_8
XFILLER_568_242 VPWR VGND sg13cmos5l_fill_1
XFILLER_568_253 VPWR VGND sg13cmos5l_fill_1
XFILLER_178_215 VPWR VGND sg13cmos5l_decap_8
X_4821_ _4821_/X Tile_X0Y7_W1END[1] Tile_X0Y7_W2MID[2] Tile_X0Y7_W2END[2] _4672_/X
+ _0361_/Q _0360_/Q VPWR VGND sg13cmos5l_mux4_1
XFILLER_528_106 VPWR VGND sg13cmos5l_decap_8
XFILLER_310_70 VPWR VGND sg13cmos5l_fill_2
XFILLER_717_217 VPWR VGND sg13cmos5l_decap_8
XFILLER_379_197 VPWR VGND sg13cmos5l_decap_8
XFILLER_717_228 VPWR VGND sg13cmos5l_fill_1
X_4752_ _4752_/X Tile_X0Y8_WW4END[7] AXI_M_SOC_RDATA15 _4807_/X _4784_/X _0543_/Q
+ _0542_/Q VPWR VGND sg13cmos5l_mux4_1
XFILLER_394_145 VPWR VGND sg13cmos5l_decap_8
X_1964_ _1964_/Q Tile_X0Y4_FrameData[25] VGND VPWR Tile_X0Y9_FrameStrobe[1] latch
XFILLER_239_35 VPWR VGND sg13cmos5l_decap_8
XFILLER_186_270 VPWR VGND sg13cmos5l_fill_2
X_3703_ AXI_M_SOC_WDATA13 Tile_X0Y7_W1END[1] Tile_X0Y7_WW4END[5] Tile_X0Y7_WW4END[13]
+ _4697_/X _0221_/Q _0220_/Q VPWR VGND sg13cmos5l_mux4_1
X_0915_ _0915_/Q Tile_X0Y9_FrameData[12] VGND VPWR Tile_X0Y9_FrameStrobe[7] latch
XFILLER_386_63 VPWR VGND sg13cmos5l_decap_4
X_4683_ _4683_/X _4229_/X _4233_/X _4212_/X _4204_/X _1856_/Q _1855_/Q VPWR VGND sg13cmos5l_mux4_1
XFILLER_239_68 VPWR VGND sg13cmos5l_fill_2
X_1895_ _1895_/Q Tile_X0Y3_FrameData[2] VGND VPWR Tile_X0Y9_FrameStrobe[6] latch
XFILLER_146_156 VPWR VGND sg13cmos5l_fill_1
X_3634_ Tile_X0Y9_S4BEG[12] _3634_/A VPWR VGND sg13cmos5l_buf_1
X_0846_ _0846_/Q Tile_X0Y9_FrameData[17] VGND VPWR Tile_X0Y9_FrameStrobe[5] latch
XFILLER_683_50 VPWR VGND sg13cmos5l_decap_8
XFILLER_551_142 VPWR VGND sg13cmos5l_decap_8
XFILLER_146_178 VPWR VGND sg13cmos5l_decap_8
XFILLER_697_146 VPWR VGND sg13cmos5l_fill_1
XFILLER_108_28 VPWR VGND sg13cmos5l_decap_8
XFILLER_536_77 VPWR VGND sg13cmos5l_decap_4
X_3565_ Tile_X0Y9_EE4BEG[11] _4875_/X VPWR VGND sg13cmos5l_buf_1
X_0777_ _0777_/Q Tile_X0Y9_FrameData[22] VGND VPWR Tile_X0Y9_FrameStrobe[3] latch
XFILLER_551_186 VPWR VGND sg13cmos5l_decap_8
XFILLER_350_237 VPWR VGND sg13cmos5l_decap_8
XFILLER_489_271 VPWR VGND sg13cmos5l_fill_2
X_2516_ _2516_/Q Tile_X0Y6_FrameData[19] VGND VPWR Tile_X0Y9_FrameStrobe[2] latch
XFILLER_303_131 VPWR VGND sg13cmos5l_fill_1
XFILLER_255_78 VPWR VGND sg13cmos5l_decap_8
X_3496_ Tile_X0Y1_E6BEG[6] _3970_/X VPWR VGND sg13cmos5l_buf_1
XFILLER_552_21 VPWR VGND sg13cmos5l_decap_8
XFILLER_638_246 VPWR VGND sg13cmos5l_fill_2
XFILLER_102_226 VPWR VGND sg13cmos5l_decap_8
XFILLER_638_257 VPWR VGND sg13cmos5l_fill_2
X_2447_ _2447_/Q Tile_X0Y6_FrameData[24] VGND VPWR Tile_X0Y9_FrameStrobe[0] latch
XFILLER_653_216 VPWR VGND sg13cmos5l_decap_8
XFILLER_68_140 VPWR VGND sg13cmos5l_decap_8
XFILLER_124_49 VPWR VGND sg13cmos5l_decap_8
X_2378_ _2378_/Q Tile_X0Y5_FrameData[27] VGND VPWR Tile_X0Y9_FrameStrobe[6] latch
XFILLER_702_35 VPWR VGND sg13cmos5l_decap_8
XFILLER_464_149 VPWR VGND sg13cmos5l_fill_1
X_4117_ _4117_/X _4091_/X _0064_/X _4090_/X Tile_X0Y0_S4END[9] _1479_/Q _1478_/Q VPWR
+ VGND sg13cmos5l_mux4_1
X_1329_ _1329_/Q Tile_X0Y1_FrameData[8] VGND VPWR Tile_X0Y9_FrameStrobe[4] latch
XFILLER_421_14 VPWR VGND sg13cmos5l_decap_8
XANTENNA__3232__X Tile_X0Y0_FrameData_O[0] VPWR VGND sg13cmos5l_antennanp
XFILLER_17_14 VPWR VGND sg13cmos5l_decap_8
X_4048_ _4048_/X Tile_X0Y2_W2END[7] AXI_M_SOC_AWREADY _4097_/X _4096_/X _1577_/Q _1576_/Q
+ VPWR VGND sg13cmos5l_mux4_1
XFILLER_472_193 VPWR VGND sg13cmos5l_decap_8
XFILLER_17_58 VPWR VGND sg13cmos5l_fill_1
XFILLER_24_210 VPWR VGND sg13cmos5l_decap_8
XFILLER_621_157 VPWR VGND sg13cmos5l_decap_4
XFILLER_231_119 VPWR VGND sg13cmos5l_decap_8
XFILLER_559_253 VPWR VGND sg13cmos5l_decap_8
XFILLER_501_91 VPWR VGND sg13cmos5l_decap_8
XFILLER_220_81 VPWR VGND sg13cmos5l_decap_8
XFILLER_169_259 VPWR VGND sg13cmos5l_decap_4
XFILLER_574_245 VPWR VGND sg13cmos5l_decap_8
XFILLER_235_7 VPWR VGND sg13cmos5l_decap_8
XFILLER_149_35 VPWR VGND sg13cmos5l_decap_8
XFILLER_577_84 VPWR VGND sg13cmos5l_decap_8
XFILLER_184_218 VPWR VGND sg13cmos5l_decap_8
XFILLER_184_229 VPWR VGND sg13cmos5l_fill_1
XFILLER_534_109 VPWR VGND sg13cmos5l_decap_4
XFILLER_177_270 VPWR VGND sg13cmos5l_fill_2
XFILLER_296_63 VPWR VGND sg13cmos5l_decap_8
XFILLER_137_112 VPWR VGND sg13cmos5l_decap_8
XFILLER_716_261 VPWR VGND sg13cmos5l_fill_1
XFILLER_149_79 VPWR VGND sg13cmos5l_decap_8
XFILLER_716_272 VPWR VGND sg13cmos5l_fill_1
XFILLER_446_22 VPWR VGND sg13cmos5l_decap_8
XFILLER_402_7 VPWR VGND sg13cmos5l_decap_8
XFILLER_688_124 VPWR VGND sg13cmos5l_fill_2
XFILLER_341_204 VPWR VGND sg13cmos5l_fill_1
XFILLER_165_23 VPWR VGND sg13cmos5l_fill_1
XFILLER_487_219 VPWR VGND sg13cmos5l_decap_8
XANTENNA__3407__X Tile_X0Y2_E1BEG[2] VPWR VGND sg13cmos5l_antennanp
XFILLER_165_67 VPWR VGND sg13cmos5l_decap_8
XFILLER_341_259 VPWR VGND sg13cmos5l_fill_2
XFILLER_165_78 VPWR VGND sg13cmos5l_fill_2
XFILLER_495_230 VPWR VGND sg13cmos5l_decap_8
XFILLER_462_21 VPWR VGND sg13cmos5l_decap_8
XFILLER_629_246 VPWR VGND sg13cmos5l_decap_8
XFILLER_495_252 VPWR VGND sg13cmos5l_decap_8
XFILLER_315_59 VPWR VGND sg13cmos5l_decap_8
XFILLER_59_140 VPWR VGND sg13cmos5l_fill_1
XFILLER_644_238 VPWR VGND sg13cmos5l_decap_8
XFILLER_59_151 VPWR VGND sg13cmos5l_decap_8
XFILLER_612_35 VPWR VGND sg13cmos5l_decap_8
XFILLER_181_77 VPWR VGND sg13cmos5l_decap_8
XFILLER_331_14 VPWR VGND sg13cmos5l_decap_8
XANTENNA__3142__X Tile_X0Y7_FrameData_O[12] VPWR VGND sg13cmos5l_antennanp
XFILLER_114_71 VPWR VGND sg13cmos5l_decap_8
XFILLER_652_271 VPWR VGND sg13cmos5l_fill_2
XFILLER_688_28 VPWR VGND sg13cmos5l_decap_8
XFILLER_612_113 VPWR VGND sg13cmos5l_decap_8
XFILLER_262_233 VPWR VGND sg13cmos5l_fill_1
XFILLER_74_176 VPWR VGND sg13cmos5l_decap_8
XFILLER_74_53 VPWR VGND sg13cmos5l_decap_8
XFILLER_261_0 VPWR VGND sg13cmos5l_decap_8
XFILLER_359_0 VPWR VGND sg13cmos5l_decap_8
XANTENNA__2981__X Tile_X0Y8_FrameData_O[21] VPWR VGND sg13cmos5l_antennanp
XFILLER_411_91 VPWR VGND sg13cmos5l_decap_8
XFILLER_404_271 VPWR VGND sg13cmos5l_fill_2
XFILLER_130_70 VPWR VGND sg13cmos5l_decap_8
XFILLER_526_0 VPWR VGND sg13cmos5l_decap_8
XFILLER_487_84 VPWR VGND sg13cmos5l_decap_8
XFILLER_30_246 VPWR VGND sg13cmos5l_decap_8
XFILLER_230_185 VPWR VGND sg13cmos5l_fill_1
XFILLER_637_21 VPWR VGND sg13cmos5l_decap_8
XFILLER_175_229 VPWR VGND sg13cmos5l_decap_8
XFILLER_714_209 VPWR VGND sg13cmos5l_fill_1
XFILLER_707_250 VPWR VGND sg13cmos5l_decap_8
XFILLER_391_126 VPWR VGND sg13cmos5l_decap_8
XFILLER_580_226 VPWR VGND sg13cmos5l_decap_8
X_0700_ _0700_/Q Tile_X0Y9_FrameData[3] VGND VPWR Tile_X0Y9_FrameStrobe[0] latch
XFILLER_518_194 VPWR VGND sg13cmos5l_decap_8
XFILLER_317_245 VPWR VGND sg13cmos5l_decap_8
X_1680_ _1680_/Q Tile_X0Y3_FrameData[25] VGND VPWR Tile_X0Y9_FrameStrobe[0] latch
XFILLER_209_49 VPWR VGND sg13cmos5l_decap_8
XFILLER_679_135 VPWR VGND sg13cmos5l_fill_2
XFILLER_332_204 VPWR VGND sg13cmos5l_fill_2
XFILLER_128_189 VPWR VGND sg13cmos5l_decap_8
XFILLER_356_77 VPWR VGND sg13cmos5l_decap_8
X_0631_ _0631_/Q Tile_X0Y8_FrameData[8] VGND VPWR Tile_X0Y9_FrameStrobe[6] latch
XFILLER_533_186 VPWR VGND sg13cmos5l_decap_8
XFILLER_506_14 VPWR VGND sg13cmos5l_decap_8
XANTENNA__3317__X Tile_X0Y4_EE4BEG[5] VPWR VGND sg13cmos5l_antennanp
XFILLER_143_148 VPWR VGND sg13cmos5l_decap_8
XFILLER_679_179 VPWR VGND sg13cmos5l_decap_8
XFILLER_653_42 VPWR VGND sg13cmos5l_decap_8
X_3350_ Tile_X0Y2_FrameData_O[21] Tile_X0Y2_FrameData[21] VPWR VGND sg13cmos5l_buf_1
X_0562_ _0562_/Q Tile_X0Y8_FrameData[13] VGND VPWR Tile_X0Y9_FrameStrobe[4] latch
XFILLER_97_202 VPWR VGND sg13cmos5l_decap_8
XFILLER_486_230 VPWR VGND sg13cmos5l_fill_1
XFILLER_687_190 VPWR VGND sg13cmos5l_decap_4
XFILLER_97_224 VPWR VGND sg13cmos5l_decap_8
X_2301_ _2301_/Q Tile_X0Y5_FrameData[8] VGND VPWR Tile_X0Y9_FrameStrobe[3] latch
XFILLER_486_252 VPWR VGND sg13cmos5l_decap_4
XFILLER_372_43 VPWR VGND sg13cmos5l_decap_8
XFILLER_97_235 VPWR VGND sg13cmos5l_fill_1
X_3281_ Tile_X0Y0_E6BEG[1] _3837_/X VPWR VGND sg13cmos5l_buf_1
X_0493_ _0493_/Q Tile_X0Y8_FrameData[18] VGND VPWR Tile_X0Y9_FrameStrobe[2] latch
XFILLER_372_65 VPWR VGND sg13cmos5l_decap_8
XFILLER_446_127 VPWR VGND sg13cmos5l_fill_1
XFILLER_372_87 VPWR VGND sg13cmos5l_decap_8
X_2232_ _2232_/Q Tile_X0Y5_FrameData[13] VGND VPWR Tile_X0Y9_FrameStrobe[1] latch
XFILLER_635_238 VPWR VGND sg13cmos5l_fill_2
XFILLER_522_35 VPWR VGND sg13cmos5l_decap_8
XFILLER_446_149 VPWR VGND sg13cmos5l_decap_4
XFILLER_238_241 VPWR VGND sg13cmos5l_decap_8
X_2163_ _2163_/Q Tile_X0Y4_FrameData[18] VGND VPWR Tile_X0Y9_FrameStrobe[7] latch
XFILLER_241_14 VPWR VGND sg13cmos5l_decap_8
XANTENNA__3052__X Tile_X0Y5_FrameData_O[11] VPWR VGND sg13cmos5l_antennanp
X_1114_ _1114_/Q Tile_X0Y0_FrameData[17] VGND VPWR Tile_X0Y9_FrameStrobe[5] latch
XFILLER_65_154 VPWR VGND sg13cmos5l_decap_8
XFILLER_598_28 VPWR VGND sg13cmos5l_decap_8
X_2094_ _2094_/Q Tile_X0Y4_FrameData[23] VGND VPWR Tile_X0Y9_FrameStrobe[5] latch
XFILLER_602_90 VPWR VGND sg13cmos5l_decap_8
XFILLER_399_248 VPWR VGND sg13cmos5l_decap_8
XANTENNA__2891__X Tile_X0Y6_FrameData_O[12] VPWR VGND sg13cmos5l_antennanp
X_1045_ _1045_/Q Tile_X0Y0_FrameData[22] VGND VPWR Tile_X0Y9_FrameStrobe[3] latch
XFILLER_402_219 VPWR VGND sg13cmos5l_decap_8
XFILLER_0_94 VPWR VGND sg13cmos5l_decap_4
XFILLER_80_168 VPWR VGND sg13cmos5l_decap_8
XFILLER_678_94 VPWR VGND sg13cmos5l_decap_8
XFILLER_410_230 VPWR VGND sg13cmos5l_decap_8
X_4804_ _4804_/X _4777_/X Tile_X0Y9_N4END[4] _4776_/X _0077_/X _0463_/Q _0462_/Q VPWR
+ VGND sg13cmos5l_mux4_1
XFILLER_367_156 VPWR VGND sg13cmos5l_decap_8
X_2996_ Tile_X0Y5_E1BEG[3] _4371_/X VPWR VGND sg13cmos5l_buf_1
XFILLER_547_21 VPWR VGND sg13cmos5l_decap_8
XFILLER_119_101 VPWR VGND sg13cmos5l_fill_1
XFILLER_21_268 VPWR VGND sg13cmos5l_decap_4
XFILLER_9_70 VPWR VGND sg13cmos5l_decap_8
X_4735_ _4735_/X Tile_X0Y8_W2MID[0] AXI_M_SOC_RDATA15 _4785_/X _4784_/X _0577_/Q _0576_/Q
+ VPWR VGND sg13cmos5l_mux4_1
X_1947_ _1947_/Q Tile_X0Y4_FrameData[10] VGND VPWR Tile_X0Y9_FrameStrobe[0] latch
XFILLER_571_226 VPWR VGND sg13cmos5l_decap_4
XFILLER_119_123 VPWR VGND sg13cmos5l_decap_8
XFILLER_119_156 VPWR VGND sg13cmos5l_decap_4
X_4666_ _4666_/X Tile_X0Y6_W1END[3] Tile_X0Y6_W6END[11] _4583_/X _4543_/X _2653_/Q
+ _2652_/Q VPWR VGND sg13cmos5l_mux4_1
XFILLER_119_49 VPWR VGND sg13cmos5l_decap_8
X_1878_ _1878_/Q Tile_X0Y3_FrameData[19] VGND VPWR Tile_X0Y9_FrameStrobe[6] latch
XFILLER_713_264 VPWR VGND sg13cmos5l_fill_1
X_3617_ Tile_X0Y9_S2BEGb[3] _4935_/X VPWR VGND sg13cmos5l_buf_1
XFILLER_469_208 VPWR VGND sg13cmos5l_decap_8
X_0829_ _0829_/Q Tile_X0Y9_FrameData[2] VGND VPWR Tile_X0Y9_FrameStrobe[4] latch
XFILLER_416_14 VPWR VGND sg13cmos5l_decap_8
X_4597_ _4597_/X Tile_X0Y8_W2MID[1] Tile_X0Y8_W2END[1] Tile_X0Y8_W6END[1] _4786_/X
+ _0651_/Q _0650_/Q VPWR VGND sg13cmos5l_mux4_1
XANTENNA__3227__X Tile_X0Y0_FrameStrobe_O[15] VPWR VGND sg13cmos5l_antennanp
XFILLER_685_116 VPWR VGND sg13cmos5l_decap_4
XFILLER_563_42 VPWR VGND sg13cmos5l_decap_8
XFILLER_685_127 VPWR VGND sg13cmos5l_decap_8
X_3548_ Tile_X0Y9_E6BEG[6] _4886_/X VPWR VGND sg13cmos5l_buf_1
XFILLER_685_149 VPWR VGND sg13cmos5l_decap_8
XFILLER_282_21 VPWR VGND sg13cmos5l_decap_8
XFILLER_678_190 VPWR VGND sg13cmos5l_decap_8
XFILLER_88_213 VPWR VGND sg13cmos5l_fill_1
XFILLER_477_241 VPWR VGND sg13cmos5l_decap_8
XFILLER_142_192 VPWR VGND sg13cmos5l_decap_8
X_3479_ Tile_X0Y1_EE4BEG[5] _3953_/X VPWR VGND sg13cmos5l_buf_1
XFILLER_437_105 VPWR VGND sg13cmos5l_decap_8
XFILLER_492_200 VPWR VGND sg13cmos5l_fill_1
XFILLER_288_185 VPWR VGND sg13cmos5l_decap_8
XFILLER_492_222 VPWR VGND sg13cmos5l_decap_8
XFILLER_282_98 VPWR VGND sg13cmos5l_decap_8
XFILLER_432_35 VPWR VGND sg13cmos5l_decap_8
XFILLER_215_70 VPWR VGND sg13cmos5l_fill_1
XFILLER_713_89 VPWR VGND sg13cmos5l_decap_8
XFILLER_229_252 VPWR VGND sg13cmos5l_decap_8
XFILLER_151_14 VPWR VGND sg13cmos5l_decap_8
XFILLER_185_7 VPWR VGND sg13cmos5l_decap_8
XFILLER_634_271 VPWR VGND sg13cmos5l_fill_2
XFILLER_56_165 VPWR VGND sg13cmos5l_decap_8
XFILLER_460_130 VPWR VGND sg13cmos5l_decap_8
XFILLER_352_7 VPWR VGND sg13cmos5l_decap_8
XFILLER_460_185 VPWR VGND sg13cmos5l_decap_8
XFILLER_71_168 VPWR VGND sg13cmos5l_decap_8
XFILLER_358_112 VPWR VGND sg13cmos5l_decap_8
XFILLER_12_224 VPWR VGND sg13cmos5l_fill_2
XFILLER_547_234 VPWR VGND sg13cmos5l_decap_8
XFILLER_401_252 VPWR VGND sg13cmos5l_decap_4
XFILLER_617_7 VPWR VGND sg13cmos5l_decap_8
XFILLER_457_21 VPWR VGND sg13cmos5l_decap_8
XFILLER_12_268 VPWR VGND sg13cmos5l_decap_4
XFILLER_212_196 VPWR VGND sg13cmos5l_decap_8
XFILLER_373_104 VPWR VGND sg13cmos5l_fill_1
XFILLER_358_189 VPWR VGND sg13cmos5l_decap_8
XFILLER_100_84 VPWR VGND sg13cmos5l_decap_8
XFILLER_373_148 VPWR VGND sg13cmos5l_decap_8
XFILLER_176_55 VPWR VGND sg13cmos5l_decap_4
XFILLER_607_35 VPWR VGND sg13cmos5l_decap_8
XFILLER_515_164 VPWR VGND sg13cmos5l_decap_8
XFILLER_180_210 VPWR VGND sg13cmos5l_fill_2
XFILLER_381_170 VPWR VGND sg13cmos5l_decap_8
XFILLER_326_14 VPWR VGND sg13cmos5l_decap_8
XFILLER_5_28 VPWR VGND sg13cmos5l_decap_8
XANTENNA__3137__X Tile_X0Y7_FrameData_O[7] VPWR VGND sg13cmos5l_antennanp
XFILLER_109_60 VPWR VGND sg13cmos5l_decap_8
XFILLER_125_148 VPWR VGND sg13cmos5l_decap_8
XFILLER_107_0 VPWR VGND sg13cmos5l_decap_8
XFILLER_473_42 VPWR VGND sg13cmos5l_decap_8
XFILLER_676_127 VPWR VGND sg13cmos5l_fill_1
XFILLER_314_259 VPWR VGND sg13cmos5l_fill_2
XFILLER_180_265 VPWR VGND sg13cmos5l_decap_8
XFILLER_69_42 VPWR VGND sg13cmos5l_decap_8
XFILLER_192_21 VPWR VGND sg13cmos5l_decap_4
XFILLER_468_230 VPWR VGND sg13cmos5l_decap_8
XFILLER_669_190 VPWR VGND sg13cmos5l_decap_8
XANTENNA__2976__X Tile_X0Y8_FrameData_O[16] VPWR VGND sg13cmos5l_antennanp
XFILLER_468_263 VPWR VGND sg13cmos5l_decap_8
XFILLER_691_108 VPWR VGND sg13cmos5l_fill_1
XFILLER_428_105 VPWR VGND sg13cmos5l_decap_8
XFILLER_133_192 VPWR VGND sg13cmos5l_decap_8
XFILLER_617_205 VPWR VGND sg13cmos5l_decap_8
XFILLER_623_56 VPWR VGND sg13cmos5l_decap_8
XFILLER_684_171 VPWR VGND sg13cmos5l_decap_8
XFILLER_125_70 VPWR VGND sg13cmos5l_decap_4
XFILLER_617_249 VPWR VGND sg13cmos5l_decap_8
XFILLER_342_35 VPWR VGND sg13cmos5l_decap_8
XFILLER_476_0 VPWR VGND sg13cmos5l_decap_8
XFILLER_294_166 VPWR VGND sg13cmos5l_decap_8
XFILLER_85_63 VPWR VGND sg13cmos5l_decap_8
XFILLER_235_211 VPWR VGND sg13cmos5l_decap_8
XFILLER_47_176 VPWR VGND sg13cmos5l_decap_8
XFILLER_643_0 VPWR VGND sg13cmos5l_decap_8
XFILLER_597_123 VPWR VGND sg13cmos5l_fill_2
XFILLER_211_28 VPWR VGND sg13cmos5l_decap_8
XFILLER_640_252 VPWR VGND sg13cmos5l_decap_4
XFILLER_62_124 VPWR VGND sg13cmos5l_decap_8
XANTENNA__3600__X Tile_X0Y9_FrameData_O[30] VPWR VGND sg13cmos5l_antennanp
XFILLER_141_91 VPWR VGND sg13cmos5l_decap_4
XFILLER_538_201 VPWR VGND sg13cmos5l_decap_8
XFILLER_349_112 VPWR VGND sg13cmos5l_decap_8
XFILLER_203_163 VPWR VGND sg13cmos5l_decap_8
XFILLER_648_42 VPWR VGND sg13cmos5l_decap_8
X_2850_ Tile_X0Y6_E2BEGb[7] _4511_/X VPWR VGND sg13cmos5l_buf_1
XFILLER_364_104 VPWR VGND sg13cmos5l_decap_8
X_1801_ _1801_/Q Tile_X0Y3_FrameData[0] VGND VPWR Tile_X0Y9_FrameStrobe[3] latch
XFILLER_367_43 VPWR VGND sg13cmos5l_decap_8
X_2781_ Tile_X0Y3_EE4BEG[7] _4171_/X VPWR VGND sg13cmos5l_buf_1
X_4520_ _4520_/X Tile_X0Y6_WW4END[7] AXI_M_SOC_RDATA31 _4575_/X _4552_/X _2567_/Q
+ _2566_/Q VPWR VGND sg13cmos5l_mux4_1
X_1732_ _1732_/Q Tile_X0Y3_FrameData[5] VGND VPWR Tile_X0Y9_FrameStrobe[1] latch
XFILLER_517_35 VPWR VGND sg13cmos5l_decap_8
XFILLER_7_272 VPWR VGND sg13cmos5l_fill_1
X_4451_ _4451_/X _4418_/X _0157_/X _4417_/X _0143_/X _2237_/Q _2236_/Q VPWR VGND sg13cmos5l_mux4_1
XFILLER_664_63 VPWR VGND sg13cmos5l_fill_2
X_1663_ _1663_/Q Tile_X0Y2_FrameData[18] VGND VPWR Tile_X0Y9_FrameStrobe[7] latch
XFILLER_506_186 VPWR VGND sg13cmos5l_fill_2
XFILLER_236_14 VPWR VGND sg13cmos5l_decap_8
XANTENNA__3047__X Tile_X0Y5_FrameData_O[6] VPWR VGND sg13cmos5l_antennanp
XFILLER_116_148 VPWR VGND sg13cmos5l_fill_2
XFILLER_667_105 VPWR VGND sg13cmos5l_decap_8
X_3402_ Tile_X0Y2_E2BEG[5] _4045_/X VPWR VGND sg13cmos5l_buf_1
XFILLER_710_234 VPWR VGND sg13cmos5l_decap_8
X_0614_ _0614_/Q Tile_X0Y8_FrameData[25] VGND VPWR Tile_X0Y9_FrameStrobe[6] latch
X_4382_ _4382_/X Tile_X0Y5_W2END[5] AXI_M_SOC_RLAST _4432_/X _4431_/X _2339_/Q _2338_/Q
+ VPWR VGND sg13cmos5l_mux4_1
X_1594_ _1594_/Q Tile_X0Y2_FrameData[23] VGND VPWR Tile_X0Y9_FrameStrobe[5] latch
XFILLER_710_256 VPWR VGND sg13cmos5l_fill_2
XFILLER_667_149 VPWR VGND sg13cmos5l_decap_8
XFILLER_320_229 VPWR VGND sg13cmos5l_decap_8
XANTENNA__2886__X Tile_X0Y6_FrameData_O[7] VPWR VGND sg13cmos5l_antennanp
X_3333_ Tile_X0Y2_FrameData_O[4] Tile_X0Y2_FrameData[4] VPWR VGND sg13cmos5l_buf_1
X_0545_ _0545_/Q Tile_X0Y8_FrameData[30] VGND VPWR Tile_X0Y9_FrameStrobe[4] latch
XFILLER_682_119 VPWR VGND sg13cmos5l_decap_8
XFILLER_675_160 VPWR VGND sg13cmos5l_fill_2
XFILLER_316_80 VPWR VGND sg13cmos5l_decap_8
XFILLER_680_62 VPWR VGND sg13cmos5l_decap_8
XFILLER_533_56 VPWR VGND sg13cmos5l_decap_4
XFILLER_285_133 VPWR VGND sg13cmos5l_decap_8
X_3264_ Tile_X0Y0_EE4BEG[0] _3820_/X VPWR VGND sg13cmos5l_buf_1
XFILLER_22_0 VPWR VGND sg13cmos5l_decap_8
X_0476_ _0476_/Q Tile_X0Y8_FrameData[3] VGND VPWR Tile_X0Y9_FrameStrobe[1] latch
XFILLER_675_193 VPWR VGND sg13cmos5l_decap_8
XFILLER_608_249 VPWR VGND sg13cmos5l_decap_8
XFILLER_252_35 VPWR VGND sg13cmos5l_decap_8
XFILLER_474_266 VPWR VGND sg13cmos5l_decap_8
X_2215_ _2215_/Q Tile_X0Y5_FrameData[30] VGND VPWR Tile_X0Y9_FrameStrobe[1] latch
X_3195_ Tile_X0Y0_N2BEGb[3] _3895_/X VPWR VGND sg13cmos5l_buf_1
XFILLER_226_211 VPWR VGND sg13cmos5l_decap_8
XFILLER_616_271 VPWR VGND sg13cmos5l_fill_2
XFILLER_38_143 VPWR VGND sg13cmos5l_decap_8
XFILLER_690_196 VPWR VGND sg13cmos5l_fill_1
XFILLER_427_182 VPWR VGND sg13cmos5l_decap_8
X_2146_ _2146_/Q Tile_X0Y4_FrameData[3] VGND VPWR Tile_X0Y9_FrameStrobe[6] latch
XFILLER_402_49 VPWR VGND sg13cmos5l_decap_8
XFILLER_689_71 VPWR VGND sg13cmos5l_decap_8
XFILLER_631_241 VPWR VGND sg13cmos5l_fill_2
XFILLER_121_28 VPWR VGND sg13cmos5l_decap_8
X_2077_ _2077_/Q Tile_X0Y4_FrameData[8] VGND VPWR Tile_X0Y9_FrameStrobe[4] latch
XANTENNA__3510__X Tile_X0Y1_E2BEG[0] VPWR VGND sg13cmos5l_antennanp
XFILLER_198_118 VPWR VGND sg13cmos5l_decap_8
XFILLER_241_236 VPWR VGND sg13cmos5l_decap_4
X_1028_ _1028_/Q Tile_X0Y0_FrameData[7] VGND VPWR Tile_X0Y9_FrameStrobe[2] latch
XFILLER_529_223 VPWR VGND sg13cmos5l_decap_8
XFILLER_558_42 VPWR VGND sg13cmos5l_decap_8
XFILLER_277_21 VPWR VGND sg13cmos5l_decap_8
XFILLER_558_86 VPWR VGND sg13cmos5l_fill_1
XFILLER_355_126 VPWR VGND sg13cmos5l_decap_8
X_2979_ Tile_X0Y8_FrameData_O[19] Tile_X0Y8_FrameData[19] VPWR VGND sg13cmos5l_buf_1
XFILLER_708_56 VPWR VGND sg13cmos5l_decap_8
X_4718_ _4718_/X Tile_X0Y8_W1END[1] Tile_X0Y8_WW4END[13] Tile_X0Y8_W6END[5] _4801_/X
+ _0608_/Q _0607_/Q VPWR VGND sg13cmos5l_mux4_1
XFILLER_277_98 VPWR VGND sg13cmos5l_decap_8
XFILLER_30_14 VPWR VGND sg13cmos5l_decap_8
XFILLER_427_35 VPWR VGND sg13cmos5l_decap_8
XFILLER_30_25 VPWR VGND sg13cmos5l_fill_1
XFILLER_146_14 VPWR VGND sg13cmos5l_decap_8
X_4649_ _4649_/X AXI_M_SOC_RDATA17 _4690_/X _4694_/X _4671_/X _0261_/Q _0260_/Q VPWR
+ VGND sg13cmos5l_mux4_1
XFILLER_574_63 VPWR VGND sg13cmos5l_decap_8
XFILLER_512_112 VPWR VGND sg13cmos5l_decap_8
XFILLER_162_243 VPWR VGND sg13cmos5l_decap_8
XFILLER_363_192 VPWR VGND sg13cmos5l_fill_2
XFILLER_162_254 VPWR VGND sg13cmos5l_decap_8
XFILLER_293_42 VPWR VGND sg13cmos5l_decap_8
XFILLER_100_7 VPWR VGND sg13cmos5l_decap_8
XFILLER_658_138 VPWR VGND sg13cmos5l_decap_8
XFILLER_658_149 VPWR VGND sg13cmos5l_fill_1
XFILLER_122_118 VPWR VGND sg13cmos5l_decap_8
XANTENNA__2796__X Tile_X0Y3_E6BEG[6] VPWR VGND sg13cmos5l_antennanp
XFILLER_443_56 VPWR VGND sg13cmos5l_decap_8
XFILLER_130_140 VPWR VGND sg13cmos5l_decap_8
XFILLER_162_35 VPWR VGND sg13cmos5l_decap_8
XFILLER_590_84 VPWR VGND sg13cmos5l_decap_8
XFILLER_276_166 VPWR VGND sg13cmos5l_decap_8
XFILLER_76_238 VPWR VGND sg13cmos5l_decap_8
XFILLER_29_110 VPWR VGND sg13cmos5l_decap_8
XFILLER_614_208 VPWR VGND sg13cmos5l_fill_2
XFILLER_567_7 VPWR VGND sg13cmos5l_decap_8
XFILLER_425_119 VPWR VGND sg13cmos5l_decap_8
XFILLER_607_260 VPWR VGND sg13cmos5l_decap_8
XFILLER_607_271 VPWR VGND sg13cmos5l_fill_2
XFILLER_579_112 VPWR VGND sg13cmos5l_fill_2
XFILLER_480_269 VPWR VGND sg13cmos5l_decap_4
XFILLER_217_266 VPWR VGND sg13cmos5l_decap_8
XFILLER_579_145 VPWR VGND sg13cmos5l_fill_1
XFILLER_232_203 VPWR VGND sg13cmos5l_decap_8
XFILLER_599_93 VPWR VGND sg13cmos5l_decap_8
XANTENNA__3420__X Tile_X0Y4_FrameData_O[11] VPWR VGND sg13cmos5l_antennanp
XFILLER_433_174 VPWR VGND sg13cmos5l_decap_8
XFILLER_579_167 VPWR VGND sg13cmos5l_fill_2
XFILLER_44_179 VPWR VGND sg13cmos5l_decap_8
XFILLER_71_21 VPWR VGND sg13cmos5l_decap_8
XFILLER_594_159 VPWR VGND sg13cmos5l_decap_8
XFILLER_468_42 VPWR VGND sg13cmos5l_decap_8
XFILLER_197_151 VPWR VGND sg13cmos5l_fill_2
XFILLER_111_94 VPWR VGND sg13cmos5l_decap_8
XFILLER_187_21 VPWR VGND sg13cmos5l_decap_4
XFILLER_468_86 VPWR VGND sg13cmos5l_decap_8
XFILLER_197_195 VPWR VGND sg13cmos5l_fill_1
XFILLER_200_144 VPWR VGND sg13cmos5l_decap_8
XFILLER_224_0 VPWR VGND sg13cmos5l_decap_8
XFILLER_71_98 VPWR VGND sg13cmos5l_decap_8
XFILLER_618_56 VPWR VGND sg13cmos5l_decap_8
XFILLER_337_35 VPWR VGND sg13cmos5l_decap_8
XFILLER_337_46 VPWR VGND sg13cmos5l_fill_2
XFILLER_484_63 VPWR VGND sg13cmos5l_decap_8
XFILLER_503_112 VPWR VGND sg13cmos5l_decap_8
XFILLER_299_214 VPWR VGND sg13cmos5l_decap_8
XFILLER_649_105 VPWR VGND sg13cmos5l_decap_8
XFILLER_4_220 VPWR VGND sg13cmos5l_fill_2
XFILLER_593_0 VPWR VGND sg13cmos5l_decap_8
XFILLER_503_189 VPWR VGND sg13cmos5l_fill_2
XFILLER_106_181 VPWR VGND sg13cmos5l_fill_2
XFILLER_206_28 VPWR VGND sg13cmos5l_decap_8
XFILLER_20_91 VPWR VGND sg13cmos5l_decap_8
XFILLER_664_108 VPWR VGND sg13cmos5l_fill_1
XFILLER_634_77 VPWR VGND sg13cmos5l_decap_8
XFILLER_353_56 VPWR VGND sg13cmos5l_decap_8
XFILLER_121_140 VPWR VGND sg13cmos5l_decap_8
XFILLER_136_91 VPWR VGND sg13cmos5l_decap_8
X_0330_ _0330_/Q Tile_X0Y7_FrameData[21] VGND VPWR Tile_X0Y9_FrameStrobe[5] latch
XFILLER_650_21 VPWR VGND sg13cmos5l_decap_8
XFILLER_267_155 VPWR VGND sg13cmos5l_fill_1
XFILLER_121_184 VPWR VGND sg13cmos5l_decap_8
XFILLER_67_238 VPWR VGND sg13cmos5l_decap_8
X_0261_ _0261_/Q Tile_X0Y7_FrameData[26] VGND VPWR Tile_X0Y9_FrameStrobe[3] latch
XFILLER_605_208 VPWR VGND sg13cmos5l_decap_8
X_2000_ _2000_/Q Tile_X0Y4_FrameData[21] VGND VPWR Tile_X0Y9_FrameStrobe[2] latch
XFILLER_471_236 VPWR VGND sg13cmos5l_decap_8
XFILLER_282_147 VPWR VGND sg13cmos5l_decap_8
XFILLER_208_244 VPWR VGND sg13cmos5l_decap_8
X_0192_ _0192_/Q Tile_X0Y7_FrameData[31] VGND VPWR Tile_X0Y9_FrameStrobe[1] latch
XFILLER_650_98 VPWR VGND sg13cmos5l_decap_8
XFILLER_208_255 VPWR VGND sg13cmos5l_fill_1
XFILLER_222_49 VPWR VGND sg13cmos5l_decap_8
XANTENNA__3330__X Tile_X0Y2_FrameData_O[1] VPWR VGND sg13cmos5l_antennanp
XFILLER_369_207 VPWR VGND sg13cmos5l_fill_2
XFILLER_223_236 VPWR VGND sg13cmos5l_fill_2
XFILLER_424_196 VPWR VGND sg13cmos5l_decap_8
XFILLER_90_263 VPWR VGND sg13cmos5l_fill_2
X_3951_ _3951_/X Tile_X0Y1_WW4END[12] AXI_M_SOC_ARREADY _4005_/X _3994_/X _1307_/Q
+ _1306_/Q VPWR VGND sg13cmos5l_mux4_1
XFILLER_585_148 VPWR VGND sg13cmos5l_decap_4
XFILLER_188_140 VPWR VGND sg13cmos5l_decap_8
X_2902_ Tile_X0Y6_FrameData_O[23] Tile_X0Y6_FrameData[23] VPWR VGND sg13cmos5l_buf_1
X_3882_ _3882_/X _3849_/X _0086_/X Tile_X0Y0_S1END[1] Tile_X0Y0_S4END[1] _0993_/Q
+ _0992_/Q VPWR VGND sg13cmos5l_mux4_1
XFILLER_378_75 VPWR VGND sg13cmos5l_decap_8
X_2833_ Tile_X0Y6_E1BEG[2] _4494_/X VPWR VGND sg13cmos5l_buf_1
XFILLER_593_181 VPWR VGND sg13cmos5l_decap_4
XFILLER_526_237 VPWR VGND sg13cmos5l_decap_8
XFILLER_528_56 VPWR VGND sg13cmos5l_decap_8
X_2764_ Tile_X0Y3_FrameData_O[22] Tile_X0Y3_FrameData[22] VPWR VGND sg13cmos5l_buf_1
XFILLER_528_78 VPWR VGND sg13cmos5l_decap_8
XFILLER_247_35 VPWR VGND sg13cmos5l_decap_8
XFILLER_144_210 VPWR VGND sg13cmos5l_decap_8
X_4503_ _4503_/X Tile_X0Y6_W2MID[0] AXI_M_SOC_RDATA31 _4553_/X _4552_/X _2601_/Q _2600_/Q
+ VPWR VGND sg13cmos5l_mux4_1
X_1715_ _1715_/Q Tile_X0Y3_FrameData[22] VGND VPWR Tile_X0Y9_FrameStrobe[1] latch
XFILLER_345_181 VPWR VGND sg13cmos5l_decap_8
X_2695_ _2695_/Q Tile_X0Y6_FrameData[0] VGND VPWR Tile_X0Y9_FrameStrobe[7] latch
X_4434_ _4434_/X _4359_/X _4475_/X _4474_/X _4358_/X _2199_/Q _2198_/Q VPWR VGND sg13cmos5l_mux4_1
X_1646_ _1646_/Q Tile_X0Y2_FrameData[3] VGND VPWR Tile_X0Y9_FrameStrobe[6] latch
XFILLER_116_28 VPWR VGND sg13cmos5l_decap_8
X_4365_ _4365_/X Tile_X0Y6_W2MID[1] Tile_X0Y6_W2END[1] Tile_X0Y6_W6END[1] _4554_/X
+ _2675_/Q _2674_/Q VPWR VGND sg13cmos5l_mux4_1
X_1577_ _1577_/Q Tile_X0Y2_FrameData[8] VGND VPWR Tile_X0Y9_FrameStrobe[4] latch
XFILLER_655_119 VPWR VGND sg13cmos5l_decap_8
XFILLER_447_200 VPWR VGND sg13cmos5l_decap_8
XANTENNA__3505__X Tile_X0Y1_E2BEGb[3] VPWR VGND sg13cmos5l_antennanp
XFILLER_263_56 VPWR VGND sg13cmos5l_fill_1
X_3316_ Tile_X0Y4_EE4BEG[4] _4276_/X VPWR VGND sg13cmos5l_buf_1
XFILLER_263_67 VPWR VGND sg13cmos5l_decap_8
X_0528_ _0528_/Q Tile_X0Y8_FrameData[15] VGND VPWR Tile_X0Y9_FrameStrobe[3] latch
XFILLER_112_162 VPWR VGND sg13cmos5l_decap_8
X_4296_ _4296_/X AXI_M_SOC_BRESP0 _4339_/X _4343_/X _4318_/X _2021_/Q _2020_/Q VPWR
+ VGND sg13cmos5l_mux4_1
XFILLER_560_21 VPWR VGND sg13cmos5l_decap_8
XFILLER_258_177 VPWR VGND sg13cmos5l_decap_8
X_3247_ Tile_X0Y0_FrameData_O[15] Tile_X0Y0_FrameData[15] VPWR VGND sg13cmos5l_buf_1
X_0459_ _0459_/Q Tile_X0Y8_FrameData[20] VGND VPWR Tile_X0Y9_FrameStrobe[1] latch
XFILLER_560_98 VPWR VGND sg13cmos5l_decap_8
XFILLER_132_49 VPWR VGND sg13cmos5l_decap_8
X_3178_ Tile_X0Y0_N4BEG[2] _3178_/A VPWR VGND sg13cmos5l_buf_1
XFILLER_462_258 VPWR VGND sg13cmos5l_decap_8
XFILLER_710_35 VPWR VGND sg13cmos5l_decap_8
XFILLER_415_152 VPWR VGND sg13cmos5l_fill_1
X_2129_ _2129_/Q Tile_X0Y4_FrameData[20] VGND VPWR Tile_X0Y9_FrameStrobe[6] latch
XFILLER_26_135 VPWR VGND sg13cmos5l_decap_8
XANTENNA__3240__X Tile_X0Y0_FrameData_O[8] VPWR VGND sg13cmos5l_antennanp
XFILLER_81_252 VPWR VGND sg13cmos5l_decap_8
XFILLER_25_14 VPWR VGND sg13cmos5l_decap_8
XFILLER_430_133 VPWR VGND sg13cmos5l_decap_8
XFILLER_569_63 VPWR VGND sg13cmos5l_decap_8
XFILLER_41_116 VPWR VGND sg13cmos5l_fill_2
XFILLER_25_47 VPWR VGND sg13cmos5l_fill_2
XFILLER_179_151 VPWR VGND sg13cmos5l_decap_8
XFILLER_148_7 VPWR VGND sg13cmos5l_decap_8
XFILLER_288_64 VPWR VGND sg13cmos5l_decap_8
XFILLER_194_110 VPWR VGND sg13cmos5l_decap_8
XFILLER_383_210 VPWR VGND sg13cmos5l_decap_8
XFILLER_328_137 VPWR VGND sg13cmos5l_fill_1
XFILLER_438_56 VPWR VGND sg13cmos5l_decap_8
XFILLER_315_7 VPWR VGND sg13cmos5l_decap_8
XFILLER_585_84 VPWR VGND sg13cmos5l_decap_8
XFILLER_41_68 VPWR VGND sg13cmos5l_decap_8
XFILLER_585_95 VPWR VGND sg13cmos5l_fill_1
XFILLER_194_198 VPWR VGND sg13cmos5l_decap_8
XFILLER_135_232 VPWR VGND sg13cmos5l_decap_8
XFILLER_157_79 VPWR VGND sg13cmos5l_decap_4
XFILLER_351_140 VPWR VGND sg13cmos5l_decap_8
XFILLER_686_233 VPWR VGND sg13cmos5l_decap_8
XFILLER_540_240 VPWR VGND sg13cmos5l_decap_8
XFILLER_497_133 VPWR VGND sg13cmos5l_decap_8
XFILLER_150_224 VPWR VGND sg13cmos5l_fill_2
XFILLER_500_126 VPWR VGND sg13cmos5l_decap_8
XFILLER_684_7 VPWR VGND sg13cmos5l_decap_8
XFILLER_646_119 VPWR VGND sg13cmos5l_decap_8
XFILLER_604_14 VPWR VGND sg13cmos5l_decap_8
XANTENNA__3415__X Tile_X0Y4_FrameData_O[6] VPWR VGND sg13cmos5l_antennanp
XFILLER_173_56 VPWR VGND sg13cmos5l_fill_1
XFILLER_103_140 VPWR VGND sg13cmos5l_decap_8
XFILLER_639_182 VPWR VGND sg13cmos5l_decap_8
XFILLER_106_50 VPWR VGND sg13cmos5l_decap_4
XFILLER_470_21 VPWR VGND sg13cmos5l_decap_8
XFILLER_323_15 VPWR VGND sg13cmos5l_decap_8
XFILLER_66_21 VPWR VGND sg13cmos5l_decap_8
XFILLER_453_203 VPWR VGND sg13cmos5l_decap_8
XFILLER_654_163 VPWR VGND sg13cmos5l_decap_8
XFILLER_599_207 VPWR VGND sg13cmos5l_decap_4
XFILLER_620_35 VPWR VGND sg13cmos5l_decap_8
XFILLER_57_271 VPWR VGND sg13cmos5l_fill_2
XFILLER_264_169 VPWR VGND sg13cmos5l_decap_8
XFILLER_66_98 VPWR VGND sg13cmos5l_decap_8
XFILLER_174_0 VPWR VGND sg13cmos5l_decap_8
XFILLER_205_203 VPWR VGND sg13cmos5l_decap_8
XANTENNA__3150__X Tile_X0Y7_FrameData_O[20] VPWR VGND sg13cmos5l_antennanp
XFILLER_72_241 VPWR VGND sg13cmos5l_decap_8
XFILLER_421_133 VPWR VGND sg13cmos5l_decap_8
XFILLER_82_42 VPWR VGND sg13cmos5l_decap_4
XFILLER_696_28 VPWR VGND sg13cmos5l_decap_8
XFILLER_567_126 VPWR VGND sg13cmos5l_decap_8
XFILLER_479_63 VPWR VGND sg13cmos5l_decap_8
XFILLER_479_85 VPWR VGND sg13cmos5l_decap_8
XFILLER_341_0 VPWR VGND sg13cmos5l_decap_8
XFILLER_82_75 VPWR VGND sg13cmos5l_decap_8
XFILLER_32_138 VPWR VGND sg13cmos5l_decap_8
XFILLER_198_42 VPWR VGND sg13cmos5l_fill_2
XFILLER_439_0 VPWR VGND sg13cmos5l_decap_8
XFILLER_198_75 VPWR VGND sg13cmos5l_decap_8
XFILLER_582_118 VPWR VGND sg13cmos5l_decap_8
XFILLER_508_204 VPWR VGND sg13cmos5l_decap_8
XFILLER_709_175 VPWR VGND sg13cmos5l_decap_4
XFILLER_629_77 VPWR VGND sg13cmos5l_decap_8
XFILLER_508_226 VPWR VGND sg13cmos5l_decap_8
XFILLER_606_0 VPWR VGND sg13cmos5l_decap_8
XFILLER_348_56 VPWR VGND sg13cmos5l_decap_8
XFILLER_70_8 VPWR VGND sg13cmos5l_decap_8
XFILLER_495_84 VPWR VGND sg13cmos5l_decap_8
XFILLER_334_107 VPWR VGND sg13cmos5l_decap_4
XFILLER_645_21 VPWR VGND sg13cmos5l_decap_8
XFILLER_126_210 VPWR VGND sg13cmos5l_fill_2
XFILLER_63_7 VPWR VGND sg13cmos5l_decap_8
X_1500_ _1500_/Q Tile_X0Y2_FrameData[21] VGND VPWR Tile_X0Y9_FrameStrobe[2] latch
X_2480_ _2480_/Q Tile_X0Y6_FrameData[23] VGND VPWR Tile_X0Y9_FrameStrobe[1] latch
XFILLER_645_98 VPWR VGND sg13cmos5l_decap_8
XFILLER_217_49 VPWR VGND sg13cmos5l_decap_8
XFILLER_677_244 VPWR VGND sg13cmos5l_decap_8
X_1431_ _1431_/Q Tile_X0Y2_FrameData[26] VGND VPWR Tile_X0Y9_FrameStrobe[0] latch
XFILLER_364_77 VPWR VGND sg13cmos5l_decap_8
XFILLER_692_203 VPWR VGND sg13cmos5l_fill_2
XFILLER_514_14 VPWR VGND sg13cmos5l_decap_8
XANTENNA__3325__X Tile_X0Y4_EE4BEG[13] VPWR VGND sg13cmos5l_antennanp
XFILLER_488_199 VPWR VGND sg13cmos5l_fill_2
XFILLER_661_42 VPWR VGND sg13cmos5l_decap_8
X_4150_ _4150_/X Tile_X0Y3_W2MID[5] AXI_M_SOC_WREADY _4209_/X _4208_/X _1841_/Q _1840_/Q
+ VPWR VGND sg13cmos5l_mux4_1
X_1362_ _1362_/Q Tile_X0Y1_FrameData[7] VGND VPWR Tile_X0Y9_FrameStrobe[5] latch
XFILLER_692_258 VPWR VGND sg13cmos5l_decap_8
XFILLER_380_21 VPWR VGND sg13cmos5l_decap_8
X_3101_ Tile_X0Y7_E2BEGb[7] _4627_/X VPWR VGND sg13cmos5l_buf_1
XFILLER_295_261 VPWR VGND sg13cmos5l_fill_1
X_0313_ _0313_/Q Tile_X0Y7_FrameData[6] VGND VPWR Tile_X0Y9_FrameStrobe[4] latch
XFILLER_295_272 VPWR VGND sg13cmos5l_fill_1
X_4081_ _4081_/X AXI_M_SOC_AWREADY _4118_/X _4122_/X _4100_/X _1511_/Q _1510_/Q VPWR
+ VGND sg13cmos5l_mux4_1
X_1293_ _1293_/Q Tile_X0Y1_FrameData[12] VGND VPWR Tile_X0Y9_FrameStrobe[3] latch
XFILLER_444_225 VPWR VGND sg13cmos5l_decap_8
X_3032_ Tile_X0Y5_EE4BEG[7] _4395_/X VPWR VGND sg13cmos5l_buf_1
XFILLER_645_196 VPWR VGND sg13cmos5l_decap_8
XFILLER_444_247 VPWR VGND sg13cmos5l_fill_1
X_0244_ _0244_/Q Tile_X0Y7_FrameData[11] VGND VPWR Tile_X0Y9_FrameStrobe[2] latch
XFILLER_380_98 VPWR VGND sg13cmos5l_decap_8
XFILLER_530_35 VPWR VGND sg13cmos5l_decap_8
XFILLER_313_81 VPWR VGND sg13cmos5l_decap_8
XFILLER_63_230 VPWR VGND sg13cmos5l_decap_8
XANTENNA__3060__X Tile_X0Y5_FrameData_O[19] VPWR VGND sg13cmos5l_antennanp
X_0175_ _0175_/Q Tile_X0Y7_FrameData[16] VGND VPWR Tile_X0Y9_FrameStrobe[0] latch
XFILLER_530_79 VPWR VGND sg13cmos5l_fill_1
XFILLER_558_115 VPWR VGND sg13cmos5l_decap_4
XFILLER_389_63 VPWR VGND sg13cmos5l_decap_8
XFILLER_558_126 VPWR VGND sg13cmos5l_decap_8
XFILLER_23_116 VPWR VGND sg13cmos5l_decap_8
XFILLER_610_90 VPWR VGND sg13cmos5l_decap_4
X_3934_ _3934_/X Tile_X0Y1_W2MID[5] AXI_M_SOC_ARREADY _3993_/X _3992_/X _1341_/Q _1340_/Q
+ VPWR VGND sg13cmos5l_mux4_1
XFILLER_176_121 VPWR VGND sg13cmos5l_decap_8
X_3865_ _3865_/X Tile_X0Y4_W1END[0] Tile_X0Y4_WW4END[0] Tile_X0Y4_W6END[8] _4336_/X
+ _2157_/Q _2156_/Q VPWR VGND sg13cmos5l_mux4_1
XFILLER_715_112 VPWR VGND sg13cmos5l_decap_8
XFILLER_686_94 VPWR VGND sg13cmos5l_decap_4
XFILLER_258_56 VPWR VGND sg13cmos5l_decap_8
X_2816_ Tile_X0Y3_E2BEG[6] _4154_/X VPWR VGND sg13cmos5l_buf_1
XFILLER_581_140 VPWR VGND sg13cmos5l_decap_8
X_3796_ _3796_/X Tile_X0Y0_W1END[2] Tile_X0Y0_WW4END[2] Tile_X0Y0_W6END[10] _3883_/X
+ _1147_/Q _1146_/Q VPWR VGND sg13cmos5l_mux4_1
XFILLER_117_221 VPWR VGND sg13cmos5l_decap_8
XFILLER_715_189 VPWR VGND sg13cmos5l_decap_8
XFILLER_191_146 VPWR VGND sg13cmos5l_decap_8
X_2747_ Tile_X0Y3_FrameData_O[5] Tile_X0Y3_FrameData[5] VPWR VGND sg13cmos5l_buf_1
XFILLER_581_195 VPWR VGND sg13cmos5l_decap_8
XFILLER_11_49 VPWR VGND sg13cmos5l_decap_8
XFILLER_555_65 VPWR VGND sg13cmos5l_decap_8
XFILLER_668_222 VPWR VGND sg13cmos5l_decap_8
XFILLER_127_49 VPWR VGND sg13cmos5l_decap_8
X_2678_ _2678_/Q Tile_X0Y6_FrameData[17] VGND VPWR Tile_X0Y9_FrameStrobe[7] latch
XFILLER_333_162 VPWR VGND sg13cmos5l_decap_4
XFILLER_705_35 VPWR VGND sg13cmos5l_decap_8
XFILLER_132_235 VPWR VGND sg13cmos5l_decap_8
X_4417_ _4417_/X Tile_X0Y4_W1END[0] Tile_X0Y4_W6END[8] _4348_/X _4300_/X _2145_/Q
+ _2144_/Q VPWR VGND sg13cmos5l_mux4_1
XFILLER_479_177 VPWR VGND sg13cmos5l_decap_8
XFILLER_278_217 VPWR VGND sg13cmos5l_decap_8
XFILLER_274_77 VPWR VGND sg13cmos5l_decap_8
X_1629_ _1629_/Q Tile_X0Y2_FrameData[20] VGND VPWR Tile_X0Y9_FrameStrobe[6] latch
XFILLER_424_14 VPWR VGND sg13cmos5l_decap_8
XANTENNA__3235__X Tile_X0Y0_FrameData_O[3] VPWR VGND sg13cmos5l_antennanp
XFILLER_571_42 VPWR VGND sg13cmos5l_decap_8
XFILLER_494_147 VPWR VGND sg13cmos5l_decap_8
X_4348_ _4348_/X _4302_/X _0099_/X _4301_/X _0112_/X _1957_/Q _1956_/Q VPWR VGND sg13cmos5l_mux4_1
XFILLER_290_43 VPWR VGND sg13cmos5l_decap_8
XFILLER_286_272 VPWR VGND sg13cmos5l_fill_1
X_4279_ _4279_/X Tile_X0Y4_WW4END[8] AXI_M_SOC_BRESP1 _4344_/X _4313_/X _2055_/Q _2054_/Q
+ VPWR VGND sg13cmos5l_mux4_1
XFILLER_435_214 VPWR VGND sg13cmos5l_decap_8
XFILLER_46_208 VPWR VGND sg13cmos5l_fill_2
XFILLER_504_91 VPWR VGND sg13cmos5l_decap_8
XFILLER_651_133 VPWR VGND sg13cmos5l_decap_8
XFILLER_435_258 VPWR VGND sg13cmos5l_fill_1
XFILLER_39_271 VPWR VGND sg13cmos5l_fill_2
XFILLER_440_35 VPWR VGND sg13cmos5l_decap_8
XFILLER_450_206 VPWR VGND sg13cmos5l_decap_8
XFILLER_36_35 VPWR VGND sg13cmos5l_fill_2
XFILLER_261_117 VPWR VGND sg13cmos5l_decap_8
XFILLER_403_100 VPWR VGND sg13cmos5l_decap_4
XFILLER_265_7 VPWR VGND sg13cmos5l_decap_8
XFILLER_199_213 VPWR VGND sg13cmos5l_decap_8
XFILLER_403_111 VPWR VGND sg13cmos5l_decap_8
XFILLER_36_79 VPWR VGND sg13cmos5l_decap_8
XFILLER_299_63 VPWR VGND sg13cmos5l_decap_8
XFILLER_299_74 VPWR VGND sg13cmos5l_fill_1
XFILLER_549_148 VPWR VGND sg13cmos5l_decap_8
XFILLER_299_96 VPWR VGND sg13cmos5l_decap_8
XFILLER_432_7 VPWR VGND sg13cmos5l_decap_8
XFILLER_356_210 VPWR VGND sg13cmos5l_decap_8
XFILLER_449_77 VPWR VGND sg13cmos5l_decap_8
XFILLER_706_112 VPWR VGND sg13cmos5l_decap_8
XFILLER_167_154 VPWR VGND sg13cmos5l_decap_8
XFILLER_572_140 VPWR VGND sg13cmos5l_decap_8
XFILLER_168_78 VPWR VGND sg13cmos5l_decap_8
XFILLER_465_21 VPWR VGND sg13cmos5l_decap_8
XFILLER_318_15 VPWR VGND sg13cmos5l_decap_8
XFILLER_371_224 VPWR VGND sg13cmos5l_decap_8
XFILLER_309_181 VPWR VGND sg13cmos5l_decap_4
XFILLER_318_48 VPWR VGND sg13cmos5l_fill_1
XFILLER_309_192 VPWR VGND sg13cmos5l_decap_8
XFILLER_182_157 VPWR VGND sg13cmos5l_decap_8
XFILLER_659_200 VPWR VGND sg13cmos5l_fill_1
XFILLER_182_168 VPWR VGND sg13cmos5l_fill_2
XFILLER_184_22 VPWR VGND sg13cmos5l_decap_8
XFILLER_659_222 VPWR VGND sg13cmos5l_decap_8
XFILLER_615_35 VPWR VGND sg13cmos5l_decap_8
XFILLER_485_114 VPWR VGND sg13cmos5l_decap_8
XFILLER_334_14 VPWR VGND sg13cmos5l_decap_8
XANTENNA__3145__X Tile_X0Y7_FrameData_O[15] VPWR VGND sg13cmos5l_antennanp
XFILLER_184_99 VPWR VGND sg13cmos5l_decap_8
XFILLER_96_108 VPWR VGND sg13cmos5l_fill_1
XFILLER_481_42 VPWR VGND sg13cmos5l_decap_8
XFILLER_89_182 VPWR VGND sg13cmos5l_decap_4
XFILLER_291_0 VPWR VGND sg13cmos5l_decap_4
XFILLER_89_193 VPWR VGND sg13cmos5l_decap_8
XANTENNA__2984__X Tile_X0Y8_FrameData_O[24] VPWR VGND sg13cmos5l_antennanp
XFILLER_426_203 VPWR VGND sg13cmos5l_decap_8
XFILLER_389_0 VPWR VGND sg13cmos5l_decap_8
XFILLER_631_56 VPWR VGND sg13cmos5l_decap_8
XFILLER_627_196 VPWR VGND sg13cmos5l_decap_4
XFILLER_37_208 VPWR VGND sg13cmos5l_decap_8
XFILLER_642_133 VPWR VGND sg13cmos5l_decap_8
XFILLER_133_70 VPWR VGND sg13cmos5l_decap_8
XFILLER_350_35 VPWR VGND sg13cmos5l_decap_8
XFILLER_237_169 VPWR VGND sg13cmos5l_fill_2
XFILLER_556_0 VPWR VGND sg13cmos5l_decap_8
XFILLER_45_230 VPWR VGND sg13cmos5l_decap_8
XFILLER_595_221 VPWR VGND sg13cmos5l_fill_2
XFILLER_500_49 VPWR VGND sg13cmos5l_decap_8
X_1980_ _1980_/Q Tile_X0Y4_FrameData[9] VGND VPWR Tile_X0Y9_FrameStrobe[1] latch
XFILLER_260_194 VPWR VGND sg13cmos5l_decap_8
XFILLER_158_110 VPWR VGND sg13cmos5l_decap_8
XFILLER_20_119 VPWR VGND sg13cmos5l_decap_8
X_0931_ _0931_/Q Tile_X0Y9_FrameData[22] VGND VPWR Tile_X0Y9_FrameStrobe[8] latch
XFILLER_359_77 VPWR VGND sg13cmos5l_decap_8
XFILLER_509_14 VPWR VGND sg13cmos5l_decap_8
XFILLER_201_272 VPWR VGND sg13cmos5l_fill_1
XFILLER_9_142 VPWR VGND sg13cmos5l_decap_8
XFILLER_656_42 VPWR VGND sg13cmos5l_decap_8
X_3650_ AXI_M_SOC_AWADDR11 Tile_X0Y5_WW4END[3] Tile_X0Y5_WW4END[11] Tile_X0Y5_W6END[11]
+ _4462_/X _2249_/Q _2248_/Q VPWR VGND sg13cmos5l_mux4_1
XFILLER_563_140 VPWR VGND sg13cmos5l_decap_8
X_0862_ _0862_/Q Tile_X0Y9_FrameData[1] VGND VPWR Tile_X0Y9_FrameStrobe[5] latch
XFILLER_563_151 VPWR VGND sg13cmos5l_fill_1
XFILLER_9_175 VPWR VGND sg13cmos5l_decap_8
XFILLER_375_21 VPWR VGND sg13cmos5l_decap_8
XFILLER_307_129 VPWR VGND sg13cmos5l_decap_4
XFILLER_9_186 VPWR VGND sg13cmos5l_fill_2
X_2601_ _2601_/Q Tile_X0Y6_FrameData[30] VGND VPWR Tile_X0Y9_FrameStrobe[5] latch
XFILLER_656_86 VPWR VGND sg13cmos5l_decap_4
XFILLER_173_135 VPWR VGND sg13cmos5l_decap_8
X_3581_ Tile_X0Y9_FrameData_O[11] Tile_X0Y9_FrameData[11] VPWR VGND sg13cmos5l_buf_1
XFILLER_712_126 VPWR VGND sg13cmos5l_decap_8
X_0793_ _0793_/Q Tile_X0Y9_FrameData[6] VGND VPWR Tile_X0Y9_FrameStrobe[3] latch
X_2532_ _2532_/Q Tile_X0Y6_FrameData[3] VGND VPWR Tile_X0Y9_FrameStrobe[2] latch
XFILLER_504_251 VPWR VGND sg13cmos5l_decap_8
XFILLER_315_162 VPWR VGND sg13cmos5l_decap_8
XFILLER_525_35 VPWR VGND sg13cmos5l_decap_8
XFILLER_308_70 VPWR VGND sg13cmos5l_decap_8
X_2463_ _2463_/Q Tile_X0Y6_FrameData[8] VGND VPWR Tile_X0Y9_FrameStrobe[0] latch
XFILLER_244_14 VPWR VGND sg13cmos5l_decap_8
XANTENNA__3055__X Tile_X0Y5_FrameData_O[14] VPWR VGND sg13cmos5l_antennanp
X_4202_ _4202_/X Tile_X0Y2_W1END[3] Tile_X0Y2_W6END[11] _4104_/X _4087_/X _1631_/Q
+ _1630_/Q VPWR VGND sg13cmos5l_mux4_1
XFILLER_672_96 VPWR VGND sg13cmos5l_decap_8
XFILLER_391_42 VPWR VGND sg13cmos5l_fill_2
X_1414_ _1414_/Q Tile_X0Y1_FrameData[19] VGND VPWR Tile_X0Y9_FrameStrobe[7] latch
XFILLER_476_147 VPWR VGND sg13cmos5l_fill_1
XFILLER_665_247 VPWR VGND sg13cmos5l_decap_8
X_2394_ _2394_/Q Tile_X0Y5_FrameData[11] VGND VPWR Tile_X0Y9_FrameStrobe[6] latch
XFILLER_476_169 VPWR VGND sg13cmos5l_decap_8
XFILLER_330_176 VPWR VGND sg13cmos5l_decap_8
XFILLER_605_90 VPWR VGND sg13cmos5l_fill_1
XFILLER_268_261 VPWR VGND sg13cmos5l_fill_1
XANTENNA__2894__X Tile_X0Y6_FrameData_O[15] VPWR VGND sg13cmos5l_antennanp
X_4133_ _4133_/X Tile_X0Y4_W2MID[5] Tile_X0Y4_W2END[5] Tile_X0Y4_W6END[5] _4317_/X
+ _2169_/Q _2168_/Q VPWR VGND sg13cmos5l_mux4_1
X_1345_ _1345_/Q Tile_X0Y1_FrameData[24] VGND VPWR Tile_X0Y9_FrameStrobe[5] latch
XFILLER_324_80 VPWR VGND sg13cmos5l_decap_8
XFILLER_541_56 VPWR VGND sg13cmos5l_decap_8
XFILLER_28_208 VPWR VGND sg13cmos5l_decap_8
XFILLER_283_231 VPWR VGND sg13cmos5l_decap_4
X_4064_ _4064_/X Tile_X0Y2_WW4END[7] AXI_M_SOC_AWREADY _4123_/X _4096_/X _1545_/Q
+ _1544_/Q VPWR VGND sg13cmos5l_mux4_1
XFILLER_633_133 VPWR VGND sg13cmos5l_decap_8
X_1276_ _1276_/Q Tile_X0Y1_FrameData[29] VGND VPWR Tile_X0Y9_FrameStrobe[3] latch
XFILLER_283_264 VPWR VGND sg13cmos5l_fill_1
XFILLER_260_35 VPWR VGND sg13cmos5l_decap_8
X_3015_ Tile_X0Y5_E6BEG[2] _4406_/X VPWR VGND sg13cmos5l_buf_1
XFILLER_243_117 VPWR VGND sg13cmos5l_decap_4
X_0227_ _0227_/Q Tile_X0Y7_FrameData[28] VGND VPWR Tile_X0Y9_FrameStrobe[2] latch
XFILLER_243_128 VPWR VGND sg13cmos5l_decap_8
XFILLER_243_139 VPWR VGND sg13cmos5l_fill_1
XFILLER_586_210 VPWR VGND sg13cmos5l_decap_8
XFILLER_397_121 VPWR VGND sg13cmos5l_decap_8
X_0158_ _0158_/X _4326_/X _4327_/X _0642_/Q VPWR VGND sg13cmos5l_mux2_1
XFILLER_410_49 VPWR VGND sg13cmos5l_decap_8
XFILLER_440_261 VPWR VGND sg13cmos5l_fill_2
XFILLER_440_272 VPWR VGND sg13cmos5l_fill_1
X_0089_ _0089_/X _4213_/X _4214_/X _0389_/Q VPWR VGND sg13cmos5l_mux2_1
XFILLER_397_198 VPWR VGND sg13cmos5l_decap_8
XFILLER_149_121 VPWR VGND sg13cmos5l_decap_8
XFILLER_400_147 VPWR VGND sg13cmos5l_decap_8
X_3917_ _3917_/X _4121_/X _4125_/X _4110_/X _4099_/X _1646_/Q _1645_/Q VPWR VGND sg13cmos5l_mux4_1
XFILLER_419_14 VPWR VGND sg13cmos5l_decap_8
X_4897_ _4897_/X Tile_X0Y8_W1END[1] Tile_X0Y8_W6END[9] _4813_/X _4773_/X _0633_/Q
+ _0632_/Q VPWR VGND sg13cmos5l_mux4_1
XFILLER_566_42 VPWR VGND sg13cmos5l_decap_8
X_3848_ _3848_/X Tile_X0Y1_W1END[0] Tile_X0Y1_W6END[4] _4005_/X _3976_/X _1425_/Q
+ _1424_/Q VPWR VGND sg13cmos5l_mux4_1
XFILLER_285_21 VPWR VGND sg13cmos5l_decap_8
XFILLER_353_224 VPWR VGND sg13cmos5l_decap_8
XFILLER_499_217 VPWR VGND sg13cmos5l_decap_8
XFILLER_703_126 VPWR VGND sg13cmos5l_decap_8
X_3779_ AXI_M_SOC_RREADY Tile_X0Y5_W2MID[0] Tile_X0Y5_W2END[0] Tile_X0Y5_W6END[0]
+ _4467_/X _2239_/Q _2238_/Q VPWR VGND sg13cmos5l_mux4_1
XFILLER_285_98 VPWR VGND sg13cmos5l_decap_8
XFILLER_218_70 VPWR VGND sg13cmos5l_fill_2
XFILLER_435_35 VPWR VGND sg13cmos5l_decap_8
XFILLER_154_14 VPWR VGND sg13cmos5l_decap_8
XFILLER_582_63 VPWR VGND sg13cmos5l_decap_8
XFILLER_467_114 VPWR VGND sg13cmos5l_decap_8
XFILLER_656_225 VPWR VGND sg13cmos5l_decap_8
XFILLER_321_154 VPWR VGND sg13cmos5l_decap_8
XFILLER_467_169 VPWR VGND sg13cmos5l_fill_1
XFILLER_120_249 VPWR VGND sg13cmos5l_decap_8
XANTENNA__0101__Y AXI_M_SOC_ARLEN6 VPWR VGND sg13cmos5l_antennanp
XFILLER_609_163 VPWR VGND sg13cmos5l_fill_2
XFILLER_408_203 VPWR VGND sg13cmos5l_decap_8
XFILLER_382_7 VPWR VGND sg13cmos5l_decap_8
XFILLER_304_28 VPWR VGND sg13cmos5l_decap_8
XFILLER_451_56 VPWR VGND sg13cmos5l_decap_8
XFILLER_19_219 VPWR VGND sg13cmos5l_decap_4
XFILLER_624_122 VPWR VGND sg13cmos5l_decap_8
XFILLER_219_169 VPWR VGND sg13cmos5l_decap_8
XFILLER_170_35 VPWR VGND sg13cmos5l_decap_8
XFILLER_647_7 VPWR VGND sg13cmos5l_decap_8
XFILLER_423_239 VPWR VGND sg13cmos5l_decap_8
XFILLER_27_252 VPWR VGND sg13cmos5l_decap_8
XFILLER_388_110 VPWR VGND sg13cmos5l_decap_8
XFILLER_27_263 VPWR VGND sg13cmos5l_fill_2
XFILLER_42_200 VPWR VGND sg13cmos5l_decap_8
XFILLER_103_84 VPWR VGND sg13cmos5l_decap_8
XFILLER_179_44 VPWR VGND sg13cmos5l_fill_2
XFILLER_63_77 VPWR VGND sg13cmos5l_decap_8
XFILLER_42_266 VPWR VGND sg13cmos5l_decap_8
XFILLER_8_28 VPWR VGND sg13cmos5l_decap_8
XFILLER_329_232 VPWR VGND sg13cmos5l_fill_1
XFILLER_137_0 VPWR VGND sg13cmos5l_decap_8
XFILLER_329_36 VPWR VGND sg13cmos5l_decap_8
XFILLER_476_42 VPWR VGND sg13cmos5l_decap_8
XFILLER_545_151 VPWR VGND sg13cmos5l_decap_8
XFILLER_195_21 VPWR VGND sg13cmos5l_decap_8
XFILLER_476_75 VPWR VGND sg13cmos5l_decap_8
XFILLER_545_184 VPWR VGND sg13cmos5l_fill_2
XANTENNA__2979__X Tile_X0Y8_FrameData_O[19] VPWR VGND sg13cmos5l_antennanp
XFILLER_10_185 VPWR VGND sg13cmos5l_decap_8
XFILLER_344_268 VPWR VGND sg13cmos5l_decap_4
XFILLER_304_0 VPWR VGND sg13cmos5l_decap_8
XFILLER_12_70 VPWR VGND sg13cmos5l_decap_8
XFILLER_155_179 VPWR VGND sg13cmos5l_decap_8
XFILLER_170_105 VPWR VGND sg13cmos5l_decap_4
XFILLER_626_56 VPWR VGND sg13cmos5l_decap_8
XFILLER_560_154 VPWR VGND sg13cmos5l_decap_8
XFILLER_6_189 VPWR VGND sg13cmos5l_decap_8
XFILLER_345_35 VPWR VGND sg13cmos5l_decap_8
XFILLER_128_70 VPWR VGND sg13cmos5l_decap_8
XFILLER_647_203 VPWR VGND sg13cmos5l_decap_8
XFILLER_501_210 VPWR VGND sg13cmos5l_decap_8
XFILLER_492_63 VPWR VGND sg13cmos5l_decap_8
XFILLER_312_121 VPWR VGND sg13cmos5l_decap_8
XFILLER_88_63 VPWR VGND sg13cmos5l_decap_8
XFILLER_702_192 VPWR VGND sg13cmos5l_decap_8
XFILLER_88_74 VPWR VGND sg13cmos5l_fill_1
XFILLER_69_119 VPWR VGND sg13cmos5l_decap_8
XFILLER_458_147 VPWR VGND sg13cmos5l_decap_8
XFILLER_673_0 VPWR VGND sg13cmos5l_decap_8
XFILLER_111_249 VPWR VGND sg13cmos5l_decap_8
XFILLER_214_28 VPWR VGND sg13cmos5l_decap_8
XFILLER_642_77 VPWR VGND sg13cmos5l_decap_8
XFILLER_26_7 VPWR VGND sg13cmos5l_decap_8
XFILLER_615_100 VPWR VGND sg13cmos5l_decap_8
XANTENNA__3603__X Tile_X0Y9_S1BEG[1] VPWR VGND sg13cmos5l_antennanp
XFILLER_466_180 VPWR VGND sg13cmos5l_decap_8
XFILLER_361_56 VPWR VGND sg13cmos5l_decap_8
XFILLER_144_91 VPWR VGND sg13cmos5l_fill_1
X_1130_ _1130_/Q Tile_X0Y0_FrameData[1] VGND VPWR Tile_X0Y9_FrameStrobe[5] latch
XFILLER_481_150 VPWR VGND sg13cmos5l_fill_1
XFILLER_670_250 VPWR VGND sg13cmos5l_decap_8
XFILLER_670_261 VPWR VGND sg13cmos5l_fill_1
XFILLER_481_172 VPWR VGND sg13cmos5l_decap_8
X_1061_ _1061_/Q Tile_X0Y0_FrameData[6] VGND VPWR Tile_X0Y9_FrameStrobe[3] latch
XFILLER_670_272 VPWR VGND sg13cmos5l_fill_1
XFILLER_615_188 VPWR VGND sg13cmos5l_decap_4
XFILLER_18_252 VPWR VGND sg13cmos5l_decap_8
XFILLER_92_166 VPWR VGND sg13cmos5l_decap_8
XFILLER_218_191 VPWR VGND sg13cmos5l_decap_8
XFILLER_568_210 VPWR VGND sg13cmos5l_decap_8
X_4820_ _4820_/X Tile_X0Y7_W1END[0] Tile_X0Y7_W2MID[3] Tile_X0Y7_W2END[3] _4674_/X
+ _0363_/Q _0362_/Q VPWR VGND sg13cmos5l_mux4_1
XFILLER_422_272 VPWR VGND sg13cmos5l_fill_1
XFILLER_233_183 VPWR VGND sg13cmos5l_decap_8
XFILLER_394_124 VPWR VGND sg13cmos5l_decap_8
XFILLER_310_93 VPWR VGND sg13cmos5l_decap_8
X_1963_ _1963_/Q Tile_X0Y4_FrameData[26] VGND VPWR Tile_X0Y9_FrameStrobe[1] latch
X_4751_ _4751_/X Tile_X0Y8_WW4END[8] AXI_M_SOC_RDATA15 _4808_/X _4785_/X _0545_/Q
+ _0544_/Q VPWR VGND sg13cmos5l_mux4_1
XFILLER_667_63 VPWR VGND sg13cmos5l_decap_8
XFILLER_239_14 VPWR VGND sg13cmos5l_decap_8
XFILLER_583_257 VPWR VGND sg13cmos5l_decap_4
XFILLER_386_42 VPWR VGND sg13cmos5l_decap_8
XFILLER_186_260 VPWR VGND sg13cmos5l_fill_2
X_0914_ _0914_/Q Tile_X0Y9_FrameData[13] VGND VPWR Tile_X0Y9_FrameStrobe[7] latch
X_3702_ AXI_M_SOC_WDATA12 Tile_X0Y7_W1END[0] Tile_X0Y7_WW4END[4] Tile_X0Y7_WW4END[12]
+ _4696_/X _0223_/Q _0222_/Q VPWR VGND sg13cmos5l_mux4_1
X_4682_ _4682_/X Tile_X0Y3_W1END[3] Tile_X0Y3_WW4END[15] Tile_X0Y3_W6END[7] _4225_/X
+ _1856_/Q _1855_/Q VPWR VGND sg13cmos5l_mux4_1
X_1894_ _1894_/Q Tile_X0Y3_FrameData[3] VGND VPWR Tile_X0Y9_FrameStrobe[6] latch
XFILLER_536_162 VPWR VGND sg13cmos5l_decap_4
XFILLER_536_173 VPWR VGND sg13cmos5l_decap_8
X_3633_ Tile_X0Y9_S4BEG[11] _3633_/A VPWR VGND sg13cmos5l_buf_1
XFILLER_551_110 VPWR VGND sg13cmos5l_decap_8
XFILLER_386_97 VPWR VGND sg13cmos5l_decap_8
XANTENNA__2889__X Tile_X0Y6_FrameData_O[10] VPWR VGND sg13cmos5l_antennanp
X_0845_ _0845_/Q Tile_X0Y9_FrameData[18] VGND VPWR Tile_X0Y9_FrameStrobe[5] latch
XFILLER_551_132 VPWR VGND sg13cmos5l_fill_2
XFILLER_697_125 VPWR VGND sg13cmos5l_decap_8
XFILLER_536_56 VPWR VGND sg13cmos5l_decap_8
X_3564_ Tile_X0Y9_EE4BEG[10] _4874_/X VPWR VGND sg13cmos5l_buf_1
XFILLER_350_216 VPWR VGND sg13cmos5l_decap_8
X_0776_ _0776_/Q Tile_X0Y9_FrameData[23] VGND VPWR Tile_X0Y9_FrameStrobe[3] latch
XFILLER_161_138 VPWR VGND sg13cmos5l_decap_8
XFILLER_536_89 VPWR VGND sg13cmos5l_decap_8
XFILLER_52_0 VPWR VGND sg13cmos5l_fill_2
X_2515_ _2515_/Q Tile_X0Y6_FrameData[20] VGND VPWR Tile_X0Y9_FrameStrobe[2] latch
XFILLER_255_57 VPWR VGND sg13cmos5l_decap_8
X_3495_ Tile_X0Y1_E6BEG[5] _3969_/X VPWR VGND sg13cmos5l_buf_1
XFILLER_303_143 VPWR VGND sg13cmos5l_fill_2
X_2446_ _2446_/Q Tile_X0Y6_FrameData[25] VGND VPWR Tile_X0Y9_FrameStrobe[0] latch
XFILLER_405_49 VPWR VGND sg13cmos5l_decap_8
XFILLER_552_77 VPWR VGND sg13cmos5l_decap_4
XFILLER_124_28 VPWR VGND sg13cmos5l_decap_8
X_2377_ _2377_/Q Tile_X0Y5_FrameData[28] VGND VPWR Tile_X0Y9_FrameStrobe[6] latch
XFILLER_702_14 VPWR VGND sg13cmos5l_decap_8
XANTENNA__3513__X Tile_X0Y1_E2BEG[3] VPWR VGND sg13cmos5l_antennanp
XFILLER_271_56 VPWR VGND sg13cmos5l_decap_8
X_4116_ _4116_/X _4089_/X _0079_/X _4088_/X Tile_X0Y0_S4END[8] _1481_/Q _1480_/Q VPWR
+ VGND sg13cmos5l_mux4_1
X_1328_ _1328_/Q Tile_X0Y1_FrameData[9] VGND VPWR Tile_X0Y9_FrameStrobe[4] latch
XFILLER_256_253 VPWR VGND sg13cmos5l_decap_8
XFILLER_606_144 VPWR VGND sg13cmos5l_decap_8
XFILLER_68_196 VPWR VGND sg13cmos5l_decap_8
XFILLER_405_206 VPWR VGND sg13cmos5l_fill_2
XFILLER_83_144 VPWR VGND sg13cmos5l_fill_1
X_4047_ _4047_/X Tile_X0Y2_W2MID[0] AXI_M_SOC_AWREADY _4097_/X _4096_/X _1579_/Q _1578_/Q
+ VPWR VGND sg13cmos5l_mux4_1
XFILLER_661_272 VPWR VGND sg13cmos5l_fill_1
X_1259_ _1259_/Q Tile_X0Y1_FrameData[14] VGND VPWR Tile_X0Y9_FrameStrobe[2] latch
XFILLER_621_114 VPWR VGND sg13cmos5l_fill_1
XFILLER_606_188 VPWR VGND sg13cmos5l_decap_8
XFILLER_621_136 VPWR VGND sg13cmos5l_decap_8
XFILLER_140_49 VPWR VGND sg13cmos5l_decap_8
XFILLER_501_70 VPWR VGND sg13cmos5l_decap_8
XFILLER_413_272 VPWR VGND sg13cmos5l_fill_1
XFILLER_224_194 VPWR VGND sg13cmos5l_decap_8
XFILLER_169_238 VPWR VGND sg13cmos5l_decap_8
XFILLER_385_113 VPWR VGND sg13cmos5l_decap_8
XFILLER_33_14 VPWR VGND sg13cmos5l_decap_8
XFILLER_33_25 VPWR VGND sg13cmos5l_fill_2
XFILLER_708_229 VPWR VGND sg13cmos5l_decap_8
XFILLER_574_224 VPWR VGND sg13cmos5l_decap_8
XFILLER_577_63 VPWR VGND sg13cmos5l_decap_8
XFILLER_149_14 VPWR VGND sg13cmos5l_decap_8
XFILLER_33_69 VPWR VGND sg13cmos5l_decap_4
XFILLER_296_42 VPWR VGND sg13cmos5l_decap_8
XFILLER_130_7 VPWR VGND sg13cmos5l_decap_8
XFILLER_228_7 VPWR VGND sg13cmos5l_decap_8
XFILLER_192_230 VPWR VGND sg13cmos5l_decap_4
XFILLER_326_235 VPWR VGND sg13cmos5l_decap_8
XANTENNA__2799__X Tile_X0Y3_E6BEG[9] VPWR VGND sg13cmos5l_antennanp
XFILLER_137_168 VPWR VGND sg13cmos5l_fill_1
XFILLER_192_263 VPWR VGND sg13cmos5l_decap_8
XFILLER_229_91 VPWR VGND sg13cmos5l_decap_8
XFILLER_542_165 VPWR VGND sg13cmos5l_decap_8
XFILLER_446_78 VPWR VGND sg13cmos5l_fill_2
XFILLER_109_4 VPWR VGND sg13cmos5l_fill_1
XFILLER_542_198 VPWR VGND sg13cmos5l_decap_8
XFILLER_145_190 VPWR VGND sg13cmos5l_decap_8
XFILLER_629_225 VPWR VGND sg13cmos5l_decap_8
XFILLER_597_7 VPWR VGND sg13cmos5l_decap_8
XFILLER_58_11 VPWR VGND sg13cmos5l_fill_2
XFILLER_239_209 VPWR VGND sg13cmos5l_decap_8
XFILLER_644_217 VPWR VGND sg13cmos5l_decap_8
XFILLER_612_14 VPWR VGND sg13cmos5l_decap_8
XANTENNA__3423__X Tile_X0Y4_FrameData_O[14] VPWR VGND sg13cmos5l_antennanp
XFILLER_181_56 VPWR VGND sg13cmos5l_decap_8
XFILLER_58_88 VPWR VGND sg13cmos5l_decap_8
XFILLER_101_271 VPWR VGND sg13cmos5l_fill_2
XFILLER_247_253 VPWR VGND sg13cmos5l_decap_8
XFILLER_247_264 VPWR VGND sg13cmos5l_fill_1
XFILLER_74_21 VPWR VGND sg13cmos5l_decap_4
XFILLER_74_155 VPWR VGND sg13cmos5l_decap_8
XFILLER_215_150 VPWR VGND sg13cmos5l_decap_8
XFILLER_411_70 VPWR VGND sg13cmos5l_decap_8
XFILLER_254_0 VPWR VGND sg13cmos5l_decap_8
XFILLER_15_255 VPWR VGND sg13cmos5l_decap_4
XFILLER_215_183 VPWR VGND sg13cmos5l_decap_8
XFILLER_215_194 VPWR VGND sg13cmos5l_fill_1
XFILLER_487_63 VPWR VGND sg13cmos5l_decap_8
XFILLER_230_164 VPWR VGND sg13cmos5l_decap_8
XFILLER_90_53 VPWR VGND sg13cmos5l_decap_8
XFILLER_565_246 VPWR VGND sg13cmos5l_fill_1
XFILLER_421_0 VPWR VGND sg13cmos5l_decap_8
XFILLER_376_168 VPWR VGND sg13cmos5l_decap_4
XFILLER_519_0 VPWR VGND sg13cmos5l_decap_8
XFILLER_580_205 VPWR VGND sg13cmos5l_decap_8
XFILLER_391_105 VPWR VGND sg13cmos5l_decap_8
XFILLER_90_97 VPWR VGND sg13cmos5l_decap_8
XFILLER_128_113 VPWR VGND sg13cmos5l_decap_8
XFILLER_317_224 VPWR VGND sg13cmos5l_decap_8
XFILLER_637_77 VPWR VGND sg13cmos5l_decap_8
XFILLER_209_28 VPWR VGND sg13cmos5l_decap_8
XFILLER_679_114 VPWR VGND sg13cmos5l_decap_8
XFILLER_139_91 VPWR VGND sg13cmos5l_decap_8
XFILLER_143_105 VPWR VGND sg13cmos5l_decap_4
XFILLER_356_56 VPWR VGND sg13cmos5l_decap_8
XFILLER_143_116 VPWR VGND sg13cmos5l_decap_8
X_0630_ _0630_/Q Tile_X0Y8_FrameData[9] VGND VPWR Tile_X0Y9_FrameStrobe[6] latch
XFILLER_533_165 VPWR VGND sg13cmos5l_decap_8
XFILLER_679_158 VPWR VGND sg13cmos5l_decap_8
XFILLER_332_227 VPWR VGND sg13cmos5l_decap_8
XFILLER_143_138 VPWR VGND sg13cmos5l_fill_2
XFILLER_653_21 VPWR VGND sg13cmos5l_decap_8
XFILLER_99_95 VPWR VGND sg13cmos5l_decap_8
X_0561_ _0561_/Q Tile_X0Y8_FrameData[14] VGND VPWR Tile_X0Y9_FrameStrobe[4] latch
XFILLER_486_220 VPWR VGND sg13cmos5l_fill_2
X_2300_ _2300_/Q Tile_X0Y5_FrameData[9] VGND VPWR Tile_X0Y9_FrameStrobe[3] latch
XFILLER_372_22 VPWR VGND sg13cmos5l_decap_8
X_3280_ Tile_X0Y0_E6BEG[0] _3836_/X VPWR VGND sg13cmos5l_buf_1
XFILLER_653_98 VPWR VGND sg13cmos5l_decap_8
XFILLER_225_49 VPWR VGND sg13cmos5l_decap_4
X_0492_ _0492_/Q Tile_X0Y8_FrameData[19] VGND VPWR Tile_X0Y9_FrameStrobe[2] latch
X_2231_ _2231_/Q Tile_X0Y5_FrameData[14] VGND VPWR Tile_X0Y9_FrameStrobe[1] latch
XFILLER_300_135 VPWR VGND sg13cmos5l_decap_8
XFILLER_97_269 VPWR VGND sg13cmos5l_decap_4
XFILLER_522_14 VPWR VGND sg13cmos5l_decap_8
XFILLER_238_220 VPWR VGND sg13cmos5l_decap_8
XANTENNA__3333__X Tile_X0Y2_FrameData_O[4] VPWR VGND sg13cmos5l_antennanp
X_2162_ _2162_/Q Tile_X0Y4_FrameData[19] VGND VPWR Tile_X0Y9_FrameStrobe[7] latch
XFILLER_65_133 VPWR VGND sg13cmos5l_decap_8
XFILLER_454_161 VPWR VGND sg13cmos5l_decap_4
X_1113_ _1113_/Q Tile_X0Y0_FrameData[18] VGND VPWR Tile_X0Y9_FrameStrobe[5] latch
X_2093_ _2093_/Q Tile_X0Y4_FrameData[24] VGND VPWR Tile_X0Y9_FrameStrobe[5] latch
XFILLER_399_227 VPWR VGND sg13cmos5l_decap_8
X_1044_ _1044_/Q Tile_X0Y0_FrameData[23] VGND VPWR Tile_X0Y9_FrameStrobe[3] latch
XFILLER_253_267 VPWR VGND sg13cmos5l_decap_4
XFILLER_213_109 VPWR VGND sg13cmos5l_decap_8
XFILLER_402_209 VPWR VGND sg13cmos5l_fill_2
XFILLER_321_92 VPWR VGND sg13cmos5l_decap_8
XFILLER_678_62 VPWR VGND sg13cmos5l_decap_8
XFILLER_221_153 VPWR VGND sg13cmos5l_decap_8
X_4803_ _4803_/X _4783_/X Tile_X0Y9_N4END[7] _4782_/X _0074_/X _0465_/Q _0464_/Q VPWR
+ VGND sg13cmos5l_mux4_1
XFILLER_367_135 VPWR VGND sg13cmos5l_decap_8
XFILLER_21_225 VPWR VGND sg13cmos5l_decap_4
X_2995_ Tile_X0Y5_E1BEG[2] _4370_/X VPWR VGND sg13cmos5l_buf_1
XFILLER_556_257 VPWR VGND sg13cmos5l_fill_1
XFILLER_556_268 VPWR VGND sg13cmos5l_decap_4
XFILLER_382_105 VPWR VGND sg13cmos5l_decap_8
X_4734_ _4734_/X Tile_X0Y8_W2MID[1] AXI_M_SOC_RDATA14 _4787_/X _4786_/X _0579_/Q _0578_/Q
+ VPWR VGND sg13cmos5l_mux4_1
X_1946_ _1946_/Q Tile_X0Y4_FrameData[11] VGND VPWR Tile_X0Y9_FrameStrobe[0] latch
XFILLER_509_162 VPWR VGND sg13cmos5l_fill_2
XFILLER_308_213 VPWR VGND sg13cmos5l_decap_8
XFILLER_382_138 VPWR VGND sg13cmos5l_fill_1
XFILLER_308_224 VPWR VGND sg13cmos5l_fill_1
XFILLER_174_230 VPWR VGND sg13cmos5l_decap_8
XFILLER_713_210 VPWR VGND sg13cmos5l_fill_1
XFILLER_547_77 VPWR VGND sg13cmos5l_decap_8
XFILLER_119_28 VPWR VGND sg13cmos5l_decap_8
X_1877_ _1877_/Q Tile_X0Y3_FrameData[20] VGND VPWR Tile_X0Y9_FrameStrobe[6] latch
X_4665_ _4665_/X Tile_X0Y8_W1END[2] Tile_X0Y8_W6END[6] _4814_/X _4774_/X _0667_/Q
+ _0666_/Q VPWR VGND sg13cmos5l_mux4_1
XFILLER_713_232 VPWR VGND sg13cmos5l_decap_8
XANTENNA__3508__X Tile_X0Y1_E2BEGb[6] VPWR VGND sg13cmos5l_antennanp
XFILLER_308_268 VPWR VGND sg13cmos5l_decap_4
XFILLER_266_56 VPWR VGND sg13cmos5l_decap_8
X_0828_ _0828_/Q Tile_X0Y9_FrameData[3] VGND VPWR Tile_X0Y9_FrameStrobe[4] latch
X_3616_ Tile_X0Y9_S2BEGb[2] _4934_/X VPWR VGND sg13cmos5l_buf_1
X_4596_ _4596_/X Tile_X0Y5_W1END[2] Tile_X0Y5_W2MID[1] Tile_X0Y5_W2END[1] _4429_/X
+ _2383_/Q _2382_/Q VPWR VGND sg13cmos5l_mux4_1
XFILLER_563_21 VPWR VGND sg13cmos5l_decap_8
XFILLER_134_149 VPWR VGND sg13cmos5l_decap_8
XFILLER_127_190 VPWR VGND sg13cmos5l_decap_4
XFILLER_323_249 VPWR VGND sg13cmos5l_decap_8
X_0759_ _0759_/Q Tile_X0Y9_FrameData[8] VGND VPWR Tile_X0Y9_FrameStrobe[2] latch
X_3547_ Tile_X0Y9_E6BEG[5] _4885_/X VPWR VGND sg13cmos5l_buf_1
XFILLER_142_171 VPWR VGND sg13cmos5l_decap_8
XFILLER_88_225 VPWR VGND sg13cmos5l_fill_1
XFILLER_135_49 VPWR VGND sg13cmos5l_decap_8
X_3478_ Tile_X0Y1_EE4BEG[4] _3952_/X VPWR VGND sg13cmos5l_buf_1
XFILLER_563_98 VPWR VGND sg13cmos5l_decap_8
XFILLER_331_271 VPWR VGND sg13cmos5l_fill_2
XFILLER_288_164 VPWR VGND sg13cmos5l_decap_8
XFILLER_626_206 VPWR VGND sg13cmos5l_decap_8
XFILLER_282_77 VPWR VGND sg13cmos5l_decap_8
X_2429_ _2429_/Q Tile_X0Y5_FrameData[8] VGND VPWR Tile_X0Y9_FrameStrobe[7] latch
XFILLER_713_68 VPWR VGND sg13cmos5l_decap_8
XFILLER_432_14 VPWR VGND sg13cmos5l_decap_8
XANTENNA__3243__X Tile_X0Y0_FrameData_O[11] VPWR VGND sg13cmos5l_antennanp
XFILLER_626_239 VPWR VGND sg13cmos5l_decap_8
XFILLER_28_14 VPWR VGND sg13cmos5l_decap_8
XFILLER_28_25 VPWR VGND sg13cmos5l_fill_2
XFILLER_445_161 VPWR VGND sg13cmos5l_fill_1
XFILLER_28_69 VPWR VGND sg13cmos5l_decap_4
XFILLER_244_212 VPWR VGND sg13cmos5l_decap_8
XFILLER_56_144 VPWR VGND sg13cmos5l_decap_8
XFILLER_445_194 VPWR VGND sg13cmos5l_decap_8
XFILLER_512_91 VPWR VGND sg13cmos5l_decap_8
XFILLER_244_267 VPWR VGND sg13cmos5l_decap_4
XFILLER_56_199 VPWR VGND sg13cmos5l_decap_8
XFILLER_301_29 VPWR VGND sg13cmos5l_decap_8
XFILLER_460_164 VPWR VGND sg13cmos5l_decap_8
XFILLER_44_13 VPWR VGND sg13cmos5l_fill_1
XFILLER_71_147 VPWR VGND sg13cmos5l_decap_8
XFILLER_44_35 VPWR VGND sg13cmos5l_decap_4
XFILLER_398_260 VPWR VGND sg13cmos5l_fill_1
XFILLER_345_7 VPWR VGND sg13cmos5l_decap_8
XFILLER_588_84 VPWR VGND sg13cmos5l_decap_4
XFILLER_401_220 VPWR VGND sg13cmos5l_decap_8
XFILLER_547_213 VPWR VGND sg13cmos5l_decap_8
XFILLER_44_79 VPWR VGND sg13cmos5l_fill_1
XFILLER_401_264 VPWR VGND sg13cmos5l_decap_8
XFILLER_212_175 VPWR VGND sg13cmos5l_decap_8
XFILLER_358_168 VPWR VGND sg13cmos5l_decap_8
XFILLER_512_7 VPWR VGND sg13cmos5l_decap_8
XFILLER_100_63 VPWR VGND sg13cmos5l_decap_8
XFILLER_373_116 VPWR VGND sg13cmos5l_fill_2
XFILLER_562_227 VPWR VGND sg13cmos5l_fill_2
XFILLER_60_56 VPWR VGND sg13cmos5l_fill_1
XFILLER_457_77 VPWR VGND sg13cmos5l_decap_8
XFILLER_607_14 VPWR VGND sg13cmos5l_decap_8
XFILLER_165_252 VPWR VGND sg13cmos5l_decap_8
XANTENNA__3418__X Tile_X0Y4_FrameData_O[9] VPWR VGND sg13cmos5l_antennanp
XFILLER_165_263 VPWR VGND sg13cmos5l_fill_2
XFILLER_125_116 VPWR VGND sg13cmos5l_decap_8
XFILLER_381_160 VPWR VGND sg13cmos5l_fill_2
XFILLER_314_216 VPWR VGND sg13cmos5l_decap_4
XFILLER_109_50 VPWR VGND sg13cmos5l_fill_2
XFILLER_314_227 VPWR VGND sg13cmos5l_decap_8
XFILLER_473_21 VPWR VGND sg13cmos5l_decap_8
XFILLER_314_238 VPWR VGND sg13cmos5l_fill_1
XFILLER_180_244 VPWR VGND sg13cmos5l_decap_8
XFILLER_326_37 VPWR VGND sg13cmos5l_fill_1
XFILLER_69_21 VPWR VGND sg13cmos5l_decap_8
XFILLER_79_203 VPWR VGND sg13cmos5l_decap_8
XFILLER_669_180 VPWR VGND sg13cmos5l_fill_2
XFILLER_133_160 VPWR VGND sg13cmos5l_decap_4
XFILLER_140_119 VPWR VGND sg13cmos5l_decap_8
XFILLER_530_179 VPWR VGND sg13cmos5l_fill_1
XFILLER_473_87 VPWR VGND sg13cmos5l_decap_8
XFILLER_322_271 VPWR VGND sg13cmos5l_fill_2
XFILLER_192_55 VPWR VGND sg13cmos5l_decap_8
XFILLER_623_35 VPWR VGND sg13cmos5l_decap_8
XFILLER_192_66 VPWR VGND sg13cmos5l_fill_1
XFILLER_69_98 VPWR VGND sg13cmos5l_decap_8
XFILLER_684_150 VPWR VGND sg13cmos5l_decap_8
XFILLER_483_201 VPWR VGND sg13cmos5l_decap_4
XFILLER_406_70 VPWR VGND sg13cmos5l_decap_8
XFILLER_192_88 VPWR VGND sg13cmos5l_decap_8
XFILLER_617_228 VPWR VGND sg13cmos5l_decap_8
XFILLER_342_14 VPWR VGND sg13cmos5l_decap_8
XFILLER_192_99 VPWR VGND sg13cmos5l_fill_1
XANTENNA__3153__X Tile_X0Y7_FrameData_O[23] VPWR VGND sg13cmos5l_antennanp
XFILLER_94_239 VPWR VGND sg13cmos5l_decap_8
XFILLER_371_0 VPWR VGND sg13cmos5l_decap_8
XFILLER_625_261 VPWR VGND sg13cmos5l_decap_8
XFILLER_436_161 VPWR VGND sg13cmos5l_decap_4
XANTENNA__2992__X Tile_X0Y8_UserCLKo VPWR VGND sg13cmos5l_antennanp
XFILLER_469_0 VPWR VGND sg13cmos5l_decap_8
XFILLER_625_272 VPWR VGND sg13cmos5l_fill_1
XFILLER_47_155 VPWR VGND sg13cmos5l_decap_8
XFILLER_640_231 VPWR VGND sg13cmos5l_decap_8
XFILLER_62_103 VPWR VGND sg13cmos5l_decap_8
XFILLER_422_91 VPWR VGND sg13cmos5l_decap_8
XFILLER_141_70 VPWR VGND sg13cmos5l_decap_8
XFILLER_250_204 VPWR VGND sg13cmos5l_decap_8
XFILLER_597_157 VPWR VGND sg13cmos5l_fill_1
XFILLER_636_0 VPWR VGND sg13cmos5l_decap_8
XFILLER_498_84 VPWR VGND sg13cmos5l_decap_8
XFILLER_648_21 VPWR VGND sg13cmos5l_decap_8
XFILLER_203_142 VPWR VGND sg13cmos5l_decap_8
XFILLER_538_224 VPWR VGND sg13cmos5l_fill_1
XFILLER_93_7 VPWR VGND sg13cmos5l_decap_8
XFILLER_538_246 VPWR VGND sg13cmos5l_decap_8
XFILLER_538_268 VPWR VGND sg13cmos5l_decap_4
XFILLER_367_22 VPWR VGND sg13cmos5l_decap_8
X_1800_ _1800_/Q Tile_X0Y3_FrameData[1] VGND VPWR Tile_X0Y9_FrameStrobe[3] latch
X_2780_ Tile_X0Y3_EE4BEG[6] _4170_/X VPWR VGND sg13cmos5l_buf_1
XFILLER_648_98 VPWR VGND sg13cmos5l_decap_8
X_1731_ _1731_/Q Tile_X0Y3_FrameData[6] VGND VPWR Tile_X0Y9_FrameStrobe[1] latch
XFILLER_517_14 VPWR VGND sg13cmos5l_decap_8
XANTENNA__3328__X Tile_X0Y2_UserCLKo VPWR VGND sg13cmos5l_antennanp
XFILLER_664_42 VPWR VGND sg13cmos5l_decap_8
XFILLER_305_205 VPWR VGND sg13cmos5l_fill_2
X_1662_ _1662_/Q Tile_X0Y2_FrameData[19] VGND VPWR Tile_X0Y9_FrameStrobe[7] latch
X_4450_ _4450_/X _4923_/X _4927_/X _4931_/X _4907_/X _0894_/Q _0893_/Q VPWR VGND sg13cmos5l_mux4_1
XFILLER_710_202 VPWR VGND sg13cmos5l_fill_1
XFILLER_561_271 VPWR VGND sg13cmos5l_fill_2
XFILLER_383_21 VPWR VGND sg13cmos5l_decap_8
XFILLER_372_182 VPWR VGND sg13cmos5l_decap_8
X_0613_ _0613_/Q Tile_X0Y8_FrameData[26] VGND VPWR Tile_X0Y9_FrameStrobe[6] latch
X_3401_ Tile_X0Y2_E2BEG[4] _4044_/X VPWR VGND sg13cmos5l_buf_1
X_4381_ _4381_/X Tile_X0Y5_W2END[6] AXI_M_SOC_RRESP0 _4430_/X _4429_/X _2341_/Q _2340_/Q
+ VPWR VGND sg13cmos5l_mux4_1
X_1593_ _1593_/Q Tile_X0Y2_FrameData[24] VGND VPWR Tile_X0Y9_FrameStrobe[5] latch
XFILLER_320_208 VPWR VGND sg13cmos5l_decap_8
X_3332_ Tile_X0Y2_FrameData_O[3] Tile_X0Y2_FrameData[3] VPWR VGND sg13cmos5l_buf_1
X_0544_ _0544_/Q Tile_X0Y8_FrameData[31] VGND VPWR Tile_X0Y9_FrameStrobe[4] latch
XFILLER_383_98 VPWR VGND sg13cmos5l_decap_8
XFILLER_533_35 VPWR VGND sg13cmos5l_decap_8
XFILLER_285_112 VPWR VGND sg13cmos5l_decap_8
X_3263_ Tile_X0Y0_FrameData_O[31] Tile_X0Y0_FrameData[31] VPWR VGND sg13cmos5l_buf_1
XFILLER_608_228 VPWR VGND sg13cmos5l_decap_8
XFILLER_252_14 VPWR VGND sg13cmos5l_decap_8
X_0475_ _0475_/Q Tile_X0Y8_FrameData[4] VGND VPWR Tile_X0Y9_FrameStrobe[1] latch
XANTENNA__3063__X Tile_X0Y5_FrameData_O[22] VPWR VGND sg13cmos5l_antennanp
XFILLER_474_245 VPWR VGND sg13cmos5l_decap_8
X_2214_ _2214_/Q Tile_X0Y5_FrameData[31] VGND VPWR Tile_X0Y9_FrameStrobe[1] latch
XFILLER_85_239 VPWR VGND sg13cmos5l_decap_8
XFILLER_690_142 VPWR VGND sg13cmos5l_decap_8
X_3194_ Tile_X0Y0_N2BEGb[2] _3893_/X VPWR VGND sg13cmos5l_buf_1
XFILLER_434_109 VPWR VGND sg13cmos5l_fill_2
XFILLER_15_0 VPWR VGND sg13cmos5l_decap_8
XFILLER_690_164 VPWR VGND sg13cmos5l_decap_8
XFILLER_38_122 VPWR VGND sg13cmos5l_decap_8
XFILLER_285_189 VPWR VGND sg13cmos5l_decap_8
XFILLER_427_161 VPWR VGND sg13cmos5l_decap_8
X_2145_ _2145_/Q Tile_X0Y4_FrameData[4] VGND VPWR Tile_X0Y9_FrameStrobe[6] latch
XFILLER_402_28 VPWR VGND sg13cmos5l_decap_8
XFILLER_631_220 VPWR VGND sg13cmos5l_decap_8
XFILLER_689_50 VPWR VGND sg13cmos5l_decap_8
XFILLER_53_114 VPWR VGND sg13cmos5l_decap_8
XFILLER_38_188 VPWR VGND sg13cmos5l_decap_8
X_2076_ _2076_/Q Tile_X0Y4_FrameData[9] VGND VPWR Tile_X0Y9_FrameStrobe[4] latch
XFILLER_442_153 VPWR VGND sg13cmos5l_fill_1
XFILLER_241_215 VPWR VGND sg13cmos5l_decap_8
XFILLER_442_175 VPWR VGND sg13cmos5l_decap_8
XFILLER_53_158 VPWR VGND sg13cmos5l_decap_8
XFILLER_442_186 VPWR VGND sg13cmos5l_fill_2
X_1027_ _1027_/Q Tile_X0Y0_FrameData[8] VGND VPWR Tile_X0Y9_FrameStrobe[2] latch
XFILLER_558_21 VPWR VGND sg13cmos5l_decap_8
XFILLER_395_241 VPWR VGND sg13cmos5l_fill_1
XFILLER_201_84 VPWR VGND sg13cmos5l_decap_4
XFILLER_529_257 VPWR VGND sg13cmos5l_fill_2
XFILLER_14_49 VPWR VGND sg13cmos5l_decap_8
XFILLER_395_263 VPWR VGND sg13cmos5l_decap_8
XFILLER_544_205 VPWR VGND sg13cmos5l_fill_2
XFILLER_355_105 VPWR VGND sg13cmos5l_decap_8
X_2978_ Tile_X0Y8_FrameData_O[18] Tile_X0Y8_FrameData[18] VPWR VGND sg13cmos5l_buf_1
XFILLER_708_35 VPWR VGND sg13cmos5l_decap_8
XFILLER_277_77 VPWR VGND sg13cmos5l_decap_8
XFILLER_147_241 VPWR VGND sg13cmos5l_decap_8
X_4717_ _4717_/X _4804_/X _4808_/X _4812_/X _4790_/X _0611_/Q _0610_/Q VPWR VGND sg13cmos5l_mux4_1
X_1929_ _1929_/Q Tile_X0Y4_FrameData[28] VGND VPWR Tile_X0Y9_FrameStrobe[0] latch
XFILLER_427_14 VPWR VGND sg13cmos5l_decap_8
XANTENNA__3238__X Tile_X0Y0_FrameData_O[6] VPWR VGND sg13cmos5l_antennanp
XFILLER_698_220 VPWR VGND sg13cmos5l_decap_8
XFILLER_574_42 VPWR VGND sg13cmos5l_decap_8
XFILLER_370_119 VPWR VGND sg13cmos5l_fill_2
XFILLER_107_116 VPWR VGND sg13cmos5l_fill_2
X_4648_ _4648_/X AXI_M_SOC_RDATA16 _4691_/X _4695_/X _4669_/X _0263_/Q _0262_/Q VPWR
+ VGND sg13cmos5l_mux4_1
XFILLER_293_21 VPWR VGND sg13cmos5l_decap_8
XFILLER_701_224 VPWR VGND sg13cmos5l_decap_8
X_4579_ _4579_/X _4551_/X Tile_X0Y9_N4END[15] _4550_/X _0150_/X _2473_/Q _2472_/Q
+ VPWR VGND sg13cmos5l_mux4_1
XFILLER_701_268 VPWR VGND sg13cmos5l_decap_4
XFILLER_507_91 VPWR VGND sg13cmos5l_decap_8
XFILLER_115_182 VPWR VGND sg13cmos5l_fill_1
XFILLER_443_35 VPWR VGND sg13cmos5l_decap_8
XFILLER_666_150 VPWR VGND sg13cmos5l_fill_2
XFILLER_39_24 VPWR VGND sg13cmos5l_decap_8
XFILLER_276_112 VPWR VGND sg13cmos5l_decap_8
XFILLER_162_14 VPWR VGND sg13cmos5l_decap_8
XFILLER_590_63 VPWR VGND sg13cmos5l_decap_8
XFILLER_520_190 VPWR VGND sg13cmos5l_decap_8
XFILLER_276_145 VPWR VGND sg13cmos5l_decap_8
XFILLER_76_217 VPWR VGND sg13cmos5l_decap_8
XFILLER_681_120 VPWR VGND sg13cmos5l_fill_2
XFILLER_465_256 VPWR VGND sg13cmos5l_decap_8
XFILLER_162_58 VPWR VGND sg13cmos5l_fill_1
XFILLER_681_164 VPWR VGND sg13cmos5l_decap_8
XFILLER_418_150 VPWR VGND sg13cmos5l_decap_8
XFILLER_29_144 VPWR VGND sg13cmos5l_fill_1
XFILLER_681_186 VPWR VGND sg13cmos5l_decap_8
XFILLER_312_28 VPWR VGND sg13cmos5l_decap_8
XFILLER_462_7 VPWR VGND sg13cmos5l_decap_8
XFILLER_291_148 VPWR VGND sg13cmos5l_decap_8
XFILLER_480_248 VPWR VGND sg13cmos5l_decap_8
XFILLER_242_80 VPWR VGND sg13cmos5l_decap_8
XANTENNA__3701__X AXI_M_SOC_WDATA11 VPWR VGND sg13cmos5l_antennanp
XFILLER_29_177 VPWR VGND sg13cmos5l_fill_2
XFILLER_217_256 VPWR VGND sg13cmos5l_decap_4
XFILLER_84_272 VPWR VGND sg13cmos5l_fill_1
XFILLER_55_45 VPWR VGND sg13cmos5l_decap_4
XFILLER_433_153 VPWR VGND sg13cmos5l_decap_8
XFILLER_189_108 VPWR VGND sg13cmos5l_fill_1
XFILLER_468_21 VPWR VGND sg13cmos5l_decap_8
XFILLER_197_130 VPWR VGND sg13cmos5l_decap_8
XFILLER_111_84 VPWR VGND sg13cmos5l_fill_2
XFILLER_386_252 VPWR VGND sg13cmos5l_decap_8
XFILLER_200_112 VPWR VGND sg13cmos5l_decap_8
XFILLER_197_174 VPWR VGND sg13cmos5l_decap_8
XFILLER_71_77 VPWR VGND sg13cmos5l_decap_8
XFILLER_618_35 VPWR VGND sg13cmos5l_decap_8
XFILLER_346_138 VPWR VGND sg13cmos5l_decap_8
XFILLER_138_252 VPWR VGND sg13cmos5l_fill_1
XFILLER_337_14 VPWR VGND sg13cmos5l_decap_8
XANTENNA__3148__X Tile_X0Y7_FrameData_O[18] VPWR VGND sg13cmos5l_antennanp
XFILLER_217_0 VPWR VGND sg13cmos5l_decap_8
XFILLER_484_42 VPWR VGND sg13cmos5l_decap_8
XFILLER_689_242 VPWR VGND sg13cmos5l_decap_4
XFILLER_550_219 VPWR VGND sg13cmos5l_decap_8
XFILLER_354_182 VPWR VGND sg13cmos5l_decap_8
XFILLER_337_69 VPWR VGND sg13cmos5l_decap_4
XANTENNA__2987__X Tile_X0Y8_FrameData_O[27] VPWR VGND sg13cmos5l_antennanp
XFILLER_106_160 VPWR VGND sg13cmos5l_decap_8
XFILLER_20_70 VPWR VGND sg13cmos5l_decap_8
XFILLER_634_56 VPWR VGND sg13cmos5l_decap_8
XFILLER_503_168 VPWR VGND sg13cmos5l_decap_8
XFILLER_417_91 VPWR VGND sg13cmos5l_decap_8
XFILLER_353_35 VPWR VGND sg13cmos5l_decap_8
XFILLER_136_70 VPWR VGND sg13cmos5l_decap_8
XFILLER_456_201 VPWR VGND sg13cmos5l_fill_2
XFILLER_96_30 VPWR VGND sg13cmos5l_fill_1
XFILLER_586_0 VPWR VGND sg13cmos5l_decap_8
XFILLER_267_112 VPWR VGND sg13cmos5l_decap_4
XFILLER_96_52 VPWR VGND sg13cmos5l_decap_8
XFILLER_657_183 VPWR VGND sg13cmos5l_decap_8
XFILLER_67_217 VPWR VGND sg13cmos5l_decap_8
XFILLER_456_256 VPWR VGND sg13cmos5l_decap_8
X_0260_ _0260_/Q Tile_X0Y7_FrameData[27] VGND VPWR Tile_X0Y9_FrameStrobe[3] latch
XFILLER_503_49 VPWR VGND sg13cmos5l_decap_8
XFILLER_471_215 VPWR VGND sg13cmos5l_decap_8
XFILLER_267_189 VPWR VGND sg13cmos5l_decap_4
XFILLER_282_126 VPWR VGND sg13cmos5l_decap_8
XFILLER_650_77 VPWR VGND sg13cmos5l_decap_8
XFILLER_222_28 VPWR VGND sg13cmos5l_decap_8
X_0191_ _0191_/Q Tile_X0Y7_FrameData[0] VGND VPWR Tile_X0Y9_FrameStrobe[0] latch
XANTENNA__3611__X Tile_X0Y9_S2BEG[5] VPWR VGND sg13cmos5l_antennanp
XFILLER_35_103 VPWR VGND sg13cmos5l_fill_1
XFILLER_35_125 VPWR VGND sg13cmos5l_decap_8
XFILLER_35_136 VPWR VGND sg13cmos5l_fill_2
XFILLER_223_215 VPWR VGND sg13cmos5l_decap_8
XFILLER_424_175 VPWR VGND sg13cmos5l_decap_8
XFILLER_659_42 VPWR VGND sg13cmos5l_decap_8
X_3950_ _3950_/X Tile_X0Y1_WW4END[13] AXI_M_SOC_ARREADY _4002_/X _3992_/X _1309_/Q
+ _1308_/Q VPWR VGND sg13cmos5l_mux4_1
XFILLER_50_106 VPWR VGND sg13cmos5l_decap_8
XFILLER_223_259 VPWR VGND sg13cmos5l_fill_2
XFILLER_659_75 VPWR VGND sg13cmos5l_decap_8
XFILLER_659_86 VPWR VGND sg13cmos5l_fill_2
X_2901_ Tile_X0Y6_FrameData_O[22] Tile_X0Y6_FrameData[22] VPWR VGND sg13cmos5l_buf_1
XFILLER_378_43 VPWR VGND sg13cmos5l_decap_8
X_3881_ _3881_/X _3848_/X _0067_/X Tile_X0Y0_S1END[0] Tile_X0Y0_S4END[0] _0995_/Q
+ _0994_/Q VPWR VGND sg13cmos5l_mux4_1
XFILLER_43_191 VPWR VGND sg13cmos5l_decap_8
XFILLER_392_200 VPWR VGND sg13cmos5l_decap_8
X_2832_ Tile_X0Y6_E1BEG[1] _4493_/X VPWR VGND sg13cmos5l_buf_1
XFILLER_526_216 VPWR VGND sg13cmos5l_decap_8
XFILLER_337_116 VPWR VGND sg13cmos5l_fill_2
XFILLER_188_196 VPWR VGND sg13cmos5l_decap_8
XFILLER_593_171 VPWR VGND sg13cmos5l_fill_2
XFILLER_528_35 VPWR VGND sg13cmos5l_decap_8
XFILLER_247_14 VPWR VGND sg13cmos5l_decap_8
XFILLER_129_252 VPWR VGND sg13cmos5l_fill_2
X_2763_ Tile_X0Y3_FrameData_O[21] Tile_X0Y3_FrameData[21] VPWR VGND sg13cmos5l_buf_1
XANTENNA__3058__X Tile_X0Y5_FrameData_O[17] VPWR VGND sg13cmos5l_antennanp
XFILLER_352_119 VPWR VGND sg13cmos5l_decap_8
X_4502_ _4502_/X Tile_X0Y6_W2MID[1] AXI_M_SOC_RDATA30 _4555_/X _4554_/X _2603_/Q _2602_/Q
+ VPWR VGND sg13cmos5l_mux4_1
XFILLER_345_160 VPWR VGND sg13cmos5l_decap_8
X_1714_ _1714_/Q Tile_X0Y3_FrameData[23] VGND VPWR Tile_X0Y9_FrameStrobe[1] latch
X_2694_ _2694_/Q Tile_X0Y6_FrameData[1] VGND VPWR Tile_X0Y9_FrameStrobe[7] latch
XANTENNA__2897__X Tile_X0Y6_FrameData_O[18] VPWR VGND sg13cmos5l_antennanp
X_1645_ _1645_/Q Tile_X0Y2_FrameData[4] VGND VPWR Tile_X0Y9_FrameStrobe[6] latch
X_4433_ _4433_/X _4361_/X _4477_/X _4476_/X _4360_/X _2197_/Q _2196_/Q VPWR VGND sg13cmos5l_mux4_1
XFILLER_695_223 VPWR VGND sg13cmos5l_decap_8
XFILLER_327_80 VPWR VGND sg13cmos5l_decap_4
XFILLER_544_56 VPWR VGND sg13cmos5l_decap_8
XFILLER_360_163 VPWR VGND sg13cmos5l_fill_1
XFILLER_695_267 VPWR VGND sg13cmos5l_decap_4
XFILLER_360_185 VPWR VGND sg13cmos5l_decap_8
X_1576_ _1576_/Q Tile_X0Y2_FrameData[9] VGND VPWR Tile_X0Y9_FrameStrobe[4] latch
X_4364_ _4364_/X Tile_X0Y3_W1END[2] Tile_X0Y3_W2MID[1] Tile_X0Y3_W2END[1] _4206_/X
+ _1869_/Q _1868_/Q VPWR VGND sg13cmos5l_mux4_1
XFILLER_691_84 VPWR VGND sg13cmos5l_decap_4
XFILLER_263_35 VPWR VGND sg13cmos5l_decap_8
XFILLER_258_101 VPWR VGND sg13cmos5l_decap_8
XFILLER_648_161 VPWR VGND sg13cmos5l_fill_2
X_0527_ _0527_/Q Tile_X0Y8_FrameData[16] VGND VPWR Tile_X0Y9_FrameStrobe[3] latch
X_3315_ Tile_X0Y4_EE4BEG[3] _4275_/X VPWR VGND sg13cmos5l_buf_1
X_4295_ _4295_/X AXI_M_SOC_BRESP1 _4340_/X _4344_/X _4319_/X _2023_/Q _2022_/Q VPWR
+ VGND sg13cmos5l_mux4_1
XFILLER_301_252 VPWR VGND sg13cmos5l_decap_8
XFILLER_663_131 VPWR VGND sg13cmos5l_decap_4
XFILLER_258_156 VPWR VGND sg13cmos5l_decap_8
X_3246_ Tile_X0Y0_FrameData_O[14] Tile_X0Y0_FrameData[14] VPWR VGND sg13cmos5l_buf_1
XFILLER_58_239 VPWR VGND sg13cmos5l_decap_8
X_0458_ _0458_/Q Tile_X0Y8_FrameData[21] VGND VPWR Tile_X0Y9_FrameStrobe[1] latch
XFILLER_413_49 VPWR VGND sg13cmos5l_decap_8
XFILLER_560_77 VPWR VGND sg13cmos5l_decap_8
XFILLER_132_28 VPWR VGND sg13cmos5l_decap_8
XFILLER_73_209 VPWR VGND sg13cmos5l_decap_4
XFILLER_462_237 VPWR VGND sg13cmos5l_decap_8
X_3177_ Tile_X0Y0_N4BEG[1] _3177_/A VPWR VGND sg13cmos5l_buf_1
XFILLER_710_14 VPWR VGND sg13cmos5l_decap_8
XANTENNA__3521__X Tile_X0Y1_E1BEG[3] VPWR VGND sg13cmos5l_antennanp
X_0389_ _0389_/Q Tile_X0Y7_FrameData[26] VGND VPWR Tile_X0Y9_FrameStrobe[7] latch
XFILLER_66_272 VPWR VGND sg13cmos5l_fill_1
XFILLER_26_114 VPWR VGND sg13cmos5l_decap_8
X_2128_ _2128_/Q Tile_X0Y4_FrameData[21] VGND VPWR Tile_X0Y9_FrameStrobe[6] latch
XFILLER_604_242 VPWR VGND sg13cmos5l_fill_2
XFILLER_430_112 VPWR VGND sg13cmos5l_decap_8
XFILLER_576_105 VPWR VGND sg13cmos5l_decap_8
XFILLER_569_42 VPWR VGND sg13cmos5l_decap_8
X_2059_ _2059_/Q Tile_X0Y4_FrameData[26] VGND VPWR Tile_X0Y9_FrameStrobe[4] latch
XFILLER_288_43 VPWR VGND sg13cmos5l_decap_8
XFILLER_430_189 VPWR VGND sg13cmos5l_decap_8
XFILLER_368_252 VPWR VGND sg13cmos5l_decap_8
XFILLER_591_119 VPWR VGND sg13cmos5l_decap_8
XFILLER_517_205 VPWR VGND sg13cmos5l_decap_4
XFILLER_438_35 VPWR VGND sg13cmos5l_decap_8
XFILLER_41_14 VPWR VGND sg13cmos5l_fill_2
XFILLER_584_193 VPWR VGND sg13cmos5l_decap_8
XFILLER_517_238 VPWR VGND sg13cmos5l_fill_2
XFILLER_517_249 VPWR VGND sg13cmos5l_fill_1
XFILLER_328_149 VPWR VGND sg13cmos5l_fill_1
XFILLER_585_63 VPWR VGND sg13cmos5l_decap_8
XFILLER_157_14 VPWR VGND sg13cmos5l_decap_8
XFILLER_194_177 VPWR VGND sg13cmos5l_decap_8
XFILLER_157_36 VPWR VGND sg13cmos5l_decap_8
XFILLER_210_7 VPWR VGND sg13cmos5l_decap_8
XFILLER_336_160 VPWR VGND sg13cmos5l_decap_8
XFILLER_135_211 VPWR VGND sg13cmos5l_decap_8
XFILLER_157_58 VPWR VGND sg13cmos5l_decap_8
XFILLER_308_7 VPWR VGND sg13cmos5l_decap_8
XFILLER_497_112 VPWR VGND sg13cmos5l_decap_8
XFILLER_686_212 VPWR VGND sg13cmos5l_decap_8
XFILLER_307_28 VPWR VGND sg13cmos5l_decap_8
XFILLER_454_56 VPWR VGND sg13cmos5l_decap_4
XFILLER_500_105 VPWR VGND sg13cmos5l_decap_8
XFILLER_173_35 VPWR VGND sg13cmos5l_decap_8
XFILLER_351_196 VPWR VGND sg13cmos5l_decap_8
XFILLER_497_189 VPWR VGND sg13cmos5l_decap_8
XFILLER_639_161 VPWR VGND sg13cmos5l_decap_8
XFILLER_1_268 VPWR VGND sg13cmos5l_decap_4
XFILLER_677_7 VPWR VGND sg13cmos5l_decap_8
XFILLER_49_217 VPWR VGND sg13cmos5l_fill_1
XFILLER_654_142 VPWR VGND sg13cmos5l_decap_8
XFILLER_49_239 VPWR VGND sg13cmos5l_decap_8
XFILLER_620_14 VPWR VGND sg13cmos5l_decap_8
XFILLER_264_148 VPWR VGND sg13cmos5l_decap_8
XFILLER_66_77 VPWR VGND sg13cmos5l_decap_8
XFILLER_406_120 VPWR VGND sg13cmos5l_decap_8
XANTENNA__3431__X Tile_X0Y4_FrameData_O[22] VPWR VGND sg13cmos5l_antennanp
XFILLER_453_259 VPWR VGND sg13cmos5l_fill_1
XFILLER_406_131 VPWR VGND sg13cmos5l_fill_1
XFILLER_403_71 VPWR VGND sg13cmos5l_fill_1
XFILLER_72_220 VPWR VGND sg13cmos5l_decap_8
XFILLER_406_153 VPWR VGND sg13cmos5l_decap_4
XFILLER_403_93 VPWR VGND sg13cmos5l_decap_8
XFILLER_406_186 VPWR VGND sg13cmos5l_decap_8
XFILLER_272_181 VPWR VGND sg13cmos5l_decap_8
XFILLER_167_0 VPWR VGND sg13cmos5l_decap_8
XFILLER_82_21 VPWR VGND sg13cmos5l_decap_8
XFILLER_567_105 VPWR VGND sg13cmos5l_decap_8
XFILLER_479_42 VPWR VGND sg13cmos5l_decap_8
XFILLER_421_112 VPWR VGND sg13cmos5l_decap_8
XFILLER_122_83 VPWR VGND sg13cmos5l_decap_8
XFILLER_17_169 VPWR VGND sg13cmos5l_decap_8
XFILLER_198_21 VPWR VGND sg13cmos5l_decap_8
XFILLER_82_54 VPWR VGND sg13cmos5l_decap_8
XFILLER_700_91 VPWR VGND sg13cmos5l_decap_8
XFILLER_32_128 VPWR VGND sg13cmos5l_fill_2
XFILLER_25_180 VPWR VGND sg13cmos5l_decap_8
XFILLER_421_189 VPWR VGND sg13cmos5l_decap_8
XFILLER_334_0 VPWR VGND sg13cmos5l_decap_8
XFILLER_709_154 VPWR VGND sg13cmos5l_decap_8
XFILLER_629_56 VPWR VGND sg13cmos5l_decap_8
XFILLER_319_105 VPWR VGND sg13cmos5l_fill_1
XFILLER_15_81 VPWR VGND sg13cmos5l_decap_8
XFILLER_575_182 VPWR VGND sg13cmos5l_decap_8
XFILLER_348_35 VPWR VGND sg13cmos5l_decap_8
XFILLER_185_155 VPWR VGND sg13cmos5l_decap_4
XFILLER_495_63 VPWR VGND sg13cmos5l_decap_8
XFILLER_590_141 VPWR VGND sg13cmos5l_fill_2
XFILLER_374_255 VPWR VGND sg13cmos5l_decap_8
XFILLER_501_0 VPWR VGND sg13cmos5l_decap_8
XFILLER_327_182 VPWR VGND sg13cmos5l_fill_1
XFILLER_488_112 VPWR VGND sg13cmos5l_decap_8
XFILLER_645_77 VPWR VGND sg13cmos5l_decap_8
XFILLER_217_28 VPWR VGND sg13cmos5l_decap_8
XFILLER_677_223 VPWR VGND sg13cmos5l_decap_8
XANTENNA__3606__X Tile_X0Y9_S2BEG[0] VPWR VGND sg13cmos5l_antennanp
XFILLER_342_163 VPWR VGND sg13cmos5l_decap_8
XFILLER_141_214 VPWR VGND sg13cmos5l_decap_4
XFILLER_99_128 VPWR VGND sg13cmos5l_decap_8
XFILLER_364_56 VPWR VGND sg13cmos5l_decap_8
X_1430_ _1430_/Q Tile_X0Y2_FrameData[27] VGND VPWR Tile_X0Y9_FrameStrobe[0] latch
XFILLER_661_21 VPWR VGND sg13cmos5l_decap_8
XFILLER_141_269 VPWR VGND sg13cmos5l_decap_4
XFILLER_692_226 VPWR VGND sg13cmos5l_decap_8
X_1361_ _1361_/Q Tile_X0Y1_FrameData[8] VGND VPWR Tile_X0Y9_FrameStrobe[5] latch
XFILLER_429_245 VPWR VGND sg13cmos5l_decap_8
X_3100_ Tile_X0Y7_E2BEGb[6] _4626_/X VPWR VGND sg13cmos5l_buf_1
X_0312_ _0312_/Q Tile_X0Y7_FrameData[7] VGND VPWR Tile_X0Y9_FrameStrobe[4] latch
X_4080_ _4080_/X AXI_M_SOC_AWREADY _4119_/X _4123_/X _4102_/X _1513_/Q _1512_/Q VPWR
+ VGND sg13cmos5l_mux4_1
X_1292_ _1292_/Q Tile_X0Y1_FrameData[13] VGND VPWR Tile_X0Y9_FrameStrobe[3] latch
XFILLER_444_204 VPWR VGND sg13cmos5l_decap_8
XFILLER_645_175 VPWR VGND sg13cmos5l_decap_8
X_3031_ Tile_X0Y5_EE4BEG[6] _4394_/X VPWR VGND sg13cmos5l_buf_1
XFILLER_660_112 VPWR VGND sg13cmos5l_decap_4
XFILLER_255_137 VPWR VGND sg13cmos5l_decap_4
X_0243_ _0243_/Q Tile_X0Y7_FrameData[12] VGND VPWR Tile_X0Y9_FrameStrobe[2] latch
XFILLER_530_14 VPWR VGND sg13cmos5l_decap_8
XANTENNA__3341__X Tile_X0Y2_FrameData_O[12] VPWR VGND sg13cmos5l_antennanp
XFILLER_660_134 VPWR VGND sg13cmos5l_fill_2
XFILLER_444_259 VPWR VGND sg13cmos5l_fill_1
X_0174_ _0174_/Q Tile_X0Y7_FrameData[17] VGND VPWR Tile_X0Y9_FrameStrobe[0] latch
XFILLER_598_241 VPWR VGND sg13cmos5l_decap_8
XFILLER_263_181 VPWR VGND sg13cmos5l_decap_8
XFILLER_412_123 VPWR VGND sg13cmos5l_decap_8
XFILLER_389_42 VPWR VGND sg13cmos5l_decap_8
XFILLER_601_223 VPWR VGND sg13cmos5l_decap_8
XFILLER_601_245 VPWR VGND sg13cmos5l_fill_2
XFILLER_558_138 VPWR VGND sg13cmos5l_decap_8
X_3933_ _3933_/X Tile_X0Y1_W2MID[6] AXI_M_SOC_ARREADY _3991_/X _3990_/X _1343_/Q _1342_/Q
+ VPWR VGND sg13cmos5l_mux4_1
XFILLER_601_267 VPWR VGND sg13cmos5l_decap_4
XFILLER_211_229 VPWR VGND sg13cmos5l_decap_8
XFILLER_539_56 VPWR VGND sg13cmos5l_decap_8
XFILLER_573_119 VPWR VGND sg13cmos5l_decap_8
XFILLER_686_73 VPWR VGND sg13cmos5l_decap_8
X_3864_ _3864_/X _3851_/X _0078_/X Tile_X0Y0_S1END[3] Tile_X0Y0_S4END[3] _0973_/Q
+ _0972_/Q VPWR VGND sg13cmos5l_mux4_1
XFILLER_539_78 VPWR VGND sg13cmos5l_decap_8
XFILLER_82_0 VPWR VGND sg13cmos5l_decap_8
XFILLER_566_182 VPWR VGND sg13cmos5l_decap_8
XFILLER_258_35 VPWR VGND sg13cmos5l_decap_8
X_2815_ Tile_X0Y3_E2BEG[5] _4153_/X VPWR VGND sg13cmos5l_buf_1
XFILLER_31_194 VPWR VGND sg13cmos5l_decap_8
X_3795_ _3795_/X _3886_/X _3872_/X _3871_/X _3855_/X _1150_/Q _1149_/Q VPWR VGND sg13cmos5l_mux4_1
XFILLER_380_203 VPWR VGND sg13cmos5l_decap_8
XFILLER_117_200 VPWR VGND sg13cmos5l_decap_8
XFILLER_715_168 VPWR VGND sg13cmos5l_decap_8
XFILLER_176_199 VPWR VGND sg13cmos5l_decap_8
XFILLER_191_125 VPWR VGND sg13cmos5l_decap_8
XFILLER_318_160 VPWR VGND sg13cmos5l_fill_1
XFILLER_507_260 VPWR VGND sg13cmos5l_fill_2
XFILLER_380_225 VPWR VGND sg13cmos5l_decap_4
X_2746_ Tile_X0Y3_FrameData_O[4] Tile_X0Y3_FrameData[4] VPWR VGND sg13cmos5l_buf_1
XFILLER_555_44 VPWR VGND sg13cmos5l_decap_8
XFILLER_318_182 VPWR VGND sg13cmos5l_decap_8
XFILLER_11_28 VPWR VGND sg13cmos5l_decap_8
XFILLER_408_49 VPWR VGND sg13cmos5l_decap_8
XFILLER_338_90 VPWR VGND sg13cmos5l_fill_1
XFILLER_127_28 VPWR VGND sg13cmos5l_decap_8
XFILLER_380_269 VPWR VGND sg13cmos5l_decap_4
XFILLER_705_14 VPWR VGND sg13cmos5l_decap_8
XFILLER_555_88 VPWR VGND sg13cmos5l_decap_8
XFILLER_479_134 VPWR VGND sg13cmos5l_decap_8
X_2677_ _2677_/Q Tile_X0Y6_FrameData[18] VGND VPWR Tile_X0Y9_FrameStrobe[7] latch
XFILLER_555_99 VPWR VGND sg13cmos5l_fill_1
XANTENNA__3516__X Tile_X0Y1_E2BEG[6] VPWR VGND sg13cmos5l_antennanp
XFILLER_274_56 VPWR VGND sg13cmos5l_decap_8
X_4416_ _4416_/X _4418_/X Tile_X0Y5_W6END[0] _4417_/X _4416_/A3 _2189_/Q _2188_/Q
+ VPWR VGND sg13cmos5l_mux4_1
X_1628_ _1628_/Q Tile_X0Y2_FrameData[21] VGND VPWR Tile_X0Y9_FrameStrobe[6] latch
XFILLER_333_196 VPWR VGND sg13cmos5l_decap_8
XFILLER_571_21 VPWR VGND sg13cmos5l_decap_8
XFILLER_494_126 VPWR VGND sg13cmos5l_decap_8
X_4347_ _4347_/X _4311_/X _0040_/X _4310_/X _0109_/X _1959_/Q _1958_/Q VPWR VGND sg13cmos5l_mux4_1
XFILLER_98_161 VPWR VGND sg13cmos5l_decap_8
X_1559_ _1559_/Q Tile_X0Y2_FrameData[26] VGND VPWR Tile_X0Y9_FrameStrobe[4] latch
XFILLER_683_248 VPWR VGND sg13cmos5l_decap_8
XFILLER_290_22 VPWR VGND sg13cmos5l_decap_8
XFILLER_98_183 VPWR VGND sg13cmos5l_decap_8
XFILLER_143_49 VPWR VGND sg13cmos5l_decap_8
XFILLER_571_98 VPWR VGND sg13cmos5l_decap_8
XFILLER_246_104 VPWR VGND sg13cmos5l_decap_4
X_4278_ _4278_/X Tile_X0Y4_WW4END[9] AXI_M_SOC_BRESP0 _4345_/X _4315_/X _2057_/Q _2056_/Q
+ VPWR VGND sg13cmos5l_mux4_1
XFILLER_504_70 VPWR VGND sg13cmos5l_decap_8
XFILLER_100_155 VPWR VGND sg13cmos5l_decap_8
XFILLER_651_112 VPWR VGND sg13cmos5l_decap_8
X_3229_ Tile_X0Y0_FrameStrobe_O[17] Tile_X0Y9_FrameStrobe[17] VPWR VGND sg13cmos5l_buf_1
XFILLER_636_197 VPWR VGND sg13cmos5l_decap_8
XFILLER_440_14 VPWR VGND sg13cmos5l_decap_8
XFILLER_435_248 VPWR VGND sg13cmos5l_fill_1
XANTENNA__3251__X Tile_X0Y0_FrameData_O[19] VPWR VGND sg13cmos5l_antennanp
XFILLER_290_99 VPWR VGND sg13cmos5l_decap_8
XFILLER_36_14 VPWR VGND sg13cmos5l_decap_8
XFILLER_54_231 VPWR VGND sg13cmos5l_decap_8
XFILLER_651_189 VPWR VGND sg13cmos5l_decap_8
XFILLER_36_58 VPWR VGND sg13cmos5l_decap_8
XFILLER_254_181 VPWR VGND sg13cmos5l_decap_8
XFILLER_299_42 VPWR VGND sg13cmos5l_decap_8
XFILLER_254_192 VPWR VGND sg13cmos5l_fill_1
XFILLER_160_7 VPWR VGND sg13cmos5l_decap_8
XFILLER_258_7 VPWR VGND sg13cmos5l_decap_8
XFILLER_520_80 VPWR VGND sg13cmos5l_decap_8
XFILLER_202_229 VPWR VGND sg13cmos5l_decap_8
XFILLER_564_119 VPWR VGND sg13cmos5l_decap_8
XFILLER_449_56 VPWR VGND sg13cmos5l_decap_8
XFILLER_425_7 VPWR VGND sg13cmos5l_decap_8
XFILLER_167_133 VPWR VGND sg13cmos5l_decap_8
XFILLER_596_84 VPWR VGND sg13cmos5l_decap_8
XFILLER_52_68 VPWR VGND sg13cmos5l_decap_4
XFILLER_596_95 VPWR VGND sg13cmos5l_fill_1
XFILLER_557_193 VPWR VGND sg13cmos5l_fill_1
XFILLER_52_79 VPWR VGND sg13cmos5l_decap_8
XFILLER_182_114 VPWR VGND sg13cmos5l_fill_1
XFILLER_108_200 VPWR VGND sg13cmos5l_fill_2
XFILLER_706_179 VPWR VGND sg13cmos5l_decap_8
XFILLER_572_196 VPWR VGND sg13cmos5l_decap_8
XFILLER_615_14 VPWR VGND sg13cmos5l_decap_8
XFILLER_465_88 VPWR VGND sg13cmos5l_decap_8
XANTENNA__3426__X Tile_X0Y4_FrameData_O[17] VPWR VGND sg13cmos5l_antennanp
XFILLER_190_180 VPWR VGND sg13cmos5l_decap_8
XFILLER_324_185 VPWR VGND sg13cmos5l_decap_8
XFILLER_481_21 VPWR VGND sg13cmos5l_decap_8
XFILLER_674_237 VPWR VGND sg13cmos5l_fill_2
XFILLER_89_161 VPWR VGND sg13cmos5l_decap_8
XFILLER_485_159 VPWR VGND sg13cmos5l_decap_8
XFILLER_481_76 VPWR VGND sg13cmos5l_fill_2
XFILLER_277_251 VPWR VGND sg13cmos5l_decap_8
XFILLER_77_65 VPWR VGND sg13cmos5l_decap_8
XFILLER_627_142 VPWR VGND sg13cmos5l_decap_4
XFILLER_631_35 VPWR VGND sg13cmos5l_decap_8
XFILLER_414_70 VPWR VGND sg13cmos5l_decap_8
XFILLER_284_0 VPWR VGND sg13cmos5l_decap_8
XFILLER_642_112 VPWR VGND sg13cmos5l_decap_8
XFILLER_350_14 VPWR VGND sg13cmos5l_decap_8
XANTENNA__3161__X Tile_X0Y7_FrameData_O[31] VPWR VGND sg13cmos5l_antennanp
XFILLER_252_118 VPWR VGND sg13cmos5l_fill_1
XFILLER_642_189 VPWR VGND sg13cmos5l_decap_8
XFILLER_451_0 VPWR VGND sg13cmos5l_decap_8
XFILLER_549_0 VPWR VGND sg13cmos5l_decap_8
XFILLER_500_28 VPWR VGND sg13cmos5l_decap_8
XANTENNA_230 Tile_X0Y0_FrameData[6] VPWR VGND sg13cmos5l_antennanp
XFILLER_430_91 VPWR VGND sg13cmos5l_decap_8
XFILLER_60_245 VPWR VGND sg13cmos5l_fill_1
XFILLER_26_91 VPWR VGND sg13cmos5l_fill_2
XFILLER_260_173 VPWR VGND sg13cmos5l_decap_8
XFILLER_716_0 VPWR VGND sg13cmos5l_decap_8
XFILLER_359_56 VPWR VGND sg13cmos5l_decap_8
X_0930_ _0930_/Q Tile_X0Y9_FrameData[21] VGND VPWR Tile_X0Y9_FrameStrobe[8] latch
XFILLER_347_222 VPWR VGND sg13cmos5l_decap_8
XFILLER_9_121 VPWR VGND sg13cmos5l_decap_8
XFILLER_656_21 VPWR VGND sg13cmos5l_decap_8
X_0861_ _0861_/Q Tile_X0Y9_FrameData[2] VGND VPWR Tile_X0Y9_FrameStrobe[5] latch
XFILLER_158_188 VPWR VGND sg13cmos5l_decap_8
XFILLER_173_114 VPWR VGND sg13cmos5l_decap_8
X_2600_ _2600_/Q Tile_X0Y6_FrameData[31] VGND VPWR Tile_X0Y9_FrameStrobe[5] latch
XFILLER_712_105 VPWR VGND sg13cmos5l_decap_8
X_0792_ _0792_/Q Tile_X0Y9_FrameData[7] VGND VPWR Tile_X0Y9_FrameStrobe[3] latch
X_3580_ Tile_X0Y9_FrameData_O[10] Tile_X0Y9_FrameData[10] VPWR VGND sg13cmos5l_buf_1
XFILLER_504_230 VPWR VGND sg13cmos5l_decap_8
X_2531_ _2531_/Q Tile_X0Y6_FrameData[4] VGND VPWR Tile_X0Y9_FrameStrobe[2] latch
XFILLER_315_141 VPWR VGND sg13cmos5l_decap_8
XFILLER_525_14 VPWR VGND sg13cmos5l_decap_8
XANTENNA__3336__X Tile_X0Y2_FrameData_O[7] VPWR VGND sg13cmos5l_antennanp
XFILLER_672_42 VPWR VGND sg13cmos5l_decap_4
XFILLER_330_100 VPWR VGND sg13cmos5l_fill_1
X_2462_ _2462_/Q Tile_X0Y6_FrameData[9] VGND VPWR Tile_X0Y9_FrameStrobe[0] latch
XFILLER_308_93 VPWR VGND sg13cmos5l_fill_1
XFILLER_672_75 VPWR VGND sg13cmos5l_decap_8
XFILLER_391_21 VPWR VGND sg13cmos5l_decap_8
XFILLER_665_215 VPWR VGND sg13cmos5l_fill_1
XFILLER_476_126 VPWR VGND sg13cmos5l_decap_8
X_4201_ _4201_/X _4197_/X Tile_X0Y3_W6END[1] _4196_/X _4201_/A3 _1679_/Q _1678_/Q
+ VPWR VGND sg13cmos5l_mux4_1
XFILLER_665_226 VPWR VGND sg13cmos5l_decap_8
X_1413_ _1413_/Q Tile_X0Y1_FrameData[20] VGND VPWR Tile_X0Y9_FrameStrobe[7] latch
X_2393_ _2393_/Q Tile_X0Y5_FrameData[12] VGND VPWR Tile_X0Y9_FrameStrobe[6] latch
X_1344_ _1344_/Q Tile_X0Y1_FrameData[25] VGND VPWR Tile_X0Y9_FrameStrobe[5] latch
X_4132_ _4132_/X Tile_X0Y1_W2MID[5] Tile_X0Y1_W2END[5] Tile_X0Y1_W6END[10] _3993_/X
+ _1377_/Q _1376_/Q VPWR VGND sg13cmos5l_mux4_1
XFILLER_391_98 VPWR VGND sg13cmos5l_decap_8
XFILLER_541_35 VPWR VGND sg13cmos5l_decap_8
XFILLER_283_210 VPWR VGND sg13cmos5l_decap_8
XFILLER_228_126 VPWR VGND sg13cmos5l_decap_8
XFILLER_3_84 VPWR VGND sg13cmos5l_decap_8
XFILLER_633_112 VPWR VGND sg13cmos5l_decap_8
XFILLER_484_181 VPWR VGND sg13cmos5l_decap_8
XFILLER_95_164 VPWR VGND sg13cmos5l_decap_8
XFILLER_260_14 VPWR VGND sg13cmos5l_decap_8
XFILLER_95_175 VPWR VGND sg13cmos5l_fill_2
X_1275_ _1275_/Q Tile_X0Y1_FrameData[30] VGND VPWR Tile_X0Y9_FrameStrobe[3] latch
X_4063_ _4063_/X Tile_X0Y2_WW4END[8] AXI_M_SOC_AWREADY _4124_/X _4097_/X _1547_/Q
+ _1546_/Q VPWR VGND sg13cmos5l_mux4_1
XFILLER_283_243 VPWR VGND sg13cmos5l_decap_8
XANTENNA__3071__X Tile_X0Y5_FrameData_O[30] VPWR VGND sg13cmos5l_antennanp
X_0226_ _0226_/Q Tile_X0Y7_FrameData[29] VGND VPWR Tile_X0Y9_FrameStrobe[2] latch
X_3014_ Tile_X0Y5_E6BEG[1] _4405_/X VPWR VGND sg13cmos5l_buf_1
XFILLER_236_181 VPWR VGND sg13cmos5l_decap_4
XFILLER_410_28 VPWR VGND sg13cmos5l_decap_8
XFILLER_397_100 VPWR VGND sg13cmos5l_decap_8
X_0157_ _0157_/X _4437_/X _4438_/X _0901_/Q VPWR VGND sg13cmos5l_mux2_1
XFILLER_586_244 VPWR VGND sg13cmos5l_fill_2
X_0088_ _0088_/X _4216_/X _4217_/X _0386_/Q VPWR VGND sg13cmos5l_mux2_1
XFILLER_251_184 VPWR VGND sg13cmos5l_decap_8
XFILLER_51_256 VPWR VGND sg13cmos5l_decap_8
XFILLER_397_177 VPWR VGND sg13cmos5l_decap_8
XFILLER_400_126 VPWR VGND sg13cmos5l_decap_8
XFILLER_269_56 VPWR VGND sg13cmos5l_decap_8
X_3916_ _3916_/X Tile_X0Y2_W1END[1] Tile_X0Y2_WW4END[1] Tile_X0Y2_W6END[9] _4117_/X
+ _1646_/Q _1645_/Q VPWR VGND sg13cmos5l_mux4_1
XFILLER_338_222 VPWR VGND sg13cmos5l_decap_8
X_4896_ _4896_/X Tile_X0Y8_W1END[0] Tile_X0Y8_W6END[8] _4812_/X _4772_/X _0635_/Q
+ _0634_/Q VPWR VGND sg13cmos5l_mux4_1
XFILLER_338_233 VPWR VGND sg13cmos5l_fill_1
XFILLER_149_144 VPWR VGND sg13cmos5l_decap_8
XFILLER_566_21 VPWR VGND sg13cmos5l_decap_8
XFILLER_149_155 VPWR VGND sg13cmos5l_fill_2
XFILLER_338_255 VPWR VGND sg13cmos5l_decap_8
X_3847_ _3847_/X Tile_X0Y0_W2MID[7] _3881_/X _3885_/X _3852_/X _1011_/Q _1010_/Q VPWR
+ VGND sg13cmos5l_mux4_1
XFILLER_353_203 VPWR VGND sg13cmos5l_decap_8
XFILLER_22_49 VPWR VGND sg13cmos5l_decap_8
XFILLER_149_199 VPWR VGND sg13cmos5l_decap_8
XFILLER_703_105 VPWR VGND sg13cmos5l_decap_8
XFILLER_566_98 VPWR VGND sg13cmos5l_decap_8
XFILLER_554_185 VPWR VGND sg13cmos5l_decap_8
XFILLER_138_49 VPWR VGND sg13cmos5l_decap_8
X_3778_ AXI_M_SOC_ARVALID Tile_X0Y1_WW4END[0] Tile_X0Y1_WW4END[8] Tile_X0Y1_W6END[0]
+ _4008_/X _1257_/Q _1256_/Q VPWR VGND sg13cmos5l_mux4_1
XFILLER_285_77 VPWR VGND sg13cmos5l_decap_8
X_2729_ _3861_/A3 VPWR VGND sg13cmos5l_tielo
XFILLER_435_14 VPWR VGND sg13cmos5l_decap_8
XANTENNA__3246__X Tile_X0Y0_FrameData_O[14] VPWR VGND sg13cmos5l_antennanp
XFILLER_582_42 VPWR VGND sg13cmos5l_decap_8
XFILLER_172_180 VPWR VGND sg13cmos5l_fill_1
XFILLER_711_182 VPWR VGND sg13cmos5l_fill_2
XFILLER_321_133 VPWR VGND sg13cmos5l_decap_8
XFILLER_120_217 VPWR VGND sg13cmos5l_decap_4
XFILLER_120_228 VPWR VGND sg13cmos5l_decap_8
XFILLER_515_91 VPWR VGND sg13cmos5l_decap_8
XFILLER_259_262 VPWR VGND sg13cmos5l_decap_8
XFILLER_219_104 VPWR VGND sg13cmos5l_decap_8
XFILLER_451_35 VPWR VGND sg13cmos5l_decap_8
XFILLER_234_81 VPWR VGND sg13cmos5l_decap_8
XFILLER_475_192 VPWR VGND sg13cmos5l_decap_8
XFILLER_170_14 VPWR VGND sg13cmos5l_decap_8
XFILLER_219_148 VPWR VGND sg13cmos5l_decap_8
XFILLER_86_175 VPWR VGND sg13cmos5l_decap_8
XFILLER_375_7 VPWR VGND sg13cmos5l_decap_8
XFILLER_274_254 VPWR VGND sg13cmos5l_decap_8
XFILLER_490_140 VPWR VGND sg13cmos5l_decap_8
XFILLER_423_218 VPWR VGND sg13cmos5l_decap_8
XFILLER_601_49 VPWR VGND sg13cmos5l_decap_8
XFILLER_423_229 VPWR VGND sg13cmos5l_fill_2
XFILLER_27_231 VPWR VGND sg13cmos5l_decap_8
XFILLER_103_63 VPWR VGND sg13cmos5l_decap_8
XFILLER_542_7 VPWR VGND sg13cmos5l_decap_8
XFILLER_63_56 VPWR VGND sg13cmos5l_decap_8
XFILLER_577_255 VPWR VGND sg13cmos5l_decap_8
XFILLER_431_262 VPWR VGND sg13cmos5l_fill_1
XFILLER_388_166 VPWR VGND sg13cmos5l_decap_8
XFILLER_577_266 VPWR VGND sg13cmos5l_decap_8
XFILLER_42_256 VPWR VGND sg13cmos5l_fill_2
XFILLER_388_177 VPWR VGND sg13cmos5l_fill_1
XFILLER_537_119 VPWR VGND sg13cmos5l_decap_8
XFILLER_388_199 VPWR VGND sg13cmos5l_decap_8
XFILLER_329_211 VPWR VGND sg13cmos5l_decap_8
XFILLER_476_21 VPWR VGND sg13cmos5l_decap_8
XFILLER_329_15 VPWR VGND sg13cmos5l_decap_8
XFILLER_592_269 VPWR VGND sg13cmos5l_decap_4
XFILLER_476_98 VPWR VGND sg13cmos5l_decap_8
XFILLER_155_147 VPWR VGND sg13cmos5l_fill_2
XFILLER_626_35 VPWR VGND sg13cmos5l_decap_8
XFILLER_560_133 VPWR VGND sg13cmos5l_decap_8
XFILLER_409_70 VPWR VGND sg13cmos5l_decap_8
XFILLER_344_258 VPWR VGND sg13cmos5l_decap_4
XFILLER_6_168 VPWR VGND sg13cmos5l_decap_8
XFILLER_345_14 VPWR VGND sg13cmos5l_decap_8
XFILLER_195_99 VPWR VGND sg13cmos5l_decap_8
XANTENNA__3156__X Tile_X0Y7_FrameData_O[26] VPWR VGND sg13cmos5l_antennanp
XFILLER_170_139 VPWR VGND sg13cmos5l_decap_8
XFILLER_492_42 VPWR VGND sg13cmos5l_decap_8
XFILLER_312_100 VPWR VGND sg13cmos5l_decap_8
XFILLER_560_188 VPWR VGND sg13cmos5l_fill_1
XFILLER_702_160 VPWR VGND sg13cmos5l_decap_4
XANTENNA__2995__X Tile_X0Y5_E1BEG[2] VPWR VGND sg13cmos5l_antennanp
XFILLER_111_206 VPWR VGND sg13cmos5l_fill_1
XFILLER_499_0 VPWR VGND sg13cmos5l_decap_8
XFILLER_501_266 VPWR VGND sg13cmos5l_decap_8
XFILLER_111_228 VPWR VGND sg13cmos5l_decap_8
XFILLER_647_259 VPWR VGND sg13cmos5l_decap_8
XFILLER_642_56 VPWR VGND sg13cmos5l_decap_8
XFILLER_425_91 VPWR VGND sg13cmos5l_decap_8
XFILLER_144_70 VPWR VGND sg13cmos5l_decap_8
XFILLER_662_229 VPWR VGND sg13cmos5l_decap_8
XFILLER_473_129 VPWR VGND sg13cmos5l_decap_8
XFILLER_361_35 VPWR VGND sg13cmos5l_decap_8
XFILLER_666_0 VPWR VGND sg13cmos5l_decap_8
XFILLER_19_7 VPWR VGND sg13cmos5l_decap_8
XFILLER_77_186 VPWR VGND sg13cmos5l_decap_8
XFILLER_92_134 VPWR VGND sg13cmos5l_decap_8
X_1060_ _1060_/Q Tile_X0Y0_FrameData[7] VGND VPWR Tile_X0Y9_FrameStrobe[3] latch
XFILLER_511_49 VPWR VGND sg13cmos5l_decap_8
XFILLER_441_90 VPWR VGND sg13cmos5l_decap_4
XFILLER_414_229 VPWR VGND sg13cmos5l_decap_8
XFILLER_280_235 VPWR VGND sg13cmos5l_fill_2
XFILLER_230_28 VPWR VGND sg13cmos5l_decap_8
XFILLER_230_39 VPWR VGND sg13cmos5l_fill_2
XFILLER_630_148 VPWR VGND sg13cmos5l_decap_8
XFILLER_280_268 VPWR VGND sg13cmos5l_decap_4
XFILLER_160_91 VPWR VGND sg13cmos5l_decap_8
XFILLER_233_162 VPWR VGND sg13cmos5l_decap_8
XFILLER_33_256 VPWR VGND sg13cmos5l_decap_4
XFILLER_33_267 VPWR VGND sg13cmos5l_decap_4
XFILLER_667_42 VPWR VGND sg13cmos5l_decap_8
X_4750_ _4750_/X Tile_X0Y8_WW4END[9] AXI_M_SOC_RDATA14 _4809_/X _4787_/X _0547_/Q
+ _0546_/Q VPWR VGND sg13cmos5l_mux4_1
X_1962_ _1962_/Q Tile_X0Y4_FrameData[27] VGND VPWR Tile_X0Y9_FrameStrobe[1] latch
XFILLER_583_236 VPWR VGND sg13cmos5l_decap_8
XFILLER_386_21 VPWR VGND sg13cmos5l_decap_8
X_3701_ AXI_M_SOC_WDATA11 Tile_X0Y7_WW4END[3] Tile_X0Y7_WW4END[11] Tile_X0Y7_W6END[11]
+ _4695_/X _0225_/Q _0224_/Q VPWR VGND sg13cmos5l_mux4_1
X_0913_ _0913_/Q Tile_X0Y9_FrameData[14] VGND VPWR Tile_X0Y9_FrameStrobe[7] latch
XFILLER_536_141 VPWR VGND sg13cmos5l_decap_8
X_4681_ _4681_/X _4228_/X _4232_/X _4215_/X _4206_/X _1859_/Q _1858_/Q VPWR VGND sg13cmos5l_mux4_1
XFILLER_186_272 VPWR VGND sg13cmos5l_fill_1
X_1893_ _1893_/Q Tile_X0Y3_FrameData[4] VGND VPWR Tile_X0Y9_FrameStrobe[6] latch
XFILLER_239_59 VPWR VGND sg13cmos5l_fill_1
X_3632_ Tile_X0Y9_S4BEG[10] _3632_/A VPWR VGND sg13cmos5l_buf_1
X_0844_ _0844_/Q Tile_X0Y9_FrameData[19] VGND VPWR Tile_X0Y9_FrameStrobe[5] latch
XFILLER_536_35 VPWR VGND sg13cmos5l_decap_8
XFILLER_161_117 VPWR VGND sg13cmos5l_decap_8
X_3563_ Tile_X0Y9_EE4BEG[9] _4873_/X VPWR VGND sg13cmos5l_buf_1
XANTENNA__3066__X Tile_X0Y5_FrameData_O[25] VPWR VGND sg13cmos5l_antennanp
X_0775_ _0775_/Q Tile_X0Y9_FrameData[24] VGND VPWR Tile_X0Y9_FrameStrobe[3] latch
XFILLER_255_36 VPWR VGND sg13cmos5l_decap_8
XFILLER_489_251 VPWR VGND sg13cmos5l_decap_4
X_2514_ _2514_/Q Tile_X0Y6_FrameData[21] VGND VPWR Tile_X0Y9_FrameStrobe[2] latch
XFILLER_303_122 VPWR VGND sg13cmos5l_decap_8
X_3494_ Tile_X0Y1_E6BEG[4] _3968_/X VPWR VGND sg13cmos5l_buf_1
XFILLER_45_0 VPWR VGND sg13cmos5l_fill_2
XFILLER_638_226 VPWR VGND sg13cmos5l_fill_2
X_2445_ _2445_/Q Tile_X0Y6_FrameData[26] VGND VPWR Tile_X0Y9_FrameStrobe[0] latch
XFILLER_405_28 VPWR VGND sg13cmos5l_decap_8
XFILLER_449_159 VPWR VGND sg13cmos5l_decap_8
XFILLER_552_56 VPWR VGND sg13cmos5l_decap_8
X_2376_ _2376_/Q Tile_X0Y5_FrameData[29] VGND VPWR Tile_X0Y9_FrameStrobe[6] latch
XFILLER_552_89 VPWR VGND sg13cmos5l_decap_8
XFILLER_271_35 VPWR VGND sg13cmos5l_decap_8
XFILLER_457_170 VPWR VGND sg13cmos5l_decap_8
XFILLER_256_232 VPWR VGND sg13cmos5l_decap_8
X_4115_ _4115_/X _4575_/X _4579_/X _4583_/X _4559_/X _2662_/Q _2661_/Q VPWR VGND sg13cmos5l_mux4_1
XFILLER_606_123 VPWR VGND sg13cmos5l_decap_8
XFILLER_83_101 VPWR VGND sg13cmos5l_decap_8
X_1327_ _1327_/Q Tile_X0Y1_FrameData[10] VGND VPWR Tile_X0Y9_FrameStrobe[4] latch
XFILLER_68_175 VPWR VGND sg13cmos5l_decap_8
XFILLER_110_272 VPWR VGND sg13cmos5l_fill_1
XFILLER_83_112 VPWR VGND sg13cmos5l_fill_2
X_1258_ _1258_/Q Tile_X0Y1_FrameData[15] VGND VPWR Tile_X0Y9_FrameStrobe[2] latch
X_4046_ _4046_/X Tile_X0Y2_W2MID[1] AXI_M_SOC_AWREADY _4099_/X _4098_/X _1581_/Q _1580_/Q
+ VPWR VGND sg13cmos5l_mux4_1
XFILLER_204_84 VPWR VGND sg13cmos5l_decap_4
XFILLER_209_170 VPWR VGND sg13cmos5l_decap_8
XFILLER_83_156 VPWR VGND sg13cmos5l_decap_4
XFILLER_421_49 VPWR VGND sg13cmos5l_decap_8
XFILLER_405_229 VPWR VGND sg13cmos5l_decap_8
XFILLER_17_49 VPWR VGND sg13cmos5l_decap_8
XFILLER_140_28 VPWR VGND sg13cmos5l_decap_8
XFILLER_83_189 VPWR VGND sg13cmos5l_fill_2
X_0209_ _0209_/Q Tile_X0Y7_FrameData[14] VGND VPWR Tile_X0Y9_FrameStrobe[1] latch
X_1189_ _1189_/Q Tile_X0Y1_FrameData[20] VGND VPWR Tile_X0Y9_FrameStrobe[0] latch
XFILLER_413_251 VPWR VGND sg13cmos5l_decap_8
XFILLER_169_217 VPWR VGND sg13cmos5l_decap_8
XFILLER_574_203 VPWR VGND sg13cmos5l_decap_8
XFILLER_577_42 VPWR VGND sg13cmos5l_decap_8
XFILLER_385_158 VPWR VGND sg13cmos5l_fill_2
XFILLER_296_21 VPWR VGND sg13cmos5l_decap_8
XFILLER_177_272 VPWR VGND sg13cmos5l_fill_1
X_4879_ _4879_/X Tile_X0Y9_WW4END[0] AXI_M_SOC_RDATA0 _4916_/X _4901_/X _0785_/Q _0784_/Q
+ VPWR VGND sg13cmos5l_mux4_1
XFILLER_326_214 VPWR VGND sg13cmos5l_decap_8
XFILLER_123_7 VPWR VGND sg13cmos5l_decap_8
XFILLER_137_147 VPWR VGND sg13cmos5l_decap_8
XFILLER_192_242 VPWR VGND sg13cmos5l_decap_8
XFILLER_229_70 VPWR VGND sg13cmos5l_decap_8
XFILLER_542_133 VPWR VGND sg13cmos5l_decap_8
XFILLER_688_126 VPWR VGND sg13cmos5l_fill_1
XFILLER_688_137 VPWR VGND sg13cmos5l_fill_2
XFILLER_593_63 VPWR VGND sg13cmos5l_fill_1
XFILLER_446_57 VPWR VGND sg13cmos5l_decap_8
XFILLER_326_269 VPWR VGND sg13cmos5l_decap_4
XFILLER_165_14 VPWR VGND sg13cmos5l_decap_8
XFILLER_3_105 VPWR VGND sg13cmos5l_decap_8
XFILLER_593_85 VPWR VGND sg13cmos5l_decap_8
XFILLER_152_139 VPWR VGND sg13cmos5l_decap_8
XFILLER_629_204 VPWR VGND sg13cmos5l_decap_8
XFILLER_160_161 VPWR VGND sg13cmos5l_decap_4
XFILLER_492_7 VPWR VGND sg13cmos5l_decap_8
XFILLER_315_28 VPWR VGND sg13cmos5l_decap_8
XFILLER_160_172 VPWR VGND sg13cmos5l_decap_8
XANTENNA__3704__X AXI_M_SOC_WDATA14 VPWR VGND sg13cmos5l_antennanp
XFILLER_462_56 VPWR VGND sg13cmos5l_decap_8
XFILLER_160_194 VPWR VGND sg13cmos5l_fill_1
XFILLER_455_118 VPWR VGND sg13cmos5l_decap_8
XFILLER_181_35 VPWR VGND sg13cmos5l_decap_8
XFILLER_59_131 VPWR VGND sg13cmos5l_decap_8
XFILLER_58_67 VPWR VGND sg13cmos5l_decap_8
XFILLER_247_232 VPWR VGND sg13cmos5l_decap_8
XFILLER_59_186 VPWR VGND sg13cmos5l_decap_8
XFILLER_463_151 VPWR VGND sg13cmos5l_decap_8
XFILLER_74_134 VPWR VGND sg13cmos5l_decap_8
XFILLER_262_202 VPWR VGND sg13cmos5l_decap_8
XFILLER_262_224 VPWR VGND sg13cmos5l_decap_8
XFILLER_463_184 VPWR VGND sg13cmos5l_decap_8
XFILLER_15_234 VPWR VGND sg13cmos5l_decap_8
XFILLER_74_99 VPWR VGND sg13cmos5l_decap_8
XFILLER_90_21 VPWR VGND sg13cmos5l_decap_8
XFILLER_487_42 VPWR VGND sg13cmos5l_decap_8
XFILLER_247_0 VPWR VGND sg13cmos5l_decap_8
XFILLER_230_143 VPWR VGND sg13cmos5l_decap_8
XFILLER_565_225 VPWR VGND sg13cmos5l_decap_8
XFILLER_376_136 VPWR VGND sg13cmos5l_decap_8
XFILLER_376_147 VPWR VGND sg13cmos5l_fill_2
XFILLER_168_261 VPWR VGND sg13cmos5l_fill_1
XFILLER_168_272 VPWR VGND sg13cmos5l_fill_1
XFILLER_414_0 VPWR VGND sg13cmos5l_decap_8
XFILLER_637_56 VPWR VGND sg13cmos5l_decap_8
XFILLER_128_158 VPWR VGND sg13cmos5l_fill_2
XFILLER_139_70 VPWR VGND sg13cmos5l_decap_8
XFILLER_356_35 VPWR VGND sg13cmos5l_decap_8
XFILLER_183_264 VPWR VGND sg13cmos5l_decap_8
XFILLER_533_144 VPWR VGND sg13cmos5l_decap_8
XFILLER_317_269 VPWR VGND sg13cmos5l_decap_4
XFILLER_99_63 VPWR VGND sg13cmos5l_decap_8
X_0560_ _0560_/Q Tile_X0Y8_FrameData[15] VGND VPWR Tile_X0Y9_FrameStrobe[4] latch
XFILLER_506_49 VPWR VGND sg13cmos5l_decap_8
XFILLER_687_170 VPWR VGND sg13cmos5l_decap_8
XFILLER_687_181 VPWR VGND sg13cmos5l_fill_2
XFILLER_225_28 VPWR VGND sg13cmos5l_decap_8
XFILLER_653_77 VPWR VGND sg13cmos5l_decap_8
X_0491_ _0491_/Q Tile_X0Y8_FrameData[20] VGND VPWR Tile_X0Y9_FrameStrobe[2] latch
XFILLER_340_261 VPWR VGND sg13cmos5l_decap_8
XFILLER_340_272 VPWR VGND sg13cmos5l_fill_1
XANTENNA__3614__X Tile_X0Y9_S2BEGb[0] VPWR VGND sg13cmos5l_antennanp
XFILLER_300_114 VPWR VGND sg13cmos5l_decap_8
XFILLER_2_171 VPWR VGND sg13cmos5l_decap_8
X_2230_ _2230_/Q Tile_X0Y5_FrameData[15] VGND VPWR Tile_X0Y9_FrameStrobe[1] latch
XFILLER_446_118 VPWR VGND sg13cmos5l_decap_8
X_2161_ _2161_/Q Tile_X0Y4_FrameData[20] VGND VPWR Tile_X0Y9_FrameStrobe[7] latch
XFILLER_305_83 VPWR VGND sg13cmos5l_decap_8
XFILLER_65_112 VPWR VGND sg13cmos5l_decap_8
XFILLER_454_140 VPWR VGND sg13cmos5l_decap_8
X_1112_ _1112_/Q Tile_X0Y0_FrameData[19] VGND VPWR Tile_X0Y9_FrameStrobe[5] latch
X_2092_ _2092_/Q Tile_X0Y4_FrameData[25] VGND VPWR Tile_X0Y9_FrameStrobe[5] latch
XFILLER_253_246 VPWR VGND sg13cmos5l_decap_8
X_1043_ _1043_/Q Tile_X0Y0_FrameData[24] VGND VPWR Tile_X0Y9_FrameStrobe[3] latch
XFILLER_65_189 VPWR VGND sg13cmos5l_decap_8
XFILLER_0_63 VPWR VGND sg13cmos5l_decap_8
XFILLER_603_159 VPWR VGND sg13cmos5l_decap_8
XFILLER_206_151 VPWR VGND sg13cmos5l_decap_8
XFILLER_321_71 VPWR VGND sg13cmos5l_decap_8
XFILLER_21_204 VPWR VGND sg13cmos5l_decap_8
X_4802_ _4802_/X _4781_/X Tile_X0Y9_N4END[6] _4780_/X _0075_/X _0467_/Q _0466_/Q VPWR
+ VGND sg13cmos5l_mux4_1
XFILLER_556_214 VPWR VGND sg13cmos5l_fill_1
XFILLER_397_42 VPWR VGND sg13cmos5l_decap_8
XFILLER_556_236 VPWR VGND sg13cmos5l_decap_8
XFILLER_397_64 VPWR VGND sg13cmos5l_fill_1
X_2994_ Tile_X0Y5_E1BEG[1] _4369_/X VPWR VGND sg13cmos5l_buf_1
XFILLER_159_250 VPWR VGND sg13cmos5l_decap_8
XFILLER_397_86 VPWR VGND sg13cmos5l_decap_8
XFILLER_159_261 VPWR VGND sg13cmos5l_fill_1
XFILLER_21_259 VPWR VGND sg13cmos5l_fill_2
X_4733_ _4733_/X Tile_X0Y8_W2MID[2] AXI_M_SOC_RDATA13 _4789_/X _4788_/X _0581_/Q _0580_/Q
+ VPWR VGND sg13cmos5l_mux4_1
XFILLER_509_141 VPWR VGND sg13cmos5l_decap_8
X_1945_ _1945_/Q Tile_X0Y4_FrameData[12] VGND VPWR Tile_X0Y9_FrameStrobe[0] latch
XFILLER_159_272 VPWR VGND sg13cmos5l_fill_1
XFILLER_571_217 VPWR VGND sg13cmos5l_decap_4
XFILLER_547_56 VPWR VGND sg13cmos5l_decap_8
XFILLER_524_100 VPWR VGND sg13cmos5l_decap_8
X_4664_ _4664_/X Tile_X0Y6_W1END[2] Tile_X0Y6_W6END[10] _4582_/X _4542_/X _2655_/Q
+ _2654_/Q VPWR VGND sg13cmos5l_mux4_1
X_1876_ _1876_/Q Tile_X0Y3_FrameData[21] VGND VPWR Tile_X0Y9_FrameStrobe[6] latch
XFILLER_266_35 VPWR VGND sg13cmos5l_decap_8
XFILLER_119_169 VPWR VGND sg13cmos5l_decap_8
X_3615_ Tile_X0Y9_S2BEGb[1] _4933_/X VPWR VGND sg13cmos5l_buf_1
XFILLER_390_150 VPWR VGND sg13cmos5l_fill_2
X_0827_ _0827_/Q Tile_X0Y9_FrameData[4] VGND VPWR Tile_X0Y9_FrameStrobe[4] latch
X_4595_ _4595_/X Tile_X0Y8_W2MID[2] Tile_X0Y8_W2END[2] Tile_X0Y8_W6END[2] _4788_/X
+ _0653_/Q _0652_/Q VPWR VGND sg13cmos5l_mux4_1
XFILLER_134_128 VPWR VGND sg13cmos5l_decap_8
XFILLER_323_228 VPWR VGND sg13cmos5l_decap_8
XFILLER_390_194 VPWR VGND sg13cmos5l_decap_8
X_3546_ Tile_X0Y9_E6BEG[4] _4884_/X VPWR VGND sg13cmos5l_buf_1
X_0758_ _0758_/Q Tile_X0Y9_FrameData[9] VGND VPWR Tile_X0Y9_FrameStrobe[2] latch
XFILLER_416_49 VPWR VGND sg13cmos5l_decap_8
XFILLER_135_28 VPWR VGND sg13cmos5l_decap_8
XFILLER_142_150 VPWR VGND sg13cmos5l_decap_8
XFILLER_563_77 VPWR VGND sg13cmos5l_decap_8
XFILLER_288_143 VPWR VGND sg13cmos5l_decap_8
XFILLER_713_14 VPWR VGND sg13cmos5l_decap_8
X_3477_ Tile_X0Y1_EE4BEG[3] _3951_/X VPWR VGND sg13cmos5l_buf_1
XANTENNA__3524__X Tile_X0Y9_E1BEG[2] VPWR VGND sg13cmos5l_antennanp
X_0689_ _0689_/Q Tile_X0Y9_FrameData[14] VGND VPWR Tile_X0Y9_FrameStrobe[0] latch
XFILLER_282_56 VPWR VGND sg13cmos5l_decap_8
XFILLER_713_47 VPWR VGND sg13cmos5l_decap_8
XFILLER_88_259 VPWR VGND sg13cmos5l_fill_1
X_2428_ _2428_/Q Tile_X0Y5_FrameData[9] VGND VPWR Tile_X0Y9_FrameStrobe[7] latch
XFILLER_693_173 VPWR VGND sg13cmos5l_fill_1
XFILLER_492_257 VPWR VGND sg13cmos5l_fill_2
X_2359_ _2359_/Q Tile_X0Y5_FrameData[14] VGND VPWR Tile_X0Y9_FrameStrobe[5] latch
XFILLER_229_265 VPWR VGND sg13cmos5l_decap_8
XFILLER_56_123 VPWR VGND sg13cmos5l_decap_8
XFILLER_151_49 VPWR VGND sg13cmos5l_decap_8
XFILLER_512_70 VPWR VGND sg13cmos5l_decap_8
XFILLER_178_8 VPWR VGND sg13cmos5l_decap_8
X_4029_ _4029_/X Tile_X0Y3_W2MID[3] Tile_X0Y3_W2END[3] Tile_X0Y3_W6END[3] _4210_/X
+ _1909_/Q _1908_/Q VPWR VGND sg13cmos5l_mux4_1
XFILLER_588_63 VPWR VGND sg13cmos5l_decap_8
XFILLER_398_272 VPWR VGND sg13cmos5l_fill_1
XFILLER_240_7 VPWR VGND sg13cmos5l_decap_8
XFILLER_212_154 VPWR VGND sg13cmos5l_decap_8
XFILLER_12_226 VPWR VGND sg13cmos5l_fill_1
XFILLER_358_147 VPWR VGND sg13cmos5l_decap_8
XFILLER_338_7 VPWR VGND sg13cmos5l_decap_8
XFILLER_100_42 VPWR VGND sg13cmos5l_decap_8
XFILLER_12_248 VPWR VGND sg13cmos5l_decap_8
XANTENNA__0107__Y AXI_M_SOC_ARLEN2 VPWR VGND sg13cmos5l_antennanp
XFILLER_562_206 VPWR VGND sg13cmos5l_decap_8
XFILLER_457_56 VPWR VGND sg13cmos5l_decap_8
XFILLER_366_180 VPWR VGND sg13cmos5l_fill_2
XFILLER_704_211 VPWR VGND sg13cmos5l_decap_8
XFILLER_505_7 VPWR VGND sg13cmos5l_decap_8
XFILLER_176_35 VPWR VGND sg13cmos5l_decap_8
XFILLER_704_222 VPWR VGND sg13cmos5l_fill_1
XFILLER_515_122 VPWR VGND sg13cmos5l_decap_4
XFILLER_176_46 VPWR VGND sg13cmos5l_fill_2
XFILLER_704_233 VPWR VGND sg13cmos5l_decap_4
XFILLER_704_255 VPWR VGND sg13cmos5l_fill_2
XFILLER_180_212 VPWR VGND sg13cmos5l_fill_1
XFILLER_570_272 VPWR VGND sg13cmos5l_fill_1
XFILLER_180_234 VPWR VGND sg13cmos5l_fill_2
XFILLER_109_84 VPWR VGND sg13cmos5l_fill_2
XFILLER_256_90 VPWR VGND sg13cmos5l_fill_1
XFILLER_530_158 VPWR VGND sg13cmos5l_decap_8
XFILLER_79_226 VPWR VGND sg13cmos5l_fill_2
XFILLER_623_14 VPWR VGND sg13cmos5l_decap_8
XFILLER_279_154 VPWR VGND sg13cmos5l_decap_8
XANTENNA__3434__X Tile_X0Y4_FrameData_O[25] VPWR VGND sg13cmos5l_antennanp
XFILLER_69_77 VPWR VGND sg13cmos5l_decap_8
XFILLER_79_259 VPWR VGND sg13cmos5l_fill_2
XFILLER_294_124 VPWR VGND sg13cmos5l_decap_4
XFILLER_279_198 VPWR VGND sg13cmos5l_decap_8
XFILLER_197_0 VPWR VGND sg13cmos5l_decap_8
XFILLER_85_21 VPWR VGND sg13cmos5l_decap_8
XFILLER_699_29 VPWR VGND sg13cmos5l_decap_8
XFILLER_47_112 VPWR VGND sg13cmos5l_decap_8
XFILLER_436_140 VPWR VGND sg13cmos5l_decap_8
XFILLER_703_91 VPWR VGND sg13cmos5l_decap_8
XFILLER_422_70 VPWR VGND sg13cmos5l_decap_8
XFILLER_640_210 VPWR VGND sg13cmos5l_decap_8
XFILLER_436_195 VPWR VGND sg13cmos5l_decap_8
XFILLER_364_0 VPWR VGND sg13cmos5l_decap_8
XFILLER_235_246 VPWR VGND sg13cmos5l_decap_8
XFILLER_18_70 VPWR VGND sg13cmos5l_decap_8
XFILLER_235_268 VPWR VGND sg13cmos5l_decap_4
XFILLER_451_154 VPWR VGND sg13cmos5l_decap_8
XFILLER_62_159 VPWR VGND sg13cmos5l_decap_8
XFILLER_498_63 VPWR VGND sg13cmos5l_decap_8
XFILLER_250_249 VPWR VGND sg13cmos5l_decap_8
XFILLER_203_121 VPWR VGND sg13cmos5l_decap_8
XFILLER_531_0 VPWR VGND sg13cmos5l_decap_8
XFILLER_389_272 VPWR VGND sg13cmos5l_fill_1
XFILLER_629_0 VPWR VGND sg13cmos5l_decap_8
XFILLER_349_147 VPWR VGND sg13cmos5l_decap_8
XFILLER_648_77 VPWR VGND sg13cmos5l_decap_8
XFILLER_34_91 VPWR VGND sg13cmos5l_decap_8
XFILLER_86_7 VPWR VGND sg13cmos5l_decap_8
XANTENNA__3609__X Tile_X0Y9_S2BEG[3] VPWR VGND sg13cmos5l_antennanp
XFILLER_553_239 VPWR VGND sg13cmos5l_decap_8
XFILLER_364_139 VPWR VGND sg13cmos5l_decap_8
X_1730_ _1730_/Q Tile_X0Y3_FrameData[7] VGND VPWR Tile_X0Y9_FrameStrobe[1] latch
XFILLER_367_78 VPWR VGND sg13cmos5l_fill_1
XFILLER_7_241 VPWR VGND sg13cmos5l_decap_8
XFILLER_664_21 VPWR VGND sg13cmos5l_decap_8
XFILLER_372_150 VPWR VGND sg13cmos5l_decap_8
X_1661_ _1661_/Q Tile_X0Y2_FrameData[20] VGND VPWR Tile_X0Y9_FrameStrobe[7] latch
XFILLER_664_65 VPWR VGND sg13cmos5l_fill_1
XFILLER_171_234 VPWR VGND sg13cmos5l_decap_8
X_3400_ Tile_X0Y2_E2BEG[3] _4043_/X VPWR VGND sg13cmos5l_buf_1
X_0612_ _0612_/Q Tile_X0Y8_FrameData[27] VGND VPWR Tile_X0Y9_FrameStrobe[6] latch
X_4380_ _4380_/X Tile_X0Y5_W2END[7] AXI_M_SOC_RRESP1 _4467_/X _4428_/X _2343_/Q _2342_/Q
+ VPWR VGND sg13cmos5l_mux4_1
X_1592_ _1592_/Q Tile_X0Y2_FrameData[25] VGND VPWR Tile_X0Y9_FrameStrobe[5] latch
XFILLER_710_258 VPWR VGND sg13cmos5l_fill_1
XFILLER_124_161 VPWR VGND sg13cmos5l_decap_8
X_3331_ Tile_X0Y2_FrameData_O[2] Tile_X0Y2_FrameData[2] VPWR VGND sg13cmos5l_buf_1
XFILLER_383_77 VPWR VGND sg13cmos5l_decap_8
X_0543_ _0543_/Q Tile_X0Y8_FrameData[0] VGND VPWR Tile_X0Y9_FrameStrobe[3] latch
XFILLER_533_14 VPWR VGND sg13cmos5l_decap_8
XFILLER_313_272 VPWR VGND sg13cmos5l_fill_1
XANTENNA__3344__X Tile_X0Y2_FrameData_O[15] VPWR VGND sg13cmos5l_antennanp
XFILLER_675_140 VPWR VGND sg13cmos5l_decap_4
X_3262_ Tile_X0Y0_FrameData_O[30] Tile_X0Y0_FrameData[30] VPWR VGND sg13cmos5l_buf_1
XFILLER_419_129 VPWR VGND sg13cmos5l_decap_8
X_0474_ _0474_/Q Tile_X0Y8_FrameData[5] VGND VPWR Tile_X0Y9_FrameStrobe[1] latch
XFILLER_474_224 VPWR VGND sg13cmos5l_decap_8
X_2213_ _2213_/Q Tile_X0Y5_FrameData[0] VGND VPWR Tile_X0Y9_FrameStrobe[0] latch
XFILLER_680_97 VPWR VGND sg13cmos5l_decap_8
XFILLER_285_168 VPWR VGND sg13cmos5l_decap_8
X_3193_ Tile_X0Y0_N2BEGb[1] _3891_/X VPWR VGND sg13cmos5l_buf_1
XFILLER_427_140 VPWR VGND sg13cmos5l_decap_8
XFILLER_93_240 VPWR VGND sg13cmos5l_fill_2
X_2144_ _2144_/Q Tile_X0Y4_FrameData[5] VGND VPWR Tile_X0Y9_FrameStrobe[6] latch
XFILLER_690_187 VPWR VGND sg13cmos5l_decap_8
XFILLER_588_114 VPWR VGND sg13cmos5l_decap_8
XFILLER_332_81 VPWR VGND sg13cmos5l_decap_8
XFILLER_442_132 VPWR VGND sg13cmos5l_decap_8
XFILLER_631_243 VPWR VGND sg13cmos5l_fill_1
XFILLER_588_125 VPWR VGND sg13cmos5l_decap_8
X_2075_ _2075_/Q Tile_X0Y4_FrameData[10] VGND VPWR Tile_X0Y9_FrameStrobe[4] latch
XFILLER_53_137 VPWR VGND sg13cmos5l_decap_8
X_1026_ _1026_/Q Tile_X0Y0_FrameData[9] VGND VPWR Tile_X0Y9_FrameStrobe[2] latch
XFILLER_529_203 VPWR VGND sg13cmos5l_decap_8
XFILLER_529_214 VPWR VGND sg13cmos5l_fill_2
XFILLER_201_63 VPWR VGND sg13cmos5l_decap_8
XFILLER_395_220 VPWR VGND sg13cmos5l_decap_8
XFILLER_14_28 VPWR VGND sg13cmos5l_decap_8
XFILLER_558_77 VPWR VGND sg13cmos5l_decap_8
X_2977_ Tile_X0Y8_FrameData_O[17] Tile_X0Y8_FrameData[17] VPWR VGND sg13cmos5l_buf_1
XFILLER_708_14 VPWR VGND sg13cmos5l_decap_8
XANTENNA__3519__X Tile_X0Y1_E1BEG[1] VPWR VGND sg13cmos5l_antennanp
XFILLER_544_228 VPWR VGND sg13cmos5l_decap_8
XFILLER_277_56 VPWR VGND sg13cmos5l_decap_8
X_4716_ _4716_/X Tile_X0Y8_W1END[0] Tile_X0Y8_WW4END[12] Tile_X0Y8_W6END[4] _4800_/X
+ _0611_/Q _0610_/Q VPWR VGND sg13cmos5l_mux4_1
X_1928_ _1928_/Q Tile_X0Y4_FrameData[29] VGND VPWR Tile_X0Y9_FrameStrobe[0] latch
XFILLER_574_21 VPWR VGND sg13cmos5l_decap_8
X_4647_ _4647_/X Tile_X0Y9_N4END[11] _0053_/X _4692_/X _4696_/X _0265_/Q _0264_/Q
+ VPWR VGND sg13cmos5l_mux4_1
XFILLER_162_212 VPWR VGND sg13cmos5l_fill_2
X_1859_ _1859_/Q Tile_X0Y3_FrameData[6] VGND VPWR Tile_X0Y9_FrameStrobe[5] latch
XFILLER_552_272 VPWR VGND sg13cmos5l_fill_1
XFILLER_107_139 VPWR VGND sg13cmos5l_decap_8
XFILLER_574_98 VPWR VGND sg13cmos5l_decap_8
XFILLER_146_49 VPWR VGND sg13cmos5l_decap_8
X_4578_ _4578_/X _4549_/X Tile_X0Y9_N4END[14] _4548_/X _0155_/X _2475_/Q _2474_/Q
+ VPWR VGND sg13cmos5l_mux4_1
XFILLER_507_70 VPWR VGND sg13cmos5l_decap_8
XFILLER_512_169 VPWR VGND sg13cmos5l_decap_8
XFILLER_293_77 VPWR VGND sg13cmos5l_decap_8
X_3529_ Tile_X0Y9_E2BEG[3] _4851_/X VPWR VGND sg13cmos5l_buf_1
XFILLER_443_14 VPWR VGND sg13cmos5l_decap_8
XFILLER_304_272 VPWR VGND sg13cmos5l_fill_1
XANTENNA__3254__X Tile_X0Y0_FrameData_O[22] VPWR VGND sg13cmos5l_antennanp
XFILLER_115_194 VPWR VGND sg13cmos5l_decap_4
XFILLER_590_42 VPWR VGND sg13cmos5l_decap_8
XFILLER_226_93 VPWR VGND sg13cmos5l_decap_8
XFILLER_465_235 VPWR VGND sg13cmos5l_decap_8
XFILLER_295_8 VPWR VGND sg13cmos5l_decap_8
XFILLER_39_69 VPWR VGND sg13cmos5l_decap_8
XFILLER_130_175 VPWR VGND sg13cmos5l_decap_8
XFILLER_190_7 VPWR VGND sg13cmos5l_decap_8
XFILLER_681_143 VPWR VGND sg13cmos5l_decap_8
XFILLER_523_91 VPWR VGND sg13cmos5l_decap_8
XFILLER_291_127 VPWR VGND sg13cmos5l_decap_8
XFILLER_418_184 VPWR VGND sg13cmos5l_fill_2
XFILLER_29_156 VPWR VGND sg13cmos5l_decap_8
XFILLER_622_221 VPWR VGND sg13cmos5l_decap_4
XFILLER_55_24 VPWR VGND sg13cmos5l_decap_8
XFILLER_579_114 VPWR VGND sg13cmos5l_fill_1
XFILLER_622_232 VPWR VGND sg13cmos5l_decap_8
XFILLER_44_115 VPWR VGND sg13cmos5l_decap_8
XFILLER_622_243 VPWR VGND sg13cmos5l_fill_1
XFILLER_579_136 VPWR VGND sg13cmos5l_decap_8
XFILLER_455_7 VPWR VGND sg13cmos5l_decap_8
XFILLER_232_238 VPWR VGND sg13cmos5l_decap_8
XFILLER_232_249 VPWR VGND sg13cmos5l_fill_2
XFILLER_111_63 VPWR VGND sg13cmos5l_decap_8
XFILLER_622_7 VPWR VGND sg13cmos5l_decap_8
XFILLER_386_231 VPWR VGND sg13cmos5l_decap_8
XFILLER_71_56 VPWR VGND sg13cmos5l_decap_8
XFILLER_187_34 VPWR VGND sg13cmos5l_decap_8
XFILLER_535_206 VPWR VGND sg13cmos5l_decap_8
XFILLER_618_14 VPWR VGND sg13cmos5l_decap_8
XFILLER_535_217 VPWR VGND sg13cmos5l_fill_1
XFILLER_346_117 VPWR VGND sg13cmos5l_decap_8
XANTENNA__3429__X Tile_X0Y4_FrameData_O[20] VPWR VGND sg13cmos5l_antennanp
XFILLER_138_231 VPWR VGND sg13cmos5l_decap_8
XFILLER_138_242 VPWR VGND sg13cmos5l_fill_2
XFILLER_484_21 VPWR VGND sg13cmos5l_decap_8
XFILLER_689_221 VPWR VGND sg13cmos5l_decap_8
XFILLER_543_250 VPWR VGND sg13cmos5l_decap_8
XFILLER_354_161 VPWR VGND sg13cmos5l_decap_8
XFILLER_112_0 VPWR VGND sg13cmos5l_decap_8
XFILLER_543_272 VPWR VGND sg13cmos5l_fill_1
XFILLER_4_211 VPWR VGND sg13cmos5l_fill_1
XFILLER_153_245 VPWR VGND sg13cmos5l_decap_8
XFILLER_634_35 VPWR VGND sg13cmos5l_decap_8
XFILLER_503_147 VPWR VGND sg13cmos5l_decap_8
XFILLER_417_70 VPWR VGND sg13cmos5l_decap_8
XFILLER_299_249 VPWR VGND sg13cmos5l_decap_8
XFILLER_353_14 VPWR VGND sg13cmos5l_decap_8
XANTENNA__3164__X Tile_X0Y4_E6BEG[1] VPWR VGND sg13cmos5l_antennanp
XFILLER_106_183 VPWR VGND sg13cmos5l_fill_1
XFILLER_657_151 VPWR VGND sg13cmos5l_decap_8
XFILLER_672_110 VPWR VGND sg13cmos5l_decap_8
XFILLER_481_0 VPWR VGND sg13cmos5l_decap_8
XFILLER_267_146 VPWR VGND sg13cmos5l_decap_8
XFILLER_121_175 VPWR VGND sg13cmos5l_fill_2
XFILLER_579_0 VPWR VGND sg13cmos5l_decap_8
XFILLER_503_28 VPWR VGND sg13cmos5l_decap_8
XFILLER_456_268 VPWR VGND sg13cmos5l_decap_4
XFILLER_96_97 VPWR VGND sg13cmos5l_decap_8
XFILLER_282_105 VPWR VGND sg13cmos5l_decap_8
XFILLER_650_56 VPWR VGND sg13cmos5l_decap_8
XFILLER_433_91 VPWR VGND sg13cmos5l_decap_8
XFILLER_208_224 VPWR VGND sg13cmos5l_decap_8
X_0190_ _0190_/Q Tile_X0Y7_FrameData[1] VGND VPWR Tile_X0Y9_FrameStrobe[0] latch
XFILLER_424_154 VPWR VGND sg13cmos5l_decap_8
XFILLER_659_21 VPWR VGND sg13cmos5l_decap_8
XFILLER_369_209 VPWR VGND sg13cmos5l_fill_1
XFILLER_290_193 VPWR VGND sg13cmos5l_decap_8
X_2900_ Tile_X0Y6_FrameData_O[21] Tile_X0Y6_FrameData[21] VPWR VGND sg13cmos5l_buf_1
XFILLER_378_22 VPWR VGND sg13cmos5l_decap_8
XFILLER_43_170 VPWR VGND sg13cmos5l_decap_8
X_3880_ _3880_/X _3851_/X Tile_X0Y0_W6END[3] Tile_X0Y0_S1END[3] _3880_/A3 _0941_/Q
+ _1178_/Q VPWR VGND sg13cmos5l_mux4_1
XFILLER_188_175 VPWR VGND sg13cmos5l_decap_8
X_2831_ Tile_X0Y6_E1BEG[0] _4492_/X VPWR VGND sg13cmos5l_buf_1
XFILLER_528_14 VPWR VGND sg13cmos5l_decap_8
XANTENNA__3339__X Tile_X0Y2_FrameData_O[10] VPWR VGND sg13cmos5l_antennanp
XFILLER_392_223 VPWR VGND sg13cmos5l_decap_8
XFILLER_675_42 VPWR VGND sg13cmos5l_decap_8
XFILLER_337_139 VPWR VGND sg13cmos5l_decap_8
XFILLER_129_242 VPWR VGND sg13cmos5l_fill_2
X_2762_ Tile_X0Y3_FrameData_O[20] Tile_X0Y3_FrameData[20] VPWR VGND sg13cmos5l_buf_1
X_4501_ _4501_/X Tile_X0Y6_W2MID[2] AXI_M_SOC_RDATA29 _4557_/X _4556_/X _2605_/Q _2604_/Q
+ VPWR VGND sg13cmos5l_mux4_1
XFILLER_675_86 VPWR VGND sg13cmos5l_decap_8
X_1713_ _1713_/Q Tile_X0Y3_FrameData[24] VGND VPWR Tile_X0Y9_FrameStrobe[1] latch
XFILLER_394_43 VPWR VGND sg13cmos5l_fill_2
X_2693_ _2693_/Q Tile_X0Y6_FrameData[2] VGND VPWR Tile_X0Y9_FrameStrobe[7] latch
XFILLER_534_272 VPWR VGND sg13cmos5l_fill_1
X_4432_ _4432_/X _4357_/X _4473_/X _4472_/X _4356_/X _2201_/Q _2200_/Q VPWR VGND sg13cmos5l_mux4_1
XFILLER_144_256 VPWR VGND sg13cmos5l_decap_8
X_1644_ _1644_/Q Tile_X0Y2_FrameData[5] VGND VPWR Tile_X0Y9_FrameStrobe[6] latch
XFILLER_360_131 VPWR VGND sg13cmos5l_decap_4
XFILLER_544_35 VPWR VGND sg13cmos5l_decap_8
XFILLER_6_84 VPWR VGND sg13cmos5l_decap_8
XFILLER_691_63 VPWR VGND sg13cmos5l_decap_8
X_4363_ _4363_/X Tile_X0Y6_W2MID[2] Tile_X0Y6_W2END[2] Tile_X0Y6_W6END[2] _4556_/X
+ _2677_/Q _2676_/Q VPWR VGND sg13cmos5l_mux4_1
XFILLER_263_14 VPWR VGND sg13cmos5l_decap_8
XANTENNA__3074__X Tile_X0Y4_E2BEGb[0] VPWR VGND sg13cmos5l_antennanp
X_1575_ _1575_/Q Tile_X0Y2_FrameData[10] VGND VPWR Tile_X0Y9_FrameStrobe[4] latch
XFILLER_648_140 VPWR VGND sg13cmos5l_decap_8
X_3314_ Tile_X0Y4_EE4BEG[2] _4274_/X VPWR VGND sg13cmos5l_buf_1
X_0526_ _0526_/Q Tile_X0Y8_FrameData[17] VGND VPWR Tile_X0Y9_FrameStrobe[3] latch
X_4294_ _4294_/X AXI_M_SOC_BRESP0 _4341_/X _4345_/X _4317_/X _2025_/Q _2024_/Q VPWR
+ VGND sg13cmos5l_mux4_1
XFILLER_58_207 VPWR VGND sg13cmos5l_decap_4
XFILLER_447_235 VPWR VGND sg13cmos5l_decap_8
XFILLER_648_195 VPWR VGND sg13cmos5l_decap_8
XFILLER_58_218 VPWR VGND sg13cmos5l_decap_8
XFILLER_447_246 VPWR VGND sg13cmos5l_decap_8
XFILLER_258_146 VPWR VGND sg13cmos5l_fill_2
X_3245_ Tile_X0Y0_FrameData_O[13] Tile_X0Y0_FrameData[13] VPWR VGND sg13cmos5l_buf_1
XFILLER_413_28 VPWR VGND sg13cmos5l_decap_8
X_0457_ _0457_/Q Tile_X0Y8_FrameData[22] VGND VPWR Tile_X0Y9_FrameStrobe[1] latch
XFILLER_112_197 VPWR VGND sg13cmos5l_decap_8
XFILLER_663_165 VPWR VGND sg13cmos5l_decap_4
XFILLER_560_56 VPWR VGND sg13cmos5l_decap_8
X_3176_ Tile_X0Y0_N4BEG[0] _3176_/A VPWR VGND sg13cmos5l_buf_1
XFILLER_273_149 VPWR VGND sg13cmos5l_decap_8
X_0388_ _0388_/Q Tile_X0Y7_FrameData[27] VGND VPWR Tile_X0Y9_FrameStrobe[7] latch
XFILLER_415_121 VPWR VGND sg13cmos5l_decap_8
XFILLER_266_190 VPWR VGND sg13cmos5l_decap_8
X_2127_ _2127_/Q Tile_X0Y4_FrameData[22] VGND VPWR Tile_X0Y9_FrameStrobe[6] latch
XFILLER_604_265 VPWR VGND sg13cmos5l_decap_8
XFILLER_569_21 VPWR VGND sg13cmos5l_decap_8
XFILLER_214_227 VPWR VGND sg13cmos5l_decap_8
XFILLER_281_182 VPWR VGND sg13cmos5l_decap_8
XFILLER_212_84 VPWR VGND sg13cmos5l_decap_8
XFILLER_214_249 VPWR VGND sg13cmos5l_decap_4
X_2058_ _2058_/Q Tile_X0Y4_FrameData[27] VGND VPWR Tile_X0Y9_FrameStrobe[4] latch
XFILLER_41_118 VPWR VGND sg13cmos5l_fill_1
XFILLER_576_139 VPWR VGND sg13cmos5l_decap_8
XFILLER_288_22 VPWR VGND sg13cmos5l_decap_8
X_1009_ _1009_/Q Tile_X0Y0_FrameData[26] VGND VPWR Tile_X0Y9_FrameStrobe[2] latch
XFILLER_430_168 VPWR VGND sg13cmos5l_decap_8
XFILLER_569_98 VPWR VGND sg13cmos5l_decap_8
XFILLER_179_186 VPWR VGND sg13cmos5l_decap_8
XFILLER_438_14 VPWR VGND sg13cmos5l_decap_8
XFILLER_288_99 VPWR VGND sg13cmos5l_decap_8
XANTENNA__3249__X Tile_X0Y0_FrameData_O[17] VPWR VGND sg13cmos5l_antennanp
XFILLER_584_172 VPWR VGND sg13cmos5l_decap_8
XFILLER_585_42 VPWR VGND sg13cmos5l_decap_8
XFILLER_194_156 VPWR VGND sg13cmos5l_decap_8
XFILLER_383_245 VPWR VGND sg13cmos5l_decap_8
XFILLER_343_109 VPWR VGND sg13cmos5l_decap_8
XFILLER_518_91 VPWR VGND sg13cmos5l_decap_8
XFILLER_203_7 VPWR VGND sg13cmos5l_decap_8
XFILLER_454_35 VPWR VGND sg13cmos5l_decap_8
XFILLER_237_92 VPWR VGND sg13cmos5l_decap_8
XFILLER_173_14 VPWR VGND sg13cmos5l_decap_8
XFILLER_1_203 VPWR VGND sg13cmos5l_decap_8
XFILLER_351_175 VPWR VGND sg13cmos5l_decap_8
XFILLER_497_168 VPWR VGND sg13cmos5l_decap_8
XFILLER_639_140 VPWR VGND sg13cmos5l_decap_8
XFILLER_438_213 VPWR VGND sg13cmos5l_decap_8
XFILLER_604_49 VPWR VGND sg13cmos5l_decap_8
XFILLER_438_246 VPWR VGND sg13cmos5l_decap_8
XFILLER_654_132 VPWR VGND sg13cmos5l_decap_8
XFILLER_572_7 VPWR VGND sg13cmos5l_decap_8
XFILLER_438_268 VPWR VGND sg13cmos5l_decap_4
XFILLER_106_74 VPWR VGND sg13cmos5l_decap_4
XFILLER_264_105 VPWR VGND sg13cmos5l_fill_1
XANTENNA__3712__X AXI_M_SOC_WDATA22 VPWR VGND sg13cmos5l_antennanp
XFILLER_470_56 VPWR VGND sg13cmos5l_decap_4
XFILLER_253_91 VPWR VGND sg13cmos5l_decap_8
XFILLER_66_56 VPWR VGND sg13cmos5l_decap_8
XFILLER_403_50 VPWR VGND sg13cmos5l_decap_8
XFILLER_17_115 VPWR VGND sg13cmos5l_decap_8
XFILLER_479_21 VPWR VGND sg13cmos5l_decap_8
XFILLER_406_165 VPWR VGND sg13cmos5l_decap_8
XFILLER_272_160 VPWR VGND sg13cmos5l_decap_8
XFILLER_17_148 VPWR VGND sg13cmos5l_decap_8
XFILLER_205_238 VPWR VGND sg13cmos5l_decap_8
XFILLER_700_70 VPWR VGND sg13cmos5l_decap_8
XFILLER_32_107 VPWR VGND sg13cmos5l_decap_8
XFILLER_610_257 VPWR VGND sg13cmos5l_fill_1
XFILLER_421_168 VPWR VGND sg13cmos5l_decap_8
XFILLER_709_133 VPWR VGND sg13cmos5l_decap_4
XFILLER_629_35 VPWR VGND sg13cmos5l_decap_8
XFILLER_582_109 VPWR VGND sg13cmos5l_fill_2
XFILLER_374_201 VPWR VGND sg13cmos5l_decap_8
XFILLER_185_112 VPWR VGND sg13cmos5l_fill_1
XFILLER_575_161 VPWR VGND sg13cmos5l_decap_8
XFILLER_348_14 VPWR VGND sg13cmos5l_decap_8
XANTENNA__3159__X Tile_X0Y7_FrameData_O[29] VPWR VGND sg13cmos5l_antennanp
XFILLER_709_188 VPWR VGND sg13cmos5l_fill_1
XFILLER_327_0 VPWR VGND sg13cmos5l_decap_4
XFILLER_495_42 VPWR VGND sg13cmos5l_decap_8
XFILLER_40_184 VPWR VGND sg13cmos5l_decap_8
XFILLER_374_245 VPWR VGND sg13cmos5l_fill_2
XFILLER_590_153 VPWR VGND sg13cmos5l_fill_2
XFILLER_185_189 VPWR VGND sg13cmos5l_fill_2
XANTENNA__2998__X Tile_X0Y5_E2BEG[1] VPWR VGND sg13cmos5l_antennanp
XFILLER_126_201 VPWR VGND sg13cmos5l_fill_2
XFILLER_327_161 VPWR VGND sg13cmos5l_decap_8
XFILLER_126_212 VPWR VGND sg13cmos5l_fill_1
XFILLER_516_261 VPWR VGND sg13cmos5l_decap_8
XFILLER_516_272 VPWR VGND sg13cmos5l_fill_1
XFILLER_126_234 VPWR VGND sg13cmos5l_decap_8
XFILLER_590_197 VPWR VGND sg13cmos5l_decap_8
XFILLER_645_56 VPWR VGND sg13cmos5l_decap_8
XFILLER_428_91 VPWR VGND sg13cmos5l_decap_8
XFILLER_126_245 VPWR VGND sg13cmos5l_fill_1
XFILLER_677_213 VPWR VGND sg13cmos5l_fill_2
XFILLER_147_70 VPWR VGND sg13cmos5l_decap_8
XFILLER_531_242 VPWR VGND sg13cmos5l_fill_1
XFILLER_364_35 VPWR VGND sg13cmos5l_decap_8
XFILLER_342_153 VPWR VGND sg13cmos5l_fill_2
XFILLER_696_0 VPWR VGND sg13cmos5l_decap_8
XFILLER_531_264 VPWR VGND sg13cmos5l_fill_1
XFILLER_141_248 VPWR VGND sg13cmos5l_decap_8
X_1360_ _1360_/Q Tile_X0Y1_FrameData[9] VGND VPWR Tile_X0Y9_FrameStrobe[5] latch
XFILLER_429_224 VPWR VGND sg13cmos5l_decap_8
XFILLER_514_49 VPWR VGND sg13cmos5l_decap_8
XFILLER_295_241 VPWR VGND sg13cmos5l_decap_4
X_0311_ _0311_/Q Tile_X0Y7_FrameData[8] VGND VPWR Tile_X0Y9_FrameStrobe[4] latch
XFILLER_233_28 VPWR VGND sg13cmos5l_decap_8
XFILLER_429_268 VPWR VGND sg13cmos5l_decap_4
XFILLER_163_80 VPWR VGND sg13cmos5l_decap_8
X_1291_ _1291_/Q Tile_X0Y1_FrameData[14] VGND VPWR Tile_X0Y9_FrameStrobe[3] latch
XFILLER_645_154 VPWR VGND sg13cmos5l_decap_8
XANTENNA__3622__X Tile_X0Y9_S4BEG[0] VPWR VGND sg13cmos5l_antennanp
X_3030_ Tile_X0Y5_EE4BEG[5] _4393_/X VPWR VGND sg13cmos5l_buf_1
X_0242_ _0242_/Q Tile_X0Y7_FrameData[13] VGND VPWR Tile_X0Y9_FrameStrobe[2] latch
XFILLER_444_238 VPWR VGND sg13cmos5l_decap_8
XFILLER_380_78 VPWR VGND sg13cmos5l_decap_4
XFILLER_48_262 VPWR VGND sg13cmos5l_decap_8
X_0173_ _0173_/Q Tile_X0Y7_FrameData[18] VGND VPWR Tile_X0Y9_FrameStrobe[0] latch
XFILLER_660_157 VPWR VGND sg13cmos5l_decap_8
XFILLER_263_160 VPWR VGND sg13cmos5l_decap_8
XFILLER_389_21 VPWR VGND sg13cmos5l_decap_8
XFILLER_601_202 VPWR VGND sg13cmos5l_decap_8
XFILLER_412_146 VPWR VGND sg13cmos5l_decap_8
XFILLER_211_208 VPWR VGND sg13cmos5l_decap_8
X_3932_ _3932_/X Tile_X0Y1_W2MID[7] AXI_M_SOC_ARREADY _3989_/X _3988_/X _1345_/Q _1344_/Q
+ VPWR VGND sg13cmos5l_mux4_1
XFILLER_539_35 VPWR VGND sg13cmos5l_decap_8
XFILLER_686_52 VPWR VGND sg13cmos5l_decap_8
X_3863_ _3863_/X _3851_/X _0078_/X Tile_X0Y0_S1END[3] Tile_X0Y0_S4END[3] _0965_/Q
+ _0964_/Q VPWR VGND sg13cmos5l_mux4_1
XFILLER_566_161 VPWR VGND sg13cmos5l_decap_8
XFILLER_258_14 VPWR VGND sg13cmos5l_decap_8
XFILLER_365_212 VPWR VGND sg13cmos5l_fill_2
XANTENNA__3069__X Tile_X0Y5_FrameData_O[28] VPWR VGND sg13cmos5l_antennanp
X_2814_ Tile_X0Y3_E2BEG[4] _4152_/X VPWR VGND sg13cmos5l_buf_1
XFILLER_31_184 VPWR VGND sg13cmos5l_fill_2
XFILLER_715_147 VPWR VGND sg13cmos5l_decap_8
X_3794_ _3794_/X Tile_X0Y0_W1END[1] Tile_X0Y0_WW4END[1] Tile_X0Y0_W6END[9] _3882_/X
+ _1150_/Q _1149_/Q VPWR VGND sg13cmos5l_mux4_1
XFILLER_176_178 VPWR VGND sg13cmos5l_decap_8
XFILLER_75_0 VPWR VGND sg13cmos5l_decap_8
XFILLER_191_104 VPWR VGND sg13cmos5l_decap_8
XFILLER_555_23 VPWR VGND sg13cmos5l_decap_8
X_2745_ Tile_X0Y3_FrameData_O[3] Tile_X0Y3_FrameData[3] VPWR VGND sg13cmos5l_buf_1
XFILLER_581_175 VPWR VGND sg13cmos5l_decap_4
XFILLER_408_28 VPWR VGND sg13cmos5l_decap_8
XFILLER_507_272 VPWR VGND sg13cmos5l_fill_1
XFILLER_380_237 VPWR VGND sg13cmos5l_decap_8
XFILLER_479_113 VPWR VGND sg13cmos5l_decap_8
X_2676_ _2676_/Q Tile_X0Y6_FrameData[19] VGND VPWR Tile_X0Y9_FrameStrobe[7] latch
XFILLER_274_35 VPWR VGND sg13cmos5l_decap_8
XFILLER_132_215 VPWR VGND sg13cmos5l_decap_8
X_4415_ _4415_/X AXI_M_SOC_RRESP1 _4451_/X _4455_/X _4428_/X _2273_/Q _2272_/Q VPWR
+ VGND sg13cmos5l_mux4_1
XFILLER_522_264 VPWR VGND sg13cmos5l_fill_1
XFILLER_132_226 VPWR VGND sg13cmos5l_decap_4
X_1627_ _1627_/Q Tile_X0Y2_FrameData[22] VGND VPWR Tile_X0Y9_FrameStrobe[6] latch
XFILLER_668_257 VPWR VGND sg13cmos5l_decap_8
XFILLER_494_105 VPWR VGND sg13cmos5l_decap_8
XFILLER_98_140 VPWR VGND sg13cmos5l_decap_8
X_4346_ _4346_/X _4308_/X _0160_/X _4307_/X _0110_/X _1961_/Q _1960_/Q VPWR VGND sg13cmos5l_mux4_1
XFILLER_683_227 VPWR VGND sg13cmos5l_decap_8
X_1558_ _1558_/Q Tile_X0Y2_FrameData[27] VGND VPWR Tile_X0Y9_FrameStrobe[4] latch
XFILLER_424_49 VPWR VGND sg13cmos5l_decap_8
XFILLER_207_84 VPWR VGND sg13cmos5l_decap_8
XFILLER_571_77 VPWR VGND sg13cmos5l_decap_8
XFILLER_286_252 VPWR VGND sg13cmos5l_fill_2
XFILLER_143_28 VPWR VGND sg13cmos5l_decap_8
X_0509_ _0509_/Q Tile_X0Y8_FrameData[2] VGND VPWR Tile_X0Y9_FrameStrobe[2] latch
XFILLER_286_263 VPWR VGND sg13cmos5l_fill_2
X_4277_ _4277_/X Tile_X0Y4_WW4END[10] AXI_M_SOC_BRESP1 _4346_/X _4317_/X _2059_/Q
+ _2058_/Q VPWR VGND sg13cmos5l_mux4_1
XFILLER_636_154 VPWR VGND sg13cmos5l_decap_4
XANTENNA__3532__X Tile_X0Y9_E2BEG[6] VPWR VGND sg13cmos5l_antennanp
X_1489_ _1489_/Q Tile_X0Y2_FrameData[0] VGND VPWR Tile_X0Y9_FrameStrobe[1] latch
XFILLER_100_134 VPWR VGND sg13cmos5l_decap_8
XFILLER_246_116 VPWR VGND sg13cmos5l_decap_8
XFILLER_435_227 VPWR VGND sg13cmos5l_decap_8
X_3228_ Tile_X0Y0_FrameStrobe_O[16] Tile_X0Y9_FrameStrobe[16] VPWR VGND sg13cmos5l_buf_1
XFILLER_290_78 VPWR VGND sg13cmos5l_decap_8
XFILLER_223_50 VPWR VGND sg13cmos5l_decap_4
XFILLER_223_83 VPWR VGND sg13cmos5l_decap_8
XFILLER_54_210 VPWR VGND sg13cmos5l_decap_8
X_3159_ Tile_X0Y7_FrameData_O[29] Tile_X0Y7_FrameData[29] VPWR VGND sg13cmos5l_buf_1
XFILLER_651_168 VPWR VGND sg13cmos5l_decap_8
XFILLER_443_260 VPWR VGND sg13cmos5l_fill_2
XFILLER_299_21 VPWR VGND sg13cmos5l_decap_8
XFILLER_14_129 VPWR VGND sg13cmos5l_decap_8
XFILLER_202_208 VPWR VGND sg13cmos5l_decap_8
XFILLER_153_7 VPWR VGND sg13cmos5l_decap_8
XFILLER_403_179 VPWR VGND sg13cmos5l_decap_8
XFILLER_449_35 VPWR VGND sg13cmos5l_decap_8
XFILLER_167_112 VPWR VGND sg13cmos5l_decap_8
XFILLER_168_14 VPWR VGND sg13cmos5l_decap_8
XFILLER_596_63 VPWR VGND sg13cmos5l_decap_8
XFILLER_52_47 VPWR VGND sg13cmos5l_decap_8
XFILLER_168_36 VPWR VGND sg13cmos5l_decap_8
XFILLER_22_173 VPWR VGND sg13cmos5l_decap_8
XFILLER_356_245 VPWR VGND sg13cmos5l_decap_8
XFILLER_418_7 VPWR VGND sg13cmos5l_decap_8
XFILLER_706_158 VPWR VGND sg13cmos5l_decap_8
XANTENNA__0115__Y AXI_M_SOC_ARSIZE0 VPWR VGND sg13cmos5l_antennanp
XFILLER_572_175 VPWR VGND sg13cmos5l_decap_8
XANTENNA__3707__X AXI_M_SOC_WDATA17 VPWR VGND sg13cmos5l_antennanp
XFILLER_465_56 VPWR VGND sg13cmos5l_decap_4
XFILLER_465_67 VPWR VGND sg13cmos5l_decap_8
XFILLER_371_259 VPWR VGND sg13cmos5l_decap_8
XFILLER_248_91 VPWR VGND sg13cmos5l_fill_2
XFILLER_184_57 VPWR VGND sg13cmos5l_decap_8
XFILLER_324_164 VPWR VGND sg13cmos5l_decap_8
XFILLER_659_257 VPWR VGND sg13cmos5l_decap_8
XFILLER_659_268 VPWR VGND sg13cmos5l_decap_4
XFILLER_123_237 VPWR VGND sg13cmos5l_decap_8
XANTENNA__0131__X AXI_M_SOC_AWSIZE1 VPWR VGND sg13cmos5l_antennanp
XFILLER_117_62 VPWR VGND sg13cmos5l_decap_8
XFILLER_674_216 VPWR VGND sg13cmos5l_decap_8
XFILLER_89_140 VPWR VGND sg13cmos5l_decap_8
XFILLER_77_22 VPWR VGND sg13cmos5l_decap_8
XFILLER_485_138 VPWR VGND sg13cmos5l_decap_8
XFILLER_117_84 VPWR VGND sg13cmos5l_decap_8
XFILLER_277_241 VPWR VGND sg13cmos5l_decap_8
XFILLER_77_55 VPWR VGND sg13cmos5l_fill_2
XFILLER_631_14 VPWR VGND sg13cmos5l_decap_8
XANTENNA__3442__X Tile_X0Y1_FrameData_O[0] VPWR VGND sg13cmos5l_antennanp
XFILLER_493_182 VPWR VGND sg13cmos5l_decap_8
XFILLER_493_193 VPWR VGND sg13cmos5l_fill_2
XFILLER_426_238 VPWR VGND sg13cmos5l_decap_8
XFILLER_426_249 VPWR VGND sg13cmos5l_decap_8
XFILLER_93_21 VPWR VGND sg13cmos5l_decap_8
XFILLER_277_0 VPWR VGND sg13cmos5l_decap_8
XFILLER_642_168 VPWR VGND sg13cmos5l_decap_8
XFILLER_711_91 VPWR VGND sg13cmos5l_decap_8
XFILLER_434_271 VPWR VGND sg13cmos5l_fill_2
XANTENNA_220 Tile_X0Y9_N4END[14] VPWR VGND sg13cmos5l_antennanp
XFILLER_45_265 VPWR VGND sg13cmos5l_decap_8
XANTENNA_231 Tile_X0Y0_FrameData[6] VPWR VGND sg13cmos5l_antennanp
XFILLER_430_70 VPWR VGND sg13cmos5l_decap_8
XFILLER_595_223 VPWR VGND sg13cmos5l_fill_1
XFILLER_444_0 VPWR VGND sg13cmos5l_decap_8
XFILLER_60_224 VPWR VGND sg13cmos5l_decap_8
XFILLER_26_70 VPWR VGND sg13cmos5l_decap_8
XFILLER_260_152 VPWR VGND sg13cmos5l_decap_8
XFILLER_595_245 VPWR VGND sg13cmos5l_fill_1
XFILLER_359_35 VPWR VGND sg13cmos5l_decap_8
XFILLER_60_257 VPWR VGND sg13cmos5l_decap_4
XFILLER_548_150 VPWR VGND sg13cmos5l_fill_2
XFILLER_347_201 VPWR VGND sg13cmos5l_decap_8
XFILLER_13_151 VPWR VGND sg13cmos5l_decap_8
XFILLER_611_0 VPWR VGND sg13cmos5l_decap_8
XFILLER_709_0 VPWR VGND sg13cmos5l_decap_8
X_0860_ _0860_/Q Tile_X0Y9_FrameData[3] VGND VPWR Tile_X0Y9_FrameStrobe[5] latch
XFILLER_509_49 VPWR VGND sg13cmos5l_decap_8
XFILLER_42_80 VPWR VGND sg13cmos5l_fill_1
XFILLER_228_28 VPWR VGND sg13cmos5l_decap_8
XFILLER_362_226 VPWR VGND sg13cmos5l_decap_8
X_0791_ _0791_/Q Tile_X0Y9_FrameData[8] VGND VPWR Tile_X0Y9_FrameStrobe[3] latch
XANTENNA__3617__X Tile_X0Y9_S2BEGb[3] VPWR VGND sg13cmos5l_antennanp
X_2530_ _2530_/Q Tile_X0Y6_FrameData[5] VGND VPWR Tile_X0Y9_FrameStrobe[2] latch
XFILLER_375_67 VPWR VGND sg13cmos5l_decap_8
XFILLER_362_259 VPWR VGND sg13cmos5l_fill_1
XFILLER_672_21 VPWR VGND sg13cmos5l_decap_8
X_2461_ _2461_/Q Tile_X0Y6_FrameData[10] VGND VPWR Tile_X0Y9_FrameStrobe[0] latch
XFILLER_370_270 VPWR VGND sg13cmos5l_fill_2
XFILLER_476_105 VPWR VGND sg13cmos5l_decap_8
XFILLER_181_192 VPWR VGND sg13cmos5l_decap_8
XFILLER_315_197 VPWR VGND sg13cmos5l_decap_4
X_4200_ _4200_/X Tile_X0Y4_W1END[2] Tile_X0Y4_W6END[6] _4350_/X _4306_/X _2177_/Q
+ _2176_/Q VPWR VGND sg13cmos5l_mux4_1
XFILLER_330_134 VPWR VGND sg13cmos5l_decap_8
X_1412_ _1412_/Q Tile_X0Y1_FrameData[21] VGND VPWR Tile_X0Y9_FrameStrobe[7] latch
X_2392_ _2392_/Q Tile_X0Y5_FrameData[13] VGND VPWR Tile_X0Y9_FrameStrobe[6] latch
XFILLER_244_49 VPWR VGND sg13cmos5l_decap_8
XFILLER_174_90 VPWR VGND sg13cmos5l_decap_8
XFILLER_122_270 VPWR VGND sg13cmos5l_fill_2
X_4131_ _4131_/X Tile_X0Y4_W2MID[6] Tile_X0Y4_W2END[6] Tile_X0Y4_W6END[6] _4315_/X
+ _2171_/Q _2170_/Q VPWR VGND sg13cmos5l_mux4_1
XFILLER_268_252 VPWR VGND sg13cmos5l_decap_8
X_1343_ _1343_/Q Tile_X0Y1_FrameData[26] VGND VPWR Tile_X0Y9_FrameStrobe[5] latch
XFILLER_541_14 VPWR VGND sg13cmos5l_decap_8
XFILLER_618_154 VPWR VGND sg13cmos5l_decap_8
XFILLER_491_119 VPWR VGND sg13cmos5l_decap_8
XFILLER_3_63 VPWR VGND sg13cmos5l_decap_8
XANTENNA__3352__X Tile_X0Y2_FrameData_O[23] VPWR VGND sg13cmos5l_antennanp
XFILLER_618_165 VPWR VGND sg13cmos5l_fill_1
XFILLER_417_216 VPWR VGND sg13cmos5l_decap_8
XFILLER_95_154 VPWR VGND sg13cmos5l_fill_2
X_4062_ _4062_/X Tile_X0Y2_WW4END[9] AXI_M_SOC_AWREADY _4125_/X _4099_/X _1549_/Q
+ _1548_/Q VPWR VGND sg13cmos5l_mux4_1
XFILLER_417_238 VPWR VGND sg13cmos5l_fill_1
X_1274_ _1274_/Q Tile_X0Y1_FrameData[31] VGND VPWR Tile_X0Y9_FrameStrobe[3] latch
XFILLER_95_198 VPWR VGND sg13cmos5l_decap_8
X_3013_ Tile_X0Y5_E6BEG[0] _4404_/X VPWR VGND sg13cmos5l_buf_1
X_0225_ _0225_/Q Tile_X0Y7_FrameData[30] VGND VPWR Tile_X0Y9_FrameStrobe[2] latch
XFILLER_36_221 VPWR VGND sg13cmos5l_decap_8
XFILLER_621_91 VPWR VGND sg13cmos5l_decap_8
XFILLER_425_271 VPWR VGND sg13cmos5l_fill_2
XFILLER_36_243 VPWR VGND sg13cmos5l_fill_2
X_0156_ _0156_/X _4447_/X _4448_/X _1354_/Q VPWR VGND sg13cmos5l_mux2_1
XFILLER_586_201 VPWR VGND sg13cmos5l_fill_2
XFILLER_251_163 VPWR VGND sg13cmos5l_decap_8
XFILLER_51_235 VPWR VGND sg13cmos5l_decap_8
XFILLER_397_156 VPWR VGND sg13cmos5l_decap_8
X_0087_ _0087_/X _4218_/X _4219_/X _0383_/Q VPWR VGND sg13cmos5l_mux2_1
XFILLER_697_84 VPWR VGND sg13cmos5l_decap_4
XFILLER_269_35 VPWR VGND sg13cmos5l_decap_8
X_3915_ _3915_/X _4122_/X _4126_/X _4107_/X _4101_/X _1643_/Q _1642_/Q VPWR VGND sg13cmos5l_mux4_1
X_4895_ _4895_/X Tile_X0Y9_N1END[3] Tile_X0Y9_W6END[3] _4899_/X _4895_/A3 _0673_/Q
+ _0928_/Q VPWR VGND sg13cmos5l_mux4_1
XFILLER_539_183 VPWR VGND sg13cmos5l_decap_8
X_3846_ _3846_/X Tile_X0Y0_W2MID[6] _3882_/X _3886_/X _3854_/X _1013_/Q _1012_/Q VPWR
+ VGND sg13cmos5l_mux4_1
XFILLER_22_28 VPWR VGND sg13cmos5l_decap_8
XFILLER_554_142 VPWR VGND sg13cmos5l_decap_8
XFILLER_419_49 VPWR VGND sg13cmos5l_decap_8
XFILLER_149_178 VPWR VGND sg13cmos5l_decap_8
XFILLER_566_77 VPWR VGND sg13cmos5l_decap_8
XFILLER_138_28 VPWR VGND sg13cmos5l_decap_8
XFILLER_164_126 VPWR VGND sg13cmos5l_decap_8
X_3777_ _3777_/X Tile_X0Y0_WW4END[6] Tile_X0Y0_WW4END[14] Tile_X0Y0_W6END[6] _3887_/X
+ _0997_/Q _0996_/Q VPWR VGND sg13cmos5l_mux4_1
XANTENNA__3527__X Tile_X0Y9_E2BEG[1] VPWR VGND sg13cmos5l_antennanp
X_0989_ _0989_/Q Tile_X0Y0_FrameData[14] VGND VPWR Tile_X0Y9_FrameStrobe[1] latch
XFILLER_716_36 VPWR VGND sg13cmos5l_fill_2
XFILLER_285_56 VPWR VGND sg13cmos5l_decap_8
X_2728_ _4893_/A3 VPWR VGND sg13cmos5l_tielo
XFILLER_306_131 VPWR VGND sg13cmos5l_decap_8
XFILLER_582_21 VPWR VGND sg13cmos5l_decap_8
XFILLER_306_153 VPWR VGND sg13cmos5l_fill_2
XFILLER_218_72 VPWR VGND sg13cmos5l_fill_1
XFILLER_510_201 VPWR VGND sg13cmos5l_decap_4
XFILLER_218_83 VPWR VGND sg13cmos5l_fill_1
X_2659_ _2659_/Q Tile_X0Y6_FrameData[4] VGND VPWR Tile_X0Y9_FrameStrobe[6] latch
XFILLER_510_234 VPWR VGND sg13cmos5l_fill_2
XFILLER_154_49 VPWR VGND sg13cmos5l_decap_8
XFILLER_582_98 VPWR VGND sg13cmos5l_decap_8
XFILLER_609_110 VPWR VGND sg13cmos5l_decap_8
XFILLER_515_70 VPWR VGND sg13cmos5l_decap_8
X_4329_ _4329_/X _3887_/X _3868_/X _3867_/X _3854_/X _1111_/Q _1110_/Q VPWR VGND sg13cmos5l_mux4_1
XFILLER_451_14 VPWR VGND sg13cmos5l_decap_8
XFILLER_609_154 VPWR VGND sg13cmos5l_fill_2
XANTENNA__3262__X Tile_X0Y0_FrameData_O[30] VPWR VGND sg13cmos5l_antennanp
XFILLER_671_219 VPWR VGND sg13cmos5l_decap_8
XFILLER_482_119 VPWR VGND sg13cmos5l_decap_8
XFILLER_234_60 VPWR VGND sg13cmos5l_decap_8
XFILLER_609_165 VPWR VGND sg13cmos5l_fill_1
XFILLER_664_271 VPWR VGND sg13cmos5l_fill_2
XFILLER_86_154 VPWR VGND sg13cmos5l_decap_8
XFILLER_609_187 VPWR VGND sg13cmos5l_decap_8
XFILLER_274_233 VPWR VGND sg13cmos5l_decap_8
XFILLER_624_157 VPWR VGND sg13cmos5l_fill_2
XFILLER_601_28 VPWR VGND sg13cmos5l_decap_8
XFILLER_27_210 VPWR VGND sg13cmos5l_decap_8
XFILLER_270_7 VPWR VGND sg13cmos5l_decap_8
XFILLER_103_42 VPWR VGND sg13cmos5l_decap_8
XFILLER_531_91 VPWR VGND sg13cmos5l_fill_1
XFILLER_490_185 VPWR VGND sg13cmos5l_decap_8
XFILLER_416_271 VPWR VGND sg13cmos5l_fill_2
XFILLER_227_193 VPWR VGND sg13cmos5l_decap_8
XFILLER_320_29 VPWR VGND sg13cmos5l_decap_8
XFILLER_63_35 VPWR VGND sg13cmos5l_decap_8
XFILLER_250_92 VPWR VGND sg13cmos5l_decap_8
XFILLER_577_234 VPWR VGND sg13cmos5l_decap_8
XFILLER_388_145 VPWR VGND sg13cmos5l_decap_8
XFILLER_535_7 VPWR VGND sg13cmos5l_decap_8
XFILLER_42_235 VPWR VGND sg13cmos5l_decap_8
XFILLER_249_4 VPWR VGND sg13cmos5l_fill_1
XFILLER_329_201 VPWR VGND sg13cmos5l_fill_2
XFILLER_592_226 VPWR VGND sg13cmos5l_decap_8
XFILLER_400_84 VPWR VGND sg13cmos5l_decap_8
XFILLER_10_110 VPWR VGND sg13cmos5l_fill_2
XFILLER_702_7 VPWR VGND sg13cmos5l_decap_8
XFILLER_195_262 VPWR VGND sg13cmos5l_decap_8
XFILLER_155_126 VPWR VGND sg13cmos5l_decap_8
XFILLER_626_14 VPWR VGND sg13cmos5l_decap_8
XFILLER_545_186 VPWR VGND sg13cmos5l_fill_1
XFILLER_560_112 VPWR VGND sg13cmos5l_decap_8
XANTENNA__3437__X Tile_X0Y4_FrameData_O[28] VPWR VGND sg13cmos5l_antennanp
XFILLER_195_56 VPWR VGND sg13cmos5l_decap_8
XFILLER_492_21 VPWR VGND sg13cmos5l_decap_8
XFILLER_560_178 VPWR VGND sg13cmos5l_fill_1
XFILLER_88_21 VPWR VGND sg13cmos5l_decap_8
XFILLER_706_91 VPWR VGND sg13cmos5l_decap_8
XFILLER_5_0 VPWR VGND sg13cmos5l_decap_8
XFILLER_501_245 VPWR VGND sg13cmos5l_decap_8
XFILLER_647_238 VPWR VGND sg13cmos5l_decap_8
XFILLER_492_98 VPWR VGND sg13cmos5l_decap_8
XFILLER_312_156 VPWR VGND sg13cmos5l_decap_4
XFILLER_642_35 VPWR VGND sg13cmos5l_decap_8
XFILLER_425_70 VPWR VGND sg13cmos5l_decap_8
XFILLER_394_0 VPWR VGND sg13cmos5l_decap_4
XFILLER_312_189 VPWR VGND sg13cmos5l_decap_8
XFILLER_662_208 VPWR VGND sg13cmos5l_decap_8
XFILLER_473_108 VPWR VGND sg13cmos5l_decap_8
XFILLER_361_14 VPWR VGND sg13cmos5l_decap_8
XANTENNA__3172__X Tile_X0Y4_E6BEG[9] VPWR VGND sg13cmos5l_antennanp
XFILLER_77_154 VPWR VGND sg13cmos5l_decap_4
XFILLER_655_271 VPWR VGND sg13cmos5l_fill_2
XFILLER_77_165 VPWR VGND sg13cmos5l_decap_8
XFILLER_92_102 VPWR VGND sg13cmos5l_decap_4
XFILLER_615_135 VPWR VGND sg13cmos5l_decap_8
XFILLER_561_0 VPWR VGND sg13cmos5l_decap_8
XFILLER_615_146 VPWR VGND sg13cmos5l_fill_1
XFILLER_659_0 VPWR VGND sg13cmos5l_decap_8
XFILLER_615_157 VPWR VGND sg13cmos5l_decap_4
XFILLER_511_28 VPWR VGND sg13cmos5l_decap_8
XFILLER_280_203 VPWR VGND sg13cmos5l_decap_4
XFILLER_615_168 VPWR VGND sg13cmos5l_decap_4
XFILLER_160_70 VPWR VGND sg13cmos5l_decap_8
XFILLER_623_190 VPWR VGND sg13cmos5l_decap_8
XFILLER_33_235 VPWR VGND sg13cmos5l_decap_8
XFILLER_667_21 VPWR VGND sg13cmos5l_decap_8
XFILLER_178_229 VPWR VGND sg13cmos5l_decap_8
X_1961_ _1961_/Q Tile_X0Y4_FrameData[28] VGND VPWR Tile_X0Y9_FrameStrobe[1] latch
X_3700_ AXI_M_SOC_WDATA10 Tile_X0Y7_WW4END[2] Tile_X0Y7_WW4END[10] Tile_X0Y7_W6END[10]
+ _4694_/X _0227_/Q _0226_/Q VPWR VGND sg13cmos5l_mux4_1
XFILLER_536_120 VPWR VGND sg13cmos5l_decap_8
X_0912_ _0912_/Q Tile_X0Y9_FrameData[15] VGND VPWR Tile_X0Y9_FrameStrobe[7] latch
XFILLER_394_159 VPWR VGND sg13cmos5l_decap_8
X_4680_ _4680_/X Tile_X0Y3_W1END[2] Tile_X0Y3_WW4END[14] Tile_X0Y3_W6END[6] _4224_/X
+ _1859_/Q _1858_/Q VPWR VGND sg13cmos5l_mux4_1
X_1892_ _1892_/Q Tile_X0Y3_FrameData[5] VGND VPWR Tile_X0Y9_FrameStrobe[6] latch
XFILLER_146_115 VPWR VGND sg13cmos5l_decap_4
X_3631_ Tile_X0Y9_S4BEG[9] _3631_/A VPWR VGND sg13cmos5l_buf_1
X_0843_ _0843_/Q Tile_X0Y9_FrameData[20] VGND VPWR Tile_X0Y9_FrameStrobe[5] latch
XFILLER_536_14 VPWR VGND sg13cmos5l_decap_8
XFILLER_536_186 VPWR VGND sg13cmos5l_decap_4
XFILLER_335_237 VPWR VGND sg13cmos5l_fill_1
XANTENNA__3347__X Tile_X0Y2_FrameData_O[18] VPWR VGND sg13cmos5l_antennanp
XFILLER_319_60 VPWR VGND sg13cmos5l_decap_8
XFILLER_683_42 VPWR VGND sg13cmos5l_fill_1
XFILLER_551_134 VPWR VGND sg13cmos5l_fill_1
X_3562_ Tile_X0Y9_EE4BEG[8] _4872_/X VPWR VGND sg13cmos5l_buf_1
X_0774_ _0774_/Q Tile_X0Y9_FrameData[25] VGND VPWR Tile_X0Y9_FrameStrobe[3] latch
XFILLER_683_64 VPWR VGND sg13cmos5l_decap_8
XFILLER_255_15 VPWR VGND sg13cmos5l_decap_8
X_2513_ _2513_/Q Tile_X0Y6_FrameData[22] VGND VPWR Tile_X0Y9_FrameStrobe[2] latch
XFILLER_154_181 VPWR VGND sg13cmos5l_decap_8
XFILLER_343_270 VPWR VGND sg13cmos5l_fill_2
X_3493_ Tile_X0Y1_E6BEG[3] _3967_/X VPWR VGND sg13cmos5l_buf_1
XFILLER_449_105 VPWR VGND sg13cmos5l_decap_8
XFILLER_638_205 VPWR VGND sg13cmos5l_decap_8
XFILLER_616_91 VPWR VGND sg13cmos5l_decap_8
X_2444_ _2444_/Q Tile_X0Y6_FrameData[27] VGND VPWR Tile_X0Y9_FrameStrobe[0] latch
XFILLER_449_149 VPWR VGND sg13cmos5l_fill_2
XFILLER_552_35 VPWR VGND sg13cmos5l_decap_8
XFILLER_335_70 VPWR VGND sg13cmos5l_decap_8
XFILLER_38_0 VPWR VGND sg13cmos5l_fill_2
XFILLER_271_14 VPWR VGND sg13cmos5l_decap_8
X_2375_ _2375_/Q Tile_X0Y5_FrameData[30] VGND VPWR Tile_X0Y9_FrameStrobe[6] latch
XANTENNA__3082__X Tile_X0Y7_E1BEG[0] VPWR VGND sg13cmos5l_antennanp
XFILLER_256_211 VPWR VGND sg13cmos5l_decap_8
X_4114_ _4114_/X Tile_X0Y6_W1END[3] Tile_X0Y6_WW4END[3] Tile_X0Y6_W6END[11] _4571_/X
+ _2662_/Q _2661_/Q VPWR VGND sg13cmos5l_mux4_1
XFILLER_68_154 VPWR VGND sg13cmos5l_decap_8
X_1326_ _1326_/Q Tile_X0Y1_FrameData[11] VGND VPWR Tile_X0Y9_FrameStrobe[4] latch
XFILLER_702_49 VPWR VGND sg13cmos5l_decap_8
XFILLER_204_63 VPWR VGND sg13cmos5l_decap_8
X_4045_ _4045_/X Tile_X0Y2_W2MID[2] AXI_M_SOC_AWREADY _4101_/X _4100_/X _1583_/Q _1582_/Q
+ VPWR VGND sg13cmos5l_mux4_1
XFILLER_421_28 VPWR VGND sg13cmos5l_decap_8
XFILLER_83_135 VPWR VGND sg13cmos5l_decap_8
X_1257_ _1257_/Q Tile_X0Y1_FrameData[16] VGND VPWR Tile_X0Y9_FrameStrobe[2] latch
XFILLER_472_163 VPWR VGND sg13cmos5l_decap_8
XFILLER_17_28 VPWR VGND sg13cmos5l_decap_8
XFILLER_621_105 VPWR VGND sg13cmos5l_decap_8
XFILLER_606_179 VPWR VGND sg13cmos5l_fill_2
XFILLER_271_225 VPWR VGND sg13cmos5l_decap_8
XFILLER_351_91 VPWR VGND sg13cmos5l_decap_8
X_0208_ _0208_/Q Tile_X0Y7_FrameData[15] VGND VPWR Tile_X0Y9_FrameStrobe[1] latch
XFILLER_271_247 VPWR VGND sg13cmos5l_decap_8
X_1188_ _1188_/Q Tile_X0Y1_FrameData[21] VGND VPWR Tile_X0Y9_FrameStrobe[0] latch
XFILLER_224_152 VPWR VGND sg13cmos5l_decap_8
XFILLER_24_224 VPWR VGND sg13cmos5l_decap_4
X_0139_ AXI_M_SOC_ARLEN0 _0933_/Q _3760_/X VPWR VGND sg13cmos5l_nor2b_1
XFILLER_577_21 VPWR VGND sg13cmos5l_decap_8
XFILLER_24_257 VPWR VGND sg13cmos5l_fill_2
XFILLER_519_109 VPWR VGND sg13cmos5l_decap_8
XFILLER_220_95 VPWR VGND sg13cmos5l_fill_2
XFILLER_574_259 VPWR VGND sg13cmos5l_decap_8
XFILLER_149_49 VPWR VGND sg13cmos5l_decap_8
XFILLER_577_98 VPWR VGND sg13cmos5l_decap_8
X_4878_ _4878_/X Tile_X0Y9_WW4END[1] AXI_M_SOC_RDATA1 _4917_/X _4903_/X _0787_/Q _0786_/Q
+ VPWR VGND sg13cmos5l_mux4_1
XFILLER_137_126 VPWR VGND sg13cmos5l_decap_8
XFILLER_527_175 VPWR VGND sg13cmos5l_fill_2
X_3829_ _3829_/X Tile_X0Y0_WW4END[6] Tile_X0Y0_WW4END[7] _3887_/X _3854_/X _1047_/Q
+ _1046_/Q VPWR VGND sg13cmos5l_mux4_1
XFILLER_542_112 VPWR VGND sg13cmos5l_decap_8
XANTENNA__3257__X Tile_X0Y0_FrameData_O[25] VPWR VGND sg13cmos5l_antennanp
XFILLER_446_36 VPWR VGND sg13cmos5l_decap_8
XFILLER_593_42 VPWR VGND sg13cmos5l_decap_8
XFILLER_116_7 VPWR VGND sg13cmos5l_decap_8
XFILLER_152_118 VPWR VGND sg13cmos5l_decap_8
XFILLER_145_170 VPWR VGND sg13cmos5l_decap_8
XFILLER_145_181 VPWR VGND sg13cmos5l_fill_2
XFILLER_160_140 VPWR VGND sg13cmos5l_decap_8
XFILLER_58_13 VPWR VGND sg13cmos5l_fill_1
XFILLER_495_244 VPWR VGND sg13cmos5l_decap_4
XFILLER_462_35 VPWR VGND sg13cmos5l_decap_8
XFILLER_181_14 VPWR VGND sg13cmos5l_decap_8
XFILLER_58_46 VPWR VGND sg13cmos5l_decap_8
XFILLER_485_7 VPWR VGND sg13cmos5l_decap_8
XFILLER_462_79 VPWR VGND sg13cmos5l_decap_8
XFILLER_247_211 VPWR VGND sg13cmos5l_decap_8
XFILLER_101_240 VPWR VGND sg13cmos5l_decap_4
XFILLER_59_165 VPWR VGND sg13cmos5l_decap_8
XFILLER_612_49 VPWR VGND sg13cmos5l_decap_8
XFILLER_74_113 VPWR VGND sg13cmos5l_decap_8
XFILLER_652_252 VPWR VGND sg13cmos5l_decap_4
XFILLER_114_63 VPWR VGND sg13cmos5l_fill_1
XFILLER_652_7 VPWR VGND sg13cmos5l_decap_8
XANTENNA__3720__X AXI_M_SOC_WDATA30 VPWR VGND sg13cmos5l_antennanp
XFILLER_114_85 VPWR VGND sg13cmos5l_decap_8
XFILLER_74_34 VPWR VGND sg13cmos5l_decap_8
XFILLER_74_45 VPWR VGND sg13cmos5l_fill_1
XFILLER_366_4 VPWR VGND sg13cmos5l_fill_1
XFILLER_261_91 VPWR VGND sg13cmos5l_decap_4
XFILLER_612_127 VPWR VGND sg13cmos5l_decap_8
XFILLER_74_67 VPWR VGND sg13cmos5l_decap_8
XFILLER_262_269 VPWR VGND sg13cmos5l_decap_4
XFILLER_15_213 VPWR VGND sg13cmos5l_decap_8
XFILLER_215_174 VPWR VGND sg13cmos5l_fill_2
XFILLER_620_160 VPWR VGND sg13cmos5l_decap_8
XFILLER_487_21 VPWR VGND sg13cmos5l_decap_8
XFILLER_230_122 VPWR VGND sg13cmos5l_decap_8
XFILLER_30_205 VPWR VGND sg13cmos5l_decap_8
XFILLER_130_84 VPWR VGND sg13cmos5l_decap_8
XFILLER_376_126 VPWR VGND sg13cmos5l_fill_2
XFILLER_142_0 VPWR VGND sg13cmos5l_decap_8
XFILLER_128_104 VPWR VGND sg13cmos5l_fill_2
XFILLER_637_35 VPWR VGND sg13cmos5l_decap_8
XFILLER_707_264 VPWR VGND sg13cmos5l_fill_1
XFILLER_356_14 VPWR VGND sg13cmos5l_decap_8
XANTENNA__3167__X Tile_X0Y4_E6BEG[4] VPWR VGND sg13cmos5l_antennanp
XFILLER_183_243 VPWR VGND sg13cmos5l_decap_8
XFILLER_533_123 VPWR VGND sg13cmos5l_decap_8
XFILLER_407_0 VPWR VGND sg13cmos5l_decap_8
XFILLER_99_42 VPWR VGND sg13cmos5l_decap_8
XFILLER_136_170 VPWR VGND sg13cmos5l_decap_4
XFILLER_506_28 VPWR VGND sg13cmos5l_decap_8
XFILLER_653_56 VPWR VGND sg13cmos5l_decap_8
XFILLER_436_91 VPWR VGND sg13cmos5l_decap_8
XFILLER_486_222 VPWR VGND sg13cmos5l_fill_1
XFILLER_297_133 VPWR VGND sg13cmos5l_fill_2
X_0490_ _0490_/Q Tile_X0Y8_FrameData[21] VGND VPWR Tile_X0Y9_FrameStrobe[2] latch
XFILLER_151_173 VPWR VGND sg13cmos5l_decap_8
XFILLER_372_57 VPWR VGND sg13cmos5l_fill_1
XFILLER_31_7 VPWR VGND sg13cmos5l_decap_8
XFILLER_2_183 VPWR VGND sg13cmos5l_decap_8
XFILLER_372_79 VPWR VGND sg13cmos5l_fill_1
XFILLER_439_182 VPWR VGND sg13cmos5l_decap_8
X_2160_ _2160_/Q Tile_X0Y4_FrameData[21] VGND VPWR Tile_X0Y9_FrameStrobe[7] latch
XFILLER_522_49 VPWR VGND sg13cmos5l_decap_4
XFILLER_238_255 VPWR VGND sg13cmos5l_decap_4
X_1111_ _1111_/Q Tile_X0Y0_FrameData[20] VGND VPWR Tile_X0Y9_FrameStrobe[5] latch
XFILLER_643_252 VPWR VGND sg13cmos5l_fill_2
XFILLER_253_203 VPWR VGND sg13cmos5l_decap_8
XFILLER_241_28 VPWR VGND sg13cmos5l_decap_8
X_2091_ _2091_/Q Tile_X0Y4_FrameData[26] VGND VPWR Tile_X0Y9_FrameStrobe[5] latch
XANTENNA__3630__X Tile_X0Y9_S4BEG[8] VPWR VGND sg13cmos5l_antennanp
XFILLER_253_225 VPWR VGND sg13cmos5l_decap_8
XFILLER_65_168 VPWR VGND sg13cmos5l_decap_8
XFILLER_0_42 VPWR VGND sg13cmos5l_decap_8
X_1042_ _1042_/Q Tile_X0Y0_FrameData[25] VGND VPWR Tile_X0Y9_FrameStrobe[3] latch
XFILLER_206_130 VPWR VGND sg13cmos5l_decap_8
XFILLER_80_127 VPWR VGND sg13cmos5l_decap_8
XFILLER_678_42 VPWR VGND sg13cmos5l_decap_8
XFILLER_206_174 VPWR VGND sg13cmos5l_decap_4
XFILLER_410_200 VPWR VGND sg13cmos5l_fill_2
XFILLER_221_111 VPWR VGND sg13cmos5l_decap_8
XFILLER_397_21 VPWR VGND sg13cmos5l_decap_8
X_4801_ _4801_/X _4779_/X Tile_X0Y9_N4END[5] _4778_/X _0076_/X _0469_/Q _0468_/Q VPWR
+ VGND sg13cmos5l_mux4_1
X_2993_ Tile_X0Y5_E1BEG[0] _4368_/X VPWR VGND sg13cmos5l_buf_1
XFILLER_410_244 VPWR VGND sg13cmos5l_decap_8
X_1944_ _1944_/Q Tile_X0Y4_FrameData[13] VGND VPWR Tile_X0Y9_FrameStrobe[0] latch
X_4732_ _4732_/X Tile_X0Y8_W2MID[3] AXI_M_SOC_RDATA12 _4791_/X _4790_/X _0583_/Q _0582_/Q
+ VPWR VGND sg13cmos5l_mux4_1
XFILLER_547_35 VPWR VGND sg13cmos5l_decap_8
XFILLER_9_84 VPWR VGND sg13cmos5l_decap_8
XFILLER_509_175 VPWR VGND sg13cmos5l_decap_4
XFILLER_713_201 VPWR VGND sg13cmos5l_decap_8
X_4663_ _4663_/X Tile_X0Y8_W1END[1] Tile_X0Y8_W6END[5] _4813_/X _4773_/X _0669_/Q
+ _0668_/Q VPWR VGND sg13cmos5l_mux4_1
XFILLER_694_63 VPWR VGND sg13cmos5l_decap_8
XFILLER_266_14 VPWR VGND sg13cmos5l_decap_8
XFILLER_119_137 VPWR VGND sg13cmos5l_decap_4
X_1875_ _1875_/Q Tile_X0Y3_FrameData[22] VGND VPWR Tile_X0Y9_FrameStrobe[6] latch
XFILLER_375_181 VPWR VGND sg13cmos5l_decap_8
XANTENNA__3077__X Tile_X0Y4_E2BEGb[3] VPWR VGND sg13cmos5l_antennanp
X_3614_ Tile_X0Y9_S2BEGb[0] _4932_/X VPWR VGND sg13cmos5l_buf_1
X_0826_ _0826_/Q Tile_X0Y9_FrameData[5] VGND VPWR Tile_X0Y9_FrameStrobe[4] latch
X_4594_ _4594_/X Tile_X0Y5_W1END[1] Tile_X0Y5_W2MID[2] Tile_X0Y5_W2END[2] _4431_/X
+ _2385_/Q _2384_/Q VPWR VGND sg13cmos5l_mux4_1
XFILLER_323_207 VPWR VGND sg13cmos5l_decap_8
X_3545_ Tile_X0Y9_E6BEG[3] _4883_/X VPWR VGND sg13cmos5l_buf_1
XFILLER_416_28 VPWR VGND sg13cmos5l_decap_8
X_0757_ _0757_/Q Tile_X0Y9_FrameData[10] VGND VPWR Tile_X0Y9_FrameStrobe[2] latch
XFILLER_563_56 VPWR VGND sg13cmos5l_decap_8
XFILLER_477_211 VPWR VGND sg13cmos5l_decap_8
XFILLER_288_122 VPWR VGND sg13cmos5l_decap_8
X_3476_ Tile_X0Y1_EE4BEG[2] _3950_/X VPWR VGND sg13cmos5l_buf_1
X_0688_ _0688_/Q Tile_X0Y9_FrameData[15] VGND VPWR Tile_X0Y9_FrameStrobe[0] latch
XFILLER_282_35 VPWR VGND sg13cmos5l_decap_8
XFILLER_713_26 VPWR VGND sg13cmos5l_decap_8
XFILLER_477_255 VPWR VGND sg13cmos5l_decap_8
X_2427_ _2427_/Q Tile_X0Y5_FrameData[10] VGND VPWR Tile_X0Y9_FrameStrobe[7] latch
XFILLER_437_119 VPWR VGND sg13cmos5l_decap_8
XFILLER_288_199 VPWR VGND sg13cmos5l_decap_8
XFILLER_229_222 VPWR VGND sg13cmos5l_fill_2
XFILLER_492_236 VPWR VGND sg13cmos5l_decap_8
X_2358_ _2358_/Q Tile_X0Y5_FrameData[15] VGND VPWR Tile_X0Y9_FrameStrobe[5] latch
XFILLER_432_49 VPWR VGND sg13cmos5l_decap_8
XFILLER_96_271 VPWR VGND sg13cmos5l_fill_2
XFILLER_56_102 VPWR VGND sg13cmos5l_decap_8
XFILLER_215_95 VPWR VGND sg13cmos5l_decap_8
XFILLER_151_28 VPWR VGND sg13cmos5l_decap_8
X_1309_ _1309_/Q Tile_X0Y1_FrameData[28] VGND VPWR Tile_X0Y9_FrameStrobe[4] latch
XANTENNA__3540__X Tile_X0Y9_E2BEGb[6] VPWR VGND sg13cmos5l_antennanp
X_2289_ _2289_/Q Tile_X0Y5_FrameData[20] VGND VPWR Tile_X0Y9_FrameStrobe[3] latch
X_4028_ _4028_/X Tile_X0Y0_W1END[0] Tile_X0Y0_W2MID[3] Tile_X0Y0_W2END[3] _3858_/X
+ _1125_/Q _1124_/Q VPWR VGND sg13cmos5l_mux4_1
XFILLER_244_247 VPWR VGND sg13cmos5l_decap_8
XFILLER_460_144 VPWR VGND sg13cmos5l_decap_8
XFILLER_460_155 VPWR VGND sg13cmos5l_fill_2
XFILLER_588_42 VPWR VGND sg13cmos5l_decap_8
XFILLER_44_26 VPWR VGND sg13cmos5l_fill_2
XFILLER_398_251 VPWR VGND sg13cmos5l_decap_8
XFILLER_460_199 VPWR VGND sg13cmos5l_decap_8
XFILLER_44_48 VPWR VGND sg13cmos5l_fill_1
XFILLER_212_133 VPWR VGND sg13cmos5l_decap_8
XFILLER_588_97 VPWR VGND sg13cmos5l_decap_8
XFILLER_358_126 VPWR VGND sg13cmos5l_decap_8
XFILLER_602_193 VPWR VGND sg13cmos5l_decap_8
XFILLER_100_21 VPWR VGND sg13cmos5l_decap_8
XFILLER_547_248 VPWR VGND sg13cmos5l_decap_4
XFILLER_547_259 VPWR VGND sg13cmos5l_decap_4
XFILLER_233_7 VPWR VGND sg13cmos5l_decap_8
XFILLER_60_14 VPWR VGND sg13cmos5l_fill_2
XFILLER_457_35 VPWR VGND sg13cmos5l_decap_8
XFILLER_60_36 VPWR VGND sg13cmos5l_decap_8
XFILLER_373_129 VPWR VGND sg13cmos5l_fill_1
XFILLER_100_98 VPWR VGND sg13cmos5l_decap_4
XFILLER_176_14 VPWR VGND sg13cmos5l_decap_8
XFILLER_20_271 VPWR VGND sg13cmos5l_fill_2
XFILLER_60_69 VPWR VGND sg13cmos5l_decap_8
XFILLER_400_7 VPWR VGND sg13cmos5l_decap_8
XFILLER_607_49 VPWR VGND sg13cmos5l_decap_8
XFILLER_381_162 VPWR VGND sg13cmos5l_fill_1
XFILLER_515_178 VPWR VGND sg13cmos5l_decap_8
XANTENNA__0123__Y AXI_M_SOC_ARSIZE2 VPWR VGND sg13cmos5l_antennanp
XFILLER_109_52 VPWR VGND sg13cmos5l_fill_1
XFILLER_326_28 VPWR VGND sg13cmos5l_decap_8
XFILLER_109_74 VPWR VGND sg13cmos5l_fill_2
XFILLER_530_137 VPWR VGND sg13cmos5l_decap_8
XANTENNA__3715__X AXI_M_SOC_WDATA25 VPWR VGND sg13cmos5l_antennanp
XFILLER_669_160 VPWR VGND sg13cmos5l_decap_4
XFILLER_473_56 VPWR VGND sg13cmos5l_decap_8
XFILLER_669_182 VPWR VGND sg13cmos5l_fill_1
XFILLER_279_133 VPWR VGND sg13cmos5l_decap_8
XFILLER_69_56 VPWR VGND sg13cmos5l_decap_8
XFILLER_468_244 VPWR VGND sg13cmos5l_decap_8
XFILLER_468_255 VPWR VGND sg13cmos5l_fill_1
XFILLER_428_119 VPWR VGND sg13cmos5l_decap_8
XFILLER_617_219 VPWR VGND sg13cmos5l_fill_2
XFILLER_684_185 VPWR VGND sg13cmos5l_decap_8
XFILLER_294_136 VPWR VGND sg13cmos5l_fill_2
XFILLER_87_271 VPWR VGND sg13cmos5l_fill_2
XFILLER_483_258 VPWR VGND sg13cmos5l_fill_1
XFILLER_342_49 VPWR VGND sg13cmos5l_decap_8
XFILLER_125_95 VPWR VGND sg13cmos5l_decap_8
XFILLER_703_70 VPWR VGND sg13cmos5l_decap_8
XFILLER_85_77 VPWR VGND sg13cmos5l_decap_4
XFILLER_436_174 VPWR VGND sg13cmos5l_decap_8
XANTENNA__3450__X Tile_X0Y1_FrameData_O[8] VPWR VGND sg13cmos5l_antennanp
XFILLER_235_225 VPWR VGND sg13cmos5l_decap_8
XFILLER_597_104 VPWR VGND sg13cmos5l_decap_4
XFILLER_451_133 VPWR VGND sg13cmos5l_decap_8
XFILLER_62_138 VPWR VGND sg13cmos5l_decap_8
XFILLER_498_42 VPWR VGND sg13cmos5l_decap_8
XFILLER_357_0 VPWR VGND sg13cmos5l_decap_8
XFILLER_451_177 VPWR VGND sg13cmos5l_decap_8
XFILLER_250_228 VPWR VGND sg13cmos5l_decap_8
XFILLER_538_215 VPWR VGND sg13cmos5l_decap_8
XFILLER_349_126 VPWR VGND sg13cmos5l_decap_8
XFILLER_70_182 VPWR VGND sg13cmos5l_decap_4
XFILLER_524_0 VPWR VGND sg13cmos5l_decap_8
XFILLER_648_56 VPWR VGND sg13cmos5l_decap_8
XFILLER_553_218 VPWR VGND sg13cmos5l_decap_8
XFILLER_364_118 VPWR VGND sg13cmos5l_decap_8
XFILLER_156_210 VPWR VGND sg13cmos5l_decap_8
XFILLER_367_57 VPWR VGND sg13cmos5l_decap_8
XFILLER_506_112 VPWR VGND sg13cmos5l_decap_4
XFILLER_79_7 VPWR VGND sg13cmos5l_decap_8
XFILLER_506_145 VPWR VGND sg13cmos5l_decap_4
X_1660_ _1660_/Q Tile_X0Y2_FrameData[21] VGND VPWR Tile_X0Y9_FrameStrobe[7] latch
XFILLER_517_49 VPWR VGND sg13cmos5l_decap_8
XFILLER_116_118 VPWR VGND sg13cmos5l_decap_8
XFILLER_171_213 VPWR VGND sg13cmos5l_decap_8
X_0611_ _0611_/Q Tile_X0Y8_FrameData[28] VGND VPWR Tile_X0Y9_FrameStrobe[6] latch
XFILLER_521_115 VPWR VGND sg13cmos5l_decap_4
XFILLER_521_126 VPWR VGND sg13cmos5l_fill_2
XFILLER_236_28 VPWR VGND sg13cmos5l_decap_8
X_1591_ _1591_/Q Tile_X0Y2_FrameData[26] VGND VPWR Tile_X0Y9_FrameStrobe[5] latch
XFILLER_667_119 VPWR VGND sg13cmos5l_decap_4
XANTENNA__3625__X Tile_X0Y9_S4BEG[3] VPWR VGND sg13cmos5l_antennanp
XFILLER_710_248 VPWR VGND sg13cmos5l_fill_1
XFILLER_124_140 VPWR VGND sg13cmos5l_decap_8
X_3330_ Tile_X0Y2_FrameData_O[1] Tile_X0Y2_FrameData[1] VPWR VGND sg13cmos5l_buf_1
X_0542_ _0542_/Q Tile_X0Y8_FrameData[1] VGND VPWR Tile_X0Y9_FrameStrobe[3] latch
XFILLER_680_21 VPWR VGND sg13cmos5l_decap_4
X_3261_ Tile_X0Y0_FrameData_O[29] Tile_X0Y0_FrameData[29] VPWR VGND sg13cmos5l_buf_1
XFILLER_474_203 VPWR VGND sg13cmos5l_decap_8
XFILLER_419_108 VPWR VGND sg13cmos5l_decap_8
X_0473_ _0473_/Q Tile_X0Y8_FrameData[6] VGND VPWR Tile_X0Y9_FrameStrobe[1] latch
XFILLER_316_94 VPWR VGND sg13cmos5l_fill_2
XFILLER_680_76 VPWR VGND sg13cmos5l_decap_8
X_2212_ _2212_/Q Tile_X0Y5_FrameData[1] VGND VPWR Tile_X0Y9_FrameStrobe[0] latch
XFILLER_285_147 VPWR VGND sg13cmos5l_decap_8
XFILLER_85_219 VPWR VGND sg13cmos5l_decap_8
X_3192_ Tile_X0Y0_N2BEGb[0] _3889_/X VPWR VGND sg13cmos5l_buf_1
XFILLER_252_49 VPWR VGND sg13cmos5l_decap_8
XFILLER_613_70 VPWR VGND sg13cmos5l_decap_8
X_2143_ _2143_/Q Tile_X0Y4_FrameData[6] VGND VPWR Tile_X0Y9_FrameStrobe[6] latch
XANTENNA__3360__X Tile_X0Y2_FrameData_O[31] VPWR VGND sg13cmos5l_antennanp
XFILLER_226_225 VPWR VGND sg13cmos5l_decap_4
XFILLER_226_236 VPWR VGND sg13cmos5l_fill_2
XFILLER_38_157 VPWR VGND sg13cmos5l_decap_8
XFILLER_93_263 VPWR VGND sg13cmos5l_fill_2
XFILLER_588_104 VPWR VGND sg13cmos5l_fill_2
XFILLER_427_196 VPWR VGND sg13cmos5l_decap_8
X_2074_ _2074_/Q Tile_X0Y4_FrameData[11] VGND VPWR Tile_X0Y9_FrameStrobe[4] latch
XFILLER_689_85 VPWR VGND sg13cmos5l_decap_8
XFILLER_631_255 VPWR VGND sg13cmos5l_decap_8
X_1025_ _1025_/Q Tile_X0Y0_FrameData[10] VGND VPWR Tile_X0Y9_FrameStrobe[2] latch
XFILLER_201_42 VPWR VGND sg13cmos5l_decap_8
XFILLER_61_182 VPWR VGND sg13cmos5l_decap_8
XFILLER_529_237 VPWR VGND sg13cmos5l_decap_8
XFILLER_558_56 VPWR VGND sg13cmos5l_decap_8
X_2976_ Tile_X0Y8_FrameData_O[16] Tile_X0Y8_FrameData[16] VPWR VGND sg13cmos5l_buf_1
XFILLER_277_35 VPWR VGND sg13cmos5l_decap_8
XFILLER_147_221 VPWR VGND sg13cmos5l_decap_8
X_4715_ _4715_/X Tile_X0Y9_W2MID[0] Tile_X0Y9_W2END[0] Tile_X0Y9_W6END[0] _4900_/X
+ _0905_/Q _0904_/Q VPWR VGND sg13cmos5l_mux4_1
XFILLER_147_232 VPWR VGND sg13cmos5l_fill_2
X_1927_ _1927_/Q Tile_X0Y4_FrameData[30] VGND VPWR Tile_X0Y9_FrameStrobe[0] latch
XFILLER_348_192 VPWR VGND sg13cmos5l_decap_8
X_1858_ _1858_/Q Tile_X0Y3_FrameData[7] VGND VPWR Tile_X0Y9_FrameStrobe[5] latch
X_4646_ _4646_/X Tile_X0Y9_N4END[10] _0054_/X _4693_/X _4697_/X _0267_/Q _0266_/Q
+ VPWR VGND sg13cmos5l_mux4_1
XFILLER_552_262 VPWR VGND sg13cmos5l_fill_2
XFILLER_427_49 VPWR VGND sg13cmos5l_decap_8
XFILLER_146_28 VPWR VGND sg13cmos5l_decap_8
X_0809_ _0809_/Q Tile_X0Y9_FrameData[22] VGND VPWR Tile_X0Y9_FrameStrobe[4] latch
XFILLER_574_77 VPWR VGND sg13cmos5l_decap_8
X_4577_ _4577_/X _4547_/X Tile_X0Y9_N4END[13] _4546_/X _0153_/X _2477_/Q _2476_/Q
+ VPWR VGND sg13cmos5l_mux4_1
XFILLER_512_126 VPWR VGND sg13cmos5l_decap_8
X_1789_ _1789_/Q Tile_X0Y3_FrameData[12] VGND VPWR Tile_X0Y9_FrameStrobe[3] latch
XANTENNA__3535__X Tile_X0Y9_E2BEGb[1] VPWR VGND sg13cmos5l_antennanp
XFILLER_162_268 VPWR VGND sg13cmos5l_decap_4
XFILLER_512_148 VPWR VGND sg13cmos5l_decap_8
XFILLER_293_56 VPWR VGND sg13cmos5l_decap_8
X_3528_ Tile_X0Y9_E2BEG[2] _4850_/X VPWR VGND sg13cmos5l_buf_1
XFILLER_590_21 VPWR VGND sg13cmos5l_decap_8
XFILLER_304_262 VPWR VGND sg13cmos5l_fill_2
XFILLER_666_152 VPWR VGND sg13cmos5l_fill_1
X_3459_ Tile_X0Y1_FrameData_O[17] Tile_X0Y1_FrameData[17] VPWR VGND sg13cmos5l_buf_1
XFILLER_681_100 VPWR VGND sg13cmos5l_fill_2
XFILLER_666_174 VPWR VGND sg13cmos5l_decap_8
XFILLER_465_214 VPWR VGND sg13cmos5l_decap_8
XFILLER_130_154 VPWR VGND sg13cmos5l_decap_8
XFILLER_76_208 VPWR VGND sg13cmos5l_fill_2
XFILLER_162_49 VPWR VGND sg13cmos5l_decap_8
XFILLER_607_230 VPWR VGND sg13cmos5l_fill_1
XFILLER_523_70 VPWR VGND sg13cmos5l_decap_8
XFILLER_288_8 VPWR VGND sg13cmos5l_decap_8
XFILLER_480_206 VPWR VGND sg13cmos5l_decap_8
XFILLER_29_124 VPWR VGND sg13cmos5l_decap_4
XFILLER_183_7 VPWR VGND sg13cmos5l_decap_8
XANTENNA__3270__X Tile_X0Y0_EE4BEG[6] VPWR VGND sg13cmos5l_antennanp
XFILLER_433_122 VPWR VGND sg13cmos5l_decap_8
XFILLER_29_179 VPWR VGND sg13cmos5l_fill_1
XFILLER_599_63 VPWR VGND sg13cmos5l_decap_8
XFILLER_55_69 VPWR VGND sg13cmos5l_decap_8
XFILLER_44_138 VPWR VGND sg13cmos5l_decap_8
XFILLER_350_7 VPWR VGND sg13cmos5l_decap_8
XFILLER_232_217 VPWR VGND sg13cmos5l_decap_8
XFILLER_448_7 VPWR VGND sg13cmos5l_decap_8
XFILLER_433_188 VPWR VGND sg13cmos5l_decap_8
XFILLER_594_107 VPWR VGND sg13cmos5l_decap_8
XFILLER_111_42 VPWR VGND sg13cmos5l_decap_8
XANTENNA__0118__Y AXI_M_SOC_ARBURST1 VPWR VGND sg13cmos5l_antennanp
XFILLER_587_192 VPWR VGND sg13cmos5l_decap_8
XFILLER_240_250 VPWR VGND sg13cmos5l_decap_8
XFILLER_111_86 VPWR VGND sg13cmos5l_fill_1
XFILLER_71_35 VPWR VGND sg13cmos5l_decap_8
XFILLER_468_56 VPWR VGND sg13cmos5l_decap_8
XFILLER_615_7 VPWR VGND sg13cmos5l_decap_8
XFILLER_468_67 VPWR VGND sg13cmos5l_fill_2
XFILLER_240_272 VPWR VGND sg13cmos5l_fill_1
XFILLER_329_4 VPWR VGND sg13cmos5l_fill_1
XFILLER_138_210 VPWR VGND sg13cmos5l_decap_8
XFILLER_200_158 VPWR VGND sg13cmos5l_decap_4
XFILLER_187_79 VPWR VGND sg13cmos5l_decap_8
XFILLER_200_169 VPWR VGND sg13cmos5l_decap_8
XFILLER_689_211 VPWR VGND sg13cmos5l_fill_2
XFILLER_354_140 VPWR VGND sg13cmos5l_decap_8
XFILLER_153_213 VPWR VGND sg13cmos5l_decap_8
XFILLER_689_255 VPWR VGND sg13cmos5l_decap_8
XFILLER_153_235 VPWR VGND sg13cmos5l_fill_2
XFILLER_484_77 VPWR VGND sg13cmos5l_decap_8
XFILLER_634_14 VPWR VGND sg13cmos5l_decap_8
XFILLER_503_126 VPWR VGND sg13cmos5l_decap_8
XFILLER_299_228 VPWR VGND sg13cmos5l_decap_8
XFILLER_649_119 VPWR VGND sg13cmos5l_decap_8
XFILLER_4_234 VPWR VGND sg13cmos5l_fill_1
XFILLER_484_99 VPWR VGND sg13cmos5l_fill_2
XANTENNA__3445__X Tile_X0Y1_FrameData_O[3] VPWR VGND sg13cmos5l_antennanp
XFILLER_105_0 VPWR VGND sg13cmos5l_decap_8
XFILLER_4_256 VPWR VGND sg13cmos5l_decap_4
XFILLER_657_130 VPWR VGND sg13cmos5l_decap_8
XFILLER_96_21 VPWR VGND sg13cmos5l_decap_8
XFILLER_310_210 VPWR VGND sg13cmos5l_decap_8
XFILLER_310_221 VPWR VGND sg13cmos5l_fill_1
XFILLER_456_214 VPWR VGND sg13cmos5l_fill_1
XFILLER_456_225 VPWR VGND sg13cmos5l_fill_2
XFILLER_121_154 VPWR VGND sg13cmos5l_decap_8
XFILLER_714_91 VPWR VGND sg13cmos5l_decap_8
XFILLER_310_254 VPWR VGND sg13cmos5l_decap_8
XFILLER_267_169 VPWR VGND sg13cmos5l_fill_2
XFILLER_650_35 VPWR VGND sg13cmos5l_decap_8
XFILLER_433_70 VPWR VGND sg13cmos5l_decap_8
XFILLER_474_0 VPWR VGND sg13cmos5l_decap_8
XFILLER_208_203 VPWR VGND sg13cmos5l_decap_8
XFILLER_672_166 VPWR VGND sg13cmos5l_decap_8
XFILLER_672_188 VPWR VGND sg13cmos5l_decap_8
XANTENNA__3180__X Tile_X0Y0_N4BEG[4] VPWR VGND sg13cmos5l_antennanp
XFILLER_613_200 VPWR VGND sg13cmos5l_fill_1
XFILLER_152_82 VPWR VGND sg13cmos5l_fill_1
XFILLER_424_133 VPWR VGND sg13cmos5l_decap_8
XFILLER_641_0 VPWR VGND sg13cmos5l_decap_8
XFILLER_90_233 VPWR VGND sg13cmos5l_fill_2
XFILLER_613_266 VPWR VGND sg13cmos5l_decap_8
XFILLER_302_63 VPWR VGND sg13cmos5l_decap_4
XFILLER_290_172 VPWR VGND sg13cmos5l_decap_8
XFILLER_302_96 VPWR VGND sg13cmos5l_decap_8
XFILLER_188_121 VPWR VGND sg13cmos5l_decap_8
XFILLER_188_132 VPWR VGND sg13cmos5l_fill_1
XFILLER_377_243 VPWR VGND sg13cmos5l_decap_8
XFILLER_188_154 VPWR VGND sg13cmos5l_decap_8
X_2830_ Tile_X0Y4_UserCLKo Tile_X0Y4_UserCLK VPWR VGND sg13cmos5l_buf_1
XFILLER_231_272 VPWR VGND sg13cmos5l_fill_1
XFILLER_675_21 VPWR VGND sg13cmos5l_decap_8
XFILLER_378_89 VPWR VGND sg13cmos5l_decap_4
XFILLER_593_173 VPWR VGND sg13cmos5l_fill_1
X_2761_ Tile_X0Y3_FrameData_O[19] Tile_X0Y3_FrameData[19] VPWR VGND sg13cmos5l_buf_1
XFILLER_129_254 VPWR VGND sg13cmos5l_fill_1
XFILLER_394_22 VPWR VGND sg13cmos5l_decap_8
X_1712_ _1712_/Q Tile_X0Y3_FrameData[25] VGND VPWR Tile_X0Y9_FrameStrobe[1] latch
X_4500_ _4500_/X Tile_X0Y6_W2MID[3] AXI_M_SOC_RDATA28 _4559_/X _4558_/X _2607_/Q _2606_/Q
+ VPWR VGND sg13cmos5l_mux4_1
X_2692_ _2692_/Q Tile_X0Y6_FrameData[3] VGND VPWR Tile_X0Y9_FrameStrobe[7] latch
XFILLER_534_251 VPWR VGND sg13cmos5l_decap_8
XFILLER_608_70 VPWR VGND sg13cmos5l_decap_8
XFILLER_144_224 VPWR VGND sg13cmos5l_decap_8
XFILLER_394_66 VPWR VGND sg13cmos5l_decap_8
XANTENNA_1 _3688_/X VPWR VGND sg13cmos5l_antennanp
X_4431_ _4431_/X _4363_/X _4479_/X _4478_/X _4362_/X _2195_/Q _2194_/Q VPWR VGND sg13cmos5l_mux4_1
X_1643_ _1643_/Q Tile_X0Y2_FrameData[6] VGND VPWR Tile_X0Y9_FrameStrobe[6] latch
XFILLER_544_14 VPWR VGND sg13cmos5l_decap_8
XANTENNA__3355__X Tile_X0Y2_FrameData_O[26] VPWR VGND sg13cmos5l_antennanp
XFILLER_6_63 VPWR VGND sg13cmos5l_decap_8
XFILLER_144_268 VPWR VGND sg13cmos5l_decap_4
XFILLER_691_42 VPWR VGND sg13cmos5l_decap_8
X_4362_ _4362_/X Tile_X0Y3_W1END[1] Tile_X0Y3_W2MID[2] Tile_X0Y3_W2END[2] _4208_/X
+ _1871_/Q _1870_/Q VPWR VGND sg13cmos5l_mux4_1
X_1574_ _1574_/Q Tile_X0Y2_FrameData[11] VGND VPWR Tile_X0Y9_FrameStrobe[4] latch
XFILLER_327_93 VPWR VGND sg13cmos5l_decap_8
XFILLER_298_250 VPWR VGND sg13cmos5l_decap_8
X_3313_ Tile_X0Y4_EE4BEG[1] _4273_/X VPWR VGND sg13cmos5l_buf_1
XFILLER_301_210 VPWR VGND sg13cmos5l_fill_1
X_0525_ _0525_/Q Tile_X0Y8_FrameData[18] VGND VPWR Tile_X0Y9_FrameStrobe[3] latch
XFILLER_691_97 VPWR VGND sg13cmos5l_decap_8
XFILLER_298_272 VPWR VGND sg13cmos5l_fill_1
X_4293_ _4293_/X AXI_M_SOC_BRESP1 _4342_/X _4346_/X _4315_/X _2027_/Q _2026_/Q VPWR
+ VGND sg13cmos5l_mux4_1
XFILLER_648_163 VPWR VGND sg13cmos5l_fill_1
XFILLER_447_214 VPWR VGND sg13cmos5l_decap_8
XFILLER_258_125 VPWR VGND sg13cmos5l_decap_8
X_3244_ Tile_X0Y0_FrameData_O[12] Tile_X0Y0_FrameData[12] VPWR VGND sg13cmos5l_buf_1
XFILLER_112_176 VPWR VGND sg13cmos5l_decap_8
X_0456_ _0456_/Q Tile_X0Y8_FrameData[23] VGND VPWR Tile_X0Y9_FrameStrobe[1] latch
XFILLER_20_0 VPWR VGND sg13cmos5l_decap_8
XFILLER_560_35 VPWR VGND sg13cmos5l_decap_8
XFILLER_343_70 VPWR VGND sg13cmos5l_decap_8
X_3175_ Tile_X0Y0_UserCLKo Tile_X0Y0_UserCLK VPWR VGND sg13cmos5l_buf_1
XANTENNA__3090__X Tile_X0Y7_E2BEG[4] VPWR VGND sg13cmos5l_antennanp
X_0387_ _0387_/Q Tile_X0Y7_FrameData[28] VGND VPWR Tile_X0Y9_FrameStrobe[7] latch
XFILLER_415_100 VPWR VGND sg13cmos5l_decap_8
X_2126_ _2126_/Q Tile_X0Y4_FrameData[23] VGND VPWR Tile_X0Y9_FrameStrobe[6] latch
XFILLER_604_222 VPWR VGND sg13cmos5l_fill_2
XFILLER_604_233 VPWR VGND sg13cmos5l_fill_2
XFILLER_710_49 VPWR VGND sg13cmos5l_decap_8
XFILLER_281_161 VPWR VGND sg13cmos5l_decap_8
XFILLER_26_149 VPWR VGND sg13cmos5l_decap_8
XFILLER_19_190 VPWR VGND sg13cmos5l_decap_8
XFILLER_212_63 VPWR VGND sg13cmos5l_decap_8
X_2057_ _2057_/Q Tile_X0Y4_FrameData[28] VGND VPWR Tile_X0Y9_FrameStrobe[4] latch
XFILLER_415_199 VPWR VGND sg13cmos5l_decap_8
XFILLER_25_28 VPWR VGND sg13cmos5l_decap_8
X_1008_ _1008_/Q Tile_X0Y0_FrameData[27] VGND VPWR Tile_X0Y9_FrameStrobe[2] latch
XFILLER_430_147 VPWR VGND sg13cmos5l_decap_8
XFILLER_368_210 VPWR VGND sg13cmos5l_decap_4
XFILLER_179_121 VPWR VGND sg13cmos5l_fill_2
XFILLER_569_77 VPWR VGND sg13cmos5l_decap_8
XFILLER_179_165 VPWR VGND sg13cmos5l_decap_8
XFILLER_222_272 VPWR VGND sg13cmos5l_fill_1
XFILLER_584_151 VPWR VGND sg13cmos5l_decap_8
XFILLER_288_78 VPWR VGND sg13cmos5l_decap_8
XFILLER_194_124 VPWR VGND sg13cmos5l_decap_8
XFILLER_585_21 VPWR VGND sg13cmos5l_decap_8
XFILLER_383_224 VPWR VGND sg13cmos5l_decap_8
X_2959_ Tile_X0Y8_EE4BEG[15] _4759_/X VPWR VGND sg13cmos5l_buf_1
XFILLER_383_268 VPWR VGND sg13cmos5l_decap_4
XFILLER_336_140 VPWR VGND sg13cmos5l_fill_1
XFILLER_518_70 VPWR VGND sg13cmos5l_decap_8
XFILLER_135_246 VPWR VGND sg13cmos5l_decap_8
X_4629_ _4629_/X Tile_X0Y7_WW4END[14] AXI_M_SOC_RDATA17 _4698_/X _4670_/X _0301_/Q
+ _0300_/Q VPWR VGND sg13cmos5l_mux4_1
XFILLER_454_14 VPWR VGND sg13cmos5l_decap_8
XANTENNA__3265__X Tile_X0Y0_EE4BEG[1] VPWR VGND sg13cmos5l_antennanp
XFILLER_351_154 VPWR VGND sg13cmos5l_decap_8
XFILLER_540_254 VPWR VGND sg13cmos5l_decap_8
XFILLER_497_147 VPWR VGND sg13cmos5l_decap_8
XFILLER_1_215 VPWR VGND sg13cmos5l_decap_8
XFILLER_9_7 VPWR VGND sg13cmos5l_decap_8
XFILLER_454_69 VPWR VGND sg13cmos5l_decap_8
XFILLER_289_261 VPWR VGND sg13cmos5l_decap_4
XFILLER_1_237 VPWR VGND sg13cmos5l_fill_2
XFILLER_289_272 VPWR VGND sg13cmos5l_fill_1
XFILLER_604_28 VPWR VGND sg13cmos5l_decap_8
XFILLER_398_7 VPWR VGND sg13cmos5l_decap_8
XFILLER_103_154 VPWR VGND sg13cmos5l_decap_8
XFILLER_654_111 VPWR VGND sg13cmos5l_decap_8
XFILLER_49_208 VPWR VGND sg13cmos5l_decap_8
XFILLER_639_196 VPWR VGND sg13cmos5l_decap_8
XFILLER_470_35 VPWR VGND sg13cmos5l_decap_8
XFILLER_323_29 VPWR VGND sg13cmos5l_fill_2
XFILLER_66_35 VPWR VGND sg13cmos5l_decap_8
XFILLER_453_217 VPWR VGND sg13cmos5l_fill_2
XFILLER_654_177 VPWR VGND sg13cmos5l_decap_8
XFILLER_565_7 VPWR VGND sg13cmos5l_decap_8
XFILLER_620_49 VPWR VGND sg13cmos5l_decap_8
XFILLER_205_217 VPWR VGND sg13cmos5l_decap_8
XFILLER_122_63 VPWR VGND sg13cmos5l_decap_8
XFILLER_122_74 VPWR VGND sg13cmos5l_fill_2
XFILLER_72_255 VPWR VGND sg13cmos5l_fill_2
XFILLER_446_4 VPWR VGND sg13cmos5l_fill_1
XFILLER_610_236 VPWR VGND sg13cmos5l_decap_8
XFILLER_421_147 VPWR VGND sg13cmos5l_decap_8
XFILLER_479_77 VPWR VGND sg13cmos5l_fill_1
XFILLER_709_112 VPWR VGND sg13cmos5l_decap_8
XFILLER_629_14 VPWR VGND sg13cmos5l_decap_8
XFILLER_213_261 VPWR VGND sg13cmos5l_decap_8
XFILLER_82_89 VPWR VGND sg13cmos5l_decap_8
XFILLER_479_99 VPWR VGND sg13cmos5l_decap_8
XFILLER_213_272 VPWR VGND sg13cmos5l_fill_1
XFILLER_359_254 VPWR VGND sg13cmos5l_decap_8
XFILLER_709_145 VPWR VGND sg13cmos5l_fill_2
XFILLER_575_140 VPWR VGND sg13cmos5l_decap_8
XFILLER_198_89 VPWR VGND sg13cmos5l_decap_8
XFILLER_508_218 VPWR VGND sg13cmos5l_fill_1
XFILLER_495_21 VPWR VGND sg13cmos5l_decap_8
XFILLER_40_163 VPWR VGND sg13cmos5l_decap_8
XFILLER_185_168 VPWR VGND sg13cmos5l_decap_8
XFILLER_222_0 VPWR VGND sg13cmos5l_decap_8
XFILLER_709_91 VPWR VGND sg13cmos5l_decap_8
XFILLER_495_98 VPWR VGND sg13cmos5l_decap_8
XFILLER_645_35 VPWR VGND sg13cmos5l_decap_8
XFILLER_428_70 VPWR VGND sg13cmos5l_decap_8
XFILLER_531_221 VPWR VGND sg13cmos5l_decap_8
XFILLER_364_14 VPWR VGND sg13cmos5l_decap_8
XFILLER_126_257 VPWR VGND sg13cmos5l_fill_1
XFILLER_342_132 VPWR VGND sg13cmos5l_decap_8
XANTENNA__3175__X Tile_X0Y0_UserCLKo VPWR VGND sg13cmos5l_antennanp
XFILLER_677_258 VPWR VGND sg13cmos5l_decap_8
XFILLER_49_8 VPWR VGND sg13cmos5l_decap_8
XFILLER_591_0 VPWR VGND sg13cmos5l_decap_8
XFILLER_689_0 VPWR VGND sg13cmos5l_decap_8
XFILLER_514_28 VPWR VGND sg13cmos5l_decap_8
XFILLER_429_203 VPWR VGND sg13cmos5l_decap_8
XFILLER_661_56 VPWR VGND sg13cmos5l_decap_8
X_0310_ _0310_/Q Tile_X0Y7_FrameData[9] VGND VPWR Tile_X0Y9_FrameStrobe[4] latch
XFILLER_661_78 VPWR VGND sg13cmos5l_decap_4
XFILLER_645_133 VPWR VGND sg13cmos5l_decap_8
X_1290_ _1290_/Q Tile_X0Y1_FrameData[15] VGND VPWR Tile_X0Y9_FrameStrobe[3] latch
XFILLER_380_35 VPWR VGND sg13cmos5l_decap_8
XFILLER_255_106 VPWR VGND sg13cmos5l_decap_8
XFILLER_380_57 VPWR VGND sg13cmos5l_decap_8
X_0241_ _0241_/Q Tile_X0Y7_FrameData[14] VGND VPWR Tile_X0Y9_FrameStrobe[2] latch
XFILLER_48_241 VPWR VGND sg13cmos5l_decap_8
XFILLER_313_62 VPWR VGND sg13cmos5l_decap_8
XFILLER_313_73 VPWR VGND sg13cmos5l_fill_1
X_0172_ _0172_/Q Tile_X0Y7_FrameData[19] VGND VPWR Tile_X0Y9_FrameStrobe[0] latch
XFILLER_530_49 VPWR VGND sg13cmos5l_decap_8
XFILLER_452_250 VPWR VGND sg13cmos5l_decap_4
XFILLER_313_95 VPWR VGND sg13cmos5l_decap_8
XFILLER_63_244 VPWR VGND sg13cmos5l_decap_8
XFILLER_389_77 VPWR VGND sg13cmos5l_decap_8
X_3931_ _3931_/X _3987_/X Tile_X0Y1_WW4END[7] _3986_/X AXI_M_SOC_ARREADY _1347_/Q
+ _1346_/Q VPWR VGND sg13cmos5l_mux4_1
XFILLER_601_258 VPWR VGND sg13cmos5l_decap_4
XFILLER_539_14 VPWR VGND sg13cmos5l_decap_8
XFILLER_686_42 VPWR VGND sg13cmos5l_fill_2
XFILLER_566_140 VPWR VGND sg13cmos5l_decap_8
XFILLER_176_102 VPWR VGND sg13cmos5l_decap_4
X_3862_ _3862_/X _3848_/X Tile_X0Y0_W6END[0] Tile_X0Y0_S1END[0] _3862_/A3 _0947_/Q
+ _0946_/Q VPWR VGND sg13cmos5l_mux4_1
XFILLER_420_180 VPWR VGND sg13cmos5l_decap_4
XFILLER_31_163 VPWR VGND sg13cmos5l_decap_8
XFILLER_176_135 VPWR VGND sg13cmos5l_decap_8
X_2813_ Tile_X0Y3_E2BEG[3] _4151_/X VPWR VGND sg13cmos5l_buf_1
XFILLER_365_235 VPWR VGND sg13cmos5l_decap_8
XFILLER_715_126 VPWR VGND sg13cmos5l_decap_8
XFILLER_176_157 VPWR VGND sg13cmos5l_decap_8
X_3793_ _3793_/X _3885_/X _3876_/X _3875_/X _3853_/X _1153_/Q _1152_/Q VPWR VGND sg13cmos5l_mux4_1
XFILLER_619_91 VPWR VGND sg13cmos5l_fill_2
XFILLER_581_154 VPWR VGND sg13cmos5l_decap_8
X_2744_ Tile_X0Y3_FrameData_O[2] Tile_X0Y3_FrameData[2] VPWR VGND sg13cmos5l_buf_1
XFILLER_507_251 VPWR VGND sg13cmos5l_fill_2
XFILLER_117_235 VPWR VGND sg13cmos5l_decap_8
XFILLER_68_0 VPWR VGND sg13cmos5l_decap_8
XFILLER_184_190 VPWR VGND sg13cmos5l_decap_8
X_2675_ _2675_/Q Tile_X0Y6_FrameData[20] VGND VPWR Tile_X0Y9_FrameStrobe[7] latch
XFILLER_274_14 VPWR VGND sg13cmos5l_decap_8
XANTENNA__3085__X Tile_X0Y7_E1BEG[3] VPWR VGND sg13cmos5l_antennanp
XFILLER_555_79 VPWR VGND sg13cmos5l_decap_4
XFILLER_668_236 VPWR VGND sg13cmos5l_decap_8
X_1626_ _1626_/Q Tile_X0Y2_FrameData[23] VGND VPWR Tile_X0Y9_FrameStrobe[6] latch
X_4414_ _4414_/X AXI_M_SOC_RRESP0 _4452_/X _4456_/X _4429_/X _2275_/Q _2274_/Q VPWR
+ VGND sg13cmos5l_mux4_1
XFILLER_705_49 VPWR VGND sg13cmos5l_decap_8
XFILLER_132_249 VPWR VGND sg13cmos5l_decap_4
XFILLER_683_206 VPWR VGND sg13cmos5l_decap_8
XFILLER_424_28 VPWR VGND sg13cmos5l_decap_8
XFILLER_207_63 VPWR VGND sg13cmos5l_decap_8
X_1557_ _1557_/Q Tile_X0Y2_FrameData[28] VGND VPWR Tile_X0Y9_FrameStrobe[4] latch
X_4345_ _4345_/X _4305_/X _0158_/X _4304_/X _0111_/X _1963_/Q _1962_/Q VPWR VGND sg13cmos5l_mux4_1
XFILLER_571_56 VPWR VGND sg13cmos5l_decap_8
XFILLER_487_191 VPWR VGND sg13cmos5l_decap_8
XFILLER_354_91 VPWR VGND sg13cmos5l_decap_8
X_0508_ _0508_/Q Tile_X0Y8_FrameData[3] VGND VPWR Tile_X0Y9_FrameStrobe[2] latch
X_4276_ _4276_/X Tile_X0Y4_WW4END[11] AXI_M_SOC_BRESP0 _4347_/X _4319_/X _2061_/Q
+ _2060_/Q VPWR VGND sg13cmos5l_mux4_1
XFILLER_636_133 VPWR VGND sg13cmos5l_decap_8
XFILLER_100_113 VPWR VGND sg13cmos5l_decap_8
X_1488_ _1488_/Q Tile_X0Y2_FrameData[1] VGND VPWR Tile_X0Y9_FrameStrobe[1] latch
XFILLER_636_166 VPWR VGND sg13cmos5l_fill_2
XFILLER_290_57 VPWR VGND sg13cmos5l_decap_8
X_3227_ Tile_X0Y0_FrameStrobe_O[15] Tile_X0Y9_FrameStrobe[15] VPWR VGND sg13cmos5l_buf_1
X_0439_ _0439_/Q Tile_X0Y8_FrameData[8] VGND VPWR Tile_X0Y9_FrameStrobe[0] latch
XFILLER_691_272 VPWR VGND sg13cmos5l_fill_1
X_3158_ Tile_X0Y7_FrameData_O[28] Tile_X0Y7_FrameData[28] VPWR VGND sg13cmos5l_buf_1
XFILLER_651_147 VPWR VGND sg13cmos5l_decap_8
XFILLER_589_221 VPWR VGND sg13cmos5l_decap_8
XFILLER_440_49 VPWR VGND sg13cmos5l_decap_8
XFILLER_254_150 VPWR VGND sg13cmos5l_fill_2
X_2109_ _2109_/Q Tile_X0Y4_FrameData[8] VGND VPWR Tile_X0Y9_FrameStrobe[5] latch
XFILLER_443_272 VPWR VGND sg13cmos5l_fill_1
X_3089_ Tile_X0Y7_E2BEG[3] _4615_/X VPWR VGND sg13cmos5l_buf_1
XFILLER_403_125 VPWR VGND sg13cmos5l_decap_8
XFILLER_403_158 VPWR VGND sg13cmos5l_decap_8
XFILLER_449_14 VPWR VGND sg13cmos5l_decap_8
XFILLER_596_42 VPWR VGND sg13cmos5l_decap_8
XFILLER_52_26 VPWR VGND sg13cmos5l_fill_2
XFILLER_146_7 VPWR VGND sg13cmos5l_decap_8
XFILLER_557_162 VPWR VGND sg13cmos5l_fill_2
XFILLER_210_231 VPWR VGND sg13cmos5l_decap_8
XFILLER_356_224 VPWR VGND sg13cmos5l_decap_8
XFILLER_706_126 VPWR VGND sg13cmos5l_decap_8
XFILLER_320_8 VPWR VGND sg13cmos5l_decap_8
XFILLER_210_264 VPWR VGND sg13cmos5l_fill_1
XFILLER_167_168 VPWR VGND sg13cmos5l_decap_8
XFILLER_182_105 VPWR VGND sg13cmos5l_decap_8
XFILLER_572_154 VPWR VGND sg13cmos5l_decap_8
XFILLER_356_268 VPWR VGND sg13cmos5l_decap_4
XFILLER_313_7 VPWR VGND sg13cmos5l_decap_8
XFILLER_465_35 VPWR VGND sg13cmos5l_decap_8
XFILLER_318_29 VPWR VGND sg13cmos5l_decap_8
XFILLER_248_70 VPWR VGND sg13cmos5l_decap_8
XFILLER_371_238 VPWR VGND sg13cmos5l_decap_8
XFILLER_184_36 VPWR VGND sg13cmos5l_decap_8
XFILLER_513_243 VPWR VGND sg13cmos5l_fill_1
XFILLER_324_143 VPWR VGND sg13cmos5l_decap_8
XFILLER_659_236 VPWR VGND sg13cmos5l_decap_8
XFILLER_615_49 VPWR VGND sg13cmos5l_decap_8
XFILLER_269_209 VPWR VGND sg13cmos5l_decap_8
XFILLER_682_7 VPWR VGND sg13cmos5l_decap_8
XFILLER_485_128 VPWR VGND sg13cmos5l_fill_2
XFILLER_334_28 VPWR VGND sg13cmos5l_fill_2
XFILLER_277_220 VPWR VGND sg13cmos5l_decap_8
XFILLER_674_239 VPWR VGND sg13cmos5l_fill_1
XFILLER_481_56 VPWR VGND sg13cmos5l_decap_8
XFILLER_264_91 VPWR VGND sg13cmos5l_decap_8
XFILLER_481_78 VPWR VGND sg13cmos5l_fill_1
XFILLER_131_271 VPWR VGND sg13cmos5l_fill_2
XFILLER_627_155 VPWR VGND sg13cmos5l_decap_4
XFILLER_237_106 VPWR VGND sg13cmos5l_decap_4
XFILLER_493_161 VPWR VGND sg13cmos5l_decap_8
XFILLER_292_201 VPWR VGND sg13cmos5l_fill_1
XFILLER_426_217 VPWR VGND sg13cmos5l_decap_8
XFILLER_642_147 VPWR VGND sg13cmos5l_decap_8
XFILLER_45_200 VPWR VGND sg13cmos5l_decap_8
XFILLER_133_84 VPWR VGND sg13cmos5l_decap_8
XFILLER_350_49 VPWR VGND sg13cmos5l_decap_8
XFILLER_252_109 VPWR VGND sg13cmos5l_fill_2
XFILLER_711_70 VPWR VGND sg13cmos5l_decap_8
XFILLER_172_0 VPWR VGND sg13cmos5l_decap_8
XFILLER_245_172 VPWR VGND sg13cmos5l_decap_8
XFILLER_45_244 VPWR VGND sg13cmos5l_decap_8
XANTENNA_210 Tile_X0Y9_N4END[14] VPWR VGND sg13cmos5l_antennanp
XANTENNA_221 Tile_X0Y9_N4END[14] VPWR VGND sg13cmos5l_antennanp
XFILLER_595_202 VPWR VGND sg13cmos5l_fill_2
XANTENNA_232 Tile_X0Y0_FrameData[6] VPWR VGND sg13cmos5l_antennanp
XFILLER_60_203 VPWR VGND sg13cmos5l_decap_8
XFILLER_93_99 VPWR VGND sg13cmos5l_decap_8
XFILLER_359_14 VPWR VGND sg13cmos5l_decap_8
XFILLER_595_257 VPWR VGND sg13cmos5l_fill_1
XFILLER_595_268 VPWR VGND sg13cmos5l_decap_4
XFILLER_437_0 VPWR VGND sg13cmos5l_decap_8
XFILLER_13_130 VPWR VGND sg13cmos5l_decap_8
XFILLER_158_124 VPWR VGND sg13cmos5l_decap_8
XFILLER_548_173 VPWR VGND sg13cmos5l_decap_8
XFILLER_548_184 VPWR VGND sg13cmos5l_fill_1
XFILLER_509_28 VPWR VGND sg13cmos5l_decap_8
XFILLER_13_196 VPWR VGND sg13cmos5l_decap_8
XFILLER_604_0 VPWR VGND sg13cmos5l_decap_8
XFILLER_9_156 VPWR VGND sg13cmos5l_decap_8
XFILLER_656_56 VPWR VGND sg13cmos5l_decap_8
XFILLER_9_167 VPWR VGND sg13cmos5l_fill_1
XANTENNA__2802__X Tile_X0Y3_E2BEGb[0] VPWR VGND sg13cmos5l_antennanp
X_0790_ _0790_/Q Tile_X0Y9_FrameData[9] VGND VPWR Tile_X0Y9_FrameStrobe[3] latch
XFILLER_375_35 VPWR VGND sg13cmos5l_decap_8
XFILLER_173_149 VPWR VGND sg13cmos5l_decap_8
XFILLER_114_205 VPWR VGND sg13cmos5l_decap_8
X_2460_ _2460_/Q Tile_X0Y6_FrameData[11] VGND VPWR Tile_X0Y9_FrameStrobe[0] latch
XFILLER_114_227 VPWR VGND sg13cmos5l_decap_8
XFILLER_181_171 VPWR VGND sg13cmos5l_decap_8
XFILLER_315_176 VPWR VGND sg13cmos5l_decap_8
XFILLER_525_49 VPWR VGND sg13cmos5l_decap_8
XFILLER_308_84 VPWR VGND sg13cmos5l_fill_2
X_1411_ _1411_/Q Tile_X0Y1_FrameData[22] VGND VPWR Tile_X0Y9_FrameStrobe[7] latch
XFILLER_244_28 VPWR VGND sg13cmos5l_decap_8
X_2391_ _2391_/Q Tile_X0Y5_FrameData[14] VGND VPWR Tile_X0Y9_FrameStrobe[6] latch
XANTENNA__3633__X Tile_X0Y9_S4BEG[11] VPWR VGND sg13cmos5l_antennanp
X_4130_ _4130_/X Tile_X0Y1_W2MID[6] Tile_X0Y1_W2END[6] Tile_X0Y1_W6END[9] _3991_/X
+ _1379_/Q _1378_/Q VPWR VGND sg13cmos5l_mux4_1
X_1342_ _1342_/Q Tile_X0Y1_FrameData[27] VGND VPWR Tile_X0Y9_FrameStrobe[5] latch
XFILLER_618_133 VPWR VGND sg13cmos5l_decap_8
XFILLER_3_42 VPWR VGND sg13cmos5l_decap_8
XFILLER_95_133 VPWR VGND sg13cmos5l_decap_8
X_4061_ _4061_/X Tile_X0Y2_WW4END[10] AXI_M_SOC_AWREADY _4126_/X _4101_/X _1551_/Q
+ _1550_/Q VPWR VGND sg13cmos5l_mux4_1
XFILLER_673_272 VPWR VGND sg13cmos5l_fill_1
X_1273_ _1273_/Q Tile_X0Y1_FrameData[0] VGND VPWR Tile_X0Y9_FrameStrobe[2] latch
XFILLER_324_94 VPWR VGND sg13cmos5l_decap_8
X_3012_ Tile_X0Y5_E2BEGb[7] _4387_/X VPWR VGND sg13cmos5l_buf_1
X_0224_ _0224_/Q Tile_X0Y7_FrameData[31] VGND VPWR Tile_X0Y9_FrameStrobe[2] latch
XFILLER_633_147 VPWR VGND sg13cmos5l_decap_8
XFILLER_260_49 VPWR VGND sg13cmos5l_decap_8
XFILLER_621_70 VPWR VGND sg13cmos5l_decap_8
X_0155_ _0155_/X _4564_/X _4565_/X _1605_/Q VPWR VGND sg13cmos5l_mux2_1
XFILLER_36_266 VPWR VGND sg13cmos5l_decap_8
XFILLER_440_220 VPWR VGND sg13cmos5l_decap_8
XFILLER_440_231 VPWR VGND sg13cmos5l_fill_2
XFILLER_586_224 VPWR VGND sg13cmos5l_decap_4
XFILLER_51_214 VPWR VGND sg13cmos5l_decap_8
XFILLER_397_135 VPWR VGND sg13cmos5l_decap_8
XFILLER_251_142 VPWR VGND sg13cmos5l_decap_8
XFILLER_697_63 VPWR VGND sg13cmos5l_decap_8
X_0086_ _0086_/X _3869_/X _3870_/X _2152_/Q VPWR VGND sg13cmos5l_mux2_1
XFILLER_269_14 VPWR VGND sg13cmos5l_decap_8
XFILLER_196_208 VPWR VGND sg13cmos5l_decap_8
XFILLER_586_268 VPWR VGND sg13cmos5l_decap_4
X_3914_ _3914_/X Tile_X0Y2_W1END[2] Tile_X0Y2_WW4END[2] Tile_X0Y2_W6END[10] _4118_/X
+ _1643_/Q _1642_/Q VPWR VGND sg13cmos5l_mux4_1
X_4894_ _4894_/X Tile_X0Y9_N1END[2] Tile_X0Y9_W6END[2] _4898_/X _4894_/A3 _0675_/Q
+ _0674_/Q VPWR VGND sg13cmos5l_mux4_1
XFILLER_539_162 VPWR VGND sg13cmos5l_decap_8
XFILLER_149_135 VPWR VGND sg13cmos5l_fill_2
X_3845_ _3845_/X Tile_X0Y0_W2MID[5] _3883_/X _3887_/X _3856_/X _1015_/Q _1014_/Q VPWR
+ VGND sg13cmos5l_mux4_1
XFILLER_419_28 VPWR VGND sg13cmos5l_decap_8
XFILLER_164_105 VPWR VGND sg13cmos5l_decap_8
XFILLER_566_56 VPWR VGND sg13cmos5l_decap_8
XFILLER_349_91 VPWR VGND sg13cmos5l_decap_8
XFILLER_716_15 VPWR VGND sg13cmos5l_fill_2
X_0988_ _0988_/Q Tile_X0Y0_FrameData[15] VGND VPWR Tile_X0Y9_FrameStrobe[1] latch
X_3776_ _3776_/X Tile_X0Y0_WW4END[5] Tile_X0Y0_WW4END[13] Tile_X0Y0_W6END[5] _3886_/X
+ _0999_/Q _0998_/Q VPWR VGND sg13cmos5l_mux4_1
XFILLER_285_35 VPWR VGND sg13cmos5l_decap_8
XFILLER_353_238 VPWR VGND sg13cmos5l_decap_8
X_2727_ _4894_/A3 VPWR VGND sg13cmos5l_tielo
XFILLER_716_59 VPWR VGND sg13cmos5l_fill_2
XFILLER_711_140 VPWR VGND sg13cmos5l_decap_8
X_2658_ _2658_/Q Tile_X0Y6_FrameData[5] VGND VPWR Tile_X0Y9_FrameStrobe[6] latch
XFILLER_435_49 VPWR VGND sg13cmos5l_decap_8
XFILLER_306_187 VPWR VGND sg13cmos5l_fill_2
XFILLER_510_213 VPWR VGND sg13cmos5l_decap_8
XFILLER_321_113 VPWR VGND sg13cmos5l_decap_8
XFILLER_321_124 VPWR VGND sg13cmos5l_fill_2
XFILLER_154_28 VPWR VGND sg13cmos5l_decap_8
XFILLER_711_184 VPWR VGND sg13cmos5l_fill_1
XFILLER_582_77 VPWR VGND sg13cmos5l_decap_8
X_1609_ _1609_/Q Tile_X0Y2_FrameData[8] VGND VPWR Tile_X0Y9_FrameStrobe[5] latch
XFILLER_467_128 VPWR VGND sg13cmos5l_decap_4
X_2589_ _2589_/Q Tile_X0Y6_FrameData[10] VGND VPWR Tile_X0Y9_FrameStrobe[4] latch
XFILLER_467_139 VPWR VGND sg13cmos5l_decap_8
XANTENNA__3543__X Tile_X0Y9_E6BEG[1] VPWR VGND sg13cmos5l_antennanp
XFILLER_656_239 VPWR VGND sg13cmos5l_decap_8
XFILLER_113_260 VPWR VGND sg13cmos5l_decap_4
XFILLER_321_179 VPWR VGND sg13cmos5l_decap_8
X_4328_ _4328_/X Tile_X0Y0_W1END[2] Tile_X0Y0_WW4END[14] Tile_X0Y0_W6END[6] _3883_/X
+ _1111_/Q _1110_/Q VPWR VGND sg13cmos5l_mux4_1
XFILLER_274_201 VPWR VGND sg13cmos5l_decap_8
XFILLER_86_133 VPWR VGND sg13cmos5l_decap_8
XFILLER_47_15 VPWR VGND sg13cmos5l_decap_8
XFILLER_408_217 VPWR VGND sg13cmos5l_decap_8
X_4259_ _4259_/X Tile_X0Y4_W2MID[4] AXI_M_SOC_BRESP1 _4319_/X _4318_/X _2095_/Q _2094_/Q
+ VPWR VGND sg13cmos5l_mux4_1
XFILLER_408_239 VPWR VGND sg13cmos5l_decap_8
XFILLER_47_59 VPWR VGND sg13cmos5l_decap_8
XFILLER_170_49 VPWR VGND sg13cmos5l_decap_8
XFILLER_103_21 VPWR VGND sg13cmos5l_decap_8
XFILLER_531_70 VPWR VGND sg13cmos5l_decap_8
XFILLER_368_8 VPWR VGND sg13cmos5l_decap_8
XFILLER_227_172 VPWR VGND sg13cmos5l_decap_8
XFILLER_263_7 VPWR VGND sg13cmos5l_decap_8
XFILLER_63_14 VPWR VGND sg13cmos5l_decap_8
XFILLER_632_180 VPWR VGND sg13cmos5l_decap_8
XFILLER_388_124 VPWR VGND sg13cmos5l_decap_8
XFILLER_103_98 VPWR VGND sg13cmos5l_decap_8
XFILLER_179_14 VPWR VGND sg13cmos5l_decap_8
XFILLER_187_219 VPWR VGND sg13cmos5l_decap_8
XFILLER_42_258 VPWR VGND sg13cmos5l_fill_1
XFILLER_592_205 VPWR VGND sg13cmos5l_decap_8
XFILLER_430_7 VPWR VGND sg13cmos5l_decap_8
XFILLER_400_63 VPWR VGND sg13cmos5l_decap_8
XFILLER_528_7 VPWR VGND sg13cmos5l_decap_8
XFILLER_195_230 VPWR VGND sg13cmos5l_decap_8
XFILLER_396_190 VPWR VGND sg13cmos5l_fill_2
XANTENNA__3718__X AXI_M_SOC_WDATA28 VPWR VGND sg13cmos5l_antennanp
XFILLER_329_268 VPWR VGND sg13cmos5l_decap_4
XFILLER_476_56 VPWR VGND sg13cmos5l_decap_4
XFILLER_10_155 VPWR VGND sg13cmos5l_fill_2
XFILLER_545_165 VPWR VGND sg13cmos5l_decap_4
XFILLER_311_4 VPWR VGND sg13cmos5l_fill_1
XFILLER_155_149 VPWR VGND sg13cmos5l_fill_1
XFILLER_195_79 VPWR VGND sg13cmos5l_fill_2
XFILLER_498_231 VPWR VGND sg13cmos5l_decap_8
XFILLER_345_49 VPWR VGND sg13cmos5l_decap_8
XFILLER_128_84 VPWR VGND sg13cmos5l_decap_8
XFILLER_706_70 VPWR VGND sg13cmos5l_decap_8
XFILLER_163_193 VPWR VGND sg13cmos5l_decap_8
XFILLER_647_217 VPWR VGND sg13cmos5l_decap_8
XFILLER_501_224 VPWR VGND sg13cmos5l_decap_8
XFILLER_492_77 VPWR VGND sg13cmos5l_decap_8
XFILLER_312_135 VPWR VGND sg13cmos5l_decap_8
XFILLER_642_14 VPWR VGND sg13cmos5l_decap_8
XANTENNA__3453__X Tile_X0Y1_FrameData_O[11] VPWR VGND sg13cmos5l_antennanp
XFILLER_312_168 VPWR VGND sg13cmos5l_decap_8
XFILLER_77_133 VPWR VGND sg13cmos5l_decap_8
XFILLER_265_201 VPWR VGND sg13cmos5l_decap_8
XFILLER_387_0 VPWR VGND sg13cmos5l_decap_8
XFILLER_615_114 VPWR VGND sg13cmos5l_decap_8
XFILLER_466_194 VPWR VGND sg13cmos5l_decap_8
XFILLER_225_109 VPWR VGND sg13cmos5l_decap_8
XFILLER_441_70 VPWR VGND sg13cmos5l_decap_4
XFILLER_18_233 VPWR VGND sg13cmos5l_decap_8
XFILLER_554_0 VPWR VGND sg13cmos5l_decap_8
XFILLER_481_186 VPWR VGND sg13cmos5l_decap_8
XFILLER_280_237 VPWR VGND sg13cmos5l_fill_1
XFILLER_280_248 VPWR VGND sg13cmos5l_fill_1
XFILLER_37_92 VPWR VGND sg13cmos5l_fill_2
XFILLER_280_259 VPWR VGND sg13cmos5l_decap_4
XFILLER_568_224 VPWR VGND sg13cmos5l_decap_8
XFILLER_568_246 VPWR VGND sg13cmos5l_decap_8
XFILLER_178_208 VPWR VGND sg13cmos5l_decap_8
XFILLER_568_268 VPWR VGND sg13cmos5l_decap_4
XFILLER_379_179 VPWR VGND sg13cmos5l_decap_8
XFILLER_310_63 VPWR VGND sg13cmos5l_decap_8
XFILLER_394_116 VPWR VGND sg13cmos5l_fill_1
X_1960_ _1960_/Q Tile_X0Y4_FrameData[29] VGND VPWR Tile_X0Y9_FrameStrobe[1] latch
XFILLER_394_138 VPWR VGND sg13cmos5l_decap_8
X_0911_ _0911_/Q Tile_X0Y9_FrameData[16] VGND VPWR Tile_X0Y9_FrameStrobe[7] latch
XFILLER_667_77 VPWR VGND sg13cmos5l_decap_8
XFILLER_239_28 VPWR VGND sg13cmos5l_decap_8
X_1891_ _1891_/Q Tile_X0Y3_FrameData[6] VGND VPWR Tile_X0Y9_FrameStrobe[6] latch
XANTENNA__3628__X Tile_X0Y9_S4BEG[6] VPWR VGND sg13cmos5l_antennanp
XFILLER_386_56 VPWR VGND sg13cmos5l_decap_8
XFILLER_169_91 VPWR VGND sg13cmos5l_decap_8
XFILLER_386_67 VPWR VGND sg13cmos5l_fill_2
X_0842_ _0842_/Q Tile_X0Y9_FrameData[21] VGND VPWR Tile_X0Y9_FrameStrobe[5] latch
X_3630_ Tile_X0Y9_S4BEG[8] _3630_/A VPWR VGND sg13cmos5l_buf_1
XFILLER_683_21 VPWR VGND sg13cmos5l_decap_8
XFILLER_146_149 VPWR VGND sg13cmos5l_decap_8
XFILLER_536_198 VPWR VGND sg13cmos5l_decap_8
X_0773_ _0773_/Q Tile_X0Y9_FrameData[26] VGND VPWR Tile_X0Y9_FrameStrobe[3] latch
X_3561_ Tile_X0Y9_EE4BEG[7] _4871_/X VPWR VGND sg13cmos5l_buf_1
XFILLER_697_139 VPWR VGND sg13cmos5l_decap_8
XFILLER_551_157 VPWR VGND sg13cmos5l_fill_1
XANTENNA__0052__X AXI_M_SOC_AWBURST0 VPWR VGND sg13cmos5l_antennanp
X_2512_ _2512_/Q Tile_X0Y6_FrameData[23] VGND VPWR Tile_X0Y9_FrameStrobe[2] latch
XFILLER_551_179 VPWR VGND sg13cmos5l_decap_8
X_3492_ Tile_X0Y1_E6BEG[2] _3966_/X VPWR VGND sg13cmos5l_buf_1
XFILLER_616_70 VPWR VGND sg13cmos5l_decap_8
X_2443_ _2443_/Q Tile_X0Y6_FrameData[28] VGND VPWR Tile_X0Y9_FrameStrobe[0] latch
XFILLER_638_228 VPWR VGND sg13cmos5l_fill_1
XFILLER_552_14 VPWR VGND sg13cmos5l_decap_8
XANTENNA__3363__X Tile_X0Y2_EE4BEG[2] VPWR VGND sg13cmos5l_antennanp
XFILLER_638_239 VPWR VGND sg13cmos5l_decap_8
XFILLER_102_219 VPWR VGND sg13cmos5l_decap_8
X_2374_ _2374_/Q Tile_X0Y5_FrameData[31] VGND VPWR Tile_X0Y9_FrameStrobe[6] latch
XFILLER_653_209 VPWR VGND sg13cmos5l_decap_8
XFILLER_68_133 VPWR VGND sg13cmos5l_decap_8
X_1325_ _1325_/Q Tile_X0Y1_FrameData[12] VGND VPWR Tile_X0Y9_FrameStrobe[4] latch
X_4113_ _4113_/X _4089_/X _0079_/X _4088_/X Tile_X0Y0_S4END[8] _1457_/Q _1456_/Q VPWR
+ VGND sg13cmos5l_mux4_1
XFILLER_702_28 VPWR VGND sg13cmos5l_decap_8
XFILLER_632_91 VPWR VGND sg13cmos5l_decap_8
XFILLER_204_42 VPWR VGND sg13cmos5l_decap_8
XFILLER_256_267 VPWR VGND sg13cmos5l_decap_4
X_1256_ _1256_/Q Tile_X0Y1_FrameData[17] VGND VPWR Tile_X0Y9_FrameStrobe[2] latch
X_4044_ _4044_/X Tile_X0Y2_W2MID[3] AXI_M_SOC_AWREADY _4103_/X _4102_/X _1585_/Q _1584_/Q
+ VPWR VGND sg13cmos5l_mux4_1
XFILLER_351_70 VPWR VGND sg13cmos5l_decap_8
X_0207_ _0207_/Q Tile_X0Y7_FrameData[16] VGND VPWR Tile_X0Y9_FrameStrobe[1] latch
XFILLER_472_186 VPWR VGND sg13cmos5l_decap_8
XFILLER_83_169 VPWR VGND sg13cmos5l_fill_2
X_1187_ _1187_/Q Tile_X0Y1_FrameData[22] VGND VPWR Tile_X0Y9_FrameStrobe[0] latch
XFILLER_559_213 VPWR VGND sg13cmos5l_decap_4
XFILLER_24_203 VPWR VGND sg13cmos5l_decap_8
X_0138_ AXI_M_SOC_AWLEN0 _0940_/Q _3671_/X VPWR VGND sg13cmos5l_nor2b_1
XFILLER_91_180 VPWR VGND sg13cmos5l_decap_8
XFILLER_501_84 VPWR VGND sg13cmos5l_decap_8
XFILLER_224_175 VPWR VGND sg13cmos5l_fill_2
XFILLER_220_63 VPWR VGND sg13cmos5l_decap_4
XFILLER_220_74 VPWR VGND sg13cmos5l_decap_8
X_0069_ AXI_M_SOC_WSTRB2 _0935_/Q _3724_/X VPWR VGND sg13cmos5l_or2_1
XFILLER_574_238 VPWR VGND sg13cmos5l_decap_8
XFILLER_527_110 VPWR VGND sg13cmos5l_fill_1
XFILLER_716_210 VPWR VGND sg13cmos5l_decap_8
XFILLER_577_77 VPWR VGND sg13cmos5l_decap_8
XFILLER_149_28 VPWR VGND sg13cmos5l_decap_8
X_4877_ _4877_/X Tile_X0Y9_WW4END[2] AXI_M_SOC_RDATA2 _4918_/X _4905_/X _0789_/Q _0788_/Q
+ VPWR VGND sg13cmos5l_mux4_1
XANTENNA__3538__X Tile_X0Y9_E2BEGb[4] VPWR VGND sg13cmos5l_antennanp
XFILLER_177_263 VPWR VGND sg13cmos5l_decap_8
XFILLER_296_56 VPWR VGND sg13cmos5l_decap_8
XFILLER_137_105 VPWR VGND sg13cmos5l_decap_8
XFILLER_716_254 VPWR VGND sg13cmos5l_decap_8
XFILLER_192_211 VPWR VGND sg13cmos5l_decap_4
X_3828_ _3828_/X Tile_X0Y0_WW4END[7] Tile_X0Y0_WW4END[9] _3879_/X _3852_/X _1049_/Q
+ _1048_/Q VPWR VGND sg13cmos5l_mux4_1
XFILLER_582_260 VPWR VGND sg13cmos5l_fill_2
XFILLER_393_171 VPWR VGND sg13cmos5l_decap_8
XFILLER_446_15 VPWR VGND sg13cmos5l_decap_8
XFILLER_593_21 VPWR VGND sg13cmos5l_decap_8
XFILLER_326_249 VPWR VGND sg13cmos5l_decap_4
XFILLER_688_117 VPWR VGND sg13cmos5l_decap_8
X_3759_ AXI_M_SOC_ARADDR31 Tile_X0Y8_W1END[3] Tile_X0Y8_WW4END[7] Tile_X0Y8_WW4END[15]
+ _4815_/X _0473_/Q _0472_/Q VPWR VGND sg13cmos5l_mux4_1
XFILLER_341_219 VPWR VGND sg13cmos5l_decap_4
XFILLER_542_179 VPWR VGND sg13cmos5l_decap_4
XFILLER_334_260 VPWR VGND sg13cmos5l_decap_8
XFILLER_334_271 VPWR VGND sg13cmos5l_fill_2
XFILLER_495_223 VPWR VGND sg13cmos5l_decap_8
XFILLER_462_14 VPWR VGND sg13cmos5l_decap_8
XFILLER_629_239 VPWR VGND sg13cmos5l_decap_8
XANTENNA__3273__X Tile_X0Y0_EE4BEG[9] VPWR VGND sg13cmos5l_antennanp
XFILLER_245_82 VPWR VGND sg13cmos5l_decap_8
XFILLER_59_111 VPWR VGND sg13cmos5l_decap_8
XFILLER_637_250 VPWR VGND sg13cmos5l_decap_4
XFILLER_59_122 VPWR VGND sg13cmos5l_fill_2
XFILLER_59_144 VPWR VGND sg13cmos5l_decap_8
XFILLER_448_172 VPWR VGND sg13cmos5l_decap_4
XFILLER_612_28 VPWR VGND sg13cmos5l_decap_8
XFILLER_380_7 VPWR VGND sg13cmos5l_decap_8
XFILLER_302_190 VPWR VGND sg13cmos5l_decap_8
XFILLER_478_7 VPWR VGND sg13cmos5l_decap_8
XFILLER_542_91 VPWR VGND sg13cmos5l_decap_8
XFILLER_114_42 VPWR VGND sg13cmos5l_decap_8
XFILLER_652_231 VPWR VGND sg13cmos5l_decap_8
XFILLER_612_106 VPWR VGND sg13cmos5l_decap_8
XFILLER_74_169 VPWR VGND sg13cmos5l_decap_8
XFILLER_645_7 VPWR VGND sg13cmos5l_decap_8
XFILLER_605_180 VPWR VGND sg13cmos5l_decap_8
XFILLER_82_180 VPWR VGND sg13cmos5l_decap_8
XFILLER_411_84 VPWR VGND sg13cmos5l_decap_8
XFILLER_404_264 VPWR VGND sg13cmos5l_decap_8
XFILLER_130_63 VPWR VGND sg13cmos5l_decap_8
XFILLER_376_105 VPWR VGND sg13cmos5l_decap_8
XFILLER_487_77 VPWR VGND sg13cmos5l_decap_8
XFILLER_30_239 VPWR VGND sg13cmos5l_decap_8
XFILLER_230_178 VPWR VGND sg13cmos5l_decap_8
XFILLER_90_67 VPWR VGND sg13cmos5l_fill_2
XFILLER_168_252 VPWR VGND sg13cmos5l_decap_8
XFILLER_637_14 VPWR VGND sg13cmos5l_decap_8
XANTENNA__3448__X Tile_X0Y1_FrameData_O[6] VPWR VGND sg13cmos5l_antennanp
XFILLER_518_143 VPWR VGND sg13cmos5l_fill_1
XFILLER_135_0 VPWR VGND sg13cmos5l_decap_8
XFILLER_707_243 VPWR VGND sg13cmos5l_decap_8
XFILLER_580_219 VPWR VGND sg13cmos5l_decap_8
XFILLER_391_119 VPWR VGND sg13cmos5l_decap_8
XFILLER_183_222 VPWR VGND sg13cmos5l_decap_8
XFILLER_533_102 VPWR VGND sg13cmos5l_decap_8
XFILLER_518_187 VPWR VGND sg13cmos5l_decap_8
XFILLER_317_238 VPWR VGND sg13cmos5l_decap_8
XFILLER_384_193 VPWR VGND sg13cmos5l_decap_8
XFILLER_99_21 VPWR VGND sg13cmos5l_decap_8
XFILLER_679_128 VPWR VGND sg13cmos5l_decap_8
XFILLER_302_0 VPWR VGND sg13cmos5l_decap_8
XFILLER_533_179 VPWR VGND sg13cmos5l_decap_8
XFILLER_653_35 VPWR VGND sg13cmos5l_decap_8
XFILLER_436_70 VPWR VGND sg13cmos5l_decap_8
XFILLER_297_101 VPWR VGND sg13cmos5l_decap_8
XFILLER_136_193 VPWR VGND sg13cmos5l_decap_8
XFILLER_151_130 VPWR VGND sg13cmos5l_decap_8
XANTENNA__3183__X Tile_X0Y0_N4BEG[7] VPWR VGND sg13cmos5l_antennanp
XFILLER_151_152 VPWR VGND sg13cmos5l_decap_8
XFILLER_97_217 VPWR VGND sg13cmos5l_decap_8
XFILLER_372_36 VPWR VGND sg13cmos5l_decap_8
XFILLER_486_256 VPWR VGND sg13cmos5l_fill_1
XFILLER_297_167 VPWR VGND sg13cmos5l_decap_4
XFILLER_671_0 VPWR VGND sg13cmos5l_decap_8
XFILLER_628_272 VPWR VGND sg13cmos5l_fill_1
XFILLER_522_28 VPWR VGND sg13cmos5l_decap_8
XFILLER_439_172 VPWR VGND sg13cmos5l_fill_2
XFILLER_24_7 VPWR VGND sg13cmos5l_decap_8
XFILLER_305_63 VPWR VGND sg13cmos5l_decap_4
XFILLER_238_234 VPWR VGND sg13cmos5l_decap_8
X_1110_ _1110_/Q Tile_X0Y0_FrameData[21] VGND VPWR Tile_X0Y9_FrameStrobe[5] latch
XFILLER_643_231 VPWR VGND sg13cmos5l_decap_8
X_2090_ _2090_/Q Tile_X0Y4_FrameData[27] VGND VPWR Tile_X0Y9_FrameStrobe[5] latch
XFILLER_65_147 VPWR VGND sg13cmos5l_decap_8
XFILLER_0_21 VPWR VGND sg13cmos5l_decap_8
XFILLER_171_92 VPWR VGND sg13cmos5l_decap_8
X_1041_ _1041_/Q Tile_X0Y0_FrameData[26] VGND VPWR Tile_X0Y9_FrameStrobe[3] latch
XFILLER_678_21 VPWR VGND sg13cmos5l_decap_8
XFILLER_0_87 VPWR VGND sg13cmos5l_decap_8
XFILLER_0_98 VPWR VGND sg13cmos5l_fill_2
X_4800_ _4800_/X _4777_/X Tile_X0Y9_N4END[4] _4776_/X _0077_/X _0471_/Q _0470_/Q VPWR
+ VGND sg13cmos5l_mux4_1
XFILLER_410_223 VPWR VGND sg13cmos5l_decap_8
X_2992_ Tile_X0Y8_UserCLKo Tile_X0Y8_UserCLK VPWR VGND sg13cmos5l_buf_1
XFILLER_221_167 VPWR VGND sg13cmos5l_decap_4
XFILLER_367_149 VPWR VGND sg13cmos5l_decap_8
X_4731_ _4731_/X Tile_X0Y8_W2MID[4] AXI_M_SOC_RDATA11 _4791_/X _4790_/X _0585_/Q _0584_/Q
+ VPWR VGND sg13cmos5l_mux4_1
XFILLER_410_267 VPWR VGND sg13cmos5l_decap_4
X_1943_ _1943_/Q Tile_X0Y4_FrameData[14] VGND VPWR Tile_X0Y9_FrameStrobe[0] latch
XFILLER_547_14 VPWR VGND sg13cmos5l_decap_8
XFILLER_9_63 VPWR VGND sg13cmos5l_decap_8
XANTENNA__3358__X Tile_X0Y2_FrameData_O[29] VPWR VGND sg13cmos5l_antennanp
XFILLER_694_42 VPWR VGND sg13cmos5l_decap_8
XFILLER_119_116 VPWR VGND sg13cmos5l_decap_8
X_4662_ _4662_/X Tile_X0Y6_W1END[1] Tile_X0Y6_W6END[9] _4581_/X _4541_/X _2657_/Q
+ _2656_/Q VPWR VGND sg13cmos5l_mux4_1
XFILLER_564_271 VPWR VGND sg13cmos5l_fill_2
X_1874_ _1874_/Q Tile_X0Y3_FrameData[23] VGND VPWR Tile_X0Y9_FrameStrobe[6] latch
XFILLER_119_149 VPWR VGND sg13cmos5l_decap_8
XFILLER_174_244 VPWR VGND sg13cmos5l_fill_1
X_3613_ Tile_X0Y9_S2BEG[7] _4835_/X VPWR VGND sg13cmos5l_buf_1
XFILLER_174_266 VPWR VGND sg13cmos5l_decap_8
X_0825_ _0825_/Q Tile_X0Y9_FrameData[6] VGND VPWR Tile_X0Y9_FrameStrobe[4] latch
XFILLER_713_246 VPWR VGND sg13cmos5l_decap_8
X_4593_ _4593_/X Tile_X0Y8_W2MID[3] Tile_X0Y8_W2END[3] Tile_X0Y8_W6END[3] _4790_/X
+ _0655_/Q _0654_/Q VPWR VGND sg13cmos5l_mux4_1
XFILLER_627_91 VPWR VGND sg13cmos5l_decap_4
X_3544_ Tile_X0Y9_E6BEG[2] _4882_/X VPWR VGND sg13cmos5l_buf_1
X_0756_ _0756_/Q Tile_X0Y9_FrameData[11] VGND VPWR Tile_X0Y9_FrameStrobe[2] latch
XFILLER_685_109 VPWR VGND sg13cmos5l_decap_8
XFILLER_563_35 VPWR VGND sg13cmos5l_decap_8
XFILLER_50_0 VPWR VGND sg13cmos5l_fill_1
XFILLER_678_183 VPWR VGND sg13cmos5l_decap_8
XFILLER_532_190 VPWR VGND sg13cmos5l_decap_4
XFILLER_282_14 VPWR VGND sg13cmos5l_decap_8
XANTENNA__3093__X Tile_X0Y7_E2BEG[7] VPWR VGND sg13cmos5l_antennanp
XFILLER_88_206 VPWR VGND sg13cmos5l_decap_8
X_0687_ _0687_/Q Tile_X0Y9_FrameData[16] VGND VPWR Tile_X0Y9_FrameStrobe[0] latch
X_3475_ Tile_X0Y1_EE4BEG[1] _3949_/X VPWR VGND sg13cmos5l_buf_1
XFILLER_477_234 VPWR VGND sg13cmos5l_decap_8
XFILLER_142_185 VPWR VGND sg13cmos5l_decap_8
X_2426_ _2426_/Q Tile_X0Y5_FrameData[11] VGND VPWR Tile_X0Y9_FrameStrobe[7] latch
XFILLER_288_178 VPWR VGND sg13cmos5l_decap_8
XFILLER_619_272 VPWR VGND sg13cmos5l_fill_1
XFILLER_215_63 VPWR VGND sg13cmos5l_decap_8
XFILLER_432_28 VPWR VGND sg13cmos5l_decap_8
X_2357_ _2357_/Q Tile_X0Y5_FrameData[16] VGND VPWR Tile_X0Y9_FrameStrobe[5] latch
XFILLER_215_85 VPWR VGND sg13cmos5l_fill_2
XFILLER_229_245 VPWR VGND sg13cmos5l_decap_8
XFILLER_362_91 VPWR VGND sg13cmos5l_decap_8
X_1308_ _1308_/Q Tile_X0Y1_FrameData[29] VGND VPWR Tile_X0Y9_FrameStrobe[4] latch
X_2288_ _2288_/Q Tile_X0Y5_FrameData[21] VGND VPWR Tile_X0Y9_FrameStrobe[3] latch
XFILLER_244_226 VPWR VGND sg13cmos5l_decap_8
XFILLER_56_158 VPWR VGND sg13cmos5l_decap_8
X_1239_ _1239_/Q Tile_X0Y1_FrameData[2] VGND VPWR Tile_X0Y9_FrameStrobe[1] latch
X_4027_ _4027_/X Tile_X0Y3_W2MID[4] Tile_X0Y3_W2END[4] Tile_X0Y3_W6END[4] _4211_/X
+ _1911_/Q _1910_/Q VPWR VGND sg13cmos5l_mux4_1
XFILLER_460_123 VPWR VGND sg13cmos5l_decap_8
XFILLER_588_21 VPWR VGND sg13cmos5l_decap_8
XFILLER_460_178 VPWR VGND sg13cmos5l_decap_8
XFILLER_212_112 VPWR VGND sg13cmos5l_decap_8
XFILLER_358_105 VPWR VGND sg13cmos5l_decap_8
XFILLER_401_234 VPWR VGND sg13cmos5l_decap_4
XFILLER_547_227 VPWR VGND sg13cmos5l_decap_8
XFILLER_12_217 VPWR VGND sg13cmos5l_decap_8
XFILLER_401_245 VPWR VGND sg13cmos5l_decap_8
XFILLER_401_256 VPWR VGND sg13cmos5l_fill_1
X_4929_ _4929_/X Tile_X0Y9_N1END[1] Tile_X0Y9_N4END[1] _4897_/X _0082_/X _0701_/Q
+ _0700_/Q VPWR VGND sg13cmos5l_mux4_1
XFILLER_457_14 VPWR VGND sg13cmos5l_decap_8
XFILLER_212_189 VPWR VGND sg13cmos5l_decap_8
XANTENNA__3268__X Tile_X0Y0_EE4BEG[4] VPWR VGND sg13cmos5l_antennanp
XFILLER_100_77 VPWR VGND sg13cmos5l_decap_8
XFILLER_20_250 VPWR VGND sg13cmos5l_decap_8
XFILLER_226_7 VPWR VGND sg13cmos5l_decap_8
XFILLER_20_261 VPWR VGND sg13cmos5l_fill_1
XFILLER_555_271 VPWR VGND sg13cmos5l_fill_2
XFILLER_366_182 VPWR VGND sg13cmos5l_fill_1
XFILLER_515_135 VPWR VGND sg13cmos5l_fill_1
XFILLER_607_28 VPWR VGND sg13cmos5l_decap_8
XFILLER_180_203 VPWR VGND sg13cmos5l_decap_8
XFILLER_704_257 VPWR VGND sg13cmos5l_fill_1
XFILLER_570_252 VPWR VGND sg13cmos5l_decap_4
XFILLER_537_91 VPWR VGND sg13cmos5l_decap_8
XANTENNA__2900__X Tile_X0Y6_FrameData_O[21] VPWR VGND sg13cmos5l_antennanp
XFILLER_118_171 VPWR VGND sg13cmos5l_decap_4
XFILLER_307_271 VPWR VGND sg13cmos5l_fill_2
XFILLER_180_236 VPWR VGND sg13cmos5l_fill_1
XFILLER_473_35 VPWR VGND sg13cmos5l_decap_8
XFILLER_468_201 VPWR VGND sg13cmos5l_fill_1
XFILLER_279_112 VPWR VGND sg13cmos5l_decap_8
XFILLER_256_81 VPWR VGND sg13cmos5l_decap_8
XFILLER_109_86 VPWR VGND sg13cmos5l_fill_1
XFILLER_69_35 VPWR VGND sg13cmos5l_decap_8
XFILLER_192_14 VPWR VGND sg13cmos5l_decap_8
XFILLER_468_223 VPWR VGND sg13cmos5l_decap_8
XFILLER_192_25 VPWR VGND sg13cmos5l_fill_2
XFILLER_595_7 VPWR VGND sg13cmos5l_decap_8
XFILLER_79_217 VPWR VGND sg13cmos5l_fill_2
XFILLER_79_228 VPWR VGND sg13cmos5l_fill_1
XFILLER_133_185 VPWR VGND sg13cmos5l_decap_8
XFILLER_623_49 VPWR VGND sg13cmos5l_decap_8
XFILLER_684_164 VPWR VGND sg13cmos5l_decap_8
XFILLER_125_63 VPWR VGND sg13cmos5l_decap_8
XFILLER_342_28 VPWR VGND sg13cmos5l_decap_8
XANTENNA__3731__X AXI_M_SOC_ARADDR3 VPWR VGND sg13cmos5l_antennanp
XFILLER_294_159 VPWR VGND sg13cmos5l_decap_8
XFILLER_272_91 VPWR VGND sg13cmos5l_fill_1
XFILLER_85_56 VPWR VGND sg13cmos5l_decap_8
XFILLER_235_204 VPWR VGND sg13cmos5l_decap_8
XFILLER_85_89 VPWR VGND sg13cmos5l_decap_4
XFILLER_451_112 VPWR VGND sg13cmos5l_decap_8
XFILLER_47_169 VPWR VGND sg13cmos5l_decap_8
XFILLER_597_116 VPWR VGND sg13cmos5l_decap_8
XFILLER_640_245 VPWR VGND sg13cmos5l_decap_8
XFILLER_62_117 VPWR VGND sg13cmos5l_decap_8
XFILLER_498_21 VPWR VGND sg13cmos5l_decap_8
XFILLER_18_94 VPWR VGND sg13cmos5l_decap_8
XFILLER_141_84 VPWR VGND sg13cmos5l_decap_8
XFILLER_55_191 VPWR VGND sg13cmos5l_decap_8
XFILLER_252_0 VPWR VGND sg13cmos5l_decap_8
XFILLER_389_263 VPWR VGND sg13cmos5l_fill_2
XFILLER_349_105 VPWR VGND sg13cmos5l_decap_8
XFILLER_498_98 VPWR VGND sg13cmos5l_decap_8
XFILLER_70_172 VPWR VGND sg13cmos5l_decap_4
XFILLER_648_35 VPWR VGND sg13cmos5l_decap_8
XFILLER_203_156 VPWR VGND sg13cmos5l_decap_8
XFILLER_34_60 VPWR VGND sg13cmos5l_fill_2
XANTENNA__3178__X Tile_X0Y0_N4BEG[2] VPWR VGND sg13cmos5l_antennanp
XFILLER_517_0 VPWR VGND sg13cmos5l_decap_8
XFILLER_367_36 VPWR VGND sg13cmos5l_decap_8
XFILLER_11_261 VPWR VGND sg13cmos5l_fill_1
XFILLER_357_182 VPWR VGND sg13cmos5l_decap_8
XFILLER_11_272 VPWR VGND sg13cmos5l_fill_1
XFILLER_517_28 VPWR VGND sg13cmos5l_decap_8
XFILLER_561_252 VPWR VGND sg13cmos5l_decap_4
XFILLER_664_56 VPWR VGND sg13cmos5l_decap_8
XFILLER_50_70 VPWR VGND sg13cmos5l_decap_4
XFILLER_506_179 VPWR VGND sg13cmos5l_decap_8
XANTENNA__2810__X Tile_X0Y3_E2BEG[0] VPWR VGND sg13cmos5l_antennanp
X_0610_ _0610_/Q Tile_X0Y8_FrameData[29] VGND VPWR Tile_X0Y9_FrameStrobe[6] latch
X_1590_ _1590_/Q Tile_X0Y2_FrameData[27] VGND VPWR Tile_X0Y9_FrameStrobe[5] latch
XFILLER_50_92 VPWR VGND sg13cmos5l_decap_8
X_0541_ _0541_/Q Tile_X0Y8_FrameData[2] VGND VPWR Tile_X0Y9_FrameStrobe[3] latch
XFILLER_313_252 VPWR VGND sg13cmos5l_decap_8
XFILLER_313_263 VPWR VGND sg13cmos5l_fill_2
X_0472_ _0472_/Q Tile_X0Y8_FrameData[7] VGND VPWR Tile_X0Y9_FrameStrobe[1] latch
X_3260_ Tile_X0Y0_FrameData_O[28] Tile_X0Y0_FrameData[28] VPWR VGND sg13cmos5l_buf_1
XFILLER_675_153 VPWR VGND sg13cmos5l_decap_8
XFILLER_316_73 VPWR VGND sg13cmos5l_decap_8
XFILLER_680_55 VPWR VGND sg13cmos5l_decap_8
XFILLER_533_49 VPWR VGND sg13cmos5l_decap_8
XFILLER_285_126 VPWR VGND sg13cmos5l_decap_8
X_2211_ _2211_/Q Tile_X0Y5_FrameData[2] VGND VPWR Tile_X0Y9_FrameStrobe[0] latch
XFILLER_675_186 VPWR VGND sg13cmos5l_decap_8
XFILLER_59_90 VPWR VGND sg13cmos5l_decap_8
XFILLER_252_28 VPWR VGND sg13cmos5l_decap_8
X_3191_ Tile_X0Y0_N4BEG[15] _3191_/A VPWR VGND sg13cmos5l_buf_1
XANTENNA__3641__X AXI_M_SOC_AWADDR2 VPWR VGND sg13cmos5l_antennanp
XFILLER_474_259 VPWR VGND sg13cmos5l_decap_8
X_2142_ _2142_/Q Tile_X0Y4_FrameData[7] VGND VPWR Tile_X0Y9_FrameStrobe[6] latch
XFILLER_226_204 VPWR VGND sg13cmos5l_decap_8
XFILLER_690_178 VPWR VGND sg13cmos5l_fill_2
XFILLER_616_264 VPWR VGND sg13cmos5l_decap_8
XFILLER_38_136 VPWR VGND sg13cmos5l_decap_8
XFILLER_442_101 VPWR VGND sg13cmos5l_fill_2
XFILLER_427_175 VPWR VGND sg13cmos5l_decap_8
XFILLER_293_181 VPWR VGND sg13cmos5l_decap_8
XFILLER_689_42 VPWR VGND sg13cmos5l_fill_1
X_2073_ _2073_/Q Tile_X0Y4_FrameData[12] VGND VPWR Tile_X0Y9_FrameStrobe[4] latch
XFILLER_226_259 VPWR VGND sg13cmos5l_fill_2
XFILLER_631_234 VPWR VGND sg13cmos5l_decap_8
XFILLER_689_64 VPWR VGND sg13cmos5l_decap_8
X_1024_ _1024_/Q Tile_X0Y0_FrameData[11] VGND VPWR Tile_X0Y9_FrameStrobe[2] latch
XFILLER_46_180 VPWR VGND sg13cmos5l_decap_8
XFILLER_241_229 VPWR VGND sg13cmos5l_decap_8
XFILLER_201_21 VPWR VGND sg13cmos5l_decap_8
XFILLER_596_160 VPWR VGND sg13cmos5l_decap_8
XFILLER_61_161 VPWR VGND sg13cmos5l_decap_8
XFILLER_558_35 VPWR VGND sg13cmos5l_decap_8
XFILLER_98_0 VPWR VGND sg13cmos5l_decap_8
XFILLER_61_194 VPWR VGND sg13cmos5l_decap_4
XFILLER_277_14 VPWR VGND sg13cmos5l_decap_8
X_2975_ Tile_X0Y8_FrameData_O[15] Tile_X0Y8_FrameData[15] VPWR VGND sg13cmos5l_buf_1
XANTENNA__3088__X Tile_X0Y7_E2BEG[2] VPWR VGND sg13cmos5l_antennanp
XFILLER_147_200 VPWR VGND sg13cmos5l_decap_8
XFILLER_355_119 VPWR VGND sg13cmos5l_decap_8
X_4714_ _4714_/X Tile_X0Y6_W1END[3] Tile_X0Y6_W2MID[0] Tile_X0Y6_W2END[0] _4552_/X
+ _2637_/Q _2636_/Q VPWR VGND sg13cmos5l_mux4_1
X_1926_ _1926_/Q Tile_X0Y3_FrameData[31] VGND VPWR Tile_X0Y9_FrameStrobe[0] latch
XFILLER_537_271 VPWR VGND sg13cmos5l_fill_2
XFILLER_708_49 VPWR VGND sg13cmos5l_decap_8
XFILLER_147_255 VPWR VGND sg13cmos5l_fill_2
X_4645_ _4645_/X Tile_X0Y9_N4END[9] _0055_/X _4694_/X _4698_/X _0269_/Q _0268_/Q VPWR
+ VGND sg13cmos5l_mux4_1
XFILLER_552_241 VPWR VGND sg13cmos5l_decap_8
XFILLER_427_28 VPWR VGND sg13cmos5l_decap_8
X_1857_ _1857_/Q Tile_X0Y3_FrameData[8] VGND VPWR Tile_X0Y9_FrameStrobe[5] latch
XFILLER_698_234 VPWR VGND sg13cmos5l_decap_4
XFILLER_162_214 VPWR VGND sg13cmos5l_fill_1
XFILLER_574_56 VPWR VGND sg13cmos5l_decap_8
XFILLER_357_91 VPWR VGND sg13cmos5l_decap_8
XFILLER_512_105 VPWR VGND sg13cmos5l_decap_8
X_0808_ _0808_/Q Tile_X0Y9_FrameData[23] VGND VPWR Tile_X0Y9_FrameStrobe[4] latch
XFILLER_698_267 VPWR VGND sg13cmos5l_decap_4
X_4576_ _4576_/X _4545_/X Tile_X0Y9_N4END[12] _4544_/X _0152_/X _2479_/Q _2478_/Q
+ VPWR VGND sg13cmos5l_mux4_1
XFILLER_701_216 VPWR VGND sg13cmos5l_fill_1
XFILLER_658_109 VPWR VGND sg13cmos5l_decap_4
XFILLER_293_35 VPWR VGND sg13cmos5l_decap_8
X_1788_ _1788_/Q Tile_X0Y3_FrameData[13] VGND VPWR Tile_X0Y9_FrameStrobe[3] latch
X_3527_ Tile_X0Y9_E2BEG[1] _4849_/X VPWR VGND sg13cmos5l_buf_1
XFILLER_304_241 VPWR VGND sg13cmos5l_decap_8
XFILLER_115_152 VPWR VGND sg13cmos5l_decap_8
X_0739_ _0739_/Q Tile_X0Y9_FrameData[28] VGND VPWR Tile_X0Y9_FrameStrobe[2] latch
XFILLER_666_142 VPWR VGND sg13cmos5l_fill_1
X_3458_ Tile_X0Y1_FrameData_O[16] Tile_X0Y1_FrameData[16] VPWR VGND sg13cmos5l_buf_1
XFILLER_443_49 VPWR VGND sg13cmos5l_decap_8
XFILLER_130_133 VPWR VGND sg13cmos5l_decap_8
XFILLER_373_90 VPWR VGND sg13cmos5l_fill_2
XFILLER_276_126 VPWR VGND sg13cmos5l_fill_2
XFILLER_162_28 VPWR VGND sg13cmos5l_decap_8
X_2409_ _2409_/Q Tile_X0Y5_FrameData[28] VGND VPWR Tile_X0Y9_FrameStrobe[7] latch
XFILLER_276_159 VPWR VGND sg13cmos5l_decap_8
XANTENNA__3551__X Tile_X0Y9_E6BEG[9] VPWR VGND sg13cmos5l_antennanp
X_3389_ Tile_X0Y2_E2BEGb[0] _4048_/X VPWR VGND sg13cmos5l_buf_1
XFILLER_29_103 VPWR VGND sg13cmos5l_decap_8
XFILLER_418_164 VPWR VGND sg13cmos5l_decap_4
XFILLER_84_231 VPWR VGND sg13cmos5l_fill_2
XFILLER_681_178 VPWR VGND sg13cmos5l_fill_1
XFILLER_217_226 VPWR VGND sg13cmos5l_decap_4
XFILLER_599_42 VPWR VGND sg13cmos5l_decap_8
XFILLER_433_112 VPWR VGND sg13cmos5l_decap_8
XFILLER_418_186 VPWR VGND sg13cmos5l_fill_1
XFILLER_579_105 VPWR VGND sg13cmos5l_decap_8
XFILLER_242_94 VPWR VGND sg13cmos5l_decap_8
XFILLER_176_7 VPWR VGND sg13cmos5l_decap_8
XFILLER_599_86 VPWR VGND sg13cmos5l_decap_8
XFILLER_433_167 VPWR VGND sg13cmos5l_decap_8
XFILLER_37_180 VPWR VGND sg13cmos5l_decap_8
XFILLER_111_21 VPWR VGND sg13cmos5l_decap_8
XFILLER_343_7 VPWR VGND sg13cmos5l_decap_8
XFILLER_587_171 VPWR VGND sg13cmos5l_decap_8
XFILLER_71_14 VPWR VGND sg13cmos5l_decap_8
XFILLER_468_35 VPWR VGND sg13cmos5l_decap_8
XFILLER_197_144 VPWR VGND sg13cmos5l_decap_8
XFILLER_187_14 VPWR VGND sg13cmos5l_decap_8
XFILLER_187_25 VPWR VGND sg13cmos5l_fill_2
XFILLER_386_266 VPWR VGND sg13cmos5l_decap_8
XFILLER_468_79 VPWR VGND sg13cmos5l_decap_8
XFILLER_197_188 VPWR VGND sg13cmos5l_decap_8
XFILLER_200_137 VPWR VGND sg13cmos5l_decap_8
XFILLER_510_7 VPWR VGND sg13cmos5l_decap_8
XFILLER_608_7 VPWR VGND sg13cmos5l_decap_8
XFILLER_339_182 VPWR VGND sg13cmos5l_decap_8
XFILLER_618_49 VPWR VGND sg13cmos5l_decap_8
XANTENNA__0134__Y AXI_M_SOC_AWLEN4 VPWR VGND sg13cmos5l_antennanp
XFILLER_337_28 VPWR VGND sg13cmos5l_decap_8
XANTENNA__3726__X AXI_M_SOC_WVALID VPWR VGND sg13cmos5l_antennanp
XFILLER_484_56 VPWR VGND sg13cmos5l_decap_8
XFILLER_267_91 VPWR VGND sg13cmos5l_decap_8
XFILLER_503_105 VPWR VGND sg13cmos5l_decap_8
XFILLER_354_196 VPWR VGND sg13cmos5l_decap_8
XFILLER_106_141 VPWR VGND sg13cmos5l_decap_8
XFILLER_106_152 VPWR VGND sg13cmos5l_fill_1
XFILLER_106_174 VPWR VGND sg13cmos5l_decap_8
XFILLER_20_84 VPWR VGND sg13cmos5l_fill_2
XFILLER_353_49 VPWR VGND sg13cmos5l_decap_8
XFILLER_121_133 VPWR VGND sg13cmos5l_decap_8
XFILLER_136_84 VPWR VGND sg13cmos5l_decap_8
XFILLER_714_70 VPWR VGND sg13cmos5l_decap_8
XFILLER_650_14 VPWR VGND sg13cmos5l_decap_8
XANTENNA__3461__X Tile_X0Y1_FrameData_O[19] VPWR VGND sg13cmos5l_antennanp
XFILLER_471_229 VPWR VGND sg13cmos5l_decap_8
XFILLER_29_93 VPWR VGND sg13cmos5l_fill_2
XFILLER_467_0 VPWR VGND sg13cmos5l_decap_8
XFILLER_424_112 VPWR VGND sg13cmos5l_decap_8
XFILLER_409_197 VPWR VGND sg13cmos5l_fill_1
XFILLER_90_212 VPWR VGND sg13cmos5l_decap_8
XFILLER_302_42 VPWR VGND sg13cmos5l_decap_8
XFILLER_290_151 VPWR VGND sg13cmos5l_decap_8
XFILLER_28_180 VPWR VGND sg13cmos5l_decap_8
XFILLER_90_256 VPWR VGND sg13cmos5l_decap_8
XFILLER_424_189 VPWR VGND sg13cmos5l_decap_8
XFILLER_302_75 VPWR VGND sg13cmos5l_decap_8
XFILLER_634_0 VPWR VGND sg13cmos5l_decap_8
XFILLER_659_56 VPWR VGND sg13cmos5l_decap_4
XANTENNA__2805__X Tile_X0Y3_E2BEGb[3] VPWR VGND sg13cmos5l_antennanp
XFILLER_377_222 VPWR VGND sg13cmos5l_decap_8
XFILLER_578_193 VPWR VGND sg13cmos5l_fill_1
XFILLER_91_7 VPWR VGND sg13cmos5l_decap_8
XFILLER_378_57 VPWR VGND sg13cmos5l_decap_4
XFILLER_378_68 VPWR VGND sg13cmos5l_decap_8
XFILLER_392_214 VPWR VGND sg13cmos5l_fill_2
XFILLER_519_260 VPWR VGND sg13cmos5l_decap_8
XFILLER_129_222 VPWR VGND sg13cmos5l_decap_4
X_2760_ Tile_X0Y3_FrameData_O[18] Tile_X0Y3_FrameData[18] VPWR VGND sg13cmos5l_buf_1
XFILLER_593_185 VPWR VGND sg13cmos5l_fill_2
XFILLER_519_271 VPWR VGND sg13cmos5l_fill_2
XFILLER_528_49 VPWR VGND sg13cmos5l_decap_8
X_1711_ _1711_/Q Tile_X0Y3_FrameData[26] VGND VPWR Tile_X0Y9_FrameStrobe[1] latch
XFILLER_61_91 VPWR VGND sg13cmos5l_decap_8
XFILLER_392_269 VPWR VGND sg13cmos5l_decap_4
XFILLER_247_28 VPWR VGND sg13cmos5l_decap_8
XFILLER_144_203 VPWR VGND sg13cmos5l_decap_8
X_2691_ _2691_/Q Tile_X0Y6_FrameData[4] VGND VPWR Tile_X0Y9_FrameStrobe[7] latch
XFILLER_394_45 VPWR VGND sg13cmos5l_fill_1
XANTENNA__3636__X Tile_X0Y9_S4BEG[14] VPWR VGND sg13cmos5l_antennanp
XFILLER_345_174 VPWR VGND sg13cmos5l_decap_8
X_4430_ _4430_/X _4355_/X _4471_/X _4470_/X _4354_/X _2203_/Q _2202_/Q VPWR VGND sg13cmos5l_mux4_1
XANTENNA_2 AXI_M_SOC_RDATA26 VPWR VGND sg13cmos5l_antennanp
X_1642_ _1642_/Q Tile_X0Y2_FrameData[7] VGND VPWR Tile_X0Y9_FrameStrobe[6] latch
XFILLER_6_42 VPWR VGND sg13cmos5l_decap_8
XFILLER_691_21 VPWR VGND sg13cmos5l_decap_8
X_4361_ _4361_/X Tile_X0Y6_W2MID[3] Tile_X0Y6_W2END[3] Tile_X0Y6_W6END[3] _4558_/X
+ _2679_/Q _2678_/Q VPWR VGND sg13cmos5l_mux4_1
X_1573_ _1573_/Q Tile_X0Y2_FrameData[12] VGND VPWR Tile_X0Y9_FrameStrobe[4] latch
X_3312_ Tile_X0Y4_EE4BEG[0] _4272_/X VPWR VGND sg13cmos5l_buf_1
XFILLER_360_199 VPWR VGND sg13cmos5l_fill_2
X_0524_ _0524_/Q Tile_X0Y8_FrameData[19] VGND VPWR Tile_X0Y9_FrameStrobe[3] latch
X_4292_ _4292_/X AXI_M_SOC_BRESP0 _4343_/X _4347_/X _4313_/X _2029_/Q _2028_/Q VPWR
+ VGND sg13cmos5l_mux4_1
XFILLER_263_49 VPWR VGND sg13cmos5l_decap_8
XFILLER_648_175 VPWR VGND sg13cmos5l_fill_2
XFILLER_624_70 VPWR VGND sg13cmos5l_decap_8
XFILLER_502_182 VPWR VGND sg13cmos5l_decap_8
XFILLER_112_155 VPWR VGND sg13cmos5l_decap_8
X_0455_ _0455_/Q Tile_X0Y8_FrameData[24] VGND VPWR Tile_X0Y9_FrameStrobe[1] latch
X_3243_ Tile_X0Y0_FrameData_O[11] Tile_X0Y0_FrameData[11] VPWR VGND sg13cmos5l_buf_1
XFILLER_663_123 VPWR VGND sg13cmos5l_fill_1
XFILLER_560_14 VPWR VGND sg13cmos5l_decap_8
XFILLER_258_148 VPWR VGND sg13cmos5l_fill_1
XANTENNA__3371__X Tile_X0Y2_EE4BEG[10] VPWR VGND sg13cmos5l_antennanp
XFILLER_273_118 VPWR VGND sg13cmos5l_fill_2
X_0386_ _0386_/Q Tile_X0Y7_FrameData[29] VGND VPWR Tile_X0Y9_FrameStrobe[7] latch
X_3174_ Tile_X0Y4_E6BEG[11] _4299_/X VPWR VGND sg13cmos5l_buf_1
XFILLER_13_0 VPWR VGND sg13cmos5l_decap_8
XFILLER_66_253 VPWR VGND sg13cmos5l_decap_8
X_2125_ _2125_/Q Tile_X0Y4_FrameData[24] VGND VPWR Tile_X0Y9_FrameStrobe[6] latch
XFILLER_710_28 VPWR VGND sg13cmos5l_decap_8
XFILLER_66_264 VPWR VGND sg13cmos5l_fill_1
XFILLER_281_140 VPWR VGND sg13cmos5l_decap_8
XFILLER_640_91 VPWR VGND sg13cmos5l_decap_8
XFILLER_26_128 VPWR VGND sg13cmos5l_decap_8
XFILLER_212_42 VPWR VGND sg13cmos5l_decap_8
XFILLER_214_207 VPWR VGND sg13cmos5l_decap_4
X_2056_ _2056_/Q Tile_X0Y4_FrameData[29] VGND VPWR Tile_X0Y9_FrameStrobe[4] latch
XFILLER_470_262 VPWR VGND sg13cmos5l_decap_8
XFILLER_81_245 VPWR VGND sg13cmos5l_decap_8
XFILLER_430_126 VPWR VGND sg13cmos5l_decap_8
XFILLER_179_100 VPWR VGND sg13cmos5l_decap_8
XFILLER_576_119 VPWR VGND sg13cmos5l_fill_2
XFILLER_569_56 VPWR VGND sg13cmos5l_decap_8
XFILLER_41_109 VPWR VGND sg13cmos5l_decap_8
X_1007_ _1007_/Q Tile_X0Y0_FrameData[28] VGND VPWR Tile_X0Y9_FrameStrobe[2] latch
XFILLER_569_182 VPWR VGND sg13cmos5l_decap_8
XFILLER_179_144 VPWR VGND sg13cmos5l_decap_8
XFILLER_288_57 VPWR VGND sg13cmos5l_decap_8
XFILLER_194_103 VPWR VGND sg13cmos5l_decap_8
XFILLER_383_203 VPWR VGND sg13cmos5l_decap_8
X_2958_ Tile_X0Y8_EE4BEG[14] _4758_/X VPWR VGND sg13cmos5l_buf_1
XFILLER_438_49 VPWR VGND sg13cmos5l_decap_8
XFILLER_585_77 VPWR VGND sg13cmos5l_decap_8
XFILLER_157_28 VPWR VGND sg13cmos5l_fill_1
X_1909_ _1909_/Q Tile_X0Y3_FrameData[20] VGND VPWR Tile_X0Y9_FrameStrobe[7] latch
XANTENNA__3546__X Tile_X0Y9_E6BEG[4] VPWR VGND sg13cmos5l_antennanp
X_2889_ Tile_X0Y6_FrameData_O[10] Tile_X0Y6_FrameData[10] VPWR VGND sg13cmos5l_buf_1
XFILLER_135_225 VPWR VGND sg13cmos5l_decap_8
X_4628_ _4628_/X Tile_X0Y7_WW4END[15] AXI_M_SOC_RDATA16 _4699_/X _4668_/X _0303_/Q
+ _0302_/Q VPWR VGND sg13cmos5l_mux4_1
XFILLER_351_133 VPWR VGND sg13cmos5l_decap_8
XFILLER_540_233 VPWR VGND sg13cmos5l_decap_8
XFILLER_497_126 VPWR VGND sg13cmos5l_decap_8
XFILLER_686_226 VPWR VGND sg13cmos5l_decap_8
XFILLER_237_72 VPWR VGND sg13cmos5l_decap_4
XFILLER_150_217 VPWR VGND sg13cmos5l_decap_8
X_4559_ _4559_/X _4475_/X _4591_/X _4590_/X _4474_/X _2457_/Q _2456_/Q VPWR VGND sg13cmos5l_mux4_1
XFILLER_500_119 VPWR VGND sg13cmos5l_decap_8
XFILLER_249_104 VPWR VGND sg13cmos5l_decap_4
XFILLER_173_49 VPWR VGND sg13cmos5l_decap_8
XFILLER_103_133 VPWR VGND sg13cmos5l_decap_8
XFILLER_534_70 VPWR VGND sg13cmos5l_decap_4
XFILLER_639_175 VPWR VGND sg13cmos5l_decap_8
XFILLER_534_81 VPWR VGND sg13cmos5l_decap_8
XFILLER_249_137 VPWR VGND sg13cmos5l_decap_4
XFILLER_106_43 VPWR VGND sg13cmos5l_decap_8
XFILLER_470_14 VPWR VGND sg13cmos5l_decap_8
XFILLER_106_54 VPWR VGND sg13cmos5l_fill_2
XFILLER_293_7 VPWR VGND sg13cmos5l_decap_8
XANTENNA__3281__X Tile_X0Y0_E6BEG[1] VPWR VGND sg13cmos5l_antennanp
XFILLER_66_14 VPWR VGND sg13cmos5l_decap_8
XFILLER_103_199 VPWR VGND sg13cmos5l_decap_8
XFILLER_654_156 VPWR VGND sg13cmos5l_decap_8
XFILLER_106_87 VPWR VGND sg13cmos5l_fill_2
XFILLER_57_231 VPWR VGND sg13cmos5l_decap_8
XFILLER_57_253 VPWR VGND sg13cmos5l_fill_1
XFILLER_620_28 VPWR VGND sg13cmos5l_decap_8
XFILLER_57_264 VPWR VGND sg13cmos5l_fill_1
XFILLER_460_7 VPWR VGND sg13cmos5l_decap_8
XFILLER_558_7 VPWR VGND sg13cmos5l_decap_8
XFILLER_550_91 VPWR VGND sg13cmos5l_decap_8
XFILLER_122_42 VPWR VGND sg13cmos5l_decap_8
XFILLER_72_234 VPWR VGND sg13cmos5l_decap_8
XFILLER_272_195 VPWR VGND sg13cmos5l_decap_8
XFILLER_82_35 VPWR VGND sg13cmos5l_decap_8
XFILLER_479_56 VPWR VGND sg13cmos5l_decap_8
XFILLER_421_126 VPWR VGND sg13cmos5l_decap_8
XFILLER_82_46 VPWR VGND sg13cmos5l_fill_1
XFILLER_567_119 VPWR VGND sg13cmos5l_decap_8
XFILLER_359_200 VPWR VGND sg13cmos5l_decap_8
XFILLER_198_35 VPWR VGND sg13cmos5l_decap_8
XFILLER_25_194 VPWR VGND sg13cmos5l_decap_8
XFILLER_198_68 VPWR VGND sg13cmos5l_decap_8
XFILLER_40_142 VPWR VGND sg13cmos5l_decap_8
XFILLER_709_168 VPWR VGND sg13cmos5l_decap_8
XFILLER_15_95 VPWR VGND sg13cmos5l_fill_1
XFILLER_709_179 VPWR VGND sg13cmos5l_fill_2
XFILLER_575_196 VPWR VGND sg13cmos5l_decap_8
XFILLER_374_247 VPWR VGND sg13cmos5l_fill_1
XFILLER_348_49 VPWR VGND sg13cmos5l_decap_8
XFILLER_709_70 VPWR VGND sg13cmos5l_decap_8
XFILLER_495_77 VPWR VGND sg13cmos5l_decap_8
XFILLER_327_141 VPWR VGND sg13cmos5l_decap_8
XFILLER_645_14 VPWR VGND sg13cmos5l_decap_8
XANTENNA__3456__X Tile_X0Y1_FrameData_O[14] VPWR VGND sg13cmos5l_antennanp
XFILLER_215_0 VPWR VGND sg13cmos5l_decap_8
XFILLER_531_200 VPWR VGND sg13cmos5l_decap_8
XFILLER_193_191 VPWR VGND sg13cmos5l_decap_8
XFILLER_31_72 VPWR VGND sg13cmos5l_decap_8
XFILLER_31_83 VPWR VGND sg13cmos5l_fill_2
XFILLER_677_215 VPWR VGND sg13cmos5l_fill_1
XFILLER_99_109 VPWR VGND sg13cmos5l_decap_4
XFILLER_677_237 VPWR VGND sg13cmos5l_decap_8
XFILLER_342_155 VPWR VGND sg13cmos5l_fill_1
XFILLER_488_148 VPWR VGND sg13cmos5l_decap_4
XFILLER_342_177 VPWR VGND sg13cmos5l_fill_2
XFILLER_661_35 VPWR VGND sg13cmos5l_decap_8
XFILLER_645_112 VPWR VGND sg13cmos5l_decap_8
XFILLER_584_0 VPWR VGND sg13cmos5l_decap_8
XFILLER_380_14 VPWR VGND sg13cmos5l_decap_8
XANTENNA__3191__X Tile_X0Y0_N4BEG[15] VPWR VGND sg13cmos5l_antennanp
XFILLER_429_259 VPWR VGND sg13cmos5l_decap_4
XFILLER_295_254 VPWR VGND sg13cmos5l_decap_8
XFILLER_0_271 VPWR VGND sg13cmos5l_fill_2
X_0240_ _0240_/Q Tile_X0Y7_FrameData[15] VGND VPWR Tile_X0Y9_FrameStrobe[2] latch
XFILLER_48_220 VPWR VGND sg13cmos5l_decap_8
XFILLER_444_218 VPWR VGND sg13cmos5l_decap_8
XFILLER_255_129 VPWR VGND sg13cmos5l_fill_1
XFILLER_645_189 VPWR VGND sg13cmos5l_decap_8
X_0171_ _0171_/Q Tile_X0Y7_FrameData[20] VGND VPWR Tile_X0Y9_FrameStrobe[0] latch
XFILLER_530_28 VPWR VGND sg13cmos5l_decap_8
XFILLER_63_223 VPWR VGND sg13cmos5l_decap_8
XFILLER_598_255 VPWR VGND sg13cmos5l_decap_8
XFILLER_452_262 VPWR VGND sg13cmos5l_decap_8
XFILLER_263_195 VPWR VGND sg13cmos5l_decap_4
XFILLER_389_56 VPWR VGND sg13cmos5l_decap_8
XFILLER_23_109 VPWR VGND sg13cmos5l_decap_8
X_3930_ _3930_/X _3985_/X Tile_X0Y1_WW4END[6] _3984_/X AXI_M_SOC_ARREADY _1349_/Q
+ _1348_/Q VPWR VGND sg13cmos5l_mux4_1
XFILLER_610_83 VPWR VGND sg13cmos5l_decap_8
XFILLER_686_21 VPWR VGND sg13cmos5l_decap_8
XFILLER_31_120 VPWR VGND sg13cmos5l_fill_1
X_3861_ _3861_/X _3850_/X Tile_X0Y0_W6END[2] Tile_X0Y0_S1END[2] _3861_/A3 _0943_/Q
+ _0942_/Q VPWR VGND sg13cmos5l_mux4_1
XFILLER_31_142 VPWR VGND sg13cmos5l_decap_8
XFILLER_176_114 VPWR VGND sg13cmos5l_decap_8
XFILLER_715_105 VPWR VGND sg13cmos5l_decap_8
X_2812_ Tile_X0Y3_E2BEG[2] _4150_/X VPWR VGND sg13cmos5l_buf_1
XFILLER_686_87 VPWR VGND sg13cmos5l_decap_8
XFILLER_686_98 VPWR VGND sg13cmos5l_fill_1
X_3792_ _3792_/X Tile_X0Y0_W1END[0] Tile_X0Y0_WW4END[0] Tile_X0Y0_W6END[8] _3881_/X
+ _1153_/Q _1152_/Q VPWR VGND sg13cmos5l_mux4_1
XFILLER_566_196 VPWR VGND sg13cmos5l_decap_8
XFILLER_31_186 VPWR VGND sg13cmos5l_fill_1
XFILLER_258_49 VPWR VGND sg13cmos5l_decap_8
XFILLER_619_70 VPWR VGND sg13cmos5l_decap_8
XFILLER_581_133 VPWR VGND sg13cmos5l_decap_8
XFILLER_507_230 VPWR VGND sg13cmos5l_decap_8
X_2743_ Tile_X0Y3_FrameData_O[1] Tile_X0Y3_FrameData[1] VPWR VGND sg13cmos5l_buf_1
XFILLER_708_190 VPWR VGND sg13cmos5l_decap_8
XFILLER_507_241 VPWR VGND sg13cmos5l_fill_2
XANTENNA__3366__X Tile_X0Y2_EE4BEG[5] VPWR VGND sg13cmos5l_antennanp
XFILLER_117_214 VPWR VGND sg13cmos5l_decap_8
XFILLER_191_139 VPWR VGND sg13cmos5l_decap_8
XFILLER_581_188 VPWR VGND sg13cmos5l_decap_8
XFILLER_555_58 VPWR VGND sg13cmos5l_decap_8
X_2674_ _2674_/Q Tile_X0Y6_FrameData[21] VGND VPWR Tile_X0Y9_FrameStrobe[7] latch
XFILLER_333_122 VPWR VGND sg13cmos5l_decap_8
XFILLER_318_196 VPWR VGND sg13cmos5l_decap_8
X_4413_ _4413_/X AXI_M_SOC_RLAST _4453_/X _4457_/X _4431_/X _2277_/Q _2276_/Q VPWR
+ VGND sg13cmos5l_mux4_1
XFILLER_333_155 VPWR VGND sg13cmos5l_decap_8
X_1625_ _1625_/Q Tile_X0Y2_FrameData[24] VGND VPWR Tile_X0Y9_FrameStrobe[6] latch
XFILLER_705_28 VPWR VGND sg13cmos5l_decap_8
XFILLER_479_148 VPWR VGND sg13cmos5l_fill_1
XFILLER_333_166 VPWR VGND sg13cmos5l_fill_2
XFILLER_635_91 VPWR VGND sg13cmos5l_decap_8
XFILLER_207_42 VPWR VGND sg13cmos5l_decap_8
X_4344_ _4344_/X _4302_/X _0099_/X _4301_/X _0112_/X _1965_/Q _1964_/Q VPWR VGND sg13cmos5l_mux4_1
X_1556_ _1556_/Q Tile_X0Y2_FrameData[29] VGND VPWR Tile_X0Y9_FrameStrobe[4] latch
XFILLER_571_35 VPWR VGND sg13cmos5l_decap_8
XFILLER_354_70 VPWR VGND sg13cmos5l_decap_8
XFILLER_286_210 VPWR VGND sg13cmos5l_decap_8
XFILLER_636_112 VPWR VGND sg13cmos5l_decap_8
X_0507_ _0507_/Q Tile_X0Y8_FrameData[4] VGND VPWR Tile_X0Y9_FrameStrobe[2] latch
XFILLER_98_175 VPWR VGND sg13cmos5l_decap_4
X_4275_ _4275_/X Tile_X0Y4_WW4END[12] AXI_M_SOC_BRESP1 _4348_/X _4318_/X _2063_/Q
+ _2062_/Q VPWR VGND sg13cmos5l_mux4_1
XFILLER_286_254 VPWR VGND sg13cmos5l_fill_1
XFILLER_140_272 VPWR VGND sg13cmos5l_fill_1
X_1487_ _1487_/Q Tile_X0Y2_FrameData[2] VGND VPWR Tile_X0Y9_FrameStrobe[1] latch
XFILLER_290_36 VPWR VGND sg13cmos5l_decap_8
XFILLER_435_207 VPWR VGND sg13cmos5l_decap_8
X_3226_ Tile_X0Y0_FrameStrobe_O[14] Tile_X0Y9_FrameStrobe[14] VPWR VGND sg13cmos5l_buf_1
X_0438_ _0438_/Q Tile_X0Y8_FrameData[9] VGND VPWR Tile_X0Y9_FrameStrobe[0] latch
XFILLER_636_189 VPWR VGND sg13cmos5l_fill_1
XFILLER_504_84 VPWR VGND sg13cmos5l_decap_8
XFILLER_100_169 VPWR VGND sg13cmos5l_decap_4
XFILLER_651_126 VPWR VGND sg13cmos5l_decap_8
XFILLER_589_200 VPWR VGND sg13cmos5l_decap_8
XFILLER_440_28 VPWR VGND sg13cmos5l_decap_8
X_3157_ Tile_X0Y7_FrameData_O[27] Tile_X0Y7_FrameData[27] VPWR VGND sg13cmos5l_buf_1
X_0369_ _0369_/Q Tile_X0Y7_FrameData[14] VGND VPWR Tile_X0Y9_FrameStrobe[6] latch
XFILLER_36_28 VPWR VGND sg13cmos5l_decap_8
X_2108_ _2108_/Q Tile_X0Y4_FrameData[9] VGND VPWR Tile_X0Y9_FrameStrobe[5] latch
XFILLER_199_206 VPWR VGND sg13cmos5l_decap_8
XFILLER_54_245 VPWR VGND sg13cmos5l_decap_4
X_3088_ Tile_X0Y7_E2BEG[2] _4614_/X VPWR VGND sg13cmos5l_buf_1
XFILLER_299_56 VPWR VGND sg13cmos5l_decap_8
X_2039_ _2039_/Q Tile_X0Y4_FrameData[14] VGND VPWR Tile_X0Y9_FrameStrobe[3] latch
XFILLER_520_94 VPWR VGND sg13cmos5l_decap_4
XFILLER_596_21 VPWR VGND sg13cmos5l_decap_8
XFILLER_299_89 VPWR VGND sg13cmos5l_decap_8
XFILLER_557_152 VPWR VGND sg13cmos5l_fill_2
XFILLER_22_142 VPWR VGND sg13cmos5l_fill_2
XFILLER_356_203 VPWR VGND sg13cmos5l_decap_8
XFILLER_706_105 VPWR VGND sg13cmos5l_decap_8
XFILLER_139_7 VPWR VGND sg13cmos5l_decap_8
XFILLER_167_147 VPWR VGND sg13cmos5l_decap_8
XFILLER_572_133 VPWR VGND sg13cmos5l_decap_8
XFILLER_309_130 VPWR VGND sg13cmos5l_decap_8
XFILLER_465_14 VPWR VGND sg13cmos5l_decap_8
XANTENNA__3276__X Tile_X0Y0_EE4BEG[12] VPWR VGND sg13cmos5l_antennanp
XFILLER_309_174 VPWR VGND sg13cmos5l_decap_8
XFILLER_513_211 VPWR VGND sg13cmos5l_decap_8
XFILLER_184_15 VPWR VGND sg13cmos5l_decap_8
XFILLER_324_122 VPWR VGND sg13cmos5l_decap_8
XFILLER_306_7 VPWR VGND sg13cmos5l_decap_8
XFILLER_714_182 VPWR VGND sg13cmos5l_decap_8
XFILLER_659_215 VPWR VGND sg13cmos5l_decap_8
XFILLER_108_269 VPWR VGND sg13cmos5l_decap_4
XFILLER_615_28 VPWR VGND sg13cmos5l_decap_8
XFILLER_117_42 VPWR VGND sg13cmos5l_decap_8
XFILLER_190_194 VPWR VGND sg13cmos5l_fill_1
XFILLER_545_91 VPWR VGND sg13cmos5l_decap_8
XFILLER_485_107 VPWR VGND sg13cmos5l_decap_8
XFILLER_117_53 VPWR VGND sg13cmos5l_fill_2
XFILLER_324_199 VPWR VGND sg13cmos5l_decap_4
XFILLER_481_35 VPWR VGND sg13cmos5l_decap_8
XFILLER_89_175 VPWR VGND sg13cmos5l_decap_8
XFILLER_675_7 VPWR VGND sg13cmos5l_decap_8
XFILLER_77_57 VPWR VGND sg13cmos5l_fill_1
XFILLER_627_134 VPWR VGND sg13cmos5l_fill_1
XFILLER_291_4 VPWR VGND sg13cmos5l_fill_1
XFILLER_493_140 VPWR VGND sg13cmos5l_decap_8
XFILLER_631_49 VPWR VGND sg13cmos5l_decap_8
XFILLER_627_189 VPWR VGND sg13cmos5l_decap_8
XFILLER_642_126 VPWR VGND sg13cmos5l_decap_8
XFILLER_350_28 VPWR VGND sg13cmos5l_decap_8
XFILLER_133_63 VPWR VGND sg13cmos5l_decap_8
XFILLER_245_140 VPWR VGND sg13cmos5l_decap_8
XFILLER_280_91 VPWR VGND sg13cmos5l_decap_8
XFILLER_245_151 VPWR VGND sg13cmos5l_decap_8
XFILLER_45_223 VPWR VGND sg13cmos5l_decap_8
XANTENNA_200 Tile_X0Y9_N2MID[5] VPWR VGND sg13cmos5l_antennanp
XANTENNA_211 Tile_X0Y9_N4END[14] VPWR VGND sg13cmos5l_antennanp
XANTENNA_222 Tile_X0Y9_N4END[14] VPWR VGND sg13cmos5l_antennanp
XFILLER_165_0 VPWR VGND sg13cmos5l_decap_8
XANTENNA_233 Tile_X0Y0_FrameData[6] VPWR VGND sg13cmos5l_antennanp
XFILLER_595_214 VPWR VGND sg13cmos5l_decap_8
XFILLER_260_187 VPWR VGND sg13cmos5l_decap_8
XFILLER_158_103 VPWR VGND sg13cmos5l_decap_8
XFILLER_198_272 VPWR VGND sg13cmos5l_fill_1
XFILLER_402_170 VPWR VGND sg13cmos5l_decap_8
XFILLER_332_0 VPWR VGND sg13cmos5l_decap_8
XFILLER_347_236 VPWR VGND sg13cmos5l_fill_2
XFILLER_9_135 VPWR VGND sg13cmos5l_decap_8
XFILLER_656_35 VPWR VGND sg13cmos5l_decap_8
XFILLER_563_133 VPWR VGND sg13cmos5l_decap_8
XFILLER_439_70 VPWR VGND sg13cmos5l_decap_4
XFILLER_42_71 VPWR VGND sg13cmos5l_decap_8
XFILLER_375_14 VPWR VGND sg13cmos5l_decap_8
XFILLER_656_79 VPWR VGND sg13cmos5l_decap_8
XANTENNA__3186__X Tile_X0Y0_N4BEG[10] VPWR VGND sg13cmos5l_antennanp
XFILLER_173_128 VPWR VGND sg13cmos5l_decap_8
XFILLER_712_119 VPWR VGND sg13cmos5l_decap_8
XFILLER_315_111 VPWR VGND sg13cmos5l_decap_8
XFILLER_705_193 VPWR VGND sg13cmos5l_decap_8
XFILLER_504_244 VPWR VGND sg13cmos5l_decap_8
XFILLER_181_150 VPWR VGND sg13cmos5l_decap_8
XFILLER_315_155 VPWR VGND sg13cmos5l_decap_8
XFILLER_525_28 VPWR VGND sg13cmos5l_decap_8
XFILLER_308_63 VPWR VGND sg13cmos5l_decap_8
XFILLER_370_272 VPWR VGND sg13cmos5l_fill_1
X_1410_ _1410_/Q Tile_X0Y1_FrameData[23] VGND VPWR Tile_X0Y9_FrameStrobe[7] latch
X_2390_ _2390_/Q Tile_X0Y5_FrameData[15] VGND VPWR Tile_X0Y9_FrameStrobe[6] latch
XFILLER_672_89 VPWR VGND sg13cmos5l_decap_8
XFILLER_391_35 VPWR VGND sg13cmos5l_decap_8
XFILLER_618_112 VPWR VGND sg13cmos5l_decap_8
XFILLER_3_21 VPWR VGND sg13cmos5l_decap_8
XFILLER_330_169 VPWR VGND sg13cmos5l_decap_8
X_1341_ _1341_/Q Tile_X0Y1_FrameData[28] VGND VPWR Tile_X0Y9_FrameStrobe[5] latch
XFILLER_391_68 VPWR VGND sg13cmos5l_decap_4
XFILLER_122_272 VPWR VGND sg13cmos5l_fill_1
XFILLER_95_112 VPWR VGND sg13cmos5l_decap_8
XFILLER_673_251 VPWR VGND sg13cmos5l_decap_8
XFILLER_484_162 VPWR VGND sg13cmos5l_decap_4
X_4060_ _4060_/X Tile_X0Y2_WW4END[11] AXI_M_SOC_AWREADY _4127_/X _4103_/X _1553_/Q
+ _1552_/Q VPWR VGND sg13cmos5l_mux4_1
XFILLER_324_73 VPWR VGND sg13cmos5l_decap_8
X_1272_ _1272_/Q Tile_X0Y1_FrameData[1] VGND VPWR Tile_X0Y9_FrameStrobe[2] latch
XFILLER_541_49 VPWR VGND sg13cmos5l_decap_8
XFILLER_283_224 VPWR VGND sg13cmos5l_decap_8
XFILLER_95_156 VPWR VGND sg13cmos5l_fill_1
XFILLER_3_98 VPWR VGND sg13cmos5l_decap_8
XFILLER_283_235 VPWR VGND sg13cmos5l_fill_1
XFILLER_633_126 VPWR VGND sg13cmos5l_decap_8
XFILLER_484_195 VPWR VGND sg13cmos5l_decap_8
X_3011_ Tile_X0Y5_E2BEGb[6] _4386_/X VPWR VGND sg13cmos5l_buf_1
XFILLER_260_28 VPWR VGND sg13cmos5l_decap_8
X_0223_ _0223_/Q Tile_X0Y7_FrameData[0] VGND VPWR Tile_X0Y9_FrameStrobe[1] latch
X_0154_ _3183_/A _3912_/X _3913_/X _1638_/Q VPWR VGND sg13cmos5l_mux2_1
XFILLER_251_121 VPWR VGND sg13cmos5l_decap_8
XFILLER_697_42 VPWR VGND sg13cmos5l_decap_8
XFILLER_397_114 VPWR VGND sg13cmos5l_decap_8
X_0085_ _0085_/X _3873_/X _3874_/X _2149_/Q VPWR VGND sg13cmos5l_mux2_1
XFILLER_440_254 VPWR VGND sg13cmos5l_decap_8
X_3913_ _3913_/X _4123_/X _4127_/X _4104_/X _4103_/X _1640_/Q _1639_/Q VPWR VGND sg13cmos5l_mux4_1
XFILLER_539_141 VPWR VGND sg13cmos5l_decap_8
XFILLER_251_198 VPWR VGND sg13cmos5l_decap_8
X_4893_ _4893_/X Tile_X0Y9_N1END[1] Tile_X0Y9_W6END[1] _4897_/X _4893_/A3 _0677_/Q
+ _0676_/Q VPWR VGND sg13cmos5l_mux4_1
XFILLER_554_100 VPWR VGND sg13cmos5l_fill_1
X_3844_ _3844_/X Tile_X0Y0_W2MID[2] _3884_/X _3879_/X _3858_/X _1017_/Q _1016_/Q VPWR
+ VGND sg13cmos5l_mux4_1
XFILLER_80_0 VPWR VGND sg13cmos5l_decap_8
XFILLER_566_35 VPWR VGND sg13cmos5l_decap_8
XFILLER_349_70 VPWR VGND sg13cmos5l_decap_8
XFILLER_338_269 VPWR VGND sg13cmos5l_decap_4
XFILLER_285_14 VPWR VGND sg13cmos5l_decap_8
X_3775_ _3775_/X Tile_X0Y0_WW4END[4] Tile_X0Y0_WW4END[12] Tile_X0Y0_W6END[4] _3885_/X
+ _1001_/Q _1000_/Q VPWR VGND sg13cmos5l_mux4_1
XFILLER_353_217 VPWR VGND sg13cmos5l_decap_8
XANTENNA__3096__X Tile_X0Y7_E2BEGb[2] VPWR VGND sg13cmos5l_antennanp
X_0987_ _0987_/Q Tile_X0Y0_FrameData[16] VGND VPWR Tile_X0Y9_FrameStrobe[1] latch
XFILLER_703_119 VPWR VGND sg13cmos5l_decap_8
XFILLER_716_38 VPWR VGND sg13cmos5l_fill_1
X_2726_ _4895_/A3 VPWR VGND sg13cmos5l_tielo
XFILLER_554_199 VPWR VGND sg13cmos5l_decap_8
XFILLER_8_190 VPWR VGND sg13cmos5l_fill_1
XFILLER_218_63 VPWR VGND sg13cmos5l_decap_8
XFILLER_435_28 VPWR VGND sg13cmos5l_decap_8
X_2657_ _2657_/Q Tile_X0Y6_FrameData[6] VGND VPWR Tile_X0Y9_FrameStrobe[6] latch
XFILLER_361_272 VPWR VGND sg13cmos5l_fill_1
XFILLER_582_56 VPWR VGND sg13cmos5l_decap_8
XFILLER_656_207 VPWR VGND sg13cmos5l_decap_4
XFILLER_467_107 VPWR VGND sg13cmos5l_decap_8
X_1608_ _1608_/Q Tile_X0Y2_FrameData[9] VGND VPWR Tile_X0Y9_FrameStrobe[5] latch
XFILLER_656_218 VPWR VGND sg13cmos5l_decap_8
XFILLER_510_236 VPWR VGND sg13cmos5l_fill_1
X_2588_ _2588_/Q Tile_X0Y6_FrameData[11] VGND VPWR Tile_X0Y9_FrameStrobe[4] latch
XFILLER_321_147 VPWR VGND sg13cmos5l_decap_8
XFILLER_510_258 VPWR VGND sg13cmos5l_decap_4
X_4327_ _4327_/X _4805_/X _4809_/X _4813_/X _4787_/X _0644_/Q _0643_/Q VPWR VGND sg13cmos5l_mux4_1
X_1539_ _1539_/Q Tile_X0Y2_FrameData[14] VGND VPWR Tile_X0Y9_FrameStrobe[3] latch
XFILLER_113_272 VPWR VGND sg13cmos5l_fill_1
XFILLER_86_112 VPWR VGND sg13cmos5l_decap_8
XFILLER_664_240 VPWR VGND sg13cmos5l_decap_4
XFILLER_475_151 VPWR VGND sg13cmos5l_decap_8
XFILLER_664_251 VPWR VGND sg13cmos5l_decap_4
XFILLER_219_118 VPWR VGND sg13cmos5l_fill_2
XFILLER_475_162 VPWR VGND sg13cmos5l_fill_2
X_4258_ _4258_/X Tile_X0Y4_W2MID[5] AXI_M_SOC_BRESP0 _4317_/X _4316_/X _2097_/Q _2096_/Q
+ VPWR VGND sg13cmos5l_mux4_1
XFILLER_451_49 VPWR VGND sg13cmos5l_decap_8
XFILLER_234_95 VPWR VGND sg13cmos5l_decap_8
XFILLER_170_28 VPWR VGND sg13cmos5l_decap_8
X_3209_ Tile_X0Y0_N1BEG[1] _3781_/X VPWR VGND sg13cmos5l_buf_1
XFILLER_86_189 VPWR VGND sg13cmos5l_fill_2
X_4189_ _4189_/X AXI_M_SOC_BVALID _4224_/X _4228_/X _4208_/X _1763_/Q _1762_/Q VPWR
+ VGND sg13cmos5l_mux4_1
XFILLER_490_154 VPWR VGND sg13cmos5l_decap_4
XFILLER_227_151 VPWR VGND sg13cmos5l_decap_8
XFILLER_27_245 VPWR VGND sg13cmos5l_decap_8
XFILLER_388_103 VPWR VGND sg13cmos5l_decap_8
XFILLER_431_221 VPWR VGND sg13cmos5l_decap_8
XFILLER_103_77 VPWR VGND sg13cmos5l_decap_8
XFILLER_242_143 VPWR VGND sg13cmos5l_decap_4
XFILLER_256_7 VPWR VGND sg13cmos5l_decap_8
XFILLER_400_42 VPWR VGND sg13cmos5l_decap_8
XFILLER_179_37 VPWR VGND sg13cmos5l_decap_8
XFILLER_329_203 VPWR VGND sg13cmos5l_fill_1
XFILLER_329_225 VPWR VGND sg13cmos5l_decap_8
XANTENNA__2903__X Tile_X0Y6_FrameData_O[24] VPWR VGND sg13cmos5l_antennanp
XFILLER_423_7 VPWR VGND sg13cmos5l_decap_8
XFILLER_10_112 VPWR VGND sg13cmos5l_fill_1
XFILLER_476_35 VPWR VGND sg13cmos5l_decap_8
XFILLER_329_29 VPWR VGND sg13cmos5l_decap_8
XFILLER_545_144 VPWR VGND sg13cmos5l_decap_8
XFILLER_195_14 VPWR VGND sg13cmos5l_decap_8
XFILLER_344_206 VPWR VGND sg13cmos5l_decap_8
XFILLER_6_105 VPWR VGND sg13cmos5l_decap_8
XFILLER_545_177 VPWR VGND sg13cmos5l_decap_8
XFILLER_10_178 VPWR VGND sg13cmos5l_decap_8
XFILLER_12_63 VPWR VGND sg13cmos5l_decap_8
XFILLER_626_49 VPWR VGND sg13cmos5l_decap_8
XFILLER_498_210 VPWR VGND sg13cmos5l_decap_8
XFILLER_560_147 VPWR VGND sg13cmos5l_decap_8
XFILLER_170_109 VPWR VGND sg13cmos5l_fill_2
XFILLER_345_28 VPWR VGND sg13cmos5l_decap_8
XFILLER_128_63 VPWR VGND sg13cmos5l_decap_8
XFILLER_163_172 VPWR VGND sg13cmos5l_decap_8
XFILLER_352_272 VPWR VGND sg13cmos5l_fill_1
XANTENNA__3734__X AXI_M_SOC_ARADDR6 VPWR VGND sg13cmos5l_antennanp
XFILLER_501_203 VPWR VGND sg13cmos5l_decap_8
XFILLER_492_56 VPWR VGND sg13cmos5l_decap_8
XFILLER_312_114 VPWR VGND sg13cmos5l_decap_8
XFILLER_458_107 VPWR VGND sg13cmos5l_decap_4
XFILLER_275_91 VPWR VGND sg13cmos5l_decap_4
XFILLER_88_56 VPWR VGND sg13cmos5l_decap_8
XFILLER_77_101 VPWR VGND sg13cmos5l_decap_8
XFILLER_466_173 VPWR VGND sg13cmos5l_decap_8
XFILLER_361_49 VPWR VGND sg13cmos5l_decap_8
XFILLER_282_0 VPWR VGND sg13cmos5l_decap_8
XFILLER_481_143 VPWR VGND sg13cmos5l_decap_8
XFILLER_670_243 VPWR VGND sg13cmos5l_decap_8
XFILLER_18_212 VPWR VGND sg13cmos5l_decap_8
XFILLER_407_251 VPWR VGND sg13cmos5l_decap_8
XFILLER_37_60 VPWR VGND sg13cmos5l_decap_4
XFILLER_92_159 VPWR VGND sg13cmos5l_decap_8
XFILLER_568_203 VPWR VGND sg13cmos5l_decap_8
XFILLER_547_0 VPWR VGND sg13cmos5l_decap_8
XFILLER_422_243 VPWR VGND sg13cmos5l_fill_2
XFILLER_422_254 VPWR VGND sg13cmos5l_decap_4
XFILLER_233_176 VPWR VGND sg13cmos5l_decap_8
XFILLER_714_0 VPWR VGND sg13cmos5l_decap_8
XFILLER_310_86 VPWR VGND sg13cmos5l_decap_8
XFILLER_667_56 VPWR VGND sg13cmos5l_decap_8
XANTENNA__2813__X Tile_X0Y3_E2BEG[3] VPWR VGND sg13cmos5l_antennanp
X_0910_ _0910_/Q Tile_X0Y9_FrameData[17] VGND VPWR Tile_X0Y9_FrameStrobe[7] latch
X_1890_ _1890_/Q Tile_X0Y3_FrameData[7] VGND VPWR Tile_X0Y9_FrameStrobe[6] latch
XFILLER_386_35 VPWR VGND sg13cmos5l_decap_8
XFILLER_169_70 VPWR VGND sg13cmos5l_decap_8
XFILLER_186_253 VPWR VGND sg13cmos5l_decap_8
XFILLER_536_155 VPWR VGND sg13cmos5l_decap_8
X_0841_ _0841_/Q Tile_X0Y9_FrameData[22] VGND VPWR Tile_X0Y9_FrameStrobe[5] latch
XFILLER_591_272 VPWR VGND sg13cmos5l_fill_1
XFILLER_551_125 VPWR VGND sg13cmos5l_decap_8
X_3560_ Tile_X0Y9_EE4BEG[6] _4870_/X VPWR VGND sg13cmos5l_buf_1
XFILLER_697_118 VPWR VGND sg13cmos5l_decap_8
X_0772_ _0772_/Q Tile_X0Y9_FrameData[27] VGND VPWR Tile_X0Y9_FrameStrobe[3] latch
XFILLER_536_49 VPWR VGND sg13cmos5l_decap_8
XFILLER_489_210 VPWR VGND sg13cmos5l_fill_1
XFILLER_466_90 VPWR VGND sg13cmos5l_decap_4
X_2511_ _2511_/Q Tile_X0Y6_FrameData[24] VGND VPWR Tile_X0Y9_FrameStrobe[2] latch
XFILLER_350_209 VPWR VGND sg13cmos5l_decap_8
X_3491_ Tile_X0Y1_E6BEG[1] _3965_/X VPWR VGND sg13cmos5l_buf_1
XANTENNA__3644__X AXI_M_SOC_AWADDR5 VPWR VGND sg13cmos5l_antennanp
XFILLER_185_80 VPWR VGND sg13cmos5l_decap_4
XFILLER_343_272 VPWR VGND sg13cmos5l_fill_1
XFILLER_185_91 VPWR VGND sg13cmos5l_decap_8
X_2442_ _2442_/Q Tile_X0Y6_FrameData[29] VGND VPWR Tile_X0Y9_FrameStrobe[0] latch
X_2373_ _2373_/Q Tile_X0Y5_FrameData[0] VGND VPWR Tile_X0Y9_FrameStrobe[5] latch
XFILLER_68_112 VPWR VGND sg13cmos5l_decap_8
X_4112_ _4112_/X _4574_/X _4578_/X _4582_/X _4557_/X _2665_/Q _2664_/Q VPWR VGND sg13cmos5l_mux4_1
X_1324_ _1324_/Q Tile_X0Y1_FrameData[13] VGND VPWR Tile_X0Y9_FrameStrobe[4] latch
XFILLER_110_242 VPWR VGND sg13cmos5l_fill_2
XFILLER_271_49 VPWR VGND sg13cmos5l_decap_8
XFILLER_632_70 VPWR VGND sg13cmos5l_decap_8
XFILLER_204_21 VPWR VGND sg13cmos5l_decap_8
XFILLER_256_246 VPWR VGND sg13cmos5l_decap_8
XFILLER_606_137 VPWR VGND sg13cmos5l_decap_8
X_4043_ _4043_/X Tile_X0Y2_W2MID[4] AXI_M_SOC_AWREADY _4103_/X _4102_/X _1587_/Q _1586_/Q
+ VPWR VGND sg13cmos5l_mux4_1
XFILLER_68_189 VPWR VGND sg13cmos5l_decap_8
X_1255_ _1255_/Q Tile_X0Y1_FrameData[18] VGND VPWR Tile_X0Y9_FrameStrobe[2] latch
XFILLER_606_159 VPWR VGND sg13cmos5l_decap_4
X_0206_ _0206_/Q Tile_X0Y7_FrameData[17] VGND VPWR Tile_X0Y9_FrameStrobe[1] latch
XFILLER_209_184 VPWR VGND sg13cmos5l_decap_8
X_1186_ _1186_/Q Tile_X0Y1_FrameData[23] VGND VPWR Tile_X0Y9_FrameStrobe[0] latch
XFILLER_621_129 VPWR VGND sg13cmos5l_decap_8
XFILLER_413_221 VPWR VGND sg13cmos5l_decap_8
XFILLER_501_63 VPWR VGND sg13cmos5l_decap_8
X_0137_ AXI_M_SOC_AWLEN6 _0940_/Q _3677_/X VPWR VGND sg13cmos5l_nor2b_1
XFILLER_413_265 VPWR VGND sg13cmos5l_decap_8
XFILLER_220_42 VPWR VGND sg13cmos5l_decap_8
XFILLER_224_187 VPWR VGND sg13cmos5l_decap_8
X_0068_ AXI_M_SOC_WSTRB3 _0935_/Q _3725_/X VPWR VGND sg13cmos5l_or2_1
XFILLER_385_106 VPWR VGND sg13cmos5l_decap_8
XFILLER_574_217 VPWR VGND sg13cmos5l_decap_8
XFILLER_577_56 VPWR VGND sg13cmos5l_decap_8
XFILLER_220_97 VPWR VGND sg13cmos5l_fill_1
XFILLER_378_180 VPWR VGND sg13cmos5l_decap_8
XFILLER_177_242 VPWR VGND sg13cmos5l_decap_8
X_4876_ _4876_/X Tile_X0Y9_WW4END[3] AXI_M_SOC_RDATA3 _4919_/X _4907_/X _0791_/Q _0790_/Q
+ VPWR VGND sg13cmos5l_mux4_1
XFILLER_296_35 VPWR VGND sg13cmos5l_decap_8
X_3827_ _3827_/X Tile_X0Y0_WW4END[8] _3876_/X _3853_/X _3860_/X _1051_/Q _1050_/Q
+ VPWR VGND sg13cmos5l_mux4_1
XFILLER_192_223 VPWR VGND sg13cmos5l_decap_8
XFILLER_582_272 VPWR VGND sg13cmos5l_fill_1
XFILLER_326_228 VPWR VGND sg13cmos5l_decap_8
XFILLER_192_234 VPWR VGND sg13cmos5l_fill_1
XFILLER_192_256 VPWR VGND sg13cmos5l_decap_8
X_3758_ AXI_M_SOC_ARADDR30 Tile_X0Y8_W1END[2] Tile_X0Y8_WW4END[6] Tile_X0Y8_WW4END[14]
+ _4814_/X _0475_/Q _0474_/Q VPWR VGND sg13cmos5l_mux4_1
XFILLER_229_84 VPWR VGND sg13cmos5l_decap_8
XFILLER_542_147 VPWR VGND sg13cmos5l_decap_4
XFILLER_542_158 VPWR VGND sg13cmos5l_decap_8
X_2709_ _4422_/A3 VPWR VGND sg13cmos5l_tielo
XFILLER_3_119 VPWR VGND sg13cmos5l_decap_4
XANTENNA__3554__X Tile_X0Y9_EE4BEG[0] VPWR VGND sg13cmos5l_antennanp
X_3689_ AXI_M_SOC_AWVALID Tile_X0Y2_WW4END[0] Tile_X0Y2_WW4END[8] Tile_X0Y2_W6END[0]
+ _4116_/X _1505_/Q _1504_/Q VPWR VGND sg13cmos5l_mux4_1
XFILLER_109_8 VPWR VGND sg13cmos5l_decap_8
XFILLER_696_162 VPWR VGND sg13cmos5l_decap_8
XFILLER_696_184 VPWR VGND sg13cmos5l_decap_4
XFILLER_550_191 VPWR VGND sg13cmos5l_decap_8
XFILLER_58_37 VPWR VGND sg13cmos5l_decap_4
XFILLER_448_140 VPWR VGND sg13cmos5l_decap_8
XFILLER_448_151 VPWR VGND sg13cmos5l_decap_8
XFILLER_181_49 VPWR VGND sg13cmos5l_decap_8
XFILLER_542_70 VPWR VGND sg13cmos5l_decap_8
XFILLER_114_21 VPWR VGND sg13cmos5l_decap_8
XFILLER_463_121 VPWR VGND sg13cmos5l_decap_8
XFILLER_247_246 VPWR VGND sg13cmos5l_decap_8
XFILLER_373_7 VPWR VGND sg13cmos5l_decap_8
XFILLER_74_14 VPWR VGND sg13cmos5l_decap_8
XFILLER_74_148 VPWR VGND sg13cmos5l_decap_8
XFILLER_74_25 VPWR VGND sg13cmos5l_fill_2
XFILLER_262_216 VPWR VGND sg13cmos5l_fill_1
XFILLER_463_198 VPWR VGND sg13cmos5l_decap_8
XFILLER_215_132 VPWR VGND sg13cmos5l_decap_4
XFILLER_404_221 VPWR VGND sg13cmos5l_decap_8
XFILLER_215_143 VPWR VGND sg13cmos5l_decap_8
XFILLER_540_7 VPWR VGND sg13cmos5l_decap_8
XFILLER_411_63 VPWR VGND sg13cmos5l_decap_8
XFILLER_638_7 VPWR VGND sg13cmos5l_decap_8
XFILLER_270_260 VPWR VGND sg13cmos5l_decap_4
XFILLER_130_42 VPWR VGND sg13cmos5l_decap_8
XFILLER_15_248 VPWR VGND sg13cmos5l_decap_8
XFILLER_270_271 VPWR VGND sg13cmos5l_fill_2
XFILLER_15_259 VPWR VGND sg13cmos5l_fill_2
XANTENNA__0137__Y AXI_M_SOC_AWLEN6 VPWR VGND sg13cmos5l_antennanp
XANTENNA__3729__X AXI_M_SOC_ARADDR1 VPWR VGND sg13cmos5l_antennanp
XFILLER_620_195 VPWR VGND sg13cmos5l_fill_2
XFILLER_376_128 VPWR VGND sg13cmos5l_fill_1
XFILLER_230_157 VPWR VGND sg13cmos5l_decap_8
XFILLER_90_46 VPWR VGND sg13cmos5l_decap_8
XFILLER_565_239 VPWR VGND sg13cmos5l_decap_8
XFILLER_487_56 VPWR VGND sg13cmos5l_decap_8
XFILLER_168_242 VPWR VGND sg13cmos5l_fill_2
XFILLER_183_201 VPWR VGND sg13cmos5l_decap_8
XFILLER_384_161 VPWR VGND sg13cmos5l_decap_8
XFILLER_573_261 VPWR VGND sg13cmos5l_decap_8
XFILLER_317_217 VPWR VGND sg13cmos5l_decap_8
XFILLER_573_272 VPWR VGND sg13cmos5l_fill_1
XFILLER_128_0 VPWR VGND sg13cmos5l_decap_8
XFILLER_679_107 VPWR VGND sg13cmos5l_decap_8
XFILLER_139_84 VPWR VGND sg13cmos5l_decap_8
XFILLER_356_49 VPWR VGND sg13cmos5l_decap_8
XFILLER_717_70 VPWR VGND sg13cmos5l_decap_4
XFILLER_533_158 VPWR VGND sg13cmos5l_decap_8
XFILLER_653_14 VPWR VGND sg13cmos5l_decap_8
XFILLER_325_272 VPWR VGND sg13cmos5l_fill_1
XANTENNA__3464__X Tile_X0Y1_FrameData_O[22] VPWR VGND sg13cmos5l_antennanp
XFILLER_687_162 VPWR VGND sg13cmos5l_decap_4
XFILLER_486_213 VPWR VGND sg13cmos5l_decap_8
XFILLER_372_15 VPWR VGND sg13cmos5l_decap_8
XFILLER_2_130 VPWR VGND sg13cmos5l_fill_2
XFILLER_297_135 VPWR VGND sg13cmos5l_fill_1
XFILLER_497_0 VPWR VGND sg13cmos5l_decap_8
XFILLER_300_128 VPWR VGND sg13cmos5l_decap_8
XFILLER_439_151 VPWR VGND sg13cmos5l_decap_8
XFILLER_628_262 VPWR VGND sg13cmos5l_fill_2
XFILLER_305_42 VPWR VGND sg13cmos5l_decap_8
XFILLER_238_213 VPWR VGND sg13cmos5l_decap_8
XFILLER_643_210 VPWR VGND sg13cmos5l_decap_8
XFILLER_664_0 VPWR VGND sg13cmos5l_decap_8
XANTENNA__2808__X Tile_X0Y3_E2BEGb[6] VPWR VGND sg13cmos5l_antennanp
XFILLER_17_7 VPWR VGND sg13cmos5l_decap_8
XFILLER_305_97 VPWR VGND sg13cmos5l_decap_8
XFILLER_65_126 VPWR VGND sg13cmos5l_decap_8
XFILLER_454_154 VPWR VGND sg13cmos5l_decap_8
XFILLER_643_254 VPWR VGND sg13cmos5l_fill_1
XFILLER_171_71 VPWR VGND sg13cmos5l_decap_8
XFILLER_454_165 VPWR VGND sg13cmos5l_fill_2
X_1040_ _1040_/Q Tile_X0Y0_FrameData[27] VGND VPWR Tile_X0Y9_FrameStrobe[3] latch
XFILLER_0_77 VPWR VGND sg13cmos5l_fill_2
XFILLER_206_165 VPWR VGND sg13cmos5l_fill_2
XFILLER_73_181 VPWR VGND sg13cmos5l_decap_4
XFILLER_73_192 VPWR VGND sg13cmos5l_decap_8
XFILLER_321_85 VPWR VGND sg13cmos5l_decap_8
XFILLER_261_260 VPWR VGND sg13cmos5l_decap_8
XFILLER_261_271 VPWR VGND sg13cmos5l_fill_2
XFILLER_64_91 VPWR VGND sg13cmos5l_decap_8
XANTENNA__0047__Y AXI_M_SOC_AWCACHE2 VPWR VGND sg13cmos5l_antennanp
X_2991_ Tile_X0Y8_FrameData_O[31] Tile_X0Y8_FrameData[31] VPWR VGND sg13cmos5l_buf_1
XANTENNA__3639__X AXI_M_SOC_AWADDR0 VPWR VGND sg13cmos5l_antennanp
XFILLER_221_146 VPWR VGND sg13cmos5l_decap_8
XFILLER_367_128 VPWR VGND sg13cmos5l_decap_8
XFILLER_21_218 VPWR VGND sg13cmos5l_decap_8
XFILLER_21_229 VPWR VGND sg13cmos5l_fill_2
X_4730_ _4730_/X Tile_X0Y8_W2MID[5] AXI_M_SOC_RDATA10 _4789_/X _4788_/X _0587_/Q _0586_/Q
+ VPWR VGND sg13cmos5l_mux4_1
XFILLER_9_42 VPWR VGND sg13cmos5l_decap_8
X_1942_ _1942_/Q Tile_X0Y4_FrameData[15] VGND VPWR Tile_X0Y9_FrameStrobe[0] latch
XFILLER_221_179 VPWR VGND sg13cmos5l_decap_4
XFILLER_694_21 VPWR VGND sg13cmos5l_decap_8
XFILLER_509_155 VPWR VGND sg13cmos5l_decap_8
X_4661_ _4661_/X Tile_X0Y8_W1END[0] Tile_X0Y8_W6END[4] _4812_/X _4772_/X _0671_/Q
+ _0670_/Q VPWR VGND sg13cmos5l_mux4_1
X_1873_ _1873_/Q Tile_X0Y3_FrameData[24] VGND VPWR Tile_X0Y9_FrameStrobe[6] latch
XFILLER_174_223 VPWR VGND sg13cmos5l_decap_8
X_3612_ Tile_X0Y9_S2BEG[6] _4834_/X VPWR VGND sg13cmos5l_buf_1
XFILLER_390_120 VPWR VGND sg13cmos5l_fill_2
XFILLER_713_225 VPWR VGND sg13cmos5l_decap_8
X_0824_ _0824_/Q Tile_X0Y9_FrameData[7] VGND VPWR Tile_X0Y9_FrameStrobe[4] latch
X_4592_ _4592_/X Tile_X0Y5_W1END[0] Tile_X0Y5_W2MID[3] Tile_X0Y5_W2END[3] _4433_/X
+ _2387_/Q _2386_/Q VPWR VGND sg13cmos5l_mux4_1
XFILLER_266_49 VPWR VGND sg13cmos5l_decap_8
XFILLER_627_70 VPWR VGND sg13cmos5l_decap_8
X_3543_ Tile_X0Y9_E6BEG[1] _4881_/X VPWR VGND sg13cmos5l_buf_1
XFILLER_563_14 VPWR VGND sg13cmos5l_decap_8
XFILLER_316_261 VPWR VGND sg13cmos5l_fill_1
X_0755_ _0755_/Q Tile_X0Y9_FrameData[12] VGND VPWR Tile_X0Y9_FrameStrobe[2] latch
XANTENNA__3374__X Tile_X0Y2_EE4BEG[13] VPWR VGND sg13cmos5l_antennanp
XFILLER_127_183 VPWR VGND sg13cmos5l_decap_8
XFILLER_346_60 VPWR VGND sg13cmos5l_fill_1
XFILLER_127_194 VPWR VGND sg13cmos5l_fill_2
XFILLER_331_220 VPWR VGND sg13cmos5l_fill_1
XFILLER_288_113 VPWR VGND sg13cmos5l_fill_2
X_3474_ Tile_X0Y1_EE4BEG[0] _3948_/X VPWR VGND sg13cmos5l_buf_1
X_0686_ _0686_/Q Tile_X0Y9_FrameData[17] VGND VPWR Tile_X0Y9_FrameStrobe[0] latch
XFILLER_43_0 VPWR VGND sg13cmos5l_fill_1
XFILLER_331_242 VPWR VGND sg13cmos5l_decap_8
XFILLER_693_121 VPWR VGND sg13cmos5l_decap_8
XFILLER_142_164 VPWR VGND sg13cmos5l_decap_8
XFILLER_331_264 VPWR VGND sg13cmos5l_decap_8
XFILLER_288_157 VPWR VGND sg13cmos5l_decap_8
X_2425_ _2425_/Q Tile_X0Y5_FrameData[12] VGND VPWR Tile_X0Y9_FrameStrobe[7] latch
XFILLER_693_154 VPWR VGND sg13cmos5l_fill_2
XFILLER_215_42 VPWR VGND sg13cmos5l_decap_8
XFILLER_643_91 VPWR VGND sg13cmos5l_decap_8
X_2356_ _2356_/Q Tile_X0Y5_FrameData[17] VGND VPWR Tile_X0Y9_FrameStrobe[5] latch
XFILLER_362_70 VPWR VGND sg13cmos5l_decap_8
XFILLER_634_221 VPWR VGND sg13cmos5l_decap_4
X_1307_ _1307_/Q Tile_X0Y1_FrameData[30] VGND VPWR Tile_X0Y9_FrameStrobe[4] latch
X_2287_ _2287_/Q Tile_X0Y5_FrameData[22] VGND VPWR Tile_X0Y9_FrameStrobe[3] latch
XFILLER_244_205 VPWR VGND sg13cmos5l_decap_8
XFILLER_56_137 VPWR VGND sg13cmos5l_decap_8
XFILLER_460_102 VPWR VGND sg13cmos5l_decap_8
X_4026_ _4026_/X Tile_X0Y0_W2MID[4] Tile_X0Y0_W2END[4] Tile_X0Y0_W6END[11] _3859_/X
+ _1127_/Q _1126_/Q VPWR VGND sg13cmos5l_mux4_1
X_1238_ _1238_/Q Tile_X0Y1_FrameData[3] VGND VPWR Tile_X0Y9_FrameStrobe[1] latch
XFILLER_512_84 VPWR VGND sg13cmos5l_decap_8
XFILLER_231_63 VPWR VGND sg13cmos5l_fill_2
X_1169_ _1169_/Q Tile_X0Y0_FrameData[26] VGND VPWR Tile_X0Y9_FrameStrobe[7] latch
XFILLER_44_28 VPWR VGND sg13cmos5l_fill_1
XFILLER_44_39 VPWR VGND sg13cmos5l_fill_2
XFILLER_588_77 VPWR VGND sg13cmos5l_decap_8
XFILLER_401_213 VPWR VGND sg13cmos5l_decap_8
XFILLER_588_88 VPWR VGND sg13cmos5l_fill_2
XANTENNA__3549__X Tile_X0Y9_E6BEG[7] VPWR VGND sg13cmos5l_antennanp
XFILLER_212_168 VPWR VGND sg13cmos5l_decap_8
X_4928_ _4928_/X Tile_X0Y9_N1END[0] Tile_X0Y9_N4END[0] _4896_/X _0083_/X _0703_/Q
+ _0702_/Q VPWR VGND sg13cmos5l_mux4_1
XFILLER_100_56 VPWR VGND sg13cmos5l_decap_8
XFILLER_60_27 VPWR VGND sg13cmos5l_decap_4
XFILLER_555_250 VPWR VGND sg13cmos5l_decap_8
XFILLER_366_161 VPWR VGND sg13cmos5l_decap_8
XFILLER_165_223 VPWR VGND sg13cmos5l_fill_1
X_4859_ _4859_/X Tile_X0Y9_W2END[4] AXI_M_SOC_RDATA4 _4907_/X _4906_/X _0825_/Q _0824_/Q
+ VPWR VGND sg13cmos5l_mux4_1
XFILLER_366_172 VPWR VGND sg13cmos5l_fill_1
XFILLER_60_49 VPWR VGND sg13cmos5l_decap_8
XFILLER_121_7 VPWR VGND sg13cmos5l_decap_8
XFILLER_570_231 VPWR VGND sg13cmos5l_decap_8
XFILLER_219_7 VPWR VGND sg13cmos5l_decap_8
XFILLER_125_109 VPWR VGND sg13cmos5l_decap_8
XFILLER_381_153 VPWR VGND sg13cmos5l_decap_8
XFILLER_314_209 VPWR VGND sg13cmos5l_decap_8
XFILLER_109_43 VPWR VGND sg13cmos5l_decap_8
XFILLER_473_14 VPWR VGND sg13cmos5l_decap_8
XANTENNA__3284__X Tile_X0Y0_E6BEG[4] VPWR VGND sg13cmos5l_antennanp
XFILLER_69_14 VPWR VGND sg13cmos5l_decap_8
XFILLER_109_76 VPWR VGND sg13cmos5l_fill_1
XFILLER_669_173 VPWR VGND sg13cmos5l_decap_8
XFILLER_133_153 VPWR VGND sg13cmos5l_decap_8
XFILLER_322_264 VPWR VGND sg13cmos5l_decap_8
XFILLER_490_7 VPWR VGND sg13cmos5l_decap_8
XFILLER_684_143 VPWR VGND sg13cmos5l_decap_8
XFILLER_623_28 VPWR VGND sg13cmos5l_decap_8
XFILLER_406_63 VPWR VGND sg13cmos5l_decap_8
XFILLER_279_168 VPWR VGND sg13cmos5l_decap_4
XFILLER_588_7 VPWR VGND sg13cmos5l_decap_8
XFILLER_294_105 VPWR VGND sg13cmos5l_decap_4
XFILLER_483_205 VPWR VGND sg13cmos5l_fill_1
XFILLER_125_42 VPWR VGND sg13cmos5l_decap_8
XFILLER_483_227 VPWR VGND sg13cmos5l_fill_2
XFILLER_272_70 VPWR VGND sg13cmos5l_decap_8
XFILLER_436_154 VPWR VGND sg13cmos5l_decap_8
XFILLER_436_165 VPWR VGND sg13cmos5l_fill_2
XFILLER_47_148 VPWR VGND sg13cmos5l_decap_8
XFILLER_422_84 VPWR VGND sg13cmos5l_decap_8
XFILLER_640_224 VPWR VGND sg13cmos5l_decap_8
XFILLER_18_84 VPWR VGND sg13cmos5l_fill_2
XFILLER_141_63 VPWR VGND sg13cmos5l_decap_8
XFILLER_451_168 VPWR VGND sg13cmos5l_fill_2
XFILLER_498_77 VPWR VGND sg13cmos5l_decap_8
XFILLER_648_14 VPWR VGND sg13cmos5l_decap_8
XFILLER_203_135 VPWR VGND sg13cmos5l_decap_8
XFILLER_70_151 VPWR VGND sg13cmos5l_decap_8
XANTENNA__3459__X Tile_X0Y1_FrameData_O[17] VPWR VGND sg13cmos5l_antennanp
XFILLER_245_0 VPWR VGND sg13cmos5l_decap_8
XFILLER_367_15 VPWR VGND sg13cmos5l_decap_8
XFILLER_546_261 VPWR VGND sg13cmos5l_fill_1
XFILLER_357_161 VPWR VGND sg13cmos5l_decap_8
XFILLER_546_272 VPWR VGND sg13cmos5l_fill_1
XFILLER_412_0 VPWR VGND sg13cmos5l_decap_4
XFILLER_7_222 VPWR VGND sg13cmos5l_fill_1
XFILLER_156_245 VPWR VGND sg13cmos5l_decap_8
XFILLER_561_220 VPWR VGND sg13cmos5l_decap_4
XFILLER_156_256 VPWR VGND sg13cmos5l_decap_4
XFILLER_664_35 VPWR VGND sg13cmos5l_decap_8
XFILLER_383_14 VPWR VGND sg13cmos5l_decap_8
XANTENNA__3194__X Tile_X0Y0_N2BEGb[2] VPWR VGND sg13cmos5l_antennanp
XFILLER_710_217 VPWR VGND sg13cmos5l_decap_4
XFILLER_109_194 VPWR VGND sg13cmos5l_decap_8
XFILLER_521_128 VPWR VGND sg13cmos5l_fill_1
XFILLER_171_259 VPWR VGND sg13cmos5l_decap_4
X_0540_ _0540_/Q Tile_X0Y8_FrameData[3] VGND VPWR Tile_X0Y9_FrameStrobe[3] latch
XFILLER_675_110 VPWR VGND sg13cmos5l_decap_8
XFILLER_316_52 VPWR VGND sg13cmos5l_decap_8
XFILLER_533_28 VPWR VGND sg13cmos5l_decap_8
X_0471_ _0471_/Q Tile_X0Y8_FrameData[8] VGND VPWR Tile_X0Y9_FrameStrobe[1] latch
XFILLER_459_268 VPWR VGND sg13cmos5l_decap_4
XFILLER_124_197 VPWR VGND sg13cmos5l_decap_8
XFILLER_285_105 VPWR VGND sg13cmos5l_decap_8
X_2210_ _2210_/Q Tile_X0Y5_FrameData[3] VGND VPWR Tile_X0Y9_FrameStrobe[0] latch
XFILLER_675_176 VPWR VGND sg13cmos5l_fill_2
X_3190_ Tile_X0Y0_N4BEG[14] _3190_/A VPWR VGND sg13cmos5l_buf_1
XFILLER_474_238 VPWR VGND sg13cmos5l_decap_8
XFILLER_182_70 VPWR VGND sg13cmos5l_decap_8
XFILLER_690_135 VPWR VGND sg13cmos5l_decap_8
XFILLER_38_104 VPWR VGND sg13cmos5l_decap_4
X_2141_ _2141_/Q Tile_X0Y4_FrameData[8] VGND VPWR Tile_X0Y9_FrameStrobe[6] latch
XFILLER_690_157 VPWR VGND sg13cmos5l_decap_8
XFILLER_38_115 VPWR VGND sg13cmos5l_decap_8
XFILLER_427_154 VPWR VGND sg13cmos5l_decap_8
XFILLER_689_21 VPWR VGND sg13cmos5l_decap_8
X_2072_ _2072_/Q Tile_X0Y4_FrameData[13] VGND VPWR Tile_X0Y9_FrameStrobe[4] latch
XFILLER_631_213 VPWR VGND sg13cmos5l_decap_8
XFILLER_588_106 VPWR VGND sg13cmos5l_fill_1
XFILLER_53_107 VPWR VGND sg13cmos5l_decap_8
XFILLER_332_95 VPWR VGND sg13cmos5l_decap_8
XFILLER_442_146 VPWR VGND sg13cmos5l_decap_8
X_1023_ _1023_/Q Tile_X0Y0_FrameData[12] VGND VPWR Tile_X0Y9_FrameStrobe[2] latch
XFILLER_588_139 VPWR VGND sg13cmos5l_decap_4
XFILLER_442_168 VPWR VGND sg13cmos5l_decap_8
XFILLER_241_208 VPWR VGND sg13cmos5l_decap_8
XFILLER_234_271 VPWR VGND sg13cmos5l_fill_2
XFILLER_61_140 VPWR VGND sg13cmos5l_decap_8
XFILLER_558_14 VPWR VGND sg13cmos5l_decap_8
XANTENNA__3369__X Tile_X0Y2_EE4BEG[8] VPWR VGND sg13cmos5l_antennanp
XFILLER_201_77 VPWR VGND sg13cmos5l_decap_8
XFILLER_201_88 VPWR VGND sg13cmos5l_fill_1
X_2974_ Tile_X0Y8_FrameData_O[14] Tile_X0Y8_FrameData[14] VPWR VGND sg13cmos5l_buf_1
XFILLER_348_150 VPWR VGND sg13cmos5l_decap_4
X_1925_ _1925_/Q Tile_X0Y3_FrameData[4] VGND VPWR Tile_X0Y9_FrameStrobe[7] latch
X_4713_ _4713_/X Tile_X0Y9_W2MID[1] Tile_X0Y9_W2END[1] Tile_X0Y9_W6END[1] _4902_/X
+ _0907_/Q _0906_/Q VPWR VGND sg13cmos5l_mux4_1
XFILLER_348_161 VPWR VGND sg13cmos5l_decap_8
XFILLER_708_28 VPWR VGND sg13cmos5l_decap_8
XFILLER_638_91 VPWR VGND sg13cmos5l_decap_8
X_4644_ _4644_/X Tile_X0Y9_N4END[8] _0056_/X _4695_/X _4699_/X _0271_/Q _0270_/Q VPWR
+ VGND sg13cmos5l_mux4_1
XFILLER_698_213 VPWR VGND sg13cmos5l_decap_8
X_1856_ _1856_/Q Tile_X0Y3_FrameData[9] VGND VPWR Tile_X0Y9_FrameStrobe[5] latch
XFILLER_574_35 VPWR VGND sg13cmos5l_decap_8
XFILLER_357_70 VPWR VGND sg13cmos5l_decap_8
XFILLER_107_109 VPWR VGND sg13cmos5l_decap_8
XFILLER_552_264 VPWR VGND sg13cmos5l_fill_1
X_0807_ _0807_/Q Tile_X0Y9_FrameData[24] VGND VPWR Tile_X0Y9_FrameStrobe[4] latch
XFILLER_293_14 VPWR VGND sg13cmos5l_decap_8
X_4575_ _4575_/X _4551_/X Tile_X0Y9_N4END[15] _4550_/X _0150_/X _2481_/Q _2480_/Q
+ VPWR VGND sg13cmos5l_mux4_1
X_1787_ _1787_/Q Tile_X0Y3_FrameData[14] VGND VPWR Tile_X0Y9_FrameStrobe[3] latch
XFILLER_304_220 VPWR VGND sg13cmos5l_decap_8
X_3526_ Tile_X0Y9_E2BEG[0] _4848_/X VPWR VGND sg13cmos5l_buf_1
X_0738_ _0738_/Q Tile_X0Y9_FrameData[29] VGND VPWR Tile_X0Y9_FrameStrobe[2] latch
XFILLER_505_191 VPWR VGND sg13cmos5l_decap_4
XFILLER_507_84 VPWR VGND sg13cmos5l_decap_8
XFILLER_654_90 VPWR VGND sg13cmos5l_decap_8
XFILLER_304_264 VPWR VGND sg13cmos5l_fill_1
XFILLER_115_175 VPWR VGND sg13cmos5l_decap_8
XFILLER_443_28 VPWR VGND sg13cmos5l_decap_8
XFILLER_130_112 VPWR VGND sg13cmos5l_decap_8
X_3457_ Tile_X0Y1_FrameData_O[15] Tile_X0Y1_FrameData[15] VPWR VGND sg13cmos5l_buf_1
XFILLER_520_161 VPWR VGND sg13cmos5l_decap_8
X_0669_ _0669_/Q Tile_X0Y8_FrameData[2] VGND VPWR Tile_X0Y9_FrameStrobe[7] latch
XFILLER_39_17 VPWR VGND sg13cmos5l_decap_8
XFILLER_276_105 VPWR VGND sg13cmos5l_decap_8
XFILLER_590_56 VPWR VGND sg13cmos5l_decap_8
X_2408_ _2408_/Q Tile_X0Y5_FrameData[29] VGND VPWR Tile_X0Y9_FrameStrobe[7] latch
XFILLER_276_138 VPWR VGND sg13cmos5l_decap_8
X_3388_ Tile_X0Y2_E6BEG[11] _4083_/X VPWR VGND sg13cmos5l_buf_1
XFILLER_465_249 VPWR VGND sg13cmos5l_decap_8
XFILLER_418_143 VPWR VGND sg13cmos5l_decap_8
XFILLER_84_210 VPWR VGND sg13cmos5l_fill_1
X_2339_ _2339_/Q Tile_X0Y5_FrameData[2] VGND VPWR Tile_X0Y9_FrameStrobe[4] latch
XFILLER_681_157 VPWR VGND sg13cmos5l_decap_8
XFILLER_29_137 VPWR VGND sg13cmos5l_decap_8
XFILLER_599_21 VPWR VGND sg13cmos5l_decap_8
XFILLER_284_182 VPWR VGND sg13cmos5l_decap_8
XFILLER_217_249 VPWR VGND sg13cmos5l_decap_8
XFILLER_55_38 VPWR VGND sg13cmos5l_decap_8
XFILLER_55_49 VPWR VGND sg13cmos5l_fill_2
XFILLER_433_146 VPWR VGND sg13cmos5l_decap_8
X_4009_ _4009_/X _3983_/X _0096_/X _3982_/X Tile_X0Y0_S4END[5] _1231_/Q _1230_/Q VPWR
+ VGND sg13cmos5l_mux4_1
XFILLER_44_129 VPWR VGND sg13cmos5l_fill_2
XFILLER_169_7 VPWR VGND sg13cmos5l_decap_8
XFILLER_386_201 VPWR VGND sg13cmos5l_decap_8
XFILLER_468_14 VPWR VGND sg13cmos5l_decap_8
XFILLER_197_123 VPWR VGND sg13cmos5l_decap_8
XANTENNA__3279__X Tile_X0Y0_EE4BEG[15] VPWR VGND sg13cmos5l_antennanp
XFILLER_111_77 VPWR VGND sg13cmos5l_decap_8
XFILLER_386_245 VPWR VGND sg13cmos5l_decap_8
XFILLER_336_7 VPWR VGND sg13cmos5l_decap_8
XFILLER_197_167 VPWR VGND sg13cmos5l_decap_8
XFILLER_528_250 VPWR VGND sg13cmos5l_decap_8
XFILLER_187_48 VPWR VGND sg13cmos5l_fill_2
XFILLER_618_28 VPWR VGND sg13cmos5l_decap_8
XFILLER_528_261 VPWR VGND sg13cmos5l_fill_1
XFILLER_339_161 VPWR VGND sg13cmos5l_decap_8
XFILLER_528_272 VPWR VGND sg13cmos5l_fill_1
XFILLER_548_91 VPWR VGND sg13cmos5l_decap_8
XANTENNA__2911__X Tile_X0Y6_UserCLKo VPWR VGND sg13cmos5l_antennanp
XFILLER_503_7 VPWR VGND sg13cmos5l_decap_8
XFILLER_138_256 VPWR VGND sg13cmos5l_decap_4
XFILLER_689_213 VPWR VGND sg13cmos5l_fill_1
XFILLER_484_35 VPWR VGND sg13cmos5l_decap_8
XFILLER_689_235 VPWR VGND sg13cmos5l_decap_8
XFILLER_267_70 VPWR VGND sg13cmos5l_decap_8
XFILLER_153_204 VPWR VGND sg13cmos5l_fill_2
XFILLER_689_246 VPWR VGND sg13cmos5l_fill_2
XFILLER_543_264 VPWR VGND sg13cmos5l_fill_1
XFILLER_354_175 VPWR VGND sg13cmos5l_decap_8
XFILLER_153_237 VPWR VGND sg13cmos5l_fill_1
XFILLER_153_259 VPWR VGND sg13cmos5l_fill_2
XFILLER_20_63 VPWR VGND sg13cmos5l_decap_8
XFILLER_634_49 VPWR VGND sg13cmos5l_decap_8
XFILLER_417_84 VPWR VGND sg13cmos5l_decap_8
XFILLER_136_63 VPWR VGND sg13cmos5l_decap_8
XFILLER_353_28 VPWR VGND sg13cmos5l_decap_8
XFILLER_267_105 VPWR VGND sg13cmos5l_decap_8
XANTENNA__3742__X AXI_M_SOC_ARADDR14 VPWR VGND sg13cmos5l_antennanp
XFILLER_700_272 VPWR VGND sg13cmos5l_fill_1
XFILLER_283_91 VPWR VGND sg13cmos5l_decap_8
XFILLER_267_116 VPWR VGND sg13cmos5l_fill_2
XFILLER_96_45 VPWR VGND sg13cmos5l_decap_8
XFILLER_657_176 VPWR VGND sg13cmos5l_decap_8
XFILLER_456_227 VPWR VGND sg13cmos5l_fill_1
XFILLER_672_124 VPWR VGND sg13cmos5l_decap_8
XFILLER_456_249 VPWR VGND sg13cmos5l_decap_8
XFILLER_195_0 VPWR VGND sg13cmos5l_decap_8
XFILLER_471_208 VPWR VGND sg13cmos5l_decap_8
XFILLER_409_154 VPWR VGND sg13cmos5l_fill_1
XFILLER_282_119 VPWR VGND sg13cmos5l_decap_8
XFILLER_464_260 VPWR VGND sg13cmos5l_fill_2
XFILLER_208_238 VPWR VGND sg13cmos5l_fill_2
XFILLER_613_235 VPWR VGND sg13cmos5l_fill_2
XFILLER_362_0 VPWR VGND sg13cmos5l_decap_8
XFILLER_302_21 VPWR VGND sg13cmos5l_decap_8
XFILLER_223_208 VPWR VGND sg13cmos5l_decap_8
XFILLER_424_168 VPWR VGND sg13cmos5l_decap_8
XFILLER_216_271 VPWR VGND sg13cmos5l_fill_2
XFILLER_659_35 VPWR VGND sg13cmos5l_decap_8
XFILLER_90_268 VPWR VGND sg13cmos5l_decap_4
XFILLER_578_161 VPWR VGND sg13cmos5l_decap_8
XFILLER_659_68 VPWR VGND sg13cmos5l_decap_8
XANTENNA__3189__X Tile_X0Y0_N4BEG[13] VPWR VGND sg13cmos5l_antennanp
XFILLER_578_172 VPWR VGND sg13cmos5l_decap_8
XFILLER_45_93 VPWR VGND sg13cmos5l_decap_4
XFILLER_231_241 VPWR VGND sg13cmos5l_decap_8
XFILLER_627_0 VPWR VGND sg13cmos5l_decap_8
XFILLER_378_36 VPWR VGND sg13cmos5l_decap_8
XFILLER_43_184 VPWR VGND sg13cmos5l_decap_8
XFILLER_593_131 VPWR VGND sg13cmos5l_decap_8
XFILLER_377_267 VPWR VGND sg13cmos5l_decap_4
XFILLER_526_209 VPWR VGND sg13cmos5l_decap_8
XFILLER_337_109 VPWR VGND sg13cmos5l_decap_8
XFILLER_188_189 VPWR VGND sg13cmos5l_decap_8
XFILLER_593_164 VPWR VGND sg13cmos5l_decap_8
XFILLER_519_250 VPWR VGND sg13cmos5l_fill_2
XFILLER_84_7 VPWR VGND sg13cmos5l_decap_8
XFILLER_528_28 VPWR VGND sg13cmos5l_decap_8
XFILLER_458_80 VPWR VGND sg13cmos5l_decap_4
XFILLER_61_70 VPWR VGND sg13cmos5l_decap_8
XANTENNA__2821__X Tile_X0Y3_E1BEG[3] VPWR VGND sg13cmos5l_antennanp
X_1710_ _1710_/Q Tile_X0Y3_FrameData[27] VGND VPWR Tile_X0Y9_FrameStrobe[1] latch
XFILLER_345_120 VPWR VGND sg13cmos5l_decap_8
X_2690_ _2690_/Q Tile_X0Y6_FrameData[5] VGND VPWR Tile_X0Y9_FrameStrobe[7] latch
XFILLER_345_153 VPWR VGND sg13cmos5l_decap_8
XFILLER_177_81 VPWR VGND sg13cmos5l_decap_8
XFILLER_6_21 VPWR VGND sg13cmos5l_decap_8
XFILLER_394_57 VPWR VGND sg13cmos5l_fill_2
X_1641_ _1641_/Q Tile_X0Y2_FrameData[8] VGND VPWR Tile_X0Y9_FrameStrobe[6] latch
XANTENNA_3 AXI_M_SOC_RDATA26 VPWR VGND sg13cmos5l_antennanp
XFILLER_360_112 VPWR VGND sg13cmos5l_decap_8
XFILLER_360_123 VPWR VGND sg13cmos5l_fill_1
XFILLER_695_216 VPWR VGND sg13cmos5l_decap_8
X_4360_ _4360_/X Tile_X0Y3_W1END[0] Tile_X0Y3_W2MID[3] Tile_X0Y3_W2END[3] _4210_/X
+ _1873_/Q _1872_/Q VPWR VGND sg13cmos5l_mux4_1
X_1572_ _1572_/Q Tile_X0Y2_FrameData[13] VGND VPWR Tile_X0Y9_FrameStrobe[4] latch
XFILLER_544_49 VPWR VGND sg13cmos5l_decap_8
XFILLER_327_73 VPWR VGND sg13cmos5l_decap_8
XFILLER_6_98 VPWR VGND sg13cmos5l_decap_8
XFILLER_327_84 VPWR VGND sg13cmos5l_fill_2
X_3311_ Tile_X0Y0_E1BEG[3] _3803_/X VPWR VGND sg13cmos5l_buf_1
XFILLER_691_77 VPWR VGND sg13cmos5l_decap_8
X_0523_ _0523_/Q Tile_X0Y8_FrameData[20] VGND VPWR Tile_X0Y9_FrameStrobe[3] latch
XFILLER_263_28 VPWR VGND sg13cmos5l_decap_8
X_4291_ _4291_/X _0040_/X _0109_/X _4344_/X _4348_/X _2031_/Q _2030_/Q VPWR VGND sg13cmos5l_mux4_1
XFILLER_691_88 VPWR VGND sg13cmos5l_fill_2
XFILLER_502_161 VPWR VGND sg13cmos5l_decap_8
XFILLER_298_263 VPWR VGND sg13cmos5l_fill_2
XANTENNA__3652__X AXI_M_SOC_AWADDR13 VPWR VGND sg13cmos5l_antennanp
XFILLER_648_154 VPWR VGND sg13cmos5l_decap_8
X_3242_ Tile_X0Y0_FrameData_O[10] Tile_X0Y0_FrameData[10] VPWR VGND sg13cmos5l_buf_1
XFILLER_301_245 VPWR VGND sg13cmos5l_decap_8
X_0454_ _0454_/Q Tile_X0Y8_FrameData[25] VGND VPWR Tile_X0Y9_FrameStrobe[1] latch
XFILLER_663_135 VPWR VGND sg13cmos5l_fill_2
XFILLER_66_210 VPWR VGND sg13cmos5l_decap_8
X_3173_ Tile_X0Y4_E6BEG[10] _4298_/X VPWR VGND sg13cmos5l_buf_1
X_0385_ _0385_/Q Tile_X0Y7_FrameData[30] VGND VPWR Tile_X0Y9_FrameStrobe[7] latch
XFILLER_66_221 VPWR VGND sg13cmos5l_fill_2
XFILLER_66_232 VPWR VGND sg13cmos5l_decap_8
XFILLER_663_179 VPWR VGND sg13cmos5l_fill_2
XFILLER_455_271 VPWR VGND sg13cmos5l_fill_2
X_2124_ _2124_/Q Tile_X0Y4_FrameData[25] VGND VPWR Tile_X0Y9_FrameStrobe[6] latch
XFILLER_640_70 VPWR VGND sg13cmos5l_decap_8
XFILLER_604_224 VPWR VGND sg13cmos5l_fill_1
XFILLER_26_107 VPWR VGND sg13cmos5l_decap_8
XFILLER_212_21 VPWR VGND sg13cmos5l_decap_8
X_2055_ _2055_/Q Tile_X0Y4_FrameData[30] VGND VPWR Tile_X0Y9_FrameStrobe[4] latch
XFILLER_569_35 VPWR VGND sg13cmos5l_decap_8
XFILLER_430_105 VPWR VGND sg13cmos5l_decap_8
X_1006_ _1006_/Q Tile_X0Y0_FrameData[29] VGND VPWR Tile_X0Y9_FrameStrobe[2] latch
XFILLER_281_196 VPWR VGND sg13cmos5l_decap_8
XFILLER_212_98 VPWR VGND sg13cmos5l_decap_8
XFILLER_569_161 VPWR VGND sg13cmos5l_decap_8
XANTENNA__3099__X Tile_X0Y7_E2BEGb[5] VPWR VGND sg13cmos5l_antennanp
XFILLER_423_190 VPWR VGND sg13cmos5l_decap_8
XFILLER_288_36 VPWR VGND sg13cmos5l_decap_8
XFILLER_584_120 VPWR VGND sg13cmos5l_fill_2
XFILLER_517_209 VPWR VGND sg13cmos5l_fill_1
X_2957_ Tile_X0Y8_EE4BEG[13] _4757_/X VPWR VGND sg13cmos5l_buf_1
XFILLER_438_28 VPWR VGND sg13cmos5l_decap_8
XFILLER_584_186 VPWR VGND sg13cmos5l_decap_8
XFILLER_585_56 VPWR VGND sg13cmos5l_decap_8
XFILLER_41_29 VPWR VGND sg13cmos5l_decap_4
X_1908_ _1908_/Q Tile_X0Y3_FrameData[21] VGND VPWR Tile_X0Y9_FrameStrobe[7] latch
XFILLER_383_259 VPWR VGND sg13cmos5l_fill_2
XFILLER_336_131 VPWR VGND sg13cmos5l_decap_8
XFILLER_525_231 VPWR VGND sg13cmos5l_decap_8
X_2888_ Tile_X0Y6_FrameData_O[9] Tile_X0Y6_FrameData[9] VPWR VGND sg13cmos5l_buf_1
XFILLER_135_204 VPWR VGND sg13cmos5l_decap_8
X_1839_ _1839_/Q Tile_X0Y3_FrameData[26] VGND VPWR Tile_X0Y9_FrameStrobe[5] latch
X_4627_ _4627_/X Tile_X0Y7_W2END[0] AXI_M_SOC_RDATA16 _4669_/X _4668_/X _0305_/Q _0304_/Q
+ VPWR VGND sg13cmos5l_mux4_1
XFILLER_540_212 VPWR VGND sg13cmos5l_decap_8
XFILLER_497_105 VPWR VGND sg13cmos5l_decap_8
XFILLER_351_112 VPWR VGND sg13cmos5l_decap_8
XFILLER_686_205 VPWR VGND sg13cmos5l_decap_8
X_4558_ _4558_/X _4477_/X _4593_/X _4592_/X _4476_/X _2455_/Q _2454_/Q VPWR VGND sg13cmos5l_mux4_1
XFILLER_454_49 VPWR VGND sg13cmos5l_decap_8
XFILLER_289_241 VPWR VGND sg13cmos5l_decap_8
XFILLER_173_28 VPWR VGND sg13cmos5l_decap_8
XFILLER_351_189 VPWR VGND sg13cmos5l_decap_8
XFILLER_289_252 VPWR VGND sg13cmos5l_fill_2
XFILLER_103_112 VPWR VGND sg13cmos5l_decap_8
X_3509_ Tile_X0Y1_E2BEGb[7] _3947_/X VPWR VGND sg13cmos5l_buf_1
XFILLER_1_239 VPWR VGND sg13cmos5l_fill_1
X_4489_ _4489_/X _4574_/X _4578_/X _4582_/X _4554_/X _2629_/Q _2628_/Q VPWR VGND sg13cmos5l_mux4_1
XFILLER_639_154 VPWR VGND sg13cmos5l_decap_8
XFILLER_438_205 VPWR VGND sg13cmos5l_fill_1
XANTENNA__3562__X Tile_X0Y9_EE4BEG[8] VPWR VGND sg13cmos5l_antennanp
XFILLER_106_22 VPWR VGND sg13cmos5l_decap_8
XFILLER_438_227 VPWR VGND sg13cmos5l_fill_1
XFILLER_453_219 VPWR VGND sg13cmos5l_fill_1
XFILLER_286_7 VPWR VGND sg13cmos5l_decap_8
XFILLER_406_113 VPWR VGND sg13cmos5l_decap_8
XFILLER_257_193 VPWR VGND sg13cmos5l_decap_8
XFILLER_403_64 VPWR VGND sg13cmos5l_decap_8
XFILLER_122_21 VPWR VGND sg13cmos5l_decap_8
XFILLER_550_70 VPWR VGND sg13cmos5l_decap_8
XFILLER_72_213 VPWR VGND sg13cmos5l_decap_8
XFILLER_662_190 VPWR VGND sg13cmos5l_decap_8
XFILLER_406_146 VPWR VGND sg13cmos5l_decap_8
XFILLER_17_129 VPWR VGND sg13cmos5l_decap_4
XFILLER_406_157 VPWR VGND sg13cmos5l_fill_1
XFILLER_403_86 VPWR VGND sg13cmos5l_decap_8
XANTENNA__2906__X Tile_X0Y6_FrameData_O[27] VPWR VGND sg13cmos5l_antennanp
XFILLER_453_7 VPWR VGND sg13cmos5l_decap_8
XFILLER_82_14 VPWR VGND sg13cmos5l_decap_8
XFILLER_610_205 VPWR VGND sg13cmos5l_fill_2
XFILLER_479_35 VPWR VGND sg13cmos5l_decap_8
XFILLER_421_105 VPWR VGND sg13cmos5l_decap_8
XFILLER_406_179 VPWR VGND sg13cmos5l_decap_8
XFILLER_272_174 VPWR VGND sg13cmos5l_decap_8
XFILLER_72_257 VPWR VGND sg13cmos5l_fill_1
XFILLER_72_268 VPWR VGND sg13cmos5l_decap_4
XFILLER_198_14 VPWR VGND sg13cmos5l_decap_8
XFILLER_700_84 VPWR VGND sg13cmos5l_decap_8
XFILLER_414_190 VPWR VGND sg13cmos5l_decap_4
XFILLER_620_7 VPWR VGND sg13cmos5l_decap_8
XFILLER_25_173 VPWR VGND sg13cmos5l_decap_8
XFILLER_198_58 VPWR VGND sg13cmos5l_fill_2
XFILLER_15_63 VPWR VGND sg13cmos5l_fill_1
XFILLER_629_49 VPWR VGND sg13cmos5l_decap_8
XFILLER_15_74 VPWR VGND sg13cmos5l_decap_8
XFILLER_590_101 VPWR VGND sg13cmos5l_decap_8
XFILLER_575_175 VPWR VGND sg13cmos5l_decap_8
XFILLER_348_28 VPWR VGND sg13cmos5l_decap_8
XFILLER_590_112 VPWR VGND sg13cmos5l_fill_1
XANTENNA__3737__X AXI_M_SOC_ARADDR9 VPWR VGND sg13cmos5l_antennanp
XFILLER_185_148 VPWR VGND sg13cmos5l_decap_8
XFILLER_185_159 VPWR VGND sg13cmos5l_fill_2
XFILLER_495_56 VPWR VGND sg13cmos5l_decap_8
XFILLER_278_91 VPWR VGND sg13cmos5l_decap_8
XFILLER_40_198 VPWR VGND sg13cmos5l_decap_8
XFILLER_327_175 VPWR VGND sg13cmos5l_decap_8
XFILLER_110_0 VPWR VGND sg13cmos5l_decap_8
XFILLER_488_105 VPWR VGND sg13cmos5l_decap_8
XFILLER_208_0 VPWR VGND sg13cmos5l_decap_8
XFILLER_141_207 VPWR VGND sg13cmos5l_decap_8
XFILLER_147_84 VPWR VGND sg13cmos5l_fill_2
XFILLER_364_49 VPWR VGND sg13cmos5l_decap_8
XFILLER_141_218 VPWR VGND sg13cmos5l_fill_2
XFILLER_661_14 VPWR VGND sg13cmos5l_decap_8
XANTENNA__3472__X Tile_X0Y1_FrameData_O[30] VPWR VGND sg13cmos5l_antennanp
XFILLER_692_219 VPWR VGND sg13cmos5l_decap_8
XFILLER_685_271 VPWR VGND sg13cmos5l_fill_2
XFILLER_295_222 VPWR VGND sg13cmos5l_decap_4
XFILLER_496_182 VPWR VGND sg13cmos5l_decap_8
XFILLER_429_238 VPWR VGND sg13cmos5l_decap_8
XFILLER_163_72 VPWR VGND sg13cmos5l_fill_1
XFILLER_577_0 VPWR VGND sg13cmos5l_decap_8
XFILLER_645_168 VPWR VGND sg13cmos5l_decap_8
XFILLER_248_160 VPWR VGND sg13cmos5l_fill_1
XFILLER_660_105 VPWR VGND sg13cmos5l_decap_8
XFILLER_248_182 VPWR VGND sg13cmos5l_decap_8
XFILLER_660_127 VPWR VGND sg13cmos5l_decap_8
X_0170_ _0170_/Q Tile_X0Y7_FrameData[21] VGND VPWR Tile_X0Y9_FrameStrobe[0] latch
XFILLER_63_202 VPWR VGND sg13cmos5l_decap_8
XFILLER_460_81 VPWR VGND sg13cmos5l_decap_8
XFILLER_598_234 VPWR VGND sg13cmos5l_decap_8
XANTENNA__2816__X Tile_X0Y3_E2BEG[6] VPWR VGND sg13cmos5l_antennanp
XFILLER_56_81 VPWR VGND sg13cmos5l_decap_8
XFILLER_263_174 VPWR VGND sg13cmos5l_decap_8
XFILLER_412_116 VPWR VGND sg13cmos5l_decap_8
XFILLER_389_35 VPWR VGND sg13cmos5l_decap_8
XFILLER_601_216 VPWR VGND sg13cmos5l_decap_8
XFILLER_601_238 VPWR VGND sg13cmos5l_decap_8
XFILLER_16_151 VPWR VGND sg13cmos5l_decap_8
XFILLER_204_241 VPWR VGND sg13cmos5l_decap_8
X_3860_ _3860_/X _3849_/X Tile_X0Y0_W6END[1] Tile_X0Y0_S1END[1] _3860_/A3 _0945_/Q
+ _0944_/Q VPWR VGND sg13cmos5l_mux4_1
XFILLER_686_44 VPWR VGND sg13cmos5l_fill_1
XFILLER_539_49 VPWR VGND sg13cmos5l_decap_8
XFILLER_72_80 VPWR VGND sg13cmos5l_decap_8
XFILLER_686_66 VPWR VGND sg13cmos5l_decap_8
X_2811_ Tile_X0Y3_E2BEG[1] _4149_/X VPWR VGND sg13cmos5l_buf_1
XFILLER_566_175 VPWR VGND sg13cmos5l_decap_8
XFILLER_258_28 VPWR VGND sg13cmos5l_decap_8
X_3791_ _3791_/X Tile_X0Y0_W2MID[0] Tile_X0Y0_W2END[0] Tile_X0Y0_W6END[0] _3852_/X
+ _1155_/Q _1154_/Q VPWR VGND sg13cmos5l_mux4_1
XFILLER_420_193 VPWR VGND sg13cmos5l_fill_1
XFILLER_581_112 VPWR VGND sg13cmos5l_decap_8
XANTENNA__3647__X AXI_M_SOC_AWADDR8 VPWR VGND sg13cmos5l_antennanp
XFILLER_188_91 VPWR VGND sg13cmos5l_decap_8
X_2742_ Tile_X0Y3_FrameData_O[0] Tile_X0Y3_FrameData[0] VPWR VGND sg13cmos5l_buf_1
XFILLER_318_153 VPWR VGND sg13cmos5l_decap_8
XFILLER_191_118 VPWR VGND sg13cmos5l_decap_8
XFILLER_380_218 VPWR VGND sg13cmos5l_decap_8
XFILLER_555_37 VPWR VGND sg13cmos5l_decap_8
XFILLER_380_229 VPWR VGND sg13cmos5l_fill_1
XFILLER_522_201 VPWR VGND sg13cmos5l_decap_4
XFILLER_338_72 VPWR VGND sg13cmos5l_decap_8
XFILLER_333_101 VPWR VGND sg13cmos5l_decap_8
XFILLER_318_175 VPWR VGND sg13cmos5l_decap_8
X_2673_ _2673_/Q Tile_X0Y6_FrameData[22] VGND VPWR Tile_X0Y9_FrameStrobe[7] latch
XANTENNA__0071__X AXI_M_SOC_WSTRB0 VPWR VGND sg13cmos5l_antennanp
X_4412_ _4412_/X AXI_M_SOC_RVALID _4454_/X _4458_/X _4433_/X _2279_/Q _2278_/Q VPWR
+ VGND sg13cmos5l_mux4_1
XFILLER_479_127 VPWR VGND sg13cmos5l_decap_8
X_1624_ _1624_/Q Tile_X0Y2_FrameData[25] VGND VPWR Tile_X0Y9_FrameStrobe[6] latch
XFILLER_274_49 VPWR VGND sg13cmos5l_decap_8
XFILLER_207_21 VPWR VGND sg13cmos5l_decap_8
XFILLER_635_70 VPWR VGND sg13cmos5l_decap_8
XFILLER_98_110 VPWR VGND sg13cmos5l_decap_8
X_4343_ _4343_/X _4311_/X _0040_/X _4310_/X _0109_/X _1967_/Q _1966_/Q VPWR VGND sg13cmos5l_mux4_1
XFILLER_98_121 VPWR VGND sg13cmos5l_fill_2
X_1555_ _1555_/Q Tile_X0Y2_FrameData[30] VGND VPWR Tile_X0Y9_FrameStrobe[4] latch
XFILLER_571_14 VPWR VGND sg13cmos5l_decap_8
XANTENNA__3382__X Tile_X0Y2_E6BEG[5] VPWR VGND sg13cmos5l_antennanp
XFILLER_494_119 VPWR VGND sg13cmos5l_decap_8
XFILLER_487_160 VPWR VGND sg13cmos5l_decap_8
XFILLER_676_271 VPWR VGND sg13cmos5l_fill_2
XFILLER_98_154 VPWR VGND sg13cmos5l_decap_8
X_0506_ _0506_/Q Tile_X0Y8_FrameData[5] VGND VPWR Tile_X0Y9_FrameStrobe[2] latch
XFILLER_140_251 VPWR VGND sg13cmos5l_decap_8
X_4274_ _4274_/X Tile_X0Y4_WW4END[13] AXI_M_SOC_BRESP0 _4349_/X _4316_/X _2065_/Q
+ _2064_/Q VPWR VGND sg13cmos5l_mux4_1
X_1486_ _1486_/Q Tile_X0Y2_FrameData[3] VGND VPWR Tile_X0Y9_FrameStrobe[1] latch
XFILLER_290_15 VPWR VGND sg13cmos5l_decap_8
XFILLER_691_230 VPWR VGND sg13cmos5l_fill_1
X_3225_ Tile_X0Y0_FrameStrobe_O[13] Tile_X0Y9_FrameStrobe[13] VPWR VGND sg13cmos5l_buf_1
XFILLER_246_108 VPWR VGND sg13cmos5l_fill_1
X_0437_ _0437_/Q Tile_X0Y8_FrameData[10] VGND VPWR Tile_X0Y9_FrameStrobe[0] latch
XFILLER_691_252 VPWR VGND sg13cmos5l_decap_8
XFILLER_504_63 VPWR VGND sg13cmos5l_decap_8
XFILLER_100_148 VPWR VGND sg13cmos5l_decap_8
XFILLER_651_105 VPWR VGND sg13cmos5l_decap_8
XFILLER_651_91 VPWR VGND sg13cmos5l_decap_8
XFILLER_428_271 VPWR VGND sg13cmos5l_fill_2
X_3156_ Tile_X0Y7_FrameData_O[26] Tile_X0Y7_FrameData[26] VPWR VGND sg13cmos5l_buf_1
X_0368_ _0368_/Q Tile_X0Y7_FrameData[15] VGND VPWR Tile_X0Y9_FrameStrobe[6] latch
XFILLER_223_97 VPWR VGND sg13cmos5l_decap_8
X_2107_ _2107_/Q Tile_X0Y4_FrameData[10] VGND VPWR Tile_X0Y9_FrameStrobe[5] latch
XFILLER_54_224 VPWR VGND sg13cmos5l_decap_8
XFILLER_370_92 VPWR VGND sg13cmos5l_decap_8
XFILLER_254_152 VPWR VGND sg13cmos5l_fill_1
X_3087_ Tile_X0Y7_E2BEG[1] _4613_/X VPWR VGND sg13cmos5l_buf_1
XFILLER_254_174 VPWR VGND sg13cmos5l_decap_8
X_0299_ _0299_/Q Tile_X0Y7_FrameData[20] VGND VPWR Tile_X0Y9_FrameStrobe[4] latch
XFILLER_299_35 VPWR VGND sg13cmos5l_decap_8
XFILLER_520_51 VPWR VGND sg13cmos5l_fill_1
X_2038_ _2038_/Q Tile_X0Y4_FrameData[15] VGND VPWR Tile_X0Y9_FrameStrobe[3] latch
XFILLER_22_121 VPWR VGND sg13cmos5l_decap_8
XFILLER_449_49 VPWR VGND sg13cmos5l_decap_8
XFILLER_210_211 VPWR VGND sg13cmos5l_decap_8
XFILLER_600_260 VPWR VGND sg13cmos5l_fill_1
XFILLER_600_271 VPWR VGND sg13cmos5l_fill_2
XFILLER_557_164 VPWR VGND sg13cmos5l_fill_1
XFILLER_167_126 VPWR VGND sg13cmos5l_decap_8
XFILLER_168_28 VPWR VGND sg13cmos5l_fill_1
XFILLER_596_77 VPWR VGND sg13cmos5l_decap_8
XFILLER_572_112 VPWR VGND sg13cmos5l_decap_8
XFILLER_557_186 VPWR VGND sg13cmos5l_decap_8
XANTENNA__3557__X Tile_X0Y9_EE4BEG[3] VPWR VGND sg13cmos5l_antennanp
XFILLER_210_255 VPWR VGND sg13cmos5l_fill_2
X_3989_ _3989_/X _3888_/X _4021_/X _4020_/X Tile_X0Y0_S2MID[0] _1201_/Q _1200_/Q VPWR
+ VGND sg13cmos5l_mux4_1
XFILLER_529_82 VPWR VGND sg13cmos5l_decap_8
XFILLER_356_259 VPWR VGND sg13cmos5l_decap_4
XFILLER_572_189 VPWR VGND sg13cmos5l_decap_8
XFILLER_324_101 VPWR VGND sg13cmos5l_decap_8
XFILLER_714_161 VPWR VGND sg13cmos5l_decap_8
XFILLER_108_237 VPWR VGND sg13cmos5l_fill_2
XFILLER_201_7 VPWR VGND sg13cmos5l_decap_8
XFILLER_117_21 VPWR VGND sg13cmos5l_decap_8
XFILLER_545_70 VPWR VGND sg13cmos5l_decap_8
XFILLER_190_173 VPWR VGND sg13cmos5l_decap_8
XFILLER_324_178 VPWR VGND sg13cmos5l_decap_8
XFILLER_481_14 VPWR VGND sg13cmos5l_decap_8
XANTENNA__3292__X Tile_X0Y0_E2BEGb[0] VPWR VGND sg13cmos5l_antennanp
XFILLER_667_260 VPWR VGND sg13cmos5l_fill_2
XFILLER_117_76 VPWR VGND sg13cmos5l_fill_1
XFILLER_89_154 VPWR VGND sg13cmos5l_decap_8
XFILLER_77_36 VPWR VGND sg13cmos5l_decap_4
XFILLER_117_98 VPWR VGND sg13cmos5l_decap_8
XFILLER_627_146 VPWR VGND sg13cmos5l_fill_2
XFILLER_631_28 VPWR VGND sg13cmos5l_decap_8
XFILLER_570_7 VPWR VGND sg13cmos5l_decap_8
XFILLER_414_63 VPWR VGND sg13cmos5l_decap_8
XFILLER_668_7 VPWR VGND sg13cmos5l_decap_8
XFILLER_642_105 VPWR VGND sg13cmos5l_decap_8
XFILLER_561_91 VPWR VGND sg13cmos5l_decap_8
XFILLER_133_42 VPWR VGND sg13cmos5l_decap_8
XFILLER_280_70 VPWR VGND sg13cmos5l_decap_8
XFILLER_434_241 VPWR VGND sg13cmos5l_decap_8
XFILLER_93_35 VPWR VGND sg13cmos5l_fill_2
XANTENNA_201 Tile_X0Y9_N2MID[5] VPWR VGND sg13cmos5l_antennanp
XANTENNA_212 Tile_X0Y9_N4END[14] VPWR VGND sg13cmos5l_antennanp
XANTENNA_223 Tile_X0Y9_N4END[14] VPWR VGND sg13cmos5l_antennanp
XANTENNA_234 Tile_X0Y0_FrameData[6] VPWR VGND sg13cmos5l_antennanp
XFILLER_650_182 VPWR VGND sg13cmos5l_decap_8
XFILLER_430_84 VPWR VGND sg13cmos5l_decap_8
XFILLER_60_238 VPWR VGND sg13cmos5l_decap_8
XFILLER_26_84 VPWR VGND sg13cmos5l_decap_8
XFILLER_260_166 VPWR VGND sg13cmos5l_decap_8
XFILLER_158_0 VPWR VGND sg13cmos5l_decap_4
XFILLER_201_200 VPWR VGND sg13cmos5l_decap_8
XFILLER_359_49 VPWR VGND sg13cmos5l_decap_8
XFILLER_347_215 VPWR VGND sg13cmos5l_decap_8
XFILLER_13_165 VPWR VGND sg13cmos5l_fill_2
XFILLER_9_114 VPWR VGND sg13cmos5l_decap_8
XFILLER_656_14 VPWR VGND sg13cmos5l_decap_8
XFILLER_563_112 VPWR VGND sg13cmos5l_decap_8
XANTENNA__3467__X Tile_X0Y1_FrameData_O[25] VPWR VGND sg13cmos5l_antennanp
XFILLER_347_248 VPWR VGND sg13cmos5l_decap_4
XFILLER_325_0 VPWR VGND sg13cmos5l_decap_8
XFILLER_173_107 VPWR VGND sg13cmos5l_decap_8
XFILLER_158_50 VPWR VGND sg13cmos5l_decap_8
XFILLER_362_207 VPWR VGND sg13cmos5l_decap_4
XFILLER_166_192 VPWR VGND sg13cmos5l_decap_8
XFILLER_504_223 VPWR VGND sg13cmos5l_decap_8
XFILLER_315_134 VPWR VGND sg13cmos5l_decap_8
XFILLER_308_42 VPWR VGND sg13cmos5l_fill_2
XFILLER_672_35 VPWR VGND sg13cmos5l_decap_8
XFILLER_694_0 VPWR VGND sg13cmos5l_decap_8
XFILLER_672_46 VPWR VGND sg13cmos5l_fill_2
XFILLER_330_115 VPWR VGND sg13cmos5l_decap_4
XFILLER_455_92 VPWR VGND sg13cmos5l_decap_4
XFILLER_391_14 VPWR VGND sg13cmos5l_decap_8
XFILLER_665_208 VPWR VGND sg13cmos5l_decap_8
XFILLER_476_119 VPWR VGND sg13cmos5l_decap_8
XFILLER_330_148 VPWR VGND sg13cmos5l_decap_8
X_1340_ _1340_/Q Tile_X0Y1_FrameData[29] VGND VPWR Tile_X0Y9_FrameStrobe[5] latch
XFILLER_391_58 VPWR VGND sg13cmos5l_fill_2
XFILLER_673_230 VPWR VGND sg13cmos5l_decap_8
XFILLER_541_28 VPWR VGND sg13cmos5l_decap_8
XFILLER_484_152 VPWR VGND sg13cmos5l_fill_2
XFILLER_283_203 VPWR VGND sg13cmos5l_decap_8
XFILLER_228_119 VPWR VGND sg13cmos5l_decap_8
X_1271_ _1271_/Q Tile_X0Y1_FrameData[2] VGND VPWR Tile_X0Y9_FrameStrobe[2] latch
XFILLER_3_77 VPWR VGND sg13cmos5l_decap_8
XFILLER_484_174 VPWR VGND sg13cmos5l_decap_8
XFILLER_633_105 VPWR VGND sg13cmos5l_decap_8
X_3010_ Tile_X0Y5_E2BEGb[5] _4385_/X VPWR VGND sg13cmos5l_buf_1
X_0222_ _0222_/Q Tile_X0Y7_FrameData[1] VGND VPWR Tile_X0Y9_FrameStrobe[1] latch
XFILLER_67_91 VPWR VGND sg13cmos5l_decap_8
XFILLER_190_70 VPWR VGND sg13cmos5l_fill_2
X_0153_ _0153_/X _4562_/X _4563_/X _1608_/Q VPWR VGND sg13cmos5l_mux2_1
XFILLER_251_100 VPWR VGND sg13cmos5l_decap_8
XFILLER_236_174 VPWR VGND sg13cmos5l_decap_8
XFILLER_236_185 VPWR VGND sg13cmos5l_fill_2
XFILLER_697_21 VPWR VGND sg13cmos5l_decap_8
XFILLER_641_182 VPWR VGND sg13cmos5l_decap_8
XFILLER_51_205 VPWR VGND sg13cmos5l_fill_2
X_0084_ _0084_/X _4006_/X _4007_/X _2404_/Q VPWR VGND sg13cmos5l_mux2_1
XFILLER_586_237 VPWR VGND sg13cmos5l_decap_8
XFILLER_340_95 VPWR VGND sg13cmos5l_decap_8
XFILLER_539_120 VPWR VGND sg13cmos5l_decap_8
X_3912_ _3912_/X Tile_X0Y2_W1END[3] Tile_X0Y2_WW4END[3] Tile_X0Y2_W6END[11] _4119_/X
+ _1640_/Q _1639_/Q VPWR VGND sg13cmos5l_mux4_1
XFILLER_51_249 VPWR VGND sg13cmos5l_decap_8
XFILLER_400_119 VPWR VGND sg13cmos5l_decap_8
XFILLER_189_262 VPWR VGND sg13cmos5l_decap_8
X_4892_ _4892_/X Tile_X0Y9_N1END[0] Tile_X0Y9_W6END[0] _4896_/X _4892_/A3 _0679_/Q
+ _0678_/Q VPWR VGND sg13cmos5l_mux4_1
XFILLER_269_49 VPWR VGND sg13cmos5l_decap_8
XFILLER_338_215 VPWR VGND sg13cmos5l_decap_8
X_3843_ _3843_/X _3885_/X _3876_/X _3859_/X _3880_/X _1019_/Q _1018_/Q VPWR VGND sg13cmos5l_mux4_1
XFILLER_566_14 VPWR VGND sg13cmos5l_decap_8
XFILLER_539_197 VPWR VGND sg13cmos5l_decap_8
XANTENNA__3377__X Tile_X0Y2_E6BEG[0] VPWR VGND sg13cmos5l_antennanp
XFILLER_338_248 VPWR VGND sg13cmos5l_decap_8
X_3774_ _3774_/X Tile_X0Y0_WW4END[3] Tile_X0Y0_WW4END[11] Tile_X0Y0_W6END[3] _3884_/X
+ _1003_/Q _1002_/Q VPWR VGND sg13cmos5l_mux4_1
XFILLER_554_156 VPWR VGND sg13cmos5l_fill_1
X_0986_ _0986_/Q Tile_X0Y0_FrameData[17] VGND VPWR Tile_X0Y9_FrameStrobe[1] latch
XFILLER_73_0 VPWR VGND sg13cmos5l_decap_8
XFILLER_554_178 VPWR VGND sg13cmos5l_decap_8
X_2725_ _4772_/A3 VPWR VGND sg13cmos5l_tielo
XFILLER_157_192 VPWR VGND sg13cmos5l_decap_8
XFILLER_646_91 VPWR VGND sg13cmos5l_decap_8
XFILLER_218_42 VPWR VGND sg13cmos5l_decap_4
XFILLER_172_151 VPWR VGND sg13cmos5l_fill_1
X_2656_ _2656_/Q Tile_X0Y6_FrameData[7] VGND VPWR Tile_X0Y9_FrameStrobe[6] latch
XFILLER_582_35 VPWR VGND sg13cmos5l_decap_8
XFILLER_172_173 VPWR VGND sg13cmos5l_decap_8
XFILLER_365_70 VPWR VGND sg13cmos5l_decap_4
X_1607_ _1607_/Q Tile_X0Y2_FrameData[10] VGND VPWR Tile_X0Y9_FrameStrobe[5] latch
XFILLER_172_195 VPWR VGND sg13cmos5l_decap_4
X_2587_ _2587_/Q Tile_X0Y6_FrameData[12] VGND VPWR Tile_X0Y9_FrameStrobe[4] latch
XFILLER_259_211 VPWR VGND sg13cmos5l_decap_8
X_1538_ _1538_/Q Tile_X0Y2_FrameData[15] VGND VPWR Tile_X0Y9_FrameStrobe[3] latch
X_4326_ _4326_/X Tile_X0Y8_W1END[1] Tile_X0Y8_WW4END[1] Tile_X0Y8_W6END[9] _4801_/X
+ _0644_/Q _0643_/Q VPWR VGND sg13cmos5l_mux4_1
XFILLER_515_84 VPWR VGND sg13cmos5l_decap_8
XFILLER_609_135 VPWR VGND sg13cmos5l_decap_4
XFILLER_259_255 VPWR VGND sg13cmos5l_decap_8
XFILLER_451_28 VPWR VGND sg13cmos5l_decap_8
X_4257_ _4257_/X Tile_X0Y4_W2MID[6] AXI_M_SOC_BRESP1 _4315_/X _4314_/X _2099_/Q _2098_/Q
+ VPWR VGND sg13cmos5l_mux4_1
X_1469_ _1469_/Q Tile_X0Y2_FrameData[20] VGND VPWR Tile_X0Y9_FrameStrobe[1] latch
XFILLER_234_74 VPWR VGND sg13cmos5l_decap_8
XFILLER_86_168 VPWR VGND sg13cmos5l_decap_8
X_3208_ Tile_X0Y0_N1BEG[0] _3780_/X VPWR VGND sg13cmos5l_buf_1
XFILLER_274_247 VPWR VGND sg13cmos5l_decap_8
XFILLER_490_133 VPWR VGND sg13cmos5l_decap_8
X_4188_ _4188_/X AXI_M_SOC_WREADY _4225_/X _4229_/X _4210_/X _1765_/Q _1764_/Q VPWR
+ VGND sg13cmos5l_mux4_1
XFILLER_27_224 VPWR VGND sg13cmos5l_decap_8
X_3139_ Tile_X0Y7_FrameData_O[9] Tile_X0Y7_FrameData[9] VPWR VGND sg13cmos5l_buf_1
XFILLER_416_263 VPWR VGND sg13cmos5l_fill_2
XFILLER_103_56 VPWR VGND sg13cmos5l_decap_8
XFILLER_490_199 VPWR VGND sg13cmos5l_decap_8
XFILLER_242_122 VPWR VGND sg13cmos5l_decap_8
XFILLER_400_21 VPWR VGND sg13cmos5l_decap_8
XFILLER_63_49 VPWR VGND sg13cmos5l_decap_8
XFILLER_577_248 VPWR VGND sg13cmos5l_decap_8
XFILLER_388_159 VPWR VGND sg13cmos5l_decap_8
XFILLER_151_7 VPWR VGND sg13cmos5l_decap_8
XFILLER_42_249 VPWR VGND sg13cmos5l_decap_8
XFILLER_476_14 VPWR VGND sg13cmos5l_decap_8
XFILLER_545_112 VPWR VGND sg13cmos5l_decap_8
XANTENNA__3287__X Tile_X0Y0_E6BEG[7] VPWR VGND sg13cmos5l_antennanp
XFILLER_416_7 VPWR VGND sg13cmos5l_decap_8
XFILLER_12_42 VPWR VGND sg13cmos5l_decap_8
XFILLER_626_28 VPWR VGND sg13cmos5l_decap_8
XFILLER_409_63 VPWR VGND sg13cmos5l_decap_8
XFILLER_560_126 VPWR VGND sg13cmos5l_decap_8
XFILLER_556_91 VPWR VGND sg13cmos5l_decap_8
XFILLER_128_42 VPWR VGND sg13cmos5l_decap_8
XFILLER_163_151 VPWR VGND sg13cmos5l_decap_8
XFILLER_492_35 VPWR VGND sg13cmos5l_decap_8
XFILLER_275_70 VPWR VGND sg13cmos5l_decap_8
XFILLER_702_153 VPWR VGND sg13cmos5l_decap_8
XFILLER_501_259 VPWR VGND sg13cmos5l_decap_8
XFILLER_104_262 VPWR VGND sg13cmos5l_fill_2
XFILLER_642_49 VPWR VGND sg13cmos5l_decap_8
XFILLER_425_84 VPWR VGND sg13cmos5l_decap_8
XFILLER_466_152 VPWR VGND sg13cmos5l_decap_8
XFILLER_144_63 VPWR VGND sg13cmos5l_decap_8
XFILLER_361_28 VPWR VGND sg13cmos5l_decap_8
XANTENNA__3750__X AXI_M_SOC_ARADDR22 VPWR VGND sg13cmos5l_antennanp
XFILLER_77_179 VPWR VGND sg13cmos5l_decap_8
XFILLER_407_230 VPWR VGND sg13cmos5l_decap_8
XFILLER_265_269 VPWR VGND sg13cmos5l_decap_4
XFILLER_92_127 VPWR VGND sg13cmos5l_decap_8
XFILLER_275_0 VPWR VGND sg13cmos5l_decap_8
XFILLER_441_83 VPWR VGND sg13cmos5l_decap_8
XFILLER_441_94 VPWR VGND sg13cmos5l_fill_2
XFILLER_233_111 VPWR VGND sg13cmos5l_decap_8
XFILLER_18_268 VPWR VGND sg13cmos5l_decap_4
XFILLER_422_222 VPWR VGND sg13cmos5l_decap_8
XFILLER_442_0 VPWR VGND sg13cmos5l_decap_4
XFILLER_33_249 VPWR VGND sg13cmos5l_decap_8
XFILLER_667_35 VPWR VGND sg13cmos5l_decap_8
XFILLER_53_60 VPWR VGND sg13cmos5l_decap_8
XFILLER_583_229 VPWR VGND sg13cmos5l_decap_8
XFILLER_53_71 VPWR VGND sg13cmos5l_fill_1
XFILLER_387_170 VPWR VGND sg13cmos5l_fill_1
XFILLER_186_232 VPWR VGND sg13cmos5l_decap_8
XFILLER_53_82 VPWR VGND sg13cmos5l_decap_8
XFILLER_386_14 VPWR VGND sg13cmos5l_decap_8
XANTENNA__3197__X Tile_X0Y0_N2BEGb[5] VPWR VGND sg13cmos5l_antennanp
XFILLER_707_0 VPWR VGND sg13cmos5l_decap_8
XFILLER_536_134 VPWR VGND sg13cmos5l_decap_8
X_0840_ _0840_/Q Tile_X0Y9_FrameData[23] VGND VPWR Tile_X0Y9_FrameStrobe[5] latch
XFILLER_536_28 VPWR VGND sg13cmos5l_decap_8
X_0771_ _0771_/Q Tile_X0Y9_FrameData[28] VGND VPWR Tile_X0Y9_FrameStrobe[3] latch
X_2510_ _2510_/Q Tile_X0Y6_FrameData[25] VGND VPWR Tile_X0Y9_FrameStrobe[2] latch
XFILLER_319_96 VPWR VGND sg13cmos5l_decap_8
XFILLER_343_240 VPWR VGND sg13cmos5l_fill_2
X_3490_ Tile_X0Y1_E6BEG[0] _3964_/X VPWR VGND sg13cmos5l_buf_1
XFILLER_683_78 VPWR VGND sg13cmos5l_decap_4
XFILLER_255_29 VPWR VGND sg13cmos5l_decap_8
XFILLER_343_262 VPWR VGND sg13cmos5l_fill_2
XFILLER_489_255 VPWR VGND sg13cmos5l_fill_2
XFILLER_5_172 VPWR VGND sg13cmos5l_decap_8
XFILLER_154_195 VPWR VGND sg13cmos5l_fill_1
X_2441_ _2441_/Q Tile_X0Y6_FrameData[30] VGND VPWR Tile_X0Y9_FrameStrobe[0] latch
XFILLER_449_119 VPWR VGND sg13cmos5l_fill_2
XFILLER_638_219 VPWR VGND sg13cmos5l_decap_8
X_2372_ _2372_/Q Tile_X0Y5_FrameData[1] VGND VPWR Tile_X0Y9_FrameStrobe[5] latch
XFILLER_552_49 VPWR VGND sg13cmos5l_decap_8
XFILLER_457_141 VPWR VGND sg13cmos5l_fill_1
X_4111_ _4111_/X Tile_X0Y6_W1END[2] Tile_X0Y6_WW4END[2] Tile_X0Y6_W6END[10] _4570_/X
+ _2665_/Q _2664_/Q VPWR VGND sg13cmos5l_mux4_1
X_1323_ _1323_/Q Tile_X0Y1_FrameData[14] VGND VPWR Tile_X0Y9_FrameStrobe[4] latch
XFILLER_646_252 VPWR VGND sg13cmos5l_decap_8
XFILLER_311_170 VPWR VGND sg13cmos5l_decap_8
XFILLER_271_28 VPWR VGND sg13cmos5l_decap_8
XFILLER_110_232 VPWR VGND sg13cmos5l_fill_2
XANTENNA__3660__X AXI_M_SOC_AWADDR21 VPWR VGND sg13cmos5l_antennanp
XFILLER_256_225 VPWR VGND sg13cmos5l_decap_8
XFILLER_68_168 VPWR VGND sg13cmos5l_decap_8
XFILLER_661_211 VPWR VGND sg13cmos5l_decap_8
XFILLER_606_116 VPWR VGND sg13cmos5l_decap_8
XFILLER_110_265 VPWR VGND sg13cmos5l_decap_8
X_4042_ _4042_/X Tile_X0Y2_W2MID[5] AXI_M_SOC_AWREADY _4101_/X _4100_/X _1589_/Q _1588_/Q
+ VPWR VGND sg13cmos5l_mux4_1
X_1254_ _1254_/Q Tile_X0Y1_FrameData[19] VGND VPWR Tile_X0Y9_FrameStrobe[2] latch
XFILLER_661_233 VPWR VGND sg13cmos5l_decap_4
XFILLER_661_244 VPWR VGND sg13cmos5l_fill_1
XFILLER_472_155 VPWR VGND sg13cmos5l_fill_1
XFILLER_204_77 VPWR VGND sg13cmos5l_decap_8
X_0205_ _0205_/Q Tile_X0Y7_FrameData[18] VGND VPWR Tile_X0Y9_FrameStrobe[1] latch
XFILLER_209_163 VPWR VGND sg13cmos5l_decap_8
XFILLER_83_149 VPWR VGND sg13cmos5l_decap_8
XFILLER_204_88 VPWR VGND sg13cmos5l_fill_2
X_1185_ _1185_/Q Tile_X0Y1_FrameData[24] VGND VPWR Tile_X0Y9_FrameStrobe[0] latch
XFILLER_413_200 VPWR VGND sg13cmos5l_decap_8
XFILLER_271_239 VPWR VGND sg13cmos5l_fill_1
XFILLER_501_42 VPWR VGND sg13cmos5l_decap_8
X_0136_ AXI_M_SOC_AWLEN3 _0940_/Q _3674_/X VPWR VGND sg13cmos5l_nor2b_1
XFILLER_559_226 VPWR VGND sg13cmos5l_decap_4
XFILLER_413_244 VPWR VGND sg13cmos5l_decap_8
XFILLER_220_21 VPWR VGND sg13cmos5l_decap_8
XFILLER_224_166 VPWR VGND sg13cmos5l_fill_2
X_0067_ _0067_/X _3865_/X _3866_/X _2155_/Q VPWR VGND sg13cmos5l_mux2_1
XFILLER_577_35 VPWR VGND sg13cmos5l_decap_8
XFILLER_177_221 VPWR VGND sg13cmos5l_decap_8
XFILLER_296_14 VPWR VGND sg13cmos5l_decap_8
X_4875_ _4875_/X Tile_X0Y9_WW4END[4] AXI_M_SOC_RDATA4 _4920_/X _4906_/X _0793_/Q _0792_/Q
+ VPWR VGND sg13cmos5l_mux4_1
X_3826_ _3826_/X Tile_X0Y0_WW4END[9] _3872_/X _3855_/X _3862_/X _1053_/Q _1052_/Q
+ VPWR VGND sg13cmos5l_mux4_1
XFILLER_326_207 VPWR VGND sg13cmos5l_decap_8
XFILLER_229_63 VPWR VGND sg13cmos5l_decap_8
XFILLER_542_126 VPWR VGND sg13cmos5l_decap_8
X_0969_ _0969_/Q Tile_X0Y0_FrameData[2] VGND VPWR Tile_X0Y9_FrameStrobe[0] latch
X_3757_ AXI_M_SOC_ARADDR29 Tile_X0Y8_W1END[1] Tile_X0Y8_WW4END[5] Tile_X0Y8_WW4END[13]
+ _4813_/X _0477_/Q _0476_/Q VPWR VGND sg13cmos5l_mux4_1
XFILLER_593_56 VPWR VGND sg13cmos5l_decap_8
XFILLER_376_91 VPWR VGND sg13cmos5l_decap_8
X_2708_ _4303_/A3 VPWR VGND sg13cmos5l_tielo
X_3688_ _3688_/X Tile_X0Y3_WW4END[6] Tile_X0Y3_WW4END[14] Tile_X0Y3_W6END[6] _4228_/X
+ _1745_/Q _1744_/Q VPWR VGND sg13cmos5l_mux4_1
XFILLER_495_203 VPWR VGND sg13cmos5l_fill_2
X_2639_ _2639_/Q Tile_X0Y6_FrameData[24] VGND VPWR Tile_X0Y9_FrameStrobe[6] latch
XFILLER_160_154 VPWR VGND sg13cmos5l_decap_8
XFILLER_462_49 VPWR VGND sg13cmos5l_decap_8
XFILLER_160_187 VPWR VGND sg13cmos5l_decap_8
XFILLER_181_28 VPWR VGND sg13cmos5l_decap_8
X_4309_ _4309_/X _4311_/X Tile_X0Y4_W6END[3] _4310_/X _4309_/A3 _1927_/Q _2182_/Q
+ VPWR VGND sg13cmos5l_mux4_1
XANTENNA__3570__X Tile_X0Y9_FrameData_O[0] VPWR VGND sg13cmos5l_antennanp
XFILLER_199_7 VPWR VGND sg13cmos5l_decap_8
XFILLER_463_100 VPWR VGND sg13cmos5l_decap_8
XFILLER_247_225 VPWR VGND sg13cmos5l_decap_8
XFILLER_59_179 VPWR VGND sg13cmos5l_decap_8
XFILLER_463_144 VPWR VGND sg13cmos5l_decap_8
XFILLER_247_269 VPWR VGND sg13cmos5l_decap_4
XFILLER_74_127 VPWR VGND sg13cmos5l_decap_8
XFILLER_261_61 VPWR VGND sg13cmos5l_decap_8
XFILLER_463_177 VPWR VGND sg13cmos5l_decap_8
XFILLER_215_111 VPWR VGND sg13cmos5l_decap_8
XFILLER_411_42 VPWR VGND sg13cmos5l_decap_8
XFILLER_130_21 VPWR VGND sg13cmos5l_decap_8
XFILLER_15_227 VPWR VGND sg13cmos5l_decap_8
XANTENNA__2914__X Tile_X0Y8_E1BEG[2] VPWR VGND sg13cmos5l_antennanp
XFILLER_533_7 VPWR VGND sg13cmos5l_decap_8
XFILLER_90_14 VPWR VGND sg13cmos5l_decap_8
XFILLER_620_174 VPWR VGND sg13cmos5l_decap_8
XFILLER_487_35 VPWR VGND sg13cmos5l_decap_8
XFILLER_230_136 VPWR VGND sg13cmos5l_decap_8
XFILLER_30_219 VPWR VGND sg13cmos5l_decap_4
XFILLER_130_98 VPWR VGND sg13cmos5l_decap_8
XFILLER_168_221 VPWR VGND sg13cmos5l_decap_8
XFILLER_707_234 VPWR VGND sg13cmos5l_decap_4
XFILLER_700_7 VPWR VGND sg13cmos5l_decap_8
XFILLER_637_49 VPWR VGND sg13cmos5l_decap_8
XFILLER_384_184 VPWR VGND sg13cmos5l_fill_2
XFILLER_139_63 VPWR VGND sg13cmos5l_decap_8
XFILLER_356_28 VPWR VGND sg13cmos5l_decap_8
XFILLER_183_257 VPWR VGND sg13cmos5l_decap_8
XFILLER_533_137 VPWR VGND sg13cmos5l_decap_8
XANTENNA__3745__X AXI_M_SOC_ARADDR17 VPWR VGND sg13cmos5l_antennanp
XFILLER_286_91 VPWR VGND sg13cmos5l_decap_8
XFILLER_717_82 VPWR VGND sg13cmos5l_fill_2
XFILLER_99_56 VPWR VGND sg13cmos5l_decap_8
XFILLER_325_251 VPWR VGND sg13cmos5l_decap_8
XFILLER_151_121 VPWR VGND sg13cmos5l_fill_2
XFILLER_340_232 VPWR VGND sg13cmos5l_decap_8
XFILLER_541_192 VPWR VGND sg13cmos5l_decap_8
XFILLER_3_0 VPWR VGND sg13cmos5l_decap_8
XFILLER_340_254 VPWR VGND sg13cmos5l_decap_8
XFILLER_300_107 VPWR VGND sg13cmos5l_decap_8
XFILLER_151_187 VPWR VGND sg13cmos5l_decap_4
XFILLER_2_164 VPWR VGND sg13cmos5l_decap_8
XFILLER_392_0 VPWR VGND sg13cmos5l_decap_8
XFILLER_305_21 VPWR VGND sg13cmos5l_decap_8
XANTENNA__3480__X Tile_X0Y1_EE4BEG[6] VPWR VGND sg13cmos5l_antennanp
XFILLER_452_60 VPWR VGND sg13cmos5l_fill_1
XFILLER_439_174 VPWR VGND sg13cmos5l_fill_1
XFILLER_305_76 VPWR VGND sg13cmos5l_decap_8
XFILLER_65_105 VPWR VGND sg13cmos5l_decap_8
XFILLER_452_82 VPWR VGND sg13cmos5l_fill_2
XFILLER_454_133 VPWR VGND sg13cmos5l_decap_8
XFILLER_657_0 VPWR VGND sg13cmos5l_decap_8
XFILLER_603_119 VPWR VGND sg13cmos5l_decap_4
XFILLER_454_188 VPWR VGND sg13cmos5l_decap_4
XFILLER_253_239 VPWR VGND sg13cmos5l_decap_8
XFILLER_0_56 VPWR VGND sg13cmos5l_decap_8
XFILLER_206_144 VPWR VGND sg13cmos5l_decap_8
XFILLER_678_56 VPWR VGND sg13cmos5l_fill_2
XFILLER_64_70 VPWR VGND sg13cmos5l_decap_8
XANTENNA__2824__X Tile_X0Y4_E2BEG[2] VPWR VGND sg13cmos5l_antennanp
X_2990_ Tile_X0Y8_FrameData_O[30] Tile_X0Y8_FrameData[30] VPWR VGND sg13cmos5l_buf_1
XFILLER_556_207 VPWR VGND sg13cmos5l_decap_8
XFILLER_397_35 VPWR VGND sg13cmos5l_decap_8
XFILLER_159_210 VPWR VGND sg13cmos5l_decap_4
XFILLER_9_21 VPWR VGND sg13cmos5l_decap_8
XFILLER_397_57 VPWR VGND sg13cmos5l_decap_8
XFILLER_14_271 VPWR VGND sg13cmos5l_fill_2
X_1941_ _1941_/Q Tile_X0Y4_FrameData[16] VGND VPWR Tile_X0Y9_FrameStrobe[0] latch
XFILLER_509_112 VPWR VGND sg13cmos5l_fill_1
XFILLER_410_258 VPWR VGND sg13cmos5l_decap_4
XFILLER_159_243 VPWR VGND sg13cmos5l_decap_8
XFILLER_397_79 VPWR VGND sg13cmos5l_decap_8
XFILLER_174_202 VPWR VGND sg13cmos5l_decap_8
X_1872_ _1872_/Q Tile_X0Y3_FrameData[25] VGND VPWR Tile_X0Y9_FrameStrobe[6] latch
X_4660_ _4660_/X Tile_X0Y6_W1END[0] Tile_X0Y6_W6END[8] _4580_/X _4540_/X _2659_/Q
+ _2658_/Q VPWR VGND sg13cmos5l_mux4_1
XFILLER_564_251 VPWR VGND sg13cmos5l_decap_4
XFILLER_547_49 VPWR VGND sg13cmos5l_decap_8
XFILLER_375_162 VPWR VGND sg13cmos5l_decap_8
XFILLER_9_98 VPWR VGND sg13cmos5l_fill_2
XFILLER_375_173 VPWR VGND sg13cmos5l_fill_1
X_0823_ _0823_/Q Tile_X0Y9_FrameData[8] VGND VPWR Tile_X0Y9_FrameStrobe[4] latch
X_3611_ Tile_X0Y9_S2BEG[5] _4833_/X VPWR VGND sg13cmos5l_buf_1
XFILLER_694_77 VPWR VGND sg13cmos5l_decap_4
XFILLER_266_28 VPWR VGND sg13cmos5l_decap_8
XFILLER_694_88 VPWR VGND sg13cmos5l_fill_1
XFILLER_375_195 VPWR VGND sg13cmos5l_decap_8
X_4591_ _4591_/X Tile_X0Y8_W2MID[4] Tile_X0Y8_W2END[4] Tile_X0Y8_W6END[4] _4791_/X
+ _0657_/Q _0656_/Q VPWR VGND sg13cmos5l_mux4_1
XANTENNA__3655__X AXI_M_SOC_AWADDR16 VPWR VGND sg13cmos5l_antennanp
XFILLER_390_143 VPWR VGND sg13cmos5l_decap_8
XFILLER_196_91 VPWR VGND sg13cmos5l_decap_8
X_0754_ _0754_/Q Tile_X0Y9_FrameData[13] VGND VPWR Tile_X0Y9_FrameStrobe[2] latch
X_3542_ Tile_X0Y9_E6BEG[0] _4880_/X VPWR VGND sg13cmos5l_buf_1
XFILLER_127_162 VPWR VGND sg13cmos5l_decap_8
XFILLER_390_187 VPWR VGND sg13cmos5l_decap_8
X_3473_ Tile_X0Y1_FrameData_O[31] Tile_X0Y1_FrameData[31] VPWR VGND sg13cmos5l_buf_1
X_0685_ _0685_/Q Tile_X0Y9_FrameData[18] VGND VPWR Tile_X0Y9_FrameStrobe[0] latch
XFILLER_678_174 VPWR VGND sg13cmos5l_fill_2
XFILLER_142_143 VPWR VGND sg13cmos5l_decap_8
XFILLER_288_136 VPWR VGND sg13cmos5l_decap_8
X_2424_ _2424_/Q Tile_X0Y5_FrameData[13] VGND VPWR Tile_X0Y9_FrameStrobe[7] latch
XFILLER_282_49 VPWR VGND sg13cmos5l_decap_8
XFILLER_215_21 VPWR VGND sg13cmos5l_decap_8
XFILLER_643_70 VPWR VGND sg13cmos5l_decap_8
XFILLER_477_269 VPWR VGND sg13cmos5l_decap_4
XFILLER_36_0 VPWR VGND sg13cmos5l_decap_8
XFILLER_693_166 VPWR VGND sg13cmos5l_decap_8
X_2355_ _2355_/Q Tile_X0Y5_FrameData[18] VGND VPWR Tile_X0Y9_FrameStrobe[5] latch
XANTENNA__3390__X Tile_X0Y2_E2BEGb[1] VPWR VGND sg13cmos5l_antennanp
XFILLER_296_191 VPWR VGND sg13cmos5l_fill_1
X_1306_ _1306_/Q Tile_X0Y1_FrameData[31] VGND VPWR Tile_X0Y9_FrameStrobe[4] latch
XFILLER_445_122 VPWR VGND sg13cmos5l_decap_8
XFILLER_215_87 VPWR VGND sg13cmos5l_fill_1
X_2286_ _2286_/Q Tile_X0Y5_FrameData[23] VGND VPWR Tile_X0Y9_FrameStrobe[3] latch
XFILLER_56_116 VPWR VGND sg13cmos5l_decap_8
XFILLER_634_255 VPWR VGND sg13cmos5l_fill_2
X_4025_ _4025_/X Tile_X0Y3_W2MID[5] Tile_X0Y3_W2END[5] Tile_X0Y3_W6END[5] _4209_/X
+ _1913_/Q _1912_/Q VPWR VGND sg13cmos5l_mux4_1
X_1237_ _1237_/Q Tile_X0Y1_FrameData[4] VGND VPWR Tile_X0Y9_FrameStrobe[1] latch
XFILLER_512_63 VPWR VGND sg13cmos5l_decap_8
XFILLER_231_42 VPWR VGND sg13cmos5l_decap_8
X_1168_ _1168_/Q Tile_X0Y0_FrameData[27] VGND VPWR Tile_X0Y9_FrameStrobe[7] latch
XFILLER_599_181 VPWR VGND sg13cmos5l_decap_8
XFILLER_64_182 VPWR VGND sg13cmos5l_decap_8
XFILLER_231_86 VPWR VGND sg13cmos5l_decap_4
XFILLER_588_56 VPWR VGND sg13cmos5l_decap_8
X_0119_ AXI_M_SOC_ARCACHE1 _0929_/Q _3775_/X VPWR VGND sg13cmos5l_or2_1
XFILLER_602_163 VPWR VGND sg13cmos5l_fill_2
X_1099_ _1099_/Q Tile_X0Y0_FrameData[0] VGND VPWR Tile_X0Y9_FrameStrobe[4] latch
XFILLER_12_208 VPWR VGND sg13cmos5l_fill_2
XFILLER_212_147 VPWR VGND sg13cmos5l_decap_8
X_4927_ _4927_/X Tile_X0Y9_N1END[3] Tile_X0Y9_N4END[3] _4899_/X _0080_/X _0705_/Q
+ _0704_/Q VPWR VGND sg13cmos5l_mux4_1
XFILLER_100_35 VPWR VGND sg13cmos5l_decap_8
X_4858_ _4858_/X Tile_X0Y9_W2END[5] AXI_M_SOC_RDATA5 _4905_/X _4904_/X _0827_/Q _0826_/Q
+ VPWR VGND sg13cmos5l_mux4_1
XFILLER_457_49 VPWR VGND sg13cmos5l_decap_8
XFILLER_704_204 VPWR VGND sg13cmos5l_decap_8
XFILLER_570_210 VPWR VGND sg13cmos5l_decap_8
XFILLER_515_115 VPWR VGND sg13cmos5l_decap_8
XFILLER_176_28 VPWR VGND sg13cmos5l_decap_8
X_3809_ _3809_/X Tile_X0Y0_W2MID[2] Tile_X0Y0_WW4END[15] _3857_/X _3856_/X _1087_/Q
+ _1086_/Q VPWR VGND sg13cmos5l_mux4_1
XFILLER_515_126 VPWR VGND sg13cmos5l_fill_2
XFILLER_381_132 VPWR VGND sg13cmos5l_decap_8
XANTENNA__3565__X Tile_X0Y9_EE4BEG[11] VPWR VGND sg13cmos5l_antennanp
X_4789_ _4789_/X _4705_/X Tile_X0Y9_N2MID[2] _4818_/X _4704_/X _0435_/Q _0434_/Q VPWR
+ VGND sg13cmos5l_mux4_1
XFILLER_704_237 VPWR VGND sg13cmos5l_fill_2
XFILLER_165_268 VPWR VGND sg13cmos5l_decap_4
XFILLER_109_22 VPWR VGND sg13cmos5l_decap_8
XFILLER_114_7 VPWR VGND sg13cmos5l_decap_8
XFILLER_307_251 VPWR VGND sg13cmos5l_decap_8
XFILLER_307_262 VPWR VGND sg13cmos5l_fill_1
XFILLER_180_227 VPWR VGND sg13cmos5l_decap_8
XFILLER_256_72 VPWR VGND sg13cmos5l_fill_2
XFILLER_133_132 VPWR VGND sg13cmos5l_decap_8
XFILLER_523_192 VPWR VGND sg13cmos5l_decap_8
XFILLER_684_122 VPWR VGND sg13cmos5l_decap_8
XFILLER_406_42 VPWR VGND sg13cmos5l_decap_8
XFILLER_279_147 VPWR VGND sg13cmos5l_decap_8
XFILLER_553_70 VPWR VGND sg13cmos5l_decap_8
XFILLER_125_21 VPWR VGND sg13cmos5l_decap_8
XFILLER_294_117 VPWR VGND sg13cmos5l_decap_8
XFILLER_87_230 VPWR VGND sg13cmos5l_decap_8
XFILLER_294_128 VPWR VGND sg13cmos5l_fill_1
XANTENNA__2909__X Tile_X0Y6_FrameData_O[30] VPWR VGND sg13cmos5l_antennanp
XFILLER_85_14 VPWR VGND sg13cmos5l_decap_8
XFILLER_47_105 VPWR VGND sg13cmos5l_decap_8
XFILLER_436_133 VPWR VGND sg13cmos5l_decap_8
XFILLER_703_84 VPWR VGND sg13cmos5l_decap_8
XFILLER_650_7 VPWR VGND sg13cmos5l_decap_8
XFILLER_422_63 VPWR VGND sg13cmos5l_decap_8
XFILLER_640_203 VPWR VGND sg13cmos5l_decap_8
XFILLER_436_188 VPWR VGND sg13cmos5l_decap_8
XFILLER_235_239 VPWR VGND sg13cmos5l_decap_8
XFILLER_18_63 VPWR VGND sg13cmos5l_decap_8
XFILLER_141_42 VPWR VGND sg13cmos5l_decap_8
XFILLER_451_147 VPWR VGND sg13cmos5l_decap_8
XANTENNA__0148__Y AXI_M_SOC_ARCACHE2 VPWR VGND sg13cmos5l_antennanp
XFILLER_498_56 VPWR VGND sg13cmos5l_decap_8
XFILLER_243_272 VPWR VGND sg13cmos5l_fill_1
XFILLER_203_114 VPWR VGND sg13cmos5l_decap_8
XFILLER_70_130 VPWR VGND sg13cmos5l_decap_8
XFILLER_140_0 VPWR VGND sg13cmos5l_decap_8
XFILLER_70_196 VPWR VGND sg13cmos5l_decap_8
XFILLER_34_84 VPWR VGND sg13cmos5l_decap_8
XFILLER_357_140 VPWR VGND sg13cmos5l_decap_8
XFILLER_238_0 VPWR VGND sg13cmos5l_decap_8
XFILLER_546_251 VPWR VGND sg13cmos5l_fill_2
XFILLER_11_252 VPWR VGND sg13cmos5l_decap_8
XFILLER_372_110 VPWR VGND sg13cmos5l_fill_1
XFILLER_7_234 VPWR VGND sg13cmos5l_decap_8
XFILLER_664_14 VPWR VGND sg13cmos5l_decap_8
XANTENNA__3475__X Tile_X0Y1_EE4BEG[1] VPWR VGND sg13cmos5l_antennanp
XFILLER_156_268 VPWR VGND sg13cmos5l_decap_4
XFILLER_405_0 VPWR VGND sg13cmos5l_decap_8
XFILLER_372_143 VPWR VGND sg13cmos5l_decap_8
XFILLER_109_140 VPWR VGND sg13cmos5l_fill_1
XFILLER_7_256 VPWR VGND sg13cmos5l_decap_4
XFILLER_109_162 VPWR VGND sg13cmos5l_fill_2
XFILLER_171_227 VPWR VGND sg13cmos5l_decap_8
XFILLER_675_100 VPWR VGND sg13cmos5l_fill_2
XFILLER_514_192 VPWR VGND sg13cmos5l_decap_8
XFILLER_124_154 VPWR VGND sg13cmos5l_decap_8
X_0470_ _0470_/Q Tile_X0Y8_FrameData[9] VGND VPWR Tile_X0Y9_FrameStrobe[1] latch
XFILLER_675_133 VPWR VGND sg13cmos5l_decap_8
XFILLER_459_258 VPWR VGND sg13cmos5l_decap_8
XFILLER_675_144 VPWR VGND sg13cmos5l_fill_2
XFILLER_474_217 VPWR VGND sg13cmos5l_decap_8
XANTENNA__2819__X Tile_X0Y3_E1BEG[1] VPWR VGND sg13cmos5l_antennanp
X_2140_ _2140_/Q Tile_X0Y4_FrameData[9] VGND VPWR Tile_X0Y9_FrameStrobe[6] latch
XFILLER_427_133 VPWR VGND sg13cmos5l_decap_8
XFILLER_93_222 VPWR VGND sg13cmos5l_decap_8
XFILLER_482_261 VPWR VGND sg13cmos5l_decap_8
XFILLER_332_52 VPWR VGND sg13cmos5l_fill_1
X_2071_ _2071_/Q Tile_X0Y4_FrameData[14] VGND VPWR Tile_X0Y9_FrameStrobe[4] latch
XFILLER_482_272 VPWR VGND sg13cmos5l_fill_1
XFILLER_442_103 VPWR VGND sg13cmos5l_fill_1
XFILLER_332_74 VPWR VGND sg13cmos5l_decap_8
XFILLER_442_125 VPWR VGND sg13cmos5l_decap_8
X_1022_ _1022_/Q Tile_X0Y0_FrameData[13] VGND VPWR Tile_X0Y9_FrameStrobe[2] latch
XFILLER_689_99 VPWR VGND sg13cmos5l_decap_8
XFILLER_234_250 VPWR VGND sg13cmos5l_decap_8
XFILLER_201_56 VPWR VGND sg13cmos5l_decap_8
XFILLER_395_213 VPWR VGND sg13cmos5l_decap_8
X_2973_ Tile_X0Y8_FrameData_O[13] Tile_X0Y8_FrameData[13] VPWR VGND sg13cmos5l_buf_1
X_4712_ _4712_/X Tile_X0Y6_W1END[2] Tile_X0Y6_W2MID[1] Tile_X0Y6_W2END[1] _4554_/X
+ _2639_/Q _2638_/Q VPWR VGND sg13cmos5l_mux4_1
X_1924_ _1924_/Q Tile_X0Y3_FrameData[5] VGND VPWR Tile_X0Y9_FrameStrobe[7] latch
XFILLER_277_49 VPWR VGND sg13cmos5l_decap_8
XFILLER_638_70 VPWR VGND sg13cmos5l_decap_8
X_4643_ _4643_/X Tile_X0Y7_WW4END[0] AXI_M_SOC_RDATA16 _4684_/X _4669_/X _0273_/Q
+ _0272_/Q VPWR VGND sg13cmos5l_mux4_1
XFILLER_574_14 VPWR VGND sg13cmos5l_decap_8
X_1855_ _1855_/Q Tile_X0Y3_FrameData[10] VGND VPWR Tile_X0Y9_FrameStrobe[5] latch
XANTENNA__3385__X Tile_X0Y2_E6BEG[8] VPWR VGND sg13cmos5l_antennanp
X_0806_ _0806_/Q Tile_X0Y9_FrameData[25] VGND VPWR Tile_X0Y9_FrameStrobe[4] latch
X_1786_ _1786_/Q Tile_X0Y3_FrameData[15] VGND VPWR Tile_X0Y9_FrameStrobe[3] latch
X_4574_ _4574_/X _4549_/X Tile_X0Y9_N4END[14] _4548_/X _0155_/X _2483_/Q _2482_/Q
+ VPWR VGND sg13cmos5l_mux4_1
XFILLER_115_110 VPWR VGND sg13cmos5l_decap_8
X_3525_ Tile_X0Y9_E1BEG[3] _4847_/X VPWR VGND sg13cmos5l_buf_1
XFILLER_507_63 VPWR VGND sg13cmos5l_decap_8
X_0737_ _0737_/Q Tile_X0Y9_FrameData[30] VGND VPWR Tile_X0Y9_FrameStrobe[2] latch
XFILLER_226_42 VPWR VGND sg13cmos5l_decap_8
X_0668_ _0668_/Q Tile_X0Y8_FrameData[3] VGND VPWR Tile_X0Y9_FrameStrobe[7] latch
X_3456_ Tile_X0Y1_FrameData_O[14] Tile_X0Y1_FrameData[14] VPWR VGND sg13cmos5l_buf_1
XFILLER_590_35 VPWR VGND sg13cmos5l_decap_8
XFILLER_115_187 VPWR VGND sg13cmos5l_decap_8
XFILLER_115_198 VPWR VGND sg13cmos5l_fill_1
XFILLER_226_86 VPWR VGND sg13cmos5l_decap_8
XFILLER_373_92 VPWR VGND sg13cmos5l_fill_1
X_2407_ _2407_/Q Tile_X0Y5_FrameData[30] VGND VPWR Tile_X0Y9_FrameStrobe[7] latch
X_3387_ Tile_X0Y2_E6BEG[10] _4082_/X VPWR VGND sg13cmos5l_buf_1
XFILLER_666_188 VPWR VGND sg13cmos5l_fill_2
XFILLER_465_228 VPWR VGND sg13cmos5l_decap_8
X_0599_ _0599_/Q Tile_X0Y8_FrameData[8] VGND VPWR Tile_X0Y9_FrameStrobe[5] latch
XFILLER_69_252 VPWR VGND sg13cmos5l_decap_8
XFILLER_607_200 VPWR VGND sg13cmos5l_decap_8
XFILLER_418_111 VPWR VGND sg13cmos5l_decap_8
XFILLER_269_180 VPWR VGND sg13cmos5l_fill_1
XFILLER_130_168 VPWR VGND sg13cmos5l_decap_8
XFILLER_607_211 VPWR VGND sg13cmos5l_fill_1
XFILLER_681_136 VPWR VGND sg13cmos5l_decap_8
X_2338_ _2338_/Q Tile_X0Y5_FrameData[3] VGND VPWR Tile_X0Y9_FrameStrobe[4] latch
XFILLER_523_84 VPWR VGND sg13cmos5l_decap_8
XFILLER_84_222 VPWR VGND sg13cmos5l_fill_2
XFILLER_284_161 VPWR VGND sg13cmos5l_decap_8
XFILLER_84_233 VPWR VGND sg13cmos5l_fill_1
XFILLER_473_272 VPWR VGND sg13cmos5l_fill_1
XFILLER_418_177 VPWR VGND sg13cmos5l_decap_8
XFILLER_84_255 VPWR VGND sg13cmos5l_decap_8
X_2269_ _2269_/Q Tile_X0Y5_FrameData[8] VGND VPWR Tile_X0Y9_FrameStrobe[2] latch
XFILLER_55_17 VPWR VGND sg13cmos5l_decap_8
XFILLER_622_214 VPWR VGND sg13cmos5l_decap_8
XFILLER_44_108 VPWR VGND sg13cmos5l_decap_8
XFILLER_579_129 VPWR VGND sg13cmos5l_decap_8
XFILLER_433_136 VPWR VGND sg13cmos5l_decap_4
X_4008_ _4008_/X _3981_/X _0073_/X _3980_/X Tile_X0Y0_S4END[4] _1233_/Q _1232_/Q VPWR
+ VGND sg13cmos5l_mux4_1
XFILLER_225_272 VPWR VGND sg13cmos5l_fill_1
XFILLER_197_102 VPWR VGND sg13cmos5l_decap_8
XFILLER_240_220 VPWR VGND sg13cmos5l_fill_1
XFILLER_111_56 VPWR VGND sg13cmos5l_decap_8
XFILLER_441_180 VPWR VGND sg13cmos5l_decap_8
XFILLER_386_224 VPWR VGND sg13cmos5l_decap_8
XFILLER_71_49 VPWR VGND sg13cmos5l_decap_8
XFILLER_339_140 VPWR VGND sg13cmos5l_decap_8
XFILLER_231_7 VPWR VGND sg13cmos5l_decap_8
XFILLER_548_70 VPWR VGND sg13cmos5l_decap_8
XFILLER_138_224 VPWR VGND sg13cmos5l_decap_8
XFILLER_484_14 VPWR VGND sg13cmos5l_decap_8
XANTENNA__3295__X Tile_X0Y0_E2BEGb[3] VPWR VGND sg13cmos5l_antennanp
XFILLER_138_268 VPWR VGND sg13cmos5l_decap_4
XFILLER_543_243 VPWR VGND sg13cmos5l_decap_8
XFILLER_354_154 VPWR VGND sg13cmos5l_decap_8
XFILLER_689_269 VPWR VGND sg13cmos5l_decap_4
XFILLER_106_110 VPWR VGND sg13cmos5l_decap_8
XFILLER_4_226 VPWR VGND sg13cmos5l_fill_1
XFILLER_20_42 VPWR VGND sg13cmos5l_decap_8
XFILLER_634_28 VPWR VGND sg13cmos5l_decap_8
XFILLER_417_63 VPWR VGND sg13cmos5l_decap_8
XFILLER_698_7 VPWR VGND sg13cmos5l_decap_8
XFILLER_136_42 VPWR VGND sg13cmos5l_decap_8
XFILLER_564_91 VPWR VGND sg13cmos5l_decap_8
XFILLER_161_260 VPWR VGND sg13cmos5l_fill_2
XFILLER_20_86 VPWR VGND sg13cmos5l_fill_1
XFILLER_511_151 VPWR VGND sg13cmos5l_decap_4
XFILLER_657_144 VPWR VGND sg13cmos5l_decap_8
XFILLER_283_70 VPWR VGND sg13cmos5l_decap_8
XFILLER_106_198 VPWR VGND sg13cmos5l_decap_8
XFILLER_700_262 VPWR VGND sg13cmos5l_fill_2
XFILLER_672_103 VPWR VGND sg13cmos5l_decap_8
XFILLER_267_139 VPWR VGND sg13cmos5l_decap_8
XFILLER_121_168 VPWR VGND sg13cmos5l_decap_8
XFILLER_310_268 VPWR VGND sg13cmos5l_decap_4
XFILLER_650_49 VPWR VGND sg13cmos5l_decap_8
XFILLER_433_84 VPWR VGND sg13cmos5l_decap_8
XFILLER_208_217 VPWR VGND sg13cmos5l_decap_8
XFILLER_188_0 VPWR VGND sg13cmos5l_decap_8
XFILLER_29_95 VPWR VGND sg13cmos5l_fill_1
XFILLER_424_147 VPWR VGND sg13cmos5l_decap_8
XFILLER_659_14 VPWR VGND sg13cmos5l_decap_8
XFILLER_355_0 VPWR VGND sg13cmos5l_decap_8
XFILLER_578_140 VPWR VGND sg13cmos5l_decap_8
XFILLER_45_72 VPWR VGND sg13cmos5l_decap_8
XFILLER_378_15 VPWR VGND sg13cmos5l_decap_8
XFILLER_377_213 VPWR VGND sg13cmos5l_fill_2
XFILLER_43_163 VPWR VGND sg13cmos5l_decap_8
XFILLER_522_0 VPWR VGND sg13cmos5l_decap_8
XFILLER_377_257 VPWR VGND sg13cmos5l_decap_8
XFILLER_188_168 VPWR VGND sg13cmos5l_decap_8
XFILLER_675_35 VPWR VGND sg13cmos5l_decap_8
XFILLER_129_235 VPWR VGND sg13cmos5l_decap_8
XFILLER_534_221 VPWR VGND sg13cmos5l_decap_8
XFILLER_177_60 VPWR VGND sg13cmos5l_decap_8
XFILLER_675_79 VPWR VGND sg13cmos5l_decap_8
XFILLER_394_36 VPWR VGND sg13cmos5l_decap_8
X_1640_ _1640_/Q Tile_X0Y2_FrameData[9] VGND VPWR Tile_X0Y9_FrameStrobe[6] latch
XANTENNA_4 AXI_M_SOC_RDATA26 VPWR VGND sg13cmos5l_antennanp
XFILLER_345_198 VPWR VGND sg13cmos5l_decap_8
X_1571_ _1571_/Q Tile_X0Y2_FrameData[14] VGND VPWR Tile_X0Y9_FrameStrobe[4] latch
XFILLER_544_28 VPWR VGND sg13cmos5l_decap_8
XFILLER_6_77 VPWR VGND sg13cmos5l_decap_8
XFILLER_691_56 VPWR VGND sg13cmos5l_decap_8
XFILLER_474_91 VPWR VGND sg13cmos5l_decap_8
XFILLER_360_168 VPWR VGND sg13cmos5l_decap_8
X_0522_ _0522_/Q Tile_X0Y8_FrameData[21] VGND VPWR Tile_X0Y9_FrameStrobe[3] latch
X_3310_ Tile_X0Y0_E1BEG[2] _3802_/X VPWR VGND sg13cmos5l_buf_1
XFILLER_502_140 VPWR VGND sg13cmos5l_decap_8
XFILLER_152_271 VPWR VGND sg13cmos5l_fill_2
X_4290_ _4290_/X _0160_/X _0110_/X _4345_/X _4349_/X _2033_/Q _2032_/Q VPWR VGND sg13cmos5l_mux4_1
XFILLER_648_133 VPWR VGND sg13cmos5l_decap_8
XFILLER_193_70 VPWR VGND sg13cmos5l_fill_2
X_3241_ Tile_X0Y0_FrameData_O[9] Tile_X0Y0_FrameData[9] VPWR VGND sg13cmos5l_buf_1
X_0453_ _0453_/Q Tile_X0Y8_FrameData[26] VGND VPWR Tile_X0Y9_FrameStrobe[1] latch
XFILLER_447_228 VPWR VGND sg13cmos5l_decap_8
XFILLER_648_188 VPWR VGND sg13cmos5l_decap_8
XFILLER_258_139 VPWR VGND sg13cmos5l_decap_8
XFILLER_301_268 VPWR VGND sg13cmos5l_decap_4
X_3172_ Tile_X0Y4_E6BEG[9] _4297_/X VPWR VGND sg13cmos5l_buf_1
X_0384_ _0384_/Q Tile_X0Y7_FrameData[31] VGND VPWR Tile_X0Y9_FrameStrobe[7] latch
XFILLER_560_49 VPWR VGND sg13cmos5l_decap_8
XFILLER_343_95 VPWR VGND sg13cmos5l_decap_8
XFILLER_266_150 VPWR VGND sg13cmos5l_decap_8
X_2123_ _2123_/Q Tile_X0Y4_FrameData[26] VGND VPWR Tile_X0Y9_FrameStrobe[6] latch
XANTENNA__0069__X AXI_M_SOC_WSTRB2 VPWR VGND sg13cmos5l_antennanp
XFILLER_266_183 VPWR VGND sg13cmos5l_decap_8
XFILLER_415_114 VPWR VGND sg13cmos5l_decap_8
XFILLER_415_136 VPWR VGND sg13cmos5l_fill_2
XFILLER_671_191 VPWR VGND sg13cmos5l_decap_8
X_2054_ _2054_/Q Tile_X0Y4_FrameData[31] VGND VPWR Tile_X0Y9_FrameStrobe[4] latch
XFILLER_569_14 VPWR VGND sg13cmos5l_decap_8
XFILLER_281_175 VPWR VGND sg13cmos5l_decap_8
X_1005_ _1005_/Q Tile_X0Y0_FrameData[30] VGND VPWR Tile_X0Y9_FrameStrobe[2] latch
XFILLER_212_77 VPWR VGND sg13cmos5l_decap_8
XFILLER_569_140 VPWR VGND sg13cmos5l_decap_8
XFILLER_34_152 VPWR VGND sg13cmos5l_decap_4
XFILLER_288_15 VPWR VGND sg13cmos5l_decap_8
XFILLER_222_242 VPWR VGND sg13cmos5l_decap_4
XFILLER_34_163 VPWR VGND sg13cmos5l_decap_4
XFILLER_34_196 VPWR VGND sg13cmos5l_decap_8
XFILLER_179_179 VPWR VGND sg13cmos5l_decap_8
XFILLER_649_91 VPWR VGND sg13cmos5l_decap_8
XFILLER_584_165 VPWR VGND sg13cmos5l_decap_8
X_2956_ Tile_X0Y8_EE4BEG[12] _4756_/X VPWR VGND sg13cmos5l_buf_1
XFILLER_585_35 VPWR VGND sg13cmos5l_decap_8
XFILLER_383_238 VPWR VGND sg13cmos5l_decap_8
XFILLER_336_110 VPWR VGND sg13cmos5l_decap_8
XFILLER_194_149 VPWR VGND sg13cmos5l_decap_8
X_1907_ _1907_/Q Tile_X0Y3_FrameData[22] VGND VPWR Tile_X0Y9_FrameStrobe[7] latch
X_2887_ Tile_X0Y6_FrameData_O[8] Tile_X0Y6_FrameData[8] VPWR VGND sg13cmos5l_buf_1
X_4626_ _4626_/X Tile_X0Y7_W2END[1] AXI_M_SOC_RDATA17 _4671_/X _4670_/X _0307_/Q _0306_/Q
+ VPWR VGND sg13cmos5l_mux4_1
X_1838_ _1838_/Q Tile_X0Y3_FrameData[27] VGND VPWR Tile_X0Y9_FrameStrobe[5] latch
XFILLER_518_84 VPWR VGND sg13cmos5l_decap_8
XFILLER_454_28 VPWR VGND sg13cmos5l_decap_8
X_4557_ _4557_/X _4473_/X _4589_/X _4588_/X _4472_/X _2459_/Q _2458_/Q VPWR VGND sg13cmos5l_mux4_1
X_1769_ _1769_/Q Tile_X0Y3_FrameData[0] VGND VPWR Tile_X0Y9_FrameStrobe[2] latch
XFILLER_351_168 VPWR VGND sg13cmos5l_decap_8
XFILLER_237_85 VPWR VGND sg13cmos5l_decap_8
XFILLER_540_268 VPWR VGND sg13cmos5l_decap_4
X_3508_ Tile_X0Y1_E2BEGb[6] _3946_/X VPWR VGND sg13cmos5l_buf_1
XFILLER_639_133 VPWR VGND sg13cmos5l_decap_8
XFILLER_1_229 VPWR VGND sg13cmos5l_fill_1
X_4488_ _4488_/X Tile_X0Y6_W1END[2] Tile_X0Y6_WW4END[14] Tile_X0Y6_W6END[6] _4570_/X
+ _2629_/Q _2628_/Q VPWR VGND sg13cmos5l_mux4_1
XFILLER_694_261 VPWR VGND sg13cmos5l_decap_8
XFILLER_694_272 VPWR VGND sg13cmos5l_fill_1
X_3439_ Tile_X0Y4_FrameData_O[30] Tile_X0Y4_FrameData[30] VPWR VGND sg13cmos5l_buf_1
XFILLER_438_239 VPWR VGND sg13cmos5l_decap_8
XFILLER_654_125 VPWR VGND sg13cmos5l_decap_8
XFILLER_106_67 VPWR VGND sg13cmos5l_decap_8
XFILLER_106_78 VPWR VGND sg13cmos5l_fill_2
XFILLER_470_49 VPWR VGND sg13cmos5l_decap_8
XFILLER_253_84 VPWR VGND sg13cmos5l_decap_8
XFILLER_66_49 VPWR VGND sg13cmos5l_decap_8
XFILLER_257_172 VPWR VGND sg13cmos5l_decap_8
XFILLER_446_272 VPWR VGND sg13cmos5l_fill_1
XFILLER_403_43 VPWR VGND sg13cmos5l_decap_8
XFILLER_181_7 VPWR VGND sg13cmos5l_decap_8
XFILLER_279_7 VPWR VGND sg13cmos5l_decap_8
XFILLER_17_108 VPWR VGND sg13cmos5l_decap_8
XFILLER_461_220 VPWR VGND sg13cmos5l_fill_1
XFILLER_272_131 VPWR VGND sg13cmos5l_decap_8
XFILLER_272_153 VPWR VGND sg13cmos5l_decap_8
XFILLER_479_14 VPWR VGND sg13cmos5l_decap_8
XFILLER_700_63 VPWR VGND sg13cmos5l_decap_8
XFILLER_25_152 VPWR VGND sg13cmos5l_decap_8
XFILLER_709_126 VPWR VGND sg13cmos5l_decap_8
XFILLER_15_42 VPWR VGND sg13cmos5l_decap_8
XFILLER_629_28 VPWR VGND sg13cmos5l_decap_8
XFILLER_709_137 VPWR VGND sg13cmos5l_fill_1
XFILLER_359_268 VPWR VGND sg13cmos5l_decap_4
XFILLER_185_105 VPWR VGND sg13cmos5l_decap_8
XFILLER_575_154 VPWR VGND sg13cmos5l_decap_8
XFILLER_559_91 VPWR VGND sg13cmos5l_decap_8
XANTENNA__2922__X Tile_X0Y8_E2BEG[6] VPWR VGND sg13cmos5l_antennanp
XFILLER_613_7 VPWR VGND sg13cmos5l_decap_8
XFILLER_495_35 VPWR VGND sg13cmos5l_decap_8
XFILLER_278_70 VPWR VGND sg13cmos5l_decap_8
XFILLER_40_177 VPWR VGND sg13cmos5l_decap_8
XFILLER_374_238 VPWR VGND sg13cmos5l_decap_8
XFILLER_327_4 VPWR VGND sg13cmos5l_fill_1
XFILLER_516_221 VPWR VGND sg13cmos5l_decap_8
XFILLER_717_181 VPWR VGND sg13cmos5l_decap_8
XFILLER_717_192 VPWR VGND sg13cmos5l_fill_1
XFILLER_516_232 VPWR VGND sg13cmos5l_fill_1
XFILLER_327_154 VPWR VGND sg13cmos5l_decap_8
XFILLER_193_171 VPWR VGND sg13cmos5l_decap_4
XFILLER_126_227 VPWR VGND sg13cmos5l_decap_8
XFILLER_645_49 VPWR VGND sg13cmos5l_decap_8
XFILLER_428_84 VPWR VGND sg13cmos5l_decap_8
XFILLER_531_235 VPWR VGND sg13cmos5l_decap_8
XFILLER_364_28 VPWR VGND sg13cmos5l_decap_8
XFILLER_147_63 VPWR VGND sg13cmos5l_decap_8
XFILLER_488_128 VPWR VGND sg13cmos5l_decap_4
XFILLER_342_146 VPWR VGND sg13cmos5l_decap_8
XANTENNA__3753__X AXI_M_SOC_ARADDR25 VPWR VGND sg13cmos5l_antennanp
XFILLER_103_0 VPWR VGND sg13cmos5l_decap_8
XFILLER_294_91 VPWR VGND sg13cmos5l_decap_8
XFILLER_531_268 VPWR VGND sg13cmos5l_decap_4
XFILLER_685_250 VPWR VGND sg13cmos5l_decap_8
XFILLER_496_161 VPWR VGND sg13cmos5l_decap_8
XFILLER_429_217 VPWR VGND sg13cmos5l_decap_8
XFILLER_295_234 VPWR VGND sg13cmos5l_decap_8
XFILLER_295_245 VPWR VGND sg13cmos5l_fill_2
XFILLER_645_147 VPWR VGND sg13cmos5l_decap_8
XFILLER_380_49 VPWR VGND sg13cmos5l_fill_1
XFILLER_163_95 VPWR VGND sg13cmos5l_decap_8
XFILLER_313_21 VPWR VGND sg13cmos5l_decap_8
XFILLER_472_0 VPWR VGND sg13cmos5l_decap_8
XFILLER_437_261 VPWR VGND sg13cmos5l_fill_1
XFILLER_313_32 VPWR VGND sg13cmos5l_fill_2
XFILLER_437_272 VPWR VGND sg13cmos5l_fill_1
XFILLER_48_255 VPWR VGND sg13cmos5l_decap_8
XFILLER_460_60 VPWR VGND sg13cmos5l_decap_8
XFILLER_56_60 VPWR VGND sg13cmos5l_decap_4
XFILLER_263_153 VPWR VGND sg13cmos5l_decap_8
XFILLER_389_14 VPWR VGND sg13cmos5l_decap_8
XFILLER_610_63 VPWR VGND sg13cmos5l_decap_4
XFILLER_412_139 VPWR VGND sg13cmos5l_decap_8
XFILLER_539_28 VPWR VGND sg13cmos5l_decap_8
XFILLER_16_196 VPWR VGND sg13cmos5l_decap_8
XFILLER_72_70 VPWR VGND sg13cmos5l_decap_8
XFILLER_566_154 VPWR VGND sg13cmos5l_decap_8
XANTENNA__2832__X Tile_X0Y6_E1BEG[1] VPWR VGND sg13cmos5l_antennanp
X_2810_ Tile_X0Y3_E2BEG[0] _4148_/X VPWR VGND sg13cmos5l_buf_1
XFILLER_365_205 VPWR VGND sg13cmos5l_decap_8
X_3790_ _3790_/X Tile_X0Y0_W2MID[1] Tile_X0Y0_W2END[1] Tile_X0Y0_W6END[1] _3854_/X
+ _1157_/Q _1156_/Q VPWR VGND sg13cmos5l_mux4_1
XFILLER_31_177 VPWR VGND sg13cmos5l_decap_8
XFILLER_365_249 VPWR VGND sg13cmos5l_fill_2
X_2741_ Tile_X0Y3_UserCLKo Tile_X0Y3_UserCLK VPWR VGND sg13cmos5l_buf_1
XFILLER_318_132 VPWR VGND sg13cmos5l_decap_8
XFILLER_555_16 VPWR VGND sg13cmos5l_decap_8
XFILLER_581_168 VPWR VGND sg13cmos5l_decap_8
XFILLER_581_179 VPWR VGND sg13cmos5l_fill_2
X_2672_ _2672_/Q Tile_X0Y6_FrameData[23] VGND VPWR Tile_X0Y9_FrameStrobe[7] latch
XFILLER_485_90 VPWR VGND sg13cmos5l_decap_4
XFILLER_479_106 VPWR VGND sg13cmos5l_decap_8
X_4411_ _4411_/X AXI_M_SOC_RRESP1 _4455_/X _4459_/X _4434_/X _2281_/Q _2280_/Q VPWR
+ VGND sg13cmos5l_mux4_1
X_1623_ _1623_/Q Tile_X0Y2_FrameData[26] VGND VPWR Tile_X0Y9_FrameStrobe[6] latch
XFILLER_274_28 VPWR VGND sg13cmos5l_decap_8
XFILLER_522_246 VPWR VGND sg13cmos5l_decap_8
XANTENNA__3663__X AXI_M_SOC_AWADDR24 VPWR VGND sg13cmos5l_antennanp
XFILLER_132_208 VPWR VGND sg13cmos5l_decap_8
XFILLER_522_257 VPWR VGND sg13cmos5l_decap_8
XFILLER_522_268 VPWR VGND sg13cmos5l_decap_4
X_4342_ _4342_/X _4308_/X _0160_/X _4307_/X _0110_/X _1969_/Q _1968_/Q VPWR VGND sg13cmos5l_mux4_1
X_1554_ _1554_/Q Tile_X0Y2_FrameData[31] VGND VPWR Tile_X0Y9_FrameStrobe[4] latch
XFILLER_98_133 VPWR VGND sg13cmos5l_decap_8
XFILLER_207_77 VPWR VGND sg13cmos5l_decap_8
X_0505_ _0505_/Q Tile_X0Y8_FrameData[6] VGND VPWR Tile_X0Y9_FrameStrobe[2] latch
X_1485_ _1485_/Q Tile_X0Y2_FrameData[4] VGND VPWR Tile_X0Y9_FrameStrobe[1] latch
X_4273_ _4273_/X Tile_X0Y4_WW4END[14] AXI_M_SOC_BRESP1 _4350_/X _4314_/X _2067_/Q
+ _2066_/Q VPWR VGND sg13cmos5l_mux4_1
XFILLER_286_245 VPWR VGND sg13cmos5l_decap_8
XFILLER_504_42 VPWR VGND sg13cmos5l_decap_8
X_0436_ _0436_/Q Tile_X0Y8_FrameData[11] VGND VPWR Tile_X0Y9_FrameStrobe[0] latch
X_3224_ Tile_X0Y0_FrameStrobe_O[12] Tile_X0Y9_FrameStrobe[12] VPWR VGND sg13cmos5l_buf_1
XFILLER_636_147 VPWR VGND sg13cmos5l_decap_8
.ends
