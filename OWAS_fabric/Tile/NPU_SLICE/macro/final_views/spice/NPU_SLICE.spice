* NGSPICE file created from NPU_SLICE.ext - technology: ihp-sg13cmos5l

* Black-box entry subcircuit for latch abstract view
.subckt latch Q D VSS VDD GATE
.ends

* Black-box entry subcircuit for sg13cmos5l_decap_8 abstract view
.subckt sg13cmos5l_decap_8 VDD VSS
.ends

* Black-box entry subcircuit for sg13cmos5l_decap_4 abstract view
.subckt sg13cmos5l_decap_4 VDD VSS
.ends

* Black-box entry subcircuit for sg13cmos5l_fill_2 abstract view
.subckt sg13cmos5l_fill_2 VDD VSS
.ends

* Black-box entry subcircuit for sg13cmos5l_fill_1 abstract view
.subckt sg13cmos5l_fill_1 VDD VSS
.ends

* Black-box entry subcircuit for sg13cmos5l_antennanp abstract view
.subckt sg13cmos5l_antennanp A VDD VSS
.ends

* Black-box entry subcircuit for sg13cmos5l_mux2_1 abstract view
.subckt sg13cmos5l_mux2_1 X A0 A1 S VDD VSS
.ends

* Black-box entry subcircuit for sg13cmos5l_mux4_1 abstract view
.subckt sg13cmos5l_mux4_1 X A0 A1 A2 A3 S0 S1 VDD VSS
.ends

* Black-box entry subcircuit for sg13cmos5l_buf_1 abstract view
.subckt sg13cmos5l_buf_1 X A VDD VSS
.ends

* Black-box entry subcircuit for sg13cmos5l_tiehi abstract view
.subckt sg13cmos5l_tiehi L_HI VDD VSS
.ends

* Black-box entry subcircuit for sg13cmos5l_dfrbpq_1 abstract view
.subckt sg13cmos5l_dfrbpq_1 Q CLK D RESET_B VDD VSS
.ends

* Black-box entry subcircuit for sg13cmos5l_tielo abstract view
.subckt sg13cmos5l_tielo L_LO VDD VSS
.ends

* Black-box entry subcircuit for sg13cmos5l_or2_1 abstract view
.subckt sg13cmos5l_or2_1 X A B VDD VSS
.ends

* Black-box entry subcircuit for sg13cmos5l_nor2b_1 abstract view
.subckt sg13cmos5l_nor2b_1 Y A B_N VDD VSS
.ends

.subckt NPU_SLICE FAB_USER_CLK NPU_ACT_ADDR0 NPU_ACT_ADDR1 NPU_ACT_ADDR2 NPU_ACT_ADDR3
+ NPU_ACT_ADDR4 NPU_ACT_ADDR5 NPU_ACT_ADDR6 NPU_ACT_ADDR7 NPU_ACT_ADDR8 NPU_ACT_RDATA0
+ NPU_ACT_RDATA1 NPU_ACT_RDATA2 NPU_ACT_RDATA3 NPU_ACT_RDATA4 NPU_ACT_RDATA5 NPU_ACT_RDATA6
+ NPU_ACT_RDATA7 NPU_ACT_WDATA0 NPU_ACT_WDATA1 NPU_ACT_WDATA2 NPU_ACT_WDATA3 NPU_ACT_WDATA4
+ NPU_ACT_WDATA5 NPU_ACT_WDATA6 NPU_ACT_WDATA7 NPU_ACT_WE NPU_OUT_ACT0 NPU_OUT_ACT1
+ NPU_OUT_ACT2 NPU_OUT_ACT3 NPU_OUT_ACT4 NPU_OUT_ACT5 NPU_OUT_ACT6 NPU_OUT_ACT7 NPU_WEIGHT_IN0
+ NPU_WEIGHT_IN1 NPU_WEIGHT_IN2 NPU_WEIGHT_IN3 NPU_WEIGHT_IN4 NPU_WEIGHT_IN5 NPU_WEIGHT_IN6
+ NPU_WEIGHT_IN7 NPU_WEIGHT_SHIFT_EN NPU_XBAR_SEL0 NPU_XBAR_SEL1 NPU_XBAR_SEL2 NPU_XBAR_SEL3
+ Tile_X0Y0_E1END[0] Tile_X0Y0_E1END[1] Tile_X0Y0_E1END[2] Tile_X0Y0_E1END[3] Tile_X0Y0_E2END[0]
+ Tile_X0Y0_E2END[1] Tile_X0Y0_E2END[2] Tile_X0Y0_E2END[3] Tile_X0Y0_E2END[4] Tile_X0Y0_E2END[5]
+ Tile_X0Y0_E2END[6] Tile_X0Y0_E2END[7] Tile_X0Y0_E2MID[0] Tile_X0Y0_E2MID[1] Tile_X0Y0_E2MID[2]
+ Tile_X0Y0_E2MID[3] Tile_X0Y0_E2MID[4] Tile_X0Y0_E2MID[5] Tile_X0Y0_E2MID[6] Tile_X0Y0_E2MID[7]
+ Tile_X0Y0_E6END[0] Tile_X0Y0_E6END[10] Tile_X0Y0_E6END[11] Tile_X0Y0_E6END[1] Tile_X0Y0_E6END[2]
+ Tile_X0Y0_E6END[3] Tile_X0Y0_E6END[4] Tile_X0Y0_E6END[5] Tile_X0Y0_E6END[6] Tile_X0Y0_E6END[7]
+ Tile_X0Y0_E6END[8] Tile_X0Y0_E6END[9] Tile_X0Y0_EE4END[0] Tile_X0Y0_EE4END[10] Tile_X0Y0_EE4END[11]
+ Tile_X0Y0_EE4END[12] Tile_X0Y0_EE4END[13] Tile_X0Y0_EE4END[14] Tile_X0Y0_EE4END[15]
+ Tile_X0Y0_EE4END[1] Tile_X0Y0_EE4END[2] Tile_X0Y0_EE4END[3] Tile_X0Y0_EE4END[4]
+ Tile_X0Y0_EE4END[5] Tile_X0Y0_EE4END[6] Tile_X0Y0_EE4END[7] Tile_X0Y0_EE4END[8]
+ Tile_X0Y0_EE4END[9] Tile_X0Y0_FrameData[0] Tile_X0Y0_FrameData[10] Tile_X0Y0_FrameData[11]
+ Tile_X0Y0_FrameData[12] Tile_X0Y0_FrameData[13] Tile_X0Y0_FrameData[14] Tile_X0Y0_FrameData[15]
+ Tile_X0Y0_FrameData[16] Tile_X0Y0_FrameData[17] Tile_X0Y0_FrameData[18] Tile_X0Y0_FrameData[19]
+ Tile_X0Y0_FrameData[1] Tile_X0Y0_FrameData[20] Tile_X0Y0_FrameData[21] Tile_X0Y0_FrameData[22]
+ Tile_X0Y0_FrameData[23] Tile_X0Y0_FrameData[24] Tile_X0Y0_FrameData[25] Tile_X0Y0_FrameData[26]
+ Tile_X0Y0_FrameData[27] Tile_X0Y0_FrameData[28] Tile_X0Y0_FrameData[29] Tile_X0Y0_FrameData[2]
+ Tile_X0Y0_FrameData[30] Tile_X0Y0_FrameData[31] Tile_X0Y0_FrameData[3] Tile_X0Y0_FrameData[4]
+ Tile_X0Y0_FrameData[5] Tile_X0Y0_FrameData[6] Tile_X0Y0_FrameData[7] Tile_X0Y0_FrameData[8]
+ Tile_X0Y0_FrameData[9] Tile_X0Y0_FrameData_O[0] Tile_X0Y0_FrameData_O[10] Tile_X0Y0_FrameData_O[11]
+ Tile_X0Y0_FrameData_O[12] Tile_X0Y0_FrameData_O[13] Tile_X0Y0_FrameData_O[14] Tile_X0Y0_FrameData_O[15]
+ Tile_X0Y0_FrameData_O[16] Tile_X0Y0_FrameData_O[17] Tile_X0Y0_FrameData_O[18] Tile_X0Y0_FrameData_O[19]
+ Tile_X0Y0_FrameData_O[1] Tile_X0Y0_FrameData_O[20] Tile_X0Y0_FrameData_O[21] Tile_X0Y0_FrameData_O[22]
+ Tile_X0Y0_FrameData_O[23] Tile_X0Y0_FrameData_O[24] Tile_X0Y0_FrameData_O[25] Tile_X0Y0_FrameData_O[26]
+ Tile_X0Y0_FrameData_O[27] Tile_X0Y0_FrameData_O[28] Tile_X0Y0_FrameData_O[29] Tile_X0Y0_FrameData_O[2]
+ Tile_X0Y0_FrameData_O[30] Tile_X0Y0_FrameData_O[31] Tile_X0Y0_FrameData_O[3] Tile_X0Y0_FrameData_O[4]
+ Tile_X0Y0_FrameData_O[5] Tile_X0Y0_FrameData_O[6] Tile_X0Y0_FrameData_O[7] Tile_X0Y0_FrameData_O[8]
+ Tile_X0Y0_FrameData_O[9] Tile_X0Y0_FrameStrobe_O[0] Tile_X0Y0_FrameStrobe_O[10]
+ Tile_X0Y0_FrameStrobe_O[11] Tile_X0Y0_FrameStrobe_O[12] Tile_X0Y0_FrameStrobe_O[13]
+ Tile_X0Y0_FrameStrobe_O[14] Tile_X0Y0_FrameStrobe_O[15] Tile_X0Y0_FrameStrobe_O[16]
+ Tile_X0Y0_FrameStrobe_O[17] Tile_X0Y0_FrameStrobe_O[18] Tile_X0Y0_FrameStrobe_O[19]
+ Tile_X0Y0_FrameStrobe_O[1] Tile_X0Y0_FrameStrobe_O[2] Tile_X0Y0_FrameStrobe_O[3]
+ Tile_X0Y0_FrameStrobe_O[4] Tile_X0Y0_FrameStrobe_O[5] Tile_X0Y0_FrameStrobe_O[6]
+ Tile_X0Y0_FrameStrobe_O[7] Tile_X0Y0_FrameStrobe_O[8] Tile_X0Y0_FrameStrobe_O[9]
+ Tile_X0Y0_N1BEG[0] Tile_X0Y0_N1BEG[1] Tile_X0Y0_N1BEG[2] Tile_X0Y0_N1BEG[3] Tile_X0Y0_N2BEG[0]
+ Tile_X0Y0_N2BEG[1] Tile_X0Y0_N2BEG[2] Tile_X0Y0_N2BEG[3] Tile_X0Y0_N2BEG[4] Tile_X0Y0_N2BEG[5]
+ Tile_X0Y0_N2BEG[6] Tile_X0Y0_N2BEG[7] Tile_X0Y0_N2BEGb[0] Tile_X0Y0_N2BEGb[1] Tile_X0Y0_N2BEGb[2]
+ Tile_X0Y0_N2BEGb[3] Tile_X0Y0_N2BEGb[4] Tile_X0Y0_N2BEGb[5] Tile_X0Y0_N2BEGb[6]
+ Tile_X0Y0_N2BEGb[7] Tile_X0Y0_N4BEG[0] Tile_X0Y0_N4BEG[10] Tile_X0Y0_N4BEG[11] Tile_X0Y0_N4BEG[12]
+ Tile_X0Y0_N4BEG[13] Tile_X0Y0_N4BEG[14] Tile_X0Y0_N4BEG[15] Tile_X0Y0_N4BEG[1] Tile_X0Y0_N4BEG[2]
+ Tile_X0Y0_N4BEG[3] Tile_X0Y0_N4BEG[4] Tile_X0Y0_N4BEG[5] Tile_X0Y0_N4BEG[6] Tile_X0Y0_N4BEG[7]
+ Tile_X0Y0_N4BEG[8] Tile_X0Y0_N4BEG[9] Tile_X0Y0_S1END[0] Tile_X0Y0_S1END[1] Tile_X0Y0_S1END[2]
+ Tile_X0Y0_S1END[3] Tile_X0Y0_S2END[0] Tile_X0Y0_S2END[1] Tile_X0Y0_S2END[2] Tile_X0Y0_S2END[3]
+ Tile_X0Y0_S2END[4] Tile_X0Y0_S2END[5] Tile_X0Y0_S2END[6] Tile_X0Y0_S2END[7] Tile_X0Y0_S2MID[0]
+ Tile_X0Y0_S2MID[1] Tile_X0Y0_S2MID[2] Tile_X0Y0_S2MID[3] Tile_X0Y0_S2MID[4] Tile_X0Y0_S2MID[5]
+ Tile_X0Y0_S2MID[6] Tile_X0Y0_S2MID[7] Tile_X0Y0_S4END[0] Tile_X0Y0_S4END[10] Tile_X0Y0_S4END[11]
+ Tile_X0Y0_S4END[12] Tile_X0Y0_S4END[13] Tile_X0Y0_S4END[14] Tile_X0Y0_S4END[15]
+ Tile_X0Y0_S4END[1] Tile_X0Y0_S4END[2] Tile_X0Y0_S4END[3] Tile_X0Y0_S4END[4] Tile_X0Y0_S4END[5]
+ Tile_X0Y0_S4END[6] Tile_X0Y0_S4END[7] Tile_X0Y0_S4END[8] Tile_X0Y0_S4END[9] Tile_X0Y0_UserCLK
+ Tile_X0Y0_UserCLKo Tile_X0Y0_W1BEG[0] Tile_X0Y0_W1BEG[1] Tile_X0Y0_W1BEG[2] Tile_X0Y0_W1BEG[3]
+ Tile_X0Y0_W2BEG[0] Tile_X0Y0_W2BEG[1] Tile_X0Y0_W2BEG[2] Tile_X0Y0_W2BEG[3] Tile_X0Y0_W2BEG[4]
+ Tile_X0Y0_W2BEG[5] Tile_X0Y0_W2BEG[6] Tile_X0Y0_W2BEG[7] Tile_X0Y0_W2BEGb[0] Tile_X0Y0_W2BEGb[1]
+ Tile_X0Y0_W2BEGb[2] Tile_X0Y0_W2BEGb[3] Tile_X0Y0_W2BEGb[4] Tile_X0Y0_W2BEGb[5]
+ Tile_X0Y0_W2BEGb[6] Tile_X0Y0_W2BEGb[7] Tile_X0Y0_W6BEG[0] Tile_X0Y0_W6BEG[10] Tile_X0Y0_W6BEG[11]
+ Tile_X0Y0_W6BEG[1] Tile_X0Y0_W6BEG[2] Tile_X0Y0_W6BEG[3] Tile_X0Y0_W6BEG[4] Tile_X0Y0_W6BEG[5]
+ Tile_X0Y0_W6BEG[6] Tile_X0Y0_W6BEG[7] Tile_X0Y0_W6BEG[8] Tile_X0Y0_W6BEG[9] Tile_X0Y0_WW4BEG[0]
+ Tile_X0Y0_WW4BEG[10] Tile_X0Y0_WW4BEG[11] Tile_X0Y0_WW4BEG[12] Tile_X0Y0_WW4BEG[13]
+ Tile_X0Y0_WW4BEG[14] Tile_X0Y0_WW4BEG[15] Tile_X0Y0_WW4BEG[1] Tile_X0Y0_WW4BEG[2]
+ Tile_X0Y0_WW4BEG[3] Tile_X0Y0_WW4BEG[4] Tile_X0Y0_WW4BEG[5] Tile_X0Y0_WW4BEG[6]
+ Tile_X0Y0_WW4BEG[7] Tile_X0Y0_WW4BEG[8] Tile_X0Y0_WW4BEG[9] Tile_X0Y1_E1END[0] Tile_X0Y1_E1END[1]
+ Tile_X0Y1_E1END[2] Tile_X0Y1_E1END[3] Tile_X0Y1_E2END[0] Tile_X0Y1_E2END[1] Tile_X0Y1_E2END[2]
+ Tile_X0Y1_E2END[3] Tile_X0Y1_E2END[4] Tile_X0Y1_E2END[5] Tile_X0Y1_E2END[6] Tile_X0Y1_E2END[7]
+ Tile_X0Y1_E2MID[0] Tile_X0Y1_E2MID[1] Tile_X0Y1_E2MID[2] Tile_X0Y1_E2MID[3] Tile_X0Y1_E2MID[4]
+ Tile_X0Y1_E2MID[5] Tile_X0Y1_E2MID[6] Tile_X0Y1_E2MID[7] Tile_X0Y1_E6END[0] Tile_X0Y1_E6END[10]
+ Tile_X0Y1_E6END[11] Tile_X0Y1_E6END[1] Tile_X0Y1_E6END[2] Tile_X0Y1_E6END[3] Tile_X0Y1_E6END[4]
+ Tile_X0Y1_E6END[5] Tile_X0Y1_E6END[6] Tile_X0Y1_E6END[7] Tile_X0Y1_E6END[8] Tile_X0Y1_E6END[9]
+ Tile_X0Y1_EE4END[0] Tile_X0Y1_EE4END[10] Tile_X0Y1_EE4END[11] Tile_X0Y1_EE4END[12]
+ Tile_X0Y1_EE4END[13] Tile_X0Y1_EE4END[14] Tile_X0Y1_EE4END[15] Tile_X0Y1_EE4END[1]
+ Tile_X0Y1_EE4END[2] Tile_X0Y1_EE4END[3] Tile_X0Y1_EE4END[4] Tile_X0Y1_EE4END[5]
+ Tile_X0Y1_EE4END[6] Tile_X0Y1_EE4END[7] Tile_X0Y1_EE4END[8] Tile_X0Y1_EE4END[9]
+ Tile_X0Y1_FrameData[0] Tile_X0Y1_FrameData[10] Tile_X0Y1_FrameData[11] Tile_X0Y1_FrameData[12]
+ Tile_X0Y1_FrameData[13] Tile_X0Y1_FrameData[14] Tile_X0Y1_FrameData[15] Tile_X0Y1_FrameData[16]
+ Tile_X0Y1_FrameData[17] Tile_X0Y1_FrameData[18] Tile_X0Y1_FrameData[19] Tile_X0Y1_FrameData[1]
+ Tile_X0Y1_FrameData[20] Tile_X0Y1_FrameData[21] Tile_X0Y1_FrameData[22] Tile_X0Y1_FrameData[23]
+ Tile_X0Y1_FrameData[24] Tile_X0Y1_FrameData[25] Tile_X0Y1_FrameData[26] Tile_X0Y1_FrameData[27]
+ Tile_X0Y1_FrameData[28] Tile_X0Y1_FrameData[29] Tile_X0Y1_FrameData[2] Tile_X0Y1_FrameData[30]
+ Tile_X0Y1_FrameData[31] Tile_X0Y1_FrameData[3] Tile_X0Y1_FrameData[4] Tile_X0Y1_FrameData[5]
+ Tile_X0Y1_FrameData[6] Tile_X0Y1_FrameData[7] Tile_X0Y1_FrameData[8] Tile_X0Y1_FrameData[9]
+ Tile_X0Y1_FrameData_O[0] Tile_X0Y1_FrameData_O[10] Tile_X0Y1_FrameData_O[11] Tile_X0Y1_FrameData_O[12]
+ Tile_X0Y1_FrameData_O[13] Tile_X0Y1_FrameData_O[14] Tile_X0Y1_FrameData_O[15] Tile_X0Y1_FrameData_O[16]
+ Tile_X0Y1_FrameData_O[17] Tile_X0Y1_FrameData_O[18] Tile_X0Y1_FrameData_O[19] Tile_X0Y1_FrameData_O[1]
+ Tile_X0Y1_FrameData_O[20] Tile_X0Y1_FrameData_O[21] Tile_X0Y1_FrameData_O[22] Tile_X0Y1_FrameData_O[23]
+ Tile_X0Y1_FrameData_O[24] Tile_X0Y1_FrameData_O[25] Tile_X0Y1_FrameData_O[26] Tile_X0Y1_FrameData_O[27]
+ Tile_X0Y1_FrameData_O[28] Tile_X0Y1_FrameData_O[29] Tile_X0Y1_FrameData_O[2] Tile_X0Y1_FrameData_O[30]
+ Tile_X0Y1_FrameData_O[31] Tile_X0Y1_FrameData_O[3] Tile_X0Y1_FrameData_O[4] Tile_X0Y1_FrameData_O[5]
+ Tile_X0Y1_FrameData_O[6] Tile_X0Y1_FrameData_O[7] Tile_X0Y1_FrameData_O[8] Tile_X0Y1_FrameData_O[9]
+ Tile_X0Y1_FrameStrobe[0] Tile_X0Y1_FrameStrobe[10] Tile_X0Y1_FrameStrobe[11] Tile_X0Y1_FrameStrobe[12]
+ Tile_X0Y1_FrameStrobe[13] Tile_X0Y1_FrameStrobe[14] Tile_X0Y1_FrameStrobe[15] Tile_X0Y1_FrameStrobe[16]
+ Tile_X0Y1_FrameStrobe[17] Tile_X0Y1_FrameStrobe[18] Tile_X0Y1_FrameStrobe[19] Tile_X0Y1_FrameStrobe[1]
+ Tile_X0Y1_FrameStrobe[2] Tile_X0Y1_FrameStrobe[3] Tile_X0Y1_FrameStrobe[4] Tile_X0Y1_FrameStrobe[5]
+ Tile_X0Y1_FrameStrobe[6] Tile_X0Y1_FrameStrobe[7] Tile_X0Y1_FrameStrobe[8] Tile_X0Y1_FrameStrobe[9]
+ Tile_X0Y1_N1END[0] Tile_X0Y1_N1END[1] Tile_X0Y1_N1END[2] Tile_X0Y1_N1END[3] Tile_X0Y1_N2END[0]
+ Tile_X0Y1_N2END[1] Tile_X0Y1_N2END[2] Tile_X0Y1_N2END[3] Tile_X0Y1_N2END[4] Tile_X0Y1_N2END[5]
+ Tile_X0Y1_N2END[6] Tile_X0Y1_N2END[7] Tile_X0Y1_N2MID[0] Tile_X0Y1_N2MID[1] Tile_X0Y1_N2MID[2]
+ Tile_X0Y1_N2MID[3] Tile_X0Y1_N2MID[4] Tile_X0Y1_N2MID[5] Tile_X0Y1_N2MID[6] Tile_X0Y1_N2MID[7]
+ Tile_X0Y1_N4END[0] Tile_X0Y1_N4END[10] Tile_X0Y1_N4END[11] Tile_X0Y1_N4END[12] Tile_X0Y1_N4END[13]
+ Tile_X0Y1_N4END[14] Tile_X0Y1_N4END[15] Tile_X0Y1_N4END[1] Tile_X0Y1_N4END[2] Tile_X0Y1_N4END[3]
+ Tile_X0Y1_N4END[4] Tile_X0Y1_N4END[5] Tile_X0Y1_N4END[6] Tile_X0Y1_N4END[7] Tile_X0Y1_N4END[8]
+ Tile_X0Y1_N4END[9] Tile_X0Y1_S1BEG[0] Tile_X0Y1_S1BEG[1] Tile_X0Y1_S1BEG[2] Tile_X0Y1_S1BEG[3]
+ Tile_X0Y1_S2BEG[0] Tile_X0Y1_S2BEG[1] Tile_X0Y1_S2BEG[2] Tile_X0Y1_S2BEG[3] Tile_X0Y1_S2BEG[4]
+ Tile_X0Y1_S2BEG[5] Tile_X0Y1_S2BEG[6] Tile_X0Y1_S2BEG[7] Tile_X0Y1_S2BEGb[0] Tile_X0Y1_S2BEGb[1]
+ Tile_X0Y1_S2BEGb[2] Tile_X0Y1_S2BEGb[3] Tile_X0Y1_S2BEGb[4] Tile_X0Y1_S2BEGb[5]
+ Tile_X0Y1_S2BEGb[6] Tile_X0Y1_S2BEGb[7] Tile_X0Y1_S4BEG[0] Tile_X0Y1_S4BEG[10] Tile_X0Y1_S4BEG[11]
+ Tile_X0Y1_S4BEG[12] Tile_X0Y1_S4BEG[13] Tile_X0Y1_S4BEG[14] Tile_X0Y1_S4BEG[15]
+ Tile_X0Y1_S4BEG[1] Tile_X0Y1_S4BEG[2] Tile_X0Y1_S4BEG[3] Tile_X0Y1_S4BEG[4] Tile_X0Y1_S4BEG[5]
+ Tile_X0Y1_S4BEG[6] Tile_X0Y1_S4BEG[7] Tile_X0Y1_S4BEG[8] Tile_X0Y1_S4BEG[9] Tile_X0Y1_UserCLK
+ Tile_X0Y1_UserCLKo Tile_X0Y1_W1BEG[0] Tile_X0Y1_W1BEG[1] Tile_X0Y1_W1BEG[2] Tile_X0Y1_W1BEG[3]
+ Tile_X0Y1_W2BEG[0] Tile_X0Y1_W2BEG[1] Tile_X0Y1_W2BEG[2] Tile_X0Y1_W2BEG[3] Tile_X0Y1_W2BEG[4]
+ Tile_X0Y1_W2BEG[5] Tile_X0Y1_W2BEG[6] Tile_X0Y1_W2BEG[7] Tile_X0Y1_W2BEGb[0] Tile_X0Y1_W2BEGb[1]
+ Tile_X0Y1_W2BEGb[2] Tile_X0Y1_W2BEGb[3] Tile_X0Y1_W2BEGb[4] Tile_X0Y1_W2BEGb[5]
+ Tile_X0Y1_W2BEGb[6] Tile_X0Y1_W2BEGb[7] Tile_X0Y1_W6BEG[0] Tile_X0Y1_W6BEG[10] Tile_X0Y1_W6BEG[11]
+ Tile_X0Y1_W6BEG[1] Tile_X0Y1_W6BEG[2] Tile_X0Y1_W6BEG[3] Tile_X0Y1_W6BEG[4] Tile_X0Y1_W6BEG[5]
+ Tile_X0Y1_W6BEG[6] Tile_X0Y1_W6BEG[7] Tile_X0Y1_W6BEG[8] Tile_X0Y1_W6BEG[9] Tile_X0Y1_WW4BEG[0]
+ Tile_X0Y1_WW4BEG[10] Tile_X0Y1_WW4BEG[11] Tile_X0Y1_WW4BEG[12] Tile_X0Y1_WW4BEG[13]
+ Tile_X0Y1_WW4BEG[14] Tile_X0Y1_WW4BEG[15] Tile_X0Y1_WW4BEG[1] Tile_X0Y1_WW4BEG[2]
+ Tile_X0Y1_WW4BEG[3] Tile_X0Y1_WW4BEG[4] Tile_X0Y1_WW4BEG[5] Tile_X0Y1_WW4BEG[6]
+ Tile_X0Y1_WW4BEG[7] Tile_X0Y1_WW4BEG[8] Tile_X0Y1_WW4BEG[9] VGND VPWR
X_0367_ _0367_/Q Tile_X0Y1_FrameData[11] VGND VPWR Tile_X0Y1_FrameStrobe[0] latch
X_0298_ _0298_/Q Tile_X0Y0_FrameData[18] VGND VPWR Tile_X0Y1_FrameStrobe[6] latch
XFILLER_22_199 VPWR VGND sg13cmos5l_decap_8
XFILLER_52_29 VPWR VGND sg13cmos5l_decap_4
XFILLER_108_238 VPWR VGND sg13cmos5l_decap_8
XFILLER_116_260 VPWR VGND sg13cmos5l_decap_8
XFILLER_116_271 VPWR VGND sg13cmos5l_fill_2
XFILLER_117_11 VPWR VGND sg13cmos5l_decap_8
XFILLER_123_219 VPWR VGND sg13cmos5l_decap_8
XFILLER_89_100 VPWR VGND sg13cmos5l_decap_8
XFILLER_117_99 VPWR VGND sg13cmos5l_decap_8
XFILLER_131_241 VPWR VGND sg13cmos5l_decap_8
XFILLER_133_21 VPWR VGND sg13cmos5l_decap_8
XFILLER_77_26 VPWR VGND sg13cmos5l_fill_1
XFILLER_133_98 VPWR VGND sg13cmos5l_decap_8
XFILLER_26_30 VPWR VGND sg13cmos5l_fill_2
XFILLER_45_203 VPWR VGND sg13cmos5l_decap_8
XFILLER_60_206 VPWR VGND sg13cmos5l_decap_8
XANTENNA__0900__X Tile_X0Y1_S2BEGb[0] VPWR VGND sg13cmos5l_antennanp
XFILLER_107_260 VPWR VGND sg13cmos5l_decap_8
XFILLER_107_271 VPWR VGND sg13cmos5l_fill_2
XFILLER_114_219 VPWR VGND sg13cmos5l_decap_8
XFILLER_3_56 VPWR VGND sg13cmos5l_decap_8
XFILLER_67_70 VPWR VGND sg13cmos5l_decap_8
X_0221_ _0221_/Q Tile_X0Y0_FrameData[31] VGND VPWR Tile_X0Y1_FrameStrobe[4] latch
X_0152_ _0152_/Q Tile_X0Y0_FrameData[4] VGND VPWR Tile_X0Y1_FrameStrobe[1] latch
X_0083_ _0916_/A _1019_/X _1020_/X _0284_/Q VPWR VGND sg13cmos5l_mux2_1
XANTENNA__0810__X Tile_X0Y0_FrameStrobe_O[7] VPWR VGND sg13cmos5l_antennanp
XFILLER_66_0 VPWR VGND sg13cmos5l_decap_8
X_0985_ _0985_/X Tile_X0Y1_EE4END[3] Tile_X0Y1_EE4END[11] Tile_X0Y1_E6END[3] _1206_/X
+ _0428_/Q _0427_/Q VPWR VGND sg13cmos5l_mux4_1
XFILLER_113_241 VPWR VGND sg13cmos5l_decap_8
XFILLER_47_29 VPWR VGND sg13cmos5l_decap_8
XFILLER_86_169 VPWR VGND sg13cmos5l_decap_8
X_0419_ _0419_/Q Tile_X0Y1_FrameData[23] VGND VPWR Tile_X0Y1_FrameStrobe[2] latch
XFILLER_27_225 VPWR VGND sg13cmos5l_decap_8
XFILLER_63_28 VPWR VGND sg13cmos5l_decap_8
XFILLER_10_125 VPWR VGND sg13cmos5l_decap_8
XFILLER_128_21 VPWR VGND sg13cmos5l_decap_8
XANTENNA__0720__X Tile_X0Y0_W1BEG[1] VPWR VGND sg13cmos5l_antennanp
XFILLER_104_263 VPWR VGND sg13cmos5l_decap_8
XFILLER_128_98 VPWR VGND sg13cmos5l_decap_8
XFILLER_12_65 VPWR VGND sg13cmos5l_fill_1
XFILLER_88_58 VPWR VGND sg13cmos5l_decap_4
XFILLER_18_203 VPWR VGND sg13cmos5l_decap_8
XFILLER_77_136 VPWR VGND sg13cmos5l_decap_8
XFILLER_92_139 VPWR VGND sg13cmos5l_fill_2
XFILLER_41_261 VPWR VGND sg13cmos5l_decap_8
XFILLER_41_272 VPWR VGND sg13cmos5l_fill_1
XFILLER_53_72 VPWR VGND sg13cmos5l_fill_2
XFILLER_139_171 VPWR VGND sg13cmos5l_fill_2
XFILLER_5_140 VPWR VGND sg13cmos5l_decap_4
X_0770_ Tile_X0Y0_WW4BEG[3] _1050_/X VPWR VGND sg13cmos5l_buf_1
XFILLER_110_266 VPWR VGND sg13cmos5l_decap_8
XFILLER_5_184 VPWR VGND sg13cmos5l_decap_4
XFILLER_83_128 VPWR VGND sg13cmos5l_decap_8
X_1184_ _1184_/X _0649_/Q _1209_/X _1213_/X _1196_/X _0448_/Q _0447_/Q VPWR VGND sg13cmos5l_mux4_1
X_0204_ _0204_/Q Tile_X0Y0_FrameData[16] VGND VPWR Tile_X0Y1_FrameStrobe[3] latch
X_0135_ _0135_/Q Tile_X0Y0_FrameData[21] VGND VPWR Tile_X0Y1_FrameStrobe[1] latch
XFILLER_91_161 VPWR VGND sg13cmos5l_fill_2
XANTENNA__0805__X Tile_X0Y0_FrameStrobe_O[2] VPWR VGND sg13cmos5l_antennanp
XFILLER_137_119 VPWR VGND sg13cmos5l_decap_8
X_0968_ Tile_X0Y1_WW4BEG[11] _1174_/X VPWR VGND sg13cmos5l_buf_1
XFILLER_58_28 VPWR VGND sg13cmos5l_decap_8
X_0899_ Tile_X0Y1_S2BEG[7] _1134_/X VPWR VGND sg13cmos5l_buf_1
XFILLER_99_272 VPWR VGND sg13cmos5l_fill_1
XFILLER_59_147 VPWR VGND sg13cmos5l_decap_4
XFILLER_67_191 VPWR VGND sg13cmos5l_decap_8
XFILLER_74_49 VPWR VGND sg13cmos5l_decap_8
XFILLER_130_77 VPWR VGND sg13cmos5l_decap_8
XFILLER_23_272 VPWR VGND sg13cmos5l_fill_1
XFILLER_82_172 VPWR VGND sg13cmos5l_decap_8
XFILLER_90_48 VPWR VGND sg13cmos5l_fill_1
XFILLER_90_37 VPWR VGND sg13cmos5l_decap_8
XFILLER_90_15 VPWR VGND sg13cmos5l_fill_1
XFILLER_128_119 VPWR VGND sg13cmos5l_decap_8
XFILLER_139_53 VPWR VGND sg13cmos5l_decap_8
XFILLER_23_86 VPWR VGND sg13cmos5l_fill_2
XFILLER_99_57 VPWR VGND sg13cmos5l_fill_1
XFILLER_99_46 VPWR VGND sg13cmos5l_decap_8
XFILLER_136_196 VPWR VGND sg13cmos5l_decap_8
XFILLER_2_165 VPWR VGND sg13cmos5l_decap_8
XFILLER_48_61 VPWR VGND sg13cmos5l_decap_8
XFILLER_97_209 VPWR VGND sg13cmos5l_decap_8
XFILLER_0_35 VPWR VGND sg13cmos5l_fill_2
XFILLER_58_191 VPWR VGND sg13cmos5l_decap_8
XFILLER_73_161 VPWR VGND sg13cmos5l_decap_8
XFILLER_14_250 VPWR VGND sg13cmos5l_decap_8
XFILLER_14_261 VPWR VGND sg13cmos5l_fill_1
XFILLER_14_272 VPWR VGND sg13cmos5l_fill_1
XFILLER_80_92 VPWR VGND sg13cmos5l_decap_8
X_0822_ Tile_X0Y0_FrameStrobe_O[19] Tile_X0Y1_FrameStrobe[19] VPWR VGND sg13cmos5l_buf_1
XFILLER_9_88 VPWR VGND sg13cmos5l_decap_8
XFILLER_127_163 VPWR VGND sg13cmos5l_decap_8
XFILLER_89_90 VPWR VGND sg13cmos5l_fill_2
X_0753_ Tile_X0Y0_N4BEG[2] Tile_X0Y1_N4END[10] VPWR VGND sg13cmos5l_buf_1
X_0684_ _0684_/L_HI VPWR VGND sg13cmos5l_tiehi
XFILLER_29_0 VPWR VGND sg13cmos5l_fill_2
XFILLER_49_191 VPWR VGND sg13cmos5l_decap_8
XFILLER_96_253 VPWR VGND sg13cmos5l_decap_8
XFILLER_64_161 VPWR VGND sg13cmos5l_decap_8
X_1098_ _1098_/X _1109_/X Tile_X0Y1_N2MID[6] Tile_X0Y0_S2MID[6] Tile_X0Y0_S2END[6]
+ _0104_/Q _0103_/Q VPWR VGND sg13cmos5l_mux4_1
X_1167_ _1167_/X _0644_/Q _0648_/Q _1214_/X _1198_/X _0482_/Q _0481_/Q VPWR VGND sg13cmos5l_mux4_1
X_0118_ _0118_/Q Tile_X0Y0_FrameData[6] VGND VPWR Tile_X0Y1_FrameStrobe[0] latch
XFILLER_109_45 VPWR VGND sg13cmos5l_fill_1
XFILLER_114_8 VPWR VGND sg13cmos5l_decap_8
XFILLER_118_152 VPWR VGND sg13cmos5l_decap_8
XFILLER_20_231 VPWR VGND sg13cmos5l_fill_1
XFILLER_133_133 VPWR VGND sg13cmos5l_decap_8
XFILLER_133_199 VPWR VGND sg13cmos5l_decap_8
XFILLER_125_99 VPWR VGND sg13cmos5l_decap_4
XFILLER_18_86 VPWR VGND sg13cmos5l_decap_4
XFILLER_18_97 VPWR VGND sg13cmos5l_fill_2
XFILLER_55_150 VPWR VGND sg13cmos5l_decap_8
XFILLER_87_264 VPWR VGND sg13cmos5l_fill_1
XFILLER_11_253 VPWR VGND sg13cmos5l_decap_8
XFILLER_11_264 VPWR VGND sg13cmos5l_fill_1
XFILLER_133_0 VPWR VGND sg13cmos5l_decap_8
XFILLER_34_52 VPWR VGND sg13cmos5l_fill_1
XFILLER_124_133 VPWR VGND sg13cmos5l_decap_8
XFILLER_7_268 VPWR VGND sg13cmos5l_decap_4
XFILLER_78_220 VPWR VGND sg13cmos5l_decap_8
XFILLER_93_256 VPWR VGND sg13cmos5l_decap_8
XFILLER_46_183 VPWR VGND sg13cmos5l_decap_8
XFILLER_61_153 VPWR VGND sg13cmos5l_decap_8
XFILLER_61_164 VPWR VGND sg13cmos5l_fill_1
XFILLER_61_175 VPWR VGND sg13cmos5l_decap_8
XFILLER_75_70 VPWR VGND sg13cmos5l_decap_8
X_1021_ _1021_/X Tile_X0Y0_E1END[1] Tile_X0Y0_EE4END[13] Tile_X0Y0_E6END[5] _1089_/X
+ _0283_/Q _0282_/Q VPWR VGND sg13cmos5l_mux4_1
X_0805_ Tile_X0Y0_FrameStrobe_O[2] Tile_X0Y1_FrameStrobe[2] VPWR VGND sg13cmos5l_buf_1
XFILLER_115_133 VPWR VGND sg13cmos5l_decap_8
XFILLER_130_147 VPWR VGND sg13cmos5l_decap_8
X_0736_ Tile_X0Y0_W2BEGb[5] _1044_/X VPWR VGND sg13cmos5l_buf_1
X_0667_ _0667_/L_HI VPWR VGND sg13cmos5l_tiehi
X_0598_ _0598_/Q Tile_X0Y1_FrameData[4] VGND VPWR Tile_X0Y1_FrameStrobe[7] latch
XFILLER_37_150 VPWR VGND sg13cmos5l_decap_8
XFILLER_44_109 VPWR VGND sg13cmos5l_fill_2
XFILLER_84_234 VPWR VGND sg13cmos5l_decap_8
X_1219_ _1219_/X Tile_X0Y0_E2MID[7] Tile_X0Y0_E2END[7] Tile_X0Y0_E6END[8] _1092_/X
+ _0302_/Q _0301_/Q VPWR VGND sg13cmos5l_mux4_1
XFILLER_111_35 VPWR VGND sg13cmos5l_fill_1
XFILLER_111_57 VPWR VGND sg13cmos5l_fill_2
XFILLER_138_203 VPWR VGND sg13cmos5l_decap_8
XFILLER_52_164 VPWR VGND sg13cmos5l_decap_8
XFILLER_71_28 VPWR VGND sg13cmos5l_decap_8
XFILLER_136_21 VPWR VGND sg13cmos5l_decap_8
XFILLER_4_216 VPWR VGND sg13cmos5l_decap_8
XFILLER_106_188 VPWR VGND sg13cmos5l_decap_8
XFILLER_136_98 VPWR VGND sg13cmos5l_decap_8
XFILLER_75_245 VPWR VGND sg13cmos5l_decap_8
XFILLER_90_204 VPWR VGND sg13cmos5l_decap_8
XANTENNA__0903__X Tile_X0Y1_S2BEGb[3] VPWR VGND sg13cmos5l_antennanp
XFILLER_129_225 VPWR VGND sg13cmos5l_decap_8
XANTENNA_5 Tile_X0Y0_S2MID[1] VPWR VGND sg13cmos5l_antennanp
XFILLER_112_147 VPWR VGND sg13cmos5l_decap_8
XFILLER_3_260 VPWR VGND sg13cmos5l_fill_2
XFILLER_6_56 VPWR VGND sg13cmos5l_decap_8
X_0521_ _0521_/Q Tile_X0Y1_FrameData[17] VGND VPWR Tile_X0Y1_FrameStrobe[5] latch
X_0452_ _0452_/Q Tile_X0Y1_FrameData[22] VGND VPWR Tile_X0Y1_FrameStrobe[3] latch
XFILLER_120_180 VPWR VGND sg13cmos5l_decap_8
XFILLER_19_161 VPWR VGND sg13cmos5l_decap_8
XFILLER_66_223 VPWR VGND sg13cmos5l_fill_2
XFILLER_81_204 VPWR VGND sg13cmos5l_decap_8
X_0383_ _0383_/Q Tile_X0Y1_FrameData[27] VGND VPWR Tile_X0Y1_FrameStrobe[1] latch
X_1004_ _1004_/X Tile_X0Y0_E2MID[6] Tile_X0Y0_E2END[6] Tile_X0Y0_E6END[6] _1093_/X
+ _0336_/Q _0335_/Q VPWR VGND sg13cmos5l_mux4_1
XFILLER_96_0 VPWR VGND sg13cmos5l_decap_8
XANTENNA__0813__X Tile_X0Y0_FrameStrobe_O[10] VPWR VGND sg13cmos5l_antennanp
XFILLER_106_13 VPWR VGND sg13cmos5l_fill_2
XFILLER_106_68 VPWR VGND sg13cmos5l_fill_2
XFILLER_57_212 VPWR VGND sg13cmos5l_decap_8
XFILLER_66_28 VPWR VGND sg13cmos5l_decap_8
X_0719_ Tile_X0Y0_W1BEG[0] _1027_/X VPWR VGND sg13cmos5l_buf_1
XFILLER_122_34 VPWR VGND sg13cmos5l_decap_4
XFILLER_25_120 VPWR VGND sg13cmos5l_fill_1
XFILLER_25_131 VPWR VGND sg13cmos5l_decap_8
XFILLER_72_259 VPWR VGND sg13cmos5l_decap_8
XANTENNA__0723__X Tile_X0Y0_W2BEG[0] VPWR VGND sg13cmos5l_antennanp
XFILLER_40_167 VPWR VGND sg13cmos5l_decap_8
XFILLER_48_223 VPWR VGND sg13cmos5l_decap_8
XFILLER_16_175 VPWR VGND sg13cmos5l_decap_8
XFILLER_31_101 VPWR VGND sg13cmos5l_fill_2
XFILLER_100_117 VPWR VGND sg13cmos5l_decap_8
XFILLER_100_128 VPWR VGND sg13cmos5l_fill_2
XFILLER_125_272 VPWR VGND sg13cmos5l_fill_1
XFILLER_140_242 VPWR VGND sg13cmos5l_decap_8
X_0504_ _0504_/Q Tile_X0Y1_FrameData[2] VGND VPWR Tile_X0Y1_FrameStrobe[4] latch
X_0435_ _0435_/Q Tile_X0Y1_FrameData[7] VGND VPWR Tile_X0Y1_FrameStrobe[2] latch
XANTENNA__0808__X Tile_X0Y0_FrameStrobe_O[5] VPWR VGND sg13cmos5l_antennanp
XFILLER_11_0 VPWR VGND sg13cmos5l_decap_4
XFILLER_39_245 VPWR VGND sg13cmos5l_fill_1
X_0366_ _0366_/Q Tile_X0Y1_FrameData[12] VGND VPWR Tile_X0Y1_FrameStrobe[0] latch
X_0297_ _0297_/Q Tile_X0Y0_FrameData[19] VGND VPWR Tile_X0Y1_FrameStrobe[6] latch
XFILLER_22_178 VPWR VGND sg13cmos5l_decap_8
XFILLER_108_217 VPWR VGND sg13cmos5l_decap_8
XFILLER_117_34 VPWR VGND sg13cmos5l_decap_8
XFILLER_131_220 VPWR VGND sg13cmos5l_decap_8
XANTENNA__0718__X Tile_X0Y0_UserCLKo VPWR VGND sg13cmos5l_antennanp
XFILLER_131_264 VPWR VGND sg13cmos5l_fill_1
XFILLER_133_77 VPWR VGND sg13cmos5l_decap_8
XFILLER_13_134 VPWR VGND sg13cmos5l_decap_8
XFILLER_45_259 VPWR VGND sg13cmos5l_fill_2
XFILLER_9_116 VPWR VGND sg13cmos5l_decap_8
XFILLER_13_189 VPWR VGND sg13cmos5l_decap_8
XFILLER_9_149 VPWR VGND sg13cmos5l_decap_8
XFILLER_122_253 VPWR VGND sg13cmos5l_decap_8
XFILLER_3_35 VPWR VGND sg13cmos5l_decap_8
X_0220_ _0220_/Q Tile_X0Y0_FrameData[0] VGND VPWR Tile_X0Y1_FrameStrobe[3] latch
X_0151_ _0151_/Q Tile_X0Y0_FrameData[5] VGND VPWR Tile_X0Y1_FrameStrobe[1] latch
X_0082_ _0763_/A _1011_/X _1012_/X _0320_/Q VPWR VGND sg13cmos5l_mux2_1
XFILLER_51_229 VPWR VGND sg13cmos5l_decap_8
X_0984_ _0984_/X Tile_X0Y1_EE4END[2] Tile_X0Y1_EE4END[10] Tile_X0Y1_E6END[2] _1205_/X
+ _0430_/Q _0429_/Q VPWR VGND sg13cmos5l_mux4_1
XFILLER_113_220 VPWR VGND sg13cmos5l_decap_8
XFILLER_59_0 VPWR VGND sg13cmos5l_decap_8
XFILLER_113_264 VPWR VGND sg13cmos5l_fill_1
XFILLER_27_204 VPWR VGND sg13cmos5l_decap_8
XFILLER_86_148 VPWR VGND sg13cmos5l_fill_2
X_0418_ _0418_/Q Tile_X0Y1_FrameData[24] VGND VPWR Tile_X0Y1_FrameStrobe[2] latch
X_0349_ _0349_/Q Tile_X0Y1_FrameData[29] VGND VPWR Tile_X0Y1_FrameStrobe[0] latch
XFILLER_103_47 VPWR VGND sg13cmos5l_decap_4
XFILLER_42_229 VPWR VGND sg13cmos5l_decap_8
XFILLER_94_181 VPWR VGND sg13cmos5l_decap_8
XFILLER_10_115 VPWR VGND sg13cmos5l_decap_4
XFILLER_137_7 VPWR VGND sg13cmos5l_decap_8
XFILLER_6_119 VPWR VGND sg13cmos5l_decap_8
XFILLER_104_242 VPWR VGND sg13cmos5l_decap_8
XFILLER_128_77 VPWR VGND sg13cmos5l_decap_8
XFILLER_77_115 VPWR VGND sg13cmos5l_decap_8
XFILLER_18_259 VPWR VGND sg13cmos5l_fill_2
XFILLER_85_181 VPWR VGND sg13cmos5l_decap_8
XFILLER_33_229 VPWR VGND sg13cmos5l_decap_8
XANTENNA__0911__X Tile_X0Y1_S4BEG[3] VPWR VGND sg13cmos5l_antennanp
XFILLER_139_183 VPWR VGND sg13cmos5l_decap_8
XFILLER_5_163 VPWR VGND sg13cmos5l_decap_8
XFILLER_110_245 VPWR VGND sg13cmos5l_decap_8
XFILLER_68_159 VPWR VGND sg13cmos5l_decap_8
X_0203_ _0203_/Q Tile_X0Y0_FrameData[17] VGND VPWR Tile_X0Y1_FrameStrobe[3] latch
XFILLER_24_229 VPWR VGND sg13cmos5l_decap_8
X_1183_ _1183_/X _0648_/Q _1210_/X _1214_/X _1195_/X _0450_/Q _0449_/Q VPWR VGND sg13cmos5l_mux4_1
X_0134_ _0134_/Q Tile_X0Y0_FrameData[22] VGND VPWR Tile_X0Y1_FrameStrobe[1] latch
XFILLER_91_195 VPWR VGND sg13cmos5l_decap_8
XANTENNA__0821__X Tile_X0Y0_FrameStrobe_O[18] VPWR VGND sg13cmos5l_antennanp
XFILLER_32_262 VPWR VGND sg13cmos5l_decap_8
X_0967_ Tile_X0Y1_WW4BEG[10] _1173_/X VPWR VGND sg13cmos5l_buf_1
XFILLER_101_223 VPWR VGND sg13cmos5l_decap_8
XFILLER_59_126 VPWR VGND sg13cmos5l_decap_8
X_0898_ Tile_X0Y1_S2BEG[6] _1133_/X VPWR VGND sg13cmos5l_buf_1
XFILLER_114_46 VPWR VGND sg13cmos5l_fill_2
XFILLER_67_170 VPWR VGND sg13cmos5l_decap_8
XFILLER_74_28 VPWR VGND sg13cmos5l_decap_8
XFILLER_82_151 VPWR VGND sg13cmos5l_decap_8
XFILLER_130_56 VPWR VGND sg13cmos5l_decap_8
XFILLER_139_21 VPWR VGND sg13cmos5l_decap_8
XFILLER_23_54 VPWR VGND sg13cmos5l_decap_4
XANTENNA__0731__X Tile_X0Y0_W2BEGb[0] VPWR VGND sg13cmos5l_antennanp
XFILLER_136_175 VPWR VGND sg13cmos5l_decap_8
XFILLER_99_36 VPWR VGND sg13cmos5l_fill_2
XFILLER_99_14 VPWR VGND sg13cmos5l_fill_1
XFILLER_2_144 VPWR VGND sg13cmos5l_decap_8
XANTENNA__0906__X Tile_X0Y1_S2BEGb[6] VPWR VGND sg13cmos5l_antennanp
XFILLER_0_14 VPWR VGND sg13cmos5l_decap_8
XFILLER_58_170 VPWR VGND sg13cmos5l_decap_8
XFILLER_73_140 VPWR VGND sg13cmos5l_decap_8
XFILLER_127_142 VPWR VGND sg13cmos5l_decap_8
X_0821_ Tile_X0Y0_FrameStrobe_O[18] Tile_X0Y1_FrameStrobe[18] VPWR VGND sg13cmos5l_buf_1
X_0752_ Tile_X0Y0_N4BEG[1] Tile_X0Y1_N4END[9] VPWR VGND sg13cmos5l_buf_1
XFILLER_9_67 VPWR VGND sg13cmos5l_decap_8
XFILLER_9_45 VPWR VGND sg13cmos5l_decap_8
X_0683_ _0683_/L_HI VPWR VGND sg13cmos5l_tiehi
XFILLER_49_170 VPWR VGND sg13cmos5l_decap_8
XFILLER_64_140 VPWR VGND sg13cmos5l_decap_8
X_1235_ _1235_/X Tile_X0Y0_E1END[1] Tile_X0Y0_E6END[1] _1101_/X _1235_/A3 _0152_/Q
+ _0151_/Q VPWR VGND sg13cmos5l_mux4_1
X_1166_ _1166_/X _0647_/Q _0651_/Q _1215_/X _1199_/X _0484_/Q _0483_/Q VPWR VGND sg13cmos5l_mux4_1
XFILLER_96_232 VPWR VGND sg13cmos5l_decap_8
XANTENNA__0816__X Tile_X0Y0_FrameStrobe_O[13] VPWR VGND sg13cmos5l_antennanp
XFILLER_100_15 VPWR VGND sg13cmos5l_decap_4
XFILLER_100_26 VPWR VGND sg13cmos5l_fill_1
XFILLER_20_210 VPWR VGND sg13cmos5l_decap_8
X_1097_ _1097_/X _1108_/X Tile_X0Y1_N2MID[5] Tile_X0Y0_S2MID[5] Tile_X0Y0_S2END[5]
+ _0106_/Q _0105_/Q VPWR VGND sg13cmos5l_mux4_1
X_0117_ _0117_/Q Tile_X0Y0_FrameData[7] VGND VPWR Tile_X0Y1_FrameStrobe[0] latch
XFILLER_118_131 VPWR VGND sg13cmos5l_decap_8
XFILLER_133_112 VPWR VGND sg13cmos5l_decap_8
XFILLER_69_28 VPWR VGND sg13cmos5l_decap_8
XFILLER_125_78 VPWR VGND sg13cmos5l_decap_8
XFILLER_133_178 VPWR VGND sg13cmos5l_decap_8
XFILLER_87_243 VPWR VGND sg13cmos5l_decap_8
XANTENNA__0726__X Tile_X0Y0_W2BEG[3] VPWR VGND sg13cmos5l_antennanp
XFILLER_141_77 VPWR VGND sg13cmos5l_decap_4
XFILLER_11_232 VPWR VGND sg13cmos5l_decap_8
XFILLER_126_0 VPWR VGND sg13cmos5l_decap_8
XFILLER_7_247 VPWR VGND sg13cmos5l_decap_8
XFILLER_109_186 VPWR VGND sg13cmos5l_decap_8
XFILLER_124_112 VPWR VGND sg13cmos5l_decap_8
XFILLER_124_189 VPWR VGND sg13cmos5l_decap_8
X_1020_ _1020_/X _1087_/X _1083_/X _1075_/X _1096_/X _0286_/Q _0285_/Q VPWR VGND sg13cmos5l_mux4_1
XFILLER_93_235 VPWR VGND sg13cmos5l_decap_8
XFILLER_46_162 VPWR VGND sg13cmos5l_decap_8
XFILLER_61_132 VPWR VGND sg13cmos5l_decap_8
X_0804_ Tile_X0Y0_FrameStrobe_O[1] Tile_X0Y1_FrameStrobe[1] VPWR VGND sg13cmos5l_buf_1
X_0735_ Tile_X0Y0_W2BEGb[4] _1043_/X VPWR VGND sg13cmos5l_buf_1
XFILLER_130_126 VPWR VGND sg13cmos5l_decap_8
XFILLER_41_0 VPWR VGND sg13cmos5l_fill_2
XFILLER_69_221 VPWR VGND sg13cmos5l_decap_8
XFILLER_69_232 VPWR VGND sg13cmos5l_fill_2
XFILLER_69_265 VPWR VGND sg13cmos5l_decap_8
X_0666_ _0666_/L_HI VPWR VGND sg13cmos5l_tiehi
X_0597_ _0597_/Q Tile_X0Y1_FrameData[5] VGND VPWR Tile_X0Y1_FrameStrobe[7] latch
XFILLER_1_90 VPWR VGND sg13cmos5l_fill_2
XFILLER_52_143 VPWR VGND sg13cmos5l_decap_8
XFILLER_84_213 VPWR VGND sg13cmos5l_decap_8
X_1218_ _1218_/X Tile_X0Y1_N1END[3] Tile_X0Y1_N4END[3] _1230_/X Tile_X0Y0_S4END[7]
+ _0372_/Q _0371_/Q VPWR VGND sg13cmos5l_mux4_1
X_1149_ _1149_/X Tile_X0Y1_E2END[2] _0646_/Q _1197_/X _1200_/X _0518_/Q _0517_/Q VPWR
+ VGND sg13cmos5l_mux4_1
XFILLER_138_259 VPWR VGND sg13cmos5l_decap_8
XFILLER_52_198 VPWR VGND sg13cmos5l_decap_8
XFILLER_106_167 VPWR VGND sg13cmos5l_decap_8
XFILLER_136_77 VPWR VGND sg13cmos5l_decap_8
XFILLER_20_66 VPWR VGND sg13cmos5l_fill_1
XFILLER_96_15 VPWR VGND sg13cmos5l_fill_2
XFILLER_29_97 VPWR VGND sg13cmos5l_fill_1
XFILLER_75_224 VPWR VGND sg13cmos5l_decap_8
XFILLER_43_187 VPWR VGND sg13cmos5l_decap_8
XANTENNA_6 Tile_X0Y0_S2MID[1] VPWR VGND sg13cmos5l_antennanp
XFILLER_129_204 VPWR VGND sg13cmos5l_decap_8
XFILLER_6_35 VPWR VGND sg13cmos5l_decap_8
XFILLER_112_126 VPWR VGND sg13cmos5l_decap_8
XFILLER_112_159 VPWR VGND sg13cmos5l_decap_8
XFILLER_3_272 VPWR VGND sg13cmos5l_fill_1
XFILLER_66_202 VPWR VGND sg13cmos5l_decap_8
X_0520_ _0520_/Q Tile_X0Y1_FrameData[18] VGND VPWR Tile_X0Y1_FrameStrobe[5] latch
X_0451_ _0451_/Q Tile_X0Y1_FrameData[23] VGND VPWR Tile_X0Y1_FrameStrobe[3] latch
X_0382_ _0382_/Q Tile_X0Y1_FrameData[28] VGND VPWR Tile_X0Y1_FrameStrobe[1] latch
XFILLER_66_235 VPWR VGND sg13cmos5l_fill_1
X_1003_ _1003_/X Tile_X0Y0_E2MID[7] Tile_X0Y0_E2END[7] Tile_X0Y0_E6END[7] _1092_/X
+ _0338_/Q _0337_/Q VPWR VGND sg13cmos5l_mux4_1
XFILLER_89_0 VPWR VGND sg13cmos5l_decap_4
X_0718_ Tile_X0Y0_UserCLKo Tile_X0Y0_UserCLK VPWR VGND sg13cmos5l_buf_1
X_0649_ _0649_/Q Tile_X0Y1_UserCLK NPU_ACT_RDATA5 _0657_/L_HI VPWR VGND sg13cmos5l_dfrbpq_1
XFILLER_72_238 VPWR VGND sg13cmos5l_decap_8
XFILLER_0_231 VPWR VGND sg13cmos5l_decap_8
XFILLER_103_2 VPWR VGND sg13cmos5l_fill_1
XFILLER_16_121 VPWR VGND sg13cmos5l_fill_1
XFILLER_48_202 VPWR VGND sg13cmos5l_decap_8
XFILLER_48_268 VPWR VGND sg13cmos5l_decap_4
XFILLER_56_84 VPWR VGND sg13cmos5l_decap_8
XFILLER_63_238 VPWR VGND sg13cmos5l_fill_1
XANTENNA__0914__X Tile_X0Y1_S4BEG[6] VPWR VGND sg13cmos5l_antennanp
XFILLER_16_154 VPWR VGND sg13cmos5l_decap_8
XFILLER_117_229 VPWR VGND sg13cmos5l_decap_8
XFILLER_100_107 VPWR VGND sg13cmos5l_fill_2
XFILLER_140_221 VPWR VGND sg13cmos5l_decap_8
XFILLER_39_224 VPWR VGND sg13cmos5l_decap_8
X_0503_ _0503_/Q Tile_X0Y1_FrameData[3] VGND VPWR Tile_X0Y1_FrameStrobe[4] latch
X_0434_ _0434_/Q Tile_X0Y1_FrameData[8] VGND VPWR Tile_X0Y1_FrameStrobe[2] latch
X_0365_ _0365_/Q Tile_X0Y1_FrameData[13] VGND VPWR Tile_X0Y1_FrameStrobe[0] latch
XANTENNA__0824__X Tile_X0Y1_FrameData_O[0] VPWR VGND sg13cmos5l_antennanp
XFILLER_54_227 VPWR VGND sg13cmos5l_decap_4
XFILLER_62_271 VPWR VGND sg13cmos5l_fill_2
X_0296_ _0296_/Q Tile_X0Y0_FrameData[20] VGND VPWR Tile_X0Y1_FrameStrobe[6] latch
XFILLER_117_46 VPWR VGND sg13cmos5l_fill_1
XFILLER_89_135 VPWR VGND sg13cmos5l_fill_2
XFILLER_89_179 VPWR VGND sg13cmos5l_decap_8
XFILLER_133_56 VPWR VGND sg13cmos5l_decap_8
XFILLER_26_10 VPWR VGND sg13cmos5l_decap_8
XFILLER_26_32 VPWR VGND sg13cmos5l_fill_1
XFILLER_45_238 VPWR VGND sg13cmos5l_decap_8
XANTENNA__0734__X Tile_X0Y0_W2BEGb[3] VPWR VGND sg13cmos5l_antennanp
XFILLER_13_113 VPWR VGND sg13cmos5l_decap_8
XFILLER_13_168 VPWR VGND sg13cmos5l_decap_8
XFILLER_9_128 VPWR VGND sg13cmos5l_decap_8
XANTENNA__0909__X Tile_X0Y1_S4BEG[1] VPWR VGND sg13cmos5l_antennanp
XFILLER_122_232 VPWR VGND sg13cmos5l_decap_8
XFILLER_3_14 VPWR VGND sg13cmos5l_decap_8
XFILLER_95_105 VPWR VGND sg13cmos5l_decap_4
XFILLER_36_227 VPWR VGND sg13cmos5l_decap_8
XFILLER_51_208 VPWR VGND sg13cmos5l_decap_8
XFILLER_83_82 VPWR VGND sg13cmos5l_decap_4
X_0150_ _0150_/Q Tile_X0Y0_FrameData[6] VGND VPWR Tile_X0Y1_FrameStrobe[1] latch
X_0081_ _0764_/A _1013_/X _1014_/X _0317_/Q VPWR VGND sg13cmos5l_mux2_1
X_0983_ _0983_/X Tile_X0Y1_EE4END[1] Tile_X0Y1_EE4END[9] Tile_X0Y1_E6END[1] _1204_/X
+ _0432_/Q _0431_/Q VPWR VGND sg13cmos5l_mux4_1
XFILLER_8_194 VPWR VGND sg13cmos5l_decap_8
XANTENNA__0819__X Tile_X0Y0_FrameStrobe_O[16] VPWR VGND sg13cmos5l_antennanp
XFILLER_86_127 VPWR VGND sg13cmos5l_decap_8
X_0417_ _0417_/Q Tile_X0Y1_FrameData[25] VGND VPWR Tile_X0Y1_FrameStrobe[2] latch
X_0348_ _0348_/Q Tile_X0Y1_FrameData[30] VGND VPWR Tile_X0Y1_FrameStrobe[0] latch
XFILLER_42_208 VPWR VGND sg13cmos5l_decap_8
X_0279_ _0279_/Q Tile_X0Y0_FrameData[5] VGND VPWR Tile_X0Y1_FrameStrobe[5] latch
XFILLER_128_56 VPWR VGND sg13cmos5l_decap_8
XFILLER_12_89 VPWR VGND sg13cmos5l_decap_8
XFILLER_88_27 VPWR VGND sg13cmos5l_decap_8
XANTENNA__0729__X Tile_X0Y0_W2BEG[6] VPWR VGND sg13cmos5l_antennanp
XFILLER_104_221 VPWR VGND sg13cmos5l_decap_8
XFILLER_18_238 VPWR VGND sg13cmos5l_decap_8
XFILLER_26_260 VPWR VGND sg13cmos5l_fill_1
XFILLER_33_208 VPWR VGND sg13cmos5l_decap_8
XFILLER_37_64 VPWR VGND sg13cmos5l_decap_4
XFILLER_139_151 VPWR VGND sg13cmos5l_decap_8
XFILLER_53_74 VPWR VGND sg13cmos5l_fill_1
XFILLER_52_8 VPWR VGND sg13cmos5l_decap_8
XFILLER_110_224 VPWR VGND sg13cmos5l_decap_8
XFILLER_68_116 VPWR VGND sg13cmos5l_decap_4
XFILLER_68_138 VPWR VGND sg13cmos5l_decap_8
XFILLER_76_182 VPWR VGND sg13cmos5l_decap_8
X_1182_ _1182_/X Tile_X0Y1_N4END[3] Tile_X0Y0_S4END[7] _1211_/X _1215_/X _0452_/Q
+ _0451_/Q VPWR VGND sg13cmos5l_mux4_1
X_0202_ _0202_/Q Tile_X0Y0_FrameData[18] VGND VPWR Tile_X0Y1_FrameStrobe[3] latch
X_0133_ _0133_/Q Tile_X0Y0_FrameData[23] VGND VPWR Tile_X0Y1_FrameStrobe[1] latch
XFILLER_24_208 VPWR VGND sg13cmos5l_decap_8
XFILLER_32_241 VPWR VGND sg13cmos5l_decap_8
XFILLER_91_174 VPWR VGND sg13cmos5l_decap_8
XFILLER_91_163 VPWR VGND sg13cmos5l_fill_1
XFILLER_71_0 VPWR VGND sg13cmos5l_decap_8
X_0897_ Tile_X0Y1_S2BEG[5] _1132_/X VPWR VGND sg13cmos5l_buf_1
X_0966_ Tile_X0Y1_WW4BEG[9] _1172_/X VPWR VGND sg13cmos5l_buf_1
XFILLER_101_202 VPWR VGND sg13cmos5l_decap_8
XFILLER_101_257 VPWR VGND sg13cmos5l_fill_2
XFILLER_59_105 VPWR VGND sg13cmos5l_decap_8
XFILLER_99_263 VPWR VGND sg13cmos5l_fill_2
XFILLER_99_230 VPWR VGND sg13cmos5l_fill_1
XFILLER_101_268 VPWR VGND sg13cmos5l_decap_4
XFILLER_130_35 VPWR VGND sg13cmos5l_decap_8
XFILLER_74_119 VPWR VGND sg13cmos5l_decap_8
XFILLER_136_154 VPWR VGND sg13cmos5l_decap_8
XFILLER_139_88 VPWR VGND sg13cmos5l_decap_8
XFILLER_2_123 VPWR VGND sg13cmos5l_decap_8
XFILLER_48_41 VPWR VGND sg13cmos5l_decap_8
XFILLER_48_52 VPWR VGND sg13cmos5l_fill_1
XFILLER_65_119 VPWR VGND sg13cmos5l_decap_8
XFILLER_0_37 VPWR VGND sg13cmos5l_fill_1
XFILLER_64_84 VPWR VGND sg13cmos5l_decap_8
XFILLER_73_196 VPWR VGND sg13cmos5l_decap_8
XANTENNA__0922__X Tile_X0Y1_S4BEG[14] VPWR VGND sg13cmos5l_antennanp
X_0820_ Tile_X0Y0_FrameStrobe_O[17] Tile_X0Y1_FrameStrobe[17] VPWR VGND sg13cmos5l_buf_1
X_0751_ Tile_X0Y0_N4BEG[0] Tile_X0Y1_N4END[8] VPWR VGND sg13cmos5l_buf_1
XFILLER_127_198 VPWR VGND sg13cmos5l_decap_8
XFILLER_89_92 VPWR VGND sg13cmos5l_fill_1
X_0682_ _0682_/L_HI VPWR VGND sg13cmos5l_tiehi
XFILLER_96_211 VPWR VGND sg13cmos5l_decap_8
XFILLER_56_119 VPWR VGND sg13cmos5l_decap_8
X_1096_ _1096_/X _1107_/X Tile_X0Y1_N2MID[4] Tile_X0Y0_S2MID[4] Tile_X0Y0_S2END[4]
+ _0108_/Q _0107_/Q VPWR VGND sg13cmos5l_mux4_1
X_1234_ _1234_/X Tile_X0Y0_E1END[2] Tile_X0Y0_E6END[2] _1102_/X _1234_/A3 _0150_/Q
+ _0149_/Q VPWR VGND sg13cmos5l_mux4_1
X_1165_ _1165_/X _0646_/Q _0650_/Q _1216_/X _1200_/X _0486_/Q _0485_/Q VPWR VGND sg13cmos5l_mux4_1
X_0116_ _0116_/Q Tile_X0Y0_FrameData[8] VGND VPWR Tile_X0Y1_FrameStrobe[0] latch
XANTENNA__0832__X Tile_X0Y1_FrameData_O[8] VPWR VGND sg13cmos5l_antennanp
XFILLER_64_196 VPWR VGND sg13cmos5l_decap_8
XFILLER_118_187 VPWR VGND sg13cmos5l_decap_8
XFILLER_133_157 VPWR VGND sg13cmos5l_decap_8
X_0949_ Tile_X0Y1_W6BEG[4] _1183_/X VPWR VGND sg13cmos5l_buf_1
XFILLER_125_35 VPWR VGND sg13cmos5l_decap_4
XFILLER_125_57 VPWR VGND sg13cmos5l_decap_8
XFILLER_87_222 VPWR VGND sg13cmos5l_decap_8
XFILLER_141_56 VPWR VGND sg13cmos5l_decap_8
XFILLER_141_89 VPWR VGND sg13cmos5l_decap_8
XFILLER_55_185 VPWR VGND sg13cmos5l_decap_8
XANTENNA__0742__X Tile_X0Y0_W6BEG[3] VPWR VGND sg13cmos5l_antennanp
XFILLER_119_0 VPWR VGND sg13cmos5l_fill_2
XFILLER_11_211 VPWR VGND sg13cmos5l_decap_8
XFILLER_34_98 VPWR VGND sg13cmos5l_decap_4
XFILLER_50_64 VPWR VGND sg13cmos5l_decap_4
XFILLER_7_226 VPWR VGND sg13cmos5l_decap_8
XFILLER_124_168 VPWR VGND sg13cmos5l_decap_8
XFILLER_1_0 VPWR VGND sg13cmos5l_decap_8
XFILLER_59_84 VPWR VGND sg13cmos5l_decap_8
XANTENNA__0917__X Tile_X0Y1_S4BEG[9] VPWR VGND sg13cmos5l_antennanp
XFILLER_78_255 VPWR VGND sg13cmos5l_decap_8
XFILLER_93_214 VPWR VGND sg13cmos5l_decap_8
XFILLER_61_111 VPWR VGND sg13cmos5l_decap_8
X_0803_ Tile_X0Y0_FrameStrobe_O[0] Tile_X0Y1_FrameStrobe[0] VPWR VGND sg13cmos5l_buf_1
X_0734_ Tile_X0Y0_W2BEGb[3] _1042_/X VPWR VGND sg13cmos5l_buf_1
X_0665_ _0665_/L_HI VPWR VGND sg13cmos5l_tiehi
XFILLER_130_105 VPWR VGND sg13cmos5l_decap_8
XFILLER_69_200 VPWR VGND sg13cmos5l_decap_8
X_0596_ _0596_/Q Tile_X0Y1_FrameData[6] VGND VPWR Tile_X0Y1_FrameStrobe[7] latch
XANTENNA__0827__X Tile_X0Y1_FrameData_O[3] VPWR VGND sg13cmos5l_antennanp
XFILLER_37_185 VPWR VGND sg13cmos5l_decap_8
XFILLER_84_269 VPWR VGND sg13cmos5l_decap_4
X_1079_ _1079_/X _1114_/X Tile_X0Y1_N4END[7] Tile_X0Y0_S1END[3] Tile_X0Y0_S4END[3]
+ _0118_/Q _0117_/Q VPWR VGND sg13cmos5l_mux4_1
X_1217_ _1217_/X Tile_X0Y1_N1END[2] Tile_X0Y1_N4END[2] _1229_/X Tile_X0Y0_S4END[6]
+ _0374_/Q _0373_/Q VPWR VGND sg13cmos5l_mux4_1
X_1148_ _1148_/X Tile_X0Y1_E2MID[3] _0645_/Q _1196_/X _1201_/X _0520_/Q _0519_/Q VPWR
+ VGND sg13cmos5l_mux4_1
XFILLER_138_238 VPWR VGND sg13cmos5l_decap_8
XFILLER_121_127 VPWR VGND sg13cmos5l_decap_4
XFILLER_121_138 VPWR VGND sg13cmos5l_fill_1
XFILLER_136_56 VPWR VGND sg13cmos5l_decap_8
XANTENNA__0737__X Tile_X0Y0_W2BEGb[6] VPWR VGND sg13cmos5l_antennanp
XFILLER_29_54 VPWR VGND sg13cmos5l_fill_2
XFILLER_75_203 VPWR VGND sg13cmos5l_decap_8
XFILLER_28_185 VPWR VGND sg13cmos5l_decap_8
XFILLER_43_166 VPWR VGND sg13cmos5l_decap_8
XFILLER_90_239 VPWR VGND sg13cmos5l_decap_8
XANTENNA_7 Tile_X0Y0_S2MID[2] VPWR VGND sg13cmos5l_antennanp
XFILLER_61_63 VPWR VGND sg13cmos5l_decap_8
XFILLER_6_14 VPWR VGND sg13cmos5l_decap_8
XFILLER_112_116 VPWR VGND sg13cmos5l_decap_8
XFILLER_3_251 VPWR VGND sg13cmos5l_fill_1
XFILLER_66_225 VPWR VGND sg13cmos5l_fill_1
XFILLER_86_82 VPWR VGND sg13cmos5l_decap_8
X_0450_ _0450_/Q Tile_X0Y1_FrameData[24] VGND VPWR Tile_X0Y1_FrameStrobe[3] latch
X_0381_ _0381_/Q Tile_X0Y1_FrameData[29] VGND VPWR Tile_X0Y1_FrameStrobe[1] latch
XFILLER_19_130 VPWR VGND sg13cmos5l_fill_2
XFILLER_19_196 VPWR VGND sg13cmos5l_decap_8
XFILLER_81_239 VPWR VGND sg13cmos5l_decap_8
X_1002_ _1002_/X Tile_X0Y0_E1END[3] Tile_X0Y0_E6END[7] _1079_/X _1078_/X _0340_/Q
+ _0339_/Q VPWR VGND sg13cmos5l_mux4_1
XFILLER_103_127 VPWR VGND sg13cmos5l_fill_2
XFILLER_106_26 VPWR VGND sg13cmos5l_decap_8
XFILLER_135_219 VPWR VGND sg13cmos5l_decap_8
X_0717_ _0974_/A3 VPWR VGND sg13cmos5l_tielo
X_0648_ _0648_/Q Tile_X0Y1_UserCLK NPU_ACT_RDATA4 _0675_/L_HI VPWR VGND sg13cmos5l_dfrbpq_1
XFILLER_72_217 VPWR VGND sg13cmos5l_decap_8
X_0579_ _0579_/Q Tile_X0Y1_FrameData[23] VGND VPWR Tile_X0Y1_FrameStrobe[7] latch
XFILLER_25_188 VPWR VGND sg13cmos5l_decap_8
XFILLER_40_147 VPWR VGND sg13cmos5l_fill_2
XFILLER_126_219 VPWR VGND sg13cmos5l_decap_8
XFILLER_134_252 VPWR VGND sg13cmos5l_decap_8
XFILLER_102_182 VPWR VGND sg13cmos5l_decap_8
XFILLER_16_133 VPWR VGND sg13cmos5l_fill_2
XFILLER_48_258 VPWR VGND sg13cmos5l_decap_4
XFILLER_56_63 VPWR VGND sg13cmos5l_decap_8
XFILLER_63_217 VPWR VGND sg13cmos5l_fill_2
XFILLER_117_208 VPWR VGND sg13cmos5l_decap_8
XFILLER_31_103 VPWR VGND sg13cmos5l_fill_1
XFILLER_71_261 VPWR VGND sg13cmos5l_decap_8
XFILLER_71_272 VPWR VGND sg13cmos5l_fill_1
XFILLER_72_84 VPWR VGND sg13cmos5l_decap_8
XFILLER_75_7 VPWR VGND sg13cmos5l_decap_8
XANTENNA__0930__X Tile_X0Y1_W2BEG[1] VPWR VGND sg13cmos5l_antennanp
XFILLER_140_200 VPWR VGND sg13cmos5l_decap_8
X_0502_ _0502_/Q Tile_X0Y1_FrameData[4] VGND VPWR Tile_X0Y1_FrameStrobe[4] latch
XFILLER_98_147 VPWR VGND sg13cmos5l_fill_1
XFILLER_98_136 VPWR VGND sg13cmos5l_decap_8
XFILLER_98_125 VPWR VGND sg13cmos5l_decap_4
XFILLER_39_203 VPWR VGND sg13cmos5l_decap_8
XFILLER_54_206 VPWR VGND sg13cmos5l_decap_8
X_0433_ _0433_/Q Tile_X0Y1_FrameData[9] VGND VPWR Tile_X0Y1_FrameStrobe[2] latch
X_0364_ _0364_/Q Tile_X0Y1_FrameData[14] VGND VPWR Tile_X0Y1_FrameStrobe[0] latch
X_0295_ _0295_/Q Tile_X0Y0_FrameData[21] VGND VPWR Tile_X0Y1_FrameStrobe[6] latch
XFILLER_98_169 VPWR VGND sg13cmos5l_fill_2
XANTENNA__0840__X Tile_X0Y1_FrameData_O[16] VPWR VGND sg13cmos5l_antennanp
XFILLER_131_255 VPWR VGND sg13cmos5l_decap_8
XFILLER_133_35 VPWR VGND sg13cmos5l_decap_8
XFILLER_45_217 VPWR VGND sg13cmos5l_decap_8
XFILLER_13_147 VPWR VGND sg13cmos5l_fill_2
XFILLER_42_21 VPWR VGND sg13cmos5l_decap_8
XFILLER_42_76 VPWR VGND sg13cmos5l_fill_2
XFILLER_53_272 VPWR VGND sg13cmos5l_fill_1
XANTENNA__0750__X Tile_X0Y0_W6BEG[11] VPWR VGND sg13cmos5l_antennanp
XFILLER_122_211 VPWR VGND sg13cmos5l_decap_8
XFILLER_36_206 VPWR VGND sg13cmos5l_decap_8
XFILLER_67_84 VPWR VGND sg13cmos5l_decap_8
XFILLER_95_139 VPWR VGND sg13cmos5l_decap_4
XANTENNA__0925__X Tile_X0Y1_W1BEG[0] VPWR VGND sg13cmos5l_antennanp
XFILLER_44_261 VPWR VGND sg13cmos5l_decap_8
XFILLER_44_272 VPWR VGND sg13cmos5l_fill_1
XFILLER_83_94 VPWR VGND sg13cmos5l_decap_4
X_0080_ _0923_/A _1141_/X _1142_/X _0531_/Q VPWR VGND sg13cmos5l_mux2_1
XFILLER_8_173 VPWR VGND sg13cmos5l_decap_8
X_0982_ _0982_/X Tile_X0Y1_EE4END[0] Tile_X0Y1_EE4END[8] Tile_X0Y1_E6END[0] _1203_/X
+ _0434_/Q _0433_/Q VPWR VGND sg13cmos5l_mux4_1
XFILLER_113_255 VPWR VGND sg13cmos5l_decap_8
XANTENNA__0835__X Tile_X0Y1_FrameData_O[11] VPWR VGND sg13cmos5l_antennanp
XFILLER_103_27 VPWR VGND sg13cmos5l_decap_8
XFILLER_27_239 VPWR VGND sg13cmos5l_decap_8
X_0416_ _0416_/Q Tile_X0Y1_FrameData[26] VGND VPWR Tile_X0Y1_FrameStrobe[2] latch
X_0347_ _0347_/Q Tile_X0Y0_FrameData[31] VGND VPWR Tile_X0Y1_FrameStrobe[0] latch
X_0278_ _0278_/Q Tile_X0Y0_FrameData[6] VGND VPWR Tile_X0Y1_FrameStrobe[5] latch
XFILLER_10_139 VPWR VGND sg13cmos5l_decap_8
XFILLER_104_200 VPWR VGND sg13cmos5l_decap_8
XFILLER_128_35 VPWR VGND sg13cmos5l_decap_8
XFILLER_12_35 VPWR VGND sg13cmos5l_fill_1
XFILLER_5_7 VPWR VGND sg13cmos5l_decap_8
XFILLER_85_161 VPWR VGND sg13cmos5l_decap_8
XANTENNA__0745__X Tile_X0Y0_W6BEG[6] VPWR VGND sg13cmos5l_antennanp
XFILLER_18_217 VPWR VGND sg13cmos5l_decap_8
XFILLER_26_272 VPWR VGND sg13cmos5l_fill_1
XFILLER_37_43 VPWR VGND sg13cmos5l_decap_8
XFILLER_53_31 VPWR VGND sg13cmos5l_decap_8
XFILLER_53_42 VPWR VGND sg13cmos5l_fill_2
XFILLER_139_130 VPWR VGND sg13cmos5l_decap_8
XFILLER_53_86 VPWR VGND sg13cmos5l_fill_1
XFILLER_110_203 VPWR VGND sg13cmos5l_decap_8
XFILLER_76_161 VPWR VGND sg13cmos5l_decap_8
X_1181_ _1181_/X Tile_X0Y1_N4END[2] Tile_X0Y0_S4END[6] _1212_/X _1216_/X _0454_/Q
+ _0453_/Q VPWR VGND sg13cmos5l_mux4_1
X_0201_ _0201_/Q Tile_X0Y0_FrameData[19] VGND VPWR Tile_X0Y1_FrameStrobe[3] latch
X_0132_ _0132_/Q Tile_X0Y0_FrameData[24] VGND VPWR Tile_X0Y1_FrameStrobe[1] latch
XFILLER_94_71 VPWR VGND sg13cmos5l_decap_8
XFILLER_91_153 VPWR VGND sg13cmos5l_fill_1
XFILLER_17_250 VPWR VGND sg13cmos5l_decap_8
XFILLER_17_261 VPWR VGND sg13cmos5l_fill_1
XFILLER_17_272 VPWR VGND sg13cmos5l_fill_1
XFILLER_32_220 VPWR VGND sg13cmos5l_decap_8
XFILLER_64_0 VPWR VGND sg13cmos5l_decap_8
X_0896_ Tile_X0Y1_S2BEG[4] _1131_/X VPWR VGND sg13cmos5l_buf_1
X_0965_ Tile_X0Y1_WW4BEG[8] _1171_/X VPWR VGND sg13cmos5l_buf_1
XFILLER_114_15 VPWR VGND sg13cmos5l_decap_4
XFILLER_4_91 VPWR VGND sg13cmos5l_decap_8
XFILLER_99_242 VPWR VGND sg13cmos5l_decap_8
XFILLER_130_14 VPWR VGND sg13cmos5l_decap_8
XFILLER_15_209 VPWR VGND sg13cmos5l_decap_8
XFILLER_82_186 VPWR VGND sg13cmos5l_decap_8
XFILLER_136_133 VPWR VGND sg13cmos5l_decap_8
XFILLER_139_67 VPWR VGND sg13cmos5l_decap_8
XFILLER_23_242 VPWR VGND sg13cmos5l_decap_8
XFILLER_23_264 VPWR VGND sg13cmos5l_fill_1
XFILLER_99_38 VPWR VGND sg13cmos5l_fill_1
XFILLER_2_102 VPWR VGND sg13cmos5l_decap_8
XFILLER_2_179 VPWR VGND sg13cmos5l_decap_8
XFILLER_48_75 VPWR VGND sg13cmos5l_decap_8
XFILLER_58_161 VPWR VGND sg13cmos5l_decap_4
XFILLER_64_63 VPWR VGND sg13cmos5l_decap_8
XFILLER_73_175 VPWR VGND sg13cmos5l_decap_8
XFILLER_127_177 VPWR VGND sg13cmos5l_decap_8
X_0750_ Tile_X0Y0_W6BEG[11] _1074_/X VPWR VGND sg13cmos5l_buf_1
X_0681_ _0681_/L_HI VPWR VGND sg13cmos5l_tiehi
X_1233_ _1233_/X Tile_X0Y0_EE4END[2] Tile_X0Y0_EE4END[10] Tile_X0Y0_E6END[2] _1090_/X
+ _0174_/Q _0173_/Q VPWR VGND sg13cmos5l_mux4_1
XFILLER_96_267 VPWR VGND sg13cmos5l_decap_4
XFILLER_64_175 VPWR VGND sg13cmos5l_decap_8
X_1095_ _1095_/X _1106_/X Tile_X0Y1_N2MID[3] Tile_X0Y0_S2MID[3] Tile_X0Y0_S2END[3]
+ _0110_/Q _0109_/Q VPWR VGND sg13cmos5l_mux4_1
X_1164_ _1164_/X _0645_/Q _0649_/Q _1217_/X _1201_/X _0488_/Q _0487_/Q VPWR VGND sg13cmos5l_mux4_1
X_0115_ _0115_/Q Tile_X0Y0_FrameData[9] VGND VPWR Tile_X0Y1_FrameStrobe[0] latch
X_0948_ Tile_X0Y1_W6BEG[3] _1182_/X VPWR VGND sg13cmos5l_buf_1
XFILLER_109_37 VPWR VGND sg13cmos5l_fill_2
XFILLER_118_166 VPWR VGND sg13cmos5l_decap_8
XFILLER_125_14 VPWR VGND sg13cmos5l_decap_8
XFILLER_133_147 VPWR VGND sg13cmos5l_decap_4
XFILLER_87_201 VPWR VGND sg13cmos5l_decap_8
X_0879_ Tile_X0Y0_FrameData_O[23] Tile_X0Y0_FrameData[23] VPWR VGND sg13cmos5l_buf_1
XFILLER_141_180 VPWR VGND sg13cmos5l_decap_8
XFILLER_55_164 VPWR VGND sg13cmos5l_decap_8
XFILLER_70_189 VPWR VGND sg13cmos5l_decap_8
XFILLER_50_76 VPWR VGND sg13cmos5l_decap_4
XFILLER_7_205 VPWR VGND sg13cmos5l_decap_8
XFILLER_124_147 VPWR VGND sg13cmos5l_decap_8
XFILLER_59_63 VPWR VGND sg13cmos5l_decap_8
XFILLER_78_234 VPWR VGND sg13cmos5l_decap_8
XFILLER_46_131 VPWR VGND sg13cmos5l_fill_2
XFILLER_46_197 VPWR VGND sg13cmos5l_decap_8
XFILLER_75_84 VPWR VGND sg13cmos5l_decap_8
XANTENNA__0933__X Tile_X0Y1_W2BEG[4] VPWR VGND sg13cmos5l_antennanp
XFILLER_61_189 VPWR VGND sg13cmos5l_decap_8
X_0802_ Tile_X0Y0_N1BEG[3] _1002_/X VPWR VGND sg13cmos5l_buf_1
XFILLER_115_147 VPWR VGND sg13cmos5l_decap_8
XFILLER_115_169 VPWR VGND sg13cmos5l_decap_8
X_0733_ Tile_X0Y0_W2BEGb[2] _1041_/X VPWR VGND sg13cmos5l_buf_1
X_0664_ _0664_/L_HI VPWR VGND sg13cmos5l_tiehi
XFILLER_123_191 VPWR VGND sg13cmos5l_decap_8
XFILLER_37_120 VPWR VGND sg13cmos5l_fill_2
XFILLER_84_248 VPWR VGND sg13cmos5l_decap_8
X_1216_ _1216_/X Tile_X0Y1_N1END[1] Tile_X0Y1_N4END[1] _1228_/X Tile_X0Y0_S4END[5]
+ _0376_/Q _0375_/Q VPWR VGND sg13cmos5l_mux4_1
X_0595_ _0595_/Q Tile_X0Y1_FrameData[7] VGND VPWR Tile_X0Y1_FrameStrobe[7] latch
XANTENNA__0843__X Tile_X0Y1_FrameData_O[19] VPWR VGND sg13cmos5l_antennanp
XFILLER_37_164 VPWR VGND sg13cmos5l_decap_8
XFILLER_52_178 VPWR VGND sg13cmos5l_decap_8
X_1078_ _1078_/X _1114_/X Tile_X0Y0_E6END[3] Tile_X0Y0_S1END[3] _1078_/A3 _0094_/Q
+ _0347_/Q VPWR VGND sg13cmos5l_mux4_1
X_1147_ _1147_/X Tile_X0Y1_E2MID[0] _0644_/Q _1195_/X _1202_/X _0522_/Q _0521_/Q VPWR
+ VGND sg13cmos5l_mux4_1
XFILLER_138_217 VPWR VGND sg13cmos5l_decap_8
XFILLER_106_136 VPWR VGND sg13cmos5l_fill_2
XFILLER_114_191 VPWR VGND sg13cmos5l_decap_8
XFILLER_121_106 VPWR VGND sg13cmos5l_decap_8
XFILLER_136_35 VPWR VGND sg13cmos5l_decap_8
XFILLER_20_35 VPWR VGND sg13cmos5l_decap_4
XFILLER_96_17 VPWR VGND sg13cmos5l_fill_1
XFILLER_28_164 VPWR VGND sg13cmos5l_decap_8
XFILLER_29_77 VPWR VGND sg13cmos5l_decap_8
XFILLER_75_259 VPWR VGND sg13cmos5l_decap_8
XFILLER_90_218 VPWR VGND sg13cmos5l_decap_8
XANTENNA__0753__X Tile_X0Y0_N4BEG[2] VPWR VGND sg13cmos5l_antennanp
XFILLER_129_239 VPWR VGND sg13cmos5l_decap_8
XFILLER_131_0 VPWR VGND sg13cmos5l_decap_8
XFILLER_61_42 VPWR VGND sg13cmos5l_decap_8
XANTENNA_8 Tile_X0Y0_S2MID[2] VPWR VGND sg13cmos5l_antennanp
XFILLER_137_272 VPWR VGND sg13cmos5l_fill_1
XANTENNA__0928__X Tile_X0Y1_W1BEG[3] VPWR VGND sg13cmos5l_antennanp
XFILLER_105_191 VPWR VGND sg13cmos5l_decap_4
XFILLER_120_194 VPWR VGND sg13cmos5l_decap_8
X_0380_ _0380_/Q Tile_X0Y1_FrameData[30] VGND VPWR Tile_X0Y1_FrameStrobe[1] latch
XFILLER_19_175 VPWR VGND sg13cmos5l_decap_8
XFILLER_34_123 VPWR VGND sg13cmos5l_decap_4
XFILLER_81_218 VPWR VGND sg13cmos5l_decap_8
X_1001_ _1001_/X Tile_X0Y0_E1END[2] Tile_X0Y0_E6END[6] _1077_/X _1102_/X _0342_/Q
+ _0341_/Q VPWR VGND sg13cmos5l_mux4_1
XANTENNA__0612__Q NPU_WEIGHT_IN2 VPWR VGND sg13cmos5l_antennanp
X_0716_ _0975_/A3 VPWR VGND sg13cmos5l_tielo
X_0647_ _0647_/Q Tile_X0Y1_UserCLK NPU_ACT_RDATA3 _0677_/L_HI VPWR VGND sg13cmos5l_dfrbpq_1
X_0578_ _0578_/Q Tile_X0Y1_FrameData[24] VGND VPWR Tile_X0Y1_FrameStrobe[7] latch
XANTENNA__0838__X Tile_X0Y1_FrameData_O[14] VPWR VGND sg13cmos5l_antennanp
XFILLER_111_183 VPWR VGND sg13cmos5l_decap_8
XFILLER_122_15 VPWR VGND sg13cmos5l_fill_2
XFILLER_57_226 VPWR VGND sg13cmos5l_decap_8
XFILLER_25_145 VPWR VGND sg13cmos5l_decap_8
XFILLER_25_167 VPWR VGND sg13cmos5l_decap_8
XFILLER_80_262 VPWR VGND sg13cmos5l_decap_8
XFILLER_119_250 VPWR VGND sg13cmos5l_decap_8
XFILLER_119_272 VPWR VGND sg13cmos5l_fill_1
XFILLER_134_231 VPWR VGND sg13cmos5l_decap_8
XFILLER_31_34 VPWR VGND sg13cmos5l_decap_8
XANTENNA__0748__X Tile_X0Y0_W6BEG[9] VPWR VGND sg13cmos5l_antennanp
XFILLER_102_161 VPWR VGND sg13cmos5l_decap_8
XFILLER_48_237 VPWR VGND sg13cmos5l_decap_8
XFILLER_16_189 VPWR VGND sg13cmos5l_decap_8
XFILLER_56_42 VPWR VGND sg13cmos5l_decap_8
XFILLER_71_240 VPWR VGND sg13cmos5l_decap_8
XFILLER_68_7 VPWR VGND sg13cmos5l_decap_8
XFILLER_72_63 VPWR VGND sg13cmos5l_decap_8
XFILLER_125_220 VPWR VGND sg13cmos5l_decap_4
XFILLER_125_253 VPWR VGND sg13cmos5l_decap_8
XFILLER_125_264 VPWR VGND sg13cmos5l_fill_1
XFILLER_140_256 VPWR VGND sg13cmos5l_decap_8
X_0501_ _0501_/Q Tile_X0Y1_FrameData[5] VGND VPWR Tile_X0Y1_FrameStrobe[4] latch
X_0432_ _0432_/Q Tile_X0Y1_FrameData[10] VGND VPWR Tile_X0Y1_FrameStrobe[2] latch
XFILLER_100_109 VPWR VGND sg13cmos5l_fill_1
X_0363_ _0363_/Q Tile_X0Y1_FrameData[15] VGND VPWR Tile_X0Y1_FrameStrobe[0] latch
X_0294_ _0294_/Q Tile_X0Y0_FrameData[22] VGND VPWR Tile_X0Y1_FrameStrobe[6] latch
XFILLER_22_137 VPWR VGND sg13cmos5l_decap_4
XFILLER_94_0 VPWR VGND sg13cmos5l_decap_4
XFILLER_116_253 VPWR VGND sg13cmos5l_decap_8
XFILLER_131_234 VPWR VGND sg13cmos5l_decap_8
XFILLER_133_14 VPWR VGND sg13cmos5l_decap_8
XFILLER_97_170 VPWR VGND sg13cmos5l_decap_8
XFILLER_13_159 VPWR VGND sg13cmos5l_fill_1
XFILLER_21_192 VPWR VGND sg13cmos5l_decap_8
XFILLER_107_253 VPWR VGND sg13cmos5l_decap_8
XFILLER_122_267 VPWR VGND sg13cmos5l_decap_4
XFILLER_3_49 VPWR VGND sg13cmos5l_decap_8
XFILLER_67_63 VPWR VGND sg13cmos5l_decap_8
XFILLER_44_240 VPWR VGND sg13cmos5l_decap_8
X_0981_ _0981_/X Tile_X0Y0_E1END[0] Tile_X0Y0_E6END[0] _1100_/X _0981_/A3 _0154_/Q
+ _0153_/Q VPWR VGND sg13cmos5l_mux4_1
XANTENNA__0941__X Tile_X0Y1_W2BEGb[4] VPWR VGND sg13cmos5l_antennanp
XFILLER_8_152 VPWR VGND sg13cmos5l_decap_8
XFILLER_113_234 VPWR VGND sg13cmos5l_decap_8
X_0415_ _0415_/Q Tile_X0Y1_FrameData[27] VGND VPWR Tile_X0Y1_FrameStrobe[2] latch
XFILLER_27_218 VPWR VGND sg13cmos5l_decap_8
XFILLER_35_240 VPWR VGND sg13cmos5l_decap_4
X_0346_ _0346_/Q Tile_X0Y0_FrameData[2] VGND VPWR Tile_X0Y1_FrameStrobe[7] latch
X_0277_ _0277_/Q Tile_X0Y0_FrameData[7] VGND VPWR Tile_X0Y1_FrameStrobe[5] latch
XFILLER_94_195 VPWR VGND sg13cmos5l_decap_8
XFILLER_94_151 VPWR VGND sg13cmos5l_fill_1
XFILLER_94_140 VPWR VGND sg13cmos5l_decap_8
XANTENNA__0851__X Tile_X0Y1_FrameData_O[27] VPWR VGND sg13cmos5l_antennanp
XFILLER_50_221 VPWR VGND sg13cmos5l_decap_8
XFILLER_104_256 VPWR VGND sg13cmos5l_decap_8
XFILLER_128_14 VPWR VGND sg13cmos5l_decap_8
XFILLER_37_22 VPWR VGND sg13cmos5l_decap_4
XFILLER_37_33 VPWR VGND sg13cmos5l_decap_8
XFILLER_77_129 VPWR VGND sg13cmos5l_decap_8
XFILLER_85_195 VPWR VGND sg13cmos5l_decap_8
XFILLER_41_232 VPWR VGND sg13cmos5l_fill_2
XANTENNA__0761__X Tile_X0Y0_N4BEG[10] VPWR VGND sg13cmos5l_antennanp
XFILLER_139_197 VPWR VGND sg13cmos5l_decap_8
XFILLER_5_133 VPWR VGND sg13cmos5l_decap_8
XFILLER_5_144 VPWR VGND sg13cmos5l_fill_1
XFILLER_5_177 VPWR VGND sg13cmos5l_decap_8
XFILLER_5_188 VPWR VGND sg13cmos5l_fill_2
XANTENNA__0936__X Tile_X0Y1_W2BEG[7] VPWR VGND sg13cmos5l_antennanp
XFILLER_110_259 VPWR VGND sg13cmos5l_decap_8
XFILLER_76_140 VPWR VGND sg13cmos5l_decap_8
X_1180_ _1180_/X Tile_X0Y1_N4END[1] Tile_X0Y0_S4END[5] _1213_/X _1217_/X _0456_/Q
+ _0455_/Q VPWR VGND sg13cmos5l_mux4_1
X_0200_ _0200_/Q Tile_X0Y0_FrameData[20] VGND VPWR Tile_X0Y1_FrameStrobe[3] latch
X_0131_ _0131_/Q Tile_X0Y0_FrameData[25] VGND VPWR Tile_X0Y1_FrameStrobe[1] latch
X_0964_ Tile_X0Y1_WW4BEG[7] _1170_/X VPWR VGND sg13cmos5l_buf_1
XANTENNA__0620__Q NPU_ACT_WDATA2 VPWR VGND sg13cmos5l_antennanp
XFILLER_57_0 VPWR VGND sg13cmos5l_decap_8
X_0895_ Tile_X0Y1_S2BEG[3] _1130_/X VPWR VGND sg13cmos5l_buf_1
XANTENNA__0846__X Tile_X0Y1_FrameData_O[22] VPWR VGND sg13cmos5l_antennanp
XFILLER_101_237 VPWR VGND sg13cmos5l_fill_2
XFILLER_101_259 VPWR VGND sg13cmos5l_fill_1
XFILLER_114_27 VPWR VGND sg13cmos5l_decap_4
XFILLER_4_70 VPWR VGND sg13cmos5l_decap_8
XFILLER_67_184 VPWR VGND sg13cmos5l_decap_8
X_0329_ _0329_/Q Tile_X0Y0_FrameData[19] VGND VPWR Tile_X0Y1_FrameStrobe[7] latch
XFILLER_23_221 VPWR VGND sg13cmos5l_decap_8
XFILLER_82_165 VPWR VGND sg13cmos5l_decap_8
XFILLER_135_7 VPWR VGND sg13cmos5l_decap_8
XFILLER_136_112 VPWR VGND sg13cmos5l_decap_8
XFILLER_139_46 VPWR VGND sg13cmos5l_decap_8
XFILLER_23_79 VPWR VGND sg13cmos5l_decap_8
XFILLER_136_189 VPWR VGND sg13cmos5l_decap_8
XFILLER_2_158 VPWR VGND sg13cmos5l_decap_8
XANTENNA__0756__X Tile_X0Y0_N4BEG[5] VPWR VGND sg13cmos5l_antennanp
XFILLER_0_28 VPWR VGND sg13cmos5l_decap_8
XFILLER_58_140 VPWR VGND sg13cmos5l_decap_8
XFILLER_58_184 VPWR VGND sg13cmos5l_decap_8
XFILLER_64_42 VPWR VGND sg13cmos5l_decap_8
XFILLER_73_154 VPWR VGND sg13cmos5l_decap_8
XFILLER_120_70 VPWR VGND sg13cmos5l_fill_1
XFILLER_14_243 VPWR VGND sg13cmos5l_decap_8
XFILLER_127_112 VPWR VGND sg13cmos5l_decap_8
XFILLER_127_123 VPWR VGND sg13cmos5l_fill_1
XFILLER_127_156 VPWR VGND sg13cmos5l_decap_8
XFILLER_89_83 VPWR VGND sg13cmos5l_decap_8
X_0680_ _0680_/L_HI VPWR VGND sg13cmos5l_tiehi
XFILLER_49_184 VPWR VGND sg13cmos5l_decap_8
X_1232_ _1232_/X Tile_X0Y0_EE4END[1] Tile_X0Y0_EE4END[9] Tile_X0Y0_E6END[1] _1089_/X
+ _0176_/Q _0175_/Q VPWR VGND sg13cmos5l_mux4_1
XFILLER_96_246 VPWR VGND sg13cmos5l_decap_8
XFILLER_64_154 VPWR VGND sg13cmos5l_decap_8
X_1094_ _1094_/X _1105_/X Tile_X0Y1_N2MID[2] Tile_X0Y0_S2MID[2] Tile_X0Y0_S2END[2]
+ _0112_/Q _0111_/Q VPWR VGND sg13cmos5l_mux4_1
X_1163_ _1163_/X _0644_/Q _0648_/Q _1218_/X _1202_/X _0490_/Q _0489_/Q VPWR VGND sg13cmos5l_mux4_1
X_0114_ _0114_/Q Tile_X0Y0_FrameData[10] VGND VPWR Tile_X0Y1_FrameStrobe[0] latch
XANTENNA__0615__Q NPU_WEIGHT_IN5 VPWR VGND sg13cmos5l_antennanp
XFILLER_118_112 VPWR VGND sg13cmos5l_fill_2
XFILLER_118_145 VPWR VGND sg13cmos5l_decap_8
XFILLER_20_224 VPWR VGND sg13cmos5l_decap_8
X_0947_ Tile_X0Y1_W6BEG[2] _1181_/X VPWR VGND sg13cmos5l_buf_1
XFILLER_133_126 VPWR VGND sg13cmos5l_decap_8
X_0878_ Tile_X0Y0_FrameData_O[22] Tile_X0Y0_FrameData[22] VPWR VGND sg13cmos5l_buf_1
XFILLER_18_79 VPWR VGND sg13cmos5l_decap_8
XFILLER_55_143 VPWR VGND sg13cmos5l_decap_8
XFILLER_87_257 VPWR VGND sg13cmos5l_decap_8
XFILLER_87_268 VPWR VGND sg13cmos5l_decap_4
XFILLER_11_246 VPWR VGND sg13cmos5l_decap_8
XFILLER_34_67 VPWR VGND sg13cmos5l_fill_2
XFILLER_109_112 VPWR VGND sg13cmos5l_fill_2
XFILLER_11_268 VPWR VGND sg13cmos5l_decap_4
XFILLER_124_126 VPWR VGND sg13cmos5l_decap_8
XFILLER_50_33 VPWR VGND sg13cmos5l_fill_2
XFILLER_59_42 VPWR VGND sg13cmos5l_decap_8
XFILLER_78_213 VPWR VGND sg13cmos5l_decap_8
XFILLER_131_91 VPWR VGND sg13cmos5l_decap_8
XFILLER_46_176 VPWR VGND sg13cmos5l_decap_8
XFILLER_61_146 VPWR VGND sg13cmos5l_decap_8
XFILLER_61_168 VPWR VGND sg13cmos5l_decap_8
XFILLER_75_63 VPWR VGND sg13cmos5l_decap_8
XFILLER_93_249 VPWR VGND sg13cmos5l_decap_8
X_0801_ Tile_X0Y0_N1BEG[2] _1001_/X VPWR VGND sg13cmos5l_buf_1
XFILLER_123_170 VPWR VGND sg13cmos5l_decap_8
XFILLER_6_261 VPWR VGND sg13cmos5l_decap_8
XFILLER_6_272 VPWR VGND sg13cmos5l_fill_1
X_0732_ Tile_X0Y0_W2BEGb[1] _1040_/X VPWR VGND sg13cmos5l_buf_1
X_0663_ _0663_/L_HI VPWR VGND sg13cmos5l_tiehi
X_0594_ _0594_/Q Tile_X0Y1_FrameData[8] VGND VPWR Tile_X0Y1_FrameStrobe[7] latch
XFILLER_84_227 VPWR VGND sg13cmos5l_decap_8
X_1215_ _1215_/X Tile_X0Y1_N1END[0] Tile_X0Y1_N4END[0] _1227_/X Tile_X0Y0_S4END[4]
+ _0378_/Q _0377_/Q VPWR VGND sg13cmos5l_mux4_1
X_1146_ _1146_/X Tile_X0Y1_N1END[3] _1230_/X _0645_/Q _0648_/Q _0524_/Q _0523_/Q VPWR
+ VGND sg13cmos5l_mux4_1
XFILLER_111_28 VPWR VGND sg13cmos5l_decap_8
XFILLER_52_157 VPWR VGND sg13cmos5l_decap_8
X_1077_ _1077_/X _1113_/X Tile_X0Y1_N4END[6] Tile_X0Y0_S1END[2] Tile_X0Y0_S4END[2]
+ _0120_/Q _0119_/Q VPWR VGND sg13cmos5l_mux4_1
XFILLER_136_14 VPWR VGND sg13cmos5l_decap_8
XFILLER_4_209 VPWR VGND sg13cmos5l_decap_8
XFILLER_114_170 VPWR VGND sg13cmos5l_decap_8
XFILLER_75_238 VPWR VGND sg13cmos5l_decap_8
XFILLER_124_0 VPWR VGND sg13cmos5l_decap_4
XFILLER_129_218 VPWR VGND sg13cmos5l_decap_8
XFILLER_61_21 VPWR VGND sg13cmos5l_decap_8
XANTENNA_9 Tile_X0Y0_S2MID[3] VPWR VGND sg13cmos5l_antennanp
XFILLER_105_170 VPWR VGND sg13cmos5l_decap_8
XFILLER_10_80 VPWR VGND sg13cmos5l_decap_8
XFILLER_137_251 VPWR VGND sg13cmos5l_decap_8
XFILLER_3_242 VPWR VGND sg13cmos5l_decap_8
XFILLER_6_49 VPWR VGND sg13cmos5l_decap_8
XFILLER_120_173 VPWR VGND sg13cmos5l_decap_8
XFILLER_19_132 VPWR VGND sg13cmos5l_fill_1
XFILLER_66_216 VPWR VGND sg13cmos5l_decap_8
XFILLER_86_40 VPWR VGND sg13cmos5l_decap_4
X_1000_ _1000_/X Tile_X0Y0_E1END[1] Tile_X0Y0_E6END[5] _1076_/X _1101_/X _0344_/Q
+ _0343_/Q VPWR VGND sg13cmos5l_mux4_1
XANTENNA__0944__X Tile_X0Y1_W2BEGb[7] VPWR VGND sg13cmos5l_antennanp
X_0715_ _0976_/A3 VPWR VGND sg13cmos5l_tielo
XFILLER_57_205 VPWR VGND sg13cmos5l_decap_8
X_0646_ _0646_/Q Tile_X0Y1_UserCLK NPU_ACT_RDATA2 _0678_/L_HI VPWR VGND sg13cmos5l_dfrbpq_1
X_0577_ _0577_/Q Tile_X0Y1_FrameData[25] VGND VPWR Tile_X0Y1_FrameStrobe[7] latch
XANTENNA__0854__X Tile_X0Y1_FrameData_O[30] VPWR VGND sg13cmos5l_antennanp
XFILLER_122_38 VPWR VGND sg13cmos5l_fill_2
XFILLER_80_241 VPWR VGND sg13cmos5l_decap_8
X_1129_ _1129_/X Tile_X0Y1_E2MID[5] Tile_X0Y1_E2END[5] Tile_X0Y1_E6END[10] _1197_/X
+ _0554_/Q _0553_/Q VPWR VGND sg13cmos5l_mux4_1
XFILLER_134_210 VPWR VGND sg13cmos5l_decap_8
XFILLER_0_245 VPWR VGND sg13cmos5l_fill_2
XFILLER_48_216 VPWR VGND sg13cmos5l_decap_8
XFILLER_56_21 VPWR VGND sg13cmos5l_decap_8
XANTENNA__0764__X Tile_X0Y0_N4BEG[13] VPWR VGND sg13cmos5l_antennanp
XFILLER_16_135 VPWR VGND sg13cmos5l_fill_1
XFILLER_16_168 VPWR VGND sg13cmos5l_decap_8
XFILLER_56_98 VPWR VGND sg13cmos5l_decap_8
XFILLER_72_42 VPWR VGND sg13cmos5l_decap_8
XANTENNA__0939__X Tile_X0Y1_W2BEGb[2] VPWR VGND sg13cmos5l_antennanp
XFILLER_125_232 VPWR VGND sg13cmos5l_decap_8
XFILLER_140_235 VPWR VGND sg13cmos5l_decap_8
X_0500_ _0500_/Q Tile_X0Y1_FrameData[6] VGND VPWR Tile_X0Y1_FrameStrobe[4] latch
X_0431_ _0431_/Q Tile_X0Y1_FrameData[11] VGND VPWR Tile_X0Y1_FrameStrobe[2] latch
X_0362_ _0362_/Q Tile_X0Y1_FrameData[16] VGND VPWR Tile_X0Y1_FrameStrobe[0] latch
XFILLER_11_4 VPWR VGND sg13cmos5l_fill_1
XFILLER_39_238 VPWR VGND sg13cmos5l_decap_8
X_0293_ _0293_/Q Tile_X0Y0_FrameData[23] VGND VPWR Tile_X0Y1_FrameStrobe[6] latch
XANTENNA__0623__Q NPU_ACT_WDATA5 VPWR VGND sg13cmos5l_antennanp
XFILLER_30_182 VPWR VGND sg13cmos5l_decap_8
XFILLER_87_0 VPWR VGND sg13cmos5l_fill_2
XFILLER_116_232 VPWR VGND sg13cmos5l_decap_8
XFILLER_117_27 VPWR VGND sg13cmos5l_decap_8
XFILLER_131_213 VPWR VGND sg13cmos5l_decap_8
XANTENNA__0849__X Tile_X0Y1_FrameData_O[25] VPWR VGND sg13cmos5l_antennanp
XFILLER_131_268 VPWR VGND sg13cmos5l_decap_4
X_0629_ NPU_ACT_ADDR3 Tile_X0Y1_UserCLK _0976_/X _0682_/L_HI VPWR VGND sg13cmos5l_dfrbpq_1
XFILLER_13_127 VPWR VGND sg13cmos5l_decap_8
XFILLER_42_67 VPWR VGND sg13cmos5l_fill_2
XFILLER_42_78 VPWR VGND sg13cmos5l_fill_1
XFILLER_9_109 VPWR VGND sg13cmos5l_decap_8
XANTENNA__0759__X Tile_X0Y0_N4BEG[8] VPWR VGND sg13cmos5l_antennanp
XFILLER_107_232 VPWR VGND sg13cmos5l_decap_8
XFILLER_122_246 VPWR VGND sg13cmos5l_decap_8
XFILLER_3_28 VPWR VGND sg13cmos5l_decap_8
XFILLER_67_42 VPWR VGND sg13cmos5l_decap_8
XFILLER_88_193 VPWR VGND sg13cmos5l_decap_8
X_0980_ _0980_/X Tile_X0Y0_E2MID[7] Tile_X0Y0_E2END[7] _1099_/X _0980_/A3 _0156_/Q
+ _0155_/Q VPWR VGND sg13cmos5l_mux4_1
XFILLER_113_213 VPWR VGND sg13cmos5l_decap_8
XFILLER_12_193 VPWR VGND sg13cmos5l_decap_8
XFILLER_8_131 VPWR VGND sg13cmos5l_decap_8
XFILLER_113_268 VPWR VGND sg13cmos5l_decap_4
XFILLER_79_193 VPWR VGND sg13cmos5l_decap_8
X_0414_ _0414_/Q Tile_X0Y1_FrameData[28] VGND VPWR Tile_X0Y1_FrameStrobe[2] latch
X_0345_ _0345_/Q Tile_X0Y0_FrameData[3] VGND VPWR Tile_X0Y1_FrameStrobe[7] latch
XANTENNA__0618__Q NPU_ACT_WDATA0 VPWR VGND sg13cmos5l_antennanp
XFILLER_50_200 VPWR VGND sg13cmos5l_decap_8
X_0276_ _0276_/Q Tile_X0Y0_FrameData[8] VGND VPWR Tile_X0Y1_FrameStrobe[5] latch
XFILLER_94_174 VPWR VGND sg13cmos5l_decap_8
XFILLER_94_163 VPWR VGND sg13cmos5l_decap_8
XFILLER_10_108 VPWR VGND sg13cmos5l_decap_8
XFILLER_10_119 VPWR VGND sg13cmos5l_fill_2
XFILLER_77_108 VPWR VGND sg13cmos5l_decap_8
XFILLER_85_174 VPWR VGND sg13cmos5l_decap_8
XFILLER_41_211 VPWR VGND sg13cmos5l_decap_8
XFILLER_139_165 VPWR VGND sg13cmos5l_fill_2
XFILLER_139_176 VPWR VGND sg13cmos5l_decap_8
XFILLER_5_112 VPWR VGND sg13cmos5l_decap_8
XFILLER_5_156 VPWR VGND sg13cmos5l_decap_8
XFILLER_110_238 VPWR VGND sg13cmos5l_decap_8
XFILLER_68_108 VPWR VGND sg13cmos5l_decap_4
XFILLER_78_96 VPWR VGND sg13cmos5l_decap_4
XFILLER_134_91 VPWR VGND sg13cmos5l_decap_8
XFILLER_76_196 VPWR VGND sg13cmos5l_decap_8
X_0130_ _0130_/Q Tile_X0Y0_FrameData[26] VGND VPWR Tile_X0Y1_FrameStrobe[1] latch
XFILLER_91_188 VPWR VGND sg13cmos5l_decap_8
XFILLER_91_111 VPWR VGND sg13cmos5l_decap_8
XANTENNA__0952__X Tile_X0Y1_W6BEG[7] VPWR VGND sg13cmos5l_antennanp
XFILLER_32_255 VPWR VGND sg13cmos5l_decap_8
X_0894_ Tile_X0Y1_S2BEG[2] _1129_/X VPWR VGND sg13cmos5l_buf_1
X_0963_ Tile_X0Y1_WW4BEG[6] _1169_/X VPWR VGND sg13cmos5l_buf_1
XFILLER_59_119 VPWR VGND sg13cmos5l_decap_8
XFILLER_101_216 VPWR VGND sg13cmos5l_decap_8
XFILLER_114_39 VPWR VGND sg13cmos5l_decap_8
XFILLER_67_163 VPWR VGND sg13cmos5l_decap_8
X_0328_ _0328_/Q Tile_X0Y0_FrameData[20] VGND VPWR Tile_X0Y1_FrameStrobe[7] latch
XANTENNA__0862__X Tile_X0Y0_FrameData_O[6] VPWR VGND sg13cmos5l_antennanp
XFILLER_130_49 VPWR VGND sg13cmos5l_decap_8
XFILLER_23_200 VPWR VGND sg13cmos5l_decap_8
X_0259_ _0259_/Q Tile_X0Y0_FrameData[25] VGND VPWR Tile_X0Y1_FrameStrobe[5] latch
XFILLER_128_7 VPWR VGND sg13cmos5l_decap_8
XFILLER_136_168 VPWR VGND sg13cmos5l_decap_8
XFILLER_139_14 VPWR VGND sg13cmos5l_decap_8
XFILLER_23_47 VPWR VGND sg13cmos5l_decap_8
XFILLER_23_58 VPWR VGND sg13cmos5l_fill_1
XFILLER_2_137 VPWR VGND sg13cmos5l_decap_8
XFILLER_14_222 VPWR VGND sg13cmos5l_decap_8
XFILLER_64_21 VPWR VGND sg13cmos5l_decap_8
XFILLER_73_133 VPWR VGND sg13cmos5l_decap_8
XANTENNA__0772__X Tile_X0Y0_WW4BEG[5] VPWR VGND sg13cmos5l_antennanp
XFILLER_64_98 VPWR VGND sg13cmos5l_decap_8
XFILLER_127_135 VPWR VGND sg13cmos5l_decap_8
XFILLER_129_91 VPWR VGND sg13cmos5l_decap_8
XANTENNA__0947__X Tile_X0Y1_W6BEG[2] VPWR VGND sg13cmos5l_antennanp
XFILLER_49_163 VPWR VGND sg13cmos5l_decap_8
XFILLER_64_133 VPWR VGND sg13cmos5l_decap_8
X_1231_ _1231_/X Tile_X0Y0_EE4END[0] Tile_X0Y0_EE4END[8] Tile_X0Y0_E6END[0] _1088_/X
+ _0178_/Q _0177_/Q VPWR VGND sg13cmos5l_mux4_1
X_1162_ _1162_/X Tile_X0Y1_E2MID[5] _0651_/Q _1195_/X _1202_/X _0492_/Q _0491_/Q VPWR
+ VGND sg13cmos5l_mux4_1
XFILLER_96_225 VPWR VGND sg13cmos5l_decap_8
XFILLER_20_203 VPWR VGND sg13cmos5l_decap_8
X_1093_ _1093_/X _1104_/X Tile_X0Y1_N2MID[1] Tile_X0Y0_S2MID[1] Tile_X0Y0_S2END[1]
+ _0114_/Q _0113_/Q VPWR VGND sg13cmos5l_mux4_1
X_0113_ _0113_/Q Tile_X0Y0_FrameData[11] VGND VPWR Tile_X0Y1_FrameStrobe[0] latch
XANTENNA__0631__Q NPU_ACT_ADDR5 VPWR VGND sg13cmos5l_antennanp
XFILLER_109_39 VPWR VGND sg13cmos5l_fill_1
XFILLER_118_124 VPWR VGND sg13cmos5l_decap_8
XFILLER_133_105 VPWR VGND sg13cmos5l_decap_8
X_0877_ Tile_X0Y0_FrameData_O[21] Tile_X0Y0_FrameData[21] VPWR VGND sg13cmos5l_buf_1
X_0946_ Tile_X0Y1_W6BEG[1] _1180_/X VPWR VGND sg13cmos5l_buf_1
XANTENNA__0857__X Tile_X0Y0_FrameData_O[1] VPWR VGND sg13cmos5l_antennanp
XFILLER_87_236 VPWR VGND sg13cmos5l_decap_8
XFILLER_55_122 VPWR VGND sg13cmos5l_decap_8
XFILLER_55_199 VPWR VGND sg13cmos5l_decap_8
XFILLER_11_225 VPWR VGND sg13cmos5l_decap_8
XFILLER_34_35 VPWR VGND sg13cmos5l_fill_2
XFILLER_109_179 VPWR VGND sg13cmos5l_decap_8
XFILLER_124_105 VPWR VGND sg13cmos5l_decap_8
XFILLER_59_21 VPWR VGND sg13cmos5l_decap_8
XANTENNA__0767__X Tile_X0Y0_WW4BEG[0] VPWR VGND sg13cmos5l_antennanp
XFILLER_132_182 VPWR VGND sg13cmos5l_decap_8
XFILLER_46_100 VPWR VGND sg13cmos5l_decap_8
XFILLER_46_133 VPWR VGND sg13cmos5l_fill_1
XFILLER_59_98 VPWR VGND sg13cmos5l_decap_8
XFILLER_75_42 VPWR VGND sg13cmos5l_decap_8
XFILLER_78_269 VPWR VGND sg13cmos5l_decap_4
XFILLER_93_228 VPWR VGND sg13cmos5l_decap_8
XFILLER_131_70 VPWR VGND sg13cmos5l_decap_8
XFILLER_61_125 VPWR VGND sg13cmos5l_decap_8
XFILLER_6_240 VPWR VGND sg13cmos5l_decap_8
X_0800_ Tile_X0Y0_N1BEG[1] _1000_/X VPWR VGND sg13cmos5l_buf_1
X_0731_ Tile_X0Y0_W2BEGb[0] _1039_/X VPWR VGND sg13cmos5l_buf_1
XFILLER_130_119 VPWR VGND sg13cmos5l_decap_8
XFILLER_69_214 VPWR VGND sg13cmos5l_decap_8
X_0662_ _0662_/L_HI VPWR VGND sg13cmos5l_tiehi
X_0593_ _0593_/Q Tile_X0Y1_FrameData[9] VGND VPWR Tile_X0Y1_FrameStrobe[7] latch
XFILLER_37_199 VPWR VGND sg13cmos5l_decap_8
XFILLER_84_206 VPWR VGND sg13cmos5l_decap_8
X_1214_ _1214_/X Tile_X0Y1_N1END[3] Tile_X0Y1_N4END[3] _1230_/X Tile_X0Y0_S4END[7]
+ _0380_/Q _0379_/Q VPWR VGND sg13cmos5l_mux4_1
X_1145_ _1145_/X Tile_X0Y1_N1END[2] _1229_/X _0644_/Q _0649_/Q _0526_/Q _0525_/Q VPWR
+ VGND sg13cmos5l_mux4_1
XFILLER_92_272 VPWR VGND sg13cmos5l_fill_1
XFILLER_92_261 VPWR VGND sg13cmos5l_decap_8
XANTENNA__0626__Q NPU_ACT_ADDR0 VPWR VGND sg13cmos5l_antennanp
XFILLER_52_136 VPWR VGND sg13cmos5l_decap_8
X_1076_ _1076_/X _1112_/X Tile_X0Y1_N4END[5] Tile_X0Y0_S1END[1] Tile_X0Y0_S4END[1]
+ _0122_/Q _0121_/Q VPWR VGND sg13cmos5l_mux4_1
XFILLER_106_138 VPWR VGND sg13cmos5l_fill_1
X_0929_ Tile_X0Y1_W2BEG[0] _1147_/X VPWR VGND sg13cmos5l_buf_1
XFILLER_28_111 VPWR VGND sg13cmos5l_fill_1
XFILLER_29_13 VPWR VGND sg13cmos5l_fill_2
XFILLER_75_217 VPWR VGND sg13cmos5l_decap_8
XFILLER_28_199 VPWR VGND sg13cmos5l_decap_8
XFILLER_83_272 VPWR VGND sg13cmos5l_fill_1
XFILLER_117_0 VPWR VGND sg13cmos5l_fill_1
XFILLER_137_230 VPWR VGND sg13cmos5l_decap_8
XFILLER_51_180 VPWR VGND sg13cmos5l_decap_8
XFILLER_61_77 VPWR VGND sg13cmos5l_decap_4
XFILLER_6_28 VPWR VGND sg13cmos5l_decap_8
XFILLER_112_108 VPWR VGND sg13cmos5l_fill_1
XFILLER_3_221 VPWR VGND sg13cmos5l_decap_8
XFILLER_120_152 VPWR VGND sg13cmos5l_decap_8
XFILLER_86_96 VPWR VGND sg13cmos5l_fill_2
XANTENNA__0960__X Tile_X0Y1_WW4BEG[3] VPWR VGND sg13cmos5l_antennanp
XFILLER_42_180 VPWR VGND sg13cmos5l_decap_8
XFILLER_89_4 VPWR VGND sg13cmos5l_fill_1
XFILLER_128_252 VPWR VGND sg13cmos5l_decap_8
X_0714_ _0977_/A3 VPWR VGND sg13cmos5l_tielo
X_0645_ _0645_/Q Tile_X0Y1_UserCLK NPU_ACT_RDATA1 _0676_/L_HI VPWR VGND sg13cmos5l_dfrbpq_1
XFILLER_111_163 VPWR VGND sg13cmos5l_fill_2
XFILLER_32_0 VPWR VGND sg13cmos5l_fill_2
X_0576_ _0576_/Q Tile_X0Y1_FrameData[26] VGND VPWR Tile_X0Y1_FrameStrobe[7] latch
XFILLER_122_17 VPWR VGND sg13cmos5l_fill_1
XFILLER_65_272 VPWR VGND sg13cmos5l_fill_1
XFILLER_80_220 VPWR VGND sg13cmos5l_decap_8
X_1059_ _1059_/X _0636_/Q _0640_/Q _1091_/X _1095_/X _0210_/Q _0209_/Q VPWR VGND sg13cmos5l_mux4_1
X_1128_ _1128_/X Tile_X0Y1_E2MID[6] Tile_X0Y1_E2END[6] Tile_X0Y1_E6END[9] _1196_/X
+ _0556_/Q _0555_/Q VPWR VGND sg13cmos5l_mux4_1
XANTENNA__0091__Q NPU_XBAR_SEL1 VPWR VGND sg13cmos5l_antennanp
XANTENNA__0870__X Tile_X0Y0_FrameData_O[14] VPWR VGND sg13cmos5l_antennanp
XFILLER_0_224 VPWR VGND sg13cmos5l_decap_8
XFILLER_134_266 VPWR VGND sg13cmos5l_decap_8
XFILLER_102_196 VPWR VGND sg13cmos5l_decap_8
XFILLER_56_250 VPWR VGND sg13cmos5l_decap_8
XFILLER_56_272 VPWR VGND sg13cmos5l_fill_1
XFILLER_56_77 VPWR VGND sg13cmos5l_decap_8
XANTENNA__0780__X Tile_X0Y0_WW4BEG[13] VPWR VGND sg13cmos5l_antennanp
XFILLER_16_147 VPWR VGND sg13cmos5l_decap_8
XFILLER_72_21 VPWR VGND sg13cmos5l_decap_8
XFILLER_72_98 VPWR VGND sg13cmos5l_decap_8
XFILLER_137_91 VPWR VGND sg13cmos5l_decap_8
XFILLER_140_214 VPWR VGND sg13cmos5l_decap_8
XFILLER_39_217 VPWR VGND sg13cmos5l_decap_8
X_0430_ _0430_/Q Tile_X0Y1_FrameData[12] VGND VPWR Tile_X0Y1_FrameStrobe[2] latch
X_0361_ _0361_/Q Tile_X0Y1_FrameData[17] VGND VPWR Tile_X0Y1_FrameStrobe[0] latch
XANTENNA__0955__X Tile_X0Y1_W6BEG[10] VPWR VGND sg13cmos5l_antennanp
XFILLER_47_250 VPWR VGND sg13cmos5l_decap_8
XFILLER_47_272 VPWR VGND sg13cmos5l_fill_1
XFILLER_62_231 VPWR VGND sg13cmos5l_fill_2
X_0292_ _0292_/Q Tile_X0Y0_FrameData[24] VGND VPWR Tile_X0Y1_FrameStrobe[6] latch
XFILLER_30_161 VPWR VGND sg13cmos5l_decap_8
XFILLER_116_211 VPWR VGND sg13cmos5l_decap_8
XFILLER_7_93 VPWR VGND sg13cmos5l_decap_8
X_0628_ NPU_ACT_ADDR2 Tile_X0Y1_UserCLK _0975_/X _0683_/L_HI VPWR VGND sg13cmos5l_dfrbpq_1
XANTENNA__0865__X Tile_X0Y0_FrameData_O[9] VPWR VGND sg13cmos5l_antennanp
XFILLER_133_49 VPWR VGND sg13cmos5l_decap_8
XFILLER_38_250 VPWR VGND sg13cmos5l_decap_8
X_0559_ _0559_/Q Tile_X0Y1_FrameData[11] VGND VPWR Tile_X0Y1_FrameStrobe[6] latch
XFILLER_13_106 VPWR VGND sg13cmos5l_decap_8
XFILLER_42_35 VPWR VGND sg13cmos5l_decap_4
XFILLER_53_220 VPWR VGND sg13cmos5l_decap_8
XFILLER_107_211 VPWR VGND sg13cmos5l_decap_8
XFILLER_42_46 VPWR VGND sg13cmos5l_decap_4
XFILLER_122_225 VPWR VGND sg13cmos5l_decap_8
XFILLER_67_21 VPWR VGND sg13cmos5l_decap_8
XFILLER_88_172 VPWR VGND sg13cmos5l_decap_8
XFILLER_95_109 VPWR VGND sg13cmos5l_fill_2
XANTENNA__0775__X Tile_X0Y0_WW4BEG[8] VPWR VGND sg13cmos5l_antennanp
XFILLER_83_31 VPWR VGND sg13cmos5l_fill_2
XFILLER_83_86 VPWR VGND sg13cmos5l_fill_1
XFILLER_12_150 VPWR VGND sg13cmos5l_decap_4
XFILLER_12_172 VPWR VGND sg13cmos5l_decap_8
XFILLER_73_7 VPWR VGND sg13cmos5l_decap_8
XFILLER_8_110 VPWR VGND sg13cmos5l_decap_8
XFILLER_8_187 VPWR VGND sg13cmos5l_decap_8
XFILLER_79_172 VPWR VGND sg13cmos5l_decap_8
X_0413_ _0413_/Q Tile_X0Y1_FrameData[29] VGND VPWR Tile_X0Y1_FrameStrobe[2] latch
X_0344_ _0344_/Q Tile_X0Y0_FrameData[4] VGND VPWR Tile_X0Y1_FrameStrobe[7] latch
X_0275_ _0275_/Q Tile_X0Y0_FrameData[9] VGND VPWR Tile_X0Y1_FrameStrobe[5] latch
XANTENNA__0634__Q NPU_ACT_ADDR8 VPWR VGND sg13cmos5l_antennanp
XFILLER_128_49 VPWR VGND sg13cmos5l_decap_8
XFILLER_104_214 VPWR VGND sg13cmos5l_decap_8
XFILLER_26_242 VPWR VGND sg13cmos5l_decap_8
XFILLER_139_144 VPWR VGND sg13cmos5l_decap_8
XFILLER_118_71 VPWR VGND sg13cmos5l_fill_1
XFILLER_110_217 VPWR VGND sg13cmos5l_decap_8
XFILLER_134_70 VPWR VGND sg13cmos5l_decap_8
XFILLER_76_175 VPWR VGND sg13cmos5l_decap_8
XFILLER_17_231 VPWR VGND sg13cmos5l_decap_8
XFILLER_27_90 VPWR VGND sg13cmos5l_decap_4
XFILLER_32_234 VPWR VGND sg13cmos5l_decap_8
XFILLER_94_96 VPWR VGND sg13cmos5l_fill_1
X_0893_ Tile_X0Y1_S2BEG[1] _1128_/X VPWR VGND sg13cmos5l_buf_1
X_0962_ Tile_X0Y1_WW4BEG[5] _1168_/X VPWR VGND sg13cmos5l_buf_1
XFILLER_99_256 VPWR VGND sg13cmos5l_decap_8
XFILLER_99_212 VPWR VGND sg13cmos5l_decap_8
XANTENNA__0629__Q NPU_ACT_ADDR3 VPWR VGND sg13cmos5l_antennanp
XFILLER_67_142 VPWR VGND sg13cmos5l_decap_8
X_0327_ _0327_/Q Tile_X0Y0_FrameData[21] VGND VPWR Tile_X0Y1_FrameStrobe[7] latch
X_0258_ _0258_/Q Tile_X0Y0_FrameData[26] VGND VPWR Tile_X0Y1_FrameStrobe[5] latch
XFILLER_130_28 VPWR VGND sg13cmos5l_decap_8
XFILLER_23_256 VPWR VGND sg13cmos5l_decap_4
X_0189_ _0189_/Q Tile_X0Y0_FrameData[31] VGND VPWR Tile_X0Y1_FrameStrobe[3] latch
XFILLER_136_147 VPWR VGND sg13cmos5l_decap_8
XFILLER_2_116 VPWR VGND sg13cmos5l_decap_8
XFILLER_3_7 VPWR VGND sg13cmos5l_decap_8
XFILLER_48_34 VPWR VGND sg13cmos5l_decap_8
XFILLER_104_73 VPWR VGND sg13cmos5l_decap_4
XFILLER_104_84 VPWR VGND sg13cmos5l_decap_4
XFILLER_14_201 VPWR VGND sg13cmos5l_decap_8
XFILLER_64_77 VPWR VGND sg13cmos5l_decap_8
XFILLER_73_112 VPWR VGND sg13cmos5l_decap_8
XFILLER_73_189 VPWR VGND sg13cmos5l_decap_8
XFILLER_13_92 VPWR VGND sg13cmos5l_decap_8
XFILLER_129_70 VPWR VGND sg13cmos5l_decap_8
XFILLER_135_191 VPWR VGND sg13cmos5l_decap_8
XFILLER_96_204 VPWR VGND sg13cmos5l_decap_8
XFILLER_1_171 VPWR VGND sg13cmos5l_decap_8
XFILLER_1_182 VPWR VGND sg13cmos5l_fill_2
XFILLER_49_142 VPWR VGND sg13cmos5l_decap_8
XFILLER_64_112 VPWR VGND sg13cmos5l_decap_8
X_1092_ _1092_/X _1103_/X Tile_X0Y1_N2MID[0] Tile_X0Y0_S2MID[0] Tile_X0Y0_S2END[0]
+ _0116_/Q _0115_/Q VPWR VGND sg13cmos5l_mux4_1
X_1230_ _1230_/X Tile_X0Y0_E1END[3] Tile_X0Y0_E6END[11] _1079_/X _1078_/X _0304_/Q
+ _0303_/Q VPWR VGND sg13cmos5l_mux4_1
X_1161_ _1161_/X Tile_X0Y1_E2MID[2] _0650_/Q _1196_/X _1201_/X _0494_/Q _0493_/Q VPWR
+ VGND sg13cmos5l_mux4_1
X_0112_ _0112_/Q Tile_X0Y0_FrameData[12] VGND VPWR Tile_X0Y1_FrameStrobe[0] latch
XANTENNA__0963__X Tile_X0Y1_WW4BEG[6] VPWR VGND sg13cmos5l_antennanp
XFILLER_64_189 VPWR VGND sg13cmos5l_decap_8
XFILLER_62_0 VPWR VGND sg13cmos5l_decap_8
X_0876_ Tile_X0Y0_FrameData_O[20] Tile_X0Y0_FrameData[20] VPWR VGND sg13cmos5l_buf_1
X_0945_ Tile_X0Y1_W6BEG[0] _1179_/X VPWR VGND sg13cmos5l_buf_1
XFILLER_125_28 VPWR VGND sg13cmos5l_decap_8
XFILLER_125_39 VPWR VGND sg13cmos5l_fill_1
XFILLER_126_191 VPWR VGND sg13cmos5l_decap_8
XFILLER_141_194 VPWR VGND sg13cmos5l_decap_8
XFILLER_87_215 VPWR VGND sg13cmos5l_decap_8
XANTENNA__0873__X Tile_X0Y0_FrameData_O[17] VPWR VGND sg13cmos5l_antennanp
XFILLER_55_178 VPWR VGND sg13cmos5l_decap_8
XFILLER_109_114 VPWR VGND sg13cmos5l_fill_1
XFILLER_109_136 VPWR VGND sg13cmos5l_decap_4
XFILLER_11_204 VPWR VGND sg13cmos5l_decap_8
XFILLER_140_7 VPWR VGND sg13cmos5l_decap_8
XFILLER_34_69 VPWR VGND sg13cmos5l_fill_1
XFILLER_50_35 VPWR VGND sg13cmos5l_fill_1
XFILLER_7_219 VPWR VGND sg13cmos5l_decap_8
XFILLER_117_180 VPWR VGND sg13cmos5l_decap_8
XFILLER_132_161 VPWR VGND sg13cmos5l_decap_8
XFILLER_50_68 VPWR VGND sg13cmos5l_fill_1
XFILLER_59_77 VPWR VGND sg13cmos5l_decap_8
XFILLER_115_94 VPWR VGND sg13cmos5l_decap_4
XFILLER_75_21 VPWR VGND sg13cmos5l_decap_8
XFILLER_75_98 VPWR VGND sg13cmos5l_decap_8
XFILLER_78_248 VPWR VGND sg13cmos5l_decap_8
XFILLER_93_207 VPWR VGND sg13cmos5l_decap_8
XANTENNA__0783__X Tile_X0Y0_N2BEGb[0] VPWR VGND sg13cmos5l_antennanp
XFILLER_91_64 VPWR VGND sg13cmos5l_fill_2
XFILLER_91_31 VPWR VGND sg13cmos5l_fill_1
X_0730_ Tile_X0Y0_W2BEG[7] _1038_/X VPWR VGND sg13cmos5l_buf_1
X_0661_ _0661_/L_HI VPWR VGND sg13cmos5l_tiehi
XANTENNA__0958__X Tile_X0Y1_WW4BEG[1] VPWR VGND sg13cmos5l_antennanp
XFILLER_123_150 VPWR VGND sg13cmos5l_fill_2
X_1213_ _1213_/X Tile_X0Y1_N1END[2] Tile_X0Y1_N4END[2] _1229_/X Tile_X0Y0_S4END[6]
+ _0382_/Q _0381_/Q VPWR VGND sg13cmos5l_mux4_1
X_0592_ _0592_/Q Tile_X0Y1_FrameData[10] VGND VPWR Tile_X0Y1_FrameStrobe[7] latch
XFILLER_37_178 VPWR VGND sg13cmos5l_decap_8
X_1075_ _1075_/X _1111_/X Tile_X0Y1_N4END[4] Tile_X0Y0_S1END[0] Tile_X0Y0_S4END[0]
+ _0124_/Q _0123_/Q VPWR VGND sg13cmos5l_mux4_1
X_1144_ _1144_/X Tile_X0Y1_N1END[1] _1228_/X _0647_/Q _0650_/Q _0528_/Q _0527_/Q VPWR
+ VGND sg13cmos5l_mux4_1
XFILLER_92_240 VPWR VGND sg13cmos5l_decap_8
XFILLER_60_192 VPWR VGND sg13cmos5l_decap_8
XANTENNA__0868__X Tile_X0Y0_FrameData_O[12] VPWR VGND sg13cmos5l_antennanp
XFILLER_136_49 VPWR VGND sg13cmos5l_decap_8
X_0859_ Tile_X0Y0_FrameData_O[3] Tile_X0Y0_FrameData[3] VPWR VGND sg13cmos5l_buf_1
X_0928_ Tile_X0Y1_W1BEG[3] _1146_/X VPWR VGND sg13cmos5l_buf_1
XANTENNA__0089__Q NPU_ACT_WE VPWR VGND sg13cmos5l_antennanp
XFILLER_28_123 VPWR VGND sg13cmos5l_decap_4
XFILLER_29_36 VPWR VGND sg13cmos5l_decap_4
XFILLER_29_47 VPWR VGND sg13cmos5l_decap_8
XFILLER_28_178 VPWR VGND sg13cmos5l_decap_8
XFILLER_3_200 VPWR VGND sg13cmos5l_decap_8
XFILLER_61_56 VPWR VGND sg13cmos5l_decap_8
XANTENNA__0778__X Tile_X0Y0_WW4BEG[11] VPWR VGND sg13cmos5l_antennanp
XFILLER_120_131 VPWR VGND sg13cmos5l_decap_8
XFILLER_126_93 VPWR VGND sg13cmos5l_decap_8
XFILLER_13_9 VPWR VGND sg13cmos5l_fill_2
XFILLER_19_189 VPWR VGND sg13cmos5l_decap_8
XFILLER_19_80 VPWR VGND sg13cmos5l_fill_2
XFILLER_86_75 VPWR VGND sg13cmos5l_decap_8
XFILLER_128_231 VPWR VGND sg13cmos5l_decap_8
X_0713_ _0978_/A3 VPWR VGND sg13cmos5l_tielo
X_0644_ _0644_/Q Tile_X0Y1_UserCLK NPU_ACT_RDATA0 _0671_/L_HI VPWR VGND sg13cmos5l_dfrbpq_1
XFILLER_111_197 VPWR VGND sg13cmos5l_decap_8
XFILLER_122_29 VPWR VGND sg13cmos5l_fill_1
XFILLER_25_0 VPWR VGND sg13cmos5l_decap_4
X_0575_ _0575_/Q Tile_X0Y1_FrameData[27] VGND VPWR Tile_X0Y1_FrameStrobe[7] latch
XFILLER_40_107 VPWR VGND sg13cmos5l_fill_1
X_1058_ _1058_/X _0639_/Q _0643_/Q _1087_/X _1096_/X _0212_/Q _0211_/Q VPWR VGND sg13cmos5l_mux4_1
X_1127_ _1127_/X Tile_X0Y1_E2MID[7] Tile_X0Y1_E2END[7] Tile_X0Y1_E6END[8] _1195_/X
+ _0558_/Q _0557_/Q VPWR VGND sg13cmos5l_mux4_1
XFILLER_110_8 VPWR VGND sg13cmos5l_decap_8
XFILLER_119_264 VPWR VGND sg13cmos5l_fill_1
XFILLER_0_247 VPWR VGND sg13cmos5l_fill_1
XFILLER_134_245 VPWR VGND sg13cmos5l_decap_8
XFILLER_102_175 VPWR VGND sg13cmos5l_decap_8
XFILLER_16_126 VPWR VGND sg13cmos5l_decap_8
XFILLER_56_56 VPWR VGND sg13cmos5l_decap_8
XFILLER_31_118 VPWR VGND sg13cmos5l_fill_1
XFILLER_71_254 VPWR VGND sg13cmos5l_decap_8
XFILLER_72_77 VPWR VGND sg13cmos5l_decap_8
XFILLER_137_70 VPWR VGND sg13cmos5l_decap_8
XFILLER_98_118 VPWR VGND sg13cmos5l_decap_8
X_0360_ _0360_/Q Tile_X0Y1_FrameData[18] VGND VPWR Tile_X0Y1_FrameStrobe[0] latch
X_0291_ _0291_/Q Tile_X0Y0_FrameData[25] VGND VPWR Tile_X0Y1_FrameStrobe[6] latch
XANTENNA__0971__X Tile_X0Y1_WW4BEG[14] VPWR VGND sg13cmos5l_antennanp
XFILLER_62_210 VPWR VGND sg13cmos5l_decap_8
XFILLER_15_181 VPWR VGND sg13cmos5l_decap_8
XFILLER_7_72 VPWR VGND sg13cmos5l_decap_8
XFILLER_116_267 VPWR VGND sg13cmos5l_decap_4
XFILLER_117_18 VPWR VGND sg13cmos5l_fill_2
XFILLER_131_248 VPWR VGND sg13cmos5l_decap_8
X_0627_ NPU_ACT_ADDR1 Tile_X0Y1_UserCLK _0974_/X _0684_/L_HI VPWR VGND sg13cmos5l_dfrbpq_1
X_0558_ _0558_/Q Tile_X0Y1_FrameData[12] VGND VPWR Tile_X0Y1_FrameStrobe[6] latch
XFILLER_133_28 VPWR VGND sg13cmos5l_decap_8
X_0489_ _0489_/Q Tile_X0Y1_FrameData[17] VGND VPWR Tile_X0Y1_FrameStrobe[4] latch
XFILLER_97_195 VPWR VGND sg13cmos5l_decap_8
XFILLER_97_184 VPWR VGND sg13cmos5l_fill_2
XANTENNA__0881__X Tile_X0Y0_FrameData_O[25] VPWR VGND sg13cmos5l_antennanp
XFILLER_42_14 VPWR VGND sg13cmos5l_decap_8
XFILLER_53_265 VPWR VGND sg13cmos5l_decap_8
XFILLER_107_267 VPWR VGND sg13cmos5l_decap_4
XFILLER_122_204 VPWR VGND sg13cmos5l_decap_8
XFILLER_21_173 VPWR VGND sg13cmos5l_decap_4
XFILLER_67_77 VPWR VGND sg13cmos5l_decap_8
XANTENNA__0791__X Tile_X0Y0_N2BEG[0] VPWR VGND sg13cmos5l_antennanp
XFILLER_123_72 VPWR VGND sg13cmos5l_fill_1
XFILLER_29_262 VPWR VGND sg13cmos5l_decap_8
XFILLER_44_254 VPWR VGND sg13cmos5l_decap_8
XFILLER_66_7 VPWR VGND sg13cmos5l_decap_8
XFILLER_8_166 VPWR VGND sg13cmos5l_decap_8
XFILLER_113_248 VPWR VGND sg13cmos5l_decap_8
XFILLER_79_151 VPWR VGND sg13cmos5l_decap_8
X_0412_ _0412_/Q Tile_X0Y1_FrameData[30] VGND VPWR Tile_X0Y1_FrameStrobe[2] latch
XANTENNA__0966__X Tile_X0Y1_WW4BEG[9] VPWR VGND sg13cmos5l_antennanp
X_0343_ _0343_/Q Tile_X0Y0_FrameData[5] VGND VPWR Tile_X0Y1_FrameStrobe[7] latch
X_0274_ _0274_/Q Tile_X0Y0_FrameData[10] VGND VPWR Tile_X0Y1_FrameStrobe[5] latch
XFILLER_94_132 VPWR VGND sg13cmos5l_fill_1
XFILLER_50_235 VPWR VGND sg13cmos5l_fill_1
XFILLER_128_28 VPWR VGND sg13cmos5l_decap_8
XANTENNA__0876__X Tile_X0Y0_FrameData_O[20] VPWR VGND sg13cmos5l_antennanp
XFILLER_26_221 VPWR VGND sg13cmos5l_decap_8
XFILLER_85_154 VPWR VGND sg13cmos5l_decap_8
XFILLER_139_123 VPWR VGND sg13cmos5l_decap_8
XFILLER_41_268 VPWR VGND sg13cmos5l_decap_4
XANTENNA__0786__X Tile_X0Y0_N2BEGb[3] VPWR VGND sg13cmos5l_antennanp
XFILLER_17_210 VPWR VGND sg13cmos5l_decap_8
XFILLER_76_154 VPWR VGND sg13cmos5l_decap_8
XFILLER_17_243 VPWR VGND sg13cmos5l_decap_8
XFILLER_32_213 VPWR VGND sg13cmos5l_decap_8
X_0961_ Tile_X0Y1_WW4BEG[4] _1167_/X VPWR VGND sg13cmos5l_buf_1
XFILLER_91_168 VPWR VGND sg13cmos5l_fill_2
X_0892_ Tile_X0Y1_S2BEG[0] _1127_/X VPWR VGND sg13cmos5l_buf_1
XFILLER_114_19 VPWR VGND sg13cmos5l_fill_1
XFILLER_4_84 VPWR VGND sg13cmos5l_decap_8
XFILLER_67_121 VPWR VGND sg13cmos5l_decap_8
XFILLER_99_268 VPWR VGND sg13cmos5l_decap_4
XFILLER_99_235 VPWR VGND sg13cmos5l_decap_8
XFILLER_67_198 VPWR VGND sg13cmos5l_decap_8
XFILLER_82_179 VPWR VGND sg13cmos5l_decap_8
X_0326_ _0326_/Q Tile_X0Y0_FrameData[22] VGND VPWR Tile_X0Y1_FrameStrobe[7] latch
X_0257_ _0257_/Q Tile_X0Y0_FrameData[27] VGND VPWR Tile_X0Y1_FrameStrobe[5] latch
X_0188_ _0188_/Q Tile_X0Y0_FrameData[0] VGND VPWR Tile_X0Y1_FrameStrobe[2] latch
XFILLER_23_235 VPWR VGND sg13cmos5l_decap_8
XFILLER_23_268 VPWR VGND sg13cmos5l_decap_4
XFILLER_90_190 VPWR VGND sg13cmos5l_decap_8
XFILLER_136_126 VPWR VGND sg13cmos5l_decap_8
XFILLER_100_262 VPWR VGND sg13cmos5l_decap_8
XFILLER_58_154 VPWR VGND sg13cmos5l_decap_8
XFILLER_58_165 VPWR VGND sg13cmos5l_fill_1
XFILLER_58_198 VPWR VGND sg13cmos5l_decap_8
XFILLER_14_257 VPWR VGND sg13cmos5l_decap_4
XFILLER_14_268 VPWR VGND sg13cmos5l_decap_4
XFILLER_64_56 VPWR VGND sg13cmos5l_decap_8
XFILLER_73_168 VPWR VGND sg13cmos5l_decap_8
XFILLER_81_190 VPWR VGND sg13cmos5l_decap_8
XFILLER_80_44 VPWR VGND sg13cmos5l_fill_2
XFILLER_80_99 VPWR VGND sg13cmos5l_fill_2
XFILLER_135_170 VPWR VGND sg13cmos5l_decap_8
XFILLER_1_150 VPWR VGND sg13cmos5l_decap_8
XFILLER_49_198 VPWR VGND sg13cmos5l_decap_8
XFILLER_64_168 VPWR VGND sg13cmos5l_decap_8
X_1091_ _1091_/X _1114_/X Tile_X0Y1_N4END[7] Tile_X0Y0_S1END[3] Tile_X0Y0_S4END[3]
+ _0142_/Q _0141_/Q VPWR VGND sg13cmos5l_mux4_1
X_1160_ _1160_/X _0649_/Q _1197_/X _1200_/X _1194_/X _0496_/Q _0495_/Q VPWR VGND sg13cmos5l_mux4_1
X_0111_ _0111_/Q Tile_X0Y0_FrameData[13] VGND VPWR Tile_X0Y1_FrameStrobe[0] latch
X_0944_ Tile_X0Y1_W2BEGb[7] _1162_/X VPWR VGND sg13cmos5l_buf_1
XFILLER_9_261 VPWR VGND sg13cmos5l_decap_4
XFILLER_118_159 VPWR VGND sg13cmos5l_decap_8
XFILLER_126_170 VPWR VGND sg13cmos5l_decap_8
XFILLER_55_0 VPWR VGND sg13cmos5l_decap_8
X_0875_ Tile_X0Y0_FrameData_O[19] Tile_X0Y0_FrameData[19] VPWR VGND sg13cmos5l_buf_1
XFILLER_9_272 VPWR VGND sg13cmos5l_fill_1
XFILLER_141_173 VPWR VGND sg13cmos5l_decap_8
XFILLER_18_38 VPWR VGND sg13cmos5l_fill_1
XFILLER_95_271 VPWR VGND sg13cmos5l_fill_2
XFILLER_95_260 VPWR VGND sg13cmos5l_decap_8
XFILLER_34_48 VPWR VGND sg13cmos5l_decap_4
XFILLER_55_157 VPWR VGND sg13cmos5l_decap_8
X_0309_ _0309_/Q Tile_X0Y0_FrameData[7] VGND VPWR Tile_X0Y1_FrameStrobe[6] latch
XFILLER_133_7 VPWR VGND sg13cmos5l_decap_8
XFILLER_50_14 VPWR VGND sg13cmos5l_decap_4
XFILLER_132_140 VPWR VGND sg13cmos5l_decap_8
XFILLER_59_56 VPWR VGND sg13cmos5l_decap_8
XFILLER_78_227 VPWR VGND sg13cmos5l_decap_8
XFILLER_46_124 VPWR VGND sg13cmos5l_decap_8
XFILLER_75_77 VPWR VGND sg13cmos5l_decap_8
XFILLER_86_260 VPWR VGND sg13cmos5l_decap_8
XFILLER_86_271 VPWR VGND sg13cmos5l_fill_2
XFILLER_91_98 VPWR VGND sg13cmos5l_decap_8
XFILLER_91_87 VPWR VGND sg13cmos5l_decap_4
X_0660_ _0660_/L_HI VPWR VGND sg13cmos5l_tiehi
X_0591_ _0591_/Q Tile_X0Y1_FrameData[11] VGND VPWR Tile_X0Y1_FrameStrobe[7] latch
XFILLER_123_184 VPWR VGND sg13cmos5l_decap_8
X_1212_ _1212_/X Tile_X0Y1_N1END[1] Tile_X0Y1_N4END[1] _1228_/X Tile_X0Y0_S4END[5]
+ _0384_/Q _0383_/Q VPWR VGND sg13cmos5l_mux4_1
X_1074_ _1074_/X _0639_/Q _1088_/X _1087_/X _1099_/X _0180_/Q _0179_/Q VPWR VGND sg13cmos5l_mux4_1
X_1143_ _1143_/X Tile_X0Y1_N1END[0] _1227_/X _0646_/Q _0651_/Q _0530_/Q _0529_/Q VPWR
+ VGND sg13cmos5l_mux4_1
XFILLER_60_160 VPWR VGND sg13cmos5l_fill_1
X_0927_ Tile_X0Y1_W1BEG[2] _1145_/X VPWR VGND sg13cmos5l_buf_1
XFILLER_114_184 VPWR VGND sg13cmos5l_decap_8
XFILLER_136_28 VPWR VGND sg13cmos5l_decap_8
XFILLER_20_39 VPWR VGND sg13cmos5l_fill_2
X_0858_ Tile_X0Y0_FrameData_O[2] Tile_X0Y0_FrameData[2] VPWR VGND sg13cmos5l_buf_1
X_0789_ Tile_X0Y0_N2BEGb[6] _1109_/X VPWR VGND sg13cmos5l_buf_1
XANTENNA__0884__X Tile_X0Y0_FrameData_O[28] VPWR VGND sg13cmos5l_antennanp
XFILLER_83_263 VPWR VGND sg13cmos5l_fill_2
XFILLER_101_31 VPWR VGND sg13cmos5l_decap_8
XFILLER_101_42 VPWR VGND sg13cmos5l_fill_2
XFILLER_101_64 VPWR VGND sg13cmos5l_fill_2
XFILLER_61_35 VPWR VGND sg13cmos5l_decap_8
XFILLER_105_184 VPWR VGND sg13cmos5l_decap_8
XFILLER_105_195 VPWR VGND sg13cmos5l_fill_1
XFILLER_10_94 VPWR VGND sg13cmos5l_decap_8
XFILLER_120_110 VPWR VGND sg13cmos5l_decap_8
XFILLER_120_187 VPWR VGND sg13cmos5l_decap_8
XFILLER_126_72 VPWR VGND sg13cmos5l_decap_8
XFILLER_3_256 VPWR VGND sg13cmos5l_decap_4
XFILLER_59_260 VPWR VGND sg13cmos5l_decap_4
XFILLER_86_65 VPWR VGND sg13cmos5l_fill_2
XFILLER_86_98 VPWR VGND sg13cmos5l_fill_1
XANTENNA__0794__X Tile_X0Y0_N2BEG[3] VPWR VGND sg13cmos5l_antennanp
XFILLER_19_168 VPWR VGND sg13cmos5l_fill_2
XFILLER_27_190 VPWR VGND sg13cmos5l_decap_8
XFILLER_34_127 VPWR VGND sg13cmos5l_fill_2
XFILLER_74_252 VPWR VGND sg13cmos5l_decap_8
XFILLER_128_210 VPWR VGND sg13cmos5l_decap_8
XFILLER_96_7 VPWR VGND sg13cmos5l_fill_1
XANTENNA__0969__X Tile_X0Y1_WW4BEG[12] VPWR VGND sg13cmos5l_antennanp
XFILLER_111_110 VPWR VGND sg13cmos5l_decap_4
X_0712_ _1191_/A3 VPWR VGND sg13cmos5l_tielo
X_0643_ _0643_/Q Tile_X0Y1_UserCLK NPU_OUT_ACT7 _0673_/L_HI VPWR VGND sg13cmos5l_dfrbpq_1
X_0574_ _0574_/Q Tile_X0Y1_FrameData[28] VGND VPWR Tile_X0Y1_FrameStrobe[7] latch
XFILLER_111_176 VPWR VGND sg13cmos5l_decap_8
XFILLER_57_219 VPWR VGND sg13cmos5l_decap_8
X_1126_ _1126_/X Tile_X0Y1_E1END[3] Tile_X0Y1_E6END[11] _1218_/X _1194_/X _0560_/Q
+ _0559_/Q VPWR VGND sg13cmos5l_mux4_1
XFILLER_25_116 VPWR VGND sg13cmos5l_decap_4
XFILLER_25_138 VPWR VGND sg13cmos5l_decap_8
XFILLER_80_255 VPWR VGND sg13cmos5l_decap_8
X_1057_ _1057_/X _0638_/Q _0642_/Q _1086_/X _1097_/X _0214_/Q _0213_/Q VPWR VGND sg13cmos5l_mux4_1
XANTENNA__0879__X Tile_X0Y0_FrameData_O[23] VPWR VGND sg13cmos5l_antennanp
XFILLER_119_243 VPWR VGND sg13cmos5l_decap_8
XFILLER_134_224 VPWR VGND sg13cmos5l_decap_8
XFILLER_31_27 VPWR VGND sg13cmos5l_decap_8
XFILLER_16_116 VPWR VGND sg13cmos5l_fill_1
XFILLER_56_35 VPWR VGND sg13cmos5l_decap_8
XFILLER_71_233 VPWR VGND sg13cmos5l_decap_8
XFILLER_112_96 VPWR VGND sg13cmos5l_fill_1
XFILLER_122_0 VPWR VGND sg13cmos5l_fill_2
XFILLER_72_56 VPWR VGND sg13cmos5l_decap_8
XANTENNA__0789__X Tile_X0Y0_N2BEGb[6] VPWR VGND sg13cmos5l_antennanp
XFILLER_125_213 VPWR VGND sg13cmos5l_decap_8
XFILLER_125_224 VPWR VGND sg13cmos5l_fill_2
XFILLER_125_246 VPWR VGND sg13cmos5l_decap_8
XFILLER_125_268 VPWR VGND sg13cmos5l_decap_4
XFILLER_140_249 VPWR VGND sg13cmos5l_decap_8
X_0290_ _0290_/Q Tile_X0Y0_FrameData[26] VGND VPWR Tile_X0Y1_FrameStrobe[6] latch
XFILLER_97_75 VPWR VGND sg13cmos5l_fill_1
XFILLER_15_160 VPWR VGND sg13cmos5l_fill_2
XFILLER_62_233 VPWR VGND sg13cmos5l_fill_1
XFILLER_116_246 VPWR VGND sg13cmos5l_decap_8
XFILLER_30_196 VPWR VGND sg13cmos5l_decap_8
XFILLER_7_51 VPWR VGND sg13cmos5l_decap_8
XFILLER_131_227 VPWR VGND sg13cmos5l_decap_8
X_0626_ NPU_ACT_ADDR0 Tile_X0Y1_UserCLK _0973_/X _0685_/L_HI VPWR VGND sg13cmos5l_dfrbpq_1
X_0557_ _0557_/Q Tile_X0Y1_FrameData[13] VGND VPWR Tile_X0Y1_FrameStrobe[6] latch
XFILLER_97_163 VPWR VGND sg13cmos5l_decap_8
X_1109_ _1109_/X Tile_X0Y1_E2MID[1] Tile_X0Y1_E2END[1] Tile_X0Y1_E6END[1] _1201_/X
+ _0582_/Q _0581_/Q VPWR VGND sg13cmos5l_mux4_1
X_0488_ _0488_/Q Tile_X0Y1_FrameData[18] VGND VPWR Tile_X0Y1_FrameStrobe[4] latch
XFILLER_21_185 VPWR VGND sg13cmos5l_decap_8
XFILLER_107_246 VPWR VGND sg13cmos5l_decap_8
XFILLER_29_241 VPWR VGND sg13cmos5l_decap_8
XFILLER_67_56 VPWR VGND sg13cmos5l_decap_8
XFILLER_88_141 VPWR VGND sg13cmos5l_decap_8
XFILLER_44_233 VPWR VGND sg13cmos5l_decap_8
XFILLER_32_81 VPWR VGND sg13cmos5l_fill_2
XFILLER_8_145 VPWR VGND sg13cmos5l_decap_8
XFILLER_113_227 VPWR VGND sg13cmos5l_decap_8
XFILLER_59_7 VPWR VGND sg13cmos5l_decap_8
X_0411_ _0411_/Q Tile_X0Y1_FrameData[31] VGND VPWR Tile_X0Y1_FrameStrobe[2] latch
X_0342_ _0342_/Q Tile_X0Y0_FrameData[6] VGND VPWR Tile_X0Y1_FrameStrobe[7] latch
XFILLER_35_233 VPWR VGND sg13cmos5l_decap_8
XFILLER_35_244 VPWR VGND sg13cmos5l_fill_2
X_0273_ _0273_/Q Tile_X0Y0_FrameData[11] VGND VPWR Tile_X0Y1_FrameStrobe[5] latch
XFILLER_94_188 VPWR VGND sg13cmos5l_decap_8
XFILLER_94_111 VPWR VGND sg13cmos5l_fill_2
XFILLER_50_214 VPWR VGND sg13cmos5l_decap_8
XFILLER_85_0 VPWR VGND sg13cmos5l_fill_2
XFILLER_104_249 VPWR VGND sg13cmos5l_decap_8
XFILLER_112_271 VPWR VGND sg13cmos5l_fill_2
XFILLER_37_15 VPWR VGND sg13cmos5l_decap_8
X_0609_ _0609_/Q Tile_X0Y1_FrameData[31] VGND VPWR Tile_X0Y1_FrameStrobe[8] latch
XANTENNA__0892__X Tile_X0Y1_S2BEG[0] VPWR VGND sg13cmos5l_antennanp
XFILLER_26_200 VPWR VGND sg13cmos5l_decap_8
XFILLER_41_225 VPWR VGND sg13cmos5l_decap_8
XFILLER_85_188 VPWR VGND sg13cmos5l_decap_8
XFILLER_139_102 VPWR VGND sg13cmos5l_decap_8
XFILLER_5_126 VPWR VGND sg13cmos5l_decap_8
XFILLER_78_66 VPWR VGND sg13cmos5l_fill_2
XFILLER_76_133 VPWR VGND sg13cmos5l_decap_8
XFILLER_94_32 VPWR VGND sg13cmos5l_decap_8
XFILLER_91_125 VPWR VGND sg13cmos5l_fill_2
XFILLER_32_269 VPWR VGND sg13cmos5l_decap_4
X_0960_ Tile_X0Y1_WW4BEG[3] _1166_/X VPWR VGND sg13cmos5l_buf_1
X_0891_ Tile_X0Y1_S1BEG[3] _1126_/X VPWR VGND sg13cmos5l_buf_1
XFILLER_4_63 VPWR VGND sg13cmos5l_decap_8
X_0325_ _0325_/Q Tile_X0Y0_FrameData[23] VGND VPWR Tile_X0Y1_FrameStrobe[7] latch
XFILLER_23_214 VPWR VGND sg13cmos5l_decap_8
XFILLER_67_177 VPWR VGND sg13cmos5l_decap_8
XFILLER_82_158 VPWR VGND sg13cmos5l_decap_8
X_0256_ _0256_/Q Tile_X0Y0_FrameData[28] VGND VPWR Tile_X0Y1_FrameStrobe[5] latch
X_0187_ _0187_/Q Tile_X0Y0_FrameData[1] VGND VPWR Tile_X0Y1_FrameStrobe[2] latch
XFILLER_136_105 VPWR VGND sg13cmos5l_decap_8
XFILLER_139_28 VPWR VGND sg13cmos5l_decap_8
XFILLER_139_39 VPWR VGND sg13cmos5l_decap_8
XFILLER_23_17 VPWR VGND sg13cmos5l_fill_2
XANTENNA__0887__X Tile_X0Y0_FrameData_O[31] VPWR VGND sg13cmos5l_antennanp
XFILLER_129_190 VPWR VGND sg13cmos5l_decap_8
XFILLER_100_241 VPWR VGND sg13cmos5l_decap_8
XFILLER_58_133 VPWR VGND sg13cmos5l_decap_8
XFILLER_58_177 VPWR VGND sg13cmos5l_decap_8
XFILLER_64_35 VPWR VGND sg13cmos5l_decap_8
XFILLER_73_147 VPWR VGND sg13cmos5l_decap_8
XFILLER_14_236 VPWR VGND sg13cmos5l_decap_8
XFILLER_127_105 VPWR VGND sg13cmos5l_decap_8
XFILLER_127_149 VPWR VGND sg13cmos5l_decap_8
XFILLER_89_65 VPWR VGND sg13cmos5l_decap_8
XFILLER_89_76 VPWR VGND sg13cmos5l_decap_8
XANTENNA__0797__X Tile_X0Y0_N2BEG[6] VPWR VGND sg13cmos5l_antennanp
XFILLER_96_239 VPWR VGND sg13cmos5l_decap_8
XFILLER_49_177 VPWR VGND sg13cmos5l_decap_8
XFILLER_64_147 VPWR VGND sg13cmos5l_decap_8
X_1090_ _1090_/X _1113_/X Tile_X0Y1_N4END[6] Tile_X0Y0_S1END[2] Tile_X0Y0_S4END[2]
+ _0144_/Q _0143_/Q VPWR VGND sg13cmos5l_mux4_1
X_0110_ _0110_/Q Tile_X0Y0_FrameData[14] VGND VPWR Tile_X0Y1_FrameStrobe[0] latch
XFILLER_118_138 VPWR VGND sg13cmos5l_decap_8
XFILLER_20_217 VPWR VGND sg13cmos5l_decap_8
X_0874_ Tile_X0Y0_FrameData_O[18] Tile_X0Y0_FrameData[18] VPWR VGND sg13cmos5l_buf_1
X_0943_ Tile_X0Y1_W2BEGb[6] _1161_/X VPWR VGND sg13cmos5l_buf_1
XFILLER_9_240 VPWR VGND sg13cmos5l_decap_8
XFILLER_133_119 VPWR VGND sg13cmos5l_decap_8
XFILLER_48_0 VPWR VGND sg13cmos5l_fill_2
XFILLER_55_136 VPWR VGND sg13cmos5l_decap_8
X_0308_ _0308_/Q Tile_X0Y0_FrameData[8] VGND VPWR Tile_X0Y1_FrameStrobe[6] latch
XFILLER_11_239 VPWR VGND sg13cmos5l_decap_8
X_0239_ _0239_/Q Tile_X0Y0_FrameData[13] VGND VPWR Tile_X0Y1_FrameStrobe[4] latch
XFILLER_109_105 VPWR VGND sg13cmos5l_decap_8
XFILLER_124_119 VPWR VGND sg13cmos5l_decap_8
XFILLER_126_7 VPWR VGND sg13cmos5l_decap_8
XFILLER_132_196 VPWR VGND sg13cmos5l_decap_8
XFILLER_59_35 VPWR VGND sg13cmos5l_decap_8
XFILLER_78_206 VPWR VGND sg13cmos5l_decap_8
XFILLER_131_84 VPWR VGND sg13cmos5l_decap_8
XFILLER_46_169 VPWR VGND sg13cmos5l_decap_8
XFILLER_54_180 VPWR VGND sg13cmos5l_decap_8
XFILLER_61_139 VPWR VGND sg13cmos5l_decap_8
XFILLER_75_56 VPWR VGND sg13cmos5l_decap_8
XFILLER_108_182 VPWR VGND sg13cmos5l_decap_8
XFILLER_10_272 VPWR VGND sg13cmos5l_fill_1
XFILLER_123_163 VPWR VGND sg13cmos5l_decap_8
XFILLER_6_254 VPWR VGND sg13cmos5l_decap_8
X_0590_ _0590_/Q Tile_X0Y1_FrameData[12] VGND VPWR Tile_X0Y1_FrameStrobe[7] latch
XFILLER_1_42 VPWR VGND sg13cmos5l_decap_8
XFILLER_37_103 VPWR VGND sg13cmos5l_decap_4
XFILLER_69_228 VPWR VGND sg13cmos5l_decap_4
XFILLER_77_272 VPWR VGND sg13cmos5l_fill_1
X_1211_ _1211_/X Tile_X0Y1_N1END[0] Tile_X0Y1_N4END[0] _1227_/X Tile_X0Y0_S4END[4]
+ _0386_/Q _0385_/Q VPWR VGND sg13cmos5l_mux4_1
X_1142_ _1142_/X _1210_/X _1214_/X _1218_/X _1202_/X _0533_/Q _0532_/Q VPWR VGND sg13cmos5l_mux4_1
XFILLER_1_86 VPWR VGND sg13cmos5l_decap_4
X_1073_ _1073_/X _0638_/Q _1089_/X _1086_/X _1098_/X _0182_/Q _0181_/Q VPWR VGND sg13cmos5l_mux4_1
X_0857_ Tile_X0Y0_FrameData_O[1] Tile_X0Y0_FrameData[1] VPWR VGND sg13cmos5l_buf_1
X_0926_ Tile_X0Y1_W1BEG[1] _1144_/X VPWR VGND sg13cmos5l_buf_1
XFILLER_114_163 VPWR VGND sg13cmos5l_decap_8
X_0788_ Tile_X0Y0_N2BEGb[5] _1108_/X VPWR VGND sg13cmos5l_buf_1
XFILLER_45_59 VPWR VGND sg13cmos5l_fill_2
XFILLER_83_242 VPWR VGND sg13cmos5l_decap_8
XFILLER_51_194 VPWR VGND sg13cmos5l_decap_8
XFILLER_61_14 VPWR VGND sg13cmos5l_decap_8
XFILLER_105_152 VPWR VGND sg13cmos5l_decap_4
XFILLER_10_73 VPWR VGND sg13cmos5l_decap_8
XFILLER_137_244 VPWR VGND sg13cmos5l_decap_8
XFILLER_3_235 VPWR VGND sg13cmos5l_decap_8
XFILLER_3_268 VPWR VGND sg13cmos5l_decap_4
XFILLER_105_163 VPWR VGND sg13cmos5l_decap_8
XFILLER_120_166 VPWR VGND sg13cmos5l_decap_8
XFILLER_126_51 VPWR VGND sg13cmos5l_decap_8
XFILLER_59_272 VPWR VGND sg13cmos5l_fill_1
XFILLER_66_209 VPWR VGND sg13cmos5l_decap_8
XFILLER_74_231 VPWR VGND sg13cmos5l_decap_8
XFILLER_86_33 VPWR VGND sg13cmos5l_decap_8
XFILLER_35_70 VPWR VGND sg13cmos5l_fill_1
XFILLER_128_266 VPWR VGND sg13cmos5l_decap_8
XFILLER_42_194 VPWR VGND sg13cmos5l_decap_8
X_0711_ _0980_/A3 VPWR VGND sg13cmos5l_tielo
X_0642_ _0642_/Q Tile_X0Y1_UserCLK NPU_OUT_ACT6 _0674_/L_HI VPWR VGND sg13cmos5l_dfrbpq_1
X_0573_ _0573_/Q Tile_X0Y1_FrameData[29] VGND VPWR Tile_X0Y1_FrameStrobe[7] latch
XFILLER_80_234 VPWR VGND sg13cmos5l_decap_8
X_1125_ _1125_/X Tile_X0Y1_E1END[2] Tile_X0Y1_E6END[10] _1217_/X _1193_/X _0562_/Q
+ _0561_/Q VPWR VGND sg13cmos5l_mux4_1
XFILLER_33_194 VPWR VGND sg13cmos5l_decap_8
X_1056_ _1056_/X _0637_/Q _0641_/Q _1085_/X _1098_/X _0216_/Q _0215_/Q VPWR VGND sg13cmos5l_mux4_1
XFILLER_119_222 VPWR VGND sg13cmos5l_decap_8
XFILLER_134_203 VPWR VGND sg13cmos5l_decap_8
X_0909_ Tile_X0Y1_S4BEG[1] Tile_X0Y0_S4END[9] VPWR VGND sg13cmos5l_buf_1
XANTENNA__0895__X Tile_X0Y1_S2BEG[3] VPWR VGND sg13cmos5l_antennanp
XFILLER_0_238 VPWR VGND sg13cmos5l_fill_2
XFILLER_48_209 VPWR VGND sg13cmos5l_decap_8
XFILLER_56_14 VPWR VGND sg13cmos5l_decap_8
XFILLER_56_231 VPWR VGND sg13cmos5l_decap_4
XFILLER_112_75 VPWR VGND sg13cmos5l_fill_2
XFILLER_24_161 VPWR VGND sg13cmos5l_fill_2
XFILLER_56_264 VPWR VGND sg13cmos5l_fill_1
XFILLER_71_212 VPWR VGND sg13cmos5l_decap_8
XFILLER_72_35 VPWR VGND sg13cmos5l_decap_8
XANTENNA_90 Tile_X0Y1_FrameData[19] VPWR VGND sg13cmos5l_antennanp
XFILLER_24_194 VPWR VGND sg13cmos5l_decap_8
XFILLER_115_0 VPWR VGND sg13cmos5l_fill_2
XFILLER_140_228 VPWR VGND sg13cmos5l_decap_8
XFILLER_47_264 VPWR VGND sg13cmos5l_fill_1
XFILLER_116_225 VPWR VGND sg13cmos5l_decap_8
XFILLER_131_206 VPWR VGND sg13cmos5l_decap_8
XFILLER_30_175 VPWR VGND sg13cmos5l_decap_8
XFILLER_7_30 VPWR VGND sg13cmos5l_decap_8
X_0625_ NPU_ACT_WDATA7 Tile_X0Y1_UserCLK _0989_/X _0690_/L_HI VPWR VGND sg13cmos5l_dfrbpq_1
XFILLER_30_0 VPWR VGND sg13cmos5l_fill_2
X_0556_ _0556_/Q Tile_X0Y1_FrameData[14] VGND VPWR Tile_X0Y1_FrameStrobe[6] latch
X_0487_ _0487_/Q Tile_X0Y1_FrameData[19] VGND VPWR Tile_X0Y1_FrameStrobe[4] latch
XFILLER_97_186 VPWR VGND sg13cmos5l_fill_1
XFILLER_97_142 VPWR VGND sg13cmos5l_decap_8
X_1039_ _1039_/X Tile_X0Y0_EE4END[6] _0636_/Q _1092_/X _1099_/X _0250_/Q _0249_/Q
+ VPWR VGND sg13cmos5l_mux4_1
X_1108_ _1108_/X Tile_X0Y1_E2MID[2] Tile_X0Y1_E2END[2] Tile_X0Y1_E6END[2] _1200_/X
+ _0584_/Q _0583_/Q VPWR VGND sg13cmos5l_mux4_1
XFILLER_107_225 VPWR VGND sg13cmos5l_decap_8
XFILLER_107_64 VPWR VGND sg13cmos5l_decap_4
XFILLER_122_239 VPWR VGND sg13cmos5l_decap_8
XFILLER_29_220 VPWR VGND sg13cmos5l_decap_8
XFILLER_44_212 VPWR VGND sg13cmos5l_decap_8
XFILLER_67_35 VPWR VGND sg13cmos5l_decap_8
XFILLER_88_186 VPWR VGND sg13cmos5l_decap_8
XFILLER_12_186 VPWR VGND sg13cmos5l_decap_8
XFILLER_8_124 VPWR VGND sg13cmos5l_decap_8
XFILLER_113_206 VPWR VGND sg13cmos5l_decap_8
XFILLER_121_250 VPWR VGND sg13cmos5l_decap_8
XFILLER_121_272 VPWR VGND sg13cmos5l_fill_1
XFILLER_79_186 VPWR VGND sg13cmos5l_decap_8
X_0410_ _0410_/Q Tile_X0Y1_FrameData[0] VGND VPWR Tile_X0Y1_FrameStrobe[1] latch
X_0341_ _0341_/Q Tile_X0Y0_FrameData[7] VGND VPWR Tile_X0Y1_FrameStrobe[7] latch
XFILLER_35_212 VPWR VGND sg13cmos5l_decap_8
X_0272_ _0272_/Q Tile_X0Y0_FrameData[12] VGND VPWR Tile_X0Y1_FrameStrobe[5] latch
XFILLER_94_156 VPWR VGND sg13cmos5l_decap_8
XFILLER_78_0 VPWR VGND sg13cmos5l_fill_2
XFILLER_104_228 VPWR VGND sg13cmos5l_decap_8
X_0608_ _0608_/Q Tile_X0Y1_FrameData[30] VGND VPWR Tile_X0Y1_FrameStrobe[8] latch
XFILLER_112_250 VPWR VGND sg13cmos5l_decap_8
X_0539_ _0539_/Q Tile_X0Y1_FrameData[31] VGND VPWR Tile_X0Y1_FrameStrobe[6] latch
XFILLER_26_256 VPWR VGND sg13cmos5l_decap_4
XFILLER_41_204 VPWR VGND sg13cmos5l_decap_8
XFILLER_139_158 VPWR VGND sg13cmos5l_decap_8
XFILLER_5_105 VPWR VGND sg13cmos5l_decap_8
XFILLER_5_149 VPWR VGND sg13cmos5l_decap_8
XFILLER_103_250 VPWR VGND sg13cmos5l_decap_8
XFILLER_103_272 VPWR VGND sg13cmos5l_fill_1
XFILLER_76_112 VPWR VGND sg13cmos5l_decap_8
XFILLER_134_84 VPWR VGND sg13cmos5l_decap_8
XFILLER_76_189 VPWR VGND sg13cmos5l_decap_8
XFILLER_32_248 VPWR VGND sg13cmos5l_decap_8
XFILLER_71_7 VPWR VGND sg13cmos5l_decap_8
X_0890_ Tile_X0Y1_S1BEG[2] _1125_/X VPWR VGND sg13cmos5l_buf_1
XFILLER_4_182 VPWR VGND sg13cmos5l_decap_8
XFILLER_4_42 VPWR VGND sg13cmos5l_decap_8
XFILLER_99_226 VPWR VGND sg13cmos5l_decap_4
XFILLER_101_209 VPWR VGND sg13cmos5l_decap_8
XFILLER_67_156 VPWR VGND sg13cmos5l_decap_8
X_0324_ _0324_/Q Tile_X0Y0_FrameData[24] VGND VPWR Tile_X0Y1_FrameStrobe[7] latch
X_0255_ _0255_/Q Tile_X0Y0_FrameData[29] VGND VPWR Tile_X0Y1_FrameStrobe[5] latch
X_0186_ _0186_/Q Tile_X0Y0_FrameData[2] VGND VPWR Tile_X0Y1_FrameStrobe[2] latch
XFILLER_48_48 VPWR VGND sg13cmos5l_decap_4
XFILLER_100_220 VPWR VGND sg13cmos5l_decap_8
XFILLER_64_14 VPWR VGND sg13cmos5l_decap_8
XFILLER_73_126 VPWR VGND sg13cmos5l_decap_8
XFILLER_14_215 VPWR VGND sg13cmos5l_decap_8
XFILLER_127_128 VPWR VGND sg13cmos5l_decap_8
XFILLER_129_84 VPWR VGND sg13cmos5l_decap_8
XFILLER_8_0 VPWR VGND sg13cmos5l_fill_2
XFILLER_1_130 VPWR VGND sg13cmos5l_decap_4
XFILLER_38_81 VPWR VGND sg13cmos5l_decap_4
XFILLER_49_156 VPWR VGND sg13cmos5l_decap_8
XFILLER_96_218 VPWR VGND sg13cmos5l_decap_8
XFILLER_64_126 VPWR VGND sg13cmos5l_decap_8
XFILLER_118_117 VPWR VGND sg13cmos5l_decap_8
X_0873_ Tile_X0Y0_FrameData_O[17] Tile_X0Y0_FrameData[17] VPWR VGND sg13cmos5l_buf_1
X_0942_ Tile_X0Y1_W2BEGb[5] _1160_/X VPWR VGND sg13cmos5l_buf_1
XFILLER_141_142 VPWR VGND sg13cmos5l_decap_8
XFILLER_87_229 VPWR VGND sg13cmos5l_decap_8
XFILLER_55_115 VPWR VGND sg13cmos5l_decap_8
X_0307_ _0307_/Q Tile_X0Y0_FrameData[9] VGND VPWR Tile_X0Y1_FrameStrobe[6] latch
X_0238_ _0238_/Q Tile_X0Y0_FrameData[14] VGND VPWR Tile_X0Y1_FrameStrobe[4] latch
XFILLER_11_218 VPWR VGND sg13cmos5l_decap_8
X_0169_ _0169_/Q Tile_X0Y0_FrameData[19] VGND VPWR Tile_X0Y1_FrameStrobe[2] latch
XANTENNA__0898__X Tile_X0Y1_S2BEG[6] VPWR VGND sg13cmos5l_antennanp
XFILLER_117_194 VPWR VGND sg13cmos5l_decap_8
XFILLER_59_14 VPWR VGND sg13cmos5l_decap_8
XFILLER_115_64 VPWR VGND sg13cmos5l_decap_4
XFILLER_132_175 VPWR VGND sg13cmos5l_decap_8
XFILLER_1_7 VPWR VGND sg13cmos5l_decap_8
XFILLER_75_35 VPWR VGND sg13cmos5l_decap_8
XFILLER_131_63 VPWR VGND sg13cmos5l_decap_8
XFILLER_61_118 VPWR VGND sg13cmos5l_decap_8
XFILLER_10_251 VPWR VGND sg13cmos5l_decap_8
XFILLER_6_233 VPWR VGND sg13cmos5l_decap_8
XFILLER_69_207 VPWR VGND sg13cmos5l_decap_8
XFILLER_1_21 VPWR VGND sg13cmos5l_decap_8
XFILLER_77_262 VPWR VGND sg13cmos5l_fill_2
X_1072_ _1072_/X _0637_/Q _1090_/X _1085_/X _1097_/X _0184_/Q _0183_/Q VPWR VGND sg13cmos5l_mux4_1
X_1210_ _1210_/X Tile_X0Y1_N1END[3] Tile_X0Y1_N4END[3] _1230_/X Tile_X0Y0_S4END[7]
+ _0388_/Q _0387_/Q VPWR VGND sg13cmos5l_mux4_1
X_1141_ _1141_/X Tile_X0Y1_E1END[3] Tile_X0Y1_EE4END[15] Tile_X0Y1_E6END[7] _1206_/X
+ _0533_/Q _0532_/Q VPWR VGND sg13cmos5l_mux4_1
XFILLER_92_254 VPWR VGND sg13cmos5l_decap_8
XFILLER_52_129 VPWR VGND sg13cmos5l_decap_8
XFILLER_60_0 VPWR VGND sg13cmos5l_decap_8
X_0856_ Tile_X0Y0_FrameData_O[0] Tile_X0Y0_FrameData[0] VPWR VGND sg13cmos5l_buf_1
X_0925_ Tile_X0Y1_W1BEG[0] _1143_/X VPWR VGND sg13cmos5l_buf_1
X_0787_ Tile_X0Y0_N2BEGb[4] _1107_/X VPWR VGND sg13cmos5l_buf_1
XFILLER_28_104 VPWR VGND sg13cmos5l_fill_2
XFILLER_68_262 VPWR VGND sg13cmos5l_decap_8
XFILLER_36_192 VPWR VGND sg13cmos5l_decap_8
XFILLER_45_16 VPWR VGND sg13cmos5l_fill_1
XFILLER_83_221 VPWR VGND sg13cmos5l_decap_8
XFILLER_101_55 VPWR VGND sg13cmos5l_fill_2
XFILLER_101_66 VPWR VGND sg13cmos5l_fill_1
XFILLER_137_223 VPWR VGND sg13cmos5l_decap_8
XFILLER_51_173 VPWR VGND sg13cmos5l_decap_8
XFILLER_10_30 VPWR VGND sg13cmos5l_fill_2
XFILLER_3_214 VPWR VGND sg13cmos5l_decap_8
XFILLER_120_145 VPWR VGND sg13cmos5l_decap_8
XFILLER_74_210 VPWR VGND sg13cmos5l_decap_8
XFILLER_86_67 VPWR VGND sg13cmos5l_fill_1
XFILLER_86_89 VPWR VGND sg13cmos5l_decap_8
XFILLER_42_173 VPWR VGND sg13cmos5l_decap_8
XFILLER_128_245 VPWR VGND sg13cmos5l_decap_8
X_0710_ _0979_/A3 VPWR VGND sg13cmos5l_tielo
X_0641_ _0641_/Q Tile_X0Y1_UserCLK NPU_OUT_ACT5 _0672_/L_HI VPWR VGND sg13cmos5l_dfrbpq_1
X_0572_ _0572_/Q Tile_X0Y1_FrameData[30] VGND VPWR Tile_X0Y1_FrameStrobe[7] latch
XFILLER_18_170 VPWR VGND sg13cmos5l_decap_8
XFILLER_80_213 VPWR VGND sg13cmos5l_decap_8
X_1055_ _1055_/X _0636_/Q _0640_/Q _1084_/X _1099_/X _0218_/Q _0217_/Q VPWR VGND sg13cmos5l_mux4_1
X_1124_ _1124_/X Tile_X0Y1_E1END[1] Tile_X0Y1_E6END[9] _1216_/X _1192_/X _0564_/Q
+ _0563_/Q VPWR VGND sg13cmos5l_mux4_1
XFILLER_119_201 VPWR VGND sg13cmos5l_decap_8
XFILLER_0_217 VPWR VGND sg13cmos5l_decap_8
XFILLER_134_259 VPWR VGND sg13cmos5l_decap_8
X_0908_ Tile_X0Y1_S4BEG[0] Tile_X0Y0_S4END[8] VPWR VGND sg13cmos5l_buf_1
X_0839_ Tile_X0Y1_FrameData_O[15] Tile_X0Y1_FrameData[15] VPWR VGND sg13cmos5l_buf_1
XFILLER_102_189 VPWR VGND sg13cmos5l_decap_8
XFILLER_56_210 VPWR VGND sg13cmos5l_decap_8
XFILLER_56_243 VPWR VGND sg13cmos5l_decap_8
XFILLER_71_268 VPWR VGND sg13cmos5l_decap_4
XFILLER_72_14 VPWR VGND sg13cmos5l_decap_8
XANTENNA_80 Tile_X0Y1_FrameData[19] VPWR VGND sg13cmos5l_antennanp
XANTENNA_91 Tile_X0Y1_FrameData[19] VPWR VGND sg13cmos5l_antennanp
XFILLER_21_40 VPWR VGND sg13cmos5l_decap_4
XFILLER_108_0 VPWR VGND sg13cmos5l_decap_4
XFILLER_137_84 VPWR VGND sg13cmos5l_decap_8
XFILLER_140_207 VPWR VGND sg13cmos5l_decap_8
XFILLER_46_92 VPWR VGND sg13cmos5l_fill_1
XFILLER_47_243 VPWR VGND sg13cmos5l_decap_8
XFILLER_62_224 VPWR VGND sg13cmos5l_decap_8
XFILLER_15_162 VPWR VGND sg13cmos5l_fill_1
XFILLER_15_195 VPWR VGND sg13cmos5l_decap_8
XFILLER_62_91 VPWR VGND sg13cmos5l_decap_8
XFILLER_116_204 VPWR VGND sg13cmos5l_decap_8
XFILLER_7_86 VPWR VGND sg13cmos5l_decap_8
X_0624_ NPU_ACT_WDATA6 Tile_X0Y1_UserCLK _0988_/X _0691_/L_HI VPWR VGND sg13cmos5l_dfrbpq_1
XFILLER_23_0 VPWR VGND sg13cmos5l_fill_2
XFILLER_38_243 VPWR VGND sg13cmos5l_decap_8
X_0555_ _0555_/Q Tile_X0Y1_FrameData[15] VGND VPWR Tile_X0Y1_FrameStrobe[6] latch
X_0486_ _0486_/Q Tile_X0Y1_FrameData[20] VGND VPWR Tile_X0Y1_FrameStrobe[4] latch
XFILLER_53_213 VPWR VGND sg13cmos5l_decap_8
X_1038_ _1038_/X Tile_X0Y0_EE4END[5] _0643_/Q _1092_/X _1099_/X _0252_/Q _0251_/Q
+ VPWR VGND sg13cmos5l_mux4_1
X_1107_ _1107_/X Tile_X0Y1_E2MID[3] Tile_X0Y1_E2END[3] Tile_X0Y1_E6END[3] _1199_/X
+ _0586_/Q _0585_/Q VPWR VGND sg13cmos5l_mux4_1
XFILLER_107_204 VPWR VGND sg13cmos5l_decap_8
XFILLER_21_143 VPWR VGND sg13cmos5l_fill_2
XFILLER_42_28 VPWR VGND sg13cmos5l_decap_8
XFILLER_107_43 VPWR VGND sg13cmos5l_fill_2
XFILLER_122_218 VPWR VGND sg13cmos5l_decap_8
XFILLER_67_14 VPWR VGND sg13cmos5l_decap_8
XFILLER_88_165 VPWR VGND sg13cmos5l_decap_8
XFILLER_12_143 VPWR VGND sg13cmos5l_decap_8
XFILLER_12_165 VPWR VGND sg13cmos5l_decap_8
XFILLER_44_268 VPWR VGND sg13cmos5l_decap_4
XFILLER_8_103 VPWR VGND sg13cmos5l_fill_2
XFILLER_32_83 VPWR VGND sg13cmos5l_fill_1
XFILLER_79_165 VPWR VGND sg13cmos5l_decap_8
X_0340_ _0340_/Q Tile_X0Y0_FrameData[8] VGND VPWR Tile_X0Y1_FrameStrobe[7] latch
X_0271_ _0271_/Q Tile_X0Y0_FrameData[13] VGND VPWR Tile_X0Y1_FrameStrobe[5] latch
XFILLER_94_113 VPWR VGND sg13cmos5l_fill_1
XFILLER_57_91 VPWR VGND sg13cmos5l_decap_8
XFILLER_85_2 VPWR VGND sg13cmos5l_fill_1
XFILLER_104_207 VPWR VGND sg13cmos5l_decap_8
XFILLER_7_191 VPWR VGND sg13cmos5l_decap_8
X_0607_ _0607_/Q Tile_X0Y1_FrameData[29] VGND VPWR Tile_X0Y1_FrameStrobe[8] latch
X_0538_ _0538_/Q Tile_X0Y1_FrameData[0] VGND VPWR Tile_X0Y1_FrameStrobe[5] latch
XFILLER_26_235 VPWR VGND sg13cmos5l_decap_8
XFILLER_85_168 VPWR VGND sg13cmos5l_fill_2
X_0469_ _0469_/Q Tile_X0Y1_FrameData[5] VGND VPWR Tile_X0Y1_FrameStrobe[3] latch
XFILLER_139_137 VPWR VGND sg13cmos5l_decap_8
XFILLER_26_268 VPWR VGND sg13cmos5l_decap_4
XFILLER_53_38 VPWR VGND sg13cmos5l_decap_4
XFILLER_134_63 VPWR VGND sg13cmos5l_decap_8
XFILLER_17_224 VPWR VGND sg13cmos5l_decap_8
XFILLER_17_257 VPWR VGND sg13cmos5l_decap_4
XFILLER_17_268 VPWR VGND sg13cmos5l_decap_4
XFILLER_27_94 VPWR VGND sg13cmos5l_fill_1
XFILLER_32_227 VPWR VGND sg13cmos5l_decap_8
XFILLER_76_168 VPWR VGND sg13cmos5l_decap_8
XFILLER_94_78 VPWR VGND sg13cmos5l_decap_8
XFILLER_91_149 VPWR VGND sg13cmos5l_decap_4
XFILLER_91_127 VPWR VGND sg13cmos5l_fill_1
XFILLER_91_105 VPWR VGND sg13cmos5l_fill_2
XFILLER_4_161 VPWR VGND sg13cmos5l_decap_8
XFILLER_4_21 VPWR VGND sg13cmos5l_decap_8
XFILLER_64_7 VPWR VGND sg13cmos5l_decap_8
XFILLER_99_249 VPWR VGND sg13cmos5l_decap_8
XFILLER_99_205 VPWR VGND sg13cmos5l_decap_8
XFILLER_4_98 VPWR VGND sg13cmos5l_decap_8
XFILLER_67_135 VPWR VGND sg13cmos5l_decap_8
X_0323_ _0323_/Q Tile_X0Y0_FrameData[25] VGND VPWR Tile_X0Y1_FrameStrobe[7] latch
X_0254_ _0254_/Q Tile_X0Y0_FrameData[30] VGND VPWR Tile_X0Y1_FrameStrobe[5] latch
X_0185_ _0185_/Q Tile_X0Y0_FrameData[3] VGND VPWR Tile_X0Y1_FrameStrobe[2] latch
XFILLER_23_249 VPWR VGND sg13cmos5l_decap_8
XFILLER_90_0 VPWR VGND sg13cmos5l_fill_2
XFILLER_2_109 VPWR VGND sg13cmos5l_decap_8
XFILLER_104_11 VPWR VGND sg13cmos5l_decap_8
XFILLER_104_22 VPWR VGND sg13cmos5l_fill_2
XFILLER_104_66 VPWR VGND sg13cmos5l_decap_8
XFILLER_104_88 VPWR VGND sg13cmos5l_fill_1
XFILLER_73_105 VPWR VGND sg13cmos5l_decap_8
XFILLER_80_36 VPWR VGND sg13cmos5l_fill_1
XFILLER_129_63 VPWR VGND sg13cmos5l_decap_8
XFILLER_135_184 VPWR VGND sg13cmos5l_decap_8
XFILLER_1_164 VPWR VGND sg13cmos5l_decap_8
XFILLER_49_135 VPWR VGND sg13cmos5l_decap_8
XFILLER_64_105 VPWR VGND sg13cmos5l_decap_8
XFILLER_54_70 VPWR VGND sg13cmos5l_decap_8
XFILLER_72_182 VPWR VGND sg13cmos5l_decap_8
X_0941_ Tile_X0Y1_W2BEGb[4] _1159_/X VPWR VGND sg13cmos5l_buf_1
XFILLER_70_91 VPWR VGND sg13cmos5l_fill_2
X_0872_ Tile_X0Y0_FrameData_O[16] Tile_X0Y0_FrameData[16] VPWR VGND sg13cmos5l_buf_1
XFILLER_126_184 VPWR VGND sg13cmos5l_decap_8
XFILLER_141_121 VPWR VGND sg13cmos5l_decap_8
XFILLER_141_187 VPWR VGND sg13cmos5l_decap_8
XFILLER_87_208 VPWR VGND sg13cmos5l_decap_8
XFILLER_48_190 VPWR VGND sg13cmos5l_fill_1
XFILLER_63_182 VPWR VGND sg13cmos5l_decap_8
X_0306_ _0306_/Q Tile_X0Y0_FrameData[10] VGND VPWR Tile_X0Y1_FrameStrobe[6] latch
X_0237_ _0237_/Q Tile_X0Y0_FrameData[15] VGND VPWR Tile_X0Y1_FrameStrobe[4] latch
X_0168_ _0168_/Q Tile_X0Y0_FrameData[20] VGND VPWR Tile_X0Y1_FrameStrobe[2] latch
X_0099_ _0099_/Q Tile_X0Y0_FrameData[25] VGND VPWR Tile_X0Y1_FrameStrobe[0] latch
XFILLER_117_173 VPWR VGND sg13cmos5l_decap_8
XFILLER_119_8 VPWR VGND sg13cmos5l_decap_8
XFILLER_132_154 VPWR VGND sg13cmos5l_decap_8
XFILLER_115_98 VPWR VGND sg13cmos5l_fill_1
XFILLER_75_14 VPWR VGND sg13cmos5l_decap_8
XFILLER_131_42 VPWR VGND sg13cmos5l_decap_8
XFILLER_10_230 VPWR VGND sg13cmos5l_decap_8
XFILLER_138_0 VPWR VGND sg13cmos5l_decap_8
XFILLER_6_212 VPWR VGND sg13cmos5l_decap_8
XFILLER_123_143 VPWR VGND sg13cmos5l_decap_8
XFILLER_123_198 VPWR VGND sg13cmos5l_decap_8
XFILLER_77_241 VPWR VGND sg13cmos5l_decap_8
XFILLER_37_116 VPWR VGND sg13cmos5l_decap_4
XFILLER_65_91 VPWR VGND sg13cmos5l_decap_8
X_1071_ _1071_/X _0636_/Q _1091_/X _1084_/X _1096_/X _0186_/Q _0185_/Q VPWR VGND sg13cmos5l_mux4_1
X_1140_ _1140_/X _1209_/X _1213_/X _1217_/X _1201_/X _0536_/Q _0535_/Q VPWR VGND sg13cmos5l_mux4_1
XFILLER_92_233 VPWR VGND sg13cmos5l_decap_8
XFILLER_45_182 VPWR VGND sg13cmos5l_decap_8
X_0924_ Tile_X0Y1_UserCLKo Tile_X0Y1_UserCLK VPWR VGND sg13cmos5l_buf_1
XFILLER_53_0 VPWR VGND sg13cmos5l_fill_2
X_0855_ Tile_X0Y1_FrameData_O[31] Tile_X0Y1_FrameData[31] VPWR VGND sg13cmos5l_buf_1
X_0786_ Tile_X0Y0_N2BEGb[3] _1106_/X VPWR VGND sg13cmos5l_buf_1
XFILLER_114_198 VPWR VGND sg13cmos5l_decap_8
XFILLER_28_127 VPWR VGND sg13cmos5l_fill_2
XFILLER_68_230 VPWR VGND sg13cmos5l_decap_8
XFILLER_83_200 VPWR VGND sg13cmos5l_decap_8
XFILLER_51_152 VPWR VGND sg13cmos5l_decap_8
XFILLER_131_7 VPWR VGND sg13cmos5l_decap_8
XFILLER_137_202 VPWR VGND sg13cmos5l_decap_8
XFILLER_137_268 VPWR VGND sg13cmos5l_decap_4
XFILLER_61_49 VPWR VGND sg13cmos5l_decap_8
XFILLER_120_124 VPWR VGND sg13cmos5l_decap_8
XFILLER_126_86 VPWR VGND sg13cmos5l_decap_8
XFILLER_86_13 VPWR VGND sg13cmos5l_fill_2
XFILLER_19_73 VPWR VGND sg13cmos5l_decap_8
XFILLER_74_266 VPWR VGND sg13cmos5l_decap_8
XFILLER_128_224 VPWR VGND sg13cmos5l_decap_8
XFILLER_51_71 VPWR VGND sg13cmos5l_decap_4
X_0640_ _0640_/Q Tile_X0Y1_UserCLK NPU_OUT_ACT4 _0667_/L_HI VPWR VGND sg13cmos5l_dfrbpq_1
X_0571_ _0571_/Q Tile_X0Y1_FrameData[31] VGND VPWR Tile_X0Y1_FrameStrobe[7] latch
XFILLER_80_269 VPWR VGND sg13cmos5l_decap_4
X_1054_ _1054_/X _0639_/Q _0643_/Q _1083_/X _1092_/X _0220_/Q _0219_/Q VPWR VGND sg13cmos5l_mux4_1
X_1123_ _1123_/X Tile_X0Y1_E1END[0] Tile_X0Y1_E6END[8] _1215_/X _1191_/X _0566_/Q
+ _0565_/Q VPWR VGND sg13cmos5l_mux4_1
XFILLER_119_257 VPWR VGND sg13cmos5l_decap_8
XFILLER_119_268 VPWR VGND sg13cmos5l_decap_4
X_0907_ Tile_X0Y1_S2BEGb[7] _1226_/X VPWR VGND sg13cmos5l_buf_1
XFILLER_134_238 VPWR VGND sg13cmos5l_decap_8
X_0838_ Tile_X0Y1_FrameData_O[14] Tile_X0Y1_FrameData[14] VPWR VGND sg13cmos5l_buf_1
X_0769_ Tile_X0Y0_WW4BEG[2] _1049_/X VPWR VGND sg13cmos5l_buf_1
XFILLER_102_168 VPWR VGND sg13cmos5l_decap_8
XFILLER_112_11 VPWR VGND sg13cmos5l_decap_4
XFILLER_56_49 VPWR VGND sg13cmos5l_decap_8
XFILLER_112_77 VPWR VGND sg13cmos5l_fill_1
XFILLER_71_247 VPWR VGND sg13cmos5l_decap_8
XANTENNA_70 Tile_X0Y1_N4END[4] VPWR VGND sg13cmos5l_antennanp
XANTENNA_81 Tile_X0Y1_FrameData[19] VPWR VGND sg13cmos5l_antennanp
XANTENNA_92 Tile_X0Y1_FrameData[19] VPWR VGND sg13cmos5l_antennanp
XFILLER_137_63 VPWR VGND sg13cmos5l_decap_8
XFILLER_47_222 VPWR VGND sg13cmos5l_decap_8
XFILLER_97_45 VPWR VGND sg13cmos5l_fill_2
XFILLER_62_203 VPWR VGND sg13cmos5l_decap_8
XFILLER_15_174 VPWR VGND sg13cmos5l_decap_8
XFILLER_62_70 VPWR VGND sg13cmos5l_decap_8
XFILLER_7_65 VPWR VGND sg13cmos5l_decap_8
X_0623_ NPU_ACT_WDATA5 Tile_X0Y1_UserCLK _0987_/X _0692_/L_HI VPWR VGND sg13cmos5l_dfrbpq_1
X_0554_ _0554_/Q Tile_X0Y1_FrameData[16] VGND VPWR Tile_X0Y1_FrameStrobe[6] latch
XFILLER_16_0 VPWR VGND sg13cmos5l_decap_4
XFILLER_38_222 VPWR VGND sg13cmos5l_decap_8
X_1106_ _1106_/X Tile_X0Y1_E2MID[4] Tile_X0Y1_E2END[4] Tile_X0Y1_E6END[4] _1198_/X
+ _0588_/Q _0587_/Q VPWR VGND sg13cmos5l_mux4_1
X_0485_ _0485_/Q Tile_X0Y1_FrameData[21] VGND VPWR Tile_X0Y1_FrameStrobe[4] latch
XFILLER_97_177 VPWR VGND sg13cmos5l_decap_8
XFILLER_21_111 VPWR VGND sg13cmos5l_fill_2
X_1037_ _1037_/X Tile_X0Y0_EE4END[4] _0642_/Q _1093_/X _1098_/X _0254_/Q _0253_/Q
+ VPWR VGND sg13cmos5l_mux4_1
XFILLER_21_199 VPWR VGND sg13cmos5l_decap_8
XFILLER_130_252 VPWR VGND sg13cmos5l_decap_8
XFILLER_88_111 VPWR VGND sg13cmos5l_decap_8
XFILLER_88_122 VPWR VGND sg13cmos5l_fill_1
XFILLER_88_155 VPWR VGND sg13cmos5l_fill_2
XFILLER_29_255 VPWR VGND sg13cmos5l_decap_8
XFILLER_44_247 VPWR VGND sg13cmos5l_decap_8
XFILLER_120_0 VPWR VGND sg13cmos5l_decap_4
XFILLER_12_122 VPWR VGND sg13cmos5l_decap_8
XFILLER_32_40 VPWR VGND sg13cmos5l_fill_1
XFILLER_8_159 VPWR VGND sg13cmos5l_decap_8
XFILLER_79_122 VPWR VGND sg13cmos5l_decap_4
XFILLER_79_133 VPWR VGND sg13cmos5l_decap_4
XFILLER_57_70 VPWR VGND sg13cmos5l_decap_8
XFILLER_79_144 VPWR VGND sg13cmos5l_decap_8
X_0270_ _0270_/Q Tile_X0Y0_FrameData[14] VGND VPWR Tile_X0Y1_FrameStrobe[5] latch
XFILLER_94_147 VPWR VGND sg13cmos5l_decap_4
XFILLER_94_125 VPWR VGND sg13cmos5l_decap_8
XFILLER_50_228 VPWR VGND sg13cmos5l_decap_8
XFILLER_73_91 VPWR VGND sg13cmos5l_decap_8
XFILLER_78_2 VPWR VGND sg13cmos5l_fill_1
XFILLER_7_170 VPWR VGND sg13cmos5l_decap_8
XANTENNA__0800__X Tile_X0Y0_N1BEG[1] VPWR VGND sg13cmos5l_antennanp
X_0606_ _0606_/Q Tile_X0Y1_FrameData[28] VGND VPWR Tile_X0Y1_FrameStrobe[8] latch
X_0537_ _0537_/Q Tile_X0Y1_FrameData[1] VGND VPWR Tile_X0Y1_FrameStrobe[5] latch
XFILLER_26_214 VPWR VGND sg13cmos5l_decap_8
X_0468_ _0468_/Q Tile_X0Y1_FrameData[6] VGND VPWR Tile_X0Y1_FrameStrobe[3] latch
X_0399_ _0399_/Q Tile_X0Y1_FrameData[11] VGND VPWR Tile_X0Y1_FrameStrobe[1] latch
XFILLER_139_116 VPWR VGND sg13cmos5l_decap_8
XFILLER_134_42 VPWR VGND sg13cmos5l_decap_8
XFILLER_17_203 VPWR VGND sg13cmos5l_decap_8
XFILLER_76_147 VPWR VGND sg13cmos5l_decap_8
XFILLER_27_51 VPWR VGND sg13cmos5l_fill_1
XFILLER_32_206 VPWR VGND sg13cmos5l_decap_8
XFILLER_138_182 VPWR VGND sg13cmos5l_decap_8
XFILLER_40_272 VPWR VGND sg13cmos5l_fill_1
XFILLER_43_72 VPWR VGND sg13cmos5l_fill_1
XFILLER_43_94 VPWR VGND sg13cmos5l_fill_1
XFILLER_4_140 VPWR VGND sg13cmos5l_decap_8
XFILLER_4_77 VPWR VGND sg13cmos5l_decap_8
XFILLER_57_7 VPWR VGND sg13cmos5l_decap_8
X_0322_ _0322_/Q Tile_X0Y0_FrameData[26] VGND VPWR Tile_X0Y1_FrameStrobe[7] latch
X_0253_ _0253_/Q Tile_X0Y0_FrameData[31] VGND VPWR Tile_X0Y1_FrameStrobe[5] latch
X_0184_ _0184_/Q Tile_X0Y0_FrameData[4] VGND VPWR Tile_X0Y1_FrameStrobe[2] latch
XFILLER_23_228 VPWR VGND sg13cmos5l_decap_8
XFILLER_31_261 VPWR VGND sg13cmos5l_decap_8
XFILLER_31_272 VPWR VGND sg13cmos5l_fill_1
XFILLER_83_0 VPWR VGND sg13cmos5l_fill_2
XFILLER_90_183 VPWR VGND sg13cmos5l_decap_8
XFILLER_136_119 VPWR VGND sg13cmos5l_decap_8
XFILLER_100_255 VPWR VGND sg13cmos5l_decap_8
XFILLER_58_147 VPWR VGND sg13cmos5l_decap_8
XFILLER_98_272 VPWR VGND sg13cmos5l_fill_1
XFILLER_64_49 VPWR VGND sg13cmos5l_decap_8
XFILLER_81_183 VPWR VGND sg13cmos5l_decap_8
XFILLER_127_119 VPWR VGND sg13cmos5l_decap_4
XFILLER_129_42 VPWR VGND sg13cmos5l_decap_8
XFILLER_13_64 VPWR VGND sg13cmos5l_decap_8
XFILLER_22_272 VPWR VGND sg13cmos5l_fill_1
XFILLER_135_130 VPWR VGND sg13cmos5l_fill_1
XFILLER_135_163 VPWR VGND sg13cmos5l_decap_8
XFILLER_1_143 VPWR VGND sg13cmos5l_decap_8
XFILLER_89_272 VPWR VGND sg13cmos5l_fill_1
XFILLER_57_191 VPWR VGND sg13cmos5l_decap_8
XFILLER_72_161 VPWR VGND sg13cmos5l_decap_8
X_0940_ Tile_X0Y1_W2BEGb[3] _1158_/X VPWR VGND sg13cmos5l_buf_1
XFILLER_118_108 VPWR VGND sg13cmos5l_decap_4
XFILLER_126_163 VPWR VGND sg13cmos5l_decap_8
XFILLER_70_70 VPWR VGND sg13cmos5l_decap_8
X_0871_ Tile_X0Y0_FrameData_O[15] Tile_X0Y0_FrameData[15] VPWR VGND sg13cmos5l_buf_1
XFILLER_9_254 VPWR VGND sg13cmos5l_decap_8
XFILLER_141_166 VPWR VGND sg13cmos5l_decap_8
X_0305_ _0305_/Q Tile_X0Y0_FrameData[11] VGND VPWR Tile_X0Y1_FrameStrobe[6] latch
XFILLER_95_253 VPWR VGND sg13cmos5l_decap_8
XFILLER_63_161 VPWR VGND sg13cmos5l_decap_8
X_0236_ _0236_/Q Tile_X0Y0_FrameData[16] VGND VPWR Tile_X0Y1_FrameStrobe[4] latch
X_0167_ _0167_/Q Tile_X0Y0_FrameData[21] VGND VPWR Tile_X0Y1_FrameStrobe[2] latch
X_0098_ _0098_/Q Tile_X0Y0_FrameData[26] VGND VPWR Tile_X0Y1_FrameStrobe[0] latch
XFILLER_117_152 VPWR VGND sg13cmos5l_decap_8
XFILLER_132_133 VPWR VGND sg13cmos5l_decap_8
XFILLER_59_49 VPWR VGND sg13cmos5l_decap_8
XFILLER_131_21 VPWR VGND sg13cmos5l_decap_8
XFILLER_39_191 VPWR VGND sg13cmos5l_fill_1
XFILLER_46_117 VPWR VGND sg13cmos5l_decap_4
XFILLER_86_253 VPWR VGND sg13cmos5l_decap_8
XFILLER_131_98 VPWR VGND sg13cmos5l_decap_8
XFILLER_54_194 VPWR VGND sg13cmos5l_fill_2
XFILLER_6_268 VPWR VGND sg13cmos5l_decap_4
XFILLER_108_196 VPWR VGND sg13cmos5l_decap_8
XFILLER_123_122 VPWR VGND sg13cmos5l_decap_8
XFILLER_123_177 VPWR VGND sg13cmos5l_decap_8
XFILLER_49_71 VPWR VGND sg13cmos5l_fill_2
XFILLER_77_220 VPWR VGND sg13cmos5l_decap_8
XFILLER_77_264 VPWR VGND sg13cmos5l_fill_1
XFILLER_45_161 VPWR VGND sg13cmos5l_decap_8
XFILLER_65_70 VPWR VGND sg13cmos5l_decap_8
X_1070_ _1070_/X _0643_/Q _1087_/X _1083_/X _1095_/X _0188_/Q _0187_/Q VPWR VGND sg13cmos5l_mux4_1
XFILLER_92_212 VPWR VGND sg13cmos5l_decap_8
XFILLER_60_142 VPWR VGND sg13cmos5l_decap_8
XFILLER_81_80 VPWR VGND sg13cmos5l_fill_1
X_0854_ Tile_X0Y1_FrameData_O[30] Tile_X0Y1_FrameData[30] VPWR VGND sg13cmos5l_buf_1
X_0923_ Tile_X0Y1_S4BEG[15] _0923_/A VPWR VGND sg13cmos5l_buf_1
XFILLER_114_177 VPWR VGND sg13cmos5l_decap_8
XFILLER_46_0 VPWR VGND sg13cmos5l_fill_2
X_0785_ Tile_X0Y0_N2BEGb[2] _1105_/X VPWR VGND sg13cmos5l_buf_1
XFILLER_83_256 VPWR VGND sg13cmos5l_decap_8
XFILLER_51_131 VPWR VGND sg13cmos5l_decap_8
XFILLER_61_28 VPWR VGND sg13cmos5l_decap_8
X_1199_ _1199_/X Tile_X0Y1_N2MID[4] Tile_X0Y1_N2END[4] _1223_/X Tile_X0Y0_S2MID[4]
+ _0362_/Q _0361_/Q VPWR VGND sg13cmos5l_mux4_1
X_0219_ _0219_/Q Tile_X0Y0_FrameData[1] VGND VPWR Tile_X0Y1_FrameStrobe[3] latch
XFILLER_137_258 VPWR VGND sg13cmos5l_decap_8
XFILLER_105_177 VPWR VGND sg13cmos5l_decap_8
XFILLER_10_87 VPWR VGND sg13cmos5l_decap_8
XFILLER_120_103 VPWR VGND sg13cmos5l_decap_8
XFILLER_126_21 VPWR VGND sg13cmos5l_decap_8
XFILLER_126_65 VPWR VGND sg13cmos5l_decap_8
XFILLER_3_249 VPWR VGND sg13cmos5l_fill_2
XFILLER_59_253 VPWR VGND sg13cmos5l_decap_8
XFILLER_59_264 VPWR VGND sg13cmos5l_fill_1
XFILLER_86_58 VPWR VGND sg13cmos5l_decap_8
XFILLER_19_52 VPWR VGND sg13cmos5l_fill_1
XFILLER_27_150 VPWR VGND sg13cmos5l_fill_2
XFILLER_27_183 VPWR VGND sg13cmos5l_decap_8
XFILLER_74_245 VPWR VGND sg13cmos5l_decap_8
XFILLER_128_203 VPWR VGND sg13cmos5l_decap_8
X_0570_ _0570_/Q Tile_X0Y1_FrameData[0] VGND VPWR Tile_X0Y1_FrameStrobe[6] latch
XFILLER_111_169 VPWR VGND sg13cmos5l_decap_8
XFILLER_2_271 VPWR VGND sg13cmos5l_fill_2
XFILLER_65_212 VPWR VGND sg13cmos5l_decap_8
XFILLER_76_91 VPWR VGND sg13cmos5l_decap_8
X_1122_ _1122_/X _1207_/X _1211_/X _1215_/X _1195_/X _0578_/Q _0577_/Q VPWR VGND sg13cmos5l_mux4_1
XFILLER_25_109 VPWR VGND sg13cmos5l_decap_8
XFILLER_80_248 VPWR VGND sg13cmos5l_decap_8
X_1053_ _1053_/X _0638_/Q _0642_/Q _1082_/X _1093_/X _0222_/Q _0221_/Q VPWR VGND sg13cmos5l_mux4_1
XANTENNA__0803__X Tile_X0Y0_FrameStrobe_O[0] VPWR VGND sg13cmos5l_antennanp
XFILLER_119_236 VPWR VGND sg13cmos5l_decap_8
XFILLER_134_217 VPWR VGND sg13cmos5l_decap_8
X_0906_ Tile_X0Y1_S2BEGb[6] _1225_/X VPWR VGND sg13cmos5l_buf_1
X_0837_ Tile_X0Y1_FrameData_O[13] Tile_X0Y1_FrameData[13] VPWR VGND sg13cmos5l_buf_1
XFILLER_102_103 VPWR VGND sg13cmos5l_decap_4
X_0768_ Tile_X0Y0_WW4BEG[1] _1048_/X VPWR VGND sg13cmos5l_buf_1
X_0699_ _0981_/A3 VPWR VGND sg13cmos5l_tielo
XFILLER_112_23 VPWR VGND sg13cmos5l_fill_2
XFILLER_16_109 VPWR VGND sg13cmos5l_decap_8
XFILLER_56_28 VPWR VGND sg13cmos5l_decap_8
XFILLER_71_226 VPWR VGND sg13cmos5l_decap_8
XFILLER_24_131 VPWR VGND sg13cmos5l_fill_2
XFILLER_72_49 VPWR VGND sg13cmos5l_decap_8
XANTENNA_60 Tile_X0Y1_N4END[4] VPWR VGND sg13cmos5l_antennanp
XANTENNA_71 Tile_X0Y1_N4END[4] VPWR VGND sg13cmos5l_antennanp
XANTENNA_82 Tile_X0Y1_FrameData[19] VPWR VGND sg13cmos5l_antennanp
XANTENNA_93 Tile_X0Y1_FrameData[19] VPWR VGND sg13cmos5l_antennanp
XFILLER_125_206 VPWR VGND sg13cmos5l_decap_8
XFILLER_125_239 VPWR VGND sg13cmos5l_decap_8
XFILLER_137_42 VPWR VGND sg13cmos5l_decap_8
XFILLER_21_53 VPWR VGND sg13cmos5l_fill_1
XFILLER_133_272 VPWR VGND sg13cmos5l_fill_1
XFILLER_47_201 VPWR VGND sg13cmos5l_decap_8
XFILLER_15_153 VPWR VGND sg13cmos5l_decap_8
XFILLER_46_83 VPWR VGND sg13cmos5l_fill_1
XFILLER_30_123 VPWR VGND sg13cmos5l_fill_2
XFILLER_30_189 VPWR VGND sg13cmos5l_decap_8
XFILLER_7_44 VPWR VGND sg13cmos5l_decap_8
XFILLER_116_239 VPWR VGND sg13cmos5l_decap_8
XFILLER_124_272 VPWR VGND sg13cmos5l_fill_1
X_0622_ NPU_ACT_WDATA4 Tile_X0Y1_UserCLK _0986_/X _0663_/L_HI VPWR VGND sg13cmos5l_dfrbpq_1
X_0553_ _0553_/Q Tile_X0Y1_FrameData[17] VGND VPWR Tile_X0Y1_FrameStrobe[6] latch
X_0484_ _0484_/Q Tile_X0Y1_FrameData[22] VGND VPWR Tile_X0Y1_FrameStrobe[4] latch
XFILLER_97_156 VPWR VGND sg13cmos5l_decap_8
XFILLER_38_201 VPWR VGND sg13cmos5l_decap_8
X_1105_ _1105_/X Tile_X0Y1_E2MID[5] Tile_X0Y1_E2END[5] Tile_X0Y1_E6END[5] _1197_/X
+ _0590_/Q _0589_/Q VPWR VGND sg13cmos5l_mux4_1
X_1036_ _1036_/X Tile_X0Y0_EE4END[15] _0641_/Q _1094_/X _1097_/X _0256_/Q _0255_/Q
+ VPWR VGND sg13cmos5l_mux4_1
XFILLER_107_239 VPWR VGND sg13cmos5l_decap_8
XFILLER_107_45 VPWR VGND sg13cmos5l_fill_1
XFILLER_115_272 VPWR VGND sg13cmos5l_fill_1
XFILLER_130_231 VPWR VGND sg13cmos5l_decap_8
XFILLER_29_234 VPWR VGND sg13cmos5l_decap_8
XFILLER_67_49 VPWR VGND sg13cmos5l_decap_8
XFILLER_88_134 VPWR VGND sg13cmos5l_decap_8
XFILLER_12_101 VPWR VGND sg13cmos5l_decap_4
XFILLER_44_226 VPWR VGND sg13cmos5l_decap_8
XFILLER_32_63 VPWR VGND sg13cmos5l_decap_4
XFILLER_32_74 VPWR VGND sg13cmos5l_decap_8
XFILLER_8_105 VPWR VGND sg13cmos5l_fill_1
XFILLER_8_138 VPWR VGND sg13cmos5l_decap_8
XFILLER_106_272 VPWR VGND sg13cmos5l_fill_1
XFILLER_113_0 VPWR VGND sg13cmos5l_fill_1
XFILLER_121_220 VPWR VGND sg13cmos5l_decap_8
XFILLER_121_264 VPWR VGND sg13cmos5l_fill_1
XFILLER_35_226 VPWR VGND sg13cmos5l_decap_8
XFILLER_94_104 VPWR VGND sg13cmos5l_decap_8
XFILLER_50_207 VPWR VGND sg13cmos5l_decap_8
XFILLER_73_70 VPWR VGND sg13cmos5l_decap_8
XFILLER_112_264 VPWR VGND sg13cmos5l_decap_8
X_0605_ _0605_/Q Tile_X0Y1_FrameData[27] VGND VPWR Tile_X0Y1_FrameStrobe[8] latch
X_0536_ _0536_/Q Tile_X0Y1_FrameData[2] VGND VPWR Tile_X0Y1_FrameStrobe[5] latch
X_0467_ _0467_/Q Tile_X0Y1_FrameData[7] VGND VPWR Tile_X0Y1_FrameStrobe[3] latch
XFILLER_41_218 VPWR VGND sg13cmos5l_decap_8
X_1019_ _1019_/X Tile_X0Y0_E1END[0] Tile_X0Y0_EE4END[12] Tile_X0Y0_E6END[4] _1088_/X
+ _0286_/Q _0285_/Q VPWR VGND sg13cmos5l_mux4_1
X_0398_ _0398_/Q Tile_X0Y1_FrameData[12] VGND VPWR Tile_X0Y1_FrameStrobe[1] latch
XFILLER_5_119 VPWR VGND sg13cmos5l_decap_8
XFILLER_103_264 VPWR VGND sg13cmos5l_fill_1
XFILLER_134_21 VPWR VGND sg13cmos5l_decap_8
XFILLER_134_98 VPWR VGND sg13cmos5l_decap_8
XFILLER_27_63 VPWR VGND sg13cmos5l_decap_4
XFILLER_76_126 VPWR VGND sg13cmos5l_decap_8
XFILLER_94_25 VPWR VGND sg13cmos5l_decap_8
XFILLER_91_118 VPWR VGND sg13cmos5l_decap_8
XFILLER_43_40 VPWR VGND sg13cmos5l_decap_4
XFILLER_84_192 VPWR VGND sg13cmos5l_decap_8
XANTENNA__0901__X Tile_X0Y1_S2BEGb[1] VPWR VGND sg13cmos5l_antennanp
XFILLER_138_161 VPWR VGND sg13cmos5l_decap_8
XFILLER_4_56 VPWR VGND sg13cmos5l_decap_8
XFILLER_68_81 VPWR VGND sg13cmos5l_decap_8
X_0321_ _0321_/Q Tile_X0Y0_FrameData[27] VGND VPWR Tile_X0Y1_FrameStrobe[7] latch
XFILLER_23_207 VPWR VGND sg13cmos5l_decap_8
X_0252_ _0252_/Q Tile_X0Y0_FrameData[0] VGND VPWR Tile_X0Y1_FrameStrobe[4] latch
X_0183_ _0183_/Q Tile_X0Y0_FrameData[5] VGND VPWR Tile_X0Y1_FrameStrobe[2] latch
XFILLER_90_162 VPWR VGND sg13cmos5l_decap_8
XFILLER_31_240 VPWR VGND sg13cmos5l_decap_8
XFILLER_76_0 VPWR VGND sg13cmos5l_decap_8
XANTENNA__0811__X Tile_X0Y0_FrameStrobe_O[8] VPWR VGND sg13cmos5l_antennanp
XFILLER_129_183 VPWR VGND sg13cmos5l_decap_8
XFILLER_100_234 VPWR VGND sg13cmos5l_fill_2
XFILLER_58_126 VPWR VGND sg13cmos5l_decap_8
XFILLER_66_181 VPWR VGND sg13cmos5l_decap_8
X_0519_ _0519_/Q Tile_X0Y1_FrameData[19] VGND VPWR Tile_X0Y1_FrameStrobe[5] latch
XFILLER_98_251 VPWR VGND sg13cmos5l_decap_8
XFILLER_14_229 VPWR VGND sg13cmos5l_decap_8
XFILLER_64_28 VPWR VGND sg13cmos5l_decap_8
XFILLER_81_162 VPWR VGND sg13cmos5l_decap_8
XANTENNA__0721__X Tile_X0Y0_W1BEG[2] VPWR VGND sg13cmos5l_antennanp
XFILLER_129_21 VPWR VGND sg13cmos5l_decap_8
XFILLER_129_98 VPWR VGND sg13cmos5l_decap_8
XFILLER_135_142 VPWR VGND sg13cmos5l_decap_8
XFILLER_22_262 VPWR VGND sg13cmos5l_fill_2
XFILLER_1_100 VPWR VGND sg13cmos5l_decap_8
XFILLER_1_111 VPWR VGND sg13cmos5l_fill_1
XFILLER_54_50 VPWR VGND sg13cmos5l_decap_8
XFILLER_72_140 VPWR VGND sg13cmos5l_decap_8
X_0870_ Tile_X0Y0_FrameData_O[14] Tile_X0Y0_FrameData[14] VPWR VGND sg13cmos5l_buf_1
XFILLER_9_233 VPWR VGND sg13cmos5l_decap_8
XFILLER_126_142 VPWR VGND sg13cmos5l_decap_8
XFILLER_141_101 VPWR VGND sg13cmos5l_decap_8
XFILLER_70_93 VPWR VGND sg13cmos5l_fill_1
XFILLER_55_129 VPWR VGND sg13cmos5l_decap_8
X_0304_ _0304_/Q Tile_X0Y0_FrameData[12] VGND VPWR Tile_X0Y1_FrameStrobe[6] latch
X_0235_ _0235_/Q Tile_X0Y0_FrameData[17] VGND VPWR Tile_X0Y1_FrameStrobe[4] latch
XFILLER_95_232 VPWR VGND sg13cmos5l_decap_8
XANTENNA__0806__X Tile_X0Y0_FrameStrobe_O[3] VPWR VGND sg13cmos5l_antennanp
XFILLER_48_181 VPWR VGND sg13cmos5l_decap_8
XFILLER_63_140 VPWR VGND sg13cmos5l_decap_8
X_0166_ _0166_/Q Tile_X0Y0_FrameData[22] VGND VPWR Tile_X0Y1_FrameStrobe[2] latch
X_0097_ _0097_/Q Tile_X0Y0_FrameData[27] VGND VPWR Tile_X0Y1_FrameStrobe[0] latch
XFILLER_117_131 VPWR VGND sg13cmos5l_decap_8
X_0999_ _0999_/X Tile_X0Y0_E1END[0] Tile_X0Y0_E6END[4] _1075_/X _1100_/X _0346_/Q
+ _0345_/Q VPWR VGND sg13cmos5l_mux4_1
XFILLER_115_12 VPWR VGND sg13cmos5l_decap_4
XFILLER_132_112 VPWR VGND sg13cmos5l_decap_8
XFILLER_132_189 VPWR VGND sg13cmos5l_decap_8
XFILLER_59_28 VPWR VGND sg13cmos5l_decap_8
XFILLER_86_232 VPWR VGND sg13cmos5l_decap_8
XFILLER_46_107 VPWR VGND sg13cmos5l_fill_2
XFILLER_75_49 VPWR VGND sg13cmos5l_decap_8
XFILLER_131_77 VPWR VGND sg13cmos5l_decap_8
XFILLER_54_173 VPWR VGND sg13cmos5l_decap_8
XFILLER_108_142 VPWR VGND sg13cmos5l_decap_4
XFILLER_108_175 VPWR VGND sg13cmos5l_decap_8
XFILLER_123_101 VPWR VGND sg13cmos5l_decap_8
XFILLER_40_85 VPWR VGND sg13cmos5l_fill_1
XFILLER_6_0 VPWR VGND sg13cmos5l_decap_8
XFILLER_6_247 VPWR VGND sg13cmos5l_decap_8
XFILLER_123_156 VPWR VGND sg13cmos5l_decap_8
XFILLER_1_35 VPWR VGND sg13cmos5l_decap_8
XFILLER_37_107 VPWR VGND sg13cmos5l_fill_2
XFILLER_49_94 VPWR VGND sg13cmos5l_decap_4
XFILLER_60_121 VPWR VGND sg13cmos5l_decap_8
XFILLER_92_268 VPWR VGND sg13cmos5l_decap_4
XFILLER_81_70 VPWR VGND sg13cmos5l_decap_4
X_0853_ Tile_X0Y1_FrameData_O[29] Tile_X0Y1_FrameData[29] VPWR VGND sg13cmos5l_buf_1
X_0922_ Tile_X0Y1_S4BEG[14] _0922_/A VPWR VGND sg13cmos5l_buf_1
XFILLER_114_101 VPWR VGND sg13cmos5l_fill_1
XFILLER_114_156 VPWR VGND sg13cmos5l_decap_8
XFILLER_39_0 VPWR VGND sg13cmos5l_decap_4
XFILLER_53_2 VPWR VGND sg13cmos5l_fill_1
X_0784_ Tile_X0Y0_N2BEGb[1] _1104_/X VPWR VGND sg13cmos5l_buf_1
XFILLER_83_235 VPWR VGND sg13cmos5l_decap_8
XFILLER_83_268 VPWR VGND sg13cmos5l_decap_4
X_1198_ _1198_/X Tile_X0Y1_N2MID[3] Tile_X0Y1_N2END[3] _1222_/X Tile_X0Y0_S2MID[3]
+ _0364_/Q _0363_/Q VPWR VGND sg13cmos5l_mux4_1
X_0218_ _0218_/Q Tile_X0Y0_FrameData[2] VGND VPWR Tile_X0Y1_FrameStrobe[3] latch
XFILLER_51_187 VPWR VGND sg13cmos5l_decap_8
X_0149_ _0149_/Q Tile_X0Y0_FrameData[7] VGND VPWR Tile_X0Y1_FrameStrobe[1] latch
XFILLER_124_8 VPWR VGND sg13cmos5l_decap_8
XFILLER_137_237 VPWR VGND sg13cmos5l_decap_8
XFILLER_3_228 VPWR VGND sg13cmos5l_decap_8
XFILLER_105_145 VPWR VGND sg13cmos5l_decap_8
XFILLER_120_159 VPWR VGND sg13cmos5l_decap_8
XFILLER_126_44 VPWR VGND sg13cmos5l_decap_8
XFILLER_59_232 VPWR VGND sg13cmos5l_decap_8
XFILLER_86_26 VPWR VGND sg13cmos5l_decap_8
XFILLER_27_162 VPWR VGND sg13cmos5l_decap_8
XFILLER_74_224 VPWR VGND sg13cmos5l_decap_8
XFILLER_128_259 VPWR VGND sg13cmos5l_decap_8
XFILLER_42_187 VPWR VGND sg13cmos5l_decap_8
XFILLER_2_250 VPWR VGND sg13cmos5l_decap_4
XFILLER_76_70 VPWR VGND sg13cmos5l_decap_8
X_1052_ _1052_/X _0637_/Q _0641_/Q _1081_/X _1094_/X _0224_/Q _0223_/Q VPWR VGND sg13cmos5l_mux4_1
X_1121_ _1121_/X Tile_X0Y1_E1END[0] Tile_X0Y1_EE4END[0] Tile_X0Y1_E6END[8] _1203_/X
+ _0578_/Q _0577_/Q VPWR VGND sg13cmos5l_mux4_1
XFILLER_18_184 VPWR VGND sg13cmos5l_fill_1
XFILLER_33_187 VPWR VGND sg13cmos5l_decap_8
XFILLER_80_227 VPWR VGND sg13cmos5l_decap_8
XFILLER_92_80 VPWR VGND sg13cmos5l_decap_8
XFILLER_119_215 VPWR VGND sg13cmos5l_decap_8
X_0905_ Tile_X0Y1_S2BEGb[5] _1224_/X VPWR VGND sg13cmos5l_buf_1
X_0836_ Tile_X0Y1_FrameData_O[12] Tile_X0Y1_FrameData[12] VPWR VGND sg13cmos5l_buf_1
X_0767_ Tile_X0Y0_WW4BEG[0] _1047_/X VPWR VGND sg13cmos5l_buf_1
X_0698_ _0698_/L_HI VPWR VGND sg13cmos5l_tiehi
XFILLER_56_224 VPWR VGND sg13cmos5l_decap_8
XFILLER_56_257 VPWR VGND sg13cmos5l_decap_8
XFILLER_56_268 VPWR VGND sg13cmos5l_decap_4
XFILLER_71_205 VPWR VGND sg13cmos5l_decap_8
XFILLER_72_28 VPWR VGND sg13cmos5l_decap_8
XANTENNA_50 Tile_X0Y1_N4END[4] VPWR VGND sg13cmos5l_antennanp
XANTENNA_61 Tile_X0Y1_N4END[4] VPWR VGND sg13cmos5l_antennanp
XANTENNA_72 Tile_X0Y1_N4END[4] VPWR VGND sg13cmos5l_antennanp
XANTENNA_83 Tile_X0Y1_FrameData[19] VPWR VGND sg13cmos5l_antennanp
XANTENNA_94 Tile_X0Y1_FrameData[19] VPWR VGND sg13cmos5l_antennanp
XFILLER_133_262 VPWR VGND sg13cmos5l_fill_2
XFILLER_137_21 VPWR VGND sg13cmos5l_decap_8
XFILLER_137_98 VPWR VGND sg13cmos5l_decap_8
XFILLER_101_181 VPWR VGND sg13cmos5l_decap_8
XFILLER_47_257 VPWR VGND sg13cmos5l_decap_8
XFILLER_47_268 VPWR VGND sg13cmos5l_decap_4
XANTENNA__0904__X Tile_X0Y1_S2BEGb[4] VPWR VGND sg13cmos5l_antennanp
XFILLER_15_121 VPWR VGND sg13cmos5l_fill_2
XFILLER_15_132 VPWR VGND sg13cmos5l_decap_8
XFILLER_46_73 VPWR VGND sg13cmos5l_decap_4
XFILLER_116_218 VPWR VGND sg13cmos5l_decap_8
XFILLER_30_168 VPWR VGND sg13cmos5l_decap_8
XFILLER_7_23 VPWR VGND sg13cmos5l_decap_8
X_0621_ NPU_ACT_WDATA3 Tile_X0Y1_UserCLK _0985_/X _0662_/L_HI VPWR VGND sg13cmos5l_dfrbpq_1
XFILLER_124_251 VPWR VGND sg13cmos5l_decap_8
X_0552_ _0552_/Q Tile_X0Y1_FrameData[18] VGND VPWR Tile_X0Y1_FrameStrobe[6] latch
X_0483_ _0483_/Q Tile_X0Y1_FrameData[23] VGND VPWR Tile_X0Y1_FrameStrobe[4] latch
XFILLER_53_227 VPWR VGND sg13cmos5l_decap_8
X_1035_ _1035_/X Tile_X0Y0_EE4END[8] _0640_/Q _1095_/X _1096_/X _0258_/Q _0257_/Q
+ VPWR VGND sg13cmos5l_mux4_1
X_1104_ _1104_/X Tile_X0Y1_E2MID[6] Tile_X0Y1_E2END[6] Tile_X0Y1_E6END[6] _1196_/X
+ _0592_/Q _0591_/Q VPWR VGND sg13cmos5l_mux4_1
XANTENNA__0814__X Tile_X0Y0_FrameStrobe_O[11] VPWR VGND sg13cmos5l_antennanp
XFILLER_21_113 VPWR VGND sg13cmos5l_fill_1
XFILLER_61_271 VPWR VGND sg13cmos5l_fill_2
XFILLER_107_218 VPWR VGND sg13cmos5l_decap_8
XFILLER_130_210 VPWR VGND sg13cmos5l_decap_8
X_0819_ Tile_X0Y0_FrameStrobe_O[16] Tile_X0Y1_FrameStrobe[16] VPWR VGND sg13cmos5l_buf_1
XFILLER_29_213 VPWR VGND sg13cmos5l_decap_8
XFILLER_44_205 VPWR VGND sg13cmos5l_decap_8
XFILLER_67_28 VPWR VGND sg13cmos5l_decap_8
XFILLER_88_157 VPWR VGND sg13cmos5l_fill_1
XFILLER_88_179 VPWR VGND sg13cmos5l_decap_8
XFILLER_96_190 VPWR VGND sg13cmos5l_decap_8
XANTENNA__0724__X Tile_X0Y0_W2BEG[1] VPWR VGND sg13cmos5l_antennanp
XFILLER_16_98 VPWR VGND sg13cmos5l_decap_4
XFILLER_12_179 VPWR VGND sg13cmos5l_decap_8
XFILLER_8_117 VPWR VGND sg13cmos5l_decap_8
XFILLER_106_0 VPWR VGND sg13cmos5l_fill_2
XFILLER_106_251 VPWR VGND sg13cmos5l_decap_8
XFILLER_121_243 VPWR VGND sg13cmos5l_decap_8
XFILLER_79_179 VPWR VGND sg13cmos5l_decap_8
XFILLER_35_205 VPWR VGND sg13cmos5l_decap_8
XFILLER_43_271 VPWR VGND sg13cmos5l_fill_2
XFILLER_11_190 VPWR VGND sg13cmos5l_decap_8
X_0604_ _0604_/Q Tile_X0Y1_FrameData[26] VGND VPWR Tile_X0Y1_FrameStrobe[8] latch
XANTENNA__0809__X Tile_X0Y0_FrameStrobe_O[6] VPWR VGND sg13cmos5l_antennanp
XFILLER_112_243 VPWR VGND sg13cmos5l_decap_8
X_0535_ _0535_/Q Tile_X0Y1_FrameData[3] VGND VPWR Tile_X0Y1_FrameStrobe[5] latch
X_0466_ _0466_/Q Tile_X0Y1_FrameData[8] VGND VPWR Tile_X0Y1_FrameStrobe[3] latch
X_0397_ _0397_/Q Tile_X0Y1_FrameData[13] VGND VPWR Tile_X0Y1_FrameStrobe[1] latch
XFILLER_98_90 VPWR VGND sg13cmos5l_fill_2
XFILLER_26_249 VPWR VGND sg13cmos5l_decap_8
X_1018_ _1018_/X _1084_/X _1080_/X _1079_/X _1095_/X _0313_/Q _0312_/Q VPWR VGND sg13cmos5l_mux4_1
XFILLER_93_193 VPWR VGND sg13cmos5l_decap_8
XFILLER_103_243 VPWR VGND sg13cmos5l_decap_8
XFILLER_76_105 VPWR VGND sg13cmos5l_decap_8
XANTENNA__0719__X Tile_X0Y0_W1BEG[0] VPWR VGND sg13cmos5l_antennanp
XFILLER_134_77 VPWR VGND sg13cmos5l_decap_8
XFILLER_17_238 VPWR VGND sg13cmos5l_fill_1
XFILLER_84_171 VPWR VGND sg13cmos5l_decap_8
XFILLER_25_260 VPWR VGND sg13cmos5l_fill_1
XFILLER_40_263 VPWR VGND sg13cmos5l_fill_2
XFILLER_138_140 VPWR VGND sg13cmos5l_decap_8
XFILLER_4_175 VPWR VGND sg13cmos5l_decap_8
XFILLER_99_219 VPWR VGND sg13cmos5l_decap_8
XFILLER_4_35 VPWR VGND sg13cmos5l_decap_8
XFILLER_67_149 VPWR VGND sg13cmos5l_decap_8
X_0320_ _0320_/Q Tile_X0Y0_FrameData[28] VGND VPWR Tile_X0Y1_FrameStrobe[7] latch
X_0251_ _0251_/Q Tile_X0Y0_FrameData[1] VGND VPWR Tile_X0Y1_FrameStrobe[4] latch
XFILLER_75_182 VPWR VGND sg13cmos5l_decap_8
X_0182_ _0182_/Q Tile_X0Y0_FrameData[6] VGND VPWR Tile_X0Y1_FrameStrobe[2] latch
XFILLER_129_162 VPWR VGND sg13cmos5l_decap_8
XFILLER_69_0 VPWR VGND sg13cmos5l_decap_8
X_0518_ _0518_/Q Tile_X0Y1_FrameData[20] VGND VPWR Tile_X0Y1_FrameStrobe[5] latch
XFILLER_98_230 VPWR VGND sg13cmos5l_decap_8
XFILLER_100_213 VPWR VGND sg13cmos5l_decap_8
XFILLER_66_160 VPWR VGND sg13cmos5l_decap_8
XFILLER_73_119 VPWR VGND sg13cmos5l_decap_8
X_0449_ _0449_/Q Tile_X0Y1_FrameData[25] VGND VPWR Tile_X0Y1_FrameStrobe[3] latch
XFILLER_120_68 VPWR VGND sg13cmos5l_fill_2
XFILLER_14_208 VPWR VGND sg13cmos5l_decap_8
XFILLER_22_241 VPWR VGND sg13cmos5l_decap_8
XFILLER_81_141 VPWR VGND sg13cmos5l_decap_8
XFILLER_129_77 VPWR VGND sg13cmos5l_decap_8
XFILLER_13_99 VPWR VGND sg13cmos5l_decap_8
XFILLER_89_26 VPWR VGND sg13cmos5l_decap_4
XFILLER_135_198 VPWR VGND sg13cmos5l_decap_8
XFILLER_1_123 VPWR VGND sg13cmos5l_decap_8
XFILLER_1_134 VPWR VGND sg13cmos5l_fill_1
XFILLER_1_178 VPWR VGND sg13cmos5l_decap_4
XFILLER_49_149 VPWR VGND sg13cmos5l_decap_8
XFILLER_38_74 VPWR VGND sg13cmos5l_decap_8
XFILLER_38_85 VPWR VGND sg13cmos5l_fill_1
XFILLER_64_119 VPWR VGND sg13cmos5l_decap_8
XFILLER_72_196 VPWR VGND sg13cmos5l_decap_8
XANTENNA__0912__X Tile_X0Y1_S4BEG[4] VPWR VGND sg13cmos5l_antennanp
XFILLER_13_252 VPWR VGND sg13cmos5l_decap_8
XFILLER_9_212 VPWR VGND sg13cmos5l_decap_8
XFILLER_126_121 VPWR VGND sg13cmos5l_decap_8
XFILLER_126_198 VPWR VGND sg13cmos5l_decap_8
XFILLER_141_135 VPWR VGND sg13cmos5l_decap_8
XFILLER_62_7 VPWR VGND sg13cmos5l_decap_8
XFILLER_79_81 VPWR VGND sg13cmos5l_decap_4
XFILLER_48_160 VPWR VGND sg13cmos5l_decap_8
XFILLER_55_108 VPWR VGND sg13cmos5l_decap_8
X_0303_ _0303_/Q Tile_X0Y0_FrameData[13] VGND VPWR Tile_X0Y1_FrameStrobe[6] latch
X_0234_ _0234_/Q Tile_X0Y0_FrameData[18] VGND VPWR Tile_X0Y1_FrameStrobe[4] latch
XFILLER_95_211 VPWR VGND sg13cmos5l_decap_8
XFILLER_63_196 VPWR VGND sg13cmos5l_decap_8
X_0165_ _0165_/Q Tile_X0Y0_FrameData[23] VGND VPWR Tile_X0Y1_FrameStrobe[2] latch
X_0096_ _0096_/Q Tile_X0Y0_FrameData[28] VGND VPWR Tile_X0Y1_FrameStrobe[0] latch
XANTENNA__0822__X Tile_X0Y0_FrameStrobe_O[19] VPWR VGND sg13cmos5l_antennanp
X_0998_ _0998_/X Tile_X0Y0_EE4END[3] Tile_X0Y0_EE4END[11] Tile_X0Y0_E6END[3] _1091_/X
+ _0172_/Q _0171_/Q VPWR VGND sg13cmos5l_mux4_1
XFILLER_115_68 VPWR VGND sg13cmos5l_fill_1
XFILLER_117_187 VPWR VGND sg13cmos5l_decap_8
XFILLER_132_168 VPWR VGND sg13cmos5l_decap_8
XFILLER_75_28 VPWR VGND sg13cmos5l_decap_8
XFILLER_86_211 VPWR VGND sg13cmos5l_decap_8
XFILLER_131_56 VPWR VGND sg13cmos5l_decap_8
XFILLER_39_182 VPWR VGND sg13cmos5l_decap_8
XFILLER_54_152 VPWR VGND sg13cmos5l_decap_8
XFILLER_91_27 VPWR VGND sg13cmos5l_decap_4
XANTENNA__0732__X Tile_X0Y0_W2BEGb[1] VPWR VGND sg13cmos5l_antennanp
XFILLER_10_244 VPWR VGND sg13cmos5l_decap_8
XFILLER_24_10 VPWR VGND sg13cmos5l_fill_1
XFILLER_6_226 VPWR VGND sg13cmos5l_decap_8
XFILLER_108_154 VPWR VGND sg13cmos5l_decap_8
XFILLER_40_31 VPWR VGND sg13cmos5l_decap_4
XFILLER_1_14 VPWR VGND sg13cmos5l_decap_8
XFILLER_77_255 VPWR VGND sg13cmos5l_decap_8
XFILLER_92_247 VPWR VGND sg13cmos5l_decap_8
XANTENNA__0907__X Tile_X0Y1_S2BEGb[7] VPWR VGND sg13cmos5l_antennanp
XFILLER_45_196 VPWR VGND sg13cmos5l_decap_8
X_0921_ Tile_X0Y1_S4BEG[13] _0921_/A VPWR VGND sg13cmos5l_buf_1
XFILLER_60_199 VPWR VGND sg13cmos5l_decap_8
X_0852_ Tile_X0Y1_FrameData_O[28] Tile_X0Y1_FrameData[28] VPWR VGND sg13cmos5l_buf_1
X_0783_ Tile_X0Y0_N2BEGb[0] _1103_/X VPWR VGND sg13cmos5l_buf_1
XFILLER_122_190 VPWR VGND sg13cmos5l_decap_8
XFILLER_68_255 VPWR VGND sg13cmos5l_decap_8
XANTENNA__0817__X Tile_X0Y0_FrameStrobe_O[14] VPWR VGND sg13cmos5l_antennanp
XFILLER_36_141 VPWR VGND sg13cmos5l_decap_8
XFILLER_36_185 VPWR VGND sg13cmos5l_decap_8
XFILLER_83_214 VPWR VGND sg13cmos5l_decap_8
X_1197_ _1197_/X Tile_X0Y1_N2MID[2] Tile_X0Y1_N2END[2] _1221_/X Tile_X0Y0_S2MID[2]
+ _0366_/Q _0365_/Q VPWR VGND sg13cmos5l_mux4_1
X_0217_ _0217_/Q Tile_X0Y0_FrameData[3] VGND VPWR Tile_X0Y1_FrameStrobe[3] latch
X_0148_ _0148_/Q Tile_X0Y0_FrameData[8] VGND VPWR Tile_X0Y1_FrameStrobe[1] latch
XFILLER_101_48 VPWR VGND sg13cmos5l_decap_8
XFILLER_137_216 VPWR VGND sg13cmos5l_decap_8
XFILLER_51_166 VPWR VGND sg13cmos5l_decap_8
X_0079_ _0922_/A _1139_/X _1140_/X _0534_/Q VPWR VGND sg13cmos5l_mux2_1
XFILLER_105_124 VPWR VGND sg13cmos5l_decap_4
XFILLER_3_207 VPWR VGND sg13cmos5l_decap_8
XFILLER_120_138 VPWR VGND sg13cmos5l_decap_8
XFILLER_59_211 VPWR VGND sg13cmos5l_decap_8
XFILLER_74_203 VPWR VGND sg13cmos5l_decap_8
XANTENNA__0727__X Tile_X0Y0_W2BEG[4] VPWR VGND sg13cmos5l_antennanp
XFILLER_42_144 VPWR VGND sg13cmos5l_decap_4
XFILLER_42_166 VPWR VGND sg13cmos5l_decap_8
XFILLER_128_238 VPWR VGND sg13cmos5l_decap_8
XFILLER_136_0 VPWR VGND sg13cmos5l_decap_8
XFILLER_18_163 VPWR VGND sg13cmos5l_decap_8
XFILLER_80_206 VPWR VGND sg13cmos5l_decap_8
X_1051_ _1051_/X _0636_/Q _0640_/Q _1080_/X _1095_/X _0226_/Q _0225_/Q VPWR VGND sg13cmos5l_mux4_1
X_1120_ _1120_/X _1208_/X _1212_/X _1216_/X _1196_/X _0575_/Q _0574_/Q VPWR VGND sg13cmos5l_mux4_1
XFILLER_18_196 VPWR VGND sg13cmos5l_decap_8
X_0904_ Tile_X0Y1_S2BEGb[4] _1223_/X VPWR VGND sg13cmos5l_buf_1
XFILLER_92_70 VPWR VGND sg13cmos5l_fill_2
XFILLER_51_0 VPWR VGND sg13cmos5l_fill_1
X_0835_ Tile_X0Y1_FrameData_O[11] Tile_X0Y1_FrameData[11] VPWR VGND sg13cmos5l_buf_1
X_0766_ Tile_X0Y0_N4BEG[15] _0766_/A VPWR VGND sg13cmos5l_buf_1
X_0697_ _0697_/L_HI VPWR VGND sg13cmos5l_tiehi
XFILLER_102_116 VPWR VGND sg13cmos5l_fill_1
XFILLER_102_138 VPWR VGND sg13cmos5l_fill_2
XFILLER_110_182 VPWR VGND sg13cmos5l_decap_8
XFILLER_56_203 VPWR VGND sg13cmos5l_decap_8
XFILLER_112_25 VPWR VGND sg13cmos5l_fill_1
XANTENNA_40 Tile_X0Y1_N2MID[5] VPWR VGND sg13cmos5l_antennanp
XANTENNA_51 Tile_X0Y1_N4END[4] VPWR VGND sg13cmos5l_antennanp
XANTENNA_62 Tile_X0Y1_N4END[4] VPWR VGND sg13cmos5l_antennanp
XANTENNA_73 Tile_X0Y1_N4END[4] VPWR VGND sg13cmos5l_antennanp
XANTENNA_84 Tile_X0Y1_FrameData[19] VPWR VGND sg13cmos5l_antennanp
XANTENNA_95 Tile_X0Y1_FrameData[19] VPWR VGND sg13cmos5l_antennanp
XFILLER_21_44 VPWR VGND sg13cmos5l_fill_2
XFILLER_108_4 VPWR VGND sg13cmos5l_fill_1
XFILLER_118_271 VPWR VGND sg13cmos5l_fill_2
XFILLER_133_241 VPWR VGND sg13cmos5l_decap_8
XFILLER_137_77 VPWR VGND sg13cmos5l_decap_8
XFILLER_101_160 VPWR VGND sg13cmos5l_decap_8
XFILLER_47_236 VPWR VGND sg13cmos5l_decap_8
XFILLER_62_217 VPWR VGND sg13cmos5l_decap_8
XFILLER_15_188 VPWR VGND sg13cmos5l_decap_8
XFILLER_30_125 VPWR VGND sg13cmos5l_fill_1
XFILLER_62_84 VPWR VGND sg13cmos5l_decap_8
XFILLER_70_272 VPWR VGND sg13cmos5l_fill_1
XFILLER_87_9 VPWR VGND sg13cmos5l_decap_8
XANTENNA__0920__X Tile_X0Y1_S4BEG[12] VPWR VGND sg13cmos5l_antennanp
XFILLER_7_79 VPWR VGND sg13cmos5l_decap_8
X_0620_ NPU_ACT_WDATA2 Tile_X0Y1_UserCLK _0984_/X _0661_/L_HI VPWR VGND sg13cmos5l_dfrbpq_1
X_0551_ _0551_/Q Tile_X0Y1_FrameData[19] VGND VPWR Tile_X0Y1_FrameStrobe[6] latch
XFILLER_38_236 VPWR VGND sg13cmos5l_decap_8
X_0482_ _0482_/Q Tile_X0Y1_FrameData[24] VGND VPWR Tile_X0Y1_FrameStrobe[4] latch
XFILLER_21_103 VPWR VGND sg13cmos5l_decap_4
XFILLER_38_269 VPWR VGND sg13cmos5l_decap_4
XFILLER_53_206 VPWR VGND sg13cmos5l_decap_8
XFILLER_61_250 VPWR VGND sg13cmos5l_decap_8
X_1034_ _1034_/X Tile_X0Y0_EE4END[7] _0639_/Q _1095_/X _1096_/X _0260_/Q _0259_/Q
+ VPWR VGND sg13cmos5l_mux4_1
X_1103_ _1103_/X Tile_X0Y1_E2MID[7] Tile_X0Y1_E2END[7] Tile_X0Y1_E6END[7] _1195_/X
+ _0594_/Q _0593_/Q VPWR VGND sg13cmos5l_mux4_1
XFILLER_21_125 VPWR VGND sg13cmos5l_decap_8
XFILLER_99_0 VPWR VGND sg13cmos5l_decap_4
XANTENNA__0830__X Tile_X0Y1_FrameData_O[6] VPWR VGND sg13cmos5l_antennanp
XFILLER_115_252 VPWR VGND sg13cmos5l_decap_8
XFILLER_115_263 VPWR VGND sg13cmos5l_fill_2
X_0818_ Tile_X0Y0_FrameStrobe_O[15] Tile_X0Y1_FrameStrobe[15] VPWR VGND sg13cmos5l_buf_1
X_0749_ Tile_X0Y0_W6BEG[10] _1073_/X VPWR VGND sg13cmos5l_buf_1
XFILLER_130_266 VPWR VGND sg13cmos5l_decap_8
XFILLER_29_269 VPWR VGND sg13cmos5l_decap_4
XFILLER_12_136 VPWR VGND sg13cmos5l_decap_8
XFILLER_12_158 VPWR VGND sg13cmos5l_decap_8
XFILLER_52_261 VPWR VGND sg13cmos5l_decap_4
XFILLER_52_272 VPWR VGND sg13cmos5l_fill_1
XANTENNA__0740__X Tile_X0Y0_W6BEG[1] VPWR VGND sg13cmos5l_antennanp
XFILLER_106_230 VPWR VGND sg13cmos5l_decap_8
XFILLER_79_114 VPWR VGND sg13cmos5l_decap_4
XFILLER_79_158 VPWR VGND sg13cmos5l_decap_8
XFILLER_87_180 VPWR VGND sg13cmos5l_decap_8
XANTENNA__0915__X Tile_X0Y1_S4BEG[7] VPWR VGND sg13cmos5l_antennanp
XFILLER_43_250 VPWR VGND sg13cmos5l_decap_8
XFILLER_57_84 VPWR VGND sg13cmos5l_decap_8
XFILLER_112_222 VPWR VGND sg13cmos5l_decap_8
XFILLER_7_184 VPWR VGND sg13cmos5l_decap_8
X_0603_ _0603_/Q Tile_X0Y1_FrameData[31] VGND VPWR Tile_X0Y1_FrameStrobe[0] latch
X_0534_ _0534_/Q Tile_X0Y1_FrameData[4] VGND VPWR Tile_X0Y1_FrameStrobe[5] latch
XFILLER_14_0 VPWR VGND sg13cmos5l_fill_2
XFILLER_26_228 VPWR VGND sg13cmos5l_decap_8
X_0465_ _0465_/Q Tile_X0Y1_FrameData[9] VGND VPWR Tile_X0Y1_FrameStrobe[3] latch
X_0396_ _0396_/Q Tile_X0Y1_FrameData[14] VGND VPWR Tile_X0Y1_FrameStrobe[1] latch
XANTENNA__0825__X Tile_X0Y1_FrameData_O[1] VPWR VGND sg13cmos5l_antennanp
XFILLER_34_272 VPWR VGND sg13cmos5l_fill_1
X_1017_ _1017_/X Tile_X0Y0_E1END[3] Tile_X0Y0_EE4END[3] Tile_X0Y0_E6END[11] _1091_/X
+ _0313_/Q _0312_/Q VPWR VGND sg13cmos5l_mux4_1
XFILLER_103_222 VPWR VGND sg13cmos5l_decap_8
XFILLER_118_79 VPWR VGND sg13cmos5l_fill_1
XFILLER_134_56 VPWR VGND sg13cmos5l_decap_8
XANTENNA__0735__X Tile_X0Y0_W2BEGb[4] VPWR VGND sg13cmos5l_antennanp
XFILLER_17_217 VPWR VGND sg13cmos5l_decap_8
XFILLER_84_150 VPWR VGND sg13cmos5l_decap_8
XFILLER_25_272 VPWR VGND sg13cmos5l_fill_1
XFILLER_40_231 VPWR VGND sg13cmos5l_fill_1
XFILLER_138_196 VPWR VGND sg13cmos5l_decap_8
XFILLER_4_14 VPWR VGND sg13cmos5l_decap_8
XFILLER_4_154 VPWR VGND sg13cmos5l_decap_8
XFILLER_67_128 VPWR VGND sg13cmos5l_decap_8
XFILLER_68_61 VPWR VGND sg13cmos5l_fill_2
XFILLER_68_94 VPWR VGND sg13cmos5l_decap_8
XFILLER_75_161 VPWR VGND sg13cmos5l_decap_8
X_0250_ _0250_/Q Tile_X0Y0_FrameData[2] VGND VPWR Tile_X0Y1_FrameStrobe[4] latch
X_0181_ _0181_/Q Tile_X0Y0_FrameData[7] VGND VPWR Tile_X0Y1_FrameStrobe[2] latch
XFILLER_16_272 VPWR VGND sg13cmos5l_fill_1
XFILLER_84_82 VPWR VGND sg13cmos5l_decap_4
XFILLER_90_197 VPWR VGND sg13cmos5l_decap_8
XFILLER_129_141 VPWR VGND sg13cmos5l_decap_8
X_0517_ _0517_/Q Tile_X0Y1_FrameData[21] VGND VPWR Tile_X0Y1_FrameStrobe[5] latch
XFILLER_100_236 VPWR VGND sg13cmos5l_fill_1
XFILLER_100_269 VPWR VGND sg13cmos5l_decap_4
XFILLER_104_59 VPWR VGND sg13cmos5l_decap_8
XFILLER_120_14 VPWR VGND sg13cmos5l_decap_4
X_0448_ _0448_/Q Tile_X0Y1_FrameData[26] VGND VPWR Tile_X0Y1_FrameStrobe[3] latch
X_0379_ _0379_/Q Tile_X0Y1_FrameData[31] VGND VPWR Tile_X0Y1_FrameStrobe[1] latch
XFILLER_22_220 VPWR VGND sg13cmos5l_decap_8
XFILLER_22_264 VPWR VGND sg13cmos5l_fill_1
XFILLER_81_197 VPWR VGND sg13cmos5l_decap_8
XFILLER_129_56 VPWR VGND sg13cmos5l_decap_8
XFILLER_135_177 VPWR VGND sg13cmos5l_decap_8
XFILLER_1_157 VPWR VGND sg13cmos5l_decap_8
XFILLER_49_128 VPWR VGND sg13cmos5l_decap_8
XFILLER_89_242 VPWR VGND sg13cmos5l_decap_8
XFILLER_89_264 VPWR VGND sg13cmos5l_fill_1
XFILLER_13_231 VPWR VGND sg13cmos5l_decap_8
XFILLER_54_85 VPWR VGND sg13cmos5l_decap_4
XFILLER_72_175 VPWR VGND sg13cmos5l_decap_8
XFILLER_126_100 VPWR VGND sg13cmos5l_decap_8
XFILLER_70_84 VPWR VGND sg13cmos5l_decap_8
XFILLER_9_268 VPWR VGND sg13cmos5l_decap_4
XFILLER_126_177 VPWR VGND sg13cmos5l_decap_8
XFILLER_55_7 VPWR VGND sg13cmos5l_decap_8
X_0302_ _0302_/Q Tile_X0Y0_FrameData[14] VGND VPWR Tile_X0Y1_FrameStrobe[6] latch
X_0233_ _0233_/Q Tile_X0Y0_FrameData[19] VGND VPWR Tile_X0Y1_FrameStrobe[4] latch
X_0164_ _0164_/Q Tile_X0Y0_FrameData[24] VGND VPWR Tile_X0Y1_FrameStrobe[2] latch
XFILLER_95_267 VPWR VGND sg13cmos5l_decap_4
XFILLER_63_175 VPWR VGND sg13cmos5l_decap_8
XFILLER_81_0 VPWR VGND sg13cmos5l_decap_4
X_0095_ _0095_/Q Tile_X0Y0_FrameData[29] VGND VPWR Tile_X0Y1_FrameStrobe[0] latch
XFILLER_117_166 VPWR VGND sg13cmos5l_decap_8
X_0997_ _0997_/X Tile_X0Y1_E1END[3] Tile_X0Y1_EE4END[7] Tile_X0Y1_EE4END[15] _1218_/X
+ _0404_/Q _0403_/Q VPWR VGND sg13cmos5l_mux4_1
XFILLER_132_147 VPWR VGND sg13cmos5l_decap_8
XFILLER_39_161 VPWR VGND sg13cmos5l_decap_8
XFILLER_86_267 VPWR VGND sg13cmos5l_decap_4
XFILLER_131_35 VPWR VGND sg13cmos5l_decap_8
XFILLER_54_131 VPWR VGND sg13cmos5l_decap_8
XFILLER_10_223 VPWR VGND sg13cmos5l_decap_8
XFILLER_6_205 VPWR VGND sg13cmos5l_decap_8
XFILLER_123_136 VPWR VGND sg13cmos5l_decap_8
XFILLER_40_65 VPWR VGND sg13cmos5l_decap_4
XFILLER_105_80 VPWR VGND sg13cmos5l_fill_1
XFILLER_65_84 VPWR VGND sg13cmos5l_decap_8
XFILLER_77_234 VPWR VGND sg13cmos5l_decap_8
XFILLER_92_226 VPWR VGND sg13cmos5l_decap_8
XANTENNA__0923__X Tile_X0Y1_S4BEG[15] VPWR VGND sg13cmos5l_antennanp
XFILLER_45_175 VPWR VGND sg13cmos5l_decap_8
XFILLER_60_156 VPWR VGND sg13cmos5l_decap_4
X_0920_ Tile_X0Y1_S4BEG[12] _0920_/A VPWR VGND sg13cmos5l_buf_1
X_0851_ Tile_X0Y1_FrameData_O[27] Tile_X0Y1_FrameData[27] VPWR VGND sg13cmos5l_buf_1
X_0782_ Tile_X0Y0_WW4BEG[15] _1062_/X VPWR VGND sg13cmos5l_buf_1
XFILLER_28_109 VPWR VGND sg13cmos5l_fill_2
XFILLER_68_223 VPWR VGND sg13cmos5l_decap_8
XFILLER_101_38 VPWR VGND sg13cmos5l_decap_4
XFILLER_51_145 VPWR VGND sg13cmos5l_decap_8
X_1196_ _1196_/X Tile_X0Y1_N2MID[1] Tile_X0Y1_N2END[1] _1220_/X Tile_X0Y0_S2MID[1]
+ _0368_/Q _0367_/Q VPWR VGND sg13cmos5l_mux4_1
X_0216_ _0216_/Q Tile_X0Y0_FrameData[4] VGND VPWR Tile_X0Y1_FrameStrobe[3] latch
X_0147_ _0147_/Q Tile_X0Y0_FrameData[9] VGND VPWR Tile_X0Y1_FrameStrobe[1] latch
X_0078_ _0921_/A _1137_/X _1138_/X _0537_/Q VPWR VGND sg13cmos5l_mux2_1
XANTENNA__0833__X Tile_X0Y1_FrameData_O[9] VPWR VGND sg13cmos5l_antennanp
XFILLER_120_117 VPWR VGND sg13cmos5l_decap_8
XFILLER_126_35 VPWR VGND sg13cmos5l_decap_4
XFILLER_126_79 VPWR VGND sg13cmos5l_decap_8
XFILLER_74_259 VPWR VGND sg13cmos5l_decap_8
XANTENNA__0743__X Tile_X0Y0_W6BEG[4] VPWR VGND sg13cmos5l_antennanp
XFILLER_27_197 VPWR VGND sg13cmos5l_decap_8
XFILLER_82_270 VPWR VGND sg13cmos5l_fill_2
XFILLER_128_217 VPWR VGND sg13cmos5l_decap_8
XFILLER_129_0 VPWR VGND sg13cmos5l_decap_8
XFILLER_51_75 VPWR VGND sg13cmos5l_fill_2
XANTENNA__0918__X Tile_X0Y1_S4BEG[10] VPWR VGND sg13cmos5l_antennanp
X_1050_ _1050_/X _0639_/Q _0643_/Q _1075_/X _1096_/X _0228_/Q _0227_/Q VPWR VGND sg13cmos5l_mux4_1
XFILLER_33_156 VPWR VGND sg13cmos5l_decap_4
X_0903_ Tile_X0Y1_S2BEGb[3] _1222_/X VPWR VGND sg13cmos5l_buf_1
X_0834_ Tile_X0Y1_FrameData_O[10] Tile_X0Y1_FrameData[10] VPWR VGND sg13cmos5l_buf_1
XFILLER_127_261 VPWR VGND sg13cmos5l_decap_4
XFILLER_127_272 VPWR VGND sg13cmos5l_fill_1
XFILLER_44_0 VPWR VGND sg13cmos5l_fill_2
X_0765_ Tile_X0Y0_N4BEG[14] _0765_/A VPWR VGND sg13cmos5l_buf_1
X_0696_ _0696_/L_HI VPWR VGND sg13cmos5l_tiehi
XANTENNA__0828__X Tile_X0Y1_FrameData_O[4] VPWR VGND sg13cmos5l_antennanp
XFILLER_110_161 VPWR VGND sg13cmos5l_decap_8
XFILLER_112_15 VPWR VGND sg13cmos5l_fill_1
X_1179_ _1179_/X Tile_X0Y1_N4END[0] Tile_X0Y0_S4END[4] _1214_/X _1218_/X _0458_/Q
+ _0457_/Q VPWR VGND sg13cmos5l_mux4_1
XANTENNA_30 Tile_X0Y1_N2MID[1] VPWR VGND sg13cmos5l_antennanp
XANTENNA_41 Tile_X0Y1_N2MID[5] VPWR VGND sg13cmos5l_antennanp
XANTENNA_52 Tile_X0Y1_N4END[4] VPWR VGND sg13cmos5l_antennanp
XANTENNA_63 Tile_X0Y1_N4END[4] VPWR VGND sg13cmos5l_antennanp
XANTENNA_74 Tile_X0Y1_N4END[4] VPWR VGND sg13cmos5l_antennanp
XANTENNA_85 Tile_X0Y1_FrameData[19] VPWR VGND sg13cmos5l_antennanp
XANTENNA_96 Tile_X0Y1_FrameData[19] VPWR VGND sg13cmos5l_antennanp
XFILLER_118_250 VPWR VGND sg13cmos5l_decap_8
XFILLER_137_56 VPWR VGND sg13cmos5l_decap_8
XFILLER_133_220 VPWR VGND sg13cmos5l_decap_8
XFILLER_133_264 VPWR VGND sg13cmos5l_fill_1
XFILLER_97_38 VPWR VGND sg13cmos5l_decap_8
XANTENNA__0738__X Tile_X0Y0_W2BEGb[7] VPWR VGND sg13cmos5l_antennanp
XFILLER_15_123 VPWR VGND sg13cmos5l_fill_1
XFILLER_47_215 VPWR VGND sg13cmos5l_decap_8
XFILLER_15_167 VPWR VGND sg13cmos5l_decap_8
XFILLER_62_63 VPWR VGND sg13cmos5l_decap_8
XFILLER_109_272 VPWR VGND sg13cmos5l_fill_1
XFILLER_7_58 VPWR VGND sg13cmos5l_decap_8
X_0550_ _0550_/Q Tile_X0Y1_FrameData[20] VGND VPWR Tile_X0Y1_FrameStrobe[6] latch
XFILLER_97_104 VPWR VGND sg13cmos5l_decap_4
XFILLER_38_215 VPWR VGND sg13cmos5l_decap_8
X_1102_ _1102_/X _1113_/X Tile_X0Y0_E6END[2] Tile_X0Y0_S1END[2] _1102_/A3 _0096_/Q
+ _0095_/Q VPWR VGND sg13cmos5l_mux4_1
X_0481_ _0481_/Q Tile_X0Y1_FrameData[25] VGND VPWR Tile_X0Y1_FrameStrobe[4] latch
X_1033_ _1033_/X Tile_X0Y0_EE4END[6] _0638_/Q _1094_/X _1097_/X _0262_/Q _0261_/Q
+ VPWR VGND sg13cmos5l_mux4_1
X_0817_ Tile_X0Y0_FrameStrobe_O[14] Tile_X0Y1_FrameStrobe[14] VPWR VGND sg13cmos5l_buf_1
XFILLER_107_37 VPWR VGND sg13cmos5l_fill_2
XFILLER_130_245 VPWR VGND sg13cmos5l_decap_8
XFILLER_88_104 VPWR VGND sg13cmos5l_decap_8
XFILLER_88_148 VPWR VGND sg13cmos5l_decap_8
X_0748_ Tile_X0Y0_W6BEG[9] _1072_/X VPWR VGND sg13cmos5l_buf_1
X_0679_ _0679_/L_HI VPWR VGND sg13cmos5l_tiehi
XFILLER_16_34 VPWR VGND sg13cmos5l_fill_1
XFILLER_29_248 VPWR VGND sg13cmos5l_decap_8
XFILLER_12_115 VPWR VGND sg13cmos5l_decap_8
XFILLER_16_45 VPWR VGND sg13cmos5l_fill_1
XFILLER_52_240 VPWR VGND sg13cmos5l_decap_8
XFILLER_20_170 VPWR VGND sg13cmos5l_fill_1
XFILLER_20_181 VPWR VGND sg13cmos5l_decap_8
XFILLER_57_63 VPWR VGND sg13cmos5l_decap_8
XFILLER_94_118 VPWR VGND sg13cmos5l_decap_8
XFILLER_73_84 VPWR VGND sg13cmos5l_decap_8
XANTENNA__0931__X Tile_X0Y1_W2BEG[2] VPWR VGND sg13cmos5l_antennanp
XFILLER_7_163 VPWR VGND sg13cmos5l_decap_8
XFILLER_112_201 VPWR VGND sg13cmos5l_decap_8
X_0602_ _0602_/Q Tile_X0Y1_FrameData[0] VGND VPWR Tile_X0Y1_FrameStrobe[7] latch
X_0533_ _0533_/Q Tile_X0Y1_FrameData[5] VGND VPWR Tile_X0Y1_FrameStrobe[5] latch
X_0464_ _0464_/Q Tile_X0Y1_FrameData[10] VGND VPWR Tile_X0Y1_FrameStrobe[3] latch
XFILLER_98_92 VPWR VGND sg13cmos5l_fill_1
XFILLER_26_207 VPWR VGND sg13cmos5l_decap_8
XFILLER_78_192 VPWR VGND sg13cmos5l_decap_8
X_0395_ _0395_/Q Tile_X0Y1_FrameData[15] VGND VPWR Tile_X0Y1_FrameStrobe[1] latch
XFILLER_139_109 VPWR VGND sg13cmos5l_decap_8
X_1016_ _1016_/X _1085_/X _1081_/X _1077_/X _1094_/X _0316_/Q _0315_/Q VPWR VGND sg13cmos5l_mux4_1
XANTENNA__0841__X Tile_X0Y1_FrameData_O[17] VPWR VGND sg13cmos5l_antennanp
XFILLER_118_36 VPWR VGND sg13cmos5l_decap_8
XFILLER_103_201 VPWR VGND sg13cmos5l_decap_8
XFILLER_134_35 VPWR VGND sg13cmos5l_decap_8
XFILLER_94_39 VPWR VGND sg13cmos5l_decap_4
XFILLER_25_251 VPWR VGND sg13cmos5l_decap_8
XFILLER_27_44 VPWR VGND sg13cmos5l_decap_8
XANTENNA__0751__X Tile_X0Y0_N4BEG[0] VPWR VGND sg13cmos5l_antennanp
XFILLER_138_175 VPWR VGND sg13cmos5l_decap_8
XFILLER_4_133 VPWR VGND sg13cmos5l_decap_8
XANTENNA__0926__X Tile_X0Y1_W1BEG[1] VPWR VGND sg13cmos5l_antennanp
XFILLER_75_140 VPWR VGND sg13cmos5l_decap_8
X_0180_ _0180_/Q Tile_X0Y0_FrameData[8] VGND VPWR Tile_X0Y1_FrameStrobe[2] latch
XFILLER_31_254 VPWR VGND sg13cmos5l_decap_8
XFILLER_90_176 VPWR VGND sg13cmos5l_decap_8
XFILLER_129_197 VPWR VGND sg13cmos5l_decap_8
XANTENNA__0610__Q NPU_WEIGHT_IN0 VPWR VGND sg13cmos5l_antennanp
XFILLER_100_248 VPWR VGND sg13cmos5l_decap_8
X_0516_ _0516_/Q Tile_X0Y1_FrameData[22] VGND VPWR Tile_X0Y1_FrameStrobe[5] latch
X_0447_ _0447_/Q Tile_X0Y1_FrameData[27] VGND VPWR Tile_X0Y1_FrameStrobe[3] latch
XFILLER_98_265 VPWR VGND sg13cmos5l_decap_8
XANTENNA__0836__X Tile_X0Y1_FrameData_O[12] VPWR VGND sg13cmos5l_antennanp
XFILLER_66_195 VPWR VGND sg13cmos5l_decap_8
XFILLER_81_176 VPWR VGND sg13cmos5l_decap_8
X_0378_ _0378_/Q Tile_X0Y1_FrameData[0] VGND VPWR Tile_X0Y1_FrameStrobe[0] latch
XFILLER_129_35 VPWR VGND sg13cmos5l_decap_8
XFILLER_135_112 VPWR VGND sg13cmos5l_decap_8
XFILLER_135_156 VPWR VGND sg13cmos5l_decap_8
XFILLER_89_221 VPWR VGND sg13cmos5l_decap_8
XANTENNA__0746__X Tile_X0Y0_W6BEG[7] VPWR VGND sg13cmos5l_antennanp
XFILLER_13_210 VPWR VGND sg13cmos5l_decap_8
XFILLER_72_154 VPWR VGND sg13cmos5l_decap_8
XFILLER_126_156 VPWR VGND sg13cmos5l_decap_8
XFILLER_70_63 VPWR VGND sg13cmos5l_decap_8
XFILLER_9_247 VPWR VGND sg13cmos5l_decap_8
XFILLER_141_115 VPWR VGND sg13cmos5l_fill_2
XFILLER_141_159 VPWR VGND sg13cmos5l_decap_8
X_0301_ _0301_/Q Tile_X0Y0_FrameData[15] VGND VPWR Tile_X0Y1_FrameStrobe[6] latch
XFILLER_95_246 VPWR VGND sg13cmos5l_decap_8
XFILLER_48_195 VPWR VGND sg13cmos5l_decap_8
XFILLER_63_154 VPWR VGND sg13cmos5l_decap_8
X_0232_ _0232_/Q Tile_X0Y0_FrameData[20] VGND VPWR Tile_X0Y1_FrameStrobe[4] latch
X_0163_ _0163_/Q Tile_X0Y0_FrameData[25] VGND VPWR Tile_X0Y1_FrameStrobe[2] latch
X_0094_ _0094_/Q Tile_X0Y0_FrameData[30] VGND VPWR Tile_X0Y1_FrameStrobe[0] latch
XFILLER_74_0 VPWR VGND sg13cmos5l_decap_8
X_0996_ _0996_/X Tile_X0Y1_E1END[2] Tile_X0Y1_EE4END[6] Tile_X0Y1_EE4END[14] _1217_/X
+ _0406_/Q _0405_/Q VPWR VGND sg13cmos5l_mux4_1
XFILLER_117_145 VPWR VGND sg13cmos5l_decap_8
XFILLER_132_126 VPWR VGND sg13cmos5l_decap_8
XFILLER_5_91 VPWR VGND sg13cmos5l_decap_8
XFILLER_131_14 VPWR VGND sg13cmos5l_decap_8
XFILLER_86_246 VPWR VGND sg13cmos5l_decap_8
XFILLER_54_187 VPWR VGND sg13cmos5l_decap_8
XFILLER_10_202 VPWR VGND sg13cmos5l_decap_8
XFILLER_10_268 VPWR VGND sg13cmos5l_decap_4
XFILLER_40_22 VPWR VGND sg13cmos5l_fill_2
XFILLER_40_77 VPWR VGND sg13cmos5l_fill_1
XFILLER_108_189 VPWR VGND sg13cmos5l_decap_8
XFILLER_123_115 VPWR VGND sg13cmos5l_decap_8
XFILLER_131_192 VPWR VGND sg13cmos5l_decap_8
XFILLER_77_213 VPWR VGND sg13cmos5l_decap_8
XANTENNA_120 Tile_X0Y1_FrameData[23] VPWR VGND sg13cmos5l_antennanp
XFILLER_1_49 VPWR VGND sg13cmos5l_fill_2
XFILLER_60_102 VPWR VGND sg13cmos5l_fill_1
XFILLER_65_63 VPWR VGND sg13cmos5l_decap_8
XFILLER_77_268 VPWR VGND sg13cmos5l_decap_4
XFILLER_92_205 VPWR VGND sg13cmos5l_decap_8
XFILLER_60_135 VPWR VGND sg13cmos5l_decap_8
X_0850_ Tile_X0Y1_FrameData_O[26] Tile_X0Y1_FrameData[26] VPWR VGND sg13cmos5l_buf_1
XFILLER_5_272 VPWR VGND sg13cmos5l_fill_1
X_0781_ Tile_X0Y0_WW4BEG[14] _1061_/X VPWR VGND sg13cmos5l_buf_1
XFILLER_68_202 VPWR VGND sg13cmos5l_decap_8
XFILLER_83_249 VPWR VGND sg13cmos5l_decap_8
X_0215_ _0215_/Q Tile_X0Y0_FrameData[5] VGND VPWR Tile_X0Y1_FrameStrobe[3] latch
XFILLER_51_102 VPWR VGND sg13cmos5l_fill_1
XFILLER_51_124 VPWR VGND sg13cmos5l_decap_8
X_1195_ _1195_/X Tile_X0Y1_N2MID[0] Tile_X0Y1_N2END[0] _1219_/X Tile_X0Y0_S2MID[0]
+ _0370_/Q _0369_/Q VPWR VGND sg13cmos5l_mux4_1
X_0146_ _0146_/Q Tile_X0Y0_FrameData[10] VGND VPWR Tile_X0Y1_FrameStrobe[1] latch
X_0077_ _0920_/A _1135_/X _1136_/X _0540_/Q VPWR VGND sg13cmos5l_mux2_1
X_0979_ _0979_/X Tile_X0Y0_E2MID[6] Tile_X0Y0_E2END[6] _1098_/X _0979_/A3 _0158_/Q
+ _0157_/Q VPWR VGND sg13cmos5l_mux4_1
XFILLER_113_192 VPWR VGND sg13cmos5l_decap_8
XFILLER_126_14 VPWR VGND sg13cmos5l_decap_8
XFILLER_126_58 VPWR VGND sg13cmos5l_decap_8
XFILLER_59_246 VPWR VGND sg13cmos5l_decap_8
XFILLER_27_176 VPWR VGND sg13cmos5l_decap_8
XFILLER_59_268 VPWR VGND sg13cmos5l_decap_4
XFILLER_74_238 VPWR VGND sg13cmos5l_decap_8
XFILLER_35_66 VPWR VGND sg13cmos5l_decap_4
XFILLER_4_0 VPWR VGND sg13cmos5l_decap_8
XFILLER_51_98 VPWR VGND sg13cmos5l_decap_4
XFILLER_65_205 VPWR VGND sg13cmos5l_decap_8
XFILLER_76_84 VPWR VGND sg13cmos5l_decap_8
XANTENNA__0934__X Tile_X0Y1_W2BEG[5] VPWR VGND sg13cmos5l_antennanp
XFILLER_18_143 VPWR VGND sg13cmos5l_decap_4
XFILLER_92_72 VPWR VGND sg13cmos5l_fill_1
XFILLER_119_229 VPWR VGND sg13cmos5l_decap_8
XFILLER_127_240 VPWR VGND sg13cmos5l_decap_8
XFILLER_41_190 VPWR VGND sg13cmos5l_decap_8
X_0902_ Tile_X0Y1_S2BEGb[2] _1221_/X VPWR VGND sg13cmos5l_buf_1
X_0833_ Tile_X0Y1_FrameData_O[9] Tile_X0Y1_FrameData[9] VPWR VGND sg13cmos5l_buf_1
XFILLER_102_107 VPWR VGND sg13cmos5l_fill_2
XFILLER_37_0 VPWR VGND sg13cmos5l_decap_4
X_0764_ Tile_X0Y0_N4BEG[13] _0764_/A VPWR VGND sg13cmos5l_buf_1
X_0695_ _0695_/L_HI VPWR VGND sg13cmos5l_tiehi
XFILLER_2_81 VPWR VGND sg13cmos5l_decap_8
XFILLER_71_219 VPWR VGND sg13cmos5l_decap_8
X_1178_ _1178_/X _0647_/Q _0651_/Q _1203_/X _1195_/X _0460_/Q _0459_/Q VPWR VGND sg13cmos5l_mux4_1
XANTENNA_20 Tile_X0Y0_S4END[15] VPWR VGND sg13cmos5l_antennanp
XANTENNA_31 Tile_X0Y1_N2MID[2] VPWR VGND sg13cmos5l_antennanp
XANTENNA__0844__X Tile_X0Y1_FrameData_O[20] VPWR VGND sg13cmos5l_antennanp
XFILLER_64_271 VPWR VGND sg13cmos5l_fill_2
X_0129_ _0129_/Q Tile_X0Y0_FrameData[27] VGND VPWR Tile_X0Y1_FrameStrobe[1] latch
XANTENNA_42 Tile_X0Y1_N2MID[5] VPWR VGND sg13cmos5l_antennanp
XANTENNA_53 Tile_X0Y1_N4END[4] VPWR VGND sg13cmos5l_antennanp
XANTENNA_64 Tile_X0Y1_N4END[4] VPWR VGND sg13cmos5l_antennanp
XANTENNA_75 NPU_OUT_ACT0 VPWR VGND sg13cmos5l_antennanp
XANTENNA_86 Tile_X0Y1_FrameData[19] VPWR VGND sg13cmos5l_antennanp
XANTENNA_97 Tile_X0Y1_FrameData[19] VPWR VGND sg13cmos5l_antennanp
XFILLER_122_8 VPWR VGND sg13cmos5l_decap_8
XFILLER_137_35 VPWR VGND sg13cmos5l_decap_8
XANTENNA__0754__X Tile_X0Y0_N4BEG[3] VPWR VGND sg13cmos5l_antennanp
XFILLER_101_195 VPWR VGND sg13cmos5l_decap_8
XFILLER_15_146 VPWR VGND sg13cmos5l_decap_8
XFILLER_141_0 VPWR VGND sg13cmos5l_fill_2
XFILLER_62_42 VPWR VGND sg13cmos5l_decap_8
XFILLER_7_37 VPWR VGND sg13cmos5l_decap_8
XANTENNA__0929__X Tile_X0Y1_W2BEG[0] VPWR VGND sg13cmos5l_antennanp
XFILLER_109_262 VPWR VGND sg13cmos5l_fill_2
XFILLER_124_210 VPWR VGND sg13cmos5l_decap_8
XFILLER_124_221 VPWR VGND sg13cmos5l_fill_1
XFILLER_124_265 VPWR VGND sg13cmos5l_decap_8
X_0480_ _0480_/Q Tile_X0Y1_FrameData[26] VGND VPWR Tile_X0Y1_FrameStrobe[4] latch
XFILLER_97_149 VPWR VGND sg13cmos5l_decap_8
XFILLER_46_260 VPWR VGND sg13cmos5l_decap_4
X_1032_ _1032_/X Tile_X0Y0_EE4END[5] _0637_/Q _1093_/X _1098_/X _0264_/Q _0263_/Q
+ VPWR VGND sg13cmos5l_mux4_1
X_1101_ _1101_/X _1112_/X Tile_X0Y0_E6END[1] Tile_X0Y0_S1END[1] _1101_/A3 _0098_/Q
+ _0097_/Q VPWR VGND sg13cmos5l_mux4_1
XANTENNA__0613__Q NPU_WEIGHT_IN3 VPWR VGND sg13cmos5l_antennanp
XFILLER_115_232 VPWR VGND sg13cmos5l_fill_2
X_0816_ Tile_X0Y0_FrameStrobe_O[13] Tile_X0Y1_FrameStrobe[13] VPWR VGND sg13cmos5l_buf_1
X_0747_ Tile_X0Y0_W6BEG[8] _1071_/X VPWR VGND sg13cmos5l_buf_1
XANTENNA__0839__X Tile_X0Y1_FrameData_O[15] VPWR VGND sg13cmos5l_antennanp
XFILLER_107_27 VPWR VGND sg13cmos5l_fill_2
XFILLER_130_224 VPWR VGND sg13cmos5l_decap_8
XFILLER_29_227 VPWR VGND sg13cmos5l_decap_8
XFILLER_88_127 VPWR VGND sg13cmos5l_decap_8
X_0678_ _0678_/L_HI VPWR VGND sg13cmos5l_tiehi
XFILLER_37_271 VPWR VGND sg13cmos5l_fill_2
XFILLER_44_219 VPWR VGND sg13cmos5l_decap_8
XFILLER_32_56 VPWR VGND sg13cmos5l_decap_8
XFILLER_106_265 VPWR VGND sg13cmos5l_decap_8
XFILLER_121_213 VPWR VGND sg13cmos5l_decap_8
XANTENNA__0749__X Tile_X0Y0_W6BEG[10] VPWR VGND sg13cmos5l_antennanp
XFILLER_121_257 VPWR VGND sg13cmos5l_decap_8
XFILLER_121_268 VPWR VGND sg13cmos5l_decap_4
XFILLER_35_219 VPWR VGND sg13cmos5l_decap_8
XFILLER_57_42 VPWR VGND sg13cmos5l_decap_8
XFILLER_73_63 VPWR VGND sg13cmos5l_decap_8
XFILLER_7_142 VPWR VGND sg13cmos5l_decap_8
X_0601_ _0601_/Q Tile_X0Y1_FrameData[1] VGND VPWR Tile_X0Y1_FrameStrobe[7] latch
XFILLER_112_257 VPWR VGND sg13cmos5l_decap_8
XFILLER_78_171 VPWR VGND sg13cmos5l_decap_8
X_0532_ _0532_/Q Tile_X0Y1_FrameData[6] VGND VPWR Tile_X0Y1_FrameStrobe[5] latch
X_0463_ _0463_/Q Tile_X0Y1_FrameData[11] VGND VPWR Tile_X0Y1_FrameStrobe[3] latch
X_0394_ _0394_/Q Tile_X0Y1_FrameData[16] VGND VPWR Tile_X0Y1_FrameStrobe[1] latch
XFILLER_98_82 VPWR VGND sg13cmos5l_fill_1
XFILLER_98_71 VPWR VGND sg13cmos5l_decap_8
X_1015_ _1015_/X Tile_X0Y0_E1END[2] Tile_X0Y0_EE4END[2] Tile_X0Y0_E6END[10] _1090_/X
+ _0316_/Q _0315_/Q VPWR VGND sg13cmos5l_mux4_1
XFILLER_93_130 VPWR VGND sg13cmos5l_decap_4
XFILLER_34_263 VPWR VGND sg13cmos5l_fill_1
XFILLER_103_257 VPWR VGND sg13cmos5l_decap_8
XFILLER_103_268 VPWR VGND sg13cmos5l_decap_4
XFILLER_134_14 VPWR VGND sg13cmos5l_decap_8
XFILLER_69_193 VPWR VGND sg13cmos5l_decap_8
XFILLER_76_119 VPWR VGND sg13cmos5l_decap_8
XFILLER_84_130 VPWR VGND sg13cmos5l_decap_8
XFILLER_25_230 VPWR VGND sg13cmos5l_decap_8
XFILLER_27_56 VPWR VGND sg13cmos5l_decap_8
XFILLER_27_67 VPWR VGND sg13cmos5l_fill_2
XFILLER_40_222 VPWR VGND sg13cmos5l_decap_8
XFILLER_84_185 VPWR VGND sg13cmos5l_decap_8
XFILLER_138_154 VPWR VGND sg13cmos5l_decap_8
XFILLER_4_112 VPWR VGND sg13cmos5l_decap_8
XFILLER_104_0 VPWR VGND sg13cmos5l_fill_2
XFILLER_108_92 VPWR VGND sg13cmos5l_fill_1
XFILLER_4_189 VPWR VGND sg13cmos5l_fill_2
XFILLER_4_49 VPWR VGND sg13cmos5l_decap_8
XFILLER_68_74 VPWR VGND sg13cmos5l_decap_8
XFILLER_124_80 VPWR VGND sg13cmos5l_decap_4
XFILLER_124_91 VPWR VGND sg13cmos5l_decap_8
XFILLER_75_196 VPWR VGND sg13cmos5l_decap_8
XFILLER_90_155 VPWR VGND sg13cmos5l_decap_8
XFILLER_90_122 VPWR VGND sg13cmos5l_decap_8
XANTENNA__0942__X Tile_X0Y1_W2BEGb[5] VPWR VGND sg13cmos5l_antennanp
XFILLER_16_263 VPWR VGND sg13cmos5l_fill_2
XFILLER_31_233 VPWR VGND sg13cmos5l_decap_8
XFILLER_129_176 VPWR VGND sg13cmos5l_decap_8
XFILLER_100_227 VPWR VGND sg13cmos5l_decap_8
X_0515_ _0515_/Q Tile_X0Y1_FrameData[23] VGND VPWR Tile_X0Y1_FrameStrobe[5] latch
X_0446_ _0446_/Q Tile_X0Y1_FrameData[28] VGND VPWR Tile_X0Y1_FrameStrobe[3] latch
X_0377_ _0377_/Q Tile_X0Y1_FrameData[1] VGND VPWR Tile_X0Y1_FrameStrobe[0] latch
XFILLER_98_244 VPWR VGND sg13cmos5l_decap_8
XFILLER_66_174 VPWR VGND sg13cmos5l_decap_8
XFILLER_81_122 VPWR VGND sg13cmos5l_decap_8
XFILLER_81_155 VPWR VGND sg13cmos5l_decap_8
XANTENNA__0852__X Tile_X0Y1_FrameData_O[28] VPWR VGND sg13cmos5l_antennanp
XFILLER_129_14 VPWR VGND sg13cmos5l_decap_8
XFILLER_135_135 VPWR VGND sg13cmos5l_decap_8
XFILLER_22_255 VPWR VGND sg13cmos5l_decap_8
XFILLER_89_200 VPWR VGND sg13cmos5l_decap_8
XFILLER_38_33 VPWR VGND sg13cmos5l_fill_2
XFILLER_54_21 VPWR VGND sg13cmos5l_decap_8
XFILLER_57_163 VPWR VGND sg13cmos5l_fill_1
XFILLER_72_133 VPWR VGND sg13cmos5l_decap_8
XANTENNA__0762__X Tile_X0Y0_N4BEG[11] VPWR VGND sg13cmos5l_antennanp
XFILLER_110_60 VPWR VGND sg13cmos5l_fill_1
XFILLER_13_266 VPWR VGND sg13cmos5l_decap_8
XFILLER_54_43 VPWR VGND sg13cmos5l_decap_8
XFILLER_70_42 VPWR VGND sg13cmos5l_decap_8
XFILLER_9_226 VPWR VGND sg13cmos5l_decap_8
XFILLER_126_135 VPWR VGND sg13cmos5l_decap_8
XFILLER_48_8 VPWR VGND sg13cmos5l_fill_1
XANTENNA__0937__X Tile_X0Y1_W2BEGb[0] VPWR VGND sg13cmos5l_antennanp
XFILLER_141_149 VPWR VGND sg13cmos5l_decap_8
X_0300_ _0300_/Q Tile_X0Y0_FrameData[16] VGND VPWR Tile_X0Y1_FrameStrobe[6] latch
X_0231_ _0231_/Q Tile_X0Y0_FrameData[21] VGND VPWR Tile_X0Y1_FrameStrobe[4] latch
XFILLER_95_225 VPWR VGND sg13cmos5l_decap_8
XFILLER_48_174 VPWR VGND sg13cmos5l_decap_8
XFILLER_63_133 VPWR VGND sg13cmos5l_decap_8
X_0162_ _0162_/Q Tile_X0Y0_FrameData[26] VGND VPWR Tile_X0Y1_FrameStrobe[2] latch
X_0093_ NPU_XBAR_SEL3 Tile_X0Y1_UserCLK _0093_/D _0652_/L_HI VPWR VGND sg13cmos5l_dfrbpq_1
XFILLER_117_113 VPWR VGND sg13cmos5l_fill_2
XFILLER_117_124 VPWR VGND sg13cmos5l_decap_8
XFILLER_67_0 VPWR VGND sg13cmos5l_decap_8
X_0995_ _0995_/X Tile_X0Y1_E1END[1] Tile_X0Y1_EE4END[5] Tile_X0Y1_EE4END[13] _1216_/X
+ _0408_/Q _0407_/Q VPWR VGND sg13cmos5l_mux4_1
XANTENNA__0621__Q NPU_ACT_WDATA3 VPWR VGND sg13cmos5l_antennanp
XFILLER_115_27 VPWR VGND sg13cmos5l_fill_2
XFILLER_132_105 VPWR VGND sg13cmos5l_decap_8
XFILLER_5_70 VPWR VGND sg13cmos5l_decap_8
XANTENNA__0847__X Tile_X0Y1_FrameData_O[23] VPWR VGND sg13cmos5l_antennanp
XFILLER_140_193 VPWR VGND sg13cmos5l_decap_8
XFILLER_39_152 VPWR VGND sg13cmos5l_decap_4
XFILLER_39_196 VPWR VGND sg13cmos5l_decap_8
XFILLER_86_225 VPWR VGND sg13cmos5l_decap_8
X_0429_ _0429_/Q Tile_X0Y1_FrameData[13] VGND VPWR Tile_X0Y1_FrameStrobe[2] latch
XFILLER_54_166 VPWR VGND sg13cmos5l_decap_8
XFILLER_54_199 VPWR VGND sg13cmos5l_decap_8
XFILLER_108_135 VPWR VGND sg13cmos5l_decap_8
XFILLER_108_146 VPWR VGND sg13cmos5l_fill_1
XFILLER_108_168 VPWR VGND sg13cmos5l_decap_8
XFILLER_10_258 VPWR VGND sg13cmos5l_decap_8
XANTENNA__0757__X Tile_X0Y0_N4BEG[6] VPWR VGND sg13cmos5l_antennanp
XFILLER_116_190 VPWR VGND sg13cmos5l_decap_8
XFILLER_131_171 VPWR VGND sg13cmos5l_decap_8
XFILLER_1_28 VPWR VGND sg13cmos5l_decap_8
XFILLER_49_98 VPWR VGND sg13cmos5l_fill_2
XANTENNA_110 Tile_X0Y1_FrameData[23] VPWR VGND sg13cmos5l_antennanp
XANTENNA_121 Tile_X0Y1_FrameData[23] VPWR VGND sg13cmos5l_antennanp
XFILLER_60_114 VPWR VGND sg13cmos5l_decap_8
XFILLER_65_42 VPWR VGND sg13cmos5l_decap_8
XFILLER_139_260 VPWR VGND sg13cmos5l_decap_8
XFILLER_139_271 VPWR VGND sg13cmos5l_fill_2
XFILLER_81_63 VPWR VGND sg13cmos5l_decap_8
X_0780_ Tile_X0Y0_WW4BEG[13] _1060_/X VPWR VGND sg13cmos5l_buf_1
XFILLER_107_190 VPWR VGND sg13cmos5l_decap_8
XFILLER_114_105 VPWR VGND sg13cmos5l_fill_2
XFILLER_114_149 VPWR VGND sg13cmos5l_decap_8
XFILLER_39_4 VPWR VGND sg13cmos5l_fill_1
XFILLER_60_7 VPWR VGND sg13cmos5l_decap_8
XFILLER_68_269 VPWR VGND sg13cmos5l_decap_4
XFILLER_83_228 VPWR VGND sg13cmos5l_decap_8
X_1194_ _1194_/X Tile_X0Y1_N1END[3] Tile_X0Y1_E6END[3] _1230_/X _1194_/A3 _0348_/Q
+ _0603_/Q VPWR VGND sg13cmos5l_mux4_1
X_0214_ _0214_/Q Tile_X0Y0_FrameData[6] VGND VPWR Tile_X0Y1_FrameStrobe[3] latch
XANTENNA__0616__Q NPU_WEIGHT_IN6 VPWR VGND sg13cmos5l_antennanp
XFILLER_36_155 VPWR VGND sg13cmos5l_fill_2
XFILLER_36_199 VPWR VGND sg13cmos5l_decap_8
X_0145_ _0145_/Q Tile_X0Y0_FrameData[11] VGND VPWR Tile_X0Y1_FrameStrobe[1] latch
X_0076_ _0762_/A _1115_/X _1116_/X _0567_/Q VPWR VGND sg13cmos5l_mux2_1
XFILLER_91_272 VPWR VGND sg13cmos5l_fill_1
X_0978_ _0978_/X Tile_X0Y0_E2MID[5] Tile_X0Y0_E2END[5] _1097_/X _0978_/A3 _0160_/Q
+ _0159_/Q VPWR VGND sg13cmos5l_mux4_1
XFILLER_113_182 VPWR VGND sg13cmos5l_decap_4
XFILLER_59_225 VPWR VGND sg13cmos5l_decap_8
XFILLER_27_144 VPWR VGND sg13cmos5l_fill_2
XFILLER_27_155 VPWR VGND sg13cmos5l_decap_8
XFILLER_74_217 VPWR VGND sg13cmos5l_decap_8
XFILLER_82_272 VPWR VGND sg13cmos5l_fill_1
XFILLER_136_252 VPWR VGND sg13cmos5l_decap_8
XFILLER_2_243 VPWR VGND sg13cmos5l_decap_8
XFILLER_104_193 VPWR VGND sg13cmos5l_decap_8
XFILLER_116_81 VPWR VGND sg13cmos5l_decap_4
XFILLER_76_63 VPWR VGND sg13cmos5l_decap_8
XFILLER_132_91 VPWR VGND sg13cmos5l_decap_8
XFILLER_18_177 VPWR VGND sg13cmos5l_decap_8
XFILLER_92_95 VPWR VGND sg13cmos5l_fill_2
XFILLER_92_62 VPWR VGND sg13cmos5l_fill_1
XANTENNA__0950__X Tile_X0Y1_W6BEG[5] VPWR VGND sg13cmos5l_antennanp
XFILLER_119_208 VPWR VGND sg13cmos5l_decap_8
X_0901_ Tile_X0Y1_S2BEGb[1] _1220_/X VPWR VGND sg13cmos5l_buf_1
X_0832_ Tile_X0Y1_FrameData_O[8] Tile_X0Y1_FrameData[8] VPWR VGND sg13cmos5l_buf_1
X_0763_ Tile_X0Y0_N4BEG[12] _0763_/A VPWR VGND sg13cmos5l_buf_1
X_0694_ _0694_/L_HI VPWR VGND sg13cmos5l_tiehi
XFILLER_110_152 VPWR VGND sg13cmos5l_fill_2
XFILLER_110_196 VPWR VGND sg13cmos5l_decap_8
XFILLER_56_217 VPWR VGND sg13cmos5l_decap_8
X_1177_ _1177_/X _0646_/Q _0650_/Q _1204_/X _1196_/X _0462_/Q _0461_/Q VPWR VGND sg13cmos5l_mux4_1
X_0128_ _0128_/Q Tile_X0Y0_FrameData[28] VGND VPWR Tile_X0Y1_FrameStrobe[1] latch
XANTENNA_10 Tile_X0Y0_S2MID[3] VPWR VGND sg13cmos5l_antennanp
XANTENNA_21 Tile_X0Y1_N2MID[0] VPWR VGND sg13cmos5l_antennanp
XANTENNA_32 Tile_X0Y1_N2MID[2] VPWR VGND sg13cmos5l_antennanp
XANTENNA_43 Tile_X0Y1_N2MID[5] VPWR VGND sg13cmos5l_antennanp
XANTENNA_54 Tile_X0Y1_N4END[4] VPWR VGND sg13cmos5l_antennanp
XANTENNA_65 Tile_X0Y1_N4END[4] VPWR VGND sg13cmos5l_antennanp
XANTENNA__0860__X Tile_X0Y0_FrameData_O[4] VPWR VGND sg13cmos5l_antennanp
XANTENNA_76 NPU_OUT_ACT3 VPWR VGND sg13cmos5l_antennanp
XANTENNA_87 Tile_X0Y1_FrameData[19] VPWR VGND sg13cmos5l_antennanp
XANTENNA_98 Tile_X0Y1_FrameData[19] VPWR VGND sg13cmos5l_antennanp
XFILLER_133_255 VPWR VGND sg13cmos5l_decap_8
XFILLER_137_14 VPWR VGND sg13cmos5l_decap_8
XFILLER_97_29 VPWR VGND sg13cmos5l_fill_2
XFILLER_101_174 VPWR VGND sg13cmos5l_decap_8
XFILLER_99_191 VPWR VGND sg13cmos5l_decap_8
XFILLER_102_61 VPWR VGND sg13cmos5l_fill_1
XFILLER_102_72 VPWR VGND sg13cmos5l_fill_1
XFILLER_15_114 VPWR VGND sg13cmos5l_decap_8
XFILLER_46_44 VPWR VGND sg13cmos5l_fill_2
XFILLER_46_66 VPWR VGND sg13cmos5l_decap_8
XFILLER_46_77 VPWR VGND sg13cmos5l_fill_2
XFILLER_55_272 VPWR VGND sg13cmos5l_fill_1
XFILLER_62_21 VPWR VGND sg13cmos5l_decap_8
XFILLER_70_231 VPWR VGND sg13cmos5l_fill_2
XANTENNA__0770__X Tile_X0Y0_WW4BEG[3] VPWR VGND sg13cmos5l_antennanp
XFILLER_109_241 VPWR VGND sg13cmos5l_decap_8
XFILLER_134_0 VPWR VGND sg13cmos5l_decap_8
XFILLER_62_98 VPWR VGND sg13cmos5l_decap_8
XFILLER_7_16 VPWR VGND sg13cmos5l_decap_8
XFILLER_124_244 VPWR VGND sg13cmos5l_decap_8
XFILLER_127_91 VPWR VGND sg13cmos5l_decap_8
XFILLER_87_84 VPWR VGND sg13cmos5l_decap_4
XANTENNA__0945__X Tile_X0Y1_W6BEG[0] VPWR VGND sg13cmos5l_antennanp
XFILLER_46_272 VPWR VGND sg13cmos5l_fill_1
X_1031_ _1031_/X Tile_X0Y0_EE4END[4] _0636_/Q _1092_/X _1099_/X _0266_/Q _0265_/Q
+ VPWR VGND sg13cmos5l_mux4_1
X_1100_ _1100_/X _1111_/X Tile_X0Y0_E6END[0] Tile_X0Y0_S1END[0] _1100_/A3 _0100_/Q
+ _0099_/Q VPWR VGND sg13cmos5l_mux4_1
XFILLER_14_180 VPWR VGND sg13cmos5l_decap_8
XFILLER_21_139 VPWR VGND sg13cmos5l_decap_4
XFILLER_61_231 VPWR VGND sg13cmos5l_decap_8
XFILLER_61_264 VPWR VGND sg13cmos5l_decap_8
XFILLER_107_39 VPWR VGND sg13cmos5l_fill_1
XFILLER_115_211 VPWR VGND sg13cmos5l_decap_8
X_0815_ Tile_X0Y0_FrameStrobe_O[12] Tile_X0Y1_FrameStrobe[12] VPWR VGND sg13cmos5l_buf_1
X_0746_ Tile_X0Y0_W6BEG[7] _1070_/X VPWR VGND sg13cmos5l_buf_1
XFILLER_130_203 VPWR VGND sg13cmos5l_decap_8
XFILLER_29_206 VPWR VGND sg13cmos5l_decap_8
X_0677_ _0677_/L_HI VPWR VGND sg13cmos5l_tiehi
XFILLER_96_183 VPWR VGND sg13cmos5l_decap_8
XANTENNA__0855__X Tile_X0Y1_FrameData_O[31] VPWR VGND sg13cmos5l_antennanp
XFILLER_16_25 VPWR VGND sg13cmos5l_decap_4
X_1229_ _1229_/X Tile_X0Y0_E1END[2] Tile_X0Y0_E6END[10] _1077_/X _1102_/X _0306_/Q
+ _0305_/Q VPWR VGND sg13cmos5l_mux4_1
XFILLER_106_244 VPWR VGND sg13cmos5l_decap_8
XFILLER_121_236 VPWR VGND sg13cmos5l_decap_8
XANTENNA__0765__X Tile_X0Y0_N4BEG[14] VPWR VGND sg13cmos5l_antennanp
XFILLER_28_272 VPWR VGND sg13cmos5l_fill_1
XFILLER_57_21 VPWR VGND sg13cmos5l_decap_8
XFILLER_57_98 VPWR VGND sg13cmos5l_fill_1
XFILLER_87_194 VPWR VGND sg13cmos5l_decap_8
XFILLER_43_264 VPWR VGND sg13cmos5l_decap_8
XFILLER_73_42 VPWR VGND sg13cmos5l_decap_8
XFILLER_11_183 VPWR VGND sg13cmos5l_decap_8
XFILLER_7_121 VPWR VGND sg13cmos5l_decap_8
XFILLER_7_198 VPWR VGND sg13cmos5l_decap_8
X_0600_ _0600_/Q Tile_X0Y1_FrameData[2] VGND VPWR Tile_X0Y1_FrameStrobe[7] latch
X_0531_ _0531_/Q Tile_X0Y1_FrameData[7] VGND VPWR Tile_X0Y1_FrameStrobe[5] latch
XFILLER_112_236 VPWR VGND sg13cmos5l_decap_8
XFILLER_78_150 VPWR VGND sg13cmos5l_decap_8
X_0462_ _0462_/Q Tile_X0Y1_FrameData[12] VGND VPWR Tile_X0Y1_FrameStrobe[3] latch
X_0393_ _0393_/Q Tile_X0Y1_FrameData[17] VGND VPWR Tile_X0Y1_FrameStrobe[1] latch
XFILLER_19_250 VPWR VGND sg13cmos5l_decap_8
XFILLER_19_272 VPWR VGND sg13cmos5l_fill_1
XFILLER_34_231 VPWR VGND sg13cmos5l_fill_1
X_1014_ _1014_/X _1086_/X _1082_/X _1076_/X _1093_/X _0319_/Q _0318_/Q VPWR VGND sg13cmos5l_mux4_1
XFILLER_93_186 VPWR VGND sg13cmos5l_decap_8
XANTENNA__0624__Q NPU_ACT_WDATA6 VPWR VGND sg13cmos5l_antennanp
XFILLER_97_0 VPWR VGND sg13cmos5l_fill_1
XFILLER_103_236 VPWR VGND sg13cmos5l_decap_8
X_0729_ Tile_X0Y0_W2BEG[6] _1037_/X VPWR VGND sg13cmos5l_buf_1
XFILLER_84_164 VPWR VGND sg13cmos5l_decap_8
XFILLER_40_201 VPWR VGND sg13cmos5l_decap_8
XFILLER_138_133 VPWR VGND sg13cmos5l_decap_8
XFILLER_4_168 VPWR VGND sg13cmos5l_decap_8
XFILLER_4_28 VPWR VGND sg13cmos5l_decap_8
XFILLER_68_42 VPWR VGND sg13cmos5l_fill_1
XFILLER_16_231 VPWR VGND sg13cmos5l_fill_1
XFILLER_75_175 VPWR VGND sg13cmos5l_decap_8
XFILLER_129_155 VPWR VGND sg13cmos5l_decap_8
XFILLER_31_212 VPWR VGND sg13cmos5l_decap_8
X_0514_ _0514_/Q Tile_X0Y1_FrameData[24] VGND VPWR Tile_X0Y1_FrameStrobe[5] latch
XFILLER_98_223 VPWR VGND sg13cmos5l_decap_8
XANTENNA__0619__Q NPU_ACT_WDATA1 VPWR VGND sg13cmos5l_antennanp
XFILLER_100_206 VPWR VGND sg13cmos5l_decap_8
XFILLER_66_153 VPWR VGND sg13cmos5l_decap_8
X_0445_ _0445_/Q Tile_X0Y1_FrameData[29] VGND VPWR Tile_X0Y1_FrameStrobe[3] latch
X_0376_ _0376_/Q Tile_X0Y1_FrameData[2] VGND VPWR Tile_X0Y1_FrameStrobe[0] latch
XFILLER_22_234 VPWR VGND sg13cmos5l_decap_8
XFILLER_81_134 VPWR VGND sg13cmos5l_decap_8
XFILLER_1_116 VPWR VGND sg13cmos5l_decap_8
XFILLER_89_256 VPWR VGND sg13cmos5l_decap_4
XFILLER_57_142 VPWR VGND sg13cmos5l_decap_8
XFILLER_72_112 VPWR VGND sg13cmos5l_decap_8
XFILLER_72_189 VPWR VGND sg13cmos5l_decap_8
XFILLER_13_245 VPWR VGND sg13cmos5l_decap_8
XFILLER_54_77 VPWR VGND sg13cmos5l_fill_1
XFILLER_70_21 VPWR VGND sg13cmos5l_decap_8
XFILLER_9_205 VPWR VGND sg13cmos5l_decap_8
XFILLER_119_70 VPWR VGND sg13cmos5l_fill_2
XFILLER_126_114 VPWR VGND sg13cmos5l_decap_8
XFILLER_141_117 VPWR VGND sg13cmos5l_fill_1
XFILLER_141_128 VPWR VGND sg13cmos5l_decap_8
XFILLER_79_85 VPWR VGND sg13cmos5l_fill_1
XFILLER_0_160 VPWR VGND sg13cmos5l_decap_8
XFILLER_135_91 VPWR VGND sg13cmos5l_decap_8
XFILLER_48_153 VPWR VGND sg13cmos5l_decap_8
XFILLER_63_112 VPWR VGND sg13cmos5l_decap_8
X_0230_ _0230_/Q Tile_X0Y0_FrameData[22] VGND VPWR Tile_X0Y1_FrameStrobe[4] latch
X_0161_ _0161_/Q Tile_X0Y0_FrameData[27] VGND VPWR Tile_X0Y1_FrameStrobe[2] latch
XFILLER_95_62 VPWR VGND sg13cmos5l_fill_1
XFILLER_95_51 VPWR VGND sg13cmos5l_decap_8
XFILLER_95_204 VPWR VGND sg13cmos5l_decap_8
XANTENNA__0953__X Tile_X0Y1_W6BEG[8] VPWR VGND sg13cmos5l_antennanp
XFILLER_63_189 VPWR VGND sg13cmos5l_decap_8
X_0092_ NPU_XBAR_SEL2 Tile_X0Y1_UserCLK _0092_/D _0698_/L_HI VPWR VGND sg13cmos5l_dfrbpq_1
X_0994_ _0994_/X Tile_X0Y1_E1END[0] Tile_X0Y1_EE4END[4] Tile_X0Y1_EE4END[12] _1215_/X
+ _0410_/Q _0409_/Q VPWR VGND sg13cmos5l_mux4_1
XFILLER_140_172 VPWR VGND sg13cmos5l_decap_8
XFILLER_86_204 VPWR VGND sg13cmos5l_decap_8
XANTENNA__0863__X Tile_X0Y0_FrameData_O[7] VPWR VGND sg13cmos5l_antennanp
XFILLER_131_49 VPWR VGND sg13cmos5l_decap_8
XFILLER_39_175 VPWR VGND sg13cmos5l_decap_8
XFILLER_54_145 VPWR VGND sg13cmos5l_decap_8
X_0428_ _0428_/Q Tile_X0Y1_FrameData[14] VGND VPWR Tile_X0Y1_FrameStrobe[2] latch
X_0359_ _0359_/Q Tile_X0Y1_FrameData[19] VGND VPWR Tile_X0Y1_FrameStrobe[0] latch
XFILLER_10_237 VPWR VGND sg13cmos5l_decap_8
XFILLER_138_7 VPWR VGND sg13cmos5l_decap_8
XFILLER_108_125 VPWR VGND sg13cmos5l_fill_2
XFILLER_40_35 VPWR VGND sg13cmos5l_fill_2
XFILLER_6_219 VPWR VGND sg13cmos5l_decap_8
XFILLER_131_150 VPWR VGND sg13cmos5l_decap_8
XFILLER_65_21 VPWR VGND sg13cmos5l_decap_8
XFILLER_77_248 VPWR VGND sg13cmos5l_decap_8
XANTENNA_100 Tile_X0Y1_FrameData[19] VPWR VGND sg13cmos5l_antennanp
XANTENNA_111 Tile_X0Y1_FrameData[23] VPWR VGND sg13cmos5l_antennanp
XANTENNA_122 Tile_X0Y1_FrameData[23] VPWR VGND sg13cmos5l_antennanp
XANTENNA__0773__X Tile_X0Y0_WW4BEG[6] VPWR VGND sg13cmos5l_antennanp
XFILLER_45_189 VPWR VGND sg13cmos5l_decap_8
XFILLER_65_98 VPWR VGND sg13cmos5l_decap_8
XANTENNA__0948__X Tile_X0Y1_W6BEG[3] VPWR VGND sg13cmos5l_antennanp
XFILLER_122_183 VPWR VGND sg13cmos5l_decap_8
XFILLER_5_263 VPWR VGND sg13cmos5l_fill_2
XFILLER_68_248 VPWR VGND sg13cmos5l_decap_8
XFILLER_83_207 VPWR VGND sg13cmos5l_decap_8
X_1193_ _1193_/X Tile_X0Y1_N1END[2] Tile_X0Y1_E6END[2] _1229_/X _1193_/A3 _0350_/Q
+ _0349_/Q VPWR VGND sg13cmos5l_mux4_1
X_0213_ _0213_/Q Tile_X0Y0_FrameData[7] VGND VPWR Tile_X0Y1_FrameStrobe[3] latch
X_0144_ _0144_/Q Tile_X0Y0_FrameData[12] VGND VPWR Tile_X0Y1_FrameStrobe[1] latch
XFILLER_91_251 VPWR VGND sg13cmos5l_decap_8
XFILLER_137_209 VPWR VGND sg13cmos5l_decap_8
XFILLER_51_159 VPWR VGND sg13cmos5l_decap_8
X_0075_ _0761_/A _1117_/X _1118_/X _0570_/Q VPWR VGND sg13cmos5l_mux2_1
XANTENNA__0632__Q NPU_ACT_ADDR6 VPWR VGND sg13cmos5l_antennanp
X_0977_ _0977_/X Tile_X0Y0_E2MID[4] Tile_X0Y0_E2END[4] _1096_/X _0977_/A3 _0162_/Q
+ _0161_/Q VPWR VGND sg13cmos5l_mux4_1
XANTENNA__0858__X Tile_X0Y0_FrameData_O[2] VPWR VGND sg13cmos5l_antennanp
XFILLER_113_161 VPWR VGND sg13cmos5l_decap_8
XFILLER_59_204 VPWR VGND sg13cmos5l_decap_8
XFILLER_42_137 VPWR VGND sg13cmos5l_decap_8
XFILLER_42_148 VPWR VGND sg13cmos5l_fill_1
XFILLER_42_159 VPWR VGND sg13cmos5l_decap_8
XFILLER_136_231 VPWR VGND sg13cmos5l_decap_8
XANTENNA__0768__X Tile_X0Y0_WW4BEG[1] VPWR VGND sg13cmos5l_antennanp
XFILLER_104_172 VPWR VGND sg13cmos5l_decap_8
XFILLER_2_222 VPWR VGND sg13cmos5l_decap_8
XFILLER_132_70 VPWR VGND sg13cmos5l_decap_8
XFILLER_76_42 VPWR VGND sg13cmos5l_decap_8
XFILLER_18_189 VPWR VGND sg13cmos5l_decap_8
XFILLER_33_104 VPWR VGND sg13cmos5l_fill_2
X_0900_ Tile_X0Y1_S2BEGb[0] _1219_/X VPWR VGND sg13cmos5l_buf_1
X_0831_ Tile_X0Y1_FrameData_O[7] Tile_X0Y1_FrameData[7] VPWR VGND sg13cmos5l_buf_1
X_0762_ Tile_X0Y0_N4BEG[11] _0762_/A VPWR VGND sg13cmos5l_buf_1
X_0693_ _0693_/L_HI VPWR VGND sg13cmos5l_tiehi
XFILLER_110_131 VPWR VGND sg13cmos5l_decap_8
XFILLER_110_175 VPWR VGND sg13cmos5l_decap_8
XANTENNA__0627__Q NPU_ACT_ADDR1 VPWR VGND sg13cmos5l_antennanp
XFILLER_24_104 VPWR VGND sg13cmos5l_fill_2
X_1176_ _1176_/X _0645_/Q _0649_/Q _1205_/X _1197_/X _0464_/Q _0463_/Q VPWR VGND sg13cmos5l_mux4_1
X_0127_ _0127_/Q Tile_X0Y0_FrameData[29] VGND VPWR Tile_X0Y1_FrameStrobe[1] latch
XANTENNA_11 Tile_X0Y0_S2MID[4] VPWR VGND sg13cmos5l_antennanp
XANTENNA_22 Tile_X0Y1_N2MID[0] VPWR VGND sg13cmos5l_antennanp
XANTENNA_33 Tile_X0Y1_N2MID[2] VPWR VGND sg13cmos5l_antennanp
XANTENNA_44 Tile_X0Y1_N2MID[5] VPWR VGND sg13cmos5l_antennanp
XANTENNA_55 Tile_X0Y1_N4END[4] VPWR VGND sg13cmos5l_antennanp
XANTENNA_66 Tile_X0Y1_N4END[4] VPWR VGND sg13cmos5l_antennanp
XANTENNA_77 NPU_OUT_ACT5 VPWR VGND sg13cmos5l_antennanp
XANTENNA_88 Tile_X0Y1_FrameData[19] VPWR VGND sg13cmos5l_antennanp
XANTENNA_99 Tile_X0Y1_FrameData[19] VPWR VGND sg13cmos5l_antennanp
XFILLER_32_192 VPWR VGND sg13cmos5l_decap_8
XFILLER_118_264 VPWR VGND sg13cmos5l_decap_8
XFILLER_133_234 VPWR VGND sg13cmos5l_decap_8
XFILLER_99_170 VPWR VGND sg13cmos5l_decap_8
XFILLER_47_229 VPWR VGND sg13cmos5l_decap_8
XFILLER_62_77 VPWR VGND sg13cmos5l_decap_8
XFILLER_70_210 VPWR VGND sg13cmos5l_decap_8
XFILLER_70_265 VPWR VGND sg13cmos5l_decap_8
XFILLER_109_264 VPWR VGND sg13cmos5l_fill_1
XFILLER_127_0 VPWR VGND sg13cmos5l_decap_8
XFILLER_11_70 VPWR VGND sg13cmos5l_decap_4
XFILLER_127_70 VPWR VGND sg13cmos5l_decap_8
XFILLER_30_9 VPWR VGND sg13cmos5l_fill_2
XFILLER_38_229 VPWR VGND sg13cmos5l_decap_8
XFILLER_61_210 VPWR VGND sg13cmos5l_decap_8
XFILLER_61_243 VPWR VGND sg13cmos5l_decap_8
X_1030_ _1030_/X _1114_/X Tile_X0Y0_S1END[3] _0637_/Q _0640_/Q _0268_/Q _0267_/Q VPWR
+ VGND sg13cmos5l_mux4_1
XANTENNA__0961__X Tile_X0Y1_WW4BEG[4] VPWR VGND sg13cmos5l_antennanp
XFILLER_21_118 VPWR VGND sg13cmos5l_decap_8
X_0814_ Tile_X0Y0_FrameStrobe_O[11] Tile_X0Y1_FrameStrobe[11] VPWR VGND sg13cmos5l_buf_1
XFILLER_99_4 VPWR VGND sg13cmos5l_fill_1
XFILLER_107_29 VPWR VGND sg13cmos5l_fill_1
XFILLER_115_234 VPWR VGND sg13cmos5l_fill_1
XFILLER_115_245 VPWR VGND sg13cmos5l_decap_8
XFILLER_42_0 VPWR VGND sg13cmos5l_fill_1
XFILLER_88_118 VPWR VGND sg13cmos5l_decap_4
X_0745_ Tile_X0Y0_W6BEG[6] _1069_/X VPWR VGND sg13cmos5l_buf_1
X_0676_ _0676_/L_HI VPWR VGND sg13cmos5l_tiehi
XFILLER_130_259 VPWR VGND sg13cmos5l_decap_8
X_1228_ _1228_/X Tile_X0Y0_E1END[1] Tile_X0Y0_E6END[9] _1076_/X _1101_/X _0308_/Q
+ _0307_/Q VPWR VGND sg13cmos5l_mux4_1
XANTENNA__0871__X Tile_X0Y0_FrameData_O[15] VPWR VGND sg13cmos5l_antennanp
XFILLER_12_129 VPWR VGND sg13cmos5l_decap_8
XFILLER_52_254 VPWR VGND sg13cmos5l_decap_8
X_1159_ _1159_/X Tile_X0Y1_EE4END[9] _0648_/Q _1198_/X _1199_/X _0498_/Q _0497_/Q
+ VPWR VGND sg13cmos5l_mux4_1
XANTENNA__0092__Q NPU_XBAR_SEL2 VPWR VGND sg13cmos5l_antennanp
XFILLER_106_223 VPWR VGND sg13cmos5l_decap_8
XFILLER_20_195 VPWR VGND sg13cmos5l_decap_4
XFILLER_32_36 VPWR VGND sg13cmos5l_decap_4
XFILLER_113_72 VPWR VGND sg13cmos5l_fill_1
XFILLER_113_94 VPWR VGND sg13cmos5l_fill_1
XFILLER_28_262 VPWR VGND sg13cmos5l_fill_2
XFILLER_43_243 VPWR VGND sg13cmos5l_decap_8
XFILLER_57_77 VPWR VGND sg13cmos5l_decap_8
XFILLER_73_21 VPWR VGND sg13cmos5l_decap_8
XFILLER_87_173 VPWR VGND sg13cmos5l_fill_2
XANTENNA__0781__X Tile_X0Y0_WW4BEG[14] VPWR VGND sg13cmos5l_antennanp
XFILLER_11_162 VPWR VGND sg13cmos5l_decap_8
XFILLER_73_98 VPWR VGND sg13cmos5l_decap_8
XFILLER_7_100 VPWR VGND sg13cmos5l_decap_8
XFILLER_112_215 VPWR VGND sg13cmos5l_decap_8
XFILLER_138_91 VPWR VGND sg13cmos5l_decap_8
XFILLER_7_177 VPWR VGND sg13cmos5l_decap_8
X_0530_ _0530_/Q Tile_X0Y1_FrameData[8] VGND VPWR Tile_X0Y1_FrameStrobe[5] latch
XANTENNA__0956__X Tile_X0Y1_W6BEG[11] VPWR VGND sg13cmos5l_antennanp
X_0461_ _0461_/Q Tile_X0Y1_FrameData[13] VGND VPWR Tile_X0Y1_FrameStrobe[3] latch
X_0392_ _0392_/Q Tile_X0Y1_FrameData[18] VGND VPWR Tile_X0Y1_FrameStrobe[1] latch
X_1013_ _1013_/X Tile_X0Y0_E1END[1] Tile_X0Y0_EE4END[1] Tile_X0Y0_E6END[9] _1089_/X
+ _0319_/Q _0318_/Q VPWR VGND sg13cmos5l_mux4_1
XFILLER_118_28 VPWR VGND sg13cmos5l_fill_1
XFILLER_8_82 VPWR VGND sg13cmos5l_decap_8
XFILLER_103_215 VPWR VGND sg13cmos5l_decap_8
XFILLER_134_49 VPWR VGND sg13cmos5l_decap_8
XFILLER_69_151 VPWR VGND sg13cmos5l_decap_4
X_0728_ Tile_X0Y0_W2BEG[5] _1036_/X VPWR VGND sg13cmos5l_buf_1
X_0659_ _0659_/L_HI VPWR VGND sg13cmos5l_tiehi
XANTENNA__0866__X Tile_X0Y0_FrameData_O[10] VPWR VGND sg13cmos5l_antennanp
XFILLER_84_143 VPWR VGND sg13cmos5l_decap_8
XFILLER_138_112 VPWR VGND sg13cmos5l_decap_8
XFILLER_40_268 VPWR VGND sg13cmos5l_decap_4
XFILLER_138_189 VPWR VGND sg13cmos5l_decap_8
XFILLER_4_147 VPWR VGND sg13cmos5l_decap_8
XANTENNA__0776__X Tile_X0Y0_WW4BEG[9] VPWR VGND sg13cmos5l_antennanp
XFILLER_68_21 VPWR VGND sg13cmos5l_decap_8
XFILLER_68_54 VPWR VGND sg13cmos5l_decap_8
XFILLER_75_154 VPWR VGND sg13cmos5l_decap_8
XFILLER_140_81 VPWR VGND sg13cmos5l_decap_8
XFILLER_16_210 VPWR VGND sg13cmos5l_decap_8
XFILLER_84_42 VPWR VGND sg13cmos5l_decap_4
XFILLER_129_112 VPWR VGND sg13cmos5l_decap_8
XFILLER_129_134 VPWR VGND sg13cmos5l_decap_8
XFILLER_31_268 VPWR VGND sg13cmos5l_decap_4
X_0513_ _0513_/Q Tile_X0Y1_FrameData[25] VGND VPWR Tile_X0Y1_FrameStrobe[5] latch
X_0444_ _0444_/Q Tile_X0Y1_FrameData[30] VGND VPWR Tile_X0Y1_FrameStrobe[3] latch
XFILLER_98_202 VPWR VGND sg13cmos5l_decap_8
X_0375_ _0375_/Q Tile_X0Y1_FrameData[3] VGND VPWR Tile_X0Y1_FrameStrobe[0] latch
XANTENNA__0635__Q NPU_WEIGHT_SHIFT_EN VPWR VGND sg13cmos5l_antennanp
XFILLER_120_18 VPWR VGND sg13cmos5l_fill_2
XFILLER_22_213 VPWR VGND sg13cmos5l_decap_8
XFILLER_22_268 VPWR VGND sg13cmos5l_decap_4
XFILLER_129_49 VPWR VGND sg13cmos5l_decap_8
XFILLER_135_126 VPWR VGND sg13cmos5l_decap_4
XFILLER_57_121 VPWR VGND sg13cmos5l_decap_8
XFILLER_89_235 VPWR VGND sg13cmos5l_decap_8
XFILLER_89_268 VPWR VGND sg13cmos5l_decap_4
XFILLER_13_224 VPWR VGND sg13cmos5l_decap_8
XFILLER_57_198 VPWR VGND sg13cmos5l_decap_8
XFILLER_72_168 VPWR VGND sg13cmos5l_decap_8
XFILLER_70_77 VPWR VGND sg13cmos5l_decap_8
XFILLER_135_70 VPWR VGND sg13cmos5l_decap_8
X_0160_ _0160_/Q Tile_X0Y0_FrameData[28] VGND VPWR Tile_X0Y1_FrameStrobe[2] latch
X_0091_ NPU_XBAR_SEL1 Tile_X0Y1_UserCLK _0091_/D _0654_/L_HI VPWR VGND sg13cmos5l_dfrbpq_1
XFILLER_63_168 VPWR VGND sg13cmos5l_decap_8
X_0993_ _0993_/X Tile_X0Y1_EE4END[3] Tile_X0Y1_EE4END[11] Tile_X0Y1_E6END[11] _1214_/X
+ _0412_/Q _0411_/Q VPWR VGND sg13cmos5l_mux4_1
XFILLER_117_115 VPWR VGND sg13cmos5l_fill_1
XFILLER_117_159 VPWR VGND sg13cmos5l_decap_8
XFILLER_8_272 VPWR VGND sg13cmos5l_fill_1
XFILLER_8_261 VPWR VGND sg13cmos5l_fill_1
XFILLER_8_250 VPWR VGND sg13cmos5l_decap_8
XFILLER_125_192 VPWR VGND sg13cmos5l_decap_8
XFILLER_140_151 VPWR VGND sg13cmos5l_decap_8
XFILLER_39_110 VPWR VGND sg13cmos5l_fill_1
X_0427_ _0427_/Q Tile_X0Y1_FrameData[15] VGND VPWR Tile_X0Y1_FrameStrobe[2] latch
XFILLER_131_28 VPWR VGND sg13cmos5l_decap_8
XFILLER_54_124 VPWR VGND sg13cmos5l_decap_8
X_0358_ _0358_/Q Tile_X0Y1_FrameData[20] VGND VPWR Tile_X0Y1_FrameStrobe[0] latch
X_0289_ _0289_/Q Tile_X0Y0_FrameData[27] VGND VPWR Tile_X0Y1_FrameStrobe[6] latch
XFILLER_10_216 VPWR VGND sg13cmos5l_decap_8
XFILLER_123_129 VPWR VGND sg13cmos5l_decap_8
XFILLER_131_140 VPWR VGND sg13cmos5l_decap_4
XFILLER_40_69 VPWR VGND sg13cmos5l_fill_1
XFILLER_105_51 VPWR VGND sg13cmos5l_fill_1
XFILLER_77_227 VPWR VGND sg13cmos5l_decap_8
XFILLER_92_219 VPWR VGND sg13cmos5l_decap_8
XANTENNA_101 Tile_X0Y1_FrameData[19] VPWR VGND sg13cmos5l_antennanp
XANTENNA_112 Tile_X0Y1_FrameData[23] VPWR VGND sg13cmos5l_antennanp
XANTENNA_123 Tile_X0Y1_FrameData[23] VPWR VGND sg13cmos5l_antennanp
XFILLER_45_168 VPWR VGND sg13cmos5l_decap_8
XFILLER_60_149 VPWR VGND sg13cmos5l_decap_8
XFILLER_65_77 VPWR VGND sg13cmos5l_decap_8
XFILLER_5_242 VPWR VGND sg13cmos5l_decap_8
XFILLER_122_162 VPWR VGND sg13cmos5l_decap_8
XFILLER_68_216 VPWR VGND sg13cmos5l_decap_8
XANTENNA__0964__X Tile_X0Y1_WW4BEG[7] VPWR VGND sg13cmos5l_antennanp
XFILLER_36_157 VPWR VGND sg13cmos5l_fill_1
X_1192_ _1192_/X Tile_X0Y1_N1END[1] Tile_X0Y1_E6END[1] _1228_/X _1192_/A3 _0352_/Q
+ _0351_/Q VPWR VGND sg13cmos5l_mux4_1
X_0212_ _0212_/Q Tile_X0Y0_FrameData[8] VGND VPWR Tile_X0Y1_FrameStrobe[3] latch
X_0143_ _0143_/Q Tile_X0Y0_FrameData[13] VGND VPWR Tile_X0Y1_FrameStrobe[1] latch
X_0074_ _0760_/A _1119_/X _1120_/X _0573_/Q VPWR VGND sg13cmos5l_mux2_1
XFILLER_91_230 VPWR VGND sg13cmos5l_decap_8
XFILLER_51_138 VPWR VGND sg13cmos5l_decap_8
XFILLER_72_0 VPWR VGND sg13cmos5l_decap_8
X_0976_ _0976_/X Tile_X0Y0_E2MID[3] Tile_X0Y0_E2END[3] _1095_/X _0976_/A3 _0164_/Q
+ _0163_/Q VPWR VGND sg13cmos5l_mux4_1
XFILLER_126_28 VPWR VGND sg13cmos5l_decap_8
XFILLER_126_39 VPWR VGND sg13cmos5l_fill_2
XANTENNA__0874__X Tile_X0Y0_FrameData_O[18] VPWR VGND sg13cmos5l_antennanp
XFILLER_67_271 VPWR VGND sg13cmos5l_fill_2
XFILLER_82_263 VPWR VGND sg13cmos5l_decap_8
XFILLER_136_210 VPWR VGND sg13cmos5l_decap_8
XFILLER_50_193 VPWR VGND sg13cmos5l_decap_8
XFILLER_116_61 VPWR VGND sg13cmos5l_decap_4
XFILLER_2_201 VPWR VGND sg13cmos5l_decap_8
XFILLER_76_21 VPWR VGND sg13cmos5l_decap_8
XANTENNA__0784__X Tile_X0Y0_N2BEGb[1] VPWR VGND sg13cmos5l_antennanp
XFILLER_18_102 VPWR VGND sg13cmos5l_decap_8
XFILLER_65_219 VPWR VGND sg13cmos5l_fill_1
XFILLER_73_252 VPWR VGND sg13cmos5l_decap_8
XFILLER_76_98 VPWR VGND sg13cmos5l_decap_8
XFILLER_92_42 VPWR VGND sg13cmos5l_decap_8
XFILLER_25_91 VPWR VGND sg13cmos5l_decap_8
X_0830_ Tile_X0Y1_FrameData_O[6] Tile_X0Y1_FrameData[6] VPWR VGND sg13cmos5l_buf_1
XANTENNA__0959__X Tile_X0Y1_WW4BEG[2] VPWR VGND sg13cmos5l_antennanp
XFILLER_127_254 VPWR VGND sg13cmos5l_decap_8
X_0761_ Tile_X0Y0_N4BEG[10] _0761_/A VPWR VGND sg13cmos5l_buf_1
X_0692_ _0692_/L_HI VPWR VGND sg13cmos5l_tiehi
XFILLER_2_95 VPWR VGND sg13cmos5l_decap_8
XFILLER_49_271 VPWR VGND sg13cmos5l_fill_2
XFILLER_24_127 VPWR VGND sg13cmos5l_decap_4
X_1175_ _1175_/X _0644_/Q _0648_/Q _1206_/X _1198_/X _0466_/Q _0465_/Q VPWR VGND sg13cmos5l_mux4_1
X_0126_ _0126_/Q Tile_X0Y0_FrameData[30] VGND VPWR Tile_X0Y1_FrameStrobe[1] latch
XANTENNA_12 Tile_X0Y0_S2MID[4] VPWR VGND sg13cmos5l_antennanp
XANTENNA_23 Tile_X0Y1_N2MID[0] VPWR VGND sg13cmos5l_antennanp
XANTENNA_34 Tile_X0Y1_N2MID[2] VPWR VGND sg13cmos5l_antennanp
XANTENNA_45 Tile_X0Y1_N2MID[6] VPWR VGND sg13cmos5l_antennanp
XANTENNA_56 Tile_X0Y1_N4END[4] VPWR VGND sg13cmos5l_antennanp
XANTENNA_67 Tile_X0Y1_N4END[4] VPWR VGND sg13cmos5l_antennanp
XANTENNA_78 NPU_OUT_ACT7 VPWR VGND sg13cmos5l_antennanp
XANTENNA_89 Tile_X0Y1_FrameData[19] VPWR VGND sg13cmos5l_antennanp
XFILLER_118_243 VPWR VGND sg13cmos5l_decap_8
XFILLER_32_171 VPWR VGND sg13cmos5l_decap_8
X_0959_ Tile_X0Y1_WW4BEG[2] _1165_/X VPWR VGND sg13cmos5l_buf_1
XANTENNA__0869__X Tile_X0Y0_FrameData_O[13] VPWR VGND sg13cmos5l_antennanp
XFILLER_133_213 VPWR VGND sg13cmos5l_decap_8
XFILLER_133_268 VPWR VGND sg13cmos5l_decap_4
XFILLER_137_49 VPWR VGND sg13cmos5l_decap_8
XFILLER_47_208 VPWR VGND sg13cmos5l_decap_8
XFILLER_102_96 VPWR VGND sg13cmos5l_decap_8
XFILLER_23_193 VPWR VGND sg13cmos5l_decap_8
XFILLER_62_56 VPWR VGND sg13cmos5l_decap_8
XFILLER_70_233 VPWR VGND sg13cmos5l_fill_1
XANTENNA__0779__X Tile_X0Y0_WW4BEG[12] VPWR VGND sg13cmos5l_antennanp
XFILLER_109_221 VPWR VGND sg13cmos5l_decap_8
XFILLER_11_93 VPWR VGND sg13cmos5l_fill_2
XFILLER_2_0 VPWR VGND sg13cmos5l_decap_8
XFILLER_38_208 VPWR VGND sg13cmos5l_decap_8
XFILLER_97_108 VPWR VGND sg13cmos5l_fill_2
XFILLER_36_90 VPWR VGND sg13cmos5l_fill_2
X_0813_ Tile_X0Y0_FrameStrobe_O[10] Tile_X0Y1_FrameStrobe[10] VPWR VGND sg13cmos5l_buf_1
XFILLER_115_268 VPWR VGND sg13cmos5l_decap_4
XFILLER_130_238 VPWR VGND sg13cmos5l_decap_8
X_0744_ Tile_X0Y0_W6BEG[5] _1068_/X VPWR VGND sg13cmos5l_buf_1
X_0675_ _0675_/L_HI VPWR VGND sg13cmos5l_tiehi
XFILLER_37_241 VPWR VGND sg13cmos5l_fill_2
X_1227_ _1227_/X Tile_X0Y0_E1END[0] Tile_X0Y0_E6END[8] _1075_/X _1100_/X _0310_/Q
+ _0309_/Q VPWR VGND sg13cmos5l_mux4_1
X_1158_ _1158_/X Tile_X0Y1_EE4END[5] _0647_/Q _1198_/X _1199_/X _0500_/Q _0499_/Q
+ VPWR VGND sg13cmos5l_mux4_1
XFILLER_12_108 VPWR VGND sg13cmos5l_decap_8
XFILLER_52_233 VPWR VGND sg13cmos5l_decap_8
X_1089_ _1089_/X _1112_/X Tile_X0Y1_N4END[5] Tile_X0Y0_S1END[1] Tile_X0Y0_S4END[1]
+ _0146_/Q _0145_/Q VPWR VGND sg13cmos5l_mux4_1
X_0109_ _0109_/Q Tile_X0Y0_FrameData[15] VGND VPWR Tile_X0Y1_FrameStrobe[0] latch
XFILLER_106_202 VPWR VGND sg13cmos5l_decap_8
XFILLER_121_227 VPWR VGND sg13cmos5l_fill_2
XFILLER_57_56 VPWR VGND sg13cmos5l_decap_8
XFILLER_87_152 VPWR VGND sg13cmos5l_decap_8
XFILLER_28_241 VPWR VGND sg13cmos5l_decap_8
XFILLER_43_222 VPWR VGND sg13cmos5l_decap_8
XFILLER_73_77 VPWR VGND sg13cmos5l_decap_8
XFILLER_11_141 VPWR VGND sg13cmos5l_decap_8
XFILLER_7_156 VPWR VGND sg13cmos5l_decap_8
XFILLER_138_70 VPWR VGND sg13cmos5l_decap_8
X_0460_ _0460_/Q Tile_X0Y1_FrameData[14] VGND VPWR Tile_X0Y1_FrameStrobe[3] latch
XFILLER_120_271 VPWR VGND sg13cmos5l_fill_2
XFILLER_78_185 VPWR VGND sg13cmos5l_decap_8
X_1012_ _1012_/X _1087_/X _1083_/X _1075_/X _1092_/X _0322_/Q _0321_/Q VPWR VGND sg13cmos5l_mux4_1
X_0391_ _0391_/Q Tile_X0Y1_FrameData[19] VGND VPWR Tile_X0Y1_FrameStrobe[1] latch
XANTENNA__0972__X Tile_X0Y1_WW4BEG[15] VPWR VGND sg13cmos5l_antennanp
XFILLER_34_222 VPWR VGND sg13cmos5l_decap_8
X_0727_ Tile_X0Y0_W2BEG[4] _1035_/X VPWR VGND sg13cmos5l_buf_1
XFILLER_8_61 VPWR VGND sg13cmos5l_decap_8
XFILLER_111_260 VPWR VGND sg13cmos5l_decap_4
XFILLER_134_28 VPWR VGND sg13cmos5l_decap_8
X_0658_ _0658_/L_HI VPWR VGND sg13cmos5l_tiehi
X_0589_ _0589_/Q Tile_X0Y1_FrameData[13] VGND VPWR Tile_X0Y1_FrameStrobe[7] latch
XANTENNA__0882__X Tile_X0Y0_FrameData_O[26] VPWR VGND sg13cmos5l_antennanp
XFILLER_25_244 VPWR VGND sg13cmos5l_decap_8
XFILLER_27_37 VPWR VGND sg13cmos5l_decap_8
XFILLER_84_199 VPWR VGND sg13cmos5l_decap_8
XFILLER_138_168 VPWR VGND sg13cmos5l_decap_8
XFILLER_4_126 VPWR VGND sg13cmos5l_decap_8
XFILLER_68_88 VPWR VGND sg13cmos5l_fill_2
XFILLER_75_133 VPWR VGND sg13cmos5l_decap_8
XANTENNA__0792__X Tile_X0Y0_N2BEG[1] VPWR VGND sg13cmos5l_antennanp
XFILLER_140_60 VPWR VGND sg13cmos5l_decap_8
XFILLER_31_247 VPWR VGND sg13cmos5l_decap_8
XFILLER_90_169 VPWR VGND sg13cmos5l_decap_8
XFILLER_76_7 VPWR VGND sg13cmos5l_decap_8
XANTENNA__0967__X Tile_X0Y1_WW4BEG[10] VPWR VGND sg13cmos5l_antennanp
XFILLER_3_192 VPWR VGND sg13cmos5l_decap_4
X_0512_ _0512_/Q Tile_X0Y1_FrameData[26] VGND VPWR Tile_X0Y1_FrameStrobe[5] latch
X_0443_ _0443_/Q Tile_X0Y1_FrameData[31] VGND VPWR Tile_X0Y1_FrameStrobe[3] latch
X_0374_ _0374_/Q Tile_X0Y1_FrameData[4] VGND VPWR Tile_X0Y1_FrameStrobe[0] latch
XFILLER_98_258 VPWR VGND sg13cmos5l_decap_8
XFILLER_66_188 VPWR VGND sg13cmos5l_decap_8
XFILLER_81_169 VPWR VGND sg13cmos5l_decap_8
XFILLER_129_28 VPWR VGND sg13cmos5l_decap_8
XFILLER_135_105 VPWR VGND sg13cmos5l_decap_8
XFILLER_135_149 VPWR VGND sg13cmos5l_decap_8
XFILLER_1_107 VPWR VGND sg13cmos5l_decap_4
XFILLER_89_214 VPWR VGND sg13cmos5l_decap_8
XANTENNA__0877__X Tile_X0Y0_FrameData_O[21] VPWR VGND sg13cmos5l_antennanp
XFILLER_13_203 VPWR VGND sg13cmos5l_decap_8
XFILLER_54_35 VPWR VGND sg13cmos5l_fill_1
XFILLER_54_57 VPWR VGND sg13cmos5l_fill_2
XFILLER_72_147 VPWR VGND sg13cmos5l_decap_8
XFILLER_119_72 VPWR VGND sg13cmos5l_fill_1
XFILLER_126_149 VPWR VGND sg13cmos5l_decap_8
XFILLER_70_56 VPWR VGND sg13cmos5l_decap_8
XANTENNA__0787__X Tile_X0Y0_N2BEGb[4] VPWR VGND sg13cmos5l_antennanp
XFILLER_102_0 VPWR VGND sg13cmos5l_fill_2
XFILLER_134_182 VPWR VGND sg13cmos5l_decap_8
XFILLER_141_108 VPWR VGND sg13cmos5l_decap_8
XFILLER_95_239 VPWR VGND sg13cmos5l_decap_8
XFILLER_48_188 VPWR VGND sg13cmos5l_fill_2
XFILLER_63_147 VPWR VGND sg13cmos5l_decap_8
X_0090_ NPU_XBAR_SEL0 Tile_X0Y1_UserCLK _0090_/D _0655_/L_HI VPWR VGND sg13cmos5l_dfrbpq_1
XFILLER_71_191 VPWR VGND sg13cmos5l_decap_8
X_0992_ _0992_/X Tile_X0Y1_EE4END[2] Tile_X0Y1_EE4END[10] Tile_X0Y1_E6END[10] _1213_/X
+ _0414_/Q _0413_/Q VPWR VGND sg13cmos5l_mux4_1
XFILLER_117_138 VPWR VGND sg13cmos5l_decap_8
XFILLER_125_171 VPWR VGND sg13cmos5l_decap_8
XFILLER_132_119 VPWR VGND sg13cmos5l_decap_8
XFILLER_140_130 VPWR VGND sg13cmos5l_decap_8
XFILLER_5_84 VPWR VGND sg13cmos5l_decap_8
XFILLER_86_239 VPWR VGND sg13cmos5l_decap_8
X_0426_ _0426_/Q Tile_X0Y1_FrameData[16] VGND VPWR Tile_X0Y1_FrameStrobe[2] latch
X_0357_ _0357_/Q Tile_X0Y1_FrameData[21] VGND VPWR Tile_X0Y1_FrameStrobe[0] latch
X_0288_ _0288_/Q Tile_X0Y0_FrameData[28] VGND VPWR Tile_X0Y1_FrameStrobe[6] latch
XFILLER_94_272 VPWR VGND sg13cmos5l_fill_1
XFILLER_108_127 VPWR VGND sg13cmos5l_fill_1
XFILLER_123_108 VPWR VGND sg13cmos5l_decap_8
XFILLER_49_35 VPWR VGND sg13cmos5l_fill_1
XFILLER_6_7 VPWR VGND sg13cmos5l_decap_8
XFILLER_77_206 VPWR VGND sg13cmos5l_decap_8
XANTENNA_102 Tile_X0Y1_FrameData[19] VPWR VGND sg13cmos5l_antennanp
XANTENNA_113 Tile_X0Y1_FrameData[23] VPWR VGND sg13cmos5l_antennanp
XANTENNA_124 Tile_X0Y1_FrameData[23] VPWR VGND sg13cmos5l_antennanp
XFILLER_131_185 VPWR VGND sg13cmos5l_decap_8
XFILLER_65_56 VPWR VGND sg13cmos5l_decap_8
XFILLER_85_272 VPWR VGND sg13cmos5l_fill_1
XFILLER_60_128 VPWR VGND sg13cmos5l_decap_8
XFILLER_81_88 VPWR VGND sg13cmos5l_fill_2
XFILLER_107_171 VPWR VGND sg13cmos5l_fill_2
XFILLER_5_221 VPWR VGND sg13cmos5l_decap_8
XFILLER_122_141 VPWR VGND sg13cmos5l_decap_8
X_1191_ _1191_/X Tile_X0Y1_N1END[0] Tile_X0Y1_E6END[0] _1227_/X _1191_/A3 _0354_/Q
+ _0353_/Q VPWR VGND sg13cmos5l_mux4_1
X_0211_ _0211_/Q Tile_X0Y0_FrameData[9] VGND VPWR Tile_X0Y1_FrameStrobe[3] latch
XFILLER_44_191 VPWR VGND sg13cmos5l_decap_8
X_0142_ _0142_/Q Tile_X0Y0_FrameData[14] VGND VPWR Tile_X0Y1_FrameStrobe[1] latch
X_0073_ _0759_/A _1121_/X _1122_/X _0576_/Q VPWR VGND sg13cmos5l_mux2_1
XFILLER_65_0 VPWR VGND sg13cmos5l_decap_8
X_0975_ _0975_/X Tile_X0Y0_E2MID[2] Tile_X0Y0_E2END[2] _1094_/X _0975_/A3 _0166_/Q
+ _0165_/Q VPWR VGND sg13cmos5l_mux4_1
XFILLER_59_239 VPWR VGND sg13cmos5l_decap_8
XFILLER_82_242 VPWR VGND sg13cmos5l_decap_8
X_0409_ _0409_/Q Tile_X0Y1_FrameData[1] VGND VPWR Tile_X0Y1_FrameStrobe[1] latch
XANTENNA__0890__X Tile_X0Y1_S1BEG[2] VPWR VGND sg13cmos5l_antennanp
XFILLER_27_169 VPWR VGND sg13cmos5l_decap_8
XFILLER_35_191 VPWR VGND sg13cmos5l_decap_8
XFILLER_50_172 VPWR VGND sg13cmos5l_decap_8
XFILLER_51_36 VPWR VGND sg13cmos5l_decap_8
XFILLER_136_266 VPWR VGND sg13cmos5l_decap_8
XFILLER_18_147 VPWR VGND sg13cmos5l_fill_2
XFILLER_33_106 VPWR VGND sg13cmos5l_fill_1
XFILLER_58_272 VPWR VGND sg13cmos5l_fill_1
XFILLER_73_231 VPWR VGND sg13cmos5l_decap_8
XFILLER_76_77 VPWR VGND sg13cmos5l_decap_8
XFILLER_92_87 VPWR VGND sg13cmos5l_fill_1
XFILLER_127_233 VPWR VGND sg13cmos5l_decap_8
XFILLER_41_183 VPWR VGND sg13cmos5l_decap_8
X_0760_ Tile_X0Y0_N4BEG[9] _0760_/A VPWR VGND sg13cmos5l_buf_1
XFILLER_37_4 VPWR VGND sg13cmos5l_fill_1
X_0691_ _0691_/L_HI VPWR VGND sg13cmos5l_tiehi
XFILLER_2_63 VPWR VGND sg13cmos5l_fill_2
XFILLER_2_74 VPWR VGND sg13cmos5l_decap_8
XFILLER_49_261 VPWR VGND sg13cmos5l_fill_1
X_1174_ _1174_/X _0647_/Q _0651_/Q _1207_/X _1199_/X _0468_/Q _0467_/Q VPWR VGND sg13cmos5l_mux4_1
XANTENNA_13 Tile_X0Y0_S2MID[5] VPWR VGND sg13cmos5l_antennanp
X_0125_ _0125_/Q Tile_X0Y0_FrameData[31] VGND VPWR Tile_X0Y1_FrameStrobe[1] latch
XANTENNA_24 Tile_X0Y1_N2MID[0] VPWR VGND sg13cmos5l_antennanp
XANTENNA_35 Tile_X0Y1_N2MID[3] VPWR VGND sg13cmos5l_antennanp
XANTENNA_46 Tile_X0Y1_N2MID[6] VPWR VGND sg13cmos5l_antennanp
XANTENNA_57 Tile_X0Y1_N4END[4] VPWR VGND sg13cmos5l_antennanp
XANTENNA_68 Tile_X0Y1_N4END[4] VPWR VGND sg13cmos5l_antennanp
XANTENNA_79 Tile_X0Y1_FrameData[19] VPWR VGND sg13cmos5l_antennanp
XFILLER_118_222 VPWR VGND sg13cmos5l_decap_8
XFILLER_137_28 VPWR VGND sg13cmos5l_decap_8
XFILLER_21_28 VPWR VGND sg13cmos5l_fill_2
X_0889_ Tile_X0Y1_S1BEG[1] _1124_/X VPWR VGND sg13cmos5l_buf_1
X_0958_ Tile_X0Y1_WW4BEG[1] _1164_/X VPWR VGND sg13cmos5l_buf_1
XANTENNA__0885__X Tile_X0Y0_FrameData_O[29] VPWR VGND sg13cmos5l_antennanp
XFILLER_101_188 VPWR VGND sg13cmos5l_decap_8
XFILLER_15_128 VPWR VGND sg13cmos5l_fill_1
XFILLER_15_139 VPWR VGND sg13cmos5l_decap_8
XFILLER_55_220 VPWR VGND sg13cmos5l_decap_8
XFILLER_55_264 VPWR VGND sg13cmos5l_fill_1
XFILLER_109_200 VPWR VGND sg13cmos5l_decap_8
XFILLER_23_172 VPWR VGND sg13cmos5l_decap_8
XFILLER_62_35 VPWR VGND sg13cmos5l_decap_8
XFILLER_109_255 VPWR VGND sg13cmos5l_decap_8
XFILLER_124_203 VPWR VGND sg13cmos5l_decap_8
XFILLER_124_258 VPWR VGND sg13cmos5l_decap_8
XANTENNA__0795__X Tile_X0Y0_N2BEG[4] VPWR VGND sg13cmos5l_antennanp
XFILLER_46_253 VPWR VGND sg13cmos5l_decap_8
XFILLER_46_264 VPWR VGND sg13cmos5l_fill_1
XFILLER_14_194 VPWR VGND sg13cmos5l_decap_8
X_0812_ Tile_X0Y0_FrameStrobe_O[9] Tile_X0Y1_FrameStrobe[9] VPWR VGND sg13cmos5l_buf_1
X_0743_ Tile_X0Y0_W6BEG[4] _1067_/X VPWR VGND sg13cmos5l_buf_1
XFILLER_115_225 VPWR VGND sg13cmos5l_decap_8
XFILLER_130_217 VPWR VGND sg13cmos5l_decap_8
X_0674_ _0674_/L_HI VPWR VGND sg13cmos5l_tiehi
XFILLER_96_131 VPWR VGND sg13cmos5l_decap_8
XFILLER_37_220 VPWR VGND sg13cmos5l_decap_8
XFILLER_52_212 VPWR VGND sg13cmos5l_decap_8
X_1226_ _1226_/X Tile_X0Y0_E1END[3] Tile_X0Y0_E2MID[0] Tile_X0Y0_E2END[0] _1099_/X
+ _0288_/Q _0287_/Q VPWR VGND sg13cmos5l_mux4_1
X_1157_ _1157_/X Tile_X0Y1_E2END[3] _0646_/Q _1197_/X _1200_/X _0502_/Q _0501_/Q VPWR
+ VGND sg13cmos5l_mux4_1
X_0108_ _0108_/Q Tile_X0Y0_FrameData[16] VGND VPWR Tile_X0Y1_FrameStrobe[0] latch
XFILLER_96_197 VPWR VGND sg13cmos5l_decap_8
XFILLER_20_131 VPWR VGND sg13cmos5l_fill_1
XFILLER_32_49 VPWR VGND sg13cmos5l_decap_8
X_1088_ _1088_/X _1111_/X Tile_X0Y1_N4END[4] Tile_X0Y0_S1END[0] Tile_X0Y0_S4END[0]
+ _0148_/Q _0147_/Q VPWR VGND sg13cmos5l_mux4_1
XFILLER_106_258 VPWR VGND sg13cmos5l_decap_8
XFILLER_121_206 VPWR VGND sg13cmos5l_decap_8
XFILLER_28_220 VPWR VGND sg13cmos5l_decap_8
XFILLER_57_35 VPWR VGND sg13cmos5l_decap_8
XFILLER_87_175 VPWR VGND sg13cmos5l_fill_1
XFILLER_28_264 VPWR VGND sg13cmos5l_fill_1
XFILLER_43_201 VPWR VGND sg13cmos5l_decap_8
XFILLER_73_56 VPWR VGND sg13cmos5l_decap_8
XFILLER_11_120 VPWR VGND sg13cmos5l_decap_8
XFILLER_11_197 VPWR VGND sg13cmos5l_decap_8
XFILLER_132_0 VPWR VGND sg13cmos5l_decap_8
XFILLER_7_135 VPWR VGND sg13cmos5l_decap_8
X_0390_ _0390_/Q Tile_X0Y1_FrameData[20] VGND VPWR Tile_X0Y1_FrameStrobe[1] latch
XFILLER_98_64 VPWR VGND sg13cmos5l_decap_8
XFILLER_120_250 VPWR VGND sg13cmos5l_decap_8
XFILLER_19_264 VPWR VGND sg13cmos5l_fill_1
XFILLER_34_201 VPWR VGND sg13cmos5l_decap_8
XFILLER_78_164 VPWR VGND sg13cmos5l_decap_8
X_1011_ _1011_/X Tile_X0Y0_E1END[0] Tile_X0Y0_EE4END[0] Tile_X0Y0_E6END[8] _1088_/X
+ _0322_/Q _0321_/Q VPWR VGND sg13cmos5l_mux4_1
XFILLER_8_40 VPWR VGND sg13cmos5l_decap_8
X_0726_ Tile_X0Y0_W2BEG[3] _1034_/X VPWR VGND sg13cmos5l_buf_1
XFILLER_111_272 VPWR VGND sg13cmos5l_fill_1
XFILLER_69_186 VPWR VGND sg13cmos5l_decap_8
X_0657_ _0657_/L_HI VPWR VGND sg13cmos5l_tiehi
X_0588_ _0588_/Q Tile_X0Y1_FrameData[14] VGND VPWR Tile_X0Y1_FrameStrobe[7] latch
XFILLER_25_223 VPWR VGND sg13cmos5l_decap_8
XFILLER_40_215 VPWR VGND sg13cmos5l_decap_8
XFILLER_84_178 VPWR VGND sg13cmos5l_decap_8
X_1209_ _1209_/X Tile_X0Y1_N1END[2] Tile_X0Y1_N4END[2] _1229_/X Tile_X0Y0_S4END[6]
+ _0390_/Q _0389_/Q VPWR VGND sg13cmos5l_mux4_1
XFILLER_138_147 VPWR VGND sg13cmos5l_decap_8
XFILLER_4_105 VPWR VGND sg13cmos5l_fill_2
XFILLER_108_85 VPWR VGND sg13cmos5l_decap_8
XFILLER_68_67 VPWR VGND sg13cmos5l_decap_8
XFILLER_124_40 VPWR VGND sg13cmos5l_fill_1
XFILLER_124_51 VPWR VGND sg13cmos5l_fill_1
XFILLER_124_73 VPWR VGND sg13cmos5l_decap_8
XFILLER_75_112 VPWR VGND sg13cmos5l_decap_8
XFILLER_75_189 VPWR VGND sg13cmos5l_decap_8
XFILLER_84_55 VPWR VGND sg13cmos5l_decap_4
XFILLER_31_226 VPWR VGND sg13cmos5l_decap_8
XFILLER_83_9 VPWR VGND sg13cmos5l_decap_8
XFILLER_90_148 VPWR VGND sg13cmos5l_decap_8
XFILLER_129_169 VPWR VGND sg13cmos5l_decap_8
XFILLER_69_7 VPWR VGND sg13cmos5l_decap_8
X_0511_ _0511_/Q Tile_X0Y1_FrameData[27] VGND VPWR Tile_X0Y1_FrameStrobe[5] latch
X_0442_ _0442_/Q Tile_X0Y1_FrameData[0] VGND VPWR Tile_X0Y1_FrameStrobe[2] latch
X_0373_ _0373_/Q Tile_X0Y1_FrameData[5] VGND VPWR Tile_X0Y1_FrameStrobe[0] latch
XFILLER_98_237 VPWR VGND sg13cmos5l_decap_8
XFILLER_66_167 VPWR VGND sg13cmos5l_decap_8
XFILLER_81_148 VPWR VGND sg13cmos5l_decap_8
XFILLER_22_248 VPWR VGND sg13cmos5l_decap_8
XFILLER_95_0 VPWR VGND sg13cmos5l_fill_2
X_0709_ _1192_/A3 VPWR VGND sg13cmos5l_tielo
XANTENNA__0893__X Tile_X0Y1_S2BEG[1] VPWR VGND sg13cmos5l_antennanp
XFILLER_54_14 VPWR VGND sg13cmos5l_decap_8
XFILLER_57_156 VPWR VGND sg13cmos5l_decap_8
XFILLER_72_126 VPWR VGND sg13cmos5l_decap_8
XFILLER_110_75 VPWR VGND sg13cmos5l_fill_2
XFILLER_13_259 VPWR VGND sg13cmos5l_decap_8
XFILLER_70_35 VPWR VGND sg13cmos5l_decap_8
XFILLER_80_192 VPWR VGND sg13cmos5l_decap_8
XFILLER_9_219 VPWR VGND sg13cmos5l_decap_8
XFILLER_119_180 VPWR VGND sg13cmos5l_decap_8
XFILLER_126_128 VPWR VGND sg13cmos5l_decap_8
XFILLER_0_130 VPWR VGND sg13cmos5l_fill_2
XFILLER_0_174 VPWR VGND sg13cmos5l_decap_4
XFILLER_134_161 VPWR VGND sg13cmos5l_decap_8
XFILLER_88_270 VPWR VGND sg13cmos5l_fill_2
XFILLER_95_218 VPWR VGND sg13cmos5l_decap_8
XFILLER_48_167 VPWR VGND sg13cmos5l_decap_8
XFILLER_63_126 VPWR VGND sg13cmos5l_decap_8
XFILLER_95_98 VPWR VGND sg13cmos5l_decap_8
XFILLER_117_106 VPWR VGND sg13cmos5l_decap_4
XFILLER_44_91 VPWR VGND sg13cmos5l_decap_8
X_0991_ _0991_/X Tile_X0Y1_EE4END[1] Tile_X0Y1_EE4END[9] Tile_X0Y1_E6END[9] _1212_/X
+ _0416_/Q _0415_/Q VPWR VGND sg13cmos5l_mux4_1
XFILLER_125_150 VPWR VGND sg13cmos5l_decap_8
XFILLER_5_63 VPWR VGND sg13cmos5l_decap_8
XFILLER_140_186 VPWR VGND sg13cmos5l_decap_8
XFILLER_39_156 VPWR VGND sg13cmos5l_fill_1
XFILLER_39_189 VPWR VGND sg13cmos5l_fill_2
XFILLER_86_218 VPWR VGND sg13cmos5l_decap_8
X_0425_ _0425_/Q Tile_X0Y1_FrameData[17] VGND VPWR Tile_X0Y1_FrameStrobe[2] latch
X_0356_ _0356_/Q Tile_X0Y1_FrameData[22] VGND VPWR Tile_X0Y1_FrameStrobe[0] latch
X_0287_ _0287_/Q Tile_X0Y0_FrameData[29] VGND VPWR Tile_X0Y1_FrameStrobe[6] latch
XFILLER_94_251 VPWR VGND sg13cmos5l_decap_8
XFILLER_24_39 VPWR VGND sg13cmos5l_fill_2
XFILLER_54_159 VPWR VGND sg13cmos5l_decap_8
XANTENNA__0888__X Tile_X0Y1_S1BEG[0] VPWR VGND sg13cmos5l_antennanp
XFILLER_105_42 VPWR VGND sg13cmos5l_decap_8
XFILLER_116_183 VPWR VGND sg13cmos5l_decap_8
XFILLER_131_164 VPWR VGND sg13cmos5l_decap_8
XANTENNA_103 Tile_X0Y1_FrameData[19] VPWR VGND sg13cmos5l_antennanp
XANTENNA_114 Tile_X0Y1_FrameData[23] VPWR VGND sg13cmos5l_antennanp
XANTENNA_125 _0997_/X VPWR VGND sg13cmos5l_antennanp
XFILLER_60_107 VPWR VGND sg13cmos5l_decap_8
XFILLER_65_35 VPWR VGND sg13cmos5l_decap_8
XFILLER_85_251 VPWR VGND sg13cmos5l_decap_8
XFILLER_139_253 VPWR VGND sg13cmos5l_decap_8
XFILLER_14_61 VPWR VGND sg13cmos5l_fill_2
XFILLER_53_192 VPWR VGND sg13cmos5l_decap_8
XFILLER_81_78 VPWR VGND sg13cmos5l_fill_2
XANTENNA__0798__X Tile_X0Y0_N2BEG[7] VPWR VGND sg13cmos5l_antennanp
XFILLER_107_183 VPWR VGND sg13cmos5l_decap_8
XFILLER_122_120 VPWR VGND sg13cmos5l_decap_8
XFILLER_5_200 VPWR VGND sg13cmos5l_decap_8
XFILLER_122_197 VPWR VGND sg13cmos5l_decap_8
X_1190_ _1190_/X _0647_/Q _1203_/X _1207_/X _1202_/X _0436_/Q _0435_/Q VPWR VGND sg13cmos5l_mux4_1
X_0210_ _0210_/Q Tile_X0Y0_FrameData[10] VGND VPWR Tile_X0Y1_FrameStrobe[3] latch
X_0141_ _0141_/Q Tile_X0Y0_FrameData[15] VGND VPWR Tile_X0Y1_FrameStrobe[1] latch
XFILLER_36_148 VPWR VGND sg13cmos5l_decap_8
XFILLER_44_170 VPWR VGND sg13cmos5l_decap_8
XFILLER_55_90 VPWR VGND sg13cmos5l_decap_8
X_0072_ _0092_/D _1233_/X _0605_/Q _0608_/Q VPWR VGND sg13cmos5l_mux2_1
XFILLER_91_265 VPWR VGND sg13cmos5l_decap_8
X_0974_ _0974_/X Tile_X0Y0_E2MID[1] Tile_X0Y0_E2END[1] _1093_/X _0974_/A3 _0168_/Q
+ _0167_/Q VPWR VGND sg13cmos5l_mux4_1
XFILLER_113_175 VPWR VGND sg13cmos5l_decap_8
XFILLER_113_186 VPWR VGND sg13cmos5l_fill_2
XFILLER_19_28 VPWR VGND sg13cmos5l_decap_4
XFILLER_58_0 VPWR VGND sg13cmos5l_decap_8
XFILLER_59_218 VPWR VGND sg13cmos5l_decap_8
XFILLER_27_126 VPWR VGND sg13cmos5l_decap_4
XFILLER_27_137 VPWR VGND sg13cmos5l_decap_8
XFILLER_82_221 VPWR VGND sg13cmos5l_decap_8
X_0408_ _0408_/Q Tile_X0Y1_FrameData[2] VGND VPWR Tile_X0Y1_FrameStrobe[1] latch
X_0339_ _0339_/Q Tile_X0Y0_FrameData[9] VGND VPWR Tile_X0Y1_FrameStrobe[7] latch
XFILLER_136_7 VPWR VGND sg13cmos5l_decap_8
XFILLER_35_170 VPWR VGND sg13cmos5l_decap_4
XFILLER_42_129 VPWR VGND sg13cmos5l_fill_1
XFILLER_50_151 VPWR VGND sg13cmos5l_decap_8
XFILLER_136_245 VPWR VGND sg13cmos5l_decap_8
XFILLER_2_236 VPWR VGND sg13cmos5l_decap_8
XFILLER_104_186 VPWR VGND sg13cmos5l_decap_8
XFILLER_116_74 VPWR VGND sg13cmos5l_decap_8
XFILLER_116_85 VPWR VGND sg13cmos5l_fill_2
XFILLER_2_258 VPWR VGND sg13cmos5l_fill_1
XFILLER_73_210 VPWR VGND sg13cmos5l_decap_8
XFILLER_76_56 VPWR VGND sg13cmos5l_decap_8
XFILLER_132_84 VPWR VGND sg13cmos5l_decap_8
XFILLER_127_212 VPWR VGND sg13cmos5l_decap_8
XFILLER_41_162 VPWR VGND sg13cmos5l_decap_8
XFILLER_41_70 VPWR VGND sg13cmos5l_fill_2
X_0690_ _0690_/L_HI VPWR VGND sg13cmos5l_tiehi
XFILLER_110_145 VPWR VGND sg13cmos5l_decap_8
XFILLER_110_189 VPWR VGND sg13cmos5l_decap_8
XFILLER_2_42 VPWR VGND sg13cmos5l_decap_8
XFILLER_49_240 VPWR VGND sg13cmos5l_decap_8
XFILLER_64_210 VPWR VGND sg13cmos5l_decap_8
X_1173_ _1173_/X _0646_/Q _0650_/Q _1208_/X _1200_/X _0470_/Q _0469_/Q VPWR VGND sg13cmos5l_mux4_1
X_0124_ _0124_/Q Tile_X0Y0_FrameData[0] VGND VPWR Tile_X0Y1_FrameStrobe[0] latch
XANTENNA_14 Tile_X0Y0_S2MID[5] VPWR VGND sg13cmos5l_antennanp
XANTENNA_25 Tile_X0Y1_N2MID[0] VPWR VGND sg13cmos5l_antennanp
XANTENNA_36 Tile_X0Y1_N2MID[3] VPWR VGND sg13cmos5l_antennanp
XANTENNA_47 Tile_X0Y1_N2MID[6] VPWR VGND sg13cmos5l_antennanp
XFILLER_17_170 VPWR VGND sg13cmos5l_fill_1
XANTENNA_58 Tile_X0Y1_N4END[4] VPWR VGND sg13cmos5l_antennanp
XANTENNA_69 Tile_X0Y1_N4END[4] VPWR VGND sg13cmos5l_antennanp
XFILLER_118_201 VPWR VGND sg13cmos5l_decap_8
XFILLER_133_248 VPWR VGND sg13cmos5l_decap_8
X_0888_ Tile_X0Y1_S1BEG[0] _1123_/X VPWR VGND sg13cmos5l_buf_1
X_0957_ Tile_X0Y1_WW4BEG[0] _1163_/X VPWR VGND sg13cmos5l_buf_1
XFILLER_101_145 VPWR VGND sg13cmos5l_decap_4
XFILLER_101_167 VPWR VGND sg13cmos5l_decap_8
XFILLER_99_184 VPWR VGND sg13cmos5l_decap_8
XFILLER_15_107 VPWR VGND sg13cmos5l_decap_8
XFILLER_46_37 VPWR VGND sg13cmos5l_decap_8
XFILLER_62_14 VPWR VGND sg13cmos5l_decap_8
XFILLER_70_224 VPWR VGND sg13cmos5l_decap_8
XFILLER_109_234 VPWR VGND sg13cmos5l_decap_8
XFILLER_124_237 VPWR VGND sg13cmos5l_decap_8
XFILLER_127_84 VPWR VGND sg13cmos5l_decap_8
XFILLER_87_55 VPWR VGND sg13cmos5l_fill_1
XFILLER_87_77 VPWR VGND sg13cmos5l_decap_8
XFILLER_46_232 VPWR VGND sg13cmos5l_decap_8
XFILLER_87_88 VPWR VGND sg13cmos5l_fill_2
XFILLER_14_140 VPWR VGND sg13cmos5l_decap_8
XFILLER_14_173 VPWR VGND sg13cmos5l_decap_8
XFILLER_61_224 VPWR VGND sg13cmos5l_decap_8
XFILLER_61_257 VPWR VGND sg13cmos5l_decap_8
XFILLER_115_204 VPWR VGND sg13cmos5l_decap_8
X_0811_ Tile_X0Y0_FrameStrobe_O[8] Tile_X0Y1_FrameStrobe[8] VPWR VGND sg13cmos5l_buf_1
X_0742_ Tile_X0Y0_W6BEG[3] _1066_/X VPWR VGND sg13cmos5l_buf_1
X_0673_ _0673_/L_HI VPWR VGND sg13cmos5l_tiehi
XFILLER_115_259 VPWR VGND sg13cmos5l_decap_4
XFILLER_96_176 VPWR VGND sg13cmos5l_decap_8
XFILLER_96_110 VPWR VGND sg13cmos5l_decap_8
XFILLER_16_29 VPWR VGND sg13cmos5l_fill_2
XFILLER_37_243 VPWR VGND sg13cmos5l_fill_1
XFILLER_52_268 VPWR VGND sg13cmos5l_decap_4
X_1087_ _1087_/X _1111_/X Tile_X0Y1_N4END[4] Tile_X0Y0_S1END[0] Tile_X0Y0_S4END[0]
+ _0140_/Q _0139_/Q VPWR VGND sg13cmos5l_mux4_1
X_1225_ _1225_/X Tile_X0Y0_E1END[2] Tile_X0Y0_E2MID[1] Tile_X0Y0_E2END[1] _1098_/X
+ _0290_/Q _0289_/Q VPWR VGND sg13cmos5l_mux4_1
X_1156_ _1156_/X Tile_X0Y1_E2MID[4] _0645_/Q _1196_/X _1201_/X _0504_/Q _0503_/Q VPWR
+ VGND sg13cmos5l_mux4_1
X_0107_ _0107_/Q Tile_X0Y0_FrameData[17] VGND VPWR Tile_X0Y1_FrameStrobe[0] latch
XFILLER_32_28 VPWR VGND sg13cmos5l_fill_1
XANTENNA__0896__X Tile_X0Y1_S2BEG[4] VPWR VGND sg13cmos5l_antennanp
XFILLER_106_237 VPWR VGND sg13cmos5l_decap_8
XFILLER_57_14 VPWR VGND sg13cmos5l_decap_8
XFILLER_87_187 VPWR VGND sg13cmos5l_decap_8
XFILLER_43_257 VPWR VGND sg13cmos5l_decap_8
XFILLER_73_35 VPWR VGND sg13cmos5l_decap_8
XFILLER_11_176 VPWR VGND sg13cmos5l_decap_8
XFILLER_125_0 VPWR VGND sg13cmos5l_decap_8
XFILLER_7_114 VPWR VGND sg13cmos5l_decap_8
XFILLER_98_32 VPWR VGND sg13cmos5l_fill_1
XFILLER_98_10 VPWR VGND sg13cmos5l_fill_1
XFILLER_112_229 VPWR VGND sg13cmos5l_decap_8
XFILLER_19_243 VPWR VGND sg13cmos5l_decap_8
X_1010_ _1010_/X Tile_X0Y0_E2MID[0] Tile_X0Y0_E2END[0] Tile_X0Y0_E6END[0] _1099_/X
+ _0324_/Q _0323_/Q VPWR VGND sg13cmos5l_mux4_1
XFILLER_93_179 VPWR VGND sg13cmos5l_decap_8
XFILLER_103_229 VPWR VGND sg13cmos5l_decap_8
XFILLER_40_0 VPWR VGND sg13cmos5l_fill_1
X_0725_ Tile_X0Y0_W2BEG[2] _1033_/X VPWR VGND sg13cmos5l_buf_1
X_0656_ _0656_/L_HI VPWR VGND sg13cmos5l_tiehi
XFILLER_8_96 VPWR VGND sg13cmos5l_decap_8
XFILLER_27_28 VPWR VGND sg13cmos5l_fill_2
XFILLER_84_157 VPWR VGND sg13cmos5l_decap_8
X_1208_ _1208_/X Tile_X0Y1_N1END[1] Tile_X0Y1_N4END[1] _1228_/X Tile_X0Y0_S4END[5]
+ _0392_/Q _0391_/Q VPWR VGND sg13cmos5l_mux4_1
X_0587_ _0587_/Q Tile_X0Y1_FrameData[15] VGND VPWR Tile_X0Y1_FrameStrobe[7] latch
XFILLER_25_202 VPWR VGND sg13cmos5l_decap_8
XFILLER_25_268 VPWR VGND sg13cmos5l_decap_4
X_1139_ _1139_/X Tile_X0Y1_E1END[2] Tile_X0Y1_EE4END[14] Tile_X0Y1_E6END[6] _1205_/X
+ _0536_/Q _0535_/Q VPWR VGND sg13cmos5l_mux4_1
XFILLER_138_126 VPWR VGND sg13cmos5l_decap_8
XFILLER_68_35 VPWR VGND sg13cmos5l_decap_8
XFILLER_16_224 VPWR VGND sg13cmos5l_decap_8
XFILLER_17_72 VPWR VGND sg13cmos5l_decap_4
XFILLER_75_168 VPWR VGND sg13cmos5l_decap_8
XFILLER_129_126 VPWR VGND sg13cmos5l_decap_4
XFILLER_129_148 VPWR VGND sg13cmos5l_decap_8
XFILLER_140_95 VPWR VGND sg13cmos5l_decap_8
XFILLER_16_268 VPWR VGND sg13cmos5l_decap_4
XFILLER_31_205 VPWR VGND sg13cmos5l_decap_8
XFILLER_137_181 VPWR VGND sg13cmos5l_decap_8
XFILLER_3_150 VPWR VGND sg13cmos5l_decap_8
X_0510_ _0510_/Q Tile_X0Y1_FrameData[28] VGND VPWR Tile_X0Y1_FrameStrobe[5] latch
XFILLER_98_216 VPWR VGND sg13cmos5l_decap_8
XFILLER_3_183 VPWR VGND sg13cmos5l_fill_2
XFILLER_66_146 VPWR VGND sg13cmos5l_decap_8
X_0441_ _0441_/Q Tile_X0Y1_FrameData[1] VGND VPWR Tile_X0Y1_FrameStrobe[2] latch
X_0372_ _0372_/Q Tile_X0Y1_FrameData[6] VGND VPWR Tile_X0Y1_FrameStrobe[0] latch
XFILLER_22_227 VPWR VGND sg13cmos5l_decap_8
XFILLER_88_0 VPWR VGND sg13cmos5l_fill_2
XFILLER_57_102 VPWR VGND sg13cmos5l_decap_8
XFILLER_89_249 VPWR VGND sg13cmos5l_decap_8
X_0708_ _1193_/A3 VPWR VGND sg13cmos5l_tielo
X_0639_ _0639_/Q Tile_X0Y1_UserCLK NPU_OUT_ACT3 _0669_/L_HI VPWR VGND sg13cmos5l_dfrbpq_1
XFILLER_57_135 VPWR VGND sg13cmos5l_decap_8
XFILLER_72_105 VPWR VGND sg13cmos5l_decap_8
XFILLER_13_238 VPWR VGND sg13cmos5l_decap_8
XFILLER_54_59 VPWR VGND sg13cmos5l_fill_1
XFILLER_70_14 VPWR VGND sg13cmos5l_decap_8
XFILLER_80_171 VPWR VGND sg13cmos5l_decap_8
XFILLER_126_107 VPWR VGND sg13cmos5l_decap_8
XFILLER_134_140 VPWR VGND sg13cmos5l_decap_8
XFILLER_0_142 VPWR VGND sg13cmos5l_fill_1
XFILLER_0_153 VPWR VGND sg13cmos5l_fill_1
XFILLER_0_197 VPWR VGND sg13cmos5l_fill_2
XFILLER_135_84 VPWR VGND sg13cmos5l_decap_8
XFILLER_48_146 VPWR VGND sg13cmos5l_decap_8
XFILLER_95_44 VPWR VGND sg13cmos5l_decap_8
XFILLER_63_105 VPWR VGND sg13cmos5l_decap_8
XFILLER_12_260 VPWR VGND sg13cmos5l_fill_2
XFILLER_60_91 VPWR VGND sg13cmos5l_decap_8
X_0990_ _0990_/X Tile_X0Y1_EE4END[0] Tile_X0Y1_EE4END[8] Tile_X0Y1_E6END[8] _1211_/X
+ _0418_/Q _0417_/Q VPWR VGND sg13cmos5l_mux4_1
XFILLER_140_165 VPWR VGND sg13cmos5l_decap_8
XFILLER_5_42 VPWR VGND sg13cmos5l_decap_8
X_0424_ _0424_/Q Tile_X0Y1_FrameData[18] VGND VPWR Tile_X0Y1_FrameStrobe[2] latch
XFILLER_39_168 VPWR VGND sg13cmos5l_decap_8
XFILLER_54_138 VPWR VGND sg13cmos5l_decap_8
X_0355_ _0355_/Q Tile_X0Y1_FrameData[23] VGND VPWR Tile_X0Y1_FrameStrobe[0] latch
X_0286_ _0286_/Q Tile_X0Y0_FrameData[30] VGND VPWR Tile_X0Y1_FrameStrobe[6] latch
XFILLER_94_230 VPWR VGND sg13cmos5l_decap_8
XFILLER_62_182 VPWR VGND sg13cmos5l_decap_8
XFILLER_116_162 VPWR VGND sg13cmos5l_decap_8
XFILLER_65_14 VPWR VGND sg13cmos5l_decap_8
XFILLER_85_230 VPWR VGND sg13cmos5l_decap_8
XANTENNA_104 Tile_X0Y1_FrameData[23] VPWR VGND sg13cmos5l_antennanp
XANTENNA_115 Tile_X0Y1_FrameData[23] VPWR VGND sg13cmos5l_antennanp
XANTENNA_126 Tile_X0Y0_S4END[12] VPWR VGND sg13cmos5l_antennanp
XFILLER_53_171 VPWR VGND sg13cmos5l_decap_8
XFILLER_139_232 VPWR VGND sg13cmos5l_decap_8
XFILLER_107_162 VPWR VGND sg13cmos5l_decap_4
XFILLER_30_50 VPWR VGND sg13cmos5l_decap_8
XFILLER_30_61 VPWR VGND sg13cmos5l_fill_1
XFILLER_30_83 VPWR VGND sg13cmos5l_fill_2
XFILLER_5_256 VPWR VGND sg13cmos5l_decap_8
XFILLER_122_176 VPWR VGND sg13cmos5l_decap_8
XFILLER_76_252 VPWR VGND sg13cmos5l_decap_8
X_0140_ _0140_/Q Tile_X0Y0_FrameData[16] VGND VPWR Tile_X0Y1_FrameStrobe[1] latch
X_0071_ _0091_/D _1232_/X _0606_/Q _0608_/Q VPWR VGND sg13cmos5l_mux2_1
XFILLER_91_244 VPWR VGND sg13cmos5l_decap_8
X_0973_ _0973_/X Tile_X0Y0_E2MID[0] Tile_X0Y0_E2END[0] _1092_/X _0973_/A3 _0170_/Q
+ _0169_/Q VPWR VGND sg13cmos5l_mux4_1
XFILLER_113_154 VPWR VGND sg13cmos5l_decap_8
X_0407_ _0407_/Q Tile_X0Y1_FrameData[3] VGND VPWR Tile_X0Y1_FrameStrobe[1] latch
XFILLER_82_200 VPWR VGND sg13cmos5l_decap_8
X_0338_ _0338_/Q Tile_X0Y0_FrameData[10] VGND VPWR Tile_X0Y1_FrameStrobe[7] latch
X_0269_ _0269_/Q Tile_X0Y0_FrameData[15] VGND VPWR Tile_X0Y1_FrameStrobe[5] latch
XFILLER_129_7 VPWR VGND sg13cmos5l_decap_8
XFILLER_136_224 VPWR VGND sg13cmos5l_decap_8
XFILLER_50_130 VPWR VGND sg13cmos5l_decap_8
XANTENNA__0899__X Tile_X0Y1_S2BEG[7] VPWR VGND sg13cmos5l_antennanp
XFILLER_104_165 VPWR VGND sg13cmos5l_decap_8
XFILLER_2_215 VPWR VGND sg13cmos5l_decap_8
XFILLER_132_63 VPWR VGND sg13cmos5l_decap_8
XFILLER_76_35 VPWR VGND sg13cmos5l_decap_8
XFILLER_26_193 VPWR VGND sg13cmos5l_decap_8
XFILLER_73_266 VPWR VGND sg13cmos5l_decap_8
XFILLER_127_268 VPWR VGND sg13cmos5l_decap_4
XFILLER_110_124 VPWR VGND sg13cmos5l_fill_2
XFILLER_2_21 VPWR VGND sg13cmos5l_decap_8
XFILLER_110_168 VPWR VGND sg13cmos5l_decap_8
XFILLER_17_182 VPWR VGND sg13cmos5l_decap_8
X_1172_ _1172_/X _0645_/Q _0649_/Q _1209_/X _1201_/X _0472_/Q _0471_/Q VPWR VGND sg13cmos5l_mux4_1
X_0123_ _0123_/Q Tile_X0Y0_FrameData[1] VGND VPWR Tile_X0Y1_FrameStrobe[0] latch
XANTENNA_15 Tile_X0Y0_S2MID[6] VPWR VGND sg13cmos5l_antennanp
XANTENNA_26 Tile_X0Y1_N2MID[1] VPWR VGND sg13cmos5l_antennanp
XANTENNA_37 Tile_X0Y1_N2MID[3] VPWR VGND sg13cmos5l_antennanp
XANTENNA_48 Tile_X0Y1_N2MID[6] VPWR VGND sg13cmos5l_antennanp
XANTENNA_59 Tile_X0Y1_N4END[4] VPWR VGND sg13cmos5l_antennanp
XFILLER_32_185 VPWR VGND sg13cmos5l_decap_8
XFILLER_70_0 VPWR VGND sg13cmos5l_decap_8
X_0956_ Tile_X0Y1_W6BEG[11] _1190_/X VPWR VGND sg13cmos5l_buf_1
XFILLER_118_257 VPWR VGND sg13cmos5l_decap_8
XFILLER_133_227 VPWR VGND sg13cmos5l_decap_8
X_0887_ Tile_X0Y0_FrameData_O[31] Tile_X0Y0_FrameData[31] VPWR VGND sg13cmos5l_buf_1
XFILLER_99_141 VPWR VGND sg13cmos5l_fill_1
XFILLER_101_124 VPWR VGND sg13cmos5l_fill_2
XFILLER_46_49 VPWR VGND sg13cmos5l_decap_4
XFILLER_102_88 VPWR VGND sg13cmos5l_fill_1
XFILLER_23_152 VPWR VGND sg13cmos5l_decap_4
XFILLER_70_203 VPWR VGND sg13cmos5l_decap_8
XFILLER_109_268 VPWR VGND sg13cmos5l_decap_4
XFILLER_11_63 VPWR VGND sg13cmos5l_decap_8
XFILLER_11_74 VPWR VGND sg13cmos5l_fill_1
XFILLER_127_63 VPWR VGND sg13cmos5l_decap_8
XFILLER_36_71 VPWR VGND sg13cmos5l_decap_4
XFILLER_46_211 VPWR VGND sg13cmos5l_decap_8
XFILLER_61_203 VPWR VGND sg13cmos5l_decap_8
XFILLER_14_152 VPWR VGND sg13cmos5l_decap_8
XFILLER_52_70 VPWR VGND sg13cmos5l_fill_2
X_0810_ Tile_X0Y0_FrameStrobe_O[7] Tile_X0Y1_FrameStrobe[7] VPWR VGND sg13cmos5l_buf_1
XFILLER_115_238 VPWR VGND sg13cmos5l_decap_8
X_0741_ Tile_X0Y0_W6BEG[2] _1065_/X VPWR VGND sg13cmos5l_buf_1
X_0672_ _0672_/L_HI VPWR VGND sg13cmos5l_tiehi
X_1224_ _1224_/X Tile_X0Y0_E1END[1] Tile_X0Y0_E2MID[2] Tile_X0Y0_E2END[2] _1097_/X
+ _0292_/Q _0291_/Q VPWR VGND sg13cmos5l_mux4_1
XFILLER_52_247 VPWR VGND sg13cmos5l_decap_8
X_1086_ _1086_/X _1112_/X Tile_X0Y1_N4END[5] Tile_X0Y0_S1END[1] Tile_X0Y0_S4END[1]
+ _0138_/Q _0137_/Q VPWR VGND sg13cmos5l_mux4_1
X_1155_ _1155_/X Tile_X0Y1_E2MID[1] _0644_/Q _1195_/X _1202_/X _0506_/Q _0505_/Q VPWR
+ VGND sg13cmos5l_mux4_1
X_0106_ _0106_/Q Tile_X0Y0_FrameData[18] VGND VPWR Tile_X0Y1_FrameStrobe[0] latch
XFILLER_20_188 VPWR VGND sg13cmos5l_decap_8
X_0939_ Tile_X0Y1_W2BEGb[2] _1157_/X VPWR VGND sg13cmos5l_buf_1
XFILLER_106_216 VPWR VGND sg13cmos5l_decap_8
XFILLER_106_9 VPWR VGND sg13cmos5l_decap_4
XFILLER_87_144 VPWR VGND sg13cmos5l_fill_1
XFILLER_28_255 VPWR VGND sg13cmos5l_decap_8
XFILLER_73_14 VPWR VGND sg13cmos5l_decap_8
XFILLER_87_166 VPWR VGND sg13cmos5l_decap_8
XFILLER_11_155 VPWR VGND sg13cmos5l_decap_8
XFILLER_43_236 VPWR VGND sg13cmos5l_decap_8
XFILLER_138_84 VPWR VGND sg13cmos5l_decap_8
XFILLER_22_51 VPWR VGND sg13cmos5l_fill_2
XFILLER_0_0 VPWR VGND sg13cmos5l_decap_8
XFILLER_112_208 VPWR VGND sg13cmos5l_decap_8
XFILLER_19_222 VPWR VGND sg13cmos5l_decap_8
XFILLER_78_100 VPWR VGND sg13cmos5l_fill_2
XFILLER_78_199 VPWR VGND sg13cmos5l_decap_8
XFILLER_93_169 VPWR VGND sg13cmos5l_decap_8
XFILLER_63_91 VPWR VGND sg13cmos5l_decap_8
XFILLER_8_75 VPWR VGND sg13cmos5l_decap_8
XFILLER_103_208 VPWR VGND sg13cmos5l_decap_8
XFILLER_33_0 VPWR VGND sg13cmos5l_fill_2
XFILLER_69_144 VPWR VGND sg13cmos5l_decap_8
X_0724_ Tile_X0Y0_W2BEG[1] _1032_/X VPWR VGND sg13cmos5l_buf_1
X_0655_ _0655_/L_HI VPWR VGND sg13cmos5l_tiehi
X_0586_ _0586_/Q Tile_X0Y1_FrameData[16] VGND VPWR Tile_X0Y1_FrameStrobe[7] latch
XFILLER_69_155 VPWR VGND sg13cmos5l_fill_1
XFILLER_84_114 VPWR VGND sg13cmos5l_fill_2
X_1207_ _1207_/X Tile_X0Y1_N1END[0] Tile_X0Y1_N4END[0] _1227_/X Tile_X0Y0_S4END[4]
+ _0394_/Q _0393_/Q VPWR VGND sg13cmos5l_mux4_1
XFILLER_138_105 VPWR VGND sg13cmos5l_decap_8
XFILLER_25_258 VPWR VGND sg13cmos5l_fill_2
X_1069_ _1069_/X _0642_/Q _1086_/X _1082_/X _1094_/X _0190_/Q _0189_/Q VPWR VGND sg13cmos5l_mux4_1
X_1138_ _1138_/X _1208_/X _1212_/X _1216_/X _1200_/X _0539_/Q _0538_/Q VPWR VGND sg13cmos5l_mux4_1
XFILLER_92_191 VPWR VGND sg13cmos5l_decap_8
XFILLER_4_107 VPWR VGND sg13cmos5l_fill_1
XFILLER_102_252 VPWR VGND sg13cmos5l_decap_8
XFILLER_68_14 VPWR VGND sg13cmos5l_decap_8
XFILLER_68_47 VPWR VGND sg13cmos5l_decap_8
XFILLER_140_74 VPWR VGND sg13cmos5l_decap_8
XFILLER_16_203 VPWR VGND sg13cmos5l_decap_8
XFILLER_75_147 VPWR VGND sg13cmos5l_decap_8
XFILLER_84_35 VPWR VGND sg13cmos5l_decap_8
XFILLER_84_46 VPWR VGND sg13cmos5l_fill_2
XFILLER_129_105 VPWR VGND sg13cmos5l_decap_8
XFILLER_33_61 VPWR VGND sg13cmos5l_decap_8
XFILLER_137_160 VPWR VGND sg13cmos5l_decap_8
XFILLER_3_162 VPWR VGND sg13cmos5l_decap_8
X_0440_ _0440_/Q Tile_X0Y1_FrameData[2] VGND VPWR Tile_X0Y1_FrameStrobe[2] latch
XFILLER_58_91 VPWR VGND sg13cmos5l_decap_8
X_0371_ _0371_/Q Tile_X0Y1_FrameData[7] VGND VPWR Tile_X0Y1_FrameStrobe[0] latch
XFILLER_22_206 VPWR VGND sg13cmos5l_decap_8
XFILLER_128_182 VPWR VGND sg13cmos5l_decap_8
XFILLER_135_119 VPWR VGND sg13cmos5l_decap_8
X_0707_ _1194_/A3 VPWR VGND sg13cmos5l_tielo
XFILLER_89_228 VPWR VGND sg13cmos5l_decap_8
X_0638_ _0638_/Q Tile_X0Y1_UserCLK NPU_OUT_ACT2 _0670_/L_HI VPWR VGND sg13cmos5l_dfrbpq_1
X_0569_ _0569_/Q Tile_X0Y1_FrameData[1] VGND VPWR Tile_X0Y1_FrameStrobe[6] latch
XFILLER_97_272 VPWR VGND sg13cmos5l_fill_1
XFILLER_65_191 VPWR VGND sg13cmos5l_decap_8
XFILLER_80_150 VPWR VGND sg13cmos5l_decap_8
XFILLER_13_217 VPWR VGND sg13cmos5l_decap_8
XFILLER_21_272 VPWR VGND sg13cmos5l_fill_1
XFILLER_0_110 VPWR VGND sg13cmos5l_fill_2
XFILLER_0_121 VPWR VGND sg13cmos5l_fill_2
XFILLER_134_196 VPWR VGND sg13cmos5l_decap_8
XFILLER_135_63 VPWR VGND sg13cmos5l_decap_8
XFILLER_88_272 VPWR VGND sg13cmos5l_fill_1
XFILLER_71_161 VPWR VGND sg13cmos5l_decap_8
XFILLER_71_172 VPWR VGND sg13cmos5l_fill_1
XFILLER_12_272 VPWR VGND sg13cmos5l_fill_1
XFILLER_5_21 VPWR VGND sg13cmos5l_decap_8
XFILLER_60_70 VPWR VGND sg13cmos5l_decap_8
XFILLER_74_7 VPWR VGND sg13cmos5l_decap_8
XFILLER_8_243 VPWR VGND sg13cmos5l_decap_8
XFILLER_125_185 VPWR VGND sg13cmos5l_decap_8
XFILLER_140_144 VPWR VGND sg13cmos5l_decap_8
XFILLER_5_98 VPWR VGND sg13cmos5l_decap_8
XFILLER_79_272 VPWR VGND sg13cmos5l_fill_1
X_0423_ _0423_/Q Tile_X0Y1_FrameData[19] VGND VPWR Tile_X0Y1_FrameStrobe[2] latch
XFILLER_47_180 VPWR VGND sg13cmos5l_decap_8
XFILLER_54_117 VPWR VGND sg13cmos5l_decap_8
X_0354_ _0354_/Q Tile_X0Y1_FrameData[24] VGND VPWR Tile_X0Y1_FrameStrobe[0] latch
X_0285_ _0285_/Q Tile_X0Y0_FrameData[31] VGND VPWR Tile_X0Y1_FrameStrobe[6] latch
XFILLER_10_209 VPWR VGND sg13cmos5l_decap_8
XFILLER_40_18 VPWR VGND sg13cmos5l_decap_4
XFILLER_62_161 VPWR VGND sg13cmos5l_decap_8
XFILLER_116_141 VPWR VGND sg13cmos5l_decap_8
XFILLER_131_133 VPWR VGND sg13cmos5l_decap_8
XFILLER_131_144 VPWR VGND sg13cmos5l_fill_2
XFILLER_131_199 VPWR VGND sg13cmos5l_decap_8
XANTENNA_105 Tile_X0Y1_FrameData[23] VPWR VGND sg13cmos5l_antennanp
XANTENNA_116 Tile_X0Y1_FrameData[23] VPWR VGND sg13cmos5l_antennanp
XFILLER_38_180 VPWR VGND sg13cmos5l_decap_8
XFILLER_53_150 VPWR VGND sg13cmos5l_decap_8
XFILLER_139_211 VPWR VGND sg13cmos5l_decap_8
XFILLER_14_30 VPWR VGND sg13cmos5l_fill_2
XFILLER_5_235 VPWR VGND sg13cmos5l_decap_8
XFILLER_100_0 VPWR VGND sg13cmos5l_fill_2
XFILLER_122_155 VPWR VGND sg13cmos5l_decap_8
XFILLER_30_95 VPWR VGND sg13cmos5l_decap_8
XFILLER_5_268 VPWR VGND sg13cmos5l_decap_4
XFILLER_68_209 VPWR VGND sg13cmos5l_decap_8
XFILLER_76_231 VPWR VGND sg13cmos5l_decap_8
X_0070_ _0090_/D _1231_/X _0607_/Q _0608_/Q VPWR VGND sg13cmos5l_mux2_1
XFILLER_91_223 VPWR VGND sg13cmos5l_decap_8
XFILLER_71_91 VPWR VGND sg13cmos5l_decap_8
X_0972_ Tile_X0Y1_WW4BEG[15] _1178_/X VPWR VGND sg13cmos5l_buf_1
XFILLER_113_111 VPWR VGND sg13cmos5l_decap_4
XFILLER_113_199 VPWR VGND sg13cmos5l_decap_8
XFILLER_67_264 VPWR VGND sg13cmos5l_decap_8
X_0406_ _0406_/Q Tile_X0Y1_FrameData[4] VGND VPWR Tile_X0Y1_FrameStrobe[1] latch
X_0337_ _0337_/Q Tile_X0Y0_FrameData[11] VGND VPWR Tile_X0Y1_FrameStrobe[7] latch
XFILLER_82_256 VPWR VGND sg13cmos5l_decap_8
X_0268_ _0268_/Q Tile_X0Y0_FrameData[16] VGND VPWR Tile_X0Y1_FrameStrobe[5] latch
X_0199_ _0199_/Q Tile_X0Y0_FrameData[21] VGND VPWR Tile_X0Y1_FrameStrobe[3] latch
XFILLER_136_203 VPWR VGND sg13cmos5l_decap_8
XFILLER_50_186 VPWR VGND sg13cmos5l_decap_8
XFILLER_116_32 VPWR VGND sg13cmos5l_fill_1
XFILLER_116_65 VPWR VGND sg13cmos5l_fill_2
XFILLER_4_7 VPWR VGND sg13cmos5l_decap_8
XFILLER_76_14 VPWR VGND sg13cmos5l_decap_8
XFILLER_132_42 VPWR VGND sg13cmos5l_decap_8
XFILLER_73_245 VPWR VGND sg13cmos5l_decap_8
XFILLER_92_35 VPWR VGND sg13cmos5l_decap_8
XFILLER_25_51 VPWR VGND sg13cmos5l_fill_1
XFILLER_26_161 VPWR VGND sg13cmos5l_fill_1
XFILLER_41_131 VPWR VGND sg13cmos5l_fill_2
XFILLER_41_197 VPWR VGND sg13cmos5l_decap_8
XFILLER_127_247 VPWR VGND sg13cmos5l_decap_8
XFILLER_41_72 VPWR VGND sg13cmos5l_fill_1
XFILLER_41_94 VPWR VGND sg13cmos5l_decap_8
X_1171_ _1171_/X _0644_/Q _0648_/Q _1210_/X _1202_/X _0474_/Q _0473_/Q VPWR VGND sg13cmos5l_mux4_1
XFILLER_2_88 VPWR VGND sg13cmos5l_decap_8
XFILLER_66_91 VPWR VGND sg13cmos5l_decap_8
X_0122_ _0122_/Q Tile_X0Y0_FrameData[2] VGND VPWR Tile_X0Y1_FrameStrobe[0] latch
XANTENNA_16 Tile_X0Y0_S2MID[6] VPWR VGND sg13cmos5l_antennanp
XANTENNA_27 Tile_X0Y1_N2MID[1] VPWR VGND sg13cmos5l_antennanp
XANTENNA_38 Tile_X0Y1_N2MID[3] VPWR VGND sg13cmos5l_antennanp
XANTENNA_49 Tile_X0Y1_N2MID[6] VPWR VGND sg13cmos5l_antennanp
XFILLER_118_236 VPWR VGND sg13cmos5l_decap_8
XFILLER_32_164 VPWR VGND sg13cmos5l_fill_2
X_0886_ Tile_X0Y0_FrameData_O[30] Tile_X0Y0_FrameData[30] VPWR VGND sg13cmos5l_buf_1
X_0955_ Tile_X0Y1_W6BEG[10] _1189_/X VPWR VGND sg13cmos5l_buf_1
XFILLER_133_206 VPWR VGND sg13cmos5l_decap_8
XFILLER_63_0 VPWR VGND sg13cmos5l_decap_8
XFILLER_55_234 VPWR VGND sg13cmos5l_fill_2
XFILLER_23_164 VPWR VGND sg13cmos5l_fill_1
XFILLER_23_186 VPWR VGND sg13cmos5l_decap_8
XFILLER_62_49 VPWR VGND sg13cmos5l_decap_8
XFILLER_109_214 VPWR VGND sg13cmos5l_decap_8
XFILLER_124_217 VPWR VGND sg13cmos5l_decap_4
XFILLER_127_42 VPWR VGND sg13cmos5l_decap_8
XFILLER_11_86 VPWR VGND sg13cmos5l_decap_8
X_0740_ Tile_X0Y0_W6BEG[1] _1064_/X VPWR VGND sg13cmos5l_buf_1
XFILLER_123_261 VPWR VGND sg13cmos5l_fill_1
XFILLER_123_272 VPWR VGND sg13cmos5l_fill_1
X_0671_ _0671_/L_HI VPWR VGND sg13cmos5l_tiehi
XFILLER_37_234 VPWR VGND sg13cmos5l_decap_8
X_1223_ _1223_/X Tile_X0Y0_E1END[0] Tile_X0Y0_E2MID[3] Tile_X0Y0_E2END[3] _1096_/X
+ _0294_/Q _0293_/Q VPWR VGND sg13cmos5l_mux4_1
X_1154_ _1154_/X _0651_/Q _1195_/X _1202_/X _1193_/X _0508_/Q _0507_/Q VPWR VGND sg13cmos5l_mux4_1
XFILLER_96_145 VPWR VGND sg13cmos5l_fill_2
XFILLER_32_19 VPWR VGND sg13cmos5l_fill_2
XFILLER_52_226 VPWR VGND sg13cmos5l_decap_8
X_1085_ _1085_/X _1113_/X Tile_X0Y1_N4END[6] Tile_X0Y0_S1END[2] Tile_X0Y0_S4END[2]
+ _0136_/Q _0135_/Q VPWR VGND sg13cmos5l_mux4_1
X_0105_ _0105_/Q Tile_X0Y0_FrameData[19] VGND VPWR Tile_X0Y1_FrameStrobe[0] latch
X_0869_ Tile_X0Y0_FrameData_O[13] Tile_X0Y0_FrameData[13] VPWR VGND sg13cmos5l_buf_1
X_0938_ Tile_X0Y1_W2BEGb[1] _1156_/X VPWR VGND sg13cmos5l_buf_1
XFILLER_57_49 VPWR VGND sg13cmos5l_decap_8
XFILLER_113_33 VPWR VGND sg13cmos5l_decap_4
XFILLER_28_234 VPWR VGND sg13cmos5l_decap_8
XFILLER_43_215 VPWR VGND sg13cmos5l_decap_8
XFILLER_11_134 VPWR VGND sg13cmos5l_fill_2
XFILLER_51_270 VPWR VGND sg13cmos5l_fill_2
XFILLER_138_63 VPWR VGND sg13cmos5l_decap_8
XFILLER_22_74 VPWR VGND sg13cmos5l_decap_4
XFILLER_7_149 VPWR VGND sg13cmos5l_decap_8
XFILLER_98_78 VPWR VGND sg13cmos5l_decap_4
XFILLER_105_272 VPWR VGND sg13cmos5l_fill_1
XFILLER_120_264 VPWR VGND sg13cmos5l_decap_8
XFILLER_78_178 VPWR VGND sg13cmos5l_decap_8
XFILLER_34_215 VPWR VGND sg13cmos5l_decap_8
XFILLER_42_270 VPWR VGND sg13cmos5l_fill_2
XFILLER_47_93 VPWR VGND sg13cmos5l_decap_4
XFILLER_63_70 VPWR VGND sg13cmos5l_decap_8
X_0723_ Tile_X0Y0_W2BEG[0] _1031_/X VPWR VGND sg13cmos5l_buf_1
XFILLER_8_54 VPWR VGND sg13cmos5l_decap_8
XFILLER_111_253 VPWR VGND sg13cmos5l_decap_8
XFILLER_111_264 VPWR VGND sg13cmos5l_fill_1
XFILLER_6_182 VPWR VGND sg13cmos5l_decap_8
XFILLER_6_193 VPWR VGND sg13cmos5l_fill_1
X_0654_ _0654_/L_HI VPWR VGND sg13cmos5l_tiehi
X_0585_ _0585_/Q Tile_X0Y1_FrameData[17] VGND VPWR Tile_X0Y1_FrameStrobe[7] latch
XFILLER_25_237 VPWR VGND sg13cmos5l_decap_8
XFILLER_84_137 VPWR VGND sg13cmos5l_fill_2
X_1137_ _1137_/X Tile_X0Y1_E1END[1] Tile_X0Y1_EE4END[13] Tile_X0Y1_E6END[5] _1204_/X
+ _0539_/Q _0538_/Q VPWR VGND sg13cmos5l_mux4_1
X_1206_ _1206_/X Tile_X0Y1_N1END[3] Tile_X0Y1_N4END[3] _1230_/X Tile_X0Y0_S4END[7]
+ _0396_/Q _0395_/Q VPWR VGND sg13cmos5l_mux4_1
XFILLER_92_181 VPWR VGND sg13cmos5l_decap_4
XFILLER_40_229 VPWR VGND sg13cmos5l_fill_2
X_1068_ _1068_/X _0641_/Q _1085_/X _1081_/X _1093_/X _0192_/Q _0191_/Q VPWR VGND sg13cmos5l_mux4_1
XFILLER_4_119 VPWR VGND sg13cmos5l_decap_8
XFILLER_102_231 VPWR VGND sg13cmos5l_decap_8
XFILLER_124_98 VPWR VGND sg13cmos5l_decap_8
XFILLER_75_126 VPWR VGND sg13cmos5l_decap_8
XFILLER_17_41 VPWR VGND sg13cmos5l_fill_1
XFILLER_90_129 VPWR VGND sg13cmos5l_fill_2
XFILLER_130_0 VPWR VGND sg13cmos5l_decap_8
XFILLER_3_185 VPWR VGND sg13cmos5l_fill_1
XFILLER_3_196 VPWR VGND sg13cmos5l_fill_1
X_0370_ _0370_/Q Tile_X0Y1_FrameData[8] VGND VPWR Tile_X0Y1_FrameStrobe[0] latch
XFILLER_58_70 VPWR VGND sg13cmos5l_decap_8
XFILLER_81_129 VPWR VGND sg13cmos5l_fill_1
XFILLER_74_91 VPWR VGND sg13cmos5l_decap_8
XANTENNA__0801__X Tile_X0Y0_N1BEG[2] VPWR VGND sg13cmos5l_antennanp
XFILLER_128_161 VPWR VGND sg13cmos5l_decap_8
XFILLER_89_207 VPWR VGND sg13cmos5l_decap_8
X_0706_ _1078_/A3 VPWR VGND sg13cmos5l_tielo
X_0637_ _0637_/Q Tile_X0Y1_UserCLK NPU_OUT_ACT1 _0668_/L_HI VPWR VGND sg13cmos5l_dfrbpq_1
X_0568_ _0568_/Q Tile_X0Y1_FrameData[2] VGND VPWR Tile_X0Y1_FrameStrobe[6] latch
X_0499_ _0499_/Q Tile_X0Y1_FrameData[7] VGND VPWR Tile_X0Y1_FrameStrobe[4] latch
XFILLER_97_251 VPWR VGND sg13cmos5l_decap_8
XFILLER_54_28 VPWR VGND sg13cmos5l_decap_8
XFILLER_65_170 VPWR VGND sg13cmos5l_decap_8
XFILLER_21_262 VPWR VGND sg13cmos5l_fill_2
XFILLER_70_49 VPWR VGND sg13cmos5l_decap_8
XFILLER_119_194 VPWR VGND sg13cmos5l_decap_8
XFILLER_134_175 VPWR VGND sg13cmos5l_decap_8
XFILLER_135_42 VPWR VGND sg13cmos5l_decap_8
XFILLER_28_62 VPWR VGND sg13cmos5l_decap_8
XFILLER_71_140 VPWR VGND sg13cmos5l_decap_8
XFILLER_71_184 VPWR VGND sg13cmos5l_decap_8
XFILLER_125_164 VPWR VGND sg13cmos5l_decap_8
XFILLER_67_7 VPWR VGND sg13cmos5l_decap_8
XFILLER_8_222 VPWR VGND sg13cmos5l_decap_8
XFILLER_140_123 VPWR VGND sg13cmos5l_decap_8
XFILLER_5_77 VPWR VGND sg13cmos5l_decap_8
X_0422_ _0422_/Q Tile_X0Y1_FrameData[20] VGND VPWR Tile_X0Y1_FrameStrobe[2] latch
X_0353_ _0353_/Q Tile_X0Y1_FrameData[25] VGND VPWR Tile_X0Y1_FrameStrobe[0] latch
XFILLER_62_140 VPWR VGND sg13cmos5l_decap_8
X_0284_ _0284_/Q Tile_X0Y0_FrameData[0] VGND VPWR Tile_X0Y1_FrameStrobe[5] latch
XFILLER_94_265 VPWR VGND sg13cmos5l_decap_8
XFILLER_93_0 VPWR VGND sg13cmos5l_fill_2
XFILLER_116_120 VPWR VGND sg13cmos5l_decap_8
XFILLER_116_197 VPWR VGND sg13cmos5l_decap_8
XFILLER_131_112 VPWR VGND sg13cmos5l_decap_8
XANTENNA_106 Tile_X0Y1_FrameData[23] VPWR VGND sg13cmos5l_antennanp
XFILLER_131_178 VPWR VGND sg13cmos5l_decap_8
XFILLER_65_49 VPWR VGND sg13cmos5l_decap_8
XANTENNA_117 Tile_X0Y1_FrameData[23] VPWR VGND sg13cmos5l_antennanp
XFILLER_121_99 VPWR VGND sg13cmos5l_fill_2
XFILLER_139_267 VPWR VGND sg13cmos5l_decap_4
XFILLER_5_214 VPWR VGND sg13cmos5l_decap_8
XFILLER_107_197 VPWR VGND sg13cmos5l_decap_8
XFILLER_122_134 VPWR VGND sg13cmos5l_decap_8
XFILLER_39_72 VPWR VGND sg13cmos5l_decap_4
XFILLER_76_210 VPWR VGND sg13cmos5l_decap_8
XFILLER_29_192 VPWR VGND sg13cmos5l_decap_8
XFILLER_55_60 VPWR VGND sg13cmos5l_fill_2
XFILLER_91_202 VPWR VGND sg13cmos5l_decap_8
XFILLER_44_184 VPWR VGND sg13cmos5l_decap_8
XFILLER_71_70 VPWR VGND sg13cmos5l_decap_8
X_0971_ Tile_X0Y1_WW4BEG[14] _1177_/X VPWR VGND sg13cmos5l_buf_1
XFILLER_113_134 VPWR VGND sg13cmos5l_decap_4
XFILLER_82_235 VPWR VGND sg13cmos5l_decap_8
X_0405_ _0405_/Q Tile_X0Y1_FrameData[5] VGND VPWR Tile_X0Y1_FrameStrobe[1] latch
X_0336_ _0336_/Q Tile_X0Y0_FrameData[12] VGND VPWR Tile_X0Y1_FrameStrobe[7] latch
X_0267_ _0267_/Q Tile_X0Y0_FrameData[17] VGND VPWR Tile_X0Y1_FrameStrobe[5] latch
XFILLER_35_184 VPWR VGND sg13cmos5l_decap_8
XFILLER_50_165 VPWR VGND sg13cmos5l_decap_8
X_0198_ _0198_/Q Tile_X0Y0_FrameData[22] VGND VPWR Tile_X0Y1_FrameStrobe[3] latch
XFILLER_136_259 VPWR VGND sg13cmos5l_decap_8
XFILLER_132_21 VPWR VGND sg13cmos5l_decap_8
XFILLER_132_98 VPWR VGND sg13cmos5l_decap_8
XFILLER_25_30 VPWR VGND sg13cmos5l_fill_2
XFILLER_73_224 VPWR VGND sg13cmos5l_decap_8
XFILLER_92_58 VPWR VGND sg13cmos5l_decap_4
XFILLER_41_176 VPWR VGND sg13cmos5l_decap_8
XFILLER_127_226 VPWR VGND sg13cmos5l_decap_8
XFILLER_110_126 VPWR VGND sg13cmos5l_fill_1
XFILLER_1_250 VPWR VGND sg13cmos5l_fill_1
XFILLER_2_56 VPWR VGND sg13cmos5l_decap_8
XFILLER_37_8 VPWR VGND sg13cmos5l_decap_8
XFILLER_49_254 VPWR VGND sg13cmos5l_decap_8
XFILLER_66_70 VPWR VGND sg13cmos5l_decap_8
X_1170_ _1170_/X _0647_/Q _0651_/Q _1211_/X _1195_/X _0476_/Q _0475_/Q VPWR VGND sg13cmos5l_mux4_1
X_0121_ _0121_/Q Tile_X0Y0_FrameData[3] VGND VPWR Tile_X0Y1_FrameStrobe[0] latch
XANTENNA_17 Tile_X0Y0_S2MID[7] VPWR VGND sg13cmos5l_antennanp
XANTENNA_28 Tile_X0Y1_N2MID[1] VPWR VGND sg13cmos5l_antennanp
XANTENNA_39 Tile_X0Y1_N2MID[3] VPWR VGND sg13cmos5l_antennanp
XFILLER_118_215 VPWR VGND sg13cmos5l_decap_8
X_0885_ Tile_X0Y0_FrameData_O[29] Tile_X0Y0_FrameData[29] VPWR VGND sg13cmos5l_buf_1
X_0954_ Tile_X0Y1_W6BEG[9] _1188_/X VPWR VGND sg13cmos5l_buf_1
XFILLER_56_0 VPWR VGND sg13cmos5l_decap_8
XFILLER_99_198 VPWR VGND sg13cmos5l_decap_8
XFILLER_55_213 VPWR VGND sg13cmos5l_decap_8
XFILLER_55_268 VPWR VGND sg13cmos5l_decap_4
X_0319_ _0319_/Q Tile_X0Y0_FrameData[29] VGND VPWR Tile_X0Y1_FrameStrobe[7] latch
XFILLER_134_7 VPWR VGND sg13cmos5l_decap_8
XFILLER_62_28 VPWR VGND sg13cmos5l_decap_8
XFILLER_109_248 VPWR VGND sg13cmos5l_decap_8
XFILLER_127_21 VPWR VGND sg13cmos5l_decap_8
XFILLER_127_98 VPWR VGND sg13cmos5l_decap_8
XFILLER_100_192 VPWR VGND sg13cmos5l_decap_8
XFILLER_46_246 VPWR VGND sg13cmos5l_decap_8
XFILLER_46_268 VPWR VGND sg13cmos5l_decap_4
XFILLER_61_238 VPWR VGND sg13cmos5l_fill_1
XFILLER_14_187 VPWR VGND sg13cmos5l_decap_8
X_0670_ _0670_/L_HI VPWR VGND sg13cmos5l_tiehi
XFILLER_115_218 VPWR VGND sg13cmos5l_decap_8
XFILLER_123_240 VPWR VGND sg13cmos5l_decap_8
XFILLER_96_124 VPWR VGND sg13cmos5l_decap_8
XFILLER_37_213 VPWR VGND sg13cmos5l_decap_8
XFILLER_52_205 VPWR VGND sg13cmos5l_decap_8
X_1084_ _1084_/X _1114_/X Tile_X0Y1_N4END[7] Tile_X0Y0_S1END[3] Tile_X0Y0_S4END[3]
+ _0134_/Q _0133_/Q VPWR VGND sg13cmos5l_mux4_1
X_1222_ _1222_/X Tile_X0Y0_E2MID[4] Tile_X0Y0_E2END[4] Tile_X0Y0_E6END[11] _1095_/X
+ _0296_/Q _0295_/Q VPWR VGND sg13cmos5l_mux4_1
X_1153_ _1153_/X _0650_/Q _1196_/X _1201_/X _1192_/X _0510_/Q _0509_/Q VPWR VGND sg13cmos5l_mux4_1
X_0104_ _0104_/Q Tile_X0Y0_FrameData[20] VGND VPWR Tile_X0Y1_FrameStrobe[0] latch
XANTENNA__0804__X Tile_X0Y0_FrameStrobe_O[1] VPWR VGND sg13cmos5l_antennanp
X_0868_ Tile_X0Y0_FrameData_O[12] Tile_X0Y0_FrameData[12] VPWR VGND sg13cmos5l_buf_1
X_0937_ Tile_X0Y1_W2BEGb[0] _1155_/X VPWR VGND sg13cmos5l_buf_1
X_0799_ Tile_X0Y0_N1BEG[0] _0999_/X VPWR VGND sg13cmos5l_buf_1
XFILLER_9_191 VPWR VGND sg13cmos5l_decap_8
XFILLER_28_213 VPWR VGND sg13cmos5l_decap_8
XFILLER_57_28 VPWR VGND sg13cmos5l_decap_8
XFILLER_28_268 VPWR VGND sg13cmos5l_decap_4
XFILLER_73_49 VPWR VGND sg13cmos5l_decap_8
XFILLER_95_190 VPWR VGND sg13cmos5l_decap_8
XFILLER_11_113 VPWR VGND sg13cmos5l_decap_8
XFILLER_138_42 VPWR VGND sg13cmos5l_decap_8
XFILLER_7_128 VPWR VGND sg13cmos5l_decap_8
XFILLER_78_113 VPWR VGND sg13cmos5l_fill_2
XFILLER_120_243 VPWR VGND sg13cmos5l_decap_8
XFILLER_19_257 VPWR VGND sg13cmos5l_decap_8
XFILLER_19_268 VPWR VGND sg13cmos5l_decap_4
XFILLER_78_157 VPWR VGND sg13cmos5l_decap_8
XFILLER_86_190 VPWR VGND sg13cmos5l_decap_8
XFILLER_8_33 VPWR VGND sg13cmos5l_decap_8
XFILLER_6_161 VPWR VGND sg13cmos5l_decap_8
X_0722_ Tile_X0Y0_W1BEG[3] _1030_/X VPWR VGND sg13cmos5l_buf_1
X_0653_ _0653_/L_HI VPWR VGND sg13cmos5l_tiehi
XFILLER_111_232 VPWR VGND sg13cmos5l_decap_8
XFILLER_88_90 VPWR VGND sg13cmos5l_decap_8
X_0584_ _0584_/Q Tile_X0Y1_FrameData[18] VGND VPWR Tile_X0Y1_FrameStrobe[7] latch
XFILLER_25_216 VPWR VGND sg13cmos5l_decap_8
XFILLER_40_208 VPWR VGND sg13cmos5l_decap_8
X_1067_ _1067_/X _0640_/Q _1084_/X _1080_/X _1092_/X _0194_/Q _0193_/Q VPWR VGND sg13cmos5l_mux4_1
X_1136_ _1136_/X _1207_/X _1211_/X _1215_/X _1199_/X _0542_/Q _0541_/Q VPWR VGND sg13cmos5l_mux4_1
X_1205_ _1205_/X Tile_X0Y1_N1END[2] Tile_X0Y1_N4END[2] _1229_/X Tile_X0Y0_S4END[6]
+ _0398_/Q _0397_/Q VPWR VGND sg13cmos5l_mux4_1
XFILLER_92_160 VPWR VGND sg13cmos5l_decap_8
XFILLER_102_210 VPWR VGND sg13cmos5l_decap_8
XFILLER_108_12 VPWR VGND sg13cmos5l_fill_2
XFILLER_124_22 VPWR VGND sg13cmos5l_decap_8
XFILLER_124_44 VPWR VGND sg13cmos5l_decap_8
XFILLER_75_105 VPWR VGND sg13cmos5l_decap_8
XFILLER_83_160 VPWR VGND sg13cmos5l_fill_1
XFILLER_84_26 VPWR VGND sg13cmos5l_fill_2
XFILLER_84_59 VPWR VGND sg13cmos5l_fill_1
XFILLER_140_54 VPWR VGND sg13cmos5l_fill_2
XFILLER_31_219 VPWR VGND sg13cmos5l_decap_8
XFILLER_83_193 VPWR VGND sg13cmos5l_decap_8
XFILLER_137_140 VPWR VGND sg13cmos5l_fill_2
XFILLER_137_195 VPWR VGND sg13cmos5l_decap_8
XFILLER_33_96 VPWR VGND sg13cmos5l_fill_1
XFILLER_66_105 VPWR VGND sg13cmos5l_decap_4
XFILLER_59_190 VPWR VGND sg13cmos5l_decap_8
XFILLER_74_182 VPWR VGND sg13cmos5l_decap_8
XFILLER_74_70 VPWR VGND sg13cmos5l_decap_8
XFILLER_30_252 VPWR VGND sg13cmos5l_decap_8
XFILLER_128_140 VPWR VGND sg13cmos5l_decap_8
X_0705_ _0973_/A3 VPWR VGND sg13cmos5l_tielo
X_0636_ _0636_/Q Tile_X0Y1_UserCLK NPU_OUT_ACT0 _0664_/L_HI VPWR VGND sg13cmos5l_dfrbpq_1
XFILLER_57_116 VPWR VGND sg13cmos5l_fill_1
XFILLER_57_149 VPWR VGND sg13cmos5l_decap_8
XFILLER_72_119 VPWR VGND sg13cmos5l_decap_8
X_0567_ _0567_/Q Tile_X0Y1_FrameData[3] VGND VPWR Tile_X0Y1_FrameStrobe[6] latch
X_0498_ _0498_/Q Tile_X0Y1_FrameData[8] VGND VPWR Tile_X0Y1_FrameStrobe[4] latch
XFILLER_97_230 VPWR VGND sg13cmos5l_decap_8
XFILLER_110_68 VPWR VGND sg13cmos5l_decap_8
XFILLER_80_185 VPWR VGND sg13cmos5l_decap_8
X_1119_ _1119_/X Tile_X0Y1_E1END[1] Tile_X0Y1_EE4END[1] Tile_X0Y1_E6END[9] _1204_/X
+ _0575_/Q _0574_/Q VPWR VGND sg13cmos5l_mux4_1
XFILLER_119_173 VPWR VGND sg13cmos5l_decap_8
XFILLER_119_22 VPWR VGND sg13cmos5l_decap_8
XFILLER_21_241 VPWR VGND sg13cmos5l_decap_8
XFILLER_70_28 VPWR VGND sg13cmos5l_decap_8
XFILLER_0_101 VPWR VGND sg13cmos5l_fill_2
XFILLER_0_123 VPWR VGND sg13cmos5l_fill_1
XFILLER_0_167 VPWR VGND sg13cmos5l_decap_8
XFILLER_0_178 VPWR VGND sg13cmos5l_fill_2
XFILLER_134_154 VPWR VGND sg13cmos5l_decap_8
XFILLER_135_21 VPWR VGND sg13cmos5l_decap_8
XFILLER_135_98 VPWR VGND sg13cmos5l_decap_8
XFILLER_88_263 VPWR VGND sg13cmos5l_decap_8
XFILLER_0_189 VPWR VGND sg13cmos5l_fill_2
XFILLER_56_182 VPWR VGND sg13cmos5l_decap_8
XFILLER_63_119 VPWR VGND sg13cmos5l_decap_8
XFILLER_95_58 VPWR VGND sg13cmos5l_decap_4
XFILLER_44_40 VPWR VGND sg13cmos5l_decap_8
XFILLER_44_51 VPWR VGND sg13cmos5l_fill_1
XFILLER_8_201 VPWR VGND sg13cmos5l_decap_8
XANTENNA__0902__X Tile_X0Y1_S2BEGb[2] VPWR VGND sg13cmos5l_antennanp
XFILLER_125_143 VPWR VGND sg13cmos5l_decap_8
XFILLER_140_102 VPWR VGND sg13cmos5l_decap_8
XFILLER_5_56 VPWR VGND sg13cmos5l_decap_8
XFILLER_140_179 VPWR VGND sg13cmos5l_decap_8
XFILLER_79_263 VPWR VGND sg13cmos5l_fill_2
X_0421_ _0421_/Q Tile_X0Y1_FrameData[21] VGND VPWR Tile_X0Y1_FrameStrobe[2] latch
X_0352_ _0352_/Q Tile_X0Y1_FrameData[26] VGND VPWR Tile_X0Y1_FrameStrobe[0] latch
X_0283_ _0283_/Q Tile_X0Y0_FrameData[1] VGND VPWR Tile_X0Y1_FrameStrobe[5] latch
XFILLER_94_244 VPWR VGND sg13cmos5l_decap_8
XFILLER_62_196 VPWR VGND sg13cmos5l_decap_8
XANTENNA__0812__X Tile_X0Y0_FrameStrobe_O[9] VPWR VGND sg13cmos5l_antennanp
XFILLER_86_0 VPWR VGND sg13cmos5l_fill_2
XFILLER_116_176 VPWR VGND sg13cmos5l_decap_8
XFILLER_131_157 VPWR VGND sg13cmos5l_decap_8
X_0619_ NPU_ACT_WDATA1 Tile_X0Y1_UserCLK _0983_/X _0660_/L_HI VPWR VGND sg13cmos5l_dfrbpq_1
XANTENNA_107 Tile_X0Y1_FrameData[23] VPWR VGND sg13cmos5l_antennanp
XANTENNA_118 Tile_X0Y1_FrameData[23] VPWR VGND sg13cmos5l_antennanp
XFILLER_105_35 VPWR VGND sg13cmos5l_decap_8
XFILLER_45_119 VPWR VGND sg13cmos5l_decap_8
XFILLER_65_28 VPWR VGND sg13cmos5l_decap_8
XFILLER_85_244 VPWR VGND sg13cmos5l_decap_8
XFILLER_139_246 VPWR VGND sg13cmos5l_decap_8
XFILLER_14_32 VPWR VGND sg13cmos5l_fill_1
XFILLER_53_185 VPWR VGND sg13cmos5l_decap_8
XANTENNA__0722__X Tile_X0Y0_W1BEG[3] VPWR VGND sg13cmos5l_antennanp
XFILLER_107_110 VPWR VGND sg13cmos5l_decap_4
XFILLER_107_132 VPWR VGND sg13cmos5l_fill_2
XFILLER_107_176 VPWR VGND sg13cmos5l_decap_8
XFILLER_122_113 VPWR VGND sg13cmos5l_decap_8
XFILLER_39_40 VPWR VGND sg13cmos5l_decap_8
XFILLER_76_266 VPWR VGND sg13cmos5l_decap_8
XFILLER_29_171 VPWR VGND sg13cmos5l_decap_8
XFILLER_44_163 VPWR VGND sg13cmos5l_decap_8
XFILLER_91_258 VPWR VGND sg13cmos5l_decap_8
X_0970_ Tile_X0Y1_WW4BEG[13] _1176_/X VPWR VGND sg13cmos5l_buf_1
XFILLER_113_102 VPWR VGND sg13cmos5l_fill_2
XFILLER_113_168 VPWR VGND sg13cmos5l_decap_8
X_0404_ _0404_/Q Tile_X0Y1_FrameData[6] VGND VPWR Tile_X0Y1_FrameStrobe[1] latch
XANTENNA__0807__X Tile_X0Y0_FrameStrobe_O[4] VPWR VGND sg13cmos5l_antennanp
XFILLER_82_214 VPWR VGND sg13cmos5l_decap_8
X_0335_ _0335_/Q Tile_X0Y0_FrameData[13] VGND VPWR Tile_X0Y1_FrameStrobe[7] latch
X_0266_ _0266_/Q Tile_X0Y0_FrameData[18] VGND VPWR Tile_X0Y1_FrameStrobe[5] latch
XFILLER_96_90 VPWR VGND sg13cmos5l_decap_4
XFILLER_35_163 VPWR VGND sg13cmos5l_decap_8
XFILLER_35_174 VPWR VGND sg13cmos5l_fill_2
XFILLER_50_111 VPWR VGND sg13cmos5l_fill_1
XFILLER_50_144 VPWR VGND sg13cmos5l_decap_8
X_0197_ _0197_/Q Tile_X0Y0_FrameData[23] VGND VPWR Tile_X0Y1_FrameStrobe[3] latch
XFILLER_136_238 VPWR VGND sg13cmos5l_decap_8
XFILLER_2_229 VPWR VGND sg13cmos5l_decap_8
XFILLER_104_179 VPWR VGND sg13cmos5l_decap_8
XFILLER_76_49 VPWR VGND sg13cmos5l_decap_8
XFILLER_132_77 VPWR VGND sg13cmos5l_decap_8
XFILLER_73_203 VPWR VGND sg13cmos5l_decap_8
XFILLER_127_205 VPWR VGND sg13cmos5l_decap_8
XFILLER_41_133 VPWR VGND sg13cmos5l_fill_1
XFILLER_110_138 VPWR VGND sg13cmos5l_decap_8
XFILLER_2_35 VPWR VGND sg13cmos5l_decap_8
XFILLER_49_233 VPWR VGND sg13cmos5l_decap_8
XFILLER_64_203 VPWR VGND sg13cmos5l_decap_8
XFILLER_64_236 VPWR VGND sg13cmos5l_fill_1
X_0120_ _0120_/Q Tile_X0Y0_FrameData[4] VGND VPWR Tile_X0Y1_FrameStrobe[0] latch
XANTENNA_18 Tile_X0Y0_S2MID[7] VPWR VGND sg13cmos5l_antennanp
XANTENNA_29 Tile_X0Y1_N2MID[1] VPWR VGND sg13cmos5l_antennanp
XFILLER_17_152 VPWR VGND sg13cmos5l_decap_8
XFILLER_17_196 VPWR VGND sg13cmos5l_decap_8
XFILLER_32_166 VPWR VGND sg13cmos5l_fill_1
XFILLER_32_199 VPWR VGND sg13cmos5l_decap_8
X_0884_ Tile_X0Y0_FrameData_O[28] Tile_X0Y0_FrameData[28] VPWR VGND sg13cmos5l_buf_1
X_0953_ Tile_X0Y1_W6BEG[8] _1187_/X VPWR VGND sg13cmos5l_buf_1
XFILLER_141_252 VPWR VGND sg13cmos5l_decap_8
XFILLER_99_177 VPWR VGND sg13cmos5l_decap_8
XFILLER_102_25 VPWR VGND sg13cmos5l_fill_1
XFILLER_55_236 VPWR VGND sg13cmos5l_fill_1
XFILLER_70_217 VPWR VGND sg13cmos5l_decap_8
X_0318_ _0318_/Q Tile_X0Y0_FrameData[30] VGND VPWR Tile_X0Y1_FrameStrobe[7] latch
X_0249_ _0249_/Q Tile_X0Y0_FrameData[3] VGND VPWR Tile_X0Y1_FrameStrobe[4] latch
XFILLER_127_7 VPWR VGND sg13cmos5l_decap_8
XFILLER_11_99 VPWR VGND sg13cmos5l_decap_8
XFILLER_127_77 VPWR VGND sg13cmos5l_decap_8
XFILLER_132_252 VPWR VGND sg13cmos5l_decap_8
XFILLER_87_26 VPWR VGND sg13cmos5l_fill_1
XFILLER_100_171 VPWR VGND sg13cmos5l_decap_8
XFILLER_46_225 VPWR VGND sg13cmos5l_decap_8
XFILLER_14_133 VPWR VGND sg13cmos5l_decap_8
XFILLER_14_166 VPWR VGND sg13cmos5l_decap_8
XFILLER_36_52 VPWR VGND sg13cmos5l_fill_2
XFILLER_36_96 VPWR VGND sg13cmos5l_fill_2
XFILLER_61_217 VPWR VGND sg13cmos5l_decap_8
XANTENNA__0910__X Tile_X0Y1_S4BEG[2] VPWR VGND sg13cmos5l_antennanp
XFILLER_77_81 VPWR VGND sg13cmos5l_fill_2
X_1221_ _1221_/X Tile_X0Y0_E2MID[5] Tile_X0Y0_E2END[5] Tile_X0Y0_E6END[10] _1094_/X
+ _0298_/Q _0297_/Q VPWR VGND sg13cmos5l_mux4_1
XFILLER_96_169 VPWR VGND sg13cmos5l_decap_8
XFILLER_96_147 VPWR VGND sg13cmos5l_fill_1
XFILLER_96_103 VPWR VGND sg13cmos5l_decap_8
X_1083_ _1083_/X _1111_/X Tile_X0Y1_N4END[4] Tile_X0Y0_S1END[0] Tile_X0Y0_S4END[0]
+ _0132_/Q _0131_/Q VPWR VGND sg13cmos5l_mux4_1
X_1152_ _1152_/X _0649_/Q _1197_/X _1200_/X _1191_/X _0512_/Q _0511_/Q VPWR VGND sg13cmos5l_mux4_1
X_0103_ _0103_/Q Tile_X0Y0_FrameData[21] VGND VPWR Tile_X0Y1_FrameStrobe[0] latch
XFILLER_60_272 VPWR VGND sg13cmos5l_fill_1
X_0936_ Tile_X0Y1_W2BEG[7] _1154_/X VPWR VGND sg13cmos5l_buf_1
XFILLER_9_170 VPWR VGND sg13cmos5l_decap_8
XANTENNA__0820__X Tile_X0Y0_FrameStrobe_O[17] VPWR VGND sg13cmos5l_antennanp
XFILLER_114_252 VPWR VGND sg13cmos5l_decap_8
X_0867_ Tile_X0Y0_FrameData_O[11] Tile_X0Y0_FrameData[11] VPWR VGND sg13cmos5l_buf_1
X_0798_ Tile_X0Y0_N2BEG[7] _1010_/X VPWR VGND sg13cmos5l_buf_1
XFILLER_51_272 VPWR VGND sg13cmos5l_fill_1
XFILLER_73_28 VPWR VGND sg13cmos5l_decap_8
XANTENNA__0730__X Tile_X0Y0_W2BEG[7] VPWR VGND sg13cmos5l_antennanp
XFILLER_11_136 VPWR VGND sg13cmos5l_fill_1
XFILLER_11_169 VPWR VGND sg13cmos5l_decap_8
XFILLER_138_21 VPWR VGND sg13cmos5l_decap_8
XFILLER_22_32 VPWR VGND sg13cmos5l_fill_2
XFILLER_7_107 VPWR VGND sg13cmos5l_decap_8
XFILLER_105_263 VPWR VGND sg13cmos5l_fill_2
XFILLER_120_222 VPWR VGND sg13cmos5l_decap_8
XFILLER_138_98 VPWR VGND sg13cmos5l_decap_8
XFILLER_19_203 VPWR VGND sg13cmos5l_fill_2
XFILLER_19_236 VPWR VGND sg13cmos5l_decap_8
XANTENNA__0905__X Tile_X0Y1_S2BEGb[5] VPWR VGND sg13cmos5l_antennanp
XFILLER_42_250 VPWR VGND sg13cmos5l_fill_2
XFILLER_42_272 VPWR VGND sg13cmos5l_fill_1
XFILLER_6_140 VPWR VGND sg13cmos5l_decap_8
X_0721_ Tile_X0Y0_W1BEG[2] _1029_/X VPWR VGND sg13cmos5l_buf_1
X_0652_ _0652_/L_HI VPWR VGND sg13cmos5l_tiehi
X_0583_ _0583_/Q Tile_X0Y1_FrameData[19] VGND VPWR Tile_X0Y1_FrameStrobe[7] latch
XFILLER_8_89 VPWR VGND sg13cmos5l_decap_8
XFILLER_111_211 VPWR VGND sg13cmos5l_decap_8
X_1204_ _1204_/X Tile_X0Y1_N1END[1] Tile_X0Y1_N4END[1] _1228_/X Tile_X0Y0_S4END[5]
+ _0400_/Q _0399_/Q VPWR VGND sg13cmos5l_mux4_1
XANTENNA__0815__X Tile_X0Y0_FrameStrobe_O[12] VPWR VGND sg13cmos5l_antennanp
X_1066_ _1066_/X Tile_X0Y1_N4END[7] Tile_X0Y0_S4END[3] _1083_/X _1075_/X _0196_/Q
+ _0195_/Q VPWR VGND sg13cmos5l_mux4_1
X_1135_ _1135_/X Tile_X0Y1_E1END[0] Tile_X0Y1_EE4END[12] Tile_X0Y1_E6END[4] _1203_/X
+ _0542_/Q _0541_/Q VPWR VGND sg13cmos5l_mux4_1
XFILLER_138_119 VPWR VGND sg13cmos5l_decap_8
X_0919_ Tile_X0Y1_S4BEG[11] _0919_/A VPWR VGND sg13cmos5l_buf_1
XFILLER_68_28 VPWR VGND sg13cmos5l_decap_8
XFILLER_102_266 VPWR VGND sg13cmos5l_decap_8
XFILLER_16_217 VPWR VGND sg13cmos5l_decap_8
XFILLER_83_172 VPWR VGND sg13cmos5l_decap_8
XANTENNA__0725__X Tile_X0Y0_W2BEG[2] VPWR VGND sg13cmos5l_antennanp
XFILLER_129_119 VPWR VGND sg13cmos5l_decap_8
XFILLER_140_88 VPWR VGND sg13cmos5l_decap_8
XFILLER_17_76 VPWR VGND sg13cmos5l_fill_1
XFILLER_17_98 VPWR VGND sg13cmos5l_decap_4
XFILLER_24_250 VPWR VGND sg13cmos5l_decap_8
XFILLER_24_272 VPWR VGND sg13cmos5l_fill_1
XFILLER_137_174 VPWR VGND sg13cmos5l_decap_8
XFILLER_3_143 VPWR VGND sg13cmos5l_decap_8
XFILLER_98_209 VPWR VGND sg13cmos5l_decap_8
XFILLER_3_176 VPWR VGND sg13cmos5l_decap_8
XFILLER_66_139 VPWR VGND sg13cmos5l_decap_8
XFILLER_74_161 VPWR VGND sg13cmos5l_decap_8
XFILLER_15_272 VPWR VGND sg13cmos5l_fill_1
XFILLER_30_231 VPWR VGND sg13cmos5l_decap_8
XFILLER_90_92 VPWR VGND sg13cmos5l_decap_8
XFILLER_128_196 VPWR VGND sg13cmos5l_decap_8
X_0704_ _1235_/A3 VPWR VGND sg13cmos5l_tielo
X_0635_ NPU_WEIGHT_SHIFT_EN Tile_X0Y1_UserCLK _1234_/X _0665_/L_HI VPWR VGND sg13cmos5l_dfrbpq_1
X_0566_ _0566_/Q Tile_X0Y1_FrameData[4] VGND VPWR Tile_X0Y1_FrameStrobe[6] latch
XFILLER_57_128 VPWR VGND sg13cmos5l_decap_8
X_0497_ _0497_/Q Tile_X0Y1_FrameData[9] VGND VPWR Tile_X0Y1_FrameStrobe[4] latch
XFILLER_21_220 VPWR VGND sg13cmos5l_decap_8
XFILLER_21_264 VPWR VGND sg13cmos5l_fill_1
XFILLER_80_164 VPWR VGND sg13cmos5l_decap_8
X_1049_ _1049_/X _0638_/Q _0642_/Q _1076_/X _1097_/X _0230_/Q _0229_/Q VPWR VGND sg13cmos5l_mux4_1
X_1118_ _1118_/X _1209_/X _1213_/X _1217_/X _1197_/X _0572_/Q _0571_/Q VPWR VGND sg13cmos5l_mux4_1
XFILLER_119_152 VPWR VGND sg13cmos5l_decap_8
XFILLER_134_133 VPWR VGND sg13cmos5l_decap_8
XFILLER_79_16 VPWR VGND sg13cmos5l_fill_1
XFILLER_79_38 VPWR VGND sg13cmos5l_fill_1
XFILLER_0_135 VPWR VGND sg13cmos5l_decap_8
XFILLER_135_77 VPWR VGND sg13cmos5l_decap_8
XFILLER_48_139 VPWR VGND sg13cmos5l_decap_8
XFILLER_88_242 VPWR VGND sg13cmos5l_decap_8
XFILLER_95_37 VPWR VGND sg13cmos5l_decap_8
XFILLER_28_97 VPWR VGND sg13cmos5l_decap_8
XFILLER_56_161 VPWR VGND sg13cmos5l_decap_8
XFILLER_12_242 VPWR VGND sg13cmos5l_decap_8
XFILLER_8_268 VPWR VGND sg13cmos5l_decap_4
XFILLER_8_257 VPWR VGND sg13cmos5l_decap_4
XFILLER_125_122 VPWR VGND sg13cmos5l_decap_8
XFILLER_125_199 VPWR VGND sg13cmos5l_decap_8
XFILLER_140_158 VPWR VGND sg13cmos5l_decap_8
XFILLER_5_35 VPWR VGND sg13cmos5l_decap_8
XFILLER_60_84 VPWR VGND sg13cmos5l_decap_8
XFILLER_79_242 VPWR VGND sg13cmos5l_decap_8
X_0420_ _0420_/Q Tile_X0Y1_FrameData[22] VGND VPWR Tile_X0Y1_FrameStrobe[2] latch
X_0351_ _0351_/Q Tile_X0Y1_FrameData[27] VGND VPWR Tile_X0Y1_FrameStrobe[0] latch
X_0282_ _0282_/Q Tile_X0Y0_FrameData[2] VGND VPWR Tile_X0Y1_FrameStrobe[5] latch
XFILLER_94_223 VPWR VGND sg13cmos5l_decap_8
XFILLER_47_194 VPWR VGND sg13cmos5l_decap_8
XFILLER_62_175 VPWR VGND sg13cmos5l_decap_8
XFILLER_116_155 VPWR VGND sg13cmos5l_decap_8
XFILLER_79_0 VPWR VGND sg13cmos5l_fill_2
XFILLER_85_223 VPWR VGND sg13cmos5l_decap_8
X_0618_ NPU_ACT_WDATA0 Tile_X0Y1_UserCLK _0982_/X _0681_/L_HI VPWR VGND sg13cmos5l_dfrbpq_1
X_0549_ _0549_/Q Tile_X0Y1_FrameData[21] VGND VPWR Tile_X0Y1_FrameStrobe[6] latch
XANTENNA_108 Tile_X0Y1_FrameData[23] VPWR VGND sg13cmos5l_antennanp
XANTENNA_119 Tile_X0Y1_FrameData[23] VPWR VGND sg13cmos5l_antennanp
XFILLER_38_194 VPWR VGND sg13cmos5l_decap_8
XFILLER_53_164 VPWR VGND sg13cmos5l_decap_8
XFILLER_139_225 VPWR VGND sg13cmos5l_decap_8
XFILLER_107_155 VPWR VGND sg13cmos5l_decap_8
XFILLER_107_166 VPWR VGND sg13cmos5l_fill_1
XFILLER_30_65 VPWR VGND sg13cmos5l_fill_2
XFILLER_5_249 VPWR VGND sg13cmos5l_decap_8
XFILLER_122_169 VPWR VGND sg13cmos5l_decap_8
XFILLER_76_245 VPWR VGND sg13cmos5l_decap_8
XFILLER_91_237 VPWR VGND sg13cmos5l_decap_8
XANTENNA__0913__X Tile_X0Y1_S4BEG[5] VPWR VGND sg13cmos5l_antennanp
XFILLER_72_7 VPWR VGND sg13cmos5l_decap_8
XFILLER_113_147 VPWR VGND sg13cmos5l_decap_4
XFILLER_4_260 VPWR VGND sg13cmos5l_decap_4
XFILLER_67_212 VPWR VGND sg13cmos5l_decap_8
XFILLER_67_223 VPWR VGND sg13cmos5l_fill_2
X_0403_ _0403_/Q Tile_X0Y1_FrameData[7] VGND VPWR Tile_X0Y1_FrameStrobe[1] latch
X_0334_ _0334_/Q Tile_X0Y0_FrameData[14] VGND VPWR Tile_X0Y1_FrameStrobe[7] latch
X_0265_ _0265_/Q Tile_X0Y0_FrameData[19] VGND VPWR Tile_X0Y1_FrameStrobe[5] latch
X_0196_ _0196_/Q Tile_X0Y0_FrameData[24] VGND VPWR Tile_X0Y1_FrameStrobe[3] latch
XANTENNA__0823__X FAB_USER_CLK VPWR VGND sg13cmos5l_antennanp
XFILLER_50_123 VPWR VGND sg13cmos5l_decap_8
XFILLER_104_125 VPWR VGND sg13cmos5l_decap_4
XFILLER_104_136 VPWR VGND sg13cmos5l_fill_1
XFILLER_136_217 VPWR VGND sg13cmos5l_decap_8
XFILLER_2_208 VPWR VGND sg13cmos5l_decap_8
XFILLER_112_180 VPWR VGND sg13cmos5l_decap_8
XFILLER_18_109 VPWR VGND sg13cmos5l_fill_1
XFILLER_58_212 VPWR VGND sg13cmos5l_decap_8
XFILLER_76_28 VPWR VGND sg13cmos5l_decap_8
XFILLER_132_56 VPWR VGND sg13cmos5l_decap_8
XFILLER_25_43 VPWR VGND sg13cmos5l_fill_1
XFILLER_26_120 VPWR VGND sg13cmos5l_decap_4
XFILLER_41_101 VPWR VGND sg13cmos5l_decap_8
XFILLER_73_259 VPWR VGND sg13cmos5l_decap_8
XFILLER_92_49 VPWR VGND sg13cmos5l_fill_2
XANTENNA__0733__X Tile_X0Y0_W2BEGb[2] VPWR VGND sg13cmos5l_antennanp
XFILLER_25_98 VPWR VGND sg13cmos5l_decap_4
XFILLER_110_117 VPWR VGND sg13cmos5l_decap_8
XFILLER_135_261 VPWR VGND sg13cmos5l_decap_4
XFILLER_135_272 VPWR VGND sg13cmos5l_fill_1
XFILLER_2_14 VPWR VGND sg13cmos5l_decap_8
XFILLER_49_212 VPWR VGND sg13cmos5l_decap_8
XANTENNA__0908__X Tile_X0Y1_S4BEG[0] VPWR VGND sg13cmos5l_antennanp
XFILLER_103_180 VPWR VGND sg13cmos5l_decap_8
XANTENNA_19 Tile_X0Y0_S4END[14] VPWR VGND sg13cmos5l_antennanp
XFILLER_17_175 VPWR VGND sg13cmos5l_decap_8
XFILLER_32_178 VPWR VGND sg13cmos5l_decap_8
X_0952_ Tile_X0Y1_W6BEG[7] _1186_/X VPWR VGND sg13cmos5l_buf_1
XFILLER_126_261 VPWR VGND sg13cmos5l_decap_8
XFILLER_126_272 VPWR VGND sg13cmos5l_fill_1
X_0883_ Tile_X0Y0_FrameData_O[27] Tile_X0Y0_FrameData[27] VPWR VGND sg13cmos5l_buf_1
XANTENNA__0818__X Tile_X0Y0_FrameStrobe_O[15] VPWR VGND sg13cmos5l_antennanp
X_0317_ _0317_/Q Tile_X0Y0_FrameData[31] VGND VPWR Tile_X0Y1_FrameStrobe[7] latch
XFILLER_102_15 VPWR VGND sg13cmos5l_fill_2
XFILLER_23_145 VPWR VGND sg13cmos5l_decap_8
XFILLER_23_156 VPWR VGND sg13cmos5l_fill_1
X_0248_ _0248_/Q Tile_X0Y0_FrameData[4] VGND VPWR Tile_X0Y1_FrameStrobe[4] latch
X_0179_ _0179_/Q Tile_X0Y0_FrameData[9] VGND VPWR Tile_X0Y1_FrameStrobe[2] latch
XFILLER_109_228 VPWR VGND sg13cmos5l_fill_2
XFILLER_117_250 VPWR VGND sg13cmos5l_decap_8
XFILLER_117_272 VPWR VGND sg13cmos5l_fill_1
XFILLER_127_56 VPWR VGND sg13cmos5l_decap_8
XFILLER_132_231 VPWR VGND sg13cmos5l_decap_8
XFILLER_2_7 VPWR VGND sg13cmos5l_decap_8
XFILLER_87_16 VPWR VGND sg13cmos5l_fill_2
XANTENNA__0728__X Tile_X0Y0_W2BEG[5] VPWR VGND sg13cmos5l_antennanp
XFILLER_100_161 VPWR VGND sg13cmos5l_fill_2
XFILLER_46_204 VPWR VGND sg13cmos5l_decap_8
XFILLER_14_112 VPWR VGND sg13cmos5l_decap_8
XFILLER_36_75 VPWR VGND sg13cmos5l_fill_1
X_1220_ _1220_/X Tile_X0Y0_E2MID[6] Tile_X0Y0_E2END[6] Tile_X0Y0_E6END[9] _1093_/X
+ _0300_/Q _0299_/Q VPWR VGND sg13cmos5l_mux4_1
X_1151_ _1151_/X Tile_X0Y1_EE4END[8] _0648_/Q _1198_/X _1199_/X _0514_/Q _0513_/Q
+ VPWR VGND sg13cmos5l_mux4_1
X_1082_ _1082_/X _1112_/X Tile_X0Y1_N4END[5] Tile_X0Y0_S1END[1] Tile_X0Y0_S4END[1]
+ _0130_/Q _0129_/Q VPWR VGND sg13cmos5l_mux4_1
X_0102_ _0102_/Q Tile_X0Y0_FrameData[22] VGND VPWR Tile_X0Y1_FrameStrobe[0] latch
XFILLER_60_262 VPWR VGND sg13cmos5l_fill_2
X_0866_ Tile_X0Y0_FrameData_O[10] Tile_X0Y0_FrameData[10] VPWR VGND sg13cmos5l_buf_1
X_0935_ Tile_X0Y1_W2BEG[6] _1153_/X VPWR VGND sg13cmos5l_buf_1
XFILLER_106_209 VPWR VGND sg13cmos5l_decap_8
XFILLER_61_0 VPWR VGND sg13cmos5l_decap_8
X_0797_ Tile_X0Y0_N2BEG[6] _1009_/X VPWR VGND sg13cmos5l_buf_1
XFILLER_113_58 VPWR VGND sg13cmos5l_decap_8
XFILLER_28_248 VPWR VGND sg13cmos5l_decap_8
XFILLER_87_137 VPWR VGND sg13cmos5l_decap_8
XFILLER_87_159 VPWR VGND sg13cmos5l_decap_8
XFILLER_43_229 VPWR VGND sg13cmos5l_decap_8
XFILLER_11_148 VPWR VGND sg13cmos5l_decap_8
XFILLER_138_77 VPWR VGND sg13cmos5l_decap_8
XFILLER_105_242 VPWR VGND sg13cmos5l_decap_8
XFILLER_120_201 VPWR VGND sg13cmos5l_decap_8
XFILLER_19_215 VPWR VGND sg13cmos5l_decap_8
XFILLER_34_229 VPWR VGND sg13cmos5l_fill_2
XANTENNA__0921__X Tile_X0Y1_S4BEG[13] VPWR VGND sg13cmos5l_antennanp
XFILLER_63_84 VPWR VGND sg13cmos5l_decap_8
X_0720_ Tile_X0Y0_W1BEG[1] _1028_/X VPWR VGND sg13cmos5l_buf_1
XFILLER_8_68 VPWR VGND sg13cmos5l_decap_8
XFILLER_10_181 VPWR VGND sg13cmos5l_decap_8
X_0651_ _0651_/Q Tile_X0Y1_UserCLK NPU_ACT_RDATA7 _0659_/L_HI VPWR VGND sg13cmos5l_dfrbpq_1
X_0582_ _0582_/Q Tile_X0Y1_FrameData[20] VGND VPWR Tile_X0Y1_FrameStrobe[7] latch
XFILLER_77_192 VPWR VGND sg13cmos5l_decap_8
XFILLER_84_107 VPWR VGND sg13cmos5l_decap_8
X_1134_ _1134_/X Tile_X0Y1_E1END[3] Tile_X0Y1_E2MID[0] Tile_X0Y1_E2END[0] _1202_/X
+ _0544_/Q _0543_/Q VPWR VGND sg13cmos5l_mux4_1
X_1203_ _1203_/X Tile_X0Y1_N1END[0] Tile_X0Y1_N4END[0] _1227_/X Tile_X0Y0_S4END[4]
+ _0402_/Q _0401_/Q VPWR VGND sg13cmos5l_mux4_1
X_1065_ _1065_/X Tile_X0Y1_N4END[6] Tile_X0Y0_S4END[2] _1082_/X _1076_/X _0198_/Q
+ _0197_/Q VPWR VGND sg13cmos5l_mux4_1
XANTENNA__0831__X Tile_X0Y1_FrameData_O[7] VPWR VGND sg13cmos5l_antennanp
XFILLER_108_14 VPWR VGND sg13cmos5l_fill_1
X_0918_ Tile_X0Y1_S4BEG[10] _0918_/A VPWR VGND sg13cmos5l_buf_1
X_0849_ Tile_X0Y1_FrameData_O[25] Tile_X0Y1_FrameData[25] VPWR VGND sg13cmos5l_buf_1
XFILLER_102_245 VPWR VGND sg13cmos5l_decap_8
XFILLER_140_67 VPWR VGND sg13cmos5l_decap_8
XFILLER_68_181 VPWR VGND sg13cmos5l_decap_8
XANTENNA__0741__X Tile_X0Y0_W6BEG[2] VPWR VGND sg13cmos5l_antennanp
XFILLER_109_0 VPWR VGND sg13cmos5l_fill_2
XFILLER_137_153 VPWR VGND sg13cmos5l_decap_8
XFILLER_3_133 VPWR VGND sg13cmos5l_decap_4
XFILLER_58_84 VPWR VGND sg13cmos5l_decap_8
XFILLER_74_140 VPWR VGND sg13cmos5l_decap_8
XANTENNA__0916__X Tile_X0Y1_S4BEG[8] VPWR VGND sg13cmos5l_antennanp
XFILLER_30_210 VPWR VGND sg13cmos5l_decap_8
XFILLER_128_175 VPWR VGND sg13cmos5l_decap_8
X_0703_ _1100_/A3 VPWR VGND sg13cmos5l_tielo
XFILLER_90_60 VPWR VGND sg13cmos5l_fill_2
XFILLER_24_0 VPWR VGND sg13cmos5l_fill_2
X_0634_ NPU_ACT_ADDR8 Tile_X0Y1_UserCLK _0981_/X _0666_/L_HI VPWR VGND sg13cmos5l_dfrbpq_1
X_0565_ _0565_/Q Tile_X0Y1_FrameData[5] VGND VPWR Tile_X0Y1_FrameStrobe[6] latch
X_0496_ _0496_/Q Tile_X0Y1_FrameData[10] VGND VPWR Tile_X0Y1_FrameStrobe[4] latch
XANTENNA__0826__X Tile_X0Y1_FrameData_O[2] VPWR VGND sg13cmos5l_antennanp
XFILLER_65_184 VPWR VGND sg13cmos5l_decap_8
XFILLER_80_143 VPWR VGND sg13cmos5l_decap_8
X_1117_ _1117_/X Tile_X0Y1_E1END[2] Tile_X0Y1_EE4END[2] Tile_X0Y1_E6END[10] _1205_/X
+ _0572_/Q _0571_/Q VPWR VGND sg13cmos5l_mux4_1
XFILLER_110_15 VPWR VGND sg13cmos5l_decap_4
XFILLER_110_26 VPWR VGND sg13cmos5l_fill_2
XFILLER_119_120 VPWR VGND sg13cmos5l_fill_2
X_1048_ _1048_/X _0637_/Q _0641_/Q _1077_/X _1098_/X _0232_/Q _0231_/Q VPWR VGND sg13cmos5l_mux4_1
XFILLER_119_131 VPWR VGND sg13cmos5l_decap_8
XFILLER_134_112 VPWR VGND sg13cmos5l_decap_8
XFILLER_134_189 VPWR VGND sg13cmos5l_decap_8
XFILLER_135_56 VPWR VGND sg13cmos5l_decap_8
XFILLER_28_32 VPWR VGND sg13cmos5l_fill_2
XFILLER_56_140 VPWR VGND sg13cmos5l_decap_8
XFILLER_88_221 VPWR VGND sg13cmos5l_decap_8
XFILLER_95_27 VPWR VGND sg13cmos5l_fill_2
XANTENNA__0736__X Tile_X0Y0_W2BEGb[5] VPWR VGND sg13cmos5l_antennanp
XFILLER_12_221 VPWR VGND sg13cmos5l_decap_8
XFILLER_71_154 VPWR VGND sg13cmos5l_decap_8
XFILLER_71_198 VPWR VGND sg13cmos5l_decap_8
XFILLER_60_63 VPWR VGND sg13cmos5l_decap_8
XFILLER_8_236 VPWR VGND sg13cmos5l_decap_8
XFILLER_125_178 VPWR VGND sg13cmos5l_decap_8
XFILLER_140_137 VPWR VGND sg13cmos5l_decap_8
XFILLER_5_14 VPWR VGND sg13cmos5l_decap_8
XFILLER_79_221 VPWR VGND sg13cmos5l_decap_8
X_0350_ _0350_/Q Tile_X0Y1_FrameData[28] VGND VPWR Tile_X0Y1_FrameStrobe[0] latch
XFILLER_47_173 VPWR VGND sg13cmos5l_decap_8
X_0281_ _0281_/Q Tile_X0Y0_FrameData[3] VGND VPWR Tile_X0Y1_FrameStrobe[5] latch
XFILLER_94_202 VPWR VGND sg13cmos5l_decap_8
XFILLER_62_154 VPWR VGND sg13cmos5l_decap_8
XFILLER_116_101 VPWR VGND sg13cmos5l_fill_1
XFILLER_116_112 VPWR VGND sg13cmos5l_fill_1
XFILLER_116_134 VPWR VGND sg13cmos5l_decap_8
XFILLER_131_126 VPWR VGND sg13cmos5l_decap_8
XFILLER_85_202 VPWR VGND sg13cmos5l_decap_8
XFILLER_85_268 VPWR VGND sg13cmos5l_decap_4
X_0617_ NPU_WEIGHT_IN7 Tile_X0Y1_UserCLK _0997_/X _0680_/L_HI VPWR VGND sg13cmos5l_dfrbpq_1
X_0548_ _0548_/Q Tile_X0Y1_FrameData[22] VGND VPWR Tile_X0Y1_FrameStrobe[6] latch
X_0479_ _0479_/Q Tile_X0Y1_FrameData[27] VGND VPWR Tile_X0Y1_FrameStrobe[4] latch
XANTENNA_109 Tile_X0Y1_FrameData[23] VPWR VGND sg13cmos5l_antennanp
XFILLER_38_173 VPWR VGND sg13cmos5l_decap_8
XFILLER_53_143 VPWR VGND sg13cmos5l_decap_8
XFILLER_81_29 VPWR VGND sg13cmos5l_fill_2
XFILLER_139_204 VPWR VGND sg13cmos5l_decap_8
XFILLER_30_11 VPWR VGND sg13cmos5l_fill_1
XFILLER_5_228 VPWR VGND sg13cmos5l_decap_8
XFILLER_122_148 VPWR VGND sg13cmos5l_decap_8
XFILLER_29_140 VPWR VGND sg13cmos5l_decap_8
XFILLER_29_151 VPWR VGND sg13cmos5l_fill_2
XFILLER_39_97 VPWR VGND sg13cmos5l_decap_4
XFILLER_76_224 VPWR VGND sg13cmos5l_decap_8
XFILLER_91_216 VPWR VGND sg13cmos5l_decap_8
XFILLER_44_198 VPWR VGND sg13cmos5l_decap_8
XFILLER_65_7 VPWR VGND sg13cmos5l_decap_8
XFILLER_71_84 VPWR VGND sg13cmos5l_decap_8
XFILLER_113_115 VPWR VGND sg13cmos5l_fill_1
XFILLER_121_192 VPWR VGND sg13cmos5l_decap_8
XFILLER_4_272 VPWR VGND sg13cmos5l_fill_1
X_0402_ _0402_/Q Tile_X0Y1_FrameData[8] VGND VPWR Tile_X0Y1_FrameStrobe[1] latch
X_0333_ _0333_/Q Tile_X0Y0_FrameData[15] VGND VPWR Tile_X0Y1_FrameStrobe[7] latch
XFILLER_35_198 VPWR VGND sg13cmos5l_decap_8
XFILLER_82_249 VPWR VGND sg13cmos5l_decap_8
X_0264_ _0264_/Q Tile_X0Y0_FrameData[20] VGND VPWR Tile_X0Y1_FrameStrobe[5] latch
X_0195_ _0195_/Q Tile_X0Y0_FrameData[25] VGND VPWR Tile_X0Y1_FrameStrobe[3] latch
XFILLER_90_271 VPWR VGND sg13cmos5l_fill_2
XFILLER_90_260 VPWR VGND sg13cmos5l_decap_8
XFILLER_50_179 VPWR VGND sg13cmos5l_decap_8
XFILLER_91_0 VPWR VGND sg13cmos5l_decap_4
XFILLER_132_35 VPWR VGND sg13cmos5l_decap_8
XFILLER_58_235 VPWR VGND sg13cmos5l_decap_4
XFILLER_73_238 VPWR VGND sg13cmos5l_decap_8
XFILLER_25_11 VPWR VGND sg13cmos5l_decap_8
XFILLER_41_124 VPWR VGND sg13cmos5l_decap_8
XFILLER_81_260 VPWR VGND sg13cmos5l_decap_4
XFILLER_135_240 VPWR VGND sg13cmos5l_decap_8
XFILLER_1_220 VPWR VGND sg13cmos5l_decap_8
XFILLER_66_84 VPWR VGND sg13cmos5l_decap_8
XANTENNA__0924__X Tile_X0Y1_UserCLKo VPWR VGND sg13cmos5l_antennanp
XFILLER_118_229 VPWR VGND sg13cmos5l_decap_8
XFILLER_82_72 VPWR VGND sg13cmos5l_fill_2
X_0882_ Tile_X0Y0_FrameData_O[26] Tile_X0Y0_FrameData[26] VPWR VGND sg13cmos5l_buf_1
X_0951_ Tile_X0Y1_W6BEG[6] _1185_/X VPWR VGND sg13cmos5l_buf_1
XFILLER_126_240 VPWR VGND sg13cmos5l_decap_8
XFILLER_101_129 VPWR VGND sg13cmos5l_fill_2
XFILLER_55_227 VPWR VGND sg13cmos5l_decap_8
X_0316_ _0316_/Q Tile_X0Y0_FrameData[0] VGND VPWR Tile_X0Y1_FrameStrobe[6] latch
XANTENNA__0834__X Tile_X0Y1_FrameData_O[10] VPWR VGND sg13cmos5l_antennanp
XFILLER_23_135 VPWR VGND sg13cmos5l_fill_2
XFILLER_23_179 VPWR VGND sg13cmos5l_decap_8
X_0247_ _0247_/Q Tile_X0Y0_FrameData[5] VGND VPWR Tile_X0Y1_FrameStrobe[4] latch
X_0178_ _0178_/Q Tile_X0Y0_FrameData[10] VGND VPWR Tile_X0Y1_FrameStrobe[2] latch
XFILLER_109_207 VPWR VGND sg13cmos5l_decap_8
XFILLER_11_35 VPWR VGND sg13cmos5l_fill_1
XFILLER_11_79 VPWR VGND sg13cmos5l_decap_8
XFILLER_127_35 VPWR VGND sg13cmos5l_decap_8
XFILLER_132_210 VPWR VGND sg13cmos5l_decap_8
XFILLER_100_140 VPWR VGND sg13cmos5l_decap_8
XANTENNA__0744__X Tile_X0Y0_W6BEG[5] VPWR VGND sg13cmos5l_antennanp
XFILLER_139_0 VPWR VGND sg13cmos5l_decap_8
XFILLER_36_98 VPWR VGND sg13cmos5l_fill_1
XFILLER_123_254 VPWR VGND sg13cmos5l_decap_8
XANTENNA__0919__X Tile_X0Y1_S4BEG[11] VPWR VGND sg13cmos5l_antennanp
XFILLER_37_227 VPWR VGND sg13cmos5l_decap_8
XFILLER_77_94 VPWR VGND sg13cmos5l_decap_8
X_1150_ _1150_/X Tile_X0Y1_EE4END[4] _0647_/Q _1198_/X _1199_/X _0516_/Q _0515_/Q
+ VPWR VGND sg13cmos5l_mux4_1
X_0101_ _0101_/Q Tile_X0Y0_FrameData[23] VGND VPWR Tile_X0Y1_FrameStrobe[0] latch
XFILLER_96_138 VPWR VGND sg13cmos5l_decap_8
XFILLER_52_219 VPWR VGND sg13cmos5l_decap_8
XFILLER_60_241 VPWR VGND sg13cmos5l_decap_8
X_1081_ _1081_/X _1113_/X Tile_X0Y1_N4END[6] Tile_X0Y0_S1END[2] Tile_X0Y0_S4END[2]
+ _0128_/Q _0127_/Q VPWR VGND sg13cmos5l_mux4_1
XFILLER_20_127 VPWR VGND sg13cmos5l_decap_4
X_0865_ Tile_X0Y0_FrameData_O[9] Tile_X0Y0_FrameData[9] VPWR VGND sg13cmos5l_buf_1
X_0934_ Tile_X0Y1_W2BEG[5] _1152_/X VPWR VGND sg13cmos5l_buf_1
XANTENNA__0829__X Tile_X0Y1_FrameData_O[5] VPWR VGND sg13cmos5l_antennanp
XFILLER_54_0 VPWR VGND sg13cmos5l_decap_8
X_0796_ Tile_X0Y0_N2BEG[5] _1008_/X VPWR VGND sg13cmos5l_buf_1
XFILLER_28_227 VPWR VGND sg13cmos5l_decap_8
XFILLER_36_271 VPWR VGND sg13cmos5l_fill_2
XFILLER_3_91 VPWR VGND sg13cmos5l_decap_8
XFILLER_43_208 VPWR VGND sg13cmos5l_decap_8
XFILLER_11_127 VPWR VGND sg13cmos5l_decap_8
XFILLER_132_7 VPWR VGND sg13cmos5l_decap_8
XFILLER_105_221 VPWR VGND sg13cmos5l_decap_8
XFILLER_138_56 VPWR VGND sg13cmos5l_decap_8
XANTENNA__0739__X Tile_X0Y0_W6BEG[0] VPWR VGND sg13cmos5l_antennanp
XFILLER_120_257 VPWR VGND sg13cmos5l_decap_8
XFILLER_103_81 VPWR VGND sg13cmos5l_decap_4
XFILLER_27_271 VPWR VGND sg13cmos5l_fill_2
XFILLER_34_208 VPWR VGND sg13cmos5l_decap_8
XFILLER_42_263 VPWR VGND sg13cmos5l_decap_8
XFILLER_63_63 VPWR VGND sg13cmos5l_decap_8
XFILLER_10_160 VPWR VGND sg13cmos5l_decap_8
XFILLER_8_47 VPWR VGND sg13cmos5l_decap_8
XFILLER_111_246 VPWR VGND sg13cmos5l_decap_8
XFILLER_69_116 VPWR VGND sg13cmos5l_fill_1
XFILLER_6_175 VPWR VGND sg13cmos5l_decap_8
X_0650_ _0650_/Q Tile_X0Y1_UserCLK NPU_ACT_RDATA6 _0658_/L_HI VPWR VGND sg13cmos5l_dfrbpq_1
X_0581_ _0581_/Q Tile_X0Y1_FrameData[21] VGND VPWR Tile_X0Y1_FrameStrobe[7] latch
XFILLER_111_268 VPWR VGND sg13cmos5l_decap_4
XFILLER_77_171 VPWR VGND sg13cmos5l_decap_8
X_1064_ _1064_/X Tile_X0Y1_N4END[5] Tile_X0Y0_S4END[1] _1081_/X _1077_/X _0200_/Q
+ _0199_/Q VPWR VGND sg13cmos5l_mux4_1
X_1133_ _1133_/X Tile_X0Y1_E1END[2] Tile_X0Y1_E2MID[1] Tile_X0Y1_E2END[1] _1201_/X
+ _0546_/Q _0545_/Q VPWR VGND sg13cmos5l_mux4_1
X_1202_ _1202_/X Tile_X0Y1_N2MID[7] Tile_X0Y1_N2END[7] _1226_/X Tile_X0Y0_S2MID[7]
+ _0356_/Q _0355_/Q VPWR VGND sg13cmos5l_mux4_1
XFILLER_92_185 VPWR VGND sg13cmos5l_fill_2
XFILLER_92_174 VPWR VGND sg13cmos5l_decap_8
XFILLER_92_141 VPWR VGND sg13cmos5l_fill_1
XFILLER_108_26 VPWR VGND sg13cmos5l_decap_4
X_0917_ Tile_X0Y1_S4BEG[9] _0917_/A VPWR VGND sg13cmos5l_buf_1
X_0848_ Tile_X0Y1_FrameData_O[24] Tile_X0Y1_FrameData[24] VPWR VGND sg13cmos5l_buf_1
X_0779_ Tile_X0Y0_WW4BEG[12] _1059_/X VPWR VGND sg13cmos5l_buf_1
XFILLER_102_224 VPWR VGND sg13cmos5l_decap_8
XFILLER_124_36 VPWR VGND sg13cmos5l_decap_4
XFILLER_75_119 VPWR VGND sg13cmos5l_decap_8
XFILLER_140_24 VPWR VGND sg13cmos5l_decap_8
XFILLER_3_112 VPWR VGND sg13cmos5l_decap_8
XFILLER_58_63 VPWR VGND sg13cmos5l_decap_8
XANTENNA__0932__X Tile_X0Y1_W2BEG[3] VPWR VGND sg13cmos5l_antennanp
XFILLER_15_230 VPWR VGND sg13cmos5l_decap_8
XFILLER_74_196 VPWR VGND sg13cmos5l_decap_8
XFILLER_74_84 VPWR VGND sg13cmos5l_decap_8
XFILLER_128_154 VPWR VGND sg13cmos5l_decap_8
XFILLER_30_266 VPWR VGND sg13cmos5l_decap_8
X_0702_ _1234_/A3 VPWR VGND sg13cmos5l_tielo
X_0633_ NPU_ACT_ADDR7 Tile_X0Y1_UserCLK _0980_/X _0688_/L_HI VPWR VGND sg13cmos5l_dfrbpq_1
X_0564_ _0564_/Q Tile_X0Y1_FrameData[6] VGND VPWR Tile_X0Y1_FrameStrobe[6] latch
X_0495_ _0495_/Q Tile_X0Y1_FrameData[11] VGND VPWR Tile_X0Y1_FrameStrobe[4] latch
XFILLER_97_244 VPWR VGND sg13cmos5l_decap_8
XFILLER_0_92 VPWR VGND sg13cmos5l_decap_4
XFILLER_65_130 VPWR VGND sg13cmos5l_fill_1
XFILLER_65_163 VPWR VGND sg13cmos5l_decap_8
X_1047_ _1047_/X _0636_/Q _0640_/Q _1079_/X _1099_/X _0234_/Q _0233_/Q VPWR VGND sg13cmos5l_mux4_1
X_1116_ _1116_/X _1210_/X _1214_/X _1218_/X _1198_/X _0569_/Q _0568_/Q VPWR VGND sg13cmos5l_mux4_1
XANTENNA__0842__X Tile_X0Y1_FrameData_O[18] VPWR VGND sg13cmos5l_antennanp
XFILLER_21_255 VPWR VGND sg13cmos5l_decap_8
XFILLER_80_199 VPWR VGND sg13cmos5l_decap_8
XFILLER_119_187 VPWR VGND sg13cmos5l_decap_8
XFILLER_134_168 VPWR VGND sg13cmos5l_decap_8
XFILLER_135_35 VPWR VGND sg13cmos5l_decap_8
XFILLER_88_200 VPWR VGND sg13cmos5l_decap_8
XANTENNA__0752__X Tile_X0Y0_N4BEG[1] VPWR VGND sg13cmos5l_antennanp
XFILLER_12_200 VPWR VGND sg13cmos5l_decap_8
XFILLER_44_76 VPWR VGND sg13cmos5l_decap_4
XFILLER_44_98 VPWR VGND sg13cmos5l_decap_8
XFILLER_56_196 VPWR VGND sg13cmos5l_decap_8
XFILLER_71_133 VPWR VGND sg13cmos5l_decap_8
XFILLER_71_177 VPWR VGND sg13cmos5l_decap_8
XFILLER_121_0 VPWR VGND sg13cmos5l_fill_2
XFILLER_60_42 VPWR VGND sg13cmos5l_decap_8
XFILLER_8_215 VPWR VGND sg13cmos5l_decap_8
XFILLER_125_157 VPWR VGND sg13cmos5l_decap_8
XFILLER_140_116 VPWR VGND sg13cmos5l_decap_8
XFILLER_39_108 VPWR VGND sg13cmos5l_fill_2
XFILLER_79_200 VPWR VGND sg13cmos5l_decap_8
X_0280_ _0280_/Q Tile_X0Y0_FrameData[4] VGND VPWR Tile_X0Y1_FrameStrobe[5] latch
XANTENNA__0927__X Tile_X0Y1_W1BEG[2] VPWR VGND sg13cmos5l_antennanp
XFILLER_10_7 VPWR VGND sg13cmos5l_fill_2
XFILLER_47_152 VPWR VGND sg13cmos5l_decap_8
XFILLER_62_133 VPWR VGND sg13cmos5l_decap_8
XFILLER_85_61 VPWR VGND sg13cmos5l_fill_2
XFILLER_94_258 VPWR VGND sg13cmos5l_decap_8
XANTENNA__0611__Q NPU_WEIGHT_IN1 VPWR VGND sg13cmos5l_antennanp
XFILLER_131_105 VPWR VGND sg13cmos5l_decap_8
X_0616_ NPU_WEIGHT_IN6 Tile_X0Y1_UserCLK _0996_/X _0679_/L_HI VPWR VGND sg13cmos5l_dfrbpq_1
XANTENNA__0837__X Tile_X0Y1_FrameData_O[13] VPWR VGND sg13cmos5l_antennanp
XFILLER_105_49 VPWR VGND sg13cmos5l_fill_2
XFILLER_85_258 VPWR VGND sg13cmos5l_decap_8
X_0547_ _0547_/Q Tile_X0Y1_FrameData[23] VGND VPWR Tile_X0Y1_FrameStrobe[6] latch
X_0478_ _0478_/Q Tile_X0Y1_FrameData[28] VGND VPWR Tile_X0Y1_FrameStrobe[4] latch
XFILLER_53_122 VPWR VGND sg13cmos5l_decap_8
XFILLER_53_199 VPWR VGND sg13cmos5l_decap_8
XFILLER_5_207 VPWR VGND sg13cmos5l_decap_8
XFILLER_115_190 VPWR VGND sg13cmos5l_decap_8
XFILLER_122_127 VPWR VGND sg13cmos5l_decap_8
XFILLER_30_67 VPWR VGND sg13cmos5l_fill_1
XFILLER_39_54 VPWR VGND sg13cmos5l_decap_4
XFILLER_39_65 VPWR VGND sg13cmos5l_decap_8
XFILLER_76_203 VPWR VGND sg13cmos5l_decap_8
XANTENNA__0747__X Tile_X0Y0_W6BEG[8] VPWR VGND sg13cmos5l_antennanp
XFILLER_130_182 VPWR VGND sg13cmos5l_decap_8
XFILLER_29_185 VPWR VGND sg13cmos5l_decap_8
XFILLER_55_42 VPWR VGND sg13cmos5l_decap_8
XFILLER_44_177 VPWR VGND sg13cmos5l_decap_8
XFILLER_55_97 VPWR VGND sg13cmos5l_decap_4
XFILLER_71_63 VPWR VGND sg13cmos5l_decap_8
XFILLER_113_127 VPWR VGND sg13cmos5l_decap_8
XFILLER_113_138 VPWR VGND sg13cmos5l_fill_2
XFILLER_4_251 VPWR VGND sg13cmos5l_decap_4
XFILLER_58_7 VPWR VGND sg13cmos5l_decap_8
XFILLER_121_171 VPWR VGND sg13cmos5l_decap_8
X_0401_ _0401_/Q Tile_X0Y1_FrameData[9] VGND VPWR Tile_X0Y1_FrameStrobe[1] latch
X_0332_ _0332_/Q Tile_X0Y0_FrameData[16] VGND VPWR Tile_X0Y1_FrameStrobe[7] latch
X_0263_ _0263_/Q Tile_X0Y0_FrameData[21] VGND VPWR Tile_X0Y1_FrameStrobe[5] latch
XFILLER_82_228 VPWR VGND sg13cmos5l_decap_8
X_0194_ _0194_/Q Tile_X0Y0_FrameData[26] VGND VPWR Tile_X0Y1_FrameStrobe[3] latch
XFILLER_129_260 VPWR VGND sg13cmos5l_decap_4
XFILLER_50_158 VPWR VGND sg13cmos5l_decap_8
XFILLER_84_0 VPWR VGND sg13cmos5l_decap_4
XFILLER_6_91 VPWR VGND sg13cmos5l_decap_8
XFILLER_132_14 VPWR VGND sg13cmos5l_decap_8
XFILLER_73_217 VPWR VGND sg13cmos5l_decap_8
XFILLER_25_23 VPWR VGND sg13cmos5l_decap_8
XFILLER_41_169 VPWR VGND sg13cmos5l_decap_8
XFILLER_81_272 VPWR VGND sg13cmos5l_fill_1
XFILLER_127_219 VPWR VGND sg13cmos5l_decap_8
XFILLER_41_33 VPWR VGND sg13cmos5l_fill_2
XFILLER_106_70 VPWR VGND sg13cmos5l_fill_1
XFILLER_110_108 VPWR VGND sg13cmos5l_fill_2
XFILLER_2_49 VPWR VGND sg13cmos5l_decap_8
XFILLER_49_247 VPWR VGND sg13cmos5l_decap_8
XFILLER_66_63 VPWR VGND sg13cmos5l_decap_8
XFILLER_17_166 VPWR VGND sg13cmos5l_decap_4
XFILLER_64_217 VPWR VGND sg13cmos5l_fill_2
XANTENNA__0940__X Tile_X0Y1_W2BEGb[3] VPWR VGND sg13cmos5l_antennanp
XFILLER_118_208 VPWR VGND sg13cmos5l_decap_8
X_0881_ Tile_X0Y0_FrameData_O[25] Tile_X0Y0_FrameData[25] VPWR VGND sg13cmos5l_buf_1
X_0950_ Tile_X0Y1_W6BEG[5] _1184_/X VPWR VGND sg13cmos5l_buf_1
XFILLER_141_222 VPWR VGND sg13cmos5l_decap_8
XFILLER_141_266 VPWR VGND sg13cmos5l_decap_8
XFILLER_102_17 VPWR VGND sg13cmos5l_fill_1
XFILLER_55_206 VPWR VGND sg13cmos5l_decap_8
X_0315_ _0315_/Q Tile_X0Y0_FrameData[1] VGND VPWR Tile_X0Y1_FrameStrobe[6] latch
X_0246_ _0246_/Q Tile_X0Y0_FrameData[6] VGND VPWR Tile_X0Y1_FrameStrobe[4] latch
XFILLER_63_272 VPWR VGND sg13cmos5l_fill_1
X_0177_ _0177_/Q Tile_X0Y0_FrameData[11] VGND VPWR Tile_X0Y1_FrameStrobe[2] latch
XANTENNA__0850__X Tile_X0Y1_FrameData_O[26] VPWR VGND sg13cmos5l_antennanp
XFILLER_127_14 VPWR VGND sg13cmos5l_decap_8
XFILLER_31_191 VPWR VGND sg13cmos5l_decap_8
XFILLER_132_266 VPWR VGND sg13cmos5l_decap_8
XFILLER_87_18 VPWR VGND sg13cmos5l_fill_1
XFILLER_100_163 VPWR VGND sg13cmos5l_fill_1
XFILLER_100_185 VPWR VGND sg13cmos5l_decap_8
XFILLER_46_239 VPWR VGND sg13cmos5l_decap_8
XFILLER_54_272 VPWR VGND sg13cmos5l_fill_1
XANTENNA__0760__X Tile_X0Y0_N4BEG[9] VPWR VGND sg13cmos5l_antennanp
XFILLER_14_147 VPWR VGND sg13cmos5l_fill_1
XFILLER_108_252 VPWR VGND sg13cmos5l_decap_8
XFILLER_123_233 VPWR VGND sg13cmos5l_decap_8
XFILLER_96_117 VPWR VGND sg13cmos5l_decap_8
XFILLER_37_206 VPWR VGND sg13cmos5l_decap_8
XFILLER_77_40 VPWR VGND sg13cmos5l_decap_8
X_1080_ _1080_/X _1114_/X Tile_X0Y1_N4END[7] Tile_X0Y0_S1END[3] Tile_X0Y0_S4END[3]
+ _0126_/Q _0125_/Q VPWR VGND sg13cmos5l_mux4_1
X_0100_ _0100_/Q Tile_X0Y0_FrameData[24] VGND VPWR Tile_X0Y1_FrameStrobe[0] latch
XANTENNA__0935__X Tile_X0Y1_W2BEG[6] VPWR VGND sg13cmos5l_antennanp
XFILLER_45_261 VPWR VGND sg13cmos5l_fill_1
XFILLER_45_272 VPWR VGND sg13cmos5l_fill_1
XFILLER_60_220 VPWR VGND sg13cmos5l_decap_8
XFILLER_60_264 VPWR VGND sg13cmos5l_fill_1
XFILLER_93_61 VPWR VGND sg13cmos5l_decap_4
X_0864_ Tile_X0Y0_FrameData_O[8] Tile_X0Y0_FrameData[8] VPWR VGND sg13cmos5l_buf_1
X_0933_ Tile_X0Y1_W2BEG[4] _1151_/X VPWR VGND sg13cmos5l_buf_1
X_0795_ Tile_X0Y0_N2BEG[4] _1007_/X VPWR VGND sg13cmos5l_buf_1
XFILLER_9_184 VPWR VGND sg13cmos5l_decap_8
XFILLER_114_233 VPWR VGND sg13cmos5l_fill_1
XFILLER_114_266 VPWR VGND sg13cmos5l_decap_8
XFILLER_3_70 VPWR VGND sg13cmos5l_decap_8
XFILLER_87_128 VPWR VGND sg13cmos5l_fill_2
XFILLER_95_150 VPWR VGND sg13cmos5l_decap_8
XANTENNA__0845__X Tile_X0Y1_FrameData_O[21] VPWR VGND sg13cmos5l_antennanp
XFILLER_28_206 VPWR VGND sg13cmos5l_decap_8
X_0229_ _0229_/Q Tile_X0Y0_FrameData[23] VGND VPWR Tile_X0Y1_FrameStrobe[4] latch
XFILLER_11_106 VPWR VGND sg13cmos5l_decap_8
XFILLER_125_7 VPWR VGND sg13cmos5l_decap_8
XFILLER_105_200 VPWR VGND sg13cmos5l_decap_8
XFILLER_138_35 VPWR VGND sg13cmos5l_decap_8
XFILLER_120_236 VPWR VGND sg13cmos5l_decap_8
XFILLER_86_150 VPWR VGND sg13cmos5l_fill_1
XFILLER_86_183 VPWR VGND sg13cmos5l_decap_8
XANTENNA__0755__X Tile_X0Y0_N4BEG[4] VPWR VGND sg13cmos5l_antennanp
XFILLER_63_42 VPWR VGND sg13cmos5l_decap_8
XFILLER_6_154 VPWR VGND sg13cmos5l_decap_8
XFILLER_111_225 VPWR VGND sg13cmos5l_decap_8
XFILLER_6_198 VPWR VGND sg13cmos5l_decap_8
X_1201_ _1201_/X Tile_X0Y1_N2MID[6] Tile_X0Y1_N2END[6] _1225_/X Tile_X0Y0_S2MID[6]
+ _0358_/Q _0357_/Q VPWR VGND sg13cmos5l_mux4_1
X_0580_ _0580_/Q Tile_X0Y1_FrameData[22] VGND VPWR Tile_X0Y1_FrameStrobe[7] latch
XFILLER_18_261 VPWR VGND sg13cmos5l_fill_1
XFILLER_18_272 VPWR VGND sg13cmos5l_fill_1
XFILLER_25_209 VPWR VGND sg13cmos5l_decap_8
XFILLER_77_150 VPWR VGND sg13cmos5l_decap_8
X_1063_ _1063_/X Tile_X0Y1_N4END[4] Tile_X0Y0_S4END[0] _1080_/X _1079_/X _0202_/Q
+ _0201_/Q VPWR VGND sg13cmos5l_mux4_1
X_1132_ _1132_/X Tile_X0Y1_E1END[1] Tile_X0Y1_E2MID[2] Tile_X0Y1_E2END[2] _1200_/X
+ _0548_/Q _0547_/Q VPWR VGND sg13cmos5l_mux4_1
XFILLER_92_153 VPWR VGND sg13cmos5l_decap_8
XANTENNA__0614__Q NPU_WEIGHT_IN4 VPWR VGND sg13cmos5l_antennanp
X_0916_ Tile_X0Y1_S4BEG[8] _0916_/A VPWR VGND sg13cmos5l_buf_1
XFILLER_102_203 VPWR VGND sg13cmos5l_decap_8
X_0847_ Tile_X0Y1_FrameData_O[23] Tile_X0Y1_FrameData[23] VPWR VGND sg13cmos5l_buf_1
X_0778_ Tile_X0Y0_WW4BEG[11] _1058_/X VPWR VGND sg13cmos5l_buf_1
XFILLER_124_15 VPWR VGND sg13cmos5l_decap_8
XFILLER_124_59 VPWR VGND sg13cmos5l_decap_8
XFILLER_83_142 VPWR VGND sg13cmos5l_decap_8
XFILLER_140_47 VPWR VGND sg13cmos5l_fill_2
XFILLER_83_186 VPWR VGND sg13cmos5l_decap_8
XFILLER_137_133 VPWR VGND sg13cmos5l_decap_8
XFILLER_137_188 VPWR VGND sg13cmos5l_decap_8
XFILLER_3_157 VPWR VGND sg13cmos5l_fill_1
XFILLER_58_42 VPWR VGND sg13cmos5l_decap_8
XFILLER_59_183 VPWR VGND sg13cmos5l_decap_8
XFILLER_74_175 VPWR VGND sg13cmos5l_decap_8
XFILLER_74_63 VPWR VGND sg13cmos5l_decap_8
XFILLER_130_91 VPWR VGND sg13cmos5l_decap_8
XFILLER_30_245 VPWR VGND sg13cmos5l_decap_8
XFILLER_90_73 VPWR VGND sg13cmos5l_fill_1
XFILLER_128_133 VPWR VGND sg13cmos5l_decap_8
X_0701_ _1102_/A3 VPWR VGND sg13cmos5l_tielo
X_0632_ NPU_ACT_ADDR6 Tile_X0Y1_UserCLK _0979_/X _0689_/L_HI VPWR VGND sg13cmos5l_dfrbpq_1
X_0563_ _0563_/Q Tile_X0Y1_FrameData[7] VGND VPWR Tile_X0Y1_FrameStrobe[6] latch
XFILLER_57_109 VPWR VGND sg13cmos5l_decap_8
X_0494_ _0494_/Q Tile_X0Y1_FrameData[12] VGND VPWR Tile_X0Y1_FrameStrobe[4] latch
XFILLER_97_223 VPWR VGND sg13cmos5l_decap_8
XFILLER_65_142 VPWR VGND sg13cmos5l_decap_8
XFILLER_80_178 VPWR VGND sg13cmos5l_decap_8
X_1046_ _1046_/X Tile_X0Y0_EE4END[14] _0643_/Q _1092_/X _1099_/X _0236_/Q _0235_/Q
+ VPWR VGND sg13cmos5l_mux4_1
X_1115_ _1115_/X Tile_X0Y1_E1END[3] Tile_X0Y1_EE4END[3] Tile_X0Y1_E6END[11] _1206_/X
+ _0569_/Q _0568_/Q VPWR VGND sg13cmos5l_mux4_1
XFILLER_119_122 VPWR VGND sg13cmos5l_fill_1
XFILLER_119_15 VPWR VGND sg13cmos5l_decap_8
XFILLER_119_166 VPWR VGND sg13cmos5l_decap_8
XFILLER_21_234 VPWR VGND sg13cmos5l_decap_8
XFILLER_0_149 VPWR VGND sg13cmos5l_decap_4
XFILLER_134_147 VPWR VGND sg13cmos5l_decap_8
XFILLER_135_14 VPWR VGND sg13cmos5l_decap_8
XFILLER_88_256 VPWR VGND sg13cmos5l_decap_8
XFILLER_95_29 VPWR VGND sg13cmos5l_fill_1
XFILLER_56_175 VPWR VGND sg13cmos5l_decap_8
XFILLER_71_112 VPWR VGND sg13cmos5l_decap_8
XFILLER_12_256 VPWR VGND sg13cmos5l_decap_4
XFILLER_44_11 VPWR VGND sg13cmos5l_fill_1
XFILLER_44_33 VPWR VGND sg13cmos5l_decap_8
XFILLER_44_66 VPWR VGND sg13cmos5l_fill_2
XFILLER_60_21 VPWR VGND sg13cmos5l_decap_8
XFILLER_114_0 VPWR VGND sg13cmos5l_fill_2
XFILLER_125_103 VPWR VGND sg13cmos5l_fill_1
XFILLER_125_136 VPWR VGND sg13cmos5l_decap_8
XFILLER_5_49 VPWR VGND sg13cmos5l_decap_8
XFILLER_60_98 VPWR VGND sg13cmos5l_decap_4
XFILLER_79_256 VPWR VGND sg13cmos5l_decap_8
XFILLER_94_237 VPWR VGND sg13cmos5l_decap_8
XANTENNA__0943__X Tile_X0Y1_W2BEGb[6] VPWR VGND sg13cmos5l_antennanp
XFILLER_62_112 VPWR VGND sg13cmos5l_decap_8
XFILLER_62_189 VPWR VGND sg13cmos5l_decap_8
XFILLER_116_169 VPWR VGND sg13cmos5l_decap_8
X_0615_ NPU_WEIGHT_IN5 Tile_X0Y1_UserCLK _0995_/X _0656_/L_HI VPWR VGND sg13cmos5l_dfrbpq_1
X_0546_ _0546_/Q Tile_X0Y1_FrameData[24] VGND VPWR Tile_X0Y1_FrameStrobe[6] latch
XFILLER_38_120 VPWR VGND sg13cmos5l_decap_8
XFILLER_85_237 VPWR VGND sg13cmos5l_decap_8
X_0477_ _0477_/Q Tile_X0Y1_FrameData[29] VGND VPWR Tile_X0Y1_FrameStrobe[4] latch
XFILLER_93_270 VPWR VGND sg13cmos5l_fill_2
XANTENNA__0853__X Tile_X0Y1_FrameData_O[29] VPWR VGND sg13cmos5l_antennanp
XFILLER_139_239 VPWR VGND sg13cmos5l_decap_8
XFILLER_53_178 VPWR VGND sg13cmos5l_decap_8
X_1029_ _1029_/X _1113_/X Tile_X0Y0_S1END[2] _0636_/Q _0641_/Q _0270_/Q _0269_/Q VPWR
+ VGND sg13cmos5l_mux4_1
XFILLER_30_57 VPWR VGND sg13cmos5l_decap_4
XFILLER_30_79 VPWR VGND sg13cmos5l_decap_4
XFILLER_122_106 VPWR VGND sg13cmos5l_decap_8
XFILLER_130_161 VPWR VGND sg13cmos5l_decap_8
XFILLER_76_259 VPWR VGND sg13cmos5l_decap_8
XANTENNA__0763__X Tile_X0Y0_N4BEG[12] VPWR VGND sg13cmos5l_antennanp
XFILLER_29_164 VPWR VGND sg13cmos5l_decap_8
XFILLER_44_156 VPWR VGND sg13cmos5l_decap_8
XFILLER_55_21 VPWR VGND sg13cmos5l_decap_8
XFILLER_55_76 VPWR VGND sg13cmos5l_decap_8
XFILLER_71_42 VPWR VGND sg13cmos5l_decap_8
XFILLER_4_230 VPWR VGND sg13cmos5l_decap_8
X_0400_ _0400_/Q Tile_X0Y1_FrameData[10] VGND VPWR Tile_X0Y1_FrameStrobe[1] latch
XANTENNA__0938__X Tile_X0Y1_W2BEGb[1] VPWR VGND sg13cmos5l_antennanp
XFILLER_121_150 VPWR VGND sg13cmos5l_decap_8
XFILLER_82_207 VPWR VGND sg13cmos5l_decap_8
X_0331_ _0331_/Q Tile_X0Y0_FrameData[17] VGND VPWR Tile_X0Y1_FrameStrobe[7] latch
X_0262_ _0262_/Q Tile_X0Y0_FrameData[22] VGND VPWR Tile_X0Y1_FrameStrobe[5] latch
X_0193_ _0193_/Q Tile_X0Y0_FrameData[27] VGND VPWR Tile_X0Y1_FrameStrobe[3] latch
XFILLER_96_94 VPWR VGND sg13cmos5l_fill_2
XFILLER_35_123 VPWR VGND sg13cmos5l_decap_4
XFILLER_50_137 VPWR VGND sg13cmos5l_decap_8
XANTENNA__0622__Q NPU_ACT_WDATA4 VPWR VGND sg13cmos5l_antennanp
XFILLER_129_272 VPWR VGND sg13cmos5l_fill_1
XFILLER_6_70 VPWR VGND sg13cmos5l_decap_8
XFILLER_77_0 VPWR VGND sg13cmos5l_fill_1
XANTENNA__0848__X Tile_X0Y1_FrameData_O[24] VPWR VGND sg13cmos5l_antennanp
XFILLER_112_194 VPWR VGND sg13cmos5l_decap_8
X_0529_ _0529_/Q Tile_X0Y1_FrameData[9] VGND VPWR Tile_X0Y1_FrameStrobe[5] latch
XFILLER_26_112 VPWR VGND sg13cmos5l_fill_1
XFILLER_66_270 VPWR VGND sg13cmos5l_fill_2
XFILLER_41_115 VPWR VGND sg13cmos5l_fill_2
XANTENNA__0758__X Tile_X0Y0_N4BEG[7] VPWR VGND sg13cmos5l_antennanp
XFILLER_103_194 VPWR VGND sg13cmos5l_decap_8
XFILLER_106_82 VPWR VGND sg13cmos5l_fill_1
XFILLER_2_28 VPWR VGND sg13cmos5l_decap_8
XFILLER_49_226 VPWR VGND sg13cmos5l_decap_8
XFILLER_66_42 VPWR VGND sg13cmos5l_decap_8
XFILLER_122_92 VPWR VGND sg13cmos5l_decap_8
XFILLER_17_145 VPWR VGND sg13cmos5l_decap_8
XFILLER_17_189 VPWR VGND sg13cmos5l_decap_8
XFILLER_82_41 VPWR VGND sg13cmos5l_fill_2
XFILLER_82_74 VPWR VGND sg13cmos5l_fill_1
XFILLER_82_96 VPWR VGND sg13cmos5l_fill_2
XFILLER_70_7 VPWR VGND sg13cmos5l_decap_8
X_0880_ Tile_X0Y0_FrameData_O[24] Tile_X0Y0_FrameData[24] VPWR VGND sg13cmos5l_buf_1
XFILLER_141_201 VPWR VGND sg13cmos5l_decap_8
XFILLER_141_245 VPWR VGND sg13cmos5l_decap_8
XANTENNA__0617__Q NPU_WEIGHT_IN7 VPWR VGND sg13cmos5l_antennanp
XFILLER_23_104 VPWR VGND sg13cmos5l_fill_2
X_0314_ _0314_/Q Tile_X0Y0_FrameData[2] VGND VPWR Tile_X0Y1_FrameStrobe[6] latch
X_0245_ _0245_/Q Tile_X0Y0_FrameData[7] VGND VPWR Tile_X0Y1_FrameStrobe[4] latch
X_0176_ _0176_/Q Tile_X0Y0_FrameData[12] VGND VPWR Tile_X0Y1_FrameStrobe[2] latch
XFILLER_23_137 VPWR VGND sg13cmos5l_fill_1
XFILLER_31_170 VPWR VGND sg13cmos5l_decap_8
XFILLER_117_264 VPWR VGND sg13cmos5l_fill_1
XFILLER_11_26 VPWR VGND sg13cmos5l_fill_2
XFILLER_132_245 VPWR VGND sg13cmos5l_decap_8
XFILLER_46_218 VPWR VGND sg13cmos5l_decap_8
XFILLER_14_126 VPWR VGND sg13cmos5l_decap_8
XFILLER_14_159 VPWR VGND sg13cmos5l_decap_8
XFILLER_36_45 VPWR VGND sg13cmos5l_decap_8
XFILLER_52_33 VPWR VGND sg13cmos5l_fill_2
XFILLER_108_231 VPWR VGND sg13cmos5l_decap_8
XFILLER_22_192 VPWR VGND sg13cmos5l_decap_8
XFILLER_123_212 VPWR VGND sg13cmos5l_decap_8
XFILLER_77_63 VPWR VGND sg13cmos5l_decap_8
XFILLER_7_0 VPWR VGND sg13cmos5l_fill_2
XFILLER_133_91 VPWR VGND sg13cmos5l_decap_8
XANTENNA__0951__X Tile_X0Y1_W6BEG[6] VPWR VGND sg13cmos5l_antennanp
X_0932_ Tile_X0Y1_W2BEG[3] _1150_/X VPWR VGND sg13cmos5l_buf_1
XFILLER_114_212 VPWR VGND sg13cmos5l_decap_8
XFILLER_114_245 VPWR VGND sg13cmos5l_decap_8
X_0863_ Tile_X0Y0_FrameData_O[7] Tile_X0Y0_FrameData[7] VPWR VGND sg13cmos5l_buf_1
X_0794_ Tile_X0Y0_N2BEG[3] _1006_/X VPWR VGND sg13cmos5l_buf_1
XFILLER_9_163 VPWR VGND sg13cmos5l_decap_8
X_0228_ _0228_/Q Tile_X0Y0_FrameData[24] VGND VPWR Tile_X0Y1_FrameStrobe[4] latch
X_0159_ _0159_/Q Tile_X0Y0_FrameData[29] VGND VPWR Tile_X0Y1_FrameStrobe[2] latch
XANTENNA__0861__X Tile_X0Y0_FrameData_O[5] VPWR VGND sg13cmos5l_antennanp
XFILLER_138_14 VPWR VGND sg13cmos5l_decap_8
XFILLER_22_47 VPWR VGND sg13cmos5l_decap_4
XFILLER_0_7 VPWR VGND sg13cmos5l_decap_8
XFILLER_105_256 VPWR VGND sg13cmos5l_decap_8
XFILLER_120_215 VPWR VGND sg13cmos5l_decap_8
XFILLER_19_229 VPWR VGND sg13cmos5l_decap_8
XFILLER_86_162 VPWR VGND sg13cmos5l_decap_8
XANTENNA__0771__X Tile_X0Y0_WW4BEG[4] VPWR VGND sg13cmos5l_antennanp
XFILLER_42_243 VPWR VGND sg13cmos5l_decap_8
XFILLER_63_21 VPWR VGND sg13cmos5l_decap_8
XFILLER_63_98 VPWR VGND sg13cmos5l_decap_8
XFILLER_8_16 VPWR VGND sg13cmos5l_fill_2
XFILLER_10_195 VPWR VGND sg13cmos5l_decap_8
XFILLER_128_91 VPWR VGND sg13cmos5l_decap_8
XFILLER_12_80 VPWR VGND sg13cmos5l_fill_2
XFILLER_6_133 VPWR VGND sg13cmos5l_decap_8
XFILLER_111_204 VPWR VGND sg13cmos5l_decap_8
X_1200_ _1200_/X Tile_X0Y1_N2MID[5] Tile_X0Y1_N2END[5] _1224_/X Tile_X0Y0_S2MID[5]
+ _0360_/Q _0359_/Q VPWR VGND sg13cmos5l_mux4_1
XANTENNA__0946__X Tile_X0Y1_W6BEG[1] VPWR VGND sg13cmos5l_antennanp
XFILLER_33_243 VPWR VGND sg13cmos5l_fill_2
X_1062_ _1062_/X _0639_/Q _0643_/Q _1088_/X _1092_/X _0204_/Q _0203_/Q VPWR VGND sg13cmos5l_mux4_1
X_1131_ _1131_/X Tile_X0Y1_E1END[0] Tile_X0Y1_E2MID[3] Tile_X0Y1_E2END[3] _1199_/X
+ _0550_/Q _0549_/Q VPWR VGND sg13cmos5l_mux4_1
XFILLER_92_198 VPWR VGND sg13cmos5l_decap_8
XFILLER_92_132 VPWR VGND sg13cmos5l_decap_8
X_0915_ Tile_X0Y1_S4BEG[7] Tile_X0Y0_S4END[15] VPWR VGND sg13cmos5l_buf_1
XANTENNA__0630__Q NPU_ACT_ADDR4 VPWR VGND sg13cmos5l_antennanp
X_0846_ Tile_X0Y1_FrameData_O[22] Tile_X0Y1_FrameData[22] VPWR VGND sg13cmos5l_buf_1
X_0777_ Tile_X0Y0_WW4BEG[10] _1057_/X VPWR VGND sg13cmos5l_buf_1
XANTENNA__0856__X Tile_X0Y0_FrameData_O[0] VPWR VGND sg13cmos5l_antennanp
XFILLER_102_259 VPWR VGND sg13cmos5l_decap_8
XFILLER_68_173 VPWR VGND sg13cmos5l_decap_4
XFILLER_68_195 VPWR VGND sg13cmos5l_decap_8
XFILLER_83_121 VPWR VGND sg13cmos5l_decap_8
XFILLER_83_165 VPWR VGND sg13cmos5l_decap_8
XFILLER_24_243 VPWR VGND sg13cmos5l_decap_8
XFILLER_137_112 VPWR VGND sg13cmos5l_decap_8
XFILLER_137_167 VPWR VGND sg13cmos5l_decap_8
XFILLER_3_169 VPWR VGND sg13cmos5l_decap_8
XFILLER_58_21 VPWR VGND sg13cmos5l_decap_8
XFILLER_58_98 VPWR VGND sg13cmos5l_fill_1
XFILLER_59_140 VPWR VGND sg13cmos5l_decap_8
XFILLER_59_151 VPWR VGND sg13cmos5l_fill_1
XANTENNA__0766__X Tile_X0Y0_N4BEG[15] VPWR VGND sg13cmos5l_antennanp
XFILLER_74_154 VPWR VGND sg13cmos5l_decap_8
XFILLER_74_42 VPWR VGND sg13cmos5l_decap_8
XFILLER_128_112 VPWR VGND sg13cmos5l_decap_8
XFILLER_130_70 VPWR VGND sg13cmos5l_decap_8
XFILLER_30_224 VPWR VGND sg13cmos5l_decap_8
X_0700_ _1101_/A3 VPWR VGND sg13cmos5l_tielo
XFILLER_95_9 VPWR VGND sg13cmos5l_decap_8
XFILLER_90_85 VPWR VGND sg13cmos5l_decap_8
XFILLER_90_30 VPWR VGND sg13cmos5l_decap_8
XFILLER_128_189 VPWR VGND sg13cmos5l_decap_8
X_0631_ NPU_ACT_ADDR5 Tile_X0Y1_UserCLK _0978_/X _0686_/L_HI VPWR VGND sg13cmos5l_dfrbpq_1
X_0562_ _0562_/Q Tile_X0Y1_FrameData[8] VGND VPWR Tile_X0Y1_FrameStrobe[6] latch
XFILLER_97_202 VPWR VGND sg13cmos5l_decap_8
X_1114_ _1114_/X Tile_X0Y1_E1END[3] Tile_X0Y1_E6END[7] _1218_/X _1194_/X _0596_/Q
+ _0595_/Q VPWR VGND sg13cmos5l_mux4_1
X_0493_ _0493_/Q Tile_X0Y1_FrameData[13] VGND VPWR Tile_X0Y1_FrameStrobe[4] latch
XFILLER_97_268 VPWR VGND sg13cmos5l_decap_4
XANTENNA__0625__Q NPU_ACT_WDATA7 VPWR VGND sg13cmos5l_antennanp
XFILLER_21_213 VPWR VGND sg13cmos5l_decap_8
XFILLER_65_198 VPWR VGND sg13cmos5l_decap_8
XFILLER_80_157 VPWR VGND sg13cmos5l_decap_8
X_1045_ _1045_/X Tile_X0Y0_EE4END[13] _0642_/Q _1093_/X _1098_/X _0238_/Q _0237_/Q
+ VPWR VGND sg13cmos5l_mux4_1
XFILLER_119_145 VPWR VGND sg13cmos5l_decap_8
XFILLER_134_126 VPWR VGND sg13cmos5l_decap_8
XFILLER_21_268 VPWR VGND sg13cmos5l_decap_4
X_0829_ Tile_X0Y1_FrameData_O[5] Tile_X0Y1_FrameData[5] VPWR VGND sg13cmos5l_buf_1
XFILLER_9_81 VPWR VGND sg13cmos5l_decap_8
XFILLER_0_106 VPWR VGND sg13cmos5l_decap_4
XFILLER_88_235 VPWR VGND sg13cmos5l_decap_8
XFILLER_56_154 VPWR VGND sg13cmos5l_decap_8
XFILLER_12_235 VPWR VGND sg13cmos5l_decap_8
XFILLER_12_268 VPWR VGND sg13cmos5l_decap_4
XFILLER_44_56 VPWR VGND sg13cmos5l_fill_2
XFILLER_71_168 VPWR VGND sg13cmos5l_decap_4
XFILLER_109_60 VPWR VGND sg13cmos5l_decap_4
XFILLER_109_93 VPWR VGND sg13cmos5l_decap_4
XFILLER_125_115 VPWR VGND sg13cmos5l_decap_8
XFILLER_5_28 VPWR VGND sg13cmos5l_decap_8
XFILLER_60_77 VPWR VGND sg13cmos5l_decap_8
XFILLER_125_92 VPWR VGND sg13cmos5l_decap_8
XFILLER_133_192 VPWR VGND sg13cmos5l_decap_8
XFILLER_79_235 VPWR VGND sg13cmos5l_decap_8
XFILLER_79_268 VPWR VGND sg13cmos5l_decap_4
XFILLER_94_216 VPWR VGND sg13cmos5l_decap_8
XFILLER_47_187 VPWR VGND sg13cmos5l_decap_8
XFILLER_62_168 VPWR VGND sg13cmos5l_decap_8
XFILLER_7_261 VPWR VGND sg13cmos5l_decap_4
XFILLER_7_272 VPWR VGND sg13cmos5l_fill_1
XFILLER_116_148 VPWR VGND sg13cmos5l_decap_8
XFILLER_22_0 VPWR VGND sg13cmos5l_decap_8
XFILLER_85_216 VPWR VGND sg13cmos5l_decap_8
X_0614_ NPU_WEIGHT_IN4 Tile_X0Y1_UserCLK _0994_/X _0653_/L_HI VPWR VGND sg13cmos5l_dfrbpq_1
X_0545_ _0545_/Q Tile_X0Y1_FrameData[25] VGND VPWR Tile_X0Y1_FrameStrobe[6] latch
X_0476_ _0476_/Q Tile_X0Y1_FrameData[30] VGND VPWR Tile_X0Y1_FrameStrobe[4] latch
XFILLER_38_187 VPWR VGND sg13cmos5l_decap_8
XFILLER_53_157 VPWR VGND sg13cmos5l_decap_8
XFILLER_139_218 VPWR VGND sg13cmos5l_decap_8
X_1028_ _1028_/X _1112_/X Tile_X0Y0_S1END[1] _0639_/Q _0642_/Q _0272_/Q _0271_/Q VPWR
+ VGND sg13cmos5l_mux4_1
XANTENNA__0090__Q NPU_XBAR_SEL0 VPWR VGND sg13cmos5l_antennanp
XFILLER_30_25 VPWR VGND sg13cmos5l_decap_4
XFILLER_130_140 VPWR VGND sg13cmos5l_decap_8
XFILLER_76_238 VPWR VGND sg13cmos5l_decap_8
XFILLER_71_21 VPWR VGND sg13cmos5l_decap_8
XFILLER_71_98 VPWR VGND sg13cmos5l_decap_8
XFILLER_106_181 VPWR VGND sg13cmos5l_decap_8
XFILLER_136_91 VPWR VGND sg13cmos5l_decap_8
XFILLER_4_264 VPWR VGND sg13cmos5l_fill_1
XFILLER_67_205 VPWR VGND sg13cmos5l_decap_8
X_0330_ _0330_/Q Tile_X0Y0_FrameData[18] VGND VPWR Tile_X0Y1_FrameStrobe[7] latch
XANTENNA__0954__X Tile_X0Y1_W6BEG[9] VPWR VGND sg13cmos5l_antennanp
X_0261_ _0261_/Q Tile_X0Y0_FrameData[23] VGND VPWR Tile_X0Y1_FrameStrobe[5] latch
X_0192_ _0192_/Q Tile_X0Y0_FrameData[28] VGND VPWR Tile_X0Y1_FrameStrobe[3] latch
XFILLER_112_140 VPWR VGND sg13cmos5l_decap_8
XFILLER_112_173 VPWR VGND sg13cmos5l_decap_8
XFILLER_116_28 VPWR VGND sg13cmos5l_decap_4
XFILLER_58_205 VPWR VGND sg13cmos5l_decap_8
X_0528_ _0528_/Q Tile_X0Y1_FrameData[10] VGND VPWR Tile_X0Y1_FrameStrobe[5] latch
X_0459_ _0459_/Q Tile_X0Y1_FrameData[15] VGND VPWR Tile_X0Y1_FrameStrobe[3] latch
XANTENNA__0864__X Tile_X0Y0_FrameData_O[8] VPWR VGND sg13cmos5l_antennanp
XFILLER_132_49 VPWR VGND sg13cmos5l_decap_8
XFILLER_25_47 VPWR VGND sg13cmos5l_decap_4
XFILLER_26_124 VPWR VGND sg13cmos5l_fill_1
XFILLER_135_254 VPWR VGND sg13cmos5l_decap_8
XFILLER_1_234 VPWR VGND sg13cmos5l_decap_8
XFILLER_49_205 VPWR VGND sg13cmos5l_decap_8
XANTENNA__0774__X Tile_X0Y0_WW4BEG[7] VPWR VGND sg13cmos5l_antennanp
XFILLER_103_173 VPWR VGND sg13cmos5l_decap_8
XFILLER_17_102 VPWR VGND sg13cmos5l_fill_2
XFILLER_57_271 VPWR VGND sg13cmos5l_fill_2
XFILLER_66_21 VPWR VGND sg13cmos5l_decap_8
XFILLER_66_98 VPWR VGND sg13cmos5l_decap_8
XFILLER_40_160 VPWR VGND sg13cmos5l_decap_8
XFILLER_72_252 VPWR VGND sg13cmos5l_decap_8
XFILLER_82_31 VPWR VGND sg13cmos5l_fill_2
XFILLER_126_254 VPWR VGND sg13cmos5l_decap_8
XFILLER_63_7 VPWR VGND sg13cmos5l_decap_8
XANTENNA__0949__X Tile_X0Y1_W6BEG[4] VPWR VGND sg13cmos5l_antennanp
X_0313_ _0313_/Q Tile_X0Y0_FrameData[3] VGND VPWR Tile_X0Y1_FrameStrobe[6] latch
X_0244_ _0244_/Q Tile_X0Y0_FrameData[8] VGND VPWR Tile_X0Y1_FrameStrobe[4] latch
X_0175_ _0175_/Q Tile_X0Y0_FrameData[13] VGND VPWR Tile_X0Y1_FrameStrobe[2] latch
XANTENNA__0633__Q NPU_ACT_ADDR7 VPWR VGND sg13cmos5l_antennanp
XANTENNA__0859__X Tile_X0Y0_FrameData_O[3] VPWR VGND sg13cmos5l_antennanp
XFILLER_117_243 VPWR VGND sg13cmos5l_decap_8
XFILLER_127_49 VPWR VGND sg13cmos5l_decap_8
XFILLER_132_224 VPWR VGND sg13cmos5l_decap_8
XFILLER_100_154 VPWR VGND sg13cmos5l_decap_8
XFILLER_36_35 VPWR VGND sg13cmos5l_fill_2
XFILLER_14_105 VPWR VGND sg13cmos5l_decap_8
XFILLER_36_57 VPWR VGND sg13cmos5l_decap_8
XFILLER_108_210 VPWR VGND sg13cmos5l_decap_8
XANTENNA__0769__X Tile_X0Y0_WW4BEG[2] VPWR VGND sg13cmos5l_antennanp
XFILLER_117_93 VPWR VGND sg13cmos5l_fill_2
XFILLER_123_268 VPWR VGND sg13cmos5l_decap_4
XFILLER_77_31 VPWR VGND sg13cmos5l_fill_2
XFILLER_89_193 VPWR VGND sg13cmos5l_decap_8
XFILLER_133_70 VPWR VGND sg13cmos5l_decap_8
XFILLER_45_252 VPWR VGND sg13cmos5l_decap_8
XFILLER_93_30 VPWR VGND sg13cmos5l_fill_2
XFILLER_13_182 VPWR VGND sg13cmos5l_decap_8
XFILLER_60_255 VPWR VGND sg13cmos5l_decap_8
X_0862_ Tile_X0Y0_FrameData_O[6] Tile_X0Y0_FrameData[6] VPWR VGND sg13cmos5l_buf_1
X_0931_ Tile_X0Y1_W2BEG[2] _1149_/X VPWR VGND sg13cmos5l_buf_1
XFILLER_9_142 VPWR VGND sg13cmos5l_decap_8
X_0793_ Tile_X0Y0_N2BEG[2] _1005_/X VPWR VGND sg13cmos5l_buf_1
XANTENNA__0628__Q NPU_ACT_ADDR2 VPWR VGND sg13cmos5l_antennanp
XFILLER_95_185 VPWR VGND sg13cmos5l_fill_2
XFILLER_36_241 VPWR VGND sg13cmos5l_fill_2
XFILLER_51_222 VPWR VGND sg13cmos5l_decap_8
X_0227_ _0227_/Q Tile_X0Y0_FrameData[25] VGND VPWR Tile_X0Y1_FrameStrobe[4] latch
X_0158_ _0158_/Q Tile_X0Y0_FrameData[30] VGND VPWR Tile_X0Y1_FrameStrobe[2] latch
X_0089_ NPU_ACT_WE Tile_X0Y1_UserCLK _0089_/D _0697_/L_HI VPWR VGND sg13cmos5l_dfrbpq_1
XFILLER_105_235 VPWR VGND sg13cmos5l_decap_8
XFILLER_105_268 VPWR VGND sg13cmos5l_decap_4
XFILLER_86_141 VPWR VGND sg13cmos5l_decap_8
XFILLER_103_51 VPWR VGND sg13cmos5l_fill_2
XFILLER_19_208 VPWR VGND sg13cmos5l_decap_8
XFILLER_137_0 VPWR VGND sg13cmos5l_decap_8
XFILLER_42_222 VPWR VGND sg13cmos5l_decap_8
XFILLER_63_77 VPWR VGND sg13cmos5l_decap_8
XFILLER_10_174 VPWR VGND sg13cmos5l_decap_8
XFILLER_128_70 VPWR VGND sg13cmos5l_decap_8
XFILLER_6_112 VPWR VGND sg13cmos5l_decap_8
XFILLER_6_189 VPWR VGND sg13cmos5l_decap_4
XFILLER_88_41 VPWR VGND sg13cmos5l_decap_4
XFILLER_77_185 VPWR VGND sg13cmos5l_decap_8
X_1130_ _1130_/X Tile_X0Y1_E2MID[4] Tile_X0Y1_E2END[4] Tile_X0Y1_E6END[11] _1198_/X
+ _0552_/Q _0551_/Q VPWR VGND sg13cmos5l_mux4_1
XANTENNA__0962__X Tile_X0Y1_WW4BEG[5] VPWR VGND sg13cmos5l_antennanp
XFILLER_18_252 VPWR VGND sg13cmos5l_decap_8
XFILLER_33_222 VPWR VGND sg13cmos5l_decap_8
X_1061_ _1061_/X _0638_/Q _0642_/Q _1089_/X _1093_/X _0206_/Q _0205_/Q VPWR VGND sg13cmos5l_mux4_1
X_0914_ Tile_X0Y1_S4BEG[6] Tile_X0Y0_S4END[14] VPWR VGND sg13cmos5l_buf_1
X_0845_ Tile_X0Y1_FrameData_O[21] Tile_X0Y1_FrameData[21] VPWR VGND sg13cmos5l_buf_1
XFILLER_102_238 VPWR VGND sg13cmos5l_decap_8
XFILLER_52_0 VPWR VGND sg13cmos5l_decap_4
X_0776_ Tile_X0Y0_WW4BEG[9] _1056_/X VPWR VGND sg13cmos5l_buf_1
XFILLER_140_49 VPWR VGND sg13cmos5l_fill_1
XFILLER_68_152 VPWR VGND sg13cmos5l_decap_8
XANTENNA__0093__Q NPU_XBAR_SEL3 VPWR VGND sg13cmos5l_antennanp
XANTENNA__0872__X Tile_X0Y0_FrameData_O[16] VPWR VGND sg13cmos5l_antennanp
XFILLER_130_7 VPWR VGND sg13cmos5l_decap_8
XFILLER_24_222 VPWR VGND sg13cmos5l_decap_8
XFILLER_137_146 VPWR VGND sg13cmos5l_decap_8
XFILLER_3_126 VPWR VGND sg13cmos5l_decap_8
XFILLER_3_137 VPWR VGND sg13cmos5l_fill_2
XFILLER_58_77 VPWR VGND sg13cmos5l_decap_8
XANTENNA__0782__X Tile_X0Y0_WW4BEG[15] VPWR VGND sg13cmos5l_antennanp
XFILLER_30_203 VPWR VGND sg13cmos5l_decap_8
XFILLER_74_133 VPWR VGND sg13cmos5l_decap_8
XFILLER_74_21 VPWR VGND sg13cmos5l_decap_8
XFILLER_74_98 VPWR VGND sg13cmos5l_decap_8
XFILLER_128_168 VPWR VGND sg13cmos5l_decap_8
X_0630_ NPU_ACT_ADDR4 Tile_X0Y1_UserCLK _0977_/X _0687_/L_HI VPWR VGND sg13cmos5l_dfrbpq_1
X_0561_ _0561_/Q Tile_X0Y1_FrameData[9] VGND VPWR Tile_X0Y1_FrameStrobe[6] latch
X_0492_ _0492_/Q Tile_X0Y1_FrameData[14] VGND VPWR Tile_X0Y1_FrameStrobe[4] latch
XFILLER_97_258 VPWR VGND sg13cmos5l_decap_8
XANTENNA__0957__X Tile_X0Y1_WW4BEG[0] VPWR VGND sg13cmos5l_antennanp
XFILLER_0_51 VPWR VGND sg13cmos5l_decap_4
XFILLER_65_177 VPWR VGND sg13cmos5l_decap_8
X_1044_ _1044_/X Tile_X0Y0_EE4END[12] _0641_/Q _1094_/X _1097_/X _0240_/Q _0239_/Q
+ VPWR VGND sg13cmos5l_mux4_1
X_1113_ _1113_/X Tile_X0Y1_E1END[2] Tile_X0Y1_E6END[6] _1217_/X _1193_/X _0598_/Q
+ _0597_/Q VPWR VGND sg13cmos5l_mux4_1
XFILLER_80_136 VPWR VGND sg13cmos5l_decap_8
XFILLER_9_60 VPWR VGND sg13cmos5l_decap_8
XFILLER_134_105 VPWR VGND sg13cmos5l_decap_8
X_0828_ Tile_X0Y1_FrameData_O[4] Tile_X0Y1_FrameData[4] VPWR VGND sg13cmos5l_buf_1
X_0759_ Tile_X0Y0_N4BEG[8] _0759_/A VPWR VGND sg13cmos5l_buf_1
XANTENNA__0867__X Tile_X0Y0_FrameData_O[11] VPWR VGND sg13cmos5l_antennanp
XFILLER_135_49 VPWR VGND sg13cmos5l_decap_8
XFILLER_88_214 VPWR VGND sg13cmos5l_decap_8
XFILLER_44_68 VPWR VGND sg13cmos5l_fill_1
XFILLER_56_133 VPWR VGND sg13cmos5l_decap_8
XFILLER_71_147 VPWR VGND sg13cmos5l_decap_8
XFILLER_100_41 VPWR VGND sg13cmos5l_fill_2
XFILLER_12_214 VPWR VGND sg13cmos5l_decap_8
XFILLER_60_56 VPWR VGND sg13cmos5l_decap_8
XFILLER_8_229 VPWR VGND sg13cmos5l_decap_8
XFILLER_133_171 VPWR VGND sg13cmos5l_decap_8
XFILLER_69_21 VPWR VGND sg13cmos5l_decap_8
XFILLER_79_214 VPWR VGND sg13cmos5l_decap_8
XANTENNA__0777__X Tile_X0Y0_WW4BEG[10] VPWR VGND sg13cmos5l_antennanp
XFILLER_125_71 VPWR VGND sg13cmos5l_decap_8
XFILLER_47_166 VPWR VGND sg13cmos5l_decap_8
XFILLER_85_31 VPWR VGND sg13cmos5l_fill_2
XFILLER_141_70 VPWR VGND sg13cmos5l_decap_8
XFILLER_141_81 VPWR VGND sg13cmos5l_fill_2
XFILLER_62_147 VPWR VGND sg13cmos5l_decap_8
XFILLER_116_127 VPWR VGND sg13cmos5l_decap_8
XFILLER_7_240 VPWR VGND sg13cmos5l_decap_8
X_0613_ NPU_WEIGHT_IN3 Tile_X0Y1_UserCLK _0993_/X _0694_/L_HI VPWR VGND sg13cmos5l_dfrbpq_1
XFILLER_124_182 VPWR VGND sg13cmos5l_decap_8
XFILLER_131_119 VPWR VGND sg13cmos5l_decap_8
X_0544_ _0544_/Q Tile_X0Y1_FrameData[26] VGND VPWR Tile_X0Y1_FrameStrobe[6] latch
X_0475_ _0475_/Q Tile_X0Y1_FrameData[31] VGND VPWR Tile_X0Y1_FrameStrobe[4] latch
XFILLER_15_0 VPWR VGND sg13cmos5l_fill_1
XFILLER_38_166 VPWR VGND sg13cmos5l_decap_8
XFILLER_53_136 VPWR VGND sg13cmos5l_decap_8
X_1027_ _1027_/X _1111_/X Tile_X0Y0_S1END[0] _0638_/Q _0643_/Q _0274_/Q _0273_/Q VPWR
+ VGND sg13cmos5l_mux4_1
XFILLER_93_272 VPWR VGND sg13cmos5l_fill_1
XFILLER_14_49 VPWR VGND sg13cmos5l_fill_2
XFILLER_130_196 VPWR VGND sg13cmos5l_decap_8
XFILLER_29_133 VPWR VGND sg13cmos5l_decap_8
XFILLER_76_217 VPWR VGND sg13cmos5l_decap_8
XFILLER_91_209 VPWR VGND sg13cmos5l_decap_8
XFILLER_29_199 VPWR VGND sg13cmos5l_decap_8
XFILLER_44_125 VPWR VGND sg13cmos5l_fill_2
XFILLER_55_56 VPWR VGND sg13cmos5l_decap_4
XFILLER_138_252 VPWR VGND sg13cmos5l_decap_8
XFILLER_71_77 VPWR VGND sg13cmos5l_decap_8
XFILLER_121_185 VPWR VGND sg13cmos5l_decap_8
XFILLER_136_70 VPWR VGND sg13cmos5l_decap_8
X_0260_ _0260_/Q Tile_X0Y0_FrameData[24] VGND VPWR Tile_X0Y1_FrameStrobe[5] latch
XFILLER_96_85 VPWR VGND sg13cmos5l_fill_1
X_0191_ _0191_/Q Tile_X0Y0_FrameData[29] VGND VPWR Tile_X0Y1_FrameStrobe[3] latch
XFILLER_90_253 VPWR VGND sg13cmos5l_decap_8
XANTENNA__0970__X Tile_X0Y1_WW4BEG[13] VPWR VGND sg13cmos5l_antennanp
XFILLER_43_180 VPWR VGND sg13cmos5l_decap_8
XFILLER_91_4 VPWR VGND sg13cmos5l_fill_2
XFILLER_132_28 VPWR VGND sg13cmos5l_decap_8
XFILLER_66_272 VPWR VGND sg13cmos5l_fill_1
X_0527_ _0527_/Q Tile_X0Y1_FrameData[11] VGND VPWR Tile_X0Y1_FrameStrobe[5] latch
X_0458_ _0458_/Q Tile_X0Y1_FrameData[16] VGND VPWR Tile_X0Y1_FrameStrobe[3] latch
X_0389_ _0389_/Q Tile_X0Y1_FrameData[21] VGND VPWR Tile_X0Y1_FrameStrobe[1] latch
XFILLER_25_59 VPWR VGND sg13cmos5l_decap_4
XFILLER_81_253 VPWR VGND sg13cmos5l_decap_8
XFILLER_81_264 VPWR VGND sg13cmos5l_fill_1
XANTENNA__0880__X Tile_X0Y0_FrameData_O[24] VPWR VGND sg13cmos5l_antennanp
XFILLER_135_233 VPWR VGND sg13cmos5l_decap_8
XFILLER_106_62 VPWR VGND sg13cmos5l_fill_2
XFILLER_1_213 VPWR VGND sg13cmos5l_decap_8
XFILLER_66_77 VPWR VGND sg13cmos5l_decap_8
XFILLER_72_231 VPWR VGND sg13cmos5l_decap_8
XANTENNA__0790__X Tile_X0Y0_N2BEGb[7] VPWR VGND sg13cmos5l_antennanp
XFILLER_82_43 VPWR VGND sg13cmos5l_fill_1
XFILLER_126_233 VPWR VGND sg13cmos5l_decap_8
XFILLER_141_236 VPWR VGND sg13cmos5l_fill_2
XFILLER_56_7 VPWR VGND sg13cmos5l_decap_8
XFILLER_99_139 VPWR VGND sg13cmos5l_fill_2
XANTENNA__0965__X Tile_X0Y1_WW4BEG[8] VPWR VGND sg13cmos5l_antennanp
X_0312_ _0312_/Q Tile_X0Y0_FrameData[4] VGND VPWR Tile_X0Y1_FrameStrobe[6] latch
X_0243_ _0243_/Q Tile_X0Y0_FrameData[9] VGND VPWR Tile_X0Y1_FrameStrobe[4] latch
XFILLER_23_106 VPWR VGND sg13cmos5l_fill_1
XFILLER_48_272 VPWR VGND sg13cmos5l_fill_1
X_0174_ _0174_/Q Tile_X0Y0_FrameData[14] VGND VPWR Tile_X0Y1_FrameStrobe[2] latch
XFILLER_117_222 VPWR VGND sg13cmos5l_decap_8
XFILLER_100_100 VPWR VGND sg13cmos5l_decap_8
XFILLER_127_28 VPWR VGND sg13cmos5l_decap_8
XFILLER_132_203 VPWR VGND sg13cmos5l_decap_8
XANTENNA__0875__X Tile_X0Y0_FrameData_O[19] VPWR VGND sg13cmos5l_antennanp
XFILLER_100_199 VPWR VGND sg13cmos5l_decap_8
XFILLER_54_220 VPWR VGND sg13cmos5l_decap_8
XFILLER_54_231 VPWR VGND sg13cmos5l_fill_2
XFILLER_52_79 VPWR VGND sg13cmos5l_fill_1
XFILLER_54_264 VPWR VGND sg13cmos5l_fill_1
XFILLER_108_266 VPWR VGND sg13cmos5l_decap_8
XANTENNA__0785__X Tile_X0Y0_N2BEGb[2] VPWR VGND sg13cmos5l_antennanp
XFILLER_117_61 VPWR VGND sg13cmos5l_decap_4
XFILLER_123_247 VPWR VGND sg13cmos5l_decap_8
XFILLER_89_172 VPWR VGND sg13cmos5l_decap_8
XFILLER_45_231 VPWR VGND sg13cmos5l_decap_8
XFILLER_60_234 VPWR VGND sg13cmos5l_decap_8
XFILLER_93_75 VPWR VGND sg13cmos5l_fill_2
X_0861_ Tile_X0Y0_FrameData_O[5] Tile_X0Y0_FrameData[5] VPWR VGND sg13cmos5l_buf_1
X_0930_ Tile_X0Y1_W2BEG[1] _1148_/X VPWR VGND sg13cmos5l_buf_1
X_0792_ Tile_X0Y0_N2BEG[1] _1004_/X VPWR VGND sg13cmos5l_buf_1
XFILLER_9_198 VPWR VGND sg13cmos5l_decap_8
XFILLER_36_220 VPWR VGND sg13cmos5l_decap_8
XFILLER_3_84 VPWR VGND sg13cmos5l_decap_8
X_0226_ _0226_/Q Tile_X0Y0_FrameData[26] VGND VPWR Tile_X0Y1_FrameStrobe[4] latch
XFILLER_95_197 VPWR VGND sg13cmos5l_decap_8
XFILLER_95_175 VPWR VGND sg13cmos5l_decap_4
XFILLER_51_201 VPWR VGND sg13cmos5l_decap_8
X_0157_ _0157_/Q Tile_X0Y0_FrameData[31] VGND VPWR Tile_X0Y1_FrameStrobe[2] latch
X_0088_ _0093_/D _0998_/X _0609_/Q VPWR VGND sg13cmos5l_or2_1
XFILLER_105_214 VPWR VGND sg13cmos5l_decap_8
XFILLER_138_49 VPWR VGND sg13cmos5l_decap_8
XFILLER_86_120 VPWR VGND sg13cmos5l_decap_8
XFILLER_103_41 VPWR VGND sg13cmos5l_fill_2
XFILLER_103_85 VPWR VGND sg13cmos5l_fill_2
XFILLER_27_253 VPWR VGND sg13cmos5l_decap_8
XFILLER_42_201 VPWR VGND sg13cmos5l_decap_8
XFILLER_47_68 VPWR VGND sg13cmos5l_decap_4
XFILLER_63_56 VPWR VGND sg13cmos5l_decap_8
XFILLER_86_197 VPWR VGND sg13cmos5l_decap_8
XFILLER_10_153 VPWR VGND sg13cmos5l_decap_8
XFILLER_42_256 VPWR VGND sg13cmos5l_decap_8
XFILLER_8_18 VPWR VGND sg13cmos5l_fill_1
XFILLER_6_168 VPWR VGND sg13cmos5l_decap_8
XFILLER_88_97 VPWR VGND sg13cmos5l_decap_8
XFILLER_111_239 VPWR VGND sg13cmos5l_decap_8
XFILLER_18_231 VPWR VGND sg13cmos5l_decap_8
XFILLER_77_164 VPWR VGND sg13cmos5l_decap_8
X_1060_ _1060_/X _0637_/Q _0641_/Q _1090_/X _1094_/X _0208_/Q _0207_/Q VPWR VGND sg13cmos5l_mux4_1
XFILLER_92_167 VPWR VGND sg13cmos5l_decap_8
XFILLER_33_201 VPWR VGND sg13cmos5l_decap_8
XFILLER_33_245 VPWR VGND sg13cmos5l_fill_1
XFILLER_108_19 VPWR VGND sg13cmos5l_decap_8
X_0913_ Tile_X0Y1_S4BEG[5] Tile_X0Y0_S4END[13] VPWR VGND sg13cmos5l_buf_1
X_0844_ Tile_X0Y1_FrameData_O[20] Tile_X0Y1_FrameData[20] VPWR VGND sg13cmos5l_buf_1
X_0775_ Tile_X0Y0_WW4BEG[8] _1055_/X VPWR VGND sg13cmos5l_buf_1
XFILLER_102_217 VPWR VGND sg13cmos5l_decap_8
XFILLER_124_29 VPWR VGND sg13cmos5l_decap_8
XFILLER_68_131 VPWR VGND sg13cmos5l_decap_8
XFILLER_140_17 VPWR VGND sg13cmos5l_decap_8
XFILLER_24_201 VPWR VGND sg13cmos5l_decap_8
XFILLER_83_112 VPWR VGND sg13cmos5l_fill_2
XFILLER_83_156 VPWR VGND sg13cmos5l_decap_4
X_1189_ _1189_/X _0646_/Q _1204_/X _1208_/X _1201_/X _0438_/Q _0437_/Q VPWR VGND sg13cmos5l_mux4_1
X_0209_ _0209_/Q Tile_X0Y0_FrameData[11] VGND VPWR Tile_X0Y1_FrameStrobe[3] latch
XFILLER_3_105 VPWR VGND sg13cmos5l_decap_8
XFILLER_101_250 VPWR VGND sg13cmos5l_decap_8
XFILLER_101_272 VPWR VGND sg13cmos5l_fill_1
XFILLER_58_56 VPWR VGND sg13cmos5l_decap_8
XFILLER_59_197 VPWR VGND sg13cmos5l_decap_8
XFILLER_74_112 VPWR VGND sg13cmos5l_decap_8
XFILLER_15_223 VPWR VGND sg13cmos5l_decap_8
XFILLER_74_189 VPWR VGND sg13cmos5l_decap_8
XFILLER_74_77 VPWR VGND sg13cmos5l_decap_8
XFILLER_128_147 VPWR VGND sg13cmos5l_decap_8
XFILLER_139_81 VPWR VGND sg13cmos5l_decap_8
XFILLER_30_259 VPWR VGND sg13cmos5l_decap_8
XFILLER_2_193 VPWR VGND sg13cmos5l_decap_4
X_0560_ _0560_/Q Tile_X0Y1_FrameData[10] VGND VPWR Tile_X0Y1_FrameStrobe[6] latch
X_0491_ _0491_/Q Tile_X0Y1_FrameData[15] VGND VPWR Tile_X0Y1_FrameStrobe[4] latch
XFILLER_97_237 VPWR VGND sg13cmos5l_decap_8
XFILLER_0_96 VPWR VGND sg13cmos5l_fill_2
XFILLER_65_112 VPWR VGND sg13cmos5l_decap_8
XFILLER_65_156 VPWR VGND sg13cmos5l_decap_8
X_1043_ _1043_/X Tile_X0Y0_EE4END[11] _0640_/Q _1095_/X _1096_/X _0242_/Q _0241_/Q
+ VPWR VGND sg13cmos5l_mux4_1
X_1112_ _1112_/X Tile_X0Y1_E1END[1] Tile_X0Y1_E6END[5] _1216_/X _1192_/X _0600_/Q
+ _0599_/Q VPWR VGND sg13cmos5l_mux4_1
XFILLER_21_248 VPWR VGND sg13cmos5l_decap_8
XFILLER_119_29 VPWR VGND sg13cmos5l_fill_1
XFILLER_127_191 VPWR VGND sg13cmos5l_decap_8
XFILLER_135_28 VPWR VGND sg13cmos5l_decap_8
X_0827_ Tile_X0Y1_FrameData_O[3] Tile_X0Y1_FrameData[3] VPWR VGND sg13cmos5l_buf_1
X_0758_ Tile_X0Y0_N4BEG[7] Tile_X0Y1_N4END[15] VPWR VGND sg13cmos5l_buf_1
XFILLER_56_112 VPWR VGND sg13cmos5l_decap_8
X_0689_ _0689_/L_HI VPWR VGND sg13cmos5l_tiehi
XANTENNA__0883__X Tile_X0Y0_FrameData_O[27] VPWR VGND sg13cmos5l_antennanp
XFILLER_44_47 VPWR VGND sg13cmos5l_decap_4
XFILLER_44_58 VPWR VGND sg13cmos5l_fill_1
XFILLER_56_189 VPWR VGND sg13cmos5l_decap_8
XFILLER_71_126 VPWR VGND sg13cmos5l_fill_2
XFILLER_100_75 VPWR VGND sg13cmos5l_fill_2
XFILLER_20_270 VPWR VGND sg13cmos5l_fill_2
XFILLER_60_35 VPWR VGND sg13cmos5l_decap_8
XFILLER_8_208 VPWR VGND sg13cmos5l_decap_8
XFILLER_118_180 VPWR VGND sg13cmos5l_decap_8
XFILLER_125_50 VPWR VGND sg13cmos5l_decap_8
XFILLER_140_109 VPWR VGND sg13cmos5l_decap_8
XANTENNA__0793__X Tile_X0Y0_N2BEG[2] VPWR VGND sg13cmos5l_antennanp
XFILLER_47_145 VPWR VGND sg13cmos5l_decap_8
XFILLER_62_126 VPWR VGND sg13cmos5l_decap_8
XANTENNA__0968__X Tile_X0Y1_WW4BEG[11] VPWR VGND sg13cmos5l_antennanp
XFILLER_124_161 VPWR VGND sg13cmos5l_decap_8
X_0612_ NPU_WEIGHT_IN2 Tile_X0Y1_UserCLK _0992_/X _0695_/L_HI VPWR VGND sg13cmos5l_dfrbpq_1
X_0543_ _0543_/Q Tile_X0Y1_FrameData[27] VGND VPWR Tile_X0Y1_FrameStrobe[6] latch
X_0474_ _0474_/Q Tile_X0Y1_FrameData[0] VGND VPWR Tile_X0Y1_FrameStrobe[3] latch
XFILLER_53_115 VPWR VGND sg13cmos5l_decap_8
X_1026_ _1026_/X _1084_/X _1080_/X _1079_/X _1099_/X _0277_/Q _0276_/Q VPWR VGND sg13cmos5l_mux4_1
XFILLER_107_128 VPWR VGND sg13cmos5l_decap_4
XANTENNA__0878__X Tile_X0Y0_FrameData_O[22] VPWR VGND sg13cmos5l_antennanp
XFILLER_115_161 VPWR VGND sg13cmos5l_decap_4
XFILLER_115_183 VPWR VGND sg13cmos5l_decap_8
XFILLER_39_47 VPWR VGND sg13cmos5l_decap_8
XFILLER_130_175 VPWR VGND sg13cmos5l_decap_8
XFILLER_29_112 VPWR VGND sg13cmos5l_fill_2
XFILLER_29_178 VPWR VGND sg13cmos5l_decap_8
XFILLER_55_35 VPWR VGND sg13cmos5l_decap_8
XFILLER_84_262 VPWR VGND sg13cmos5l_decap_8
XFILLER_52_192 VPWR VGND sg13cmos5l_fill_2
XFILLER_71_56 VPWR VGND sg13cmos5l_decap_8
XFILLER_112_0 VPWR VGND sg13cmos5l_fill_2
XFILLER_138_231 VPWR VGND sg13cmos5l_decap_8
XFILLER_4_244 VPWR VGND sg13cmos5l_decap_8
XFILLER_4_255 VPWR VGND sg13cmos5l_fill_2
XANTENNA__0788__X Tile_X0Y0_N2BEGb[5] VPWR VGND sg13cmos5l_antennanp
XFILLER_121_120 VPWR VGND sg13cmos5l_decap_8
XFILLER_121_164 VPWR VGND sg13cmos5l_decap_8
XFILLER_45_90 VPWR VGND sg13cmos5l_fill_1
X_0190_ _0190_/Q Tile_X0Y0_FrameData[30] VGND VPWR Tile_X0Y1_FrameStrobe[3] latch
XFILLER_90_232 VPWR VGND sg13cmos5l_decap_8
XFILLER_129_253 VPWR VGND sg13cmos5l_decap_8
XFILLER_129_264 VPWR VGND sg13cmos5l_fill_1
XFILLER_84_4 VPWR VGND sg13cmos5l_fill_1
XFILLER_6_84 VPWR VGND sg13cmos5l_decap_8
X_0526_ _0526_/Q Tile_X0Y1_FrameData[12] VGND VPWR Tile_X0Y1_FrameStrobe[5] latch
X_0457_ _0457_/Q Tile_X0Y1_FrameData[17] VGND VPWR Tile_X0Y1_FrameStrobe[3] latch
X_0388_ _0388_/Q Tile_X0Y1_FrameData[22] VGND VPWR Tile_X0Y1_FrameStrobe[1] latch
XFILLER_81_232 VPWR VGND sg13cmos5l_decap_8
X_1009_ _1009_/X Tile_X0Y0_E2MID[1] Tile_X0Y0_E2END[1] Tile_X0Y0_E6END[1] _1098_/X
+ _0326_/Q _0325_/Q VPWR VGND sg13cmos5l_mux4_1
XFILLER_135_212 VPWR VGND sg13cmos5l_decap_8
XFILLER_103_164 VPWR VGND sg13cmos5l_decap_4
XFILLER_1_258 VPWR VGND sg13cmos5l_fill_2
XFILLER_17_159 VPWR VGND sg13cmos5l_decap_8
XFILLER_66_56 VPWR VGND sg13cmos5l_decap_8
XFILLER_72_210 VPWR VGND sg13cmos5l_decap_8
XFILLER_82_33 VPWR VGND sg13cmos5l_fill_1
XFILLER_25_181 VPWR VGND sg13cmos5l_decap_8
XFILLER_126_212 VPWR VGND sg13cmos5l_decap_8
XFILLER_141_215 VPWR VGND sg13cmos5l_decap_8
XFILLER_141_259 VPWR VGND sg13cmos5l_decap_8
XFILLER_48_251 VPWR VGND sg13cmos5l_decap_8
XFILLER_63_210 VPWR VGND sg13cmos5l_decap_8
X_0311_ _0311_/Q Tile_X0Y0_FrameData[5] VGND VPWR Tile_X0Y1_FrameStrobe[6] latch
X_0242_ _0242_/Q Tile_X0Y0_FrameData[10] VGND VPWR Tile_X0Y1_FrameStrobe[4] latch
X_0173_ _0173_/Q Tile_X0Y0_FrameData[15] VGND VPWR Tile_X0Y1_FrameStrobe[2] latch
XFILLER_31_140 VPWR VGND sg13cmos5l_decap_8
XFILLER_117_201 VPWR VGND sg13cmos5l_decap_8
XFILLER_31_184 VPWR VGND sg13cmos5l_decap_8
XFILLER_75_0 VPWR VGND sg13cmos5l_decap_8
XFILLER_132_259 VPWR VGND sg13cmos5l_decap_8
XFILLER_140_270 VPWR VGND sg13cmos5l_fill_2
X_0509_ _0509_/Q Tile_X0Y1_FrameData[29] VGND VPWR Tile_X0Y1_FrameStrobe[5] latch
XFILLER_98_195 VPWR VGND sg13cmos5l_decap_8
XFILLER_100_178 VPWR VGND sg13cmos5l_decap_8
XFILLER_36_37 VPWR VGND sg13cmos5l_fill_1
XANTENNA__0891__X Tile_X0Y1_S1BEG[3] VPWR VGND sg13cmos5l_antennanp
XFILLER_108_245 VPWR VGND sg13cmos5l_decap_8
XFILLER_123_226 VPWR VGND sg13cmos5l_decap_8
XFILLER_45_210 VPWR VGND sg13cmos5l_decap_8
XFILLER_77_22 VPWR VGND sg13cmos5l_decap_4
XFILLER_77_77 VPWR VGND sg13cmos5l_decap_4
XFILLER_93_32 VPWR VGND sg13cmos5l_fill_1
XFILLER_60_213 VPWR VGND sg13cmos5l_decap_8
XFILLER_60_268 VPWR VGND sg13cmos5l_decap_4
XFILLER_93_98 VPWR VGND sg13cmos5l_decap_4
X_0860_ Tile_X0Y0_FrameData_O[4] Tile_X0Y0_FrameData[4] VPWR VGND sg13cmos5l_buf_1
X_0791_ Tile_X0Y0_N2BEG[0] _1003_/X VPWR VGND sg13cmos5l_buf_1
XFILLER_9_177 VPWR VGND sg13cmos5l_decap_8
XFILLER_114_226 VPWR VGND sg13cmos5l_decap_8
XFILLER_114_259 VPWR VGND sg13cmos5l_decap_8
XFILLER_3_63 VPWR VGND sg13cmos5l_decap_8
XFILLER_36_243 VPWR VGND sg13cmos5l_fill_1
X_0225_ _0225_/Q Tile_X0Y0_FrameData[27] VGND VPWR Tile_X0Y1_FrameStrobe[4] latch
X_0156_ _0156_/Q Tile_X0Y0_FrameData[0] VGND VPWR Tile_X0Y1_FrameStrobe[1] latch
XFILLER_95_165 VPWR VGND sg13cmos5l_fill_2
XFILLER_22_28 VPWR VGND sg13cmos5l_decap_4
X_0087_ _0089_/D _0604_/Q _1235_/X VPWR VGND sg13cmos5l_nor2b_1
XFILLER_138_28 VPWR VGND sg13cmos5l_decap_8
X_0989_ _0989_/X Tile_X0Y1_EE4END[7] Tile_X0Y1_EE4END[15] Tile_X0Y1_E6END[7] _1210_/X
+ _0420_/Q _0419_/Q VPWR VGND sg13cmos5l_mux4_1
XANTENNA__0886__X Tile_X0Y0_FrameData_O[30] VPWR VGND sg13cmos5l_antennanp
XFILLER_120_229 VPWR VGND sg13cmos5l_decap_8
XFILLER_86_176 VPWR VGND sg13cmos5l_decap_8
XFILLER_27_232 VPWR VGND sg13cmos5l_decap_8
XFILLER_63_35 VPWR VGND sg13cmos5l_decap_8
XFILLER_10_132 VPWR VGND sg13cmos5l_decap_8
XFILLER_6_147 VPWR VGND sg13cmos5l_decap_8
XANTENNA__0796__X Tile_X0Y0_N2BEG[5] VPWR VGND sg13cmos5l_antennanp
XFILLER_104_270 VPWR VGND sg13cmos5l_fill_2
XFILLER_111_218 VPWR VGND sg13cmos5l_decap_8
XFILLER_5_0 VPWR VGND sg13cmos5l_decap_8
XFILLER_18_210 VPWR VGND sg13cmos5l_decap_8
XFILLER_77_143 VPWR VGND sg13cmos5l_decap_8
XFILLER_92_146 VPWR VGND sg13cmos5l_decap_8
X_0912_ Tile_X0Y1_S4BEG[4] Tile_X0Y0_S4END[12] VPWR VGND sg13cmos5l_buf_1
X_0843_ Tile_X0Y1_FrameData_O[19] Tile_X0Y1_FrameData[19] VPWR VGND sg13cmos5l_buf_1
X_0774_ Tile_X0Y0_WW4BEG[7] _1054_/X VPWR VGND sg13cmos5l_buf_1
XFILLER_38_0 VPWR VGND sg13cmos5l_fill_2
XFILLER_24_257 VPWR VGND sg13cmos5l_decap_4
XFILLER_24_268 VPWR VGND sg13cmos5l_decap_4
XFILLER_83_135 VPWR VGND sg13cmos5l_decap_8
XFILLER_83_179 VPWR VGND sg13cmos5l_decap_8
X_1188_ _1188_/X _0645_/Q _1205_/X _1209_/X _1200_/X _0440_/Q _0439_/Q VPWR VGND sg13cmos5l_mux4_1
X_0208_ _0208_/Q Tile_X0Y0_FrameData[12] VGND VPWR Tile_X0Y1_FrameStrobe[3] latch
X_0139_ _0139_/Q Tile_X0Y0_FrameData[17] VGND VPWR Tile_X0Y1_FrameStrobe[1] latch
XFILLER_137_126 VPWR VGND sg13cmos5l_decap_8
XFILLER_58_35 VPWR VGND sg13cmos5l_decap_8
XFILLER_15_202 VPWR VGND sg13cmos5l_decap_8
XFILLER_74_168 VPWR VGND sg13cmos5l_decap_8
XFILLER_74_56 VPWR VGND sg13cmos5l_decap_8
XFILLER_130_84 VPWR VGND sg13cmos5l_decap_8
XFILLER_30_238 VPWR VGND sg13cmos5l_decap_8
XFILLER_90_44 VPWR VGND sg13cmos5l_decap_4
XFILLER_128_126 VPWR VGND sg13cmos5l_decap_8
XFILLER_139_60 VPWR VGND sg13cmos5l_decap_8
XFILLER_99_53 VPWR VGND sg13cmos5l_decap_4
XFILLER_90_99 VPWR VGND sg13cmos5l_fill_2
XFILLER_2_172 VPWR VGND sg13cmos5l_decap_8
X_0490_ _0490_/Q Tile_X0Y1_FrameData[16] VGND VPWR Tile_X0Y1_FrameStrobe[4] latch
XFILLER_97_216 VPWR VGND sg13cmos5l_decap_8
XFILLER_65_135 VPWR VGND sg13cmos5l_decap_8
X_1042_ _1042_/X Tile_X0Y0_EE4END[10] _0639_/Q _1095_/X _1096_/X _0244_/Q _0243_/Q
+ VPWR VGND sg13cmos5l_mux4_1
X_1111_ _1111_/X Tile_X0Y1_E1END[0] Tile_X0Y1_E6END[4] _1215_/X _1191_/X _0602_/Q
+ _0601_/Q VPWR VGND sg13cmos5l_mux4_1
XFILLER_119_115 VPWR VGND sg13cmos5l_fill_1
XFILLER_119_126 VPWR VGND sg13cmos5l_fill_1
XFILLER_119_159 VPWR VGND sg13cmos5l_decap_8
XFILLER_21_227 VPWR VGND sg13cmos5l_decap_8
XFILLER_9_95 VPWR VGND sg13cmos5l_decap_8
XFILLER_127_170 VPWR VGND sg13cmos5l_decap_8
XFILLER_88_249 VPWR VGND sg13cmos5l_decap_8
X_0826_ Tile_X0Y1_FrameData_O[2] Tile_X0Y1_FrameData[2] VPWR VGND sg13cmos5l_buf_1
X_0757_ Tile_X0Y0_N4BEG[6] Tile_X0Y1_N4END[14] VPWR VGND sg13cmos5l_buf_1
X_0688_ _0688_/L_HI VPWR VGND sg13cmos5l_tiehi
XFILLER_56_168 VPWR VGND sg13cmos5l_decap_8
XFILLER_71_105 VPWR VGND sg13cmos5l_decap_8
XFILLER_96_271 VPWR VGND sg13cmos5l_fill_2
XFILLER_96_260 VPWR VGND sg13cmos5l_decap_8
XFILLER_100_43 VPWR VGND sg13cmos5l_fill_1
XFILLER_12_249 VPWR VGND sg13cmos5l_decap_8
XFILLER_125_129 VPWR VGND sg13cmos5l_decap_8
XFILLER_60_14 VPWR VGND sg13cmos5l_decap_8
XFILLER_133_140 VPWR VGND sg13cmos5l_decap_8
XFILLER_133_151 VPWR VGND sg13cmos5l_fill_2
XFILLER_79_249 VPWR VGND sg13cmos5l_decap_8
XFILLER_62_105 VPWR VGND sg13cmos5l_decap_8
XFILLER_11_260 VPWR VGND sg13cmos5l_decap_4
XFILLER_70_182 VPWR VGND sg13cmos5l_decap_8
XFILLER_93_9 VPWR VGND sg13cmos5l_decap_4
XFILLER_124_140 VPWR VGND sg13cmos5l_decap_8
XFILLER_50_80 VPWR VGND sg13cmos5l_fill_1
X_0611_ NPU_WEIGHT_IN1 Tile_X0Y1_UserCLK _0991_/X _0696_/L_HI VPWR VGND sg13cmos5l_dfrbpq_1
X_0542_ _0542_/Q Tile_X0Y1_FrameData[28] VGND VPWR Tile_X0Y1_FrameStrobe[6] latch
X_0473_ _0473_/Q Tile_X0Y1_FrameData[1] VGND VPWR Tile_X0Y1_FrameStrobe[3] latch
XFILLER_93_263 VPWR VGND sg13cmos5l_decap_8
XFILLER_46_190 VPWR VGND sg13cmos5l_decap_8
XFILLER_61_160 VPWR VGND sg13cmos5l_decap_4
XFILLER_61_182 VPWR VGND sg13cmos5l_decap_8
X_1025_ _1025_/X Tile_X0Y0_E1END[3] Tile_X0Y0_EE4END[15] Tile_X0Y0_E6END[7] _1091_/X
+ _0277_/Q _0276_/Q VPWR VGND sg13cmos5l_mux4_1
X_0809_ Tile_X0Y0_FrameStrobe_O[6] Tile_X0Y1_FrameStrobe[6] VPWR VGND sg13cmos5l_buf_1
XFILLER_115_140 VPWR VGND sg13cmos5l_decap_8
XFILLER_130_154 VPWR VGND sg13cmos5l_decap_8
XANTENNA__0894__X Tile_X0Y1_S2BEG[2] VPWR VGND sg13cmos5l_antennanp
XFILLER_44_105 VPWR VGND sg13cmos5l_decap_4
XFILLER_44_127 VPWR VGND sg13cmos5l_fill_1
XFILLER_55_14 VPWR VGND sg13cmos5l_decap_8
XFILLER_84_241 VPWR VGND sg13cmos5l_decap_8
XFILLER_138_210 VPWR VGND sg13cmos5l_decap_8
XFILLER_52_171 VPWR VGND sg13cmos5l_decap_8
XFILLER_71_35 VPWR VGND sg13cmos5l_decap_8
XFILLER_4_223 VPWR VGND sg13cmos5l_decap_8
XFILLER_106_195 VPWR VGND sg13cmos5l_decap_8
XFILLER_121_143 VPWR VGND sg13cmos5l_decap_8
XFILLER_29_70 VPWR VGND sg13cmos5l_decap_8
XFILLER_67_219 VPWR VGND sg13cmos5l_decap_4
XFILLER_75_252 VPWR VGND sg13cmos5l_decap_8
XFILLER_35_127 VPWR VGND sg13cmos5l_fill_1
XFILLER_90_211 VPWR VGND sg13cmos5l_decap_8
XANTENNA_1 NPU_OUT_ACT4 VPWR VGND sg13cmos5l_antennanp
XFILLER_129_232 VPWR VGND sg13cmos5l_decap_8
XFILLER_112_154 VPWR VGND sg13cmos5l_fill_1
XFILLER_58_219 VPWR VGND sg13cmos5l_decap_4
XFILLER_6_63 VPWR VGND sg13cmos5l_decap_8
X_0525_ _0525_/Q Tile_X0Y1_FrameData[13] VGND VPWR Tile_X0Y1_FrameStrobe[5] latch
X_0456_ _0456_/Q Tile_X0Y1_FrameData[18] VGND VPWR Tile_X0Y1_FrameStrobe[3] latch
XFILLER_112_187 VPWR VGND sg13cmos5l_decap_8
XFILLER_26_105 VPWR VGND sg13cmos5l_decap_8
XFILLER_81_211 VPWR VGND sg13cmos5l_decap_8
X_0387_ _0387_/Q Tile_X0Y1_FrameData[23] VGND VPWR Tile_X0Y1_FrameStrobe[1] latch
XFILLER_25_39 VPWR VGND sg13cmos5l_decap_4
XFILLER_41_108 VPWR VGND sg13cmos5l_decap_8
X_1008_ _1008_/X Tile_X0Y0_E2MID[2] Tile_X0Y0_E2END[2] Tile_X0Y0_E6END[2] _1097_/X
+ _0328_/Q _0327_/Q VPWR VGND sg13cmos5l_mux4_1
XANTENNA__0889__X Tile_X0Y1_S1BEG[1] VPWR VGND sg13cmos5l_antennanp
XFILLER_135_268 VPWR VGND sg13cmos5l_decap_4
XFILLER_9_7 VPWR VGND sg13cmos5l_fill_2
XFILLER_103_187 VPWR VGND sg13cmos5l_decap_8
XFILLER_106_64 VPWR VGND sg13cmos5l_fill_1
XFILLER_106_75 VPWR VGND sg13cmos5l_decap_8
XFILLER_106_97 VPWR VGND sg13cmos5l_fill_2
XFILLER_49_219 VPWR VGND sg13cmos5l_decap_8
XFILLER_66_35 VPWR VGND sg13cmos5l_decap_8
XFILLER_15_50 VPWR VGND sg13cmos5l_fill_1
XFILLER_25_160 VPWR VGND sg13cmos5l_decap_8
XFILLER_32_119 VPWR VGND sg13cmos5l_decap_8
XFILLER_72_266 VPWR VGND sg13cmos5l_decap_8
XANTENNA__0799__X Tile_X0Y0_N1BEG[0] VPWR VGND sg13cmos5l_antennanp
XFILLER_126_268 VPWR VGND sg13cmos5l_decap_4
XFILLER_141_238 VPWR VGND sg13cmos5l_fill_1
X_0310_ _0310_/Q Tile_X0Y0_FrameData[6] VGND VPWR Tile_X0Y1_FrameStrobe[6] latch
XFILLER_48_230 VPWR VGND sg13cmos5l_decap_8
X_0241_ _0241_/Q Tile_X0Y0_FrameData[11] VGND VPWR Tile_X0Y1_FrameStrobe[4] latch
X_0172_ _0172_/Q Tile_X0Y0_FrameData[16] VGND VPWR Tile_X0Y1_FrameStrobe[2] latch
XFILLER_16_182 VPWR VGND sg13cmos5l_decap_8
XFILLER_31_163 VPWR VGND sg13cmos5l_decap_8
XFILLER_117_257 VPWR VGND sg13cmos5l_decap_8
XFILLER_117_268 VPWR VGND sg13cmos5l_decap_4
XFILLER_68_0 VPWR VGND sg13cmos5l_decap_8
XFILLER_100_124 VPWR VGND sg13cmos5l_decap_4
XFILLER_132_238 VPWR VGND sg13cmos5l_decap_8
X_0508_ _0508_/Q Tile_X0Y1_FrameData[30] VGND VPWR Tile_X0Y1_FrameStrobe[5] latch
X_0439_ _0439_/Q Tile_X0Y1_FrameData[3] VGND VPWR Tile_X0Y1_FrameStrobe[2] latch
XFILLER_14_119 VPWR VGND sg13cmos5l_decap_8
XFILLER_52_15 VPWR VGND sg13cmos5l_fill_2
XFILLER_108_224 VPWR VGND sg13cmos5l_decap_8
XFILLER_22_141 VPWR VGND sg13cmos5l_fill_2
XFILLER_22_185 VPWR VGND sg13cmos5l_decap_8
XFILLER_117_41 VPWR VGND sg13cmos5l_fill_2
XFILLER_123_205 VPWR VGND sg13cmos5l_decap_8
XFILLER_133_84 VPWR VGND sg13cmos5l_decap_8
XFILLER_77_56 VPWR VGND sg13cmos5l_decap_8
XFILLER_13_141 VPWR VGND sg13cmos5l_fill_2
XFILLER_13_152 VPWR VGND sg13cmos5l_decap_8
XFILLER_9_123 VPWR VGND sg13cmos5l_fill_1
XFILLER_114_205 VPWR VGND sg13cmos5l_decap_8
XFILLER_13_196 VPWR VGND sg13cmos5l_decap_8
XFILLER_61_7 VPWR VGND sg13cmos5l_decap_8
X_0790_ Tile_X0Y0_N2BEGb[7] _1110_/X VPWR VGND sg13cmos5l_buf_1
XFILLER_9_156 VPWR VGND sg13cmos5l_decap_8
XFILLER_114_238 VPWR VGND sg13cmos5l_decap_8
XFILLER_122_260 VPWR VGND sg13cmos5l_decap_8
XFILLER_122_271 VPWR VGND sg13cmos5l_fill_2
XFILLER_3_42 VPWR VGND sg13cmos5l_decap_8
X_0224_ _0224_/Q Tile_X0Y0_FrameData[28] VGND VPWR Tile_X0Y1_FrameStrobe[4] latch
X_0155_ _0155_/Q Tile_X0Y0_FrameData[1] VGND VPWR Tile_X0Y1_FrameStrobe[1] latch
X_0086_ _0917_/A _1021_/X _1022_/X _0281_/Q VPWR VGND sg13cmos5l_mux2_1
X_0988_ _0988_/X Tile_X0Y1_EE4END[6] Tile_X0Y1_EE4END[14] Tile_X0Y1_E6END[6] _1209_/X
+ _0422_/Q _0421_/Q VPWR VGND sg13cmos5l_mux4_1
XFILLER_105_249 VPWR VGND sg13cmos5l_decap_8
XFILLER_120_208 VPWR VGND sg13cmos5l_decap_8
XFILLER_27_211 VPWR VGND sg13cmos5l_decap_8
XFILLER_86_155 VPWR VGND sg13cmos5l_decap_8
XFILLER_42_236 VPWR VGND sg13cmos5l_decap_8
XFILLER_63_14 VPWR VGND sg13cmos5l_decap_8
XFILLER_10_188 VPWR VGND sg13cmos5l_decap_8
XFILLER_12_73 VPWR VGND sg13cmos5l_decap_8
XFILLER_6_126 VPWR VGND sg13cmos5l_decap_8
XFILLER_128_84 VPWR VGND sg13cmos5l_decap_8
XFILLER_77_122 VPWR VGND sg13cmos5l_decap_8
XFILLER_33_236 VPWR VGND sg13cmos5l_decap_8
XFILLER_37_92 VPWR VGND sg13cmos5l_fill_1
XFILLER_77_199 VPWR VGND sg13cmos5l_decap_8
X_0911_ Tile_X0Y1_S4BEG[3] Tile_X0Y0_S4END[11] VPWR VGND sg13cmos5l_buf_1
X_0842_ Tile_X0Y1_FrameData_O[18] Tile_X0Y1_FrameData[18] VPWR VGND sg13cmos5l_buf_1
XFILLER_139_190 VPWR VGND sg13cmos5l_decap_8
XFILLER_5_170 VPWR VGND sg13cmos5l_decap_8
X_0773_ Tile_X0Y0_WW4BEG[6] _1053_/X VPWR VGND sg13cmos5l_buf_1
XFILLER_110_252 VPWR VGND sg13cmos5l_decap_8
XFILLER_68_166 VPWR VGND sg13cmos5l_decap_8
XFILLER_68_188 VPWR VGND sg13cmos5l_decap_8
XFILLER_24_236 VPWR VGND sg13cmos5l_decap_8
X_1187_ _1187_/X _0644_/Q _1206_/X _1210_/X _1199_/X _0442_/Q _0441_/Q VPWR VGND sg13cmos5l_mux4_1
X_0207_ _0207_/Q Tile_X0Y0_FrameData[13] VGND VPWR Tile_X0Y1_FrameStrobe[3] latch
X_0138_ _0138_/Q Tile_X0Y0_FrameData[18] VGND VPWR Tile_X0Y1_FrameStrobe[1] latch
X_0069_ _0919_/A _1025_/X _1026_/X _0275_/Q VPWR VGND sg13cmos5l_mux2_1
XFILLER_137_105 VPWR VGND sg13cmos5l_decap_8
XANTENNA__0897__X Tile_X0Y1_S2BEG[5] VPWR VGND sg13cmos5l_antennanp
XFILLER_101_230 VPWR VGND sg13cmos5l_decap_8
XFILLER_58_14 VPWR VGND sg13cmos5l_decap_8
XFILLER_59_133 VPWR VGND sg13cmos5l_decap_8
XFILLER_114_31 VPWR VGND sg13cmos5l_fill_1
XFILLER_74_147 VPWR VGND sg13cmos5l_decap_8
XFILLER_74_35 VPWR VGND sg13cmos5l_decap_8
XFILLER_128_105 VPWR VGND sg13cmos5l_decap_8
XFILLER_130_63 VPWR VGND sg13cmos5l_decap_8
XFILLER_135_0 VPWR VGND sg13cmos5l_decap_8
XFILLER_23_72 VPWR VGND sg13cmos5l_decap_8
XFILLER_30_217 VPWR VGND sg13cmos5l_decap_8
XFILLER_90_56 VPWR VGND sg13cmos5l_decap_4
XFILLER_136_182 VPWR VGND sg13cmos5l_decap_8
XFILLER_2_151 VPWR VGND sg13cmos5l_decap_8
X_1110_ _1110_/X Tile_X0Y1_E2MID[0] Tile_X0Y1_E2END[0] Tile_X0Y1_E6END[0] _1202_/X
+ _0580_/Q _0579_/Q VPWR VGND sg13cmos5l_mux4_1
XFILLER_0_21 VPWR VGND sg13cmos5l_decap_8
XFILLER_21_206 VPWR VGND sg13cmos5l_decap_8
X_1041_ _1041_/X Tile_X0Y0_EE4END[9] _0638_/Q _1094_/X _1097_/X _0246_/Q _0245_/Q
+ VPWR VGND sg13cmos5l_mux4_1
XFILLER_9_30 VPWR VGND sg13cmos5l_fill_1
XFILLER_119_138 VPWR VGND sg13cmos5l_decap_8
XFILLER_134_119 VPWR VGND sg13cmos5l_decap_8
X_0825_ Tile_X0Y1_FrameData_O[1] Tile_X0Y1_FrameData[1] VPWR VGND sg13cmos5l_buf_1
XFILLER_9_74 VPWR VGND sg13cmos5l_decap_8
XFILLER_9_52 VPWR VGND sg13cmos5l_fill_1
XFILLER_50_0 VPWR VGND sg13cmos5l_fill_2
XFILLER_88_228 VPWR VGND sg13cmos5l_decap_8
X_0756_ Tile_X0Y0_N4BEG[5] Tile_X0Y1_N4END[13] VPWR VGND sg13cmos5l_buf_1
X_0687_ _0687_/L_HI VPWR VGND sg13cmos5l_tiehi
XFILLER_28_28 VPWR VGND sg13cmos5l_decap_4
XFILLER_56_147 VPWR VGND sg13cmos5l_decap_8
XFILLER_71_128 VPWR VGND sg13cmos5l_fill_1
XFILLER_100_77 VPWR VGND sg13cmos5l_fill_1
XFILLER_12_228 VPWR VGND sg13cmos5l_decap_8
XFILLER_109_64 VPWR VGND sg13cmos5l_fill_1
XFILLER_109_97 VPWR VGND sg13cmos5l_fill_1
XFILLER_125_108 VPWR VGND sg13cmos5l_decap_8
XFILLER_20_272 VPWR VGND sg13cmos5l_fill_1
XFILLER_125_85 VPWR VGND sg13cmos5l_decap_8
XFILLER_133_185 VPWR VGND sg13cmos5l_decap_8
XFILLER_79_228 VPWR VGND sg13cmos5l_decap_8
XFILLER_87_250 VPWR VGND sg13cmos5l_decap_8
XFILLER_87_272 VPWR VGND sg13cmos5l_fill_1
XFILLER_94_209 VPWR VGND sg13cmos5l_decap_8
XFILLER_141_51 VPWR VGND sg13cmos5l_fill_2
XFILLER_11_272 VPWR VGND sg13cmos5l_fill_1
XFILLER_7_254 VPWR VGND sg13cmos5l_decap_8
XFILLER_86_9 VPWR VGND sg13cmos5l_decap_4
XFILLER_109_193 VPWR VGND sg13cmos5l_decap_8
XFILLER_124_196 VPWR VGND sg13cmos5l_decap_8
X_0610_ NPU_WEIGHT_IN0 Tile_X0Y1_UserCLK _0990_/X _0693_/L_HI VPWR VGND sg13cmos5l_dfrbpq_1
X_0541_ _0541_/Q Tile_X0Y1_FrameData[29] VGND VPWR Tile_X0Y1_FrameStrobe[6] latch
X_0472_ _0472_/Q Tile_X0Y1_FrameData[2] VGND VPWR Tile_X0Y1_FrameStrobe[3] latch
XFILLER_85_209 VPWR VGND sg13cmos5l_decap_8
X_1024_ _1024_/X _1085_/X _1081_/X _1077_/X _1098_/X _0280_/Q _0279_/Q VPWR VGND sg13cmos5l_mux4_1
XFILLER_93_242 VPWR VGND sg13cmos5l_decap_8
X_0808_ Tile_X0Y0_FrameStrobe_O[5] Tile_X0Y1_FrameStrobe[5] VPWR VGND sg13cmos5l_buf_1
XFILLER_130_133 VPWR VGND sg13cmos5l_decap_8
XFILLER_29_114 VPWR VGND sg13cmos5l_fill_1
XFILLER_69_272 VPWR VGND sg13cmos5l_fill_1
XFILLER_84_220 VPWR VGND sg13cmos5l_decap_8
X_0739_ Tile_X0Y0_W6BEG[0] _1063_/X VPWR VGND sg13cmos5l_buf_1
XFILLER_29_147 VPWR VGND sg13cmos5l_decap_4
XFILLER_52_150 VPWR VGND sg13cmos5l_decap_8
XFILLER_111_87 VPWR VGND sg13cmos5l_fill_2
XFILLER_138_266 VPWR VGND sg13cmos5l_decap_8
XFILLER_52_194 VPWR VGND sg13cmos5l_fill_1
XFILLER_71_14 VPWR VGND sg13cmos5l_decap_8
XFILLER_106_174 VPWR VGND sg13cmos5l_decap_8
XFILLER_136_84 VPWR VGND sg13cmos5l_decap_8
XFILLER_20_62 VPWR VGND sg13cmos5l_decap_4
XFILLER_20_95 VPWR VGND sg13cmos5l_decap_4
XFILLER_4_202 VPWR VGND sg13cmos5l_decap_8
XFILLER_4_268 VPWR VGND sg13cmos5l_decap_4
XFILLER_121_199 VPWR VGND sg13cmos5l_decap_8
XFILLER_75_231 VPWR VGND sg13cmos5l_decap_8
XFILLER_96_77 VPWR VGND sg13cmos5l_decap_4
XFILLER_43_194 VPWR VGND sg13cmos5l_decap_8
XFILLER_50_109 VPWR VGND sg13cmos5l_fill_2
XFILLER_90_267 VPWR VGND sg13cmos5l_decap_4
XANTENNA_2 NPU_OUT_ACT6 VPWR VGND sg13cmos5l_antennanp
XFILLER_129_211 VPWR VGND sg13cmos5l_decap_8
XFILLER_6_42 VPWR VGND sg13cmos5l_decap_8
XFILLER_112_166 VPWR VGND sg13cmos5l_decap_8
X_0524_ _0524_/Q Tile_X0Y1_FrameData[14] VGND VPWR Tile_X0Y1_FrameStrobe[5] latch
X_0455_ _0455_/Q Tile_X0Y1_FrameData[19] VGND VPWR Tile_X0Y1_FrameStrobe[3] latch
XFILLER_13_0 VPWR VGND sg13cmos5l_fill_2
XFILLER_25_18 VPWR VGND sg13cmos5l_fill_2
X_1007_ _1007_/X Tile_X0Y0_E2MID[3] Tile_X0Y0_E2END[3] Tile_X0Y0_E6END[3] _1096_/X
+ _0330_/Q _0329_/Q VPWR VGND sg13cmos5l_mux4_1
X_0386_ _0386_/Q Tile_X0Y1_FrameData[24] VGND VPWR Tile_X0Y1_FrameStrobe[1] latch
XFILLER_34_194 VPWR VGND sg13cmos5l_decap_8
XFILLER_135_247 VPWR VGND sg13cmos5l_decap_8
XFILLER_1_227 VPWR VGND sg13cmos5l_decap_8
XFILLER_66_14 VPWR VGND sg13cmos5l_decap_8
XFILLER_72_245 VPWR VGND sg13cmos5l_decap_8
XFILLER_126_247 VPWR VGND sg13cmos5l_decap_8
X_0240_ _0240_/Q Tile_X0Y0_FrameData[12] VGND VPWR Tile_X0Y1_FrameStrobe[4] latch
XFILLER_56_91 VPWR VGND sg13cmos5l_decap_8
X_0171_ _0171_/Q Tile_X0Y0_FrameData[17] VGND VPWR Tile_X0Y1_FrameStrobe[2] latch
XFILLER_16_161 VPWR VGND sg13cmos5l_decap_8
XFILLER_117_236 VPWR VGND sg13cmos5l_decap_8
XFILLER_132_217 VPWR VGND sg13cmos5l_decap_8
XFILLER_100_147 VPWR VGND sg13cmos5l_decap_8
XFILLER_140_272 VPWR VGND sg13cmos5l_fill_1
XFILLER_36_28 VPWR VGND sg13cmos5l_decap_8
XFILLER_39_231 VPWR VGND sg13cmos5l_decap_8
X_0507_ _0507_/Q Tile_X0Y1_FrameData[31] VGND VPWR Tile_X0Y1_FrameStrobe[5] latch
X_0438_ _0438_/Q Tile_X0Y1_FrameData[4] VGND VPWR Tile_X0Y1_FrameStrobe[2] latch
X_0369_ _0369_/Q Tile_X0Y1_FrameData[9] VGND VPWR Tile_X0Y1_FrameStrobe[0] latch
XFILLER_108_203 VPWR VGND sg13cmos5l_decap_8
XFILLER_139_7 VPWR VGND sg13cmos5l_decap_8
XFILLER_22_164 VPWR VGND sg13cmos5l_decap_4
XFILLER_131_272 VPWR VGND sg13cmos5l_fill_1
XFILLER_89_186 VPWR VGND sg13cmos5l_decap_8
XFILLER_133_63 VPWR VGND sg13cmos5l_decap_8
XFILLER_45_245 VPWR VGND sg13cmos5l_decap_8
XFILLER_13_120 VPWR VGND sg13cmos5l_decap_8
XFILLER_13_164 VPWR VGND sg13cmos5l_fill_1
XFILLER_13_175 VPWR VGND sg13cmos5l_decap_8
XFILLER_26_61 VPWR VGND sg13cmos5l_fill_2
XFILLER_42_60 VPWR VGND sg13cmos5l_decap_8
XFILLER_60_248 VPWR VGND sg13cmos5l_decap_8
XFILLER_9_135 VPWR VGND sg13cmos5l_decap_8
XFILLER_9_102 VPWR VGND sg13cmos5l_decap_8
XFILLER_42_93 VPWR VGND sg13cmos5l_decap_4
XFILLER_54_7 VPWR VGND sg13cmos5l_decap_8
XFILLER_3_21 VPWR VGND sg13cmos5l_decap_8
XFILLER_3_98 VPWR VGND sg13cmos5l_decap_8
X_0223_ _0223_/Q Tile_X0Y0_FrameData[29] VGND VPWR Tile_X0Y1_FrameStrobe[4] latch
XFILLER_95_167 VPWR VGND sg13cmos5l_fill_1
XFILLER_36_234 VPWR VGND sg13cmos5l_decap_8
XFILLER_51_215 VPWR VGND sg13cmos5l_decap_8
X_0154_ _0154_/Q Tile_X0Y0_FrameData[2] VGND VPWR Tile_X0Y1_FrameStrobe[1] latch
X_0085_ _0765_/A _1015_/X _1016_/X _0314_/Q VPWR VGND sg13cmos5l_mux2_1
XFILLER_80_0 VPWR VGND sg13cmos5l_fill_1
X_0987_ _0987_/X Tile_X0Y1_EE4END[5] Tile_X0Y1_EE4END[13] Tile_X0Y1_E6END[5] _1208_/X
+ _0424_/Q _0423_/Q VPWR VGND sg13cmos5l_mux4_1
XFILLER_105_228 VPWR VGND sg13cmos5l_decap_8
XFILLER_113_272 VPWR VGND sg13cmos5l_fill_1
XFILLER_47_16 VPWR VGND sg13cmos5l_fill_2
XFILLER_86_134 VPWR VGND sg13cmos5l_decap_8
XFILLER_10_101 VPWR VGND sg13cmos5l_decap_8
XFILLER_42_215 VPWR VGND sg13cmos5l_decap_8
XFILLER_10_167 VPWR VGND sg13cmos5l_decap_8
XFILLER_128_63 VPWR VGND sg13cmos5l_decap_8
XFILLER_12_63 VPWR VGND sg13cmos5l_fill_2
XFILLER_12_96 VPWR VGND sg13cmos5l_fill_1
XFILLER_6_105 VPWR VGND sg13cmos5l_decap_8
XFILLER_88_34 VPWR VGND sg13cmos5l_decap_8
XFILLER_88_45 VPWR VGND sg13cmos5l_fill_2
XFILLER_104_272 VPWR VGND sg13cmos5l_fill_1
XFILLER_77_101 VPWR VGND sg13cmos5l_decap_8
XFILLER_77_178 VPWR VGND sg13cmos5l_decap_8
XFILLER_18_245 VPWR VGND sg13cmos5l_decap_8
XFILLER_33_215 VPWR VGND sg13cmos5l_decap_8
X_0910_ Tile_X0Y1_S4BEG[2] Tile_X0Y0_S4END[10] VPWR VGND sg13cmos5l_buf_1
X_0841_ Tile_X0Y1_FrameData_O[17] Tile_X0Y1_FrameData[17] VPWR VGND sg13cmos5l_buf_1
X_0772_ Tile_X0Y0_WW4BEG[5] _1052_/X VPWR VGND sg13cmos5l_buf_1
XFILLER_52_4 VPWR VGND sg13cmos5l_fill_1
XFILLER_5_193 VPWR VGND sg13cmos5l_decap_8
XFILLER_68_101 VPWR VGND sg13cmos5l_decap_8
XFILLER_110_231 VPWR VGND sg13cmos5l_decap_8
XFILLER_68_145 VPWR VGND sg13cmos5l_decap_8
X_1186_ _1186_/X _0651_/Q _1207_/X _1211_/X _1198_/X _0444_/Q _0443_/Q VPWR VGND sg13cmos5l_mux4_1
X_0206_ _0206_/Q Tile_X0Y0_FrameData[14] VGND VPWR Tile_X0Y1_FrameStrobe[3] latch
XFILLER_24_215 VPWR VGND sg13cmos5l_decap_8
X_0137_ _0137_/Q Tile_X0Y0_FrameData[19] VGND VPWR Tile_X0Y1_FrameStrobe[1] latch
X_0068_ _0918_/A _1023_/X _1024_/X _0278_/Q VPWR VGND sg13cmos5l_mux2_1
XFILLER_91_181 VPWR VGND sg13cmos5l_decap_8
XFILLER_91_170 VPWR VGND sg13cmos5l_fill_1
XFILLER_3_119 VPWR VGND sg13cmos5l_decap_8
XFILLER_101_264 VPWR VGND sg13cmos5l_fill_1
XFILLER_59_112 VPWR VGND sg13cmos5l_decap_8
XFILLER_130_42 VPWR VGND sg13cmos5l_decap_8
XFILLER_15_237 VPWR VGND sg13cmos5l_fill_1
XFILLER_74_126 VPWR VGND sg13cmos5l_decap_8
XFILLER_74_14 VPWR VGND sg13cmos5l_decap_8
XFILLER_128_0 VPWR VGND sg13cmos5l_decap_8
XFILLER_23_95 VPWR VGND sg13cmos5l_fill_2
XFILLER_90_13 VPWR VGND sg13cmos5l_fill_2
XFILLER_136_161 VPWR VGND sg13cmos5l_decap_8
XFILLER_139_95 VPWR VGND sg13cmos5l_decap_8
XFILLER_2_130 VPWR VGND sg13cmos5l_decap_8
XFILLER_0_44 VPWR VGND sg13cmos5l_decap_8
XFILLER_24_8 VPWR VGND sg13cmos5l_fill_2
XFILLER_65_126 VPWR VGND sg13cmos5l_decap_4
X_1040_ _1040_/X Tile_X0Y0_EE4END[7] _0637_/Q _1093_/X _1098_/X _0248_/Q _0247_/Q
+ VPWR VGND sg13cmos5l_mux4_1
XFILLER_64_91 VPWR VGND sg13cmos5l_decap_8
X_0824_ Tile_X0Y1_FrameData_O[0] Tile_X0Y1_FrameData[0] VPWR VGND sg13cmos5l_buf_1
X_0755_ Tile_X0Y0_N4BEG[4] Tile_X0Y1_N4END[12] VPWR VGND sg13cmos5l_buf_1
XFILLER_43_0 VPWR VGND sg13cmos5l_fill_1
XFILLER_88_207 VPWR VGND sg13cmos5l_decap_8
X_0686_ _0686_/L_HI VPWR VGND sg13cmos5l_tiehi
XFILLER_56_126 VPWR VGND sg13cmos5l_decap_8
X_1169_ _1169_/X _0646_/Q _0650_/Q _1212_/X _1196_/X _0478_/Q _0477_/Q VPWR VGND sg13cmos5l_mux4_1
XFILLER_100_34 VPWR VGND sg13cmos5l_decap_8
XFILLER_100_89 VPWR VGND sg13cmos5l_decap_4
XFILLER_12_207 VPWR VGND sg13cmos5l_decap_8
XFILLER_60_49 VPWR VGND sg13cmos5l_decap_8
XFILLER_109_43 VPWR VGND sg13cmos5l_fill_2
XFILLER_118_194 VPWR VGND sg13cmos5l_decap_8
XFILLER_133_164 VPWR VGND sg13cmos5l_decap_8
XFILLER_69_14 VPWR VGND sg13cmos5l_decap_8
XFILLER_79_207 VPWR VGND sg13cmos5l_decap_8
XFILLER_125_64 VPWR VGND sg13cmos5l_decap_8
XFILLER_47_159 VPWR VGND sg13cmos5l_decap_8
XFILLER_85_24 VPWR VGND sg13cmos5l_decap_8
XFILLER_141_63 VPWR VGND sg13cmos5l_decap_8
XFILLER_141_96 VPWR VGND sg13cmos5l_fill_2
XFILLER_55_192 VPWR VGND sg13cmos5l_decap_8
XFILLER_109_172 VPWR VGND sg13cmos5l_decap_8
XFILLER_7_233 VPWR VGND sg13cmos5l_decap_8
XFILLER_124_175 VPWR VGND sg13cmos5l_decap_8
XFILLER_59_91 VPWR VGND sg13cmos5l_decap_8
XFILLER_78_262 VPWR VGND sg13cmos5l_decap_8
X_0540_ _0540_/Q Tile_X0Y1_FrameData[30] VGND VPWR Tile_X0Y1_FrameStrobe[6] latch
X_0471_ _0471_/Q Tile_X0Y1_FrameData[3] VGND VPWR Tile_X0Y1_FrameStrobe[3] latch
XFILLER_53_129 VPWR VGND sg13cmos5l_decap_8
X_1023_ _1023_/X Tile_X0Y0_E1END[2] Tile_X0Y0_EE4END[14] Tile_X0Y0_E6END[6] _1090_/X
+ _0280_/Q _0279_/Q VPWR VGND sg13cmos5l_mux4_1
XFILLER_93_221 VPWR VGND sg13cmos5l_decap_8
X_0807_ Tile_X0Y0_FrameStrobe_O[4] Tile_X0Y1_FrameStrobe[4] VPWR VGND sg13cmos5l_buf_1
X_0738_ Tile_X0Y0_W2BEGb[7] _1046_/X VPWR VGND sg13cmos5l_buf_1
XFILLER_115_197 VPWR VGND sg13cmos5l_decap_8
XFILLER_130_112 VPWR VGND sg13cmos5l_decap_8
XFILLER_130_189 VPWR VGND sg13cmos5l_decap_8
XFILLER_29_126 VPWR VGND sg13cmos5l_decap_8
X_0669_ _0669_/L_HI VPWR VGND sg13cmos5l_tiehi
XFILLER_37_192 VPWR VGND sg13cmos5l_decap_8
XFILLER_44_118 VPWR VGND sg13cmos5l_decap_8
XFILLER_55_49 VPWR VGND sg13cmos5l_decap_8
XFILLER_138_245 VPWR VGND sg13cmos5l_decap_8
XFILLER_121_101 VPWR VGND sg13cmos5l_fill_1
XFILLER_136_63 VPWR VGND sg13cmos5l_decap_8
XFILLER_121_178 VPWR VGND sg13cmos5l_decap_8
XFILLER_28_192 VPWR VGND sg13cmos5l_decap_8
XFILLER_75_210 VPWR VGND sg13cmos5l_decap_8
XFILLER_90_246 VPWR VGND sg13cmos5l_decap_8
XFILLER_43_173 VPWR VGND sg13cmos5l_decap_8
XFILLER_61_70 VPWR VGND sg13cmos5l_decap_8
XANTENNA_3 Tile_X0Y0_S2MID[0] VPWR VGND sg13cmos5l_antennanp
XFILLER_6_21 VPWR VGND sg13cmos5l_decap_8
XFILLER_6_98 VPWR VGND sg13cmos5l_decap_8
X_0523_ _0523_/Q Tile_X0Y1_FrameData[15] VGND VPWR Tile_X0Y1_FrameStrobe[5] latch
X_0454_ _0454_/Q Tile_X0Y1_FrameData[20] VGND VPWR Tile_X0Y1_FrameStrobe[3] latch
X_0385_ _0385_/Q Tile_X0Y1_FrameData[25] VGND VPWR Tile_X0Y1_FrameStrobe[1] latch
XFILLER_19_170 VPWR VGND sg13cmos5l_fill_1
XFILLER_26_129 VPWR VGND sg13cmos5l_decap_4
XFILLER_81_246 VPWR VGND sg13cmos5l_decap_8
XFILLER_81_268 VPWR VGND sg13cmos5l_decap_4
X_1006_ _1006_/X Tile_X0Y0_E2MID[4] Tile_X0Y0_E2END[4] Tile_X0Y0_E6END[4] _1095_/X
+ _0332_/Q _0331_/Q VPWR VGND sg13cmos5l_mux4_1
XFILLER_135_226 VPWR VGND sg13cmos5l_decap_8
XFILLER_103_123 VPWR VGND sg13cmos5l_decap_4
XFILLER_106_33 VPWR VGND sg13cmos5l_fill_1
XFILLER_1_206 VPWR VGND sg13cmos5l_decap_8
XFILLER_106_55 VPWR VGND sg13cmos5l_decap_8
XFILLER_106_99 VPWR VGND sg13cmos5l_fill_1
XFILLER_122_65 VPWR VGND sg13cmos5l_fill_2
XFILLER_72_224 VPWR VGND sg13cmos5l_decap_8
XFILLER_25_195 VPWR VGND sg13cmos5l_decap_8
XFILLER_82_58 VPWR VGND sg13cmos5l_decap_8
XFILLER_110_0 VPWR VGND sg13cmos5l_fill_2
XFILLER_126_226 VPWR VGND sg13cmos5l_decap_8
XFILLER_0_272 VPWR VGND sg13cmos5l_fill_1
XFILLER_141_229 VPWR VGND sg13cmos5l_decap_8
XFILLER_16_140 VPWR VGND sg13cmos5l_decap_8
XFILLER_56_70 VPWR VGND sg13cmos5l_decap_8
X_0170_ _0170_/Q Tile_X0Y0_FrameData[18] VGND VPWR Tile_X0Y1_FrameStrobe[2] latch
XFILLER_117_215 VPWR VGND sg13cmos5l_decap_8
XFILLER_31_154 VPWR VGND sg13cmos5l_fill_2
XFILLER_31_198 VPWR VGND sg13cmos5l_decap_8
XFILLER_72_91 VPWR VGND sg13cmos5l_decap_8
X_0506_ _0506_/Q Tile_X0Y1_FrameData[0] VGND VPWR Tile_X0Y1_FrameStrobe[4] latch
XFILLER_98_143 VPWR VGND sg13cmos5l_decap_4
XFILLER_39_210 VPWR VGND sg13cmos5l_decap_8
XFILLER_54_213 VPWR VGND sg13cmos5l_decap_8
X_0437_ _0437_/Q Tile_X0Y1_FrameData[5] VGND VPWR Tile_X0Y1_FrameStrobe[2] latch
X_0368_ _0368_/Q Tile_X0Y1_FrameData[10] VGND VPWR Tile_X0Y1_FrameStrobe[0] latch
XFILLER_52_17 VPWR VGND sg13cmos5l_fill_1
XFILLER_54_268 VPWR VGND sg13cmos5l_decap_4
X_0299_ _0299_/Q Tile_X0Y0_FrameData[17] VGND VPWR Tile_X0Y1_FrameStrobe[6] latch
XFILLER_108_259 VPWR VGND sg13cmos5l_decap_8
XFILLER_131_262 VPWR VGND sg13cmos5l_fill_2
XFILLER_77_47 VPWR VGND sg13cmos5l_fill_2
XFILLER_89_165 VPWR VGND sg13cmos5l_decap_8
XFILLER_133_42 VPWR VGND sg13cmos5l_decap_8
XFILLER_45_224 VPWR VGND sg13cmos5l_decap_8
XFILLER_45_268 VPWR VGND sg13cmos5l_decap_4
XFILLER_60_227 VPWR VGND sg13cmos5l_decap_8
XFILLER_93_13 VPWR VGND sg13cmos5l_fill_2
XFILLER_42_50 VPWR VGND sg13cmos5l_fill_2
XFILLER_36_213 VPWR VGND sg13cmos5l_decap_8
XFILLER_3_77 VPWR VGND sg13cmos5l_decap_8
X_0222_ _0222_/Q Tile_X0Y0_FrameData[30] VGND VPWR Tile_X0Y1_FrameStrobe[4] latch
X_0153_ _0153_/Q Tile_X0Y0_FrameData[3] VGND VPWR Tile_X0Y1_FrameStrobe[1] latch
XFILLER_95_179 VPWR VGND sg13cmos5l_fill_2
XFILLER_95_157 VPWR VGND sg13cmos5l_decap_4
X_0084_ _0766_/A _1017_/X _1018_/X _0311_/Q VPWR VGND sg13cmos5l_mux2_1
XFILLER_105_207 VPWR VGND sg13cmos5l_decap_8
XFILLER_73_0 VPWR VGND sg13cmos5l_decap_8
X_0986_ _0986_/X Tile_X0Y1_EE4END[4] Tile_X0Y1_EE4END[12] Tile_X0Y1_E6END[4] _1207_/X
+ _0426_/Q _0425_/Q VPWR VGND sg13cmos5l_mux4_1
XFILLER_8_180 VPWR VGND sg13cmos5l_decap_8
XFILLER_113_262 VPWR VGND sg13cmos5l_fill_2
XFILLER_103_34 VPWR VGND sg13cmos5l_decap_8
XFILLER_27_246 VPWR VGND sg13cmos5l_decap_8
XFILLER_63_49 VPWR VGND sg13cmos5l_decap_8
XFILLER_10_146 VPWR VGND sg13cmos5l_decap_8
XFILLER_128_42 VPWR VGND sg13cmos5l_decap_8
XFILLER_18_224 VPWR VGND sg13cmos5l_decap_8
XFILLER_37_50 VPWR VGND sg13cmos5l_fill_1
XFILLER_77_157 VPWR VGND sg13cmos5l_decap_8
XFILLER_18_268 VPWR VGND sg13cmos5l_decap_4
XFILLER_53_82 VPWR VGND sg13cmos5l_decap_4
X_0840_ Tile_X0Y1_FrameData_O[16] Tile_X0Y1_FrameData[16] VPWR VGND sg13cmos5l_buf_1
X_0771_ Tile_X0Y0_WW4BEG[4] _1051_/X VPWR VGND sg13cmos5l_buf_1
XFILLER_110_210 VPWR VGND sg13cmos5l_decap_8
XFILLER_68_124 VPWR VGND sg13cmos5l_decap_8
XFILLER_83_105 VPWR VGND sg13cmos5l_decap_8
XFILLER_83_149 VPWR VGND sg13cmos5l_decap_8
X_1185_ _1185_/X _0650_/Q _1208_/X _1212_/X _1197_/X _0446_/Q _0445_/Q VPWR VGND sg13cmos5l_mux4_1
X_0205_ _0205_/Q Tile_X0Y0_FrameData[15] VGND VPWR Tile_X0Y1_FrameStrobe[3] latch
X_0136_ _0136_/Q Tile_X0Y0_FrameData[20] VGND VPWR Tile_X0Y1_FrameStrobe[1] latch
X_0969_ Tile_X0Y1_WW4BEG[12] _1175_/X VPWR VGND sg13cmos5l_buf_1
XFILLER_101_243 VPWR VGND sg13cmos5l_decap_8
XFILLER_58_49 VPWR VGND sg13cmos5l_decap_8
XFILLER_74_105 VPWR VGND sg13cmos5l_decap_8
XFILLER_130_21 VPWR VGND sg13cmos5l_decap_8
XFILLER_15_216 VPWR VGND sg13cmos5l_decap_8
XFILLER_82_193 VPWR VGND sg13cmos5l_decap_8
XFILLER_130_98 VPWR VGND sg13cmos5l_decap_8
XFILLER_136_140 VPWR VGND sg13cmos5l_decap_8
XFILLER_139_74 VPWR VGND sg13cmos5l_decap_8
XFILLER_23_63 VPWR VGND sg13cmos5l_fill_2
XFILLER_99_12 VPWR VGND sg13cmos5l_fill_2
XFILLER_90_69 VPWR VGND sg13cmos5l_decap_4
XFILLER_2_186 VPWR VGND sg13cmos5l_decap_8
XFILLER_3_0 VPWR VGND sg13cmos5l_decap_8
XFILLER_48_82 VPWR VGND sg13cmos5l_fill_1
XFILLER_65_105 VPWR VGND sg13cmos5l_decap_8
XFILLER_65_149 VPWR VGND sg13cmos5l_decap_8
XFILLER_64_70 VPWR VGND sg13cmos5l_decap_8
XFILLER_73_182 VPWR VGND sg13cmos5l_decap_8
XFILLER_127_184 VPWR VGND sg13cmos5l_decap_8
X_0823_ FAB_USER_CLK Tile_X0Y1_UserCLK VPWR VGND sg13cmos5l_buf_1
X_0754_ Tile_X0Y0_N4BEG[3] Tile_X0Y1_N4END[11] VPWR VGND sg13cmos5l_buf_1
X_0685_ _0685_/L_HI VPWR VGND sg13cmos5l_tiehi
XFILLER_56_105 VPWR VGND sg13cmos5l_decap_8
XFILLER_64_182 VPWR VGND sg13cmos5l_decap_8
XFILLER_71_119 VPWR VGND sg13cmos5l_decap_8
X_1099_ _1099_/X _1110_/X Tile_X0Y1_N2MID[7] Tile_X0Y0_S2MID[7] Tile_X0Y0_S2END[7]
+ _0102_/Q _0101_/Q VPWR VGND sg13cmos5l_mux4_1
X_1168_ _1168_/X _0645_/Q _0649_/Q _1213_/X _1197_/X _0480_/Q _0479_/Q VPWR VGND sg13cmos5l_mux4_1
X_0119_ _0119_/Q Tile_X0Y0_FrameData[5] VGND VPWR Tile_X0Y1_FrameStrobe[0] latch
XFILLER_121_8 VPWR VGND sg13cmos5l_fill_1
XFILLER_20_263 VPWR VGND sg13cmos5l_decap_8
XFILLER_60_28 VPWR VGND sg13cmos5l_decap_8
XFILLER_118_173 VPWR VGND sg13cmos5l_decap_8
XFILLER_125_21 VPWR VGND sg13cmos5l_decap_8
XFILLER_125_43 VPWR VGND sg13cmos5l_decap_8
XFILLER_47_138 VPWR VGND sg13cmos5l_decap_8
XFILLER_62_119 VPWR VGND sg13cmos5l_decap_8
XFILLER_140_0 VPWR VGND sg13cmos5l_decap_8
XFILLER_55_171 VPWR VGND sg13cmos5l_decap_8
XFILLER_70_196 VPWR VGND sg13cmos5l_decap_8
XFILLER_7_212 VPWR VGND sg13cmos5l_decap_8
XFILLER_124_154 VPWR VGND sg13cmos5l_decap_8
XFILLER_38_127 VPWR VGND sg13cmos5l_fill_1
XFILLER_59_70 VPWR VGND sg13cmos5l_decap_8
XFILLER_78_241 VPWR VGND sg13cmos5l_decap_8
X_0470_ _0470_/Q Tile_X0Y1_FrameData[4] VGND VPWR Tile_X0Y1_FrameStrobe[3] latch
XFILLER_93_200 VPWR VGND sg13cmos5l_decap_8
XFILLER_75_91 VPWR VGND sg13cmos5l_decap_8
X_1022_ _1022_/X _1086_/X _1082_/X _1076_/X _1097_/X _0283_/Q _0282_/Q VPWR VGND sg13cmos5l_mux4_1
XFILLER_61_196 VPWR VGND sg13cmos5l_decap_8
XANTENNA__0802__X Tile_X0Y0_N1BEG[3] VPWR VGND sg13cmos5l_antennanp
XFILLER_115_154 VPWR VGND sg13cmos5l_decap_8
XFILLER_115_176 VPWR VGND sg13cmos5l_decap_8
X_0806_ Tile_X0Y0_FrameStrobe_O[3] Tile_X0Y1_FrameStrobe[3] VPWR VGND sg13cmos5l_buf_1
X_0737_ Tile_X0Y0_W2BEGb[6] _1045_/X VPWR VGND sg13cmos5l_buf_1
X_0668_ _0668_/L_HI VPWR VGND sg13cmos5l_tiehi
XFILLER_130_168 VPWR VGND sg13cmos5l_decap_8
XFILLER_29_105 VPWR VGND sg13cmos5l_decap_8
XFILLER_55_28 VPWR VGND sg13cmos5l_decap_8
XFILLER_84_255 VPWR VGND sg13cmos5l_decap_8
X_0599_ _0599_/Q Tile_X0Y1_FrameData[3] VGND VPWR Tile_X0Y1_FrameStrobe[7] latch
XFILLER_37_171 VPWR VGND sg13cmos5l_decap_8
XFILLER_52_185 VPWR VGND sg13cmos5l_decap_8
XFILLER_71_49 VPWR VGND sg13cmos5l_decap_8
XFILLER_138_224 VPWR VGND sg13cmos5l_decap_8
XFILLER_4_237 VPWR VGND sg13cmos5l_decap_8
XFILLER_121_113 VPWR VGND sg13cmos5l_decap_8
XFILLER_121_157 VPWR VGND sg13cmos5l_decap_8
XFILLER_136_42 VPWR VGND sg13cmos5l_decap_8
XFILLER_28_171 VPWR VGND sg13cmos5l_decap_8
XFILLER_29_84 VPWR VGND sg13cmos5l_decap_4
XFILLER_29_95 VPWR VGND sg13cmos5l_fill_2
XFILLER_43_130 VPWR VGND sg13cmos5l_fill_2
XFILLER_45_61 VPWR VGND sg13cmos5l_fill_1
XFILLER_75_266 VPWR VGND sg13cmos5l_decap_8
XFILLER_90_225 VPWR VGND sg13cmos5l_decap_8
XFILLER_129_246 VPWR VGND sg13cmos5l_decap_8
XFILLER_129_268 VPWR VGND sg13cmos5l_decap_4
XANTENNA_4 Tile_X0Y0_S2MID[0] VPWR VGND sg13cmos5l_antennanp
XFILLER_6_77 VPWR VGND sg13cmos5l_decap_8
X_0522_ _0522_/Q Tile_X0Y1_FrameData[16] VGND VPWR Tile_X0Y1_FrameStrobe[5] latch
XFILLER_66_233 VPWR VGND sg13cmos5l_fill_2
X_0453_ _0453_/Q Tile_X0Y1_FrameData[21] VGND VPWR Tile_X0Y1_FrameStrobe[3] latch
X_0384_ _0384_/Q Tile_X0Y1_FrameData[26] VGND VPWR Tile_X0Y1_FrameStrobe[1] latch
XFILLER_19_182 VPWR VGND sg13cmos5l_decap_8
XFILLER_81_225 VPWR VGND sg13cmos5l_decap_8
X_1005_ _1005_/X Tile_X0Y0_E2MID[5] Tile_X0Y0_E2END[5] Tile_X0Y0_E6END[5] _1094_/X
+ _0334_/Q _0333_/Q VPWR VGND sg13cmos5l_mux4_1
XFILLER_135_205 VPWR VGND sg13cmos5l_decap_8
XFILLER_103_157 VPWR VGND sg13cmos5l_decap_8
XFILLER_103_168 VPWR VGND sg13cmos5l_fill_1
XFILLER_111_190 VPWR VGND sg13cmos5l_decap_8
XFILLER_122_99 VPWR VGND sg13cmos5l_decap_8
XFILLER_57_233 VPWR VGND sg13cmos5l_fill_1
XFILLER_66_49 VPWR VGND sg13cmos5l_decap_8
XFILLER_72_203 VPWR VGND sg13cmos5l_decap_8
XFILLER_25_152 VPWR VGND sg13cmos5l_fill_1
XFILLER_25_174 VPWR VGND sg13cmos5l_decap_8
XFILLER_103_0 VPWR VGND sg13cmos5l_fill_2
XFILLER_126_205 VPWR VGND sg13cmos5l_decap_8
XFILLER_141_208 VPWR VGND sg13cmos5l_decap_8
XFILLER_31_41 VPWR VGND sg13cmos5l_decap_8
XFILLER_0_240 VPWR VGND sg13cmos5l_fill_1
XFILLER_48_244 VPWR VGND sg13cmos5l_decap_8
XFILLER_63_203 VPWR VGND sg13cmos5l_decap_8
XFILLER_16_196 VPWR VGND sg13cmos5l_decap_8
XFILLER_63_236 VPWR VGND sg13cmos5l_fill_2
XFILLER_72_70 VPWR VGND sg13cmos5l_decap_8
XFILLER_31_177 VPWR VGND sg13cmos5l_decap_8
XFILLER_125_260 VPWR VGND sg13cmos5l_decap_4
XFILLER_140_263 VPWR VGND sg13cmos5l_decap_8
X_0505_ _0505_/Q Tile_X0Y1_FrameData[1] VGND VPWR Tile_X0Y1_FrameStrobe[4] latch
X_0436_ _0436_/Q Tile_X0Y1_FrameData[6] VGND VPWR Tile_X0Y1_FrameStrobe[2] latch
XFILLER_98_188 VPWR VGND sg13cmos5l_decap_8
XFILLER_98_100 VPWR VGND sg13cmos5l_decap_8
.ends
