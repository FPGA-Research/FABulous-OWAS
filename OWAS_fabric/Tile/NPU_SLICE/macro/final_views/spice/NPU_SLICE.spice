* NGSPICE file created from NPU_SLICE.ext - technology: ihp-sg13cmos5l

* Black-box entry subcircuit for sg13cmos5l_decap_8 abstract view
.subckt sg13cmos5l_decap_8 VDD VSS
.ends

* Black-box entry subcircuit for latch abstract view
.subckt latch Q D VSS VDD GATE
.ends

* Black-box entry subcircuit for sg13cmos5l_fill_2 abstract view
.subckt sg13cmos5l_fill_2 VDD VSS
.ends

* Black-box entry subcircuit for sg13cmos5l_decap_4 abstract view
.subckt sg13cmos5l_decap_4 VDD VSS
.ends

* Black-box entry subcircuit for sg13cmos5l_fill_1 abstract view
.subckt sg13cmos5l_fill_1 VDD VSS
.ends

* Black-box entry subcircuit for sg13cmos5l_antennanp abstract view
.subckt sg13cmos5l_antennanp A VDD VSS
.ends

* Black-box entry subcircuit for sg13cmos5l_mux2_1 abstract view
.subckt sg13cmos5l_mux2_1 X A0 A1 S VDD VSS
.ends

* Black-box entry subcircuit for sg13cmos5l_mux4_1 abstract view
.subckt sg13cmos5l_mux4_1 X A0 A1 A2 A3 S0 S1 VDD VSS
.ends

* Black-box entry subcircuit for sg13cmos5l_buf_1 abstract view
.subckt sg13cmos5l_buf_1 X A VDD VSS
.ends

* Black-box entry subcircuit for sg13cmos5l_tiehi abstract view
.subckt sg13cmos5l_tiehi L_HI VDD VSS
.ends

* Black-box entry subcircuit for sg13cmos5l_dfrbpq_1 abstract view
.subckt sg13cmos5l_dfrbpq_1 Q CLK D RESET_B VDD VSS
.ends

* Black-box entry subcircuit for sg13cmos5l_tielo abstract view
.subckt sg13cmos5l_tielo L_LO VDD VSS
.ends

* Black-box entry subcircuit for sg13cmos5l_or2_1 abstract view
.subckt sg13cmos5l_or2_1 X A B VDD VSS
.ends

* Black-box entry subcircuit for sg13cmos5l_nor2b_1 abstract view
.subckt sg13cmos5l_nor2b_1 Y A B_N VDD VSS
.ends

.subckt NPU_SLICE FAB_USER_CLK NPU_ACT_ADDR0 NPU_ACT_ADDR1 NPU_ACT_ADDR2 NPU_ACT_ADDR3
+ NPU_ACT_ADDR4 NPU_ACT_ADDR5 NPU_ACT_ADDR6 NPU_ACT_ADDR7 NPU_ACT_ADDR8 NPU_ACT_RDATA0
+ NPU_ACT_RDATA1 NPU_ACT_RDATA2 NPU_ACT_RDATA3 NPU_ACT_RDATA4 NPU_ACT_RDATA5 NPU_ACT_RDATA6
+ NPU_ACT_RDATA7 NPU_ACT_WDATA0 NPU_ACT_WDATA1 NPU_ACT_WDATA2 NPU_ACT_WDATA3 NPU_ACT_WDATA4
+ NPU_ACT_WDATA5 NPU_ACT_WDATA6 NPU_ACT_WDATA7 NPU_ACT_WE NPU_OUT_ACT0 NPU_OUT_ACT1
+ NPU_OUT_ACT2 NPU_OUT_ACT3 NPU_OUT_ACT4 NPU_OUT_ACT5 NPU_OUT_ACT6 NPU_OUT_ACT7 NPU_WEIGHT_IN0
+ NPU_WEIGHT_IN1 NPU_WEIGHT_IN2 NPU_WEIGHT_IN3 NPU_WEIGHT_IN4 NPU_WEIGHT_IN5 NPU_WEIGHT_IN6
+ NPU_WEIGHT_IN7 NPU_WEIGHT_SHIFT_EN NPU_XBAR_SEL0 NPU_XBAR_SEL1 NPU_XBAR_SEL2 NPU_XBAR_SEL3
+ Tile_X0Y0_E1END[0] Tile_X0Y0_E1END[1] Tile_X0Y0_E1END[2] Tile_X0Y0_E1END[3] Tile_X0Y0_E2END[0]
+ Tile_X0Y0_E2END[1] Tile_X0Y0_E2END[2] Tile_X0Y0_E2END[3] Tile_X0Y0_E2END[4] Tile_X0Y0_E2END[5]
+ Tile_X0Y0_E2END[6] Tile_X0Y0_E2END[7] Tile_X0Y0_E2MID[0] Tile_X0Y0_E2MID[1] Tile_X0Y0_E2MID[2]
+ Tile_X0Y0_E2MID[3] Tile_X0Y0_E2MID[4] Tile_X0Y0_E2MID[5] Tile_X0Y0_E2MID[6] Tile_X0Y0_E2MID[7]
+ Tile_X0Y0_E6END[0] Tile_X0Y0_E6END[10] Tile_X0Y0_E6END[11] Tile_X0Y0_E6END[1] Tile_X0Y0_E6END[2]
+ Tile_X0Y0_E6END[3] Tile_X0Y0_E6END[4] Tile_X0Y0_E6END[5] Tile_X0Y0_E6END[6] Tile_X0Y0_E6END[7]
+ Tile_X0Y0_E6END[8] Tile_X0Y0_E6END[9] Tile_X0Y0_EE4END[0] Tile_X0Y0_EE4END[10] Tile_X0Y0_EE4END[11]
+ Tile_X0Y0_EE4END[12] Tile_X0Y0_EE4END[13] Tile_X0Y0_EE4END[14] Tile_X0Y0_EE4END[15]
+ Tile_X0Y0_EE4END[1] Tile_X0Y0_EE4END[2] Tile_X0Y0_EE4END[3] Tile_X0Y0_EE4END[4]
+ Tile_X0Y0_EE4END[5] Tile_X0Y0_EE4END[6] Tile_X0Y0_EE4END[7] Tile_X0Y0_EE4END[8]
+ Tile_X0Y0_EE4END[9] Tile_X0Y0_FrameData[0] Tile_X0Y0_FrameData[10] Tile_X0Y0_FrameData[11]
+ Tile_X0Y0_FrameData[12] Tile_X0Y0_FrameData[13] Tile_X0Y0_FrameData[14] Tile_X0Y0_FrameData[15]
+ Tile_X0Y0_FrameData[16] Tile_X0Y0_FrameData[17] Tile_X0Y0_FrameData[18] Tile_X0Y0_FrameData[19]
+ Tile_X0Y0_FrameData[1] Tile_X0Y0_FrameData[20] Tile_X0Y0_FrameData[21] Tile_X0Y0_FrameData[22]
+ Tile_X0Y0_FrameData[23] Tile_X0Y0_FrameData[24] Tile_X0Y0_FrameData[25] Tile_X0Y0_FrameData[26]
+ Tile_X0Y0_FrameData[27] Tile_X0Y0_FrameData[28] Tile_X0Y0_FrameData[29] Tile_X0Y0_FrameData[2]
+ Tile_X0Y0_FrameData[30] Tile_X0Y0_FrameData[31] Tile_X0Y0_FrameData[3] Tile_X0Y0_FrameData[4]
+ Tile_X0Y0_FrameData[5] Tile_X0Y0_FrameData[6] Tile_X0Y0_FrameData[7] Tile_X0Y0_FrameData[8]
+ Tile_X0Y0_FrameData[9] Tile_X0Y0_FrameData_O[0] Tile_X0Y0_FrameData_O[10] Tile_X0Y0_FrameData_O[11]
+ Tile_X0Y0_FrameData_O[12] Tile_X0Y0_FrameData_O[13] Tile_X0Y0_FrameData_O[14] Tile_X0Y0_FrameData_O[15]
+ Tile_X0Y0_FrameData_O[16] Tile_X0Y0_FrameData_O[17] Tile_X0Y0_FrameData_O[18] Tile_X0Y0_FrameData_O[19]
+ Tile_X0Y0_FrameData_O[1] Tile_X0Y0_FrameData_O[20] Tile_X0Y0_FrameData_O[21] Tile_X0Y0_FrameData_O[22]
+ Tile_X0Y0_FrameData_O[23] Tile_X0Y0_FrameData_O[24] Tile_X0Y0_FrameData_O[25] Tile_X0Y0_FrameData_O[26]
+ Tile_X0Y0_FrameData_O[27] Tile_X0Y0_FrameData_O[28] Tile_X0Y0_FrameData_O[29] Tile_X0Y0_FrameData_O[2]
+ Tile_X0Y0_FrameData_O[30] Tile_X0Y0_FrameData_O[31] Tile_X0Y0_FrameData_O[3] Tile_X0Y0_FrameData_O[4]
+ Tile_X0Y0_FrameData_O[5] Tile_X0Y0_FrameData_O[6] Tile_X0Y0_FrameData_O[7] Tile_X0Y0_FrameData_O[8]
+ Tile_X0Y0_FrameData_O[9] Tile_X0Y0_FrameStrobe_O[0] Tile_X0Y0_FrameStrobe_O[10]
+ Tile_X0Y0_FrameStrobe_O[11] Tile_X0Y0_FrameStrobe_O[12] Tile_X0Y0_FrameStrobe_O[13]
+ Tile_X0Y0_FrameStrobe_O[14] Tile_X0Y0_FrameStrobe_O[15] Tile_X0Y0_FrameStrobe_O[16]
+ Tile_X0Y0_FrameStrobe_O[17] Tile_X0Y0_FrameStrobe_O[18] Tile_X0Y0_FrameStrobe_O[19]
+ Tile_X0Y0_FrameStrobe_O[1] Tile_X0Y0_FrameStrobe_O[2] Tile_X0Y0_FrameStrobe_O[3]
+ Tile_X0Y0_FrameStrobe_O[4] Tile_X0Y0_FrameStrobe_O[5] Tile_X0Y0_FrameStrobe_O[6]
+ Tile_X0Y0_FrameStrobe_O[7] Tile_X0Y0_FrameStrobe_O[8] Tile_X0Y0_FrameStrobe_O[9]
+ Tile_X0Y0_N1BEG[0] Tile_X0Y0_N1BEG[1] Tile_X0Y0_N1BEG[2] Tile_X0Y0_N1BEG[3] Tile_X0Y0_N2BEG[0]
+ Tile_X0Y0_N2BEG[1] Tile_X0Y0_N2BEG[2] Tile_X0Y0_N2BEG[3] Tile_X0Y0_N2BEG[4] Tile_X0Y0_N2BEG[5]
+ Tile_X0Y0_N2BEG[6] Tile_X0Y0_N2BEG[7] Tile_X0Y0_N2BEGb[0] Tile_X0Y0_N2BEGb[1] Tile_X0Y0_N2BEGb[2]
+ Tile_X0Y0_N2BEGb[3] Tile_X0Y0_N2BEGb[4] Tile_X0Y0_N2BEGb[5] Tile_X0Y0_N2BEGb[6]
+ Tile_X0Y0_N2BEGb[7] Tile_X0Y0_N4BEG[0] Tile_X0Y0_N4BEG[10] Tile_X0Y0_N4BEG[11] Tile_X0Y0_N4BEG[12]
+ Tile_X0Y0_N4BEG[13] Tile_X0Y0_N4BEG[14] Tile_X0Y0_N4BEG[15] Tile_X0Y0_N4BEG[1] Tile_X0Y0_N4BEG[2]
+ Tile_X0Y0_N4BEG[3] Tile_X0Y0_N4BEG[4] Tile_X0Y0_N4BEG[5] Tile_X0Y0_N4BEG[6] Tile_X0Y0_N4BEG[7]
+ Tile_X0Y0_N4BEG[8] Tile_X0Y0_N4BEG[9] Tile_X0Y0_S1END[0] Tile_X0Y0_S1END[1] Tile_X0Y0_S1END[2]
+ Tile_X0Y0_S1END[3] Tile_X0Y0_S2END[0] Tile_X0Y0_S2END[1] Tile_X0Y0_S2END[2] Tile_X0Y0_S2END[3]
+ Tile_X0Y0_S2END[4] Tile_X0Y0_S2END[5] Tile_X0Y0_S2END[6] Tile_X0Y0_S2END[7] Tile_X0Y0_S2MID[0]
+ Tile_X0Y0_S2MID[1] Tile_X0Y0_S2MID[2] Tile_X0Y0_S2MID[3] Tile_X0Y0_S2MID[4] Tile_X0Y0_S2MID[5]
+ Tile_X0Y0_S2MID[6] Tile_X0Y0_S2MID[7] Tile_X0Y0_S4END[0] Tile_X0Y0_S4END[10] Tile_X0Y0_S4END[11]
+ Tile_X0Y0_S4END[12] Tile_X0Y0_S4END[13] Tile_X0Y0_S4END[14] Tile_X0Y0_S4END[15]
+ Tile_X0Y0_S4END[1] Tile_X0Y0_S4END[2] Tile_X0Y0_S4END[3] Tile_X0Y0_S4END[4] Tile_X0Y0_S4END[5]
+ Tile_X0Y0_S4END[6] Tile_X0Y0_S4END[7] Tile_X0Y0_S4END[8] Tile_X0Y0_S4END[9] Tile_X0Y0_UserCLK
+ Tile_X0Y0_UserCLKo Tile_X0Y0_W1BEG[0] Tile_X0Y0_W1BEG[1] Tile_X0Y0_W1BEG[2] Tile_X0Y0_W1BEG[3]
+ Tile_X0Y0_W2BEG[0] Tile_X0Y0_W2BEG[1] Tile_X0Y0_W2BEG[2] Tile_X0Y0_W2BEG[3] Tile_X0Y0_W2BEG[4]
+ Tile_X0Y0_W2BEG[5] Tile_X0Y0_W2BEG[6] Tile_X0Y0_W2BEG[7] Tile_X0Y0_W2BEGb[0] Tile_X0Y0_W2BEGb[1]
+ Tile_X0Y0_W2BEGb[2] Tile_X0Y0_W2BEGb[3] Tile_X0Y0_W2BEGb[4] Tile_X0Y0_W2BEGb[5]
+ Tile_X0Y0_W2BEGb[6] Tile_X0Y0_W2BEGb[7] Tile_X0Y0_W6BEG[0] Tile_X0Y0_W6BEG[10] Tile_X0Y0_W6BEG[11]
+ Tile_X0Y0_W6BEG[1] Tile_X0Y0_W6BEG[2] Tile_X0Y0_W6BEG[3] Tile_X0Y0_W6BEG[4] Tile_X0Y0_W6BEG[5]
+ Tile_X0Y0_W6BEG[6] Tile_X0Y0_W6BEG[7] Tile_X0Y0_W6BEG[8] Tile_X0Y0_W6BEG[9] Tile_X0Y0_WW4BEG[0]
+ Tile_X0Y0_WW4BEG[10] Tile_X0Y0_WW4BEG[11] Tile_X0Y0_WW4BEG[12] Tile_X0Y0_WW4BEG[13]
+ Tile_X0Y0_WW4BEG[14] Tile_X0Y0_WW4BEG[15] Tile_X0Y0_WW4BEG[1] Tile_X0Y0_WW4BEG[2]
+ Tile_X0Y0_WW4BEG[3] Tile_X0Y0_WW4BEG[4] Tile_X0Y0_WW4BEG[5] Tile_X0Y0_WW4BEG[6]
+ Tile_X0Y0_WW4BEG[7] Tile_X0Y0_WW4BEG[8] Tile_X0Y0_WW4BEG[9] Tile_X0Y1_E1END[0] Tile_X0Y1_E1END[1]
+ Tile_X0Y1_E1END[2] Tile_X0Y1_E1END[3] Tile_X0Y1_E2END[0] Tile_X0Y1_E2END[1] Tile_X0Y1_E2END[2]
+ Tile_X0Y1_E2END[3] Tile_X0Y1_E2END[4] Tile_X0Y1_E2END[5] Tile_X0Y1_E2END[6] Tile_X0Y1_E2END[7]
+ Tile_X0Y1_E2MID[0] Tile_X0Y1_E2MID[1] Tile_X0Y1_E2MID[2] Tile_X0Y1_E2MID[3] Tile_X0Y1_E2MID[4]
+ Tile_X0Y1_E2MID[5] Tile_X0Y1_E2MID[6] Tile_X0Y1_E2MID[7] Tile_X0Y1_E6END[0] Tile_X0Y1_E6END[10]
+ Tile_X0Y1_E6END[11] Tile_X0Y1_E6END[1] Tile_X0Y1_E6END[2] Tile_X0Y1_E6END[3] Tile_X0Y1_E6END[4]
+ Tile_X0Y1_E6END[5] Tile_X0Y1_E6END[6] Tile_X0Y1_E6END[7] Tile_X0Y1_E6END[8] Tile_X0Y1_E6END[9]
+ Tile_X0Y1_EE4END[0] Tile_X0Y1_EE4END[10] Tile_X0Y1_EE4END[11] Tile_X0Y1_EE4END[12]
+ Tile_X0Y1_EE4END[13] Tile_X0Y1_EE4END[14] Tile_X0Y1_EE4END[15] Tile_X0Y1_EE4END[1]
+ Tile_X0Y1_EE4END[2] Tile_X0Y1_EE4END[3] Tile_X0Y1_EE4END[4] Tile_X0Y1_EE4END[5]
+ Tile_X0Y1_EE4END[6] Tile_X0Y1_EE4END[7] Tile_X0Y1_EE4END[8] Tile_X0Y1_EE4END[9]
+ Tile_X0Y1_FrameData[0] Tile_X0Y1_FrameData[10] Tile_X0Y1_FrameData[11] Tile_X0Y1_FrameData[12]
+ Tile_X0Y1_FrameData[13] Tile_X0Y1_FrameData[14] Tile_X0Y1_FrameData[15] Tile_X0Y1_FrameData[16]
+ Tile_X0Y1_FrameData[17] Tile_X0Y1_FrameData[18] Tile_X0Y1_FrameData[19] Tile_X0Y1_FrameData[1]
+ Tile_X0Y1_FrameData[20] Tile_X0Y1_FrameData[21] Tile_X0Y1_FrameData[22] Tile_X0Y1_FrameData[23]
+ Tile_X0Y1_FrameData[24] Tile_X0Y1_FrameData[25] Tile_X0Y1_FrameData[26] Tile_X0Y1_FrameData[27]
+ Tile_X0Y1_FrameData[28] Tile_X0Y1_FrameData[29] Tile_X0Y1_FrameData[2] Tile_X0Y1_FrameData[30]
+ Tile_X0Y1_FrameData[31] Tile_X0Y1_FrameData[3] Tile_X0Y1_FrameData[4] Tile_X0Y1_FrameData[5]
+ Tile_X0Y1_FrameData[6] Tile_X0Y1_FrameData[7] Tile_X0Y1_FrameData[8] Tile_X0Y1_FrameData[9]
+ Tile_X0Y1_FrameData_O[0] Tile_X0Y1_FrameData_O[10] Tile_X0Y1_FrameData_O[11] Tile_X0Y1_FrameData_O[12]
+ Tile_X0Y1_FrameData_O[13] Tile_X0Y1_FrameData_O[14] Tile_X0Y1_FrameData_O[15] Tile_X0Y1_FrameData_O[16]
+ Tile_X0Y1_FrameData_O[17] Tile_X0Y1_FrameData_O[18] Tile_X0Y1_FrameData_O[19] Tile_X0Y1_FrameData_O[1]
+ Tile_X0Y1_FrameData_O[20] Tile_X0Y1_FrameData_O[21] Tile_X0Y1_FrameData_O[22] Tile_X0Y1_FrameData_O[23]
+ Tile_X0Y1_FrameData_O[24] Tile_X0Y1_FrameData_O[25] Tile_X0Y1_FrameData_O[26] Tile_X0Y1_FrameData_O[27]
+ Tile_X0Y1_FrameData_O[28] Tile_X0Y1_FrameData_O[29] Tile_X0Y1_FrameData_O[2] Tile_X0Y1_FrameData_O[30]
+ Tile_X0Y1_FrameData_O[31] Tile_X0Y1_FrameData_O[3] Tile_X0Y1_FrameData_O[4] Tile_X0Y1_FrameData_O[5]
+ Tile_X0Y1_FrameData_O[6] Tile_X0Y1_FrameData_O[7] Tile_X0Y1_FrameData_O[8] Tile_X0Y1_FrameData_O[9]
+ Tile_X0Y1_FrameStrobe[0] Tile_X0Y1_FrameStrobe[10] Tile_X0Y1_FrameStrobe[11] Tile_X0Y1_FrameStrobe[12]
+ Tile_X0Y1_FrameStrobe[13] Tile_X0Y1_FrameStrobe[14] Tile_X0Y1_FrameStrobe[15] Tile_X0Y1_FrameStrobe[16]
+ Tile_X0Y1_FrameStrobe[17] Tile_X0Y1_FrameStrobe[18] Tile_X0Y1_FrameStrobe[19] Tile_X0Y1_FrameStrobe[1]
+ Tile_X0Y1_FrameStrobe[2] Tile_X0Y1_FrameStrobe[3] Tile_X0Y1_FrameStrobe[4] Tile_X0Y1_FrameStrobe[5]
+ Tile_X0Y1_FrameStrobe[6] Tile_X0Y1_FrameStrobe[7] Tile_X0Y1_FrameStrobe[8] Tile_X0Y1_FrameStrobe[9]
+ Tile_X0Y1_N1END[0] Tile_X0Y1_N1END[1] Tile_X0Y1_N1END[2] Tile_X0Y1_N1END[3] Tile_X0Y1_N2END[0]
+ Tile_X0Y1_N2END[1] Tile_X0Y1_N2END[2] Tile_X0Y1_N2END[3] Tile_X0Y1_N2END[4] Tile_X0Y1_N2END[5]
+ Tile_X0Y1_N2END[6] Tile_X0Y1_N2END[7] Tile_X0Y1_N2MID[0] Tile_X0Y1_N2MID[1] Tile_X0Y1_N2MID[2]
+ Tile_X0Y1_N2MID[3] Tile_X0Y1_N2MID[4] Tile_X0Y1_N2MID[5] Tile_X0Y1_N2MID[6] Tile_X0Y1_N2MID[7]
+ Tile_X0Y1_N4END[0] Tile_X0Y1_N4END[10] Tile_X0Y1_N4END[11] Tile_X0Y1_N4END[12] Tile_X0Y1_N4END[13]
+ Tile_X0Y1_N4END[14] Tile_X0Y1_N4END[15] Tile_X0Y1_N4END[1] Tile_X0Y1_N4END[2] Tile_X0Y1_N4END[3]
+ Tile_X0Y1_N4END[4] Tile_X0Y1_N4END[5] Tile_X0Y1_N4END[6] Tile_X0Y1_N4END[7] Tile_X0Y1_N4END[8]
+ Tile_X0Y1_N4END[9] Tile_X0Y1_S1BEG[0] Tile_X0Y1_S1BEG[1] Tile_X0Y1_S1BEG[2] Tile_X0Y1_S1BEG[3]
+ Tile_X0Y1_S2BEG[0] Tile_X0Y1_S2BEG[1] Tile_X0Y1_S2BEG[2] Tile_X0Y1_S2BEG[3] Tile_X0Y1_S2BEG[4]
+ Tile_X0Y1_S2BEG[5] Tile_X0Y1_S2BEG[6] Tile_X0Y1_S2BEG[7] Tile_X0Y1_S2BEGb[0] Tile_X0Y1_S2BEGb[1]
+ Tile_X0Y1_S2BEGb[2] Tile_X0Y1_S2BEGb[3] Tile_X0Y1_S2BEGb[4] Tile_X0Y1_S2BEGb[5]
+ Tile_X0Y1_S2BEGb[6] Tile_X0Y1_S2BEGb[7] Tile_X0Y1_S4BEG[0] Tile_X0Y1_S4BEG[10] Tile_X0Y1_S4BEG[11]
+ Tile_X0Y1_S4BEG[12] Tile_X0Y1_S4BEG[13] Tile_X0Y1_S4BEG[14] Tile_X0Y1_S4BEG[15]
+ Tile_X0Y1_S4BEG[1] Tile_X0Y1_S4BEG[2] Tile_X0Y1_S4BEG[3] Tile_X0Y1_S4BEG[4] Tile_X0Y1_S4BEG[5]
+ Tile_X0Y1_S4BEG[6] Tile_X0Y1_S4BEG[7] Tile_X0Y1_S4BEG[8] Tile_X0Y1_S4BEG[9] Tile_X0Y1_UserCLK
+ Tile_X0Y1_UserCLKo Tile_X0Y1_W1BEG[0] Tile_X0Y1_W1BEG[1] Tile_X0Y1_W1BEG[2] Tile_X0Y1_W1BEG[3]
+ Tile_X0Y1_W2BEG[0] Tile_X0Y1_W2BEG[1] Tile_X0Y1_W2BEG[2] Tile_X0Y1_W2BEG[3] Tile_X0Y1_W2BEG[4]
+ Tile_X0Y1_W2BEG[5] Tile_X0Y1_W2BEG[6] Tile_X0Y1_W2BEG[7] Tile_X0Y1_W2BEGb[0] Tile_X0Y1_W2BEGb[1]
+ Tile_X0Y1_W2BEGb[2] Tile_X0Y1_W2BEGb[3] Tile_X0Y1_W2BEGb[4] Tile_X0Y1_W2BEGb[5]
+ Tile_X0Y1_W2BEGb[6] Tile_X0Y1_W2BEGb[7] Tile_X0Y1_W6BEG[0] Tile_X0Y1_W6BEG[10] Tile_X0Y1_W6BEG[11]
+ Tile_X0Y1_W6BEG[1] Tile_X0Y1_W6BEG[2] Tile_X0Y1_W6BEG[3] Tile_X0Y1_W6BEG[4] Tile_X0Y1_W6BEG[5]
+ Tile_X0Y1_W6BEG[6] Tile_X0Y1_W6BEG[7] Tile_X0Y1_W6BEG[8] Tile_X0Y1_W6BEG[9] Tile_X0Y1_WW4BEG[0]
+ Tile_X0Y1_WW4BEG[10] Tile_X0Y1_WW4BEG[11] Tile_X0Y1_WW4BEG[12] Tile_X0Y1_WW4BEG[13]
+ Tile_X0Y1_WW4BEG[14] Tile_X0Y1_WW4BEG[15] Tile_X0Y1_WW4BEG[1] Tile_X0Y1_WW4BEG[2]
+ Tile_X0Y1_WW4BEG[3] Tile_X0Y1_WW4BEG[4] Tile_X0Y1_WW4BEG[5] Tile_X0Y1_WW4BEG[6]
+ Tile_X0Y1_WW4BEG[7] Tile_X0Y1_WW4BEG[8] Tile_X0Y1_WW4BEG[9] VGND VPWR
XFILLER_54_214 VPWR VGND sg13cmos5l_decap_8
X_0367_ _0367_/Q Tile_X0Y1_FrameData[11] VGND VPWR Tile_X0Y1_FrameStrobe[0] latch
X_0298_ _0298_/Q Tile_X0Y0_FrameData[18] VGND VPWR Tile_X0Y1_FrameStrobe[6] latch
XFILLER_22_100 VPWR VGND sg13cmos5l_decap_8
XFILLER_108_216 VPWR VGND sg13cmos5l_decap_8
XFILLER_108_227 VPWR VGND sg13cmos5l_fill_2
XFILLER_89_100 VPWR VGND sg13cmos5l_decap_8
XFILLER_133_21 VPWR VGND sg13cmos5l_decap_8
XFILLER_77_59 VPWR VGND sg13cmos5l_decap_4
XFILLER_93_14 VPWR VGND sg13cmos5l_decap_8
XFILLER_133_98 VPWR VGND sg13cmos5l_decap_8
XFILLER_26_63 VPWR VGND sg13cmos5l_fill_2
XFILLER_45_214 VPWR VGND sg13cmos5l_fill_2
XFILLER_60_228 VPWR VGND sg13cmos5l_fill_1
XFILLER_13_177 VPWR VGND sg13cmos5l_decap_8
XFILLER_42_40 VPWR VGND sg13cmos5l_decap_8
XFILLER_42_95 VPWR VGND sg13cmos5l_decap_8
XANTENNA__0900__X Tile_X0Y1_S2BEGb[0] VPWR VGND sg13cmos5l_antennanp
XFILLER_114_219 VPWR VGND sg13cmos5l_decap_8
XFILLER_3_56 VPWR VGND sg13cmos5l_decap_8
XFILLER_67_70 VPWR VGND sg13cmos5l_decap_8
X_0221_ _0221_/Q Tile_X0Y0_FrameData[31] VGND VPWR Tile_X0Y1_FrameStrobe[4] latch
X_0152_ _0152_/Q Tile_X0Y0_FrameData[4] VGND VPWR Tile_X0Y1_FrameStrobe[1] latch
XFILLER_83_91 VPWR VGND sg13cmos5l_decap_8
X_0083_ _0916_/A _1019_/X _1020_/X _0284_/Q VPWR VGND sg13cmos5l_mux2_1
XANTENNA__0810__X Tile_X0Y0_FrameStrobe_O[7] VPWR VGND sg13cmos5l_antennanp
XFILLER_66_0 VPWR VGND sg13cmos5l_decap_8
X_0985_ _0985_/X Tile_X0Y1_EE4END[3] Tile_X0Y1_EE4END[11] Tile_X0Y1_E6END[3] _1206_/X
+ _0428_/Q _0427_/Q VPWR VGND sg13cmos5l_mux4_1
XFILLER_8_181 VPWR VGND sg13cmos5l_decap_8
XFILLER_47_29 VPWR VGND sg13cmos5l_fill_2
X_0419_ _0419_/Q Tile_X0Y1_FrameData[23] VGND VPWR Tile_X0Y1_FrameStrobe[2] latch
XFILLER_103_57 VPWR VGND sg13cmos5l_decap_8
XFILLER_42_206 VPWR VGND sg13cmos5l_decap_8
XFILLER_63_28 VPWR VGND sg13cmos5l_decap_8
XFILLER_10_125 VPWR VGND sg13cmos5l_decap_8
XFILLER_12_43 VPWR VGND sg13cmos5l_decap_4
XANTENNA__0720__X Tile_X0Y0_W1BEG[1] VPWR VGND sg13cmos5l_antennanp
XFILLER_18_225 VPWR VGND sg13cmos5l_decap_4
XFILLER_77_169 VPWR VGND sg13cmos5l_decap_8
XFILLER_33_228 VPWR VGND sg13cmos5l_fill_1
XFILLER_139_182 VPWR VGND sg13cmos5l_fill_1
XFILLER_5_162 VPWR VGND sg13cmos5l_decap_4
X_0770_ Tile_X0Y0_WW4BEG[3] _1050_/X VPWR VGND sg13cmos5l_buf_1
XFILLER_5_184 VPWR VGND sg13cmos5l_decap_8
XFILLER_68_103 VPWR VGND sg13cmos5l_decap_8
XFILLER_83_128 VPWR VGND sg13cmos5l_fill_1
X_1184_ _1184_/X _0649_/Q _1209_/X _1213_/X _1196_/X _0448_/Q _0447_/Q VPWR VGND sg13cmos5l_mux4_1
X_0204_ _0204_/Q Tile_X0Y0_FrameData[16] VGND VPWR Tile_X0Y1_FrameStrobe[3] latch
X_0135_ _0135_/Q Tile_X0Y0_FrameData[21] VGND VPWR Tile_X0Y1_FrameStrobe[1] latch
XANTENNA__0805__X Tile_X0Y0_FrameStrobe_O[2] VPWR VGND sg13cmos5l_antennanp
XFILLER_137_119 VPWR VGND sg13cmos5l_decap_8
X_0968_ Tile_X0Y1_WW4BEG[11] _1174_/X VPWR VGND sg13cmos5l_buf_1
X_0899_ Tile_X0Y1_S2BEG[7] _1134_/X VPWR VGND sg13cmos5l_buf_1
XFILLER_114_12 VPWR VGND sg13cmos5l_decap_4
XFILLER_114_78 VPWR VGND sg13cmos5l_decap_8
XFILLER_59_147 VPWR VGND sg13cmos5l_decap_4
XFILLER_74_139 VPWR VGND sg13cmos5l_decap_8
XFILLER_130_66 VPWR VGND sg13cmos5l_decap_8
XFILLER_90_48 VPWR VGND sg13cmos5l_decap_8
XFILLER_139_64 VPWR VGND sg13cmos5l_fill_1
XFILLER_23_42 VPWR VGND sg13cmos5l_fill_2
XFILLER_99_68 VPWR VGND sg13cmos5l_decap_8
XFILLER_136_196 VPWR VGND sg13cmos5l_decap_8
XFILLER_2_165 VPWR VGND sg13cmos5l_decap_8
XFILLER_0_35 VPWR VGND sg13cmos5l_decap_8
XFILLER_64_82 VPWR VGND sg13cmos5l_decap_8
X_0822_ Tile_X0Y0_FrameStrobe_O[19] Tile_X0Y1_FrameStrobe[19] VPWR VGND sg13cmos5l_buf_1
XFILLER_127_174 VPWR VGND sg13cmos5l_decap_8
XFILLER_43_2 VPWR VGND sg13cmos5l_fill_1
X_0753_ Tile_X0Y0_N4BEG[2] Tile_X0Y1_N4END[10] VPWR VGND sg13cmos5l_buf_1
X_0684_ _0684_/L_HI VPWR VGND sg13cmos5l_tiehi
XFILLER_29_0 VPWR VGND sg13cmos5l_decap_4
XFILLER_71_109 VPWR VGND sg13cmos5l_decap_8
X_1098_ _1098_/X _1109_/X Tile_X0Y1_N2MID[6] Tile_X0Y0_S2MID[6] Tile_X0Y0_S2END[6]
+ _0104_/Q _0103_/Q VPWR VGND sg13cmos5l_mux4_1
X_1167_ _1167_/X _0644_/Q _0648_/Q _1214_/X _1198_/X _0482_/Q _0481_/Q VPWR VGND sg13cmos5l_mux4_1
X_0118_ _0118_/Q Tile_X0Y0_FrameData[6] VGND VPWR Tile_X0Y1_FrameStrobe[0] latch
XFILLER_100_47 VPWR VGND sg13cmos5l_fill_2
XFILLER_109_56 VPWR VGND sg13cmos5l_fill_2
XFILLER_118_130 VPWR VGND sg13cmos5l_fill_1
XFILLER_118_196 VPWR VGND sg13cmos5l_decap_8
XFILLER_125_55 VPWR VGND sg13cmos5l_fill_2
XFILLER_133_133 VPWR VGND sg13cmos5l_decap_8
XFILLER_133_188 VPWR VGND sg13cmos5l_decap_8
XFILLER_18_64 VPWR VGND sg13cmos5l_decap_8
XFILLER_47_128 VPWR VGND sg13cmos5l_decap_8
XFILLER_133_0 VPWR VGND sg13cmos5l_decap_8
XFILLER_34_74 VPWR VGND sg13cmos5l_decap_8
XFILLER_70_142 VPWR VGND sg13cmos5l_decap_8
XFILLER_109_196 VPWR VGND sg13cmos5l_decap_8
XFILLER_124_133 VPWR VGND sg13cmos5l_decap_8
XFILLER_50_95 VPWR VGND sg13cmos5l_fill_2
XFILLER_38_139 VPWR VGND sg13cmos5l_fill_2
XFILLER_78_220 VPWR VGND sg13cmos5l_decap_8
XFILLER_61_131 VPWR VGND sg13cmos5l_decap_8
X_1021_ _1021_/X Tile_X0Y0_E1END[1] Tile_X0Y0_EE4END[13] Tile_X0Y0_E6END[5] _1089_/X
+ _0283_/Q _0282_/Q VPWR VGND sg13cmos5l_mux4_1
X_0805_ Tile_X0Y0_FrameStrobe_O[2] Tile_X0Y1_FrameStrobe[2] VPWR VGND sg13cmos5l_buf_1
XFILLER_115_122 VPWR VGND sg13cmos5l_fill_1
XFILLER_115_144 VPWR VGND sg13cmos5l_decap_4
XFILLER_115_199 VPWR VGND sg13cmos5l_decap_8
XFILLER_130_136 VPWR VGND sg13cmos5l_decap_8
X_0736_ Tile_X0Y0_W2BEGb[5] _1044_/X VPWR VGND sg13cmos5l_buf_1
X_0667_ _0667_/L_HI VPWR VGND sg13cmos5l_tiehi
X_0598_ _0598_/Q Tile_X0Y1_FrameData[4] VGND VPWR Tile_X0Y1_FrameStrobe[7] latch
XFILLER_37_150 VPWR VGND sg13cmos5l_fill_1
X_1219_ _1219_/X Tile_X0Y0_E2MID[7] Tile_X0Y0_E2END[7] Tile_X0Y0_E6END[8] _1092_/X
+ _0302_/Q _0301_/Q VPWR VGND sg13cmos5l_mux4_1
XFILLER_52_142 VPWR VGND sg13cmos5l_decap_4
XFILLER_106_166 VPWR VGND sg13cmos5l_decap_8
XFILLER_136_21 VPWR VGND sg13cmos5l_decap_8
XFILLER_20_76 VPWR VGND sg13cmos5l_fill_2
XFILLER_121_125 VPWR VGND sg13cmos5l_fill_2
XFILLER_136_98 VPWR VGND sg13cmos5l_decap_8
XFILLER_96_36 VPWR VGND sg13cmos5l_decap_8
XFILLER_28_172 VPWR VGND sg13cmos5l_decap_8
XFILLER_43_175 VPWR VGND sg13cmos5l_decap_8
XFILLER_90_215 VPWR VGND sg13cmos5l_fill_2
XFILLER_90_204 VPWR VGND sg13cmos5l_decap_8
XANTENNA__0903__X Tile_X0Y1_S2BEGb[3] VPWR VGND sg13cmos5l_antennanp
XFILLER_129_203 VPWR VGND sg13cmos5l_decap_8
XANTENNA_5 Tile_X0Y0_S2MID[1] VPWR VGND sg13cmos5l_antennanp
X_0521_ _0521_/Q Tile_X0Y1_FrameData[17] VGND VPWR Tile_X0Y1_FrameStrobe[5] latch
X_0452_ _0452_/Q Tile_X0Y1_FrameData[22] VGND VPWR Tile_X0Y1_FrameStrobe[3] latch
X_0383_ _0383_/Q Tile_X0Y1_FrameData[27] VGND VPWR Tile_X0Y1_FrameStrobe[1] latch
XFILLER_34_131 VPWR VGND sg13cmos5l_decap_8
X_1004_ _1004_/X Tile_X0Y0_E2MID[6] Tile_X0Y0_E2END[6] Tile_X0Y0_E6END[6] _1093_/X
+ _0336_/Q _0335_/Q VPWR VGND sg13cmos5l_mux4_1
XFILLER_96_0 VPWR VGND sg13cmos5l_decap_4
XANTENNA__0813__X Tile_X0Y0_FrameStrobe_O[10] VPWR VGND sg13cmos5l_antennanp
XFILLER_103_114 VPWR VGND sg13cmos5l_decap_8
XFILLER_66_28 VPWR VGND sg13cmos5l_decap_8
X_0719_ Tile_X0Y0_W1BEG[0] _1027_/X VPWR VGND sg13cmos5l_buf_1
XFILLER_122_12 VPWR VGND sg13cmos5l_fill_1
XFILLER_25_120 VPWR VGND sg13cmos5l_decap_8
XFILLER_82_49 VPWR VGND sg13cmos5l_decap_8
XANTENNA__0723__X Tile_X0Y0_W2BEG[0] VPWR VGND sg13cmos5l_antennanp
XFILLER_40_178 VPWR VGND sg13cmos5l_decap_8
XFILLER_56_83 VPWR VGND sg13cmos5l_decap_8
XFILLER_16_142 VPWR VGND sg13cmos5l_decap_8
XFILLER_16_153 VPWR VGND sg13cmos5l_fill_2
XFILLER_39_212 VPWR VGND sg13cmos5l_fill_2
XFILLER_39_223 VPWR VGND sg13cmos5l_decap_4
X_0504_ _0504_/Q Tile_X0Y1_FrameData[2] VGND VPWR Tile_X0Y1_FrameStrobe[4] latch
X_0435_ _0435_/Q Tile_X0Y1_FrameData[7] VGND VPWR Tile_X0Y1_FrameStrobe[2] latch
XANTENNA__0808__X Tile_X0Y0_FrameStrobe_O[5] VPWR VGND sg13cmos5l_antennanp
XFILLER_11_0 VPWR VGND sg13cmos5l_decap_4
X_0366_ _0366_/Q Tile_X0Y1_FrameData[12] VGND VPWR Tile_X0Y1_FrameStrobe[0] latch
X_0297_ _0297_/Q Tile_X0Y0_FrameData[19] VGND VPWR Tile_X0Y1_FrameStrobe[6] latch
XFILLER_117_45 VPWR VGND sg13cmos5l_decap_8
XFILLER_117_56 VPWR VGND sg13cmos5l_fill_1
XFILLER_131_220 VPWR VGND sg13cmos5l_decap_8
XANTENNA__0718__X Tile_X0Y0_UserCLKo VPWR VGND sg13cmos5l_antennanp
XFILLER_133_77 VPWR VGND sg13cmos5l_decap_8
XFILLER_89_156 VPWR VGND sg13cmos5l_decap_8
XFILLER_13_156 VPWR VGND sg13cmos5l_decap_8
XFILLER_26_31 VPWR VGND sg13cmos5l_fill_2
XFILLER_9_116 VPWR VGND sg13cmos5l_decap_8
XFILLER_3_35 VPWR VGND sg13cmos5l_decap_8
XFILLER_95_115 VPWR VGND sg13cmos5l_fill_2
XFILLER_95_104 VPWR VGND sg13cmos5l_decap_8
XFILLER_36_226 VPWR VGND sg13cmos5l_fill_2
XFILLER_83_70 VPWR VGND sg13cmos5l_decap_8
X_0220_ _0220_/Q Tile_X0Y0_FrameData[0] VGND VPWR Tile_X0Y1_FrameStrobe[3] latch
X_0151_ _0151_/Q Tile_X0Y0_FrameData[5] VGND VPWR Tile_X0Y1_FrameStrobe[1] latch
X_0082_ _0763_/A _1011_/X _1012_/X _0320_/Q VPWR VGND sg13cmos5l_mux2_1
XFILLER_95_159 VPWR VGND sg13cmos5l_decap_4
X_0984_ _0984_/X Tile_X0Y1_EE4END[2] Tile_X0Y1_EE4END[10] Tile_X0Y1_E6END[2] _1205_/X
+ _0430_/Q _0429_/Q VPWR VGND sg13cmos5l_mux4_1
XFILLER_113_220 VPWR VGND sg13cmos5l_decap_8
XFILLER_59_0 VPWR VGND sg13cmos5l_decap_4
XFILLER_8_160 VPWR VGND sg13cmos5l_decap_8
XFILLER_27_215 VPWR VGND sg13cmos5l_fill_2
XFILLER_86_126 VPWR VGND sg13cmos5l_fill_2
X_0418_ _0418_/Q Tile_X0Y1_FrameData[24] VGND VPWR Tile_X0Y1_FrameStrobe[2] latch
X_0349_ _0349_/Q Tile_X0Y1_FrameData[29] VGND VPWR Tile_X0Y1_FrameStrobe[0] latch
XFILLER_137_7 VPWR VGND sg13cmos5l_decap_8
XFILLER_104_220 VPWR VGND sg13cmos5l_decap_8
XFILLER_12_99 VPWR VGND sg13cmos5l_fill_1
XFILLER_37_96 VPWR VGND sg13cmos5l_fill_1
XFILLER_77_148 VPWR VGND sg13cmos5l_decap_8
XFILLER_92_129 VPWR VGND sg13cmos5l_decap_8
XFILLER_53_73 VPWR VGND sg13cmos5l_decap_8
XANTENNA__0911__X Tile_X0Y1_S4BEG[3] VPWR VGND sg13cmos5l_antennanp
XFILLER_139_194 VPWR VGND sg13cmos5l_decap_8
XFILLER_5_141 VPWR VGND sg13cmos5l_decap_8
XFILLER_110_223 VPWR VGND sg13cmos5l_decap_4
XFILLER_68_159 VPWR VGND sg13cmos5l_decap_8
X_0203_ _0203_/Q Tile_X0Y0_FrameData[17] VGND VPWR Tile_X0Y1_FrameStrobe[3] latch
XFILLER_76_181 VPWR VGND sg13cmos5l_decap_8
X_1183_ _1183_/X _0648_/Q _1210_/X _1214_/X _1195_/X _0450_/Q _0449_/Q VPWR VGND sg13cmos5l_mux4_1
X_0134_ _0134_/Q Tile_X0Y0_FrameData[22] VGND VPWR Tile_X0Y1_FrameStrobe[1] latch
XFILLER_91_151 VPWR VGND sg13cmos5l_fill_1
XANTENNA__0821__X Tile_X0Y0_FrameStrobe_O[18] VPWR VGND sg13cmos5l_antennanp
X_0967_ Tile_X0Y1_WW4BEG[10] _1173_/X VPWR VGND sg13cmos5l_buf_1
XFILLER_59_126 VPWR VGND sg13cmos5l_decap_8
X_0898_ Tile_X0Y1_S2BEG[6] _1133_/X VPWR VGND sg13cmos5l_buf_1
XFILLER_74_118 VPWR VGND sg13cmos5l_decap_8
XFILLER_82_184 VPWR VGND sg13cmos5l_decap_8
XFILLER_90_27 VPWR VGND sg13cmos5l_decap_8
XANTENNA__0731__X Tile_X0Y0_W2BEGb[0] VPWR VGND sg13cmos5l_antennanp
XFILLER_136_175 VPWR VGND sg13cmos5l_decap_8
XFILLER_139_54 VPWR VGND sg13cmos5l_fill_1
XFILLER_139_98 VPWR VGND sg13cmos5l_fill_1
XFILLER_2_122 VPWR VGND sg13cmos5l_fill_1
XANTENNA__0906__X Tile_X0Y1_S2BEGb[6] VPWR VGND sg13cmos5l_antennanp
XFILLER_0_14 VPWR VGND sg13cmos5l_decap_8
XFILLER_0_69 VPWR VGND sg13cmos5l_decap_8
XFILLER_64_61 VPWR VGND sg13cmos5l_decap_8
XFILLER_73_195 VPWR VGND sg13cmos5l_decap_8
XFILLER_80_71 VPWR VGND sg13cmos5l_fill_2
X_0821_ Tile_X0Y0_FrameStrobe_O[18] Tile_X0Y1_FrameStrobe[18] VPWR VGND sg13cmos5l_buf_1
X_0752_ Tile_X0Y0_N4BEG[1] Tile_X0Y1_N4END[9] VPWR VGND sg13cmos5l_buf_1
XFILLER_127_153 VPWR VGND sg13cmos5l_decap_8
X_0683_ _0683_/L_HI VPWR VGND sg13cmos5l_tiehi
XFILLER_96_221 VPWR VGND sg13cmos5l_decap_8
X_1235_ _1235_/X Tile_X0Y0_E1END[1] Tile_X0Y0_E6END[1] _1101_/X _1235_/A3 _0152_/Q
+ _0151_/Q VPWR VGND sg13cmos5l_mux4_1
X_1166_ _1166_/X _0647_/Q _0651_/Q _1215_/X _1199_/X _0484_/Q _0483_/Q VPWR VGND sg13cmos5l_mux4_1
XANTENNA__0816__X Tile_X0Y0_FrameStrobe_O[13] VPWR VGND sg13cmos5l_antennanp
XFILLER_100_26 VPWR VGND sg13cmos5l_decap_8
XFILLER_100_59 VPWR VGND sg13cmos5l_decap_8
X_1097_ _1097_/X _1108_/X Tile_X0Y1_N2MID[5] Tile_X0Y0_S2MID[5] Tile_X0Y0_S2END[5]
+ _0106_/Q _0105_/Q VPWR VGND sg13cmos5l_mux4_1
X_0117_ _0117_/Q Tile_X0Y0_FrameData[7] VGND VPWR Tile_X0Y1_FrameStrobe[0] latch
XFILLER_109_35 VPWR VGND sg13cmos5l_decap_8
XFILLER_109_79 VPWR VGND sg13cmos5l_decap_8
XFILLER_118_153 VPWR VGND sg13cmos5l_decap_4
XFILLER_118_175 VPWR VGND sg13cmos5l_decap_8
XFILLER_133_112 VPWR VGND sg13cmos5l_decap_8
XFILLER_69_28 VPWR VGND sg13cmos5l_decap_8
XFILLER_69_39 VPWR VGND sg13cmos5l_fill_1
XFILLER_47_107 VPWR VGND sg13cmos5l_decap_8
XFILLER_85_49 VPWR VGND sg13cmos5l_decap_8
XFILLER_87_221 VPWR VGND sg13cmos5l_decap_8
XANTENNA__0726__X Tile_X0Y0_W2BEG[3] VPWR VGND sg13cmos5l_antennanp
XFILLER_141_88 VPWR VGND sg13cmos5l_decap_8
XFILLER_18_43 VPWR VGND sg13cmos5l_decap_8
XFILLER_11_210 VPWR VGND sg13cmos5l_decap_8
XFILLER_126_0 VPWR VGND sg13cmos5l_fill_2
XFILLER_140_2 VPWR VGND sg13cmos5l_fill_1
XFILLER_7_214 VPWR VGND sg13cmos5l_fill_2
XFILLER_124_112 VPWR VGND sg13cmos5l_decap_8
XFILLER_124_189 VPWR VGND sg13cmos5l_decap_8
XFILLER_38_118 VPWR VGND sg13cmos5l_decap_8
X_1020_ _1020_/X _1087_/X _1083_/X _1075_/X _1096_/X _0286_/Q _0285_/Q VPWR VGND sg13cmos5l_mux4_1
XFILLER_61_187 VPWR VGND sg13cmos5l_decap_8
XFILLER_98_4 VPWR VGND sg13cmos5l_fill_2
XFILLER_91_81 VPWR VGND sg13cmos5l_decap_4
XFILLER_91_70 VPWR VGND sg13cmos5l_decap_4
X_0804_ Tile_X0Y0_FrameStrobe_O[1] Tile_X0Y1_FrameStrobe[1] VPWR VGND sg13cmos5l_buf_1
X_0735_ Tile_X0Y0_W2BEGb[4] _1043_/X VPWR VGND sg13cmos5l_buf_1
XFILLER_130_115 VPWR VGND sg13cmos5l_decap_8
XFILLER_29_118 VPWR VGND sg13cmos5l_fill_1
XFILLER_41_0 VPWR VGND sg13cmos5l_decap_8
X_0666_ _0666_/L_HI VPWR VGND sg13cmos5l_tiehi
X_0597_ _0597_/Q Tile_X0Y1_FrameData[5] VGND VPWR Tile_X0Y1_FrameStrobe[7] latch
XFILLER_1_90 VPWR VGND sg13cmos5l_fill_2
XFILLER_52_121 VPWR VGND sg13cmos5l_decap_8
XFILLER_84_224 VPWR VGND sg13cmos5l_decap_4
X_1218_ _1218_/X Tile_X0Y1_N1END[3] Tile_X0Y1_N4END[3] _1230_/X Tile_X0Y0_S4END[7]
+ _0372_/Q _0371_/Q VPWR VGND sg13cmos5l_mux4_1
X_1149_ _1149_/X Tile_X0Y1_E2END[2] _0646_/Q _1197_/X _1200_/X _0518_/Q _0517_/Q VPWR
+ VGND sg13cmos5l_mux4_1
XFILLER_138_215 VPWR VGND sg13cmos5l_decap_8
XFILLER_52_165 VPWR VGND sg13cmos5l_decap_8
XFILLER_106_101 VPWR VGND sg13cmos5l_fill_2
XFILLER_136_77 VPWR VGND sg13cmos5l_decap_8
XFILLER_20_33 VPWR VGND sg13cmos5l_fill_1
XFILLER_4_228 VPWR VGND sg13cmos5l_fill_1
XFILLER_29_64 VPWR VGND sg13cmos5l_decap_8
XFILLER_29_75 VPWR VGND sg13cmos5l_fill_2
XFILLER_75_224 VPWR VGND sg13cmos5l_decap_4
XFILLER_43_154 VPWR VGND sg13cmos5l_decap_8
XFILLER_45_74 VPWR VGND sg13cmos5l_decap_8
XFILLER_90_227 VPWR VGND sg13cmos5l_fill_2
XANTENNA_6 Tile_X0Y0_S2MID[1] VPWR VGND sg13cmos5l_antennanp
XFILLER_61_95 VPWR VGND sg13cmos5l_fill_2
X_0520_ _0520_/Q Tile_X0Y1_FrameData[18] VGND VPWR Tile_X0Y1_FrameStrobe[5] latch
X_0451_ _0451_/Q Tile_X0Y1_FrameData[23] VGND VPWR Tile_X0Y1_FrameStrobe[3] latch
X_0382_ _0382_/Q Tile_X0Y1_FrameData[28] VGND VPWR Tile_X0Y1_FrameStrobe[1] latch
XFILLER_120_181 VPWR VGND sg13cmos5l_decap_8
XFILLER_13_4 VPWR VGND sg13cmos5l_fill_2
XFILLER_19_173 VPWR VGND sg13cmos5l_decap_8
XFILLER_81_205 VPWR VGND sg13cmos5l_fill_2
XFILLER_81_216 VPWR VGND sg13cmos5l_fill_1
XFILLER_81_227 VPWR VGND sg13cmos5l_fill_2
X_1003_ _1003_/X Tile_X0Y0_E2MID[7] Tile_X0Y0_E2END[7] Tile_X0Y0_E6END[7] _1092_/X
+ _0338_/Q _0337_/Q VPWR VGND sg13cmos5l_mux4_1
XFILLER_34_187 VPWR VGND sg13cmos5l_decap_8
XFILLER_89_0 VPWR VGND sg13cmos5l_fill_2
X_0718_ Tile_X0Y0_UserCLKo Tile_X0Y0_UserCLK VPWR VGND sg13cmos5l_buf_1
XFILLER_106_69 VPWR VGND sg13cmos5l_decap_8
XFILLER_57_213 VPWR VGND sg13cmos5l_fill_1
X_0649_ _0649_/Q Tile_X0Y1_UserCLK NPU_ACT_RDATA5 _0657_/L_HI VPWR VGND sg13cmos5l_dfrbpq_1
XFILLER_122_24 VPWR VGND sg13cmos5l_decap_4
XFILLER_25_187 VPWR VGND sg13cmos5l_decap_8
XFILLER_40_157 VPWR VGND sg13cmos5l_decap_8
XFILLER_31_98 VPWR VGND sg13cmos5l_decap_4
XANTENNA__0914__X Tile_X0Y1_S4BEG[6] VPWR VGND sg13cmos5l_antennanp
XFILLER_31_102 VPWR VGND sg13cmos5l_fill_1
XFILLER_72_94 VPWR VGND sg13cmos5l_decap_8
XFILLER_82_7 VPWR VGND sg13cmos5l_decap_8
X_0503_ _0503_/Q Tile_X0Y1_FrameData[3] VGND VPWR Tile_X0Y1_FrameStrobe[4] latch
X_0434_ _0434_/Q Tile_X0Y1_FrameData[8] VGND VPWR Tile_X0Y1_FrameStrobe[2] latch
X_0365_ _0365_/Q Tile_X0Y1_FrameData[13] VGND VPWR Tile_X0Y1_FrameStrobe[0] latch
XFILLER_98_146 VPWR VGND sg13cmos5l_decap_8
XFILLER_97_80 VPWR VGND sg13cmos5l_decap_4
XANTENNA__0824__X Tile_X0Y1_FrameData_O[0] VPWR VGND sg13cmos5l_antennanp
X_0296_ _0296_/Q Tile_X0Y0_FrameData[20] VGND VPWR Tile_X0Y1_FrameStrobe[6] latch
XFILLER_22_157 VPWR VGND sg13cmos5l_fill_1
XFILLER_22_179 VPWR VGND sg13cmos5l_fill_1
XFILLER_133_56 VPWR VGND sg13cmos5l_decap_8
XFILLER_45_216 VPWR VGND sg13cmos5l_fill_1
XFILLER_45_227 VPWR VGND sg13cmos5l_fill_2
XFILLER_93_49 VPWR VGND sg13cmos5l_decap_8
XANTENNA__0734__X Tile_X0Y0_W2BEGb[3] VPWR VGND sg13cmos5l_antennanp
XFILLER_13_102 VPWR VGND sg13cmos5l_decap_4
XFILLER_13_135 VPWR VGND sg13cmos5l_decap_8
XFILLER_60_219 VPWR VGND sg13cmos5l_decap_8
XANTENNA__0909__X Tile_X0Y1_S4BEG[1] VPWR VGND sg13cmos5l_antennanp
XFILLER_107_90 VPWR VGND sg13cmos5l_fill_1
XFILLER_3_14 VPWR VGND sg13cmos5l_decap_8
X_0150_ _0150_/Q Tile_X0Y0_FrameData[6] VGND VPWR Tile_X0Y1_FrameStrobe[1] latch
X_0081_ _0764_/A _1013_/X _1014_/X _0317_/Q VPWR VGND sg13cmos5l_mux2_1
XFILLER_80_4 VPWR VGND sg13cmos5l_fill_1
X_0983_ _0983_/X Tile_X0Y1_EE4END[1] Tile_X0Y1_EE4END[9] Tile_X0Y1_E6END[1] _1204_/X
+ _0432_/Q _0431_/Q VPWR VGND sg13cmos5l_mux4_1
XANTENNA__0819__X Tile_X0Y0_FrameStrobe_O[16] VPWR VGND sg13cmos5l_antennanp
XFILLER_27_227 VPWR VGND sg13cmos5l_fill_2
XFILLER_86_149 VPWR VGND sg13cmos5l_decap_8
X_0417_ _0417_/Q Tile_X0Y1_FrameData[25] VGND VPWR Tile_X0Y1_FrameStrobe[2] latch
X_0348_ _0348_/Q Tile_X0Y1_FrameData[30] VGND VPWR Tile_X0Y1_FrameStrobe[0] latch
X_0279_ _0279_/Q Tile_X0Y0_FrameData[5] VGND VPWR Tile_X0Y1_FrameStrobe[5] latch
XFILLER_12_23 VPWR VGND sg13cmos5l_fill_2
XFILLER_12_56 VPWR VGND sg13cmos5l_decap_8
XFILLER_6_109 VPWR VGND sg13cmos5l_decap_8
XANTENNA__0729__X Tile_X0Y0_W2BEG[6] VPWR VGND sg13cmos5l_antennanp
XFILLER_128_89 VPWR VGND sg13cmos5l_decap_8
XFILLER_77_127 VPWR VGND sg13cmos5l_decap_8
XFILLER_53_52 VPWR VGND sg13cmos5l_decap_8
XFILLER_5_120 VPWR VGND sg13cmos5l_decap_8
XFILLER_110_202 VPWR VGND sg13cmos5l_decap_8
XFILLER_68_138 VPWR VGND sg13cmos5l_decap_8
XFILLER_76_160 VPWR VGND sg13cmos5l_decap_8
X_1182_ _1182_/X Tile_X0Y1_N4END[3] Tile_X0Y0_S4END[7] _1211_/X _1215_/X _0452_/Q
+ _0451_/Q VPWR VGND sg13cmos5l_mux4_1
X_0202_ _0202_/Q Tile_X0Y0_FrameData[18] VGND VPWR Tile_X0Y1_FrameStrobe[3] latch
X_0133_ _0133_/Q Tile_X0Y0_FrameData[23] VGND VPWR Tile_X0Y1_FrameStrobe[1] latch
XFILLER_91_130 VPWR VGND sg13cmos5l_decap_8
XFILLER_71_0 VPWR VGND sg13cmos5l_decap_4
X_0897_ Tile_X0Y1_S2BEG[5] _1132_/X VPWR VGND sg13cmos5l_buf_1
X_0966_ Tile_X0Y1_WW4BEG[9] _1172_/X VPWR VGND sg13cmos5l_buf_1
XFILLER_59_105 VPWR VGND sg13cmos5l_decap_8
XFILLER_74_29 VPWR VGND sg13cmos5l_decap_8
XFILLER_82_163 VPWR VGND sg13cmos5l_decap_8
XFILLER_23_44 VPWR VGND sg13cmos5l_fill_1
XFILLER_128_4 VPWR VGND sg13cmos5l_fill_2
XFILLER_136_154 VPWR VGND sg13cmos5l_decap_8
XFILLER_139_77 VPWR VGND sg13cmos5l_decap_8
XFILLER_99_48 VPWR VGND sg13cmos5l_decap_8
XFILLER_65_119 VPWR VGND sg13cmos5l_decap_4
XFILLER_73_174 VPWR VGND sg13cmos5l_decap_8
XFILLER_9_13 VPWR VGND sg13cmos5l_decap_4
XANTENNA__0922__X Tile_X0Y1_S4BEG[14] VPWR VGND sg13cmos5l_antennanp
XFILLER_127_121 VPWR VGND sg13cmos5l_fill_1
XFILLER_127_132 VPWR VGND sg13cmos5l_decap_8
XFILLER_80_94 VPWR VGND sg13cmos5l_decap_8
X_0820_ Tile_X0Y0_FrameStrobe_O[17] Tile_X0Y1_FrameStrobe[17] VPWR VGND sg13cmos5l_buf_1
X_0751_ Tile_X0Y0_N4BEG[0] Tile_X0Y1_N4END[8] VPWR VGND sg13cmos5l_buf_1
X_0682_ _0682_/L_HI VPWR VGND sg13cmos5l_tiehi
XFILLER_96_200 VPWR VGND sg13cmos5l_decap_8
XFILLER_64_152 VPWR VGND sg13cmos5l_fill_2
X_1096_ _1096_/X _1107_/X Tile_X0Y1_N2MID[4] Tile_X0Y0_S2MID[4] Tile_X0Y0_S2END[4]
+ _0108_/Q _0107_/Q VPWR VGND sg13cmos5l_mux4_1
X_1234_ _1234_/X Tile_X0Y0_E1END[2] Tile_X0Y0_E6END[2] _1102_/X _1234_/A3 _0150_/Q
+ _0149_/Q VPWR VGND sg13cmos5l_mux4_1
X_1165_ _1165_/X _0646_/Q _0650_/Q _1216_/X _1200_/X _0486_/Q _0485_/Q VPWR VGND sg13cmos5l_mux4_1
X_0116_ _0116_/Q Tile_X0Y0_FrameData[8] VGND VPWR Tile_X0Y1_FrameStrobe[0] latch
XANTENNA__0832__X Tile_X0Y1_FrameData_O[8] VPWR VGND sg13cmos5l_antennanp
XFILLER_20_211 VPWR VGND sg13cmos5l_fill_2
XFILLER_118_121 VPWR VGND sg13cmos5l_decap_8
XFILLER_133_168 VPWR VGND sg13cmos5l_decap_8
X_0949_ Tile_X0Y1_W6BEG[4] _1183_/X VPWR VGND sg13cmos5l_buf_1
XFILLER_125_57 VPWR VGND sg13cmos5l_fill_1
XFILLER_125_68 VPWR VGND sg13cmos5l_fill_2
XFILLER_141_12 VPWR VGND sg13cmos5l_fill_2
XFILLER_141_45 VPWR VGND sg13cmos5l_decap_8
XFILLER_141_56 VPWR VGND sg13cmos5l_fill_1
XFILLER_141_67 VPWR VGND sg13cmos5l_decap_8
XFILLER_18_99 VPWR VGND sg13cmos5l_decap_8
XANTENNA__0742__X Tile_X0Y0_W6BEG[3] VPWR VGND sg13cmos5l_antennanp
XFILLER_109_132 VPWR VGND sg13cmos5l_fill_1
XFILLER_109_165 VPWR VGND sg13cmos5l_decap_8
XFILLER_119_0 VPWR VGND sg13cmos5l_fill_2
XFILLER_50_53 VPWR VGND sg13cmos5l_decap_8
XFILLER_109_176 VPWR VGND sg13cmos5l_fill_2
XFILLER_124_168 VPWR VGND sg13cmos5l_decap_8
XFILLER_1_0 VPWR VGND sg13cmos5l_decap_8
XFILLER_59_40 VPWR VGND sg13cmos5l_decap_4
XFILLER_59_84 VPWR VGND sg13cmos5l_decap_8
XANTENNA__0917__X Tile_X0Y1_S4BEG[9] VPWR VGND sg13cmos5l_antennanp
XFILLER_46_130 VPWR VGND sg13cmos5l_decap_8
XFILLER_46_163 VPWR VGND sg13cmos5l_decap_8
XFILLER_93_203 VPWR VGND sg13cmos5l_decap_8
XFILLER_61_166 VPWR VGND sg13cmos5l_decap_8
X_0803_ Tile_X0Y0_FrameStrobe_O[0] Tile_X0Y1_FrameStrobe[0] VPWR VGND sg13cmos5l_buf_1
X_0734_ Tile_X0Y0_W2BEGb[3] _1042_/X VPWR VGND sg13cmos5l_buf_1
X_0665_ _0665_/L_HI VPWR VGND sg13cmos5l_tiehi
XFILLER_34_0 VPWR VGND sg13cmos5l_fill_2
XFILLER_84_203 VPWR VGND sg13cmos5l_decap_8
X_0596_ _0596_/Q Tile_X0Y1_FrameData[6] VGND VPWR Tile_X0Y1_FrameStrobe[7] latch
XANTENNA__0827__X Tile_X0Y1_FrameData_O[3] VPWR VGND sg13cmos5l_antennanp
X_1079_ _1079_/X _1114_/X Tile_X0Y1_N4END[7] Tile_X0Y0_S1END[3] Tile_X0Y0_S4END[3]
+ _0118_/Q _0117_/Q VPWR VGND sg13cmos5l_mux4_1
X_1217_ _1217_/X Tile_X0Y1_N1END[2] Tile_X0Y1_N4END[2] _1229_/X Tile_X0Y0_S4END[6]
+ _0374_/Q _0373_/Q VPWR VGND sg13cmos5l_mux4_1
X_1148_ _1148_/X Tile_X0Y1_E2MID[3] _0645_/Q _1196_/X _1201_/X _0520_/Q _0519_/Q VPWR
+ VGND sg13cmos5l_mux4_1
XFILLER_121_149 VPWR VGND sg13cmos5l_decap_8
XFILLER_136_56 VPWR VGND sg13cmos5l_decap_8
XFILLER_4_207 VPWR VGND sg13cmos5l_decap_8
XANTENNA__0737__X Tile_X0Y0_W2BEGb[6] VPWR VGND sg13cmos5l_antennanp
XFILLER_28_130 VPWR VGND sg13cmos5l_decap_8
XFILLER_29_43 VPWR VGND sg13cmos5l_fill_2
XFILLER_29_87 VPWR VGND sg13cmos5l_decap_8
XFILLER_45_31 VPWR VGND sg13cmos5l_decap_8
XFILLER_75_203 VPWR VGND sg13cmos5l_decap_8
XFILLER_45_64 VPWR VGND sg13cmos5l_decap_4
XANTENNA_7 Tile_X0Y0_S2MID[2] VPWR VGND sg13cmos5l_antennanp
XFILLER_61_63 VPWR VGND sg13cmos5l_decap_4
XFILLER_6_14 VPWR VGND sg13cmos5l_decap_8
XFILLER_112_116 VPWR VGND sg13cmos5l_decap_8
X_0450_ _0450_/Q Tile_X0Y1_FrameData[24] VGND VPWR Tile_X0Y1_FrameStrobe[3] latch
X_0381_ _0381_/Q Tile_X0Y1_FrameData[29] VGND VPWR Tile_X0Y1_FrameStrobe[1] latch
XFILLER_19_141 VPWR VGND sg13cmos5l_decap_8
XFILLER_34_166 VPWR VGND sg13cmos5l_decap_8
X_1002_ _1002_/X Tile_X0Y0_E1END[3] Tile_X0Y0_E6END[7] _1079_/X _1078_/X _0340_/Q
+ _0339_/Q VPWR VGND sg13cmos5l_mux4_1
X_0717_ _0974_/A3 VPWR VGND sg13cmos5l_tielo
X_0648_ _0648_/Q Tile_X0Y1_UserCLK NPU_ACT_RDATA4 _0675_/L_HI VPWR VGND sg13cmos5l_dfrbpq_1
XFILLER_106_48 VPWR VGND sg13cmos5l_decap_8
XFILLER_111_160 VPWR VGND sg13cmos5l_fill_1
X_0579_ _0579_/Q Tile_X0Y1_FrameData[23] VGND VPWR Tile_X0Y1_FrameStrobe[7] latch
XFILLER_25_155 VPWR VGND sg13cmos5l_decap_4
XFILLER_25_166 VPWR VGND sg13cmos5l_decap_8
XFILLER_126_208 VPWR VGND sg13cmos5l_decap_8
XFILLER_48_203 VPWR VGND sg13cmos5l_decap_8
XFILLER_56_63 VPWR VGND sg13cmos5l_decap_4
XFILLER_63_228 VPWR VGND sg13cmos5l_fill_1
XFILLER_117_208 VPWR VGND sg13cmos5l_fill_2
XFILLER_16_199 VPWR VGND sg13cmos5l_decap_8
XFILLER_31_169 VPWR VGND sg13cmos5l_decap_8
XFILLER_72_73 VPWR VGND sg13cmos5l_decap_8
XANTENNA__0930__X Tile_X0Y1_W2BEG[1] VPWR VGND sg13cmos5l_antennanp
X_0502_ _0502_/Q Tile_X0Y1_FrameData[4] VGND VPWR Tile_X0Y1_FrameStrobe[4] latch
XFILLER_98_125 VPWR VGND sg13cmos5l_decap_8
XFILLER_39_214 VPWR VGND sg13cmos5l_fill_1
X_0433_ _0433_/Q Tile_X0Y1_FrameData[9] VGND VPWR Tile_X0Y1_FrameStrobe[2] latch
X_0364_ _0364_/Q Tile_X0Y1_FrameData[14] VGND VPWR Tile_X0Y1_FrameStrobe[0] latch
X_0295_ _0295_/Q Tile_X0Y0_FrameData[21] VGND VPWR Tile_X0Y1_FrameStrobe[6] latch
XFILLER_98_169 VPWR VGND sg13cmos5l_fill_1
XFILLER_22_114 VPWR VGND sg13cmos5l_decap_8
XFILLER_22_136 VPWR VGND sg13cmos5l_decap_8
XFILLER_54_228 VPWR VGND sg13cmos5l_fill_1
XANTENNA__0840__X Tile_X0Y1_FrameData_O[16] VPWR VGND sg13cmos5l_antennanp
XFILLER_117_14 VPWR VGND sg13cmos5l_fill_2
XFILLER_89_136 VPWR VGND sg13cmos5l_decap_8
XFILLER_89_114 VPWR VGND sg13cmos5l_decap_8
XFILLER_133_35 VPWR VGND sg13cmos5l_decap_8
XFILLER_93_28 VPWR VGND sg13cmos5l_decap_8
XFILLER_42_65 VPWR VGND sg13cmos5l_decap_8
XANTENNA__0750__X Tile_X0Y0_W6BEG[11] VPWR VGND sg13cmos5l_antennanp
XFILLER_101_0 VPWR VGND sg13cmos5l_fill_2
XFILLER_21_191 VPWR VGND sg13cmos5l_decap_8
XFILLER_67_84 VPWR VGND sg13cmos5l_decap_8
XANTENNA__0925__X Tile_X0Y1_W1BEG[0] VPWR VGND sg13cmos5l_antennanp
XFILLER_36_228 VPWR VGND sg13cmos5l_fill_1
X_0080_ _0923_/A _1141_/X _1142_/X _0531_/Q VPWR VGND sg13cmos5l_mux2_1
XFILLER_12_180 VPWR VGND sg13cmos5l_decap_8
X_0982_ _0982_/X Tile_X0Y1_EE4END[0] Tile_X0Y1_EE4END[8] Tile_X0Y1_E6END[0] _1203_/X
+ _0434_/Q _0433_/Q VPWR VGND sg13cmos5l_mux4_1
XFILLER_8_195 VPWR VGND sg13cmos5l_decap_8
XANTENNA__0835__X Tile_X0Y1_FrameData_O[11] VPWR VGND sg13cmos5l_antennanp
XFILLER_27_206 VPWR VGND sg13cmos5l_fill_1
X_0416_ _0416_/Q Tile_X0Y1_FrameData[26] VGND VPWR Tile_X0Y1_FrameStrobe[2] latch
X_0347_ _0347_/Q Tile_X0Y0_FrameData[31] VGND VPWR Tile_X0Y1_FrameStrobe[0] latch
X_0278_ _0278_/Q Tile_X0Y0_FrameData[6] VGND VPWR Tile_X0Y1_FrameStrobe[5] latch
XFILLER_10_117 VPWR VGND sg13cmos5l_decap_4
XFILLER_10_139 VPWR VGND sg13cmos5l_decap_8
XFILLER_50_220 VPWR VGND sg13cmos5l_decap_8
XFILLER_128_13 VPWR VGND sg13cmos5l_decap_8
XFILLER_128_68 VPWR VGND sg13cmos5l_decap_8
XFILLER_12_13 VPWR VGND sg13cmos5l_fill_2
XFILLER_5_7 VPWR VGND sg13cmos5l_decap_8
XFILLER_88_28 VPWR VGND sg13cmos5l_decap_8
XFILLER_77_117 VPWR VGND sg13cmos5l_fill_2
XFILLER_85_161 VPWR VGND sg13cmos5l_fill_1
XANTENNA__0745__X Tile_X0Y0_W6BEG[6] VPWR VGND sg13cmos5l_antennanp
XFILLER_85_194 VPWR VGND sg13cmos5l_decap_8
XFILLER_5_198 VPWR VGND sg13cmos5l_decap_8
XFILLER_68_117 VPWR VGND sg13cmos5l_decap_8
X_1181_ _1181_/X Tile_X0Y1_N4END[2] Tile_X0Y0_S4END[6] _1212_/X _1216_/X _0454_/Q
+ _0453_/Q VPWR VGND sg13cmos5l_mux4_1
X_0201_ _0201_/Q Tile_X0Y0_FrameData[19] VGND VPWR Tile_X0Y1_FrameStrobe[3] latch
X_0132_ _0132_/Q Tile_X0Y0_FrameData[24] VGND VPWR Tile_X0Y1_FrameStrobe[1] latch
XFILLER_64_0 VPWR VGND sg13cmos5l_decap_8
X_0896_ Tile_X0Y1_S2BEG[4] _1131_/X VPWR VGND sg13cmos5l_buf_1
X_0965_ Tile_X0Y1_WW4BEG[8] _1171_/X VPWR VGND sg13cmos5l_buf_1
XFILLER_99_220 VPWR VGND sg13cmos5l_decap_8
XFILLER_101_214 VPWR VGND sg13cmos5l_fill_2
XFILLER_4_91 VPWR VGND sg13cmos5l_decap_8
XFILLER_130_14 VPWR VGND sg13cmos5l_decap_8
XFILLER_23_220 VPWR VGND sg13cmos5l_decap_8
XFILLER_67_161 VPWR VGND sg13cmos5l_decap_4
XFILLER_136_133 VPWR VGND sg13cmos5l_decap_8
XFILLER_139_12 VPWR VGND sg13cmos5l_fill_2
XFILLER_23_89 VPWR VGND sg13cmos5l_decap_8
XFILLER_99_27 VPWR VGND sg13cmos5l_decap_8
XFILLER_2_102 VPWR VGND sg13cmos5l_fill_2
XFILLER_2_179 VPWR VGND sg13cmos5l_decap_8
XFILLER_0_49 VPWR VGND sg13cmos5l_decap_8
XFILLER_48_31 VPWR VGND sg13cmos5l_decap_8
XFILLER_48_42 VPWR VGND sg13cmos5l_fill_2
XFILLER_48_86 VPWR VGND sg13cmos5l_decap_8
XFILLER_58_161 VPWR VGND sg13cmos5l_fill_1
XFILLER_73_153 VPWR VGND sg13cmos5l_decap_8
XFILLER_14_220 VPWR VGND sg13cmos5l_decap_8
XFILLER_64_96 VPWR VGND sg13cmos5l_decap_8
XFILLER_80_40 VPWR VGND sg13cmos5l_decap_8
XFILLER_127_199 VPWR VGND sg13cmos5l_decap_8
X_0750_ Tile_X0Y0_W6BEG[11] _1074_/X VPWR VGND sg13cmos5l_buf_1
X_0681_ _0681_/L_HI VPWR VGND sg13cmos5l_tiehi
XFILLER_36_4 VPWR VGND sg13cmos5l_fill_2
X_1233_ _1233_/X Tile_X0Y0_EE4END[2] Tile_X0Y0_EE4END[10] Tile_X0Y0_E6END[2] _1090_/X
+ _0174_/Q _0173_/Q VPWR VGND sg13cmos5l_mux4_1
XFILLER_89_93 VPWR VGND sg13cmos5l_decap_8
XFILLER_49_183 VPWR VGND sg13cmos5l_decap_8
XFILLER_64_131 VPWR VGND sg13cmos5l_decap_8
X_1095_ _1095_/X _1106_/X Tile_X0Y1_N2MID[3] Tile_X0Y0_S2MID[3] Tile_X0Y0_S2END[3]
+ _0110_/Q _0109_/Q VPWR VGND sg13cmos5l_mux4_1
X_1164_ _1164_/X _0645_/Q _0649_/Q _1217_/X _1201_/X _0488_/Q _0487_/Q VPWR VGND sg13cmos5l_mux4_1
X_0115_ _0115_/Q Tile_X0Y0_FrameData[9] VGND VPWR Tile_X0Y1_FrameStrobe[0] latch
XFILLER_20_223 VPWR VGND sg13cmos5l_decap_4
X_0948_ Tile_X0Y1_W6BEG[3] _1182_/X VPWR VGND sg13cmos5l_buf_1
XFILLER_133_147 VPWR VGND sg13cmos5l_decap_8
X_0879_ Tile_X0Y0_FrameData_O[23] Tile_X0Y0_FrameData[23] VPWR VGND sg13cmos5l_buf_1
XFILLER_141_24 VPWR VGND sg13cmos5l_decap_4
XFILLER_34_88 VPWR VGND sg13cmos5l_decap_8
XFILLER_55_153 VPWR VGND sg13cmos5l_fill_2
XFILLER_70_156 VPWR VGND sg13cmos5l_decap_8
XFILLER_109_100 VPWR VGND sg13cmos5l_decap_8
XFILLER_109_144 VPWR VGND sg13cmos5l_decap_8
XFILLER_126_2 VPWR VGND sg13cmos5l_fill_1
XFILLER_7_205 VPWR VGND sg13cmos5l_decap_4
XFILLER_7_216 VPWR VGND sg13cmos5l_fill_1
XFILLER_7_227 VPWR VGND sg13cmos5l_fill_2
XFILLER_124_147 VPWR VGND sg13cmos5l_decap_8
XFILLER_78_201 VPWR VGND sg13cmos5l_decap_8
XFILLER_115_80 VPWR VGND sg13cmos5l_decap_4
XFILLER_46_153 VPWR VGND sg13cmos5l_fill_2
XANTENNA__0933__X Tile_X0Y1_W2BEG[4] VPWR VGND sg13cmos5l_antennanp
XFILLER_131_90 VPWR VGND sg13cmos5l_decap_8
XFILLER_61_145 VPWR VGND sg13cmos5l_decap_8
X_0802_ Tile_X0Y0_N1BEG[3] _1002_/X VPWR VGND sg13cmos5l_buf_1
XFILLER_91_50 VPWR VGND sg13cmos5l_decap_4
X_0733_ Tile_X0Y0_W2BEGb[2] _1041_/X VPWR VGND sg13cmos5l_buf_1
X_0664_ _0664_/L_HI VPWR VGND sg13cmos5l_tiehi
XFILLER_27_0 VPWR VGND sg13cmos5l_fill_1
X_1216_ _1216_/X Tile_X0Y1_N1END[1] Tile_X0Y1_N4END[1] _1228_/X Tile_X0Y0_S4END[5]
+ _0376_/Q _0375_/Q VPWR VGND sg13cmos5l_mux4_1
X_0595_ _0595_/Q Tile_X0Y1_FrameData[7] VGND VPWR Tile_X0Y1_FrameStrobe[7] latch
XANTENNA__0843__X Tile_X0Y1_FrameData_O[19] VPWR VGND sg13cmos5l_antennanp
XFILLER_111_16 VPWR VGND sg13cmos5l_fill_2
XFILLER_111_38 VPWR VGND sg13cmos5l_decap_8
XFILLER_1_92 VPWR VGND sg13cmos5l_fill_1
XFILLER_37_186 VPWR VGND sg13cmos5l_decap_8
XFILLER_37_197 VPWR VGND sg13cmos5l_fill_2
X_1078_ _1078_/X _1114_/X Tile_X0Y0_E6END[3] Tile_X0Y0_S1END[3] _1078_/A3 _0094_/Q
+ _0347_/Q VPWR VGND sg13cmos5l_mux4_1
X_1147_ _1147_/X Tile_X0Y1_E2MID[0] _0644_/Q _1195_/X _1202_/X _0522_/Q _0521_/Q VPWR
+ VGND sg13cmos5l_mux4_1
XFILLER_105_7 VPWR VGND sg13cmos5l_fill_1
XFILLER_114_191 VPWR VGND sg13cmos5l_fill_2
XFILLER_121_139 VPWR VGND sg13cmos5l_fill_2
XFILLER_136_35 VPWR VGND sg13cmos5l_decap_8
XFILLER_29_22 VPWR VGND sg13cmos5l_decap_8
XFILLER_28_186 VPWR VGND sg13cmos5l_decap_4
XFILLER_43_101 VPWR VGND sg13cmos5l_decap_8
XFILLER_45_54 VPWR VGND sg13cmos5l_fill_2
XANTENNA__0753__X Tile_X0Y0_N4BEG[2] VPWR VGND sg13cmos5l_antennanp
XFILLER_129_217 VPWR VGND sg13cmos5l_decap_8
XFILLER_129_228 VPWR VGND sg13cmos5l_fill_1
XFILLER_131_0 VPWR VGND sg13cmos5l_decap_8
XFILLER_43_189 VPWR VGND sg13cmos5l_decap_8
XANTENNA_8 Tile_X0Y0_S2MID[2] VPWR VGND sg13cmos5l_antennanp
XFILLER_61_97 VPWR VGND sg13cmos5l_fill_1
XFILLER_6_37 VPWR VGND sg13cmos5l_fill_1
XANTENNA__0928__X Tile_X0Y1_W1BEG[3] VPWR VGND sg13cmos5l_antennanp
XFILLER_86_83 VPWR VGND sg13cmos5l_decap_4
X_0380_ _0380_/Q Tile_X0Y1_FrameData[30] VGND VPWR Tile_X0Y1_FrameStrobe[1] latch
XFILLER_34_123 VPWR VGND sg13cmos5l_fill_1
XFILLER_81_207 VPWR VGND sg13cmos5l_fill_1
X_1001_ _1001_/X Tile_X0Y0_E1END[2] Tile_X0Y0_E6END[6] _1077_/X _1102_/X _0342_/Q
+ _0341_/Q VPWR VGND sg13cmos5l_mux4_1
XANTENNA__0612__Q NPU_WEIGHT_IN2 VPWR VGND sg13cmos5l_antennanp
XFILLER_135_209 VPWR VGND sg13cmos5l_decap_8
XFILLER_103_128 VPWR VGND sg13cmos5l_fill_2
X_0716_ _0975_/A3 VPWR VGND sg13cmos5l_tielo
X_0647_ _0647_/Q Tile_X0Y1_UserCLK NPU_ACT_RDATA3 _0677_/L_HI VPWR VGND sg13cmos5l_dfrbpq_1
X_0578_ _0578_/Q Tile_X0Y1_FrameData[24] VGND VPWR Tile_X0Y1_FrameStrobe[7] latch
XANTENNA__0838__X Tile_X0Y1_FrameData_O[14] VPWR VGND sg13cmos5l_antennanp
XFILLER_15_57 VPWR VGND sg13cmos5l_fill_1
XFILLER_25_134 VPWR VGND sg13cmos5l_decap_8
XANTENNA__0748__X Tile_X0Y0_W6BEG[9] VPWR VGND sg13cmos5l_antennanp
XFILLER_102_150 VPWR VGND sg13cmos5l_fill_1
XFILLER_16_178 VPWR VGND sg13cmos5l_decap_8
XFILLER_56_42 VPWR VGND sg13cmos5l_decap_8
XFILLER_56_97 VPWR VGND sg13cmos5l_decap_8
XFILLER_68_7 VPWR VGND sg13cmos5l_decap_8
X_0501_ _0501_/Q Tile_X0Y1_FrameData[5] VGND VPWR Tile_X0Y1_FrameStrobe[4] latch
X_0432_ _0432_/Q Tile_X0Y1_FrameData[10] VGND VPWR Tile_X0Y1_FrameStrobe[2] latch
XFILLER_54_207 VPWR VGND sg13cmos5l_decap_8
X_0363_ _0363_/Q Tile_X0Y1_FrameData[15] VGND VPWR Tile_X0Y1_FrameStrobe[0] latch
X_0294_ _0294_/Q Tile_X0Y0_FrameData[22] VGND VPWR Tile_X0Y1_FrameStrobe[6] latch
XFILLER_94_0 VPWR VGND sg13cmos5l_decap_4
XFILLER_108_209 VPWR VGND sg13cmos5l_decap_8
XFILLER_133_14 VPWR VGND sg13cmos5l_decap_8
XFILLER_97_192 VPWR VGND sg13cmos5l_decap_8
XFILLER_26_56 VPWR VGND sg13cmos5l_decap_8
XFILLER_21_170 VPWR VGND sg13cmos5l_decap_8
XFILLER_42_22 VPWR VGND sg13cmos5l_decap_8
XFILLER_42_88 VPWR VGND sg13cmos5l_decap_8
XFILLER_107_220 VPWR VGND sg13cmos5l_decap_8
XFILLER_122_223 VPWR VGND sg13cmos5l_decap_4
XFILLER_123_80 VPWR VGND sg13cmos5l_fill_1
XFILLER_3_49 VPWR VGND sg13cmos5l_decap_8
XFILLER_67_63 VPWR VGND sg13cmos5l_decap_8
XFILLER_83_84 VPWR VGND sg13cmos5l_decap_8
X_0981_ _0981_/X Tile_X0Y0_E1END[0] Tile_X0Y0_E6END[0] _1100_/X _0981_/A3 _0154_/Q
+ _0153_/Q VPWR VGND sg13cmos5l_mux4_1
XANTENNA__0941__X Tile_X0Y1_W2BEGb[4] VPWR VGND sg13cmos5l_antennanp
XFILLER_8_174 VPWR VGND sg13cmos5l_decap_8
XFILLER_113_201 VPWR VGND sg13cmos5l_decap_8
X_0415_ _0415_/Q Tile_X0Y1_FrameData[27] VGND VPWR Tile_X0Y1_FrameStrobe[2] latch
X_0346_ _0346_/Q Tile_X0Y0_FrameData[2] VGND VPWR Tile_X0Y1_FrameStrobe[7] latch
X_0277_ _0277_/Q Tile_X0Y0_FrameData[7] VGND VPWR Tile_X0Y1_FrameStrobe[5] latch
XFILLER_94_151 VPWR VGND sg13cmos5l_decap_8
XANTENNA__0851__X Tile_X0Y1_FrameData_O[27] VPWR VGND sg13cmos5l_antennanp
XFILLER_12_25 VPWR VGND sg13cmos5l_fill_1
XFILLER_12_36 VPWR VGND sg13cmos5l_decap_8
XFILLER_50_210 VPWR VGND sg13cmos5l_decap_8
XFILLER_104_201 VPWR VGND sg13cmos5l_fill_2
XFILLER_12_47 VPWR VGND sg13cmos5l_fill_2
XFILLER_53_87 VPWR VGND sg13cmos5l_decap_4
XANTENNA__0761__X Tile_X0Y0_N4BEG[10] VPWR VGND sg13cmos5l_antennanp
XFILLER_139_131 VPWR VGND sg13cmos5l_fill_1
XFILLER_139_142 VPWR VGND sg13cmos5l_decap_8
XFILLER_5_155 VPWR VGND sg13cmos5l_decap_8
XFILLER_5_177 VPWR VGND sg13cmos5l_decap_8
XANTENNA__0936__X Tile_X0Y1_W2BEG[7] VPWR VGND sg13cmos5l_antennanp
XFILLER_76_195 VPWR VGND sg13cmos5l_decap_8
X_1180_ _1180_/X Tile_X0Y1_N4END[1] Tile_X0Y0_S4END[5] _1213_/X _1217_/X _0456_/Q
+ _0455_/Q VPWR VGND sg13cmos5l_mux4_1
X_0200_ _0200_/Q Tile_X0Y0_FrameData[20] VGND VPWR Tile_X0Y1_FrameStrobe[3] latch
X_0131_ _0131_/Q Tile_X0Y0_FrameData[25] VGND VPWR Tile_X0Y1_FrameStrobe[1] latch
XFILLER_94_50 VPWR VGND sg13cmos5l_decap_8
X_0964_ Tile_X0Y1_WW4BEG[7] _1170_/X VPWR VGND sg13cmos5l_buf_1
XANTENNA__0620__Q NPU_ACT_WDATA2 VPWR VGND sg13cmos5l_antennanp
XFILLER_57_0 VPWR VGND sg13cmos5l_decap_8
X_0895_ Tile_X0Y1_S2BEG[3] _1130_/X VPWR VGND sg13cmos5l_buf_1
XANTENNA__0846__X Tile_X0Y1_FrameData_O[22] VPWR VGND sg13cmos5l_antennanp
XFILLER_114_27 VPWR VGND sg13cmos5l_decap_4
XFILLER_4_70 VPWR VGND sg13cmos5l_decap_8
XFILLER_67_140 VPWR VGND sg13cmos5l_decap_8
X_0329_ _0329_/Q Tile_X0Y0_FrameData[19] VGND VPWR Tile_X0Y1_FrameStrobe[7] latch
XFILLER_130_59 VPWR VGND sg13cmos5l_decap_8
XFILLER_23_210 VPWR VGND sg13cmos5l_decap_8
XFILLER_82_198 VPWR VGND sg13cmos5l_decap_8
XFILLER_135_7 VPWR VGND sg13cmos5l_decap_8
XFILLER_136_112 VPWR VGND sg13cmos5l_decap_8
XFILLER_136_189 VPWR VGND sg13cmos5l_decap_8
XFILLER_2_158 VPWR VGND sg13cmos5l_decap_8
XANTENNA__0756__X Tile_X0Y0_N4BEG[5] VPWR VGND sg13cmos5l_antennanp
XFILLER_0_28 VPWR VGND sg13cmos5l_decap_8
XFILLER_104_82 VPWR VGND sg13cmos5l_fill_2
XFILLER_48_98 VPWR VGND sg13cmos5l_decap_8
XFILLER_64_42 VPWR VGND sg13cmos5l_decap_8
XFILLER_73_132 VPWR VGND sg13cmos5l_decap_8
XFILLER_64_75 VPWR VGND sg13cmos5l_decap_8
XFILLER_127_167 VPWR VGND sg13cmos5l_decap_8
X_0680_ _0680_/L_HI VPWR VGND sg13cmos5l_tiehi
XFILLER_89_72 VPWR VGND sg13cmos5l_decap_8
XFILLER_29_4 VPWR VGND sg13cmos5l_fill_2
XFILLER_64_110 VPWR VGND sg13cmos5l_decap_8
X_1232_ _1232_/X Tile_X0Y0_EE4END[1] Tile_X0Y0_EE4END[9] Tile_X0Y0_E6END[1] _1089_/X
+ _0176_/Q _0175_/Q VPWR VGND sg13cmos5l_mux4_1
XFILLER_64_154 VPWR VGND sg13cmos5l_fill_1
XFILLER_64_165 VPWR VGND sg13cmos5l_fill_2
X_1094_ _1094_/X _1105_/X Tile_X0Y1_N2MID[2] Tile_X0Y0_S2MID[2] Tile_X0Y0_S2END[2]
+ _0112_/Q _0111_/Q VPWR VGND sg13cmos5l_mux4_1
X_1163_ _1163_/X _0644_/Q _0648_/Q _1218_/X _1202_/X _0490_/Q _0489_/Q VPWR VGND sg13cmos5l_mux4_1
X_0114_ _0114_/Q Tile_X0Y0_FrameData[10] VGND VPWR Tile_X0Y1_FrameStrobe[0] latch
XANTENNA__0615__Q NPU_WEIGHT_IN5 VPWR VGND sg13cmos5l_antennanp
XFILLER_118_134 VPWR VGND sg13cmos5l_fill_1
XFILLER_20_213 VPWR VGND sg13cmos5l_fill_1
X_0947_ Tile_X0Y1_W6BEG[2] _1181_/X VPWR VGND sg13cmos5l_buf_1
XFILLER_109_49 VPWR VGND sg13cmos5l_decap_8
XFILLER_118_189 VPWR VGND sg13cmos5l_decap_8
XFILLER_125_48 VPWR VGND sg13cmos5l_decap_8
XFILLER_133_126 VPWR VGND sg13cmos5l_decap_8
X_0878_ Tile_X0Y0_FrameData_O[22] Tile_X0Y0_FrameData[22] VPWR VGND sg13cmos5l_buf_1
XFILLER_18_57 VPWR VGND sg13cmos5l_decap_8
XFILLER_55_132 VPWR VGND sg13cmos5l_decap_8
XFILLER_11_224 VPWR VGND sg13cmos5l_decap_4
XFILLER_34_67 VPWR VGND sg13cmos5l_decap_8
XFILLER_109_189 VPWR VGND sg13cmos5l_decap_8
XFILLER_124_126 VPWR VGND sg13cmos5l_decap_8
XFILLER_78_213 VPWR VGND sg13cmos5l_decap_8
XFILLER_93_227 VPWR VGND sg13cmos5l_fill_2
XFILLER_46_121 VPWR VGND sg13cmos5l_fill_2
XFILLER_61_124 VPWR VGND sg13cmos5l_decap_8
X_0801_ Tile_X0Y0_N1BEG[2] _1001_/X VPWR VGND sg13cmos5l_buf_1
XFILLER_115_148 VPWR VGND sg13cmos5l_fill_2
XFILLER_130_129 VPWR VGND sg13cmos5l_decap_8
X_0732_ Tile_X0Y0_W2BEGb[1] _1040_/X VPWR VGND sg13cmos5l_buf_1
X_0663_ _0663_/L_HI VPWR VGND sg13cmos5l_tiehi
X_0594_ _0594_/Q Tile_X0Y1_FrameData[8] VGND VPWR Tile_X0Y1_FrameStrobe[7] latch
XFILLER_37_132 VPWR VGND sg13cmos5l_decap_8
X_1215_ _1215_/X Tile_X0Y1_N1END[0] Tile_X0Y1_N4END[0] _1227_/X Tile_X0Y0_S4END[4]
+ _0378_/Q _0377_/Q VPWR VGND sg13cmos5l_mux4_1
X_1146_ _1146_/X Tile_X0Y1_N1END[3] _1230_/X _0645_/Q _0648_/Q _0524_/Q _0523_/Q VPWR
+ VGND sg13cmos5l_mux4_1
XFILLER_52_135 VPWR VGND sg13cmos5l_decap_8
XFILLER_52_146 VPWR VGND sg13cmos5l_fill_1
XFILLER_52_179 VPWR VGND sg13cmos5l_decap_4
X_1077_ _1077_/X _1113_/X Tile_X0Y1_N4END[6] Tile_X0Y0_S1END[2] Tile_X0Y0_S4END[2]
+ _0120_/Q _0119_/Q VPWR VGND sg13cmos5l_mux4_1
XFILLER_136_14 VPWR VGND sg13cmos5l_decap_8
XFILLER_106_159 VPWR VGND sg13cmos5l_decap_8
XFILLER_121_118 VPWR VGND sg13cmos5l_decap_8
XFILLER_20_69 VPWR VGND sg13cmos5l_decap_8
XFILLER_29_12 VPWR VGND sg13cmos5l_decap_4
XFILLER_29_45 VPWR VGND sg13cmos5l_fill_1
XFILLER_96_29 VPWR VGND sg13cmos5l_decap_8
XFILLER_28_165 VPWR VGND sg13cmos5l_decap_8
XFILLER_43_168 VPWR VGND sg13cmos5l_decap_8
XFILLER_124_0 VPWR VGND sg13cmos5l_decap_4
XANTENNA_9 Tile_X0Y0_S2MID[2] VPWR VGND sg13cmos5l_antennanp
XFILLER_3_220 VPWR VGND sg13cmos5l_decap_8
XFILLER_105_192 VPWR VGND sg13cmos5l_decap_8
XFILLER_120_151 VPWR VGND sg13cmos5l_decap_8
XFILLER_120_162 VPWR VGND sg13cmos5l_fill_2
XFILLER_120_195 VPWR VGND sg13cmos5l_decap_8
XFILLER_19_110 VPWR VGND sg13cmos5l_decap_4
XFILLER_19_165 VPWR VGND sg13cmos5l_fill_1
XFILLER_66_227 VPWR VGND sg13cmos5l_fill_2
XFILLER_86_62 VPWR VGND sg13cmos5l_decap_8
X_1000_ _1000_/X Tile_X0Y0_E1END[1] Tile_X0Y0_E6END[5] _1076_/X _1101_/X _0344_/Q
+ _0343_/Q VPWR VGND sg13cmos5l_mux4_1
XANTENNA__0944__X Tile_X0Y1_W2BEGb[7] VPWR VGND sg13cmos5l_antennanp
XFILLER_34_102 VPWR VGND sg13cmos5l_decap_8
XFILLER_96_4 VPWR VGND sg13cmos5l_fill_2
X_0715_ _0976_/A3 VPWR VGND sg13cmos5l_tielo
XFILLER_103_107 VPWR VGND sg13cmos5l_decap_8
XFILLER_111_151 VPWR VGND sg13cmos5l_decap_8
X_0646_ _0646_/Q Tile_X0Y1_UserCLK NPU_ACT_RDATA2 _0678_/L_HI VPWR VGND sg13cmos5l_dfrbpq_1
X_0577_ _0577_/Q Tile_X0Y1_FrameData[25] VGND VPWR Tile_X0Y1_FrameStrobe[7] latch
XANTENNA__0854__X Tile_X0Y1_FrameData_O[30] VPWR VGND sg13cmos5l_antennanp
XFILLER_25_113 VPWR VGND sg13cmos5l_decap_8
XFILLER_57_227 VPWR VGND sg13cmos5l_fill_2
X_1129_ _1129_/X Tile_X0Y1_E2MID[5] Tile_X0Y1_E2END[5] Tile_X0Y1_E6END[10] _1197_/X
+ _0554_/Q _0553_/Q VPWR VGND sg13cmos5l_mux4_1
XFILLER_40_105 VPWR VGND sg13cmos5l_fill_2
XFILLER_134_210 VPWR VGND sg13cmos5l_decap_8
XFILLER_31_57 VPWR VGND sg13cmos5l_fill_2
XFILLER_102_140 VPWR VGND sg13cmos5l_fill_1
XFILLER_48_227 VPWR VGND sg13cmos5l_fill_2
XFILLER_56_21 VPWR VGND sg13cmos5l_decap_8
XANTENNA__0764__X Tile_X0Y0_N4BEG[13] VPWR VGND sg13cmos5l_antennanp
XFILLER_16_102 VPWR VGND sg13cmos5l_fill_2
XFILLER_56_76 VPWR VGND sg13cmos5l_decap_8
XANTENNA__0939__X Tile_X0Y1_W2BEGb[2] VPWR VGND sg13cmos5l_antennanp
XFILLER_21_90 VPWR VGND sg13cmos5l_decap_8
XFILLER_39_205 VPWR VGND sg13cmos5l_decap_8
X_0500_ _0500_/Q Tile_X0Y1_FrameData[6] VGND VPWR Tile_X0Y1_FrameStrobe[4] latch
X_0431_ _0431_/Q Tile_X0Y1_FrameData[11] VGND VPWR Tile_X0Y1_FrameStrobe[2] latch
X_0362_ _0362_/Q Tile_X0Y1_FrameData[16] VGND VPWR Tile_X0Y1_FrameStrobe[0] latch
XFILLER_11_4 VPWR VGND sg13cmos5l_fill_2
XFILLER_39_227 VPWR VGND sg13cmos5l_fill_2
X_0293_ _0293_/Q Tile_X0Y0_FrameData[23] VGND VPWR Tile_X0Y1_FrameStrobe[6] latch
XANTENNA__0623__Q NPU_ACT_WDATA5 VPWR VGND sg13cmos5l_antennanp
XFILLER_87_0 VPWR VGND sg13cmos5l_decap_8
XFILLER_116_210 VPWR VGND sg13cmos5l_decap_8
XFILLER_117_16 VPWR VGND sg13cmos5l_fill_1
XFILLER_117_38 VPWR VGND sg13cmos5l_decap_8
XANTENNA__0849__X Tile_X0Y1_FrameData_O[25] VPWR VGND sg13cmos5l_antennanp
X_0629_ NPU_ACT_ADDR3 Tile_X0Y1_UserCLK _0976_/X _0682_/L_HI VPWR VGND sg13cmos5l_dfrbpq_1
XFILLER_97_171 VPWR VGND sg13cmos5l_decap_8
XFILLER_89_149 VPWR VGND sg13cmos5l_decap_8
XFILLER_13_149 VPWR VGND sg13cmos5l_decap_8
XFILLER_26_68 VPWR VGND sg13cmos5l_decap_8
XFILLER_26_79 VPWR VGND sg13cmos5l_decap_4
XFILLER_9_109 VPWR VGND sg13cmos5l_decap_8
XANTENNA__0759__X Tile_X0Y0_N4BEG[8] VPWR VGND sg13cmos5l_antennanp
XFILLER_122_202 VPWR VGND sg13cmos5l_decap_8
XFILLER_3_28 VPWR VGND sg13cmos5l_decap_8
XFILLER_88_160 VPWR VGND sg13cmos5l_fill_1
XFILLER_67_42 VPWR VGND sg13cmos5l_decap_8
XFILLER_12_160 VPWR VGND sg13cmos5l_fill_2
X_0980_ _0980_/X Tile_X0Y0_E2MID[7] Tile_X0Y0_E2END[7] _1099_/X _0980_/A3 _0156_/Q
+ _0155_/Q VPWR VGND sg13cmos5l_mux4_1
XFILLER_59_4 VPWR VGND sg13cmos5l_fill_1
XFILLER_8_153 VPWR VGND sg13cmos5l_decap_8
XFILLER_79_182 VPWR VGND sg13cmos5l_decap_8
X_0414_ _0414_/Q Tile_X0Y1_FrameData[28] VGND VPWR Tile_X0Y1_FrameStrobe[2] latch
X_0345_ _0345_/Q Tile_X0Y0_FrameData[3] VGND VPWR Tile_X0Y1_FrameStrobe[7] latch
XFILLER_94_130 VPWR VGND sg13cmos5l_decap_8
XANTENNA__0618__Q NPU_ACT_WDATA0 VPWR VGND sg13cmos5l_antennanp
X_0276_ _0276_/Q Tile_X0Y0_FrameData[8] VGND VPWR Tile_X0Y1_FrameStrobe[5] latch
XFILLER_12_15 VPWR VGND sg13cmos5l_fill_1
XFILLER_104_213 VPWR VGND sg13cmos5l_decap_8
XFILLER_77_119 VPWR VGND sg13cmos5l_fill_1
XFILLER_88_19 VPWR VGND sg13cmos5l_fill_2
XFILLER_37_34 VPWR VGND sg13cmos5l_fill_2
XFILLER_85_130 VPWR VGND sg13cmos5l_fill_1
XFILLER_85_152 VPWR VGND sg13cmos5l_decap_8
XFILLER_139_110 VPWR VGND sg13cmos5l_decap_8
XFILLER_53_66 VPWR VGND sg13cmos5l_decap_8
XFILLER_139_187 VPWR VGND sg13cmos5l_decap_8
XFILLER_5_134 VPWR VGND sg13cmos5l_decap_8
XFILLER_110_216 VPWR VGND sg13cmos5l_decap_8
XFILLER_110_227 VPWR VGND sg13cmos5l_fill_2
XFILLER_134_91 VPWR VGND sg13cmos5l_decap_8
XFILLER_76_174 VPWR VGND sg13cmos5l_decap_8
X_0130_ _0130_/Q Tile_X0Y0_FrameData[26] VGND VPWR Tile_X0Y1_FrameStrobe[1] latch
XFILLER_94_95 VPWR VGND sg13cmos5l_decap_8
XFILLER_91_199 VPWR VGND sg13cmos5l_decap_8
XFILLER_91_188 VPWR VGND sg13cmos5l_decap_4
XFILLER_91_166 VPWR VGND sg13cmos5l_fill_1
XFILLER_91_144 VPWR VGND sg13cmos5l_decap_8
XANTENNA__0952__X Tile_X0Y1_W6BEG[7] VPWR VGND sg13cmos5l_antennanp
X_0894_ Tile_X0Y1_S2BEG[2] _1129_/X VPWR VGND sg13cmos5l_buf_1
X_0963_ Tile_X0Y1_WW4BEG[6] _1169_/X VPWR VGND sg13cmos5l_buf_1
XFILLER_101_205 VPWR VGND sg13cmos5l_decap_4
XFILLER_59_119 VPWR VGND sg13cmos5l_decap_8
XFILLER_101_216 VPWR VGND sg13cmos5l_fill_1
XFILLER_101_227 VPWR VGND sg13cmos5l_fill_2
XFILLER_67_196 VPWR VGND sg13cmos5l_fill_1
XFILLER_82_122 VPWR VGND sg13cmos5l_decap_8
XFILLER_82_133 VPWR VGND sg13cmos5l_fill_2
X_0328_ _0328_/Q Tile_X0Y0_FrameData[20] VGND VPWR Tile_X0Y1_FrameStrobe[7] latch
XANTENNA__0862__X Tile_X0Y0_FrameData_O[6] VPWR VGND sg13cmos5l_antennanp
XFILLER_82_177 VPWR VGND sg13cmos5l_decap_8
X_0259_ _0259_/Q Tile_X0Y0_FrameData[25] VGND VPWR Tile_X0Y1_FrameStrobe[5] latch
XFILLER_136_168 VPWR VGND sg13cmos5l_decap_8
XFILLER_2_137 VPWR VGND sg13cmos5l_fill_1
XFILLER_64_21 VPWR VGND sg13cmos5l_decap_8
XFILLER_64_54 VPWR VGND sg13cmos5l_decap_8
XFILLER_73_111 VPWR VGND sg13cmos5l_decap_8
XFILLER_73_188 VPWR VGND sg13cmos5l_fill_2
XANTENNA__0772__X Tile_X0Y0_WW4BEG[5] VPWR VGND sg13cmos5l_antennanp
XFILLER_127_102 VPWR VGND sg13cmos5l_decap_8
XFILLER_127_146 VPWR VGND sg13cmos5l_decap_8
XFILLER_129_91 VPWR VGND sg13cmos5l_decap_8
XFILLER_89_51 VPWR VGND sg13cmos5l_decap_8
XANTENNA__0947__X Tile_X0Y1_W6BEG[2] VPWR VGND sg13cmos5l_antennanp
X_1231_ _1231_/X Tile_X0Y0_EE4END[0] Tile_X0Y0_EE4END[8] Tile_X0Y0_E6END[0] _1088_/X
+ _0178_/Q _0177_/Q VPWR VGND sg13cmos5l_mux4_1
X_1162_ _1162_/X Tile_X0Y1_E2MID[5] _0651_/Q _1195_/X _1202_/X _0492_/Q _0491_/Q VPWR
+ VGND sg13cmos5l_mux4_1
XFILLER_96_214 VPWR VGND sg13cmos5l_decap_8
XFILLER_100_19 VPWR VGND sg13cmos5l_decap_8
X_1093_ _1093_/X _1104_/X Tile_X0Y1_N2MID[1] Tile_X0Y0_S2MID[1] Tile_X0Y0_S2END[1]
+ _0114_/Q _0113_/Q VPWR VGND sg13cmos5l_mux4_1
X_0113_ _0113_/Q Tile_X0Y0_FrameData[11] VGND VPWR Tile_X0Y1_FrameStrobe[0] latch
XANTENNA__0631__Q NPU_ACT_ADDR5 VPWR VGND sg13cmos5l_antennanp
XFILLER_118_146 VPWR VGND sg13cmos5l_decap_8
XFILLER_118_157 VPWR VGND sg13cmos5l_fill_1
XFILLER_118_168 VPWR VGND sg13cmos5l_decap_8
XFILLER_133_105 VPWR VGND sg13cmos5l_decap_8
X_0877_ Tile_X0Y0_FrameData_O[21] Tile_X0Y0_FrameData[21] VPWR VGND sg13cmos5l_buf_1
X_0946_ Tile_X0Y1_W6BEG[1] _1180_/X VPWR VGND sg13cmos5l_buf_1
XANTENNA__0857__X Tile_X0Y0_FrameData_O[1] VPWR VGND sg13cmos5l_antennanp
XFILLER_141_193 VPWR VGND sg13cmos5l_decap_8
XFILLER_87_203 VPWR VGND sg13cmos5l_decap_8
XFILLER_87_214 VPWR VGND sg13cmos5l_decap_8
XFILLER_11_203 VPWR VGND sg13cmos5l_decap_8
XFILLER_117_190 VPWR VGND sg13cmos5l_decap_8
XFILLER_50_67 VPWR VGND sg13cmos5l_fill_2
XANTENNA__0767__X Tile_X0Y0_WW4BEG[0] VPWR VGND sg13cmos5l_antennanp
XFILLER_115_93 VPWR VGND sg13cmos5l_decap_4
XFILLER_132_182 VPWR VGND sg13cmos5l_decap_8
XFILLER_59_98 VPWR VGND sg13cmos5l_decap_8
XFILLER_75_31 VPWR VGND sg13cmos5l_decap_8
XFILLER_75_42 VPWR VGND sg13cmos5l_fill_2
XFILLER_46_155 VPWR VGND sg13cmos5l_fill_1
XFILLER_46_177 VPWR VGND sg13cmos5l_decap_8
XFILLER_91_63 VPWR VGND sg13cmos5l_decap_8
X_0800_ Tile_X0Y0_N1BEG[1] _1000_/X VPWR VGND sg13cmos5l_buf_1
X_0731_ Tile_X0Y0_W2BEGb[0] _1039_/X VPWR VGND sg13cmos5l_buf_1
XFILLER_123_193 VPWR VGND sg13cmos5l_decap_8
XFILLER_130_108 VPWR VGND sg13cmos5l_decap_8
X_0662_ _0662_/L_HI VPWR VGND sg13cmos5l_tiehi
X_0593_ _0593_/Q Tile_X0Y1_FrameData[9] VGND VPWR Tile_X0Y1_FrameStrobe[7] latch
XFILLER_84_217 VPWR VGND sg13cmos5l_decap_8
XFILLER_84_228 VPWR VGND sg13cmos5l_fill_1
X_1214_ _1214_/X Tile_X0Y1_N1END[3] Tile_X0Y1_N4END[3] _1230_/X Tile_X0Y0_S4END[7]
+ _0380_/Q _0379_/Q VPWR VGND sg13cmos5l_mux4_1
X_1145_ _1145_/X Tile_X0Y1_N1END[2] _1229_/X _0644_/Q _0649_/Q _0526_/Q _0525_/Q VPWR
+ VGND sg13cmos5l_mux4_1
XANTENNA__0626__Q NPU_ACT_ADDR0 VPWR VGND sg13cmos5l_antennanp
XFILLER_138_208 VPWR VGND sg13cmos5l_decap_8
XFILLER_52_158 VPWR VGND sg13cmos5l_decap_8
XFILLER_60_191 VPWR VGND sg13cmos5l_decap_8
X_1076_ _1076_/X _1112_/X Tile_X0Y1_N4END[5] Tile_X0Y0_S1END[1] Tile_X0Y0_S4END[1]
+ _0122_/Q _0121_/Q VPWR VGND sg13cmos5l_mux4_1
X_0929_ Tile_X0Y1_W2BEG[0] _1147_/X VPWR VGND sg13cmos5l_buf_1
XFILLER_114_193 VPWR VGND sg13cmos5l_fill_1
XFILLER_28_100 VPWR VGND sg13cmos5l_fill_2
XFILLER_29_57 VPWR VGND sg13cmos5l_decap_8
XFILLER_75_217 VPWR VGND sg13cmos5l_decap_8
XFILLER_75_228 VPWR VGND sg13cmos5l_fill_1
XFILLER_43_147 VPWR VGND sg13cmos5l_decap_8
XFILLER_45_12 VPWR VGND sg13cmos5l_decap_4
XFILLER_45_45 VPWR VGND sg13cmos5l_fill_2
XFILLER_45_56 VPWR VGND sg13cmos5l_fill_1
XFILLER_117_0 VPWR VGND sg13cmos5l_decap_8
XFILLER_51_191 VPWR VGND sg13cmos5l_decap_8
XFILLER_105_171 VPWR VGND sg13cmos5l_decap_8
XFILLER_126_81 VPWR VGND sg13cmos5l_fill_1
XFILLER_120_174 VPWR VGND sg13cmos5l_decap_8
XFILLER_19_155 VPWR VGND sg13cmos5l_decap_4
XANTENNA__0960__X Tile_X0Y1_WW4BEG[3] VPWR VGND sg13cmos5l_antennanp
X_0714_ _0977_/A3 VPWR VGND sg13cmos5l_tielo
X_0645_ _0645_/Q Tile_X0Y1_UserCLK NPU_ACT_RDATA1 _0676_/L_HI VPWR VGND sg13cmos5l_dfrbpq_1
XFILLER_111_141 VPWR VGND sg13cmos5l_decap_4
XFILLER_111_196 VPWR VGND sg13cmos5l_decap_8
XFILLER_32_0 VPWR VGND sg13cmos5l_fill_2
X_0576_ _0576_/Q Tile_X0Y1_FrameData[26] VGND VPWR Tile_X0Y1_FrameStrobe[7] latch
XFILLER_122_17 VPWR VGND sg13cmos5l_decap_8
XFILLER_122_28 VPWR VGND sg13cmos5l_fill_1
X_1059_ _1059_/X _0636_/Q _0640_/Q _1091_/X _1095_/X _0210_/Q _0209_/Q VPWR VGND sg13cmos5l_mux4_1
X_1128_ _1128_/X Tile_X0Y1_E2MID[6] Tile_X0Y1_E2END[6] Tile_X0Y1_E6END[9] _1196_/X
+ _0556_/Q _0555_/Q VPWR VGND sg13cmos5l_mux4_1
XANTENNA__0091__Q NPU_XBAR_SEL1 VPWR VGND sg13cmos5l_antennanp
XANTENNA__0870__X Tile_X0Y0_FrameData_O[14] VPWR VGND sg13cmos5l_antennanp
XFILLER_0_202 VPWR VGND sg13cmos5l_decap_8
XFILLER_110_7 VPWR VGND sg13cmos5l_fill_2
XANTENNA__0780__X Tile_X0Y0_WW4BEG[13] VPWR VGND sg13cmos5l_antennanp
XFILLER_72_87 VPWR VGND sg13cmos5l_decap_8
XFILLER_125_211 VPWR VGND sg13cmos5l_decap_8
XFILLER_137_91 VPWR VGND sg13cmos5l_decap_8
X_0430_ _0430_/Q Tile_X0Y1_FrameData[12] VGND VPWR Tile_X0Y1_FrameStrobe[2] latch
X_0361_ _0361_/Q Tile_X0Y1_FrameData[17] VGND VPWR Tile_X0Y1_FrameStrobe[0] latch
XFILLER_98_139 VPWR VGND sg13cmos5l_decap_8
XFILLER_97_84 VPWR VGND sg13cmos5l_fill_1
XFILLER_97_73 VPWR VGND sg13cmos5l_decap_8
XANTENNA__0955__X Tile_X0Y1_W6BEG[10] VPWR VGND sg13cmos5l_antennanp
X_0292_ _0292_/Q Tile_X0Y0_FrameData[24] VGND VPWR Tile_X0Y1_FrameStrobe[6] latch
XFILLER_117_28 VPWR VGND sg13cmos5l_fill_2
XFILLER_131_214 VPWR VGND sg13cmos5l_fill_2
XFILLER_7_93 VPWR VGND sg13cmos5l_decap_8
X_0628_ NPU_ACT_ADDR2 Tile_X0Y1_UserCLK _0975_/X _0683_/L_HI VPWR VGND sg13cmos5l_dfrbpq_1
XFILLER_89_128 VPWR VGND sg13cmos5l_decap_4
XANTENNA__0865__X Tile_X0Y0_FrameData_O[9] VPWR VGND sg13cmos5l_antennanp
XFILLER_133_49 VPWR VGND sg13cmos5l_decap_8
X_0559_ _0559_/Q Tile_X0Y1_FrameData[11] VGND VPWR Tile_X0Y1_FrameStrobe[6] latch
XFILLER_97_150 VPWR VGND sg13cmos5l_decap_8
XFILLER_13_106 VPWR VGND sg13cmos5l_fill_1
XFILLER_13_128 VPWR VGND sg13cmos5l_decap_8
XFILLER_53_220 VPWR VGND sg13cmos5l_decap_8
XFILLER_107_50 VPWR VGND sg13cmos5l_fill_1
XFILLER_107_72 VPWR VGND sg13cmos5l_decap_8
XFILLER_67_21 VPWR VGND sg13cmos5l_decap_8
XANTENNA__0775__X Tile_X0Y0_WW4BEG[8] VPWR VGND sg13cmos5l_antennanp
XFILLER_44_220 VPWR VGND sg13cmos5l_decap_8
XFILLER_67_98 VPWR VGND sg13cmos5l_decap_8
XFILLER_12_194 VPWR VGND sg13cmos5l_decap_8
XFILLER_16_91 VPWR VGND sg13cmos5l_decap_8
XFILLER_8_132 VPWR VGND sg13cmos5l_decap_8
XFILLER_113_214 VPWR VGND sg13cmos5l_fill_2
X_0413_ _0413_/Q Tile_X0Y1_FrameData[29] VGND VPWR Tile_X0Y1_FrameStrobe[2] latch
X_0344_ _0344_/Q Tile_X0Y0_FrameData[4] VGND VPWR Tile_X0Y1_FrameStrobe[7] latch
X_0275_ _0275_/Q Tile_X0Y0_FrameData[9] VGND VPWR Tile_X0Y1_FrameStrobe[5] latch
XANTENNA__0634__Q NPU_ACT_ADDR8 VPWR VGND sg13cmos5l_antennanp
XFILLER_26_220 VPWR VGND sg13cmos5l_decap_8
XFILLER_41_212 VPWR VGND sg13cmos5l_decap_8
XFILLER_118_93 VPWR VGND sg13cmos5l_fill_2
XFILLER_5_113 VPWR VGND sg13cmos5l_decap_8
XFILLER_78_31 VPWR VGND sg13cmos5l_decap_8
XFILLER_134_70 VPWR VGND sg13cmos5l_decap_8
XFILLER_76_153 VPWR VGND sg13cmos5l_decap_8
XFILLER_78_53 VPWR VGND sg13cmos5l_fill_1
XFILLER_78_75 VPWR VGND sg13cmos5l_fill_1
XFILLER_17_220 VPWR VGND sg13cmos5l_decap_8
XFILLER_91_123 VPWR VGND sg13cmos5l_decap_8
XFILLER_71_4 VPWR VGND sg13cmos5l_fill_2
X_0893_ Tile_X0Y1_S2BEG[1] _1128_/X VPWR VGND sg13cmos5l_buf_1
X_0962_ Tile_X0Y1_WW4BEG[5] _1168_/X VPWR VGND sg13cmos5l_buf_1
XFILLER_99_212 VPWR VGND sg13cmos5l_decap_4
XANTENNA__0629__Q NPU_ACT_ADDR3 VPWR VGND sg13cmos5l_antennanp
XFILLER_82_156 VPWR VGND sg13cmos5l_decap_8
X_0327_ _0327_/Q Tile_X0Y0_FrameData[21] VGND VPWR Tile_X0Y1_FrameStrobe[7] latch
X_0258_ _0258_/Q Tile_X0Y0_FrameData[26] VGND VPWR Tile_X0Y1_FrameStrobe[5] latch
XFILLER_130_28 VPWR VGND sg13cmos5l_fill_2
X_0189_ _0189_/Q Tile_X0Y0_FrameData[31] VGND VPWR Tile_X0Y1_FrameStrobe[3] latch
XFILLER_136_147 VPWR VGND sg13cmos5l_decap_8
XFILLER_2_116 VPWR VGND sg13cmos5l_fill_2
XFILLER_3_7 VPWR VGND sg13cmos5l_decap_8
XFILLER_2_149 VPWR VGND sg13cmos5l_decap_4
XFILLER_104_84 VPWR VGND sg13cmos5l_fill_1
XFILLER_73_167 VPWR VGND sg13cmos5l_decap_8
XFILLER_9_17 VPWR VGND sg13cmos5l_fill_2
XFILLER_127_125 VPWR VGND sg13cmos5l_decap_8
XFILLER_80_87 VPWR VGND sg13cmos5l_decap_8
XFILLER_129_70 VPWR VGND sg13cmos5l_decap_8
XFILLER_89_30 VPWR VGND sg13cmos5l_decap_8
XFILLER_1_193 VPWR VGND sg13cmos5l_decap_8
XFILLER_49_197 VPWR VGND sg13cmos5l_decap_8
XFILLER_64_145 VPWR VGND sg13cmos5l_decap_8
X_1092_ _1092_/X _1103_/X Tile_X0Y1_N2MID[0] Tile_X0Y0_S2MID[0] Tile_X0Y0_S2END[0]
+ _0116_/Q _0115_/Q VPWR VGND sg13cmos5l_mux4_1
X_1230_ _1230_/X Tile_X0Y0_E1END[3] Tile_X0Y0_E6END[11] _1079_/X _1078_/X _0304_/Q
+ _0303_/Q VPWR VGND sg13cmos5l_mux4_1
X_1161_ _1161_/X Tile_X0Y1_E2MID[2] _0650_/Q _1196_/X _1201_/X _0494_/Q _0493_/Q VPWR
+ VGND sg13cmos5l_mux4_1
X_0112_ _0112_/Q Tile_X0Y0_FrameData[12] VGND VPWR Tile_X0Y1_FrameStrobe[0] latch
XANTENNA__0963__X Tile_X0Y1_WW4BEG[6] VPWR VGND sg13cmos5l_antennanp
XFILLER_20_204 VPWR VGND sg13cmos5l_decap_8
XFILLER_64_178 VPWR VGND sg13cmos5l_fill_2
XFILLER_118_103 VPWR VGND sg13cmos5l_decap_4
XFILLER_118_114 VPWR VGND sg13cmos5l_decap_8
XFILLER_126_180 VPWR VGND sg13cmos5l_decap_8
XFILLER_62_0 VPWR VGND sg13cmos5l_decap_8
X_0876_ Tile_X0Y0_FrameData_O[20] Tile_X0Y0_FrameData[20] VPWR VGND sg13cmos5l_buf_1
X_0945_ Tile_X0Y1_W6BEG[0] _1179_/X VPWR VGND sg13cmos5l_buf_1
XFILLER_125_39 VPWR VGND sg13cmos5l_fill_1
XFILLER_141_172 VPWR VGND sg13cmos5l_decap_8
XANTENNA__0873__X Tile_X0Y0_FrameData_O[17] VPWR VGND sg13cmos5l_antennanp
XFILLER_141_38 VPWR VGND sg13cmos5l_decap_8
XFILLER_55_101 VPWR VGND sg13cmos5l_fill_2
XFILLER_109_114 VPWR VGND sg13cmos5l_decap_4
XFILLER_109_125 VPWR VGND sg13cmos5l_decap_8
XFILLER_50_46 VPWR VGND sg13cmos5l_decap_8
XFILLER_109_158 VPWR VGND sg13cmos5l_decap_8
XFILLER_132_161 VPWR VGND sg13cmos5l_decap_8
XFILLER_59_33 VPWR VGND sg13cmos5l_decap_8
XFILLER_59_44 VPWR VGND sg13cmos5l_fill_2
XFILLER_59_77 VPWR VGND sg13cmos5l_decap_8
XFILLER_75_76 VPWR VGND sg13cmos5l_decap_4
XANTENNA__0783__X Tile_X0Y0_N2BEGb[0] VPWR VGND sg13cmos5l_antennanp
XFILLER_61_159 VPWR VGND sg13cmos5l_decap_8
X_0730_ Tile_X0Y0_W2BEG[7] _1038_/X VPWR VGND sg13cmos5l_buf_1
X_0661_ _0661_/L_HI VPWR VGND sg13cmos5l_tiehi
XANTENNA__0958__X Tile_X0Y1_WW4BEG[1] VPWR VGND sg13cmos5l_antennanp
XFILLER_123_172 VPWR VGND sg13cmos5l_decap_8
X_1213_ _1213_/X Tile_X0Y1_N1END[2] Tile_X0Y1_N4END[2] _1229_/X Tile_X0Y0_S4END[6]
+ _0382_/Q _0381_/Q VPWR VGND sg13cmos5l_mux4_1
X_0592_ _0592_/Q Tile_X0Y1_FrameData[10] VGND VPWR Tile_X0Y1_FrameStrobe[7] latch
X_1075_ _1075_/X _1111_/X Tile_X0Y1_N4END[4] Tile_X0Y0_S1END[0] Tile_X0Y0_S4END[0]
+ _0124_/Q _0123_/Q VPWR VGND sg13cmos5l_mux4_1
X_1144_ _1144_/X Tile_X0Y1_N1END[1] _1228_/X _0647_/Q _0650_/Q _0528_/Q _0527_/Q VPWR
+ VGND sg13cmos5l_mux4_1
XANTENNA__0868__X Tile_X0Y0_FrameData_O[12] VPWR VGND sg13cmos5l_antennanp
XFILLER_136_49 VPWR VGND sg13cmos5l_decap_8
X_0859_ Tile_X0Y0_FrameData_O[3] Tile_X0Y0_FrameData[3] VPWR VGND sg13cmos5l_buf_1
X_0928_ Tile_X0Y1_W1BEG[3] _1146_/X VPWR VGND sg13cmos5l_buf_1
XANTENNA__0089__Q NPU_ACT_WE VPWR VGND sg13cmos5l_antennanp
XFILLER_28_123 VPWR VGND sg13cmos5l_decap_8
XFILLER_29_36 VPWR VGND sg13cmos5l_decap_8
XFILLER_101_85 VPWR VGND sg13cmos5l_fill_1
XFILLER_43_115 VPWR VGND sg13cmos5l_fill_1
XFILLER_45_24 VPWR VGND sg13cmos5l_decap_8
XFILLER_45_68 VPWR VGND sg13cmos5l_fill_2
XFILLER_51_170 VPWR VGND sg13cmos5l_decap_8
XFILLER_137_220 VPWR VGND sg13cmos5l_decap_8
XFILLER_61_56 VPWR VGND sg13cmos5l_decap_8
XANTENNA__0778__X Tile_X0Y0_WW4BEG[11] VPWR VGND sg13cmos5l_antennanp
XFILLER_19_134 VPWR VGND sg13cmos5l_decap_8
XFILLER_34_159 VPWR VGND sg13cmos5l_decap_8
XFILLER_42_192 VPWR VGND sg13cmos5l_decap_8
X_0713_ _0978_/A3 VPWR VGND sg13cmos5l_tielo
X_0644_ _0644_/Q Tile_X0Y1_UserCLK NPU_ACT_RDATA0 _0671_/L_HI VPWR VGND sg13cmos5l_dfrbpq_1
XFILLER_25_0 VPWR VGND sg13cmos5l_decap_8
X_0575_ _0575_/Q Tile_X0Y1_FrameData[27] VGND VPWR Tile_X0Y1_FrameStrobe[7] latch
XFILLER_25_148 VPWR VGND sg13cmos5l_decap_8
XFILLER_40_107 VPWR VGND sg13cmos5l_fill_1
X_1058_ _1058_/X _0639_/Q _0643_/Q _1087_/X _1096_/X _0212_/Q _0211_/Q VPWR VGND sg13cmos5l_mux4_1
X_1127_ _1127_/X Tile_X0Y1_E2MID[7] Tile_X0Y1_E2END[7] Tile_X0Y1_E6END[8] _1195_/X
+ _0558_/Q _0557_/Q VPWR VGND sg13cmos5l_mux4_1
XFILLER_119_220 VPWR VGND sg13cmos5l_decap_8
XFILLER_0_225 VPWR VGND sg13cmos5l_decap_4
XFILLER_102_131 VPWR VGND sg13cmos5l_decap_8
XFILLER_103_7 VPWR VGND sg13cmos5l_fill_1
XFILLER_102_197 VPWR VGND sg13cmos5l_decap_8
XFILLER_56_56 VPWR VGND sg13cmos5l_decap_8
XFILLER_56_67 VPWR VGND sg13cmos5l_fill_2
XFILLER_71_221 VPWR VGND sg13cmos5l_decap_8
XFILLER_137_70 VPWR VGND sg13cmos5l_decap_8
XFILLER_98_118 VPWR VGND sg13cmos5l_decap_8
X_0360_ _0360_/Q Tile_X0Y1_FrameData[18] VGND VPWR Tile_X0Y1_FrameStrobe[0] latch
X_0291_ _0291_/Q Tile_X0Y0_FrameData[25] VGND VPWR Tile_X0Y1_FrameStrobe[6] latch
XANTENNA__0971__X Tile_X0Y1_WW4BEG[14] VPWR VGND sg13cmos5l_antennanp
XFILLER_22_107 VPWR VGND sg13cmos5l_decap_8
XFILLER_22_129 VPWR VGND sg13cmos5l_decap_8
XFILLER_30_173 VPWR VGND sg13cmos5l_fill_2
XFILLER_131_204 VPWR VGND sg13cmos5l_decap_4
XFILLER_7_83 VPWR VGND sg13cmos5l_fill_2
X_0627_ NPU_ACT_ADDR1 Tile_X0Y1_UserCLK _0974_/X _0684_/L_HI VPWR VGND sg13cmos5l_dfrbpq_1
X_0558_ _0558_/Q Tile_X0Y1_FrameData[12] VGND VPWR Tile_X0Y1_FrameStrobe[6] latch
XFILLER_89_107 VPWR VGND sg13cmos5l_decap_8
XFILLER_133_28 VPWR VGND sg13cmos5l_decap_8
X_0489_ _0489_/Q Tile_X0Y1_FrameData[17] VGND VPWR Tile_X0Y1_FrameStrobe[4] latch
XANTENNA__0881__X Tile_X0Y0_FrameData_O[25] VPWR VGND sg13cmos5l_antennanp
XFILLER_42_58 VPWR VGND sg13cmos5l_decap_8
XFILLER_107_212 VPWR VGND sg13cmos5l_decap_4
XFILLER_21_184 VPWR VGND sg13cmos5l_decap_8
XFILLER_67_77 VPWR VGND sg13cmos5l_decap_8
XFILLER_88_140 VPWR VGND sg13cmos5l_fill_2
XANTENNA__0791__X Tile_X0Y0_N2BEG[0] VPWR VGND sg13cmos5l_antennanp
XFILLER_123_61 VPWR VGND sg13cmos5l_decap_4
XFILLER_12_173 VPWR VGND sg13cmos5l_decap_8
XFILLER_66_7 VPWR VGND sg13cmos5l_decap_8
XFILLER_8_188 VPWR VGND sg13cmos5l_decap_8
X_0412_ _0412_/Q Tile_X0Y1_FrameData[30] VGND VPWR Tile_X0Y1_FrameStrobe[2] latch
XANTENNA__0966__X Tile_X0Y1_WW4BEG[9] VPWR VGND sg13cmos5l_antennanp
X_0343_ _0343_/Q Tile_X0Y0_FrameData[5] VGND VPWR Tile_X0Y1_FrameStrobe[7] latch
X_0274_ _0274_/Q Tile_X0Y0_FrameData[10] VGND VPWR Tile_X0Y1_FrameStrobe[5] latch
XFILLER_94_165 VPWR VGND sg13cmos5l_decap_4
XFILLER_92_0 VPWR VGND sg13cmos5l_decap_8
XANTENNA__0876__X Tile_X0Y0_FrameData_O[20] VPWR VGND sg13cmos5l_antennanp
XFILLER_85_121 VPWR VGND sg13cmos5l_decap_8
XFILLER_118_50 VPWR VGND sg13cmos5l_fill_1
XANTENNA__0786__X Tile_X0Y0_N2BEGb[3] VPWR VGND sg13cmos5l_antennanp
XFILLER_76_132 VPWR VGND sg13cmos5l_decap_8
X_0961_ Tile_X0Y1_WW4BEG[4] _1167_/X VPWR VGND sg13cmos5l_buf_1
X_0892_ Tile_X0Y1_S2BEG[0] _1127_/X VPWR VGND sg13cmos5l_buf_1
XFILLER_99_202 VPWR VGND sg13cmos5l_decap_4
XFILLER_4_84 VPWR VGND sg13cmos5l_decap_8
XFILLER_67_154 VPWR VGND sg13cmos5l_decap_8
XFILLER_67_165 VPWR VGND sg13cmos5l_fill_1
X_0326_ _0326_/Q Tile_X0Y0_FrameData[22] VGND VPWR Tile_X0Y1_FrameStrobe[7] latch
X_0257_ _0257_/Q Tile_X0Y0_FrameData[27] VGND VPWR Tile_X0Y1_FrameStrobe[5] latch
X_0188_ _0188_/Q Tile_X0Y0_FrameData[0] VGND VPWR Tile_X0Y1_FrameStrobe[2] latch
XFILLER_23_27 VPWR VGND sg13cmos5l_fill_1
XFILLER_136_126 VPWR VGND sg13cmos5l_decap_8
XFILLER_48_79 VPWR VGND sg13cmos5l_decap_8
XFILLER_58_165 VPWR VGND sg13cmos5l_fill_1
XFILLER_14_213 VPWR VGND sg13cmos5l_decap_8
XFILLER_64_89 VPWR VGND sg13cmos5l_decap_8
XFILLER_73_146 VPWR VGND sg13cmos5l_decap_8
XFILLER_80_33 VPWR VGND sg13cmos5l_decap_8
XFILLER_89_86 VPWR VGND sg13cmos5l_decap_8
XFILLER_49_176 VPWR VGND sg13cmos5l_decap_8
XFILLER_64_124 VPWR VGND sg13cmos5l_decap_8
X_1091_ _1091_/X _1114_/X Tile_X0Y1_N4END[7] Tile_X0Y0_S1END[3] Tile_X0Y0_S4END[3]
+ _0142_/Q _0141_/Q VPWR VGND sg13cmos5l_mux4_1
X_1160_ _1160_/X _0649_/Q _1197_/X _1200_/X _1194_/X _0496_/Q _0495_/Q VPWR VGND sg13cmos5l_mux4_1
X_0111_ _0111_/Q Tile_X0Y0_FrameData[13] VGND VPWR Tile_X0Y1_FrameStrobe[0] latch
XFILLER_20_227 VPWR VGND sg13cmos5l_fill_2
X_0944_ Tile_X0Y1_W2BEGb[7] _1162_/X VPWR VGND sg13cmos5l_buf_1
XFILLER_55_0 VPWR VGND sg13cmos5l_decap_4
X_0875_ Tile_X0Y0_FrameData_O[19] Tile_X0Y0_FrameData[19] VPWR VGND sg13cmos5l_buf_1
XFILLER_141_151 VPWR VGND sg13cmos5l_decap_8
XFILLER_141_17 VPWR VGND sg13cmos5l_decap_8
XFILLER_141_28 VPWR VGND sg13cmos5l_fill_1
XFILLER_34_37 VPWR VGND sg13cmos5l_fill_2
XFILLER_55_146 VPWR VGND sg13cmos5l_decap_8
XFILLER_63_190 VPWR VGND sg13cmos5l_fill_1
XFILLER_70_149 VPWR VGND sg13cmos5l_decap_8
X_0309_ _0309_/Q Tile_X0Y0_FrameData[7] VGND VPWR Tile_X0Y1_FrameStrobe[6] latch
XFILLER_133_7 VPWR VGND sg13cmos5l_decap_8
XFILLER_50_69 VPWR VGND sg13cmos5l_fill_1
XFILLER_7_209 VPWR VGND sg13cmos5l_fill_1
XFILLER_132_140 VPWR VGND sg13cmos5l_decap_8
XFILLER_78_227 VPWR VGND sg13cmos5l_fill_2
XFILLER_115_73 VPWR VGND sg13cmos5l_decap_8
XFILLER_115_84 VPWR VGND sg13cmos5l_fill_2
XFILLER_46_146 VPWR VGND sg13cmos5l_decap_8
XFILLER_131_83 VPWR VGND sg13cmos5l_decap_8
XFILLER_24_92 VPWR VGND sg13cmos5l_decap_4
XFILLER_61_138 VPWR VGND sg13cmos5l_decap_8
XFILLER_91_54 VPWR VGND sg13cmos5l_fill_2
XFILLER_91_43 VPWR VGND sg13cmos5l_decap_8
XFILLER_91_32 VPWR VGND sg13cmos5l_decap_4
XFILLER_115_118 VPWR VGND sg13cmos5l_decap_4
X_0660_ _0660_/L_HI VPWR VGND sg13cmos5l_tiehi
X_0591_ _0591_/Q Tile_X0Y1_FrameData[11] VGND VPWR Tile_X0Y1_FrameStrobe[7] latch
XFILLER_123_151 VPWR VGND sg13cmos5l_decap_8
XFILLER_69_227 VPWR VGND sg13cmos5l_fill_2
X_1212_ _1212_/X Tile_X0Y1_N1END[1] Tile_X0Y1_N4END[1] _1228_/X Tile_X0Y0_S4END[5]
+ _0384_/Q _0383_/Q VPWR VGND sg13cmos5l_mux4_1
XFILLER_37_146 VPWR VGND sg13cmos5l_decap_4
X_1074_ _1074_/X _0639_/Q _1088_/X _1087_/X _1099_/X _0180_/Q _0179_/Q VPWR VGND sg13cmos5l_mux4_1
X_1143_ _1143_/X Tile_X0Y1_N1END[0] _1227_/X _0646_/Q _0651_/Q _0530_/Q _0529_/Q VPWR
+ VGND sg13cmos5l_mux4_1
XFILLER_60_171 VPWR VGND sg13cmos5l_decap_8
X_0927_ Tile_X0Y1_W1BEG[2] _1145_/X VPWR VGND sg13cmos5l_buf_1
XFILLER_114_151 VPWR VGND sg13cmos5l_decap_8
XFILLER_114_184 VPWR VGND sg13cmos5l_decap_8
XFILLER_136_28 VPWR VGND sg13cmos5l_decap_8
X_0858_ Tile_X0Y0_FrameData_O[2] Tile_X0Y0_FrameData[2] VPWR VGND sg13cmos5l_buf_1
X_0789_ Tile_X0Y0_N2BEGb[6] _1109_/X VPWR VGND sg13cmos5l_buf_1
XANTENNA__0884__X Tile_X0Y0_FrameData_O[28] VPWR VGND sg13cmos5l_antennanp
XFILLER_28_179 VPWR VGND sg13cmos5l_decap_8
XFILLER_36_190 VPWR VGND sg13cmos5l_decap_4
XFILLER_105_151 VPWR VGND sg13cmos5l_decap_4
XFILLER_10_61 VPWR VGND sg13cmos5l_decap_8
XFILLER_10_83 VPWR VGND sg13cmos5l_fill_2
XFILLER_120_121 VPWR VGND sg13cmos5l_fill_2
XFILLER_126_50 VPWR VGND sg13cmos5l_fill_1
XFILLER_86_76 VPWR VGND sg13cmos5l_decap_8
XANTENNA__0794__X Tile_X0Y0_N2BEG[3] VPWR VGND sg13cmos5l_antennanp
XFILLER_34_116 VPWR VGND sg13cmos5l_decap_8
XFILLER_34_138 VPWR VGND sg13cmos5l_decap_8
XFILLER_35_80 VPWR VGND sg13cmos5l_decap_8
XANTENNA__0969__X Tile_X0Y1_WW4BEG[12] VPWR VGND sg13cmos5l_antennanp
XFILLER_111_110 VPWR VGND sg13cmos5l_fill_1
XFILLER_32_2 VPWR VGND sg13cmos5l_fill_1
X_0712_ _1191_/A3 VPWR VGND sg13cmos5l_tielo
X_0643_ _0643_/Q Tile_X0Y1_UserCLK NPU_OUT_ACT7 _0673_/L_HI VPWR VGND sg13cmos5l_dfrbpq_1
X_0574_ _0574_/Q Tile_X0Y1_FrameData[28] VGND VPWR Tile_X0Y1_FrameStrobe[7] latch
XFILLER_111_132 VPWR VGND sg13cmos5l_fill_2
XFILLER_18_0 VPWR VGND sg13cmos5l_fill_1
X_1126_ _1126_/X Tile_X0Y1_E1END[3] Tile_X0Y1_E6END[11] _1218_/X _1194_/X _0560_/Q
+ _0559_/Q VPWR VGND sg13cmos5l_mux4_1
XFILLER_25_127 VPWR VGND sg13cmos5l_decap_8
XFILLER_33_193 VPWR VGND sg13cmos5l_fill_2
XFILLER_40_119 VPWR VGND sg13cmos5l_fill_2
XFILLER_80_211 VPWR VGND sg13cmos5l_decap_8
X_1057_ _1057_/X _0638_/Q _0642_/Q _1086_/X _1097_/X _0214_/Q _0213_/Q VPWR VGND sg13cmos5l_mux4_1
XANTENNA__0879__X Tile_X0Y0_FrameData_O[23] VPWR VGND sg13cmos5l_antennanp
XFILLER_134_224 VPWR VGND sg13cmos5l_decap_4
XFILLER_16_149 VPWR VGND sg13cmos5l_decap_4
XFILLER_56_35 VPWR VGND sg13cmos5l_decap_8
XFILLER_71_211 VPWR VGND sg13cmos5l_fill_2
XFILLER_122_0 VPWR VGND sg13cmos5l_decap_8
XANTENNA__0789__X Tile_X0Y0_N2BEGb[6] VPWR VGND sg13cmos5l_antennanp
XFILLER_97_31 VPWR VGND sg13cmos5l_decap_8
X_0290_ _0290_/Q Tile_X0Y0_FrameData[26] VGND VPWR Tile_X0Y1_FrameStrobe[6] latch
XFILLER_15_182 VPWR VGND sg13cmos5l_decap_8
XFILLER_116_224 VPWR VGND sg13cmos5l_decap_4
XFILLER_30_196 VPWR VGND sg13cmos5l_decap_8
XFILLER_7_40 VPWR VGND sg13cmos5l_decap_8
XFILLER_7_51 VPWR VGND sg13cmos5l_fill_2
XFILLER_131_216 VPWR VGND sg13cmos5l_fill_1
XFILLER_131_227 VPWR VGND sg13cmos5l_fill_2
X_0626_ NPU_ACT_ADDR0 Tile_X0Y1_UserCLK _0973_/X _0685_/L_HI VPWR VGND sg13cmos5l_dfrbpq_1
X_0557_ _0557_/Q Tile_X0Y1_FrameData[13] VGND VPWR Tile_X0Y1_FrameStrobe[6] latch
XFILLER_97_185 VPWR VGND sg13cmos5l_decap_8
XFILLER_26_27 VPWR VGND sg13cmos5l_decap_4
X_1109_ _1109_/X Tile_X0Y1_E2MID[1] Tile_X0Y1_E2END[1] Tile_X0Y1_E6END[1] _1201_/X
+ _0582_/Q _0581_/Q VPWR VGND sg13cmos5l_mux4_1
X_0488_ _0488_/Q Tile_X0Y1_FrameData[18] VGND VPWR Tile_X0Y1_FrameStrobe[4] latch
XFILLER_21_130 VPWR VGND sg13cmos5l_decap_8
XFILLER_21_141 VPWR VGND sg13cmos5l_fill_1
XFILLER_21_163 VPWR VGND sg13cmos5l_decap_8
XFILLER_42_15 VPWR VGND sg13cmos5l_decap_8
XFILLER_107_202 VPWR VGND sg13cmos5l_decap_4
XFILLER_122_216 VPWR VGND sg13cmos5l_decap_8
XFILLER_122_227 VPWR VGND sg13cmos5l_fill_2
XFILLER_67_56 VPWR VGND sg13cmos5l_decap_8
XFILLER_88_196 VPWR VGND sg13cmos5l_decap_8
XFILLER_123_95 VPWR VGND sg13cmos5l_decap_8
XFILLER_83_77 VPWR VGND sg13cmos5l_decap_8
XFILLER_8_167 VPWR VGND sg13cmos5l_decap_8
XFILLER_113_216 VPWR VGND sg13cmos5l_fill_1
XFILLER_113_227 VPWR VGND sg13cmos5l_fill_2
X_0411_ _0411_/Q Tile_X0Y1_FrameData[31] VGND VPWR Tile_X0Y1_FrameStrobe[2] latch
X_0342_ _0342_/Q Tile_X0Y0_FrameData[6] VGND VPWR Tile_X0Y1_FrameStrobe[7] latch
XFILLER_79_196 VPWR VGND sg13cmos5l_decap_8
X_0273_ _0273_/Q Tile_X0Y0_FrameData[11] VGND VPWR Tile_X0Y1_FrameStrobe[5] latch
XFILLER_94_144 VPWR VGND sg13cmos5l_decap_8
XFILLER_50_203 VPWR VGND sg13cmos5l_decap_8
XFILLER_104_227 VPWR VGND sg13cmos5l_fill_2
XFILLER_128_29 VPWR VGND sg13cmos5l_decap_4
X_0609_ _0609_/Q Tile_X0Y1_FrameData[31] VGND VPWR Tile_X0Y1_FrameStrobe[8] latch
XANTENNA__0892__X Tile_X0Y1_S2BEG[0] VPWR VGND sg13cmos5l_antennanp
XFILLER_26_211 VPWR VGND sg13cmos5l_decap_4
XFILLER_139_124 VPWR VGND sg13cmos5l_decap_8
XFILLER_5_148 VPWR VGND sg13cmos5l_decap_8
XFILLER_76_111 VPWR VGND sg13cmos5l_decap_8
XFILLER_76_188 VPWR VGND sg13cmos5l_decap_8
XFILLER_94_43 VPWR VGND sg13cmos5l_decap_8
XFILLER_94_32 VPWR VGND sg13cmos5l_decap_4
XFILLER_43_80 VPWR VGND sg13cmos5l_decap_8
X_0960_ Tile_X0Y1_WW4BEG[3] _1166_/X VPWR VGND sg13cmos5l_buf_1
X_0891_ Tile_X0Y1_S1BEG[3] _1126_/X VPWR VGND sg13cmos5l_buf_1
XFILLER_4_63 VPWR VGND sg13cmos5l_decap_8
XFILLER_67_133 VPWR VGND sg13cmos5l_decap_8
X_0325_ _0325_/Q Tile_X0Y0_FrameData[23] VGND VPWR Tile_X0Y1_FrameStrobe[7] latch
X_0256_ _0256_/Q Tile_X0Y0_FrameData[28] VGND VPWR Tile_X0Y1_FrameStrobe[5] latch
X_0187_ _0187_/Q Tile_X0Y0_FrameData[1] VGND VPWR Tile_X0Y1_FrameStrobe[2] latch
XFILLER_136_105 VPWR VGND sg13cmos5l_decap_8
XANTENNA__0887__X Tile_X0Y0_FrameData_O[31] VPWR VGND sg13cmos5l_antennanp
XFILLER_129_190 VPWR VGND sg13cmos5l_fill_2
XFILLER_104_53 VPWR VGND sg13cmos5l_fill_1
XFILLER_64_35 VPWR VGND sg13cmos5l_decap_8
XFILLER_73_125 VPWR VGND sg13cmos5l_decap_8
XFILLER_64_68 VPWR VGND sg13cmos5l_decap_8
XFILLER_81_191 VPWR VGND sg13cmos5l_decap_8
XFILLER_89_65 VPWR VGND sg13cmos5l_decap_8
XANTENNA__0797__X Tile_X0Y0_N2BEG[6] VPWR VGND sg13cmos5l_antennanp
XFILLER_135_182 VPWR VGND sg13cmos5l_decap_8
XFILLER_49_100 VPWR VGND sg13cmos5l_decap_4
XFILLER_96_228 VPWR VGND sg13cmos5l_fill_1
XFILLER_38_91 VPWR VGND sg13cmos5l_decap_8
XFILLER_64_103 VPWR VGND sg13cmos5l_decap_8
XFILLER_64_158 VPWR VGND sg13cmos5l_decap_8
X_1090_ _1090_/X _1113_/X Tile_X0Y1_N4END[6] Tile_X0Y0_S1END[2] Tile_X0Y0_S4END[2]
+ _0144_/Q _0143_/Q VPWR VGND sg13cmos5l_mux4_1
X_0110_ _0110_/Q Tile_X0Y0_FrameData[14] VGND VPWR Tile_X0Y1_FrameStrobe[0] latch
X_0874_ Tile_X0Y0_FrameData_O[18] Tile_X0Y0_FrameData[18] VPWR VGND sg13cmos5l_buf_1
X_0943_ Tile_X0Y1_W2BEGb[6] _1161_/X VPWR VGND sg13cmos5l_buf_1
XFILLER_133_119 VPWR VGND sg13cmos5l_decap_8
XFILLER_141_130 VPWR VGND sg13cmos5l_decap_8
XFILLER_48_0 VPWR VGND sg13cmos5l_fill_1
XFILLER_55_103 VPWR VGND sg13cmos5l_fill_1
XFILLER_87_228 VPWR VGND sg13cmos5l_fill_1
X_0308_ _0308_/Q Tile_X0Y0_FrameData[8] VGND VPWR Tile_X0Y1_FrameStrobe[6] latch
XFILLER_11_217 VPWR VGND sg13cmos5l_decap_8
XFILLER_11_228 VPWR VGND sg13cmos5l_fill_1
XFILLER_63_180 VPWR VGND sg13cmos5l_fill_1
X_0239_ _0239_/Q Tile_X0Y0_FrameData[13] VGND VPWR Tile_X0Y1_FrameStrobe[4] latch
XFILLER_117_160 VPWR VGND sg13cmos5l_decap_4
XFILLER_124_119 VPWR VGND sg13cmos5l_decap_8
XFILLER_132_196 VPWR VGND sg13cmos5l_decap_8
XFILLER_131_62 VPWR VGND sg13cmos5l_decap_8
XFILLER_61_117 VPWR VGND sg13cmos5l_decap_8
XFILLER_24_71 VPWR VGND sg13cmos5l_decap_8
XFILLER_123_130 VPWR VGND sg13cmos5l_decap_8
XFILLER_41_7 VPWR VGND sg13cmos5l_fill_2
X_0590_ _0590_/Q Tile_X0Y1_FrameData[12] VGND VPWR Tile_X0Y1_FrameStrobe[7] latch
XFILLER_49_90 VPWR VGND sg13cmos5l_fill_2
X_1211_ _1211_/X Tile_X0Y1_N1END[0] Tile_X0Y1_N4END[0] _1227_/X Tile_X0Y0_S4END[4]
+ _0386_/Q _0385_/Q VPWR VGND sg13cmos5l_mux4_1
X_1142_ _1142_/X _1210_/X _1214_/X _1218_/X _1202_/X _0533_/Q _0532_/Q VPWR VGND sg13cmos5l_mux4_1
XFILLER_92_220 VPWR VGND sg13cmos5l_decap_8
XFILLER_52_128 VPWR VGND sg13cmos5l_decap_8
XFILLER_60_150 VPWR VGND sg13cmos5l_decap_8
X_1073_ _1073_/X _0638_/Q _1089_/X _1086_/X _1098_/X _0182_/Q _0181_/Q VPWR VGND sg13cmos5l_mux4_1
X_0857_ Tile_X0Y0_FrameData_O[1] Tile_X0Y0_FrameData[1] VPWR VGND sg13cmos5l_buf_1
X_0926_ Tile_X0Y1_W1BEG[1] _1144_/X VPWR VGND sg13cmos5l_buf_1
XFILLER_114_174 VPWR VGND sg13cmos5l_fill_2
XFILLER_29_16 VPWR VGND sg13cmos5l_fill_2
X_0788_ Tile_X0Y0_N2BEGb[5] _1108_/X VPWR VGND sg13cmos5l_buf_1
XFILLER_83_220 VPWR VGND sg13cmos5l_decap_8
XFILLER_61_14 VPWR VGND sg13cmos5l_decap_8
XFILLER_124_4 VPWR VGND sg13cmos5l_fill_2
XFILLER_3_213 VPWR VGND sg13cmos5l_decap_8
XFILLER_105_185 VPWR VGND sg13cmos5l_decap_8
XFILLER_120_188 VPWR VGND sg13cmos5l_decap_8
XFILLER_19_103 VPWR VGND sg13cmos5l_decap_8
XFILLER_19_114 VPWR VGND sg13cmos5l_fill_2
XFILLER_86_33 VPWR VGND sg13cmos5l_fill_1
XFILLER_128_222 VPWR VGND sg13cmos5l_decap_8
X_0711_ _0980_/A3 VPWR VGND sg13cmos5l_tielo
X_0642_ _0642_/Q Tile_X0Y1_UserCLK NPU_OUT_ACT6 _0674_/L_HI VPWR VGND sg13cmos5l_dfrbpq_1
X_0573_ _0573_/Q Tile_X0Y1_FrameData[29] VGND VPWR Tile_X0Y1_FrameStrobe[7] latch
XFILLER_25_106 VPWR VGND sg13cmos5l_decap_8
X_1125_ _1125_/X Tile_X0Y1_E1END[2] Tile_X0Y1_E6END[10] _1217_/X _1193_/X _0562_/Q
+ _0561_/Q VPWR VGND sg13cmos5l_mux4_1
XFILLER_33_172 VPWR VGND sg13cmos5l_fill_2
X_1056_ _1056_/X _0637_/Q _0641_/Q _1085_/X _1098_/X _0216_/Q _0215_/Q VPWR VGND sg13cmos5l_mux4_1
XFILLER_134_203 VPWR VGND sg13cmos5l_decap_8
XFILLER_31_39 VPWR VGND sg13cmos5l_decap_4
X_0909_ Tile_X0Y1_S4BEG[1] Tile_X0Y0_S4END[9] VPWR VGND sg13cmos5l_buf_1
XANTENNA__0895__X Tile_X0Y1_S2BEG[3] VPWR VGND sg13cmos5l_antennanp
XFILLER_56_14 VPWR VGND sg13cmos5l_decap_8
XFILLER_24_161 VPWR VGND sg13cmos5l_decap_8
XFILLER_125_225 VPWR VGND sg13cmos5l_decap_4
XFILLER_140_228 VPWR VGND sg13cmos5l_fill_1
XFILLER_21_83 VPWR VGND sg13cmos5l_decap_8
XFILLER_47_220 VPWR VGND sg13cmos5l_decap_8
XFILLER_15_150 VPWR VGND sg13cmos5l_decap_8
XFILLER_116_203 VPWR VGND sg13cmos5l_decap_8
XFILLER_7_63 VPWR VGND sg13cmos5l_decap_4
XFILLER_7_85 VPWR VGND sg13cmos5l_fill_1
X_0625_ NPU_ACT_WDATA7 Tile_X0Y1_UserCLK _0989_/X _0690_/L_HI VPWR VGND sg13cmos5l_dfrbpq_1
XFILLER_30_0 VPWR VGND sg13cmos5l_decap_8
X_0556_ _0556_/Q Tile_X0Y1_FrameData[14] VGND VPWR Tile_X0Y1_FrameStrobe[6] latch
X_0487_ _0487_/Q Tile_X0Y1_FrameData[19] VGND VPWR Tile_X0Y1_FrameStrobe[4] latch
XFILLER_97_164 VPWR VGND sg13cmos5l_decap_8
XFILLER_97_120 VPWR VGND sg13cmos5l_decap_8
X_1039_ _1039_/X Tile_X0Y0_EE4END[6] _0636_/Q _1092_/X _1099_/X _0250_/Q _0249_/Q
+ VPWR VGND sg13cmos5l_mux4_1
X_1108_ _1108_/X Tile_X0Y1_E2MID[2] Tile_X0Y1_E2END[2] Tile_X0Y1_E6END[2] _1200_/X
+ _0584_/Q _0583_/Q VPWR VGND sg13cmos5l_mux4_1
XFILLER_107_86 VPWR VGND sg13cmos5l_decap_4
XFILLER_67_35 VPWR VGND sg13cmos5l_decap_8
XFILLER_12_142 VPWR VGND sg13cmos5l_decap_8
XFILLER_16_50 VPWR VGND sg13cmos5l_decap_4
XFILLER_8_102 VPWR VGND sg13cmos5l_fill_2
XFILLER_32_82 VPWR VGND sg13cmos5l_decap_8
XFILLER_8_146 VPWR VGND sg13cmos5l_decap_8
XFILLER_79_120 VPWR VGND sg13cmos5l_decap_8
XFILLER_79_131 VPWR VGND sg13cmos5l_fill_2
XFILLER_79_175 VPWR VGND sg13cmos5l_decap_8
X_0410_ _0410_/Q Tile_X0Y1_FrameData[0] VGND VPWR Tile_X0Y1_FrameStrobe[1] latch
X_0341_ _0341_/Q Tile_X0Y0_FrameData[7] VGND VPWR Tile_X0Y1_FrameStrobe[7] latch
XFILLER_94_123 VPWR VGND sg13cmos5l_decap_8
X_0272_ _0272_/Q Tile_X0Y0_FrameData[12] VGND VPWR Tile_X0Y1_FrameStrobe[5] latch
XFILLER_78_0 VPWR VGND sg13cmos5l_decap_4
XFILLER_104_206 VPWR VGND sg13cmos5l_decap_8
X_0608_ _0608_/Q Tile_X0Y1_FrameData[30] VGND VPWR Tile_X0Y1_FrameStrobe[8] latch
XFILLER_37_27 VPWR VGND sg13cmos5l_decap_8
X_0539_ _0539_/Q Tile_X0Y1_FrameData[31] VGND VPWR Tile_X0Y1_FrameStrobe[6] latch
XFILLER_139_103 VPWR VGND sg13cmos5l_decap_8
XFILLER_41_226 VPWR VGND sg13cmos5l_fill_2
XFILLER_53_37 VPWR VGND sg13cmos5l_decap_4
XFILLER_53_59 VPWR VGND sg13cmos5l_decap_8
XFILLER_118_41 VPWR VGND sg13cmos5l_decap_8
XFILLER_139_136 VPWR VGND sg13cmos5l_fill_2
XFILLER_5_127 VPWR VGND sg13cmos5l_decap_8
XFILLER_110_209 VPWR VGND sg13cmos5l_decap_8
XFILLER_134_84 VPWR VGND sg13cmos5l_decap_8
XFILLER_76_167 VPWR VGND sg13cmos5l_decap_8
XFILLER_91_159 VPWR VGND sg13cmos5l_decap_8
XFILLER_91_137 VPWR VGND sg13cmos5l_decap_8
XFILLER_32_226 VPWR VGND sg13cmos5l_fill_2
X_0890_ Tile_X0Y1_S1BEG[2] _1125_/X VPWR VGND sg13cmos5l_buf_1
XFILLER_138_180 VPWR VGND sg13cmos5l_decap_8
XFILLER_4_193 VPWR VGND sg13cmos5l_decap_8
XFILLER_4_42 VPWR VGND sg13cmos5l_decap_8
XFILLER_101_209 VPWR VGND sg13cmos5l_fill_1
XFILLER_67_112 VPWR VGND sg13cmos5l_decap_8
X_0324_ _0324_/Q Tile_X0Y0_FrameData[24] VGND VPWR Tile_X0Y1_FrameStrobe[7] latch
X_0255_ _0255_/Q Tile_X0Y0_FrameData[29] VGND VPWR Tile_X0Y1_FrameStrobe[5] latch
X_0186_ _0186_/Q Tile_X0Y0_FrameData[2] VGND VPWR Tile_X0Y1_FrameStrobe[2] latch
XFILLER_104_32 VPWR VGND sg13cmos5l_decap_8
XFILLER_104_98 VPWR VGND sg13cmos5l_decap_8
XFILLER_64_14 VPWR VGND sg13cmos5l_decap_8
XFILLER_120_86 VPWR VGND sg13cmos5l_fill_2
XFILLER_81_170 VPWR VGND sg13cmos5l_decap_8
XFILLER_127_117 VPWR VGND sg13cmos5l_decap_4
XFILLER_127_139 VPWR VGND sg13cmos5l_decap_8
XFILLER_129_84 VPWR VGND sg13cmos5l_decap_8
XFILLER_135_161 VPWR VGND sg13cmos5l_decap_8
XFILLER_8_0 VPWR VGND sg13cmos5l_decap_4
XFILLER_89_44 VPWR VGND sg13cmos5l_decap_8
XFILLER_96_207 VPWR VGND sg13cmos5l_decap_8
XFILLER_54_91 VPWR VGND sg13cmos5l_decap_8
XFILLER_118_128 VPWR VGND sg13cmos5l_fill_2
X_0873_ Tile_X0Y0_FrameData_O[17] Tile_X0Y0_FrameData[17] VPWR VGND sg13cmos5l_buf_1
X_0942_ Tile_X0Y1_W2BEGb[5] _1160_/X VPWR VGND sg13cmos5l_buf_1
XFILLER_126_194 VPWR VGND sg13cmos5l_decap_8
XFILLER_141_186 VPWR VGND sg13cmos5l_decap_8
XFILLER_18_29 VPWR VGND sg13cmos5l_fill_1
XFILLER_70_107 VPWR VGND sg13cmos5l_decap_4
X_0307_ _0307_/Q Tile_X0Y0_FrameData[9] VGND VPWR Tile_X0Y1_FrameStrobe[6] latch
X_0238_ _0238_/Q Tile_X0Y0_FrameData[14] VGND VPWR Tile_X0Y1_FrameStrobe[4] latch
X_0169_ _0169_/Q Tile_X0Y0_FrameData[19] VGND VPWR Tile_X0Y1_FrameStrobe[2] latch
XANTENNA__0898__X Tile_X0Y1_S2BEG[6] VPWR VGND sg13cmos5l_antennanp
XFILLER_117_183 VPWR VGND sg13cmos5l_decap_8
XFILLER_132_175 VPWR VGND sg13cmos5l_decap_8
XFILLER_1_7 VPWR VGND sg13cmos5l_decap_8
XFILLER_75_24 VPWR VGND sg13cmos5l_decap_8
XFILLER_131_41 VPWR VGND sg13cmos5l_decap_8
XFILLER_46_137 VPWR VGND sg13cmos5l_fill_2
XFILLER_123_186 VPWR VGND sg13cmos5l_decap_8
XFILLER_1_21 VPWR VGND sg13cmos5l_decap_8
XFILLER_49_80 VPWR VGND sg13cmos5l_fill_2
X_1072_ _1072_/X _0637_/Q _1090_/X _1085_/X _1097_/X _0184_/Q _0183_/Q VPWR VGND sg13cmos5l_mux4_1
X_1210_ _1210_/X Tile_X0Y1_N1END[3] Tile_X0Y1_N4END[3] _1230_/X Tile_X0Y0_S4END[7]
+ _0388_/Q _0387_/Q VPWR VGND sg13cmos5l_mux4_1
X_1141_ _1141_/X Tile_X0Y1_E1END[3] Tile_X0Y1_EE4END[15] Tile_X0Y1_E6END[7] _1206_/X
+ _0533_/Q _0532_/Q VPWR VGND sg13cmos5l_mux4_1
XFILLER_60_0 VPWR VGND sg13cmos5l_decap_8
X_0856_ Tile_X0Y0_FrameData_O[0] Tile_X0Y0_FrameData[0] VPWR VGND sg13cmos5l_buf_1
X_0925_ Tile_X0Y1_W1BEG[0] _1143_/X VPWR VGND sg13cmos5l_buf_1
X_0787_ Tile_X0Y0_N2BEGb[4] _1107_/X VPWR VGND sg13cmos5l_buf_1
XFILLER_28_137 VPWR VGND sg13cmos5l_decap_8
XFILLER_45_16 VPWR VGND sg13cmos5l_fill_1
XFILLER_45_38 VPWR VGND sg13cmos5l_decap_8
XFILLER_101_44 VPWR VGND sg13cmos5l_decap_4
XFILLER_51_184 VPWR VGND sg13cmos5l_decap_8
XFILLER_105_164 VPWR VGND sg13cmos5l_decap_8
XFILLER_120_167 VPWR VGND sg13cmos5l_decap_8
XFILLER_19_148 VPWR VGND sg13cmos5l_decap_8
XFILLER_19_159 VPWR VGND sg13cmos5l_fill_2
XFILLER_19_50 VPWR VGND sg13cmos5l_fill_1
XFILLER_42_140 VPWR VGND sg13cmos5l_decap_8
XFILLER_128_201 VPWR VGND sg13cmos5l_decap_8
X_0710_ _0979_/A3 VPWR VGND sg13cmos5l_tielo
X_0641_ _0641_/Q Tile_X0Y1_UserCLK NPU_OUT_ACT5 _0672_/L_HI VPWR VGND sg13cmos5l_dfrbpq_1
XFILLER_111_145 VPWR VGND sg13cmos5l_fill_2
X_0572_ _0572_/Q Tile_X0Y1_FrameData[30] VGND VPWR Tile_X0Y1_FrameStrobe[7] latch
XFILLER_111_189 VPWR VGND sg13cmos5l_decap_8
X_1055_ _1055_/X _0636_/Q _0640_/Q _1084_/X _1099_/X _0218_/Q _0217_/Q VPWR VGND sg13cmos5l_mux4_1
X_1124_ _1124_/X Tile_X0Y1_E1END[1] Tile_X0Y1_E6END[9] _1216_/X _1192_/X _0564_/Q
+ _0563_/Q VPWR VGND sg13cmos5l_mux4_1
XFILLER_33_151 VPWR VGND sg13cmos5l_decap_8
X_0908_ Tile_X0Y1_S4BEG[0] Tile_X0Y0_S4END[8] VPWR VGND sg13cmos5l_buf_1
X_0839_ Tile_X0Y1_FrameData_O[15] Tile_X0Y1_FrameData[15] VPWR VGND sg13cmos5l_buf_1
XFILLER_102_112 VPWR VGND sg13cmos5l_decap_8
XFILLER_102_123 VPWR VGND sg13cmos5l_fill_1
XFILLER_112_32 VPWR VGND sg13cmos5l_decap_8
XFILLER_24_140 VPWR VGND sg13cmos5l_decap_8
XFILLER_125_204 VPWR VGND sg13cmos5l_decap_8
XFILLER_108_0 VPWR VGND sg13cmos5l_decap_8
XFILLER_137_84 VPWR VGND sg13cmos5l_decap_8
XFILLER_97_11 VPWR VGND sg13cmos5l_fill_2
X_0624_ NPU_ACT_WDATA6 Tile_X0Y1_UserCLK _0988_/X _0691_/L_HI VPWR VGND sg13cmos5l_dfrbpq_1
XFILLER_23_0 VPWR VGND sg13cmos5l_fill_2
X_0555_ _0555_/Q Tile_X0Y1_FrameData[15] VGND VPWR Tile_X0Y1_FrameStrobe[6] latch
X_0486_ _0486_/Q Tile_X0Y1_FrameData[20] VGND VPWR Tile_X0Y1_FrameStrobe[4] latch
XFILLER_97_143 VPWR VGND sg13cmos5l_decap_8
X_1038_ _1038_/X Tile_X0Y0_EE4END[5] _0643_/Q _1092_/X _1099_/X _0252_/Q _0251_/Q
+ VPWR VGND sg13cmos5l_mux4_1
X_1107_ _1107_/X Tile_X0Y1_E2MID[3] Tile_X0Y1_E2END[3] Tile_X0Y1_E6END[3] _1199_/X
+ _0586_/Q _0585_/Q VPWR VGND sg13cmos5l_mux4_1
XFILLER_21_198 VPWR VGND sg13cmos5l_decap_8
XFILLER_107_43 VPWR VGND sg13cmos5l_decap_8
XFILLER_67_14 VPWR VGND sg13cmos5l_decap_8
XFILLER_44_213 VPWR VGND sg13cmos5l_decap_8
XFILLER_83_35 VPWR VGND sg13cmos5l_decap_8
XFILLER_12_187 VPWR VGND sg13cmos5l_decap_8
XFILLER_57_80 VPWR VGND sg13cmos5l_decap_8
X_0340_ _0340_/Q Tile_X0Y0_FrameData[8] VGND VPWR Tile_X0Y1_FrameStrobe[7] latch
X_0271_ _0271_/Q Tile_X0Y0_FrameData[13] VGND VPWR Tile_X0Y1_FrameStrobe[5] latch
XFILLER_94_102 VPWR VGND sg13cmos5l_decap_8
XFILLER_50_227 VPWR VGND sg13cmos5l_fill_2
XFILLER_7_191 VPWR VGND sg13cmos5l_decap_8
X_0607_ _0607_/Q Tile_X0Y1_FrameData[29] VGND VPWR Tile_X0Y1_FrameStrobe[8] latch
X_0538_ _0538_/Q Tile_X0Y1_FrameData[0] VGND VPWR Tile_X0Y1_FrameStrobe[5] latch
XFILLER_26_202 VPWR VGND sg13cmos5l_decap_4
X_0469_ _0469_/Q Tile_X0Y1_FrameData[5] VGND VPWR Tile_X0Y1_FrameStrobe[3] latch
XFILLER_41_205 VPWR VGND sg13cmos5l_decap_8
XFILLER_5_106 VPWR VGND sg13cmos5l_decap_8
XFILLER_78_13 VPWR VGND sg13cmos5l_decap_4
XFILLER_118_86 VPWR VGND sg13cmos5l_decap_8
XFILLER_134_63 VPWR VGND sg13cmos5l_decap_8
XFILLER_76_146 VPWR VGND sg13cmos5l_decap_8
XFILLER_78_68 VPWR VGND sg13cmos5l_decap_8
XFILLER_4_21 VPWR VGND sg13cmos5l_decap_8
XFILLER_64_7 VPWR VGND sg13cmos5l_decap_8
XFILLER_99_227 VPWR VGND sg13cmos5l_fill_2
XFILLER_99_216 VPWR VGND sg13cmos5l_fill_1
XFILLER_4_98 VPWR VGND sg13cmos5l_decap_8
X_0323_ _0323_/Q Tile_X0Y0_FrameData[25] VGND VPWR Tile_X0Y1_FrameStrobe[7] latch
X_0254_ _0254_/Q Tile_X0Y0_FrameData[30] VGND VPWR Tile_X0Y1_FrameStrobe[5] latch
X_0185_ _0185_/Q Tile_X0Y0_FrameData[3] VGND VPWR Tile_X0Y1_FrameStrobe[2] latch
XFILLER_23_227 VPWR VGND sg13cmos5l_fill_2
XFILLER_90_0 VPWR VGND sg13cmos5l_decap_8
XFILLER_48_38 VPWR VGND sg13cmos5l_decap_4
XFILLER_58_124 VPWR VGND sg13cmos5l_fill_2
XFILLER_58_157 VPWR VGND sg13cmos5l_decap_4
XFILLER_14_227 VPWR VGND sg13cmos5l_fill_2
XFILLER_120_98 VPWR VGND sg13cmos5l_fill_2
XFILLER_129_30 VPWR VGND sg13cmos5l_fill_1
XFILLER_129_41 VPWR VGND sg13cmos5l_decap_4
XFILLER_80_47 VPWR VGND sg13cmos5l_fill_2
XFILLER_129_63 VPWR VGND sg13cmos5l_decap_8
XFILLER_135_140 VPWR VGND sg13cmos5l_decap_8
XFILLER_1_142 VPWR VGND sg13cmos5l_fill_2
XFILLER_1_186 VPWR VGND sg13cmos5l_decap_8
XFILLER_64_138 VPWR VGND sg13cmos5l_decap_8
XFILLER_72_171 VPWR VGND sg13cmos5l_decap_4
X_0941_ Tile_X0Y1_W2BEGb[4] _1159_/X VPWR VGND sg13cmos5l_buf_1
X_0872_ Tile_X0Y0_FrameData_O[16] Tile_X0Y0_FrameData[16] VPWR VGND sg13cmos5l_buf_1
XFILLER_9_220 VPWR VGND sg13cmos5l_decap_8
XFILLER_126_173 VPWR VGND sg13cmos5l_decap_8
XFILLER_141_165 VPWR VGND sg13cmos5l_decap_8
XFILLER_63_171 VPWR VGND sg13cmos5l_decap_8
X_0306_ _0306_/Q Tile_X0Y0_FrameData[10] VGND VPWR Tile_X0Y1_FrameStrobe[6] latch
X_0237_ _0237_/Q Tile_X0Y0_FrameData[15] VGND VPWR Tile_X0Y1_FrameStrobe[4] latch
X_0168_ _0168_/Q Tile_X0Y0_FrameData[20] VGND VPWR Tile_X0Y1_FrameStrobe[2] latch
XFILLER_109_107 VPWR VGND sg13cmos5l_decap_8
XFILLER_50_39 VPWR VGND sg13cmos5l_decap_8
X_0099_ _0099_/Q Tile_X0Y0_FrameData[25] VGND VPWR Tile_X0Y1_FrameStrobe[0] latch
XFILLER_117_140 VPWR VGND sg13cmos5l_fill_2
XFILLER_132_154 VPWR VGND sg13cmos5l_decap_8
XFILLER_59_26 VPWR VGND sg13cmos5l_decap_8
XFILLER_78_208 VPWR VGND sg13cmos5l_fill_1
XFILLER_131_97 VPWR VGND sg13cmos5l_decap_8
XFILLER_54_193 VPWR VGND sg13cmos5l_decap_8
XFILLER_61_108 VPWR VGND sg13cmos5l_fill_2
XFILLER_138_0 VPWR VGND sg13cmos5l_decap_8
XFILLER_6_212 VPWR VGND sg13cmos5l_decap_8
XFILLER_108_195 VPWR VGND sg13cmos5l_decap_8
XFILLER_123_165 VPWR VGND sg13cmos5l_decap_8
XFILLER_1_77 VPWR VGND sg13cmos5l_fill_1
XFILLER_49_92 VPWR VGND sg13cmos5l_fill_1
XFILLER_65_91 VPWR VGND sg13cmos5l_decap_8
X_1071_ _1071_/X _0636_/Q _1091_/X _1084_/X _1096_/X _0186_/Q _0185_/Q VPWR VGND sg13cmos5l_mux4_1
X_1140_ _1140_/X _1209_/X _1213_/X _1217_/X _1201_/X _0536_/Q _0535_/Q VPWR VGND sg13cmos5l_mux4_1
XFILLER_60_185 VPWR VGND sg13cmos5l_fill_2
X_0924_ Tile_X0Y1_UserCLKo Tile_X0Y1_UserCLK VPWR VGND sg13cmos5l_buf_1
XFILLER_114_132 VPWR VGND sg13cmos5l_fill_1
XFILLER_53_0 VPWR VGND sg13cmos5l_decap_8
X_0855_ Tile_X0Y1_FrameData_O[31] Tile_X0Y1_FrameData[31] VPWR VGND sg13cmos5l_buf_1
X_0786_ Tile_X0Y0_N2BEGb[3] _1106_/X VPWR VGND sg13cmos5l_buf_1
XFILLER_114_165 VPWR VGND sg13cmos5l_fill_2
XFILLER_114_176 VPWR VGND sg13cmos5l_fill_1
XFILLER_114_198 VPWR VGND sg13cmos5l_decap_8
XFILLER_29_29 VPWR VGND sg13cmos5l_decap_8
XFILLER_83_200 VPWR VGND sg13cmos5l_decap_8
XFILLER_51_163 VPWR VGND sg13cmos5l_decap_8
XFILLER_131_7 VPWR VGND sg13cmos5l_decap_8
XFILLER_137_213 VPWR VGND sg13cmos5l_decap_4
XFILLER_61_49 VPWR VGND sg13cmos5l_decap_8
XFILLER_10_75 VPWR VGND sg13cmos5l_decap_4
XFILLER_19_127 VPWR VGND sg13cmos5l_decap_8
XFILLER_35_94 VPWR VGND sg13cmos5l_decap_4
XFILLER_42_185 VPWR VGND sg13cmos5l_decap_8
XFILLER_51_93 VPWR VGND sg13cmos5l_decap_8
X_0640_ _0640_/Q Tile_X0Y1_UserCLK NPU_OUT_ACT4 _0667_/L_HI VPWR VGND sg13cmos5l_dfrbpq_1
X_0571_ _0571_/Q Tile_X0Y1_FrameData[31] VGND VPWR Tile_X0Y1_FrameStrobe[7] latch
XFILLER_111_102 VPWR VGND sg13cmos5l_fill_2
XFILLER_33_130 VPWR VGND sg13cmos5l_decap_8
XFILLER_80_225 VPWR VGND sg13cmos5l_decap_4
X_1054_ _1054_/X _0639_/Q _0643_/Q _1083_/X _1092_/X _0220_/Q _0219_/Q VPWR VGND sg13cmos5l_mux4_1
X_1123_ _1123_/X Tile_X0Y1_E1END[0] Tile_X0Y1_E6END[8] _1215_/X _1191_/X _0566_/Q
+ _0565_/Q VPWR VGND sg13cmos5l_mux4_1
XFILLER_119_213 VPWR VGND sg13cmos5l_decap_4
XFILLER_33_174 VPWR VGND sg13cmos5l_fill_1
X_0907_ Tile_X0Y1_S2BEGb[7] _1226_/X VPWR VGND sg13cmos5l_buf_1
X_0838_ Tile_X0Y1_FrameData_O[14] Tile_X0Y1_FrameData[14] VPWR VGND sg13cmos5l_buf_1
X_0769_ Tile_X0Y0_WW4BEG[2] _1049_/X VPWR VGND sg13cmos5l_buf_1
XFILLER_56_49 VPWR VGND sg13cmos5l_decap_8
XFILLER_112_88 VPWR VGND sg13cmos5l_decap_8
XFILLER_24_196 VPWR VGND sg13cmos5l_decap_8
XFILLER_137_63 VPWR VGND sg13cmos5l_decap_8
XFILLER_21_30 VPWR VGND sg13cmos5l_fill_2
XFILLER_21_74 VPWR VGND sg13cmos5l_fill_2
XFILLER_15_196 VPWR VGND sg13cmos5l_decap_8
XFILLER_62_70 VPWR VGND sg13cmos5l_decap_8
XFILLER_131_208 VPWR VGND sg13cmos5l_fill_2
XFILLER_7_76 VPWR VGND sg13cmos5l_decap_8
X_0623_ NPU_ACT_WDATA5 Tile_X0Y1_UserCLK _0987_/X _0692_/L_HI VPWR VGND sg13cmos5l_dfrbpq_1
X_0554_ _0554_/Q Tile_X0Y1_FrameData[16] VGND VPWR Tile_X0Y1_FrameStrobe[6] latch
XFILLER_16_0 VPWR VGND sg13cmos5l_fill_1
XFILLER_53_214 VPWR VGND sg13cmos5l_fill_2
X_1106_ _1106_/X Tile_X0Y1_E2MID[4] Tile_X0Y1_E2END[4] Tile_X0Y1_E6END[4] _1198_/X
+ _0588_/Q _0587_/Q VPWR VGND sg13cmos5l_mux4_1
X_0485_ _0485_/Q Tile_X0Y1_FrameData[21] VGND VPWR Tile_X0Y1_FrameStrobe[4] latch
XFILLER_97_199 VPWR VGND sg13cmos5l_decap_8
XFILLER_42_29 VPWR VGND sg13cmos5l_decap_4
X_1037_ _1037_/X Tile_X0Y0_EE4END[4] _0642_/Q _1093_/X _1098_/X _0254_/Q _0253_/Q
+ VPWR VGND sg13cmos5l_mux4_1
XFILLER_107_216 VPWR VGND sg13cmos5l_fill_1
XFILLER_107_227 VPWR VGND sg13cmos5l_fill_2
XFILLER_21_177 VPWR VGND sg13cmos5l_decap_8
XFILLER_107_22 VPWR VGND sg13cmos5l_decap_8
XFILLER_88_133 VPWR VGND sg13cmos5l_decap_8
XFILLER_123_65 VPWR VGND sg13cmos5l_fill_1
XFILLER_120_0 VPWR VGND sg13cmos5l_decap_4
XFILLER_12_166 VPWR VGND sg13cmos5l_decap_8
XFILLER_113_208 VPWR VGND sg13cmos5l_fill_2
X_0270_ _0270_/Q Tile_X0Y0_FrameData[14] VGND VPWR Tile_X0Y1_FrameStrobe[5] latch
XFILLER_94_158 VPWR VGND sg13cmos5l_decap_8
XFILLER_73_80 VPWR VGND sg13cmos5l_decap_8
XFILLER_7_170 VPWR VGND sg13cmos5l_decap_8
XANTENNA__0800__X Tile_X0Y0_N1BEG[1] VPWR VGND sg13cmos5l_antennanp
XFILLER_85_114 VPWR VGND sg13cmos5l_decap_8
X_0606_ _0606_/Q Tile_X0Y1_FrameData[28] VGND VPWR Tile_X0Y1_FrameStrobe[8] latch
X_0537_ _0537_/Q Tile_X0Y1_FrameData[1] VGND VPWR Tile_X0Y1_FrameStrobe[5] latch
X_0468_ _0468_/Q Tile_X0Y1_FrameData[6] VGND VPWR Tile_X0Y1_FrameStrobe[3] latch
X_0399_ _0399_/Q Tile_X0Y1_FrameData[11] VGND VPWR Tile_X0Y1_FrameStrobe[1] latch
XFILLER_93_180 VPWR VGND sg13cmos5l_decap_8
XFILLER_139_149 VPWR VGND sg13cmos5l_fill_1
XFILLER_41_228 VPWR VGND sg13cmos5l_fill_1
XFILLER_53_28 VPWR VGND sg13cmos5l_fill_2
XFILLER_118_98 VPWR VGND sg13cmos5l_fill_2
XFILLER_134_42 VPWR VGND sg13cmos5l_decap_8
XFILLER_76_125 VPWR VGND sg13cmos5l_decap_8
XFILLER_94_57 VPWR VGND sg13cmos5l_decap_8
XFILLER_17_214 VPWR VGND sg13cmos5l_fill_2
XFILLER_27_95 VPWR VGND sg13cmos5l_decap_8
XFILLER_32_228 VPWR VGND sg13cmos5l_fill_1
XFILLER_43_94 VPWR VGND sg13cmos5l_decap_8
XFILLER_4_140 VPWR VGND sg13cmos5l_decap_4
XFILLER_4_162 VPWR VGND sg13cmos5l_decap_8
XFILLER_4_77 VPWR VGND sg13cmos5l_decap_8
XFILLER_57_7 VPWR VGND sg13cmos5l_fill_2
X_0322_ _0322_/Q Tile_X0Y0_FrameData[26] VGND VPWR Tile_X0Y1_FrameStrobe[7] latch
XFILLER_99_206 VPWR VGND sg13cmos5l_fill_2
XFILLER_67_147 VPWR VGND sg13cmos5l_decap_8
XFILLER_68_91 VPWR VGND sg13cmos5l_fill_1
X_0253_ _0253_/Q Tile_X0Y0_FrameData[31] VGND VPWR Tile_X0Y1_FrameStrobe[5] latch
X_0184_ _0184_/Q Tile_X0Y0_FrameData[4] VGND VPWR Tile_X0Y1_FrameStrobe[2] latch
XFILLER_90_194 VPWR VGND sg13cmos5l_fill_2
XFILLER_136_119 VPWR VGND sg13cmos5l_decap_8
XFILLER_104_12 VPWR VGND sg13cmos5l_decap_8
XFILLER_120_22 VPWR VGND sg13cmos5l_fill_2
XFILLER_64_49 VPWR VGND sg13cmos5l_fill_2
XFILLER_73_139 VPWR VGND sg13cmos5l_decap_8
XFILLER_13_31 VPWR VGND sg13cmos5l_fill_2
XFILLER_80_26 VPWR VGND sg13cmos5l_decap_8
XFILLER_135_196 VPWR VGND sg13cmos5l_fill_2
XFILLER_89_79 VPWR VGND sg13cmos5l_decap_8
XFILLER_49_147 VPWR VGND sg13cmos5l_fill_1
XFILLER_49_169 VPWR VGND sg13cmos5l_decap_8
XFILLER_64_117 VPWR VGND sg13cmos5l_decap_8
XFILLER_54_82 VPWR VGND sg13cmos5l_fill_2
XFILLER_72_150 VPWR VGND sg13cmos5l_decap_8
X_0940_ Tile_X0Y1_W2BEGb[3] _1158_/X VPWR VGND sg13cmos5l_buf_1
XFILLER_126_152 VPWR VGND sg13cmos5l_decap_8
XFILLER_55_4 VPWR VGND sg13cmos5l_fill_2
XFILLER_70_70 VPWR VGND sg13cmos5l_decap_4
X_0871_ Tile_X0Y0_FrameData_O[15] Tile_X0Y0_FrameData[15] VPWR VGND sg13cmos5l_buf_1
XFILLER_141_144 VPWR VGND sg13cmos5l_decap_8
X_0305_ _0305_/Q Tile_X0Y0_FrameData[11] VGND VPWR Tile_X0Y1_FrameStrobe[6] latch
XFILLER_95_220 VPWR VGND sg13cmos5l_decap_8
XFILLER_55_139 VPWR VGND sg13cmos5l_decap_8
XFILLER_63_150 VPWR VGND sg13cmos5l_decap_8
X_0236_ _0236_/Q Tile_X0Y0_FrameData[16] VGND VPWR Tile_X0Y1_FrameStrobe[4] latch
X_0167_ _0167_/Q Tile_X0Y0_FrameData[21] VGND VPWR Tile_X0Y1_FrameStrobe[2] latch
X_0098_ _0098_/Q Tile_X0Y0_FrameData[26] VGND VPWR Tile_X0Y1_FrameStrobe[0] latch
XFILLER_132_133 VPWR VGND sg13cmos5l_decap_8
XFILLER_131_21 VPWR VGND sg13cmos5l_decap_8
XFILLER_39_191 VPWR VGND sg13cmos5l_decap_8
XFILLER_46_117 VPWR VGND sg13cmos5l_decap_4
XFILLER_86_220 VPWR VGND sg13cmos5l_decap_8
XFILLER_131_76 VPWR VGND sg13cmos5l_decap_8
XFILLER_24_85 VPWR VGND sg13cmos5l_decap_8
XFILLER_54_172 VPWR VGND sg13cmos5l_decap_8
XFILLER_24_96 VPWR VGND sg13cmos5l_fill_2
XFILLER_40_73 VPWR VGND sg13cmos5l_fill_2
XFILLER_6_202 VPWR VGND sg13cmos5l_decap_4
XFILLER_123_144 VPWR VGND sg13cmos5l_decap_8
XFILLER_49_82 VPWR VGND sg13cmos5l_fill_1
XFILLER_77_220 VPWR VGND sg13cmos5l_decap_8
XFILLER_37_139 VPWR VGND sg13cmos5l_decap_8
XFILLER_65_70 VPWR VGND sg13cmos5l_decap_8
X_1070_ _1070_/X _0643_/Q _1087_/X _1083_/X _1095_/X _0188_/Q _0187_/Q VPWR VGND sg13cmos5l_mux4_1
XFILLER_60_164 VPWR VGND sg13cmos5l_decap_8
XFILLER_81_80 VPWR VGND sg13cmos5l_decap_8
X_0854_ Tile_X0Y1_FrameData_O[30] Tile_X0Y1_FrameData[30] VPWR VGND sg13cmos5l_buf_1
X_0923_ Tile_X0Y1_S4BEG[15] _0923_/A VPWR VGND sg13cmos5l_buf_1
XFILLER_114_144 VPWR VGND sg13cmos5l_decap_8
XFILLER_46_0 VPWR VGND sg13cmos5l_decap_8
X_0785_ Tile_X0Y0_N2BEGb[2] _1105_/X VPWR VGND sg13cmos5l_buf_1
XFILLER_36_183 VPWR VGND sg13cmos5l_decap_8
XFILLER_36_194 VPWR VGND sg13cmos5l_fill_1
X_1199_ _1199_/X Tile_X0Y1_N2MID[4] Tile_X0Y1_N2END[4] _1223_/X Tile_X0Y0_S2MID[4]
+ _0362_/Q _0361_/Q VPWR VGND sg13cmos5l_mux4_1
X_0219_ _0219_/Q Tile_X0Y0_FrameData[1] VGND VPWR Tile_X0Y1_FrameStrobe[3] latch
XFILLER_3_227 VPWR VGND sg13cmos5l_fill_2
XFILLER_105_155 VPWR VGND sg13cmos5l_fill_2
XFILLER_105_199 VPWR VGND sg13cmos5l_decap_8
XFILLER_10_32 VPWR VGND sg13cmos5l_fill_1
XFILLER_120_158 VPWR VGND sg13cmos5l_decap_4
XFILLER_126_43 VPWR VGND sg13cmos5l_fill_2
XFILLER_59_220 VPWR VGND sg13cmos5l_decap_8
XFILLER_86_69 VPWR VGND sg13cmos5l_decap_8
XFILLER_34_109 VPWR VGND sg13cmos5l_decap_8
XFILLER_74_223 VPWR VGND sg13cmos5l_decap_4
XFILLER_35_73 VPWR VGND sg13cmos5l_decap_8
XFILLER_51_72 VPWR VGND sg13cmos5l_decap_8
X_0570_ _0570_/Q Tile_X0Y1_FrameData[0] VGND VPWR Tile_X0Y1_FrameStrobe[6] latch
XFILLER_111_125 VPWR VGND sg13cmos5l_decap_8
XFILLER_111_158 VPWR VGND sg13cmos5l_fill_2
X_1122_ _1122_/X _1207_/X _1211_/X _1215_/X _1195_/X _0578_/Q _0577_/Q VPWR VGND sg13cmos5l_mux4_1
XFILLER_18_183 VPWR VGND sg13cmos5l_fill_1
XFILLER_33_186 VPWR VGND sg13cmos5l_decap_8
XFILLER_80_204 VPWR VGND sg13cmos5l_decap_8
X_1053_ _1053_/X _0638_/Q _0642_/Q _1082_/X _1093_/X _0222_/Q _0221_/Q VPWR VGND sg13cmos5l_mux4_1
XANTENNA__0803__X Tile_X0Y0_FrameStrobe_O[0] VPWR VGND sg13cmos5l_antennanp
XFILLER_134_217 VPWR VGND sg13cmos5l_decap_8
XFILLER_134_228 VPWR VGND sg13cmos5l_fill_1
X_0906_ Tile_X0Y1_S2BEGb[6] _1225_/X VPWR VGND sg13cmos5l_buf_1
X_0837_ Tile_X0Y1_FrameData_O[13] Tile_X0Y1_FrameData[13] VPWR VGND sg13cmos5l_buf_1
X_0768_ Tile_X0Y0_WW4BEG[1] _1048_/X VPWR VGND sg13cmos5l_buf_1
X_0699_ _0981_/A3 VPWR VGND sg13cmos5l_tielo
XFILLER_56_223 VPWR VGND sg13cmos5l_decap_4
XFILLER_56_28 VPWR VGND sg13cmos5l_decap_8
XFILLER_71_204 VPWR VGND sg13cmos5l_decap_8
XFILLER_24_175 VPWR VGND sg13cmos5l_fill_2
XFILLER_137_42 VPWR VGND sg13cmos5l_decap_8
XFILLER_21_97 VPWR VGND sg13cmos5l_decap_4
XFILLER_97_24 VPWR VGND sg13cmos5l_decap_8
XFILLER_101_191 VPWR VGND sg13cmos5l_decap_8
XFILLER_47_212 VPWR VGND sg13cmos5l_fill_2
XFILLER_15_164 VPWR VGND sg13cmos5l_fill_1
XFILLER_15_175 VPWR VGND sg13cmos5l_decap_8
XFILLER_46_61 VPWR VGND sg13cmos5l_decap_8
XFILLER_116_217 VPWR VGND sg13cmos5l_decap_8
XFILLER_116_228 VPWR VGND sg13cmos5l_fill_1
XFILLER_30_123 VPWR VGND sg13cmos5l_decap_4
XFILLER_7_33 VPWR VGND sg13cmos5l_decap_8
XFILLER_87_7 VPWR VGND sg13cmos5l_decap_4
X_0622_ NPU_ACT_WDATA4 Tile_X0Y1_UserCLK _0986_/X _0663_/L_HI VPWR VGND sg13cmos5l_dfrbpq_1
X_0553_ _0553_/Q Tile_X0Y1_FrameData[17] VGND VPWR Tile_X0Y1_FrameStrobe[6] latch
X_0484_ _0484_/Q Tile_X0Y1_FrameData[22] VGND VPWR Tile_X0Y1_FrameStrobe[4] latch
XFILLER_97_134 VPWR VGND sg13cmos5l_fill_2
X_1105_ _1105_/X Tile_X0Y1_E2MID[5] Tile_X0Y1_E2END[5] Tile_X0Y1_E6END[5] _1197_/X
+ _0590_/Q _0589_/Q VPWR VGND sg13cmos5l_mux4_1
XFILLER_97_178 VPWR VGND sg13cmos5l_decap_8
XFILLER_21_101 VPWR VGND sg13cmos5l_fill_1
X_1036_ _1036_/X Tile_X0Y0_EE4END[15] _0641_/Q _1094_/X _1097_/X _0256_/Q _0255_/Q
+ VPWR VGND sg13cmos5l_mux4_1
XFILLER_107_206 VPWR VGND sg13cmos5l_fill_2
XFILLER_122_209 VPWR VGND sg13cmos5l_decap_8
XFILLER_29_212 VPWR VGND sg13cmos5l_decap_8
XFILLER_67_49 VPWR VGND sg13cmos5l_decap_8
XFILLER_88_189 VPWR VGND sg13cmos5l_decap_8
XFILLER_88_156 VPWR VGND sg13cmos5l_decap_4
XFILLER_88_112 VPWR VGND sg13cmos5l_decap_8
XFILLER_12_156 VPWR VGND sg13cmos5l_decap_4
XFILLER_32_96 VPWR VGND sg13cmos5l_decap_8
XFILLER_113_0 VPWR VGND sg13cmos5l_decap_4
XFILLER_121_220 VPWR VGND sg13cmos5l_decap_8
XFILLER_35_226 VPWR VGND sg13cmos5l_fill_2
XFILLER_79_189 VPWR VGND sg13cmos5l_decap_8
XFILLER_94_137 VPWR VGND sg13cmos5l_decap_8
XFILLER_112_220 VPWR VGND sg13cmos5l_decap_8
XFILLER_85_159 VPWR VGND sg13cmos5l_fill_2
X_0605_ _0605_/Q Tile_X0Y1_FrameData[27] VGND VPWR Tile_X0Y1_FrameStrobe[8] latch
X_0536_ _0536_/Q Tile_X0Y1_FrameData[2] VGND VPWR Tile_X0Y1_FrameStrobe[5] latch
X_0467_ _0467_/Q Tile_X0Y1_FrameData[7] VGND VPWR Tile_X0Y1_FrameStrobe[3] latch
XFILLER_26_215 VPWR VGND sg13cmos5l_fill_2
X_1019_ _1019_/X Tile_X0Y0_E1END[0] Tile_X0Y0_EE4END[12] Tile_X0Y0_E6END[4] _1088_/X
+ _0286_/Q _0285_/Q VPWR VGND sg13cmos5l_mux4_1
X_0398_ _0398_/Q Tile_X0Y1_FrameData[12] VGND VPWR Tile_X0Y1_FrameStrobe[1] latch
XFILLER_139_117 VPWR VGND sg13cmos5l_decap_8
XFILLER_103_220 VPWR VGND sg13cmos5l_decap_8
XFILLER_134_21 VPWR VGND sg13cmos5l_decap_8
XFILLER_134_98 VPWR VGND sg13cmos5l_decap_8
XFILLER_76_104 VPWR VGND sg13cmos5l_decap_8
XFILLER_84_181 VPWR VGND sg13cmos5l_fill_1
XANTENNA__0901__X Tile_X0Y1_S2BEGb[1] VPWR VGND sg13cmos5l_antennanp
XFILLER_138_194 VPWR VGND sg13cmos5l_decap_8
XFILLER_4_56 VPWR VGND sg13cmos5l_decap_8
XFILLER_67_126 VPWR VGND sg13cmos5l_decap_8
XFILLER_68_70 VPWR VGND sg13cmos5l_decap_8
X_0321_ _0321_/Q Tile_X0Y0_FrameData[27] VGND VPWR Tile_X0Y1_FrameStrobe[7] latch
XFILLER_82_129 VPWR VGND sg13cmos5l_decap_4
X_0252_ _0252_/Q Tile_X0Y0_FrameData[0] VGND VPWR Tile_X0Y1_FrameStrobe[4] latch
X_0183_ _0183_/Q Tile_X0Y0_FrameData[5] VGND VPWR Tile_X0Y1_FrameStrobe[2] latch
XFILLER_90_162 VPWR VGND sg13cmos5l_decap_8
XFILLER_76_0 VPWR VGND sg13cmos5l_fill_2
XANTENNA__0811__X Tile_X0Y0_FrameStrobe_O[8] VPWR VGND sg13cmos5l_antennanp
XFILLER_129_183 VPWR VGND sg13cmos5l_decap_8
XFILLER_100_212 VPWR VGND sg13cmos5l_decap_8
XFILLER_104_46 VPWR VGND sg13cmos5l_decap_8
XFILLER_73_118 VPWR VGND sg13cmos5l_decap_8
X_0519_ _0519_/Q Tile_X0Y1_FrameData[19] VGND VPWR Tile_X0Y1_FrameStrobe[5] latch
XFILLER_120_12 VPWR VGND sg13cmos5l_fill_2
XFILLER_120_45 VPWR VGND sg13cmos5l_fill_2
XFILLER_64_28 VPWR VGND sg13cmos5l_decap_8
XFILLER_81_184 VPWR VGND sg13cmos5l_decap_8
XANTENNA__0721__X Tile_X0Y0_W1BEG[2] VPWR VGND sg13cmos5l_antennanp
XFILLER_127_109 VPWR VGND sg13cmos5l_decap_4
XFILLER_129_21 VPWR VGND sg13cmos5l_fill_2
XFILLER_129_98 VPWR VGND sg13cmos5l_decap_8
XFILLER_13_54 VPWR VGND sg13cmos5l_fill_2
XFILLER_80_49 VPWR VGND sg13cmos5l_fill_1
XFILLER_89_58 VPWR VGND sg13cmos5l_decap_8
XFILLER_135_175 VPWR VGND sg13cmos5l_decap_8
XFILLER_1_122 VPWR VGND sg13cmos5l_fill_1
XFILLER_1_144 VPWR VGND sg13cmos5l_fill_1
XFILLER_1_155 VPWR VGND sg13cmos5l_fill_2
XFILLER_49_104 VPWR VGND sg13cmos5l_fill_1
XFILLER_38_51 VPWR VGND sg13cmos5l_decap_8
X_0870_ Tile_X0Y0_FrameData_O[14] Tile_X0Y0_FrameData[14] VPWR VGND sg13cmos5l_buf_1
XFILLER_126_131 VPWR VGND sg13cmos5l_decap_8
XFILLER_141_123 VPWR VGND sg13cmos5l_decap_8
X_0304_ _0304_/Q Tile_X0Y0_FrameData[12] VGND VPWR Tile_X0Y1_FrameStrobe[6] latch
X_0235_ _0235_/Q Tile_X0Y0_FrameData[17] VGND VPWR Tile_X0Y1_FrameStrobe[4] latch
XANTENNA__0806__X Tile_X0Y0_FrameStrobe_O[3] VPWR VGND sg13cmos5l_antennanp
X_0166_ _0166_/Q Tile_X0Y0_FrameData[22] VGND VPWR Tile_X0Y1_FrameStrobe[2] latch
X_0097_ _0097_/Q Tile_X0Y0_FrameData[27] VGND VPWR Tile_X0Y1_FrameStrobe[0] latch
XFILLER_117_142 VPWR VGND sg13cmos5l_fill_1
XFILLER_117_153 VPWR VGND sg13cmos5l_decap_8
X_0999_ _0999_/X Tile_X0Y0_E1END[0] Tile_X0Y0_E6END[4] _1075_/X _1100_/X _0346_/Q
+ _0345_/Q VPWR VGND sg13cmos5l_mux4_1
XFILLER_117_164 VPWR VGND sg13cmos5l_fill_1
XFILLER_117_197 VPWR VGND sg13cmos5l_decap_8
XFILLER_132_112 VPWR VGND sg13cmos5l_decap_8
XFILLER_132_189 VPWR VGND sg13cmos5l_decap_8
XFILLER_131_55 VPWR VGND sg13cmos5l_decap_8
XFILLER_75_38 VPWR VGND sg13cmos5l_decap_4
XFILLER_24_31 VPWR VGND sg13cmos5l_fill_2
XFILLER_24_64 VPWR VGND sg13cmos5l_decap_8
XFILLER_108_164 VPWR VGND sg13cmos5l_fill_2
XFILLER_123_123 VPWR VGND sg13cmos5l_decap_8
XFILLER_40_52 VPWR VGND sg13cmos5l_decap_8
XFILLER_6_0 VPWR VGND sg13cmos5l_decap_8
XFILLER_1_35 VPWR VGND sg13cmos5l_fill_2
XFILLER_49_61 VPWR VGND sg13cmos5l_decap_8
XFILLER_49_72 VPWR VGND sg13cmos5l_fill_1
XFILLER_92_213 VPWR VGND sg13cmos5l_decap_8
XFILLER_60_143 VPWR VGND sg13cmos5l_decap_8
XFILLER_60_187 VPWR VGND sg13cmos5l_fill_1
XFILLER_60_198 VPWR VGND sg13cmos5l_decap_8
X_0853_ Tile_X0Y1_FrameData_O[29] Tile_X0Y1_FrameData[29] VPWR VGND sg13cmos5l_buf_1
X_0922_ Tile_X0Y1_S4BEG[14] _0922_/A VPWR VGND sg13cmos5l_buf_1
XFILLER_39_0 VPWR VGND sg13cmos5l_fill_1
XFILLER_68_221 VPWR VGND sg13cmos5l_decap_8
X_0784_ Tile_X0Y0_N2BEGb[1] _1104_/X VPWR VGND sg13cmos5l_buf_1
XFILLER_36_162 VPWR VGND sg13cmos5l_decap_8
X_1198_ _1198_/X Tile_X0Y1_N2MID[3] Tile_X0Y1_N2END[3] _1222_/X Tile_X0Y0_S2MID[3]
+ _0364_/Q _0363_/Q VPWR VGND sg13cmos5l_mux4_1
X_0218_ _0218_/Q Tile_X0Y0_FrameData[2] VGND VPWR Tile_X0Y1_FrameStrobe[3] latch
XFILLER_51_121 VPWR VGND sg13cmos5l_decap_8
XFILLER_51_198 VPWR VGND sg13cmos5l_decap_8
X_0149_ _0149_/Q Tile_X0Y0_FrameData[7] VGND VPWR Tile_X0Y1_FrameStrobe[1] latch
XFILLER_117_7 VPWR VGND sg13cmos5l_decap_8
XFILLER_3_206 VPWR VGND sg13cmos5l_decap_8
XFILLER_105_178 VPWR VGND sg13cmos5l_decap_8
XFILLER_74_202 VPWR VGND sg13cmos5l_decap_8
XFILLER_27_195 VPWR VGND sg13cmos5l_decap_8
XFILLER_35_52 VPWR VGND sg13cmos5l_decap_8
XFILLER_128_215 VPWR VGND sg13cmos5l_decap_8
XFILLER_51_40 VPWR VGND sg13cmos5l_decap_8
X_1052_ _1052_/X _0637_/Q _0641_/Q _1081_/X _1094_/X _0224_/Q _0223_/Q VPWR VGND sg13cmos5l_mux4_1
X_1121_ _1121_/X Tile_X0Y1_E1END[0] Tile_X0Y1_EE4END[0] Tile_X0Y1_E6END[8] _1203_/X
+ _0578_/Q _0577_/Q VPWR VGND sg13cmos5l_mux4_1
XFILLER_33_165 VPWR VGND sg13cmos5l_decap_8
XFILLER_92_91 VPWR VGND sg13cmos5l_fill_2
X_0905_ Tile_X0Y1_S2BEGb[5] _1224_/X VPWR VGND sg13cmos5l_buf_1
X_0836_ Tile_X0Y1_FrameData_O[12] Tile_X0Y1_FrameData[12] VPWR VGND sg13cmos5l_buf_1
X_0767_ Tile_X0Y0_WW4BEG[0] _1047_/X VPWR VGND sg13cmos5l_buf_1
XFILLER_0_209 VPWR VGND sg13cmos5l_decap_4
XFILLER_102_148 VPWR VGND sg13cmos5l_fill_2
X_0698_ _0698_/L_HI VPWR VGND sg13cmos5l_tiehi
XFILLER_72_39 VPWR VGND sg13cmos5l_fill_2
XANTENNA_50 Tile_X0Y1_FrameData[15] VPWR VGND sg13cmos5l_antennanp
XFILLER_24_154 VPWR VGND sg13cmos5l_decap_8
XFILLER_125_218 VPWR VGND sg13cmos5l_decap_8
XFILLER_137_21 VPWR VGND sg13cmos5l_decap_8
XFILLER_137_98 VPWR VGND sg13cmos5l_decap_8
XFILLER_46_40 VPWR VGND sg13cmos5l_decap_8
XANTENNA__0904__X Tile_X0Y1_S2BEGb[4] VPWR VGND sg13cmos5l_antennanp
XFILLER_15_143 VPWR VGND sg13cmos5l_decap_8
XFILLER_62_227 VPWR VGND sg13cmos5l_fill_2
XFILLER_62_61 VPWR VGND sg13cmos5l_fill_2
XFILLER_7_56 VPWR VGND sg13cmos5l_decap_8
XFILLER_7_67 VPWR VGND sg13cmos5l_fill_2
X_0621_ NPU_ACT_WDATA3 Tile_X0Y1_UserCLK _0985_/X _0662_/L_HI VPWR VGND sg13cmos5l_dfrbpq_1
X_0552_ _0552_/Q Tile_X0Y1_FrameData[18] VGND VPWR Tile_X0Y1_FrameStrobe[6] latch
X_0483_ _0483_/Q Tile_X0Y1_FrameData[23] VGND VPWR Tile_X0Y1_FrameStrobe[4] latch
XFILLER_97_157 VPWR VGND sg13cmos5l_decap_8
XFILLER_97_113 VPWR VGND sg13cmos5l_decap_8
XFILLER_87_80 VPWR VGND sg13cmos5l_fill_2
XFILLER_53_216 VPWR VGND sg13cmos5l_fill_1
XFILLER_53_227 VPWR VGND sg13cmos5l_fill_2
X_1035_ _1035_/X Tile_X0Y0_EE4END[8] _0640_/Q _1095_/X _1096_/X _0258_/Q _0257_/Q
+ VPWR VGND sg13cmos5l_mux4_1
X_1104_ _1104_/X Tile_X0Y1_E2MID[6] Tile_X0Y1_E2END[6] Tile_X0Y1_E6END[6] _1196_/X
+ _0592_/Q _0591_/Q VPWR VGND sg13cmos5l_mux4_1
XANTENNA__0814__X Tile_X0Y0_FrameStrobe_O[11] VPWR VGND sg13cmos5l_antennanp
X_0819_ Tile_X0Y0_FrameStrobe_O[16] Tile_X0Y1_FrameStrobe[16] VPWR VGND sg13cmos5l_buf_1
XFILLER_107_79 VPWR VGND sg13cmos5l_decap_8
XFILLER_123_12 VPWR VGND sg13cmos5l_decap_8
XFILLER_67_28 VPWR VGND sg13cmos5l_decap_8
XANTENNA__0724__X Tile_X0Y0_W2BEG[1] VPWR VGND sg13cmos5l_antennanp
XFILLER_12_135 VPWR VGND sg13cmos5l_decap_8
XFILLER_16_54 VPWR VGND sg13cmos5l_fill_2
XFILLER_16_98 VPWR VGND sg13cmos5l_decap_4
XFILLER_44_227 VPWR VGND sg13cmos5l_fill_2
XFILLER_20_190 VPWR VGND sg13cmos5l_decap_8
XFILLER_32_31 VPWR VGND sg13cmos5l_decap_8
XFILLER_32_75 VPWR VGND sg13cmos5l_decap_8
XFILLER_8_139 VPWR VGND sg13cmos5l_decap_8
XFILLER_106_0 VPWR VGND sg13cmos5l_decap_4
XFILLER_79_113 VPWR VGND sg13cmos5l_decap_8
XFILLER_79_168 VPWR VGND sg13cmos5l_decap_8
XFILLER_94_116 VPWR VGND sg13cmos5l_decap_8
XFILLER_78_4 VPWR VGND sg13cmos5l_fill_2
X_0604_ _0604_/Q Tile_X0Y1_FrameData[26] VGND VPWR Tile_X0Y1_FrameStrobe[8] latch
XANTENNA__0809__X Tile_X0Y0_FrameStrobe_O[6] VPWR VGND sg13cmos5l_antennanp
XFILLER_21_0 VPWR VGND sg13cmos5l_decap_4
XFILLER_85_105 VPWR VGND sg13cmos5l_fill_2
X_0535_ _0535_/Q Tile_X0Y1_FrameData[3] VGND VPWR Tile_X0Y1_FrameStrobe[5] latch
X_0466_ _0466_/Q Tile_X0Y1_FrameData[8] VGND VPWR Tile_X0Y1_FrameStrobe[3] latch
X_0397_ _0397_/Q Tile_X0Y1_FrameData[13] VGND VPWR Tile_X0Y1_FrameStrobe[1] latch
XFILLER_26_227 VPWR VGND sg13cmos5l_fill_2
XFILLER_41_219 VPWR VGND sg13cmos5l_decap_8
X_1018_ _1018_/X _1084_/X _1080_/X _1079_/X _1095_/X _0313_/Q _0312_/Q VPWR VGND sg13cmos5l_mux4_1
XFILLER_118_34 VPWR VGND sg13cmos5l_decap_8
XFILLER_78_38 VPWR VGND sg13cmos5l_decap_4
XFILLER_78_49 VPWR VGND sg13cmos5l_decap_4
XANTENNA__0719__X Tile_X0Y0_W1BEG[0] VPWR VGND sg13cmos5l_antennanp
XFILLER_134_77 VPWR VGND sg13cmos5l_decap_8
XFILLER_17_216 VPWR VGND sg13cmos5l_fill_1
XFILLER_17_227 VPWR VGND sg13cmos5l_fill_2
XFILLER_138_173 VPWR VGND sg13cmos5l_decap_8
XFILLER_4_186 VPWR VGND sg13cmos5l_decap_8
XFILLER_4_35 VPWR VGND sg13cmos5l_decap_8
XFILLER_67_105 VPWR VGND sg13cmos5l_decap_8
X_0320_ _0320_/Q Tile_X0Y0_FrameData[28] VGND VPWR Tile_X0Y1_FrameStrobe[7] latch
X_0251_ _0251_/Q Tile_X0Y0_FrameData[1] VGND VPWR Tile_X0Y1_FrameStrobe[4] latch
XFILLER_75_182 VPWR VGND sg13cmos5l_decap_8
X_0182_ _0182_/Q Tile_X0Y0_FrameData[6] VGND VPWR Tile_X0Y1_FrameStrobe[2] latch
XFILLER_90_196 VPWR VGND sg13cmos5l_fill_1
XFILLER_129_162 VPWR VGND sg13cmos5l_decap_8
XFILLER_69_0 VPWR VGND sg13cmos5l_decap_8
X_0518_ _0518_/Q Tile_X0Y1_FrameData[20] VGND VPWR Tile_X0Y1_FrameStrobe[5] latch
XFILLER_104_25 VPWR VGND sg13cmos5l_decap_8
X_0449_ _0449_/Q Tile_X0Y1_FrameData[25] VGND VPWR Tile_X0Y1_FrameStrobe[3] latch
XFILLER_81_163 VPWR VGND sg13cmos5l_decap_8
XFILLER_129_77 VPWR VGND sg13cmos5l_decap_8
XFILLER_135_154 VPWR VGND sg13cmos5l_decap_8
XFILLER_89_37 VPWR VGND sg13cmos5l_decap_8
XFILLER_1_112 VPWR VGND sg13cmos5l_fill_2
XFILLER_49_116 VPWR VGND sg13cmos5l_fill_2
XFILLER_8_4 VPWR VGND sg13cmos5l_fill_2
XANTENNA__0912__X Tile_X0Y1_S4BEG[4] VPWR VGND sg13cmos5l_antennanp
XFILLER_126_110 VPWR VGND sg13cmos5l_decap_8
XFILLER_126_187 VPWR VGND sg13cmos5l_fill_2
XFILLER_141_102 VPWR VGND sg13cmos5l_decap_8
XFILLER_141_179 VPWR VGND sg13cmos5l_decap_8
XFILLER_62_7 VPWR VGND sg13cmos5l_decap_8
XFILLER_48_182 VPWR VGND sg13cmos5l_decap_8
X_0303_ _0303_/Q Tile_X0Y0_FrameData[13] VGND VPWR Tile_X0Y1_FrameStrobe[6] latch
X_0234_ _0234_/Q Tile_X0Y0_FrameData[18] VGND VPWR Tile_X0Y1_FrameStrobe[4] latch
X_0165_ _0165_/Q Tile_X0Y0_FrameData[23] VGND VPWR Tile_X0Y1_FrameStrobe[2] latch
X_0096_ _0096_/Q Tile_X0Y0_FrameData[28] VGND VPWR Tile_X0Y1_FrameStrobe[0] latch
XANTENNA__0822__X Tile_X0Y0_FrameStrobe_O[19] VPWR VGND sg13cmos5l_antennanp
XFILLER_117_176 VPWR VGND sg13cmos5l_decap_8
X_0998_ _0998_/X Tile_X0Y0_EE4END[3] Tile_X0Y0_EE4END[11] Tile_X0Y0_E6END[3] _1091_/X
+ _0172_/Q _0171_/Q VPWR VGND sg13cmos5l_mux4_1
XFILLER_132_168 VPWR VGND sg13cmos5l_decap_8
XANTENNA__0732__X Tile_X0Y0_W2BEGb[1] VPWR VGND sg13cmos5l_antennanp
XFILLER_24_54 VPWR VGND sg13cmos5l_fill_2
XFILLER_6_226 VPWR VGND sg13cmos5l_fill_2
XFILLER_108_132 VPWR VGND sg13cmos5l_decap_8
XFILLER_123_102 VPWR VGND sg13cmos5l_decap_8
XFILLER_123_179 VPWR VGND sg13cmos5l_decap_8
XFILLER_40_86 VPWR VGND sg13cmos5l_fill_1
XFILLER_131_190 VPWR VGND sg13cmos5l_decap_8
XFILLER_1_14 VPWR VGND sg13cmos5l_decap_8
XFILLER_77_211 VPWR VGND sg13cmos5l_decap_4
XANTENNA__0907__X Tile_X0Y1_S2BEGb[7] VPWR VGND sg13cmos5l_antennanp
XFILLER_60_122 VPWR VGND sg13cmos5l_decap_8
X_0921_ Tile_X0Y1_S4BEG[13] _0921_/A VPWR VGND sg13cmos5l_buf_1
X_0852_ Tile_X0Y1_FrameData_O[28] Tile_X0Y1_FrameData[28] VPWR VGND sg13cmos5l_buf_1
X_0783_ Tile_X0Y0_N2BEGb[0] _1103_/X VPWR VGND sg13cmos5l_buf_1
XFILLER_114_113 VPWR VGND sg13cmos5l_decap_4
XFILLER_68_211 VPWR VGND sg13cmos5l_decap_4
XANTENNA__0817__X Tile_X0Y0_FrameStrobe_O[14] VPWR VGND sg13cmos5l_antennanp
XFILLER_51_100 VPWR VGND sg13cmos5l_decap_8
XFILLER_83_214 VPWR VGND sg13cmos5l_fill_2
X_1197_ _1197_/X Tile_X0Y1_N2MID[2] Tile_X0Y1_N2END[2] _1221_/X Tile_X0Y0_S2MID[2]
+ _0366_/Q _0365_/Q VPWR VGND sg13cmos5l_mux4_1
X_0217_ _0217_/Q Tile_X0Y0_FrameData[3] VGND VPWR Tile_X0Y1_FrameStrobe[3] latch
X_0148_ _0148_/Q Tile_X0Y0_FrameData[8] VGND VPWR Tile_X0Y1_FrameStrobe[1] latch
XFILLER_101_37 VPWR VGND sg13cmos5l_decap_8
XFILLER_101_48 VPWR VGND sg13cmos5l_fill_2
XFILLER_137_227 VPWR VGND sg13cmos5l_fill_2
XFILLER_51_177 VPWR VGND sg13cmos5l_decap_8
X_0079_ _0922_/A _1139_/X _1140_/X _0534_/Q VPWR VGND sg13cmos5l_mux2_1
XFILLER_105_113 VPWR VGND sg13cmos5l_fill_2
XFILLER_19_43 VPWR VGND sg13cmos5l_decap_8
XFILLER_59_211 VPWR VGND sg13cmos5l_decap_4
XANTENNA__0727__X Tile_X0Y0_W2BEG[4] VPWR VGND sg13cmos5l_antennanp
XFILLER_27_141 VPWR VGND sg13cmos5l_decap_8
XFILLER_27_152 VPWR VGND sg13cmos5l_fill_1
XFILLER_35_31 VPWR VGND sg13cmos5l_decap_8
XFILLER_136_0 VPWR VGND sg13cmos5l_decap_8
XFILLER_42_199 VPWR VGND sg13cmos5l_decap_8
XFILLER_104_190 VPWR VGND sg13cmos5l_decap_8
XFILLER_18_141 VPWR VGND sg13cmos5l_fill_2
XFILLER_76_71 VPWR VGND sg13cmos5l_decap_4
X_1051_ _1051_/X _0636_/Q _0640_/Q _1080_/X _1095_/X _0226_/Q _0225_/Q VPWR VGND sg13cmos5l_mux4_1
X_1120_ _1120_/X _1208_/X _1212_/X _1216_/X _1196_/X _0575_/Q _0574_/Q VPWR VGND sg13cmos5l_mux4_1
XFILLER_119_227 VPWR VGND sg13cmos5l_fill_2
XFILLER_33_144 VPWR VGND sg13cmos5l_decap_8
X_0904_ Tile_X0Y1_S2BEGb[4] _1223_/X VPWR VGND sg13cmos5l_buf_1
XFILLER_92_70 VPWR VGND sg13cmos5l_decap_8
XFILLER_51_0 VPWR VGND sg13cmos5l_decap_8
X_0835_ Tile_X0Y1_FrameData_O[11] Tile_X0Y1_FrameData[11] VPWR VGND sg13cmos5l_buf_1
X_0766_ Tile_X0Y0_N4BEG[15] _0766_/A VPWR VGND sg13cmos5l_buf_1
X_0697_ _0697_/L_HI VPWR VGND sg13cmos5l_tiehi
XFILLER_102_105 VPWR VGND sg13cmos5l_decap_8
XFILLER_102_138 VPWR VGND sg13cmos5l_fill_2
XFILLER_110_193 VPWR VGND sg13cmos5l_decap_4
XFILLER_24_133 VPWR VGND sg13cmos5l_decap_8
XFILLER_24_177 VPWR VGND sg13cmos5l_fill_1
XFILLER_71_228 VPWR VGND sg13cmos5l_fill_1
XANTENNA_40 Tile_X0Y1_N2MID[6] VPWR VGND sg13cmos5l_antennanp
XANTENNA_51 Tile_X0Y1_FrameData[15] VPWR VGND sg13cmos5l_antennanp
XFILLER_137_77 VPWR VGND sg13cmos5l_decap_8
XFILLER_15_100 VPWR VGND sg13cmos5l_decap_8
XFILLER_102_91 VPWR VGND sg13cmos5l_decap_8
XFILLER_30_103 VPWR VGND sg13cmos5l_fill_2
XFILLER_30_169 VPWR VGND sg13cmos5l_decap_4
XFILLER_62_84 VPWR VGND sg13cmos5l_decap_8
XANTENNA__0920__X Tile_X0Y1_S4BEG[12] VPWR VGND sg13cmos5l_antennanp
X_0620_ NPU_ACT_WDATA2 Tile_X0Y1_UserCLK _0984_/X _0661_/L_HI VPWR VGND sg13cmos5l_dfrbpq_1
X_0551_ _0551_/Q Tile_X0Y1_FrameData[19] VGND VPWR Tile_X0Y1_FrameStrobe[6] latch
X_0482_ _0482_/Q Tile_X0Y1_FrameData[24] VGND VPWR Tile_X0Y1_FrameStrobe[4] latch
X_1034_ _1034_/X Tile_X0Y0_EE4END[7] _0639_/Q _1095_/X _1096_/X _0260_/Q _0259_/Q
+ VPWR VGND sg13cmos5l_mux4_1
X_1103_ _1103_/X Tile_X0Y1_E2MID[7] Tile_X0Y1_E2END[7] Tile_X0Y1_E6END[7] _1195_/X
+ _0594_/Q _0593_/Q VPWR VGND sg13cmos5l_mux4_1
XFILLER_99_0 VPWR VGND sg13cmos5l_fill_2
XANTENNA__0830__X Tile_X0Y1_FrameData_O[6] VPWR VGND sg13cmos5l_antennanp
XFILLER_107_36 VPWR VGND sg13cmos5l_decap_8
XFILLER_130_211 VPWR VGND sg13cmos5l_decap_8
X_0818_ Tile_X0Y0_FrameStrobe_O[15] Tile_X0Y1_FrameStrobe[15] VPWR VGND sg13cmos5l_buf_1
X_0749_ Tile_X0Y0_W6BEG[10] _1073_/X VPWR VGND sg13cmos5l_buf_1
XFILLER_44_206 VPWR VGND sg13cmos5l_decap_8
XFILLER_83_28 VPWR VGND sg13cmos5l_decap_8
XANTENNA__0740__X Tile_X0Y0_W6BEG[1] VPWR VGND sg13cmos5l_antennanp
XANTENNA__0915__X Tile_X0Y1_S4BEG[7] VPWR VGND sg13cmos5l_antennanp
XFILLER_35_228 VPWR VGND sg13cmos5l_fill_1
XFILLER_57_73 VPWR VGND sg13cmos5l_decap_8
XFILLER_73_50 VPWR VGND sg13cmos5l_fill_2
XFILLER_92_7 VPWR VGND sg13cmos5l_decap_8
XFILLER_7_184 VPWR VGND sg13cmos5l_decap_8
X_0603_ _0603_/Q Tile_X0Y1_FrameData[31] VGND VPWR Tile_X0Y1_FrameStrobe[0] latch
X_0534_ _0534_/Q Tile_X0Y1_FrameData[4] VGND VPWR Tile_X0Y1_FrameStrobe[5] latch
XFILLER_14_0 VPWR VGND sg13cmos5l_decap_4
XFILLER_26_206 VPWR VGND sg13cmos5l_fill_1
XFILLER_78_180 VPWR VGND sg13cmos5l_decap_8
XFILLER_85_128 VPWR VGND sg13cmos5l_fill_2
X_0465_ _0465_/Q Tile_X0Y1_FrameData[9] VGND VPWR Tile_X0Y1_FrameStrobe[3] latch
X_0396_ _0396_/Q Tile_X0Y1_FrameData[14] VGND VPWR Tile_X0Y1_FrameStrobe[1] latch
XANTENNA__0825__X Tile_X0Y1_FrameData_O[1] VPWR VGND sg13cmos5l_antennanp
X_1017_ _1017_/X Tile_X0Y0_E1END[3] Tile_X0Y0_EE4END[3] Tile_X0Y0_E6END[11] _1091_/X
+ _0313_/Q _0312_/Q VPWR VGND sg13cmos5l_mux4_1
XFILLER_103_211 VPWR VGND sg13cmos5l_decap_4
XFILLER_134_56 VPWR VGND sg13cmos5l_decap_8
XFILLER_76_139 VPWR VGND sg13cmos5l_decap_8
XANTENNA__0735__X Tile_X0Y0_W2BEGb[4] VPWR VGND sg13cmos5l_antennanp
XFILLER_84_172 VPWR VGND sg13cmos5l_decap_8
XFILLER_138_141 VPWR VGND sg13cmos5l_decap_8
XFILLER_40_220 VPWR VGND sg13cmos5l_decap_8
XFILLER_4_14 VPWR VGND sg13cmos5l_decap_8
XFILLER_75_161 VPWR VGND sg13cmos5l_decap_8
X_0250_ _0250_/Q Tile_X0Y0_FrameData[2] VGND VPWR Tile_X0Y1_FrameStrobe[4] latch
X_0181_ _0181_/Q Tile_X0Y0_FrameData[7] VGND VPWR Tile_X0Y1_FrameStrobe[2] latch
XFILLER_84_82 VPWR VGND sg13cmos5l_decap_8
XFILLER_129_141 VPWR VGND sg13cmos5l_decap_8
XFILLER_129_196 VPWR VGND sg13cmos5l_decap_8
XFILLER_76_2 VPWR VGND sg13cmos5l_fill_1
X_0517_ _0517_/Q Tile_X0Y1_FrameData[21] VGND VPWR Tile_X0Y1_FrameStrobe[5] latch
XFILLER_81_142 VPWR VGND sg13cmos5l_decap_8
X_0448_ _0448_/Q Tile_X0Y1_FrameData[26] VGND VPWR Tile_X0Y1_FrameStrobe[3] latch
X_0379_ _0379_/Q Tile_X0Y1_FrameData[31] VGND VPWR Tile_X0Y1_FrameStrobe[1] latch
XFILLER_13_56 VPWR VGND sg13cmos5l_fill_1
XFILLER_22_220 VPWR VGND sg13cmos5l_decap_8
XFILLER_129_56 VPWR VGND sg13cmos5l_decap_8
XFILLER_135_133 VPWR VGND sg13cmos5l_decap_8
XFILLER_1_135 VPWR VGND sg13cmos5l_decap_8
XFILLER_1_157 VPWR VGND sg13cmos5l_fill_1
XFILLER_1_179 VPWR VGND sg13cmos5l_decap_8
XFILLER_13_220 VPWR VGND sg13cmos5l_decap_8
XFILLER_54_30 VPWR VGND sg13cmos5l_decap_4
XFILLER_72_164 VPWR VGND sg13cmos5l_decap_8
XFILLER_9_202 VPWR VGND sg13cmos5l_fill_2
XFILLER_126_166 VPWR VGND sg13cmos5l_decap_8
XFILLER_141_158 VPWR VGND sg13cmos5l_decap_8
XFILLER_79_71 VPWR VGND sg13cmos5l_decap_8
X_0302_ _0302_/Q Tile_X0Y0_FrameData[14] VGND VPWR Tile_X0Y1_FrameStrobe[6] latch
XFILLER_63_164 VPWR VGND sg13cmos5l_decap_8
X_0233_ _0233_/Q Tile_X0Y0_FrameData[19] VGND VPWR Tile_X0Y1_FrameStrobe[4] latch
X_0164_ _0164_/Q Tile_X0Y0_FrameData[24] VGND VPWR Tile_X0Y1_FrameStrobe[2] latch
XFILLER_81_0 VPWR VGND sg13cmos5l_decap_4
X_0095_ _0095_/Q Tile_X0Y0_FrameData[29] VGND VPWR Tile_X0Y1_FrameStrobe[0] latch
XFILLER_117_133 VPWR VGND sg13cmos5l_decap_8
X_0997_ _0997_/X Tile_X0Y1_E1END[3] Tile_X0Y1_EE4END[7] Tile_X0Y1_EE4END[15] _1218_/X
+ _0404_/Q _0403_/Q VPWR VGND sg13cmos5l_mux4_1
XFILLER_132_147 VPWR VGND sg13cmos5l_decap_8
XFILLER_86_212 VPWR VGND sg13cmos5l_decap_4
XFILLER_131_35 VPWR VGND sg13cmos5l_fill_2
XFILLER_54_131 VPWR VGND sg13cmos5l_fill_2
XFILLER_54_164 VPWR VGND sg13cmos5l_decap_4
XFILLER_54_186 VPWR VGND sg13cmos5l_decap_8
XFILLER_108_111 VPWR VGND sg13cmos5l_decap_8
XFILLER_10_223 VPWR VGND sg13cmos5l_decap_4
XFILLER_108_166 VPWR VGND sg13cmos5l_fill_1
XFILLER_123_158 VPWR VGND sg13cmos5l_decap_8
XFILLER_40_98 VPWR VGND sg13cmos5l_decap_8
XFILLER_49_52 VPWR VGND sg13cmos5l_decap_4
XFILLER_1_37 VPWR VGND sg13cmos5l_fill_1
XFILLER_65_84 VPWR VGND sg13cmos5l_decap_8
XANTENNA__0923__X Tile_X0Y1_S4BEG[15] VPWR VGND sg13cmos5l_antennanp
XFILLER_45_186 VPWR VGND sg13cmos5l_fill_1
XFILLER_60_101 VPWR VGND sg13cmos5l_decap_8
XFILLER_60_178 VPWR VGND sg13cmos5l_decap_8
X_0920_ Tile_X0Y1_S4BEG[12] _0920_/A VPWR VGND sg13cmos5l_buf_1
X_0851_ Tile_X0Y1_FrameData_O[27] Tile_X0Y1_FrameData[27] VPWR VGND sg13cmos5l_buf_1
X_0782_ Tile_X0Y0_WW4BEG[15] _1062_/X VPWR VGND sg13cmos5l_buf_1
XFILLER_114_158 VPWR VGND sg13cmos5l_decap_8
X_1196_ _1196_/X Tile_X0Y1_N2MID[1] Tile_X0Y1_N2END[1] _1220_/X Tile_X0Y0_S2MID[1]
+ _0368_/Q _0367_/Q VPWR VGND sg13cmos5l_mux4_1
X_0216_ _0216_/Q Tile_X0Y0_FrameData[4] VGND VPWR Tile_X0Y1_FrameStrobe[3] latch
X_0147_ _0147_/Q Tile_X0Y0_FrameData[9] VGND VPWR Tile_X0Y1_FrameStrobe[1] latch
X_0078_ _0921_/A _1137_/X _1138_/X _0537_/Q VPWR VGND sg13cmos5l_mux2_1
XANTENNA__0833__X Tile_X0Y1_FrameData_O[9] VPWR VGND sg13cmos5l_antennanp
XFILLER_137_206 VPWR VGND sg13cmos5l_decap_8
XFILLER_51_156 VPWR VGND sg13cmos5l_decap_8
XFILLER_126_35 VPWR VGND sg13cmos5l_decap_4
XFILLER_126_79 VPWR VGND sg13cmos5l_fill_2
XFILLER_113_180 VPWR VGND sg13cmos5l_decap_8
XANTENNA__0743__X Tile_X0Y0_W6BEG[4] VPWR VGND sg13cmos5l_antennanp
XFILLER_35_87 VPWR VGND sg13cmos5l_fill_2
XFILLER_35_98 VPWR VGND sg13cmos5l_fill_1
XFILLER_42_123 VPWR VGND sg13cmos5l_fill_2
XFILLER_129_0 VPWR VGND sg13cmos5l_decap_8
XFILLER_51_86 VPWR VGND sg13cmos5l_decap_8
XANTENNA__0918__X Tile_X0Y1_S4BEG[10] VPWR VGND sg13cmos5l_antennanp
XFILLER_18_120 VPWR VGND sg13cmos5l_decap_8
XFILLER_33_123 VPWR VGND sg13cmos5l_decap_8
XFILLER_76_94 VPWR VGND sg13cmos5l_fill_2
XFILLER_80_218 VPWR VGND sg13cmos5l_decap_8
X_1050_ _1050_/X _0639_/Q _0643_/Q _1075_/X _1096_/X _0228_/Q _0227_/Q VPWR VGND sg13cmos5l_mux4_1
XFILLER_119_206 VPWR VGND sg13cmos5l_decap_8
X_0903_ Tile_X0Y1_S2BEGb[3] _1222_/X VPWR VGND sg13cmos5l_buf_1
X_0834_ Tile_X0Y1_FrameData_O[10] Tile_X0Y1_FrameData[10] VPWR VGND sg13cmos5l_buf_1
X_0765_ Tile_X0Y0_N4BEG[14] _0765_/A VPWR VGND sg13cmos5l_buf_1
X_0696_ _0696_/L_HI VPWR VGND sg13cmos5l_tiehi
XANTENNA__0828__X Tile_X0Y1_FrameData_O[4] VPWR VGND sg13cmos5l_antennanp
XFILLER_110_172 VPWR VGND sg13cmos5l_decap_8
XFILLER_56_215 VPWR VGND sg13cmos5l_fill_2
XFILLER_24_189 VPWR VGND sg13cmos5l_decap_8
X_1179_ _1179_/X Tile_X0Y1_N4END[0] Tile_X0Y0_S4END[4] _1214_/X _1218_/X _0458_/Q
+ _0457_/Q VPWR VGND sg13cmos5l_mux4_1
XANTENNA_30 Tile_X0Y1_N2MID[2] VPWR VGND sg13cmos5l_antennanp
XANTENNA_41 Tile_X0Y1_N2MID[6] VPWR VGND sg13cmos5l_antennanp
XANTENNA_52 Tile_X0Y1_FrameData[15] VPWR VGND sg13cmos5l_antennanp
XFILLER_122_7 VPWR VGND sg13cmos5l_fill_2
XFILLER_137_56 VPWR VGND sg13cmos5l_decap_8
XFILLER_133_220 VPWR VGND sg13cmos5l_decap_8
XFILLER_97_38 VPWR VGND sg13cmos5l_decap_8
XANTENNA__0738__X Tile_X0Y0_W2BEGb[7] VPWR VGND sg13cmos5l_antennanp
XFILLER_15_123 VPWR VGND sg13cmos5l_decap_4
XFILLER_46_75 VPWR VGND sg13cmos5l_fill_2
XFILLER_15_189 VPWR VGND sg13cmos5l_decap_8
XFILLER_7_47 VPWR VGND sg13cmos5l_decap_4
X_0550_ _0550_/Q Tile_X0Y1_FrameData[20] VGND VPWR Tile_X0Y1_FrameStrobe[6] latch
X_1102_ _1102_/X _1113_/X Tile_X0Y0_E6END[2] Tile_X0Y0_S1END[2] _1102_/A3 _0096_/Q
+ _0095_/Q VPWR VGND sg13cmos5l_mux4_1
X_0481_ _0481_/Q Tile_X0Y1_FrameData[25] VGND VPWR Tile_X0Y1_FrameStrobe[4] latch
XFILLER_87_82 VPWR VGND sg13cmos5l_fill_1
X_1033_ _1033_/X Tile_X0Y0_EE4END[6] _0638_/Q _1094_/X _1097_/X _0262_/Q _0261_/Q
+ VPWR VGND sg13cmos5l_mux4_1
XFILLER_21_137 VPWR VGND sg13cmos5l_decap_4
X_0817_ Tile_X0Y0_FrameStrobe_O[14] Tile_X0Y1_FrameStrobe[14] VPWR VGND sg13cmos5l_buf_1
XFILLER_107_15 VPWR VGND sg13cmos5l_decap_8
XFILLER_115_220 VPWR VGND sg13cmos5l_decap_8
X_0748_ Tile_X0Y0_W6BEG[9] _1072_/X VPWR VGND sg13cmos5l_buf_1
X_0679_ _0679_/L_HI VPWR VGND sg13cmos5l_tiehi
XFILLER_88_126 VPWR VGND sg13cmos5l_decap_8
XFILLER_29_226 VPWR VGND sg13cmos5l_fill_2
XFILLER_32_22 VPWR VGND sg13cmos5l_fill_2
XFILLER_120_4 VPWR VGND sg13cmos5l_fill_2
XFILLER_57_30 VPWR VGND sg13cmos5l_decap_8
XFILLER_87_170 VPWR VGND sg13cmos5l_decap_8
XANTENNA__0931__X Tile_X0Y1_W2BEG[2] VPWR VGND sg13cmos5l_antennanp
XFILLER_7_163 VPWR VGND sg13cmos5l_decap_8
X_0602_ _0602_/Q Tile_X0Y1_FrameData[0] VGND VPWR Tile_X0Y1_FrameStrobe[7] latch
X_0533_ _0533_/Q Tile_X0Y1_FrameData[5] VGND VPWR Tile_X0Y1_FrameStrobe[5] latch
X_0464_ _0464_/Q Tile_X0Y1_FrameData[10] VGND VPWR Tile_X0Y1_FrameStrobe[3] latch
X_0395_ _0395_/Q Tile_X0Y1_FrameData[15] VGND VPWR Tile_X0Y1_FrameStrobe[1] latch
XFILLER_93_162 VPWR VGND sg13cmos5l_decap_8
X_1016_ _1016_/X _1085_/X _1081_/X _1077_/X _1094_/X _0316_/Q _0315_/Q VPWR VGND sg13cmos5l_mux4_1
XANTENNA__0841__X Tile_X0Y1_FrameData_O[17] VPWR VGND sg13cmos5l_antennanp
XFILLER_134_35 VPWR VGND sg13cmos5l_decap_8
XFILLER_69_192 VPWR VGND sg13cmos5l_decap_4
XFILLER_76_118 VPWR VGND sg13cmos5l_decap_8
XFILLER_27_88 VPWR VGND sg13cmos5l_decap_8
XFILLER_43_21 VPWR VGND sg13cmos5l_decap_8
XANTENNA__0751__X Tile_X0Y0_N4BEG[0] VPWR VGND sg13cmos5l_antennanp
XFILLER_138_120 VPWR VGND sg13cmos5l_decap_8
XFILLER_43_87 VPWR VGND sg13cmos5l_decap_8
XFILLER_111_0 VPWR VGND sg13cmos5l_decap_8
XFILLER_4_133 VPWR VGND sg13cmos5l_decap_8
XFILLER_4_155 VPWR VGND sg13cmos5l_decap_8
XANTENNA__0926__X Tile_X0Y1_W1BEG[1] VPWR VGND sg13cmos5l_antennanp
XFILLER_68_84 VPWR VGND sg13cmos5l_decap_8
XFILLER_75_140 VPWR VGND sg13cmos5l_decap_8
XFILLER_84_61 VPWR VGND sg13cmos5l_decap_8
X_0180_ _0180_/Q Tile_X0Y0_FrameData[8] VGND VPWR Tile_X0Y1_FrameStrobe[2] latch
XANTENNA__0610__Q NPU_WEIGHT_IN0 VPWR VGND sg13cmos5l_antennanp
XFILLER_100_226 VPWR VGND sg13cmos5l_fill_2
X_0516_ _0516_/Q Tile_X0Y1_FrameData[22] VGND VPWR Tile_X0Y1_FrameStrobe[5] latch
X_0447_ _0447_/Q Tile_X0Y1_FrameData[27] VGND VPWR Tile_X0Y1_FrameStrobe[3] latch
XANTENNA__0836__X Tile_X0Y1_FrameData_O[12] VPWR VGND sg13cmos5l_antennanp
XFILLER_66_140 VPWR VGND sg13cmos5l_decap_4
XFILLER_81_198 VPWR VGND sg13cmos5l_decap_8
X_0378_ _0378_/Q Tile_X0Y1_FrameData[0] VGND VPWR Tile_X0Y1_FrameStrobe[0] latch
XFILLER_135_112 VPWR VGND sg13cmos5l_decap_8
XFILLER_135_189 VPWR VGND sg13cmos5l_decap_8
XFILLER_1_114 VPWR VGND sg13cmos5l_fill_1
XANTENNA__0746__X Tile_X0Y0_W6BEG[7] VPWR VGND sg13cmos5l_antennanp
XFILLER_38_65 VPWR VGND sg13cmos5l_fill_1
XFILLER_38_98 VPWR VGND sg13cmos5l_decap_8
XFILLER_49_118 VPWR VGND sg13cmos5l_fill_1
XFILLER_72_143 VPWR VGND sg13cmos5l_decap_8
XFILLER_126_145 VPWR VGND sg13cmos5l_decap_8
XFILLER_70_63 VPWR VGND sg13cmos5l_decap_8
XFILLER_70_74 VPWR VGND sg13cmos5l_fill_2
XFILLER_126_189 VPWR VGND sg13cmos5l_fill_1
XFILLER_141_137 VPWR VGND sg13cmos5l_decap_8
X_0301_ _0301_/Q Tile_X0Y0_FrameData[15] VGND VPWR Tile_X0Y1_FrameStrobe[6] latch
XFILLER_63_143 VPWR VGND sg13cmos5l_decap_8
X_0232_ _0232_/Q Tile_X0Y0_FrameData[20] VGND VPWR Tile_X0Y1_FrameStrobe[4] latch
X_0163_ _0163_/Q Tile_X0Y0_FrameData[25] VGND VPWR Tile_X0Y1_FrameStrobe[2] latch
X_0094_ _0094_/Q Tile_X0Y0_FrameData[30] VGND VPWR Tile_X0Y1_FrameStrobe[0] latch
XFILLER_74_0 VPWR VGND sg13cmos5l_decap_4
X_0996_ _0996_/X Tile_X0Y1_E1END[2] Tile_X0Y1_EE4END[6] Tile_X0Y1_EE4END[14] _1217_/X
+ _0406_/Q _0405_/Q VPWR VGND sg13cmos5l_mux4_1
XFILLER_117_112 VPWR VGND sg13cmos5l_decap_8
XFILLER_132_126 VPWR VGND sg13cmos5l_decap_8
XFILLER_131_14 VPWR VGND sg13cmos5l_decap_8
XFILLER_131_69 VPWR VGND sg13cmos5l_decap_8
XFILLER_24_56 VPWR VGND sg13cmos5l_fill_1
XFILLER_10_202 VPWR VGND sg13cmos5l_decap_8
XFILLER_24_78 VPWR VGND sg13cmos5l_decap_8
XFILLER_40_22 VPWR VGND sg13cmos5l_fill_2
XFILLER_40_66 VPWR VGND sg13cmos5l_decap_8
XFILLER_6_206 VPWR VGND sg13cmos5l_fill_2
XFILLER_6_228 VPWR VGND sg13cmos5l_fill_1
XFILLER_123_137 VPWR VGND sg13cmos5l_decap_8
XFILLER_131_181 VPWR VGND sg13cmos5l_decap_4
XFILLER_49_42 VPWR VGND sg13cmos5l_decap_4
XFILLER_105_92 VPWR VGND sg13cmos5l_decap_8
XFILLER_45_154 VPWR VGND sg13cmos5l_decap_4
XFILLER_65_63 VPWR VGND sg13cmos5l_decap_8
XFILLER_92_227 VPWR VGND sg13cmos5l_fill_2
XFILLER_60_157 VPWR VGND sg13cmos5l_decap_8
XFILLER_81_73 VPWR VGND sg13cmos5l_decap_8
X_0850_ Tile_X0Y1_FrameData_O[26] Tile_X0Y1_FrameData[26] VPWR VGND sg13cmos5l_buf_1
X_0781_ Tile_X0Y0_WW4BEG[14] _1061_/X VPWR VGND sg13cmos5l_buf_1
XFILLER_122_181 VPWR VGND sg13cmos5l_decap_8
XFILLER_83_216 VPWR VGND sg13cmos5l_fill_1
XFILLER_83_227 VPWR VGND sg13cmos5l_fill_2
X_0215_ _0215_/Q Tile_X0Y0_FrameData[5] VGND VPWR Tile_X0Y1_FrameStrobe[3] latch
XFILLER_36_176 VPWR VGND sg13cmos5l_decap_8
XFILLER_51_135 VPWR VGND sg13cmos5l_decap_8
X_1195_ _1195_/X Tile_X0Y1_N2MID[0] Tile_X0Y1_N2END[0] _1219_/X Tile_X0Y0_S2MID[0]
+ _0370_/Q _0369_/Q VPWR VGND sg13cmos5l_mux4_1
X_0146_ _0146_/Q Tile_X0Y0_FrameData[10] VGND VPWR Tile_X0Y1_FrameStrobe[1] latch
X_0077_ _0920_/A _1135_/X _1136_/X _0540_/Q VPWR VGND sg13cmos5l_mux2_1
X_0979_ _0979_/X Tile_X0Y0_E2MID[6] Tile_X0Y0_E2END[6] _1098_/X _0979_/A3 _0158_/Q
+ _0157_/Q VPWR VGND sg13cmos5l_mux4_1
XFILLER_105_115 VPWR VGND sg13cmos5l_fill_1
XFILLER_86_29 VPWR VGND sg13cmos5l_decap_4
XFILLER_42_102 VPWR VGND sg13cmos5l_decap_8
XFILLER_74_216 VPWR VGND sg13cmos5l_decap_8
XFILLER_74_227 VPWR VGND sg13cmos5l_fill_2
XFILLER_35_66 VPWR VGND sg13cmos5l_decap_8
XFILLER_4_0 VPWR VGND sg13cmos5l_decap_8
XFILLER_51_65 VPWR VGND sg13cmos5l_decap_8
XFILLER_111_118 VPWR VGND sg13cmos5l_decap_8
XANTENNA__0934__X Tile_X0Y1_W2BEG[5] VPWR VGND sg13cmos5l_antennanp
XFILLER_18_143 VPWR VGND sg13cmos5l_fill_1
XFILLER_33_179 VPWR VGND sg13cmos5l_decap_8
X_0902_ Tile_X0Y1_S2BEGb[2] _1221_/X VPWR VGND sg13cmos5l_buf_1
X_0833_ Tile_X0Y1_FrameData_O[9] Tile_X0Y1_FrameData[9] VPWR VGND sg13cmos5l_buf_1
XFILLER_37_0 VPWR VGND sg13cmos5l_fill_2
X_0764_ Tile_X0Y0_N4BEG[13] _0764_/A VPWR VGND sg13cmos5l_buf_1
X_0695_ _0695_/L_HI VPWR VGND sg13cmos5l_tiehi
XFILLER_110_151 VPWR VGND sg13cmos5l_decap_8
XFILLER_56_227 VPWR VGND sg13cmos5l_fill_2
X_1178_ _1178_/X _0647_/Q _0651_/Q _1203_/X _1195_/X _0460_/Q _0459_/Q VPWR VGND sg13cmos5l_mux4_1
XANTENNA_20 Tile_X0Y0_S2MID[7] VPWR VGND sg13cmos5l_antennanp
XANTENNA_31 Tile_X0Y1_N2MID[2] VPWR VGND sg13cmos5l_antennanp
XANTENNA__0844__X Tile_X0Y1_FrameData_O[20] VPWR VGND sg13cmos5l_antennanp
XFILLER_24_168 VPWR VGND sg13cmos5l_decap_8
X_0129_ _0129_/Q Tile_X0Y0_FrameData[27] VGND VPWR Tile_X0Y1_FrameStrobe[1] latch
XANTENNA_42 Tile_X0Y1_N2MID[7] VPWR VGND sg13cmos5l_antennanp
XANTENNA_53 Tile_X0Y1_FrameData[15] VPWR VGND sg13cmos5l_antennanp
XFILLER_137_35 VPWR VGND sg13cmos5l_decap_8
XFILLER_21_13 VPWR VGND sg13cmos5l_fill_2
XFILLER_97_17 VPWR VGND sg13cmos5l_decap_8
XFILLER_47_205 VPWR VGND sg13cmos5l_decap_8
XFILLER_47_227 VPWR VGND sg13cmos5l_fill_2
XANTENNA__0754__X Tile_X0Y0_N4BEG[3] VPWR VGND sg13cmos5l_antennanp
XFILLER_101_184 VPWR VGND sg13cmos5l_decap_8
XFILLER_15_157 VPWR VGND sg13cmos5l_decap_8
XFILLER_15_168 VPWR VGND sg13cmos5l_decap_8
XFILLER_46_54 VPWR VGND sg13cmos5l_decap_8
XFILLER_141_0 VPWR VGND sg13cmos5l_decap_8
XFILLER_30_105 VPWR VGND sg13cmos5l_fill_1
XFILLER_30_116 VPWR VGND sg13cmos5l_decap_8
XFILLER_62_42 VPWR VGND sg13cmos5l_fill_2
XANTENNA__0929__X Tile_X0Y1_W2BEG[0] VPWR VGND sg13cmos5l_antennanp
XFILLER_124_210 VPWR VGND sg13cmos5l_decap_8
X_0480_ _0480_/Q Tile_X0Y1_FrameData[26] VGND VPWR Tile_X0Y1_FrameStrobe[4] latch
XFILLER_97_127 VPWR VGND sg13cmos5l_decap_8
XFILLER_87_50 VPWR VGND sg13cmos5l_fill_2
X_1032_ _1032_/X Tile_X0Y0_EE4END[5] _0637_/Q _1093_/X _1098_/X _0264_/Q _0263_/Q
+ VPWR VGND sg13cmos5l_mux4_1
X_1101_ _1101_/X _1112_/X Tile_X0Y0_E6END[1] Tile_X0Y0_S1END[1] _1101_/A3 _0098_/Q
+ _0097_/Q VPWR VGND sg13cmos5l_mux4_1
XFILLER_99_2 VPWR VGND sg13cmos5l_fill_1
XANTENNA__0613__Q NPU_WEIGHT_IN3 VPWR VGND sg13cmos5l_antennanp
X_0816_ Tile_X0Y0_FrameStrobe_O[13] Tile_X0Y1_FrameStrobe[13] VPWR VGND sg13cmos5l_buf_1
X_0747_ Tile_X0Y0_W6BEG[8] _1071_/X VPWR VGND sg13cmos5l_buf_1
XANTENNA__0839__X Tile_X0Y1_FrameData_O[15] VPWR VGND sg13cmos5l_antennanp
XFILLER_29_205 VPWR VGND sg13cmos5l_decap_8
X_0678_ _0678_/L_HI VPWR VGND sg13cmos5l_tiehi
XFILLER_88_149 VPWR VGND sg13cmos5l_decap_8
XFILLER_88_105 VPWR VGND sg13cmos5l_decap_8
XFILLER_96_193 VPWR VGND sg13cmos5l_decap_8
XFILLER_12_149 VPWR VGND sg13cmos5l_decap_8
XFILLER_32_45 VPWR VGND sg13cmos5l_fill_2
XFILLER_32_89 VPWR VGND sg13cmos5l_decap_8
XFILLER_106_221 VPWR VGND sg13cmos5l_decap_8
XFILLER_113_4 VPWR VGND sg13cmos5l_fill_2
XFILLER_79_127 VPWR VGND sg13cmos5l_decap_4
XANTENNA__0749__X Tile_X0Y0_W6BEG[10] VPWR VGND sg13cmos5l_antennanp
XFILLER_11_182 VPWR VGND sg13cmos5l_decap_8
XFILLER_7_142 VPWR VGND sg13cmos5l_decap_8
X_0601_ _0601_/Q Tile_X0Y1_FrameData[1] VGND VPWR Tile_X0Y1_FrameStrobe[7] latch
XFILLER_112_213 VPWR VGND sg13cmos5l_decap_8
X_0532_ _0532_/Q Tile_X0Y1_FrameData[6] VGND VPWR Tile_X0Y1_FrameStrobe[5] latch
X_0463_ _0463_/Q Tile_X0Y1_FrameData[11] VGND VPWR Tile_X0Y1_FrameStrobe[3] latch
X_0394_ _0394_/Q Tile_X0Y1_FrameData[16] VGND VPWR Tile_X0Y1_FrameStrobe[1] latch
XFILLER_98_82 VPWR VGND sg13cmos5l_decap_8
X_1015_ _1015_/X Tile_X0Y0_E1END[2] Tile_X0Y0_EE4END[2] Tile_X0Y0_E6END[10] _1090_/X
+ _0316_/Q _0315_/Q VPWR VGND sg13cmos5l_mux4_1
XFILLER_93_196 VPWR VGND sg13cmos5l_decap_8
XFILLER_118_48 VPWR VGND sg13cmos5l_fill_2
XFILLER_134_14 VPWR VGND sg13cmos5l_decap_8
XFILLER_69_171 VPWR VGND sg13cmos5l_decap_8
XFILLER_84_196 VPWR VGND sg13cmos5l_decap_8
XFILLER_138_187 VPWR VGND sg13cmos5l_decap_8
XFILLER_43_66 VPWR VGND sg13cmos5l_decap_8
XFILLER_4_112 VPWR VGND sg13cmos5l_decap_8
XFILLER_104_0 VPWR VGND sg13cmos5l_decap_4
XFILLER_4_49 VPWR VGND sg13cmos5l_decap_4
XFILLER_67_119 VPWR VGND sg13cmos5l_decap_8
XFILLER_68_63 VPWR VGND sg13cmos5l_decap_8
XFILLER_68_96 VPWR VGND sg13cmos5l_decap_8
XFILLER_75_196 VPWR VGND sg13cmos5l_decap_8
XFILLER_84_40 VPWR VGND sg13cmos5l_decap_8
XFILLER_90_155 VPWR VGND sg13cmos5l_decap_8
XFILLER_90_122 VPWR VGND sg13cmos5l_decap_4
XANTENNA__0942__X Tile_X0Y1_W2BEGb[5] VPWR VGND sg13cmos5l_antennanp
XFILLER_129_176 VPWR VGND sg13cmos5l_decap_8
XFILLER_100_205 VPWR VGND sg13cmos5l_decap_8
XFILLER_104_39 VPWR VGND sg13cmos5l_decap_8
X_0515_ _0515_/Q Tile_X0Y1_FrameData[23] VGND VPWR Tile_X0Y1_FrameStrobe[5] latch
X_0446_ _0446_/Q Tile_X0Y1_FrameData[28] VGND VPWR Tile_X0Y1_FrameStrobe[3] latch
X_0377_ _0377_/Q Tile_X0Y1_FrameData[1] VGND VPWR Tile_X0Y1_FrameStrobe[0] latch
XFILLER_120_38 VPWR VGND sg13cmos5l_decap_8
XFILLER_66_196 VPWR VGND sg13cmos5l_fill_1
XFILLER_81_111 VPWR VGND sg13cmos5l_decap_8
XFILLER_81_177 VPWR VGND sg13cmos5l_decap_8
XANTENNA__0852__X Tile_X0Y1_FrameData_O[28] VPWR VGND sg13cmos5l_antennanp
XFILLER_129_14 VPWR VGND sg13cmos5l_decap_8
XFILLER_135_168 VPWR VGND sg13cmos5l_decap_8
XFILLER_1_148 VPWR VGND sg13cmos5l_decap_8
XFILLER_38_44 VPWR VGND sg13cmos5l_decap_8
XFILLER_57_130 VPWR VGND sg13cmos5l_decap_8
XFILLER_72_122 VPWR VGND sg13cmos5l_decap_8
XANTENNA__0762__X Tile_X0Y0_N4BEG[11] VPWR VGND sg13cmos5l_antennanp
XFILLER_110_93 VPWR VGND sg13cmos5l_decap_8
XFILLER_70_42 VPWR VGND sg13cmos5l_decap_8
XFILLER_9_215 VPWR VGND sg13cmos5l_fill_2
XFILLER_126_124 VPWR VGND sg13cmos5l_decap_8
XFILLER_141_116 VPWR VGND sg13cmos5l_decap_8
XANTENNA__0937__X Tile_X0Y1_W2BEGb[0] VPWR VGND sg13cmos5l_antennanp
XFILLER_0_181 VPWR VGND sg13cmos5l_decap_8
XFILLER_48_152 VPWR VGND sg13cmos5l_decap_8
X_0300_ _0300_/Q Tile_X0Y0_FrameData[16] VGND VPWR Tile_X0Y1_FrameStrobe[6] latch
X_0231_ _0231_/Q Tile_X0Y0_FrameData[21] VGND VPWR Tile_X0Y1_FrameStrobe[4] latch
XFILLER_95_214 VPWR VGND sg13cmos5l_fill_2
XFILLER_48_196 VPWR VGND sg13cmos5l_decap_8
XFILLER_63_122 VPWR VGND sg13cmos5l_decap_8
XFILLER_63_188 VPWR VGND sg13cmos5l_fill_2
X_0162_ _0162_/Q Tile_X0Y0_FrameData[26] VGND VPWR Tile_X0Y1_FrameStrobe[2] latch
X_0093_ NPU_XBAR_SEL3 Tile_X0Y1_UserCLK _0093_/D _0652_/L_HI VPWR VGND sg13cmos5l_dfrbpq_1
XFILLER_67_0 VPWR VGND sg13cmos5l_decap_8
X_0995_ _0995_/X Tile_X0Y1_E1END[1] Tile_X0Y1_EE4END[5] Tile_X0Y1_EE4END[13] _1216_/X
+ _0408_/Q _0407_/Q VPWR VGND sg13cmos5l_mux4_1
XANTENNA__0621__Q NPU_ACT_WDATA3 VPWR VGND sg13cmos5l_antennanp
XFILLER_117_146 VPWR VGND sg13cmos5l_decap_8
XFILLER_125_190 VPWR VGND sg13cmos5l_decap_8
XFILLER_132_105 VPWR VGND sg13cmos5l_decap_8
XFILLER_5_92 VPWR VGND sg13cmos5l_decap_8
XANTENNA__0847__X Tile_X0Y1_FrameData_O[23] VPWR VGND sg13cmos5l_antennanp
XFILLER_131_37 VPWR VGND sg13cmos5l_fill_1
XFILLER_131_48 VPWR VGND sg13cmos5l_decap_8
X_0429_ _0429_/Q Tile_X0Y1_FrameData[13] VGND VPWR Tile_X0Y1_FrameStrobe[2] latch
XFILLER_24_24 VPWR VGND sg13cmos5l_decap_8
XFILLER_108_146 VPWR VGND sg13cmos5l_decap_4
XFILLER_108_157 VPWR VGND sg13cmos5l_decap_8
XFILLER_123_116 VPWR VGND sg13cmos5l_decap_8
XFILLER_40_45 VPWR VGND sg13cmos5l_decap_8
XANTENNA__0757__X Tile_X0Y0_N4BEG[6] VPWR VGND sg13cmos5l_antennanp
XFILLER_131_160 VPWR VGND sg13cmos5l_decap_8
XFILLER_1_28 VPWR VGND sg13cmos5l_decap_8
XFILLER_49_21 VPWR VGND sg13cmos5l_decap_8
XFILLER_92_206 VPWR VGND sg13cmos5l_decap_8
XFILLER_60_136 VPWR VGND sg13cmos5l_decap_8
XFILLER_65_42 VPWR VGND sg13cmos5l_decap_8
XFILLER_81_41 VPWR VGND sg13cmos5l_decap_4
XFILLER_81_52 VPWR VGND sg13cmos5l_decap_8
X_0780_ Tile_X0Y0_WW4BEG[13] _1060_/X VPWR VGND sg13cmos5l_buf_1
XFILLER_60_7 VPWR VGND sg13cmos5l_decap_8
XFILLER_122_160 VPWR VGND sg13cmos5l_decap_8
X_1194_ _1194_/X Tile_X0Y1_N1END[3] Tile_X0Y1_E6END[3] _1230_/X _1194_/A3 _0348_/Q
+ _0603_/Q VPWR VGND sg13cmos5l_mux4_1
X_0214_ _0214_/Q Tile_X0Y0_FrameData[6] VGND VPWR Tile_X0Y1_FrameStrobe[3] latch
XANTENNA__0616__Q NPU_WEIGHT_IN6 VPWR VGND sg13cmos5l_antennanp
XFILLER_36_155 VPWR VGND sg13cmos5l_decap_8
XFILLER_51_114 VPWR VGND sg13cmos5l_decap_8
X_0145_ _0145_/Q Tile_X0Y0_FrameData[11] VGND VPWR Tile_X0Y1_FrameStrobe[1] latch
X_0076_ _0762_/A _1115_/X _1116_/X _0567_/Q VPWR VGND sg13cmos5l_mux2_1
X_0978_ _0978_/X Tile_X0Y0_E2MID[5] Tile_X0Y0_E2END[5] _1097_/X _0978_/A3 _0160_/Q
+ _0159_/Q VPWR VGND sg13cmos5l_mux4_1
XFILLER_126_48 VPWR VGND sg13cmos5l_fill_2
XFILLER_35_45 VPWR VGND sg13cmos5l_decap_8
XFILLER_42_125 VPWR VGND sg13cmos5l_fill_1
XFILLER_128_208 VPWR VGND sg13cmos5l_decap_8
XFILLER_35_89 VPWR VGND sg13cmos5l_fill_1
XFILLER_42_147 VPWR VGND sg13cmos5l_fill_2
XFILLER_51_33 VPWR VGND sg13cmos5l_decap_8
XFILLER_111_108 VPWR VGND sg13cmos5l_fill_2
XFILLER_65_228 VPWR VGND sg13cmos5l_fill_1
XFILLER_76_96 VPWR VGND sg13cmos5l_fill_1
XFILLER_132_91 VPWR VGND sg13cmos5l_decap_8
XFILLER_33_158 VPWR VGND sg13cmos5l_decap_8
XFILLER_92_84 VPWR VGND sg13cmos5l_decap_8
XANTENNA__0950__X Tile_X0Y1_W6BEG[5] VPWR VGND sg13cmos5l_antennanp
XFILLER_41_191 VPWR VGND sg13cmos5l_decap_8
X_0901_ Tile_X0Y1_S2BEGb[1] _1220_/X VPWR VGND sg13cmos5l_buf_1
X_0832_ Tile_X0Y1_FrameData_O[8] Tile_X0Y1_FrameData[8] VPWR VGND sg13cmos5l_buf_1
X_0763_ Tile_X0Y0_N4BEG[12] _0763_/A VPWR VGND sg13cmos5l_buf_1
XFILLER_102_119 VPWR VGND sg13cmos5l_decap_4
X_0694_ _0694_/L_HI VPWR VGND sg13cmos5l_tiehi
XFILLER_2_60 VPWR VGND sg13cmos5l_fill_1
X_1177_ _1177_/X _0646_/Q _0650_/Q _1204_/X _1196_/X _0462_/Q _0461_/Q VPWR VGND sg13cmos5l_mux4_1
X_0128_ _0128_/Q Tile_X0Y0_FrameData[28] VGND VPWR Tile_X0Y1_FrameStrobe[1] latch
XANTENNA_10 Tile_X0Y0_S2MID[2] VPWR VGND sg13cmos5l_antennanp
XANTENNA_21 Tile_X0Y1_N2END[5] VPWR VGND sg13cmos5l_antennanp
XANTENNA_32 Tile_X0Y1_N2MID[4] VPWR VGND sg13cmos5l_antennanp
XANTENNA_43 Tile_X0Y1_N2MID[7] VPWR VGND sg13cmos5l_antennanp
XANTENNA_54 Tile_X0Y1_FrameData[15] VPWR VGND sg13cmos5l_antennanp
XANTENNA__0860__X Tile_X0Y0_FrameData_O[4] VPWR VGND sg13cmos5l_antennanp
XFILLER_24_147 VPWR VGND sg13cmos5l_decap_8
XFILLER_32_180 VPWR VGND sg13cmos5l_decap_8
XFILLER_108_7 VPWR VGND sg13cmos5l_decap_8
XFILLER_137_14 VPWR VGND sg13cmos5l_decap_8
XFILLER_46_33 VPWR VGND sg13cmos5l_decap_8
XFILLER_15_136 VPWR VGND sg13cmos5l_decap_8
XFILLER_46_77 VPWR VGND sg13cmos5l_fill_1
XFILLER_62_21 VPWR VGND sg13cmos5l_decap_8
XFILLER_62_54 VPWR VGND sg13cmos5l_decap_8
XANTENNA__0770__X Tile_X0Y0_WW4BEG[3] VPWR VGND sg13cmos5l_antennanp
XFILLER_134_0 VPWR VGND sg13cmos5l_decap_8
XFILLER_23_191 VPWR VGND sg13cmos5l_decap_8
XFILLER_87_73 VPWR VGND sg13cmos5l_decap_8
XANTENNA__0945__X Tile_X0Y1_W6BEG[0] VPWR VGND sg13cmos5l_antennanp
XFILLER_38_228 VPWR VGND sg13cmos5l_fill_1
X_1031_ _1031_/X Tile_X0Y0_EE4END[4] _0636_/Q _1092_/X _1099_/X _0266_/Q _0265_/Q
+ VPWR VGND sg13cmos5l_mux4_1
X_1100_ _1100_/X _1111_/X Tile_X0Y0_E6END[0] Tile_X0Y0_S1END[0] _1100_/A3 _0100_/Q
+ _0099_/Q VPWR VGND sg13cmos5l_mux4_1
X_0815_ Tile_X0Y0_FrameStrobe_O[12] Tile_X0Y1_FrameStrobe[12] VPWR VGND sg13cmos5l_buf_1
X_0746_ Tile_X0Y0_W6BEG[7] _1070_/X VPWR VGND sg13cmos5l_buf_1
XFILLER_130_225 VPWR VGND sg13cmos5l_decap_4
XFILLER_29_228 VPWR VGND sg13cmos5l_fill_1
X_0677_ _0677_/L_HI VPWR VGND sg13cmos5l_tiehi
XFILLER_96_172 VPWR VGND sg13cmos5l_decap_8
XANTENNA__0855__X Tile_X0Y1_FrameData_O[31] VPWR VGND sg13cmos5l_antennanp
X_1229_ _1229_/X Tile_X0Y0_E1END[2] Tile_X0Y0_E6END[10] _1077_/X _1102_/X _0306_/Q
+ _0305_/Q VPWR VGND sg13cmos5l_mux4_1
XFILLER_20_183 VPWR VGND sg13cmos5l_decap_8
XFILLER_32_68 VPWR VGND sg13cmos5l_decap_8
XFILLER_106_200 VPWR VGND sg13cmos5l_decap_8
XFILLER_106_4 VPWR VGND sg13cmos5l_fill_2
XFILLER_121_214 VPWR VGND sg13cmos5l_fill_2
XANTENNA__0765__X Tile_X0Y0_N4BEG[14] VPWR VGND sg13cmos5l_antennanp
XFILLER_113_82 VPWR VGND sg13cmos5l_decap_8
XFILLER_57_87 VPWR VGND sg13cmos5l_fill_1
XFILLER_94_109 VPWR VGND sg13cmos5l_decap_8
XFILLER_11_161 VPWR VGND sg13cmos5l_decap_8
XFILLER_7_121 VPWR VGND sg13cmos5l_fill_2
XFILLER_7_198 VPWR VGND sg13cmos5l_decap_8
X_0600_ _0600_/Q Tile_X0Y1_FrameData[2] VGND VPWR Tile_X0Y1_FrameStrobe[7] latch
X_0531_ _0531_/Q Tile_X0Y1_FrameData[7] VGND VPWR Tile_X0Y1_FrameStrobe[5] latch
XFILLER_21_4 VPWR VGND sg13cmos5l_fill_2
XFILLER_78_194 VPWR VGND sg13cmos5l_decap_8
X_0462_ _0462_/Q Tile_X0Y1_FrameData[12] VGND VPWR Tile_X0Y1_FrameStrobe[3] latch
X_0393_ _0393_/Q Tile_X0Y1_FrameData[17] VGND VPWR Tile_X0Y1_FrameStrobe[1] latch
X_1014_ _1014_/X _1086_/X _1082_/X _1076_/X _1093_/X _0319_/Q _0318_/Q VPWR VGND sg13cmos5l_mux4_1
XANTENNA__0624__Q NPU_ACT_WDATA6 VPWR VGND sg13cmos5l_antennanp
XFILLER_97_0 VPWR VGND sg13cmos5l_decap_8
X_0729_ Tile_X0Y0_W2BEG[6] _1037_/X VPWR VGND sg13cmos5l_buf_1
XFILLER_69_150 VPWR VGND sg13cmos5l_decap_8
XFILLER_84_131 VPWR VGND sg13cmos5l_decap_8
XFILLER_25_220 VPWR VGND sg13cmos5l_decap_8
XFILLER_43_12 VPWR VGND sg13cmos5l_fill_1
XFILLER_138_155 VPWR VGND sg13cmos5l_decap_4
XFILLER_138_166 VPWR VGND sg13cmos5l_decap_8
XFILLER_4_179 VPWR VGND sg13cmos5l_decap_8
XFILLER_4_28 VPWR VGND sg13cmos5l_decap_8
XFILLER_68_42 VPWR VGND sg13cmos5l_decap_8
XFILLER_75_175 VPWR VGND sg13cmos5l_decap_8
XFILLER_84_96 VPWR VGND sg13cmos5l_decap_8
XFILLER_129_155 VPWR VGND sg13cmos5l_decap_8
XFILLER_90_7 VPWR VGND sg13cmos5l_decap_8
X_0514_ _0514_/Q Tile_X0Y1_FrameData[24] VGND VPWR Tile_X0Y1_FrameStrobe[5] latch
XFILLER_98_212 VPWR VGND sg13cmos5l_decap_8
XANTENNA__0619__Q NPU_ACT_WDATA1 VPWR VGND sg13cmos5l_antennanp
XFILLER_100_228 VPWR VGND sg13cmos5l_fill_1
XFILLER_12_0 VPWR VGND sg13cmos5l_decap_4
X_0445_ _0445_/Q Tile_X0Y1_FrameData[29] VGND VPWR Tile_X0Y1_FrameStrobe[3] latch
X_0376_ _0376_/Q Tile_X0Y1_FrameData[2] VGND VPWR Tile_X0Y1_FrameStrobe[0] latch
XFILLER_22_201 VPWR VGND sg13cmos5l_decap_8
XFILLER_129_48 VPWR VGND sg13cmos5l_fill_1
XFILLER_135_147 VPWR VGND sg13cmos5l_decap_8
XFILLER_1_105 VPWR VGND sg13cmos5l_decap_8
XFILLER_89_212 VPWR VGND sg13cmos5l_decap_8
XFILLER_54_55 VPWR VGND sg13cmos5l_fill_2
XFILLER_57_175 VPWR VGND sg13cmos5l_fill_2
XFILLER_72_101 VPWR VGND sg13cmos5l_decap_8
XFILLER_110_72 VPWR VGND sg13cmos5l_decap_8
XFILLER_70_21 VPWR VGND sg13cmos5l_decap_8
XFILLER_9_227 VPWR VGND sg13cmos5l_fill_2
XFILLER_0_160 VPWR VGND sg13cmos5l_decap_8
XFILLER_135_91 VPWR VGND sg13cmos5l_decap_8
XFILLER_48_175 VPWR VGND sg13cmos5l_decap_8
XFILLER_63_101 VPWR VGND sg13cmos5l_decap_8
X_0230_ _0230_/Q Tile_X0Y0_FrameData[22] VGND VPWR Tile_X0Y1_FrameStrobe[4] latch
X_0161_ _0161_/Q Tile_X0Y0_FrameData[27] VGND VPWR Tile_X0Y1_FrameStrobe[2] latch
XFILLER_95_62 VPWR VGND sg13cmos5l_decap_8
XANTENNA__0953__X Tile_X0Y1_W6BEG[8] VPWR VGND sg13cmos5l_antennanp
XFILLER_63_178 VPWR VGND sg13cmos5l_fill_2
X_0092_ NPU_XBAR_SEL2 Tile_X0Y1_UserCLK _0092_/D _0698_/L_HI VPWR VGND sg13cmos5l_dfrbpq_1
X_0994_ _0994_/X Tile_X0Y1_E1END[0] Tile_X0Y1_EE4END[4] Tile_X0Y1_EE4END[12] _1215_/X
+ _0410_/Q _0409_/Q VPWR VGND sg13cmos5l_mux4_1
XFILLER_117_169 VPWR VGND sg13cmos5l_decap_8
XFILLER_5_71 VPWR VGND sg13cmos5l_decap_8
XANTENNA__0863__X Tile_X0Y0_FrameData_O[7] VPWR VGND sg13cmos5l_antennanp
XFILLER_54_112 VPWR VGND sg13cmos5l_decap_8
X_0428_ _0428_/Q Tile_X0Y1_FrameData[14] VGND VPWR Tile_X0Y1_FrameStrobe[2] latch
X_0359_ _0359_/Q Tile_X0Y1_FrameData[19] VGND VPWR Tile_X0Y1_FrameStrobe[0] latch
XFILLER_138_7 VPWR VGND sg13cmos5l_decap_8
XFILLER_108_125 VPWR VGND sg13cmos5l_decap_8
XFILLER_40_79 VPWR VGND sg13cmos5l_decap_8
XFILLER_6_219 VPWR VGND sg13cmos5l_decap_8
XFILLER_65_21 VPWR VGND sg13cmos5l_decap_8
XFILLER_77_204 VPWR VGND sg13cmos5l_decap_8
XFILLER_77_215 VPWR VGND sg13cmos5l_fill_2
XANTENNA__0773__X Tile_X0Y0_WW4BEG[6] VPWR VGND sg13cmos5l_antennanp
XFILLER_60_115 VPWR VGND sg13cmos5l_decap_8
XFILLER_65_98 VPWR VGND sg13cmos5l_decap_8
XFILLER_81_20 VPWR VGND sg13cmos5l_decap_8
XANTENNA__0948__X Tile_X0Y1_W6BEG[3] VPWR VGND sg13cmos5l_antennanp
XFILLER_114_117 VPWR VGND sg13cmos5l_fill_1
XFILLER_114_128 VPWR VGND sg13cmos5l_decap_4
XFILLER_68_215 VPWR VGND sg13cmos5l_fill_2
XFILLER_36_112 VPWR VGND sg13cmos5l_decap_8
XFILLER_83_207 VPWR VGND sg13cmos5l_fill_2
X_1193_ _1193_/X Tile_X0Y1_N1END[2] Tile_X0Y1_E6END[2] _1229_/X _1193_/A3 _0350_/Q
+ _0349_/Q VPWR VGND sg13cmos5l_mux4_1
X_0213_ _0213_/Q Tile_X0Y0_FrameData[7] VGND VPWR Tile_X0Y1_FrameStrobe[3] latch
X_0144_ _0144_/Q Tile_X0Y0_FrameData[12] VGND VPWR Tile_X0Y1_FrameStrobe[1] latch
X_0075_ _0761_/A _1117_/X _1118_/X _0570_/Q VPWR VGND sg13cmos5l_mux2_1
XANTENNA__0632__Q NPU_ACT_ADDR6 VPWR VGND sg13cmos5l_antennanp
XFILLER_105_106 VPWR VGND sg13cmos5l_decap_8
X_0977_ _0977_/X Tile_X0Y0_E2MID[4] Tile_X0Y0_E2END[4] _1096_/X _0977_/A3 _0162_/Q
+ _0161_/Q VPWR VGND sg13cmos5l_mux4_1
XANTENNA__0858__X Tile_X0Y0_FrameData_O[2] VPWR VGND sg13cmos5l_antennanp
XFILLER_113_194 VPWR VGND sg13cmos5l_decap_8
XFILLER_19_14 VPWR VGND sg13cmos5l_fill_1
XFILLER_19_36 VPWR VGND sg13cmos5l_decap_8
XFILLER_19_58 VPWR VGND sg13cmos5l_decap_8
XFILLER_59_204 VPWR VGND sg13cmos5l_decap_8
XFILLER_59_215 VPWR VGND sg13cmos5l_fill_2
XFILLER_51_12 VPWR VGND sg13cmos5l_decap_8
XANTENNA__0768__X Tile_X0Y0_WW4BEG[1] VPWR VGND sg13cmos5l_antennanp
XFILLER_2_200 VPWR VGND sg13cmos5l_decap_8
XFILLER_116_71 VPWR VGND sg13cmos5l_decap_8
XFILLER_132_70 VPWR VGND sg13cmos5l_decap_8
XFILLER_18_134 VPWR VGND sg13cmos5l_decap_8
XFILLER_76_53 VPWR VGND sg13cmos5l_decap_4
XFILLER_76_75 VPWR VGND sg13cmos5l_fill_1
XFILLER_33_137 VPWR VGND sg13cmos5l_decap_8
X_0900_ Tile_X0Y1_S2BEGb[0] _1219_/X VPWR VGND sg13cmos5l_buf_1
XFILLER_92_63 VPWR VGND sg13cmos5l_decap_8
XFILLER_127_220 VPWR VGND sg13cmos5l_decap_8
X_0831_ Tile_X0Y1_FrameData_O[7] Tile_X0Y1_FrameData[7] VPWR VGND sg13cmos5l_buf_1
X_0762_ Tile_X0Y0_N4BEG[11] _0762_/A VPWR VGND sg13cmos5l_buf_1
X_0693_ _0693_/L_HI VPWR VGND sg13cmos5l_tiehi
XFILLER_37_2 VPWR VGND sg13cmos5l_fill_1
XANTENNA__0627__Q NPU_ACT_ADDR1 VPWR VGND sg13cmos5l_antennanp
XFILLER_110_186 VPWR VGND sg13cmos5l_decap_8
XFILLER_110_197 VPWR VGND sg13cmos5l_fill_1
X_1176_ _1176_/X _0645_/Q _0649_/Q _1205_/X _1197_/X _0464_/Q _0463_/Q VPWR VGND sg13cmos5l_mux4_1
X_0127_ _0127_/Q Tile_X0Y0_FrameData[29] VGND VPWR Tile_X0Y1_FrameStrobe[1] latch
XANTENNA_11 Tile_X0Y0_S2MID[3] VPWR VGND sg13cmos5l_antennanp
XANTENNA_22 Tile_X0Y1_N2MID[0] VPWR VGND sg13cmos5l_antennanp
XANTENNA_33 Tile_X0Y1_N2MID[4] VPWR VGND sg13cmos5l_antennanp
XANTENNA_44 NPU_OUT_ACT0 VPWR VGND sg13cmos5l_antennanp
XANTENNA_55 Tile_X0Y1_FrameData[15] VPWR VGND sg13cmos5l_antennanp
XFILLER_21_26 VPWR VGND sg13cmos5l_decap_4
XFILLER_101_142 VPWR VGND sg13cmos5l_decap_8
XFILLER_46_12 VPWR VGND sg13cmos5l_decap_8
XFILLER_102_84 VPWR VGND sg13cmos5l_decap_8
XFILLER_62_77 VPWR VGND sg13cmos5l_decap_8
XFILLER_109_220 VPWR VGND sg13cmos5l_decap_8
XFILLER_127_0 VPWR VGND sg13cmos5l_decap_8
X_1030_ _1030_/X _1114_/X Tile_X0Y0_S1END[3] _0637_/Q _0640_/Q _0268_/Q _0267_/Q VPWR
+ VGND sg13cmos5l_mux4_1
XANTENNA__0961__X Tile_X0Y1_WW4BEG[4] VPWR VGND sg13cmos5l_antennanp
XFILLER_14_192 VPWR VGND sg13cmos5l_decap_8
X_0814_ Tile_X0Y0_FrameStrobe_O[11] Tile_X0Y1_FrameStrobe[11] VPWR VGND sg13cmos5l_buf_1
XFILLER_107_29 VPWR VGND sg13cmos5l_decap_8
XFILLER_130_204 VPWR VGND sg13cmos5l_decap_8
XFILLER_42_0 VPWR VGND sg13cmos5l_fill_2
X_0745_ Tile_X0Y0_W6BEG[6] _1069_/X VPWR VGND sg13cmos5l_buf_1
X_0676_ _0676_/L_HI VPWR VGND sg13cmos5l_tiehi
X_1228_ _1228_/X Tile_X0Y0_E1END[1] Tile_X0Y0_E6END[9] _1076_/X _1101_/X _0308_/Q
+ _0307_/Q VPWR VGND sg13cmos5l_mux4_1
XFILLER_96_151 VPWR VGND sg13cmos5l_decap_8
XANTENNA__0871__X Tile_X0Y0_FrameData_O[15] VPWR VGND sg13cmos5l_antennanp
X_1159_ _1159_/X Tile_X0Y1_EE4END[9] _0648_/Q _1198_/X _1199_/X _0498_/Q _0497_/Q
+ VPWR VGND sg13cmos5l_mux4_1
XANTENNA__0092__Q NPU_XBAR_SEL2 VPWR VGND sg13cmos5l_antennanp
XFILLER_43_210 VPWR VGND sg13cmos5l_decap_8
XFILLER_57_66 VPWR VGND sg13cmos5l_decap_8
XANTENNA__0781__X Tile_X0Y0_WW4BEG[14] VPWR VGND sg13cmos5l_antennanp
XFILLER_73_87 VPWR VGND sg13cmos5l_fill_2
XFILLER_7_100 VPWR VGND sg13cmos5l_decap_8
XFILLER_7_177 VPWR VGND sg13cmos5l_decap_8
X_0530_ _0530_/Q Tile_X0Y1_FrameData[8] VGND VPWR Tile_X0Y1_FrameStrobe[5] latch
XANTENNA__0956__X Tile_X0Y1_W6BEG[11] VPWR VGND sg13cmos5l_antennanp
XFILLER_14_4 VPWR VGND sg13cmos5l_fill_2
XFILLER_78_173 VPWR VGND sg13cmos5l_decap_8
X_0461_ _0461_/Q Tile_X0Y1_FrameData[13] VGND VPWR Tile_X0Y1_FrameStrobe[3] latch
X_0392_ _0392_/Q Tile_X0Y1_FrameData[18] VGND VPWR Tile_X0Y1_FrameStrobe[1] latch
X_1013_ _1013_/X Tile_X0Y0_E1END[1] Tile_X0Y0_EE4END[1] Tile_X0Y0_E6END[9] _1089_/X
+ _0319_/Q _0318_/Q VPWR VGND sg13cmos5l_mux4_1
XFILLER_93_187 VPWR VGND sg13cmos5l_fill_2
XFILLER_8_60 VPWR VGND sg13cmos5l_decap_4
XFILLER_103_204 VPWR VGND sg13cmos5l_fill_2
XFILLER_103_215 VPWR VGND sg13cmos5l_fill_2
XFILLER_134_49 VPWR VGND sg13cmos5l_decap_8
X_0728_ Tile_X0Y0_W2BEG[5] _1036_/X VPWR VGND sg13cmos5l_buf_1
X_0659_ _0659_/L_HI VPWR VGND sg13cmos5l_tiehi
XANTENNA__0866__X Tile_X0Y0_FrameData_O[10] VPWR VGND sg13cmos5l_antennanp
XFILLER_27_58 VPWR VGND sg13cmos5l_fill_2
XFILLER_84_110 VPWR VGND sg13cmos5l_decap_8
XFILLER_84_165 VPWR VGND sg13cmos5l_decap_8
XFILLER_138_134 VPWR VGND sg13cmos5l_decap_8
XFILLER_40_213 VPWR VGND sg13cmos5l_decap_8
XFILLER_43_35 VPWR VGND sg13cmos5l_fill_2
XFILLER_4_169 VPWR VGND sg13cmos5l_decap_8
XANTENNA__0776__X Tile_X0Y0_WW4BEG[9] VPWR VGND sg13cmos5l_antennanp
XFILLER_108_83 VPWR VGND sg13cmos5l_decap_4
XFILLER_108_94 VPWR VGND sg13cmos5l_decap_4
XFILLER_124_82 VPWR VGND sg13cmos5l_fill_2
XFILLER_68_21 VPWR VGND sg13cmos5l_decap_8
XFILLER_75_154 VPWR VGND sg13cmos5l_decap_8
XFILLER_140_70 VPWR VGND sg13cmos5l_fill_1
XFILLER_84_75 VPWR VGND sg13cmos5l_decap_8
XFILLER_129_112 VPWR VGND sg13cmos5l_decap_8
XFILLER_129_134 VPWR VGND sg13cmos5l_decap_4
X_0513_ _0513_/Q Tile_X0Y1_FrameData[25] VGND VPWR Tile_X0Y1_FrameStrobe[5] latch
X_0444_ _0444_/Q Tile_X0Y1_FrameData[30] VGND VPWR Tile_X0Y1_FrameStrobe[3] latch
XFILLER_104_19 VPWR VGND sg13cmos5l_fill_2
XFILLER_66_176 VPWR VGND sg13cmos5l_fill_2
XFILLER_81_135 VPWR VGND sg13cmos5l_decap_8
X_0375_ _0375_/Q Tile_X0Y1_FrameData[3] VGND VPWR Tile_X0Y1_FrameStrobe[0] latch
XANTENNA__0635__Q NPU_WEIGHT_SHIFT_EN VPWR VGND sg13cmos5l_antennanp
XFILLER_13_27 VPWR VGND sg13cmos5l_decap_4
XFILLER_22_213 VPWR VGND sg13cmos5l_fill_1
XFILLER_135_126 VPWR VGND sg13cmos5l_decap_8
XFILLER_89_202 VPWR VGND sg13cmos5l_fill_2
XFILLER_54_78 VPWR VGND sg13cmos5l_decap_4
XFILLER_72_157 VPWR VGND sg13cmos5l_decap_8
XFILLER_110_51 VPWR VGND sg13cmos5l_decap_8
XFILLER_80_190 VPWR VGND sg13cmos5l_decap_8
XFILLER_126_159 VPWR VGND sg13cmos5l_decap_8
XFILLER_79_64 VPWR VGND sg13cmos5l_decap_8
XFILLER_95_205 VPWR VGND sg13cmos5l_decap_4
XFILLER_135_70 VPWR VGND sg13cmos5l_decap_8
X_0160_ _0160_/Q Tile_X0Y0_FrameData[28] VGND VPWR Tile_X0Y1_FrameStrobe[2] latch
X_0091_ NPU_XBAR_SEL1 Tile_X0Y1_UserCLK _0091_/D _0654_/L_HI VPWR VGND sg13cmos5l_dfrbpq_1
XFILLER_95_41 VPWR VGND sg13cmos5l_decap_8
XFILLER_95_227 VPWR VGND sg13cmos5l_fill_2
XFILLER_95_216 VPWR VGND sg13cmos5l_fill_1
XFILLER_63_157 VPWR VGND sg13cmos5l_decap_8
XFILLER_81_4 VPWR VGND sg13cmos5l_fill_2
X_0993_ _0993_/X Tile_X0Y1_EE4END[3] Tile_X0Y1_EE4END[11] Tile_X0Y1_E6END[11] _1214_/X
+ _0412_/Q _0411_/Q VPWR VGND sg13cmos5l_mux4_1
XFILLER_117_126 VPWR VGND sg13cmos5l_decap_8
XFILLER_140_140 VPWR VGND sg13cmos5l_decap_8
XFILLER_39_121 VPWR VGND sg13cmos5l_decap_8
XFILLER_86_205 VPWR VGND sg13cmos5l_decap_8
XFILLER_86_216 VPWR VGND sg13cmos5l_fill_1
XFILLER_86_227 VPWR VGND sg13cmos5l_fill_2
X_0427_ _0427_/Q Tile_X0Y1_FrameData[15] VGND VPWR Tile_X0Y1_FrameStrobe[2] latch
XFILLER_131_28 VPWR VGND sg13cmos5l_decap_8
XFILLER_39_198 VPWR VGND sg13cmos5l_decap_8
XFILLER_54_168 VPWR VGND sg13cmos5l_fill_1
XFILLER_54_179 VPWR VGND sg13cmos5l_decap_8
X_0358_ _0358_/Q Tile_X0Y1_FrameData[20] VGND VPWR Tile_X0Y1_FrameStrobe[0] latch
X_0289_ _0289_/Q Tile_X0Y0_FrameData[27] VGND VPWR Tile_X0Y1_FrameStrobe[6] latch
XFILLER_108_104 VPWR VGND sg13cmos5l_decap_8
XFILLER_10_216 VPWR VGND sg13cmos5l_decap_8
XFILLER_10_227 VPWR VGND sg13cmos5l_fill_2
XFILLER_105_51 VPWR VGND sg13cmos5l_decap_8
XFILLER_105_62 VPWR VGND sg13cmos5l_fill_2
XFILLER_45_113 VPWR VGND sg13cmos5l_decap_4
XFILLER_49_56 VPWR VGND sg13cmos5l_fill_1
XFILLER_77_227 VPWR VGND sg13cmos5l_fill_2
XFILLER_121_94 VPWR VGND sg13cmos5l_decap_4
XFILLER_65_77 VPWR VGND sg13cmos5l_decap_8
XFILLER_81_87 VPWR VGND sg13cmos5l_fill_2
XFILLER_5_220 VPWR VGND sg13cmos5l_decap_8
XFILLER_122_195 VPWR VGND sg13cmos5l_decap_8
XFILLER_46_7 VPWR VGND sg13cmos5l_fill_2
XANTENNA__0964__X Tile_X0Y1_WW4BEG[7] VPWR VGND sg13cmos5l_antennanp
X_1192_ _1192_/X Tile_X0Y1_N1END[1] Tile_X0Y1_E6END[1] _1228_/X _1192_/A3 _0352_/Q
+ _0351_/Q VPWR VGND sg13cmos5l_mux4_1
X_0212_ _0212_/Q Tile_X0Y0_FrameData[8] VGND VPWR Tile_X0Y1_FrameStrobe[3] latch
X_0143_ _0143_/Q Tile_X0Y0_FrameData[13] VGND VPWR Tile_X0Y1_FrameStrobe[1] latch
X_0074_ _0760_/A _1119_/X _1120_/X _0573_/Q VPWR VGND sg13cmos5l_mux2_1
XFILLER_72_0 VPWR VGND sg13cmos5l_decap_8
X_0976_ _0976_/X Tile_X0Y0_E2MID[3] Tile_X0Y0_E2END[3] _1095_/X _0976_/A3 _0164_/Q
+ _0163_/Q VPWR VGND sg13cmos5l_mux4_1
XFILLER_10_28 VPWR VGND sg13cmos5l_decap_4
XFILLER_126_39 VPWR VGND sg13cmos5l_fill_1
XANTENNA__0874__X Tile_X0Y0_FrameData_O[18] VPWR VGND sg13cmos5l_antennanp
XFILLER_113_173 VPWR VGND sg13cmos5l_decap_8
XFILLER_27_102 VPWR VGND sg13cmos5l_decap_8
XFILLER_59_227 VPWR VGND sg13cmos5l_fill_2
XFILLER_42_116 VPWR VGND sg13cmos5l_decap_8
XFILLER_42_149 VPWR VGND sg13cmos5l_fill_1
XFILLER_136_210 VPWR VGND sg13cmos5l_decap_8
XFILLER_50_182 VPWR VGND sg13cmos5l_decap_8
XFILLER_51_79 VPWR VGND sg13cmos5l_decap_8
XANTENNA__0784__X Tile_X0Y0_N2BEGb[1] VPWR VGND sg13cmos5l_antennanp
XFILLER_18_113 VPWR VGND sg13cmos5l_decap_8
XFILLER_18_179 VPWR VGND sg13cmos5l_decap_4
XFILLER_33_116 VPWR VGND sg13cmos5l_decap_8
XFILLER_76_87 VPWR VGND sg13cmos5l_decap_8
XFILLER_92_42 VPWR VGND sg13cmos5l_decap_8
X_0830_ Tile_X0Y1_FrameData_O[6] Tile_X0Y1_FrameData[6] VPWR VGND sg13cmos5l_buf_1
XANTENNA__0959__X Tile_X0Y1_WW4BEG[2] VPWR VGND sg13cmos5l_antennanp
X_0761_ Tile_X0Y0_N4BEG[10] _0761_/A VPWR VGND sg13cmos5l_buf_1
X_0692_ _0692_/L_HI VPWR VGND sg13cmos5l_tiehi
XFILLER_110_165 VPWR VGND sg13cmos5l_decap_8
XFILLER_2_95 VPWR VGND sg13cmos5l_decap_8
X_1175_ _1175_/X _0644_/Q _0648_/Q _1206_/X _1198_/X _0466_/Q _0465_/Q VPWR VGND sg13cmos5l_mux4_1
X_0126_ _0126_/Q Tile_X0Y0_FrameData[30] VGND VPWR Tile_X0Y1_FrameStrobe[1] latch
XANTENNA_12 Tile_X0Y0_S2MID[3] VPWR VGND sg13cmos5l_antennanp
XANTENNA_23 Tile_X0Y1_N2MID[0] VPWR VGND sg13cmos5l_antennanp
XANTENNA_34 Tile_X0Y1_N2MID[4] VPWR VGND sg13cmos5l_antennanp
XANTENNA_45 NPU_OUT_ACT3 VPWR VGND sg13cmos5l_antennanp
XFILLER_118_210 VPWR VGND sg13cmos5l_decap_8
X_0959_ Tile_X0Y1_WW4BEG[2] _1165_/X VPWR VGND sg13cmos5l_buf_1
XANTENNA__0869__X Tile_X0Y0_FrameData_O[13] VPWR VGND sg13cmos5l_antennanp
XFILLER_101_121 VPWR VGND sg13cmos5l_decap_8
XFILLER_133_202 VPWR VGND sg13cmos5l_decap_8
XFILLER_137_49 VPWR VGND sg13cmos5l_decap_8
XFILLER_101_198 VPWR VGND sg13cmos5l_decap_8
XFILLER_15_116 VPWR VGND sg13cmos5l_decap_8
XFILLER_46_68 VPWR VGND sg13cmos5l_decap_8
XFILLER_102_41 VPWR VGND sg13cmos5l_decap_8
XFILLER_15_127 VPWR VGND sg13cmos5l_fill_2
XANTENNA__0779__X Tile_X0Y0_WW4BEG[12] VPWR VGND sg13cmos5l_antennanp
XFILLER_124_224 VPWR VGND sg13cmos5l_decap_4
XFILLER_2_0 VPWR VGND sg13cmos5l_decap_8
XFILLER_87_20 VPWR VGND sg13cmos5l_decap_8
XFILLER_14_171 VPWR VGND sg13cmos5l_decap_8
X_0813_ Tile_X0Y0_FrameStrobe_O[10] Tile_X0Y1_FrameStrobe[10] VPWR VGND sg13cmos5l_buf_1
XFILLER_35_0 VPWR VGND sg13cmos5l_fill_1
X_0744_ Tile_X0Y0_W6BEG[5] _1068_/X VPWR VGND sg13cmos5l_buf_1
X_0675_ _0675_/L_HI VPWR VGND sg13cmos5l_tiehi
XFILLER_88_119 VPWR VGND sg13cmos5l_decap_8
XFILLER_29_219 VPWR VGND sg13cmos5l_decap_8
X_1227_ _1227_/X Tile_X0Y0_E1END[0] Tile_X0Y0_E6END[8] _1075_/X _1100_/X _0310_/Q
+ _0309_/Q VPWR VGND sg13cmos5l_mux4_1
X_1158_ _1158_/X Tile_X0Y1_EE4END[5] _0647_/Q _1198_/X _1199_/X _0500_/Q _0499_/Q
+ VPWR VGND sg13cmos5l_mux4_1
XFILLER_52_222 VPWR VGND sg13cmos5l_decap_8
X_1089_ _1089_/X _1112_/X Tile_X0Y1_N4END[5] Tile_X0Y0_S1END[1] Tile_X0Y0_S4END[1]
+ _0146_/Q _0145_/Q VPWR VGND sg13cmos5l_mux4_1
X_0109_ _0109_/Q Tile_X0Y0_FrameData[15] VGND VPWR Tile_X0Y1_FrameStrobe[0] latch
XFILLER_121_205 VPWR VGND sg13cmos5l_decap_4
XFILLER_121_216 VPWR VGND sg13cmos5l_fill_1
XFILLER_121_227 VPWR VGND sg13cmos5l_fill_2
XFILLER_87_163 VPWR VGND sg13cmos5l_decap_8
XFILLER_87_196 VPWR VGND sg13cmos5l_decap_8
XFILLER_11_196 VPWR VGND sg13cmos5l_decap_8
XFILLER_7_123 VPWR VGND sg13cmos5l_fill_1
XFILLER_7_156 VPWR VGND sg13cmos5l_decap_8
XFILLER_112_227 VPWR VGND sg13cmos5l_fill_2
XFILLER_138_92 VPWR VGND sg13cmos5l_decap_8
X_0460_ _0460_/Q Tile_X0Y1_FrameData[14] VGND VPWR Tile_X0Y1_FrameStrobe[3] latch
XFILLER_98_96 VPWR VGND sg13cmos5l_fill_1
XFILLER_78_152 VPWR VGND sg13cmos5l_decap_8
X_1012_ _1012_/X _1087_/X _1083_/X _1075_/X _1092_/X _0322_/Q _0321_/Q VPWR VGND sg13cmos5l_mux4_1
X_0391_ _0391_/Q Tile_X0Y1_FrameData[19] VGND VPWR Tile_X0Y1_FrameStrobe[1] latch
XFILLER_93_155 VPWR VGND sg13cmos5l_decap_8
XANTENNA__0972__X Tile_X0Y1_WW4BEG[15] VPWR VGND sg13cmos5l_antennanp
X_0727_ Tile_X0Y0_W2BEG[4] _1035_/X VPWR VGND sg13cmos5l_buf_1
XFILLER_103_227 VPWR VGND sg13cmos5l_fill_2
XFILLER_134_28 VPWR VGND sg13cmos5l_decap_8
XFILLER_69_185 VPWR VGND sg13cmos5l_decap_8
X_0658_ _0658_/L_HI VPWR VGND sg13cmos5l_tiehi
X_0589_ _0589_/Q Tile_X0Y1_FrameData[13] VGND VPWR Tile_X0Y1_FrameStrobe[7] latch
XANTENNA__0882__X Tile_X0Y0_FrameData_O[26] VPWR VGND sg13cmos5l_antennanp
XFILLER_69_196 VPWR VGND sg13cmos5l_fill_1
XFILLER_138_113 VPWR VGND sg13cmos5l_decap_8
XFILLER_4_126 VPWR VGND sg13cmos5l_decap_8
XFILLER_4_148 VPWR VGND sg13cmos5l_decap_8
XFILLER_124_61 VPWR VGND sg13cmos5l_decap_8
XFILLER_68_77 VPWR VGND sg13cmos5l_decap_8
XFILLER_75_133 VPWR VGND sg13cmos5l_decap_8
XFILLER_84_54 VPWR VGND sg13cmos5l_decap_8
XANTENNA__0792__X Tile_X0Y0_N2BEG[1] VPWR VGND sg13cmos5l_antennanp
XFILLER_90_169 VPWR VGND sg13cmos5l_decap_4
XANTENNA__0967__X Tile_X0Y1_WW4BEG[10] VPWR VGND sg13cmos5l_antennanp
XFILLER_100_219 VPWR VGND sg13cmos5l_decap_8
XFILLER_3_192 VPWR VGND sg13cmos5l_decap_8
X_0512_ _0512_/Q Tile_X0Y1_FrameData[26] VGND VPWR Tile_X0Y1_FrameStrobe[5] latch
X_0443_ _0443_/Q Tile_X0Y1_FrameData[31] VGND VPWR Tile_X0Y1_FrameStrobe[3] latch
X_0374_ _0374_/Q Tile_X0Y1_FrameData[4] VGND VPWR Tile_X0Y1_FrameStrobe[0] latch
XFILLER_66_133 VPWR VGND sg13cmos5l_decap_8
XFILLER_66_144 VPWR VGND sg13cmos5l_fill_2
XFILLER_81_125 VPWR VGND sg13cmos5l_fill_2
XFILLER_135_105 VPWR VGND sg13cmos5l_decap_8
XFILLER_1_118 VPWR VGND sg13cmos5l_fill_1
XANTENNA__0877__X Tile_X0Y0_FrameData_O[21] VPWR VGND sg13cmos5l_antennanp
XFILLER_38_58 VPWR VGND sg13cmos5l_decap_8
XFILLER_57_177 VPWR VGND sg13cmos5l_fill_1
XFILLER_72_136 VPWR VGND sg13cmos5l_decap_8
XFILLER_126_138 VPWR VGND sg13cmos5l_decap_8
XFILLER_70_56 VPWR VGND sg13cmos5l_decap_8
XANTENNA__0787__X Tile_X0Y0_N2BEGb[4] VPWR VGND sg13cmos5l_antennanp
XFILLER_102_0 VPWR VGND sg13cmos5l_fill_2
XFILLER_134_182 VPWR VGND sg13cmos5l_decap_8
XFILLER_0_195 VPWR VGND sg13cmos5l_decap_8
XFILLER_48_133 VPWR VGND sg13cmos5l_decap_4
XFILLER_63_136 VPWR VGND sg13cmos5l_decap_8
X_0090_ NPU_XBAR_SEL0 Tile_X0Y1_UserCLK _0090_/D _0655_/L_HI VPWR VGND sg13cmos5l_dfrbpq_1
XFILLER_95_97 VPWR VGND sg13cmos5l_decap_8
X_0992_ _0992_/X Tile_X0Y1_EE4END[2] Tile_X0Y1_EE4END[10] Tile_X0Y1_E6END[10] _1213_/X
+ _0414_/Q _0413_/Q VPWR VGND sg13cmos5l_mux4_1
XFILLER_117_105 VPWR VGND sg13cmos5l_decap_8
XFILLER_132_119 VPWR VGND sg13cmos5l_decap_8
XFILLER_74_4 VPWR VGND sg13cmos5l_fill_2
XFILLER_140_185 VPWR VGND sg13cmos5l_decap_4
X_0426_ _0426_/Q Tile_X0Y1_FrameData[16] VGND VPWR Tile_X0Y1_FrameStrobe[2] latch
X_0357_ _0357_/Q Tile_X0Y1_FrameData[21] VGND VPWR Tile_X0Y1_FrameStrobe[0] latch
X_0288_ _0288_/Q Tile_X0Y0_FrameData[28] VGND VPWR Tile_X0Y1_FrameStrobe[6] latch
XFILLER_40_15 VPWR VGND sg13cmos5l_decap_8
XFILLER_40_59 VPWR VGND sg13cmos5l_decap_8
XFILLER_116_182 VPWR VGND sg13cmos5l_decap_8
XFILLER_131_174 VPWR VGND sg13cmos5l_decap_8
XFILLER_49_35 VPWR VGND sg13cmos5l_decap_8
XFILLER_49_46 VPWR VGND sg13cmos5l_fill_2
XFILLER_6_7 VPWR VGND sg13cmos5l_decap_8
XFILLER_105_30 VPWR VGND sg13cmos5l_decap_8
XFILLER_131_185 VPWR VGND sg13cmos5l_fill_1
XFILLER_65_56 VPWR VGND sg13cmos5l_decap_8
XFILLER_81_66 VPWR VGND sg13cmos5l_decap_8
XFILLER_107_182 VPWR VGND sg13cmos5l_decap_4
XFILLER_122_174 VPWR VGND sg13cmos5l_decap_8
XFILLER_68_228 VPWR VGND sg13cmos5l_fill_1
XFILLER_83_209 VPWR VGND sg13cmos5l_fill_1
X_1191_ _1191_/X Tile_X0Y1_N1END[0] Tile_X0Y1_E6END[0] _1227_/X _1191_/A3 _0354_/Q
+ _0353_/Q VPWR VGND sg13cmos5l_mux4_1
X_0211_ _0211_/Q Tile_X0Y0_FrameData[9] VGND VPWR Tile_X0Y1_FrameStrobe[3] latch
XFILLER_36_169 VPWR VGND sg13cmos5l_decap_8
XFILLER_51_128 VPWR VGND sg13cmos5l_decap_8
X_0142_ _0142_/Q Tile_X0Y0_FrameData[14] VGND VPWR Tile_X0Y1_FrameStrobe[1] latch
X_0073_ _0759_/A _1121_/X _1122_/X _0576_/Q VPWR VGND sg13cmos5l_mux2_1
XFILLER_65_0 VPWR VGND sg13cmos5l_decap_8
X_0975_ _0975_/X Tile_X0Y0_E2MID[2] Tile_X0Y0_E2END[2] _1094_/X _0975_/A3 _0166_/Q
+ _0165_/Q VPWR VGND sg13cmos5l_mux4_1
XFILLER_113_152 VPWR VGND sg13cmos5l_decap_8
XFILLER_74_209 VPWR VGND sg13cmos5l_decap_8
X_0409_ _0409_/Q Tile_X0Y1_FrameData[1] VGND VPWR Tile_X0Y1_FrameStrobe[1] latch
XANTENNA__0890__X Tile_X0Y1_S1BEG[2] VPWR VGND sg13cmos5l_antennanp
XFILLER_35_191 VPWR VGND sg13cmos5l_decap_4
XFILLER_35_59 VPWR VGND sg13cmos5l_decap_8
XFILLER_51_47 VPWR VGND sg13cmos5l_decap_8
XFILLER_51_58 VPWR VGND sg13cmos5l_decap_8
XFILLER_104_152 VPWR VGND sg13cmos5l_fill_2
XFILLER_26_180 VPWR VGND sg13cmos5l_fill_1
XFILLER_73_220 VPWR VGND sg13cmos5l_decap_8
XFILLER_92_21 VPWR VGND sg13cmos5l_decap_8
XFILLER_25_92 VPWR VGND sg13cmos5l_decap_8
X_0760_ Tile_X0Y0_N4BEG[9] _0760_/A VPWR VGND sg13cmos5l_buf_1
X_0691_ _0691_/L_HI VPWR VGND sg13cmos5l_tiehi
XFILLER_110_100 VPWR VGND sg13cmos5l_decap_8
XFILLER_110_144 VPWR VGND sg13cmos5l_decap_8
XFILLER_2_52 VPWR VGND sg13cmos5l_fill_2
XFILLER_2_85 VPWR VGND sg13cmos5l_fill_2
X_1174_ _1174_/X _0647_/Q _0651_/Q _1207_/X _1199_/X _0468_/Q _0467_/Q VPWR VGND sg13cmos5l_mux4_1
XANTENNA_13 Tile_X0Y0_S2MID[3] VPWR VGND sg13cmos5l_antennanp
XFILLER_32_150 VPWR VGND sg13cmos5l_decap_8
X_0125_ _0125_/Q Tile_X0Y0_FrameData[31] VGND VPWR Tile_X0Y1_FrameStrobe[1] latch
XANTENNA_24 Tile_X0Y1_N2MID[0] VPWR VGND sg13cmos5l_antennanp
XANTENNA_35 Tile_X0Y1_N2MID[4] VPWR VGND sg13cmos5l_antennanp
XANTENNA_46 NPU_OUT_ACT4 VPWR VGND sg13cmos5l_antennanp
XFILLER_137_28 VPWR VGND sg13cmos5l_decap_8
XFILLER_32_194 VPWR VGND sg13cmos5l_decap_4
X_0889_ Tile_X0Y1_S1BEG[1] _1124_/X VPWR VGND sg13cmos5l_buf_1
X_0958_ Tile_X0Y1_WW4BEG[1] _1164_/X VPWR VGND sg13cmos5l_buf_1
XANTENNA__0885__X Tile_X0Y0_FrameData_O[29] VPWR VGND sg13cmos5l_antennanp
XFILLER_102_20 VPWR VGND sg13cmos5l_decap_8
XFILLER_46_47 VPWR VGND sg13cmos5l_decap_8
XFILLER_23_150 VPWR VGND sg13cmos5l_fill_2
XFILLER_30_109 VPWR VGND sg13cmos5l_decap_8
XFILLER_62_35 VPWR VGND sg13cmos5l_fill_2
XFILLER_11_50 VPWR VGND sg13cmos5l_fill_1
XFILLER_11_72 VPWR VGND sg13cmos5l_decap_4
XFILLER_124_203 VPWR VGND sg13cmos5l_decap_8
XFILLER_127_94 VPWR VGND sg13cmos5l_fill_1
XFILLER_87_43 VPWR VGND sg13cmos5l_decap_8
XANTENNA__0795__X Tile_X0Y0_N2BEG[4] VPWR VGND sg13cmos5l_antennanp
XFILLER_46_220 VPWR VGND sg13cmos5l_decap_8
XFILLER_14_150 VPWR VGND sg13cmos5l_decap_8
XFILLER_36_91 VPWR VGND sg13cmos5l_decap_8
XFILLER_115_214 VPWR VGND sg13cmos5l_fill_2
X_0812_ Tile_X0Y0_FrameStrobe_O[9] Tile_X0Y1_FrameStrobe[9] VPWR VGND sg13cmos5l_buf_1
X_0743_ Tile_X0Y0_W6BEG[4] _1067_/X VPWR VGND sg13cmos5l_buf_1
XFILLER_28_0 VPWR VGND sg13cmos5l_decap_4
XFILLER_42_2 VPWR VGND sg13cmos5l_fill_1
X_0674_ _0674_/L_HI VPWR VGND sg13cmos5l_tiehi
XFILLER_123_19 VPWR VGND sg13cmos5l_decap_4
XFILLER_16_39 VPWR VGND sg13cmos5l_decap_4
X_1226_ _1226_/X Tile_X0Y0_E1END[3] Tile_X0Y0_E2MID[0] Tile_X0Y0_E2END[0] _1099_/X
+ _0288_/Q _0287_/Q VPWR VGND sg13cmos5l_mux4_1
X_1157_ _1157_/X Tile_X0Y1_E2END[3] _0646_/Q _1197_/X _1200_/X _0502_/Q _0501_/Q VPWR
+ VGND sg13cmos5l_mux4_1
X_0108_ _0108_/Q Tile_X0Y0_FrameData[16] VGND VPWR Tile_X0Y1_FrameStrobe[0] latch
XFILLER_96_186 VPWR VGND sg13cmos5l_decap_8
XFILLER_32_16 VPWR VGND sg13cmos5l_fill_2
XFILLER_32_38 VPWR VGND sg13cmos5l_decap_8
X_1088_ _1088_/X _1111_/X Tile_X0Y1_N4END[4] Tile_X0Y0_S1END[0] Tile_X0Y0_S4END[0]
+ _0148_/Q _0147_/Q VPWR VGND sg13cmos5l_mux4_1
XFILLER_106_214 VPWR VGND sg13cmos5l_decap_8
XFILLER_20_197 VPWR VGND sg13cmos5l_decap_8
XFILLER_113_30 VPWR VGND sg13cmos5l_fill_1
XFILLER_28_220 VPWR VGND sg13cmos5l_decap_8
XFILLER_113_41 VPWR VGND sg13cmos5l_decap_8
XFILLER_113_96 VPWR VGND sg13cmos5l_decap_8
XFILLER_73_89 VPWR VGND sg13cmos5l_fill_1
XFILLER_11_175 VPWR VGND sg13cmos5l_decap_8
XFILLER_132_0 VPWR VGND sg13cmos5l_decap_8
XFILLER_22_93 VPWR VGND sg13cmos5l_decap_8
XFILLER_7_135 VPWR VGND sg13cmos5l_decap_8
XFILLER_112_206 VPWR VGND sg13cmos5l_decap_8
XFILLER_138_71 VPWR VGND sg13cmos5l_decap_8
X_0390_ _0390_/Q Tile_X0Y1_FrameData[20] VGND VPWR Tile_X0Y1_FrameStrobe[1] latch
XFILLER_98_42 VPWR VGND sg13cmos5l_decap_4
X_1011_ _1011_/X Tile_X0Y0_E1END[0] Tile_X0Y0_EE4END[0] Tile_X0Y0_E6END[8] _1088_/X
+ _0322_/Q _0321_/Q VPWR VGND sg13cmos5l_mux4_1
XFILLER_93_112 VPWR VGND sg13cmos5l_decap_8
XFILLER_103_206 VPWR VGND sg13cmos5l_fill_1
X_0726_ Tile_X0Y0_W2BEG[3] _1034_/X VPWR VGND sg13cmos5l_buf_1
XFILLER_8_95 VPWR VGND sg13cmos5l_decap_8
XFILLER_69_164 VPWR VGND sg13cmos5l_decap_8
XFILLER_84_145 VPWR VGND sg13cmos5l_fill_2
X_0657_ _0657_/L_HI VPWR VGND sg13cmos5l_tiehi
X_0588_ _0588_/Q Tile_X0Y1_FrameData[14] VGND VPWR Tile_X0Y1_FrameStrobe[7] latch
XFILLER_25_201 VPWR VGND sg13cmos5l_decap_8
XFILLER_25_212 VPWR VGND sg13cmos5l_decap_4
XFILLER_43_37 VPWR VGND sg13cmos5l_fill_1
XFILLER_84_189 VPWR VGND sg13cmos5l_decap_8
X_1209_ _1209_/X Tile_X0Y1_N1END[2] Tile_X0Y1_N4END[2] _1229_/X Tile_X0Y0_S4END[6]
+ _0390_/Q _0389_/Q VPWR VGND sg13cmos5l_mux4_1
XFILLER_43_59 VPWR VGND sg13cmos5l_decap_8
XFILLER_4_105 VPWR VGND sg13cmos5l_decap_8
XFILLER_104_4 VPWR VGND sg13cmos5l_fill_2
XFILLER_68_56 VPWR VGND sg13cmos5l_decap_8
XFILLER_75_112 VPWR VGND sg13cmos5l_decap_8
XFILLER_75_189 VPWR VGND sg13cmos5l_decap_8
XFILLER_84_33 VPWR VGND sg13cmos5l_decap_8
XFILLER_90_126 VPWR VGND sg13cmos5l_fill_1
XFILLER_90_115 VPWR VGND sg13cmos5l_decap_8
XFILLER_90_104 VPWR VGND sg13cmos5l_decap_4
XFILLER_17_82 VPWR VGND sg13cmos5l_decap_8
XFILLER_31_226 VPWR VGND sg13cmos5l_fill_2
XFILLER_129_169 VPWR VGND sg13cmos5l_decap_8
XFILLER_69_7 VPWR VGND sg13cmos5l_decap_8
X_0511_ _0511_/Q Tile_X0Y1_FrameData[27] VGND VPWR Tile_X0Y1_FrameStrobe[5] latch
XFILLER_3_171 VPWR VGND sg13cmos5l_decap_8
XFILLER_66_112 VPWR VGND sg13cmos5l_decap_8
X_0442_ _0442_/Q Tile_X0Y1_FrameData[0] VGND VPWR Tile_X0Y1_FrameStrobe[2] latch
X_0373_ _0373_/Q Tile_X0Y1_FrameData[5] VGND VPWR Tile_X0Y1_FrameStrobe[0] latch
XFILLER_98_226 VPWR VGND sg13cmos5l_fill_2
XFILLER_66_178 VPWR VGND sg13cmos5l_fill_1
XFILLER_95_0 VPWR VGND sg13cmos5l_decap_4
XFILLER_128_180 VPWR VGND sg13cmos5l_decap_8
X_0709_ _1192_/A3 VPWR VGND sg13cmos5l_tielo
XFILLER_89_226 VPWR VGND sg13cmos5l_fill_2
XANTENNA__0893__X Tile_X0Y1_S2BEG[1] VPWR VGND sg13cmos5l_antennanp
XFILLER_72_115 VPWR VGND sg13cmos5l_decap_8
XFILLER_110_86 VPWR VGND sg13cmos5l_decap_8
XFILLER_70_35 VPWR VGND sg13cmos5l_decap_8
XFILLER_9_208 VPWR VGND sg13cmos5l_decap_8
XFILLER_119_191 VPWR VGND sg13cmos5l_decap_8
XFILLER_119_40 VPWR VGND sg13cmos5l_fill_2
XFILLER_119_84 VPWR VGND sg13cmos5l_decap_4
XFILLER_126_117 VPWR VGND sg13cmos5l_decap_8
XFILLER_141_109 VPWR VGND sg13cmos5l_decap_8
XFILLER_79_33 VPWR VGND sg13cmos5l_fill_2
XFILLER_0_174 VPWR VGND sg13cmos5l_decap_8
XFILLER_134_161 VPWR VGND sg13cmos5l_decap_8
XFILLER_48_112 VPWR VGND sg13cmos5l_decap_8
XFILLER_48_189 VPWR VGND sg13cmos5l_decap_8
XFILLER_63_115 VPWR VGND sg13cmos5l_decap_8
XFILLER_95_76 VPWR VGND sg13cmos5l_decap_8
XFILLER_44_91 VPWR VGND sg13cmos5l_decap_8
X_0991_ _0991_/X Tile_X0Y1_EE4END[1] Tile_X0Y1_EE4END[9] Tile_X0Y1_E6END[9] _1212_/X
+ _0416_/Q _0415_/Q VPWR VGND sg13cmos5l_mux4_1
XFILLER_125_183 VPWR VGND sg13cmos5l_decap_8
XFILLER_5_63 VPWR VGND sg13cmos5l_fill_1
XFILLER_5_85 VPWR VGND sg13cmos5l_decap_8
X_0425_ _0425_/Q Tile_X0Y1_FrameData[17] VGND VPWR Tile_X0Y1_FrameStrobe[2] latch
X_0356_ _0356_/Q Tile_X0Y1_FrameData[22] VGND VPWR Tile_X0Y1_FrameStrobe[0] latch
X_0287_ _0287_/Q Tile_X0Y0_FrameData[29] VGND VPWR Tile_X0Y1_FrameStrobe[6] latch
XFILLER_108_139 VPWR VGND sg13cmos5l_decap_8
XFILLER_123_109 VPWR VGND sg13cmos5l_decap_8
XANTENNA__0888__X Tile_X0Y1_S1BEG[0] VPWR VGND sg13cmos5l_antennanp
XFILLER_116_161 VPWR VGND sg13cmos5l_decap_8
XFILLER_131_153 VPWR VGND sg13cmos5l_decap_8
XFILLER_131_197 VPWR VGND sg13cmos5l_decap_8
XFILLER_121_41 VPWR VGND sg13cmos5l_decap_8
XFILLER_65_35 VPWR VGND sg13cmos5l_decap_8
XFILLER_139_220 VPWR VGND sg13cmos5l_decap_8
XFILLER_60_129 VPWR VGND sg13cmos5l_decap_8
XFILLER_81_34 VPWR VGND sg13cmos5l_decap_8
XFILLER_81_89 VPWR VGND sg13cmos5l_fill_1
XANTENNA__0798__X Tile_X0Y0_N2BEG[7] VPWR VGND sg13cmos5l_antennanp
XFILLER_122_153 VPWR VGND sg13cmos5l_decap_8
XFILLER_36_126 VPWR VGND sg13cmos5l_decap_4
XFILLER_39_91 VPWR VGND sg13cmos5l_fill_2
X_1190_ _1190_/X _0647_/Q _1203_/X _1207_/X _1202_/X _0436_/Q _0435_/Q VPWR VGND sg13cmos5l_mux4_1
X_0210_ _0210_/Q Tile_X0Y0_FrameData[10] VGND VPWR Tile_X0Y1_FrameStrobe[3] latch
X_0141_ _0141_/Q Tile_X0Y0_FrameData[15] VGND VPWR Tile_X0Y1_FrameStrobe[1] latch
XFILLER_36_137 VPWR VGND sg13cmos5l_decap_8
XFILLER_36_148 VPWR VGND sg13cmos5l_decap_8
XFILLER_44_192 VPWR VGND sg13cmos5l_decap_8
XFILLER_51_107 VPWR VGND sg13cmos5l_decap_8
X_0072_ _0092_/D _1233_/X _0605_/Q _0608_/Q VPWR VGND sg13cmos5l_mux2_1
XFILLER_91_221 VPWR VGND sg13cmos5l_decap_8
X_0974_ _0974_/X Tile_X0Y0_E2MID[1] Tile_X0Y0_E2END[1] _1093_/X _0974_/A3 _0168_/Q
+ _0167_/Q VPWR VGND sg13cmos5l_mux4_1
XFILLER_113_131 VPWR VGND sg13cmos5l_decap_8
XFILLER_58_0 VPWR VGND sg13cmos5l_fill_2
XFILLER_27_148 VPWR VGND sg13cmos5l_decap_4
XFILLER_35_38 VPWR VGND sg13cmos5l_decap_8
X_0408_ _0408_/Q Tile_X0Y1_FrameData[2] VGND VPWR Tile_X0Y1_FrameStrobe[1] latch
X_0339_ _0339_/Q Tile_X0Y0_FrameData[9] VGND VPWR Tile_X0Y1_FrameStrobe[7] latch
XFILLER_136_7 VPWR VGND sg13cmos5l_decap_8
XFILLER_51_26 VPWR VGND sg13cmos5l_decap_8
XFILLER_2_225 VPWR VGND sg13cmos5l_decap_4
XFILLER_104_197 VPWR VGND sg13cmos5l_decap_4
XFILLER_116_85 VPWR VGND sg13cmos5l_decap_8
XFILLER_132_84 VPWR VGND sg13cmos5l_decap_8
XFILLER_25_71 VPWR VGND sg13cmos5l_decap_8
XFILLER_41_140 VPWR VGND sg13cmos5l_fill_1
XFILLER_92_77 VPWR VGND sg13cmos5l_decap_8
XFILLER_41_162 VPWR VGND sg13cmos5l_decap_8
XFILLER_41_184 VPWR VGND sg13cmos5l_decap_8
X_0690_ _0690_/L_HI VPWR VGND sg13cmos5l_tiehi
XFILLER_51_7 VPWR VGND sg13cmos5l_fill_2
X_1173_ _1173_/X _0646_/Q _0650_/Q _1208_/X _1200_/X _0470_/Q _0469_/Q VPWR VGND sg13cmos5l_mux4_1
X_0124_ _0124_/Q Tile_X0Y0_FrameData[0] VGND VPWR Tile_X0Y1_FrameStrobe[0] latch
XANTENNA_14 Tile_X0Y0_S2MID[3] VPWR VGND sg13cmos5l_antennanp
XANTENNA_25 Tile_X0Y1_N2MID[0] VPWR VGND sg13cmos5l_antennanp
XANTENNA_36 Tile_X0Y1_N2MID[5] VPWR VGND sg13cmos5l_antennanp
XANTENNA_47 Tile_X0Y1_FrameData[15] VPWR VGND sg13cmos5l_antennanp
XFILLER_32_173 VPWR VGND sg13cmos5l_decap_8
X_0888_ Tile_X0Y1_S1BEG[0] _1123_/X VPWR VGND sg13cmos5l_buf_1
X_0957_ Tile_X0Y1_WW4BEG[0] _1163_/X VPWR VGND sg13cmos5l_buf_1
XFILLER_101_156 VPWR VGND sg13cmos5l_decap_8
XFILLER_15_107 VPWR VGND sg13cmos5l_fill_2
XFILLER_46_26 VPWR VGND sg13cmos5l_decap_8
XFILLER_55_221 VPWR VGND sg13cmos5l_decap_8
XFILLER_62_14 VPWR VGND sg13cmos5l_decap_8
XFILLER_102_98 VPWR VGND sg13cmos5l_decap_8
XFILLER_11_95 VPWR VGND sg13cmos5l_decap_8
XFILLER_87_11 VPWR VGND sg13cmos5l_fill_1
XFILLER_87_66 VPWR VGND sg13cmos5l_decap_8
XFILLER_52_80 VPWR VGND sg13cmos5l_decap_8
X_0811_ Tile_X0Y0_FrameStrobe_O[8] Tile_X0Y1_FrameStrobe[8] VPWR VGND sg13cmos5l_buf_1
X_0742_ Tile_X0Y0_W6BEG[3] _1066_/X VPWR VGND sg13cmos5l_buf_1
X_0673_ _0673_/L_HI VPWR VGND sg13cmos5l_tiehi
XFILLER_130_218 VPWR VGND sg13cmos5l_decap_8
XFILLER_96_165 VPWR VGND sg13cmos5l_decap_8
XFILLER_16_29 VPWR VGND sg13cmos5l_decap_4
X_1087_ _1087_/X _1111_/X Tile_X0Y1_N4END[4] Tile_X0Y0_S1END[0] Tile_X0Y0_S4END[0]
+ _0140_/Q _0139_/Q VPWR VGND sg13cmos5l_mux4_1
X_1225_ _1225_/X Tile_X0Y0_E1END[2] Tile_X0Y0_E2MID[1] Tile_X0Y0_E2END[1] _1098_/X
+ _0290_/Q _0289_/Q VPWR VGND sg13cmos5l_mux4_1
X_1156_ _1156_/X Tile_X0Y1_E2MID[4] _0645_/Q _1196_/X _1201_/X _0504_/Q _0503_/Q VPWR
+ VGND sg13cmos5l_mux4_1
X_0107_ _0107_/Q Tile_X0Y0_FrameData[17] VGND VPWR Tile_X0Y1_FrameStrobe[0] latch
XFILLER_20_132 VPWR VGND sg13cmos5l_fill_2
XFILLER_20_176 VPWR VGND sg13cmos5l_decap_8
XANTENNA__0896__X Tile_X0Y1_S2BEG[4] VPWR VGND sg13cmos5l_antennanp
XFILLER_43_224 VPWR VGND sg13cmos5l_decap_4
XFILLER_73_46 VPWR VGND sg13cmos5l_decap_4
XFILLER_11_154 VPWR VGND sg13cmos5l_decap_8
XFILLER_125_0 VPWR VGND sg13cmos5l_decap_4
XFILLER_138_50 VPWR VGND sg13cmos5l_decap_8
XFILLER_7_114 VPWR VGND sg13cmos5l_decap_8
XFILLER_78_187 VPWR VGND sg13cmos5l_decap_8
X_1010_ _1010_/X Tile_X0Y0_E2MID[0] Tile_X0Y0_E2END[0] Tile_X0Y0_E6END[0] _1099_/X
+ _0324_/Q _0323_/Q VPWR VGND sg13cmos5l_mux4_1
XFILLER_40_0 VPWR VGND sg13cmos5l_decap_4
X_0725_ Tile_X0Y0_W2BEG[2] _1033_/X VPWR VGND sg13cmos5l_buf_1
X_0656_ _0656_/L_HI VPWR VGND sg13cmos5l_tiehi
XFILLER_69_143 VPWR VGND sg13cmos5l_decap_8
XFILLER_84_124 VPWR VGND sg13cmos5l_decap_8
XFILLER_84_179 VPWR VGND sg13cmos5l_fill_2
X_1208_ _1208_/X Tile_X0Y1_N1END[1] Tile_X0Y1_N4END[1] _1228_/X Tile_X0Y0_S4END[5]
+ _0392_/Q _0391_/Q VPWR VGND sg13cmos5l_mux4_1
X_0587_ _0587_/Q Tile_X0Y1_FrameData[15] VGND VPWR Tile_X0Y1_FrameStrobe[7] latch
XFILLER_40_227 VPWR VGND sg13cmos5l_fill_2
X_1139_ _1139_/X Tile_X0Y1_E1END[2] Tile_X0Y1_EE4END[14] Tile_X0Y1_E6END[6] _1205_/X
+ _0536_/Q _0535_/Q VPWR VGND sg13cmos5l_mux4_1
XFILLER_138_148 VPWR VGND sg13cmos5l_decap_8
XFILLER_138_159 VPWR VGND sg13cmos5l_fill_1
XFILLER_108_31 VPWR VGND sg13cmos5l_decap_8
XFILLER_124_30 VPWR VGND sg13cmos5l_decap_8
XFILLER_68_35 VPWR VGND sg13cmos5l_decap_8
XFILLER_124_41 VPWR VGND sg13cmos5l_fill_1
XFILLER_17_61 VPWR VGND sg13cmos5l_decap_8
XFILLER_75_168 VPWR VGND sg13cmos5l_decap_8
XFILLER_84_89 VPWR VGND sg13cmos5l_decap_8
XFILLER_129_126 VPWR VGND sg13cmos5l_decap_4
XFILLER_129_148 VPWR VGND sg13cmos5l_decap_8
XFILLER_137_192 VPWR VGND sg13cmos5l_decap_8
X_0510_ _0510_/Q Tile_X0Y1_FrameData[28] VGND VPWR Tile_X0Y1_FrameStrobe[5] latch
XFILLER_98_205 VPWR VGND sg13cmos5l_decap_8
XFILLER_12_4 VPWR VGND sg13cmos5l_fill_2
X_0441_ _0441_/Q Tile_X0Y1_FrameData[1] VGND VPWR Tile_X0Y1_FrameStrobe[2] latch
X_0372_ _0372_/Q Tile_X0Y1_FrameData[6] VGND VPWR Tile_X0Y1_FrameStrobe[0] latch
XFILLER_22_227 VPWR VGND sg13cmos5l_fill_2
XFILLER_81_127 VPWR VGND sg13cmos5l_fill_1
XFILLER_81_149 VPWR VGND sg13cmos5l_decap_8
XFILLER_88_0 VPWR VGND sg13cmos5l_decap_8
X_0708_ _1193_/A3 VPWR VGND sg13cmos5l_tielo
X_0639_ _0639_/Q Tile_X0Y1_UserCLK NPU_OUT_ACT3 _0669_/L_HI VPWR VGND sg13cmos5l_dfrbpq_1
XFILLER_57_168 VPWR VGND sg13cmos5l_decap_8
XFILLER_110_65 VPWR VGND sg13cmos5l_decap_8
XFILLER_13_205 VPWR VGND sg13cmos5l_decap_4
XFILLER_13_227 VPWR VGND sg13cmos5l_fill_2
XFILLER_70_14 VPWR VGND sg13cmos5l_decap_8
XFILLER_102_2 VPWR VGND sg13cmos5l_fill_1
XFILLER_134_140 VPWR VGND sg13cmos5l_decap_8
XFILLER_79_78 VPWR VGND sg13cmos5l_decap_8
XFILLER_0_153 VPWR VGND sg13cmos5l_decap_8
XFILLER_135_84 VPWR VGND sg13cmos5l_decap_8
XFILLER_48_168 VPWR VGND sg13cmos5l_decap_8
XFILLER_95_55 VPWR VGND sg13cmos5l_decap_8
XFILLER_28_93 VPWR VGND sg13cmos5l_decap_8
X_0990_ _0990_/X Tile_X0Y1_EE4END[0] Tile_X0Y1_EE4END[8] Tile_X0Y1_E6END[8] _1211_/X
+ _0418_/Q _0417_/Q VPWR VGND sg13cmos5l_mux4_1
XFILLER_8_220 VPWR VGND sg13cmos5l_decap_8
XFILLER_125_162 VPWR VGND sg13cmos5l_decap_8
XFILLER_140_110 VPWR VGND sg13cmos5l_decap_8
XFILLER_5_42 VPWR VGND sg13cmos5l_decap_8
X_0424_ _0424_/Q Tile_X0Y1_FrameData[18] VGND VPWR Tile_X0Y1_FrameStrobe[2] latch
XFILLER_54_105 VPWR VGND sg13cmos5l_decap_8
XFILLER_54_127 VPWR VGND sg13cmos5l_decap_4
X_0355_ _0355_/Q Tile_X0Y1_FrameData[23] VGND VPWR Tile_X0Y1_FrameStrobe[0] latch
X_0286_ _0286_/Q Tile_X0Y0_FrameData[30] VGND VPWR Tile_X0Y1_FrameStrobe[6] latch
XFILLER_62_182 VPWR VGND sg13cmos5l_decap_4
XFILLER_108_118 VPWR VGND sg13cmos5l_decap_8
XFILLER_131_132 VPWR VGND sg13cmos5l_decap_8
XFILLER_49_15 VPWR VGND sg13cmos5l_fill_2
XFILLER_65_14 VPWR VGND sg13cmos5l_decap_8
XFILLER_53_182 VPWR VGND sg13cmos5l_fill_1
XFILLER_60_108 VPWR VGND sg13cmos5l_decap_8
XFILLER_81_13 VPWR VGND sg13cmos5l_decap_8
XFILLER_14_95 VPWR VGND sg13cmos5l_decap_8
XFILLER_5_212 VPWR VGND sg13cmos5l_decap_4
XFILLER_107_195 VPWR VGND sg13cmos5l_decap_4
XFILLER_122_132 VPWR VGND sg13cmos5l_decap_8
XFILLER_30_83 VPWR VGND sg13cmos5l_decap_4
XFILLER_36_105 VPWR VGND sg13cmos5l_decap_8
X_0140_ _0140_/Q Tile_X0Y0_FrameData[16] VGND VPWR Tile_X0Y1_FrameStrobe[1] latch
X_0071_ _0091_/D _1232_/X _0606_/Q _0608_/Q VPWR VGND sg13cmos5l_mux2_1
X_0973_ _0973_/X Tile_X0Y0_E2MID[0] Tile_X0Y0_E2END[0] _1092_/X _0973_/A3 _0170_/Q
+ _0169_/Q VPWR VGND sg13cmos5l_mux4_1
XFILLER_113_110 VPWR VGND sg13cmos5l_decap_8
XFILLER_113_187 VPWR VGND sg13cmos5l_decap_8
XFILLER_19_29 VPWR VGND sg13cmos5l_decap_8
X_0407_ _0407_/Q Tile_X0Y1_FrameData[3] VGND VPWR Tile_X0Y1_FrameStrobe[1] latch
X_0338_ _0338_/Q Tile_X0Y0_FrameData[10] VGND VPWR Tile_X0Y1_FrameStrobe[7] latch
X_0269_ _0269_/Q Tile_X0Y0_FrameData[15] VGND VPWR Tile_X0Y1_FrameStrobe[5] latch
XFILLER_129_7 VPWR VGND sg13cmos5l_decap_8
XFILLER_136_224 VPWR VGND sg13cmos5l_decap_4
XFILLER_50_196 VPWR VGND sg13cmos5l_decap_8
XANTENNA__0899__X Tile_X0Y1_S2BEG[7] VPWR VGND sg13cmos5l_antennanp
XFILLER_104_154 VPWR VGND sg13cmos5l_fill_1
XFILLER_116_64 VPWR VGND sg13cmos5l_decap_8
XFILLER_132_63 VPWR VGND sg13cmos5l_decap_8
XFILLER_18_127 VPWR VGND sg13cmos5l_decap_8
XFILLER_76_24 VPWR VGND sg13cmos5l_decap_4
XFILLER_25_50 VPWR VGND sg13cmos5l_decap_8
XFILLER_92_56 VPWR VGND sg13cmos5l_decap_8
XFILLER_127_213 VPWR VGND sg13cmos5l_decap_8
XFILLER_41_60 VPWR VGND sg13cmos5l_decap_8
XFILLER_2_21 VPWR VGND sg13cmos5l_decap_4
XFILLER_2_43 VPWR VGND sg13cmos5l_fill_1
XFILLER_110_179 VPWR VGND sg13cmos5l_decap_8
X_1172_ _1172_/X _0645_/Q _0649_/Q _1209_/X _1201_/X _0472_/Q _0471_/Q VPWR VGND sg13cmos5l_mux4_1
X_0123_ _0123_/Q Tile_X0Y0_FrameData[1] VGND VPWR Tile_X0Y1_FrameStrobe[0] latch
XANTENNA_15 Tile_X0Y0_S2MID[4] VPWR VGND sg13cmos5l_antennanp
XANTENNA_26 Tile_X0Y1_N2MID[1] VPWR VGND sg13cmos5l_antennanp
XANTENNA_37 Tile_X0Y1_N2MID[5] VPWR VGND sg13cmos5l_antennanp
XANTENNA_48 Tile_X0Y1_FrameData[15] VPWR VGND sg13cmos5l_antennanp
XFILLER_21_19 VPWR VGND sg13cmos5l_decap_8
XFILLER_70_0 VPWR VGND sg13cmos5l_decap_8
X_0956_ Tile_X0Y1_W6BEG[11] _1190_/X VPWR VGND sg13cmos5l_buf_1
XFILLER_118_224 VPWR VGND sg13cmos5l_decap_4
XFILLER_133_216 VPWR VGND sg13cmos5l_fill_1
XFILLER_133_227 VPWR VGND sg13cmos5l_fill_2
X_0887_ Tile_X0Y0_FrameData_O[31] Tile_X0Y0_FrameData[31] VPWR VGND sg13cmos5l_buf_1
XFILLER_101_135 VPWR VGND sg13cmos5l_decap_8
XFILLER_102_77 VPWR VGND sg13cmos5l_decap_8
XFILLER_62_37 VPWR VGND sg13cmos5l_fill_1
XFILLER_11_30 VPWR VGND sg13cmos5l_fill_2
XFILLER_100_190 VPWR VGND sg13cmos5l_fill_1
XFILLER_14_185 VPWR VGND sg13cmos5l_decap_8
X_0810_ Tile_X0Y0_FrameStrobe_O[7] Tile_X0Y1_FrameStrobe[7] VPWR VGND sg13cmos5l_buf_1
XFILLER_115_216 VPWR VGND sg13cmos5l_fill_1
XFILLER_115_227 VPWR VGND sg13cmos5l_fill_2
X_0741_ Tile_X0Y0_W6BEG[2] _1065_/X VPWR VGND sg13cmos5l_buf_1
X_0672_ _0672_/L_HI VPWR VGND sg13cmos5l_tiehi
X_1224_ _1224_/X Tile_X0Y0_E1END[1] Tile_X0Y0_E2MID[2] Tile_X0Y0_E2END[2] _1097_/X
+ _0292_/Q _0291_/Q VPWR VGND sg13cmos5l_mux4_1
XFILLER_96_144 VPWR VGND sg13cmos5l_decap_8
XFILLER_96_100 VPWR VGND sg13cmos5l_decap_8
X_1086_ _1086_/X _1112_/X Tile_X0Y1_N4END[5] Tile_X0Y0_S1END[1] Tile_X0Y0_S4END[1]
+ _0138_/Q _0137_/Q VPWR VGND sg13cmos5l_mux4_1
X_1155_ _1155_/X Tile_X0Y1_E2MID[1] _0644_/Q _1195_/X _1202_/X _0506_/Q _0505_/Q VPWR
+ VGND sg13cmos5l_mux4_1
X_0106_ _0106_/Q Tile_X0Y0_FrameData[18] VGND VPWR Tile_X0Y1_FrameStrobe[0] latch
X_0939_ Tile_X0Y1_W2BEGb[2] _1157_/X VPWR VGND sg13cmos5l_buf_1
XFILLER_87_111 VPWR VGND sg13cmos5l_decap_8
XFILLER_113_76 VPWR VGND sg13cmos5l_fill_2
XFILLER_43_203 VPWR VGND sg13cmos5l_decap_8
XFILLER_57_37 VPWR VGND sg13cmos5l_fill_1
XFILLER_57_59 VPWR VGND sg13cmos5l_decap_8
XFILLER_87_188 VPWR VGND sg13cmos5l_fill_1
XFILLER_11_111 VPWR VGND sg13cmos5l_fill_1
XFILLER_11_133 VPWR VGND sg13cmos5l_decap_8
XFILLER_11_144 VPWR VGND sg13cmos5l_decap_8
XFILLER_118_0 VPWR VGND sg13cmos5l_decap_4
XFILLER_0_0 VPWR VGND sg13cmos5l_decap_8
XFILLER_78_122 VPWR VGND sg13cmos5l_fill_2
XFILLER_78_166 VPWR VGND sg13cmos5l_decap_8
XFILLER_93_169 VPWR VGND sg13cmos5l_decap_8
XFILLER_33_0 VPWR VGND sg13cmos5l_fill_2
XFILLER_69_122 VPWR VGND sg13cmos5l_decap_8
XFILLER_6_170 VPWR VGND sg13cmos5l_fill_1
XFILLER_6_181 VPWR VGND sg13cmos5l_decap_8
X_0724_ Tile_X0Y0_W2BEG[1] _1032_/X VPWR VGND sg13cmos5l_buf_1
X_0655_ _0655_/L_HI VPWR VGND sg13cmos5l_tiehi
X_0586_ _0586_/Q Tile_X0Y1_FrameData[16] VGND VPWR Tile_X0Y1_FrameStrobe[7] latch
XFILLER_27_29 VPWR VGND sg13cmos5l_fill_1
XFILLER_84_103 VPWR VGND sg13cmos5l_decap_8
XFILLER_84_147 VPWR VGND sg13cmos5l_fill_1
XFILLER_84_158 VPWR VGND sg13cmos5l_decap_8
X_1207_ _1207_/X Tile_X0Y1_N1END[0] Tile_X0Y1_N4END[0] _1227_/X Tile_X0Y0_S4END[4]
+ _0394_/Q _0393_/Q VPWR VGND sg13cmos5l_mux4_1
XFILLER_40_206 VPWR VGND sg13cmos5l_decap_8
X_1069_ _1069_/X _0642_/Q _1086_/X _1082_/X _1094_/X _0190_/Q _0189_/Q VPWR VGND sg13cmos5l_mux4_1
X_1138_ _1138_/X _1208_/X _1212_/X _1216_/X _1200_/X _0539_/Q _0538_/Q VPWR VGND sg13cmos5l_mux4_1
XFILLER_111_7 VPWR VGND sg13cmos5l_fill_2
XFILLER_138_127 VPWR VGND sg13cmos5l_decap_8
XFILLER_108_98 VPWR VGND sg13cmos5l_fill_2
XFILLER_124_20 VPWR VGND sg13cmos5l_fill_2
XFILLER_68_14 VPWR VGND sg13cmos5l_decap_8
XFILLER_84_13 VPWR VGND sg13cmos5l_fill_2
XFILLER_124_75 VPWR VGND sg13cmos5l_decap_8
XFILLER_16_214 VPWR VGND sg13cmos5l_fill_1
XFILLER_75_147 VPWR VGND sg13cmos5l_decap_8
XFILLER_84_68 VPWR VGND sg13cmos5l_decap_8
XFILLER_129_105 VPWR VGND sg13cmos5l_decap_8
XFILLER_140_96 VPWR VGND sg13cmos5l_decap_8
XFILLER_31_228 VPWR VGND sg13cmos5l_fill_1
XFILLER_33_72 VPWR VGND sg13cmos5l_fill_2
XFILLER_137_171 VPWR VGND sg13cmos5l_decap_8
X_0440_ _0440_/Q Tile_X0Y1_FrameData[2] VGND VPWR Tile_X0Y1_FrameStrobe[2] latch
XFILLER_98_228 VPWR VGND sg13cmos5l_fill_1
X_0371_ _0371_/Q Tile_X0Y1_FrameData[7] VGND VPWR Tile_X0Y1_FrameStrobe[0] latch
XFILLER_135_119 VPWR VGND sg13cmos5l_decap_8
X_0707_ _1194_/A3 VPWR VGND sg13cmos5l_tielo
X_0638_ _0638_/Q Tile_X0Y1_UserCLK NPU_OUT_ACT2 _0670_/L_HI VPWR VGND sg13cmos5l_dfrbpq_1
X_0569_ _0569_/Q Tile_X0Y1_FrameData[1] VGND VPWR Tile_X0Y1_FrameStrobe[6] latch
XFILLER_89_228 VPWR VGND sg13cmos5l_fill_1
XFILLER_80_150 VPWR VGND sg13cmos5l_fill_1
XFILLER_110_44 VPWR VGND sg13cmos5l_decap_8
XFILLER_80_183 VPWR VGND sg13cmos5l_decap_8
XFILLER_134_196 VPWR VGND sg13cmos5l_decap_8
XFILLER_79_35 VPWR VGND sg13cmos5l_fill_1
XFILLER_0_132 VPWR VGND sg13cmos5l_decap_8
XFILLER_135_63 VPWR VGND sg13cmos5l_decap_8
XFILLER_28_72 VPWR VGND sg13cmos5l_decap_8
XFILLER_95_34 VPWR VGND sg13cmos5l_decap_8
XFILLER_95_209 VPWR VGND sg13cmos5l_fill_1
XFILLER_44_82 VPWR VGND sg13cmos5l_decap_4
XFILLER_117_119 VPWR VGND sg13cmos5l_decap_8
XFILLER_5_21 VPWR VGND sg13cmos5l_decap_8
XFILLER_125_141 VPWR VGND sg13cmos5l_decap_8
XFILLER_140_133 VPWR VGND sg13cmos5l_decap_8
X_0423_ _0423_/Q Tile_X0Y1_FrameData[19] VGND VPWR Tile_X0Y1_FrameStrobe[2] latch
XFILLER_47_191 VPWR VGND sg13cmos5l_decap_8
X_0354_ _0354_/Q Tile_X0Y1_FrameData[24] VGND VPWR Tile_X0Y1_FrameStrobe[0] latch
X_0285_ _0285_/Q Tile_X0Y0_FrameData[31] VGND VPWR Tile_X0Y1_FrameStrobe[6] latch
XFILLER_10_209 VPWR VGND sg13cmos5l_decap_8
XFILLER_62_161 VPWR VGND sg13cmos5l_decap_8
XFILLER_116_196 VPWR VGND sg13cmos5l_decap_8
XFILLER_131_111 VPWR VGND sg13cmos5l_decap_8
XFILLER_105_44 VPWR VGND sg13cmos5l_decap_8
XFILLER_105_99 VPWR VGND sg13cmos5l_decap_8
XFILLER_45_106 VPWR VGND sg13cmos5l_decap_8
XFILLER_45_117 VPWR VGND sg13cmos5l_fill_2
XFILLER_121_87 VPWR VGND sg13cmos5l_decap_8
XFILLER_121_98 VPWR VGND sg13cmos5l_fill_2
XFILLER_53_161 VPWR VGND sg13cmos5l_decap_8
XFILLER_100_0 VPWR VGND sg13cmos5l_decap_4
XFILLER_107_152 VPWR VGND sg13cmos5l_fill_2
XFILLER_122_122 VPWR VGND sg13cmos5l_decap_8
XFILLER_122_188 VPWR VGND sg13cmos5l_decap_8
XFILLER_29_191 VPWR VGND sg13cmos5l_decap_8
XFILLER_39_82 VPWR VGND sg13cmos5l_fill_2
XFILLER_44_150 VPWR VGND sg13cmos5l_fill_2
X_0070_ _0090_/D _1231_/X _0607_/Q _0608_/Q VPWR VGND sg13cmos5l_mux2_1
X_0972_ Tile_X0Y1_WW4BEG[15] _1178_/X VPWR VGND sg13cmos5l_buf_1
XFILLER_113_166 VPWR VGND sg13cmos5l_decap_8
X_0406_ _0406_/Q Tile_X0Y1_FrameData[4] VGND VPWR Tile_X0Y1_FrameStrobe[1] latch
X_0337_ _0337_/Q Tile_X0Y0_FrameData[11] VGND VPWR Tile_X0Y1_FrameStrobe[7] latch
XFILLER_42_109 VPWR VGND sg13cmos5l_decap_8
XFILLER_82_212 VPWR VGND sg13cmos5l_decap_8
X_0268_ _0268_/Q Tile_X0Y0_FrameData[16] VGND VPWR Tile_X0Y1_FrameStrobe[5] latch
X_0199_ _0199_/Q Tile_X0Y0_FrameData[21] VGND VPWR Tile_X0Y1_FrameStrobe[3] latch
XFILLER_136_203 VPWR VGND sg13cmos5l_decap_8
XFILLER_50_175 VPWR VGND sg13cmos5l_decap_8
XFILLER_116_43 VPWR VGND sg13cmos5l_decap_8
XFILLER_4_7 VPWR VGND sg13cmos5l_decap_8
XFILLER_132_42 VPWR VGND sg13cmos5l_decap_8
XFILLER_18_106 VPWR VGND sg13cmos5l_decap_8
XFILLER_33_109 VPWR VGND sg13cmos5l_decap_8
XFILLER_58_220 VPWR VGND sg13cmos5l_decap_8
XFILLER_92_35 VPWR VGND sg13cmos5l_decap_8
XFILLER_26_150 VPWR VGND sg13cmos5l_fill_2
XFILLER_41_131 VPWR VGND sg13cmos5l_decap_8
XFILLER_110_114 VPWR VGND sg13cmos5l_decap_4
XFILLER_110_158 VPWR VGND sg13cmos5l_decap_8
XFILLER_2_77 VPWR VGND sg13cmos5l_decap_4
XFILLER_49_220 VPWR VGND sg13cmos5l_decap_8
X_1171_ _1171_/X _0644_/Q _0648_/Q _1210_/X _1202_/X _0474_/Q _0473_/Q VPWR VGND sg13cmos5l_mux4_1
XFILLER_17_172 VPWR VGND sg13cmos5l_decap_8
XFILLER_66_91 VPWR VGND sg13cmos5l_decap_8
X_0122_ _0122_/Q Tile_X0Y0_FrameData[2] VGND VPWR Tile_X0Y1_FrameStrobe[0] latch
XANTENNA_16 Tile_X0Y0_S2MID[4] VPWR VGND sg13cmos5l_antennanp
XANTENNA_27 Tile_X0Y1_N2MID[1] VPWR VGND sg13cmos5l_antennanp
XANTENNA_38 Tile_X0Y1_N2MID[6] VPWR VGND sg13cmos5l_antennanp
XANTENNA_49 Tile_X0Y1_FrameData[15] VPWR VGND sg13cmos5l_antennanp
XFILLER_118_203 VPWR VGND sg13cmos5l_decap_8
X_0886_ Tile_X0Y0_FrameData_O[30] Tile_X0Y0_FrameData[30] VPWR VGND sg13cmos5l_buf_1
X_0955_ Tile_X0Y1_W6BEG[10] _1189_/X VPWR VGND sg13cmos5l_buf_1
XFILLER_63_0 VPWR VGND sg13cmos5l_decap_8
XFILLER_102_34 VPWR VGND sg13cmos5l_decap_8
XFILLER_141_7 VPWR VGND sg13cmos5l_fill_2
XFILLER_23_131 VPWR VGND sg13cmos5l_decap_8
XFILLER_109_203 VPWR VGND sg13cmos5l_decap_8
XFILLER_109_214 VPWR VGND sg13cmos5l_fill_2
XFILLER_124_217 VPWR VGND sg13cmos5l_decap_8
XFILLER_124_228 VPWR VGND sg13cmos5l_fill_1
XFILLER_36_72 VPWR VGND sg13cmos5l_decap_8
XFILLER_36_83 VPWR VGND sg13cmos5l_fill_1
XFILLER_61_226 VPWR VGND sg13cmos5l_fill_2
XFILLER_14_164 VPWR VGND sg13cmos5l_decap_8
X_0740_ Tile_X0Y0_W6BEG[1] _1064_/X VPWR VGND sg13cmos5l_buf_1
XFILLER_115_206 VPWR VGND sg13cmos5l_decap_4
X_0671_ _0671_/L_HI VPWR VGND sg13cmos5l_tiehi
X_1223_ _1223_/X Tile_X0Y0_E1END[0] Tile_X0Y0_E2MID[3] Tile_X0Y0_E2END[3] _1096_/X
+ _0294_/Q _0293_/Q VPWR VGND sg13cmos5l_mux4_1
X_1154_ _1154_/X _0651_/Q _1195_/X _1202_/X _1193_/X _0508_/Q _0507_/Q VPWR VGND sg13cmos5l_mux4_1
XFILLER_52_215 VPWR VGND sg13cmos5l_decap_8
X_1085_ _1085_/X _1113_/X Tile_X0Y1_N4END[6] Tile_X0Y0_S1END[2] Tile_X0Y0_S4END[2]
+ _0136_/Q _0135_/Q VPWR VGND sg13cmos5l_mux4_1
X_0105_ _0105_/Q Tile_X0Y0_FrameData[19] VGND VPWR Tile_X0Y1_FrameStrobe[0] latch
XFILLER_106_228 VPWR VGND sg13cmos5l_fill_1
X_0869_ Tile_X0Y0_FrameData_O[13] Tile_X0Y0_FrameData[13] VPWR VGND sg13cmos5l_buf_1
X_0938_ Tile_X0Y1_W2BEGb[1] _1156_/X VPWR VGND sg13cmos5l_buf_1
XFILLER_121_209 VPWR VGND sg13cmos5l_fill_1
XFILLER_113_55 VPWR VGND sg13cmos5l_decap_8
XFILLER_11_189 VPWR VGND sg13cmos5l_decap_8
XFILLER_138_41 VPWR VGND sg13cmos5l_decap_4
XFILLER_138_85 VPWR VGND sg13cmos5l_decap_8
XFILLER_22_63 VPWR VGND sg13cmos5l_fill_2
XFILLER_7_149 VPWR VGND sg13cmos5l_decap_8
XFILLER_98_89 VPWR VGND sg13cmos5l_decap_8
XFILLER_19_223 VPWR VGND sg13cmos5l_decap_4
XFILLER_93_126 VPWR VGND sg13cmos5l_fill_1
X_0723_ Tile_X0Y0_W2BEG[0] _1031_/X VPWR VGND sg13cmos5l_buf_1
XFILLER_8_43 VPWR VGND sg13cmos5l_fill_2
XFILLER_111_220 VPWR VGND sg13cmos5l_decap_8
XFILLER_26_0 VPWR VGND sg13cmos5l_decap_4
XFILLER_69_101 VPWR VGND sg13cmos5l_decap_8
X_0654_ _0654_/L_HI VPWR VGND sg13cmos5l_tiehi
X_0585_ _0585_/Q Tile_X0Y1_FrameData[17] VGND VPWR Tile_X0Y1_FrameStrobe[7] latch
XFILLER_69_178 VPWR VGND sg13cmos5l_decap_8
X_1137_ _1137_/X Tile_X0Y1_E1END[1] Tile_X0Y1_EE4END[13] Tile_X0Y1_E6END[5] _1204_/X
+ _0539_/Q _0538_/Q VPWR VGND sg13cmos5l_mux4_1
X_1206_ _1206_/X Tile_X0Y1_N1END[3] Tile_X0Y1_N4END[3] _1230_/X Tile_X0Y0_S4END[7]
+ _0396_/Q _0395_/Q VPWR VGND sg13cmos5l_mux4_1
XFILLER_92_192 VPWR VGND sg13cmos5l_decap_8
XFILLER_138_106 VPWR VGND sg13cmos5l_decap_8
X_1068_ _1068_/X _0641_/Q _1085_/X _1081_/X _1093_/X _0192_/Q _0191_/Q VPWR VGND sg13cmos5l_mux4_1
XFILLER_4_119 VPWR VGND sg13cmos5l_decap_8
XFILLER_75_126 VPWR VGND sg13cmos5l_decap_8
XFILLER_84_47 VPWR VGND sg13cmos5l_decap_8
XFILLER_16_226 VPWR VGND sg13cmos5l_fill_2
XFILLER_17_96 VPWR VGND sg13cmos5l_decap_8
XFILLER_130_0 VPWR VGND sg13cmos5l_decap_8
XFILLER_3_185 VPWR VGND sg13cmos5l_decap_8
X_0370_ _0370_/Q Tile_X0Y1_FrameData[8] VGND VPWR Tile_X0Y1_FrameStrobe[0] latch
XFILLER_66_126 VPWR VGND sg13cmos5l_decap_8
XFILLER_74_181 VPWR VGND sg13cmos5l_decap_8
XFILLER_81_118 VPWR VGND sg13cmos5l_decap_8
XFILLER_74_80 VPWR VGND sg13cmos5l_decap_4
XFILLER_90_90 VPWR VGND sg13cmos5l_decap_8
XANTENNA__0801__X Tile_X0Y0_N1BEG[2] VPWR VGND sg13cmos5l_antennanp
XFILLER_128_194 VPWR VGND sg13cmos5l_decap_8
X_0706_ _1078_/A3 VPWR VGND sg13cmos5l_tielo
X_0637_ _0637_/Q Tile_X0Y1_UserCLK NPU_OUT_ACT1 _0668_/L_HI VPWR VGND sg13cmos5l_dfrbpq_1
X_0568_ _0568_/Q Tile_X0Y1_FrameData[2] VGND VPWR Tile_X0Y1_FrameStrobe[6] latch
X_0499_ _0499_/Q Tile_X0Y1_FrameData[7] VGND VPWR Tile_X0Y1_FrameStrobe[4] latch
XFILLER_110_12 VPWR VGND sg13cmos5l_decap_8
XFILLER_65_192 VPWR VGND sg13cmos5l_fill_2
XFILLER_72_129 VPWR VGND sg13cmos5l_decap_8
XFILLER_80_162 VPWR VGND sg13cmos5l_decap_8
XFILLER_70_49 VPWR VGND sg13cmos5l_decap_8
XFILLER_0_111 VPWR VGND sg13cmos5l_decap_8
XFILLER_134_175 VPWR VGND sg13cmos5l_decap_8
XFILLER_135_42 VPWR VGND sg13cmos5l_decap_8
XFILLER_0_188 VPWR VGND sg13cmos5l_decap_8
XFILLER_48_126 VPWR VGND sg13cmos5l_decap_8
XFILLER_48_137 VPWR VGND sg13cmos5l_fill_1
XFILLER_48_159 VPWR VGND sg13cmos5l_fill_2
XFILLER_63_129 VPWR VGND sg13cmos5l_decap_8
XFILLER_71_151 VPWR VGND sg13cmos5l_decap_8
XFILLER_125_120 VPWR VGND sg13cmos5l_decap_8
XFILLER_60_60 VPWR VGND sg13cmos5l_fill_2
XFILLER_67_7 VPWR VGND sg13cmos5l_decap_8
XFILLER_125_197 VPWR VGND sg13cmos5l_decap_8
XFILLER_140_178 VPWR VGND sg13cmos5l_decap_8
XFILLER_5_99 VPWR VGND sg13cmos5l_decap_8
X_0422_ _0422_/Q Tile_X0Y1_FrameData[20] VGND VPWR Tile_X0Y1_FrameStrobe[2] latch
X_0353_ _0353_/Q Tile_X0Y1_FrameData[25] VGND VPWR Tile_X0Y1_FrameStrobe[0] latch
XFILLER_94_221 VPWR VGND sg13cmos5l_decap_8
XFILLER_47_170 VPWR VGND sg13cmos5l_decap_8
XFILLER_62_140 VPWR VGND sg13cmos5l_decap_8
X_0284_ _0284_/Q Tile_X0Y0_FrameData[0] VGND VPWR Tile_X0Y1_FrameStrobe[5] latch
XFILLER_93_0 VPWR VGND sg13cmos5l_decap_8
XFILLER_116_120 VPWR VGND sg13cmos5l_decap_8
XFILLER_116_131 VPWR VGND sg13cmos5l_fill_2
XFILLER_116_175 VPWR VGND sg13cmos5l_decap_8
XFILLER_49_28 VPWR VGND sg13cmos5l_decap_8
XFILLER_105_23 VPWR VGND sg13cmos5l_decap_8
XFILLER_131_167 VPWR VGND sg13cmos5l_decap_8
XFILLER_65_49 VPWR VGND sg13cmos5l_decap_8
XFILLER_121_33 VPWR VGND sg13cmos5l_decap_4
XFILLER_121_55 VPWR VGND sg13cmos5l_decap_8
XFILLER_139_201 VPWR VGND sg13cmos5l_decap_8
XFILLER_53_140 VPWR VGND sg13cmos5l_decap_8
XFILLER_81_59 VPWR VGND sg13cmos5l_decap_8
XFILLER_14_64 VPWR VGND sg13cmos5l_fill_2
XFILLER_30_52 VPWR VGND sg13cmos5l_fill_2
XFILLER_107_186 VPWR VGND sg13cmos5l_fill_2
XFILLER_122_167 VPWR VGND sg13cmos5l_decap_8
XFILLER_30_96 VPWR VGND sg13cmos5l_decap_8
XFILLER_39_50 VPWR VGND sg13cmos5l_fill_1
XFILLER_71_81 VPWR VGND sg13cmos5l_decap_8
X_0971_ Tile_X0Y1_WW4BEG[14] _1177_/X VPWR VGND sg13cmos5l_buf_1
XFILLER_113_145 VPWR VGND sg13cmos5l_decap_8
X_0405_ _0405_/Q Tile_X0Y1_FrameData[5] VGND VPWR Tile_X0Y1_FrameStrobe[1] latch
X_0336_ _0336_/Q Tile_X0Y0_FrameData[12] VGND VPWR Tile_X0Y1_FrameStrobe[7] latch
X_0267_ _0267_/Q Tile_X0Y0_FrameData[17] VGND VPWR Tile_X0Y1_FrameStrobe[5] latch
XFILLER_35_184 VPWR VGND sg13cmos5l_decap_8
X_0198_ _0198_/Q Tile_X0Y0_FrameData[22] VGND VPWR Tile_X0Y1_FrameStrobe[3] latch
XFILLER_104_112 VPWR VGND sg13cmos5l_decap_4
XFILLER_116_99 VPWR VGND sg13cmos5l_fill_2
XFILLER_132_21 VPWR VGND sg13cmos5l_decap_8
XFILLER_132_98 VPWR VGND sg13cmos5l_decap_8
XFILLER_73_202 VPWR VGND sg13cmos5l_decap_8
XFILLER_92_14 VPWR VGND sg13cmos5l_fill_2
XFILLER_25_85 VPWR VGND sg13cmos5l_decap_8
XFILLER_26_195 VPWR VGND sg13cmos5l_decap_8
XFILLER_41_198 VPWR VGND sg13cmos5l_decap_8
XFILLER_66_70 VPWR VGND sg13cmos5l_decap_8
X_1170_ _1170_/X _0647_/Q _0651_/Q _1211_/X _1195_/X _0476_/Q _0475_/Q VPWR VGND sg13cmos5l_mux4_1
X_0121_ _0121_/Q Tile_X0Y0_FrameData[3] VGND VPWR Tile_X0Y1_FrameStrobe[0] latch
XFILLER_17_140 VPWR VGND sg13cmos5l_decap_4
XFILLER_32_110 VPWR VGND sg13cmos5l_decap_8
XFILLER_32_143 VPWR VGND sg13cmos5l_decap_8
XANTENNA_17 Tile_X0Y0_S2MID[7] VPWR VGND sg13cmos5l_antennanp
XANTENNA_28 Tile_X0Y1_N2MID[1] VPWR VGND sg13cmos5l_antennanp
XANTENNA_39 Tile_X0Y1_N2MID[6] VPWR VGND sg13cmos5l_antennanp
XFILLER_32_187 VPWR VGND sg13cmos5l_decap_8
XFILLER_32_198 VPWR VGND sg13cmos5l_fill_1
X_0885_ Tile_X0Y0_FrameData_O[29] Tile_X0Y0_FrameData[29] VPWR VGND sg13cmos5l_buf_1
X_0954_ Tile_X0Y1_W6BEG[9] _1188_/X VPWR VGND sg13cmos5l_buf_1
XFILLER_56_0 VPWR VGND sg13cmos5l_decap_8
XFILLER_99_110 VPWR VGND sg13cmos5l_decap_8
XFILLER_70_227 VPWR VGND sg13cmos5l_fill_2
X_0319_ _0319_/Q Tile_X0Y0_FrameData[29] VGND VPWR Tile_X0Y1_FrameStrobe[7] latch
XFILLER_134_7 VPWR VGND sg13cmos5l_decap_8
XFILLER_23_110 VPWR VGND sg13cmos5l_decap_8
XFILLER_23_198 VPWR VGND sg13cmos5l_decap_4
XFILLER_62_28 VPWR VGND sg13cmos5l_decap_8
XFILLER_11_32 VPWR VGND sg13cmos5l_fill_1
XFILLER_11_43 VPWR VGND sg13cmos5l_decap_8
XFILLER_11_65 VPWR VGND sg13cmos5l_decap_8
XFILLER_11_76 VPWR VGND sg13cmos5l_fill_2
XFILLER_127_32 VPWR VGND sg13cmos5l_fill_1
XFILLER_127_43 VPWR VGND sg13cmos5l_fill_2
XFILLER_127_76 VPWR VGND sg13cmos5l_decap_4
XFILLER_127_87 VPWR VGND sg13cmos5l_decap_8
XFILLER_87_36 VPWR VGND sg13cmos5l_decap_8
XFILLER_100_181 VPWR VGND sg13cmos5l_decap_8
XFILLER_14_110 VPWR VGND sg13cmos5l_decap_8
XFILLER_14_143 VPWR VGND sg13cmos5l_decap_8
XFILLER_52_94 VPWR VGND sg13cmos5l_decap_4
X_0670_ _0670_/L_HI VPWR VGND sg13cmos5l_tiehi
XFILLER_28_4 VPWR VGND sg13cmos5l_fill_2
X_1084_ _1084_/X _1114_/X Tile_X0Y1_N4END[7] Tile_X0Y0_S1END[3] Tile_X0Y0_S4END[3]
+ _0134_/Q _0133_/Q VPWR VGND sg13cmos5l_mux4_1
X_1222_ _1222_/X Tile_X0Y0_E2MID[4] Tile_X0Y0_E2END[4] Tile_X0Y0_E6END[11] _1095_/X
+ _0296_/Q _0295_/Q VPWR VGND sg13cmos5l_mux4_1
X_1153_ _1153_/X _0650_/Q _1196_/X _1201_/X _1192_/X _0510_/Q _0509_/Q VPWR VGND sg13cmos5l_mux4_1
X_0104_ _0104_/Q Tile_X0Y0_FrameData[20] VGND VPWR Tile_X0Y1_FrameStrobe[0] latch
XFILLER_96_179 VPWR VGND sg13cmos5l_decap_8
XANTENNA__0804__X Tile_X0Y0_FrameStrobe_O[1] VPWR VGND sg13cmos5l_antennanp
XFILLER_106_207 VPWR VGND sg13cmos5l_decap_8
X_0868_ Tile_X0Y0_FrameData_O[12] Tile_X0Y0_FrameData[12] VPWR VGND sg13cmos5l_buf_1
X_0937_ Tile_X0Y1_W2BEGb[0] _1155_/X VPWR VGND sg13cmos5l_buf_1
X_0799_ Tile_X0Y0_N1BEG[0] _0999_/X VPWR VGND sg13cmos5l_buf_1
XFILLER_113_12 VPWR VGND sg13cmos5l_decap_8
XFILLER_113_34 VPWR VGND sg13cmos5l_decap_8
XFILLER_113_89 VPWR VGND sg13cmos5l_decap_8
XFILLER_11_102 VPWR VGND sg13cmos5l_decap_8
XFILLER_11_168 VPWR VGND sg13cmos5l_decap_8
XFILLER_7_128 VPWR VGND sg13cmos5l_decap_8
XFILLER_138_64 VPWR VGND sg13cmos5l_decap_8
XFILLER_22_86 VPWR VGND sg13cmos5l_decap_8
XFILLER_98_46 VPWR VGND sg13cmos5l_fill_1
XFILLER_98_35 VPWR VGND sg13cmos5l_decap_8
XFILLER_98_13 VPWR VGND sg13cmos5l_fill_2
XFILLER_93_105 VPWR VGND sg13cmos5l_decap_8
XFILLER_63_93 VPWR VGND sg13cmos5l_decap_4
XFILLER_97_7 VPWR VGND sg13cmos5l_decap_4
X_0722_ Tile_X0Y0_W1BEG[3] _1030_/X VPWR VGND sg13cmos5l_buf_1
X_0653_ _0653_/L_HI VPWR VGND sg13cmos5l_tiehi
XFILLER_33_2 VPWR VGND sg13cmos5l_fill_1
XFILLER_69_157 VPWR VGND sg13cmos5l_decap_8
X_0584_ _0584_/Q Tile_X0Y1_FrameData[18] VGND VPWR Tile_X0Y1_FrameStrobe[7] latch
XFILLER_19_0 VPWR VGND sg13cmos5l_decap_8
XFILLER_25_216 VPWR VGND sg13cmos5l_fill_1
XFILLER_25_227 VPWR VGND sg13cmos5l_fill_2
XFILLER_77_190 VPWR VGND sg13cmos5l_decap_8
XFILLER_84_138 VPWR VGND sg13cmos5l_decap_8
X_1067_ _1067_/X _0640_/Q _1084_/X _1080_/X _1092_/X _0194_/Q _0193_/Q VPWR VGND sg13cmos5l_mux4_1
X_1136_ _1136_/X _1207_/X _1211_/X _1215_/X _1199_/X _0542_/Q _0541_/Q VPWR VGND sg13cmos5l_mux4_1
X_1205_ _1205_/X Tile_X0Y1_N1END[2] Tile_X0Y1_N4END[2] _1229_/X Tile_X0Y0_S4END[6]
+ _0398_/Q _0397_/Q VPWR VGND sg13cmos5l_mux4_1
XFILLER_92_171 VPWR VGND sg13cmos5l_decap_8
XFILLER_68_49 VPWR VGND sg13cmos5l_decap_8
XFILLER_124_22 VPWR VGND sg13cmos5l_fill_1
XFILLER_17_31 VPWR VGND sg13cmos5l_fill_2
XFILLER_84_26 VPWR VGND sg13cmos5l_decap_8
XFILLER_83_193 VPWR VGND sg13cmos5l_decap_8
XFILLER_123_0 VPWR VGND sg13cmos5l_decap_8
XFILLER_137_140 VPWR VGND sg13cmos5l_decap_8
XFILLER_137_151 VPWR VGND sg13cmos5l_fill_2
XFILLER_3_142 VPWR VGND sg13cmos5l_decap_8
XFILLER_3_153 VPWR VGND sg13cmos5l_fill_1
XFILLER_3_164 VPWR VGND sg13cmos5l_decap_8
XFILLER_66_105 VPWR VGND sg13cmos5l_decap_8
XFILLER_98_219 VPWR VGND sg13cmos5l_decap_8
XFILLER_59_190 VPWR VGND sg13cmos5l_decap_8
XFILLER_74_160 VPWR VGND sg13cmos5l_decap_8
XFILLER_74_92 VPWR VGND sg13cmos5l_decap_8
XFILLER_22_208 VPWR VGND sg13cmos5l_fill_1
XFILLER_95_4 VPWR VGND sg13cmos5l_fill_2
XFILLER_128_173 VPWR VGND sg13cmos5l_decap_8
X_0705_ _0973_/A3 VPWR VGND sg13cmos5l_tielo
X_0636_ _0636_/Q Tile_X0Y1_UserCLK NPU_OUT_ACT0 _0664_/L_HI VPWR VGND sg13cmos5l_dfrbpq_1
XFILLER_89_219 VPWR VGND sg13cmos5l_decap_8
XFILLER_72_108 VPWR VGND sg13cmos5l_decap_8
X_0567_ _0567_/Q Tile_X0Y1_FrameData[3] VGND VPWR Tile_X0Y1_FrameStrobe[6] latch
X_0498_ _0498_/Q Tile_X0Y1_FrameData[8] VGND VPWR Tile_X0Y1_FrameStrobe[4] latch
X_1119_ _1119_/X Tile_X0Y1_E1END[1] Tile_X0Y1_EE4END[1] Tile_X0Y1_E6END[9] _1204_/X
+ _0575_/Q _0574_/Q VPWR VGND sg13cmos5l_mux4_1
XFILLER_110_79 VPWR VGND sg13cmos5l_decap_8
XFILLER_119_162 VPWR VGND sg13cmos5l_decap_8
XFILLER_119_184 VPWR VGND sg13cmos5l_decap_8
XFILLER_119_33 VPWR VGND sg13cmos5l_decap_8
XFILLER_70_28 VPWR VGND sg13cmos5l_decap_8
XFILLER_0_167 VPWR VGND sg13cmos5l_decap_4
XFILLER_134_154 VPWR VGND sg13cmos5l_decap_8
XFILLER_135_21 VPWR VGND sg13cmos5l_decap_8
XFILLER_135_98 VPWR VGND sg13cmos5l_decap_8
XFILLER_48_105 VPWR VGND sg13cmos5l_decap_8
XFILLER_63_108 VPWR VGND sg13cmos5l_decap_8
XFILLER_71_130 VPWR VGND sg13cmos5l_decap_8
XFILLER_95_69 VPWR VGND sg13cmos5l_decap_8
XANTENNA__0902__X Tile_X0Y1_S2BEGb[2] VPWR VGND sg13cmos5l_antennanp
XFILLER_125_176 VPWR VGND sg13cmos5l_decap_8
XFILLER_140_124 VPWR VGND sg13cmos5l_decap_4
XFILLER_5_56 VPWR VGND sg13cmos5l_decap_8
XFILLER_5_78 VPWR VGND sg13cmos5l_decap_8
X_0421_ _0421_/Q Tile_X0Y1_FrameData[21] VGND VPWR Tile_X0Y1_FrameStrobe[2] latch
X_0352_ _0352_/Q Tile_X0Y1_FrameData[26] VGND VPWR Tile_X0Y1_FrameStrobe[0] latch
X_0283_ _0283_/Q Tile_X0Y0_FrameData[1] VGND VPWR Tile_X0Y1_FrameStrobe[5] latch
XFILLER_94_200 VPWR VGND sg13cmos5l_decap_8
XFILLER_54_119 VPWR VGND sg13cmos5l_fill_1
XFILLER_85_91 VPWR VGND sg13cmos5l_decap_8
XANTENNA__0812__X Tile_X0Y0_FrameStrobe_O[9] VPWR VGND sg13cmos5l_antennanp
XFILLER_86_0 VPWR VGND sg13cmos5l_decap_8
XFILLER_131_146 VPWR VGND sg13cmos5l_decap_8
X_0619_ NPU_ACT_WDATA1 Tile_X0Y1_UserCLK _0983_/X _0660_/L_HI VPWR VGND sg13cmos5l_dfrbpq_1
XFILLER_121_12 VPWR VGND sg13cmos5l_decap_8
XFILLER_38_193 VPWR VGND sg13cmos5l_decap_4
XFILLER_65_28 VPWR VGND sg13cmos5l_decap_8
XFILLER_85_222 VPWR VGND sg13cmos5l_decap_8
XFILLER_81_27 VPWR VGND sg13cmos5l_decap_8
XANTENNA__0722__X Tile_X0Y0_W1BEG[3] VPWR VGND sg13cmos5l_antennanp
XFILLER_30_31 VPWR VGND sg13cmos5l_decap_8
XFILLER_122_146 VPWR VGND sg13cmos5l_decap_8
XFILLER_29_182 VPWR VGND sg13cmos5l_decap_4
XFILLER_36_119 VPWR VGND sg13cmos5l_decap_8
XFILLER_55_94 VPWR VGND sg13cmos5l_decap_8
XFILLER_91_214 VPWR VGND sg13cmos5l_decap_8
X_0970_ Tile_X0Y1_WW4BEG[13] _1176_/X VPWR VGND sg13cmos5l_buf_1
XFILLER_113_124 VPWR VGND sg13cmos5l_decap_8
X_0404_ _0404_/Q Tile_X0Y1_FrameData[6] VGND VPWR Tile_X0Y1_FrameStrobe[1] latch
XANTENNA__0807__X Tile_X0Y0_FrameStrobe_O[4] VPWR VGND sg13cmos5l_antennanp
X_0335_ _0335_/Q Tile_X0Y0_FrameData[13] VGND VPWR Tile_X0Y1_FrameStrobe[7] latch
X_0266_ _0266_/Q Tile_X0Y0_FrameData[18] VGND VPWR Tile_X0Y1_FrameStrobe[5] latch
XFILLER_51_19 VPWR VGND sg13cmos5l_decap_8
X_0197_ _0197_/Q Tile_X0Y0_FrameData[23] VGND VPWR Tile_X0Y1_FrameStrobe[3] latch
XFILLER_2_207 VPWR VGND sg13cmos5l_fill_2
XFILLER_116_34 VPWR VGND sg13cmos5l_fill_2
XFILLER_116_78 VPWR VGND sg13cmos5l_decap_8
XFILLER_132_77 VPWR VGND sg13cmos5l_decap_8
XFILLER_25_42 VPWR VGND sg13cmos5l_decap_4
XFILLER_127_227 VPWR VGND sg13cmos5l_fill_2
XFILLER_25_64 VPWR VGND sg13cmos5l_decap_8
XFILLER_41_155 VPWR VGND sg13cmos5l_decap_8
XFILLER_41_177 VPWR VGND sg13cmos5l_decap_8
XFILLER_41_74 VPWR VGND sg13cmos5l_decap_4
X_0120_ _0120_/Q Tile_X0Y0_FrameData[4] VGND VPWR Tile_X0Y1_FrameStrobe[0] latch
XANTENNA_18 Tile_X0Y0_S2MID[7] VPWR VGND sg13cmos5l_antennanp
XANTENNA_29 Tile_X0Y1_N2MID[1] VPWR VGND sg13cmos5l_antennanp
XFILLER_32_166 VPWR VGND sg13cmos5l_decap_8
XFILLER_82_81 VPWR VGND sg13cmos5l_fill_2
X_0884_ Tile_X0Y0_FrameData_O[28] Tile_X0Y0_FrameData[28] VPWR VGND sg13cmos5l_buf_1
X_0953_ Tile_X0Y1_W6BEG[8] _1187_/X VPWR VGND sg13cmos5l_buf_1
XFILLER_101_149 VPWR VGND sg13cmos5l_decap_8
XFILLER_49_0 VPWR VGND sg13cmos5l_decap_4
XFILLER_46_19 VPWR VGND sg13cmos5l_decap_8
XFILLER_55_214 VPWR VGND sg13cmos5l_decap_8
X_0318_ _0318_/Q Tile_X0Y0_FrameData[30] VGND VPWR Tile_X0Y1_FrameStrobe[7] latch
X_0249_ _0249_/Q Tile_X0Y0_FrameData[3] VGND VPWR Tile_X0Y1_FrameStrobe[4] latch
XFILLER_109_216 VPWR VGND sg13cmos5l_fill_1
XFILLER_109_227 VPWR VGND sg13cmos5l_fill_2
XFILLER_127_7 VPWR VGND sg13cmos5l_decap_4
XFILLER_127_66 VPWR VGND sg13cmos5l_fill_2
XFILLER_87_59 VPWR VGND sg13cmos5l_decap_8
XFILLER_61_228 VPWR VGND sg13cmos5l_fill_1
XANTENNA__0910__X Tile_X0Y1_S4BEG[2] VPWR VGND sg13cmos5l_antennanp
XFILLER_14_199 VPWR VGND sg13cmos5l_decap_8
XFILLER_52_73 VPWR VGND sg13cmos5l_decap_8
X_1221_ _1221_/X Tile_X0Y0_E2MID[5] Tile_X0Y0_E2END[5] Tile_X0Y0_E6END[10] _1094_/X
+ _0298_/Q _0297_/Q VPWR VGND sg13cmos5l_mux4_1
XFILLER_96_158 VPWR VGND sg13cmos5l_decap_8
XFILLER_96_114 VPWR VGND sg13cmos5l_fill_2
X_1083_ _1083_/X _1111_/X Tile_X0Y1_N4END[4] Tile_X0Y0_S1END[0] Tile_X0Y0_S4END[0]
+ _0132_/Q _0131_/Q VPWR VGND sg13cmos5l_mux4_1
X_1152_ _1152_/X _0649_/Q _1197_/X _1200_/X _1191_/X _0512_/Q _0511_/Q VPWR VGND sg13cmos5l_mux4_1
X_0103_ _0103_/Q Tile_X0Y0_FrameData[21] VGND VPWR Tile_X0Y1_FrameStrobe[0] latch
XFILLER_93_91 VPWR VGND sg13cmos5l_decap_8
X_0936_ Tile_X0Y1_W2BEG[7] _1154_/X VPWR VGND sg13cmos5l_buf_1
XANTENNA__0820__X Tile_X0Y0_FrameStrobe_O[17] VPWR VGND sg13cmos5l_antennanp
X_0867_ Tile_X0Y0_FrameData_O[11] Tile_X0Y0_FrameData[11] VPWR VGND sg13cmos5l_buf_1
X_0798_ Tile_X0Y0_N2BEG[7] _1010_/X VPWR VGND sg13cmos5l_buf_1
XFILLER_43_217 VPWR VGND sg13cmos5l_decap_8
XFILLER_43_228 VPWR VGND sg13cmos5l_fill_1
XFILLER_73_39 VPWR VGND sg13cmos5l_decap_8
XANTENNA__0730__X Tile_X0Y0_W2BEG[7] VPWR VGND sg13cmos5l_antennanp
XFILLER_7_107 VPWR VGND sg13cmos5l_decap_8
XFILLER_47_84 VPWR VGND sg13cmos5l_decap_4
XANTENNA__0905__X Tile_X0Y1_S2BEGb[5] VPWR VGND sg13cmos5l_antennanp
XFILLER_63_72 VPWR VGND sg13cmos5l_decap_8
XFILLER_8_45 VPWR VGND sg13cmos5l_fill_1
XFILLER_8_34 VPWR VGND sg13cmos5l_decap_4
XFILLER_40_4 VPWR VGND sg13cmos5l_fill_2
XFILLER_6_151 VPWR VGND sg13cmos5l_decap_8
XFILLER_6_195 VPWR VGND sg13cmos5l_decap_8
X_0721_ Tile_X0Y0_W1BEG[2] _1029_/X VPWR VGND sg13cmos5l_buf_1
X_0652_ _0652_/L_HI VPWR VGND sg13cmos5l_tiehi
X_0583_ _0583_/Q Tile_X0Y1_FrameData[19] VGND VPWR Tile_X0Y1_FrameStrobe[7] latch
XFILLER_69_136 VPWR VGND sg13cmos5l_decap_8
XFILLER_84_117 VPWR VGND sg13cmos5l_decap_8
X_1204_ _1204_/X Tile_X0Y1_N1END[1] Tile_X0Y1_N4END[1] _1228_/X Tile_X0Y0_S4END[5]
+ _0400_/Q _0399_/Q VPWR VGND sg13cmos5l_mux4_1
XFILLER_88_91 VPWR VGND sg13cmos5l_decap_8
XANTENNA__0815__X Tile_X0Y0_FrameStrobe_O[12] VPWR VGND sg13cmos5l_antennanp
X_1066_ _1066_/X Tile_X0Y1_N4END[7] Tile_X0Y0_S4END[3] _1083_/X _1075_/X _0196_/Q
+ _0195_/Q VPWR VGND sg13cmos5l_mux4_1
X_1135_ _1135_/X Tile_X0Y1_E1END[0] Tile_X0Y1_EE4END[12] Tile_X0Y1_E6END[4] _1203_/X
+ _0542_/Q _0541_/Q VPWR VGND sg13cmos5l_mux4_1
XFILLER_92_150 VPWR VGND sg13cmos5l_decap_8
X_0919_ Tile_X0Y1_S4BEG[11] _0919_/A VPWR VGND sg13cmos5l_buf_1
XFILLER_102_211 VPWR VGND sg13cmos5l_decap_8
XFILLER_108_24 VPWR VGND sg13cmos5l_decap_8
XFILLER_68_28 VPWR VGND sg13cmos5l_decap_8
XFILLER_16_206 VPWR VGND sg13cmos5l_decap_4
XFILLER_16_228 VPWR VGND sg13cmos5l_fill_1
XFILLER_17_54 VPWR VGND sg13cmos5l_decap_8
XFILLER_83_172 VPWR VGND sg13cmos5l_decap_8
XANTENNA__0725__X Tile_X0Y0_W2BEG[2] VPWR VGND sg13cmos5l_antennanp
XFILLER_129_119 VPWR VGND sg13cmos5l_decap_8
XFILLER_33_42 VPWR VGND sg13cmos5l_decap_8
XFILLER_116_0 VPWR VGND sg13cmos5l_fill_2
XFILLER_137_185 VPWR VGND sg13cmos5l_decap_8
XFILLER_3_121 VPWR VGND sg13cmos5l_decap_8
XFILLER_58_61 VPWR VGND sg13cmos5l_decap_4
XFILLER_58_94 VPWR VGND sg13cmos5l_fill_2
XFILLER_128_152 VPWR VGND sg13cmos5l_decap_8
XFILLER_31_0 VPWR VGND sg13cmos5l_decap_4
X_0704_ _1235_/A3 VPWR VGND sg13cmos5l_tielo
X_0635_ NPU_WEIGHT_SHIFT_EN Tile_X0Y1_UserCLK _1234_/X _0665_/L_HI VPWR VGND sg13cmos5l_dfrbpq_1
X_0566_ _0566_/Q Tile_X0Y1_FrameData[4] VGND VPWR Tile_X0Y1_FrameStrobe[6] latch
XFILLER_97_220 VPWR VGND sg13cmos5l_decap_8
X_0497_ _0497_/Q Tile_X0Y1_FrameData[9] VGND VPWR Tile_X0Y1_FrameStrobe[4] latch
XFILLER_0_90 VPWR VGND sg13cmos5l_decap_8
XFILLER_110_58 VPWR VGND sg13cmos5l_decap_8
XFILLER_13_209 VPWR VGND sg13cmos5l_fill_1
XFILLER_80_197 VPWR VGND sg13cmos5l_decap_8
X_1049_ _1049_/X _0638_/Q _0642_/Q _1076_/X _1097_/X _0230_/Q _0229_/Q VPWR VGND sg13cmos5l_mux4_1
X_1118_ _1118_/X _1209_/X _1213_/X _1217_/X _1197_/X _0572_/Q _0571_/Q VPWR VGND sg13cmos5l_mux4_1
XFILLER_134_133 VPWR VGND sg13cmos5l_decap_8
XFILLER_0_146 VPWR VGND sg13cmos5l_decap_8
XFILLER_135_77 VPWR VGND sg13cmos5l_decap_8
XFILLER_95_48 VPWR VGND sg13cmos5l_decap_8
XFILLER_88_220 VPWR VGND sg13cmos5l_decap_8
XFILLER_28_86 VPWR VGND sg13cmos5l_decap_8
XFILLER_56_183 VPWR VGND sg13cmos5l_fill_1
XFILLER_100_91 VPWR VGND sg13cmos5l_decap_8
XFILLER_12_220 VPWR VGND sg13cmos5l_decap_8
XFILLER_8_213 VPWR VGND sg13cmos5l_fill_1
XFILLER_8_202 VPWR VGND sg13cmos5l_decap_8
XFILLER_125_155 VPWR VGND sg13cmos5l_decap_8
XFILLER_140_103 VPWR VGND sg13cmos5l_decap_8
XFILLER_140_147 VPWR VGND sg13cmos5l_decap_8
XFILLER_5_35 VPWR VGND sg13cmos5l_decap_8
XFILLER_79_220 VPWR VGND sg13cmos5l_decap_8
X_0420_ _0420_/Q Tile_X0Y1_FrameData[22] VGND VPWR Tile_X0Y1_FrameStrobe[2] latch
XFILLER_39_128 VPWR VGND sg13cmos5l_decap_4
X_0351_ _0351_/Q Tile_X0Y1_FrameData[27] VGND VPWR Tile_X0Y1_FrameStrobe[0] latch
X_0282_ _0282_/Q Tile_X0Y0_FrameData[2] VGND VPWR Tile_X0Y1_FrameStrobe[5] latch
XFILLER_62_175 VPWR VGND sg13cmos5l_decap_8
XFILLER_79_0 VPWR VGND sg13cmos5l_decap_4
XFILLER_131_125 VPWR VGND sg13cmos5l_decap_8
XFILLER_85_201 VPWR VGND sg13cmos5l_decap_8
X_0618_ NPU_ACT_WDATA0 Tile_X0Y1_UserCLK _0982_/X _0681_/L_HI VPWR VGND sg13cmos5l_dfrbpq_1
X_0549_ _0549_/Q Tile_X0Y1_FrameData[21] VGND VPWR Tile_X0Y1_FrameStrobe[6] latch
XFILLER_105_58 VPWR VGND sg13cmos5l_decap_4
XFILLER_38_172 VPWR VGND sg13cmos5l_decap_8
XFILLER_53_120 VPWR VGND sg13cmos5l_fill_2
XFILLER_53_175 VPWR VGND sg13cmos5l_decap_8
XFILLER_14_66 VPWR VGND sg13cmos5l_fill_1
XFILLER_30_54 VPWR VGND sg13cmos5l_fill_1
XFILLER_30_87 VPWR VGND sg13cmos5l_fill_2
XFILLER_5_205 VPWR VGND sg13cmos5l_decap_8
XFILLER_5_216 VPWR VGND sg13cmos5l_fill_1
XFILLER_5_227 VPWR VGND sg13cmos5l_fill_2
XFILLER_76_223 VPWR VGND sg13cmos5l_decap_4
XANTENNA__0913__X Tile_X0Y1_S4BEG[5] VPWR VGND sg13cmos5l_antennanp
XFILLER_72_7 VPWR VGND sg13cmos5l_fill_2
XFILLER_113_103 VPWR VGND sg13cmos5l_decap_8
X_0403_ _0403_/Q Tile_X0Y1_FrameData[7] VGND VPWR Tile_X0Y1_FrameStrobe[1] latch
XFILLER_121_191 VPWR VGND sg13cmos5l_decap_8
XFILLER_27_109 VPWR VGND sg13cmos5l_fill_1
XFILLER_35_131 VPWR VGND sg13cmos5l_fill_2
XFILLER_82_226 VPWR VGND sg13cmos5l_fill_2
X_0334_ _0334_/Q Tile_X0Y0_FrameData[14] VGND VPWR Tile_X0Y1_FrameStrobe[7] latch
X_0265_ _0265_/Q Tile_X0Y0_FrameData[19] VGND VPWR Tile_X0Y1_FrameStrobe[5] latch
X_0196_ _0196_/Q Tile_X0Y0_FrameData[24] VGND VPWR Tile_X0Y1_FrameStrobe[3] latch
XANTENNA__0823__X FAB_USER_CLK VPWR VGND sg13cmos5l_antennanp
XFILLER_50_189 VPWR VGND sg13cmos5l_decap_8
XFILLER_136_217 VPWR VGND sg13cmos5l_decap_8
XFILLER_136_228 VPWR VGND sg13cmos5l_fill_1
XFILLER_116_57 VPWR VGND sg13cmos5l_decap_8
XFILLER_132_56 VPWR VGND sg13cmos5l_decap_8
XFILLER_92_49 VPWR VGND sg13cmos5l_decap_8
XFILLER_92_16 VPWR VGND sg13cmos5l_fill_1
XANTENNA__0733__X Tile_X0Y0_W2BEGb[2] VPWR VGND sg13cmos5l_antennanp
XFILLER_127_206 VPWR VGND sg13cmos5l_decap_8
XFILLER_41_53 VPWR VGND sg13cmos5l_fill_2
XFILLER_2_14 VPWR VGND sg13cmos5l_decap_8
XFILLER_2_25 VPWR VGND sg13cmos5l_fill_2
XFILLER_9_0 VPWR VGND sg13cmos5l_fill_2
XANTENNA__0908__X Tile_X0Y1_S4BEG[0] VPWR VGND sg13cmos5l_antennanp
XFILLER_106_90 VPWR VGND sg13cmos5l_decap_8
XFILLER_2_58 VPWR VGND sg13cmos5l_fill_2
XANTENNA_19 Tile_X0Y0_S2MID[7] VPWR VGND sg13cmos5l_antennanp
X_0952_ Tile_X0Y1_W6BEG[7] _1186_/X VPWR VGND sg13cmos5l_buf_1
XFILLER_118_217 VPWR VGND sg13cmos5l_decap_8
XFILLER_118_228 VPWR VGND sg13cmos5l_fill_1
XFILLER_133_209 VPWR VGND sg13cmos5l_decap_8
XFILLER_141_220 VPWR VGND sg13cmos5l_decap_8
X_0883_ Tile_X0Y0_FrameData_O[27] Tile_X0Y0_FrameData[27] VPWR VGND sg13cmos5l_buf_1
XANTENNA__0818__X Tile_X0Y0_FrameStrobe_O[15] VPWR VGND sg13cmos5l_antennanp
XFILLER_101_128 VPWR VGND sg13cmos5l_decap_8
X_0317_ _0317_/Q Tile_X0Y0_FrameData[31] VGND VPWR Tile_X0Y1_FrameStrobe[7] latch
XFILLER_102_15 VPWR VGND sg13cmos5l_fill_1
XFILLER_102_48 VPWR VGND sg13cmos5l_fill_1
X_0248_ _0248_/Q Tile_X0Y0_FrameData[4] VGND VPWR Tile_X0Y1_FrameStrobe[4] latch
X_0179_ _0179_/Q Tile_X0Y0_FrameData[9] VGND VPWR Tile_X0Y1_FrameStrobe[2] latch
XFILLER_2_7 VPWR VGND sg13cmos5l_decap_8
XFILLER_87_27 VPWR VGND sg13cmos5l_fill_2
XANTENNA__0728__X Tile_X0Y0_W2BEG[5] VPWR VGND sg13cmos5l_antennanp
XFILLER_100_161 VPWR VGND sg13cmos5l_decap_4
XFILLER_36_20 VPWR VGND sg13cmos5l_fill_1
XFILLER_36_42 VPWR VGND sg13cmos5l_decap_8
XFILLER_46_215 VPWR VGND sg13cmos5l_fill_2
XFILLER_14_178 VPWR VGND sg13cmos5l_decap_8
XFILLER_123_220 VPWR VGND sg13cmos5l_decap_8
X_1220_ _1220_/X Tile_X0Y0_E2MID[6] Tile_X0Y0_E2END[6] Tile_X0Y0_E6END[9] _1093_/X
+ _0300_/Q _0299_/Q VPWR VGND sg13cmos5l_mux4_1
X_1151_ _1151_/X Tile_X0Y1_EE4END[8] _0648_/Q _1198_/X _1199_/X _0514_/Q _0513_/Q
+ VPWR VGND sg13cmos5l_mux4_1
XFILLER_37_226 VPWR VGND sg13cmos5l_fill_2
X_1082_ _1082_/X _1112_/X Tile_X0Y1_N4END[5] Tile_X0Y0_S1END[1] Tile_X0Y0_S4END[1]
+ _0130_/Q _0129_/Q VPWR VGND sg13cmos5l_mux4_1
X_0102_ _0102_/Q Tile_X0Y0_FrameData[22] VGND VPWR Tile_X0Y1_FrameStrobe[0] latch
X_0866_ Tile_X0Y0_FrameData_O[10] Tile_X0Y0_FrameData[10] VPWR VGND sg13cmos5l_buf_1
X_0935_ Tile_X0Y1_W2BEG[6] _1153_/X VPWR VGND sg13cmos5l_buf_1
XFILLER_9_182 VPWR VGND sg13cmos5l_decap_8
XFILLER_61_0 VPWR VGND sg13cmos5l_decap_8
X_0797_ Tile_X0Y0_N2BEG[6] _1009_/X VPWR VGND sg13cmos5l_buf_1
XFILLER_113_69 VPWR VGND sg13cmos5l_decap_8
XFILLER_11_126 VPWR VGND sg13cmos5l_decap_8
XFILLER_105_220 VPWR VGND sg13cmos5l_decap_8
XFILLER_118_4 VPWR VGND sg13cmos5l_fill_2
XFILLER_138_99 VPWR VGND sg13cmos5l_decap_8
XFILLER_120_223 VPWR VGND sg13cmos5l_decap_4
XFILLER_78_159 VPWR VGND sg13cmos5l_decap_8
XFILLER_19_215 VPWR VGND sg13cmos5l_fill_2
XANTENNA__0921__X Tile_X0Y1_S4BEG[13] VPWR VGND sg13cmos5l_antennanp
X_0720_ Tile_X0Y0_W1BEG[1] _1028_/X VPWR VGND sg13cmos5l_buf_1
XFILLER_10_181 VPWR VGND sg13cmos5l_decap_8
XFILLER_69_115 VPWR VGND sg13cmos5l_decap_8
XFILLER_6_130 VPWR VGND sg13cmos5l_decap_8
XFILLER_6_174 VPWR VGND sg13cmos5l_decap_8
X_0651_ _0651_/Q Tile_X0Y1_UserCLK NPU_ACT_RDATA7 _0659_/L_HI VPWR VGND sg13cmos5l_dfrbpq_1
X_0582_ _0582_/Q Tile_X0Y1_FrameData[20] VGND VPWR Tile_X0Y1_FrameStrobe[7] latch
X_1134_ _1134_/X Tile_X0Y1_E1END[3] Tile_X0Y1_E2MID[0] Tile_X0Y1_E2END[0] _1202_/X
+ _0544_/Q _0543_/Q VPWR VGND sg13cmos5l_mux4_1
X_1203_ _1203_/X Tile_X0Y1_N1END[0] Tile_X0Y1_N4END[0] _1227_/X Tile_X0Y0_S4END[4]
+ _0402_/Q _0401_/Q VPWR VGND sg13cmos5l_mux4_1
X_1065_ _1065_/X Tile_X0Y1_N4END[6] Tile_X0Y0_S4END[2] _1082_/X _1076_/X _0198_/Q
+ _0197_/Q VPWR VGND sg13cmos5l_mux4_1
XANTENNA__0831__X Tile_X0Y1_FrameData_O[7] VPWR VGND sg13cmos5l_antennanp
XFILLER_108_14 VPWR VGND sg13cmos5l_decap_4
X_0918_ Tile_X0Y1_S4BEG[10] _0918_/A VPWR VGND sg13cmos5l_buf_1
X_0849_ Tile_X0Y1_FrameData_O[25] Tile_X0Y1_FrameData[25] VPWR VGND sg13cmos5l_buf_1
XFILLER_124_68 VPWR VGND sg13cmos5l_decap_8
XANTENNA__0741__X Tile_X0Y0_W6BEG[2] VPWR VGND sg13cmos5l_antennanp
XFILLER_140_89 VPWR VGND sg13cmos5l_decap_8
XFILLER_33_21 VPWR VGND sg13cmos5l_decap_8
XFILLER_33_65 VPWR VGND sg13cmos5l_decap_8
XFILLER_109_0 VPWR VGND sg13cmos5l_decap_8
XFILLER_137_164 VPWR VGND sg13cmos5l_decap_8
XFILLER_3_199 VPWR VGND sg13cmos5l_decap_8
XANTENNA__0916__X Tile_X0Y1_S4BEG[8] VPWR VGND sg13cmos5l_antennanp
XFILLER_30_210 VPWR VGND sg13cmos5l_decap_8
XFILLER_30_221 VPWR VGND sg13cmos5l_decap_8
XFILLER_74_195 VPWR VGND sg13cmos5l_decap_8
XFILLER_128_131 VPWR VGND sg13cmos5l_decap_8
X_0703_ _1100_/A3 VPWR VGND sg13cmos5l_tielo
X_0634_ NPU_ACT_ADDR8 Tile_X0Y1_UserCLK _0981_/X _0666_/L_HI VPWR VGND sg13cmos5l_dfrbpq_1
X_0565_ _0565_/Q Tile_X0Y1_FrameData[5] VGND VPWR Tile_X0Y1_FrameStrobe[6] latch
X_0496_ _0496_/Q Tile_X0Y1_FrameData[10] VGND VPWR Tile_X0Y1_FrameStrobe[4] latch
XANTENNA__0826__X Tile_X0Y1_FrameData_O[2] VPWR VGND sg13cmos5l_antennanp
XFILLER_80_143 VPWR VGND sg13cmos5l_decap_8
X_1117_ _1117_/X Tile_X0Y1_E1END[2] Tile_X0Y1_EE4END[2] Tile_X0Y1_E6END[10] _1205_/X
+ _0572_/Q _0571_/Q VPWR VGND sg13cmos5l_mux4_1
XFILLER_110_26 VPWR VGND sg13cmos5l_decap_4
XFILLER_110_37 VPWR VGND sg13cmos5l_decap_8
XFILLER_80_176 VPWR VGND sg13cmos5l_decap_8
X_1048_ _1048_/X _0637_/Q _0641_/Q _1077_/X _1098_/X _0232_/Q _0231_/Q VPWR VGND sg13cmos5l_mux4_1
XFILLER_134_112 VPWR VGND sg13cmos5l_decap_8
XFILLER_134_189 VPWR VGND sg13cmos5l_decap_8
XFILLER_0_125 VPWR VGND sg13cmos5l_decap_8
XFILLER_135_56 VPWR VGND sg13cmos5l_decap_8
XFILLER_28_21 VPWR VGND sg13cmos5l_decap_8
XFILLER_28_65 VPWR VGND sg13cmos5l_decap_8
XFILLER_95_27 VPWR VGND sg13cmos5l_decap_8
XFILLER_88_210 VPWR VGND sg13cmos5l_decap_4
XANTENNA__0736__X Tile_X0Y0_W2BEGb[5] VPWR VGND sg13cmos5l_antennanp
XFILLER_44_86 VPWR VGND sg13cmos5l_fill_1
XFILLER_71_165 VPWR VGND sg13cmos5l_decap_4
XFILLER_125_134 VPWR VGND sg13cmos5l_decap_8
XFILLER_5_14 VPWR VGND sg13cmos5l_decap_8
X_0350_ _0350_/Q Tile_X0Y1_FrameData[28] VGND VPWR Tile_X0Y1_FrameStrobe[0] latch
XFILLER_47_184 VPWR VGND sg13cmos5l_decap_8
X_0281_ _0281_/Q Tile_X0Y0_FrameData[3] VGND VPWR Tile_X0Y1_FrameStrobe[5] latch
XFILLER_62_154 VPWR VGND sg13cmos5l_decap_8
XFILLER_116_189 VPWR VGND sg13cmos5l_decap_8
XFILLER_131_104 VPWR VGND sg13cmos5l_decap_8
XFILLER_105_15 VPWR VGND sg13cmos5l_decap_4
XFILLER_105_37 VPWR VGND sg13cmos5l_decap_8
X_0617_ NPU_WEIGHT_IN7 Tile_X0Y1_UserCLK _0997_/X _0680_/L_HI VPWR VGND sg13cmos5l_dfrbpq_1
X_0548_ _0548_/Q Tile_X0Y1_FrameData[22] VGND VPWR Tile_X0Y1_FrameStrobe[6] latch
X_0479_ _0479_/Q Tile_X0Y1_FrameData[27] VGND VPWR Tile_X0Y1_FrameStrobe[4] latch
XFILLER_53_154 VPWR VGND sg13cmos5l_decap_8
XFILLER_107_112 VPWR VGND sg13cmos5l_decap_8
XFILLER_100_4 VPWR VGND sg13cmos5l_fill_2
XFILLER_122_115 VPWR VGND sg13cmos5l_decap_8
XFILLER_39_31 VPWR VGND sg13cmos5l_fill_1
XFILLER_130_192 VPWR VGND sg13cmos5l_fill_2
XFILLER_29_140 VPWR VGND sg13cmos5l_fill_1
XFILLER_29_173 VPWR VGND sg13cmos5l_fill_2
XFILLER_39_75 VPWR VGND sg13cmos5l_decap_8
XFILLER_55_41 VPWR VGND sg13cmos5l_decap_8
XFILLER_76_202 VPWR VGND sg13cmos5l_decap_8
XFILLER_44_187 VPWR VGND sg13cmos5l_fill_1
XFILLER_65_7 VPWR VGND sg13cmos5l_decap_8
XFILLER_71_95 VPWR VGND sg13cmos5l_decap_8
XFILLER_113_159 VPWR VGND sg13cmos5l_decap_8
XFILLER_121_170 VPWR VGND sg13cmos5l_decap_8
X_0402_ _0402_/Q Tile_X0Y1_FrameData[8] VGND VPWR Tile_X0Y1_FrameStrobe[1] latch
X_0333_ _0333_/Q Tile_X0Y0_FrameData[15] VGND VPWR Tile_X0Y1_FrameStrobe[7] latch
XFILLER_35_154 VPWR VGND sg13cmos5l_fill_2
XFILLER_82_205 VPWR VGND sg13cmos5l_decap_8
X_0264_ _0264_/Q Tile_X0Y0_FrameData[20] VGND VPWR Tile_X0Y1_FrameStrobe[5] latch
X_0195_ _0195_/Q Tile_X0Y0_FrameData[25] VGND VPWR Tile_X0Y1_FrameStrobe[3] latch
XFILLER_50_146 VPWR VGND sg13cmos5l_fill_1
XFILLER_91_0 VPWR VGND sg13cmos5l_decap_4
XFILLER_2_209 VPWR VGND sg13cmos5l_fill_1
XFILLER_112_192 VPWR VGND sg13cmos5l_decap_8
XFILLER_132_35 VPWR VGND sg13cmos5l_decap_8
XFILLER_26_121 VPWR VGND sg13cmos5l_decap_8
XFILLER_73_216 VPWR VGND sg13cmos5l_fill_1
XFILLER_73_227 VPWR VGND sg13cmos5l_fill_2
XFILLER_25_99 VPWR VGND sg13cmos5l_decap_8
XFILLER_41_124 VPWR VGND sg13cmos5l_decap_8
XFILLER_92_28 VPWR VGND sg13cmos5l_decap_8
XFILLER_41_32 VPWR VGND sg13cmos5l_decap_8
XFILLER_110_107 VPWR VGND sg13cmos5l_decap_8
XFILLER_110_118 VPWR VGND sg13cmos5l_fill_2
XFILLER_2_48 VPWR VGND sg13cmos5l_decap_4
XFILLER_17_110 VPWR VGND sg13cmos5l_decap_4
XFILLER_64_227 VPWR VGND sg13cmos5l_fill_2
XFILLER_66_84 VPWR VGND sg13cmos5l_decap_8
XANTENNA__0924__X Tile_X0Y1_UserCLKo VPWR VGND sg13cmos5l_antennanp
XFILLER_32_157 VPWR VGND sg13cmos5l_fill_2
X_0882_ Tile_X0Y0_FrameData_O[26] Tile_X0Y0_FrameData[26] VPWR VGND sg13cmos5l_buf_1
X_0951_ Tile_X0Y1_W6BEG[6] _1185_/X VPWR VGND sg13cmos5l_buf_1
XFILLER_99_124 VPWR VGND sg13cmos5l_fill_2
X_0316_ _0316_/Q Tile_X0Y0_FrameData[0] VGND VPWR Tile_X0Y1_FrameStrobe[6] latch
XANTENNA__0834__X Tile_X0Y1_FrameData_O[10] VPWR VGND sg13cmos5l_antennanp
XFILLER_102_27 VPWR VGND sg13cmos5l_decap_8
XFILLER_23_124 VPWR VGND sg13cmos5l_decap_8
XFILLER_23_146 VPWR VGND sg13cmos5l_decap_4
X_0247_ _0247_/Q Tile_X0Y0_FrameData[5] VGND VPWR Tile_X0Y1_FrameStrobe[4] latch
X_0178_ _0178_/Q Tile_X0Y0_FrameData[10] VGND VPWR Tile_X0Y1_FrameStrobe[2] latch
XFILLER_127_68 VPWR VGND sg13cmos5l_fill_1
XFILLER_132_210 VPWR VGND sg13cmos5l_decap_8
XFILLER_100_140 VPWR VGND sg13cmos5l_decap_8
XFILLER_14_102 VPWR VGND sg13cmos5l_fill_1
XFILLER_36_65 VPWR VGND sg13cmos5l_decap_8
XFILLER_46_227 VPWR VGND sg13cmos5l_fill_2
XANTENNA__0744__X Tile_X0Y0_W6BEG[5] VPWR VGND sg13cmos5l_antennanp
XFILLER_139_0 VPWR VGND sg13cmos5l_decap_8
XFILLER_14_157 VPWR VGND sg13cmos5l_decap_8
XFILLER_36_98 VPWR VGND sg13cmos5l_decap_8
XFILLER_52_20 VPWR VGND sg13cmos5l_decap_8
XANTENNA__0919__X Tile_X0Y1_S4BEG[11] VPWR VGND sg13cmos5l_antennanp
X_1150_ _1150_/X Tile_X0Y1_EE4END[4] _0647_/Q _1198_/X _1199_/X _0516_/Q _0515_/Q
+ VPWR VGND sg13cmos5l_mux4_1
X_0101_ _0101_/Q Tile_X0Y0_FrameData[23] VGND VPWR Tile_X0Y1_FrameStrobe[0] latch
X_1081_ _1081_/X _1113_/X Tile_X0Y1_N4END[6] Tile_X0Y0_S1END[2] Tile_X0Y0_S4END[2]
+ _0128_/Q _0127_/Q VPWR VGND sg13cmos5l_mux4_1
XFILLER_20_138 VPWR VGND sg13cmos5l_decap_8
X_0865_ Tile_X0Y0_FrameData_O[9] Tile_X0Y0_FrameData[9] VPWR VGND sg13cmos5l_buf_1
X_0934_ Tile_X0Y1_W2BEG[5] _1152_/X VPWR VGND sg13cmos5l_buf_1
XFILLER_9_161 VPWR VGND sg13cmos5l_decap_8
XANTENNA__0829__X Tile_X0Y1_FrameData_O[5] VPWR VGND sg13cmos5l_antennanp
XFILLER_54_0 VPWR VGND sg13cmos5l_fill_2
X_0796_ Tile_X0Y0_N2BEG[5] _1008_/X VPWR VGND sg13cmos5l_buf_1
XFILLER_113_26 VPWR VGND sg13cmos5l_decap_4
XFILLER_113_48 VPWR VGND sg13cmos5l_decap_8
XFILLER_28_227 VPWR VGND sg13cmos5l_fill_2
XFILLER_3_91 VPWR VGND sg13cmos5l_decap_8
XFILLER_132_7 VPWR VGND sg13cmos5l_decap_8
XFILLER_22_34 VPWR VGND sg13cmos5l_decap_4
XFILLER_138_34 VPWR VGND sg13cmos5l_decap_8
XFILLER_138_45 VPWR VGND sg13cmos5l_fill_1
XFILLER_138_78 VPWR VGND sg13cmos5l_decap_8
XANTENNA__0739__X Tile_X0Y0_W6BEG[0] VPWR VGND sg13cmos5l_antennanp
XFILLER_120_202 VPWR VGND sg13cmos5l_decap_8
XFILLER_19_227 VPWR VGND sg13cmos5l_fill_2
XFILLER_47_31 VPWR VGND sg13cmos5l_fill_1
XFILLER_47_64 VPWR VGND sg13cmos5l_decap_4
XFILLER_86_160 VPWR VGND sg13cmos5l_fill_2
XFILLER_93_119 VPWR VGND sg13cmos5l_decap_8
XFILLER_10_160 VPWR VGND sg13cmos5l_decap_8
X_0650_ _0650_/Q Tile_X0Y1_UserCLK NPU_ACT_RDATA6 _0658_/L_HI VPWR VGND sg13cmos5l_dfrbpq_1
X_0581_ _0581_/Q Tile_X0Y1_FrameData[21] VGND VPWR Tile_X0Y1_FrameStrobe[7] latch
XFILLER_26_4 VPWR VGND sg13cmos5l_fill_2
X_1064_ _1064_/X Tile_X0Y1_N4END[5] Tile_X0Y0_S4END[1] _1081_/X _1077_/X _0200_/Q
+ _0199_/Q VPWR VGND sg13cmos5l_mux4_1
X_1133_ _1133_/X Tile_X0Y1_E1END[2] Tile_X0Y1_E2MID[1] Tile_X0Y1_E2END[1] _1201_/X
+ _0546_/Q _0545_/Q VPWR VGND sg13cmos5l_mux4_1
X_1202_ _1202_/X Tile_X0Y1_N2MID[7] Tile_X0Y1_N2END[7] _1226_/X Tile_X0Y0_S2MID[7]
+ _0356_/Q _0355_/Q VPWR VGND sg13cmos5l_mux4_1
XFILLER_92_185 VPWR VGND sg13cmos5l_decap_8
X_0917_ Tile_X0Y1_S4BEG[9] _0917_/A VPWR VGND sg13cmos5l_buf_1
X_0848_ Tile_X0Y1_FrameData_O[24] Tile_X0Y1_FrameData[24] VPWR VGND sg13cmos5l_buf_1
X_0779_ Tile_X0Y0_WW4BEG[12] _1059_/X VPWR VGND sg13cmos5l_buf_1
XFILLER_75_119 VPWR VGND sg13cmos5l_decap_8
XFILLER_17_89 VPWR VGND sg13cmos5l_decap_8
XFILLER_116_2 VPWR VGND sg13cmos5l_fill_1
XFILLER_3_112 VPWR VGND sg13cmos5l_decap_4
XFILLER_3_178 VPWR VGND sg13cmos5l_decap_8
XFILLER_58_30 VPWR VGND sg13cmos5l_fill_2
XFILLER_66_119 VPWR VGND sg13cmos5l_decap_8
XFILLER_74_174 VPWR VGND sg13cmos5l_decap_8
XANTENNA__0932__X Tile_X0Y1_W2BEG[3] VPWR VGND sg13cmos5l_antennanp
XFILLER_74_73 VPWR VGND sg13cmos5l_decap_8
XFILLER_74_84 VPWR VGND sg13cmos5l_fill_1
XFILLER_128_110 VPWR VGND sg13cmos5l_decap_8
XFILLER_128_187 VPWR VGND sg13cmos5l_decap_8
X_0702_ _1234_/A3 VPWR VGND sg13cmos5l_tielo
X_0633_ NPU_ACT_ADDR7 Tile_X0Y1_UserCLK _0980_/X _0688_/L_HI VPWR VGND sg13cmos5l_dfrbpq_1
XFILLER_90_83 VPWR VGND sg13cmos5l_decap_8
X_0564_ _0564_/Q Tile_X0Y1_FrameData[6] VGND VPWR Tile_X0Y1_FrameStrobe[6] latch
X_0495_ _0495_/Q Tile_X0Y1_FrameData[11] VGND VPWR Tile_X0Y1_FrameStrobe[4] latch
XFILLER_17_0 VPWR VGND sg13cmos5l_decap_4
XFILLER_80_122 VPWR VGND sg13cmos5l_decap_8
XFILLER_80_155 VPWR VGND sg13cmos5l_decap_8
X_1047_ _1047_/X _0636_/Q _0640_/Q _1079_/X _1099_/X _0234_/Q _0233_/Q VPWR VGND sg13cmos5l_mux4_1
X_1116_ _1116_/X _1210_/X _1214_/X _1218_/X _1198_/X _0569_/Q _0568_/Q VPWR VGND sg13cmos5l_mux4_1
XANTENNA__0842__X Tile_X0Y1_FrameData_O[18] VPWR VGND sg13cmos5l_antennanp
XFILLER_0_104 VPWR VGND sg13cmos5l_decap_8
XFILLER_119_198 VPWR VGND sg13cmos5l_decap_4
XFILLER_134_168 VPWR VGND sg13cmos5l_decap_8
XFILLER_135_35 VPWR VGND sg13cmos5l_decap_8
XFILLER_48_119 VPWR VGND sg13cmos5l_decap_8
XFILLER_56_130 VPWR VGND sg13cmos5l_decap_8
XANTENNA__0752__X Tile_X0Y0_N4BEG[1] VPWR VGND sg13cmos5l_antennanp
XFILLER_44_32 VPWR VGND sg13cmos5l_fill_2
XFILLER_44_98 VPWR VGND sg13cmos5l_decap_8
XFILLER_71_144 VPWR VGND sg13cmos5l_decap_8
XFILLER_121_0 VPWR VGND sg13cmos5l_decap_4
XFILLER_125_113 VPWR VGND sg13cmos5l_decap_8
XFILLER_60_53 VPWR VGND sg13cmos5l_decap_8
X_0280_ _0280_/Q Tile_X0Y0_FrameData[4] VGND VPWR Tile_X0Y1_FrameStrobe[5] latch
XFILLER_94_214 VPWR VGND sg13cmos5l_decap_8
XANTENNA__0927__X Tile_X0Y1_W1BEG[2] VPWR VGND sg13cmos5l_antennanp
XFILLER_47_163 VPWR VGND sg13cmos5l_decap_8
XFILLER_62_133 VPWR VGND sg13cmos5l_decap_8
XANTENNA__0611__Q NPU_WEIGHT_IN1 VPWR VGND sg13cmos5l_antennanp
XFILLER_116_168 VPWR VGND sg13cmos5l_decap_8
X_0616_ NPU_WEIGHT_IN6 Tile_X0Y1_UserCLK _0996_/X _0679_/L_HI VPWR VGND sg13cmos5l_dfrbpq_1
XANTENNA__0837__X Tile_X0Y1_FrameData_O[13] VPWR VGND sg13cmos5l_antennanp
XFILLER_38_152 VPWR VGND sg13cmos5l_decap_8
X_0547_ _0547_/Q Tile_X0Y1_FrameData[23] VGND VPWR Tile_X0Y1_FrameStrobe[6] latch
X_0478_ _0478_/Q Tile_X0Y1_FrameData[28] VGND VPWR Tile_X0Y1_FrameStrobe[4] latch
XFILLER_121_26 VPWR VGND sg13cmos5l_decap_8
XFILLER_121_48 VPWR VGND sg13cmos5l_decap_8
XFILLER_53_122 VPWR VGND sg13cmos5l_fill_1
XFILLER_139_227 VPWR VGND sg13cmos5l_fill_2
XFILLER_14_46 VPWR VGND sg13cmos5l_fill_1
XFILLER_14_57 VPWR VGND sg13cmos5l_decap_8
XFILLER_30_45 VPWR VGND sg13cmos5l_decap_8
XFILLER_130_171 VPWR VGND sg13cmos5l_decap_8
XFILLER_39_43 VPWR VGND sg13cmos5l_decap_8
XANTENNA__0747__X Tile_X0Y0_W6BEG[8] VPWR VGND sg13cmos5l_antennanp
XFILLER_91_228 VPWR VGND sg13cmos5l_fill_1
XFILLER_91_206 VPWR VGND sg13cmos5l_decap_4
XFILLER_111_70 VPWR VGND sg13cmos5l_fill_1
XFILLER_44_199 VPWR VGND sg13cmos5l_decap_8
XFILLER_71_74 VPWR VGND sg13cmos5l_decap_8
XFILLER_72_9 VPWR VGND sg13cmos5l_fill_1
XFILLER_113_138 VPWR VGND sg13cmos5l_decap_8
X_0401_ _0401_/Q Tile_X0Y1_FrameData[9] VGND VPWR Tile_X0Y1_FrameStrobe[1] latch
X_0332_ _0332_/Q Tile_X0Y0_FrameData[16] VGND VPWR Tile_X0Y1_FrameStrobe[7] latch
X_0263_ _0263_/Q Tile_X0Y0_FrameData[21] VGND VPWR Tile_X0Y1_FrameStrobe[5] latch
XFILLER_96_93 VPWR VGND sg13cmos5l_decap_8
XFILLER_82_228 VPWR VGND sg13cmos5l_fill_1
X_0194_ _0194_/Q Tile_X0Y0_FrameData[26] VGND VPWR Tile_X0Y1_FrameStrobe[3] latch
XFILLER_84_0 VPWR VGND sg13cmos5l_decap_4
XFILLER_104_105 VPWR VGND sg13cmos5l_decap_8
XFILLER_104_116 VPWR VGND sg13cmos5l_fill_1
XFILLER_132_14 VPWR VGND sg13cmos5l_decap_8
XFILLER_26_100 VPWR VGND sg13cmos5l_decap_8
XFILLER_25_78 VPWR VGND sg13cmos5l_decap_8
XFILLER_26_188 VPWR VGND sg13cmos5l_decap_8
XFILLER_41_169 VPWR VGND sg13cmos5l_decap_4
XFILLER_41_55 VPWR VGND sg13cmos5l_fill_1
XFILLER_41_99 VPWR VGND sg13cmos5l_decap_8
XFILLER_66_63 VPWR VGND sg13cmos5l_decap_8
XFILLER_32_103 VPWR VGND sg13cmos5l_decap_8
XFILLER_82_62 VPWR VGND sg13cmos5l_decap_8
XANTENNA__0940__X Tile_X0Y1_W2BEGb[3] VPWR VGND sg13cmos5l_antennanp
X_0881_ Tile_X0Y0_FrameData_O[25] Tile_X0Y0_FrameData[25] VPWR VGND sg13cmos5l_buf_1
X_0950_ Tile_X0Y1_W6BEG[5] _1184_/X VPWR VGND sg13cmos5l_buf_1
XFILLER_141_200 VPWR VGND sg13cmos5l_decap_8
XFILLER_99_103 VPWR VGND sg13cmos5l_decap_8
XFILLER_55_228 VPWR VGND sg13cmos5l_fill_1
X_0315_ _0315_/Q Tile_X0Y0_FrameData[1] VGND VPWR Tile_X0Y1_FrameStrobe[6] latch
X_0246_ _0246_/Q Tile_X0Y0_FrameData[6] VGND VPWR Tile_X0Y1_FrameStrobe[4] latch
XFILLER_23_103 VPWR VGND sg13cmos5l_decap_8
X_0177_ _0177_/Q Tile_X0Y0_FrameData[11] VGND VPWR Tile_X0Y1_FrameStrobe[2] latch
XANTENNA__0850__X Tile_X0Y1_FrameData_O[26] VPWR VGND sg13cmos5l_antennanp
XFILLER_11_36 VPWR VGND sg13cmos5l_decap_4
XFILLER_11_58 VPWR VGND sg13cmos5l_decap_8
XFILLER_100_174 VPWR VGND sg13cmos5l_decap_8
XFILLER_14_136 VPWR VGND sg13cmos5l_decap_8
XANTENNA__0760__X Tile_X0Y0_N4BEG[9] VPWR VGND sg13cmos5l_antennanp
XFILLER_52_87 VPWR VGND sg13cmos5l_decap_8
XFILLER_52_98 VPWR VGND sg13cmos5l_fill_2
XFILLER_123_200 VPWR VGND sg13cmos5l_decap_4
XFILLER_37_228 VPWR VGND sg13cmos5l_fill_1
X_1080_ _1080_/X _1114_/X Tile_X0Y1_N4END[7] Tile_X0Y0_S1END[3] Tile_X0Y0_S4END[3]
+ _0126_/Q _0125_/Q VPWR VGND sg13cmos5l_mux4_1
X_0100_ _0100_/Q Tile_X0Y0_FrameData[24] VGND VPWR Tile_X0Y1_FrameStrobe[0] latch
XANTENNA__0935__X Tile_X0Y1_W2BEG[6] VPWR VGND sg13cmos5l_antennanp
XFILLER_20_128 VPWR VGND sg13cmos5l_decap_4
XFILLER_13_191 VPWR VGND sg13cmos5l_decap_8
X_0864_ Tile_X0Y0_FrameData_O[8] Tile_X0Y0_FrameData[8] VPWR VGND sg13cmos5l_buf_1
X_0933_ Tile_X0Y1_W2BEG[4] _1151_/X VPWR VGND sg13cmos5l_buf_1
X_0795_ Tile_X0Y0_N2BEG[4] _1007_/X VPWR VGND sg13cmos5l_buf_1
XFILLER_9_195 VPWR VGND sg13cmos5l_decap_8
XFILLER_9_140 VPWR VGND sg13cmos5l_decap_8
XFILLER_3_70 VPWR VGND sg13cmos5l_decap_8
XFILLER_47_0 VPWR VGND sg13cmos5l_fill_2
XANTENNA__0845__X Tile_X0Y1_FrameData_O[21] VPWR VGND sg13cmos5l_antennanp
X_0229_ _0229_/Q Tile_X0Y0_FrameData[23] VGND VPWR Tile_X0Y1_FrameStrobe[4] latch
XFILLER_138_24 VPWR VGND sg13cmos5l_fill_2
XFILLER_138_57 VPWR VGND sg13cmos5l_decap_8
XFILLER_98_28 VPWR VGND sg13cmos5l_decap_8
XANTENNA__0755__X Tile_X0Y0_N4BEG[4] VPWR VGND sg13cmos5l_antennanp
XFILLER_103_71 VPWR VGND sg13cmos5l_decap_8
XFILLER_42_220 VPWR VGND sg13cmos5l_decap_8
XFILLER_63_42 VPWR VGND sg13cmos5l_decap_8
XFILLER_63_86 VPWR VGND sg13cmos5l_decap_8
XFILLER_63_97 VPWR VGND sg13cmos5l_fill_1
XFILLER_111_203 VPWR VGND sg13cmos5l_decap_8
XFILLER_111_214 VPWR VGND sg13cmos5l_fill_2
X_1201_ _1201_/X Tile_X0Y1_N2MID[6] Tile_X0Y1_N2END[6] _1225_/X Tile_X0Y0_S2MID[6]
+ _0358_/Q _0357_/Q VPWR VGND sg13cmos5l_mux4_1
X_0580_ _0580_/Q Tile_X0Y1_FrameData[22] VGND VPWR Tile_X0Y1_FrameStrobe[7] latch
XFILLER_77_183 VPWR VGND sg13cmos5l_decap_8
X_1063_ _1063_/X Tile_X0Y1_N4END[4] Tile_X0Y0_S4END[0] _1080_/X _1079_/X _0202_/Q
+ _0201_/Q VPWR VGND sg13cmos5l_mux4_1
X_1132_ _1132_/X Tile_X0Y1_E1END[1] Tile_X0Y1_E2MID[2] Tile_X0Y1_E2END[2] _1200_/X
+ _0548_/Q _0547_/Q VPWR VGND sg13cmos5l_mux4_1
XFILLER_92_164 VPWR VGND sg13cmos5l_decap_8
XANTENNA__0614__Q NPU_WEIGHT_IN4 VPWR VGND sg13cmos5l_antennanp
X_0916_ Tile_X0Y1_S4BEG[8] _0916_/A VPWR VGND sg13cmos5l_buf_1
XFILLER_108_38 VPWR VGND sg13cmos5l_decap_8
X_0847_ Tile_X0Y1_FrameData_O[23] Tile_X0Y1_FrameData[23] VPWR VGND sg13cmos5l_buf_1
X_0778_ Tile_X0Y0_WW4BEG[11] _1058_/X VPWR VGND sg13cmos5l_buf_1
XFILLER_102_225 VPWR VGND sg13cmos5l_decap_4
XFILLER_124_37 VPWR VGND sg13cmos5l_decap_4
XFILLER_83_120 VPWR VGND sg13cmos5l_fill_1
XFILLER_84_19 VPWR VGND sg13cmos5l_decap_8
XFILLER_17_68 VPWR VGND sg13cmos5l_decap_8
XFILLER_24_220 VPWR VGND sg13cmos5l_decap_8
XFILLER_83_186 VPWR VGND sg13cmos5l_decap_8
XFILLER_137_133 VPWR VGND sg13cmos5l_decap_8
XFILLER_33_56 VPWR VGND sg13cmos5l_fill_2
XFILLER_137_199 VPWR VGND sg13cmos5l_decap_8
XFILLER_3_135 VPWR VGND sg13cmos5l_decap_8
XFILLER_3_157 VPWR VGND sg13cmos5l_decap_8
XFILLER_15_220 VPWR VGND sg13cmos5l_decap_8
XFILLER_59_183 VPWR VGND sg13cmos5l_decap_8
XFILLER_74_153 VPWR VGND sg13cmos5l_decap_8
XFILLER_130_80 VPWR VGND sg13cmos5l_decap_8
XFILLER_88_7 VPWR VGND sg13cmos5l_fill_2
XFILLER_128_166 VPWR VGND sg13cmos5l_decap_8
X_0701_ _1102_/A3 VPWR VGND sg13cmos5l_tielo
X_0632_ NPU_ACT_ADDR6 Tile_X0Y1_UserCLK _0979_/X _0689_/L_HI VPWR VGND sg13cmos5l_dfrbpq_1
X_0563_ _0563_/Q Tile_X0Y1_FrameData[7] VGND VPWR Tile_X0Y1_FrameStrobe[6] latch
XFILLER_99_82 VPWR VGND sg13cmos5l_decap_8
X_0494_ _0494_/Q Tile_X0Y1_FrameData[12] VGND VPWR Tile_X0Y1_FrameStrobe[4] latch
XFILLER_21_212 VPWR VGND sg13cmos5l_decap_8
XFILLER_80_101 VPWR VGND sg13cmos5l_decap_8
X_1046_ _1046_/X Tile_X0Y0_EE4END[14] _0643_/Q _1092_/X _1099_/X _0236_/Q _0235_/Q
+ VPWR VGND sg13cmos5l_mux4_1
X_1115_ _1115_/X Tile_X0Y1_E1END[3] Tile_X0Y1_EE4END[3] Tile_X0Y1_E6END[11] _1206_/X
+ _0569_/Q _0568_/Q VPWR VGND sg13cmos5l_mux4_1
XFILLER_119_155 VPWR VGND sg13cmos5l_decap_8
XFILLER_119_177 VPWR VGND sg13cmos5l_decap_8
XFILLER_134_147 VPWR VGND sg13cmos5l_decap_8
XFILLER_135_14 VPWR VGND sg13cmos5l_decap_8
XFILLER_28_12 VPWR VGND sg13cmos5l_fill_1
XFILLER_71_123 VPWR VGND sg13cmos5l_decap_8
XFILLER_12_201 VPWR VGND sg13cmos5l_decap_8
XFILLER_44_55 VPWR VGND sg13cmos5l_decap_4
XFILLER_60_21 VPWR VGND sg13cmos5l_decap_8
XFILLER_8_227 VPWR VGND sg13cmos5l_fill_2
XFILLER_114_0 VPWR VGND sg13cmos5l_decap_4
XFILLER_125_169 VPWR VGND sg13cmos5l_decap_8
XFILLER_5_49 VPWR VGND sg13cmos5l_decap_4
XFILLER_140_117 VPWR VGND sg13cmos5l_decap_8
XFILLER_140_128 VPWR VGND sg13cmos5l_fill_2
XFILLER_79_212 VPWR VGND sg13cmos5l_decap_4
XANTENNA__0943__X Tile_X0Y1_W2BEGb[6] VPWR VGND sg13cmos5l_antennanp
XFILLER_47_142 VPWR VGND sg13cmos5l_decap_8
XFILLER_131_139 VPWR VGND sg13cmos5l_decap_8
X_0615_ NPU_WEIGHT_IN5 Tile_X0Y1_UserCLK _0995_/X _0656_/L_HI VPWR VGND sg13cmos5l_dfrbpq_1
X_0546_ _0546_/Q Tile_X0Y1_FrameData[24] VGND VPWR Tile_X0Y1_FrameStrobe[6] latch
XFILLER_38_186 VPWR VGND sg13cmos5l_decap_8
XFILLER_85_215 VPWR VGND sg13cmos5l_decap_8
X_0477_ _0477_/Q Tile_X0Y1_FrameData[29] VGND VPWR Tile_X0Y1_FrameStrobe[4] latch
XANTENNA__0853__X Tile_X0Y1_FrameData_O[29] VPWR VGND sg13cmos5l_antennanp
X_1029_ _1029_/X _1113_/X Tile_X0Y0_S1END[2] _0636_/Q _0641_/Q _0270_/Q _0269_/Q VPWR
+ VGND sg13cmos5l_mux4_1
XFILLER_122_139 VPWR VGND sg13cmos5l_decap_8
XFILLER_130_150 VPWR VGND sg13cmos5l_decap_8
XFILLER_39_55 VPWR VGND sg13cmos5l_decap_4
XANTENNA__0763__X Tile_X0Y0_N4BEG[12] VPWR VGND sg13cmos5l_antennanp
XFILLER_29_186 VPWR VGND sg13cmos5l_fill_1
XFILLER_106_180 VPWR VGND sg13cmos5l_decap_8
XFILLER_113_117 VPWR VGND sg13cmos5l_decap_8
X_0400_ _0400_/Q Tile_X0Y1_FrameData[10] VGND VPWR Tile_X0Y1_FrameStrobe[1] latch
XANTENNA__0938__X Tile_X0Y1_W2BEGb[1] VPWR VGND sg13cmos5l_antennanp
X_0331_ _0331_/Q Tile_X0Y0_FrameData[17] VGND VPWR Tile_X0Y1_FrameStrobe[7] latch
X_0262_ _0262_/Q Tile_X0Y0_FrameData[22] VGND VPWR Tile_X0Y1_FrameStrobe[5] latch
X_0193_ _0193_/Q Tile_X0Y0_FrameData[27] VGND VPWR Tile_X0Y1_FrameStrobe[3] latch
XFILLER_96_72 VPWR VGND sg13cmos5l_decap_8
XFILLER_96_50 VPWR VGND sg13cmos5l_decap_8
XANTENNA__0622__Q NPU_ACT_WDATA4 VPWR VGND sg13cmos5l_antennanp
XFILLER_77_0 VPWR VGND sg13cmos5l_decap_4
XANTENNA__0848__X Tile_X0Y1_FrameData_O[24] VPWR VGND sg13cmos5l_antennanp
XFILLER_112_183 VPWR VGND sg13cmos5l_fill_2
XFILLER_58_215 VPWR VGND sg13cmos5l_fill_2
XFILLER_6_81 VPWR VGND sg13cmos5l_decap_8
X_0529_ _0529_/Q Tile_X0Y1_FrameData[9] VGND VPWR Tile_X0Y1_FrameStrobe[5] latch
XFILLER_25_35 VPWR VGND sg13cmos5l_decap_8
XFILLER_25_57 VPWR VGND sg13cmos5l_decap_8
XFILLER_41_12 VPWR VGND sg13cmos5l_decap_4
XFILLER_41_148 VPWR VGND sg13cmos5l_decap_8
XFILLER_135_220 VPWR VGND sg13cmos5l_decap_8
XFILLER_1_200 VPWR VGND sg13cmos5l_decap_4
XFILLER_41_67 VPWR VGND sg13cmos5l_decap_8
XANTENNA__0758__X Tile_X0Y0_N4BEG[7] VPWR VGND sg13cmos5l_antennanp
XFILLER_49_204 VPWR VGND sg13cmos5l_fill_2
XFILLER_66_42 VPWR VGND sg13cmos5l_decap_8
XFILLER_40_192 VPWR VGND sg13cmos5l_decap_8
X_0880_ Tile_X0Y0_FrameData_O[24] Tile_X0Y0_FrameData[24] VPWR VGND sg13cmos5l_buf_1
XFILLER_49_4 VPWR VGND sg13cmos5l_fill_2
XFILLER_99_126 VPWR VGND sg13cmos5l_fill_1
XANTENNA__0617__Q NPU_WEIGHT_IN7 VPWR VGND sg13cmos5l_antennanp
X_0314_ _0314_/Q Tile_X0Y0_FrameData[2] VGND VPWR Tile_X0Y1_FrameStrobe[6] latch
X_0245_ _0245_/Q Tile_X0Y0_FrameData[7] VGND VPWR Tile_X0Y1_FrameStrobe[4] latch
X_0176_ _0176_/Q Tile_X0Y0_FrameData[12] VGND VPWR Tile_X0Y1_FrameStrobe[2] latch
XFILLER_23_159 VPWR VGND sg13cmos5l_fill_1
XFILLER_117_220 VPWR VGND sg13cmos5l_decap_8
XFILLER_36_12 VPWR VGND sg13cmos5l_fill_2
XFILLER_36_56 VPWR VGND sg13cmos5l_fill_2
XFILLER_117_92 VPWR VGND sg13cmos5l_fill_2
XFILLER_77_63 VPWR VGND sg13cmos5l_fill_1
XFILLER_7_0 VPWR VGND sg13cmos5l_decap_4
XFILLER_96_107 VPWR VGND sg13cmos5l_decap_8
XFILLER_89_170 VPWR VGND sg13cmos5l_decap_4
XFILLER_133_91 VPWR VGND sg13cmos5l_decap_8
XFILLER_93_84 VPWR VGND sg13cmos5l_decap_8
XANTENNA__0951__X Tile_X0Y1_W6BEG[6] VPWR VGND sg13cmos5l_antennanp
XFILLER_13_170 VPWR VGND sg13cmos5l_decap_8
X_0932_ Tile_X0Y1_W2BEG[3] _1150_/X VPWR VGND sg13cmos5l_buf_1
XFILLER_114_212 VPWR VGND sg13cmos5l_decap_8
X_0863_ Tile_X0Y0_FrameData_O[7] Tile_X0Y0_FrameData[7] VPWR VGND sg13cmos5l_buf_1
X_0794_ Tile_X0Y0_N2BEG[3] _1006_/X VPWR VGND sg13cmos5l_buf_1
X_0228_ _0228_/Q Tile_X0Y0_FrameData[24] VGND VPWR Tile_X0Y1_FrameStrobe[4] latch
X_0159_ _0159_/Q Tile_X0Y0_FrameData[29] VGND VPWR Tile_X0Y1_FrameStrobe[2] latch
XANTENNA__0861__X Tile_X0Y0_FrameData_O[5] VPWR VGND sg13cmos5l_antennanp
XFILLER_138_14 VPWR VGND sg13cmos5l_decap_4
XFILLER_0_7 VPWR VGND sg13cmos5l_decap_8
XFILLER_78_118 VPWR VGND sg13cmos5l_decap_4
XFILLER_103_50 VPWR VGND sg13cmos5l_decap_8
XFILLER_47_77 VPWR VGND sg13cmos5l_decap_8
XFILLER_47_88 VPWR VGND sg13cmos5l_fill_2
XANTENNA__0771__X Tile_X0Y0_WW4BEG[4] VPWR VGND sg13cmos5l_antennanp
XFILLER_63_21 VPWR VGND sg13cmos5l_decap_8
XFILLER_8_38 VPWR VGND sg13cmos5l_fill_2
XFILLER_10_195 VPWR VGND sg13cmos5l_decap_8
XFILLER_6_144 VPWR VGND sg13cmos5l_decap_8
XFILLER_6_166 VPWR VGND sg13cmos5l_decap_4
XFILLER_6_188 VPWR VGND sg13cmos5l_decap_8
XFILLER_69_129 VPWR VGND sg13cmos5l_decap_8
XFILLER_77_162 VPWR VGND sg13cmos5l_decap_8
X_1200_ _1200_/X Tile_X0Y1_N2MID[5] Tile_X0Y1_N2END[5] _1224_/X Tile_X0Y0_S2MID[5]
+ _0360_/Q _0359_/Q VPWR VGND sg13cmos5l_mux4_1
XFILLER_88_84 VPWR VGND sg13cmos5l_decap_8
XANTENNA__0946__X Tile_X0Y1_W6BEG[1] VPWR VGND sg13cmos5l_antennanp
X_1062_ _1062_/X _0639_/Q _0643_/Q _1088_/X _1092_/X _0204_/Q _0203_/Q VPWR VGND sg13cmos5l_mux4_1
X_1131_ _1131_/X Tile_X0Y1_E1END[0] Tile_X0Y1_E2MID[3] Tile_X0Y1_E2END[3] _1199_/X
+ _0550_/Q _0549_/Q VPWR VGND sg13cmos5l_mux4_1
XFILLER_92_143 VPWR VGND sg13cmos5l_decap_8
XFILLER_92_121 VPWR VGND sg13cmos5l_fill_1
X_0915_ Tile_X0Y1_S4BEG[7] Tile_X0Y0_S4END[15] VPWR VGND sg13cmos5l_buf_1
XANTENNA__0630__Q NPU_ACT_ADDR4 VPWR VGND sg13cmos5l_antennanp
XFILLER_102_204 VPWR VGND sg13cmos5l_decap_8
X_0846_ Tile_X0Y1_FrameData_O[22] Tile_X0Y1_FrameData[22] VPWR VGND sg13cmos5l_buf_1
X_0777_ Tile_X0Y0_WW4BEG[10] _1057_/X VPWR VGND sg13cmos5l_buf_1
XANTENNA__0856__X Tile_X0Y0_FrameData_O[0] VPWR VGND sg13cmos5l_antennanp
XFILLER_124_49 VPWR VGND sg13cmos5l_fill_2
XFILLER_68_173 VPWR VGND sg13cmos5l_fill_2
XFILLER_83_165 VPWR VGND sg13cmos5l_decap_8
XFILLER_33_35 VPWR VGND sg13cmos5l_decap_8
XFILLER_137_112 VPWR VGND sg13cmos5l_decap_8
XFILLER_137_178 VPWR VGND sg13cmos5l_decap_8
XFILLER_58_32 VPWR VGND sg13cmos5l_fill_1
XFILLER_58_65 VPWR VGND sg13cmos5l_fill_1
XFILLER_59_140 VPWR VGND sg13cmos5l_decap_8
XFILLER_59_151 VPWR VGND sg13cmos5l_fill_1
XANTENNA__0766__X Tile_X0Y0_N4BEG[15] VPWR VGND sg13cmos5l_antennanp
XFILLER_114_71 VPWR VGND sg13cmos5l_decap_8
XFILLER_15_210 VPWR VGND sg13cmos5l_decap_4
XFILLER_74_110 VPWR VGND sg13cmos5l_fill_1
XFILLER_74_132 VPWR VGND sg13cmos5l_decap_8
XFILLER_128_145 VPWR VGND sg13cmos5l_decap_8
X_0700_ _1101_/A3 VPWR VGND sg13cmos5l_tielo
XFILLER_90_41 VPWR VGND sg13cmos5l_decap_8
X_0631_ NPU_ACT_ADDR5 Tile_X0Y1_UserCLK _0978_/X _0686_/L_HI VPWR VGND sg13cmos5l_dfrbpq_1
X_0562_ _0562_/Q Tile_X0Y1_FrameData[8] VGND VPWR Tile_X0Y1_FrameStrobe[6] latch
X_1114_ _1114_/X Tile_X0Y1_E1END[3] Tile_X0Y1_E6END[7] _1218_/X _1194_/X _0596_/Q
+ _0595_/Q VPWR VGND sg13cmos5l_mux4_1
X_0493_ _0493_/Q Tile_X0Y1_FrameData[13] VGND VPWR Tile_X0Y1_FrameStrobe[4] latch
XANTENNA__0625__Q NPU_ACT_WDATA7 VPWR VGND sg13cmos5l_antennanp
XFILLER_0_83 VPWR VGND sg13cmos5l_decap_8
X_1045_ _1045_/X Tile_X0Y0_EE4END[13] _0642_/Q _1093_/X _1098_/X _0238_/Q _0237_/Q
+ VPWR VGND sg13cmos5l_mux4_1
XFILLER_134_126 VPWR VGND sg13cmos5l_decap_8
X_0829_ Tile_X0Y1_FrameData_O[5] Tile_X0Y1_FrameData[5] VPWR VGND sg13cmos5l_buf_1
XFILLER_0_139 VPWR VGND sg13cmos5l_decap_8
XFILLER_28_35 VPWR VGND sg13cmos5l_fill_2
XFILLER_28_79 VPWR VGND sg13cmos5l_decap_8
XFILLER_71_102 VPWR VGND sg13cmos5l_decap_8
XFILLER_100_40 VPWR VGND sg13cmos5l_decap_8
XFILLER_100_73 VPWR VGND sg13cmos5l_decap_4
XFILLER_100_84 VPWR VGND sg13cmos5l_decap_8
XFILLER_107_0 VPWR VGND sg13cmos5l_decap_4
XFILLER_109_93 VPWR VGND sg13cmos5l_decap_8
XFILLER_125_148 VPWR VGND sg13cmos5l_decap_8
XFILLER_5_28 VPWR VGND sg13cmos5l_decap_8
XFILLER_125_70 VPWR VGND sg13cmos5l_fill_1
XFILLER_133_181 VPWR VGND sg13cmos5l_decap_8
XFILLER_47_121 VPWR VGND sg13cmos5l_decap_8
XFILLER_47_198 VPWR VGND sg13cmos5l_decap_8
XFILLER_62_168 VPWR VGND sg13cmos5l_decap_8
XFILLER_79_4 VPWR VGND sg13cmos5l_fill_1
XFILLER_131_118 VPWR VGND sg13cmos5l_decap_8
XFILLER_22_0 VPWR VGND sg13cmos5l_decap_4
X_0614_ NPU_WEIGHT_IN4 Tile_X0Y1_UserCLK _0994_/X _0653_/L_HI VPWR VGND sg13cmos5l_dfrbpq_1
X_0545_ _0545_/Q Tile_X0Y1_FrameData[25] VGND VPWR Tile_X0Y1_FrameStrobe[6] latch
X_0476_ _0476_/Q Tile_X0Y1_FrameData[30] VGND VPWR Tile_X0Y1_FrameStrobe[4] latch
XFILLER_53_168 VPWR VGND sg13cmos5l_decap_8
X_1028_ _1028_/X _1112_/X Tile_X0Y0_S1END[1] _0639_/Q _0642_/Q _0272_/Q _0271_/Q VPWR
+ VGND sg13cmos5l_mux4_1
XANTENNA__0090__Q NPU_XBAR_SEL0 VPWR VGND sg13cmos5l_antennanp
XFILLER_107_126 VPWR VGND sg13cmos5l_fill_1
XFILLER_107_148 VPWR VGND sg13cmos5l_decap_4
XFILLER_115_192 VPWR VGND sg13cmos5l_decap_8
XFILLER_76_216 VPWR VGND sg13cmos5l_decap_8
XFILLER_76_227 VPWR VGND sg13cmos5l_fill_2
XFILLER_29_198 VPWR VGND sg13cmos5l_decap_8
XFILLER_71_43 VPWR VGND sg13cmos5l_decap_8
XFILLER_136_91 VPWR VGND sg13cmos5l_decap_8
X_0330_ _0330_/Q Tile_X0Y0_FrameData[18] VGND VPWR Tile_X0Y1_FrameStrobe[7] latch
XANTENNA__0954__X Tile_X0Y1_W6BEG[9] VPWR VGND sg13cmos5l_antennanp
XFILLER_121_184 VPWR VGND sg13cmos5l_decap_8
XFILLER_67_227 VPWR VGND sg13cmos5l_fill_2
XFILLER_82_219 VPWR VGND sg13cmos5l_decap_8
X_0261_ _0261_/Q Tile_X0Y0_FrameData[23] VGND VPWR Tile_X0Y1_FrameStrobe[5] latch
X_0192_ _0192_/Q Tile_X0Y0_FrameData[28] VGND VPWR Tile_X0Y1_FrameStrobe[3] latch
XFILLER_58_227 VPWR VGND sg13cmos5l_fill_2
X_0528_ _0528_/Q Tile_X0Y1_FrameData[10] VGND VPWR Tile_X0Y1_FrameStrobe[5] latch
X_0459_ _0459_/Q Tile_X0Y1_FrameData[15] VGND VPWR Tile_X0Y1_FrameStrobe[3] latch
XANTENNA__0864__X Tile_X0Y0_FrameData_O[8] VPWR VGND sg13cmos5l_antennanp
XFILLER_132_49 VPWR VGND sg13cmos5l_decap_8
XFILLER_26_146 VPWR VGND sg13cmos5l_decap_4
XFILLER_41_138 VPWR VGND sg13cmos5l_fill_2
XFILLER_41_46 VPWR VGND sg13cmos5l_decap_8
XFILLER_103_151 VPWR VGND sg13cmos5l_fill_2
XANTENNA__0774__X Tile_X0Y0_WW4BEG[7] VPWR VGND sg13cmos5l_antennanp
XFILLER_103_195 VPWR VGND sg13cmos5l_decap_4
XFILLER_106_83 VPWR VGND sg13cmos5l_decap_8
XFILLER_17_135 VPWR VGND sg13cmos5l_fill_1
XFILLER_49_216 VPWR VGND sg13cmos5l_fill_1
XFILLER_49_227 VPWR VGND sg13cmos5l_fill_2
XFILLER_66_21 VPWR VGND sg13cmos5l_decap_8
XFILLER_66_98 VPWR VGND sg13cmos5l_decap_8
XFILLER_122_82 VPWR VGND sg13cmos5l_decap_4
XFILLER_17_179 VPWR VGND sg13cmos5l_decap_4
XFILLER_40_171 VPWR VGND sg13cmos5l_decap_8
XFILLER_82_42 VPWR VGND sg13cmos5l_decap_8
XFILLER_63_7 VPWR VGND sg13cmos5l_decap_8
XANTENNA__0949__X Tile_X0Y1_W6BEG[4] VPWR VGND sg13cmos5l_antennanp
X_0313_ _0313_/Q Tile_X0Y0_FrameData[3] VGND VPWR Tile_X0Y1_FrameStrobe[6] latch
XFILLER_99_138 VPWR VGND sg13cmos5l_fill_2
XFILLER_23_138 VPWR VGND sg13cmos5l_fill_1
X_0244_ _0244_/Q Tile_X0Y0_FrameData[8] VGND VPWR Tile_X0Y1_FrameStrobe[4] latch
X_0175_ _0175_/Q Tile_X0Y0_FrameData[13] VGND VPWR Tile_X0Y1_FrameStrobe[2] latch
XANTENNA__0633__Q NPU_ACT_ADDR7 VPWR VGND sg13cmos5l_antennanp
XANTENNA__0859__X Tile_X0Y0_FrameData_O[3] VPWR VGND sg13cmos5l_antennanp
XFILLER_132_224 VPWR VGND sg13cmos5l_decap_4
XFILLER_100_154 VPWR VGND sg13cmos5l_decap_8
XFILLER_100_165 VPWR VGND sg13cmos5l_fill_2
XFILLER_100_198 VPWR VGND sg13cmos5l_decap_8
XFILLER_36_35 VPWR VGND sg13cmos5l_decap_8
XFILLER_36_79 VPWR VGND sg13cmos5l_decap_4
XFILLER_52_34 VPWR VGND sg13cmos5l_decap_4
XANTENNA__0769__X Tile_X0Y0_WW4BEG[2] VPWR VGND sg13cmos5l_antennanp
XFILLER_133_70 VPWR VGND sg13cmos5l_decap_8
X_0862_ Tile_X0Y0_FrameData_O[6] Tile_X0Y0_FrameData[6] VPWR VGND sg13cmos5l_buf_1
X_0931_ Tile_X0Y1_W2BEG[2] _1149_/X VPWR VGND sg13cmos5l_buf_1
XFILLER_9_175 VPWR VGND sg13cmos5l_decap_8
XFILLER_47_2 VPWR VGND sg13cmos5l_fill_1
X_0793_ Tile_X0Y0_N2BEG[2] _1005_/X VPWR VGND sg13cmos5l_buf_1
XANTENNA__0628__Q NPU_ACT_ADDR2 VPWR VGND sg13cmos5l_antennanp
XFILLER_95_152 VPWR VGND sg13cmos5l_decap_8
XFILLER_11_119 VPWR VGND sg13cmos5l_decap_8
X_0227_ _0227_/Q Tile_X0Y0_FrameData[25] VGND VPWR Tile_X0Y1_FrameStrobe[4] latch
X_0158_ _0158_/Q Tile_X0Y0_FrameData[30] VGND VPWR Tile_X0Y1_FrameStrobe[2] latch
X_0089_ NPU_ACT_WE Tile_X0Y1_UserCLK _0089_/D _0697_/L_HI VPWR VGND sg13cmos5l_dfrbpq_1
XFILLER_22_59 VPWR VGND sg13cmos5l_decap_4
XFILLER_98_19 VPWR VGND sg13cmos5l_fill_2
XFILLER_120_216 VPWR VGND sg13cmos5l_decap_8
XFILLER_120_227 VPWR VGND sg13cmos5l_fill_2
XFILLER_137_0 VPWR VGND sg13cmos5l_decap_8
XFILLER_10_174 VPWR VGND sg13cmos5l_decap_8
XFILLER_12_70 VPWR VGND sg13cmos5l_fill_1
XFILLER_69_108 VPWR VGND sg13cmos5l_decap_8
XFILLER_6_123 VPWR VGND sg13cmos5l_decap_8
XFILLER_111_216 VPWR VGND sg13cmos5l_fill_1
XFILLER_111_227 VPWR VGND sg13cmos5l_fill_2
XFILLER_77_141 VPWR VGND sg13cmos5l_decap_8
X_1130_ _1130_/X Tile_X0Y1_E2MID[4] Tile_X0Y1_E2END[4] Tile_X0Y1_E6END[11] _1198_/X
+ _0552_/Q _0551_/Q VPWR VGND sg13cmos5l_mux4_1
XANTENNA__0962__X Tile_X0Y1_WW4BEG[5] VPWR VGND sg13cmos5l_antennanp
X_1061_ _1061_/X _0638_/Q _0642_/Q _1089_/X _1093_/X _0206_/Q _0205_/Q VPWR VGND sg13cmos5l_mux4_1
XFILLER_92_199 VPWR VGND sg13cmos5l_decap_8
X_0914_ Tile_X0Y1_S4BEG[6] Tile_X0Y0_S4END[14] VPWR VGND sg13cmos5l_buf_1
X_0845_ Tile_X0Y1_FrameData_O[21] Tile_X0Y1_FrameData[21] VPWR VGND sg13cmos5l_buf_1
XFILLER_108_18 VPWR VGND sg13cmos5l_fill_2
XFILLER_52_0 VPWR VGND sg13cmos5l_decap_4
X_0776_ Tile_X0Y0_WW4BEG[9] _1056_/X VPWR VGND sg13cmos5l_buf_1
XFILLER_24_211 VPWR VGND sg13cmos5l_decap_4
XFILLER_68_152 VPWR VGND sg13cmos5l_decap_8
XANTENNA__0093__Q NPU_XBAR_SEL3 VPWR VGND sg13cmos5l_antennanp
XANTENNA__0872__X Tile_X0Y0_FrameData_O[16] VPWR VGND sg13cmos5l_antennanp
XFILLER_130_7 VPWR VGND sg13cmos5l_decap_8
XFILLER_137_157 VPWR VGND sg13cmos5l_decap_8
XANTENNA__0782__X Tile_X0Y0_WW4BEG[15] VPWR VGND sg13cmos5l_antennanp
XFILLER_30_203 VPWR VGND sg13cmos5l_decap_8
XFILLER_74_188 VPWR VGND sg13cmos5l_decap_8
XFILLER_90_20 VPWR VGND sg13cmos5l_decap_8
XFILLER_128_124 VPWR VGND sg13cmos5l_decap_8
XFILLER_139_91 VPWR VGND sg13cmos5l_decap_8
XFILLER_90_97 VPWR VGND sg13cmos5l_decap_8
X_0630_ NPU_ACT_ADDR4 Tile_X0Y1_UserCLK _0977_/X _0687_/L_HI VPWR VGND sg13cmos5l_dfrbpq_1
X_0561_ _0561_/Q Tile_X0Y1_FrameData[9] VGND VPWR Tile_X0Y1_FrameStrobe[6] latch
X_0492_ _0492_/Q Tile_X0Y1_FrameData[14] VGND VPWR Tile_X0Y1_FrameStrobe[4] latch
XFILLER_99_62 VPWR VGND sg13cmos5l_fill_2
XFILLER_97_214 VPWR VGND sg13cmos5l_fill_2
XANTENNA__0957__X Tile_X0Y1_WW4BEG[0] VPWR VGND sg13cmos5l_antennanp
X_1044_ _1044_/X Tile_X0Y0_EE4END[12] _0641_/Q _1094_/X _1097_/X _0240_/Q _0239_/Q
+ VPWR VGND sg13cmos5l_mux4_1
X_1113_ _1113_/X Tile_X0Y1_E1END[2] Tile_X0Y1_E6END[6] _1217_/X _1193_/X _0598_/Q
+ _0597_/Q VPWR VGND sg13cmos5l_mux4_1
XFILLER_110_19 VPWR VGND sg13cmos5l_decap_8
XFILLER_80_136 VPWR VGND sg13cmos5l_decap_8
XFILLER_80_169 VPWR VGND sg13cmos5l_decap_8
XFILLER_134_105 VPWR VGND sg13cmos5l_decap_8
X_0828_ Tile_X0Y1_FrameData_O[4] Tile_X0Y1_FrameData[4] VPWR VGND sg13cmos5l_buf_1
X_0759_ Tile_X0Y0_N4BEG[8] _0759_/A VPWR VGND sg13cmos5l_buf_1
XANTENNA__0867__X Tile_X0Y0_FrameData_O[11] VPWR VGND sg13cmos5l_antennanp
XFILLER_0_118 VPWR VGND sg13cmos5l_decap_8
XFILLER_135_49 VPWR VGND sg13cmos5l_decap_8
XFILLER_56_111 VPWR VGND sg13cmos5l_decap_4
XFILLER_88_203 VPWR VGND sg13cmos5l_decap_8
XFILLER_28_58 VPWR VGND sg13cmos5l_decap_8
XFILLER_56_144 VPWR VGND sg13cmos5l_decap_4
XFILLER_71_158 VPWR VGND sg13cmos5l_decap_8
XFILLER_100_52 VPWR VGND sg13cmos5l_decap_8
XFILLER_12_214 VPWR VGND sg13cmos5l_fill_2
XFILLER_109_72 VPWR VGND sg13cmos5l_decap_8
XFILLER_125_127 VPWR VGND sg13cmos5l_decap_8
XFILLER_69_21 VPWR VGND sg13cmos5l_decap_8
XFILLER_79_203 VPWR VGND sg13cmos5l_decap_4
XANTENNA__0777__X Tile_X0Y0_WW4BEG[10] VPWR VGND sg13cmos5l_antennanp
XFILLER_47_177 VPWR VGND sg13cmos5l_decap_8
XFILLER_85_42 VPWR VGND sg13cmos5l_decap_8
XFILLER_94_228 VPWR VGND sg13cmos5l_fill_1
XFILLER_141_81 VPWR VGND sg13cmos5l_decap_8
XFILLER_62_147 VPWR VGND sg13cmos5l_decap_8
XFILLER_93_7 VPWR VGND sg13cmos5l_decap_8
XFILLER_116_105 VPWR VGND sg13cmos5l_fill_1
XFILLER_116_127 VPWR VGND sg13cmos5l_decap_4
X_0613_ NPU_WEIGHT_IN3 Tile_X0Y1_UserCLK _0993_/X _0694_/L_HI VPWR VGND sg13cmos5l_dfrbpq_1
XFILLER_124_182 VPWR VGND sg13cmos5l_decap_8
X_0544_ _0544_/Q Tile_X0Y1_FrameData[26] VGND VPWR Tile_X0Y1_FrameStrobe[6] latch
X_0475_ _0475_/Q Tile_X0Y1_FrameData[31] VGND VPWR Tile_X0Y1_FrameStrobe[4] latch
XFILLER_15_0 VPWR VGND sg13cmos5l_decap_4
XFILLER_38_166 VPWR VGND sg13cmos5l_fill_2
XFILLER_53_147 VPWR VGND sg13cmos5l_decap_8
X_1027_ _1027_/X _1111_/X Tile_X0Y0_S1END[0] _0638_/Q _0643_/Q _0274_/Q _0273_/Q VPWR
+ VGND sg13cmos5l_mux4_1
XFILLER_139_208 VPWR VGND sg13cmos5l_fill_2
XFILLER_14_27 VPWR VGND sg13cmos5l_fill_2
XFILLER_61_180 VPWR VGND sg13cmos5l_decap_8
XFILLER_39_24 VPWR VGND sg13cmos5l_decap_8
XFILLER_130_185 VPWR VGND sg13cmos5l_decap_8
XFILLER_29_133 VPWR VGND sg13cmos5l_decap_8
XFILLER_39_68 VPWR VGND sg13cmos5l_decap_8
XFILLER_55_34 VPWR VGND sg13cmos5l_decap_8
XFILLER_111_62 VPWR VGND sg13cmos5l_fill_1
XFILLER_4_221 VPWR VGND sg13cmos5l_decap_8
XFILLER_71_88 VPWR VGND sg13cmos5l_decap_8
XFILLER_121_130 VPWR VGND sg13cmos5l_fill_1
XFILLER_121_141 VPWR VGND sg13cmos5l_fill_1
XFILLER_121_163 VPWR VGND sg13cmos5l_decap_8
XFILLER_136_70 VPWR VGND sg13cmos5l_decap_8
X_0260_ _0260_/Q Tile_X0Y0_FrameData[24] VGND VPWR Tile_X0Y1_FrameStrobe[5] latch
X_0191_ _0191_/Q Tile_X0Y0_FrameData[29] VGND VPWR Tile_X0Y1_FrameStrobe[3] latch
XFILLER_90_220 VPWR VGND sg13cmos5l_decap_8
XANTENNA__0970__X Tile_X0Y1_WW4BEG[13] VPWR VGND sg13cmos5l_antennanp
XFILLER_112_130 VPWR VGND sg13cmos5l_decap_8
XFILLER_132_28 VPWR VGND sg13cmos5l_decap_8
XFILLER_73_209 VPWR VGND sg13cmos5l_decap_8
X_0527_ _0527_/Q Tile_X0Y1_FrameData[11] VGND VPWR Tile_X0Y1_FrameStrobe[5] latch
X_0458_ _0458_/Q Tile_X0Y1_FrameData[16] VGND VPWR Tile_X0Y1_FrameStrobe[3] latch
X_0389_ _0389_/Q Tile_X0Y1_FrameData[21] VGND VPWR Tile_X0Y1_FrameStrobe[1] latch
XFILLER_26_114 VPWR VGND sg13cmos5l_decap_8
XFILLER_41_106 VPWR VGND sg13cmos5l_decap_8
XFILLER_41_117 VPWR VGND sg13cmos5l_decap_8
XFILLER_81_220 VPWR VGND sg13cmos5l_decap_8
XANTENNA__0880__X Tile_X0Y0_FrameData_O[24] VPWR VGND sg13cmos5l_antennanp
XFILLER_41_25 VPWR VGND sg13cmos5l_decap_8
XFILLER_106_62 VPWR VGND sg13cmos5l_decap_8
XFILLER_122_50 VPWR VGND sg13cmos5l_decap_4
XFILLER_17_103 VPWR VGND sg13cmos5l_decap_8
XFILLER_66_77 VPWR VGND sg13cmos5l_decap_8
XFILLER_82_21 VPWR VGND sg13cmos5l_decap_8
XANTENNA__0790__X Tile_X0Y0_N2BEGb[7] VPWR VGND sg13cmos5l_antennanp
XFILLER_25_180 VPWR VGND sg13cmos5l_decap_8
XFILLER_32_117 VPWR VGND sg13cmos5l_fill_1
XFILLER_40_150 VPWR VGND sg13cmos5l_decap_8
XFILLER_126_222 VPWR VGND sg13cmos5l_decap_8
XFILLER_56_7 VPWR VGND sg13cmos5l_decap_8
XFILLER_99_117 VPWR VGND sg13cmos5l_decap_4
XANTENNA__0965__X Tile_X0Y1_WW4BEG[8] VPWR VGND sg13cmos5l_antennanp
X_0312_ _0312_/Q Tile_X0Y0_FrameData[4] VGND VPWR Tile_X0Y1_FrameStrobe[6] latch
X_0243_ _0243_/Q Tile_X0Y0_FrameData[9] VGND VPWR Tile_X0Y1_FrameStrobe[4] latch
XFILLER_23_117 VPWR VGND sg13cmos5l_decap_8
X_0174_ _0174_/Q Tile_X0Y0_FrameData[14] VGND VPWR Tile_X0Y1_FrameStrobe[2] latch
XFILLER_31_183 VPWR VGND sg13cmos5l_decap_8
XFILLER_82_0 VPWR VGND sg13cmos5l_decap_8
XFILLER_132_203 VPWR VGND sg13cmos5l_decap_8
XFILLER_98_161 VPWR VGND sg13cmos5l_fill_1
XANTENNA__0875__X Tile_X0Y0_FrameData_O[19] VPWR VGND sg13cmos5l_antennanp
XFILLER_100_188 VPWR VGND sg13cmos5l_fill_2
XFILLER_14_117 VPWR VGND sg13cmos5l_fill_2
XFILLER_22_150 VPWR VGND sg13cmos5l_decap_8
XFILLER_22_194 VPWR VGND sg13cmos5l_decap_8
XFILLER_123_214 VPWR VGND sg13cmos5l_fill_2
XANTENNA__0785__X Tile_X0Y0_N2BEGb[2] VPWR VGND sg13cmos5l_antennanp
XFILLER_117_94 VPWR VGND sg13cmos5l_fill_1
XFILLER_45_220 VPWR VGND sg13cmos5l_decap_8
XFILLER_60_212 VPWR VGND sg13cmos5l_decap_8
XFILLER_93_42 VPWR VGND sg13cmos5l_decap_8
X_0861_ Tile_X0Y0_FrameData_O[5] Tile_X0Y0_FrameData[5] VPWR VGND sg13cmos5l_buf_1
X_0930_ Tile_X0Y1_W2BEG[1] _1148_/X VPWR VGND sg13cmos5l_buf_1
X_0792_ Tile_X0Y0_N2BEG[1] _1004_/X VPWR VGND sg13cmos5l_buf_1
XFILLER_9_154 VPWR VGND sg13cmos5l_decap_8
XFILLER_113_19 VPWR VGND sg13cmos5l_decap_8
XFILLER_3_84 VPWR VGND sg13cmos5l_decap_8
X_0226_ _0226_/Q Tile_X0Y0_FrameData[26] VGND VPWR Tile_X0Y1_FrameStrobe[4] latch
XFILLER_11_109 VPWR VGND sg13cmos5l_fill_2
XFILLER_51_212 VPWR VGND sg13cmos5l_fill_2
XFILLER_51_223 VPWR VGND sg13cmos5l_decap_4
X_0157_ _0157_/Q Tile_X0Y0_FrameData[31] VGND VPWR Tile_X0Y1_FrameStrobe[2] latch
X_0088_ _0093_/D _0998_/X _0609_/Q VPWR VGND sg13cmos5l_or2_1
XFILLER_105_214 VPWR VGND sg13cmos5l_fill_2
XFILLER_22_27 VPWR VGND sg13cmos5l_decap_8
XFILLER_103_96 VPWR VGND sg13cmos5l_decap_8
XFILLER_27_220 VPWR VGND sg13cmos5l_decap_8
XFILLER_47_68 VPWR VGND sg13cmos5l_fill_2
XFILLER_10_153 VPWR VGND sg13cmos5l_decap_8
XFILLER_6_102 VPWR VGND sg13cmos5l_decap_8
XFILLER_128_82 VPWR VGND sg13cmos5l_decap_8
XFILLER_19_7 VPWR VGND sg13cmos5l_decap_8
XFILLER_77_197 VPWR VGND sg13cmos5l_decap_8
X_1060_ _1060_/X _0637_/Q _0641_/Q _1090_/X _1094_/X _0208_/Q _0207_/Q VPWR VGND sg13cmos5l_mux4_1
XFILLER_92_178 VPWR VGND sg13cmos5l_decap_8
X_0913_ Tile_X0Y1_S4BEG[5] Tile_X0Y0_S4END[13] VPWR VGND sg13cmos5l_buf_1
X_0844_ Tile_X0Y1_FrameData_O[20] Tile_X0Y1_FrameData[20] VPWR VGND sg13cmos5l_buf_1
X_0775_ Tile_X0Y0_WW4BEG[8] _1055_/X VPWR VGND sg13cmos5l_buf_1
XFILLER_45_0 VPWR VGND sg13cmos5l_decap_4
XFILLER_68_131 VPWR VGND sg13cmos5l_decap_8
XFILLER_17_27 VPWR VGND sg13cmos5l_decap_4
XFILLER_68_175 VPWR VGND sg13cmos5l_fill_1
X_1189_ _1189_/X _0646_/Q _1204_/X _1208_/X _1201_/X _0438_/Q _0437_/Q VPWR VGND sg13cmos5l_mux4_1
X_0209_ _0209_/Q Tile_X0Y0_FrameData[11] VGND VPWR Tile_X0Y1_FrameStrobe[3] latch
XFILLER_123_7 VPWR VGND sg13cmos5l_fill_2
XFILLER_137_147 VPWR VGND sg13cmos5l_decap_4
XFILLER_3_105 VPWR VGND sg13cmos5l_decap_8
XFILLER_3_116 VPWR VGND sg13cmos5l_fill_1
XFILLER_3_149 VPWR VGND sg13cmos5l_decap_4
XFILLER_114_62 VPWR VGND sg13cmos5l_fill_2
XFILLER_59_197 VPWR VGND sg13cmos5l_decap_8
XFILLER_130_94 VPWR VGND sg13cmos5l_decap_8
XFILLER_74_167 VPWR VGND sg13cmos5l_decap_8
XFILLER_74_66 VPWR VGND sg13cmos5l_decap_8
XFILLER_128_103 VPWR VGND sg13cmos5l_decap_8
XFILLER_99_41 VPWR VGND sg13cmos5l_decap_8
XFILLER_2_193 VPWR VGND sg13cmos5l_decap_8
X_0560_ _0560_/Q Tile_X0Y1_FrameData[10] VGND VPWR Tile_X0Y1_FrameStrobe[6] latch
X_0491_ _0491_/Q Tile_X0Y1_FrameData[15] VGND VPWR Tile_X0Y1_FrameStrobe[4] latch
XFILLER_99_96 VPWR VGND sg13cmos5l_decap_8
XFILLER_17_4 VPWR VGND sg13cmos5l_fill_2
XFILLER_65_112 VPWR VGND sg13cmos5l_decap_8
XFILLER_65_123 VPWR VGND sg13cmos5l_fill_1
XFILLER_80_115 VPWR VGND sg13cmos5l_decap_8
X_1043_ _1043_/X Tile_X0Y0_EE4END[11] _0640_/Q _1095_/X _1096_/X _0242_/Q _0241_/Q
+ VPWR VGND sg13cmos5l_mux4_1
X_1112_ _1112_/X Tile_X0Y1_E1END[1] Tile_X0Y1_E6END[5] _1216_/X _1192_/X _0600_/Q
+ _0599_/Q VPWR VGND sg13cmos5l_mux4_1
XFILLER_21_226 VPWR VGND sg13cmos5l_fill_2
XFILLER_119_169 VPWR VGND sg13cmos5l_decap_4
XFILLER_135_28 VPWR VGND sg13cmos5l_decap_8
X_0827_ Tile_X0Y1_FrameData_O[3] Tile_X0Y1_FrameData[3] VPWR VGND sg13cmos5l_buf_1
X_0758_ Tile_X0Y0_N4BEG[7] Tile_X0Y1_N4END[15] VPWR VGND sg13cmos5l_buf_1
XFILLER_56_123 VPWR VGND sg13cmos5l_decap_8
X_0689_ _0689_/L_HI VPWR VGND sg13cmos5l_tiehi
XANTENNA__0883__X Tile_X0Y0_FrameData_O[27] VPWR VGND sg13cmos5l_antennanp
XFILLER_71_137 VPWR VGND sg13cmos5l_decap_8
XFILLER_121_4 VPWR VGND sg13cmos5l_fill_2
XFILLER_60_35 VPWR VGND sg13cmos5l_decap_4
XFILLER_60_46 VPWR VGND sg13cmos5l_decap_8
XFILLER_125_61 VPWR VGND sg13cmos5l_decap_8
XFILLER_133_161 VPWR VGND sg13cmos5l_decap_8
XFILLER_94_207 VPWR VGND sg13cmos5l_fill_2
XANTENNA__0793__X Tile_X0Y0_N2BEG[2] VPWR VGND sg13cmos5l_antennanp
XFILLER_141_60 VPWR VGND sg13cmos5l_decap_8
XFILLER_47_156 VPWR VGND sg13cmos5l_decap_8
XFILLER_62_126 VPWR VGND sg13cmos5l_decap_8
XFILLER_85_98 VPWR VGND sg13cmos5l_decap_8
XFILLER_86_7 VPWR VGND sg13cmos5l_fill_1
XANTENNA__0968__X Tile_X0Y1_WW4BEG[11] VPWR VGND sg13cmos5l_antennanp
XFILLER_124_161 VPWR VGND sg13cmos5l_decap_8
X_0612_ NPU_WEIGHT_IN2 Tile_X0Y1_UserCLK _0992_/X _0695_/L_HI VPWR VGND sg13cmos5l_dfrbpq_1
XFILLER_38_112 VPWR VGND sg13cmos5l_fill_2
X_0543_ _0543_/Q Tile_X0Y1_FrameData[27] VGND VPWR Tile_X0Y1_FrameStrobe[6] latch
X_0474_ _0474_/Q Tile_X0Y1_FrameData[0] VGND VPWR Tile_X0Y1_FrameStrobe[3] latch
XFILLER_121_19 VPWR VGND sg13cmos5l_decap_8
X_1026_ _1026_/X _1084_/X _1080_/X _1079_/X _1099_/X _0277_/Q _0276_/Q VPWR VGND sg13cmos5l_mux4_1
XFILLER_30_38 VPWR VGND sg13cmos5l_decap_8
XANTENNA__0878__X Tile_X0Y0_FrameData_O[22] VPWR VGND sg13cmos5l_antennanp
XFILLER_130_164 VPWR VGND sg13cmos5l_decap_8
XFILLER_130_197 VPWR VGND sg13cmos5l_decap_8
XFILLER_29_112 VPWR VGND sg13cmos5l_fill_2
XFILLER_111_52 VPWR VGND sg13cmos5l_decap_4
XFILLER_111_74 VPWR VGND sg13cmos5l_decap_4
XFILLER_71_34 VPWR VGND sg13cmos5l_fill_2
XFILLER_71_67 VPWR VGND sg13cmos5l_decap_8
XFILLER_112_0 VPWR VGND sg13cmos5l_decap_4
XFILLER_4_200 VPWR VGND sg13cmos5l_decap_8
XANTENNA__0788__X Tile_X0Y0_N2BEGb[5] VPWR VGND sg13cmos5l_antennanp
XFILLER_106_194 VPWR VGND sg13cmos5l_fill_2
XFILLER_20_82 VPWR VGND sg13cmos5l_decap_8
XFILLER_96_86 VPWR VGND sg13cmos5l_decap_8
X_0190_ _0190_/Q Tile_X0Y0_FrameData[30] VGND VPWR Tile_X0Y1_FrameStrobe[3] latch
XFILLER_84_4 VPWR VGND sg13cmos5l_fill_2
XFILLER_6_95 VPWR VGND sg13cmos5l_decap_8
X_0526_ _0526_/Q Tile_X0Y1_FrameData[12] VGND VPWR Tile_X0Y1_FrameStrobe[5] latch
XFILLER_112_175 VPWR VGND sg13cmos5l_decap_4
X_0457_ _0457_/Q Tile_X0Y1_FrameData[17] VGND VPWR Tile_X0Y1_FrameStrobe[3] latch
X_0388_ _0388_/Q Tile_X0Y1_FrameData[22] VGND VPWR Tile_X0Y1_FrameStrobe[1] latch
X_1009_ _1009_/X Tile_X0Y0_E2MID[1] Tile_X0Y0_E2END[1] Tile_X0Y0_E6END[1] _1098_/X
+ _0326_/Q _0325_/Q VPWR VGND sg13cmos5l_mux4_1
XFILLER_106_41 VPWR VGND sg13cmos5l_decap_8
XFILLER_32_129 VPWR VGND sg13cmos5l_decap_8
XFILLER_66_56 VPWR VGND sg13cmos5l_decap_8
XFILLER_126_201 VPWR VGND sg13cmos5l_decap_8
XFILLER_15_93 VPWR VGND sg13cmos5l_decap_8
XFILLER_82_77 VPWR VGND sg13cmos5l_decap_4
X_0311_ _0311_/Q Tile_X0Y0_FrameData[5] VGND VPWR Tile_X0Y1_FrameStrobe[6] latch
X_0242_ _0242_/Q Tile_X0Y0_FrameData[10] VGND VPWR Tile_X0Y1_FrameStrobe[4] latch
X_0173_ _0173_/Q Tile_X0Y0_FrameData[15] VGND VPWR Tile_X0Y1_FrameStrobe[2] latch
XFILLER_16_192 VPWR VGND sg13cmos5l_decap_8
XFILLER_75_0 VPWR VGND sg13cmos5l_fill_2
X_0509_ _0509_/Q Tile_X0Y1_FrameData[29] VGND VPWR Tile_X0Y1_FrameStrobe[5] latch
XFILLER_54_221 VPWR VGND sg13cmos5l_decap_8
XANTENNA__0891__X Tile_X0Y1_S1BEG[3] VPWR VGND sg13cmos5l_antennanp
XFILLER_14_129 VPWR VGND sg13cmos5l_decap_8
XFILLER_108_223 VPWR VGND sg13cmos5l_decap_4
XFILLER_123_204 VPWR VGND sg13cmos5l_fill_2
XFILLER_77_22 VPWR VGND sg13cmos5l_fill_2
XFILLER_93_21 VPWR VGND sg13cmos5l_decap_8
XFILLER_89_195 VPWR VGND sg13cmos5l_decap_8
XFILLER_93_98 VPWR VGND sg13cmos5l_decap_8
XFILLER_13_184 VPWR VGND sg13cmos5l_decap_8
X_0860_ Tile_X0Y0_FrameData_O[4] Tile_X0Y0_FrameData[4] VPWR VGND sg13cmos5l_buf_1
X_0791_ Tile_X0Y0_N2BEG[0] _1003_/X VPWR VGND sg13cmos5l_buf_1
XFILLER_9_133 VPWR VGND sg13cmos5l_decap_8
XFILLER_114_226 VPWR VGND sg13cmos5l_fill_2
XFILLER_3_63 VPWR VGND sg13cmos5l_decap_8
X_0225_ _0225_/Q Tile_X0Y0_FrameData[27] VGND VPWR Tile_X0Y1_FrameStrobe[4] latch
X_0156_ _0156_/Q Tile_X0Y0_FrameData[0] VGND VPWR Tile_X0Y1_FrameStrobe[1] latch
XFILLER_95_198 VPWR VGND sg13cmos5l_decap_8
X_0087_ _0089_/D _0604_/Q _1235_/X VPWR VGND sg13cmos5l_nor2b_1
X_0989_ _0989_/X Tile_X0Y1_EE4END[7] Tile_X0Y1_EE4END[15] Tile_X0Y1_E6END[7] _1210_/X
+ _0420_/Q _0419_/Q VPWR VGND sg13cmos5l_mux4_1
XANTENNA__0886__X Tile_X0Y0_FrameData_O[30] VPWR VGND sg13cmos5l_antennanp
XFILLER_86_198 VPWR VGND sg13cmos5l_decap_8
XFILLER_103_64 VPWR VGND sg13cmos5l_decap_8
XFILLER_42_213 VPWR VGND sg13cmos5l_decap_8
XFILLER_63_35 VPWR VGND sg13cmos5l_decap_8
XFILLER_63_79 VPWR VGND sg13cmos5l_decap_8
XFILLER_10_121 VPWR VGND sg13cmos5l_fill_1
XFILLER_10_132 VPWR VGND sg13cmos5l_decap_8
XFILLER_6_158 VPWR VGND sg13cmos5l_decap_4
XANTENNA__0796__X Tile_X0Y0_N2BEG[5] VPWR VGND sg13cmos5l_antennanp
XFILLER_5_0 VPWR VGND sg13cmos5l_decap_8
XFILLER_88_98 VPWR VGND sg13cmos5l_decap_8
XFILLER_77_176 VPWR VGND sg13cmos5l_decap_8
XFILLER_92_157 VPWR VGND sg13cmos5l_decap_8
X_0912_ Tile_X0Y1_S4BEG[4] Tile_X0Y0_S4END[12] VPWR VGND sg13cmos5l_buf_1
XFILLER_5_191 VPWR VGND sg13cmos5l_decap_8
X_0843_ Tile_X0Y1_FrameData_O[19] Tile_X0Y1_FrameData[19] VPWR VGND sg13cmos5l_buf_1
X_0774_ Tile_X0Y0_WW4BEG[7] _1054_/X VPWR VGND sg13cmos5l_buf_1
XFILLER_102_218 VPWR VGND sg13cmos5l_decap_8
XFILLER_38_0 VPWR VGND sg13cmos5l_fill_2
XFILLER_68_110 VPWR VGND sg13cmos5l_decap_8
XFILLER_83_157 VPWR VGND sg13cmos5l_fill_1
XFILLER_83_179 VPWR VGND sg13cmos5l_decap_8
X_1188_ _1188_/X _0645_/Q _1205_/X _1209_/X _1200_/X _0440_/Q _0439_/Q VPWR VGND sg13cmos5l_mux4_1
X_0208_ _0208_/Q Tile_X0Y0_FrameData[12] VGND VPWR Tile_X0Y1_FrameStrobe[3] latch
X_0139_ _0139_/Q Tile_X0Y0_FrameData[17] VGND VPWR Tile_X0Y1_FrameStrobe[1] latch
XFILLER_137_126 VPWR VGND sg13cmos5l_decap_8
XFILLER_33_49 VPWR VGND sg13cmos5l_decap_8
XFILLER_3_128 VPWR VGND sg13cmos5l_decap_8
XFILLER_114_41 VPWR VGND sg13cmos5l_decap_4
XFILLER_114_85 VPWR VGND sg13cmos5l_decap_8
XFILLER_74_146 VPWR VGND sg13cmos5l_decap_8
XFILLER_130_73 VPWR VGND sg13cmos5l_decap_8
XFILLER_90_55 VPWR VGND sg13cmos5l_decap_8
XFILLER_128_159 VPWR VGND sg13cmos5l_decap_8
XFILLER_99_75 VPWR VGND sg13cmos5l_decap_8
XFILLER_2_172 VPWR VGND sg13cmos5l_decap_8
X_0490_ _0490_/Q Tile_X0Y1_FrameData[16] VGND VPWR Tile_X0Y1_FrameStrobe[4] latch
XFILLER_97_227 VPWR VGND sg13cmos5l_fill_2
XFILLER_97_216 VPWR VGND sg13cmos5l_fill_1
XFILLER_0_42 VPWR VGND sg13cmos5l_decap_8
XFILLER_0_97 VPWR VGND sg13cmos5l_decap_8
XFILLER_73_190 VPWR VGND sg13cmos5l_fill_1
X_1042_ _1042_/X Tile_X0Y0_EE4END[10] _0639_/Q _1095_/X _1096_/X _0244_/Q _0243_/Q
+ VPWR VGND sg13cmos5l_mux4_1
X_1111_ _1111_/X Tile_X0Y1_E1END[0] Tile_X0Y1_E6END[4] _1215_/X _1191_/X _0602_/Q
+ _0601_/Q VPWR VGND sg13cmos5l_mux4_1
XFILLER_119_148 VPWR VGND sg13cmos5l_decap_8
XFILLER_21_205 VPWR VGND sg13cmos5l_decap_8
XFILLER_9_95 VPWR VGND sg13cmos5l_decap_8
XFILLER_127_181 VPWR VGND sg13cmos5l_decap_8
XFILLER_127_192 VPWR VGND sg13cmos5l_decap_8
X_0826_ Tile_X0Y1_FrameData_O[2] Tile_X0Y1_FrameData[2] VPWR VGND sg13cmos5l_buf_1
X_0757_ Tile_X0Y0_N4BEG[6] Tile_X0Y1_N4END[14] VPWR VGND sg13cmos5l_buf_1
X_0688_ _0688_/L_HI VPWR VGND sg13cmos5l_tiehi
XFILLER_88_227 VPWR VGND sg13cmos5l_fill_2
XFILLER_12_216 VPWR VGND sg13cmos5l_fill_1
XFILLER_12_227 VPWR VGND sg13cmos5l_fill_2
XFILLER_44_59 VPWR VGND sg13cmos5l_fill_2
XFILLER_64_190 VPWR VGND sg13cmos5l_fill_2
XFILLER_71_116 VPWR VGND sg13cmos5l_decap_8
XFILLER_8_209 VPWR VGND sg13cmos5l_decap_4
XFILLER_100_98 VPWR VGND sg13cmos5l_decap_8
XFILLER_114_4 VPWR VGND sg13cmos5l_fill_2
XFILLER_60_14 VPWR VGND sg13cmos5l_decap_8
XFILLER_133_140 VPWR VGND sg13cmos5l_decap_8
XFILLER_133_195 VPWR VGND sg13cmos5l_decap_8
XFILLER_79_216 VPWR VGND sg13cmos5l_fill_1
XFILLER_79_227 VPWR VGND sg13cmos5l_fill_2
XFILLER_47_135 VPWR VGND sg13cmos5l_decap_8
XFILLER_34_81 VPWR VGND sg13cmos5l_decap_8
XFILLER_7_220 VPWR VGND sg13cmos5l_decap_8
XFILLER_109_181 VPWR VGND sg13cmos5l_decap_4
XFILLER_124_140 VPWR VGND sg13cmos5l_decap_8
XFILLER_50_91 VPWR VGND sg13cmos5l_decap_4
X_0611_ NPU_WEIGHT_IN1 Tile_X0Y1_UserCLK _0991_/X _0696_/L_HI VPWR VGND sg13cmos5l_dfrbpq_1
X_0542_ _0542_/Q Tile_X0Y1_FrameData[28] VGND VPWR Tile_X0Y1_FrameStrobe[6] latch
XFILLER_38_135 VPWR VGND sg13cmos5l_decap_4
XFILLER_38_179 VPWR VGND sg13cmos5l_decap_8
XFILLER_85_208 VPWR VGND sg13cmos5l_decap_8
X_0473_ _0473_/Q Tile_X0Y1_FrameData[1] VGND VPWR Tile_X0Y1_FrameStrobe[3] latch
XFILLER_14_29 VPWR VGND sg13cmos5l_fill_1
X_1025_ _1025_/X Tile_X0Y0_E1END[3] Tile_X0Y0_EE4END[15] Tile_X0Y0_E6END[7] _1091_/X
+ _0277_/Q _0276_/Q VPWR VGND sg13cmos5l_mux4_1
X_0809_ Tile_X0Y0_FrameStrobe_O[6] Tile_X0Y1_FrameStrobe[6] VPWR VGND sg13cmos5l_buf_1
XFILLER_115_162 VPWR VGND sg13cmos5l_fill_2
XFILLER_130_143 VPWR VGND sg13cmos5l_decap_8
XFILLER_39_59 VPWR VGND sg13cmos5l_fill_2
XANTENNA__0894__X Tile_X0Y1_S2BEG[2] VPWR VGND sg13cmos5l_antennanp
XFILLER_111_31 VPWR VGND sg13cmos5l_decap_8
XFILLER_44_105 VPWR VGND sg13cmos5l_fill_2
XFILLER_71_57 VPWR VGND sg13cmos5l_fill_2
XFILLER_105_0 VPWR VGND sg13cmos5l_decap_8
XFILLER_106_173 VPWR VGND sg13cmos5l_decap_8
XFILLER_121_110 VPWR VGND sg13cmos5l_fill_1
XFILLER_121_198 VPWR VGND sg13cmos5l_decap_8
XFILLER_96_43 VPWR VGND sg13cmos5l_decap_8
XFILLER_35_127 VPWR VGND sg13cmos5l_decap_4
XFILLER_43_182 VPWR VGND sg13cmos5l_decap_8
XFILLER_90_211 VPWR VGND sg13cmos5l_decap_4
XANTENNA_1 NPU_OUT_ACT2 VPWR VGND sg13cmos5l_antennanp
XFILLER_129_210 VPWR VGND sg13cmos5l_decap_8
XFILLER_6_30 VPWR VGND sg13cmos5l_decap_8
XFILLER_77_4 VPWR VGND sg13cmos5l_fill_2
XFILLER_112_165 VPWR VGND sg13cmos5l_decap_8
XFILLER_58_208 VPWR VGND sg13cmos5l_decap_8
XFILLER_6_74 VPWR VGND sg13cmos5l_decap_8
X_0525_ _0525_/Q Tile_X0Y1_FrameData[13] VGND VPWR Tile_X0Y1_FrameStrobe[5] latch
X_0456_ _0456_/Q Tile_X0Y1_FrameData[18] VGND VPWR Tile_X0Y1_FrameStrobe[3] latch
XFILLER_20_0 VPWR VGND sg13cmos5l_fill_2
X_0387_ _0387_/Q Tile_X0Y1_FrameData[23] VGND VPWR Tile_X0Y1_FrameStrobe[1] latch
XFILLER_25_28 VPWR VGND sg13cmos5l_decap_8
XFILLER_41_16 VPWR VGND sg13cmos5l_fill_2
X_1008_ _1008_/X Tile_X0Y0_E2MID[2] Tile_X0Y0_E2END[2] Tile_X0Y0_E6END[2] _1097_/X
+ _0328_/Q _0327_/Q VPWR VGND sg13cmos5l_mux4_1
XANTENNA__0889__X Tile_X0Y1_S1BEG[1] VPWR VGND sg13cmos5l_antennanp
XFILLER_135_202 VPWR VGND sg13cmos5l_decap_8
XFILLER_103_121 VPWR VGND sg13cmos5l_decap_8
XFILLER_106_97 VPWR VGND sg13cmos5l_decap_4
XFILLER_66_35 VPWR VGND sg13cmos5l_decap_8
XFILLER_82_56 VPWR VGND sg13cmos5l_fill_2
XFILLER_40_185 VPWR VGND sg13cmos5l_decap_8
XANTENNA__0799__X Tile_X0Y0_N1BEG[0] VPWR VGND sg13cmos5l_antennanp
XFILLER_141_227 VPWR VGND sg13cmos5l_fill_2
X_0310_ _0310_/Q Tile_X0Y0_FrameData[6] VGND VPWR Tile_X0Y1_FrameStrobe[6] latch
XFILLER_56_90 VPWR VGND sg13cmos5l_decap_8
X_0241_ _0241_/Q Tile_X0Y0_FrameData[11] VGND VPWR Tile_X0Y1_FrameStrobe[4] latch
X_0172_ _0172_/Q Tile_X0Y0_FrameData[16] VGND VPWR Tile_X0Y1_FrameStrobe[2] latch
XFILLER_16_171 VPWR VGND sg13cmos5l_decap_8
XFILLER_68_0 VPWR VGND sg13cmos5l_decap_8
X_0508_ _0508_/Q Tile_X0Y1_FrameData[30] VGND VPWR Tile_X0Y1_FrameStrobe[5] latch
X_0439_ _0439_/Q Tile_X0Y1_FrameData[3] VGND VPWR Tile_X0Y1_FrameStrobe[2] latch
XFILLER_36_49 VPWR VGND sg13cmos5l_decap_8
XFILLER_54_200 VPWR VGND sg13cmos5l_decap_8
XFILLER_108_202 VPWR VGND sg13cmos5l_decap_8
XFILLER_117_30 VPWR VGND sg13cmos5l_fill_1
XFILLER_117_52 VPWR VGND sg13cmos5l_decap_4
XFILLER_117_85 VPWR VGND sg13cmos5l_decap_8
XFILLER_123_216 VPWR VGND sg13cmos5l_fill_1
XFILLER_123_227 VPWR VGND sg13cmos5l_fill_2
XFILLER_7_4 VPWR VGND sg13cmos5l_fill_1
XFILLER_89_163 VPWR VGND sg13cmos5l_decap_8
XFILLER_133_84 VPWR VGND sg13cmos5l_decap_8
XFILLER_13_163 VPWR VGND sg13cmos5l_decap_8
XFILLER_26_93 VPWR VGND sg13cmos5l_decap_8
XFILLER_9_123 VPWR VGND sg13cmos5l_fill_2
XFILLER_114_205 VPWR VGND sg13cmos5l_decap_8
XFILLER_42_81 VPWR VGND sg13cmos5l_decap_8
XFILLER_61_7 VPWR VGND sg13cmos5l_decap_8
X_0790_ Tile_X0Y0_N2BEGb[7] _1110_/X VPWR VGND sg13cmos5l_buf_1
XFILLER_9_189 VPWR VGND sg13cmos5l_fill_2
XFILLER_3_42 VPWR VGND sg13cmos5l_decap_8
XFILLER_95_111 VPWR VGND sg13cmos5l_decap_4
X_0224_ _0224_/Q Tile_X0Y0_FrameData[28] VGND VPWR Tile_X0Y1_FrameStrobe[4] latch
X_0155_ _0155_/Q Tile_X0Y0_FrameData[1] VGND VPWR Tile_X0Y1_FrameStrobe[1] latch
X_0086_ _0917_/A _1021_/X _1022_/X _0281_/Q VPWR VGND sg13cmos5l_mux2_1
XFILLER_138_18 VPWR VGND sg13cmos5l_fill_2
X_0988_ _0988_/X Tile_X0Y1_EE4END[6] Tile_X0Y1_EE4END[14] Tile_X0Y1_E6END[6] _1209_/X
+ _0422_/Q _0421_/Q VPWR VGND sg13cmos5l_mux4_1
XFILLER_105_216 VPWR VGND sg13cmos5l_fill_1
XFILLER_105_227 VPWR VGND sg13cmos5l_fill_2
XFILLER_86_122 VPWR VGND sg13cmos5l_decap_4
XFILLER_86_166 VPWR VGND sg13cmos5l_decap_4
XFILLER_103_43 VPWR VGND sg13cmos5l_decap_8
XFILLER_63_14 VPWR VGND sg13cmos5l_decap_8
XFILLER_10_188 VPWR VGND sg13cmos5l_decap_8
XFILLER_6_137 VPWR VGND sg13cmos5l_decap_8
XFILLER_77_155 VPWR VGND sg13cmos5l_decap_8
XFILLER_88_77 VPWR VGND sg13cmos5l_decap_8
XFILLER_37_92 VPWR VGND sg13cmos5l_decap_4
XFILLER_92_136 VPWR VGND sg13cmos5l_fill_2
XFILLER_53_80 VPWR VGND sg13cmos5l_decap_8
XFILLER_53_91 VPWR VGND sg13cmos5l_fill_1
X_0911_ Tile_X0Y1_S4BEG[3] Tile_X0Y0_S4END[11] VPWR VGND sg13cmos5l_buf_1
X_0842_ Tile_X0Y1_FrameData_O[18] Tile_X0Y1_FrameData[18] VPWR VGND sg13cmos5l_buf_1
XFILLER_5_170 VPWR VGND sg13cmos5l_decap_8
X_0773_ Tile_X0Y0_WW4BEG[6] _1053_/X VPWR VGND sg13cmos5l_buf_1
XFILLER_68_166 VPWR VGND sg13cmos5l_decap_8
XFILLER_24_203 VPWR VGND sg13cmos5l_decap_4
XFILLER_33_28 VPWR VGND sg13cmos5l_decap_8
X_1187_ _1187_/X _0644_/Q _1206_/X _1210_/X _1199_/X _0442_/Q _0441_/Q VPWR VGND sg13cmos5l_mux4_1
X_0207_ _0207_/Q Tile_X0Y0_FrameData[13] VGND VPWR Tile_X0Y1_FrameStrobe[3] latch
X_0138_ _0138_/Q Tile_X0Y0_FrameData[18] VGND VPWR Tile_X0Y1_FrameStrobe[1] latch
X_0069_ _0919_/A _1025_/X _1026_/X _0275_/Q VPWR VGND sg13cmos5l_mux2_1
XFILLER_137_105 VPWR VGND sg13cmos5l_decap_8
XANTENNA__0897__X Tile_X0Y1_S2BEG[5] VPWR VGND sg13cmos5l_antennanp
XFILLER_59_133 VPWR VGND sg13cmos5l_decap_8
XFILLER_114_20 VPWR VGND sg13cmos5l_decap_8
XFILLER_130_30 VPWR VGND sg13cmos5l_fill_1
XFILLER_15_203 VPWR VGND sg13cmos5l_decap_8
XFILLER_74_125 VPWR VGND sg13cmos5l_decap_8
XFILLER_74_13 VPWR VGND sg13cmos5l_fill_2
XFILLER_135_0 VPWR VGND sg13cmos5l_decap_8
XFILLER_30_228 VPWR VGND sg13cmos5l_fill_1
XFILLER_82_191 VPWR VGND sg13cmos5l_decap_8
XFILLER_90_34 VPWR VGND sg13cmos5l_decap_8
XFILLER_128_138 VPWR VGND sg13cmos5l_decap_8
XFILLER_136_182 VPWR VGND sg13cmos5l_decap_8
XFILLER_97_206 VPWR VGND sg13cmos5l_decap_4
X_1110_ _1110_/X Tile_X0Y1_E2MID[0] Tile_X0Y1_E2END[0] Tile_X0Y1_E6END[0] _1202_/X
+ _0580_/Q _0579_/Q VPWR VGND sg13cmos5l_mux4_1
XFILLER_0_21 VPWR VGND sg13cmos5l_decap_8
XFILLER_0_76 VPWR VGND sg13cmos5l_decap_8
XFILLER_21_228 VPWR VGND sg13cmos5l_fill_1
X_1041_ _1041_/X Tile_X0Y0_EE4END[9] _0638_/Q _1094_/X _1097_/X _0246_/Q _0245_/Q
+ VPWR VGND sg13cmos5l_mux4_1
XFILLER_119_116 VPWR VGND sg13cmos5l_decap_4
XFILLER_127_160 VPWR VGND sg13cmos5l_decap_8
XFILLER_134_119 VPWR VGND sg13cmos5l_decap_8
X_0825_ Tile_X0Y1_FrameData_O[1] Tile_X0Y1_FrameData[1] VPWR VGND sg13cmos5l_buf_1
XFILLER_50_0 VPWR VGND sg13cmos5l_decap_4
X_0756_ Tile_X0Y0_N4BEG[5] Tile_X0Y1_N4END[13] VPWR VGND sg13cmos5l_buf_1
X_0687_ _0687_/L_HI VPWR VGND sg13cmos5l_tiehi
XFILLER_28_28 VPWR VGND sg13cmos5l_decap_8
XFILLER_100_33 VPWR VGND sg13cmos5l_decap_8
XFILLER_100_66 VPWR VGND sg13cmos5l_decap_8
XFILLER_107_4 VPWR VGND sg13cmos5l_fill_2
XFILLER_109_42 VPWR VGND sg13cmos5l_decap_8
XFILLER_109_86 VPWR VGND sg13cmos5l_decap_8
XFILLER_118_182 VPWR VGND sg13cmos5l_decap_8
XFILLER_69_35 VPWR VGND sg13cmos5l_decap_4
XFILLER_47_114 VPWR VGND sg13cmos5l_decap_8
XFILLER_94_209 VPWR VGND sg13cmos5l_fill_1
XFILLER_141_95 VPWR VGND sg13cmos5l_decap_8
XFILLER_18_50 VPWR VGND sg13cmos5l_decap_8
XFILLER_124_196 VPWR VGND sg13cmos5l_decap_8
X_0610_ NPU_WEIGHT_IN0 Tile_X0Y1_UserCLK _0990_/X _0693_/L_HI VPWR VGND sg13cmos5l_dfrbpq_1
X_0541_ _0541_/Q Tile_X0Y1_FrameData[29] VGND VPWR Tile_X0Y1_FrameStrobe[6] latch
X_0472_ _0472_/Q Tile_X0Y1_FrameData[2] VGND VPWR Tile_X0Y1_FrameStrobe[3] latch
XFILLER_22_4 VPWR VGND sg13cmos5l_fill_2
XFILLER_38_125 VPWR VGND sg13cmos5l_fill_2
X_1024_ _1024_/X _1085_/X _1081_/X _1077_/X _1098_/X _0280_/Q _0279_/Q VPWR VGND sg13cmos5l_mux4_1
XFILLER_93_220 VPWR VGND sg13cmos5l_decap_8
XFILLER_61_194 VPWR VGND sg13cmos5l_fill_1
XFILLER_98_0 VPWR VGND sg13cmos5l_decap_4
X_0808_ Tile_X0Y0_FrameStrobe_O[5] Tile_X0Y1_FrameStrobe[5] VPWR VGND sg13cmos5l_buf_1
XFILLER_115_185 VPWR VGND sg13cmos5l_decap_8
XFILLER_130_122 VPWR VGND sg13cmos5l_decap_8
XFILLER_76_209 VPWR VGND sg13cmos5l_decap_8
X_0739_ Tile_X0Y0_W6BEG[0] _1063_/X VPWR VGND sg13cmos5l_buf_1
XFILLER_29_169 VPWR VGND sg13cmos5l_decap_4
XFILLER_55_48 VPWR VGND sg13cmos5l_decap_4
XFILLER_55_59 VPWR VGND sg13cmos5l_decap_8
XFILLER_111_87 VPWR VGND sg13cmos5l_decap_4
XFILLER_111_98 VPWR VGND sg13cmos5l_decap_4
XFILLER_138_222 VPWR VGND sg13cmos5l_decap_8
XFILLER_52_172 VPWR VGND sg13cmos5l_decap_8
XFILLER_52_183 VPWR VGND sg13cmos5l_fill_1
XFILLER_136_84 VPWR VGND sg13cmos5l_decap_8
XFILLER_20_62 VPWR VGND sg13cmos5l_decap_8
XFILLER_96_22 VPWR VGND sg13cmos5l_decap_8
XFILLER_121_177 VPWR VGND sg13cmos5l_decap_8
XFILLER_29_71 VPWR VGND sg13cmos5l_decap_4
XFILLER_43_161 VPWR VGND sg13cmos5l_decap_8
XFILLER_45_81 VPWR VGND sg13cmos5l_decap_4
XANTENNA_2 NPU_OUT_ACT7 VPWR VGND sg13cmos5l_antennanp
XFILLER_6_42 VPWR VGND sg13cmos5l_decap_4
XFILLER_112_199 VPWR VGND sg13cmos5l_decap_8
X_0524_ _0524_/Q Tile_X0Y1_FrameData[14] VGND VPWR Tile_X0Y1_FrameStrobe[5] latch
X_0455_ _0455_/Q Tile_X0Y1_FrameData[19] VGND VPWR Tile_X0Y1_FrameStrobe[3] latch
XFILLER_13_0 VPWR VGND sg13cmos5l_decap_4
XFILLER_26_139 VPWR VGND sg13cmos5l_decap_8
XFILLER_81_212 VPWR VGND sg13cmos5l_decap_4
X_1007_ _1007_/X Tile_X0Y0_E2MID[3] Tile_X0Y0_E2END[3] Tile_X0Y0_E6END[3] _1096_/X
+ _0330_/Q _0329_/Q VPWR VGND sg13cmos5l_mux4_1
X_0386_ _0386_/Q Tile_X0Y1_FrameData[24] VGND VPWR Tile_X0Y1_FrameStrobe[1] latch
XFILLER_34_194 VPWR VGND sg13cmos5l_decap_4
XFILLER_41_39 VPWR VGND sg13cmos5l_decap_8
XFILLER_103_199 VPWR VGND sg13cmos5l_fill_1
XFILLER_106_76 VPWR VGND sg13cmos5l_decap_8
XFILLER_49_209 VPWR VGND sg13cmos5l_decap_8
XFILLER_57_220 VPWR VGND sg13cmos5l_decap_8
XFILLER_66_14 VPWR VGND sg13cmos5l_decap_8
XFILLER_122_86 VPWR VGND sg13cmos5l_fill_1
XFILLER_25_194 VPWR VGND sg13cmos5l_decap_8
XFILLER_82_35 VPWR VGND sg13cmos5l_decap_8
XFILLER_31_50 VPWR VGND sg13cmos5l_decap_8
XFILLER_40_164 VPWR VGND sg13cmos5l_decap_8
X_0240_ _0240_/Q Tile_X0Y0_FrameData[12] VGND VPWR Tile_X0Y1_FrameStrobe[4] latch
XFILLER_48_220 VPWR VGND sg13cmos5l_decap_8
X_0171_ _0171_/Q Tile_X0Y0_FrameData[17] VGND VPWR Tile_X0Y1_FrameStrobe[2] latch
XFILLER_31_131 VPWR VGND sg13cmos5l_fill_2
XFILLER_31_197 VPWR VGND sg13cmos5l_fill_2
XFILLER_75_2 VPWR VGND sg13cmos5l_fill_1
XFILLER_117_214 VPWR VGND sg13cmos5l_fill_2
XFILLER_132_217 VPWR VGND sg13cmos5l_decap_8
XFILLER_132_228 VPWR VGND sg13cmos5l_fill_1
XFILLER_100_147 VPWR VGND sg13cmos5l_decap_8
XFILLER_36_28 VPWR VGND sg13cmos5l_decap_8
X_0507_ _0507_/Q Tile_X0Y1_FrameData[31] VGND VPWR Tile_X0Y1_FrameStrobe[5] latch
X_0438_ _0438_/Q Tile_X0Y1_FrameData[4] VGND VPWR Tile_X0Y1_FrameStrobe[2] latch
X_0369_ _0369_/Q Tile_X0Y1_FrameData[9] VGND VPWR Tile_X0Y1_FrameStrobe[0] latch
XFILLER_98_153 VPWR VGND sg13cmos5l_decap_4
XFILLER_52_27 VPWR VGND sg13cmos5l_decap_8
XFILLER_139_7 VPWR VGND sg13cmos5l_fill_2
XFILLER_77_13 VPWR VGND sg13cmos5l_fill_2
XFILLER_133_63 VPWR VGND sg13cmos5l_decap_8
XFILLER_13_142 VPWR VGND sg13cmos5l_decap_8
XFILLER_60_226 VPWR VGND sg13cmos5l_fill_2
XFILLER_9_102 VPWR VGND sg13cmos5l_decap_8
XFILLER_114_228 VPWR VGND sg13cmos5l_fill_1
XFILLER_9_168 VPWR VGND sg13cmos5l_decap_8
XFILLER_3_21 VPWR VGND sg13cmos5l_decap_8
XFILLER_3_98 VPWR VGND sg13cmos5l_decap_8
X_0223_ _0223_/Q Tile_X0Y0_FrameData[29] VGND VPWR Tile_X0Y1_FrameStrobe[4] latch
X_0154_ _0154_/Q Tile_X0Y0_FrameData[2] VGND VPWR Tile_X0Y1_FrameStrobe[1] latch
X_0085_ _0765_/A _1015_/X _1016_/X _0314_/Q VPWR VGND sg13cmos5l_mux2_1
XFILLER_80_0 VPWR VGND sg13cmos5l_decap_4
X_0987_ _0987_/X Tile_X0Y1_EE4END[5] Tile_X0Y1_EE4END[13] Tile_X0Y1_E6END[5] _1208_/X
+ _0424_/Q _0423_/Q VPWR VGND sg13cmos5l_mux4_1
XFILLER_105_206 VPWR VGND sg13cmos5l_decap_4
XFILLER_120_209 VPWR VGND sg13cmos5l_decap_8
XFILLER_47_16 VPWR VGND sg13cmos5l_fill_2
XFILLER_86_156 VPWR VGND sg13cmos5l_decap_4
XFILLER_10_167 VPWR VGND sg13cmos5l_decap_8
XFILLER_128_96 VPWR VGND sg13cmos5l_decap_8
XFILLER_12_63 VPWR VGND sg13cmos5l_decap_8
XFILLER_6_116 VPWR VGND sg13cmos5l_decap_8
XFILLER_88_12 VPWR VGND sg13cmos5l_decap_8
XFILLER_77_134 VPWR VGND sg13cmos5l_decap_8
XFILLER_33_226 VPWR VGND sg13cmos5l_fill_2
XFILLER_139_180 VPWR VGND sg13cmos5l_fill_2
X_0910_ Tile_X0Y1_S4BEG[2] Tile_X0Y0_S4END[10] VPWR VGND sg13cmos5l_buf_1
X_0841_ Tile_X0Y1_FrameData_O[17] Tile_X0Y1_FrameData[17] VPWR VGND sg13cmos5l_buf_1
X_0772_ Tile_X0Y0_WW4BEG[5] _1052_/X VPWR VGND sg13cmos5l_buf_1
XFILLER_52_4 VPWR VGND sg13cmos5l_fill_2
XFILLER_68_145 VPWR VGND sg13cmos5l_decap_8
X_1186_ _1186_/X _0651_/Q _1207_/X _1211_/X _1198_/X _0444_/Q _0443_/Q VPWR VGND sg13cmos5l_mux4_1
X_0206_ _0206_/Q Tile_X0Y0_FrameData[14] VGND VPWR Tile_X0Y1_FrameStrobe[3] latch
XFILLER_24_215 VPWR VGND sg13cmos5l_fill_2
X_0137_ _0137_/Q Tile_X0Y0_FrameData[19] VGND VPWR Tile_X0Y1_FrameStrobe[1] latch
X_0068_ _0918_/A _1023_/X _1024_/X _0278_/Q VPWR VGND sg13cmos5l_mux2_1
XFILLER_91_181 VPWR VGND sg13cmos5l_decap_8
XFILLER_101_220 VPWR VGND sg13cmos5l_decap_8
XFILLER_59_112 VPWR VGND sg13cmos5l_decap_8
XFILLER_74_36 VPWR VGND sg13cmos5l_fill_2
XFILLER_82_170 VPWR VGND sg13cmos5l_decap_8
XFILLER_128_0 VPWR VGND sg13cmos5l_decap_4
XFILLER_128_117 VPWR VGND sg13cmos5l_decap_8
XFILLER_139_62 VPWR VGND sg13cmos5l_fill_2
XFILLER_136_161 VPWR VGND sg13cmos5l_decap_8
XFILLER_139_84 VPWR VGND sg13cmos5l_decap_8
XFILLER_2_130 VPWR VGND sg13cmos5l_decap_8
XFILLER_99_55 VPWR VGND sg13cmos5l_decap_8
X_1040_ _1040_/X Tile_X0Y0_EE4END[7] _0637_/Q _1093_/X _1098_/X _0248_/Q _0247_/Q
+ VPWR VGND sg13cmos5l_mux4_1
XFILLER_73_181 VPWR VGND sg13cmos5l_decap_8
XFILLER_80_129 VPWR VGND sg13cmos5l_decap_8
X_0824_ Tile_X0Y1_FrameData_O[0] Tile_X0Y1_FrameData[0] VPWR VGND sg13cmos5l_buf_1
X_0755_ Tile_X0Y0_N4BEG[4] Tile_X0Y1_N4END[12] VPWR VGND sg13cmos5l_buf_1
XFILLER_43_0 VPWR VGND sg13cmos5l_fill_2
XFILLER_56_104 VPWR VGND sg13cmos5l_decap_8
X_0686_ _0686_/L_HI VPWR VGND sg13cmos5l_tiehi
XFILLER_44_28 VPWR VGND sg13cmos5l_decap_4
XFILLER_56_115 VPWR VGND sg13cmos5l_fill_1
XFILLER_56_137 VPWR VGND sg13cmos5l_decap_8
XFILLER_64_192 VPWR VGND sg13cmos5l_fill_1
X_1169_ _1169_/X _0646_/Q _0650_/Q _1212_/X _1196_/X _0478_/Q _0477_/Q VPWR VGND sg13cmos5l_mux4_1
XFILLER_100_12 VPWR VGND sg13cmos5l_decap_8
XFILLER_118_161 VPWR VGND sg13cmos5l_decap_8
XFILLER_133_175 VPWR VGND sg13cmos5l_fill_2
XFILLER_69_14 VPWR VGND sg13cmos5l_decap_8
XFILLER_79_207 VPWR VGND sg13cmos5l_fill_1
XFILLER_85_35 VPWR VGND sg13cmos5l_decap_8
XFILLER_141_52 VPWR VGND sg13cmos5l_decap_4
XFILLER_141_74 VPWR VGND sg13cmos5l_decap_8
XFILLER_109_172 VPWR VGND sg13cmos5l_decap_4
XFILLER_50_60 VPWR VGND sg13cmos5l_decap_8
XFILLER_124_175 VPWR VGND sg13cmos5l_decap_8
XFILLER_59_91 VPWR VGND sg13cmos5l_decap_8
X_0540_ _0540_/Q Tile_X0Y1_FrameData[30] VGND VPWR Tile_X0Y1_FrameStrobe[6] latch
X_0471_ _0471_/Q Tile_X0Y1_FrameData[3] VGND VPWR Tile_X0Y1_FrameStrobe[3] latch
XFILLER_15_4 VPWR VGND sg13cmos5l_fill_1
XFILLER_38_159 VPWR VGND sg13cmos5l_decap_8
XFILLER_46_170 VPWR VGND sg13cmos5l_decap_8
X_1023_ _1023_/X Tile_X0Y0_E1END[2] Tile_X0Y0_EE4END[14] Tile_X0Y0_E6END[6] _1090_/X
+ _0280_/Q _0279_/Q VPWR VGND sg13cmos5l_mux4_1
XFILLER_93_210 VPWR VGND sg13cmos5l_decap_8
XFILLER_61_173 VPWR VGND sg13cmos5l_decap_8
XFILLER_130_101 VPWR VGND sg13cmos5l_decap_8
X_0807_ Tile_X0Y0_FrameStrobe_O[4] Tile_X0Y1_FrameStrobe[4] VPWR VGND sg13cmos5l_buf_1
X_0738_ Tile_X0Y0_W2BEGb[7] _1046_/X VPWR VGND sg13cmos5l_buf_1
XFILLER_130_178 VPWR VGND sg13cmos5l_decap_8
XFILLER_29_126 VPWR VGND sg13cmos5l_decap_8
XFILLER_39_17 VPWR VGND sg13cmos5l_decap_8
XFILLER_84_210 VPWR VGND sg13cmos5l_decap_8
X_0669_ _0669_/L_HI VPWR VGND sg13cmos5l_tiehi
XFILLER_111_22 VPWR VGND sg13cmos5l_fill_2
XFILLER_44_107 VPWR VGND sg13cmos5l_fill_1
XFILLER_52_151 VPWR VGND sg13cmos5l_decap_8
XFILLER_55_27 VPWR VGND sg13cmos5l_decap_8
XFILLER_138_201 VPWR VGND sg13cmos5l_decap_8
XFILLER_4_214 VPWR VGND sg13cmos5l_decap_8
XFILLER_71_59 VPWR VGND sg13cmos5l_fill_1
XFILLER_121_156 VPWR VGND sg13cmos5l_decap_8
XFILLER_136_63 VPWR VGND sg13cmos5l_decap_8
XFILLER_20_96 VPWR VGND sg13cmos5l_decap_4
XFILLER_29_50 VPWR VGND sg13cmos5l_decap_8
XFILLER_29_94 VPWR VGND sg13cmos5l_decap_4
XFILLER_75_210 VPWR VGND sg13cmos5l_decap_8
XANTENNA_3 Tile_X0Y0_S2MID[0] VPWR VGND sg13cmos5l_antennanp
XFILLER_6_21 VPWR VGND sg13cmos5l_fill_2
XFILLER_112_123 VPWR VGND sg13cmos5l_decap_8
XFILLER_20_2 VPWR VGND sg13cmos5l_fill_1
X_0523_ _0523_/Q Tile_X0Y1_FrameData[15] VGND VPWR Tile_X0Y1_FrameStrobe[5] latch
X_0454_ _0454_/Q Tile_X0Y1_FrameData[20] VGND VPWR Tile_X0Y1_FrameStrobe[3] latch
X_0385_ _0385_/Q Tile_X0Y1_FrameData[25] VGND VPWR Tile_X0Y1_FrameStrobe[1] latch
XFILLER_26_107 VPWR VGND sg13cmos5l_decap_8
XFILLER_34_173 VPWR VGND sg13cmos5l_decap_8
X_1006_ _1006_/X Tile_X0Y0_E2MID[4] Tile_X0Y0_E2END[4] Tile_X0Y0_E6END[4] _1095_/X
+ _0332_/Q _0331_/Q VPWR VGND sg13cmos5l_mux4_1
XFILLER_1_228 VPWR VGND sg13cmos5l_fill_1
XFILLER_106_55 VPWR VGND sg13cmos5l_decap_8
XFILLER_82_14 VPWR VGND sg13cmos5l_decap_8
XFILLER_25_173 VPWR VGND sg13cmos5l_decap_8
XFILLER_40_121 VPWR VGND sg13cmos5l_fill_1
XFILLER_82_69 VPWR VGND sg13cmos5l_fill_1
XFILLER_110_0 VPWR VGND sg13cmos5l_decap_8
XFILLER_126_215 VPWR VGND sg13cmos5l_decap_8
XFILLER_141_207 VPWR VGND sg13cmos5l_decap_8
XFILLER_48_210 VPWR VGND sg13cmos5l_decap_4
X_0170_ _0170_/Q Tile_X0Y0_FrameData[18] VGND VPWR Tile_X0Y1_FrameStrobe[2] latch
XFILLER_117_204 VPWR VGND sg13cmos5l_decap_4
XFILLER_31_176 VPWR VGND sg13cmos5l_decap_8
XFILLER_72_80 VPWR VGND sg13cmos5l_decap_8
X_0506_ _0506_/Q Tile_X0Y1_FrameData[0] VGND VPWR Tile_X0Y1_FrameStrobe[4] latch
XFILLER_98_132 VPWR VGND sg13cmos5l_decap_8
XFILLER_36_18 VPWR VGND sg13cmos5l_fill_2
X_0437_ _0437_/Q Tile_X0Y1_FrameData[5] VGND VPWR Tile_X0Y1_FrameStrobe[2] latch
X_0368_ _0368_/Q Tile_X0Y1_FrameData[10] VGND VPWR Tile_X0Y1_FrameStrobe[0] latch
XFILLER_98_198 VPWR VGND sg13cmos5l_decap_8
XFILLER_22_121 VPWR VGND sg13cmos5l_fill_1
XFILLER_22_143 VPWR VGND sg13cmos5l_decap_8
X_0299_ _0299_/Q Tile_X0Y0_FrameData[17] VGND VPWR Tile_X0Y1_FrameStrobe[6] latch
XFILLER_117_21 VPWR VGND sg13cmos5l_decap_8
XFILLER_22_187 VPWR VGND sg13cmos5l_decap_8
XFILLER_117_98 VPWR VGND sg13cmos5l_decap_8
XFILLER_89_143 VPWR VGND sg13cmos5l_fill_2
XFILLER_89_121 VPWR VGND sg13cmos5l_decap_8
XFILLER_133_42 VPWR VGND sg13cmos5l_decap_8
XFILLER_26_40 VPWR VGND sg13cmos5l_fill_2
XFILLER_60_205 VPWR VGND sg13cmos5l_decap_8
XFILLER_93_35 VPWR VGND sg13cmos5l_decap_8
XFILLER_13_198 VPWR VGND sg13cmos5l_decap_8
XFILLER_42_72 VPWR VGND sg13cmos5l_fill_2
XFILLER_9_147 VPWR VGND sg13cmos5l_decap_8
XFILLER_9_125 VPWR VGND sg13cmos5l_fill_1
XFILLER_3_77 VPWR VGND sg13cmos5l_decap_8
XFILLER_67_91 VPWR VGND sg13cmos5l_decap_8
X_0222_ _0222_/Q Tile_X0Y0_FrameData[30] VGND VPWR Tile_X0Y1_FrameStrobe[4] latch
X_0153_ _0153_/Q Tile_X0Y0_FrameData[3] VGND VPWR Tile_X0Y1_FrameStrobe[1] latch
XFILLER_51_205 VPWR VGND sg13cmos5l_decap_8
XFILLER_51_227 VPWR VGND sg13cmos5l_fill_2
X_0084_ _0766_/A _1017_/X _1018_/X _0311_/Q VPWR VGND sg13cmos5l_mux2_1
XFILLER_73_0 VPWR VGND sg13cmos5l_decap_4
X_0986_ _0986_/X Tile_X0Y1_EE4END[4] Tile_X0Y1_EE4END[12] Tile_X0Y1_E6END[4] _1207_/X
+ _0426_/Q _0425_/Q VPWR VGND sg13cmos5l_mux4_1
XFILLER_103_78 VPWR VGND sg13cmos5l_decap_4
XFILLER_103_89 VPWR VGND sg13cmos5l_decap_8
XFILLER_27_202 VPWR VGND sg13cmos5l_decap_4
XFILLER_42_227 VPWR VGND sg13cmos5l_fill_2
XFILLER_63_49 VPWR VGND sg13cmos5l_fill_2
XFILLER_10_146 VPWR VGND sg13cmos5l_decap_8
XFILLER_128_20 VPWR VGND sg13cmos5l_fill_2
XFILLER_128_75 VPWR VGND sg13cmos5l_decap_8
XFILLER_88_35 VPWR VGND sg13cmos5l_decap_8
XFILLER_92_138 VPWR VGND sg13cmos5l_fill_1
X_0840_ Tile_X0Y1_FrameData_O[16] Tile_X0Y1_FrameData[16] VPWR VGND sg13cmos5l_buf_1
X_0771_ Tile_X0Y0_WW4BEG[4] _1051_/X VPWR VGND sg13cmos5l_buf_1
XFILLER_45_4 VPWR VGND sg13cmos5l_fill_2
XFILLER_68_124 VPWR VGND sg13cmos5l_decap_8
XFILLER_24_227 VPWR VGND sg13cmos5l_fill_2
XFILLER_83_116 VPWR VGND sg13cmos5l_decap_4
X_1185_ _1185_/X _0650_/Q _1208_/X _1212_/X _1197_/X _0446_/Q _0445_/Q VPWR VGND sg13cmos5l_mux4_1
X_0205_ _0205_/Q Tile_X0Y0_FrameData[15] VGND VPWR Tile_X0Y1_FrameStrobe[3] latch
X_0136_ _0136_/Q Tile_X0Y0_FrameData[20] VGND VPWR Tile_X0Y1_FrameStrobe[1] latch
X_0969_ Tile_X0Y1_WW4BEG[12] _1175_/X VPWR VGND sg13cmos5l_buf_1
XFILLER_114_55 VPWR VGND sg13cmos5l_decap_8
XFILLER_130_21 VPWR VGND sg13cmos5l_decap_8
XFILLER_130_87 VPWR VGND sg13cmos5l_decap_8
XFILLER_15_227 VPWR VGND sg13cmos5l_fill_2
XFILLER_90_14 VPWR VGND sg13cmos5l_fill_2
XFILLER_136_140 VPWR VGND sg13cmos5l_decap_8
XFILLER_23_52 VPWR VGND sg13cmos5l_fill_2
XFILLER_23_96 VPWR VGND sg13cmos5l_decap_8
XFILLER_99_34 VPWR VGND sg13cmos5l_decap_8
XFILLER_2_142 VPWR VGND sg13cmos5l_decap_8
XFILLER_2_153 VPWR VGND sg13cmos5l_fill_1
XFILLER_2_186 VPWR VGND sg13cmos5l_decap_8
XFILLER_3_0 VPWR VGND sg13cmos5l_decap_8
XFILLER_99_89 VPWR VGND sg13cmos5l_decap_8
XFILLER_0_56 VPWR VGND sg13cmos5l_fill_2
XFILLER_48_93 VPWR VGND sg13cmos5l_fill_1
XFILLER_65_105 VPWR VGND sg13cmos5l_decap_8
XFILLER_73_160 VPWR VGND sg13cmos5l_decap_8
XFILLER_80_108 VPWR VGND sg13cmos5l_decap_8
XFILLER_21_219 VPWR VGND sg13cmos5l_decap_8
XFILLER_9_43 VPWR VGND sg13cmos5l_decap_8
XFILLER_80_80 VPWR VGND sg13cmos5l_decap_8
X_0823_ FAB_USER_CLK Tile_X0Y1_UserCLK VPWR VGND sg13cmos5l_buf_1
X_0754_ Tile_X0Y0_N4BEG[3] Tile_X0Y1_N4END[11] VPWR VGND sg13cmos5l_buf_1
X_0685_ _0685_/L_HI VPWR VGND sg13cmos5l_tiehi
XFILLER_36_0 VPWR VGND sg13cmos5l_decap_4
XFILLER_12_208 VPWR VGND sg13cmos5l_fill_2
XFILLER_49_190 VPWR VGND sg13cmos5l_decap_8
XFILLER_64_171 VPWR VGND sg13cmos5l_decap_8
X_1099_ _1099_/X _1110_/X Tile_X0Y1_N2MID[7] Tile_X0Y0_S2MID[7] Tile_X0Y0_S2END[7]
+ _0102_/Q _0101_/Q VPWR VGND sg13cmos5l_mux4_1
X_1168_ _1168_/X _0645_/Q _0649_/Q _1213_/X _1197_/X _0480_/Q _0479_/Q VPWR VGND sg13cmos5l_mux4_1
X_0119_ _0119_/Q Tile_X0Y0_FrameData[5] VGND VPWR Tile_X0Y1_FrameStrobe[0] latch
XFILLER_60_28 VPWR VGND sg13cmos5l_decap_8
XFILLER_125_32 VPWR VGND sg13cmos5l_decap_8
XFILLER_125_43 VPWR VGND sg13cmos5l_fill_2
XFILLER_133_154 VPWR VGND sg13cmos5l_decap_8
XFILLER_47_149 VPWR VGND sg13cmos5l_decap_8
XFILLER_62_119 VPWR VGND sg13cmos5l_decap_8
XFILLER_140_0 VPWR VGND sg13cmos5l_fill_2
XFILLER_34_95 VPWR VGND sg13cmos5l_decap_8
XFILLER_55_182 VPWR VGND sg13cmos5l_fill_1
XFILLER_70_163 VPWR VGND sg13cmos5l_fill_2
XFILLER_109_151 VPWR VGND sg13cmos5l_decap_8
XFILLER_124_154 VPWR VGND sg13cmos5l_decap_8
XFILLER_38_105 VPWR VGND sg13cmos5l_decap_8
XFILLER_38_127 VPWR VGND sg13cmos5l_fill_1
XFILLER_59_70 VPWR VGND sg13cmos5l_decap_8
X_0470_ _0470_/Q Tile_X0Y1_FrameData[4] VGND VPWR Tile_X0Y1_FrameStrobe[3] latch
XFILLER_61_152 VPWR VGND sg13cmos5l_decap_8
X_1022_ _1022_/X _1086_/X _1082_/X _1076_/X _1097_/X _0283_/Q _0282_/Q VPWR VGND sg13cmos5l_mux4_1
XANTENNA__0802__X Tile_X0Y0_N1BEG[3] VPWR VGND sg13cmos5l_antennanp
XFILLER_115_154 VPWR VGND sg13cmos5l_fill_1
X_0806_ Tile_X0Y0_FrameStrobe_O[3] Tile_X0Y1_FrameStrobe[3] VPWR VGND sg13cmos5l_buf_1
X_0737_ Tile_X0Y0_W2BEGb[6] _1045_/X VPWR VGND sg13cmos5l_buf_1
X_0668_ _0668_/L_HI VPWR VGND sg13cmos5l_tiehi
XFILLER_130_157 VPWR VGND sg13cmos5l_decap_8
XFILLER_29_105 VPWR VGND sg13cmos5l_decap_8
X_0599_ _0599_/Q Tile_X0Y1_FrameData[3] VGND VPWR Tile_X0Y1_FrameStrobe[7] latch
XFILLER_111_12 VPWR VGND sg13cmos5l_decap_4
XFILLER_111_45 VPWR VGND sg13cmos5l_decap_8
XFILLER_111_56 VPWR VGND sg13cmos5l_fill_2
XFILLER_111_78 VPWR VGND sg13cmos5l_fill_2
XFILLER_37_193 VPWR VGND sg13cmos5l_decap_4
XFILLER_106_110 VPWR VGND sg13cmos5l_decap_8
XFILLER_20_31 VPWR VGND sg13cmos5l_fill_2
XFILLER_106_187 VPWR VGND sg13cmos5l_decap_8
XFILLER_136_42 VPWR VGND sg13cmos5l_decap_8
XFILLER_96_79 VPWR VGND sg13cmos5l_decap_8
XFILLER_96_57 VPWR VGND sg13cmos5l_decap_4
XFILLER_96_13 VPWR VGND sg13cmos5l_fill_2
XFILLER_129_224 VPWR VGND sg13cmos5l_decap_4
XFILLER_43_196 VPWR VGND sg13cmos5l_decap_8
XANTENNA_4 Tile_X0Y0_S2MID[0] VPWR VGND sg13cmos5l_antennanp
XFILLER_6_88 VPWR VGND sg13cmos5l_decap_8
X_0522_ _0522_/Q Tile_X0Y1_FrameData[16] VGND VPWR Tile_X0Y1_FrameStrobe[5] latch
X_0453_ _0453_/Q Tile_X0Y1_FrameData[21] VGND VPWR Tile_X0Y1_FrameStrobe[3] latch
X_0384_ _0384_/Q Tile_X0Y1_FrameData[26] VGND VPWR Tile_X0Y1_FrameStrobe[1] latch
XFILLER_34_152 VPWR VGND sg13cmos5l_decap_8
X_1005_ _1005_/X Tile_X0Y0_E2MID[5] Tile_X0Y0_E2END[5] Tile_X0Y0_E6END[5] _1094_/X
+ _0334_/Q _0333_/Q VPWR VGND sg13cmos5l_mux4_1
XFILLER_135_216 VPWR VGND sg13cmos5l_fill_1
XFILLER_135_227 VPWR VGND sg13cmos5l_fill_2
XFILLER_106_12 VPWR VGND sg13cmos5l_fill_1
XFILLER_25_141 VPWR VGND sg13cmos5l_decap_8
XFILLER_66_49 VPWR VGND sg13cmos5l_decap_8
XFILLER_15_86 VPWR VGND sg13cmos5l_decap_8
XFILLER_40_199 VPWR VGND sg13cmos5l_decap_8
XFILLER_103_0 VPWR VGND sg13cmos5l_decap_8
XFILLER_102_190 VPWR VGND sg13cmos5l_decap_8
XFILLER_16_163 VPWR VGND sg13cmos5l_fill_1
XFILLER_16_185 VPWR VGND sg13cmos5l_decap_8
XFILLER_31_133 VPWR VGND sg13cmos5l_fill_1
XFILLER_117_216 VPWR VGND sg13cmos5l_fill_1
XFILLER_117_227 VPWR VGND sg13cmos5l_fill_2
XFILLER_100_105 VPWR VGND sg13cmos5l_decap_8
X_0505_ _0505_/Q Tile_X0Y1_FrameData[1] VGND VPWR Tile_X0Y1_FrameStrobe[4] latch
X_0436_ _0436_/Q Tile_X0Y1_FrameData[6] VGND VPWR Tile_X0Y1_FrameStrobe[2] latch
XFILLER_98_111 VPWR VGND sg13cmos5l_decap_8
.ends
