* NGSPICE file created from NPU_SLICE.ext - technology: ihp-sg13cmos5l

* Black-box entry subcircuit for sg13cmos5l_decap_8 abstract view
.subckt sg13cmos5l_decap_8 VDD VSS
.ends

* Black-box entry subcircuit for sg13cmos5l_decap_4 abstract view
.subckt sg13cmos5l_decap_4 VDD VSS
.ends

* Black-box entry subcircuit for latch abstract view
.subckt latch Q D VSS VDD GATE
.ends

* Black-box entry subcircuit for sg13cmos5l_fill_2 abstract view
.subckt sg13cmos5l_fill_2 VDD VSS
.ends

* Black-box entry subcircuit for sg13cmos5l_fill_1 abstract view
.subckt sg13cmos5l_fill_1 VDD VSS
.ends

* Black-box entry subcircuit for sg13cmos5l_antennanp abstract view
.subckt sg13cmos5l_antennanp A VDD VSS
.ends

* Black-box entry subcircuit for sg13cmos5l_mux2_1 abstract view
.subckt sg13cmos5l_mux2_1 X A0 A1 S VDD VSS
.ends

* Black-box entry subcircuit for sg13cmos5l_mux4_1 abstract view
.subckt sg13cmos5l_mux4_1 X A0 A1 A2 A3 S0 S1 VDD VSS
.ends

* Black-box entry subcircuit for sg13cmos5l_buf_1 abstract view
.subckt sg13cmos5l_buf_1 X A VDD VSS
.ends

* Black-box entry subcircuit for sg13cmos5l_tiehi abstract view
.subckt sg13cmos5l_tiehi L_HI VDD VSS
.ends

* Black-box entry subcircuit for sg13cmos5l_dfrbpq_1 abstract view
.subckt sg13cmos5l_dfrbpq_1 Q CLK D RESET_B VDD VSS
.ends

* Black-box entry subcircuit for sg13cmos5l_tielo abstract view
.subckt sg13cmos5l_tielo L_LO VDD VSS
.ends

* Black-box entry subcircuit for sg13cmos5l_or2_1 abstract view
.subckt sg13cmos5l_or2_1 X A B VDD VSS
.ends

* Black-box entry subcircuit for sg13cmos5l_nor2b_1 abstract view
.subckt sg13cmos5l_nor2b_1 Y A B_N VDD VSS
.ends

.subckt NPU_SLICE FAB_USER_CLK NPU_ACT_ADDR0 NPU_ACT_ADDR1 NPU_ACT_ADDR2 NPU_ACT_ADDR3
+ NPU_ACT_ADDR4 NPU_ACT_ADDR5 NPU_ACT_ADDR6 NPU_ACT_ADDR7 NPU_ACT_ADDR8 NPU_ACT_RDATA0
+ NPU_ACT_RDATA1 NPU_ACT_RDATA2 NPU_ACT_RDATA3 NPU_ACT_RDATA4 NPU_ACT_RDATA5 NPU_ACT_RDATA6
+ NPU_ACT_RDATA7 NPU_ACT_WDATA0 NPU_ACT_WDATA1 NPU_ACT_WDATA2 NPU_ACT_WDATA3 NPU_ACT_WDATA4
+ NPU_ACT_WDATA5 NPU_ACT_WDATA6 NPU_ACT_WDATA7 NPU_ACT_WE NPU_OUT_ACT0 NPU_OUT_ACT1
+ NPU_OUT_ACT2 NPU_OUT_ACT3 NPU_OUT_ACT4 NPU_OUT_ACT5 NPU_OUT_ACT6 NPU_OUT_ACT7 NPU_WEIGHT_IN0
+ NPU_WEIGHT_IN1 NPU_WEIGHT_IN2 NPU_WEIGHT_IN3 NPU_WEIGHT_IN4 NPU_WEIGHT_IN5 NPU_WEIGHT_IN6
+ NPU_WEIGHT_IN7 NPU_WEIGHT_SHIFT_EN NPU_XBAR_SEL0 NPU_XBAR_SEL1 NPU_XBAR_SEL2 NPU_XBAR_SEL3
+ Tile_X0Y0_E1END[0] Tile_X0Y0_E1END[1] Tile_X0Y0_E1END[2] Tile_X0Y0_E1END[3] Tile_X0Y0_E2END[0]
+ Tile_X0Y0_E2END[1] Tile_X0Y0_E2END[2] Tile_X0Y0_E2END[3] Tile_X0Y0_E2END[4] Tile_X0Y0_E2END[5]
+ Tile_X0Y0_E2END[6] Tile_X0Y0_E2END[7] Tile_X0Y0_E2MID[0] Tile_X0Y0_E2MID[1] Tile_X0Y0_E2MID[2]
+ Tile_X0Y0_E2MID[3] Tile_X0Y0_E2MID[4] Tile_X0Y0_E2MID[5] Tile_X0Y0_E2MID[6] Tile_X0Y0_E2MID[7]
+ Tile_X0Y0_E6END[0] Tile_X0Y0_E6END[10] Tile_X0Y0_E6END[11] Tile_X0Y0_E6END[1] Tile_X0Y0_E6END[2]
+ Tile_X0Y0_E6END[3] Tile_X0Y0_E6END[4] Tile_X0Y0_E6END[5] Tile_X0Y0_E6END[6] Tile_X0Y0_E6END[7]
+ Tile_X0Y0_E6END[8] Tile_X0Y0_E6END[9] Tile_X0Y0_EE4END[0] Tile_X0Y0_EE4END[10] Tile_X0Y0_EE4END[11]
+ Tile_X0Y0_EE4END[12] Tile_X0Y0_EE4END[13] Tile_X0Y0_EE4END[14] Tile_X0Y0_EE4END[15]
+ Tile_X0Y0_EE4END[1] Tile_X0Y0_EE4END[2] Tile_X0Y0_EE4END[3] Tile_X0Y0_EE4END[4]
+ Tile_X0Y0_EE4END[5] Tile_X0Y0_EE4END[6] Tile_X0Y0_EE4END[7] Tile_X0Y0_EE4END[8]
+ Tile_X0Y0_EE4END[9] Tile_X0Y0_FrameData[0] Tile_X0Y0_FrameData[10] Tile_X0Y0_FrameData[11]
+ Tile_X0Y0_FrameData[12] Tile_X0Y0_FrameData[13] Tile_X0Y0_FrameData[14] Tile_X0Y0_FrameData[15]
+ Tile_X0Y0_FrameData[16] Tile_X0Y0_FrameData[17] Tile_X0Y0_FrameData[18] Tile_X0Y0_FrameData[19]
+ Tile_X0Y0_FrameData[1] Tile_X0Y0_FrameData[20] Tile_X0Y0_FrameData[21] Tile_X0Y0_FrameData[22]
+ Tile_X0Y0_FrameData[23] Tile_X0Y0_FrameData[24] Tile_X0Y0_FrameData[25] Tile_X0Y0_FrameData[26]
+ Tile_X0Y0_FrameData[27] Tile_X0Y0_FrameData[28] Tile_X0Y0_FrameData[29] Tile_X0Y0_FrameData[2]
+ Tile_X0Y0_FrameData[30] Tile_X0Y0_FrameData[31] Tile_X0Y0_FrameData[3] Tile_X0Y0_FrameData[4]
+ Tile_X0Y0_FrameData[5] Tile_X0Y0_FrameData[6] Tile_X0Y0_FrameData[7] Tile_X0Y0_FrameData[8]
+ Tile_X0Y0_FrameData[9] Tile_X0Y0_FrameData_O[0] Tile_X0Y0_FrameData_O[10] Tile_X0Y0_FrameData_O[11]
+ Tile_X0Y0_FrameData_O[12] Tile_X0Y0_FrameData_O[13] Tile_X0Y0_FrameData_O[14] Tile_X0Y0_FrameData_O[15]
+ Tile_X0Y0_FrameData_O[16] Tile_X0Y0_FrameData_O[17] Tile_X0Y0_FrameData_O[18] Tile_X0Y0_FrameData_O[19]
+ Tile_X0Y0_FrameData_O[1] Tile_X0Y0_FrameData_O[20] Tile_X0Y0_FrameData_O[21] Tile_X0Y0_FrameData_O[22]
+ Tile_X0Y0_FrameData_O[23] Tile_X0Y0_FrameData_O[24] Tile_X0Y0_FrameData_O[25] Tile_X0Y0_FrameData_O[26]
+ Tile_X0Y0_FrameData_O[27] Tile_X0Y0_FrameData_O[28] Tile_X0Y0_FrameData_O[29] Tile_X0Y0_FrameData_O[2]
+ Tile_X0Y0_FrameData_O[30] Tile_X0Y0_FrameData_O[31] Tile_X0Y0_FrameData_O[3] Tile_X0Y0_FrameData_O[4]
+ Tile_X0Y0_FrameData_O[5] Tile_X0Y0_FrameData_O[6] Tile_X0Y0_FrameData_O[7] Tile_X0Y0_FrameData_O[8]
+ Tile_X0Y0_FrameData_O[9] Tile_X0Y0_FrameStrobe_O[0] Tile_X0Y0_FrameStrobe_O[10]
+ Tile_X0Y0_FrameStrobe_O[11] Tile_X0Y0_FrameStrobe_O[12] Tile_X0Y0_FrameStrobe_O[13]
+ Tile_X0Y0_FrameStrobe_O[14] Tile_X0Y0_FrameStrobe_O[15] Tile_X0Y0_FrameStrobe_O[16]
+ Tile_X0Y0_FrameStrobe_O[17] Tile_X0Y0_FrameStrobe_O[18] Tile_X0Y0_FrameStrobe_O[19]
+ Tile_X0Y0_FrameStrobe_O[1] Tile_X0Y0_FrameStrobe_O[2] Tile_X0Y0_FrameStrobe_O[3]
+ Tile_X0Y0_FrameStrobe_O[4] Tile_X0Y0_FrameStrobe_O[5] Tile_X0Y0_FrameStrobe_O[6]
+ Tile_X0Y0_FrameStrobe_O[7] Tile_X0Y0_FrameStrobe_O[8] Tile_X0Y0_FrameStrobe_O[9]
+ Tile_X0Y0_N1BEG[0] Tile_X0Y0_N1BEG[1] Tile_X0Y0_N1BEG[2] Tile_X0Y0_N1BEG[3] Tile_X0Y0_N2BEG[0]
+ Tile_X0Y0_N2BEG[1] Tile_X0Y0_N2BEG[2] Tile_X0Y0_N2BEG[3] Tile_X0Y0_N2BEG[4] Tile_X0Y0_N2BEG[5]
+ Tile_X0Y0_N2BEG[6] Tile_X0Y0_N2BEG[7] Tile_X0Y0_N2BEGb[0] Tile_X0Y0_N2BEGb[1] Tile_X0Y0_N2BEGb[2]
+ Tile_X0Y0_N2BEGb[3] Tile_X0Y0_N2BEGb[4] Tile_X0Y0_N2BEGb[5] Tile_X0Y0_N2BEGb[6]
+ Tile_X0Y0_N2BEGb[7] Tile_X0Y0_N4BEG[0] Tile_X0Y0_N4BEG[10] Tile_X0Y0_N4BEG[11] Tile_X0Y0_N4BEG[12]
+ Tile_X0Y0_N4BEG[13] Tile_X0Y0_N4BEG[14] Tile_X0Y0_N4BEG[15] Tile_X0Y0_N4BEG[1] Tile_X0Y0_N4BEG[2]
+ Tile_X0Y0_N4BEG[3] Tile_X0Y0_N4BEG[4] Tile_X0Y0_N4BEG[5] Tile_X0Y0_N4BEG[6] Tile_X0Y0_N4BEG[7]
+ Tile_X0Y0_N4BEG[8] Tile_X0Y0_N4BEG[9] Tile_X0Y0_S1END[0] Tile_X0Y0_S1END[1] Tile_X0Y0_S1END[2]
+ Tile_X0Y0_S1END[3] Tile_X0Y0_S2END[0] Tile_X0Y0_S2END[1] Tile_X0Y0_S2END[2] Tile_X0Y0_S2END[3]
+ Tile_X0Y0_S2END[4] Tile_X0Y0_S2END[5] Tile_X0Y0_S2END[6] Tile_X0Y0_S2END[7] Tile_X0Y0_S2MID[0]
+ Tile_X0Y0_S2MID[1] Tile_X0Y0_S2MID[2] Tile_X0Y0_S2MID[3] Tile_X0Y0_S2MID[4] Tile_X0Y0_S2MID[5]
+ Tile_X0Y0_S2MID[6] Tile_X0Y0_S2MID[7] Tile_X0Y0_S4END[0] Tile_X0Y0_S4END[10] Tile_X0Y0_S4END[11]
+ Tile_X0Y0_S4END[12] Tile_X0Y0_S4END[13] Tile_X0Y0_S4END[14] Tile_X0Y0_S4END[15]
+ Tile_X0Y0_S4END[1] Tile_X0Y0_S4END[2] Tile_X0Y0_S4END[3] Tile_X0Y0_S4END[4] Tile_X0Y0_S4END[5]
+ Tile_X0Y0_S4END[6] Tile_X0Y0_S4END[7] Tile_X0Y0_S4END[8] Tile_X0Y0_S4END[9] Tile_X0Y0_UserCLK
+ Tile_X0Y0_UserCLKo Tile_X0Y0_W1BEG[0] Tile_X0Y0_W1BEG[1] Tile_X0Y0_W1BEG[2] Tile_X0Y0_W1BEG[3]
+ Tile_X0Y0_W2BEG[0] Tile_X0Y0_W2BEG[1] Tile_X0Y0_W2BEG[2] Tile_X0Y0_W2BEG[3] Tile_X0Y0_W2BEG[4]
+ Tile_X0Y0_W2BEG[5] Tile_X0Y0_W2BEG[6] Tile_X0Y0_W2BEG[7] Tile_X0Y0_W2BEGb[0] Tile_X0Y0_W2BEGb[1]
+ Tile_X0Y0_W2BEGb[2] Tile_X0Y0_W2BEGb[3] Tile_X0Y0_W2BEGb[4] Tile_X0Y0_W2BEGb[5]
+ Tile_X0Y0_W2BEGb[6] Tile_X0Y0_W2BEGb[7] Tile_X0Y0_W6BEG[0] Tile_X0Y0_W6BEG[10] Tile_X0Y0_W6BEG[11]
+ Tile_X0Y0_W6BEG[1] Tile_X0Y0_W6BEG[2] Tile_X0Y0_W6BEG[3] Tile_X0Y0_W6BEG[4] Tile_X0Y0_W6BEG[5]
+ Tile_X0Y0_W6BEG[6] Tile_X0Y0_W6BEG[7] Tile_X0Y0_W6BEG[8] Tile_X0Y0_W6BEG[9] Tile_X0Y0_WW4BEG[0]
+ Tile_X0Y0_WW4BEG[10] Tile_X0Y0_WW4BEG[11] Tile_X0Y0_WW4BEG[12] Tile_X0Y0_WW4BEG[13]
+ Tile_X0Y0_WW4BEG[14] Tile_X0Y0_WW4BEG[15] Tile_X0Y0_WW4BEG[1] Tile_X0Y0_WW4BEG[2]
+ Tile_X0Y0_WW4BEG[3] Tile_X0Y0_WW4BEG[4] Tile_X0Y0_WW4BEG[5] Tile_X0Y0_WW4BEG[6]
+ Tile_X0Y0_WW4BEG[7] Tile_X0Y0_WW4BEG[8] Tile_X0Y0_WW4BEG[9] Tile_X0Y1_E1END[0] Tile_X0Y1_E1END[1]
+ Tile_X0Y1_E1END[2] Tile_X0Y1_E1END[3] Tile_X0Y1_E2END[0] Tile_X0Y1_E2END[1] Tile_X0Y1_E2END[2]
+ Tile_X0Y1_E2END[3] Tile_X0Y1_E2END[4] Tile_X0Y1_E2END[5] Tile_X0Y1_E2END[6] Tile_X0Y1_E2END[7]
+ Tile_X0Y1_E2MID[0] Tile_X0Y1_E2MID[1] Tile_X0Y1_E2MID[2] Tile_X0Y1_E2MID[3] Tile_X0Y1_E2MID[4]
+ Tile_X0Y1_E2MID[5] Tile_X0Y1_E2MID[6] Tile_X0Y1_E2MID[7] Tile_X0Y1_E6END[0] Tile_X0Y1_E6END[10]
+ Tile_X0Y1_E6END[11] Tile_X0Y1_E6END[1] Tile_X0Y1_E6END[2] Tile_X0Y1_E6END[3] Tile_X0Y1_E6END[4]
+ Tile_X0Y1_E6END[5] Tile_X0Y1_E6END[6] Tile_X0Y1_E6END[7] Tile_X0Y1_E6END[8] Tile_X0Y1_E6END[9]
+ Tile_X0Y1_EE4END[0] Tile_X0Y1_EE4END[10] Tile_X0Y1_EE4END[11] Tile_X0Y1_EE4END[12]
+ Tile_X0Y1_EE4END[13] Tile_X0Y1_EE4END[14] Tile_X0Y1_EE4END[15] Tile_X0Y1_EE4END[1]
+ Tile_X0Y1_EE4END[2] Tile_X0Y1_EE4END[3] Tile_X0Y1_EE4END[4] Tile_X0Y1_EE4END[5]
+ Tile_X0Y1_EE4END[6] Tile_X0Y1_EE4END[7] Tile_X0Y1_EE4END[8] Tile_X0Y1_EE4END[9]
+ Tile_X0Y1_FrameData[0] Tile_X0Y1_FrameData[10] Tile_X0Y1_FrameData[11] Tile_X0Y1_FrameData[12]
+ Tile_X0Y1_FrameData[13] Tile_X0Y1_FrameData[14] Tile_X0Y1_FrameData[15] Tile_X0Y1_FrameData[16]
+ Tile_X0Y1_FrameData[17] Tile_X0Y1_FrameData[18] Tile_X0Y1_FrameData[19] Tile_X0Y1_FrameData[1]
+ Tile_X0Y1_FrameData[20] Tile_X0Y1_FrameData[21] Tile_X0Y1_FrameData[22] Tile_X0Y1_FrameData[23]
+ Tile_X0Y1_FrameData[24] Tile_X0Y1_FrameData[25] Tile_X0Y1_FrameData[26] Tile_X0Y1_FrameData[27]
+ Tile_X0Y1_FrameData[28] Tile_X0Y1_FrameData[29] Tile_X0Y1_FrameData[2] Tile_X0Y1_FrameData[30]
+ Tile_X0Y1_FrameData[31] Tile_X0Y1_FrameData[3] Tile_X0Y1_FrameData[4] Tile_X0Y1_FrameData[5]
+ Tile_X0Y1_FrameData[6] Tile_X0Y1_FrameData[7] Tile_X0Y1_FrameData[8] Tile_X0Y1_FrameData[9]
+ Tile_X0Y1_FrameData_O[0] Tile_X0Y1_FrameData_O[10] Tile_X0Y1_FrameData_O[11] Tile_X0Y1_FrameData_O[12]
+ Tile_X0Y1_FrameData_O[13] Tile_X0Y1_FrameData_O[14] Tile_X0Y1_FrameData_O[15] Tile_X0Y1_FrameData_O[16]
+ Tile_X0Y1_FrameData_O[17] Tile_X0Y1_FrameData_O[18] Tile_X0Y1_FrameData_O[19] Tile_X0Y1_FrameData_O[1]
+ Tile_X0Y1_FrameData_O[20] Tile_X0Y1_FrameData_O[21] Tile_X0Y1_FrameData_O[22] Tile_X0Y1_FrameData_O[23]
+ Tile_X0Y1_FrameData_O[24] Tile_X0Y1_FrameData_O[25] Tile_X0Y1_FrameData_O[26] Tile_X0Y1_FrameData_O[27]
+ Tile_X0Y1_FrameData_O[28] Tile_X0Y1_FrameData_O[29] Tile_X0Y1_FrameData_O[2] Tile_X0Y1_FrameData_O[30]
+ Tile_X0Y1_FrameData_O[31] Tile_X0Y1_FrameData_O[3] Tile_X0Y1_FrameData_O[4] Tile_X0Y1_FrameData_O[5]
+ Tile_X0Y1_FrameData_O[6] Tile_X0Y1_FrameData_O[7] Tile_X0Y1_FrameData_O[8] Tile_X0Y1_FrameData_O[9]
+ Tile_X0Y1_FrameStrobe[0] Tile_X0Y1_FrameStrobe[10] Tile_X0Y1_FrameStrobe[11] Tile_X0Y1_FrameStrobe[12]
+ Tile_X0Y1_FrameStrobe[13] Tile_X0Y1_FrameStrobe[14] Tile_X0Y1_FrameStrobe[15] Tile_X0Y1_FrameStrobe[16]
+ Tile_X0Y1_FrameStrobe[17] Tile_X0Y1_FrameStrobe[18] Tile_X0Y1_FrameStrobe[19] Tile_X0Y1_FrameStrobe[1]
+ Tile_X0Y1_FrameStrobe[2] Tile_X0Y1_FrameStrobe[3] Tile_X0Y1_FrameStrobe[4] Tile_X0Y1_FrameStrobe[5]
+ Tile_X0Y1_FrameStrobe[6] Tile_X0Y1_FrameStrobe[7] Tile_X0Y1_FrameStrobe[8] Tile_X0Y1_FrameStrobe[9]
+ Tile_X0Y1_N1END[0] Tile_X0Y1_N1END[1] Tile_X0Y1_N1END[2] Tile_X0Y1_N1END[3] Tile_X0Y1_N2END[0]
+ Tile_X0Y1_N2END[1] Tile_X0Y1_N2END[2] Tile_X0Y1_N2END[3] Tile_X0Y1_N2END[4] Tile_X0Y1_N2END[5]
+ Tile_X0Y1_N2END[6] Tile_X0Y1_N2END[7] Tile_X0Y1_N2MID[0] Tile_X0Y1_N2MID[1] Tile_X0Y1_N2MID[2]
+ Tile_X0Y1_N2MID[3] Tile_X0Y1_N2MID[4] Tile_X0Y1_N2MID[5] Tile_X0Y1_N2MID[6] Tile_X0Y1_N2MID[7]
+ Tile_X0Y1_N4END[0] Tile_X0Y1_N4END[10] Tile_X0Y1_N4END[11] Tile_X0Y1_N4END[12] Tile_X0Y1_N4END[13]
+ Tile_X0Y1_N4END[14] Tile_X0Y1_N4END[15] Tile_X0Y1_N4END[1] Tile_X0Y1_N4END[2] Tile_X0Y1_N4END[3]
+ Tile_X0Y1_N4END[4] Tile_X0Y1_N4END[5] Tile_X0Y1_N4END[6] Tile_X0Y1_N4END[7] Tile_X0Y1_N4END[8]
+ Tile_X0Y1_N4END[9] Tile_X0Y1_S1BEG[0] Tile_X0Y1_S1BEG[1] Tile_X0Y1_S1BEG[2] Tile_X0Y1_S1BEG[3]
+ Tile_X0Y1_S2BEG[0] Tile_X0Y1_S2BEG[1] Tile_X0Y1_S2BEG[2] Tile_X0Y1_S2BEG[3] Tile_X0Y1_S2BEG[4]
+ Tile_X0Y1_S2BEG[5] Tile_X0Y1_S2BEG[6] Tile_X0Y1_S2BEG[7] Tile_X0Y1_S2BEGb[0] Tile_X0Y1_S2BEGb[1]
+ Tile_X0Y1_S2BEGb[2] Tile_X0Y1_S2BEGb[3] Tile_X0Y1_S2BEGb[4] Tile_X0Y1_S2BEGb[5]
+ Tile_X0Y1_S2BEGb[6] Tile_X0Y1_S2BEGb[7] Tile_X0Y1_S4BEG[0] Tile_X0Y1_S4BEG[10] Tile_X0Y1_S4BEG[11]
+ Tile_X0Y1_S4BEG[12] Tile_X0Y1_S4BEG[13] Tile_X0Y1_S4BEG[14] Tile_X0Y1_S4BEG[15]
+ Tile_X0Y1_S4BEG[1] Tile_X0Y1_S4BEG[2] Tile_X0Y1_S4BEG[3] Tile_X0Y1_S4BEG[4] Tile_X0Y1_S4BEG[5]
+ Tile_X0Y1_S4BEG[6] Tile_X0Y1_S4BEG[7] Tile_X0Y1_S4BEG[8] Tile_X0Y1_S4BEG[9] Tile_X0Y1_UserCLK
+ Tile_X0Y1_UserCLKo Tile_X0Y1_W1BEG[0] Tile_X0Y1_W1BEG[1] Tile_X0Y1_W1BEG[2] Tile_X0Y1_W1BEG[3]
+ Tile_X0Y1_W2BEG[0] Tile_X0Y1_W2BEG[1] Tile_X0Y1_W2BEG[2] Tile_X0Y1_W2BEG[3] Tile_X0Y1_W2BEG[4]
+ Tile_X0Y1_W2BEG[5] Tile_X0Y1_W2BEG[6] Tile_X0Y1_W2BEG[7] Tile_X0Y1_W2BEGb[0] Tile_X0Y1_W2BEGb[1]
+ Tile_X0Y1_W2BEGb[2] Tile_X0Y1_W2BEGb[3] Tile_X0Y1_W2BEGb[4] Tile_X0Y1_W2BEGb[5]
+ Tile_X0Y1_W2BEGb[6] Tile_X0Y1_W2BEGb[7] Tile_X0Y1_W6BEG[0] Tile_X0Y1_W6BEG[10] Tile_X0Y1_W6BEG[11]
+ Tile_X0Y1_W6BEG[1] Tile_X0Y1_W6BEG[2] Tile_X0Y1_W6BEG[3] Tile_X0Y1_W6BEG[4] Tile_X0Y1_W6BEG[5]
+ Tile_X0Y1_W6BEG[6] Tile_X0Y1_W6BEG[7] Tile_X0Y1_W6BEG[8] Tile_X0Y1_W6BEG[9] Tile_X0Y1_WW4BEG[0]
+ Tile_X0Y1_WW4BEG[10] Tile_X0Y1_WW4BEG[11] Tile_X0Y1_WW4BEG[12] Tile_X0Y1_WW4BEG[13]
+ Tile_X0Y1_WW4BEG[14] Tile_X0Y1_WW4BEG[15] Tile_X0Y1_WW4BEG[1] Tile_X0Y1_WW4BEG[2]
+ Tile_X0Y1_WW4BEG[3] Tile_X0Y1_WW4BEG[4] Tile_X0Y1_WW4BEG[5] Tile_X0Y1_WW4BEG[6]
+ Tile_X0Y1_WW4BEG[7] Tile_X0Y1_WW4BEG[8] Tile_X0Y1_WW4BEG[9] VGND VPWR
XFILLER_39_211 VPWR VGND sg13cmos5l_decap_8
XFILLER_54_225 VPWR VGND sg13cmos5l_decap_4
XFILLER_54_236 VPWR VGND sg13cmos5l_decap_4
X_0367_ _0367_/Q Tile_X0Y1_FrameData[11] VGND VPWR Tile_X0Y1_FrameStrobe[0] latch
X_0298_ _0298_/Q Tile_X0Y0_FrameData[18] VGND VPWR Tile_X0Y1_FrameStrobe[6] latch
XFILLER_108_249 VPWR VGND sg13cmos5l_decap_8
XFILLER_116_271 VPWR VGND sg13cmos5l_fill_2
XFILLER_117_99 VPWR VGND sg13cmos5l_fill_2
XFILLER_89_177 VPWR VGND sg13cmos5l_decap_8
XFILLER_26_74 VPWR VGND sg13cmos5l_decap_8
XFILLER_26_85 VPWR VGND sg13cmos5l_fill_1
XFILLER_60_239 VPWR VGND sg13cmos5l_fill_1
XFILLER_13_155 VPWR VGND sg13cmos5l_fill_1
XANTENNA__0900__X Tile_X0Y1_S2BEGb[0] VPWR VGND sg13cmos5l_antennanp
XFILLER_114_219 VPWR VGND sg13cmos5l_decap_8
XFILLER_54_9 VPWR VGND sg13cmos5l_decap_8
XFILLER_36_247 VPWR VGND sg13cmos5l_decap_8
X_0221_ _0221_/Q Tile_X0Y0_FrameData[31] VGND VPWR Tile_X0Y1_FrameStrobe[4] latch
X_0152_ _0152_/Q Tile_X0Y0_FrameData[4] VGND VPWR Tile_X0Y1_FrameStrobe[1] latch
XFILLER_95_158 VPWR VGND sg13cmos5l_decap_8
X_0083_ _0916_/A _1019_/X _1020_/X _0284_/Q VPWR VGND sg13cmos5l_mux2_1
XANTENNA__0810__X Tile_X0Y0_FrameStrobe_O[7] VPWR VGND sg13cmos5l_antennanp
XFILLER_66_0 VPWR VGND sg13cmos5l_decap_8
X_0985_ _0985_/X Tile_X0Y1_EE4END[3] Tile_X0Y1_EE4END[11] Tile_X0Y1_E6END[3] _1206_/X
+ _0428_/Q _0427_/Q VPWR VGND sg13cmos5l_mux4_1
XFILLER_8_192 VPWR VGND sg13cmos5l_decap_8
X_0419_ _0419_/Q Tile_X0Y1_FrameData[23] VGND VPWR Tile_X0Y1_FrameStrobe[2] latch
XFILLER_10_136 VPWR VGND sg13cmos5l_decap_4
XFILLER_6_129 VPWR VGND sg13cmos5l_decap_8
XANTENNA__0720__X Tile_X0Y0_W1BEG[1] VPWR VGND sg13cmos5l_antennanp
XFILLER_88_36 VPWR VGND sg13cmos5l_decap_8
XFILLER_88_47 VPWR VGND sg13cmos5l_decap_8
XFILLER_18_214 VPWR VGND sg13cmos5l_decap_8
XFILLER_18_258 VPWR VGND sg13cmos5l_fill_1
XFILLER_77_147 VPWR VGND sg13cmos5l_decap_8
XFILLER_85_180 VPWR VGND sg13cmos5l_decap_8
XFILLER_92_139 VPWR VGND sg13cmos5l_decap_4
XFILLER_33_239 VPWR VGND sg13cmos5l_decap_8
XFILLER_37_95 VPWR VGND sg13cmos5l_decap_8
XFILLER_5_162 VPWR VGND sg13cmos5l_decap_8
X_0770_ Tile_X0Y0_WW4BEG[3] _1050_/X VPWR VGND sg13cmos5l_buf_1
XFILLER_110_222 VPWR VGND sg13cmos5l_decap_8
X_1184_ _1184_/X _0649_/Q _1209_/X _1213_/X _1196_/X _0448_/Q _0447_/Q VPWR VGND sg13cmos5l_mux4_1
X_0204_ _0204_/Q Tile_X0Y0_FrameData[16] VGND VPWR Tile_X0Y1_FrameStrobe[3] latch
X_0135_ _0135_/Q Tile_X0Y0_FrameData[21] VGND VPWR Tile_X0Y1_FrameStrobe[1] latch
XFILLER_91_194 VPWR VGND sg13cmos5l_decap_8
XANTENNA__0805__X Tile_X0Y0_FrameStrobe_O[2] VPWR VGND sg13cmos5l_antennanp
X_0968_ Tile_X0Y1_WW4BEG[11] _1174_/X VPWR VGND sg13cmos5l_buf_1
X_0899_ Tile_X0Y1_S2BEG[7] _1134_/X VPWR VGND sg13cmos5l_buf_1
XFILLER_99_272 VPWR VGND sg13cmos5l_fill_1
XFILLER_99_261 VPWR VGND sg13cmos5l_decap_8
XFILLER_101_244 VPWR VGND sg13cmos5l_decap_8
XFILLER_114_34 VPWR VGND sg13cmos5l_decap_8
XFILLER_59_147 VPWR VGND sg13cmos5l_decap_8
XFILLER_74_106 VPWR VGND sg13cmos5l_decap_8
XFILLER_99_13 VPWR VGND sg13cmos5l_decap_4
XFILLER_2_132 VPWR VGND sg13cmos5l_fill_1
XFILLER_48_72 VPWR VGND sg13cmos5l_fill_1
XFILLER_14_272 VPWR VGND sg13cmos5l_fill_1
XFILLER_64_93 VPWR VGND sg13cmos5l_decap_4
X_0822_ Tile_X0Y0_FrameStrobe_O[19] Tile_X0Y1_FrameStrobe[19] VPWR VGND sg13cmos5l_buf_1
XFILLER_9_77 VPWR VGND sg13cmos5l_fill_1
XFILLER_88_209 VPWR VGND sg13cmos5l_decap_8
X_0753_ Tile_X0Y0_N4BEG[2] Tile_X0Y1_N4END[10] VPWR VGND sg13cmos5l_buf_1
X_0684_ _0684_/L_HI VPWR VGND sg13cmos5l_tiehi
XFILLER_29_0 VPWR VGND sg13cmos5l_fill_2
XFILLER_96_220 VPWR VGND sg13cmos5l_decap_8
X_1098_ _1098_/X _1109_/X Tile_X0Y1_N2MID[6] Tile_X0Y0_S2MID[6] Tile_X0Y0_S2END[6]
+ _0104_/Q _0103_/Q VPWR VGND sg13cmos5l_mux4_1
X_1167_ _1167_/X _0644_/Q _0648_/Q _1214_/X _1198_/X _0482_/Q _0481_/Q VPWR VGND sg13cmos5l_mux4_1
X_0118_ _0118_/Q Tile_X0Y0_FrameData[6] VGND VPWR Tile_X0Y1_FrameStrobe[0] latch
XFILLER_100_69 VPWR VGND sg13cmos5l_decap_8
XFILLER_118_185 VPWR VGND sg13cmos5l_decap_8
XFILLER_47_139 VPWR VGND sg13cmos5l_decap_8
XFILLER_11_242 VPWR VGND sg13cmos5l_decap_8
XFILLER_70_197 VPWR VGND sg13cmos5l_decap_8
XFILLER_7_202 VPWR VGND sg13cmos5l_decap_8
XFILLER_109_163 VPWR VGND sg13cmos5l_decap_8
XFILLER_50_84 VPWR VGND sg13cmos5l_fill_1
XFILLER_7_268 VPWR VGND sg13cmos5l_decap_4
XFILLER_38_128 VPWR VGND sg13cmos5l_decap_8
XFILLER_59_93 VPWR VGND sg13cmos5l_fill_1
XFILLER_93_201 VPWR VGND sg13cmos5l_decap_8
XFILLER_46_194 VPWR VGND sg13cmos5l_decap_8
XFILLER_61_186 VPWR VGND sg13cmos5l_decap_8
X_1021_ _1021_/X Tile_X0Y0_E1END[1] Tile_X0Y0_EE4END[13] Tile_X0Y0_E6END[5] _1089_/X
+ _0283_/Q _0282_/Q VPWR VGND sg13cmos5l_mux4_1
X_0805_ Tile_X0Y0_FrameStrobe_O[2] Tile_X0Y1_FrameStrobe[2] VPWR VGND sg13cmos5l_buf_1
XFILLER_91_91 VPWR VGND sg13cmos5l_fill_2
XFILLER_115_100 VPWR VGND sg13cmos5l_decap_8
XFILLER_115_144 VPWR VGND sg13cmos5l_decap_8
X_0736_ Tile_X0Y0_W2BEGb[5] _1044_/X VPWR VGND sg13cmos5l_buf_1
X_0667_ _0667_/L_HI VPWR VGND sg13cmos5l_tiehi
X_0598_ _0598_/Q Tile_X0Y1_FrameData[4] VGND VPWR Tile_X0Y1_FrameStrobe[7] latch
XFILLER_44_109 VPWR VGND sg13cmos5l_fill_2
XFILLER_69_264 VPWR VGND sg13cmos5l_decap_8
XFILLER_84_223 VPWR VGND sg13cmos5l_decap_8
X_1219_ _1219_/X Tile_X0Y0_E2MID[7] Tile_X0Y0_E2END[7] Tile_X0Y0_E6END[8] _1092_/X
+ _0302_/Q _0301_/Q VPWR VGND sg13cmos5l_mux4_1
XFILLER_111_35 VPWR VGND sg13cmos5l_decap_8
XFILLER_52_175 VPWR VGND sg13cmos5l_decap_8
XFILLER_106_100 VPWR VGND sg13cmos5l_decap_4
XFILLER_106_155 VPWR VGND sg13cmos5l_decap_8
XFILLER_4_205 VPWR VGND sg13cmos5l_decap_8
XFILLER_75_212 VPWR VGND sg13cmos5l_decap_8
XFILLER_96_36 VPWR VGND sg13cmos5l_decap_4
XFILLER_45_51 VPWR VGND sg13cmos5l_fill_1
XFILLER_45_95 VPWR VGND sg13cmos5l_fill_2
XFILLER_90_248 VPWR VGND sg13cmos5l_decap_8
XANTENNA__0903__X Tile_X0Y1_S2BEGb[3] VPWR VGND sg13cmos5l_antennanp
XANTENNA_5 Tile_X0Y0_FrameData[22] VPWR VGND sg13cmos5l_antennanp
XFILLER_112_125 VPWR VGND sg13cmos5l_decap_8
XFILLER_6_56 VPWR VGND sg13cmos5l_decap_8
X_0521_ _0521_/Q Tile_X0Y1_FrameData[17] VGND VPWR Tile_X0Y1_FrameStrobe[5] latch
X_0452_ _0452_/Q Tile_X0Y1_FrameData[22] VGND VPWR Tile_X0Y1_FrameStrobe[3] latch
XFILLER_66_234 VPWR VGND sg13cmos5l_decap_8
X_0383_ _0383_/Q Tile_X0Y1_FrameData[27] VGND VPWR Tile_X0Y1_FrameStrobe[1] latch
X_1004_ _1004_/X Tile_X0Y0_E2MID[6] Tile_X0Y0_E2END[6] Tile_X0Y0_E6END[6] _1093_/X
+ _0336_/Q _0335_/Q VPWR VGND sg13cmos5l_mux4_1
XFILLER_96_0 VPWR VGND sg13cmos5l_fill_2
XANTENNA__0813__X Tile_X0Y0_FrameStrobe_O[10] VPWR VGND sg13cmos5l_antennanp
XFILLER_66_28 VPWR VGND sg13cmos5l_decap_8
X_0719_ Tile_X0Y0_W1BEG[0] _1027_/X VPWR VGND sg13cmos5l_buf_1
XFILLER_25_120 VPWR VGND sg13cmos5l_decap_8
XFILLER_72_237 VPWR VGND sg13cmos5l_decap_8
XANTENNA__0723__X Tile_X0Y0_W2BEG[0] VPWR VGND sg13cmos5l_antennanp
XFILLER_40_189 VPWR VGND sg13cmos5l_decap_8
XFILLER_31_97 VPWR VGND sg13cmos5l_decap_8
XFILLER_0_252 VPWR VGND sg13cmos5l_fill_2
XFILLER_48_201 VPWR VGND sg13cmos5l_decap_8
XFILLER_63_204 VPWR VGND sg13cmos5l_decap_8
XFILLER_16_164 VPWR VGND sg13cmos5l_decap_8
XFILLER_31_134 VPWR VGND sg13cmos5l_fill_2
XFILLER_100_128 VPWR VGND sg13cmos5l_decap_4
X_0504_ _0504_/Q Tile_X0Y1_FrameData[2] VGND VPWR Tile_X0Y1_FrameStrobe[4] latch
X_0435_ _0435_/Q Tile_X0Y1_FrameData[7] VGND VPWR Tile_X0Y1_FrameStrobe[2] latch
XFILLER_98_145 VPWR VGND sg13cmos5l_decap_8
XANTENNA__0808__X Tile_X0Y0_FrameStrobe_O[5] VPWR VGND sg13cmos5l_antennanp
XFILLER_11_0 VPWR VGND sg13cmos5l_decap_4
XFILLER_39_267 VPWR VGND sg13cmos5l_decap_4
XFILLER_54_204 VPWR VGND sg13cmos5l_decap_8
XFILLER_54_259 VPWR VGND sg13cmos5l_fill_2
X_0366_ _0366_/Q Tile_X0Y1_FrameData[12] VGND VPWR Tile_X0Y1_FrameStrobe[0] latch
X_0297_ _0297_/Q Tile_X0Y0_FrameData[19] VGND VPWR Tile_X0Y1_FrameStrobe[6] latch
XFILLER_22_101 VPWR VGND sg13cmos5l_fill_2
XFILLER_108_228 VPWR VGND sg13cmos5l_decap_8
XFILLER_116_250 VPWR VGND sg13cmos5l_decap_8
XFILLER_89_101 VPWR VGND sg13cmos5l_fill_1
XFILLER_89_112 VPWR VGND sg13cmos5l_decap_8
XANTENNA__0718__X Tile_X0Y0_UserCLKo VPWR VGND sg13cmos5l_antennanp
XFILLER_77_38 VPWR VGND sg13cmos5l_decap_8
XFILLER_89_156 VPWR VGND sg13cmos5l_decap_8
XFILLER_53_270 VPWR VGND sg13cmos5l_fill_2
XFILLER_42_96 VPWR VGND sg13cmos5l_decap_8
XFILLER_47_9 VPWR VGND sg13cmos5l_fill_1
XFILLER_36_226 VPWR VGND sg13cmos5l_decap_8
X_0220_ _0220_/Q Tile_X0Y0_FrameData[0] VGND VPWR Tile_X0Y1_FrameStrobe[3] latch
X_0151_ _0151_/Q Tile_X0Y0_FrameData[5] VGND VPWR Tile_X0Y1_FrameStrobe[1] latch
X_0082_ _0763_/A _1011_/X _1012_/X _0320_/Q VPWR VGND sg13cmos5l_mux2_1
X_0984_ _0984_/X Tile_X0Y1_EE4END[2] Tile_X0Y1_EE4END[10] Tile_X0Y1_E6END[2] _1205_/X
+ _0430_/Q _0429_/Q VPWR VGND sg13cmos5l_mux4_1
XFILLER_59_0 VPWR VGND sg13cmos5l_fill_2
XFILLER_8_171 VPWR VGND sg13cmos5l_decap_8
XFILLER_113_264 VPWR VGND sg13cmos5l_fill_1
XFILLER_86_159 VPWR VGND sg13cmos5l_fill_1
X_0418_ _0418_/Q Tile_X0Y1_FrameData[24] VGND VPWR Tile_X0Y1_FrameStrobe[2] latch
X_0349_ _0349_/Q Tile_X0Y1_FrameData[29] VGND VPWR Tile_X0Y1_FrameStrobe[0] latch
XFILLER_103_69 VPWR VGND sg13cmos5l_fill_2
XFILLER_10_115 VPWR VGND sg13cmos5l_fill_1
XFILLER_12_11 VPWR VGND sg13cmos5l_fill_1
XFILLER_104_264 VPWR VGND sg13cmos5l_decap_8
XFILLER_77_104 VPWR VGND sg13cmos5l_decap_8
XFILLER_33_218 VPWR VGND sg13cmos5l_decap_8
XFILLER_37_63 VPWR VGND sg13cmos5l_decap_8
XFILLER_37_85 VPWR VGND sg13cmos5l_fill_2
XFILLER_41_262 VPWR VGND sg13cmos5l_decap_8
XFILLER_53_51 VPWR VGND sg13cmos5l_fill_1
XANTENNA__0911__X Tile_X0Y1_S4BEG[3] VPWR VGND sg13cmos5l_antennanp
XFILLER_5_141 VPWR VGND sg13cmos5l_decap_8
XFILLER_110_201 VPWR VGND sg13cmos5l_decap_8
XFILLER_78_92 VPWR VGND sg13cmos5l_decap_8
X_0203_ _0203_/Q Tile_X0Y0_FrameData[17] VGND VPWR Tile_X0Y1_FrameStrobe[3] latch
X_1183_ _1183_/X _0648_/Q _1210_/X _1214_/X _1195_/X _0450_/Q _0449_/Q VPWR VGND sg13cmos5l_mux4_1
X_0134_ _0134_/Q Tile_X0Y0_FrameData[22] VGND VPWR Tile_X0Y1_FrameStrobe[1] latch
XFILLER_91_173 VPWR VGND sg13cmos5l_decap_8
XANTENNA__0821__X Tile_X0Y0_FrameStrobe_O[18] VPWR VGND sg13cmos5l_antennanp
X_0967_ Tile_X0Y1_WW4BEG[10] _1173_/X VPWR VGND sg13cmos5l_buf_1
XFILLER_101_223 VPWR VGND sg13cmos5l_decap_8
XFILLER_59_126 VPWR VGND sg13cmos5l_decap_8
X_0898_ Tile_X0Y1_S2BEG[6] _1133_/X VPWR VGND sg13cmos5l_buf_1
XFILLER_99_240 VPWR VGND sg13cmos5l_decap_8
XFILLER_67_192 VPWR VGND sg13cmos5l_decap_8
XFILLER_82_162 VPWR VGND sg13cmos5l_decap_8
XFILLER_15_229 VPWR VGND sg13cmos5l_decap_8
XFILLER_23_262 VPWR VGND sg13cmos5l_decap_8
XFILLER_82_184 VPWR VGND sg13cmos5l_decap_8
XANTENNA__0731__X Tile_X0Y0_W2BEGb[0] VPWR VGND sg13cmos5l_antennanp
XFILLER_2_100 VPWR VGND sg13cmos5l_decap_4
XFILLER_3_2 VPWR VGND sg13cmos5l_fill_1
XANTENNA__0906__X Tile_X0Y1_S2BEGb[6] VPWR VGND sg13cmos5l_antennanp
XFILLER_0_14 VPWR VGND sg13cmos5l_decap_8
XFILLER_0_25 VPWR VGND sg13cmos5l_fill_2
XFILLER_73_162 VPWR VGND sg13cmos5l_decap_4
XFILLER_73_184 VPWR VGND sg13cmos5l_decap_8
XFILLER_80_60 VPWR VGND sg13cmos5l_fill_1
XFILLER_80_93 VPWR VGND sg13cmos5l_fill_2
X_0821_ Tile_X0Y0_FrameStrobe_O[18] Tile_X0Y1_FrameStrobe[18] VPWR VGND sg13cmos5l_buf_1
X_0752_ Tile_X0Y0_N4BEG[1] Tile_X0Y1_N4END[9] VPWR VGND sg13cmos5l_buf_1
XFILLER_9_89 VPWR VGND sg13cmos5l_fill_1
X_0683_ _0683_/L_HI VPWR VGND sg13cmos5l_tiehi
X_1235_ _1235_/X Tile_X0Y0_E1END[1] Tile_X0Y0_E6END[1] _1101_/X _1235_/A3 _0152_/Q
+ _0151_/Q VPWR VGND sg13cmos5l_mux4_1
X_1166_ _1166_/X _0647_/Q _0651_/Q _1215_/X _1199_/X _0484_/Q _0483_/Q VPWR VGND sg13cmos5l_mux4_1
XANTENNA__0816__X Tile_X0Y0_FrameStrobe_O[13] VPWR VGND sg13cmos5l_antennanp
XFILLER_100_37 VPWR VGND sg13cmos5l_decap_8
XFILLER_64_184 VPWR VGND sg13cmos5l_decap_8
X_1097_ _1097_/X _1108_/X Tile_X0Y1_N2MID[5] Tile_X0Y0_S2MID[5] Tile_X0Y0_S2END[5]
+ _0106_/Q _0105_/Q VPWR VGND sg13cmos5l_mux4_1
X_0117_ _0117_/Q Tile_X0Y0_FrameData[7] VGND VPWR Tile_X0Y1_FrameStrobe[0] latch
XFILLER_107_8 VPWR VGND sg13cmos5l_decap_8
XFILLER_109_79 VPWR VGND sg13cmos5l_decap_8
XFILLER_118_164 VPWR VGND sg13cmos5l_decap_8
XFILLER_20_243 VPWR VGND sg13cmos5l_decap_8
XFILLER_69_17 VPWR VGND sg13cmos5l_decap_4
XFILLER_69_28 VPWR VGND sg13cmos5l_fill_2
XFILLER_87_254 VPWR VGND sg13cmos5l_decap_8
XANTENNA__0726__X Tile_X0Y0_W2BEG[3] VPWR VGND sg13cmos5l_antennanp
XFILLER_18_43 VPWR VGND sg13cmos5l_decap_4
XFILLER_18_76 VPWR VGND sg13cmos5l_decap_8
XFILLER_55_184 VPWR VGND sg13cmos5l_decap_8
XFILLER_70_132 VPWR VGND sg13cmos5l_fill_2
XFILLER_11_221 VPWR VGND sg13cmos5l_decap_8
XFILLER_70_176 VPWR VGND sg13cmos5l_decap_8
XFILLER_109_142 VPWR VGND sg13cmos5l_decap_8
XFILLER_7_258 VPWR VGND sg13cmos5l_decap_8
XFILLER_38_107 VPWR VGND sg13cmos5l_decap_8
XFILLER_78_232 VPWR VGND sg13cmos5l_fill_2
X_1020_ _1020_/X _1087_/X _1083_/X _1075_/X _1096_/X _0286_/Q _0285_/Q VPWR VGND sg13cmos5l_mux4_1
XFILLER_93_257 VPWR VGND sg13cmos5l_decap_8
XFILLER_46_173 VPWR VGND sg13cmos5l_decap_8
XFILLER_61_165 VPWR VGND sg13cmos5l_decap_8
X_0804_ Tile_X0Y0_FrameStrobe_O[1] Tile_X0Y1_FrameStrobe[1] VPWR VGND sg13cmos5l_buf_1
X_0735_ Tile_X0Y0_W2BEGb[4] _1043_/X VPWR VGND sg13cmos5l_buf_1
XFILLER_29_118 VPWR VGND sg13cmos5l_decap_4
XFILLER_41_0 VPWR VGND sg13cmos5l_fill_1
XFILLER_69_243 VPWR VGND sg13cmos5l_decap_8
XFILLER_84_202 VPWR VGND sg13cmos5l_decap_8
X_0666_ _0666_/L_HI VPWR VGND sg13cmos5l_tiehi
X_0597_ _0597_/Q Tile_X0Y1_FrameData[5] VGND VPWR Tile_X0Y1_FrameStrobe[7] latch
XFILLER_111_14 VPWR VGND sg13cmos5l_decap_8
X_1218_ _1218_/X Tile_X0Y1_N1END[3] Tile_X0Y1_N4END[3] _1230_/X Tile_X0Y0_S4END[7]
+ _0372_/Q _0371_/Q VPWR VGND sg13cmos5l_mux4_1
X_1149_ _1149_/X Tile_X0Y1_E2END[2] _0646_/Q _1197_/X _1200_/X _0518_/Q _0517_/Q VPWR
+ VGND sg13cmos5l_mux4_1
XFILLER_106_134 VPWR VGND sg13cmos5l_decap_8
XFILLER_96_15 VPWR VGND sg13cmos5l_decap_4
XFILLER_75_268 VPWR VGND sg13cmos5l_decap_4
XFILLER_28_195 VPWR VGND sg13cmos5l_decap_8
XFILLER_45_30 VPWR VGND sg13cmos5l_fill_1
XFILLER_90_227 VPWR VGND sg13cmos5l_decap_8
XANTENNA_6 Tile_X0Y0_FrameData[22] VPWR VGND sg13cmos5l_antennanp
XFILLER_101_91 VPWR VGND sg13cmos5l_fill_2
XFILLER_61_84 VPWR VGND sg13cmos5l_fill_1
XFILLER_3_272 VPWR VGND sg13cmos5l_fill_1
X_0520_ _0520_/Q Tile_X0Y1_FrameData[18] VGND VPWR Tile_X0Y1_FrameStrobe[5] latch
X_0451_ _0451_/Q Tile_X0Y1_FrameData[23] VGND VPWR Tile_X0Y1_FrameStrobe[3] latch
X_0382_ _0382_/Q Tile_X0Y1_FrameData[28] VGND VPWR Tile_X0Y1_FrameStrobe[1] latch
XFILLER_19_195 VPWR VGND sg13cmos5l_decap_8
XFILLER_66_213 VPWR VGND sg13cmos5l_decap_8
XFILLER_86_81 VPWR VGND sg13cmos5l_decap_8
X_1003_ _1003_/X Tile_X0Y0_E2MID[7] Tile_X0Y0_E2END[7] Tile_X0Y0_E6END[7] _1092_/X
+ _0338_/Q _0337_/Q VPWR VGND sg13cmos5l_mux4_1
XFILLER_34_187 VPWR VGND sg13cmos5l_decap_8
XFILLER_89_0 VPWR VGND sg13cmos5l_fill_2
X_0718_ Tile_X0Y0_UserCLKo Tile_X0Y0_UserCLK VPWR VGND sg13cmos5l_buf_1
XFILLER_57_235 VPWR VGND sg13cmos5l_decap_4
X_0649_ _0649_/Q Tile_X0Y1_UserCLK NPU_ACT_RDATA5 _0657_/L_HI VPWR VGND sg13cmos5l_dfrbpq_1
XFILLER_25_187 VPWR VGND sg13cmos5l_decap_8
XFILLER_72_216 VPWR VGND sg13cmos5l_decap_8
XFILLER_80_260 VPWR VGND sg13cmos5l_decap_8
XFILLER_80_271 VPWR VGND sg13cmos5l_fill_2
XFILLER_15_99 VPWR VGND sg13cmos5l_decap_8
XFILLER_40_168 VPWR VGND sg13cmos5l_decap_8
XFILLER_0_231 VPWR VGND sg13cmos5l_decap_8
XFILLER_48_257 VPWR VGND sg13cmos5l_decap_4
XFILLER_56_62 VPWR VGND sg13cmos5l_decap_8
XFILLER_56_84 VPWR VGND sg13cmos5l_decap_4
XANTENNA__0914__X Tile_X0Y1_S4BEG[6] VPWR VGND sg13cmos5l_antennanp
XFILLER_31_146 VPWR VGND sg13cmos5l_fill_1
XFILLER_31_179 VPWR VGND sg13cmos5l_decap_8
XFILLER_71_271 VPWR VGND sg13cmos5l_fill_2
XFILLER_39_246 VPWR VGND sg13cmos5l_decap_8
X_0503_ _0503_/Q Tile_X0Y1_FrameData[3] VGND VPWR Tile_X0Y1_FrameStrobe[4] latch
X_0434_ _0434_/Q Tile_X0Y1_FrameData[8] VGND VPWR Tile_X0Y1_FrameStrobe[2] latch
X_0365_ _0365_/Q Tile_X0Y1_FrameData[13] VGND VPWR Tile_X0Y1_FrameStrobe[0] latch
XFILLER_98_124 VPWR VGND sg13cmos5l_decap_8
XANTENNA__0824__X Tile_X0Y1_FrameData_O[0] VPWR VGND sg13cmos5l_antennanp
XFILLER_62_271 VPWR VGND sg13cmos5l_fill_2
X_0296_ _0296_/Q Tile_X0Y0_FrameData[20] VGND VPWR Tile_X0Y1_FrameStrobe[6] latch
XFILLER_108_207 VPWR VGND sg13cmos5l_decap_8
XFILLER_22_146 VPWR VGND sg13cmos5l_decap_4
XFILLER_22_179 VPWR VGND sg13cmos5l_decap_8
XFILLER_45_227 VPWR VGND sg13cmos5l_decap_4
XANTENNA__0734__X Tile_X0Y0_W2BEGb[3] VPWR VGND sg13cmos5l_antennanp
XFILLER_13_113 VPWR VGND sg13cmos5l_fill_2
XFILLER_26_65 VPWR VGND sg13cmos5l_decap_4
XFILLER_42_31 VPWR VGND sg13cmos5l_decap_8
XFILLER_42_42 VPWR VGND sg13cmos5l_fill_2
XFILLER_107_262 VPWR VGND sg13cmos5l_decap_8
XFILLER_42_75 VPWR VGND sg13cmos5l_decap_8
XANTENNA__0909__X Tile_X0Y1_S4BEG[1] VPWR VGND sg13cmos5l_antennanp
XFILLER_3_36 VPWR VGND sg13cmos5l_fill_2
XFILLER_36_205 VPWR VGND sg13cmos5l_decap_8
XFILLER_44_271 VPWR VGND sg13cmos5l_fill_2
XFILLER_67_94 VPWR VGND sg13cmos5l_decap_8
XFILLER_83_60 VPWR VGND sg13cmos5l_fill_1
X_0150_ _0150_/Q Tile_X0Y0_FrameData[6] VGND VPWR Tile_X0Y1_FrameStrobe[1] latch
X_0081_ _0764_/A _1013_/X _1014_/X _0317_/Q VPWR VGND sg13cmos5l_mux2_1
X_0983_ _0983_/X Tile_X0Y1_EE4END[1] Tile_X0Y1_EE4END[9] Tile_X0Y1_E6END[1] _1204_/X
+ _0432_/Q _0431_/Q VPWR VGND sg13cmos5l_mux4_1
XFILLER_113_243 VPWR VGND sg13cmos5l_decap_8
XANTENNA__0819__X Tile_X0Y0_FrameStrobe_O[16] VPWR VGND sg13cmos5l_antennanp
XFILLER_103_37 VPWR VGND sg13cmos5l_decap_4
XFILLER_27_227 VPWR VGND sg13cmos5l_decap_8
XFILLER_79_190 VPWR VGND sg13cmos5l_decap_8
X_0417_ _0417_/Q Tile_X0Y1_FrameData[25] VGND VPWR Tile_X0Y1_FrameStrobe[2] latch
X_0348_ _0348_/Q Tile_X0Y1_FrameData[30] VGND VPWR Tile_X0Y1_FrameStrobe[0] latch
XFILLER_94_193 VPWR VGND sg13cmos5l_decap_8
X_0279_ _0279_/Q Tile_X0Y0_FrameData[5] VGND VPWR Tile_X0Y1_FrameStrobe[5] latch
XFILLER_10_149 VPWR VGND sg13cmos5l_decap_8
XFILLER_12_78 VPWR VGND sg13cmos5l_fill_1
XANTENNA__0729__X Tile_X0Y0_W2BEG[6] VPWR VGND sg13cmos5l_antennanp
XFILLER_104_254 VPWR VGND sg13cmos5l_decap_4
XFILLER_18_249 VPWR VGND sg13cmos5l_decap_8
XFILLER_37_20 VPWR VGND sg13cmos5l_fill_1
XFILLER_37_42 VPWR VGND sg13cmos5l_decap_8
XFILLER_92_108 VPWR VGND sg13cmos5l_decap_8
XFILLER_41_241 VPWR VGND sg13cmos5l_decap_8
XFILLER_52_8 VPWR VGND sg13cmos5l_decap_4
XFILLER_5_197 VPWR VGND sg13cmos5l_decap_8
XFILLER_78_60 VPWR VGND sg13cmos5l_fill_2
XFILLER_110_257 VPWR VGND sg13cmos5l_decap_8
XFILLER_68_116 VPWR VGND sg13cmos5l_decap_8
XFILLER_68_127 VPWR VGND sg13cmos5l_fill_2
X_1182_ _1182_/X Tile_X0Y1_N4END[3] Tile_X0Y0_S4END[7] _1211_/X _1215_/X _0452_/Q
+ _0451_/Q VPWR VGND sg13cmos5l_mux4_1
X_0202_ _0202_/Q Tile_X0Y0_FrameData[18] VGND VPWR Tile_X0Y1_FrameStrobe[3] latch
X_0133_ _0133_/Q Tile_X0Y0_FrameData[23] VGND VPWR Tile_X0Y1_FrameStrobe[1] latch
XFILLER_17_260 VPWR VGND sg13cmos5l_decap_8
XFILLER_17_271 VPWR VGND sg13cmos5l_fill_2
XFILLER_24_219 VPWR VGND sg13cmos5l_decap_8
XFILLER_94_92 VPWR VGND sg13cmos5l_decap_8
XFILLER_91_152 VPWR VGND sg13cmos5l_decap_8
XFILLER_71_0 VPWR VGND sg13cmos5l_decap_4
X_0897_ Tile_X0Y1_S2BEG[5] _1132_/X VPWR VGND sg13cmos5l_buf_1
X_0966_ Tile_X0Y1_WW4BEG[9] _1172_/X VPWR VGND sg13cmos5l_buf_1
XFILLER_101_202 VPWR VGND sg13cmos5l_decap_8
XFILLER_114_14 VPWR VGND sg13cmos5l_decap_8
XFILLER_114_25 VPWR VGND sg13cmos5l_fill_2
XFILLER_114_69 VPWR VGND sg13cmos5l_decap_8
XFILLER_67_160 VPWR VGND sg13cmos5l_fill_1
XFILLER_67_171 VPWR VGND sg13cmos5l_decap_8
XFILLER_23_241 VPWR VGND sg13cmos5l_decap_8
XFILLER_23_66 VPWR VGND sg13cmos5l_fill_1
XFILLER_23_88 VPWR VGND sg13cmos5l_fill_2
XFILLER_2_167 VPWR VGND sg13cmos5l_decap_8
XFILLER_48_63 VPWR VGND sg13cmos5l_fill_2
XFILLER_58_193 VPWR VGND sg13cmos5l_decap_8
XFILLER_65_119 VPWR VGND sg13cmos5l_fill_2
XFILLER_14_252 VPWR VGND sg13cmos5l_decap_8
XFILLER_14_263 VPWR VGND sg13cmos5l_fill_2
XFILLER_9_35 VPWR VGND sg13cmos5l_decap_4
XANTENNA__0922__X Tile_X0Y1_S4BEG[14] VPWR VGND sg13cmos5l_antennanp
X_0820_ Tile_X0Y0_FrameStrobe_O[17] Tile_X0Y1_FrameStrobe[17] VPWR VGND sg13cmos5l_buf_1
X_0751_ Tile_X0Y0_N4BEG[0] Tile_X0Y1_N4END[8] VPWR VGND sg13cmos5l_buf_1
X_0682_ _0682_/L_HI VPWR VGND sg13cmos5l_tiehi
XFILLER_96_255 VPWR VGND sg13cmos5l_decap_8
XFILLER_64_163 VPWR VGND sg13cmos5l_decap_8
X_1096_ _1096_/X _1107_/X Tile_X0Y1_N2MID[4] Tile_X0Y0_S2MID[4] Tile_X0Y0_S2END[4]
+ _0108_/Q _0107_/Q VPWR VGND sg13cmos5l_mux4_1
X_1234_ _1234_/X Tile_X0Y0_E1END[2] Tile_X0Y0_E6END[2] _1102_/X _1234_/A3 _0150_/Q
+ _0149_/Q VPWR VGND sg13cmos5l_mux4_1
X_1165_ _1165_/X _0646_/Q _0650_/Q _1216_/X _1200_/X _0486_/Q _0485_/Q VPWR VGND sg13cmos5l_mux4_1
X_0116_ _0116_/Q Tile_X0Y0_FrameData[8] VGND VPWR Tile_X0Y1_FrameStrobe[0] latch
XANTENNA__0832__X Tile_X0Y1_FrameData_O[8] VPWR VGND sg13cmos5l_antennanp
XFILLER_20_222 VPWR VGND sg13cmos5l_decap_8
XFILLER_109_36 VPWR VGND sg13cmos5l_fill_2
XFILLER_118_143 VPWR VGND sg13cmos5l_decap_8
X_0949_ Tile_X0Y1_W6BEG[4] _1183_/X VPWR VGND sg13cmos5l_buf_1
XFILLER_87_233 VPWR VGND sg13cmos5l_decap_8
XFILLER_70_100 VPWR VGND sg13cmos5l_decap_8
XANTENNA__0742__X Tile_X0Y0_W6BEG[3] VPWR VGND sg13cmos5l_antennanp
XFILLER_109_121 VPWR VGND sg13cmos5l_decap_8
XFILLER_11_200 VPWR VGND sg13cmos5l_decap_8
XFILLER_34_98 VPWR VGND sg13cmos5l_decap_8
XFILLER_50_42 VPWR VGND sg13cmos5l_decap_8
XFILLER_50_53 VPWR VGND sg13cmos5l_fill_1
XFILLER_7_237 VPWR VGND sg13cmos5l_decap_8
XFILLER_109_198 VPWR VGND sg13cmos5l_decap_8
XFILLER_1_0 VPWR VGND sg13cmos5l_decap_8
XFILLER_78_211 VPWR VGND sg13cmos5l_decap_8
XANTENNA__0917__X Tile_X0Y1_S4BEG[9] VPWR VGND sg13cmos5l_antennanp
XFILLER_46_152 VPWR VGND sg13cmos5l_decap_8
XFILLER_75_83 VPWR VGND sg13cmos5l_decap_8
XFILLER_78_266 VPWR VGND sg13cmos5l_decap_8
XFILLER_93_236 VPWR VGND sg13cmos5l_decap_8
XFILLER_61_144 VPWR VGND sg13cmos5l_decap_8
XFILLER_115_124 VPWR VGND sg13cmos5l_decap_8
X_0803_ Tile_X0Y0_FrameStrobe_O[0] Tile_X0Y1_FrameStrobe[0] VPWR VGND sg13cmos5l_buf_1
X_0734_ Tile_X0Y0_W2BEGb[3] _1042_/X VPWR VGND sg13cmos5l_buf_1
X_0665_ _0665_/L_HI VPWR VGND sg13cmos5l_tiehi
XFILLER_115_179 VPWR VGND sg13cmos5l_decap_8
XFILLER_34_0 VPWR VGND sg13cmos5l_fill_1
XFILLER_69_222 VPWR VGND sg13cmos5l_decap_8
X_0596_ _0596_/Q Tile_X0Y1_FrameData[6] VGND VPWR Tile_X0Y1_FrameStrobe[7] latch
XANTENNA__0827__X Tile_X0Y1_FrameData_O[3] VPWR VGND sg13cmos5l_antennanp
XFILLER_37_174 VPWR VGND sg13cmos5l_fill_1
XFILLER_37_185 VPWR VGND sg13cmos5l_decap_8
XFILLER_84_258 VPWR VGND sg13cmos5l_decap_8
X_1079_ _1079_/X _1114_/X Tile_X0Y1_N4END[7] Tile_X0Y0_S1END[3] Tile_X0Y0_S4END[3]
+ _0118_/Q _0117_/Q VPWR VGND sg13cmos5l_mux4_1
X_1217_ _1217_/X Tile_X0Y1_N1END[2] Tile_X0Y1_N4END[2] _1229_/X Tile_X0Y0_S4END[6]
+ _0374_/Q _0373_/Q VPWR VGND sg13cmos5l_mux4_1
X_1148_ _1148_/X Tile_X0Y1_E2MID[3] _0645_/Q _1196_/X _1201_/X _0520_/Q _0519_/Q VPWR
+ VGND sg13cmos5l_mux4_1
XFILLER_106_113 VPWR VGND sg13cmos5l_decap_8
XANTENNA__0737__X Tile_X0Y0_W2BEGb[6] VPWR VGND sg13cmos5l_antennanp
XFILLER_29_54 VPWR VGND sg13cmos5l_decap_8
XFILLER_75_247 VPWR VGND sg13cmos5l_decap_8
XFILLER_90_206 VPWR VGND sg13cmos5l_decap_8
XFILLER_43_188 VPWR VGND sg13cmos5l_decap_8
XFILLER_45_42 VPWR VGND sg13cmos5l_fill_2
XANTENNA_7 Tile_X0Y0_FrameData[22] VPWR VGND sg13cmos5l_antennanp
XFILLER_105_190 VPWR VGND sg13cmos5l_decap_8
XFILLER_3_262 VPWR VGND sg13cmos5l_fill_2
X_0450_ _0450_/Q Tile_X0Y1_FrameData[24] VGND VPWR Tile_X0Y1_FrameStrobe[3] latch
X_0381_ _0381_/Q Tile_X0Y1_FrameData[29] VGND VPWR Tile_X0Y1_FrameStrobe[1] latch
XFILLER_19_174 VPWR VGND sg13cmos5l_decap_8
XFILLER_34_122 VPWR VGND sg13cmos5l_decap_8
XFILLER_34_144 VPWR VGND sg13cmos5l_fill_2
XFILLER_66_269 VPWR VGND sg13cmos5l_decap_4
XFILLER_81_217 VPWR VGND sg13cmos5l_decap_8
XFILLER_81_228 VPWR VGND sg13cmos5l_fill_1
XFILLER_81_239 VPWR VGND sg13cmos5l_decap_8
X_1002_ _1002_/X Tile_X0Y0_E1END[3] Tile_X0Y0_E6END[7] _1079_/X _1078_/X _0340_/Q
+ _0339_/Q VPWR VGND sg13cmos5l_mux4_1
XFILLER_103_149 VPWR VGND sg13cmos5l_decap_8
X_0717_ _0974_/A3 VPWR VGND sg13cmos5l_tielo
X_0648_ _0648_/Q Tile_X0Y1_UserCLK NPU_ACT_RDATA4 _0675_/L_HI VPWR VGND sg13cmos5l_dfrbpq_1
XFILLER_57_214 VPWR VGND sg13cmos5l_decap_8
X_0579_ _0579_/Q Tile_X0Y1_FrameData[23] VGND VPWR Tile_X0Y1_FrameStrobe[7] latch
XFILLER_15_23 VPWR VGND sg13cmos5l_decap_8
XFILLER_25_155 VPWR VGND sg13cmos5l_decap_8
XFILLER_40_103 VPWR VGND sg13cmos5l_fill_1
XFILLER_40_125 VPWR VGND sg13cmos5l_fill_2
XFILLER_31_66 VPWR VGND sg13cmos5l_fill_2
XFILLER_0_210 VPWR VGND sg13cmos5l_decap_8
XFILLER_16_122 VPWR VGND sg13cmos5l_fill_2
XFILLER_63_239 VPWR VGND sg13cmos5l_decap_8
XFILLER_71_250 VPWR VGND sg13cmos5l_decap_8
XFILLER_117_208 VPWR VGND sg13cmos5l_decap_8
XFILLER_16_188 VPWR VGND sg13cmos5l_decap_8
XFILLER_31_136 VPWR VGND sg13cmos5l_fill_1
XFILLER_31_158 VPWR VGND sg13cmos5l_decap_8
XFILLER_75_7 VPWR VGND sg13cmos5l_decap_8
XANTENNA__0930__X Tile_X0Y1_W2BEG[1] VPWR VGND sg13cmos5l_antennanp
X_0502_ _0502_/Q Tile_X0Y1_FrameData[4] VGND VPWR Tile_X0Y1_FrameStrobe[4] latch
XFILLER_39_225 VPWR VGND sg13cmos5l_decap_8
X_0433_ _0433_/Q Tile_X0Y1_FrameData[9] VGND VPWR Tile_X0Y1_FrameStrobe[2] latch
X_0364_ _0364_/Q Tile_X0Y1_FrameData[14] VGND VPWR Tile_X0Y1_FrameStrobe[0] latch
X_0295_ _0295_/Q Tile_X0Y0_FrameData[21] VGND VPWR Tile_X0Y1_FrameStrobe[6] latch
XFILLER_22_103 VPWR VGND sg13cmos5l_fill_1
XFILLER_22_125 VPWR VGND sg13cmos5l_decap_8
XFILLER_22_158 VPWR VGND sg13cmos5l_decap_8
XFILLER_62_250 VPWR VGND sg13cmos5l_decap_8
XANTENNA__0840__X Tile_X0Y1_FrameData_O[16] VPWR VGND sg13cmos5l_antennanp
XFILLER_30_180 VPWR VGND sg13cmos5l_decap_8
XFILLER_7_90 VPWR VGND sg13cmos5l_fill_1
XFILLER_77_29 VPWR VGND sg13cmos5l_fill_2
XFILLER_45_206 VPWR VGND sg13cmos5l_decap_8
XFILLER_60_209 VPWR VGND sg13cmos5l_decap_8
XFILLER_97_180 VPWR VGND sg13cmos5l_decap_8
XFILLER_42_54 VPWR VGND sg13cmos5l_decap_8
XFILLER_53_272 VPWR VGND sg13cmos5l_fill_1
XANTENNA__0750__X Tile_X0Y0_W6BEG[11] VPWR VGND sg13cmos5l_antennanp
XFILLER_101_0 VPWR VGND sg13cmos5l_fill_2
XFILLER_107_241 VPWR VGND sg13cmos5l_decap_8
XANTENNA__0925__X Tile_X0Y1_W1BEG[0] VPWR VGND sg13cmos5l_antennanp
X_0080_ _0923_/A _1141_/X _1142_/X _0531_/Q VPWR VGND sg13cmos5l_mux2_1
XFILLER_12_191 VPWR VGND sg13cmos5l_decap_8
X_0982_ _0982_/X Tile_X0Y1_EE4END[0] Tile_X0Y1_EE4END[8] Tile_X0Y1_E6END[0] _1203_/X
+ _0434_/Q _0433_/Q VPWR VGND sg13cmos5l_mux4_1
XFILLER_113_222 VPWR VGND sg13cmos5l_decap_8
XANTENNA__0835__X Tile_X0Y1_FrameData_O[11] VPWR VGND sg13cmos5l_antennanp
XFILLER_27_206 VPWR VGND sg13cmos5l_decap_8
XFILLER_42_209 VPWR VGND sg13cmos5l_decap_8
X_0416_ _0416_/Q Tile_X0Y1_FrameData[26] VGND VPWR Tile_X0Y1_FrameStrobe[2] latch
X_0347_ _0347_/Q Tile_X0Y0_FrameData[31] VGND VPWR Tile_X0Y1_FrameStrobe[0] latch
X_0278_ _0278_/Q Tile_X0Y0_FrameData[6] VGND VPWR Tile_X0Y1_FrameStrobe[5] latch
XFILLER_94_172 VPWR VGND sg13cmos5l_decap_8
XFILLER_10_106 VPWR VGND sg13cmos5l_fill_2
XFILLER_50_264 VPWR VGND sg13cmos5l_fill_1
XFILLER_104_233 VPWR VGND sg13cmos5l_decap_8
XFILLER_77_128 VPWR VGND sg13cmos5l_decap_8
XANTENNA__0745__X Tile_X0Y0_W6BEG[6] VPWR VGND sg13cmos5l_antennanp
XFILLER_18_228 VPWR VGND sg13cmos5l_decap_8
XFILLER_37_87 VPWR VGND sg13cmos5l_fill_1
XFILLER_41_220 VPWR VGND sg13cmos5l_decap_8
XFILLER_5_176 VPWR VGND sg13cmos5l_decap_8
XFILLER_110_236 VPWR VGND sg13cmos5l_decap_8
XFILLER_76_183 VPWR VGND sg13cmos5l_decap_8
X_1181_ _1181_/X Tile_X0Y1_N4END[2] Tile_X0Y0_S4END[6] _1212_/X _1216_/X _0454_/Q
+ _0453_/Q VPWR VGND sg13cmos5l_mux4_1
X_0201_ _0201_/Q Tile_X0Y0_FrameData[19] VGND VPWR Tile_X0Y1_FrameStrobe[3] latch
X_0132_ _0132_/Q Tile_X0Y0_FrameData[24] VGND VPWR Tile_X0Y1_FrameStrobe[1] latch
XFILLER_32_253 VPWR VGND sg13cmos5l_decap_8
XFILLER_64_0 VPWR VGND sg13cmos5l_fill_2
X_0896_ Tile_X0Y1_S2BEG[4] _1131_/X VPWR VGND sg13cmos5l_buf_1
X_0965_ Tile_X0Y1_WW4BEG[8] _1171_/X VPWR VGND sg13cmos5l_buf_1
XFILLER_101_258 VPWR VGND sg13cmos5l_decap_8
XFILLER_114_48 VPWR VGND sg13cmos5l_fill_1
XFILLER_114_59 VPWR VGND sg13cmos5l_fill_2
XFILLER_23_220 VPWR VGND sg13cmos5l_decap_8
XFILLER_23_45 VPWR VGND sg13cmos5l_fill_2
XFILLER_90_29 VPWR VGND sg13cmos5l_decap_8
XFILLER_2_124 VPWR VGND sg13cmos5l_fill_1
XFILLER_48_31 VPWR VGND sg13cmos5l_decap_8
XFILLER_58_172 VPWR VGND sg13cmos5l_decap_8
XFILLER_73_153 VPWR VGND sg13cmos5l_fill_2
XFILLER_14_231 VPWR VGND sg13cmos5l_decap_8
XFILLER_80_40 VPWR VGND sg13cmos5l_decap_4
X_0750_ Tile_X0Y0_W6BEG[11] _1074_/X VPWR VGND sg13cmos5l_buf_1
X_0681_ _0681_/L_HI VPWR VGND sg13cmos5l_tiehi
X_1233_ _1233_/X Tile_X0Y0_EE4END[2] Tile_X0Y0_EE4END[10] Tile_X0Y0_E6END[2] _1090_/X
+ _0174_/Q _0173_/Q VPWR VGND sg13cmos5l_mux4_1
XFILLER_96_234 VPWR VGND sg13cmos5l_decap_8
XFILLER_64_142 VPWR VGND sg13cmos5l_decap_8
X_1095_ _1095_/X _1106_/X Tile_X0Y1_N2MID[3] Tile_X0Y0_S2MID[3] Tile_X0Y0_S2END[3]
+ _0110_/Q _0109_/Q VPWR VGND sg13cmos5l_mux4_1
X_1164_ _1164_/X _0645_/Q _0649_/Q _1217_/X _1201_/X _0488_/Q _0487_/Q VPWR VGND sg13cmos5l_mux4_1
X_0115_ _0115_/Q Tile_X0Y0_FrameData[9] VGND VPWR Tile_X0Y1_FrameStrobe[0] latch
XFILLER_118_122 VPWR VGND sg13cmos5l_decap_8
XFILLER_20_201 VPWR VGND sg13cmos5l_decap_8
X_0948_ Tile_X0Y1_W6BEG[3] _1182_/X VPWR VGND sg13cmos5l_buf_1
XFILLER_118_199 VPWR VGND sg13cmos5l_decap_8
XFILLER_87_212 VPWR VGND sg13cmos5l_decap_8
X_0879_ Tile_X0Y0_FrameData_O[23] Tile_X0Y0_FrameData[23] VPWR VGND sg13cmos5l_buf_1
XFILLER_18_12 VPWR VGND sg13cmos5l_decap_8
XFILLER_109_100 VPWR VGND sg13cmos5l_decap_8
XFILLER_109_177 VPWR VGND sg13cmos5l_decap_8
XFILLER_11_256 VPWR VGND sg13cmos5l_decap_8
XFILLER_7_216 VPWR VGND sg13cmos5l_decap_8
XFILLER_78_234 VPWR VGND sg13cmos5l_fill_1
XFILLER_78_245 VPWR VGND sg13cmos5l_decap_8
XFILLER_15_9 VPWR VGND sg13cmos5l_decap_8
XFILLER_61_101 VPWR VGND sg13cmos5l_fill_1
XFILLER_61_123 VPWR VGND sg13cmos5l_decap_8
XFILLER_75_62 VPWR VGND sg13cmos5l_decap_8
XFILLER_93_215 VPWR VGND sg13cmos5l_decap_8
XANTENNA__0933__X Tile_X0Y1_W2BEG[4] VPWR VGND sg13cmos5l_antennanp
X_0802_ Tile_X0Y0_N1BEG[3] _1002_/X VPWR VGND sg13cmos5l_buf_1
XFILLER_115_158 VPWR VGND sg13cmos5l_decap_8
XFILLER_69_201 VPWR VGND sg13cmos5l_decap_8
X_0733_ Tile_X0Y0_W2BEGb[2] _1041_/X VPWR VGND sg13cmos5l_buf_1
X_0664_ _0664_/L_HI VPWR VGND sg13cmos5l_tiehi
XFILLER_27_0 VPWR VGND sg13cmos5l_fill_2
XFILLER_37_131 VPWR VGND sg13cmos5l_decap_8
XFILLER_84_237 VPWR VGND sg13cmos5l_decap_8
X_1216_ _1216_/X Tile_X0Y1_N1END[1] Tile_X0Y1_N4END[1] _1228_/X Tile_X0Y0_S4END[5]
+ _0376_/Q _0375_/Q VPWR VGND sg13cmos5l_mux4_1
X_0595_ _0595_/Q Tile_X0Y1_FrameData[7] VGND VPWR Tile_X0Y1_FrameStrobe[7] latch
XANTENNA__0843__X Tile_X0Y1_FrameData_O[19] VPWR VGND sg13cmos5l_antennanp
XFILLER_111_49 VPWR VGND sg13cmos5l_fill_1
XFILLER_37_153 VPWR VGND sg13cmos5l_decap_8
XFILLER_52_101 VPWR VGND sg13cmos5l_decap_8
XFILLER_52_189 VPWR VGND sg13cmos5l_decap_8
X_1078_ _1078_/X _1114_/X Tile_X0Y0_E6END[3] Tile_X0Y0_S1END[3] _1078_/A3 _0094_/Q
+ _0347_/Q VPWR VGND sg13cmos5l_mux4_1
X_1147_ _1147_/X Tile_X0Y1_E2MID[0] _0644_/Q _1195_/X _1202_/X _0522_/Q _0521_/Q VPWR
+ VGND sg13cmos5l_mux4_1
XFILLER_112_8 VPWR VGND sg13cmos5l_decap_8
XFILLER_4_219 VPWR VGND sg13cmos5l_decap_8
XFILLER_106_169 VPWR VGND sg13cmos5l_decap_8
XFILLER_114_191 VPWR VGND sg13cmos5l_decap_8
XFILLER_20_46 VPWR VGND sg13cmos5l_decap_8
XFILLER_29_22 VPWR VGND sg13cmos5l_decap_4
XFILLER_96_28 VPWR VGND sg13cmos5l_fill_1
XFILLER_29_77 VPWR VGND sg13cmos5l_decap_8
XFILLER_75_226 VPWR VGND sg13cmos5l_decap_8
XFILLER_83_270 VPWR VGND sg13cmos5l_fill_2
XANTENNA__0753__X Tile_X0Y0_N4BEG[2] VPWR VGND sg13cmos5l_antennanp
XFILLER_43_167 VPWR VGND sg13cmos5l_decap_8
XANTENNA_8 Tile_X0Y0_FrameData[22] VPWR VGND sg13cmos5l_antennanp
XANTENNA__0928__X Tile_X0Y1_W1BEG[3] VPWR VGND sg13cmos5l_antennanp
XFILLER_112_117 VPWR VGND sg13cmos5l_fill_1
XFILLER_112_139 VPWR VGND sg13cmos5l_decap_8
XFILLER_66_248 VPWR VGND sg13cmos5l_decap_8
X_0380_ _0380_/Q Tile_X0Y1_FrameData[30] VGND VPWR Tile_X0Y1_FrameStrobe[1] latch
X_1001_ _1001_/X Tile_X0Y0_E1END[2] Tile_X0Y0_E6END[6] _1077_/X _1102_/X _0342_/Q
+ _0341_/Q VPWR VGND sg13cmos5l_mux4_1
XANTENNA__0612__Q NPU_WEIGHT_IN2 VPWR VGND sg13cmos5l_antennanp
XFILLER_106_38 VPWR VGND sg13cmos5l_decap_4
X_0716_ _0975_/A3 VPWR VGND sg13cmos5l_tielo
X_0647_ _0647_/Q Tile_X0Y1_UserCLK NPU_ACT_RDATA3 _0677_/L_HI VPWR VGND sg13cmos5l_dfrbpq_1
X_0578_ _0578_/Q Tile_X0Y1_FrameData[24] VGND VPWR Tile_X0Y1_FrameStrobe[7] latch
XANTENNA__0838__X Tile_X0Y1_FrameData_O[14] VPWR VGND sg13cmos5l_antennanp
XFILLER_111_150 VPWR VGND sg13cmos5l_fill_1
XFILLER_111_183 VPWR VGND sg13cmos5l_decap_8
XFILLER_65_270 VPWR VGND sg13cmos5l_fill_2
XFILLER_15_46 VPWR VGND sg13cmos5l_decap_8
XANTENNA__0748__X Tile_X0Y0_W6BEG[9] VPWR VGND sg13cmos5l_antennanp
XFILLER_102_183 VPWR VGND sg13cmos5l_decap_8
XFILLER_48_215 VPWR VGND sg13cmos5l_decap_8
XFILLER_31_104 VPWR VGND sg13cmos5l_decap_8
XFILLER_56_42 VPWR VGND sg13cmos5l_decap_8
XFILLER_63_218 VPWR VGND sg13cmos5l_decap_8
XFILLER_82_9 VPWR VGND sg13cmos5l_fill_1
X_0501_ _0501_/Q Tile_X0Y1_FrameData[5] VGND VPWR Tile_X0Y1_FrameStrobe[4] latch
X_0432_ _0432_/Q Tile_X0Y1_FrameData[10] VGND VPWR Tile_X0Y1_FrameStrobe[2] latch
XFILLER_98_159 VPWR VGND sg13cmos5l_decap_8
XFILLER_39_204 VPWR VGND sg13cmos5l_decap_8
XFILLER_54_218 VPWR VGND sg13cmos5l_decap_8
X_0363_ _0363_/Q Tile_X0Y1_FrameData[15] VGND VPWR Tile_X0Y1_FrameStrobe[0] latch
X_0294_ _0294_/Q Tile_X0Y0_FrameData[22] VGND VPWR Tile_X0Y1_FrameStrobe[6] latch
XFILLER_94_0 VPWR VGND sg13cmos5l_decap_4
XFILLER_116_264 VPWR VGND sg13cmos5l_decap_8
XFILLER_89_126 VPWR VGND sg13cmos5l_fill_2
XFILLER_13_115 VPWR VGND sg13cmos5l_fill_1
XFILLER_26_12 VPWR VGND sg13cmos5l_fill_2
XFILLER_93_18 VPWR VGND sg13cmos5l_fill_2
XFILLER_107_220 VPWR VGND sg13cmos5l_decap_8
XFILLER_107_92 VPWR VGND sg13cmos5l_fill_2
XFILLER_95_118 VPWR VGND sg13cmos5l_fill_1
XFILLER_83_51 VPWR VGND sg13cmos5l_decap_8
X_0981_ _0981_/X Tile_X0Y0_E1END[0] Tile_X0Y0_E6END[0] _1100_/X _0981_/A3 _0154_/Q
+ _0153_/Q VPWR VGND sg13cmos5l_mux4_1
XANTENNA__0941__X Tile_X0Y1_W2BEGb[4] VPWR VGND sg13cmos5l_antennanp
XFILLER_8_185 VPWR VGND sg13cmos5l_decap_8
XFILLER_113_201 VPWR VGND sg13cmos5l_decap_8
X_0415_ _0415_/Q Tile_X0Y1_FrameData[27] VGND VPWR Tile_X0Y1_FrameStrobe[2] latch
X_0346_ _0346_/Q Tile_X0Y0_FrameData[2] VGND VPWR Tile_X0Y1_FrameStrobe[7] latch
X_0277_ _0277_/Q Tile_X0Y0_FrameData[7] VGND VPWR Tile_X0Y1_FrameStrobe[5] latch
XFILLER_94_151 VPWR VGND sg13cmos5l_decap_8
XANTENNA__0851__X Tile_X0Y1_FrameData_O[27] VPWR VGND sg13cmos5l_antennanp
XFILLER_10_129 VPWR VGND sg13cmos5l_decap_8
XFILLER_104_212 VPWR VGND sg13cmos5l_decap_8
XFILLER_88_29 VPWR VGND sg13cmos5l_decap_8
XFILLER_18_207 VPWR VGND sg13cmos5l_decap_8
XFILLER_85_173 VPWR VGND sg13cmos5l_decap_8
XFILLER_85_195 VPWR VGND sg13cmos5l_fill_2
XFILLER_26_240 VPWR VGND sg13cmos5l_decap_4
XFILLER_37_77 VPWR VGND sg13cmos5l_decap_4
XANTENNA__0761__X Tile_X0Y0_N4BEG[10] VPWR VGND sg13cmos5l_antennanp
XFILLER_5_155 VPWR VGND sg13cmos5l_decap_8
XFILLER_110_215 VPWR VGND sg13cmos5l_decap_8
XFILLER_68_107 VPWR VGND sg13cmos5l_fill_2
XANTENNA__0936__X Tile_X0Y1_W2BEG[7] VPWR VGND sg13cmos5l_antennanp
XFILLER_76_162 VPWR VGND sg13cmos5l_decap_4
X_1180_ _1180_/X Tile_X0Y1_N4END[1] Tile_X0Y0_S4END[5] _1213_/X _1217_/X _0456_/Q
+ _0455_/Q VPWR VGND sg13cmos5l_mux4_1
X_0200_ _0200_/Q Tile_X0Y0_FrameData[20] VGND VPWR Tile_X0Y1_FrameStrobe[3] latch
X_0131_ _0131_/Q Tile_X0Y0_FrameData[25] VGND VPWR Tile_X0Y1_FrameStrobe[1] latch
XFILLER_91_187 VPWR VGND sg13cmos5l_decap_8
XFILLER_91_132 VPWR VGND sg13cmos5l_fill_2
XFILLER_91_121 VPWR VGND sg13cmos5l_decap_8
XFILLER_32_232 VPWR VGND sg13cmos5l_decap_8
X_0964_ Tile_X0Y1_WW4BEG[7] _1170_/X VPWR VGND sg13cmos5l_buf_1
XANTENNA__0620__Q NPU_ACT_WDATA2 VPWR VGND sg13cmos5l_antennanp
XFILLER_57_0 VPWR VGND sg13cmos5l_decap_8
X_0895_ Tile_X0Y1_S2BEG[3] _1130_/X VPWR VGND sg13cmos5l_buf_1
XFILLER_99_254 VPWR VGND sg13cmos5l_decap_8
XANTENNA__0846__X Tile_X0Y1_FrameData_O[22] VPWR VGND sg13cmos5l_antennanp
XFILLER_101_237 VPWR VGND sg13cmos5l_decap_8
XFILLER_82_110 VPWR VGND sg13cmos5l_decap_8
X_0329_ _0329_/Q Tile_X0Y0_FrameData[19] VGND VPWR Tile_X0Y1_FrameStrobe[7] latch
XFILLER_82_198 VPWR VGND sg13cmos5l_decap_8
XANTENNA__0756__X Tile_X0Y0_N4BEG[5] VPWR VGND sg13cmos5l_antennanp
XFILLER_58_151 VPWR VGND sg13cmos5l_decap_8
XFILLER_73_132 VPWR VGND sg13cmos5l_decap_8
XFILLER_14_210 VPWR VGND sg13cmos5l_decap_8
XFILLER_64_86 VPWR VGND sg13cmos5l_decap_8
XFILLER_64_97 VPWR VGND sg13cmos5l_fill_2
XFILLER_73_198 VPWR VGND sg13cmos5l_decap_8
X_0680_ _0680_/L_HI VPWR VGND sg13cmos5l_tiehi
X_1232_ _1232_/X Tile_X0Y0_EE4END[1] Tile_X0Y0_EE4END[9] Tile_X0Y0_E6END[1] _1089_/X
+ _0176_/Q _0175_/Q VPWR VGND sg13cmos5l_mux4_1
XFILLER_96_213 VPWR VGND sg13cmos5l_decap_8
XFILLER_49_195 VPWR VGND sg13cmos5l_decap_8
XFILLER_64_121 VPWR VGND sg13cmos5l_decap_8
XFILLER_64_198 VPWR VGND sg13cmos5l_decap_8
X_1094_ _1094_/X _1105_/X Tile_X0Y1_N2MID[2] Tile_X0Y0_S2MID[2] Tile_X0Y0_S2END[2]
+ _0112_/Q _0111_/Q VPWR VGND sg13cmos5l_mux4_1
X_1163_ _1163_/X _0644_/Q _0648_/Q _1218_/X _1202_/X _0490_/Q _0489_/Q VPWR VGND sg13cmos5l_mux4_1
X_0114_ _0114_/Q Tile_X0Y0_FrameData[10] VGND VPWR Tile_X0Y1_FrameStrobe[0] latch
XANTENNA__0615__Q NPU_WEIGHT_IN5 VPWR VGND sg13cmos5l_antennanp
XFILLER_109_38 VPWR VGND sg13cmos5l_fill_1
XFILLER_118_101 VPWR VGND sg13cmos5l_decap_8
XFILLER_20_257 VPWR VGND sg13cmos5l_fill_2
XFILLER_20_268 VPWR VGND sg13cmos5l_decap_4
X_0947_ Tile_X0Y1_W6BEG[2] _1181_/X VPWR VGND sg13cmos5l_buf_1
XFILLER_109_49 VPWR VGND sg13cmos5l_decap_4
XFILLER_118_178 VPWR VGND sg13cmos5l_decap_8
X_0878_ Tile_X0Y0_FrameData_O[22] Tile_X0Y0_FrameData[22] VPWR VGND sg13cmos5l_buf_1
XFILLER_87_268 VPWR VGND sg13cmos5l_decap_4
XFILLER_11_235 VPWR VGND sg13cmos5l_decap_8
XFILLER_55_198 VPWR VGND sg13cmos5l_decap_8
XFILLER_109_156 VPWR VGND sg13cmos5l_decap_8
XFILLER_115_81 VPWR VGND sg13cmos5l_decap_8
XFILLER_59_75 VPWR VGND sg13cmos5l_fill_1
XFILLER_46_187 VPWR VGND sg13cmos5l_decap_8
XFILLER_61_179 VPWR VGND sg13cmos5l_decap_8
X_0801_ Tile_X0Y0_N1BEG[2] _1001_/X VPWR VGND sg13cmos5l_buf_1
XFILLER_91_84 VPWR VGND sg13cmos5l_decap_8
XFILLER_115_137 VPWR VGND sg13cmos5l_decap_8
XFILLER_6_272 VPWR VGND sg13cmos5l_fill_1
X_0732_ Tile_X0Y0_W2BEGb[1] _1040_/X VPWR VGND sg13cmos5l_buf_1
X_0663_ _0663_/L_HI VPWR VGND sg13cmos5l_tiehi
X_0594_ _0594_/Q Tile_X0Y1_FrameData[8] VGND VPWR Tile_X0Y1_FrameStrobe[7] latch
XFILLER_69_257 VPWR VGND sg13cmos5l_decap_8
XFILLER_84_216 VPWR VGND sg13cmos5l_decap_8
X_1215_ _1215_/X Tile_X0Y1_N1END[0] Tile_X0Y1_N4END[0] _1227_/X Tile_X0Y0_S4END[4]
+ _0378_/Q _0377_/Q VPWR VGND sg13cmos5l_mux4_1
X_1146_ _1146_/X Tile_X0Y1_N1END[3] _1230_/X _0645_/Q _0648_/Q _0524_/Q _0523_/Q VPWR
+ VGND sg13cmos5l_mux4_1
XFILLER_111_28 VPWR VGND sg13cmos5l_decap_8
XFILLER_52_168 VPWR VGND sg13cmos5l_decap_8
X_1077_ _1077_/X _1113_/X Tile_X0Y1_N4END[6] Tile_X0Y0_S1END[2] Tile_X0Y0_S4END[2]
+ _0120_/Q _0119_/Q VPWR VGND sg13cmos5l_mux4_1
XFILLER_105_8 VPWR VGND sg13cmos5l_decap_8
XFILLER_106_104 VPWR VGND sg13cmos5l_fill_2
XFILLER_106_148 VPWR VGND sg13cmos5l_decap_8
XFILLER_114_170 VPWR VGND sg13cmos5l_decap_8
XFILLER_75_205 VPWR VGND sg13cmos5l_decap_8
XFILLER_45_77 VPWR VGND sg13cmos5l_decap_4
XFILLER_45_88 VPWR VGND sg13cmos5l_decap_8
XANTENNA_9 Tile_X0Y0_FrameData[22] VPWR VGND sg13cmos5l_antennanp
XFILLER_3_264 VPWR VGND sg13cmos5l_fill_1
XFILLER_66_227 VPWR VGND sg13cmos5l_decap_8
X_1000_ _1000_/X Tile_X0Y0_E1END[1] Tile_X0Y0_E6END[5] _1076_/X _1101_/X _0344_/Q
+ _0343_/Q VPWR VGND sg13cmos5l_mux4_1
XANTENNA__0944__X Tile_X0Y1_W2BEGb[7] VPWR VGND sg13cmos5l_antennanp
XFILLER_34_157 VPWR VGND sg13cmos5l_fill_2
X_0715_ _0976_/A3 VPWR VGND sg13cmos5l_tielo
XFILLER_111_162 VPWR VGND sg13cmos5l_decap_8
X_0646_ _0646_/Q Tile_X0Y1_UserCLK NPU_ACT_RDATA2 _0678_/L_HI VPWR VGND sg13cmos5l_dfrbpq_1
X_0577_ _0577_/Q Tile_X0Y1_FrameData[25] VGND VPWR Tile_X0Y1_FrameStrobe[7] latch
XANTENNA__0854__X Tile_X0Y1_FrameData_O[30] VPWR VGND sg13cmos5l_antennanp
XFILLER_25_113 VPWR VGND sg13cmos5l_decap_8
X_1129_ _1129_/X Tile_X0Y1_E2MID[5] Tile_X0Y1_E2END[5] Tile_X0Y1_E6END[10] _1197_/X
+ _0554_/Q _0553_/Q VPWR VGND sg13cmos5l_mux4_1
XFILLER_33_190 VPWR VGND sg13cmos5l_decap_8
XFILLER_31_68 VPWR VGND sg13cmos5l_fill_1
XFILLER_0_245 VPWR VGND sg13cmos5l_decap_8
XFILLER_102_162 VPWR VGND sg13cmos5l_decap_8
XFILLER_56_21 VPWR VGND sg13cmos5l_decap_8
XANTENNA__0764__X Tile_X0Y0_N4BEG[13] VPWR VGND sg13cmos5l_antennanp
XFILLER_16_124 VPWR VGND sg13cmos5l_fill_1
XFILLER_31_127 VPWR VGND sg13cmos5l_decap_8
XFILLER_72_64 VPWR VGND sg13cmos5l_decap_4
XFILLER_72_97 VPWR VGND sg13cmos5l_decap_8
XANTENNA__0939__X Tile_X0Y1_W2BEGb[2] VPWR VGND sg13cmos5l_antennanp
XFILLER_21_90 VPWR VGND sg13cmos5l_fill_1
X_0500_ _0500_/Q Tile_X0Y1_FrameData[6] VGND VPWR Tile_X0Y1_FrameStrobe[4] latch
X_0431_ _0431_/Q Tile_X0Y1_FrameData[11] VGND VPWR Tile_X0Y1_FrameStrobe[2] latch
X_0362_ _0362_/Q Tile_X0Y1_FrameData[16] VGND VPWR Tile_X0Y1_FrameStrobe[0] latch
XFILLER_98_138 VPWR VGND sg13cmos5l_decap_8
XFILLER_97_94 VPWR VGND sg13cmos5l_decap_8
XFILLER_11_4 VPWR VGND sg13cmos5l_fill_1
XFILLER_47_271 VPWR VGND sg13cmos5l_fill_2
X_0293_ _0293_/Q Tile_X0Y0_FrameData[23] VGND VPWR Tile_X0Y1_FrameStrobe[6] latch
XANTENNA__0623__Q NPU_ACT_WDATA5 VPWR VGND sg13cmos5l_antennanp
XFILLER_87_0 VPWR VGND sg13cmos5l_fill_2
XFILLER_116_243 VPWR VGND sg13cmos5l_decap_8
XFILLER_7_81 VPWR VGND sg13cmos5l_decap_8
XANTENNA__0849__X Tile_X0Y1_FrameData_O[25] VPWR VGND sg13cmos5l_antennanp
XFILLER_89_149 VPWR VGND sg13cmos5l_decap_8
X_0629_ NPU_ACT_ADDR3 Tile_X0Y1_UserCLK _0976_/X _0682_/L_HI VPWR VGND sg13cmos5l_dfrbpq_1
XFILLER_13_138 VPWR VGND sg13cmos5l_fill_2
XFILLER_26_35 VPWR VGND sg13cmos5l_decap_4
XFILLER_26_46 VPWR VGND sg13cmos5l_decap_4
XFILLER_38_271 VPWR VGND sg13cmos5l_fill_2
XFILLER_53_263 VPWR VGND sg13cmos5l_decap_8
XANTENNA__0759__X Tile_X0Y0_N4BEG[8] VPWR VGND sg13cmos5l_antennanp
XFILLER_36_219 VPWR VGND sg13cmos5l_decap_8
XFILLER_44_230 VPWR VGND sg13cmos5l_decap_8
XFILLER_67_53 VPWR VGND sg13cmos5l_decap_4
XFILLER_83_30 VPWR VGND sg13cmos5l_decap_8
XFILLER_88_193 VPWR VGND sg13cmos5l_decap_4
XFILLER_83_96 VPWR VGND sg13cmos5l_fill_2
XFILLER_8_120 VPWR VGND sg13cmos5l_fill_1
X_0980_ _0980_/X Tile_X0Y0_E2MID[7] Tile_X0Y0_E2END[7] _1099_/X _0980_/A3 _0156_/Q
+ _0155_/Q VPWR VGND sg13cmos5l_mux4_1
XFILLER_8_164 VPWR VGND sg13cmos5l_decap_8
XFILLER_113_257 VPWR VGND sg13cmos5l_decap_8
XFILLER_113_268 VPWR VGND sg13cmos5l_decap_4
X_0414_ _0414_/Q Tile_X0Y1_FrameData[28] VGND VPWR Tile_X0Y1_FrameStrobe[2] latch
X_0345_ _0345_/Q Tile_X0Y0_FrameData[3] VGND VPWR Tile_X0Y1_FrameStrobe[7] latch
XFILLER_94_141 VPWR VGND sg13cmos5l_fill_2
XFILLER_94_130 VPWR VGND sg13cmos5l_fill_1
XANTENNA__0618__Q NPU_ACT_WDATA0 VPWR VGND sg13cmos5l_antennanp
XFILLER_35_252 VPWR VGND sg13cmos5l_decap_8
XFILLER_50_211 VPWR VGND sg13cmos5l_decap_8
X_0276_ _0276_/Q Tile_X0Y0_FrameData[8] VGND VPWR Tile_X0Y1_FrameStrobe[5] latch
XFILLER_5_9 VPWR VGND sg13cmos5l_fill_2
XFILLER_37_56 VPWR VGND sg13cmos5l_decap_8
XFILLER_85_152 VPWR VGND sg13cmos5l_decap_8
XFILLER_41_255 VPWR VGND sg13cmos5l_decap_8
XFILLER_5_134 VPWR VGND sg13cmos5l_decap_8
XFILLER_118_81 VPWR VGND sg13cmos5l_decap_4
XFILLER_76_152 VPWR VGND sg13cmos5l_decap_4
XFILLER_78_85 VPWR VGND sg13cmos5l_decap_8
XFILLER_32_211 VPWR VGND sg13cmos5l_decap_8
X_0130_ _0130_/Q Tile_X0Y0_FrameData[26] VGND VPWR Tile_X0Y1_FrameStrobe[1] latch
XFILLER_91_166 VPWR VGND sg13cmos5l_decap_8
XFILLER_91_100 VPWR VGND sg13cmos5l_decap_8
XANTENNA__0952__X Tile_X0Y1_W6BEG[7] VPWR VGND sg13cmos5l_antennanp
X_0894_ Tile_X0Y1_S2BEG[2] _1129_/X VPWR VGND sg13cmos5l_buf_1
X_0963_ Tile_X0Y1_WW4BEG[6] _1169_/X VPWR VGND sg13cmos5l_buf_1
XFILLER_59_119 VPWR VGND sg13cmos5l_decap_8
XFILLER_99_233 VPWR VGND sg13cmos5l_decap_8
XFILLER_101_216 VPWR VGND sg13cmos5l_decap_8
XFILLER_4_93 VPWR VGND sg13cmos5l_fill_2
XFILLER_67_141 VPWR VGND sg13cmos5l_fill_1
XFILLER_67_185 VPWR VGND sg13cmos5l_decap_8
X_0328_ _0328_/Q Tile_X0Y0_FrameData[20] VGND VPWR Tile_X0Y1_FrameStrobe[7] latch
XANTENNA__0862__X Tile_X0Y0_FrameData_O[6] VPWR VGND sg13cmos5l_antennanp
XFILLER_23_255 VPWR VGND sg13cmos5l_decap_8
XFILLER_82_177 VPWR VGND sg13cmos5l_decap_8
X_0259_ _0259_/Q Tile_X0Y0_FrameData[25] VGND VPWR Tile_X0Y1_FrameStrobe[5] latch
XFILLER_23_47 VPWR VGND sg13cmos5l_fill_1
XFILLER_2_115 VPWR VGND sg13cmos5l_fill_1
XFILLER_73_177 VPWR VGND sg13cmos5l_decap_8
XANTENNA__0772__X Tile_X0Y0_WW4BEG[5] VPWR VGND sg13cmos5l_antennanp
XFILLER_9_27 VPWR VGND sg13cmos5l_fill_1
XFILLER_89_40 VPWR VGND sg13cmos5l_fill_2
XANTENNA__0947__X Tile_X0Y1_W6BEG[2] VPWR VGND sg13cmos5l_antennanp
XFILLER_49_130 VPWR VGND sg13cmos5l_fill_1
X_1231_ _1231_/X Tile_X0Y0_EE4END[0] Tile_X0Y0_EE4END[8] Tile_X0Y0_E6END[0] _1088_/X
+ _0178_/Q _0177_/Q VPWR VGND sg13cmos5l_mux4_1
X_1162_ _1162_/X Tile_X0Y1_E2MID[5] _0651_/Q _1195_/X _1202_/X _0492_/Q _0491_/Q VPWR
+ VGND sg13cmos5l_mux4_1
XFILLER_96_269 VPWR VGND sg13cmos5l_decap_4
XFILLER_64_177 VPWR VGND sg13cmos5l_decap_8
X_1093_ _1093_/X _1104_/X Tile_X0Y1_N2MID[1] Tile_X0Y0_S2MID[1] Tile_X0Y0_S2END[1]
+ _0114_/Q _0113_/Q VPWR VGND sg13cmos5l_mux4_1
X_0113_ _0113_/Q Tile_X0Y0_FrameData[11] VGND VPWR Tile_X0Y1_FrameStrobe[0] latch
XANTENNA__0631__Q NPU_ACT_ADDR5 VPWR VGND sg13cmos5l_antennanp
XFILLER_118_157 VPWR VGND sg13cmos5l_decap_8
XFILLER_20_236 VPWR VGND sg13cmos5l_decap_8
X_0877_ Tile_X0Y0_FrameData_O[21] Tile_X0Y0_FrameData[21] VPWR VGND sg13cmos5l_buf_1
X_0946_ Tile_X0Y1_W6BEG[1] _1180_/X VPWR VGND sg13cmos5l_buf_1
XANTENNA__0857__X Tile_X0Y0_FrameData_O[1] VPWR VGND sg13cmos5l_antennanp
XFILLER_87_247 VPWR VGND sg13cmos5l_decap_8
XFILLER_18_36 VPWR VGND sg13cmos5l_decap_8
XFILLER_18_47 VPWR VGND sg13cmos5l_fill_1
XFILLER_55_100 VPWR VGND sg13cmos5l_decap_8
XFILLER_55_177 VPWR VGND sg13cmos5l_decap_8
XFILLER_70_114 VPWR VGND sg13cmos5l_decap_4
XFILLER_70_125 VPWR VGND sg13cmos5l_decap_8
XFILLER_11_214 VPWR VGND sg13cmos5l_decap_8
XFILLER_70_169 VPWR VGND sg13cmos5l_decap_8
XFILLER_109_135 VPWR VGND sg13cmos5l_decap_8
XANTENNA__0767__X Tile_X0Y0_WW4BEG[0] VPWR VGND sg13cmos5l_antennanp
XFILLER_78_225 VPWR VGND sg13cmos5l_decap_8
XFILLER_46_166 VPWR VGND sg13cmos5l_decap_8
XFILLER_61_158 VPWR VGND sg13cmos5l_decap_8
XFILLER_75_97 VPWR VGND sg13cmos5l_decap_4
XFILLER_91_52 VPWR VGND sg13cmos5l_fill_1
XFILLER_91_41 VPWR VGND sg13cmos5l_decap_8
X_0800_ Tile_X0Y0_N1BEG[1] _1000_/X VPWR VGND sg13cmos5l_buf_1
X_0731_ Tile_X0Y0_W2BEGb[0] _1039_/X VPWR VGND sg13cmos5l_buf_1
XFILLER_69_236 VPWR VGND sg13cmos5l_decap_8
X_0662_ _0662_/L_HI VPWR VGND sg13cmos5l_tiehi
X_0593_ _0593_/Q Tile_X0Y1_FrameData[9] VGND VPWR Tile_X0Y1_FrameStrobe[7] latch
XFILLER_37_199 VPWR VGND sg13cmos5l_decap_8
X_1214_ _1214_/X Tile_X0Y1_N1END[3] Tile_X0Y1_N4END[3] _1230_/X Tile_X0Y0_S4END[7]
+ _0380_/Q _0379_/Q VPWR VGND sg13cmos5l_mux4_1
X_1145_ _1145_/X Tile_X0Y1_N1END[2] _1229_/X _0644_/Q _0649_/Q _0526_/Q _0525_/Q VPWR
+ VGND sg13cmos5l_mux4_1
XFILLER_92_272 VPWR VGND sg13cmos5l_fill_1
XANTENNA__0626__Q NPU_ACT_ADDR0 VPWR VGND sg13cmos5l_antennanp
X_1076_ _1076_/X _1112_/X Tile_X0Y1_N4END[5] Tile_X0Y0_S1END[1] Tile_X0Y0_S4END[1]
+ _0122_/Q _0121_/Q VPWR VGND sg13cmos5l_mux4_1
XFILLER_106_127 VPWR VGND sg13cmos5l_decap_8
X_0929_ Tile_X0Y1_W2BEG[0] _1147_/X VPWR VGND sg13cmos5l_buf_1
XFILLER_29_68 VPWR VGND sg13cmos5l_fill_2
XFILLER_96_19 VPWR VGND sg13cmos5l_fill_2
XFILLER_28_188 VPWR VGND sg13cmos5l_decap_8
XFILLER_43_125 VPWR VGND sg13cmos5l_fill_1
XFILLER_45_56 VPWR VGND sg13cmos5l_decap_8
XFILLER_83_272 VPWR VGND sg13cmos5l_fill_1
XFILLER_117_0 VPWR VGND sg13cmos5l_fill_2
XFILLER_51_180 VPWR VGND sg13cmos5l_decap_8
XFILLER_61_99 VPWR VGND sg13cmos5l_fill_2
XFILLER_6_28 VPWR VGND sg13cmos5l_decap_4
XFILLER_3_232 VPWR VGND sg13cmos5l_decap_8
XFILLER_19_188 VPWR VGND sg13cmos5l_decap_8
XFILLER_66_206 VPWR VGND sg13cmos5l_decap_8
XFILLER_86_63 VPWR VGND sg13cmos5l_decap_4
XFILLER_86_74 VPWR VGND sg13cmos5l_decap_8
XANTENNA__0960__X Tile_X0Y1_WW4BEG[3] VPWR VGND sg13cmos5l_antennanp
X_0714_ _0977_/A3 VPWR VGND sg13cmos5l_tielo
X_0645_ _0645_/Q Tile_X0Y1_UserCLK NPU_ACT_RDATA1 _0676_/L_HI VPWR VGND sg13cmos5l_dfrbpq_1
XFILLER_32_0 VPWR VGND sg13cmos5l_fill_2
XFILLER_57_239 VPWR VGND sg13cmos5l_fill_1
X_0576_ _0576_/Q Tile_X0Y1_FrameData[26] VGND VPWR Tile_X0Y1_FrameStrobe[7] latch
XFILLER_65_272 VPWR VGND sg13cmos5l_fill_1
XFILLER_72_209 VPWR VGND sg13cmos5l_decap_8
XFILLER_80_253 VPWR VGND sg13cmos5l_decap_8
X_1059_ _1059_/X _0636_/Q _0640_/Q _1091_/X _1095_/X _0210_/Q _0209_/Q VPWR VGND sg13cmos5l_mux4_1
X_1128_ _1128_/X Tile_X0Y1_E2MID[6] Tile_X0Y1_E2END[6] Tile_X0Y1_E6END[9] _1196_/X
+ _0556_/Q _0555_/Q VPWR VGND sg13cmos5l_mux4_1
XANTENNA__0091__Q NPU_XBAR_SEL1 VPWR VGND sg13cmos5l_antennanp
XANTENNA__0870__X Tile_X0Y0_FrameData_O[14] VPWR VGND sg13cmos5l_antennanp
XFILLER_31_25 VPWR VGND sg13cmos5l_decap_4
XFILLER_0_224 VPWR VGND sg13cmos5l_decap_8
XFILLER_102_141 VPWR VGND sg13cmos5l_decap_8
XFILLER_56_77 VPWR VGND sg13cmos5l_decap_8
XFILLER_56_88 VPWR VGND sg13cmos5l_fill_2
XANTENNA__0780__X Tile_X0Y0_WW4BEG[13] VPWR VGND sg13cmos5l_antennanp
XFILLER_24_191 VPWR VGND sg13cmos5l_decap_8
XFILLER_71_264 VPWR VGND sg13cmos5l_decap_8
XFILLER_39_239 VPWR VGND sg13cmos5l_decap_8
X_0430_ _0430_/Q Tile_X0Y1_FrameData[12] VGND VPWR Tile_X0Y1_FrameStrobe[2] latch
X_0361_ _0361_/Q Tile_X0Y1_FrameData[17] VGND VPWR Tile_X0Y1_FrameStrobe[0] latch
XANTENNA__0955__X Tile_X0Y1_W6BEG[10] VPWR VGND sg13cmos5l_antennanp
XFILLER_62_264 VPWR VGND sg13cmos5l_decap_8
X_0292_ _0292_/Q Tile_X0Y0_FrameData[24] VGND VPWR Tile_X0Y1_FrameStrobe[6] latch
XFILLER_22_139 VPWR VGND sg13cmos5l_decap_8
XFILLER_30_194 VPWR VGND sg13cmos5l_decap_8
XFILLER_116_211 VPWR VGND sg13cmos5l_decap_8
X_0628_ NPU_ACT_ADDR2 Tile_X0Y1_UserCLK _0975_/X _0683_/L_HI VPWR VGND sg13cmos5l_dfrbpq_1
XANTENNA__0865__X Tile_X0Y0_FrameData_O[9] VPWR VGND sg13cmos5l_antennanp
XFILLER_38_250 VPWR VGND sg13cmos5l_decap_8
X_0559_ _0559_/Q Tile_X0Y1_FrameData[11] VGND VPWR Tile_X0Y1_FrameStrobe[6] latch
XFILLER_97_194 VPWR VGND sg13cmos5l_decap_8
XFILLER_97_161 VPWR VGND sg13cmos5l_fill_2
XFILLER_26_58 VPWR VGND sg13cmos5l_decap_8
XFILLER_26_69 VPWR VGND sg13cmos5l_fill_1
XFILLER_53_242 VPWR VGND sg13cmos5l_decap_8
XFILLER_107_255 VPWR VGND sg13cmos5l_decap_8
XFILLER_21_194 VPWR VGND sg13cmos5l_decap_8
XFILLER_42_68 VPWR VGND sg13cmos5l_decap_8
XFILLER_88_172 VPWR VGND sg13cmos5l_decap_8
XANTENNA__0775__X Tile_X0Y0_WW4BEG[8] VPWR VGND sg13cmos5l_antennanp
XFILLER_44_264 VPWR VGND sg13cmos5l_fill_1
XFILLER_73_7 VPWR VGND sg13cmos5l_fill_2
XFILLER_8_154 VPWR VGND sg13cmos5l_decap_4
XFILLER_113_236 VPWR VGND sg13cmos5l_decap_8
XFILLER_79_172 VPWR VGND sg13cmos5l_fill_1
XFILLER_79_183 VPWR VGND sg13cmos5l_decap_8
XFILLER_86_109 VPWR VGND sg13cmos5l_fill_1
X_0413_ _0413_/Q Tile_X0Y1_FrameData[29] VGND VPWR Tile_X0Y1_FrameStrobe[2] latch
X_0344_ _0344_/Q Tile_X0Y0_FrameData[4] VGND VPWR Tile_X0Y1_FrameStrobe[7] latch
X_0275_ _0275_/Q Tile_X0Y0_FrameData[9] VGND VPWR Tile_X0Y1_FrameStrobe[5] latch
XFILLER_94_186 VPWR VGND sg13cmos5l_decap_8
XFILLER_94_120 VPWR VGND sg13cmos5l_decap_4
XANTENNA__0634__Q NPU_ACT_ADDR8 VPWR VGND sg13cmos5l_antennanp
XFILLER_35_231 VPWR VGND sg13cmos5l_decap_8
XFILLER_50_234 VPWR VGND sg13cmos5l_fill_2
XFILLER_104_247 VPWR VGND sg13cmos5l_decap_8
XFILLER_104_258 VPWR VGND sg13cmos5l_fill_2
XFILLER_37_35 VPWR VGND sg13cmos5l_decap_8
XFILLER_85_131 VPWR VGND sg13cmos5l_decap_8
XFILLER_85_197 VPWR VGND sg13cmos5l_fill_1
XFILLER_41_234 VPWR VGND sg13cmos5l_decap_8
XFILLER_118_60 VPWR VGND sg13cmos5l_decap_8
XFILLER_5_124 VPWR VGND sg13cmos5l_decap_4
XFILLER_78_42 VPWR VGND sg13cmos5l_decap_8
XFILLER_17_253 VPWR VGND sg13cmos5l_decap_8
XFILLER_76_197 VPWR VGND sg13cmos5l_decap_8
XFILLER_94_74 VPWR VGND sg13cmos5l_decap_4
XFILLER_91_145 VPWR VGND sg13cmos5l_decap_8
XFILLER_32_267 VPWR VGND sg13cmos5l_decap_4
XFILLER_71_4 VPWR VGND sg13cmos5l_fill_2
X_0893_ Tile_X0Y1_S2BEG[1] _1128_/X VPWR VGND sg13cmos5l_buf_1
X_0962_ Tile_X0Y1_WW4BEG[5] _1168_/X VPWR VGND sg13cmos5l_buf_1
XFILLER_99_212 VPWR VGND sg13cmos5l_decap_8
XANTENNA__0629__Q NPU_ACT_ADDR3 VPWR VGND sg13cmos5l_antennanp
XFILLER_67_153 VPWR VGND sg13cmos5l_fill_1
XFILLER_67_164 VPWR VGND sg13cmos5l_decap_8
X_0327_ _0327_/Q Tile_X0Y0_FrameData[21] VGND VPWR Tile_X0Y1_FrameStrobe[7] latch
X_0258_ _0258_/Q Tile_X0Y0_FrameData[26] VGND VPWR Tile_X0Y1_FrameStrobe[5] latch
XFILLER_23_234 VPWR VGND sg13cmos5l_decap_8
XFILLER_23_59 VPWR VGND sg13cmos5l_decap_8
X_0189_ _0189_/Q Tile_X0Y0_FrameData[31] VGND VPWR Tile_X0Y1_FrameStrobe[3] latch
XFILLER_14_245 VPWR VGND sg13cmos5l_decap_8
XFILLER_58_186 VPWR VGND sg13cmos5l_decap_8
XFILLER_64_22 VPWR VGND sg13cmos5l_decap_4
XFILLER_64_55 VPWR VGND sg13cmos5l_fill_2
XFILLER_80_32 VPWR VGND sg13cmos5l_fill_1
XFILLER_43_8 VPWR VGND sg13cmos5l_decap_8
XFILLER_89_52 VPWR VGND sg13cmos5l_fill_1
XFILLER_89_74 VPWR VGND sg13cmos5l_decap_4
XFILLER_64_156 VPWR VGND sg13cmos5l_decap_8
X_1092_ _1092_/X _1103_/X Tile_X0Y1_N2MID[0] Tile_X0Y0_S2MID[0] Tile_X0Y0_S2END[0]
+ _0116_/Q _0115_/Q VPWR VGND sg13cmos5l_mux4_1
X_1230_ _1230_/X Tile_X0Y0_E1END[3] Tile_X0Y0_E6END[11] _1079_/X _1078_/X _0304_/Q
+ _0303_/Q VPWR VGND sg13cmos5l_mux4_1
X_1161_ _1161_/X Tile_X0Y1_E2MID[2] _0650_/Q _1196_/X _1201_/X _0494_/Q _0493_/Q VPWR
+ VGND sg13cmos5l_mux4_1
X_0112_ _0112_/Q Tile_X0Y0_FrameData[12] VGND VPWR Tile_X0Y1_FrameStrobe[0] latch
XFILLER_96_248 VPWR VGND sg13cmos5l_decap_8
XANTENNA__0963__X Tile_X0Y1_WW4BEG[6] VPWR VGND sg13cmos5l_antennanp
XFILLER_20_215 VPWR VGND sg13cmos5l_decap_8
XFILLER_109_18 VPWR VGND sg13cmos5l_decap_4
XFILLER_109_29 VPWR VGND sg13cmos5l_decap_8
XFILLER_118_136 VPWR VGND sg13cmos5l_decap_8
XFILLER_62_0 VPWR VGND sg13cmos5l_fill_2
X_0876_ Tile_X0Y0_FrameData_O[20] Tile_X0Y0_FrameData[20] VPWR VGND sg13cmos5l_buf_1
X_0945_ Tile_X0Y1_W6BEG[0] _1179_/X VPWR VGND sg13cmos5l_buf_1
XFILLER_9_260 VPWR VGND sg13cmos5l_fill_2
XFILLER_18_26 VPWR VGND sg13cmos5l_fill_2
XFILLER_87_226 VPWR VGND sg13cmos5l_decap_8
XANTENNA__0873__X Tile_X0Y0_FrameData_O[17] VPWR VGND sg13cmos5l_antennanp
XFILLER_55_134 VPWR VGND sg13cmos5l_fill_2
XFILLER_95_270 VPWR VGND sg13cmos5l_fill_2
XFILLER_109_114 VPWR VGND sg13cmos5l_decap_8
XFILLER_50_35 VPWR VGND sg13cmos5l_decap_8
XFILLER_117_180 VPWR VGND sg13cmos5l_decap_8
XFILLER_50_68 VPWR VGND sg13cmos5l_decap_8
XFILLER_78_204 VPWR VGND sg13cmos5l_decap_8
XFILLER_46_145 VPWR VGND sg13cmos5l_decap_8
XFILLER_75_21 VPWR VGND sg13cmos5l_decap_8
XFILLER_75_32 VPWR VGND sg13cmos5l_fill_2
XFILLER_75_76 VPWR VGND sg13cmos5l_decap_8
XFILLER_78_259 VPWR VGND sg13cmos5l_decap_8
XFILLER_93_229 VPWR VGND sg13cmos5l_decap_8
XANTENNA__0783__X Tile_X0Y0_N2BEGb[0] VPWR VGND sg13cmos5l_antennanp
XFILLER_61_137 VPWR VGND sg13cmos5l_decap_8
XFILLER_115_117 VPWR VGND sg13cmos5l_decap_8
XFILLER_6_263 VPWR VGND sg13cmos5l_fill_2
X_0730_ Tile_X0Y0_W2BEG[7] _1038_/X VPWR VGND sg13cmos5l_buf_1
X_0661_ _0661_/L_HI VPWR VGND sg13cmos5l_tiehi
XANTENNA__0958__X Tile_X0Y1_WW4BEG[1] VPWR VGND sg13cmos5l_antennanp
XFILLER_69_215 VPWR VGND sg13cmos5l_decap_8
X_1213_ _1213_/X Tile_X0Y1_N1END[2] Tile_X0Y1_N4END[2] _1229_/X Tile_X0Y0_S4END[6]
+ _0382_/Q _0381_/Q VPWR VGND sg13cmos5l_mux4_1
X_0592_ _0592_/Q Tile_X0Y1_FrameData[10] VGND VPWR Tile_X0Y1_FrameStrobe[7] latch
XFILLER_37_167 VPWR VGND sg13cmos5l_decap_8
XFILLER_37_178 VPWR VGND sg13cmos5l_decap_8
XFILLER_52_126 VPWR VGND sg13cmos5l_decap_4
X_1075_ _1075_/X _1111_/X Tile_X0Y1_N4END[4] Tile_X0Y0_S1END[0] Tile_X0Y0_S4END[0]
+ _0124_/Q _0123_/Q VPWR VGND sg13cmos5l_mux4_1
X_1144_ _1144_/X Tile_X0Y1_N1END[1] _1228_/X _0647_/Q _0650_/Q _0528_/Q _0527_/Q VPWR
+ VGND sg13cmos5l_mux4_1
XFILLER_92_262 VPWR VGND sg13cmos5l_fill_2
XFILLER_60_181 VPWR VGND sg13cmos5l_decap_8
XANTENNA__0868__X Tile_X0Y0_FrameData_O[12] VPWR VGND sg13cmos5l_antennanp
X_0859_ Tile_X0Y0_FrameData_O[3] Tile_X0Y0_FrameData[3] VPWR VGND sg13cmos5l_buf_1
X_0928_ Tile_X0Y1_W1BEG[3] _1146_/X VPWR VGND sg13cmos5l_buf_1
XANTENNA__0089__Q NPU_ACT_WE VPWR VGND sg13cmos5l_antennanp
XFILLER_28_123 VPWR VGND sg13cmos5l_fill_2
XFILLER_29_14 VPWR VGND sg13cmos5l_fill_1
XFILLER_3_211 VPWR VGND sg13cmos5l_decap_8
XANTENNA__0778__X Tile_X0Y0_WW4BEG[11] VPWR VGND sg13cmos5l_antennanp
XFILLER_105_183 VPWR VGND sg13cmos5l_decap_8
XFILLER_3_255 VPWR VGND sg13cmos5l_decap_8
XFILLER_19_123 VPWR VGND sg13cmos5l_fill_2
XFILLER_19_167 VPWR VGND sg13cmos5l_decap_8
XFILLER_34_115 VPWR VGND sg13cmos5l_decap_8
XFILLER_34_137 VPWR VGND sg13cmos5l_decap_8
XFILLER_34_159 VPWR VGND sg13cmos5l_fill_1
XFILLER_42_181 VPWR VGND sg13cmos5l_decap_8
X_0713_ _0978_/A3 VPWR VGND sg13cmos5l_tielo
X_0644_ _0644_/Q Tile_X0Y1_UserCLK NPU_ACT_RDATA0 _0671_/L_HI VPWR VGND sg13cmos5l_dfrbpq_1
XFILLER_111_197 VPWR VGND sg13cmos5l_decap_8
XFILLER_25_0 VPWR VGND sg13cmos5l_fill_2
XFILLER_57_207 VPWR VGND sg13cmos5l_decap_8
X_0575_ _0575_/Q Tile_X0Y1_FrameData[27] VGND VPWR Tile_X0Y1_FrameStrobe[7] latch
XFILLER_15_16 VPWR VGND sg13cmos5l_decap_8
XFILLER_25_148 VPWR VGND sg13cmos5l_decap_8
XFILLER_80_232 VPWR VGND sg13cmos5l_decap_8
X_1058_ _1058_/X _0639_/Q _0643_/Q _1087_/X _1096_/X _0212_/Q _0211_/Q VPWR VGND sg13cmos5l_mux4_1
X_1127_ _1127_/X Tile_X0Y1_E2MID[7] Tile_X0Y1_E2END[7] Tile_X0Y1_E6END[8] _1195_/X
+ _0558_/Q _0557_/Q VPWR VGND sg13cmos5l_mux4_1
XFILLER_31_15 VPWR VGND sg13cmos5l_fill_2
XFILLER_31_48 VPWR VGND sg13cmos5l_decap_4
XFILLER_31_59 VPWR VGND sg13cmos5l_decap_8
XFILLER_102_197 VPWR VGND sg13cmos5l_decap_8
XFILLER_16_115 VPWR VGND sg13cmos5l_decap_8
XFILLER_48_229 VPWR VGND sg13cmos5l_decap_4
XFILLER_24_170 VPWR VGND sg13cmos5l_decap_8
XFILLER_31_118 VPWR VGND sg13cmos5l_fill_2
XFILLER_71_243 VPWR VGND sg13cmos5l_decap_8
XFILLER_21_81 VPWR VGND sg13cmos5l_decap_8
XFILLER_97_30 VPWR VGND sg13cmos5l_decap_4
XFILLER_39_218 VPWR VGND sg13cmos5l_decap_8
X_0360_ _0360_/Q Tile_X0Y1_FrameData[18] VGND VPWR Tile_X0Y1_FrameStrobe[0] latch
X_0291_ _0291_/Q Tile_X0Y0_FrameData[25] VGND VPWR Tile_X0Y1_FrameStrobe[6] latch
XANTENNA__0971__X Tile_X0Y1_WW4BEG[14] VPWR VGND sg13cmos5l_antennanp
XFILLER_15_170 VPWR VGND sg13cmos5l_decap_8
XFILLER_22_107 VPWR VGND sg13cmos5l_decap_4
XFILLER_22_118 VPWR VGND sg13cmos5l_decap_8
XFILLER_62_243 VPWR VGND sg13cmos5l_decap_8
XFILLER_30_173 VPWR VGND sg13cmos5l_decap_8
X_0627_ NPU_ACT_ADDR1 Tile_X0Y1_UserCLK _0974_/X _0684_/L_HI VPWR VGND sg13cmos5l_dfrbpq_1
X_0558_ _0558_/Q Tile_X0Y1_FrameData[12] VGND VPWR Tile_X0Y1_FrameStrobe[6] latch
XFILLER_53_221 VPWR VGND sg13cmos5l_decap_8
X_0489_ _0489_/Q Tile_X0Y1_FrameData[17] VGND VPWR Tile_X0Y1_FrameStrobe[4] latch
XFILLER_97_173 VPWR VGND sg13cmos5l_decap_8
XANTENNA__0881__X Tile_X0Y0_FrameData_O[25] VPWR VGND sg13cmos5l_antennanp
XFILLER_21_140 VPWR VGND sg13cmos5l_decap_8
XFILLER_42_47 VPWR VGND sg13cmos5l_decap_8
XFILLER_107_234 VPWR VGND sg13cmos5l_decap_8
XFILLER_67_33 VPWR VGND sg13cmos5l_decap_4
XFILLER_88_151 VPWR VGND sg13cmos5l_decap_8
XANTENNA__0791__X Tile_X0Y0_N2BEG[0] VPWR VGND sg13cmos5l_antennanp
XFILLER_12_151 VPWR VGND sg13cmos5l_fill_2
XFILLER_12_184 VPWR VGND sg13cmos5l_decap_8
XFILLER_66_7 VPWR VGND sg13cmos5l_decap_8
XFILLER_113_215 VPWR VGND sg13cmos5l_decap_8
X_0412_ _0412_/Q Tile_X0Y1_FrameData[30] VGND VPWR Tile_X0Y1_FrameStrobe[2] latch
XFILLER_8_199 VPWR VGND sg13cmos5l_decap_8
XANTENNA__0966__X Tile_X0Y1_WW4BEG[9] VPWR VGND sg13cmos5l_antennanp
XFILLER_35_210 VPWR VGND sg13cmos5l_decap_8
X_0343_ _0343_/Q Tile_X0Y0_FrameData[5] VGND VPWR Tile_X0Y1_FrameStrobe[7] latch
X_0274_ _0274_/Q Tile_X0Y0_FrameData[10] VGND VPWR Tile_X0Y1_FrameStrobe[5] latch
XFILLER_94_165 VPWR VGND sg13cmos5l_decap_8
XFILLER_94_143 VPWR VGND sg13cmos5l_fill_1
XFILLER_92_0 VPWR VGND sg13cmos5l_fill_2
XANTENNA__0876__X Tile_X0Y0_FrameData_O[20] VPWR VGND sg13cmos5l_antennanp
XFILLER_104_226 VPWR VGND sg13cmos5l_decap_8
XFILLER_37_14 VPWR VGND sg13cmos5l_fill_2
XFILLER_85_110 VPWR VGND sg13cmos5l_decap_8
XFILLER_41_213 VPWR VGND sg13cmos5l_decap_8
XFILLER_85_187 VPWR VGND sg13cmos5l_decap_4
XFILLER_118_94 VPWR VGND sg13cmos5l_decap_8
XFILLER_5_169 VPWR VGND sg13cmos5l_decap_8
XFILLER_78_21 VPWR VGND sg13cmos5l_decap_8
XFILLER_78_76 VPWR VGND sg13cmos5l_fill_2
XANTENNA__0786__X Tile_X0Y0_N2BEGb[3] VPWR VGND sg13cmos5l_antennanp
XFILLER_110_229 VPWR VGND sg13cmos5l_decap_8
XFILLER_76_176 VPWR VGND sg13cmos5l_decap_8
XFILLER_17_232 VPWR VGND sg13cmos5l_decap_8
XFILLER_27_91 VPWR VGND sg13cmos5l_decap_8
XFILLER_32_246 VPWR VGND sg13cmos5l_decap_8
X_0961_ Tile_X0Y1_WW4BEG[4] _1167_/X VPWR VGND sg13cmos5l_buf_1
X_0892_ Tile_X0Y1_S2BEG[0] _1127_/X VPWR VGND sg13cmos5l_buf_1
XFILLER_4_191 VPWR VGND sg13cmos5l_decap_8
XFILLER_4_95 VPWR VGND sg13cmos5l_fill_1
XFILLER_99_268 VPWR VGND sg13cmos5l_decap_4
XFILLER_23_213 VPWR VGND sg13cmos5l_decap_8
XFILLER_82_124 VPWR VGND sg13cmos5l_fill_2
X_0326_ _0326_/Q Tile_X0Y0_FrameData[22] VGND VPWR Tile_X0Y1_FrameStrobe[7] latch
X_0257_ _0257_/Q Tile_X0Y0_FrameData[27] VGND VPWR Tile_X0Y1_FrameStrobe[5] latch
X_0188_ _0188_/Q Tile_X0Y0_FrameData[0] VGND VPWR Tile_X0Y1_FrameStrobe[2] latch
XFILLER_2_128 VPWR VGND sg13cmos5l_fill_1
XFILLER_48_24 VPWR VGND sg13cmos5l_decap_8
XFILLER_58_165 VPWR VGND sg13cmos5l_decap_8
XFILLER_14_224 VPWR VGND sg13cmos5l_decap_8
XFILLER_14_268 VPWR VGND sg13cmos5l_decap_4
XFILLER_73_146 VPWR VGND sg13cmos5l_decap_8
XFILLER_80_44 VPWR VGND sg13cmos5l_fill_1
XFILLER_1_161 VPWR VGND sg13cmos5l_decap_8
XFILLER_1_194 VPWR VGND sg13cmos5l_fill_1
XFILLER_49_121 VPWR VGND sg13cmos5l_fill_2
XFILLER_96_227 VPWR VGND sg13cmos5l_decap_8
XFILLER_64_113 VPWR VGND sg13cmos5l_decap_4
XFILLER_64_135 VPWR VGND sg13cmos5l_decap_8
X_1091_ _1091_/X _1114_/X Tile_X0Y1_N4END[7] Tile_X0Y0_S1END[3] Tile_X0Y0_S4END[3]
+ _0142_/Q _0141_/Q VPWR VGND sg13cmos5l_mux4_1
X_1160_ _1160_/X _0649_/Q _1197_/X _1200_/X _1194_/X _0496_/Q _0495_/Q VPWR VGND sg13cmos5l_mux4_1
X_0111_ _0111_/Q Tile_X0Y0_FrameData[13] VGND VPWR Tile_X0Y1_FrameStrobe[0] latch
X_0944_ Tile_X0Y1_W2BEGb[7] _1162_/X VPWR VGND sg13cmos5l_buf_1
XFILLER_118_115 VPWR VGND sg13cmos5l_decap_8
XFILLER_55_0 VPWR VGND sg13cmos5l_decap_8
X_0875_ Tile_X0Y0_FrameData_O[19] Tile_X0Y0_FrameData[19] VPWR VGND sg13cmos5l_buf_1
XFILLER_9_272 VPWR VGND sg13cmos5l_fill_1
XFILLER_87_205 VPWR VGND sg13cmos5l_decap_8
XFILLER_63_190 VPWR VGND sg13cmos5l_decap_8
X_0309_ _0309_/Q Tile_X0Y0_FrameData[7] VGND VPWR Tile_X0Y1_FrameStrobe[6] latch
XFILLER_11_249 VPWR VGND sg13cmos5l_decap_8
XFILLER_7_209 VPWR VGND sg13cmos5l_decap_8
XFILLER_78_238 VPWR VGND sg13cmos5l_decap_8
XFILLER_115_51 VPWR VGND sg13cmos5l_decap_8
XFILLER_115_95 VPWR VGND sg13cmos5l_fill_2
XFILLER_61_116 VPWR VGND sg13cmos5l_decap_8
XFILLER_75_55 VPWR VGND sg13cmos5l_decap_8
XFILLER_93_208 VPWR VGND sg13cmos5l_decap_8
XFILLER_54_190 VPWR VGND sg13cmos5l_decap_8
XFILLER_6_242 VPWR VGND sg13cmos5l_decap_8
X_0660_ _0660_/L_HI VPWR VGND sg13cmos5l_tiehi
X_0591_ _0591_/Q Tile_X0Y1_FrameData[11] VGND VPWR Tile_X0Y1_FrameStrobe[7] latch
XFILLER_37_102 VPWR VGND sg13cmos5l_fill_1
X_1212_ _1212_/X Tile_X0Y1_N1END[1] Tile_X0Y1_N4END[1] _1228_/X Tile_X0Y0_S4END[5]
+ _0384_/Q _0383_/Q VPWR VGND sg13cmos5l_mux4_1
XFILLER_37_146 VPWR VGND sg13cmos5l_decap_8
X_1074_ _1074_/X _0639_/Q _1088_/X _1087_/X _1099_/X _0180_/Q _0179_/Q VPWR VGND sg13cmos5l_mux4_1
X_1143_ _1143_/X Tile_X0Y1_N1END[0] _1227_/X _0646_/Q _0651_/Q _0530_/Q _0529_/Q VPWR
+ VGND sg13cmos5l_mux4_1
XFILLER_92_241 VPWR VGND sg13cmos5l_decap_8
XFILLER_60_160 VPWR VGND sg13cmos5l_decap_8
X_0927_ Tile_X0Y1_W1BEG[2] _1145_/X VPWR VGND sg13cmos5l_buf_1
XFILLER_114_184 VPWR VGND sg13cmos5l_decap_8
X_0858_ Tile_X0Y0_FrameData_O[2] Tile_X0Y0_FrameData[2] VPWR VGND sg13cmos5l_buf_1
X_0789_ Tile_X0Y0_N2BEGb[6] _1109_/X VPWR VGND sg13cmos5l_buf_1
XANTENNA__0884__X Tile_X0Y0_FrameData_O[28] VPWR VGND sg13cmos5l_antennanp
XFILLER_28_146 VPWR VGND sg13cmos5l_decap_4
XFILLER_75_219 VPWR VGND sg13cmos5l_decap_8
XFILLER_83_263 VPWR VGND sg13cmos5l_decap_8
XFILLER_101_20 VPWR VGND sg13cmos5l_fill_1
XFILLER_117_2 VPWR VGND sg13cmos5l_fill_1
XFILLER_105_162 VPWR VGND sg13cmos5l_decap_8
XFILLER_86_32 VPWR VGND sg13cmos5l_decap_8
XFILLER_86_43 VPWR VGND sg13cmos5l_fill_2
XANTENNA__0794__X Tile_X0Y0_N2BEG[3] VPWR VGND sg13cmos5l_antennanp
XFILLER_34_105 VPWR VGND sg13cmos5l_decap_4
XFILLER_74_252 VPWR VGND sg13cmos5l_decap_8
XFILLER_42_160 VPWR VGND sg13cmos5l_decap_8
XFILLER_51_90 VPWR VGND sg13cmos5l_decap_4
XANTENNA__0969__X Tile_X0Y1_WW4BEG[12] VPWR VGND sg13cmos5l_antennanp
XFILLER_111_110 VPWR VGND sg13cmos5l_decap_4
X_0712_ _1191_/A3 VPWR VGND sg13cmos5l_tielo
X_0643_ _0643_/Q Tile_X0Y1_UserCLK NPU_OUT_ACT7 _0673_/L_HI VPWR VGND sg13cmos5l_dfrbpq_1
X_0574_ _0574_/Q Tile_X0Y1_FrameData[28] VGND VPWR Tile_X0Y1_FrameStrobe[7] latch
XFILLER_111_143 VPWR VGND sg13cmos5l_decap_8
XFILLER_111_176 VPWR VGND sg13cmos5l_decap_8
XFILLER_18_0 VPWR VGND sg13cmos5l_fill_2
XFILLER_65_263 VPWR VGND sg13cmos5l_decap_8
X_1126_ _1126_/X Tile_X0Y1_E1END[3] Tile_X0Y1_E6END[11] _1218_/X _1194_/X _0560_/Q
+ _0559_/Q VPWR VGND sg13cmos5l_mux4_1
XFILLER_15_39 VPWR VGND sg13cmos5l_decap_8
XFILLER_25_127 VPWR VGND sg13cmos5l_decap_8
XFILLER_80_211 VPWR VGND sg13cmos5l_decap_8
X_1057_ _1057_/X _0638_/Q _0642_/Q _1086_/X _1097_/X _0214_/Q _0213_/Q VPWR VGND sg13cmos5l_mux4_1
XANTENNA__0879__X Tile_X0Y0_FrameData_O[23] VPWR VGND sg13cmos5l_antennanp
XFILLER_102_176 VPWR VGND sg13cmos5l_decap_8
XFILLER_48_208 VPWR VGND sg13cmos5l_decap_8
XFILLER_56_35 VPWR VGND sg13cmos5l_decap_8
XFILLER_71_222 VPWR VGND sg13cmos5l_decap_8
XANTENNA__0789__X Tile_X0Y0_N2BEGb[6] VPWR VGND sg13cmos5l_antennanp
XFILLER_47_230 VPWR VGND sg13cmos5l_decap_8
X_0290_ _0290_/Q Tile_X0Y0_FrameData[26] VGND VPWR Tile_X0Y1_FrameStrobe[6] latch
XFILLER_62_222 VPWR VGND sg13cmos5l_decap_8
XFILLER_94_4 VPWR VGND sg13cmos5l_fill_1
XFILLER_30_152 VPWR VGND sg13cmos5l_decap_8
XFILLER_116_257 VPWR VGND sg13cmos5l_decap_8
XFILLER_89_119 VPWR VGND sg13cmos5l_decap_8
X_0626_ NPU_ACT_ADDR0 Tile_X0Y1_UserCLK _0973_/X _0685_/L_HI VPWR VGND sg13cmos5l_dfrbpq_1
X_0557_ _0557_/Q Tile_X0Y1_FrameData[13] VGND VPWR Tile_X0Y1_FrameStrobe[6] latch
XFILLER_53_200 VPWR VGND sg13cmos5l_decap_8
X_1109_ _1109_/X Tile_X0Y1_E2MID[1] Tile_X0Y1_E2END[1] Tile_X0Y1_E6END[1] _1201_/X
+ _0582_/Q _0581_/Q VPWR VGND sg13cmos5l_mux4_1
X_0488_ _0488_/Q Tile_X0Y1_FrameData[18] VGND VPWR Tile_X0Y1_FrameStrobe[4] latch
XFILLER_107_213 VPWR VGND sg13cmos5l_decap_8
XFILLER_83_44 VPWR VGND sg13cmos5l_decap_8
XFILLER_73_9 VPWR VGND sg13cmos5l_fill_1
XFILLER_8_178 VPWR VGND sg13cmos5l_decap_8
X_0411_ _0411_/Q Tile_X0Y1_FrameData[31] VGND VPWR Tile_X0Y1_FrameStrobe[2] latch
X_0342_ _0342_/Q Tile_X0Y0_FrameData[6] VGND VPWR Tile_X0Y1_FrameStrobe[7] latch
X_0273_ _0273_/Q Tile_X0Y0_FrameData[11] VGND VPWR Tile_X0Y1_FrameStrobe[5] latch
XFILLER_94_111 VPWR VGND sg13cmos5l_fill_2
XFILLER_35_266 VPWR VGND sg13cmos5l_decap_8
XFILLER_50_225 VPWR VGND sg13cmos5l_fill_2
XFILLER_50_236 VPWR VGND sg13cmos5l_fill_1
XFILLER_85_0 VPWR VGND sg13cmos5l_fill_2
XFILLER_104_205 VPWR VGND sg13cmos5l_decap_8
XFILLER_85_166 VPWR VGND sg13cmos5l_decap_8
X_0609_ _0609_/Q Tile_X0Y1_FrameData[31] VGND VPWR Tile_X0Y1_FrameStrobe[8] latch
XANTENNA__0892__X Tile_X0Y1_S2BEG[0] VPWR VGND sg13cmos5l_antennanp
XFILLER_26_233 VPWR VGND sg13cmos5l_decap_8
XFILLER_26_244 VPWR VGND sg13cmos5l_fill_2
XFILLER_41_269 VPWR VGND sg13cmos5l_decap_4
XFILLER_110_208 VPWR VGND sg13cmos5l_decap_8
XFILLER_118_40 VPWR VGND sg13cmos5l_fill_1
XFILLER_5_148 VPWR VGND sg13cmos5l_decap_8
XFILLER_78_99 VPWR VGND sg13cmos5l_decap_8
XFILLER_17_211 VPWR VGND sg13cmos5l_decap_8
XFILLER_91_114 VPWR VGND sg13cmos5l_decap_8
XFILLER_32_225 VPWR VGND sg13cmos5l_decap_8
XFILLER_43_91 VPWR VGND sg13cmos5l_decap_4
X_0960_ Tile_X0Y1_WW4BEG[3] _1166_/X VPWR VGND sg13cmos5l_buf_1
X_0891_ Tile_X0Y1_S1BEG[3] _1126_/X VPWR VGND sg13cmos5l_buf_1
XFILLER_4_170 VPWR VGND sg13cmos5l_decap_8
X_0325_ _0325_/Q Tile_X0Y0_FrameData[23] VGND VPWR Tile_X0Y1_FrameStrobe[7] latch
XFILLER_99_247 VPWR VGND sg13cmos5l_decap_8
XFILLER_67_199 VPWR VGND sg13cmos5l_decap_8
XFILLER_82_103 VPWR VGND sg13cmos5l_decap_8
XFILLER_82_169 VPWR VGND sg13cmos5l_decap_4
X_0256_ _0256_/Q Tile_X0Y0_FrameData[28] VGND VPWR Tile_X0Y1_FrameStrobe[5] latch
X_0187_ _0187_/Q Tile_X0Y0_FrameData[1] VGND VPWR Tile_X0Y1_FrameStrobe[2] latch
XFILLER_23_269 VPWR VGND sg13cmos5l_decap_4
XANTENNA__0887__X Tile_X0Y0_FrameData_O[31] VPWR VGND sg13cmos5l_antennanp
XFILLER_100_252 VPWR VGND sg13cmos5l_decap_8
XFILLER_64_13 VPWR VGND sg13cmos5l_fill_2
XFILLER_73_125 VPWR VGND sg13cmos5l_decap_8
XFILLER_14_203 VPWR VGND sg13cmos5l_decap_8
XFILLER_64_57 VPWR VGND sg13cmos5l_fill_1
XFILLER_80_56 VPWR VGND sg13cmos5l_decap_4
XFILLER_9_19 VPWR VGND sg13cmos5l_fill_1
XFILLER_80_89 VPWR VGND sg13cmos5l_decap_4
XANTENNA__0797__X Tile_X0Y0_N2BEG[6] VPWR VGND sg13cmos5l_antennanp
XFILLER_96_206 VPWR VGND sg13cmos5l_decap_8
XFILLER_38_80 VPWR VGND sg13cmos5l_decap_8
X_1090_ _1090_/X _1113_/X Tile_X0Y1_N4END[6] Tile_X0Y0_S1END[2] Tile_X0Y0_S4END[2]
+ _0144_/Q _0143_/Q VPWR VGND sg13cmos5l_mux4_1
X_0110_ _0110_/Q Tile_X0Y0_FrameData[14] VGND VPWR Tile_X0Y1_FrameStrobe[0] latch
X_0874_ Tile_X0Y0_FrameData_O[18] Tile_X0Y0_FrameData[18] VPWR VGND sg13cmos5l_buf_1
X_0943_ Tile_X0Y1_W2BEGb[6] _1161_/X VPWR VGND sg13cmos5l_buf_1
XFILLER_48_0 VPWR VGND sg13cmos5l_decap_4
XFILLER_62_2 VPWR VGND sg13cmos5l_fill_1
XFILLER_18_28 VPWR VGND sg13cmos5l_fill_1
XFILLER_55_136 VPWR VGND sg13cmos5l_fill_1
X_0308_ _0308_/Q Tile_X0Y0_FrameData[8] VGND VPWR Tile_X0Y1_FrameStrobe[6] latch
XFILLER_95_272 VPWR VGND sg13cmos5l_fill_1
XFILLER_11_228 VPWR VGND sg13cmos5l_decap_8
X_0239_ _0239_/Q Tile_X0Y0_FrameData[13] VGND VPWR Tile_X0Y1_FrameStrobe[4] latch
XFILLER_109_149 VPWR VGND sg13cmos5l_decap_8
XFILLER_59_68 VPWR VGND sg13cmos5l_decap_8
XFILLER_115_74 VPWR VGND sg13cmos5l_decap_8
XFILLER_86_272 VPWR VGND sg13cmos5l_fill_1
XFILLER_108_193 VPWR VGND sg13cmos5l_decap_8
XFILLER_6_221 VPWR VGND sg13cmos5l_decap_8
X_0590_ _0590_/Q Tile_X0Y1_FrameData[12] VGND VPWR Tile_X0Y1_FrameStrobe[7] latch
XFILLER_84_209 VPWR VGND sg13cmos5l_decap_8
X_1211_ _1211_/X Tile_X0Y1_N1END[0] Tile_X0Y1_N4END[0] _1227_/X Tile_X0Y0_S4END[4]
+ _0386_/Q _0385_/Q VPWR VGND sg13cmos5l_mux4_1
X_1142_ _1142_/X _1210_/X _1214_/X _1218_/X _1202_/X _0533_/Q _0532_/Q VPWR VGND sg13cmos5l_mux4_1
X_1073_ _1073_/X _0638_/Q _1089_/X _1086_/X _1098_/X _0182_/Q _0181_/Q VPWR VGND sg13cmos5l_mux4_1
XFILLER_92_264 VPWR VGND sg13cmos5l_fill_1
X_0857_ Tile_X0Y0_FrameData_O[1] Tile_X0Y0_FrameData[1] VPWR VGND sg13cmos5l_buf_1
X_0926_ Tile_X0Y1_W1BEG[1] _1144_/X VPWR VGND sg13cmos5l_buf_1
XFILLER_114_163 VPWR VGND sg13cmos5l_decap_8
X_0788_ Tile_X0Y0_N2BEGb[5] _1108_/X VPWR VGND sg13cmos5l_buf_1
XFILLER_68_272 VPWR VGND sg13cmos5l_fill_1
XFILLER_83_242 VPWR VGND sg13cmos5l_decap_8
XFILLER_101_32 VPWR VGND sg13cmos5l_fill_1
XFILLER_36_191 VPWR VGND sg13cmos5l_decap_8
XFILLER_51_194 VPWR VGND sg13cmos5l_decap_4
XFILLER_3_246 VPWR VGND sg13cmos5l_fill_2
XFILLER_3_268 VPWR VGND sg13cmos5l_decap_4
XFILLER_10_95 VPWR VGND sg13cmos5l_fill_2
XFILLER_59_272 VPWR VGND sg13cmos5l_fill_1
XFILLER_74_231 VPWR VGND sg13cmos5l_decap_8
XFILLER_96_8 VPWR VGND sg13cmos5l_decap_8
X_0711_ _0980_/A3 VPWR VGND sg13cmos5l_tielo
XFILLER_111_122 VPWR VGND sg13cmos5l_decap_8
X_0642_ _0642_/Q Tile_X0Y1_UserCLK NPU_OUT_ACT6 _0674_/L_HI VPWR VGND sg13cmos5l_dfrbpq_1
X_0573_ _0573_/Q Tile_X0Y1_FrameData[29] VGND VPWR Tile_X0Y1_FrameStrobe[7] latch
XFILLER_111_155 VPWR VGND sg13cmos5l_decap_8
XFILLER_65_242 VPWR VGND sg13cmos5l_decap_8
X_1125_ _1125_/X Tile_X0Y1_E1END[2] Tile_X0Y1_E6END[10] _1217_/X _1193_/X _0562_/Q
+ _0561_/Q VPWR VGND sg13cmos5l_mux4_1
XFILLER_31_17 VPWR VGND sg13cmos5l_fill_1
XFILLER_33_183 VPWR VGND sg13cmos5l_decap_8
XFILLER_80_267 VPWR VGND sg13cmos5l_decap_4
X_1056_ _1056_/X _0637_/Q _0641_/Q _1085_/X _1098_/X _0216_/Q _0215_/Q VPWR VGND sg13cmos5l_mux4_1
X_0909_ Tile_X0Y1_S4BEG[1] Tile_X0Y0_S4END[9] VPWR VGND sg13cmos5l_buf_1
XANTENNA__0895__X Tile_X0Y1_S2BEG[3] VPWR VGND sg13cmos5l_antennanp
XFILLER_0_238 VPWR VGND sg13cmos5l_decap_8
XFILLER_102_155 VPWR VGND sg13cmos5l_decap_8
XFILLER_56_14 VPWR VGND sg13cmos5l_decap_8
XFILLER_112_31 VPWR VGND sg13cmos5l_decap_8
XFILLER_112_75 VPWR VGND sg13cmos5l_decap_4
XFILLER_56_69 VPWR VGND sg13cmos5l_fill_1
XFILLER_71_201 VPWR VGND sg13cmos5l_decap_8
XFILLER_72_24 VPWR VGND sg13cmos5l_decap_4
XFILLER_72_57 VPWR VGND sg13cmos5l_decap_8
XFILLER_72_68 VPWR VGND sg13cmos5l_fill_1
XFILLER_115_0 VPWR VGND sg13cmos5l_decap_8
XFILLER_11_8 VPWR VGND sg13cmos5l_fill_1
XFILLER_47_264 VPWR VGND sg13cmos5l_decap_8
XFILLER_62_201 VPWR VGND sg13cmos5l_decap_8
XFILLER_116_236 VPWR VGND sg13cmos5l_decap_8
XFILLER_7_74 VPWR VGND sg13cmos5l_decap_8
X_0625_ NPU_ACT_WDATA7 Tile_X0Y1_UserCLK _0989_/X _0690_/L_HI VPWR VGND sg13cmos5l_dfrbpq_1
XFILLER_30_0 VPWR VGND sg13cmos5l_fill_2
X_0556_ _0556_/Q Tile_X0Y1_FrameData[14] VGND VPWR Tile_X0Y1_FrameStrobe[6] latch
X_0487_ _0487_/Q Tile_X0Y1_FrameData[19] VGND VPWR Tile_X0Y1_FrameStrobe[4] latch
XFILLER_26_28 VPWR VGND sg13cmos5l_decap_8
XFILLER_38_264 VPWR VGND sg13cmos5l_decap_8
XFILLER_53_256 VPWR VGND sg13cmos5l_decap_8
X_1039_ _1039_/X Tile_X0Y0_EE4END[6] _0636_/Q _1092_/X _1099_/X _0250_/Q _0249_/Q
+ VPWR VGND sg13cmos5l_mux4_1
X_1108_ _1108_/X Tile_X0Y1_E2MID[2] Tile_X0Y1_E2END[2] Tile_X0Y1_E6END[2] _1200_/X
+ _0584_/Q _0583_/Q VPWR VGND sg13cmos5l_mux4_1
XFILLER_42_38 VPWR VGND sg13cmos5l_decap_4
XFILLER_107_269 VPWR VGND sg13cmos5l_decap_4
XFILLER_29_231 VPWR VGND sg13cmos5l_decap_8
XFILLER_44_223 VPWR VGND sg13cmos5l_decap_8
XFILLER_67_46 VPWR VGND sg13cmos5l_decap_8
XFILLER_67_57 VPWR VGND sg13cmos5l_fill_2
XFILLER_83_23 VPWR VGND sg13cmos5l_decap_8
XFILLER_88_186 VPWR VGND sg13cmos5l_decap_8
XFILLER_88_197 VPWR VGND sg13cmos5l_fill_1
XFILLER_79_197 VPWR VGND sg13cmos5l_decap_8
X_0410_ _0410_/Q Tile_X0Y1_FrameData[0] VGND VPWR Tile_X0Y1_FrameStrobe[1] latch
X_0341_ _0341_/Q Tile_X0Y0_FrameData[7] VGND VPWR Tile_X0Y1_FrameStrobe[7] latch
XFILLER_94_134 VPWR VGND sg13cmos5l_decap_8
XFILLER_35_245 VPWR VGND sg13cmos5l_decap_8
XFILLER_50_204 VPWR VGND sg13cmos5l_decap_8
X_0272_ _0272_/Q Tile_X0Y0_FrameData[12] VGND VPWR Tile_X0Y1_FrameStrobe[5] latch
XFILLER_78_0 VPWR VGND sg13cmos5l_decap_8
X_0608_ _0608_/Q Tile_X0Y1_FrameData[30] VGND VPWR Tile_X0Y1_FrameStrobe[8] latch
XFILLER_26_212 VPWR VGND sg13cmos5l_decap_8
XFILLER_37_49 VPWR VGND sg13cmos5l_decap_8
XFILLER_85_145 VPWR VGND sg13cmos5l_decap_8
X_0539_ _0539_/Q Tile_X0Y1_FrameData[31] VGND VPWR Tile_X0Y1_FrameStrobe[6] latch
XFILLER_41_248 VPWR VGND sg13cmos5l_decap_8
XFILLER_103_261 VPWR VGND sg13cmos5l_decap_8
XFILLER_103_272 VPWR VGND sg13cmos5l_fill_1
XFILLER_118_74 VPWR VGND sg13cmos5l_decap_8
XFILLER_118_85 VPWR VGND sg13cmos5l_fill_1
XFILLER_78_56 VPWR VGND sg13cmos5l_decap_4
XFILLER_17_267 VPWR VGND sg13cmos5l_decap_4
XFILLER_32_204 VPWR VGND sg13cmos5l_decap_8
XFILLER_76_156 VPWR VGND sg13cmos5l_fill_2
XFILLER_94_99 VPWR VGND sg13cmos5l_decap_8
XFILLER_94_55 VPWR VGND sg13cmos5l_decap_4
XFILLER_94_33 VPWR VGND sg13cmos5l_fill_1
XFILLER_91_159 VPWR VGND sg13cmos5l_decap_8
X_0890_ Tile_X0Y1_S1BEG[2] _1125_/X VPWR VGND sg13cmos5l_buf_1
XFILLER_99_226 VPWR VGND sg13cmos5l_decap_8
XFILLER_101_209 VPWR VGND sg13cmos5l_decap_8
XFILLER_67_101 VPWR VGND sg13cmos5l_decap_8
XFILLER_67_134 VPWR VGND sg13cmos5l_decap_8
XFILLER_67_178 VPWR VGND sg13cmos5l_decap_8
XFILLER_82_126 VPWR VGND sg13cmos5l_fill_1
X_0324_ _0324_/Q Tile_X0Y0_FrameData[24] VGND VPWR Tile_X0Y1_FrameStrobe[7] latch
X_0255_ _0255_/Q Tile_X0Y0_FrameData[29] VGND VPWR Tile_X0Y1_FrameStrobe[5] latch
XFILLER_23_248 VPWR VGND sg13cmos5l_decap_8
X_0186_ _0186_/Q Tile_X0Y0_FrameData[2] VGND VPWR Tile_X0Y1_FrameStrobe[2] latch
XFILLER_90_192 VPWR VGND sg13cmos5l_decap_8
XFILLER_2_108 VPWR VGND sg13cmos5l_decap_8
XFILLER_58_101 VPWR VGND sg13cmos5l_decap_4
XFILLER_100_231 VPWR VGND sg13cmos5l_decap_8
XFILLER_104_65 VPWR VGND sg13cmos5l_fill_2
XFILLER_48_59 VPWR VGND sg13cmos5l_decap_4
XFILLER_14_259 VPWR VGND sg13cmos5l_decap_4
XFILLER_89_99 VPWR VGND sg13cmos5l_fill_2
XFILLER_8_0 VPWR VGND sg13cmos5l_fill_1
XFILLER_29_9 VPWR VGND sg13cmos5l_fill_1
XFILLER_49_112 VPWR VGND sg13cmos5l_fill_2
XFILLER_72_181 VPWR VGND sg13cmos5l_decap_8
XFILLER_20_229 VPWR VGND sg13cmos5l_decap_8
X_0873_ Tile_X0Y0_FrameData_O[17] Tile_X0Y0_FrameData[17] VPWR VGND sg13cmos5l_buf_1
X_0942_ Tile_X0Y1_W2BEGb[5] _1160_/X VPWR VGND sg13cmos5l_buf_1
XFILLER_70_107 VPWR VGND sg13cmos5l_decap_8
X_0307_ _0307_/Q Tile_X0Y0_FrameData[9] VGND VPWR Tile_X0Y1_FrameStrobe[6] latch
X_0238_ _0238_/Q Tile_X0Y0_FrameData[14] VGND VPWR Tile_X0Y1_FrameStrobe[4] latch
XFILLER_11_207 VPWR VGND sg13cmos5l_decap_8
X_0169_ _0169_/Q Tile_X0Y0_FrameData[19] VGND VPWR Tile_X0Y1_FrameStrobe[2] latch
XANTENNA__0898__X Tile_X0Y1_S2BEG[6] VPWR VGND sg13cmos5l_antennanp
XFILLER_109_128 VPWR VGND sg13cmos5l_decap_8
XFILLER_117_194 VPWR VGND sg13cmos5l_decap_8
XFILLER_50_49 VPWR VGND sg13cmos5l_decap_4
XFILLER_1_7 VPWR VGND sg13cmos5l_decap_8
XFILLER_78_218 VPWR VGND sg13cmos5l_decap_8
XFILLER_86_262 VPWR VGND sg13cmos5l_fill_2
XFILLER_46_159 VPWR VGND sg13cmos5l_decap_8
XFILLER_91_34 VPWR VGND sg13cmos5l_decap_8
XFILLER_24_50 VPWR VGND sg13cmos5l_decap_8
XFILLER_6_200 VPWR VGND sg13cmos5l_decap_8
XFILLER_108_172 VPWR VGND sg13cmos5l_decap_8
XFILLER_69_229 VPWR VGND sg13cmos5l_decap_8
X_1072_ _1072_/X _0637_/Q _1090_/X _1085_/X _1097_/X _0184_/Q _0183_/Q VPWR VGND sg13cmos5l_mux4_1
X_1210_ _1210_/X Tile_X0Y1_N1END[3] Tile_X0Y1_N4END[3] _1230_/X Tile_X0Y0_S4END[7]
+ _0388_/Q _0387_/Q VPWR VGND sg13cmos5l_mux4_1
X_1141_ _1141_/X Tile_X0Y1_E1END[3] Tile_X0Y1_EE4END[15] Tile_X0Y1_E6END[7] _1206_/X
+ _0533_/Q _0532_/Q VPWR VGND sg13cmos5l_mux4_1
XFILLER_92_232 VPWR VGND sg13cmos5l_decap_4
XFILLER_45_192 VPWR VGND sg13cmos5l_decap_8
XFILLER_60_195 VPWR VGND sg13cmos5l_decap_8
XFILLER_60_0 VPWR VGND sg13cmos5l_fill_2
X_0856_ Tile_X0Y0_FrameData_O[0] Tile_X0Y0_FrameData[0] VPWR VGND sg13cmos5l_buf_1
X_0925_ Tile_X0Y1_W1BEG[0] _1143_/X VPWR VGND sg13cmos5l_buf_1
X_0787_ Tile_X0Y0_N2BEGb[4] _1107_/X VPWR VGND sg13cmos5l_buf_1
XFILLER_114_142 VPWR VGND sg13cmos5l_decap_8
XFILLER_68_262 VPWR VGND sg13cmos5l_fill_2
XFILLER_101_11 VPWR VGND sg13cmos5l_decap_8
XFILLER_36_170 VPWR VGND sg13cmos5l_decap_8
XFILLER_45_38 VPWR VGND sg13cmos5l_decap_4
XFILLER_83_221 VPWR VGND sg13cmos5l_decap_8
XFILLER_51_173 VPWR VGND sg13cmos5l_decap_8
XFILLER_61_59 VPWR VGND sg13cmos5l_decap_4
XFILLER_3_225 VPWR VGND sg13cmos5l_decap_8
XFILLER_105_197 VPWR VGND sg13cmos5l_decap_8
XFILLER_19_72 VPWR VGND sg13cmos5l_decap_8
XFILLER_74_210 VPWR VGND sg13cmos5l_decap_8
XFILLER_86_56 VPWR VGND sg13cmos5l_decap_8
XFILLER_27_192 VPWR VGND sg13cmos5l_decap_8
XFILLER_34_129 VPWR VGND sg13cmos5l_fill_1
XFILLER_42_195 VPWR VGND sg13cmos5l_decap_8
X_0710_ _0979_/A3 VPWR VGND sg13cmos5l_tielo
X_0641_ _0641_/Q Tile_X0Y1_UserCLK NPU_OUT_ACT5 _0672_/L_HI VPWR VGND sg13cmos5l_dfrbpq_1
X_0572_ _0572_/Q Tile_X0Y1_FrameData[30] VGND VPWR Tile_X0Y1_FrameStrobe[7] latch
XFILLER_65_221 VPWR VGND sg13cmos5l_decap_8
XFILLER_80_246 VPWR VGND sg13cmos5l_decap_8
X_1055_ _1055_/X _0636_/Q _0640_/Q _1084_/X _1099_/X _0218_/Q _0217_/Q VPWR VGND sg13cmos5l_mux4_1
X_1124_ _1124_/X Tile_X0Y1_E1END[1] Tile_X0Y1_E6END[9] _1216_/X _1192_/X _0564_/Q
+ _0563_/Q VPWR VGND sg13cmos5l_mux4_1
XFILLER_31_29 VPWR VGND sg13cmos5l_fill_1
XFILLER_33_162 VPWR VGND sg13cmos5l_decap_8
XFILLER_0_217 VPWR VGND sg13cmos5l_decap_8
X_0908_ Tile_X0Y1_S4BEG[0] Tile_X0Y0_S4END[8] VPWR VGND sg13cmos5l_buf_1
X_0839_ Tile_X0Y1_FrameData_O[15] Tile_X0Y1_FrameData[15] VPWR VGND sg13cmos5l_buf_1
XFILLER_102_134 VPWR VGND sg13cmos5l_decap_8
XFILLER_24_184 VPWR VGND sg13cmos5l_decap_8
XFILLER_71_257 VPWR VGND sg13cmos5l_decap_8
XFILLER_108_0 VPWR VGND sg13cmos5l_decap_4
XFILLER_97_55 VPWR VGND sg13cmos5l_decap_4
XFILLER_62_257 VPWR VGND sg13cmos5l_decap_8
XFILLER_15_184 VPWR VGND sg13cmos5l_decap_8
XFILLER_30_187 VPWR VGND sg13cmos5l_decap_8
XFILLER_116_204 VPWR VGND sg13cmos5l_decap_8
X_0624_ NPU_ACT_WDATA6 Tile_X0Y1_UserCLK _0988_/X _0691_/L_HI VPWR VGND sg13cmos5l_dfrbpq_1
XFILLER_23_0 VPWR VGND sg13cmos5l_fill_2
XFILLER_38_243 VPWR VGND sg13cmos5l_decap_8
X_0555_ _0555_/Q Tile_X0Y1_FrameData[15] VGND VPWR Tile_X0Y1_FrameStrobe[6] latch
X_0486_ _0486_/Q Tile_X0Y1_FrameData[20] VGND VPWR Tile_X0Y1_FrameStrobe[4] latch
XFILLER_97_187 VPWR VGND sg13cmos5l_decap_8
XFILLER_97_132 VPWR VGND sg13cmos5l_fill_1
XFILLER_97_121 VPWR VGND sg13cmos5l_decap_8
XFILLER_53_235 VPWR VGND sg13cmos5l_decap_8
X_1038_ _1038_/X Tile_X0Y0_EE4END[5] _0643_/Q _1092_/X _1099_/X _0252_/Q _0251_/Q
+ VPWR VGND sg13cmos5l_mux4_1
X_1107_ _1107_/X Tile_X0Y1_E2MID[3] Tile_X0Y1_E2END[3] Tile_X0Y1_E6END[3] _1199_/X
+ _0586_/Q _0585_/Q VPWR VGND sg13cmos5l_mux4_1
XFILLER_21_154 VPWR VGND sg13cmos5l_fill_2
XFILLER_21_187 VPWR VGND sg13cmos5l_decap_8
XFILLER_107_248 VPWR VGND sg13cmos5l_decap_8
XFILLER_88_165 VPWR VGND sg13cmos5l_decap_8
XFILLER_29_221 VPWR VGND sg13cmos5l_decap_4
XFILLER_44_202 VPWR VGND sg13cmos5l_decap_8
XFILLER_16_40 VPWR VGND sg13cmos5l_decap_4
XFILLER_16_51 VPWR VGND sg13cmos5l_decap_4
XFILLER_113_229 VPWR VGND sg13cmos5l_decap_8
XFILLER_12_198 VPWR VGND sg13cmos5l_decap_8
XFILLER_32_61 VPWR VGND sg13cmos5l_decap_8
XFILLER_8_158 VPWR VGND sg13cmos5l_fill_2
XFILLER_79_176 VPWR VGND sg13cmos5l_decap_8
X_0340_ _0340_/Q Tile_X0Y0_FrameData[8] VGND VPWR Tile_X0Y1_FrameStrobe[7] latch
X_0271_ _0271_/Q Tile_X0Y0_FrameData[13] VGND VPWR Tile_X0Y1_FrameStrobe[5] latch
XFILLER_35_224 VPWR VGND sg13cmos5l_decap_8
XFILLER_94_179 VPWR VGND sg13cmos5l_decap_8
X_0607_ _0607_/Q Tile_X0Y1_FrameData[29] VGND VPWR Tile_X0Y1_FrameStrobe[8] latch
X_0538_ _0538_/Q Tile_X0Y1_FrameData[0] VGND VPWR Tile_X0Y1_FrameStrobe[5] latch
XFILLER_37_28 VPWR VGND sg13cmos5l_decap_8
XFILLER_85_124 VPWR VGND sg13cmos5l_decap_8
X_0469_ _0469_/Q Tile_X0Y1_FrameData[5] VGND VPWR Tile_X0Y1_FrameStrobe[3] latch
XFILLER_41_227 VPWR VGND sg13cmos5l_decap_8
XFILLER_118_53 VPWR VGND sg13cmos5l_decap_8
XFILLER_5_128 VPWR VGND sg13cmos5l_fill_2
XFILLER_103_240 VPWR VGND sg13cmos5l_decap_8
XFILLER_78_35 VPWR VGND sg13cmos5l_decap_8
XFILLER_17_246 VPWR VGND sg13cmos5l_decap_8
XFILLER_94_67 VPWR VGND sg13cmos5l_decap_8
XFILLER_91_138 VPWR VGND sg13cmos5l_decap_8
XFILLER_99_205 VPWR VGND sg13cmos5l_decap_8
XFILLER_67_124 VPWR VGND sg13cmos5l_fill_2
X_0323_ _0323_/Q Tile_X0Y0_FrameData[25] VGND VPWR Tile_X0Y1_FrameStrobe[7] latch
X_0254_ _0254_/Q Tile_X0Y0_FrameData[30] VGND VPWR Tile_X0Y1_FrameStrobe[5] latch
X_0185_ _0185_/Q Tile_X0Y0_FrameData[3] VGND VPWR Tile_X0Y1_FrameStrobe[2] latch
XFILLER_23_227 VPWR VGND sg13cmos5l_decap_8
XFILLER_90_171 VPWR VGND sg13cmos5l_decap_4
XFILLER_90_0 VPWR VGND sg13cmos5l_decap_4
XFILLER_100_210 VPWR VGND sg13cmos5l_decap_8
XFILLER_48_38 VPWR VGND sg13cmos5l_decap_8
XFILLER_58_146 VPWR VGND sg13cmos5l_fill_1
XFILLER_98_271 VPWR VGND sg13cmos5l_fill_2
XFILLER_104_99 VPWR VGND sg13cmos5l_decap_8
XFILLER_14_238 VPWR VGND sg13cmos5l_decap_8
XFILLER_58_179 VPWR VGND sg13cmos5l_decap_8
XFILLER_64_26 VPWR VGND sg13cmos5l_fill_1
XFILLER_81_182 VPWR VGND sg13cmos5l_decap_8
XFILLER_13_96 VPWR VGND sg13cmos5l_fill_2
XFILLER_1_120 VPWR VGND sg13cmos5l_fill_1
XFILLER_1_142 VPWR VGND sg13cmos5l_fill_2
XFILLER_89_23 VPWR VGND sg13cmos5l_decap_8
XFILLER_89_45 VPWR VGND sg13cmos5l_decap_8
XFILLER_1_175 VPWR VGND sg13cmos5l_decap_4
XFILLER_1_186 VPWR VGND sg13cmos5l_fill_2
XFILLER_49_135 VPWR VGND sg13cmos5l_fill_2
XFILLER_64_149 VPWR VGND sg13cmos5l_decap_8
XFILLER_20_208 VPWR VGND sg13cmos5l_decap_8
X_0941_ Tile_X0Y1_W2BEGb[4] _1159_/X VPWR VGND sg13cmos5l_buf_1
XFILLER_118_129 VPWR VGND sg13cmos5l_decap_8
X_0872_ Tile_X0Y0_FrameData_O[16] Tile_X0Y0_FrameData[16] VPWR VGND sg13cmos5l_buf_1
XFILLER_9_242 VPWR VGND sg13cmos5l_decap_8
XFILLER_87_219 VPWR VGND sg13cmos5l_decap_8
XFILLER_18_19 VPWR VGND sg13cmos5l_decap_8
XFILLER_48_190 VPWR VGND sg13cmos5l_fill_1
XFILLER_55_127 VPWR VGND sg13cmos5l_decap_8
X_0306_ _0306_/Q Tile_X0Y0_FrameData[10] VGND VPWR Tile_X0Y1_FrameStrobe[6] latch
X_0237_ _0237_/Q Tile_X0Y0_FrameData[15] VGND VPWR Tile_X0Y1_FrameStrobe[4] latch
X_0168_ _0168_/Q Tile_X0Y0_FrameData[20] VGND VPWR Tile_X0Y1_FrameStrobe[2] latch
XFILLER_95_263 VPWR VGND sg13cmos5l_decap_8
XFILLER_109_107 VPWR VGND sg13cmos5l_fill_2
XFILLER_34_29 VPWR VGND sg13cmos5l_fill_2
X_0099_ _0099_/Q Tile_X0Y0_FrameData[25] VGND VPWR Tile_X0Y1_FrameStrobe[0] latch
XFILLER_117_173 VPWR VGND sg13cmos5l_decap_8
XFILLER_115_21 VPWR VGND sg13cmos5l_fill_1
XFILLER_75_14 VPWR VGND sg13cmos5l_fill_2
XFILLER_75_69 VPWR VGND sg13cmos5l_decap_8
XFILLER_86_241 VPWR VGND sg13cmos5l_decap_8
XFILLER_39_190 VPWR VGND sg13cmos5l_decap_8
XFILLER_108_151 VPWR VGND sg13cmos5l_decap_8
XFILLER_24_84 VPWR VGND sg13cmos5l_fill_2
XFILLER_6_256 VPWR VGND sg13cmos5l_decap_8
XFILLER_69_208 VPWR VGND sg13cmos5l_decap_8
XFILLER_37_138 VPWR VGND sg13cmos5l_fill_1
XFILLER_45_171 VPWR VGND sg13cmos5l_decap_8
XFILLER_52_108 VPWR VGND sg13cmos5l_decap_4
XFILLER_52_119 VPWR VGND sg13cmos5l_decap_8
XFILLER_77_252 VPWR VGND sg13cmos5l_decap_8
X_1071_ _1071_/X _0636_/Q _1091_/X _1084_/X _1096_/X _0186_/Q _0185_/Q VPWR VGND sg13cmos5l_mux4_1
X_1140_ _1140_/X _1209_/X _1213_/X _1217_/X _1201_/X _0536_/Q _0535_/Q VPWR VGND sg13cmos5l_mux4_1
XFILLER_92_255 VPWR VGND sg13cmos5l_decap_8
XFILLER_92_211 VPWR VGND sg13cmos5l_decap_8
XFILLER_60_174 VPWR VGND sg13cmos5l_decap_8
XFILLER_81_90 VPWR VGND sg13cmos5l_fill_2
X_0924_ Tile_X0Y1_UserCLKo Tile_X0Y1_UserCLK VPWR VGND sg13cmos5l_buf_1
XFILLER_114_121 VPWR VGND sg13cmos5l_decap_8
XFILLER_53_0 VPWR VGND sg13cmos5l_decap_4
X_0855_ Tile_X0Y1_FrameData_O[31] Tile_X0Y1_FrameData[31] VPWR VGND sg13cmos5l_buf_1
X_0786_ Tile_X0Y0_N2BEGb[3] _1106_/X VPWR VGND sg13cmos5l_buf_1
XFILLER_114_198 VPWR VGND sg13cmos5l_decap_8
XFILLER_28_116 VPWR VGND sg13cmos5l_decap_8
XFILLER_68_241 VPWR VGND sg13cmos5l_decap_8
XFILLER_83_200 VPWR VGND sg13cmos5l_decap_8
XFILLER_45_28 VPWR VGND sg13cmos5l_fill_2
XFILLER_105_176 VPWR VGND sg13cmos5l_decap_8
XFILLER_10_97 VPWR VGND sg13cmos5l_fill_1
XFILLER_3_204 VPWR VGND sg13cmos5l_decap_8
XFILLER_3_248 VPWR VGND sg13cmos5l_fill_1
XFILLER_19_51 VPWR VGND sg13cmos5l_decap_8
XFILLER_59_252 VPWR VGND sg13cmos5l_decap_8
XFILLER_59_263 VPWR VGND sg13cmos5l_fill_2
XFILLER_74_266 VPWR VGND sg13cmos5l_decap_8
XFILLER_42_174 VPWR VGND sg13cmos5l_decap_8
X_0640_ _0640_/Q Tile_X0Y1_UserCLK NPU_OUT_ACT4 _0667_/L_HI VPWR VGND sg13cmos5l_dfrbpq_1
X_0571_ _0571_/Q Tile_X0Y1_FrameData[31] VGND VPWR Tile_X0Y1_FrameStrobe[7] latch
XFILLER_65_200 VPWR VGND sg13cmos5l_decap_8
XFILLER_18_193 VPWR VGND sg13cmos5l_decap_8
XFILLER_33_141 VPWR VGND sg13cmos5l_decap_8
XFILLER_80_225 VPWR VGND sg13cmos5l_decap_8
X_1054_ _1054_/X _0639_/Q _0643_/Q _1083_/X _1092_/X _0220_/Q _0219_/Q VPWR VGND sg13cmos5l_mux4_1
X_1123_ _1123_/X Tile_X0Y1_E1END[0] Tile_X0Y1_E6END[8] _1215_/X _1191_/X _0566_/Q
+ _0565_/Q VPWR VGND sg13cmos5l_mux4_1
X_0907_ Tile_X0Y1_S2BEGb[7] _1226_/X VPWR VGND sg13cmos5l_buf_1
X_0838_ Tile_X0Y1_FrameData_O[14] Tile_X0Y1_FrameData[14] VPWR VGND sg13cmos5l_buf_1
X_0769_ Tile_X0Y0_WW4BEG[2] _1049_/X VPWR VGND sg13cmos5l_buf_1
XFILLER_56_200 VPWR VGND sg13cmos5l_decap_8
XFILLER_56_211 VPWR VGND sg13cmos5l_fill_1
XFILLER_56_49 VPWR VGND sg13cmos5l_fill_2
XFILLER_24_163 VPWR VGND sg13cmos5l_decap_8
XFILLER_71_236 VPWR VGND sg13cmos5l_decap_8
XFILLER_21_74 VPWR VGND sg13cmos5l_decap_8
XFILLER_62_236 VPWR VGND sg13cmos5l_decap_8
XFILLER_15_163 VPWR VGND sg13cmos5l_decap_8
XFILLER_30_166 VPWR VGND sg13cmos5l_decap_8
XFILLER_62_70 VPWR VGND sg13cmos5l_decap_8
XFILLER_7_43 VPWR VGND sg13cmos5l_fill_2
XFILLER_7_98 VPWR VGND sg13cmos5l_decap_8
X_0623_ NPU_ACT_WDATA5 Tile_X0Y1_UserCLK _0987_/X _0692_/L_HI VPWR VGND sg13cmos5l_dfrbpq_1
X_0554_ _0554_/Q Tile_X0Y1_FrameData[16] VGND VPWR Tile_X0Y1_FrameStrobe[6] latch
XFILLER_16_0 VPWR VGND sg13cmos5l_decap_4
XFILLER_38_222 VPWR VGND sg13cmos5l_decap_8
XFILLER_53_214 VPWR VGND sg13cmos5l_decap_8
X_1106_ _1106_/X Tile_X0Y1_E2MID[4] Tile_X0Y1_E2END[4] Tile_X0Y1_E6END[4] _1198_/X
+ _0588_/Q _0587_/Q VPWR VGND sg13cmos5l_mux4_1
X_0485_ _0485_/Q Tile_X0Y1_FrameData[21] VGND VPWR Tile_X0Y1_FrameStrobe[4] latch
XFILLER_21_133 VPWR VGND sg13cmos5l_decap_8
X_1037_ _1037_/X Tile_X0Y0_EE4END[4] _0642_/Q _1093_/X _1098_/X _0254_/Q _0253_/Q
+ VPWR VGND sg13cmos5l_mux4_1
XFILLER_107_227 VPWR VGND sg13cmos5l_decap_8
XFILLER_107_33 VPWR VGND sg13cmos5l_fill_1
XFILLER_29_200 VPWR VGND sg13cmos5l_decap_8
XFILLER_67_37 VPWR VGND sg13cmos5l_fill_2
XFILLER_88_133 VPWR VGND sg13cmos5l_decap_4
XFILLER_83_58 VPWR VGND sg13cmos5l_fill_2
XFILLER_16_85 VPWR VGND sg13cmos5l_fill_2
XFILLER_106_260 VPWR VGND sg13cmos5l_decap_4
XFILLER_113_208 VPWR VGND sg13cmos5l_decap_8
XFILLER_35_203 VPWR VGND sg13cmos5l_decap_8
X_0270_ _0270_/Q Tile_X0Y0_FrameData[14] VGND VPWR Tile_X0Y1_FrameStrobe[5] latch
XFILLER_94_158 VPWR VGND sg13cmos5l_decap_4
XFILLER_7_181 VPWR VGND sg13cmos5l_decap_8
XANTENNA__0800__X Tile_X0Y0_N1BEG[1] VPWR VGND sg13cmos5l_antennanp
XFILLER_104_219 VPWR VGND sg13cmos5l_decap_8
XFILLER_112_252 VPWR VGND sg13cmos5l_decap_8
XFILLER_85_103 VPWR VGND sg13cmos5l_decap_8
X_0606_ _0606_/Q Tile_X0Y1_FrameData[28] VGND VPWR Tile_X0Y1_FrameStrobe[8] latch
X_0537_ _0537_/Q Tile_X0Y1_FrameData[1] VGND VPWR Tile_X0Y1_FrameStrobe[5] latch
XFILLER_41_206 VPWR VGND sg13cmos5l_decap_8
X_0468_ _0468_/Q Tile_X0Y1_FrameData[6] VGND VPWR Tile_X0Y1_FrameStrobe[3] latch
X_0399_ _0399_/Q Tile_X0Y1_FrameData[11] VGND VPWR Tile_X0Y1_FrameStrobe[1] latch
XFILLER_93_180 VPWR VGND sg13cmos5l_decap_8
XFILLER_53_28 VPWR VGND sg13cmos5l_fill_2
XFILLER_78_14 VPWR VGND sg13cmos5l_decap_8
XFILLER_76_169 VPWR VGND sg13cmos5l_decap_8
XFILLER_78_69 VPWR VGND sg13cmos5l_decap_8
XFILLER_17_225 VPWR VGND sg13cmos5l_decap_8
XFILLER_27_84 VPWR VGND sg13cmos5l_decap_8
XFILLER_32_239 VPWR VGND sg13cmos5l_decap_8
XFILLER_91_128 VPWR VGND sg13cmos5l_decap_4
XFILLER_4_184 VPWR VGND sg13cmos5l_decap_8
XFILLER_57_7 VPWR VGND sg13cmos5l_decap_8
X_0322_ _0322_/Q Tile_X0Y0_FrameData[26] VGND VPWR Tile_X0Y1_FrameStrobe[7] latch
XFILLER_67_158 VPWR VGND sg13cmos5l_fill_2
XFILLER_75_191 VPWR VGND sg13cmos5l_decap_8
XFILLER_82_117 VPWR VGND sg13cmos5l_decap_8
XFILLER_84_90 VPWR VGND sg13cmos5l_decap_8
X_0253_ _0253_/Q Tile_X0Y0_FrameData[31] VGND VPWR Tile_X0Y1_FrameStrobe[5] latch
X_0184_ _0184_/Q Tile_X0Y0_FrameData[4] VGND VPWR Tile_X0Y1_FrameStrobe[2] latch
XFILLER_90_150 VPWR VGND sg13cmos5l_decap_4
XFILLER_23_206 VPWR VGND sg13cmos5l_decap_8
XFILLER_31_272 VPWR VGND sg13cmos5l_fill_1
XFILLER_83_0 VPWR VGND sg13cmos5l_fill_2
XFILLER_100_266 VPWR VGND sg13cmos5l_decap_8
XFILLER_48_17 VPWR VGND sg13cmos5l_decap_8
XFILLER_58_114 VPWR VGND sg13cmos5l_fill_1
XFILLER_58_158 VPWR VGND sg13cmos5l_decap_8
XFILLER_98_250 VPWR VGND sg13cmos5l_decap_8
XFILLER_104_67 VPWR VGND sg13cmos5l_fill_1
XFILLER_14_217 VPWR VGND sg13cmos5l_decap_8
XFILLER_73_139 VPWR VGND sg13cmos5l_decap_8
XFILLER_81_161 VPWR VGND sg13cmos5l_decap_8
XFILLER_22_272 VPWR VGND sg13cmos5l_fill_1
XFILLER_89_261 VPWR VGND sg13cmos5l_decap_8
XFILLER_89_272 VPWR VGND sg13cmos5l_fill_1
XFILLER_64_106 VPWR VGND sg13cmos5l_decap_8
XFILLER_64_128 VPWR VGND sg13cmos5l_decap_8
XFILLER_13_272 VPWR VGND sg13cmos5l_fill_1
XFILLER_72_161 VPWR VGND sg13cmos5l_fill_2
X_0940_ Tile_X0Y1_W2BEGb[3] _1158_/X VPWR VGND sg13cmos5l_buf_1
XFILLER_9_221 VPWR VGND sg13cmos5l_decap_8
XFILLER_118_108 VPWR VGND sg13cmos5l_decap_8
X_0871_ Tile_X0Y0_FrameData_O[15] Tile_X0Y0_FrameData[15] VPWR VGND sg13cmos5l_buf_1
X_0305_ _0305_/Q Tile_X0Y0_FrameData[11] VGND VPWR Tile_X0Y1_FrameStrobe[6] latch
XFILLER_95_242 VPWR VGND sg13cmos5l_decap_8
XFILLER_55_117 VPWR VGND sg13cmos5l_decap_8
XFILLER_63_183 VPWR VGND sg13cmos5l_decap_8
X_0236_ _0236_/Q Tile_X0Y0_FrameData[16] VGND VPWR Tile_X0Y1_FrameStrobe[4] latch
X_0167_ _0167_/Q Tile_X0Y0_FrameData[21] VGND VPWR Tile_X0Y1_FrameStrobe[2] latch
X_0098_ _0098_/Q Tile_X0Y0_FrameData[26] VGND VPWR Tile_X0Y1_FrameStrobe[0] latch
XFILLER_117_141 VPWR VGND sg13cmos5l_decap_4
XFILLER_59_16 VPWR VGND sg13cmos5l_decap_8
XFILLER_115_88 VPWR VGND sg13cmos5l_decap_8
XFILLER_46_106 VPWR VGND sg13cmos5l_decap_4
XFILLER_86_220 VPWR VGND sg13cmos5l_decap_8
XFILLER_86_264 VPWR VGND sg13cmos5l_fill_1
XFILLER_54_183 VPWR VGND sg13cmos5l_decap_8
XFILLER_61_109 VPWR VGND sg13cmos5l_decap_8
XFILLER_108_130 VPWR VGND sg13cmos5l_decap_8
XFILLER_6_235 VPWR VGND sg13cmos5l_decap_8
XFILLER_6_268 VPWR VGND sg13cmos5l_decap_4
XFILLER_77_231 VPWR VGND sg13cmos5l_decap_8
XFILLER_65_92 VPWR VGND sg13cmos5l_decap_4
X_1070_ _1070_/X _0643_/Q _1087_/X _1083_/X _1095_/X _0188_/Q _0187_/Q VPWR VGND sg13cmos5l_mux4_1
XFILLER_60_153 VPWR VGND sg13cmos5l_decap_8
X_0854_ Tile_X0Y1_FrameData_O[30] Tile_X0Y1_FrameData[30] VPWR VGND sg13cmos5l_buf_1
X_0923_ Tile_X0Y1_S4BEG[15] _0923_/A VPWR VGND sg13cmos5l_buf_1
XFILLER_114_177 VPWR VGND sg13cmos5l_decap_8
X_0785_ Tile_X0Y0_N2BEGb[2] _1105_/X VPWR VGND sg13cmos5l_buf_1
XFILLER_68_220 VPWR VGND sg13cmos5l_decap_8
XFILLER_68_264 VPWR VGND sg13cmos5l_fill_1
XFILLER_83_256 VPWR VGND sg13cmos5l_decap_8
XFILLER_101_68 VPWR VGND sg13cmos5l_fill_2
XFILLER_51_131 VPWR VGND sg13cmos5l_fill_1
X_1199_ _1199_/X Tile_X0Y1_N2MID[4] Tile_X0Y1_N2END[4] _1223_/X Tile_X0Y0_S2MID[4]
+ _0362_/Q _0361_/Q VPWR VGND sg13cmos5l_mux4_1
X_0219_ _0219_/Q Tile_X0Y0_FrameData[1] VGND VPWR Tile_X0Y1_FrameStrobe[3] latch
XFILLER_105_155 VPWR VGND sg13cmos5l_decap_8
XFILLER_86_25 VPWR VGND sg13cmos5l_decap_8
XFILLER_34_109 VPWR VGND sg13cmos5l_fill_2
XFILLER_74_245 VPWR VGND sg13cmos5l_decap_8
XFILLER_35_62 VPWR VGND sg13cmos5l_decap_8
XFILLER_42_131 VPWR VGND sg13cmos5l_decap_4
XFILLER_42_153 VPWR VGND sg13cmos5l_decap_8
X_0570_ _0570_/Q Tile_X0Y1_FrameData[0] VGND VPWR Tile_X0Y1_FrameStrobe[6] latch
XFILLER_111_114 VPWR VGND sg13cmos5l_fill_1
XFILLER_111_136 VPWR VGND sg13cmos5l_decap_8
XFILLER_111_169 VPWR VGND sg13cmos5l_decap_8
XFILLER_2_271 VPWR VGND sg13cmos5l_fill_2
XFILLER_65_256 VPWR VGND sg13cmos5l_decap_8
X_1122_ _1122_/X _1207_/X _1211_/X _1215_/X _1195_/X _0578_/Q _0577_/Q VPWR VGND sg13cmos5l_mux4_1
XFILLER_18_161 VPWR VGND sg13cmos5l_fill_1
XFILLER_18_172 VPWR VGND sg13cmos5l_decap_8
XFILLER_33_197 VPWR VGND sg13cmos5l_decap_8
XFILLER_80_204 VPWR VGND sg13cmos5l_decap_8
X_1053_ _1053_/X _0638_/Q _0642_/Q _1082_/X _1093_/X _0222_/Q _0221_/Q VPWR VGND sg13cmos5l_mux4_1
XANTENNA__0803__X Tile_X0Y0_FrameStrobe_O[0] VPWR VGND sg13cmos5l_antennanp
X_0906_ Tile_X0Y1_S2BEGb[6] _1225_/X VPWR VGND sg13cmos5l_buf_1
X_0837_ Tile_X0Y1_FrameData_O[13] Tile_X0Y1_FrameData[13] VPWR VGND sg13cmos5l_buf_1
XFILLER_102_169 VPWR VGND sg13cmos5l_decap_8
X_0768_ Tile_X0Y0_WW4BEG[1] _1048_/X VPWR VGND sg13cmos5l_buf_1
X_0699_ _0981_/A3 VPWR VGND sg13cmos5l_tielo
XFILLER_110_180 VPWR VGND sg13cmos5l_decap_8
XFILLER_112_45 VPWR VGND sg13cmos5l_decap_4
XFILLER_56_28 VPWR VGND sg13cmos5l_decap_8
XFILLER_71_215 VPWR VGND sg13cmos5l_decap_8
XFILLER_21_42 VPWR VGND sg13cmos5l_decap_4
XFILLER_47_223 VPWR VGND sg13cmos5l_decap_8
XFILLER_62_215 VPWR VGND sg13cmos5l_decap_8
XFILLER_94_8 VPWR VGND sg13cmos5l_decap_8
XFILLER_7_88 VPWR VGND sg13cmos5l_fill_2
X_0622_ NPU_ACT_WDATA4 Tile_X0Y1_UserCLK _0986_/X _0663_/L_HI VPWR VGND sg13cmos5l_dfrbpq_1
X_0553_ _0553_/Q Tile_X0Y1_FrameData[17] VGND VPWR Tile_X0Y1_FrameStrobe[6] latch
X_0484_ _0484_/Q Tile_X0Y1_FrameData[22] VGND VPWR Tile_X0Y1_FrameStrobe[4] latch
XFILLER_97_167 VPWR VGND sg13cmos5l_fill_2
XFILLER_97_101 VPWR VGND sg13cmos5l_decap_4
XFILLER_23_2 VPWR VGND sg13cmos5l_fill_1
XFILLER_38_201 VPWR VGND sg13cmos5l_decap_8
X_1105_ _1105_/X Tile_X0Y1_E2MID[5] Tile_X0Y1_E2END[5] Tile_X0Y1_E6END[5] _1197_/X
+ _0590_/Q _0589_/Q VPWR VGND sg13cmos5l_mux4_1
XFILLER_21_112 VPWR VGND sg13cmos5l_decap_8
X_1036_ _1036_/X Tile_X0Y0_EE4END[15] _0641_/Q _1094_/X _1097_/X _0256_/Q _0255_/Q
+ VPWR VGND sg13cmos5l_mux4_1
XFILLER_107_206 VPWR VGND sg13cmos5l_decap_8
XFILLER_115_261 VPWR VGND sg13cmos5l_decap_4
XFILLER_115_272 VPWR VGND sg13cmos5l_fill_1
XFILLER_29_245 VPWR VGND sg13cmos5l_fill_1
XFILLER_83_37 VPWR VGND sg13cmos5l_decap_8
XFILLER_8_149 VPWR VGND sg13cmos5l_fill_1
XFILLER_106_272 VPWR VGND sg13cmos5l_fill_1
XFILLER_113_0 VPWR VGND sg13cmos5l_decap_4
XFILLER_35_259 VPWR VGND sg13cmos5l_decap_8
XFILLER_50_218 VPWR VGND sg13cmos5l_decap_8
XFILLER_112_231 VPWR VGND sg13cmos5l_decap_8
XFILLER_85_159 VPWR VGND sg13cmos5l_decap_8
X_0605_ _0605_/Q Tile_X0Y1_FrameData[27] VGND VPWR Tile_X0Y1_FrameStrobe[8] latch
X_0536_ _0536_/Q Tile_X0Y1_FrameData[2] VGND VPWR Tile_X0Y1_FrameStrobe[5] latch
X_0467_ _0467_/Q Tile_X0Y1_FrameData[7] VGND VPWR Tile_X0Y1_FrameStrobe[3] latch
XFILLER_26_226 VPWR VGND sg13cmos5l_decap_8
X_1019_ _1019_/X Tile_X0Y0_E1END[0] Tile_X0Y0_EE4END[12] Tile_X0Y0_E6END[4] _1088_/X
+ _0286_/Q _0285_/Q VPWR VGND sg13cmos5l_mux4_1
X_0398_ _0398_/Q Tile_X0Y1_FrameData[12] VGND VPWR Tile_X0Y1_FrameStrobe[1] latch
XFILLER_118_11 VPWR VGND sg13cmos5l_fill_2
XFILLER_118_22 VPWR VGND sg13cmos5l_fill_1
XFILLER_118_33 VPWR VGND sg13cmos5l_fill_1
XFILLER_118_44 VPWR VGND sg13cmos5l_fill_2
XFILLER_17_204 VPWR VGND sg13cmos5l_decap_8
XFILLER_27_30 VPWR VGND sg13cmos5l_fill_1
XFILLER_84_181 VPWR VGND sg13cmos5l_decap_8
XFILLER_91_107 VPWR VGND sg13cmos5l_decap_8
XFILLER_32_218 VPWR VGND sg13cmos5l_decap_8
XFILLER_43_62 VPWR VGND sg13cmos5l_fill_1
XANTENNA__0901__X Tile_X0Y1_S2BEGb[1] VPWR VGND sg13cmos5l_antennanp
XFILLER_43_95 VPWR VGND sg13cmos5l_fill_2
XFILLER_4_141 VPWR VGND sg13cmos5l_decap_4
XFILLER_64_9 VPWR VGND sg13cmos5l_decap_4
XFILLER_4_163 VPWR VGND sg13cmos5l_decap_8
XFILLER_67_126 VPWR VGND sg13cmos5l_fill_1
X_0321_ _0321_/Q Tile_X0Y0_FrameData[27] VGND VPWR Tile_X0Y1_FrameStrobe[7] latch
X_0252_ _0252_/Q Tile_X0Y0_FrameData[0] VGND VPWR Tile_X0Y1_FrameStrobe[4] latch
X_0183_ _0183_/Q Tile_X0Y0_FrameData[5] VGND VPWR Tile_X0Y1_FrameStrobe[2] latch
XFILLER_76_0 VPWR VGND sg13cmos5l_fill_2
XANTENNA__0811__X Tile_X0Y0_FrameStrobe_O[8] VPWR VGND sg13cmos5l_antennanp
XFILLER_100_245 VPWR VGND sg13cmos5l_decap_8
XFILLER_73_118 VPWR VGND sg13cmos5l_decap_8
X_0519_ _0519_/Q Tile_X0Y1_FrameData[19] VGND VPWR Tile_X0Y1_FrameStrobe[5] latch
XFILLER_66_192 VPWR VGND sg13cmos5l_decap_8
XFILLER_81_140 VPWR VGND sg13cmos5l_decap_8
XANTENNA__0721__X Tile_X0Y0_W1BEG[2] VPWR VGND sg13cmos5l_antennanp
XFILLER_13_32 VPWR VGND sg13cmos5l_fill_1
XFILLER_13_98 VPWR VGND sg13cmos5l_fill_1
XFILLER_49_137 VPWR VGND sg13cmos5l_fill_1
XFILLER_89_240 VPWR VGND sg13cmos5l_decap_8
XFILLER_38_73 VPWR VGND sg13cmos5l_decap_8
XFILLER_38_95 VPWR VGND sg13cmos5l_fill_2
XFILLER_72_195 VPWR VGND sg13cmos5l_decap_8
X_0870_ Tile_X0Y0_FrameData_O[14] Tile_X0Y0_FrameData[14] VPWR VGND sg13cmos5l_buf_1
XFILLER_9_200 VPWR VGND sg13cmos5l_decap_8
XFILLER_48_4 VPWR VGND sg13cmos5l_fill_1
XFILLER_70_93 VPWR VGND sg13cmos5l_decap_8
XFILLER_55_107 VPWR VGND sg13cmos5l_fill_2
X_0304_ _0304_/Q Tile_X0Y0_FrameData[12] VGND VPWR Tile_X0Y1_FrameStrobe[6] latch
X_0235_ _0235_/Q Tile_X0Y0_FrameData[17] VGND VPWR Tile_X0Y1_FrameStrobe[4] latch
XFILLER_95_221 VPWR VGND sg13cmos5l_decap_8
XANTENNA__0806__X Tile_X0Y0_FrameStrobe_O[3] VPWR VGND sg13cmos5l_antennanp
XFILLER_48_181 VPWR VGND sg13cmos5l_decap_8
XFILLER_63_162 VPWR VGND sg13cmos5l_decap_8
X_0166_ _0166_/Q Tile_X0Y0_FrameData[22] VGND VPWR Tile_X0Y1_FrameStrobe[2] latch
X_0097_ _0097_/Q Tile_X0Y0_FrameData[27] VGND VPWR Tile_X0Y1_FrameStrobe[0] latch
XFILLER_109_109 VPWR VGND sg13cmos5l_fill_1
XFILLER_117_131 VPWR VGND sg13cmos5l_decap_8
X_0999_ _0999_/X Tile_X0Y0_E1END[0] Tile_X0Y0_E6END[4] _1075_/X _1100_/X _0346_/Q
+ _0345_/Q VPWR VGND sg13cmos5l_mux4_1
XFILLER_115_67 VPWR VGND sg13cmos5l_decap_8
XFILLER_54_162 VPWR VGND sg13cmos5l_decap_8
XFILLER_75_16 VPWR VGND sg13cmos5l_fill_1
XFILLER_91_15 VPWR VGND sg13cmos5l_fill_1
XFILLER_24_31 VPWR VGND sg13cmos5l_fill_1
XFILLER_24_64 VPWR VGND sg13cmos5l_decap_4
XFILLER_24_86 VPWR VGND sg13cmos5l_fill_1
XFILLER_91_48 VPWR VGND sg13cmos5l_decap_4
XFILLER_108_186 VPWR VGND sg13cmos5l_decap_8
XFILLER_6_214 VPWR VGND sg13cmos5l_decap_8
XFILLER_77_210 VPWR VGND sg13cmos5l_decap_8
XFILLER_60_132 VPWR VGND sg13cmos5l_decap_8
XFILLER_92_268 VPWR VGND sg13cmos5l_decap_4
XFILLER_81_70 VPWR VGND sg13cmos5l_fill_2
X_0853_ Tile_X0Y1_FrameData_O[29] Tile_X0Y1_FrameData[29] VPWR VGND sg13cmos5l_buf_1
X_0922_ Tile_X0Y1_S4BEG[14] _0922_/A VPWR VGND sg13cmos5l_buf_1
XFILLER_114_156 VPWR VGND sg13cmos5l_decap_8
XFILLER_39_0 VPWR VGND sg13cmos5l_decap_4
X_0784_ Tile_X0Y0_N2BEGb[1] _1104_/X VPWR VGND sg13cmos5l_buf_1
XFILLER_83_235 VPWR VGND sg13cmos5l_decap_8
X_1198_ _1198_/X Tile_X0Y1_N2MID[3] Tile_X0Y1_N2END[3] _1222_/X Tile_X0Y0_S2MID[3]
+ _0364_/Q _0363_/Q VPWR VGND sg13cmos5l_mux4_1
X_0218_ _0218_/Q Tile_X0Y0_FrameData[2] VGND VPWR Tile_X0Y1_FrameStrobe[3] latch
XFILLER_101_25 VPWR VGND sg13cmos5l_decap_8
XFILLER_36_184 VPWR VGND sg13cmos5l_decap_8
XFILLER_51_187 VPWR VGND sg13cmos5l_decap_8
XFILLER_51_198 VPWR VGND sg13cmos5l_fill_1
XFILLER_61_29 VPWR VGND sg13cmos5l_fill_2
X_0149_ _0149_/Q Tile_X0Y0_FrameData[7] VGND VPWR Tile_X0Y1_FrameStrobe[1] latch
XFILLER_105_112 VPWR VGND sg13cmos5l_decap_4
XFILLER_3_239 VPWR VGND sg13cmos5l_decap_8
XFILLER_10_88 VPWR VGND sg13cmos5l_decap_8
XFILLER_59_210 VPWR VGND sg13cmos5l_decap_8
XFILLER_19_86 VPWR VGND sg13cmos5l_fill_2
XFILLER_42_110 VPWR VGND sg13cmos5l_decap_8
XFILLER_74_224 VPWR VGND sg13cmos5l_decap_8
XFILLER_35_96 VPWR VGND sg13cmos5l_decap_8
XFILLER_65_235 VPWR VGND sg13cmos5l_decap_8
X_1052_ _1052_/X _0637_/Q _0641_/Q _1081_/X _1094_/X _0224_/Q _0223_/Q VPWR VGND sg13cmos5l_mux4_1
X_1121_ _1121_/X Tile_X0Y1_E1END[0] Tile_X0Y1_EE4END[0] Tile_X0Y1_E6END[8] _1203_/X
+ _0578_/Q _0577_/Q VPWR VGND sg13cmos5l_mux4_1
XFILLER_33_176 VPWR VGND sg13cmos5l_decap_8
X_0905_ Tile_X0Y1_S2BEGb[5] _1224_/X VPWR VGND sg13cmos5l_buf_1
X_0836_ Tile_X0Y1_FrameData_O[12] Tile_X0Y1_FrameData[12] VPWR VGND sg13cmos5l_buf_1
X_0767_ Tile_X0Y0_WW4BEG[0] _1047_/X VPWR VGND sg13cmos5l_buf_1
XFILLER_102_148 VPWR VGND sg13cmos5l_decap_8
X_0698_ _0698_/L_HI VPWR VGND sg13cmos5l_tiehi
XFILLER_112_24 VPWR VGND sg13cmos5l_decap_8
XFILLER_24_121 VPWR VGND sg13cmos5l_decap_8
XFILLER_72_28 VPWR VGND sg13cmos5l_fill_1
XANTENNA_50 Tile_X0Y1_N2MID[6] VPWR VGND sg13cmos5l_antennanp
XFILLER_21_21 VPWR VGND sg13cmos5l_decap_8
XFILLER_24_198 VPWR VGND sg13cmos5l_decap_8
XFILLER_21_98 VPWR VGND sg13cmos5l_decap_8
XFILLER_101_181 VPWR VGND sg13cmos5l_decap_8
XFILLER_47_202 VPWR VGND sg13cmos5l_decap_8
XANTENNA__0904__X Tile_X0Y1_S2BEGb[4] VPWR VGND sg13cmos5l_antennanp
XFILLER_46_62 VPWR VGND sg13cmos5l_decap_4
XFILLER_62_61 VPWR VGND sg13cmos5l_fill_2
XFILLER_70_260 VPWR VGND sg13cmos5l_decap_8
XFILLER_70_271 VPWR VGND sg13cmos5l_fill_2
XFILLER_116_218 VPWR VGND sg13cmos5l_decap_8
XFILLER_116_229 VPWR VGND sg13cmos5l_decap_8
XFILLER_7_45 VPWR VGND sg13cmos5l_fill_1
X_0621_ NPU_ACT_WDATA3 Tile_X0Y1_UserCLK _0985_/X _0662_/L_HI VPWR VGND sg13cmos5l_dfrbpq_1
X_0552_ _0552_/Q Tile_X0Y1_FrameData[18] VGND VPWR Tile_X0Y1_FrameStrobe[6] latch
X_0483_ _0483_/Q Tile_X0Y1_FrameData[23] VGND VPWR Tile_X0Y1_FrameStrobe[4] latch
XFILLER_38_257 VPWR VGND sg13cmos5l_decap_8
XFILLER_53_249 VPWR VGND sg13cmos5l_decap_8
X_1035_ _1035_/X Tile_X0Y0_EE4END[8] _0640_/Q _1095_/X _1096_/X _0258_/Q _0257_/Q
+ VPWR VGND sg13cmos5l_mux4_1
X_1104_ _1104_/X Tile_X0Y1_E2MID[6] Tile_X0Y1_E2END[6] Tile_X0Y1_E6END[6] _1196_/X
+ _0592_/Q _0591_/Q VPWR VGND sg13cmos5l_mux4_1
XANTENNA__0814__X Tile_X0Y0_FrameStrobe_O[11] VPWR VGND sg13cmos5l_antennanp
XFILLER_115_240 VPWR VGND sg13cmos5l_decap_8
XFILLER_88_113 VPWR VGND sg13cmos5l_fill_2
X_0819_ Tile_X0Y0_FrameStrobe_O[16] Tile_X0Y1_FrameStrobe[16] VPWR VGND sg13cmos5l_buf_1
XFILLER_88_179 VPWR VGND sg13cmos5l_decap_8
XANTENNA__0724__X Tile_X0Y0_W2BEG[1] VPWR VGND sg13cmos5l_antennanp
XFILLER_44_216 VPWR VGND sg13cmos5l_decap_8
XFILLER_32_75 VPWR VGND sg13cmos5l_decap_4
XFILLER_106_0 VPWR VGND sg13cmos5l_fill_2
XFILLER_79_124 VPWR VGND sg13cmos5l_fill_2
XFILLER_79_168 VPWR VGND sg13cmos5l_decap_4
XFILLER_35_238 VPWR VGND sg13cmos5l_decap_8
XFILLER_57_72 VPWR VGND sg13cmos5l_decap_8
XFILLER_73_82 VPWR VGND sg13cmos5l_decap_8
XFILLER_7_161 VPWR VGND sg13cmos5l_fill_2
X_0604_ _0604_/Q Tile_X0Y1_FrameData[26] VGND VPWR Tile_X0Y1_FrameStrobe[8] latch
XANTENNA__0809__X Tile_X0Y0_FrameStrobe_O[6] VPWR VGND sg13cmos5l_antennanp
XFILLER_21_0 VPWR VGND sg13cmos5l_decap_4
XFILLER_78_190 VPWR VGND sg13cmos5l_decap_8
XFILLER_85_138 VPWR VGND sg13cmos5l_decap_8
X_0535_ _0535_/Q Tile_X0Y1_FrameData[3] VGND VPWR Tile_X0Y1_FrameStrobe[5] latch
X_0466_ _0466_/Q Tile_X0Y1_FrameData[8] VGND VPWR Tile_X0Y1_FrameStrobe[3] latch
X_0397_ _0397_/Q Tile_X0Y1_FrameData[13] VGND VPWR Tile_X0Y1_FrameStrobe[1] latch
XFILLER_26_205 VPWR VGND sg13cmos5l_decap_8
XFILLER_34_271 VPWR VGND sg13cmos5l_fill_2
X_1018_ _1018_/X _1084_/X _1080_/X _1079_/X _1095_/X _0313_/Q _0312_/Q VPWR VGND sg13cmos5l_mux4_1
XFILLER_103_254 VPWR VGND sg13cmos5l_decap_8
XFILLER_118_67 VPWR VGND sg13cmos5l_decap_8
XFILLER_118_89 VPWR VGND sg13cmos5l_fill_2
XFILLER_78_49 VPWR VGND sg13cmos5l_decap_8
XANTENNA__0719__X Tile_X0Y0_W1BEG[0] VPWR VGND sg13cmos5l_antennanp
XFILLER_84_160 VPWR VGND sg13cmos5l_decap_8
XFILLER_94_59 VPWR VGND sg13cmos5l_fill_1
XFILLER_94_15 VPWR VGND sg13cmos5l_fill_2
XFILLER_40_252 VPWR VGND sg13cmos5l_decap_8
XFILLER_4_120 VPWR VGND sg13cmos5l_decap_8
XFILLER_99_219 VPWR VGND sg13cmos5l_decap_8
XFILLER_4_35 VPWR VGND sg13cmos5l_fill_1
XFILLER_4_57 VPWR VGND sg13cmos5l_fill_1
XFILLER_67_149 VPWR VGND sg13cmos5l_decap_4
XFILLER_68_71 VPWR VGND sg13cmos5l_decap_8
XFILLER_68_93 VPWR VGND sg13cmos5l_decap_8
X_0320_ _0320_/Q Tile_X0Y0_FrameData[28] VGND VPWR Tile_X0Y1_FrameStrobe[7] latch
X_0251_ _0251_/Q Tile_X0Y0_FrameData[1] VGND VPWR Tile_X0Y1_FrameStrobe[4] latch
XFILLER_75_171 VPWR VGND sg13cmos5l_decap_8
X_0182_ _0182_/Q Tile_X0Y0_FrameData[6] VGND VPWR Tile_X0Y1_FrameStrobe[2] latch
XFILLER_90_185 VPWR VGND sg13cmos5l_decap_8
XFILLER_90_163 VPWR VGND sg13cmos5l_decap_4
XFILLER_31_263 VPWR VGND sg13cmos5l_fill_1
XFILLER_69_0 VPWR VGND sg13cmos5l_fill_2
XFILLER_58_105 VPWR VGND sg13cmos5l_fill_2
X_0518_ _0518_/Q Tile_X0Y1_FrameData[20] VGND VPWR Tile_X0Y1_FrameStrobe[5] latch
XFILLER_100_224 VPWR VGND sg13cmos5l_decap_8
XFILLER_66_171 VPWR VGND sg13cmos5l_decap_8
X_0449_ _0449_/Q Tile_X0Y1_FrameData[25] VGND VPWR Tile_X0Y1_FrameStrobe[3] latch
XFILLER_22_263 VPWR VGND sg13cmos5l_fill_2
XFILLER_80_28 VPWR VGND sg13cmos5l_decap_4
XFILLER_81_196 VPWR VGND sg13cmos5l_decap_8
XFILLER_1_101 VPWR VGND sg13cmos5l_fill_2
XFILLER_1_134 VPWR VGND sg13cmos5l_fill_1
XFILLER_57_193 VPWR VGND sg13cmos5l_decap_8
XFILLER_72_174 VPWR VGND sg13cmos5l_decap_8
XANTENNA__0912__X Tile_X0Y1_S4BEG[4] VPWR VGND sg13cmos5l_antennanp
XFILLER_9_256 VPWR VGND sg13cmos5l_decap_4
X_0303_ _0303_/Q Tile_X0Y0_FrameData[13] VGND VPWR Tile_X0Y1_FrameStrobe[6] latch
X_0234_ _0234_/Q Tile_X0Y0_FrameData[18] VGND VPWR Tile_X0Y1_FrameStrobe[4] latch
XFILLER_95_200 VPWR VGND sg13cmos5l_decap_8
XFILLER_63_141 VPWR VGND sg13cmos5l_decap_8
X_0165_ _0165_/Q Tile_X0Y0_FrameData[23] VGND VPWR Tile_X0Y1_FrameStrobe[2] latch
X_0096_ _0096_/Q Tile_X0Y0_FrameData[28] VGND VPWR Tile_X0Y1_FrameStrobe[0] latch
XANTENNA__0822__X Tile_X0Y0_FrameStrobe_O[19] VPWR VGND sg13cmos5l_antennanp
X_0998_ _0998_/X Tile_X0Y0_EE4END[3] Tile_X0Y0_EE4END[11] Tile_X0Y0_E6END[3] _1091_/X
+ _0172_/Q _0171_/Q VPWR VGND sg13cmos5l_mux4_1
XFILLER_115_35 VPWR VGND sg13cmos5l_decap_4
XFILLER_117_187 VPWR VGND sg13cmos5l_decap_8
XFILLER_75_28 VPWR VGND sg13cmos5l_decap_4
XFILLER_86_255 VPWR VGND sg13cmos5l_decap_8
XFILLER_91_27 VPWR VGND sg13cmos5l_decap_8
XANTENNA__0732__X Tile_X0Y0_W2BEGb[1] VPWR VGND sg13cmos5l_antennanp
XFILLER_10_233 VPWR VGND sg13cmos5l_fill_2
XFILLER_24_43 VPWR VGND sg13cmos5l_decap_8
XFILLER_108_165 VPWR VGND sg13cmos5l_decap_8
XFILLER_1_14 VPWR VGND sg13cmos5l_decap_8
XFILLER_77_266 VPWR VGND sg13cmos5l_decap_8
XFILLER_92_236 VPWR VGND sg13cmos5l_fill_1
XFILLER_92_225 VPWR VGND sg13cmos5l_decap_8
XANTENNA__0907__X Tile_X0Y1_S2BEGb[7] VPWR VGND sg13cmos5l_antennanp
XFILLER_45_185 VPWR VGND sg13cmos5l_decap_8
XFILLER_60_111 VPWR VGND sg13cmos5l_decap_8
XFILLER_60_188 VPWR VGND sg13cmos5l_decap_8
X_0921_ Tile_X0Y1_S4BEG[13] _0921_/A VPWR VGND sg13cmos5l_buf_1
X_0852_ Tile_X0Y1_FrameData_O[28] Tile_X0Y1_FrameData[28] VPWR VGND sg13cmos5l_buf_1
X_0783_ Tile_X0Y0_N2BEGb[0] _1103_/X VPWR VGND sg13cmos5l_buf_1
XFILLER_114_135 VPWR VGND sg13cmos5l_decap_8
XFILLER_68_255 VPWR VGND sg13cmos5l_decap_8
XANTENNA__0817__X Tile_X0Y0_FrameStrobe_O[14] VPWR VGND sg13cmos5l_antennanp
XFILLER_36_163 VPWR VGND sg13cmos5l_decap_8
XFILLER_83_214 VPWR VGND sg13cmos5l_decap_8
X_1197_ _1197_/X Tile_X0Y1_N2MID[2] Tile_X0Y1_N2END[2] _1221_/X Tile_X0Y0_S2MID[2]
+ _0366_/Q _0365_/Q VPWR VGND sg13cmos5l_mux4_1
X_0217_ _0217_/Q Tile_X0Y0_FrameData[3] VGND VPWR Tile_X0Y1_FrameStrobe[3] latch
X_0148_ _0148_/Q Tile_X0Y0_FrameData[8] VGND VPWR Tile_X0Y1_FrameStrobe[1] latch
XFILLER_51_122 VPWR VGND sg13cmos5l_decap_8
XFILLER_51_166 VPWR VGND sg13cmos5l_decap_8
X_0079_ _0922_/A _1139_/X _1140_/X _0534_/Q VPWR VGND sg13cmos5l_mux2_1
XFILLER_105_135 VPWR VGND sg13cmos5l_fill_2
XFILLER_3_218 VPWR VGND sg13cmos5l_decap_8
XFILLER_19_65 VPWR VGND sg13cmos5l_decap_8
XFILLER_74_203 VPWR VGND sg13cmos5l_decap_8
XANTENNA__0727__X Tile_X0Y0_W2BEG[4] VPWR VGND sg13cmos5l_antennanp
XFILLER_27_185 VPWR VGND sg13cmos5l_decap_8
XFILLER_42_188 VPWR VGND sg13cmos5l_decap_8
XFILLER_51_41 VPWR VGND sg13cmos5l_decap_8
XFILLER_18_152 VPWR VGND sg13cmos5l_decap_8
XFILLER_65_214 VPWR VGND sg13cmos5l_decap_8
XFILLER_76_93 VPWR VGND sg13cmos5l_fill_2
XFILLER_80_239 VPWR VGND sg13cmos5l_decap_8
X_1051_ _1051_/X _0636_/Q _0640_/Q _1080_/X _1095_/X _0226_/Q _0225_/Q VPWR VGND sg13cmos5l_mux4_1
X_1120_ _1120_/X _1208_/X _1212_/X _1216_/X _1196_/X _0575_/Q _0574_/Q VPWR VGND sg13cmos5l_mux4_1
XFILLER_33_155 VPWR VGND sg13cmos5l_decap_8
X_0904_ Tile_X0Y1_S2BEGb[4] _1223_/X VPWR VGND sg13cmos5l_buf_1
XFILLER_51_0 VPWR VGND sg13cmos5l_fill_2
X_0835_ Tile_X0Y1_FrameData_O[11] Tile_X0Y1_FrameData[11] VPWR VGND sg13cmos5l_buf_1
X_0766_ Tile_X0Y0_N4BEG[15] _0766_/A VPWR VGND sg13cmos5l_buf_1
X_0697_ _0697_/L_HI VPWR VGND sg13cmos5l_tiehi
XFILLER_24_177 VPWR VGND sg13cmos5l_decap_8
XANTENNA_40 Tile_X0Y1_N2MID[4] VPWR VGND sg13cmos5l_antennanp
XANTENNA_51 Tile_X0Y1_N4END[5] VPWR VGND sg13cmos5l_antennanp
XFILLER_108_4 VPWR VGND sg13cmos5l_fill_2
XFILLER_21_88 VPWR VGND sg13cmos5l_fill_2
XFILLER_101_160 VPWR VGND sg13cmos5l_decap_8
XFILLER_15_177 VPWR VGND sg13cmos5l_decap_8
XFILLER_46_96 VPWR VGND sg13cmos5l_fill_2
XFILLER_62_95 VPWR VGND sg13cmos5l_fill_1
XANTENNA__0920__X Tile_X0Y1_S4BEG[12] VPWR VGND sg13cmos5l_antennanp
X_0620_ NPU_ACT_WDATA2 Tile_X0Y1_UserCLK _0984_/X _0661_/L_HI VPWR VGND sg13cmos5l_dfrbpq_1
X_0551_ _0551_/Q Tile_X0Y1_FrameData[19] VGND VPWR Tile_X0Y1_FrameStrobe[6] latch
XFILLER_38_236 VPWR VGND sg13cmos5l_decap_8
X_0482_ _0482_/Q Tile_X0Y1_FrameData[24] VGND VPWR Tile_X0Y1_FrameStrobe[4] latch
XFILLER_97_169 VPWR VGND sg13cmos5l_fill_1
XFILLER_97_114 VPWR VGND sg13cmos5l_decap_8
XFILLER_53_228 VPWR VGND sg13cmos5l_decap_8
X_1034_ _1034_/X Tile_X0Y0_EE4END[7] _0639_/Q _1095_/X _1096_/X _0260_/Q _0259_/Q
+ VPWR VGND sg13cmos5l_mux4_1
X_1103_ _1103_/X Tile_X0Y1_E2MID[7] Tile_X0Y1_E2END[7] Tile_X0Y1_E6END[7] _1195_/X
+ _0594_/Q _0593_/Q VPWR VGND sg13cmos5l_mux4_1
XFILLER_21_147 VPWR VGND sg13cmos5l_decap_8
XFILLER_61_272 VPWR VGND sg13cmos5l_fill_1
XANTENNA__0830__X Tile_X0Y1_FrameData_O[6] VPWR VGND sg13cmos5l_antennanp
XFILLER_107_69 VPWR VGND sg13cmos5l_fill_2
XFILLER_88_158 VPWR VGND sg13cmos5l_decap_8
X_0818_ Tile_X0Y0_FrameStrobe_O[15] Tile_X0Y1_FrameStrobe[15] VPWR VGND sg13cmos5l_buf_1
X_0749_ Tile_X0Y0_W6BEG[10] _1073_/X VPWR VGND sg13cmos5l_buf_1
XFILLER_29_214 VPWR VGND sg13cmos5l_decap_8
XFILLER_29_225 VPWR VGND sg13cmos5l_fill_2
XFILLER_16_55 VPWR VGND sg13cmos5l_fill_2
XFILLER_52_272 VPWR VGND sg13cmos5l_fill_1
XANTENNA__0740__X Tile_X0Y0_W6BEG[1] VPWR VGND sg13cmos5l_antennanp
XFILLER_32_32 VPWR VGND sg13cmos5l_fill_1
XFILLER_57_51 VPWR VGND sg13cmos5l_decap_8
XFILLER_94_128 VPWR VGND sg13cmos5l_fill_2
XFILLER_94_106 VPWR VGND sg13cmos5l_fill_1
XANTENNA__0915__X Tile_X0Y1_S4BEG[7] VPWR VGND sg13cmos5l_antennanp
XFILLER_35_217 VPWR VGND sg13cmos5l_decap_8
XFILLER_73_50 VPWR VGND sg13cmos5l_fill_1
XFILLER_73_72 VPWR VGND sg13cmos5l_fill_2
XFILLER_87_191 VPWR VGND sg13cmos5l_decap_8
XFILLER_43_272 VPWR VGND sg13cmos5l_fill_1
XFILLER_7_195 VPWR VGND sg13cmos5l_decap_4
X_0603_ _0603_/Q Tile_X0Y1_FrameData[31] VGND VPWR Tile_X0Y1_FrameStrobe[0] latch
X_0534_ _0534_/Q Tile_X0Y1_FrameData[4] VGND VPWR Tile_X0Y1_FrameStrobe[5] latch
XFILLER_112_266 VPWR VGND sg13cmos5l_decap_8
XFILLER_14_0 VPWR VGND sg13cmos5l_decap_4
XFILLER_85_117 VPWR VGND sg13cmos5l_decap_8
X_0465_ _0465_/Q Tile_X0Y1_FrameData[9] VGND VPWR Tile_X0Y1_FrameStrobe[3] latch
X_0396_ _0396_/Q Tile_X0Y1_FrameData[14] VGND VPWR Tile_X0Y1_FrameStrobe[1] latch
XANTENNA__0825__X Tile_X0Y1_FrameData_O[1] VPWR VGND sg13cmos5l_antennanp
XFILLER_34_250 VPWR VGND sg13cmos5l_decap_8
X_1017_ _1017_/X Tile_X0Y0_E1END[3] Tile_X0Y0_EE4END[3] Tile_X0Y0_E6END[11] _1091_/X
+ _0313_/Q _0312_/Q VPWR VGND sg13cmos5l_mux4_1
XFILLER_93_194 VPWR VGND sg13cmos5l_decap_8
XFILLER_103_233 VPWR VGND sg13cmos5l_decap_8
XFILLER_69_180 VPWR VGND sg13cmos5l_decap_8
XFILLER_78_28 VPWR VGND sg13cmos5l_decap_8
XANTENNA__0735__X Tile_X0Y0_W2BEGb[4] VPWR VGND sg13cmos5l_antennanp
XFILLER_17_239 VPWR VGND sg13cmos5l_decap_8
XFILLER_25_250 VPWR VGND sg13cmos5l_decap_8
XFILLER_27_98 VPWR VGND sg13cmos5l_decap_8
XFILLER_40_231 VPWR VGND sg13cmos5l_decap_8
XFILLER_43_31 VPWR VGND sg13cmos5l_decap_8
XFILLER_4_14 VPWR VGND sg13cmos5l_decap_8
XFILLER_4_198 VPWR VGND sg13cmos5l_decap_8
XFILLER_67_117 VPWR VGND sg13cmos5l_decap_8
X_0250_ _0250_/Q Tile_X0Y0_FrameData[2] VGND VPWR Tile_X0Y1_FrameStrobe[4] latch
X_0181_ _0181_/Q Tile_X0Y0_FrameData[7] VGND VPWR Tile_X0Y1_FrameStrobe[2] latch
XFILLER_16_272 VPWR VGND sg13cmos5l_fill_1
XFILLER_31_242 VPWR VGND sg13cmos5l_decap_8
XFILLER_100_203 VPWR VGND sg13cmos5l_decap_8
X_0517_ _0517_/Q Tile_X0Y1_FrameData[21] VGND VPWR Tile_X0Y1_FrameStrobe[5] latch
XFILLER_98_264 VPWR VGND sg13cmos5l_decap_8
XFILLER_66_150 VPWR VGND sg13cmos5l_decap_8
X_0448_ _0448_/Q Tile_X0Y1_FrameData[26] VGND VPWR Tile_X0Y1_FrameStrobe[3] latch
X_0379_ _0379_/Q Tile_X0Y1_FrameData[31] VGND VPWR Tile_X0Y1_FrameStrobe[1] latch
XFILLER_22_242 VPWR VGND sg13cmos5l_decap_8
XFILLER_81_175 VPWR VGND sg13cmos5l_decap_8
XFILLER_13_89 VPWR VGND sg13cmos5l_decap_8
XFILLER_1_168 VPWR VGND sg13cmos5l_decap_8
XFILLER_1_179 VPWR VGND sg13cmos5l_fill_1
XFILLER_38_97 VPWR VGND sg13cmos5l_fill_1
XFILLER_57_172 VPWR VGND sg13cmos5l_decap_8
XFILLER_70_51 VPWR VGND sg13cmos5l_decap_8
XFILLER_70_73 VPWR VGND sg13cmos5l_fill_2
XFILLER_9_235 VPWR VGND sg13cmos5l_decap_8
XFILLER_55_7 VPWR VGND sg13cmos5l_decap_8
X_0302_ _0302_/Q Tile_X0Y0_FrameData[14] VGND VPWR Tile_X0Y1_FrameStrobe[6] latch
XFILLER_48_194 VPWR VGND sg13cmos5l_decap_8
XFILLER_55_109 VPWR VGND sg13cmos5l_fill_1
X_0233_ _0233_/Q Tile_X0Y0_FrameData[19] VGND VPWR Tile_X0Y1_FrameStrobe[4] latch
X_0164_ _0164_/Q Tile_X0Y0_FrameData[24] VGND VPWR Tile_X0Y1_FrameStrobe[2] latch
XFILLER_95_256 VPWR VGND sg13cmos5l_decap_8
XFILLER_63_197 VPWR VGND sg13cmos5l_decap_8
XFILLER_81_0 VPWR VGND sg13cmos5l_decap_4
X_0095_ _0095_/Q Tile_X0Y0_FrameData[29] VGND VPWR Tile_X0Y1_FrameStrobe[0] latch
XFILLER_117_155 VPWR VGND sg13cmos5l_decap_4
XFILLER_117_166 VPWR VGND sg13cmos5l_decap_4
X_0997_ _0997_/X Tile_X0Y1_E1END[3] Tile_X0Y1_EE4END[7] Tile_X0Y1_EE4END[15] _1218_/X
+ _0404_/Q _0403_/Q VPWR VGND sg13cmos5l_mux4_1
XFILLER_115_14 VPWR VGND sg13cmos5l_decap_8
XFILLER_115_58 VPWR VGND sg13cmos5l_fill_2
XFILLER_86_234 VPWR VGND sg13cmos5l_decap_8
XFILLER_24_22 VPWR VGND sg13cmos5l_decap_8
XFILLER_39_183 VPWR VGND sg13cmos5l_decap_8
XFILLER_54_197 VPWR VGND sg13cmos5l_decap_8
XFILLER_10_212 VPWR VGND sg13cmos5l_decap_8
XFILLER_24_77 VPWR VGND sg13cmos5l_decap_8
XFILLER_40_10 VPWR VGND sg13cmos5l_fill_1
XFILLER_40_32 VPWR VGND sg13cmos5l_fill_2
XFILLER_6_249 VPWR VGND sg13cmos5l_decap_8
XFILLER_108_144 VPWR VGND sg13cmos5l_decap_8
XFILLER_105_91 VPWR VGND sg13cmos5l_decap_8
XFILLER_77_245 VPWR VGND sg13cmos5l_decap_8
XFILLER_92_248 VPWR VGND sg13cmos5l_decap_8
XFILLER_92_204 VPWR VGND sg13cmos5l_decap_8
XANTENNA__0923__X Tile_X0Y1_S4BEG[15] VPWR VGND sg13cmos5l_antennanp
XFILLER_60_167 VPWR VGND sg13cmos5l_decap_8
XFILLER_81_83 VPWR VGND sg13cmos5l_decap_8
X_0920_ Tile_X0Y1_S4BEG[12] _0920_/A VPWR VGND sg13cmos5l_buf_1
XFILLER_5_260 VPWR VGND sg13cmos5l_decap_4
X_0851_ Tile_X0Y1_FrameData_O[27] Tile_X0Y1_FrameData[27] VPWR VGND sg13cmos5l_buf_1
X_0782_ Tile_X0Y0_WW4BEG[15] _1062_/X VPWR VGND sg13cmos5l_buf_1
XFILLER_68_234 VPWR VGND sg13cmos5l_decap_8
X_1196_ _1196_/X Tile_X0Y1_N2MID[1] Tile_X0Y1_N2END[1] _1220_/X Tile_X0Y0_S2MID[1]
+ _0368_/Q _0367_/Q VPWR VGND sg13cmos5l_mux4_1
X_0216_ _0216_/Q Tile_X0Y0_FrameData[4] VGND VPWR Tile_X0Y1_FrameStrobe[3] latch
X_0147_ _0147_/Q Tile_X0Y0_FrameData[9] VGND VPWR Tile_X0Y1_FrameStrobe[1] latch
X_0078_ _0921_/A _1137_/X _1138_/X _0537_/Q VPWR VGND sg13cmos5l_mux2_1
XANTENNA__0833__X Tile_X0Y1_FrameData_O[9] VPWR VGND sg13cmos5l_antennanp
XFILLER_105_169 VPWR VGND sg13cmos5l_decap_8
XFILLER_10_35 VPWR VGND sg13cmos5l_decap_4
XFILLER_113_180 VPWR VGND sg13cmos5l_decap_8
XFILLER_19_44 VPWR VGND sg13cmos5l_decap_8
XFILLER_27_120 VPWR VGND sg13cmos5l_fill_1
XFILLER_59_245 VPWR VGND sg13cmos5l_decap_8
XFILLER_74_259 VPWR VGND sg13cmos5l_decap_8
XFILLER_86_39 VPWR VGND sg13cmos5l_decap_4
XANTENNA__0743__X Tile_X0Y0_W6BEG[4] VPWR VGND sg13cmos5l_antennanp
XFILLER_35_21 VPWR VGND sg13cmos5l_fill_1
XFILLER_35_76 VPWR VGND sg13cmos5l_fill_2
XFILLER_42_167 VPWR VGND sg13cmos5l_decap_8
XFILLER_104_191 VPWR VGND sg13cmos5l_decap_8
XFILLER_25_8 VPWR VGND sg13cmos5l_decap_8
XFILLER_2_252 VPWR VGND sg13cmos5l_fill_2
XANTENNA__0918__X Tile_X0Y1_S4BEG[10] VPWR VGND sg13cmos5l_antennanp
XFILLER_18_131 VPWR VGND sg13cmos5l_decap_8
XFILLER_18_186 VPWR VGND sg13cmos5l_fill_2
XFILLER_33_134 VPWR VGND sg13cmos5l_decap_8
XFILLER_80_218 VPWR VGND sg13cmos5l_decap_8
X_1050_ _1050_/X _0639_/Q _0643_/Q _1075_/X _1096_/X _0228_/Q _0227_/Q VPWR VGND sg13cmos5l_mux4_1
XFILLER_92_71 VPWR VGND sg13cmos5l_decap_8
XFILLER_92_60 VPWR VGND sg13cmos5l_decap_4
X_0903_ Tile_X0Y1_S2BEGb[3] _1222_/X VPWR VGND sg13cmos5l_buf_1
X_0834_ Tile_X0Y1_FrameData_O[10] Tile_X0Y1_FrameData[10] VPWR VGND sg13cmos5l_buf_1
XFILLER_44_0 VPWR VGND sg13cmos5l_fill_2
X_0765_ Tile_X0Y0_N4BEG[14] _0765_/A VPWR VGND sg13cmos5l_buf_1
X_0696_ _0696_/L_HI VPWR VGND sg13cmos5l_tiehi
XANTENNA__0828__X Tile_X0Y1_FrameData_O[4] VPWR VGND sg13cmos5l_antennanp
XFILLER_110_194 VPWR VGND sg13cmos5l_decap_8
XFILLER_112_15 VPWR VGND sg13cmos5l_decap_4
XFILLER_24_156 VPWR VGND sg13cmos5l_decap_8
XFILLER_71_229 VPWR VGND sg13cmos5l_decap_8
X_1179_ _1179_/X Tile_X0Y1_N4END[0] Tile_X0Y0_S4END[4] _1214_/X _1218_/X _0458_/Q
+ _0457_/Q VPWR VGND sg13cmos5l_mux4_1
XANTENNA_30 Tile_X0Y0_S2MID[6] VPWR VGND sg13cmos5l_antennanp
XANTENNA_41 Tile_X0Y1_N2MID[4] VPWR VGND sg13cmos5l_antennanp
XANTENNA_52 Tile_X0Y1_N4END[5] VPWR VGND sg13cmos5l_antennanp
XANTENNA__0738__X Tile_X0Y0_W2BEGb[7] VPWR VGND sg13cmos5l_antennanp
XFILLER_62_229 VPWR VGND sg13cmos5l_decap_8
XFILLER_15_156 VPWR VGND sg13cmos5l_decap_8
XFILLER_30_159 VPWR VGND sg13cmos5l_decap_8
XFILLER_109_261 VPWR VGND sg13cmos5l_decap_8
XFILLER_109_272 VPWR VGND sg13cmos5l_fill_1
X_0550_ _0550_/Q Tile_X0Y1_FrameData[20] VGND VPWR Tile_X0Y1_FrameStrobe[6] latch
XFILLER_16_4 VPWR VGND sg13cmos5l_fill_1
XFILLER_38_215 VPWR VGND sg13cmos5l_decap_8
XFILLER_87_93 VPWR VGND sg13cmos5l_decap_4
X_1102_ _1102_/X _1113_/X Tile_X0Y0_E6END[2] Tile_X0Y0_S1END[2] _1102_/A3 _0096_/Q
+ _0095_/Q VPWR VGND sg13cmos5l_mux4_1
X_0481_ _0481_/Q Tile_X0Y1_FrameData[25] VGND VPWR Tile_X0Y1_FrameStrobe[4] latch
XFILLER_21_126 VPWR VGND sg13cmos5l_decap_8
XFILLER_53_207 VPWR VGND sg13cmos5l_decap_8
X_1033_ _1033_/X Tile_X0Y0_EE4END[6] _0638_/Q _1094_/X _1097_/X _0262_/Q _0261_/Q
+ VPWR VGND sg13cmos5l_mux4_1
X_0817_ Tile_X0Y0_FrameStrobe_O[14] Tile_X0Y1_FrameStrobe[14] VPWR VGND sg13cmos5l_buf_1
XFILLER_107_15 VPWR VGND sg13cmos5l_decap_4
XFILLER_88_126 VPWR VGND sg13cmos5l_decap_8
X_0748_ Tile_X0Y0_W6BEG[9] _1072_/X VPWR VGND sg13cmos5l_buf_1
X_0679_ _0679_/L_HI VPWR VGND sg13cmos5l_tiehi
XFILLER_96_192 VPWR VGND sg13cmos5l_decap_8
XFILLER_32_11 VPWR VGND sg13cmos5l_decap_8
XFILLER_106_2 VPWR VGND sg13cmos5l_fill_1
XFILLER_106_253 VPWR VGND sg13cmos5l_decap_8
XFILLER_106_264 VPWR VGND sg13cmos5l_fill_1
XFILLER_57_30 VPWR VGND sg13cmos5l_decap_8
XFILLER_87_170 VPWR VGND sg13cmos5l_decap_8
XFILLER_43_251 VPWR VGND sg13cmos5l_decap_8
XANTENNA__0931__X Tile_X0Y1_W2BEG[2] VPWR VGND sg13cmos5l_antennanp
XFILLER_7_163 VPWR VGND sg13cmos5l_fill_1
XFILLER_7_174 VPWR VGND sg13cmos5l_decap_8
XFILLER_112_223 VPWR VGND sg13cmos5l_decap_4
XFILLER_112_245 VPWR VGND sg13cmos5l_decap_8
X_0602_ _0602_/Q Tile_X0Y1_FrameData[0] VGND VPWR Tile_X0Y1_FrameStrobe[7] latch
X_0533_ _0533_/Q Tile_X0Y1_FrameData[5] VGND VPWR Tile_X0Y1_FrameStrobe[5] latch
X_0464_ _0464_/Q Tile_X0Y1_FrameData[10] VGND VPWR Tile_X0Y1_FrameStrobe[3] latch
X_0395_ _0395_/Q Tile_X0Y1_FrameData[15] VGND VPWR Tile_X0Y1_FrameStrobe[1] latch
XFILLER_93_173 VPWR VGND sg13cmos5l_decap_8
XFILLER_93_140 VPWR VGND sg13cmos5l_decap_8
X_1016_ _1016_/X _1085_/X _1081_/X _1077_/X _1094_/X _0316_/Q _0315_/Q VPWR VGND sg13cmos5l_mux4_1
XANTENNA__0841__X Tile_X0Y1_FrameData_O[17] VPWR VGND sg13cmos5l_antennanp
XFILLER_103_212 VPWR VGND sg13cmos5l_decap_8
XFILLER_94_17 VPWR VGND sg13cmos5l_fill_1
XFILLER_17_218 VPWR VGND sg13cmos5l_decap_8
XFILLER_27_66 VPWR VGND sg13cmos5l_decap_8
XFILLER_40_210 VPWR VGND sg13cmos5l_decap_8
XFILLER_84_195 VPWR VGND sg13cmos5l_decap_8
XANTENNA__0751__X Tile_X0Y0_N4BEG[0] VPWR VGND sg13cmos5l_antennanp
XFILLER_111_0 VPWR VGND sg13cmos5l_decap_8
XFILLER_4_177 VPWR VGND sg13cmos5l_decap_8
XANTENNA__0926__X Tile_X0Y1_W1BEG[1] VPWR VGND sg13cmos5l_antennanp
XFILLER_75_151 VPWR VGND sg13cmos5l_fill_2
XFILLER_75_184 VPWR VGND sg13cmos5l_decap_8
XFILLER_84_83 VPWR VGND sg13cmos5l_decap_8
X_0180_ _0180_/Q Tile_X0Y0_FrameData[8] VGND VPWR Tile_X0Y1_FrameStrobe[2] latch
XFILLER_90_110 VPWR VGND sg13cmos5l_decap_4
XFILLER_16_251 VPWR VGND sg13cmos5l_decap_8
XFILLER_31_221 VPWR VGND sg13cmos5l_decap_8
XFILLER_90_154 VPWR VGND sg13cmos5l_fill_2
XFILLER_90_143 VPWR VGND sg13cmos5l_decap_8
XANTENNA__0610__Q NPU_WEIGHT_IN0 VPWR VGND sg13cmos5l_antennanp
XFILLER_100_259 VPWR VGND sg13cmos5l_decap_8
X_0516_ _0516_/Q Tile_X0Y1_FrameData[22] VGND VPWR Tile_X0Y1_FrameStrobe[5] latch
X_0447_ _0447_/Q Tile_X0Y1_FrameData[27] VGND VPWR Tile_X0Y1_FrameStrobe[3] latch
XFILLER_98_243 VPWR VGND sg13cmos5l_decap_8
XANTENNA__0836__X Tile_X0Y1_FrameData_O[12] VPWR VGND sg13cmos5l_antennanp
XFILLER_81_110 VPWR VGND sg13cmos5l_fill_2
XFILLER_81_154 VPWR VGND sg13cmos5l_decap_8
X_0378_ _0378_/Q Tile_X0Y1_FrameData[0] VGND VPWR Tile_X0Y1_FrameStrobe[0] latch
XFILLER_22_221 VPWR VGND sg13cmos5l_decap_8
XFILLER_89_254 VPWR VGND sg13cmos5l_decap_8
XANTENNA__0746__X Tile_X0Y0_W6BEG[7] VPWR VGND sg13cmos5l_antennanp
XFILLER_38_43 VPWR VGND sg13cmos5l_decap_4
XFILLER_38_87 VPWR VGND sg13cmos5l_fill_1
XFILLER_13_232 VPWR VGND sg13cmos5l_fill_2
XFILLER_9_214 VPWR VGND sg13cmos5l_decap_8
XFILLER_110_81 VPWR VGND sg13cmos5l_decap_8
XFILLER_70_30 VPWR VGND sg13cmos5l_decap_8
XFILLER_79_72 VPWR VGND sg13cmos5l_decap_8
XFILLER_79_94 VPWR VGND sg13cmos5l_fill_2
X_0301_ _0301_/Q Tile_X0Y0_FrameData[15] VGND VPWR Tile_X0Y1_FrameStrobe[6] latch
XFILLER_95_235 VPWR VGND sg13cmos5l_decap_8
XFILLER_63_176 VPWR VGND sg13cmos5l_decap_8
X_0232_ _0232_/Q Tile_X0Y0_FrameData[20] VGND VPWR Tile_X0Y1_FrameStrobe[4] latch
X_0163_ _0163_/Q Tile_X0Y0_FrameData[25] VGND VPWR Tile_X0Y1_FrameStrobe[2] latch
X_0094_ _0094_/Q Tile_X0Y0_FrameData[30] VGND VPWR Tile_X0Y1_FrameStrobe[0] latch
XFILLER_74_0 VPWR VGND sg13cmos5l_fill_1
X_0996_ _0996_/X Tile_X0Y1_E1END[2] Tile_X0Y1_EE4END[6] Tile_X0Y1_EE4END[14] _1217_/X
+ _0406_/Q _0405_/Q VPWR VGND sg13cmos5l_mux4_1
XFILLER_117_145 VPWR VGND sg13cmos5l_fill_2
XFILLER_54_121 VPWR VGND sg13cmos5l_decap_8
XFILLER_86_213 VPWR VGND sg13cmos5l_decap_8
XFILLER_86_268 VPWR VGND sg13cmos5l_decap_4
XFILLER_54_154 VPWR VGND sg13cmos5l_decap_4
XFILLER_54_176 VPWR VGND sg13cmos5l_decap_8
XFILLER_108_101 VPWR VGND sg13cmos5l_fill_1
XFILLER_6_228 VPWR VGND sg13cmos5l_decap_8
XFILLER_77_224 VPWR VGND sg13cmos5l_decap_8
XFILLER_105_81 VPWR VGND sg13cmos5l_fill_2
XFILLER_45_132 VPWR VGND sg13cmos5l_decap_4
XFILLER_45_165 VPWR VGND sg13cmos5l_fill_2
XFILLER_65_85 VPWR VGND sg13cmos5l_decap_8
XFILLER_65_96 VPWR VGND sg13cmos5l_fill_2
XFILLER_60_146 VPWR VGND sg13cmos5l_decap_8
X_0850_ Tile_X0Y1_FrameData_O[26] Tile_X0Y1_FrameData[26] VPWR VGND sg13cmos5l_buf_1
XFILLER_5_272 VPWR VGND sg13cmos5l_fill_1
X_0781_ Tile_X0Y0_WW4BEG[14] _1061_/X VPWR VGND sg13cmos5l_buf_1
XFILLER_68_213 VPWR VGND sg13cmos5l_decap_8
XFILLER_68_268 VPWR VGND sg13cmos5l_decap_4
XFILLER_83_249 VPWR VGND sg13cmos5l_decap_8
X_0215_ _0215_/Q Tile_X0Y0_FrameData[5] VGND VPWR Tile_X0Y1_FrameStrobe[3] latch
XFILLER_36_198 VPWR VGND sg13cmos5l_decap_8
X_1195_ _1195_/X Tile_X0Y1_N2MID[0] Tile_X0Y1_N2END[0] _1219_/X Tile_X0Y0_S2MID[0]
+ _0370_/Q _0369_/Q VPWR VGND sg13cmos5l_mux4_1
X_0146_ _0146_/Q Tile_X0Y0_FrameData[10] VGND VPWR Tile_X0Y1_FrameStrobe[1] latch
X_0077_ _0920_/A _1135_/X _1136_/X _0540_/Q VPWR VGND sg13cmos5l_mux2_1
XFILLER_91_271 VPWR VGND sg13cmos5l_fill_2
XFILLER_91_260 VPWR VGND sg13cmos5l_decap_8
X_0979_ _0979_/X Tile_X0Y0_E2MID[6] Tile_X0Y0_E2END[6] _1098_/X _0979_/A3 _0158_/Q
+ _0157_/Q VPWR VGND sg13cmos5l_mux4_1
XFILLER_105_148 VPWR VGND sg13cmos5l_decap_8
XFILLER_59_224 VPWR VGND sg13cmos5l_fill_2
XFILLER_19_34 VPWR VGND sg13cmos5l_fill_2
XFILLER_59_268 VPWR VGND sg13cmos5l_decap_4
XFILLER_74_238 VPWR VGND sg13cmos5l_decap_8
XFILLER_42_124 VPWR VGND sg13cmos5l_decap_8
XFILLER_42_146 VPWR VGND sg13cmos5l_decap_8
XFILLER_50_190 VPWR VGND sg13cmos5l_decap_8
XFILLER_4_0 VPWR VGND sg13cmos5l_decap_8
XFILLER_104_170 VPWR VGND sg13cmos5l_decap_8
XFILLER_111_129 VPWR VGND sg13cmos5l_decap_8
XANTENNA__0934__X Tile_X0Y1_W2BEG[5] VPWR VGND sg13cmos5l_antennanp
XFILLER_65_249 VPWR VGND sg13cmos5l_decap_8
XFILLER_76_95 VPWR VGND sg13cmos5l_fill_1
X_0902_ Tile_X0Y1_S2BEGb[2] _1221_/X VPWR VGND sg13cmos5l_buf_1
X_0833_ Tile_X0Y1_FrameData_O[9] Tile_X0Y1_FrameData[9] VPWR VGND sg13cmos5l_buf_1
XFILLER_37_0 VPWR VGND sg13cmos5l_fill_2
X_0764_ Tile_X0Y0_N4BEG[13] _0764_/A VPWR VGND sg13cmos5l_buf_1
X_0695_ _0695_/L_HI VPWR VGND sg13cmos5l_tiehi
XFILLER_110_173 VPWR VGND sg13cmos5l_decap_8
XFILLER_112_38 VPWR VGND sg13cmos5l_decap_8
XFILLER_112_49 VPWR VGND sg13cmos5l_fill_1
XFILLER_71_208 VPWR VGND sg13cmos5l_decap_8
X_1178_ _1178_/X _0647_/Q _0651_/Q _1203_/X _1195_/X _0460_/Q _0459_/Q VPWR VGND sg13cmos5l_mux4_1
XANTENNA_20 Tile_X0Y0_S2MID[3] VPWR VGND sg13cmos5l_antennanp
XANTENNA_31 Tile_X0Y0_S2MID[6] VPWR VGND sg13cmos5l_antennanp
XANTENNA__0844__X Tile_X0Y1_FrameData_O[20] VPWR VGND sg13cmos5l_antennanp
XFILLER_32_190 VPWR VGND sg13cmos5l_decap_8
X_0129_ _0129_/Q Tile_X0Y0_FrameData[27] VGND VPWR Tile_X0Y1_FrameStrobe[1] latch
XANTENNA_42 Tile_X0Y1_N2MID[5] VPWR VGND sg13cmos5l_antennanp
XANTENNA_53 Tile_X0Y1_N4END[5] VPWR VGND sg13cmos5l_antennanp
XFILLER_115_7 VPWR VGND sg13cmos5l_decap_8
XFILLER_118_262 VPWR VGND sg13cmos5l_decap_8
XFILLER_21_35 VPWR VGND sg13cmos5l_decap_8
XFILLER_47_216 VPWR VGND sg13cmos5l_decap_8
XANTENNA__0754__X Tile_X0Y0_N4BEG[3] VPWR VGND sg13cmos5l_antennanp
XFILLER_101_195 VPWR VGND sg13cmos5l_decap_8
XFILLER_46_32 VPWR VGND sg13cmos5l_fill_2
XFILLER_46_98 VPWR VGND sg13cmos5l_fill_1
XFILLER_62_208 VPWR VGND sg13cmos5l_decap_8
XFILLER_109_240 VPWR VGND sg13cmos5l_decap_8
XANTENNA__0929__X Tile_X0Y1_W2BEG[0] VPWR VGND sg13cmos5l_antennanp
XFILLER_87_61 VPWR VGND sg13cmos5l_decap_8
X_0480_ _0480_/Q Tile_X0Y1_FrameData[26] VGND VPWR Tile_X0Y1_FrameStrobe[4] latch
XFILLER_97_105 VPWR VGND sg13cmos5l_fill_2
X_1032_ _1032_/X Tile_X0Y0_EE4END[5] _0637_/Q _1093_/X _1098_/X _0264_/Q _0263_/Q
+ VPWR VGND sg13cmos5l_mux4_1
X_1101_ _1101_/X _1112_/X Tile_X0Y0_E6END[1] Tile_X0Y0_S1END[1] _1101_/A3 _0098_/Q
+ _0097_/Q VPWR VGND sg13cmos5l_mux4_1
XFILLER_21_105 VPWR VGND sg13cmos5l_decap_8
XFILLER_61_263 VPWR VGND sg13cmos5l_fill_2
XANTENNA__0613__Q NPU_WEIGHT_IN3 VPWR VGND sg13cmos5l_antennanp
XFILLER_115_221 VPWR VGND sg13cmos5l_decap_8
XFILLER_115_232 VPWR VGND sg13cmos5l_fill_1
X_0816_ Tile_X0Y0_FrameStrobe_O[13] Tile_X0Y1_FrameStrobe[13] VPWR VGND sg13cmos5l_buf_1
X_0747_ Tile_X0Y0_W6BEG[8] _1071_/X VPWR VGND sg13cmos5l_buf_1
XANTENNA__0839__X Tile_X0Y1_FrameData_O[15] VPWR VGND sg13cmos5l_antennanp
XFILLER_115_254 VPWR VGND sg13cmos5l_decap_8
X_0678_ _0678_/L_HI VPWR VGND sg13cmos5l_tiehi
XFILLER_96_171 VPWR VGND sg13cmos5l_decap_8
XFILLER_29_238 VPWR VGND sg13cmos5l_decap_8
XFILLER_52_252 VPWR VGND sg13cmos5l_decap_8
XFILLER_52_263 VPWR VGND sg13cmos5l_fill_2
XFILLER_106_232 VPWR VGND sg13cmos5l_decap_8
XFILLER_113_4 VPWR VGND sg13cmos5l_fill_2
XANTENNA__0749__X Tile_X0Y0_W6BEG[10] VPWR VGND sg13cmos5l_antennanp
XFILLER_113_81 VPWR VGND sg13cmos5l_fill_2
XFILLER_43_230 VPWR VGND sg13cmos5l_decap_8
XFILLER_73_74 VPWR VGND sg13cmos5l_fill_1
XFILLER_11_160 VPWR VGND sg13cmos5l_fill_1
XFILLER_11_193 VPWR VGND sg13cmos5l_decap_8
XFILLER_78_7 VPWR VGND sg13cmos5l_decap_8
X_0601_ _0601_/Q Tile_X0Y1_FrameData[1] VGND VPWR Tile_X0Y1_FrameStrobe[7] latch
XFILLER_112_202 VPWR VGND sg13cmos5l_decap_8
X_0532_ _0532_/Q Tile_X0Y1_FrameData[6] VGND VPWR Tile_X0Y1_FrameStrobe[5] latch
X_0463_ _0463_/Q Tile_X0Y1_FrameData[11] VGND VPWR Tile_X0Y1_FrameStrobe[3] latch
X_0394_ _0394_/Q Tile_X0Y1_FrameData[16] VGND VPWR Tile_X0Y1_FrameStrobe[1] latch
XFILLER_26_219 VPWR VGND sg13cmos5l_decap_8
X_1015_ _1015_/X Tile_X0Y0_E1END[2] Tile_X0Y0_EE4END[2] Tile_X0Y0_E6END[10] _1090_/X
+ _0316_/Q _0315_/Q VPWR VGND sg13cmos5l_mux4_1
XFILLER_103_268 VPWR VGND sg13cmos5l_decap_4
XFILLER_94_29 VPWR VGND sg13cmos5l_decap_4
XFILLER_43_22 VPWR VGND sg13cmos5l_fill_2
XFILLER_84_174 VPWR VGND sg13cmos5l_decap_8
XFILLER_40_266 VPWR VGND sg13cmos5l_decap_8
XFILLER_104_0 VPWR VGND sg13cmos5l_fill_1
XFILLER_108_81 VPWR VGND sg13cmos5l_fill_2
XFILLER_4_134 VPWR VGND sg13cmos5l_decap_8
XFILLER_4_156 VPWR VGND sg13cmos5l_fill_2
XFILLER_67_108 VPWR VGND sg13cmos5l_fill_2
XFILLER_16_230 VPWR VGND sg13cmos5l_decap_8
XFILLER_84_62 VPWR VGND sg13cmos5l_decap_8
XANTENNA__0942__X Tile_X0Y1_W2BEGb[5] VPWR VGND sg13cmos5l_antennanp
XFILLER_31_200 VPWR VGND sg13cmos5l_decap_8
XFILLER_90_199 VPWR VGND sg13cmos5l_decap_8
XFILLER_98_222 VPWR VGND sg13cmos5l_decap_8
XFILLER_100_238 VPWR VGND sg13cmos5l_decap_8
X_0515_ _0515_/Q Tile_X0Y1_FrameData[23] VGND VPWR Tile_X0Y1_FrameStrobe[5] latch
X_0446_ _0446_/Q Tile_X0Y1_FrameData[28] VGND VPWR Tile_X0Y1_FrameStrobe[3] latch
X_0377_ _0377_/Q Tile_X0Y1_FrameData[1] VGND VPWR Tile_X0Y1_FrameStrobe[0] latch
XFILLER_22_200 VPWR VGND sg13cmos5l_decap_8
XFILLER_66_185 VPWR VGND sg13cmos5l_decap_8
XFILLER_81_133 VPWR VGND sg13cmos5l_decap_8
XANTENNA__0852__X Tile_X0Y1_FrameData_O[28] VPWR VGND sg13cmos5l_antennanp
XFILLER_49_108 VPWR VGND sg13cmos5l_decap_4
XFILLER_89_233 VPWR VGND sg13cmos5l_decap_8
XFILLER_38_66 VPWR VGND sg13cmos5l_decap_8
XFILLER_54_32 VPWR VGND sg13cmos5l_decap_4
XFILLER_72_122 VPWR VGND sg13cmos5l_decap_8
XANTENNA__0762__X Tile_X0Y0_N4BEG[11] VPWR VGND sg13cmos5l_antennanp
XFILLER_13_211 VPWR VGND sg13cmos5l_decap_8
XFILLER_72_188 VPWR VGND sg13cmos5l_decap_8
XFILLER_48_8 VPWR VGND sg13cmos5l_fill_1
XFILLER_70_86 VPWR VGND sg13cmos5l_decap_8
XANTENNA__0937__X Tile_X0Y1_W2BEGb[0] VPWR VGND sg13cmos5l_antennanp
X_0300_ _0300_/Q Tile_X0Y0_FrameData[16] VGND VPWR Tile_X0Y1_FrameStrobe[6] latch
X_0231_ _0231_/Q Tile_X0Y0_FrameData[21] VGND VPWR Tile_X0Y1_FrameStrobe[4] latch
XFILLER_95_214 VPWR VGND sg13cmos5l_decap_8
XFILLER_48_174 VPWR VGND sg13cmos5l_decap_8
XFILLER_63_155 VPWR VGND sg13cmos5l_decap_8
X_0162_ _0162_/Q Tile_X0Y0_FrameData[26] VGND VPWR Tile_X0Y1_FrameStrobe[2] latch
X_0093_ NPU_XBAR_SEL3 Tile_X0Y1_UserCLK _0093_/D _0652_/L_HI VPWR VGND sg13cmos5l_dfrbpq_1
XFILLER_117_124 VPWR VGND sg13cmos5l_decap_8
XFILLER_67_0 VPWR VGND sg13cmos5l_fill_2
X_0995_ _0995_/X Tile_X0Y1_E1END[1] Tile_X0Y1_EE4END[5] Tile_X0Y1_EE4END[13] _1216_/X
+ _0408_/Q _0407_/Q VPWR VGND sg13cmos5l_mux4_1
XANTENNA__0621__Q NPU_ACT_WDATA3 VPWR VGND sg13cmos5l_antennanp
XANTENNA__0847__X Tile_X0Y1_FrameData_O[23] VPWR VGND sg13cmos5l_antennanp
XFILLER_39_163 VPWR VGND sg13cmos5l_fill_2
X_0429_ _0429_/Q Tile_X0Y1_FrameData[13] VGND VPWR Tile_X0Y1_FrameStrobe[2] latch
XFILLER_24_57 VPWR VGND sg13cmos5l_decap_8
XFILLER_24_68 VPWR VGND sg13cmos5l_fill_2
XFILLER_108_179 VPWR VGND sg13cmos5l_decap_8
XFILLER_10_269 VPWR VGND sg13cmos5l_decap_4
XFILLER_40_34 VPWR VGND sg13cmos5l_fill_1
XFILLER_6_207 VPWR VGND sg13cmos5l_decap_8
XANTENNA__0757__X Tile_X0Y0_N4BEG[6] VPWR VGND sg13cmos5l_antennanp
XFILLER_105_60 VPWR VGND sg13cmos5l_decap_8
XFILLER_116_190 VPWR VGND sg13cmos5l_decap_8
XFILLER_1_28 VPWR VGND sg13cmos5l_fill_2
XFILLER_49_76 VPWR VGND sg13cmos5l_decap_4
XFILLER_77_203 VPWR VGND sg13cmos5l_decap_8
XFILLER_45_199 VPWR VGND sg13cmos5l_decap_8
XFILLER_60_125 VPWR VGND sg13cmos5l_decap_8
XFILLER_81_41 VPWR VGND sg13cmos5l_decap_4
XFILLER_81_52 VPWR VGND sg13cmos5l_decap_8
X_0780_ Tile_X0Y0_WW4BEG[13] _1060_/X VPWR VGND sg13cmos5l_buf_1
XFILLER_114_149 VPWR VGND sg13cmos5l_decap_8
XFILLER_39_4 VPWR VGND sg13cmos5l_fill_1
XFILLER_36_122 VPWR VGND sg13cmos5l_decap_4
XFILLER_83_228 VPWR VGND sg13cmos5l_decap_8
X_1194_ _1194_/X Tile_X0Y1_N1END[3] Tile_X0Y1_E6END[3] _1230_/X _1194_/A3 _0348_/Q
+ _0603_/Q VPWR VGND sg13cmos5l_mux4_1
X_0214_ _0214_/Q Tile_X0Y0_FrameData[6] VGND VPWR Tile_X0Y1_FrameStrobe[3] latch
XANTENNA__0616__Q NPU_WEIGHT_IN6 VPWR VGND sg13cmos5l_antennanp
XFILLER_101_18 VPWR VGND sg13cmos5l_fill_2
XFILLER_36_177 VPWR VGND sg13cmos5l_decap_8
X_0145_ _0145_/Q Tile_X0Y0_FrameData[11] VGND VPWR Tile_X0Y1_FrameStrobe[1] latch
X_0076_ _0762_/A _1115_/X _1116_/X _0567_/Q VPWR VGND sg13cmos5l_mux2_1
XFILLER_105_105 VPWR VGND sg13cmos5l_fill_2
XFILLER_105_116 VPWR VGND sg13cmos5l_fill_2
X_0978_ _0978_/X Tile_X0Y0_E2MID[5] Tile_X0Y0_E2END[5] _1097_/X _0978_/A3 _0160_/Q
+ _0159_/Q VPWR VGND sg13cmos5l_mux4_1
XFILLER_59_203 VPWR VGND sg13cmos5l_decap_8
XFILLER_19_79 VPWR VGND sg13cmos5l_decap_8
XFILLER_27_199 VPWR VGND sg13cmos5l_decap_8
XFILLER_42_103 VPWR VGND sg13cmos5l_decap_8
XFILLER_74_217 VPWR VGND sg13cmos5l_decap_8
XFILLER_82_261 VPWR VGND sg13cmos5l_decap_8
XFILLER_82_272 VPWR VGND sg13cmos5l_fill_1
XFILLER_35_89 VPWR VGND sg13cmos5l_decap_8
XFILLER_51_55 VPWR VGND sg13cmos5l_fill_2
XFILLER_2_232 VPWR VGND sg13cmos5l_decap_8
XFILLER_116_70 VPWR VGND sg13cmos5l_decap_8
XFILLER_65_228 VPWR VGND sg13cmos5l_decap_8
XFILLER_18_166 VPWR VGND sg13cmos5l_fill_2
XFILLER_18_188 VPWR VGND sg13cmos5l_fill_1
XFILLER_33_169 VPWR VGND sg13cmos5l_decap_8
XFILLER_73_261 VPWR VGND sg13cmos5l_decap_4
XFILLER_73_272 VPWR VGND sg13cmos5l_fill_1
XANTENNA__0950__X Tile_X0Y1_W6BEG[5] VPWR VGND sg13cmos5l_antennanp
X_0901_ Tile_X0Y1_S2BEGb[1] _1220_/X VPWR VGND sg13cmos5l_buf_1
X_0832_ Tile_X0Y1_FrameData_O[8] Tile_X0Y1_FrameData[8] VPWR VGND sg13cmos5l_buf_1
X_0763_ Tile_X0Y0_N4BEG[12] _0763_/A VPWR VGND sg13cmos5l_buf_1
XFILLER_110_141 VPWR VGND sg13cmos5l_fill_1
X_0694_ _0694_/L_HI VPWR VGND sg13cmos5l_tiehi
XFILLER_110_152 VPWR VGND sg13cmos5l_decap_8
XFILLER_24_114 VPWR VGND sg13cmos5l_decap_8
XFILLER_2_93 VPWR VGND sg13cmos5l_decap_8
X_1177_ _1177_/X _0646_/Q _0650_/Q _1204_/X _1196_/X _0462_/Q _0461_/Q VPWR VGND sg13cmos5l_mux4_1
X_0128_ _0128_/Q Tile_X0Y0_FrameData[28] VGND VPWR Tile_X0Y1_FrameStrobe[1] latch
XANTENNA_10 Tile_X0Y0_FrameData[22] VPWR VGND sg13cmos5l_antennanp
XANTENNA_21 Tile_X0Y0_S2MID[3] VPWR VGND sg13cmos5l_antennanp
XANTENNA_32 Tile_X0Y0_S2MID[7] VPWR VGND sg13cmos5l_antennanp
XANTENNA_43 Tile_X0Y1_N2MID[5] VPWR VGND sg13cmos5l_antennanp
XANTENNA_54 Tile_X0Y1_N4END[5] VPWR VGND sg13cmos5l_antennanp
XANTENNA__0860__X Tile_X0Y0_FrameData_O[4] VPWR VGND sg13cmos5l_antennanp
XFILLER_118_241 VPWR VGND sg13cmos5l_decap_8
XFILLER_101_174 VPWR VGND sg13cmos5l_decap_8
XFILLER_99_191 VPWR VGND sg13cmos5l_decap_8
XFILLER_102_94 VPWR VGND sg13cmos5l_decap_4
XFILLER_15_114 VPWR VGND sg13cmos5l_fill_2
XFILLER_46_55 VPWR VGND sg13cmos5l_decap_8
XFILLER_46_66 VPWR VGND sg13cmos5l_fill_2
XFILLER_70_253 VPWR VGND sg13cmos5l_decap_8
XANTENNA__0770__X Tile_X0Y0_WW4BEG[3] VPWR VGND sg13cmos5l_antennanp
XFILLER_11_80 VPWR VGND sg13cmos5l_decap_8
XFILLER_87_40 VPWR VGND sg13cmos5l_decap_8
XFILLER_97_128 VPWR VGND sg13cmos5l_decap_4
XANTENNA__0945__X Tile_X0Y1_W6BEG[0] VPWR VGND sg13cmos5l_antennanp
XFILLER_46_250 VPWR VGND sg13cmos5l_decap_8
XFILLER_46_261 VPWR VGND sg13cmos5l_fill_1
XFILLER_46_272 VPWR VGND sg13cmos5l_fill_1
X_1031_ _1031_/X Tile_X0Y0_EE4END[4] _0636_/Q _1092_/X _1099_/X _0266_/Q _0265_/Q
+ VPWR VGND sg13cmos5l_mux4_1
X_1100_ _1100_/X _1111_/X Tile_X0Y0_E6END[0] Tile_X0Y0_S1END[0] _1100_/A3 _0100_/Q
+ _0099_/Q VPWR VGND sg13cmos5l_mux4_1
XFILLER_61_242 VPWR VGND sg13cmos5l_decap_8
XFILLER_115_200 VPWR VGND sg13cmos5l_decap_8
XFILLER_88_106 VPWR VGND sg13cmos5l_decap_8
X_0815_ Tile_X0Y0_FrameStrobe_O[12] Tile_X0Y1_FrameStrobe[12] VPWR VGND sg13cmos5l_buf_1
X_0746_ Tile_X0Y0_W6BEG[7] _1070_/X VPWR VGND sg13cmos5l_buf_1
X_0677_ _0677_/L_HI VPWR VGND sg13cmos5l_tiehi
XFILLER_96_150 VPWR VGND sg13cmos5l_decap_8
XANTENNA__0855__X Tile_X0Y1_FrameData_O[31] VPWR VGND sg13cmos5l_antennanp
XFILLER_44_209 VPWR VGND sg13cmos5l_decap_8
XFILLER_52_231 VPWR VGND sg13cmos5l_decap_8
X_1229_ _1229_/X Tile_X0Y0_E1END[2] Tile_X0Y0_E6END[10] _1077_/X _1102_/X _0306_/Q
+ _0305_/Q VPWR VGND sg13cmos5l_mux4_1
XFILLER_20_194 VPWR VGND sg13cmos5l_decap_8
XFILLER_32_68 VPWR VGND sg13cmos5l_decap_8
XFILLER_32_79 VPWR VGND sg13cmos5l_fill_1
XFILLER_106_211 VPWR VGND sg13cmos5l_decap_8
XANTENNA__0765__X Tile_X0Y0_N4BEG[14] VPWR VGND sg13cmos5l_antennanp
XFILLER_28_272 VPWR VGND sg13cmos5l_fill_1
XFILLER_57_21 VPWR VGND sg13cmos5l_fill_2
XFILLER_57_65 VPWR VGND sg13cmos5l_decap_8
XFILLER_73_42 VPWR VGND sg13cmos5l_decap_4
XFILLER_11_172 VPWR VGND sg13cmos5l_decap_8
XFILLER_7_121 VPWR VGND sg13cmos5l_decap_8
X_0600_ _0600_/Q Tile_X0Y1_FrameData[2] VGND VPWR Tile_X0Y1_FrameStrobe[7] latch
X_0531_ _0531_/Q Tile_X0Y1_FrameData[7] VGND VPWR Tile_X0Y1_FrameStrobe[5] latch
XFILLER_98_61 VPWR VGND sg13cmos5l_decap_4
XFILLER_21_4 VPWR VGND sg13cmos5l_fill_1
XFILLER_78_183 VPWR VGND sg13cmos5l_decap_8
X_0462_ _0462_/Q Tile_X0Y1_FrameData[12] VGND VPWR Tile_X0Y1_FrameStrobe[3] latch
X_0393_ _0393_/Q Tile_X0Y1_FrameData[17] VGND VPWR Tile_X0Y1_FrameStrobe[1] latch
XFILLER_19_272 VPWR VGND sg13cmos5l_fill_1
XFILLER_34_264 VPWR VGND sg13cmos5l_decap_8
X_1014_ _1014_/X _1086_/X _1082_/X _1076_/X _1093_/X _0319_/Q _0318_/Q VPWR VGND sg13cmos5l_mux4_1
XANTENNA__0624__Q NPU_ACT_WDATA6 VPWR VGND sg13cmos5l_antennanp
XFILLER_97_0 VPWR VGND sg13cmos5l_fill_2
XFILLER_103_247 VPWR VGND sg13cmos5l_decap_8
X_0729_ Tile_X0Y0_W2BEG[6] _1037_/X VPWR VGND sg13cmos5l_buf_1
XFILLER_69_150 VPWR VGND sg13cmos5l_decap_8
XFILLER_69_161 VPWR VGND sg13cmos5l_fill_1
XFILLER_69_194 VPWR VGND sg13cmos5l_decap_8
XFILLER_84_153 VPWR VGND sg13cmos5l_decap_8
XFILLER_25_264 VPWR VGND sg13cmos5l_fill_1
XFILLER_40_245 VPWR VGND sg13cmos5l_decap_8
XFILLER_43_45 VPWR VGND sg13cmos5l_decap_4
XFILLER_4_113 VPWR VGND sg13cmos5l_decap_8
XFILLER_68_64 VPWR VGND sg13cmos5l_decap_8
XFILLER_17_90 VPWR VGND sg13cmos5l_decap_8
XFILLER_75_164 VPWR VGND sg13cmos5l_decap_8
XFILLER_84_41 VPWR VGND sg13cmos5l_decap_8
XFILLER_90_178 VPWR VGND sg13cmos5l_decap_8
XFILLER_31_256 VPWR VGND sg13cmos5l_decap_8
X_0514_ _0514_/Q Tile_X0Y1_FrameData[24] VGND VPWR Tile_X0Y1_FrameStrobe[5] latch
XFILLER_98_201 VPWR VGND sg13cmos5l_decap_8
XANTENNA__0619__Q NPU_ACT_WDATA1 VPWR VGND sg13cmos5l_antennanp
XFILLER_100_217 VPWR VGND sg13cmos5l_decap_8
XFILLER_12_0 VPWR VGND sg13cmos5l_fill_2
XFILLER_66_164 VPWR VGND sg13cmos5l_decap_8
X_0445_ _0445_/Q Tile_X0Y1_FrameData[29] VGND VPWR Tile_X0Y1_FrameStrobe[3] latch
X_0376_ _0376_/Q Tile_X0Y1_FrameData[2] VGND VPWR Tile_X0Y1_FrameStrobe[0] latch
XFILLER_22_256 VPWR VGND sg13cmos5l_fill_2
XFILLER_81_189 VPWR VGND sg13cmos5l_decap_8
XFILLER_89_212 VPWR VGND sg13cmos5l_decap_8
XFILLER_54_55 VPWR VGND sg13cmos5l_fill_2
XFILLER_57_186 VPWR VGND sg13cmos5l_decap_8
XFILLER_72_167 VPWR VGND sg13cmos5l_decap_8
XFILLER_9_249 VPWR VGND sg13cmos5l_decap_8
XFILLER_48_131 VPWR VGND sg13cmos5l_fill_1
X_0230_ _0230_/Q Tile_X0Y0_FrameData[22] VGND VPWR Tile_X0Y1_FrameStrobe[4] latch
X_0161_ _0161_/Q Tile_X0Y0_FrameData[27] VGND VPWR Tile_X0Y1_FrameStrobe[2] latch
XANTENNA__0953__X Tile_X0Y1_W6BEG[8] VPWR VGND sg13cmos5l_antennanp
XFILLER_63_134 VPWR VGND sg13cmos5l_decap_8
X_0092_ NPU_XBAR_SEL2 Tile_X0Y1_UserCLK _0092_/D _0698_/L_HI VPWR VGND sg13cmos5l_dfrbpq_1
X_0994_ _0994_/X Tile_X0Y1_E1END[0] Tile_X0Y1_EE4END[4] Tile_X0Y1_EE4END[12] _1215_/X
+ _0410_/Q _0409_/Q VPWR VGND sg13cmos5l_mux4_1
XFILLER_115_28 VPWR VGND sg13cmos5l_decap_8
XFILLER_115_39 VPWR VGND sg13cmos5l_fill_2
XFILLER_86_248 VPWR VGND sg13cmos5l_decap_8
XANTENNA__0863__X Tile_X0Y0_FrameData_O[7] VPWR VGND sg13cmos5l_antennanp
XFILLER_39_131 VPWR VGND sg13cmos5l_decap_8
XFILLER_39_197 VPWR VGND sg13cmos5l_decap_8
X_0428_ _0428_/Q Tile_X0Y1_FrameData[14] VGND VPWR Tile_X0Y1_FrameStrobe[2] latch
X_0359_ _0359_/Q Tile_X0Y1_FrameData[19] VGND VPWR Tile_X0Y1_FrameStrobe[0] latch
XFILLER_94_270 VPWR VGND sg13cmos5l_fill_2
XFILLER_10_226 VPWR VGND sg13cmos5l_decap_8
XFILLER_24_14 VPWR VGND sg13cmos5l_fill_1
XFILLER_108_158 VPWR VGND sg13cmos5l_decap_8
XFILLER_105_83 VPWR VGND sg13cmos5l_fill_1
XFILLER_77_259 VPWR VGND sg13cmos5l_decap_8
XFILLER_92_218 VPWR VGND sg13cmos5l_decap_8
XANTENNA__0773__X Tile_X0Y0_WW4BEG[6] VPWR VGND sg13cmos5l_antennanp
XFILLER_45_167 VPWR VGND sg13cmos5l_fill_1
XFILLER_45_178 VPWR VGND sg13cmos5l_decap_8
XFILLER_65_65 VPWR VGND sg13cmos5l_decap_4
XFILLER_81_20 VPWR VGND sg13cmos5l_decap_8
XFILLER_81_75 VPWR VGND sg13cmos5l_decap_4
XANTENNA__0948__X Tile_X0Y1_W6BEG[3] VPWR VGND sg13cmos5l_antennanp
XFILLER_114_128 VPWR VGND sg13cmos5l_decap_8
XFILLER_30_90 VPWR VGND sg13cmos5l_fill_2
XFILLER_36_156 VPWR VGND sg13cmos5l_decap_8
XFILLER_68_248 VPWR VGND sg13cmos5l_decap_8
XFILLER_83_207 VPWR VGND sg13cmos5l_decap_8
X_1193_ _1193_/X Tile_X0Y1_N1END[2] Tile_X0Y1_E6END[2] _1229_/X _1193_/A3 _0350_/Q
+ _0349_/Q VPWR VGND sg13cmos5l_mux4_1
X_0213_ _0213_/Q Tile_X0Y0_FrameData[7] VGND VPWR Tile_X0Y1_FrameStrobe[3] latch
X_0144_ _0144_/Q Tile_X0Y0_FrameData[12] VGND VPWR Tile_X0Y1_FrameStrobe[1] latch
X_0075_ _0761_/A _1117_/X _1118_/X _0570_/Q VPWR VGND sg13cmos5l_mux2_1
XANTENNA__0632__Q NPU_ACT_ADDR6 VPWR VGND sg13cmos5l_antennanp
XFILLER_105_128 VPWR VGND sg13cmos5l_decap_8
X_0977_ _0977_/X Tile_X0Y0_E2MID[4] Tile_X0Y0_E2END[4] _1096_/X _0977_/A3 _0162_/Q
+ _0161_/Q VPWR VGND sg13cmos5l_mux4_1
XANTENNA__0858__X Tile_X0Y0_FrameData_O[2] VPWR VGND sg13cmos5l_antennanp
XFILLER_113_194 VPWR VGND sg13cmos5l_decap_8
XFILLER_19_36 VPWR VGND sg13cmos5l_fill_1
XFILLER_19_58 VPWR VGND sg13cmos5l_decap_8
XFILLER_59_259 VPWR VGND sg13cmos5l_decap_4
XFILLER_27_178 VPWR VGND sg13cmos5l_decap_8
XFILLER_82_240 VPWR VGND sg13cmos5l_decap_8
XFILLER_51_12 VPWR VGND sg13cmos5l_decap_8
XFILLER_51_34 VPWR VGND sg13cmos5l_decap_8
XANTENNA__0768__X Tile_X0Y0_WW4BEG[1] VPWR VGND sg13cmos5l_antennanp
XFILLER_2_211 VPWR VGND sg13cmos5l_decap_8
XFILLER_18_145 VPWR VGND sg13cmos5l_decap_8
XFILLER_65_207 VPWR VGND sg13cmos5l_decap_8
XFILLER_73_240 VPWR VGND sg13cmos5l_decap_8
XFILLER_76_20 VPWR VGND sg13cmos5l_decap_8
XFILLER_76_64 VPWR VGND sg13cmos5l_fill_1
XFILLER_92_30 VPWR VGND sg13cmos5l_decap_4
XFILLER_25_90 VPWR VGND sg13cmos5l_decap_4
XFILLER_33_148 VPWR VGND sg13cmos5l_decap_8
XFILLER_41_192 VPWR VGND sg13cmos5l_decap_8
X_0900_ Tile_X0Y1_S2BEGb[0] _1219_/X VPWR VGND sg13cmos5l_buf_1
XFILLER_92_85 VPWR VGND sg13cmos5l_decap_4
X_0831_ Tile_X0Y1_FrameData_O[7] Tile_X0Y1_FrameData[7] VPWR VGND sg13cmos5l_buf_1
X_0762_ Tile_X0Y0_N4BEG[11] _0762_/A VPWR VGND sg13cmos5l_buf_1
X_0693_ _0693_/L_HI VPWR VGND sg13cmos5l_tiehi
XFILLER_110_120 VPWR VGND sg13cmos5l_decap_8
XFILLER_56_207 VPWR VGND sg13cmos5l_decap_4
XANTENNA__0627__Q NPU_ACT_ADDR1 VPWR VGND sg13cmos5l_antennanp
X_1176_ _1176_/X _0645_/Q _0649_/Q _1205_/X _1197_/X _0464_/Q _0463_/Q VPWR VGND sg13cmos5l_mux4_1
X_0127_ _0127_/Q Tile_X0Y0_FrameData[29] VGND VPWR Tile_X0Y1_FrameStrobe[1] latch
XANTENNA_11 Tile_X0Y0_FrameData[22] VPWR VGND sg13cmos5l_antennanp
XANTENNA_22 Tile_X0Y0_S2MID[4] VPWR VGND sg13cmos5l_antennanp
XANTENNA_33 Tile_X0Y0_S2MID[7] VPWR VGND sg13cmos5l_antennanp
XANTENNA_44 Tile_X0Y1_N2MID[5] VPWR VGND sg13cmos5l_antennanp
XANTENNA_55 Tile_X0Y1_N4END[5] VPWR VGND sg13cmos5l_antennanp
XFILLER_118_220 VPWR VGND sg13cmos5l_decap_8
XFILLER_99_170 VPWR VGND sg13cmos5l_decap_8
XFILLER_101_153 VPWR VGND sg13cmos5l_decap_4
XFILLER_23_192 VPWR VGND sg13cmos5l_decap_8
XFILLER_46_89 VPWR VGND sg13cmos5l_decap_8
XFILLER_62_88 VPWR VGND sg13cmos5l_decap_8
XFILLER_70_232 VPWR VGND sg13cmos5l_decap_8
XFILLER_38_229 VPWR VGND sg13cmos5l_decap_8
XFILLER_61_221 VPWR VGND sg13cmos5l_decap_8
X_1030_ _1030_/X _1114_/X Tile_X0Y0_S1END[3] _0637_/Q _0640_/Q _0268_/Q _0267_/Q VPWR
+ VGND sg13cmos5l_mux4_1
XANTENNA__0961__X Tile_X0Y1_WW4BEG[4] VPWR VGND sg13cmos5l_antennanp
X_0814_ Tile_X0Y0_FrameStrobe_O[11] Tile_X0Y1_FrameStrobe[11] VPWR VGND sg13cmos5l_buf_1
XFILLER_107_29 VPWR VGND sg13cmos5l_decap_4
XFILLER_42_0 VPWR VGND sg13cmos5l_fill_2
X_0745_ Tile_X0Y0_W6BEG[6] _1069_/X VPWR VGND sg13cmos5l_buf_1
X_0676_ _0676_/L_HI VPWR VGND sg13cmos5l_tiehi
XFILLER_29_207 VPWR VGND sg13cmos5l_decap_8
X_1228_ _1228_/X Tile_X0Y0_E1END[1] Tile_X0Y0_E6END[9] _1076_/X _1101_/X _0308_/Q
+ _0307_/Q VPWR VGND sg13cmos5l_mux4_1
XANTENNA__0871__X Tile_X0Y0_FrameData_O[15] VPWR VGND sg13cmos5l_antennanp
XFILLER_52_210 VPWR VGND sg13cmos5l_decap_8
X_1159_ _1159_/X Tile_X0Y1_EE4END[9] _0648_/Q _1198_/X _1199_/X _0498_/Q _0497_/Q
+ VPWR VGND sg13cmos5l_mux4_1
XANTENNA__0092__Q NPU_XBAR_SEL2 VPWR VGND sg13cmos5l_antennanp
XFILLER_32_25 VPWR VGND sg13cmos5l_decap_8
XFILLER_28_251 VPWR VGND sg13cmos5l_decap_8
XFILLER_28_262 VPWR VGND sg13cmos5l_fill_2
XFILLER_73_21 VPWR VGND sg13cmos5l_decap_8
XFILLER_73_65 VPWR VGND sg13cmos5l_decap_8
XFILLER_87_184 VPWR VGND sg13cmos5l_decap_8
XANTENNA__0781__X Tile_X0Y0_WW4BEG[14] VPWR VGND sg13cmos5l_antennanp
XFILLER_7_188 VPWR VGND sg13cmos5l_decap_8
X_0530_ _0530_/Q Tile_X0Y1_FrameData[8] VGND VPWR Tile_X0Y1_FrameStrobe[5] latch
XANTENNA__0956__X Tile_X0Y1_W6BEG[11] VPWR VGND sg13cmos5l_antennanp
XFILLER_112_259 VPWR VGND sg13cmos5l_decap_8
XFILLER_78_162 VPWR VGND sg13cmos5l_decap_8
X_0461_ _0461_/Q Tile_X0Y1_FrameData[13] VGND VPWR Tile_X0Y1_FrameStrobe[3] latch
X_0392_ _0392_/Q Tile_X0Y1_FrameData[18] VGND VPWR Tile_X0Y1_FrameStrobe[1] latch
XFILLER_93_154 VPWR VGND sg13cmos5l_fill_1
XFILLER_19_251 VPWR VGND sg13cmos5l_decap_8
XFILLER_34_243 VPWR VGND sg13cmos5l_decap_8
X_1013_ _1013_/X Tile_X0Y0_E1END[1] Tile_X0Y0_EE4END[1] Tile_X0Y0_E6END[9] _1089_/X
+ _0319_/Q _0318_/Q VPWR VGND sg13cmos5l_mux4_1
XFILLER_93_187 VPWR VGND sg13cmos5l_decap_8
XFILLER_118_17 VPWR VGND sg13cmos5l_fill_2
XFILLER_103_226 VPWR VGND sg13cmos5l_decap_8
X_0728_ Tile_X0Y0_W2BEG[5] _1036_/X VPWR VGND sg13cmos5l_buf_1
X_0659_ _0659_/L_HI VPWR VGND sg13cmos5l_tiehi
XANTENNA__0866__X Tile_X0Y0_FrameData_O[10] VPWR VGND sg13cmos5l_antennanp
XFILLER_69_173 VPWR VGND sg13cmos5l_decap_8
XFILLER_84_132 VPWR VGND sg13cmos5l_decap_8
XFILLER_25_243 VPWR VGND sg13cmos5l_decap_8
XFILLER_40_224 VPWR VGND sg13cmos5l_decap_8
XFILLER_4_158 VPWR VGND sg13cmos5l_fill_1
XANTENNA__0776__X Tile_X0Y0_WW4BEG[9] VPWR VGND sg13cmos5l_antennanp
XFILLER_68_21 VPWR VGND sg13cmos5l_decap_4
XFILLER_75_143 VPWR VGND sg13cmos5l_fill_1
XFILLER_31_235 VPWR VGND sg13cmos5l_decap_8
XFILLER_75_198 VPWR VGND sg13cmos5l_decap_8
XFILLER_84_97 VPWR VGND sg13cmos5l_fill_2
XFILLER_31_268 VPWR VGND sg13cmos5l_decap_4
XFILLER_33_90 VPWR VGND sg13cmos5l_fill_2
X_0513_ _0513_/Q Tile_X0Y1_FrameData[25] VGND VPWR Tile_X0Y1_FrameStrobe[5] latch
X_0444_ _0444_/Q Tile_X0Y1_FrameData[30] VGND VPWR Tile_X0Y1_FrameStrobe[3] latch
XFILLER_98_257 VPWR VGND sg13cmos5l_decap_8
XFILLER_66_143 VPWR VGND sg13cmos5l_decap_8
X_0375_ _0375_/Q Tile_X0Y1_FrameData[3] VGND VPWR Tile_X0Y1_FrameStrobe[0] latch
XANTENNA__0635__Q NPU_WEIGHT_SHIFT_EN VPWR VGND sg13cmos5l_antennanp
XFILLER_22_235 VPWR VGND sg13cmos5l_decap_8
XFILLER_22_268 VPWR VGND sg13cmos5l_decap_4
XFILLER_81_168 VPWR VGND sg13cmos5l_decap_8
XFILLER_89_268 VPWR VGND sg13cmos5l_decap_4
XFILLER_72_157 VPWR VGND sg13cmos5l_decap_4
XFILLER_13_268 VPWR VGND sg13cmos5l_decap_4
XFILLER_70_44 VPWR VGND sg13cmos5l_decap_8
XFILLER_80_190 VPWR VGND sg13cmos5l_decap_8
XFILLER_9_228 VPWR VGND sg13cmos5l_decap_8
XFILLER_0_150 VPWR VGND sg13cmos5l_fill_2
XFILLER_0_183 VPWR VGND sg13cmos5l_fill_2
X_0160_ _0160_/Q Tile_X0Y0_FrameData[28] VGND VPWR Tile_X0Y1_FrameStrobe[2] latch
X_0091_ NPU_XBAR_SEL1 Tile_X0Y1_UserCLK _0091_/D _0654_/L_HI VPWR VGND sg13cmos5l_dfrbpq_1
XFILLER_95_249 VPWR VGND sg13cmos5l_decap_8
XFILLER_81_4 VPWR VGND sg13cmos5l_fill_1
X_0993_ _0993_/X Tile_X0Y1_EE4END[3] Tile_X0Y1_EE4END[11] Tile_X0Y1_E6END[11] _1214_/X
+ _0412_/Q _0411_/Q VPWR VGND sg13cmos5l_mux4_1
XFILLER_8_272 VPWR VGND sg13cmos5l_fill_1
XFILLER_86_227 VPWR VGND sg13cmos5l_decap_8
X_0427_ _0427_/Q Tile_X0Y1_FrameData[15] VGND VPWR Tile_X0Y1_FrameStrobe[2] latch
XFILLER_39_176 VPWR VGND sg13cmos5l_decap_8
XFILLER_54_135 VPWR VGND sg13cmos5l_decap_4
X_0358_ _0358_/Q Tile_X0Y1_FrameData[20] VGND VPWR Tile_X0Y1_FrameStrobe[0] latch
X_0289_ _0289_/Q Tile_X0Y0_FrameData[27] VGND VPWR Tile_X0Y1_FrameStrobe[6] latch
XFILLER_10_205 VPWR VGND sg13cmos5l_decap_8
XFILLER_108_137 VPWR VGND sg13cmos5l_decap_8
XFILLER_77_238 VPWR VGND sg13cmos5l_decap_8
XFILLER_85_271 VPWR VGND sg13cmos5l_fill_2
XFILLER_5_253 VPWR VGND sg13cmos5l_decap_8
XFILLER_5_264 VPWR VGND sg13cmos5l_fill_1
XFILLER_60_9 VPWR VGND sg13cmos5l_fill_2
XFILLER_107_192 VPWR VGND sg13cmos5l_decap_8
XFILLER_68_227 VPWR VGND sg13cmos5l_decap_8
XANTENNA__0964__X Tile_X0Y1_WW4BEG[7] VPWR VGND sg13cmos5l_antennanp
XFILLER_76_260 VPWR VGND sg13cmos5l_decap_8
XFILLER_76_271 VPWR VGND sg13cmos5l_fill_2
X_1192_ _1192_/X Tile_X0Y1_N1END[1] Tile_X0Y1_E6END[1] _1228_/X _1192_/A3 _0352_/Q
+ _0351_/Q VPWR VGND sg13cmos5l_mux4_1
X_0212_ _0212_/Q Tile_X0Y0_FrameData[8] VGND VPWR Tile_X0Y1_FrameStrobe[3] latch
X_0143_ _0143_/Q Tile_X0Y0_FrameData[13] VGND VPWR Tile_X0Y1_FrameStrobe[1] latch
X_0074_ _0760_/A _1119_/X _1120_/X _0573_/Q VPWR VGND sg13cmos5l_mux2_1
XFILLER_72_0 VPWR VGND sg13cmos5l_fill_2
X_0976_ _0976_/X Tile_X0Y0_E2MID[3] Tile_X0Y0_E2END[3] _1095_/X _0976_/A3 _0164_/Q
+ _0163_/Q VPWR VGND sg13cmos5l_mux4_1
XFILLER_105_107 VPWR VGND sg13cmos5l_fill_1
XANTENNA__0874__X Tile_X0Y0_FrameData_O[18] VPWR VGND sg13cmos5l_antennanp
XFILLER_113_173 VPWR VGND sg13cmos5l_decap_8
XFILLER_27_135 VPWR VGND sg13cmos5l_decap_4
XFILLER_59_238 VPWR VGND sg13cmos5l_decap_8
XFILLER_35_14 VPWR VGND sg13cmos5l_decap_8
XFILLER_35_69 VPWR VGND sg13cmos5l_decap_8
XFILLER_51_57 VPWR VGND sg13cmos5l_fill_1
XFILLER_104_184 VPWR VGND sg13cmos5l_decap_8
XFILLER_116_94 VPWR VGND sg13cmos5l_decap_8
XANTENNA__0784__X Tile_X0Y0_N2BEGb[1] VPWR VGND sg13cmos5l_antennanp
XFILLER_18_124 VPWR VGND sg13cmos5l_decap_8
XFILLER_18_168 VPWR VGND sg13cmos5l_fill_1
XFILLER_18_179 VPWR VGND sg13cmos5l_decap_8
XFILLER_33_127 VPWR VGND sg13cmos5l_decap_8
XFILLER_92_53 VPWR VGND sg13cmos5l_decap_8
XFILLER_25_80 VPWR VGND sg13cmos5l_fill_2
XFILLER_41_171 VPWR VGND sg13cmos5l_decap_8
X_0830_ Tile_X0Y1_FrameData_O[6] Tile_X0Y1_FrameData[6] VPWR VGND sg13cmos5l_buf_1
XANTENNA__0959__X Tile_X0Y1_WW4BEG[2] VPWR VGND sg13cmos5l_antennanp
X_0761_ Tile_X0Y0_N4BEG[10] _0761_/A VPWR VGND sg13cmos5l_buf_1
X_0692_ _0692_/L_HI VPWR VGND sg13cmos5l_tiehi
XFILLER_110_187 VPWR VGND sg13cmos5l_decap_8
XFILLER_2_51 VPWR VGND sg13cmos5l_fill_2
XFILLER_49_271 VPWR VGND sg13cmos5l_fill_2
XFILLER_112_19 VPWR VGND sg13cmos5l_fill_1
XFILLER_64_252 VPWR VGND sg13cmos5l_decap_8
X_1175_ _1175_/X _0644_/Q _0648_/Q _1206_/X _1198_/X _0466_/Q _0465_/Q VPWR VGND sg13cmos5l_mux4_1
X_0126_ _0126_/Q Tile_X0Y0_FrameData[30] VGND VPWR Tile_X0Y1_FrameStrobe[1] latch
XANTENNA_12 _1009_/X VPWR VGND sg13cmos5l_antennanp
XANTENNA_23 Tile_X0Y0_S2MID[4] VPWR VGND sg13cmos5l_antennanp
XANTENNA_34 Tile_X0Y0_S2MID[7] VPWR VGND sg13cmos5l_antennanp
XANTENNA_45 Tile_X0Y1_N2MID[5] VPWR VGND sg13cmos5l_antennanp
XANTENNA_56 NPU_OUT_ACT0 VPWR VGND sg13cmos5l_antennanp
X_0959_ Tile_X0Y1_WW4BEG[2] _1165_/X VPWR VGND sg13cmos5l_buf_1
XANTENNA__0869__X Tile_X0Y0_FrameData_O[13] VPWR VGND sg13cmos5l_antennanp
XFILLER_101_121 VPWR VGND sg13cmos5l_decap_4
XFILLER_15_116 VPWR VGND sg13cmos5l_fill_1
XFILLER_70_211 VPWR VGND sg13cmos5l_decap_8
XFILLER_23_171 VPWR VGND sg13cmos5l_decap_8
XANTENNA__0779__X Tile_X0Y0_WW4BEG[12] VPWR VGND sg13cmos5l_antennanp
XFILLER_109_254 VPWR VGND sg13cmos5l_decap_8
XFILLER_2_0 VPWR VGND sg13cmos5l_fill_2
XFILLER_38_208 VPWR VGND sg13cmos5l_decap_8
XFILLER_61_200 VPWR VGND sg13cmos5l_decap_8
XFILLER_14_182 VPWR VGND sg13cmos5l_decap_8
XFILLER_21_119 VPWR VGND sg13cmos5l_decap_8
X_0813_ Tile_X0Y0_FrameStrobe_O[10] Tile_X0Y1_FrameStrobe[10] VPWR VGND sg13cmos5l_buf_1
XFILLER_107_19 VPWR VGND sg13cmos5l_fill_2
XFILLER_115_268 VPWR VGND sg13cmos5l_decap_4
XFILLER_35_0 VPWR VGND sg13cmos5l_fill_2
XFILLER_88_119 VPWR VGND sg13cmos5l_decap_8
X_0744_ Tile_X0Y0_W6BEG[5] _1068_/X VPWR VGND sg13cmos5l_buf_1
X_0675_ _0675_/L_HI VPWR VGND sg13cmos5l_tiehi
XFILLER_37_252 VPWR VGND sg13cmos5l_decap_8
X_1227_ _1227_/X Tile_X0Y0_E1END[0] Tile_X0Y0_E6END[8] _1075_/X _1100_/X _0310_/Q
+ _0309_/Q VPWR VGND sg13cmos5l_mux4_1
X_1158_ _1158_/X Tile_X0Y1_EE4END[5] _0647_/Q _1198_/X _1199_/X _0500_/Q _0499_/Q
+ VPWR VGND sg13cmos5l_mux4_1
XFILLER_96_185 VPWR VGND sg13cmos5l_decap_8
X_1089_ _1089_/X _1112_/X Tile_X0Y1_N4END[5] Tile_X0Y0_S1END[1] Tile_X0Y0_S4END[1]
+ _0146_/Q _0145_/Q VPWR VGND sg13cmos5l_mux4_1
X_0109_ _0109_/Q Tile_X0Y0_FrameData[15] VGND VPWR Tile_X0Y1_FrameStrobe[0] latch
XFILLER_106_246 VPWR VGND sg13cmos5l_decap_8
XFILLER_106_268 VPWR VGND sg13cmos5l_decap_4
XFILLER_87_163 VPWR VGND sg13cmos5l_decap_8
XFILLER_113_51 VPWR VGND sg13cmos5l_fill_1
XFILLER_28_230 VPWR VGND sg13cmos5l_decap_8
XFILLER_43_244 VPWR VGND sg13cmos5l_decap_8
XFILLER_7_112 VPWR VGND sg13cmos5l_decap_4
XFILLER_7_156 VPWR VGND sg13cmos5l_fill_1
XFILLER_112_216 VPWR VGND sg13cmos5l_decap_8
XFILLER_112_238 VPWR VGND sg13cmos5l_decap_8
XFILLER_7_167 VPWR VGND sg13cmos5l_decap_8
X_0460_ _0460_/Q Tile_X0Y1_FrameData[14] VGND VPWR Tile_X0Y1_FrameStrobe[3] latch
XFILLER_19_230 VPWR VGND sg13cmos5l_decap_8
XFILLER_19_263 VPWR VGND sg13cmos5l_fill_2
X_1012_ _1012_/X _1087_/X _1083_/X _1075_/X _1092_/X _0322_/Q _0321_/Q VPWR VGND sg13cmos5l_mux4_1
X_0391_ _0391_/Q Tile_X0Y1_FrameData[19] VGND VPWR Tile_X0Y1_FrameStrobe[1] latch
XFILLER_93_166 VPWR VGND sg13cmos5l_decap_8
XFILLER_93_133 VPWR VGND sg13cmos5l_decap_8
XFILLER_93_100 VPWR VGND sg13cmos5l_fill_2
XANTENNA__0972__X Tile_X0Y1_WW4BEG[15] VPWR VGND sg13cmos5l_antennanp
XFILLER_34_222 VPWR VGND sg13cmos5l_decap_8
XFILLER_118_29 VPWR VGND sg13cmos5l_decap_4
X_0727_ Tile_X0Y0_W2BEG[4] _1035_/X VPWR VGND sg13cmos5l_buf_1
XFILLER_103_205 VPWR VGND sg13cmos5l_decap_8
X_0658_ _0658_/L_HI VPWR VGND sg13cmos5l_tiehi
X_0589_ _0589_/Q Tile_X0Y1_FrameData[13] VGND VPWR Tile_X0Y1_FrameStrobe[7] latch
XANTENNA__0882__X Tile_X0Y0_FrameData_O[26] VPWR VGND sg13cmos5l_antennanp
XFILLER_25_222 VPWR VGND sg13cmos5l_decap_8
XFILLER_27_26 VPWR VGND sg13cmos5l_decap_4
XFILLER_27_59 VPWR VGND sg13cmos5l_decap_8
XFILLER_84_188 VPWR VGND sg13cmos5l_decap_8
XFILLER_40_203 VPWR VGND sg13cmos5l_decap_8
XFILLER_43_58 VPWR VGND sg13cmos5l_decap_4
XFILLER_108_51 VPWR VGND sg13cmos5l_decap_8
XFILLER_102_260 VPWR VGND sg13cmos5l_decap_8
XFILLER_102_271 VPWR VGND sg13cmos5l_fill_2
XFILLER_75_122 VPWR VGND sg13cmos5l_decap_8
XFILLER_90_114 VPWR VGND sg13cmos5l_fill_1
XFILLER_90_103 VPWR VGND sg13cmos5l_decap_8
XANTENNA__0792__X Tile_X0Y0_N2BEG[1] VPWR VGND sg13cmos5l_antennanp
XFILLER_16_244 VPWR VGND sg13cmos5l_decap_8
XFILLER_31_214 VPWR VGND sg13cmos5l_decap_8
XFILLER_84_76 VPWR VGND sg13cmos5l_decap_8
XANTENNA__0967__X Tile_X0Y1_WW4BEG[10] VPWR VGND sg13cmos5l_antennanp
XFILLER_3_192 VPWR VGND sg13cmos5l_fill_2
X_0512_ _0512_/Q Tile_X0Y1_FrameData[26] VGND VPWR Tile_X0Y1_FrameStrobe[5] latch
X_0443_ _0443_/Q Tile_X0Y1_FrameData[31] VGND VPWR Tile_X0Y1_FrameStrobe[3] latch
X_0374_ _0374_/Q Tile_X0Y1_FrameData[4] VGND VPWR Tile_X0Y1_FrameStrobe[0] latch
XFILLER_98_236 VPWR VGND sg13cmos5l_decap_8
XFILLER_66_199 VPWR VGND sg13cmos5l_decap_8
XFILLER_81_147 VPWR VGND sg13cmos5l_decap_8
XFILLER_22_214 VPWR VGND sg13cmos5l_decap_8
XFILLER_22_258 VPWR VGND sg13cmos5l_fill_1
XFILLER_1_129 VPWR VGND sg13cmos5l_fill_2
XFILLER_89_247 VPWR VGND sg13cmos5l_decap_8
XANTENNA__0877__X Tile_X0Y0_FrameData_O[21] VPWR VGND sg13cmos5l_antennanp
XFILLER_38_36 VPWR VGND sg13cmos5l_decap_8
XFILLER_38_47 VPWR VGND sg13cmos5l_fill_1
XFILLER_57_111 VPWR VGND sg13cmos5l_decap_4
XFILLER_57_144 VPWR VGND sg13cmos5l_fill_1
XFILLER_110_30 VPWR VGND sg13cmos5l_fill_2
XFILLER_13_225 VPWR VGND sg13cmos5l_decap_8
XFILLER_54_24 VPWR VGND sg13cmos5l_fill_1
XFILLER_54_57 VPWR VGND sg13cmos5l_fill_1
XFILLER_9_207 VPWR VGND sg13cmos5l_decap_8
XFILLER_70_23 VPWR VGND sg13cmos5l_decap_8
XANTENNA__0787__X Tile_X0Y0_N2BEGb[4] VPWR VGND sg13cmos5l_antennanp
XFILLER_0_162 VPWR VGND sg13cmos5l_decap_8
XFILLER_102_0 VPWR VGND sg13cmos5l_fill_2
XFILLER_79_65 VPWR VGND sg13cmos5l_decap_8
XFILLER_79_87 VPWR VGND sg13cmos5l_decap_8
XFILLER_95_31 VPWR VGND sg13cmos5l_decap_8
XFILLER_95_228 VPWR VGND sg13cmos5l_decap_8
XFILLER_48_188 VPWR VGND sg13cmos5l_fill_2
XFILLER_63_169 VPWR VGND sg13cmos5l_decap_8
X_0090_ NPU_XBAR_SEL0 Tile_X0Y1_UserCLK _0090_/D _0655_/L_HI VPWR VGND sg13cmos5l_dfrbpq_1
XFILLER_95_86 VPWR VGND sg13cmos5l_decap_4
XFILLER_71_180 VPWR VGND sg13cmos5l_decap_8
X_0992_ _0992_/X Tile_X0Y1_EE4END[2] Tile_X0Y1_EE4END[10] Tile_X0Y1_E6END[10] _1213_/X
+ _0414_/Q _0413_/Q VPWR VGND sg13cmos5l_mux4_1
XFILLER_117_105 VPWR VGND sg13cmos5l_fill_1
XFILLER_5_62 VPWR VGND sg13cmos5l_fill_2
XFILLER_8_262 VPWR VGND sg13cmos5l_fill_2
XFILLER_86_206 VPWR VGND sg13cmos5l_decap_8
X_0426_ _0426_/Q Tile_X0Y1_FrameData[16] VGND VPWR Tile_X0Y1_FrameStrobe[2] latch
X_0357_ _0357_/Q Tile_X0Y1_FrameData[21] VGND VPWR Tile_X0Y1_FrameStrobe[0] latch
XFILLER_54_147 VPWR VGND sg13cmos5l_decap_8
XFILLER_54_169 VPWR VGND sg13cmos5l_decap_8
XFILLER_62_180 VPWR VGND sg13cmos5l_decap_8
X_0288_ _0288_/Q Tile_X0Y0_FrameData[28] VGND VPWR Tile_X0Y1_FrameStrobe[6] latch
XFILLER_94_272 VPWR VGND sg13cmos5l_fill_1
XFILLER_77_217 VPWR VGND sg13cmos5l_decap_8
XFILLER_105_30 VPWR VGND sg13cmos5l_fill_2
XFILLER_105_41 VPWR VGND sg13cmos5l_fill_1
XFILLER_105_74 VPWR VGND sg13cmos5l_decap_8
XFILLER_45_136 VPWR VGND sg13cmos5l_fill_2
XFILLER_85_250 VPWR VGND sg13cmos5l_decap_8
XFILLER_60_139 VPWR VGND sg13cmos5l_decap_8
XFILLER_81_66 VPWR VGND sg13cmos5l_decap_4
XFILLER_81_99 VPWR VGND sg13cmos5l_decap_8
XFILLER_107_171 VPWR VGND sg13cmos5l_decap_8
XFILLER_5_232 VPWR VGND sg13cmos5l_decap_8
XFILLER_39_90 VPWR VGND sg13cmos5l_fill_1
XFILLER_68_206 VPWR VGND sg13cmos5l_decap_8
X_1191_ _1191_/X Tile_X0Y1_N1END[0] Tile_X0Y1_E6END[0] _1227_/X _1191_/A3 _0354_/Q
+ _0353_/Q VPWR VGND sg13cmos5l_mux4_1
X_0211_ _0211_/Q Tile_X0Y0_FrameData[9] VGND VPWR Tile_X0Y1_FrameStrobe[3] latch
X_0142_ _0142_/Q Tile_X0Y0_FrameData[14] VGND VPWR Tile_X0Y1_FrameStrobe[1] latch
X_0073_ _0759_/A _1121_/X _1122_/X _0576_/Q VPWR VGND sg13cmos5l_mux2_1
XFILLER_91_253 VPWR VGND sg13cmos5l_decap_8
XFILLER_65_0 VPWR VGND sg13cmos5l_decap_4
X_0975_ _0975_/X Tile_X0Y0_E2MID[2] Tile_X0Y0_E2END[2] _1094_/X _0975_/A3 _0166_/Q
+ _0165_/Q VPWR VGND sg13cmos5l_mux4_1
XFILLER_113_152 VPWR VGND sg13cmos5l_decap_8
XFILLER_59_217 VPWR VGND sg13cmos5l_decap_8
XFILLER_19_16 VPWR VGND sg13cmos5l_decap_4
XFILLER_19_27 VPWR VGND sg13cmos5l_decap_8
XFILLER_27_147 VPWR VGND sg13cmos5l_decap_4
X_0409_ _0409_/Q Tile_X0Y1_FrameData[1] VGND VPWR Tile_X0Y1_FrameStrobe[1] latch
XANTENNA__0890__X Tile_X0Y1_S1BEG[2] VPWR VGND sg13cmos5l_antennanp
XFILLER_42_139 VPWR VGND sg13cmos5l_decap_8
XFILLER_50_183 VPWR VGND sg13cmos5l_decap_8
XFILLER_104_163 VPWR VGND sg13cmos5l_decap_8
XFILLER_116_84 VPWR VGND sg13cmos5l_decap_4
XFILLER_26_191 VPWR VGND sg13cmos5l_decap_8
XFILLER_58_272 VPWR VGND sg13cmos5l_fill_1
XFILLER_41_150 VPWR VGND sg13cmos5l_decap_8
X_0760_ Tile_X0Y0_N4BEG[9] _0760_/A VPWR VGND sg13cmos5l_buf_1
XFILLER_41_91 VPWR VGND sg13cmos5l_decap_8
X_0691_ _0691_/L_HI VPWR VGND sg13cmos5l_tiehi
XFILLER_110_166 VPWR VGND sg13cmos5l_decap_8
XFILLER_2_30 VPWR VGND sg13cmos5l_fill_2
X_1174_ _1174_/X _0647_/Q _0651_/Q _1207_/X _1199_/X _0468_/Q _0467_/Q VPWR VGND sg13cmos5l_mux4_1
XANTENNA_13 _1010_/X VPWR VGND sg13cmos5l_antennanp
XFILLER_32_183 VPWR VGND sg13cmos5l_decap_8
X_0125_ _0125_/Q Tile_X0Y0_FrameData[31] VGND VPWR Tile_X0Y1_FrameStrobe[1] latch
XANTENNA_24 Tile_X0Y0_S2MID[5] VPWR VGND sg13cmos5l_antennanp
XANTENNA_35 Tile_X0Y0_S2MID[7] VPWR VGND sg13cmos5l_antennanp
XANTENNA_46 Tile_X0Y1_N2MID[5] VPWR VGND sg13cmos5l_antennanp
XANTENNA_57 NPU_OUT_ACT0 VPWR VGND sg13cmos5l_antennanp
XFILLER_118_255 VPWR VGND sg13cmos5l_decap_8
XFILLER_21_28 VPWR VGND sg13cmos5l_decap_8
X_0889_ Tile_X0Y1_S1BEG[1] _1124_/X VPWR VGND sg13cmos5l_buf_1
X_0958_ Tile_X0Y1_WW4BEG[1] _1164_/X VPWR VGND sg13cmos5l_buf_1
XANTENNA__0885__X Tile_X0Y0_FrameData_O[29] VPWR VGND sg13cmos5l_antennanp
XFILLER_47_209 VPWR VGND sg13cmos5l_decap_8
XFILLER_101_188 VPWR VGND sg13cmos5l_decap_8
XFILLER_102_31 VPWR VGND sg13cmos5l_decap_4
XFILLER_15_106 VPWR VGND sg13cmos5l_fill_1
XFILLER_23_150 VPWR VGND sg13cmos5l_decap_8
XFILLER_62_24 VPWR VGND sg13cmos5l_decap_4
XFILLER_70_267 VPWR VGND sg13cmos5l_decap_4
XFILLER_109_233 VPWR VGND sg13cmos5l_decap_8
XFILLER_11_61 VPWR VGND sg13cmos5l_decap_8
XFILLER_11_72 VPWR VGND sg13cmos5l_fill_1
XANTENNA__0795__X Tile_X0Y0_N2BEG[4] VPWR VGND sg13cmos5l_antennanp
XFILLER_87_54 VPWR VGND sg13cmos5l_decap_8
XFILLER_14_161 VPWR VGND sg13cmos5l_fill_2
XFILLER_61_256 VPWR VGND sg13cmos5l_decap_8
XFILLER_115_214 VPWR VGND sg13cmos5l_decap_8
X_0812_ Tile_X0Y0_FrameStrobe_O[9] Tile_X0Y1_FrameStrobe[9] VPWR VGND sg13cmos5l_buf_1
X_0743_ Tile_X0Y0_W6BEG[4] _1067_/X VPWR VGND sg13cmos5l_buf_1
XFILLER_115_247 VPWR VGND sg13cmos5l_decap_8
XFILLER_28_0 VPWR VGND sg13cmos5l_fill_2
XFILLER_42_2 VPWR VGND sg13cmos5l_fill_1
X_0674_ _0674_/L_HI VPWR VGND sg13cmos5l_tiehi
XFILLER_37_220 VPWR VGND sg13cmos5l_decap_4
X_1226_ _1226_/X Tile_X0Y0_E1END[3] Tile_X0Y0_E2MID[0] Tile_X0Y0_E2END[0] _1099_/X
+ _0288_/Q _0287_/Q VPWR VGND sg13cmos5l_mux4_1
X_1157_ _1157_/X Tile_X0Y1_E2END[3] _0646_/Q _1197_/X _1200_/X _0502_/Q _0501_/Q VPWR
+ VGND sg13cmos5l_mux4_1
X_0108_ _0108_/Q Tile_X0Y0_FrameData[16] VGND VPWR Tile_X0Y1_FrameStrobe[0] latch
XFILLER_96_164 VPWR VGND sg13cmos5l_decap_8
XFILLER_20_153 VPWR VGND sg13cmos5l_fill_2
XFILLER_52_245 VPWR VGND sg13cmos5l_decap_8
X_1088_ _1088_/X _1111_/X Tile_X0Y1_N4END[4] Tile_X0Y0_S1END[0] Tile_X0Y0_S4END[0]
+ _0148_/Q _0147_/Q VPWR VGND sg13cmos5l_mux4_1
XFILLER_106_225 VPWR VGND sg13cmos5l_decap_8
XFILLER_57_79 VPWR VGND sg13cmos5l_fill_1
XFILLER_113_41 VPWR VGND sg13cmos5l_fill_2
XFILLER_43_223 VPWR VGND sg13cmos5l_decap_8
XFILLER_73_89 VPWR VGND sg13cmos5l_fill_1
XFILLER_11_186 VPWR VGND sg13cmos5l_decap_8
XFILLER_22_60 VPWR VGND sg13cmos5l_fill_2
XFILLER_78_120 VPWR VGND sg13cmos5l_decap_8
X_0390_ _0390_/Q Tile_X0Y1_FrameData[20] VGND VPWR Tile_X0Y1_FrameStrobe[1] latch
XFILLER_34_201 VPWR VGND sg13cmos5l_decap_8
XFILLER_78_197 VPWR VGND sg13cmos5l_decap_8
X_1011_ _1011_/X Tile_X0Y0_E1END[0] Tile_X0Y0_EE4END[0] Tile_X0Y0_E6END[8] _1088_/X
+ _0322_/Q _0321_/Q VPWR VGND sg13cmos5l_mux4_1
X_0726_ Tile_X0Y0_W2BEG[3] _1034_/X VPWR VGND sg13cmos5l_buf_1
XFILLER_111_272 VPWR VGND sg13cmos5l_fill_1
XFILLER_69_142 VPWR VGND sg13cmos5l_decap_4
X_0657_ _0657_/L_HI VPWR VGND sg13cmos5l_tiehi
X_0588_ _0588_/Q Tile_X0Y1_FrameData[14] VGND VPWR Tile_X0Y1_FrameStrobe[7] latch
XFILLER_25_201 VPWR VGND sg13cmos5l_decap_8
XFILLER_43_15 VPWR VGND sg13cmos5l_decap_8
XFILLER_84_167 VPWR VGND sg13cmos5l_decap_8
X_1209_ _1209_/X Tile_X0Y1_N1END[2] Tile_X0Y1_N4END[2] _1229_/X Tile_X0Y0_S4END[6]
+ _0390_/Q _0389_/Q VPWR VGND sg13cmos5l_mux4_1
XFILLER_40_259 VPWR VGND sg13cmos5l_decap_8
XFILLER_108_41 VPWR VGND sg13cmos5l_decap_8
XFILLER_108_74 VPWR VGND sg13cmos5l_decap_8
XFILLER_4_127 VPWR VGND sg13cmos5l_decap_8
XFILLER_4_149 VPWR VGND sg13cmos5l_decap_8
XFILLER_68_78 VPWR VGND sg13cmos5l_fill_1
XFILLER_16_223 VPWR VGND sg13cmos5l_decap_8
XFILLER_75_178 VPWR VGND sg13cmos5l_fill_2
XFILLER_84_55 VPWR VGND sg13cmos5l_decap_8
XFILLER_84_99 VPWR VGND sg13cmos5l_fill_1
X_0511_ _0511_/Q Tile_X0Y1_FrameData[27] VGND VPWR Tile_X0Y1_FrameStrobe[5] latch
XFILLER_3_171 VPWR VGND sg13cmos5l_decap_8
X_0442_ _0442_/Q Tile_X0Y1_FrameData[0] VGND VPWR Tile_X0Y1_FrameStrobe[2] latch
X_0373_ _0373_/Q Tile_X0Y1_FrameData[5] VGND VPWR Tile_X0Y1_FrameStrobe[0] latch
XFILLER_98_215 VPWR VGND sg13cmos5l_decap_8
XFILLER_66_178 VPWR VGND sg13cmos5l_decap_8
XFILLER_81_126 VPWR VGND sg13cmos5l_decap_8
XFILLER_89_226 VPWR VGND sg13cmos5l_decap_8
X_0709_ _1192_/A3 VPWR VGND sg13cmos5l_tielo
XANTENNA__0893__X Tile_X0Y1_S2BEG[1] VPWR VGND sg13cmos5l_antennanp
XFILLER_38_59 VPWR VGND sg13cmos5l_decap_8
XFILLER_72_104 VPWR VGND sg13cmos5l_decap_4
XFILLER_72_115 VPWR VGND sg13cmos5l_decap_8
XFILLER_13_204 VPWR VGND sg13cmos5l_decap_8
XFILLER_54_36 VPWR VGND sg13cmos5l_fill_2
XFILLER_0_130 VPWR VGND sg13cmos5l_decap_8
XFILLER_0_185 VPWR VGND sg13cmos5l_fill_1
XFILLER_95_207 VPWR VGND sg13cmos5l_decap_8
XFILLER_48_167 VPWR VGND sg13cmos5l_decap_8
XFILLER_63_148 VPWR VGND sg13cmos5l_decap_8
XFILLER_117_117 VPWR VGND sg13cmos5l_decap_8
X_0991_ _0991_/X Tile_X0Y1_EE4END[1] Tile_X0Y1_EE4END[9] Tile_X0Y1_E6END[9] _1212_/X
+ _0416_/Q _0415_/Q VPWR VGND sg13cmos5l_mux4_1
XFILLER_8_241 VPWR VGND sg13cmos5l_decap_8
XFILLER_39_156 VPWR VGND sg13cmos5l_decap_8
X_0425_ _0425_/Q Tile_X0Y1_FrameData[17] VGND VPWR Tile_X0Y1_FrameStrobe[2] latch
X_0356_ _0356_/Q Tile_X0Y1_FrameData[22] VGND VPWR Tile_X0Y1_FrameStrobe[0] latch
X_0287_ _0287_/Q Tile_X0Y0_FrameData[29] VGND VPWR Tile_X0Y1_FrameStrobe[6] latch
XFILLER_40_49 VPWR VGND sg13cmos5l_fill_2
XANTENNA__0888__X Tile_X0Y1_S1BEG[0] VPWR VGND sg13cmos5l_antennanp
XFILLER_116_183 VPWR VGND sg13cmos5l_decap_8
XFILLER_60_118 VPWR VGND sg13cmos5l_decap_8
XFILLER_14_50 VPWR VGND sg13cmos5l_fill_1
XFILLER_14_72 VPWR VGND sg13cmos5l_decap_8
XFILLER_81_34 VPWR VGND sg13cmos5l_decap_8
XANTENNA__0798__X Tile_X0Y0_N2BEG[7] VPWR VGND sg13cmos5l_antennanp
XFILLER_107_150 VPWR VGND sg13cmos5l_decap_8
XFILLER_5_211 VPWR VGND sg13cmos5l_decap_8
XFILLER_36_126 VPWR VGND sg13cmos5l_fill_2
XFILLER_39_8 VPWR VGND sg13cmos5l_decap_8
X_1190_ _1190_/X _0647_/Q _1203_/X _1207_/X _1202_/X _0436_/Q _0435_/Q VPWR VGND sg13cmos5l_mux4_1
X_0210_ _0210_/Q Tile_X0Y0_FrameData[10] VGND VPWR Tile_X0Y1_FrameStrobe[3] latch
X_0141_ _0141_/Q Tile_X0Y0_FrameData[15] VGND VPWR Tile_X0Y1_FrameStrobe[1] latch
XFILLER_44_181 VPWR VGND sg13cmos5l_decap_8
XFILLER_51_129 VPWR VGND sg13cmos5l_fill_2
X_0072_ _0092_/D _1233_/X _0605_/Q _0608_/Q VPWR VGND sg13cmos5l_mux2_1
XFILLER_72_2 VPWR VGND sg13cmos5l_fill_1
X_0974_ _0974_/X Tile_X0Y0_E2MID[1] Tile_X0Y0_E2END[1] _1093_/X _0974_/A3 _0168_/Q
+ _0167_/Q VPWR VGND sg13cmos5l_mux4_1
XFILLER_113_131 VPWR VGND sg13cmos5l_decap_8
XFILLER_58_0 VPWR VGND sg13cmos5l_decap_4
XFILLER_67_262 VPWR VGND sg13cmos5l_decap_8
XFILLER_82_254 VPWR VGND sg13cmos5l_decap_8
X_0408_ _0408_/Q Tile_X0Y1_FrameData[2] VGND VPWR Tile_X0Y1_FrameStrobe[1] latch
X_0339_ _0339_/Q Tile_X0Y0_FrameData[9] VGND VPWR Tile_X0Y1_FrameStrobe[7] latch
XFILLER_51_48 VPWR VGND sg13cmos5l_decap_8
XFILLER_2_225 VPWR VGND sg13cmos5l_decap_8
XFILLER_76_12 VPWR VGND sg13cmos5l_fill_1
XFILLER_76_34 VPWR VGND sg13cmos5l_fill_2
XFILLER_18_159 VPWR VGND sg13cmos5l_fill_2
XFILLER_73_254 VPWR VGND sg13cmos5l_decap_8
XFILLER_25_82 VPWR VGND sg13cmos5l_fill_1
X_0690_ _0690_/L_HI VPWR VGND sg13cmos5l_tiehi
XFILLER_110_134 VPWR VGND sg13cmos5l_fill_1
XFILLER_110_145 VPWR VGND sg13cmos5l_decap_8
XFILLER_2_86 VPWR VGND sg13cmos5l_decap_8
XFILLER_64_232 VPWR VGND sg13cmos5l_fill_2
X_1173_ _1173_/X _0646_/Q _0650_/Q _1208_/X _1200_/X _0470_/Q _0469_/Q VPWR VGND sg13cmos5l_mux4_1
X_0124_ _0124_/Q Tile_X0Y0_FrameData[0] VGND VPWR Tile_X0Y1_FrameStrobe[0] latch
XANTENNA_14 Tile_X0Y0_S2MID[0] VPWR VGND sg13cmos5l_antennanp
XANTENNA_25 Tile_X0Y0_S2MID[5] VPWR VGND sg13cmos5l_antennanp
XANTENNA_36 Tile_X0Y0_S4END[9] VPWR VGND sg13cmos5l_antennanp
XANTENNA_47 Tile_X0Y1_N2MID[6] VPWR VGND sg13cmos5l_antennanp
XFILLER_32_162 VPWR VGND sg13cmos5l_decap_8
XANTENNA_58 NPU_OUT_ACT0 VPWR VGND sg13cmos5l_antennanp
XFILLER_118_234 VPWR VGND sg13cmos5l_decap_8
X_0888_ Tile_X0Y1_S1BEG[0] _1123_/X VPWR VGND sg13cmos5l_buf_1
X_0957_ Tile_X0Y1_WW4BEG[0] _1163_/X VPWR VGND sg13cmos5l_buf_1
XFILLER_101_167 VPWR VGND sg13cmos5l_decap_8
XFILLER_99_184 VPWR VGND sg13cmos5l_decap_8
XFILLER_102_54 VPWR VGND sg13cmos5l_decap_4
XFILLER_70_246 VPWR VGND sg13cmos5l_decap_8
XFILLER_102_98 VPWR VGND sg13cmos5l_fill_1
XFILLER_109_212 VPWR VGND sg13cmos5l_decap_8
XFILLER_87_33 VPWR VGND sg13cmos5l_decap_8
XFILLER_46_243 VPWR VGND sg13cmos5l_decap_8
XFILLER_36_92 VPWR VGND sg13cmos5l_fill_2
XFILLER_61_235 VPWR VGND sg13cmos5l_decap_8
XFILLER_61_268 VPWR VGND sg13cmos5l_decap_4
X_0811_ Tile_X0Y0_FrameStrobe_O[8] Tile_X0Y1_FrameStrobe[8] VPWR VGND sg13cmos5l_buf_1
X_0742_ Tile_X0Y0_W6BEG[3] _1066_/X VPWR VGND sg13cmos5l_buf_1
X_0673_ _0673_/L_HI VPWR VGND sg13cmos5l_tiehi
XFILLER_52_224 VPWR VGND sg13cmos5l_decap_8
XFILLER_52_268 VPWR VGND sg13cmos5l_decap_4
X_1087_ _1087_/X _1111_/X Tile_X0Y1_N4END[4] Tile_X0Y0_S1END[0] Tile_X0Y0_S4END[0]
+ _0140_/Q _0139_/Q VPWR VGND sg13cmos5l_mux4_1
X_1225_ _1225_/X Tile_X0Y0_E1END[2] Tile_X0Y0_E2MID[1] Tile_X0Y0_E2END[1] _1098_/X
+ _0290_/Q _0289_/Q VPWR VGND sg13cmos5l_mux4_1
X_1156_ _1156_/X Tile_X0Y1_E2MID[4] _0645_/Q _1196_/X _1201_/X _0504_/Q _0503_/Q VPWR
+ VGND sg13cmos5l_mux4_1
X_0107_ _0107_/Q Tile_X0Y0_FrameData[17] VGND VPWR Tile_X0Y1_FrameStrobe[0] latch
XFILLER_20_121 VPWR VGND sg13cmos5l_decap_4
XFILLER_20_187 VPWR VGND sg13cmos5l_decap_8
XANTENNA__0896__X Tile_X0Y1_S2BEG[4] VPWR VGND sg13cmos5l_antennanp
XFILLER_106_204 VPWR VGND sg13cmos5l_decap_8
XFILLER_57_14 VPWR VGND sg13cmos5l_decap_8
XFILLER_57_58 VPWR VGND sg13cmos5l_decap_8
XFILLER_87_198 VPWR VGND sg13cmos5l_decap_8
XFILLER_43_202 VPWR VGND sg13cmos5l_decap_8
XFILLER_43_268 VPWR VGND sg13cmos5l_decap_4
XFILLER_73_35 VPWR VGND sg13cmos5l_decap_8
XFILLER_11_165 VPWR VGND sg13cmos5l_decap_4
XFILLER_22_94 VPWR VGND sg13cmos5l_decap_8
XFILLER_21_8 VPWR VGND sg13cmos5l_fill_2
XFILLER_78_176 VPWR VGND sg13cmos5l_decap_8
XFILLER_98_87 VPWR VGND sg13cmos5l_fill_2
XFILLER_98_65 VPWR VGND sg13cmos5l_fill_1
XFILLER_98_54 VPWR VGND sg13cmos5l_decap_8
XFILLER_34_257 VPWR VGND sg13cmos5l_decap_8
X_1010_ _1010_/X Tile_X0Y0_E2MID[0] Tile_X0Y0_E2END[0] Tile_X0Y0_E6END[0] _1099_/X
+ _0324_/Q _0323_/Q VPWR VGND sg13cmos5l_mux4_1
XFILLER_8_52 VPWR VGND sg13cmos5l_decap_8
XFILLER_40_0 VPWR VGND sg13cmos5l_decap_4
X_0725_ Tile_X0Y0_W2BEG[2] _1033_/X VPWR VGND sg13cmos5l_buf_1
X_0656_ _0656_/L_HI VPWR VGND sg13cmos5l_tiehi
XFILLER_69_132 VPWR VGND sg13cmos5l_fill_2
XFILLER_69_187 VPWR VGND sg13cmos5l_decap_8
X_1208_ _1208_/X Tile_X0Y1_N1END[1] Tile_X0Y1_N4END[1] _1228_/X Tile_X0Y0_S4END[5]
+ _0392_/Q _0391_/Q VPWR VGND sg13cmos5l_mux4_1
X_0587_ _0587_/Q Tile_X0Y1_FrameData[15] VGND VPWR Tile_X0Y1_FrameStrobe[7] latch
XFILLER_25_257 VPWR VGND sg13cmos5l_decap_8
XFILLER_40_238 VPWR VGND sg13cmos5l_decap_8
XFILLER_43_38 VPWR VGND sg13cmos5l_decap_8
XFILLER_43_49 VPWR VGND sg13cmos5l_fill_2
X_1139_ _1139_/X Tile_X0Y1_E1END[2] Tile_X0Y1_EE4END[14] Tile_X0Y1_E6END[6] _1205_/X
+ _0536_/Q _0535_/Q VPWR VGND sg13cmos5l_mux4_1
XFILLER_92_190 VPWR VGND sg13cmos5l_decap_8
XFILLER_4_106 VPWR VGND sg13cmos5l_decap_8
XFILLER_108_97 VPWR VGND sg13cmos5l_decap_4
XFILLER_68_46 VPWR VGND sg13cmos5l_decap_4
XFILLER_68_57 VPWR VGND sg13cmos5l_decap_8
XFILLER_16_202 VPWR VGND sg13cmos5l_decap_8
XFILLER_17_61 VPWR VGND sg13cmos5l_fill_1
XFILLER_75_157 VPWR VGND sg13cmos5l_decap_8
XFILLER_84_34 VPWR VGND sg13cmos5l_decap_8
XFILLER_16_268 VPWR VGND sg13cmos5l_decap_4
XFILLER_31_249 VPWR VGND sg13cmos5l_decap_8
XFILLER_3_150 VPWR VGND sg13cmos5l_decap_4
X_0510_ _0510_/Q Tile_X0Y1_FrameData[28] VGND VPWR Tile_X0Y1_FrameStrobe[5] latch
XFILLER_66_157 VPWR VGND sg13cmos5l_decap_8
X_0441_ _0441_/Q Tile_X0Y1_FrameData[1] VGND VPWR Tile_X0Y1_FrameStrobe[2] latch
X_0372_ _0372_/Q Tile_X0Y1_FrameData[6] VGND VPWR Tile_X0Y1_FrameStrobe[0] latch
XFILLER_22_249 VPWR VGND sg13cmos5l_decap_8
XFILLER_88_0 VPWR VGND sg13cmos5l_fill_1
XFILLER_89_205 VPWR VGND sg13cmos5l_decap_8
X_0708_ _1193_/A3 VPWR VGND sg13cmos5l_tielo
X_0639_ _0639_/Q Tile_X0Y1_UserCLK NPU_OUT_ACT3 _0669_/L_HI VPWR VGND sg13cmos5l_dfrbpq_1
XFILLER_57_179 VPWR VGND sg13cmos5l_decap_8
XFILLER_97_271 VPWR VGND sg13cmos5l_fill_2
XFILLER_21_271 VPWR VGND sg13cmos5l_fill_2
XFILLER_70_58 VPWR VGND sg13cmos5l_decap_4
XFILLER_70_69 VPWR VGND sg13cmos5l_decap_4
XFILLER_102_2 VPWR VGND sg13cmos5l_fill_1
XFILLER_79_34 VPWR VGND sg13cmos5l_fill_2
XFILLER_88_271 VPWR VGND sg13cmos5l_fill_2
X_0990_ _0990_/X Tile_X0Y1_EE4END[0] Tile_X0Y1_EE4END[8] Tile_X0Y1_E6END[8] _1211_/X
+ _0418_/Q _0417_/Q VPWR VGND sg13cmos5l_mux4_1
XFILLER_8_264 VPWR VGND sg13cmos5l_fill_1
XFILLER_8_220 VPWR VGND sg13cmos5l_decap_8
XFILLER_5_64 VPWR VGND sg13cmos5l_fill_1
X_0424_ _0424_/Q Tile_X0Y1_FrameData[18] VGND VPWR Tile_X0Y1_FrameStrobe[2] latch
XFILLER_39_124 VPWR VGND sg13cmos5l_decap_8
X_0355_ _0355_/Q Tile_X0Y1_FrameData[23] VGND VPWR Tile_X0Y1_FrameStrobe[0] latch
X_0286_ _0286_/Q Tile_X0Y0_FrameData[30] VGND VPWR Tile_X0Y1_FrameStrobe[6] latch
XFILLER_94_263 VPWR VGND sg13cmos5l_decap_8
XFILLER_10_219 VPWR VGND sg13cmos5l_decap_8
XFILLER_24_29 VPWR VGND sg13cmos5l_fill_2
XFILLER_116_162 VPWR VGND sg13cmos5l_decap_8
XFILLER_49_26 VPWR VGND sg13cmos5l_fill_1
XFILLER_105_98 VPWR VGND sg13cmos5l_decap_8
XFILLER_53_193 VPWR VGND sg13cmos5l_decap_8
XFILLER_65_25 VPWR VGND sg13cmos5l_decap_4
XFILLER_65_69 VPWR VGND sg13cmos5l_fill_2
XFILLER_36_149 VPWR VGND sg13cmos5l_decap_8
X_0140_ _0140_/Q Tile_X0Y0_FrameData[16] VGND VPWR Tile_X0Y1_FrameStrobe[1] latch
X_0071_ _0091_/D _1232_/X _0606_/Q _0608_/Q VPWR VGND sg13cmos5l_mux2_1
XFILLER_91_233 VPWR VGND sg13cmos5l_fill_2
XFILLER_91_222 VPWR VGND sg13cmos5l_decap_8
XFILLER_44_160 VPWR VGND sg13cmos5l_decap_8
X_0973_ _0973_/X Tile_X0Y0_E2MID[0] Tile_X0Y0_E2END[0] _1092_/X _0973_/A3 _0170_/Q
+ _0169_/Q VPWR VGND sg13cmos5l_mux4_1
XFILLER_113_187 VPWR VGND sg13cmos5l_decap_8
XFILLER_67_241 VPWR VGND sg13cmos5l_decap_8
X_0407_ _0407_/Q Tile_X0Y1_FrameData[3] VGND VPWR Tile_X0Y1_FrameStrobe[1] latch
XFILLER_27_116 VPWR VGND sg13cmos5l_decap_4
XFILLER_35_182 VPWR VGND sg13cmos5l_decap_8
XFILLER_82_233 VPWR VGND sg13cmos5l_decap_8
X_0338_ _0338_/Q Tile_X0Y0_FrameData[10] VGND VPWR Tile_X0Y1_FrameStrobe[7] latch
X_0269_ _0269_/Q Tile_X0Y0_FrameData[15] VGND VPWR Tile_X0Y1_FrameStrobe[5] latch
XFILLER_50_163 VPWR VGND sg13cmos5l_fill_2
XFILLER_51_27 VPWR VGND sg13cmos5l_decap_8
XANTENNA__0899__X Tile_X0Y1_S2BEG[7] VPWR VGND sg13cmos5l_antennanp
XFILLER_116_20 VPWR VGND sg13cmos5l_fill_2
XFILLER_2_204 VPWR VGND sg13cmos5l_decap_8
XFILLER_104_198 VPWR VGND sg13cmos5l_decap_8
XFILLER_18_138 VPWR VGND sg13cmos5l_decap_8
XFILLER_73_233 VPWR VGND sg13cmos5l_decap_8
XFILLER_25_94 VPWR VGND sg13cmos5l_fill_1
XFILLER_92_89 VPWR VGND sg13cmos5l_fill_1
XFILLER_92_78 VPWR VGND sg13cmos5l_decap_8
XFILLER_92_34 VPWR VGND sg13cmos5l_fill_1
XFILLER_41_185 VPWR VGND sg13cmos5l_decap_8
XFILLER_17_171 VPWR VGND sg13cmos5l_fill_2
XFILLER_24_108 VPWR VGND sg13cmos5l_fill_2
XFILLER_64_266 VPWR VGND sg13cmos5l_decap_8
X_1172_ _1172_/X _0645_/Q _0649_/Q _1209_/X _1201_/X _0472_/Q _0471_/Q VPWR VGND sg13cmos5l_mux4_1
X_0123_ _0123_/Q Tile_X0Y0_FrameData[1] VGND VPWR Tile_X0Y1_FrameStrobe[0] latch
XANTENNA_15 Tile_X0Y0_S2MID[0] VPWR VGND sg13cmos5l_antennanp
XANTENNA_26 Tile_X0Y0_S2MID[5] VPWR VGND sg13cmos5l_antennanp
XANTENNA_37 Tile_X0Y1_N2MID[4] VPWR VGND sg13cmos5l_antennanp
XANTENNA_48 Tile_X0Y1_N2MID[6] VPWR VGND sg13cmos5l_antennanp
XANTENNA_59 NPU_OUT_ACT1 VPWR VGND sg13cmos5l_antennanp
XFILLER_118_213 VPWR VGND sg13cmos5l_decap_8
XFILLER_70_0 VPWR VGND sg13cmos5l_fill_2
X_0956_ Tile_X0Y1_W6BEG[11] _1190_/X VPWR VGND sg13cmos5l_buf_1
X_0887_ Tile_X0Y0_FrameData_O[31] Tile_X0Y0_FrameData[31] VPWR VGND sg13cmos5l_buf_1
XFILLER_99_163 VPWR VGND sg13cmos5l_decap_8
XFILLER_101_146 VPWR VGND sg13cmos5l_decap_8
XFILLER_102_44 VPWR VGND sg13cmos5l_fill_2
XFILLER_70_225 VPWR VGND sg13cmos5l_decap_8
XFILLER_109_268 VPWR VGND sg13cmos5l_decap_4
XFILLER_23_185 VPWR VGND sg13cmos5l_decap_8
XFILLER_46_222 VPWR VGND sg13cmos5l_decap_8
XFILLER_61_214 VPWR VGND sg13cmos5l_decap_8
XFILLER_14_152 VPWR VGND sg13cmos5l_decap_4
XFILLER_14_163 VPWR VGND sg13cmos5l_fill_1
XFILLER_14_196 VPWR VGND sg13cmos5l_decap_8
X_0810_ Tile_X0Y0_FrameStrobe_O[7] Tile_X0Y1_FrameStrobe[7] VPWR VGND sg13cmos5l_buf_1
X_0741_ Tile_X0Y0_W6BEG[2] _1065_/X VPWR VGND sg13cmos5l_buf_1
X_0672_ _0672_/L_HI VPWR VGND sg13cmos5l_tiehi
X_1224_ _1224_/X Tile_X0Y0_E1END[1] Tile_X0Y0_E2MID[2] Tile_X0Y0_E2END[2] _1097_/X
+ _0292_/Q _0291_/Q VPWR VGND sg13cmos5l_mux4_1
XFILLER_96_199 VPWR VGND sg13cmos5l_decap_8
XFILLER_37_266 VPWR VGND sg13cmos5l_decap_8
XFILLER_52_203 VPWR VGND sg13cmos5l_decap_8
X_1086_ _1086_/X _1112_/X Tile_X0Y1_N4END[5] Tile_X0Y0_S1END[1] Tile_X0Y0_S4END[1]
+ _0138_/Q _0137_/Q VPWR VGND sg13cmos5l_mux4_1
X_1155_ _1155_/X Tile_X0Y1_E2MID[1] _0644_/Q _1195_/X _1202_/X _0506_/Q _0505_/Q VPWR
+ VGND sg13cmos5l_mux4_1
X_0106_ _0106_/Q Tile_X0Y0_FrameData[18] VGND VPWR Tile_X0Y1_FrameStrobe[0] latch
XFILLER_20_155 VPWR VGND sg13cmos5l_fill_1
XFILLER_32_18 VPWR VGND sg13cmos5l_decap_8
X_0939_ Tile_X0Y1_W2BEGb[2] _1157_/X VPWR VGND sg13cmos5l_buf_1
XFILLER_113_43 VPWR VGND sg13cmos5l_fill_1
XFILLER_28_244 VPWR VGND sg13cmos5l_decap_8
XFILLER_57_37 VPWR VGND sg13cmos5l_decap_8
XFILLER_87_177 VPWR VGND sg13cmos5l_decap_8
XFILLER_43_258 VPWR VGND sg13cmos5l_decap_4
XFILLER_73_58 VPWR VGND sg13cmos5l_decap_8
XFILLER_118_0 VPWR VGND sg13cmos5l_decap_8
XFILLER_22_73 VPWR VGND sg13cmos5l_fill_2
XFILLER_98_22 VPWR VGND sg13cmos5l_decap_8
XFILLER_98_11 VPWR VGND sg13cmos5l_decap_8
XFILLER_0_0 VPWR VGND sg13cmos5l_decap_8
XFILLER_105_260 VPWR VGND sg13cmos5l_decap_8
XFILLER_105_271 VPWR VGND sg13cmos5l_fill_2
XFILLER_78_155 VPWR VGND sg13cmos5l_decap_8
XFILLER_19_244 VPWR VGND sg13cmos5l_decap_8
XFILLER_34_236 VPWR VGND sg13cmos5l_decap_8
XFILLER_93_147 VPWR VGND sg13cmos5l_decap_8
XFILLER_103_219 VPWR VGND sg13cmos5l_decap_8
XFILLER_33_0 VPWR VGND sg13cmos5l_fill_2
X_0724_ Tile_X0Y0_W2BEG[1] _1032_/X VPWR VGND sg13cmos5l_buf_1
X_0655_ _0655_/L_HI VPWR VGND sg13cmos5l_tiehi
X_0586_ _0586_/Q Tile_X0Y1_FrameData[16] VGND VPWR Tile_X0Y1_FrameStrobe[7] latch
XFILLER_111_263 VPWR VGND sg13cmos5l_fill_2
XFILLER_69_166 VPWR VGND sg13cmos5l_decap_8
XFILLER_84_125 VPWR VGND sg13cmos5l_decap_8
X_1207_ _1207_/X Tile_X0Y1_N1END[0] Tile_X0Y1_N4END[0] _1227_/X Tile_X0Y0_S4END[4]
+ _0394_/Q _0393_/Q VPWR VGND sg13cmos5l_mux4_1
XFILLER_25_236 VPWR VGND sg13cmos5l_decap_8
XFILLER_25_269 VPWR VGND sg13cmos5l_decap_4
XFILLER_40_217 VPWR VGND sg13cmos5l_decap_8
X_1069_ _1069_/X _0642_/Q _1086_/X _1082_/X _1094_/X _0190_/Q _0189_/Q VPWR VGND sg13cmos5l_mux4_1
X_1138_ _1138_/X _1208_/X _1212_/X _1216_/X _1200_/X _0539_/Q _0538_/Q VPWR VGND sg13cmos5l_mux4_1
XFILLER_111_7 VPWR VGND sg13cmos5l_decap_8
XFILLER_75_136 VPWR VGND sg13cmos5l_decap_8
XFILLER_16_258 VPWR VGND sg13cmos5l_decap_4
XFILLER_31_228 VPWR VGND sg13cmos5l_decap_8
XFILLER_69_9 VPWR VGND sg13cmos5l_fill_1
X_0440_ _0440_/Q Tile_X0Y1_FrameData[2] VGND VPWR Tile_X0Y1_FrameStrobe[2] latch
XFILLER_66_136 VPWR VGND sg13cmos5l_decap_8
XFILLER_81_106 VPWR VGND sg13cmos5l_decap_4
X_0371_ _0371_/Q Tile_X0Y1_FrameData[7] VGND VPWR Tile_X0Y1_FrameStrobe[0] latch
XFILLER_22_228 VPWR VGND sg13cmos5l_decap_8
X_0707_ _1194_/A3 VPWR VGND sg13cmos5l_tielo
X_0638_ _0638_/Q Tile_X0Y1_UserCLK NPU_OUT_ACT2 _0670_/L_HI VPWR VGND sg13cmos5l_dfrbpq_1
X_0569_ _0569_/Q Tile_X0Y1_FrameData[1] VGND VPWR Tile_X0Y1_FrameStrobe[6] latch
XFILLER_97_250 VPWR VGND sg13cmos5l_decap_8
XFILLER_54_16 VPWR VGND sg13cmos5l_fill_1
XFILLER_110_88 VPWR VGND sg13cmos5l_decap_4
XFILLER_21_250 VPWR VGND sg13cmos5l_decap_4
XFILLER_70_37 VPWR VGND sg13cmos5l_decap_8
XFILLER_80_183 VPWR VGND sg13cmos5l_decap_8
XFILLER_0_110 VPWR VGND sg13cmos5l_fill_2
XFILLER_79_79 VPWR VGND sg13cmos5l_fill_1
XFILLER_0_176 VPWR VGND sg13cmos5l_decap_8
XFILLER_88_250 VPWR VGND sg13cmos5l_decap_8
XFILLER_95_56 VPWR VGND sg13cmos5l_fill_2
XFILLER_71_194 VPWR VGND sg13cmos5l_decap_8
XFILLER_12_272 VPWR VGND sg13cmos5l_fill_1
XFILLER_81_8 VPWR VGND sg13cmos5l_decap_8
X_0423_ _0423_/Q Tile_X0Y1_FrameData[19] VGND VPWR Tile_X0Y1_FrameStrobe[2] latch
XFILLER_39_169 VPWR VGND sg13cmos5l_decap_8
XFILLER_54_128 VPWR VGND sg13cmos5l_decap_8
XFILLER_54_139 VPWR VGND sg13cmos5l_fill_1
X_0354_ _0354_/Q Tile_X0Y1_FrameData[24] VGND VPWR Tile_X0Y1_FrameStrobe[0] latch
X_0285_ _0285_/Q Tile_X0Y0_FrameData[31] VGND VPWR Tile_X0Y1_FrameStrobe[6] latch
XFILLER_94_242 VPWR VGND sg13cmos5l_decap_8
XFILLER_62_194 VPWR VGND sg13cmos5l_decap_8
XFILLER_105_22 VPWR VGND sg13cmos5l_fill_1
XFILLER_85_264 VPWR VGND sg13cmos5l_decap_8
XFILLER_38_180 VPWR VGND sg13cmos5l_decap_8
XFILLER_53_172 VPWR VGND sg13cmos5l_decap_8
XFILLER_5_246 VPWR VGND sg13cmos5l_decap_8
XFILLER_100_0 VPWR VGND sg13cmos5l_decap_4
XFILLER_107_185 VPWR VGND sg13cmos5l_decap_8
XFILLER_5_268 VPWR VGND sg13cmos5l_decap_4
XFILLER_76_253 VPWR VGND sg13cmos5l_decap_8
X_0070_ _0090_/D _1231_/X _0607_/Q _0608_/Q VPWR VGND sg13cmos5l_mux2_1
XFILLER_91_267 VPWR VGND sg13cmos5l_decap_4
XFILLER_91_201 VPWR VGND sg13cmos5l_decap_8
X_0972_ Tile_X0Y1_WW4BEG[15] _1178_/X VPWR VGND sg13cmos5l_buf_1
XFILLER_113_166 VPWR VGND sg13cmos5l_decap_8
XFILLER_67_220 VPWR VGND sg13cmos5l_decap_8
X_0406_ _0406_/Q Tile_X0Y1_FrameData[4] VGND VPWR Tile_X0Y1_FrameStrobe[1] latch
X_0337_ _0337_/Q Tile_X0Y0_FrameData[11] VGND VPWR Tile_X0Y1_FrameStrobe[7] latch
XFILLER_27_128 VPWR VGND sg13cmos5l_decap_8
XFILLER_27_139 VPWR VGND sg13cmos5l_fill_1
XFILLER_35_29 VPWR VGND sg13cmos5l_fill_1
XFILLER_82_212 VPWR VGND sg13cmos5l_decap_8
X_0268_ _0268_/Q Tile_X0Y0_FrameData[16] VGND VPWR Tile_X0Y1_FrameStrobe[5] latch
X_0199_ _0199_/Q Tile_X0Y0_FrameData[21] VGND VPWR Tile_X0Y1_FrameStrobe[3] latch
XFILLER_50_197 VPWR VGND sg13cmos5l_decap_8
XFILLER_104_177 VPWR VGND sg13cmos5l_decap_8
XFILLER_4_7 VPWR VGND sg13cmos5l_decap_8
XFILLER_73_212 VPWR VGND sg13cmos5l_decap_8
XFILLER_25_51 VPWR VGND sg13cmos5l_fill_1
XFILLER_41_164 VPWR VGND sg13cmos5l_decap_8
XFILLER_44_8 VPWR VGND sg13cmos5l_fill_2
X_1171_ _1171_/X _0644_/Q _0648_/Q _1210_/X _1202_/X _0474_/Q _0473_/Q VPWR VGND sg13cmos5l_mux4_1
XFILLER_17_150 VPWR VGND sg13cmos5l_decap_8
XFILLER_64_212 VPWR VGND sg13cmos5l_decap_8
XFILLER_64_234 VPWR VGND sg13cmos5l_fill_1
XFILLER_64_245 VPWR VGND sg13cmos5l_decap_8
X_0122_ _0122_/Q Tile_X0Y0_FrameData[2] VGND VPWR Tile_X0Y1_FrameStrobe[0] latch
XANTENNA_16 Tile_X0Y0_S2MID[1] VPWR VGND sg13cmos5l_antennanp
XANTENNA_27 Tile_X0Y0_S2MID[5] VPWR VGND sg13cmos5l_antennanp
XANTENNA_38 Tile_X0Y1_N2MID[4] VPWR VGND sg13cmos5l_antennanp
XANTENNA_49 Tile_X0Y1_N2MID[6] VPWR VGND sg13cmos5l_antennanp
XFILLER_32_197 VPWR VGND sg13cmos5l_decap_8
X_0886_ Tile_X0Y0_FrameData_O[30] Tile_X0Y0_FrameData[30] VPWR VGND sg13cmos5l_buf_1
X_0955_ Tile_X0Y1_W6BEG[10] _1189_/X VPWR VGND sg13cmos5l_buf_1
XFILLER_118_269 VPWR VGND sg13cmos5l_decap_4
XFILLER_63_0 VPWR VGND sg13cmos5l_fill_2
XFILLER_46_28 VPWR VGND sg13cmos5l_decap_4
XFILLER_55_212 VPWR VGND sg13cmos5l_decap_8
XFILLER_23_164 VPWR VGND sg13cmos5l_decap_8
XFILLER_70_204 VPWR VGND sg13cmos5l_decap_8
XFILLER_109_247 VPWR VGND sg13cmos5l_decap_8
XFILLER_11_53 VPWR VGND sg13cmos5l_fill_1
XFILLER_87_68 VPWR VGND sg13cmos5l_decap_4
XFILLER_46_201 VPWR VGND sg13cmos5l_decap_8
XFILLER_14_175 VPWR VGND sg13cmos5l_decap_8
X_0740_ Tile_X0Y0_W6BEG[1] _1064_/X VPWR VGND sg13cmos5l_buf_1
XFILLER_115_228 VPWR VGND sg13cmos5l_decap_4
X_0671_ _0671_/L_HI VPWR VGND sg13cmos5l_tiehi
X_1223_ _1223_/X Tile_X0Y0_E1END[0] Tile_X0Y0_E2MID[3] Tile_X0Y0_E2END[3] _1096_/X
+ _0294_/Q _0293_/Q VPWR VGND sg13cmos5l_mux4_1
X_1154_ _1154_/X _0651_/Q _1195_/X _1202_/X _1193_/X _0508_/Q _0507_/Q VPWR VGND sg13cmos5l_mux4_1
XFILLER_96_178 VPWR VGND sg13cmos5l_decap_8
XFILLER_96_123 VPWR VGND sg13cmos5l_decap_4
XFILLER_20_101 VPWR VGND sg13cmos5l_decap_4
XFILLER_52_259 VPWR VGND sg13cmos5l_decap_4
X_1085_ _1085_/X _1113_/X Tile_X0Y1_N4END[6] Tile_X0Y0_S1END[2] Tile_X0Y0_S4END[2]
+ _0136_/Q _0135_/Q VPWR VGND sg13cmos5l_mux4_1
X_0105_ _0105_/Q Tile_X0Y0_FrameData[19] VGND VPWR Tile_X0Y1_FrameStrobe[0] latch
XFILLER_106_239 VPWR VGND sg13cmos5l_decap_8
X_0869_ Tile_X0Y0_FrameData_O[13] Tile_X0Y0_FrameData[13] VPWR VGND sg13cmos5l_buf_1
X_0938_ Tile_X0Y1_W2BEGb[1] _1156_/X VPWR VGND sg13cmos5l_buf_1
XFILLER_114_261 VPWR VGND sg13cmos5l_decap_8
XFILLER_114_272 VPWR VGND sg13cmos5l_fill_1
XFILLER_28_223 VPWR VGND sg13cmos5l_decap_8
XFILLER_43_237 VPWR VGND sg13cmos5l_decap_8
XFILLER_11_112 VPWR VGND sg13cmos5l_fill_2
XFILLER_11_156 VPWR VGND sg13cmos5l_decap_4
XFILLER_7_105 VPWR VGND sg13cmos5l_decap_8
XFILLER_7_116 VPWR VGND sg13cmos5l_fill_2
XFILLER_112_209 VPWR VGND sg13cmos5l_decap_8
XFILLER_7_149 VPWR VGND sg13cmos5l_decap_8
XFILLER_98_89 VPWR VGND sg13cmos5l_fill_1
XFILLER_19_223 VPWR VGND sg13cmos5l_decap_8
XFILLER_47_60 VPWR VGND sg13cmos5l_fill_1
XFILLER_47_82 VPWR VGND sg13cmos5l_decap_8
XFILLER_93_159 VPWR VGND sg13cmos5l_decap_8
XFILLER_34_215 VPWR VGND sg13cmos5l_decap_8
X_0723_ Tile_X0Y0_W2BEG[0] _1031_/X VPWR VGND sg13cmos5l_buf_1
XFILLER_111_242 VPWR VGND sg13cmos5l_decap_8
XFILLER_26_0 VPWR VGND sg13cmos5l_fill_2
XFILLER_69_134 VPWR VGND sg13cmos5l_fill_1
XFILLER_6_193 VPWR VGND sg13cmos5l_decap_8
X_0654_ _0654_/L_HI VPWR VGND sg13cmos5l_tiehi
X_0585_ _0585_/Q Tile_X0Y1_FrameData[17] VGND VPWR Tile_X0Y1_FrameStrobe[7] latch
XFILLER_25_215 VPWR VGND sg13cmos5l_decap_8
X_1137_ _1137_/X Tile_X0Y1_E1END[1] Tile_X0Y1_EE4END[13] Tile_X0Y1_E6END[5] _1204_/X
+ _0539_/Q _0538_/Q VPWR VGND sg13cmos5l_mux4_1
X_1206_ _1206_/X Tile_X0Y1_N1END[3] Tile_X0Y1_N4END[3] _1230_/X Tile_X0Y0_S4END[7]
+ _0396_/Q _0395_/Q VPWR VGND sg13cmos5l_mux4_1
X_1068_ _1068_/X _0641_/Q _1085_/X _1081_/X _1093_/X _0192_/Q _0191_/Q VPWR VGND sg13cmos5l_mux4_1
XFILLER_108_66 VPWR VGND sg13cmos5l_fill_1
XFILLER_102_253 VPWR VGND sg13cmos5l_decap_8
XFILLER_16_237 VPWR VGND sg13cmos5l_decap_8
XFILLER_31_207 VPWR VGND sg13cmos5l_decap_8
XFILLER_83_181 VPWR VGND sg13cmos5l_fill_1
XFILLER_84_69 VPWR VGND sg13cmos5l_decap_8
XFILLER_33_40 VPWR VGND sg13cmos5l_decap_8
XFILLER_3_141 VPWR VGND sg13cmos5l_decap_4
XFILLER_3_185 VPWR VGND sg13cmos5l_decap_8
X_0370_ _0370_/Q Tile_X0Y1_FrameData[8] VGND VPWR Tile_X0Y1_FrameStrobe[0] latch
XFILLER_98_229 VPWR VGND sg13cmos5l_decap_8
XFILLER_74_170 VPWR VGND sg13cmos5l_fill_2
XFILLER_22_207 VPWR VGND sg13cmos5l_decap_8
XANTENNA__0801__X Tile_X0Y0_N1BEG[2] VPWR VGND sg13cmos5l_antennanp
X_0706_ _1078_/A3 VPWR VGND sg13cmos5l_tielo
XFILLER_38_29 VPWR VGND sg13cmos5l_decap_8
XFILLER_57_115 VPWR VGND sg13cmos5l_fill_2
X_0637_ _0637_/Q Tile_X0Y1_UserCLK NPU_OUT_ACT1 _0668_/L_HI VPWR VGND sg13cmos5l_dfrbpq_1
X_0568_ _0568_/Q Tile_X0Y1_FrameData[2] VGND VPWR Tile_X0Y1_FrameStrobe[6] latch
X_0499_ _0499_/Q Tile_X0Y1_FrameData[7] VGND VPWR Tile_X0Y1_FrameStrobe[4] latch
XFILLER_13_218 VPWR VGND sg13cmos5l_decap_8
XFILLER_72_129 VPWR VGND sg13cmos5l_decap_8
XFILLER_70_16 VPWR VGND sg13cmos5l_decap_8
XFILLER_0_100 VPWR VGND sg13cmos5l_fill_2
XFILLER_79_36 VPWR VGND sg13cmos5l_fill_1
XFILLER_79_58 VPWR VGND sg13cmos5l_decap_8
XFILLER_0_155 VPWR VGND sg13cmos5l_decap_8
XFILLER_12_240 VPWR VGND sg13cmos5l_decap_8
XFILLER_71_173 VPWR VGND sg13cmos5l_decap_8
XFILLER_117_109 VPWR VGND sg13cmos5l_decap_4
XFILLER_5_22 VPWR VGND sg13cmos5l_fill_2
XFILLER_5_55 VPWR VGND sg13cmos5l_decap_8
XFILLER_8_255 VPWR VGND sg13cmos5l_decap_8
X_0422_ _0422_/Q Tile_X0Y1_FrameData[20] VGND VPWR Tile_X0Y1_FrameStrobe[2] latch
X_0353_ _0353_/Q Tile_X0Y1_FrameData[25] VGND VPWR Tile_X0Y1_FrameStrobe[0] latch
XFILLER_94_221 VPWR VGND sg13cmos5l_decap_8
XFILLER_47_181 VPWR VGND sg13cmos5l_decap_8
XFILLER_62_173 VPWR VGND sg13cmos5l_decap_8
X_0284_ _0284_/Q Tile_X0Y0_FrameData[0] VGND VPWR Tile_X0Y1_FrameStrobe[5] latch
XFILLER_93_0 VPWR VGND sg13cmos5l_fill_2
XFILLER_116_197 VPWR VGND sg13cmos5l_decap_8
XFILLER_105_45 VPWR VGND sg13cmos5l_fill_1
XFILLER_105_67 VPWR VGND sg13cmos5l_decap_8
XFILLER_85_243 VPWR VGND sg13cmos5l_decap_8
XFILLER_53_151 VPWR VGND sg13cmos5l_decap_8
XFILLER_81_15 VPWR VGND sg13cmos5l_fill_1
XFILLER_81_59 VPWR VGND sg13cmos5l_decap_8
XFILLER_107_164 VPWR VGND sg13cmos5l_decap_8
XFILLER_5_225 VPWR VGND sg13cmos5l_decap_8
XFILLER_76_232 VPWR VGND sg13cmos5l_decap_8
XFILLER_55_93 VPWR VGND sg13cmos5l_decap_8
XFILLER_91_246 VPWR VGND sg13cmos5l_decap_8
XFILLER_44_195 VPWR VGND sg13cmos5l_decap_8
X_0971_ Tile_X0Y1_WW4BEG[14] _1177_/X VPWR VGND sg13cmos5l_buf_1
XFILLER_113_145 VPWR VGND sg13cmos5l_decap_8
X_0405_ _0405_/Q Tile_X0Y1_FrameData[5] VGND VPWR Tile_X0Y1_FrameStrobe[1] latch
X_0336_ _0336_/Q Tile_X0Y0_FrameData[12] VGND VPWR Tile_X0Y1_FrameStrobe[7] latch
X_0267_ _0267_/Q Tile_X0Y0_FrameData[17] VGND VPWR Tile_X0Y1_FrameStrobe[5] latch
XFILLER_35_162 VPWR VGND sg13cmos5l_decap_8
XFILLER_50_165 VPWR VGND sg13cmos5l_fill_1
XFILLER_82_268 VPWR VGND sg13cmos5l_decap_4
X_0198_ _0198_/Q Tile_X0Y0_FrameData[22] VGND VPWR Tile_X0Y1_FrameStrobe[3] latch
XFILLER_50_176 VPWR VGND sg13cmos5l_decap_8
XFILLER_104_156 VPWR VGND sg13cmos5l_decap_8
XFILLER_116_77 VPWR VGND sg13cmos5l_decap_8
XFILLER_2_239 VPWR VGND sg13cmos5l_decap_4
XFILLER_58_221 VPWR VGND sg13cmos5l_decap_4
XFILLER_73_268 VPWR VGND sg13cmos5l_decap_4
XFILLER_26_184 VPWR VGND sg13cmos5l_decap_8
XFILLER_41_143 VPWR VGND sg13cmos5l_decap_8
XFILLER_41_84 VPWR VGND sg13cmos5l_decap_8
XFILLER_110_159 VPWR VGND sg13cmos5l_decap_8
X_1170_ _1170_/X _0647_/Q _0651_/Q _1211_/X _1195_/X _0476_/Q _0475_/Q VPWR VGND sg13cmos5l_mux4_1
X_0121_ _0121_/Q Tile_X0Y0_FrameData[3] VGND VPWR Tile_X0Y1_FrameStrobe[0] latch
XFILLER_66_92 VPWR VGND sg13cmos5l_fill_2
XANTENNA_17 Tile_X0Y0_S2MID[1] VPWR VGND sg13cmos5l_antennanp
XANTENNA_28 Tile_X0Y0_S2MID[6] VPWR VGND sg13cmos5l_antennanp
XANTENNA_39 Tile_X0Y1_N2MID[4] VPWR VGND sg13cmos5l_antennanp
XFILLER_118_248 VPWR VGND sg13cmos5l_decap_8
XFILLER_32_176 VPWR VGND sg13cmos5l_decap_8
X_0885_ Tile_X0Y0_FrameData_O[29] Tile_X0Y0_FrameData[29] VPWR VGND sg13cmos5l_buf_1
X_0954_ Tile_X0Y1_W6BEG[9] _1188_/X VPWR VGND sg13cmos5l_buf_1
XFILLER_56_0 VPWR VGND sg13cmos5l_decap_8
XFILLER_99_198 VPWR VGND sg13cmos5l_decap_8
XFILLER_102_35 VPWR VGND sg13cmos5l_fill_2
XFILLER_102_46 VPWR VGND sg13cmos5l_fill_1
X_0319_ _0319_/Q Tile_X0Y0_FrameData[29] VGND VPWR Tile_X0Y1_FrameStrobe[7] latch
XFILLER_23_143 VPWR VGND sg13cmos5l_decap_8
XFILLER_62_28 VPWR VGND sg13cmos5l_fill_1
XFILLER_109_226 VPWR VGND sg13cmos5l_fill_2
XFILLER_11_21 VPWR VGND sg13cmos5l_fill_1
XFILLER_11_87 VPWR VGND sg13cmos5l_fill_2
XFILLER_87_47 VPWR VGND sg13cmos5l_decap_8
XFILLER_14_121 VPWR VGND sg13cmos5l_fill_2
XFILLER_46_257 VPWR VGND sg13cmos5l_decap_4
XFILLER_46_268 VPWR VGND sg13cmos5l_decap_4
XFILLER_61_249 VPWR VGND sg13cmos5l_decap_8
XFILLER_52_94 VPWR VGND sg13cmos5l_decap_8
X_0670_ _0670_/L_HI VPWR VGND sg13cmos5l_tiehi
XFILLER_115_207 VPWR VGND sg13cmos5l_decap_8
XFILLER_96_135 VPWR VGND sg13cmos5l_decap_8
XFILLER_96_102 VPWR VGND sg13cmos5l_decap_8
XFILLER_37_213 VPWR VGND sg13cmos5l_decap_8
XFILLER_37_224 VPWR VGND sg13cmos5l_fill_1
X_1084_ _1084_/X _1114_/X Tile_X0Y1_N4END[7] Tile_X0Y0_S1END[3] Tile_X0Y0_S4END[3]
+ _0134_/Q _0133_/Q VPWR VGND sg13cmos5l_mux4_1
X_1222_ _1222_/X Tile_X0Y0_E2MID[4] Tile_X0Y0_E2END[4] Tile_X0Y0_E6END[11] _1095_/X
+ _0296_/Q _0295_/Q VPWR VGND sg13cmos5l_mux4_1
X_1153_ _1153_/X _0650_/Q _1196_/X _1201_/X _1192_/X _0510_/Q _0509_/Q VPWR VGND sg13cmos5l_mux4_1
X_0104_ _0104_/Q Tile_X0Y0_FrameData[20] VGND VPWR Tile_X0Y1_FrameStrobe[0] latch
XFILLER_96_157 VPWR VGND sg13cmos5l_decap_8
XANTENNA__0804__X Tile_X0Y0_FrameStrobe_O[1] VPWR VGND sg13cmos5l_antennanp
XFILLER_52_238 VPWR VGND sg13cmos5l_decap_8
XFILLER_106_218 VPWR VGND sg13cmos5l_decap_8
X_0868_ Tile_X0Y0_FrameData_O[12] Tile_X0Y0_FrameData[12] VPWR VGND sg13cmos5l_buf_1
X_0937_ Tile_X0Y1_W2BEGb[0] _1155_/X VPWR VGND sg13cmos5l_buf_1
X_0799_ Tile_X0Y0_N1BEG[0] _0999_/X VPWR VGND sg13cmos5l_buf_1
XFILLER_114_240 VPWR VGND sg13cmos5l_decap_8
XFILLER_28_202 VPWR VGND sg13cmos5l_decap_8
XFILLER_113_34 VPWR VGND sg13cmos5l_decap_8
XFILLER_43_216 VPWR VGND sg13cmos5l_decap_8
XFILLER_11_179 VPWR VGND sg13cmos5l_decap_8
XFILLER_22_75 VPWR VGND sg13cmos5l_fill_1
XFILLER_7_128 VPWR VGND sg13cmos5l_decap_8
XFILLER_78_113 VPWR VGND sg13cmos5l_decap_8
XFILLER_19_202 VPWR VGND sg13cmos5l_decap_8
XFILLER_19_268 VPWR VGND sg13cmos5l_decap_4
XFILLER_8_33 VPWR VGND sg13cmos5l_fill_2
XFILLER_6_172 VPWR VGND sg13cmos5l_decap_8
X_0722_ Tile_X0Y0_W1BEG[3] _1030_/X VPWR VGND sg13cmos5l_buf_1
X_0653_ _0653_/L_HI VPWR VGND sg13cmos5l_tiehi
XFILLER_8_66 VPWR VGND sg13cmos5l_fill_1
XFILLER_69_157 VPWR VGND sg13cmos5l_decap_4
XFILLER_88_90 VPWR VGND sg13cmos5l_decap_8
X_0584_ _0584_/Q Tile_X0Y1_FrameData[18] VGND VPWR Tile_X0Y1_FrameStrobe[7] latch
XFILLER_19_0 VPWR VGND sg13cmos5l_fill_2
X_1067_ _1067_/X _0640_/Q _1084_/X _1080_/X _1092_/X _0194_/Q _0193_/Q VPWR VGND sg13cmos5l_mux4_1
X_1136_ _1136_/X _1207_/X _1211_/X _1215_/X _1199_/X _0542_/Q _0541_/Q VPWR VGND sg13cmos5l_mux4_1
X_1205_ _1205_/X Tile_X0Y1_N1END[2] Tile_X0Y1_N4END[2] _1229_/X Tile_X0Y0_S4END[6]
+ _0398_/Q _0397_/Q VPWR VGND sg13cmos5l_mux4_1
XFILLER_33_260 VPWR VGND sg13cmos5l_decap_8
XFILLER_33_271 VPWR VGND sg13cmos5l_fill_2
XFILLER_102_232 VPWR VGND sg13cmos5l_decap_8
XFILLER_17_31 VPWR VGND sg13cmos5l_fill_2
XFILLER_84_48 VPWR VGND sg13cmos5l_decap_8
XFILLER_16_216 VPWR VGND sg13cmos5l_decap_8
XFILLER_17_97 VPWR VGND sg13cmos5l_decap_8
XFILLER_83_193 VPWR VGND sg13cmos5l_decap_8
XFILLER_3_164 VPWR VGND sg13cmos5l_decap_8
XFILLER_3_197 VPWR VGND sg13cmos5l_decap_8
XFILLER_98_208 VPWR VGND sg13cmos5l_decap_8
XFILLER_74_92 VPWR VGND sg13cmos5l_decap_8
XFILLER_81_119 VPWR VGND sg13cmos5l_decap_8
XFILLER_89_219 VPWR VGND sg13cmos5l_decap_8
X_0705_ _0973_/A3 VPWR VGND sg13cmos5l_tielo
X_0636_ _0636_/Q Tile_X0Y1_UserCLK NPU_OUT_ACT0 _0664_/L_HI VPWR VGND sg13cmos5l_dfrbpq_1
X_0567_ _0567_/Q Tile_X0Y1_FrameData[3] VGND VPWR Tile_X0Y1_FrameStrobe[6] latch
X_0498_ _0498_/Q Tile_X0Y1_FrameData[8] VGND VPWR Tile_X0Y1_FrameStrobe[4] latch
XFILLER_65_193 VPWR VGND sg13cmos5l_decap_8
XFILLER_80_163 VPWR VGND sg13cmos5l_fill_2
X_1119_ _1119_/X Tile_X0Y1_E1END[1] Tile_X0Y1_EE4END[1] Tile_X0Y1_E6END[9] _1204_/X
+ _0575_/Q _0574_/Q VPWR VGND sg13cmos5l_mux4_1
XFILLER_79_15 VPWR VGND sg13cmos5l_decap_4
XFILLER_88_230 VPWR VGND sg13cmos5l_decap_8
XFILLER_28_85 VPWR VGND sg13cmos5l_decap_4
XFILLER_56_193 VPWR VGND sg13cmos5l_decap_8
XFILLER_71_130 VPWR VGND sg13cmos5l_fill_1
XFILLER_44_62 VPWR VGND sg13cmos5l_decap_8
XFILLER_71_163 VPWR VGND sg13cmos5l_decap_8
XFILLER_8_234 VPWR VGND sg13cmos5l_decap_8
XANTENNA__0902__X Tile_X0Y1_S2BEGb[2] VPWR VGND sg13cmos5l_antennanp
XFILLER_5_45 VPWR VGND sg13cmos5l_fill_2
XFILLER_39_138 VPWR VGND sg13cmos5l_decap_8
XFILLER_39_149 VPWR VGND sg13cmos5l_decap_8
XFILLER_79_252 VPWR VGND sg13cmos5l_decap_8
X_0421_ _0421_/Q Tile_X0Y1_FrameData[21] VGND VPWR Tile_X0Y1_FrameStrobe[2] latch
X_0352_ _0352_/Q Tile_X0Y1_FrameData[26] VGND VPWR Tile_X0Y1_FrameStrobe[0] latch
X_0283_ _0283_/Q Tile_X0Y0_FrameData[1] VGND VPWR Tile_X0Y1_FrameStrobe[5] latch
XFILLER_94_200 VPWR VGND sg13cmos5l_decap_8
XFILLER_47_160 VPWR VGND sg13cmos5l_decap_8
XFILLER_62_152 VPWR VGND sg13cmos5l_decap_8
XANTENNA__0812__X Tile_X0Y0_FrameStrobe_O[9] VPWR VGND sg13cmos5l_antennanp
XFILLER_86_0 VPWR VGND sg13cmos5l_fill_1
XFILLER_116_143 VPWR VGND sg13cmos5l_fill_1
XFILLER_116_176 VPWR VGND sg13cmos5l_decap_8
X_0619_ NPU_ACT_WDATA1 Tile_X0Y1_UserCLK _0983_/X _0660_/L_HI VPWR VGND sg13cmos5l_dfrbpq_1
XFILLER_85_222 VPWR VGND sg13cmos5l_decap_8
XFILLER_14_32 VPWR VGND sg13cmos5l_decap_4
XFILLER_14_43 VPWR VGND sg13cmos5l_decap_8
XFILLER_14_65 VPWR VGND sg13cmos5l_decap_8
XFILLER_81_27 VPWR VGND sg13cmos5l_decap_8
XANTENNA__0722__X Tile_X0Y0_W1BEG[3] VPWR VGND sg13cmos5l_antennanp
XFILLER_107_143 VPWR VGND sg13cmos5l_decap_8
XFILLER_30_86 VPWR VGND sg13cmos5l_decap_4
XFILLER_5_204 VPWR VGND sg13cmos5l_decap_8
XFILLER_39_62 VPWR VGND sg13cmos5l_decap_8
XFILLER_76_211 VPWR VGND sg13cmos5l_decap_8
XFILLER_29_193 VPWR VGND sg13cmos5l_decap_8
XFILLER_44_174 VPWR VGND sg13cmos5l_decap_8
XFILLER_71_71 VPWR VGND sg13cmos5l_decap_8
XFILLER_71_93 VPWR VGND sg13cmos5l_fill_2
X_0970_ Tile_X0Y1_WW4BEG[13] _1176_/X VPWR VGND sg13cmos5l_buf_1
XFILLER_58_4 VPWR VGND sg13cmos5l_fill_2
X_0404_ _0404_/Q Tile_X0Y1_FrameData[6] VGND VPWR Tile_X0Y1_FrameStrobe[1] latch
XANTENNA__0807__X Tile_X0Y0_FrameStrobe_O[4] VPWR VGND sg13cmos5l_antennanp
XFILLER_67_255 VPWR VGND sg13cmos5l_decap_8
XFILLER_82_247 VPWR VGND sg13cmos5l_decap_8
X_0335_ _0335_/Q Tile_X0Y0_FrameData[13] VGND VPWR Tile_X0Y1_FrameStrobe[7] latch
X_0266_ _0266_/Q Tile_X0Y0_FrameData[18] VGND VPWR Tile_X0Y1_FrameStrobe[5] latch
XFILLER_35_196 VPWR VGND sg13cmos5l_decap_8
XFILLER_51_19 VPWR VGND sg13cmos5l_fill_1
X_0197_ _0197_/Q Tile_X0Y0_FrameData[23] VGND VPWR Tile_X0Y1_FrameStrobe[3] latch
XFILLER_2_218 VPWR VGND sg13cmos5l_decap_8
XFILLER_104_124 VPWR VGND sg13cmos5l_fill_1
XFILLER_58_200 VPWR VGND sg13cmos5l_decap_8
XFILLER_58_233 VPWR VGND sg13cmos5l_fill_2
XFILLER_76_27 VPWR VGND sg13cmos5l_decap_8
XFILLER_73_247 VPWR VGND sg13cmos5l_decap_8
XFILLER_41_199 VPWR VGND sg13cmos5l_decap_8
XFILLER_41_52 VPWR VGND sg13cmos5l_decap_8
XFILLER_110_127 VPWR VGND sg13cmos5l_decap_8
XFILLER_2_46 VPWR VGND sg13cmos5l_fill_2
XFILLER_2_79 VPWR VGND sg13cmos5l_fill_1
XFILLER_66_60 VPWR VGND sg13cmos5l_decap_8
X_0120_ _0120_/Q Tile_X0Y0_FrameData[4] VGND VPWR Tile_X0Y1_FrameStrobe[0] latch
XANTENNA_18 Tile_X0Y0_S2MID[2] VPWR VGND sg13cmos5l_antennanp
XANTENNA_29 Tile_X0Y0_S2MID[6] VPWR VGND sg13cmos5l_antennanp
XFILLER_32_122 VPWR VGND sg13cmos5l_decap_4
XFILLER_118_227 VPWR VGND sg13cmos5l_decap_8
XFILLER_63_2 VPWR VGND sg13cmos5l_fill_1
X_0884_ Tile_X0Y0_FrameData_O[28] Tile_X0Y0_FrameData[28] VPWR VGND sg13cmos5l_buf_1
X_0953_ Tile_X0Y1_W6BEG[8] _1187_/X VPWR VGND sg13cmos5l_buf_1
XFILLER_49_0 VPWR VGND sg13cmos5l_decap_4
XFILLER_99_177 VPWR VGND sg13cmos5l_decap_8
XFILLER_102_58 VPWR VGND sg13cmos5l_fill_1
XFILLER_70_239 VPWR VGND sg13cmos5l_decap_8
X_0318_ _0318_/Q Tile_X0Y0_FrameData[30] VGND VPWR Tile_X0Y1_FrameStrobe[7] latch
X_0249_ _0249_/Q Tile_X0Y0_FrameData[3] VGND VPWR Tile_X0Y1_FrameStrobe[4] latch
XFILLER_109_205 VPWR VGND sg13cmos5l_decap_8
XFILLER_23_199 VPWR VGND sg13cmos5l_decap_8
XFILLER_87_26 VPWR VGND sg13cmos5l_decap_8
XFILLER_100_182 VPWR VGND sg13cmos5l_decap_8
XFILLER_46_236 VPWR VGND sg13cmos5l_fill_2
XFILLER_36_41 VPWR VGND sg13cmos5l_decap_8
XFILLER_36_63 VPWR VGND sg13cmos5l_fill_1
XFILLER_61_228 VPWR VGND sg13cmos5l_decap_8
XANTENNA__0910__X Tile_X0Y1_S4BEG[2] VPWR VGND sg13cmos5l_antennanp
X_1221_ _1221_/X Tile_X0Y0_E2MID[5] Tile_X0Y0_E2END[5] Tile_X0Y0_E6END[10] _1094_/X
+ _0298_/Q _0297_/Q VPWR VGND sg13cmos5l_mux4_1
XFILLER_52_217 VPWR VGND sg13cmos5l_decap_8
X_1083_ _1083_/X _1111_/X Tile_X0Y1_N4END[4] Tile_X0Y0_S1END[0] Tile_X0Y0_S4END[0]
+ _0132_/Q _0131_/Q VPWR VGND sg13cmos5l_mux4_1
X_1152_ _1152_/X _0649_/Q _1197_/X _1200_/X _1191_/X _0512_/Q _0511_/Q VPWR VGND sg13cmos5l_mux4_1
X_0103_ _0103_/Q Tile_X0Y0_FrameData[21] VGND VPWR Tile_X0Y1_FrameStrobe[0] latch
XFILLER_20_114 VPWR VGND sg13cmos5l_decap_8
XFILLER_60_272 VPWR VGND sg13cmos5l_fill_1
X_0936_ Tile_X0Y1_W2BEG[7] _1154_/X VPWR VGND sg13cmos5l_buf_1
XANTENNA__0820__X Tile_X0Y0_FrameStrobe_O[17] VPWR VGND sg13cmos5l_antennanp
X_0867_ Tile_X0Y0_FrameData_O[11] Tile_X0Y0_FrameData[11] VPWR VGND sg13cmos5l_buf_1
X_0798_ Tile_X0Y0_N2BEG[7] _1010_/X VPWR VGND sg13cmos5l_buf_1
XFILLER_87_125 VPWR VGND sg13cmos5l_decap_8
XFILLER_28_258 VPWR VGND sg13cmos5l_decap_4
XFILLER_51_272 VPWR VGND sg13cmos5l_fill_1
XFILLER_73_28 VPWR VGND sg13cmos5l_decap_8
XANTENNA__0730__X Tile_X0Y0_W2BEG[7] VPWR VGND sg13cmos5l_antennanp
XFILLER_22_87 VPWR VGND sg13cmos5l_decap_8
XFILLER_78_169 VPWR VGND sg13cmos5l_decap_8
XFILLER_98_36 VPWR VGND sg13cmos5l_decap_8
XFILLER_19_258 VPWR VGND sg13cmos5l_fill_1
XANTENNA__0905__X Tile_X0Y1_S2BEGb[5] VPWR VGND sg13cmos5l_antennanp
XFILLER_42_272 VPWR VGND sg13cmos5l_fill_1
XFILLER_63_61 VPWR VGND sg13cmos5l_fill_1
XFILLER_8_45 VPWR VGND sg13cmos5l_decap_8
XFILLER_10_191 VPWR VGND sg13cmos5l_decap_8
XFILLER_40_4 VPWR VGND sg13cmos5l_fill_1
XFILLER_6_151 VPWR VGND sg13cmos5l_decap_8
X_0721_ Tile_X0Y0_W1BEG[2] _1029_/X VPWR VGND sg13cmos5l_buf_1
X_0652_ _0652_/L_HI VPWR VGND sg13cmos5l_tiehi
X_0583_ _0583_/Q Tile_X0Y1_FrameData[19] VGND VPWR Tile_X0Y1_FrameStrobe[7] latch
XFILLER_111_211 VPWR VGND sg13cmos5l_decap_8
XFILLER_69_125 VPWR VGND sg13cmos5l_decap_8
XFILLER_84_139 VPWR VGND sg13cmos5l_decap_8
X_1204_ _1204_/X Tile_X0Y1_N1END[1] Tile_X0Y1_N4END[1] _1228_/X Tile_X0Y0_S4END[5]
+ _0400_/Q _0399_/Q VPWR VGND sg13cmos5l_mux4_1
XANTENNA__0815__X Tile_X0Y0_FrameStrobe_O[12] VPWR VGND sg13cmos5l_antennanp
X_1066_ _1066_/X Tile_X0Y1_N4END[7] Tile_X0Y0_S4END[3] _1083_/X _1075_/X _0196_/Q
+ _0195_/Q VPWR VGND sg13cmos5l_mux4_1
X_1135_ _1135_/X Tile_X0Y1_E1END[0] Tile_X0Y1_EE4END[12] Tile_X0Y1_E6END[4] _1203_/X
+ _0542_/Q _0541_/Q VPWR VGND sg13cmos5l_mux4_1
XFILLER_92_183 VPWR VGND sg13cmos5l_decap_8
X_0919_ Tile_X0Y1_S4BEG[11] _0919_/A VPWR VGND sg13cmos5l_buf_1
XFILLER_102_211 VPWR VGND sg13cmos5l_decap_8
XFILLER_17_54 VPWR VGND sg13cmos5l_decap_8
XFILLER_84_27 VPWR VGND sg13cmos5l_decap_8
XANTENNA__0725__X Tile_X0Y0_W2BEG[2] VPWR VGND sg13cmos5l_antennanp
XFILLER_24_261 VPWR VGND sg13cmos5l_decap_8
XFILLER_24_272 VPWR VGND sg13cmos5l_fill_1
XFILLER_116_0 VPWR VGND sg13cmos5l_decap_8
XFILLER_15_250 VPWR VGND sg13cmos5l_decap_8
XFILLER_74_172 VPWR VGND sg13cmos5l_fill_1
XFILLER_15_272 VPWR VGND sg13cmos5l_fill_1
XFILLER_30_242 VPWR VGND sg13cmos5l_decap_4
XFILLER_90_81 VPWR VGND sg13cmos5l_fill_1
XFILLER_90_70 VPWR VGND sg13cmos5l_decap_8
XFILLER_31_0 VPWR VGND sg13cmos5l_fill_2
X_0704_ _1235_/A3 VPWR VGND sg13cmos5l_tielo
X_0635_ NPU_WEIGHT_SHIFT_EN Tile_X0Y1_UserCLK _1234_/X _0665_/L_HI VPWR VGND sg13cmos5l_dfrbpq_1
X_0566_ _0566_/Q Tile_X0Y1_FrameData[4] VGND VPWR Tile_X0Y1_FrameStrobe[6] latch
XFILLER_65_172 VPWR VGND sg13cmos5l_decap_8
X_0497_ _0497_/Q Tile_X0Y1_FrameData[9] VGND VPWR Tile_X0Y1_FrameStrobe[4] latch
XFILLER_97_264 VPWR VGND sg13cmos5l_decap_8
XFILLER_21_264 VPWR VGND sg13cmos5l_fill_1
XFILLER_80_142 VPWR VGND sg13cmos5l_decap_8
XFILLER_80_197 VPWR VGND sg13cmos5l_decap_8
X_1049_ _1049_/X _0638_/Q _0642_/Q _1076_/X _1097_/X _0230_/Q _0229_/Q VPWR VGND sg13cmos5l_mux4_1
X_1118_ _1118_/X _1209_/X _1213_/X _1217_/X _1197_/X _0572_/Q _0571_/Q VPWR VGND sg13cmos5l_mux4_1
XFILLER_79_27 VPWR VGND sg13cmos5l_decap_8
XFILLER_0_102 VPWR VGND sg13cmos5l_fill_1
XFILLER_88_264 VPWR VGND sg13cmos5l_decap_8
XFILLER_28_42 VPWR VGND sg13cmos5l_fill_2
XFILLER_56_172 VPWR VGND sg13cmos5l_decap_8
XFILLER_12_264 VPWR VGND sg13cmos5l_fill_1
XFILLER_60_40 VPWR VGND sg13cmos5l_decap_4
XFILLER_8_268 VPWR VGND sg13cmos5l_decap_4
XFILLER_8_213 VPWR VGND sg13cmos5l_decap_8
XFILLER_79_231 VPWR VGND sg13cmos5l_decap_8
X_0420_ _0420_/Q Tile_X0Y1_FrameData[22] VGND VPWR Tile_X0Y1_FrameStrobe[2] latch
X_0351_ _0351_/Q Tile_X0Y1_FrameData[27] VGND VPWR Tile_X0Y1_FrameStrobe[0] latch
X_0282_ _0282_/Q Tile_X0Y0_FrameData[2] VGND VPWR Tile_X0Y1_FrameStrobe[5] latch
XFILLER_94_256 VPWR VGND sg13cmos5l_decap_8
XFILLER_62_131 VPWR VGND sg13cmos5l_decap_8
XFILLER_116_122 VPWR VGND sg13cmos5l_decap_8
XFILLER_116_155 VPWR VGND sg13cmos5l_decap_8
XFILLER_79_0 VPWR VGND sg13cmos5l_decap_4
XFILLER_85_201 VPWR VGND sg13cmos5l_decap_8
X_0618_ NPU_ACT_WDATA0 Tile_X0Y1_UserCLK _0982_/X _0681_/L_HI VPWR VGND sg13cmos5l_dfrbpq_1
X_0549_ _0549_/Q Tile_X0Y1_FrameData[21] VGND VPWR Tile_X0Y1_FrameStrobe[6] latch
XFILLER_38_194 VPWR VGND sg13cmos5l_decap_8
XFILLER_65_29 VPWR VGND sg13cmos5l_fill_1
XFILLER_53_186 VPWR VGND sg13cmos5l_decap_8
XFILLER_107_199 VPWR VGND sg13cmos5l_decap_8
XFILLER_29_172 VPWR VGND sg13cmos5l_decap_8
XFILLER_39_30 VPWR VGND sg13cmos5l_decap_4
XFILLER_76_267 VPWR VGND sg13cmos5l_decap_4
XFILLER_91_215 VPWR VGND sg13cmos5l_decap_8
XFILLER_44_153 VPWR VGND sg13cmos5l_decap_8
XANTENNA__0913__X Tile_X0Y1_S4BEG[5] VPWR VGND sg13cmos5l_antennanp
XFILLER_67_234 VPWR VGND sg13cmos5l_decap_8
X_0403_ _0403_/Q Tile_X0Y1_FrameData[7] VGND VPWR Tile_X0Y1_FrameStrobe[1] latch
XFILLER_27_109 VPWR VGND sg13cmos5l_decap_8
XFILLER_82_226 VPWR VGND sg13cmos5l_decap_8
X_0334_ _0334_/Q Tile_X0Y0_FrameData[14] VGND VPWR Tile_X0Y1_FrameStrobe[7] latch
X_0265_ _0265_/Q Tile_X0Y0_FrameData[19] VGND VPWR Tile_X0Y1_FrameStrobe[5] latch
X_0196_ _0196_/Q Tile_X0Y0_FrameData[24] VGND VPWR Tile_X0Y1_FrameStrobe[3] latch
XANTENNA__0823__X FAB_USER_CLK VPWR VGND sg13cmos5l_antennanp
XFILLER_73_226 VPWR VGND sg13cmos5l_decap_8
XFILLER_26_142 VPWR VGND sg13cmos5l_decap_8
XFILLER_92_38 VPWR VGND sg13cmos5l_decap_4
XANTENNA__0733__X Tile_X0Y0_W2BEGb[2] VPWR VGND sg13cmos5l_antennanp
XFILLER_41_178 VPWR VGND sg13cmos5l_decap_8
XFILLER_41_20 VPWR VGND sg13cmos5l_decap_4
XFILLER_110_139 VPWR VGND sg13cmos5l_fill_2
XFILLER_1_241 VPWR VGND sg13cmos5l_fill_2
XFILLER_49_223 VPWR VGND sg13cmos5l_decap_4
XFILLER_9_0 VPWR VGND sg13cmos5l_fill_2
XANTENNA__0908__X Tile_X0Y1_S4BEG[0] VPWR VGND sg13cmos5l_antennanp
XFILLER_103_191 VPWR VGND sg13cmos5l_decap_8
XFILLER_17_164 VPWR VGND sg13cmos5l_decap_8
XFILLER_2_69 VPWR VGND sg13cmos5l_fill_2
XFILLER_64_226 VPWR VGND sg13cmos5l_fill_2
XFILLER_64_259 VPWR VGND sg13cmos5l_decap_8
XANTENNA_19 Tile_X0Y0_S2MID[2] VPWR VGND sg13cmos5l_antennanp
XFILLER_82_82 VPWR VGND sg13cmos5l_decap_8
X_0952_ Tile_X0Y1_W6BEG[7] _1186_/X VPWR VGND sg13cmos5l_buf_1
XFILLER_118_206 VPWR VGND sg13cmos5l_decap_8
X_0883_ Tile_X0Y0_FrameData_O[27] Tile_X0Y0_FrameData[27] VPWR VGND sg13cmos5l_buf_1
XANTENNA__0818__X Tile_X0Y0_FrameStrobe_O[15] VPWR VGND sg13cmos5l_antennanp
X_0317_ _0317_/Q Tile_X0Y0_FrameData[31] VGND VPWR Tile_X0Y1_FrameStrobe[7] latch
XFILLER_99_156 VPWR VGND sg13cmos5l_decap_8
XFILLER_70_218 VPWR VGND sg13cmos5l_decap_8
X_0248_ _0248_/Q Tile_X0Y0_FrameData[4] VGND VPWR Tile_X0Y1_FrameStrobe[4] latch
X_0179_ _0179_/Q Tile_X0Y0_FrameData[9] VGND VPWR Tile_X0Y1_FrameStrobe[2] latch
XFILLER_109_228 VPWR VGND sg13cmos5l_fill_1
XFILLER_23_178 VPWR VGND sg13cmos5l_decap_8
XFILLER_117_272 VPWR VGND sg13cmos5l_fill_1
XANTENNA__0728__X Tile_X0Y0_W2BEG[5] VPWR VGND sg13cmos5l_antennanp
XFILLER_100_161 VPWR VGND sg13cmos5l_decap_8
XFILLER_46_215 VPWR VGND sg13cmos5l_decap_8
XFILLER_61_207 VPWR VGND sg13cmos5l_decap_8
XFILLER_14_134 VPWR VGND sg13cmos5l_decap_4
XFILLER_14_145 VPWR VGND sg13cmos5l_decap_8
XFILLER_14_156 VPWR VGND sg13cmos5l_fill_1
XFILLER_14_189 VPWR VGND sg13cmos5l_decap_8
XFILLER_108_272 VPWR VGND sg13cmos5l_fill_1
X_1220_ _1220_/X Tile_X0Y0_E2MID[6] Tile_X0Y0_E2END[6] Tile_X0Y0_E6END[9] _1093_/X
+ _0300_/Q _0299_/Q VPWR VGND sg13cmos5l_mux4_1
X_1151_ _1151_/X Tile_X0Y1_EE4END[8] _0648_/Q _1198_/X _1199_/X _0514_/Q _0513_/Q
+ VPWR VGND sg13cmos5l_mux4_1
XFILLER_37_259 VPWR VGND sg13cmos5l_decap_8
X_1082_ _1082_/X _1112_/X Tile_X0Y1_N4END[5] Tile_X0Y0_S1END[1] Tile_X0Y0_S4END[1]
+ _0130_/Q _0129_/Q VPWR VGND sg13cmos5l_mux4_1
X_0102_ _0102_/Q Tile_X0Y0_FrameData[22] VGND VPWR Tile_X0Y1_FrameStrobe[0] latch
XFILLER_93_70 VPWR VGND sg13cmos5l_fill_2
XFILLER_60_251 VPWR VGND sg13cmos5l_decap_8
X_0866_ Tile_X0Y0_FrameData_O[10] Tile_X0Y0_FrameData[10] VPWR VGND sg13cmos5l_buf_1
X_0935_ Tile_X0Y1_W2BEG[6] _1153_/X VPWR VGND sg13cmos5l_buf_1
XFILLER_9_193 VPWR VGND sg13cmos5l_decap_8
XFILLER_61_0 VPWR VGND sg13cmos5l_fill_1
X_0797_ Tile_X0Y0_N2BEG[6] _1009_/X VPWR VGND sg13cmos5l_buf_1
XFILLER_28_237 VPWR VGND sg13cmos5l_decap_8
XFILLER_51_251 VPWR VGND sg13cmos5l_decap_8
XFILLER_105_253 VPWR VGND sg13cmos5l_decap_8
XFILLER_19_237 VPWR VGND sg13cmos5l_decap_8
XFILLER_34_229 VPWR VGND sg13cmos5l_decap_8
XFILLER_47_96 VPWR VGND sg13cmos5l_fill_1
XFILLER_86_192 VPWR VGND sg13cmos5l_decap_8
XANTENNA__0921__X Tile_X0Y1_S4BEG[13] VPWR VGND sg13cmos5l_antennanp
XFILLER_10_170 VPWR VGND sg13cmos5l_decap_8
XFILLER_42_251 VPWR VGND sg13cmos5l_decap_8
X_0720_ Tile_X0Y0_W1BEG[1] _1028_/X VPWR VGND sg13cmos5l_buf_1
X_0651_ _0651_/Q Tile_X0Y1_UserCLK NPU_ACT_RDATA7 _0659_/L_HI VPWR VGND sg13cmos5l_dfrbpq_1
X_0582_ _0582_/Q Tile_X0Y1_FrameData[20] VGND VPWR Tile_X0Y1_FrameStrobe[7] latch
XFILLER_111_256 VPWR VGND sg13cmos5l_decap_8
X_1134_ _1134_/X Tile_X0Y1_E1END[3] Tile_X0Y1_E2MID[0] Tile_X0Y1_E2END[0] _1202_/X
+ _0544_/Q _0543_/Q VPWR VGND sg13cmos5l_mux4_1
X_1203_ _1203_/X Tile_X0Y1_N1END[0] Tile_X0Y1_N4END[0] _1227_/X Tile_X0Y0_S4END[4]
+ _0402_/Q _0401_/Q VPWR VGND sg13cmos5l_mux4_1
XFILLER_25_229 VPWR VGND sg13cmos5l_decap_8
X_1065_ _1065_/X Tile_X0Y1_N4END[6] Tile_X0Y0_S4END[2] _1082_/X _1076_/X _0198_/Q
+ _0197_/Q VPWR VGND sg13cmos5l_mux4_1
XFILLER_92_162 VPWR VGND sg13cmos5l_decap_8
XANTENNA__0831__X Tile_X0Y1_FrameData_O[7] VPWR VGND sg13cmos5l_antennanp
X_0918_ Tile_X0Y1_S4BEG[10] _0918_/A VPWR VGND sg13cmos5l_buf_1
X_0849_ Tile_X0Y1_FrameData_O[25] Tile_X0Y1_FrameData[25] VPWR VGND sg13cmos5l_buf_1
XFILLER_102_267 VPWR VGND sg13cmos5l_decap_4
XFILLER_108_58 VPWR VGND sg13cmos5l_fill_1
XFILLER_68_192 VPWR VGND sg13cmos5l_decap_8
XFILLER_75_129 VPWR VGND sg13cmos5l_decap_8
XANTENNA__0741__X Tile_X0Y0_W6BEG[2] VPWR VGND sg13cmos5l_antennanp
XFILLER_24_240 VPWR VGND sg13cmos5l_decap_8
XFILLER_109_0 VPWR VGND sg13cmos5l_fill_1
XFILLER_3_122 VPWR VGND sg13cmos5l_fill_1
XFILLER_12_9 VPWR VGND sg13cmos5l_fill_2
XFILLER_66_129 VPWR VGND sg13cmos5l_decap_8
XANTENNA__0916__X Tile_X0Y1_S4BEG[8] VPWR VGND sg13cmos5l_antennanp
XFILLER_74_184 VPWR VGND sg13cmos5l_fill_1
XFILLER_74_50 VPWR VGND sg13cmos5l_decap_8
X_0703_ _1100_/A3 VPWR VGND sg13cmos5l_tielo
XFILLER_24_0 VPWR VGND sg13cmos5l_fill_2
X_0634_ NPU_ACT_ADDR8 Tile_X0Y1_UserCLK _0981_/X _0666_/L_HI VPWR VGND sg13cmos5l_dfrbpq_1
X_0565_ _0565_/Q Tile_X0Y1_FrameData[5] VGND VPWR Tile_X0Y1_FrameStrobe[6] latch
X_0496_ _0496_/Q Tile_X0Y1_FrameData[10] VGND VPWR Tile_X0Y1_FrameStrobe[4] latch
XFILLER_97_243 VPWR VGND sg13cmos5l_decap_8
XANTENNA__0826__X Tile_X0Y1_FrameData_O[2] VPWR VGND sg13cmos5l_antennanp
XFILLER_65_140 VPWR VGND sg13cmos5l_fill_1
XFILLER_65_151 VPWR VGND sg13cmos5l_decap_8
X_1117_ _1117_/X Tile_X0Y1_E1END[2] Tile_X0Y1_EE4END[2] Tile_X0Y1_E6END[10] _1205_/X
+ _0572_/Q _0571_/Q VPWR VGND sg13cmos5l_mux4_1
XFILLER_21_243 VPWR VGND sg13cmos5l_decap_8
XFILLER_21_254 VPWR VGND sg13cmos5l_fill_2
XFILLER_80_176 VPWR VGND sg13cmos5l_decap_8
X_1048_ _1048_/X _0637_/Q _0641_/Q _1077_/X _1098_/X _0232_/Q _0231_/Q VPWR VGND sg13cmos5l_mux4_1
XFILLER_0_169 VPWR VGND sg13cmos5l_decap_8
XFILLER_28_54 VPWR VGND sg13cmos5l_fill_2
XFILLER_88_243 VPWR VGND sg13cmos5l_decap_8
XFILLER_95_49 VPWR VGND sg13cmos5l_decap_8
XFILLER_95_38 VPWR VGND sg13cmos5l_decap_8
XANTENNA__0736__X Tile_X0Y0_W2BEGb[5] VPWR VGND sg13cmos5l_antennanp
XFILLER_71_187 VPWR VGND sg13cmos5l_decap_8
XFILLER_100_92 VPWR VGND sg13cmos5l_decap_8
XFILLER_12_254 VPWR VGND sg13cmos5l_decap_4
XFILLER_5_47 VPWR VGND sg13cmos5l_fill_1
X_0350_ _0350_/Q Tile_X0Y1_FrameData[28] VGND VPWR Tile_X0Y1_FrameStrobe[0] latch
XFILLER_47_195 VPWR VGND sg13cmos5l_decap_8
X_0281_ _0281_/Q Tile_X0Y0_FrameData[3] VGND VPWR Tile_X0Y1_FrameStrobe[5] latch
XFILLER_94_235 VPWR VGND sg13cmos5l_decap_8
XFILLER_62_187 VPWR VGND sg13cmos5l_decap_8
XFILLER_116_101 VPWR VGND sg13cmos5l_decap_8
XFILLER_105_15 VPWR VGND sg13cmos5l_decap_8
XFILLER_85_257 VPWR VGND sg13cmos5l_decap_8
X_0617_ NPU_WEIGHT_IN7 Tile_X0Y1_UserCLK _0997_/X _0680_/L_HI VPWR VGND sg13cmos5l_dfrbpq_1
X_0548_ _0548_/Q Tile_X0Y1_FrameData[22] VGND VPWR Tile_X0Y1_FrameStrobe[6] latch
X_0479_ _0479_/Q Tile_X0Y1_FrameData[27] VGND VPWR Tile_X0Y1_FrameStrobe[4] latch
XFILLER_38_173 VPWR VGND sg13cmos5l_decap_8
XFILLER_53_165 VPWR VGND sg13cmos5l_decap_8
XFILLER_100_4 VPWR VGND sg13cmos5l_fill_1
XFILLER_107_178 VPWR VGND sg13cmos5l_decap_8
XFILLER_30_44 VPWR VGND sg13cmos5l_decap_8
XFILLER_30_99 VPWR VGND sg13cmos5l_decap_4
XFILLER_5_239 VPWR VGND sg13cmos5l_decap_8
XFILLER_76_246 VPWR VGND sg13cmos5l_decap_8
XFILLER_113_159 VPWR VGND sg13cmos5l_decap_8
XFILLER_4_261 VPWR VGND sg13cmos5l_fill_1
XFILLER_4_272 VPWR VGND sg13cmos5l_fill_1
XFILLER_67_213 VPWR VGND sg13cmos5l_decap_8
X_0402_ _0402_/Q Tile_X0Y1_FrameData[8] VGND VPWR Tile_X0Y1_FrameStrobe[1] latch
X_0333_ _0333_/Q Tile_X0Y0_FrameData[15] VGND VPWR Tile_X0Y1_FrameStrobe[7] latch
XFILLER_35_132 VPWR VGND sg13cmos5l_fill_2
XFILLER_35_176 VPWR VGND sg13cmos5l_fill_2
XFILLER_82_205 VPWR VGND sg13cmos5l_decap_8
X_0264_ _0264_/Q Tile_X0Y0_FrameData[20] VGND VPWR Tile_X0Y1_FrameStrobe[5] latch
X_0195_ _0195_/Q Tile_X0Y0_FrameData[25] VGND VPWR Tile_X0Y1_FrameStrobe[3] latch
XFILLER_50_157 VPWR VGND sg13cmos5l_fill_2
XFILLER_91_0 VPWR VGND sg13cmos5l_fill_2
XFILLER_112_181 VPWR VGND sg13cmos5l_decap_8
XFILLER_73_205 VPWR VGND sg13cmos5l_decap_8
XFILLER_25_22 VPWR VGND sg13cmos5l_decap_4
XFILLER_26_198 VPWR VGND sg13cmos5l_decap_8
XFILLER_41_157 VPWR VGND sg13cmos5l_decap_8
XFILLER_81_260 VPWR VGND sg13cmos5l_decap_8
XFILLER_81_271 VPWR VGND sg13cmos5l_fill_2
XFILLER_41_98 VPWR VGND sg13cmos5l_decap_8
XFILLER_103_170 VPWR VGND sg13cmos5l_decap_8
XFILLER_1_220 VPWR VGND sg13cmos5l_decap_8
XFILLER_49_202 VPWR VGND sg13cmos5l_decap_8
XFILLER_17_132 VPWR VGND sg13cmos5l_decap_8
XFILLER_64_205 VPWR VGND sg13cmos5l_decap_8
XFILLER_64_238 VPWR VGND sg13cmos5l_decap_8
XANTENNA__0924__X Tile_X0Y1_UserCLKo VPWR VGND sg13cmos5l_antennanp
XFILLER_82_61 VPWR VGND sg13cmos5l_decap_8
X_0882_ Tile_X0Y0_FrameData_O[26] Tile_X0Y0_FrameData[26] VPWR VGND sg13cmos5l_buf_1
X_0951_ Tile_X0Y1_W6BEG[6] _1185_/X VPWR VGND sg13cmos5l_buf_1
XFILLER_55_205 VPWR VGND sg13cmos5l_decap_8
X_0316_ _0316_/Q Tile_X0Y0_FrameData[0] VGND VPWR Tile_X0Y1_FrameStrobe[6] latch
XANTENNA__0834__X Tile_X0Y1_FrameData_O[10] VPWR VGND sg13cmos5l_antennanp
XFILLER_23_135 VPWR VGND sg13cmos5l_decap_4
XFILLER_23_157 VPWR VGND sg13cmos5l_decap_8
XFILLER_63_260 VPWR VGND sg13cmos5l_decap_8
XFILLER_63_271 VPWR VGND sg13cmos5l_fill_2
X_0247_ _0247_/Q Tile_X0Y0_FrameData[5] VGND VPWR Tile_X0Y1_FrameStrobe[4] latch
X_0178_ _0178_/Q Tile_X0Y0_FrameData[10] VGND VPWR Tile_X0Y1_FrameStrobe[2] latch
XFILLER_117_251 VPWR VGND sg13cmos5l_decap_8
XFILLER_11_13 VPWR VGND sg13cmos5l_fill_1
XFILLER_11_68 VPWR VGND sg13cmos5l_decap_4
XFILLER_46_238 VPWR VGND sg13cmos5l_fill_1
XFILLER_54_271 VPWR VGND sg13cmos5l_fill_2
XANTENNA__0744__X Tile_X0Y0_W6BEG[5] VPWR VGND sg13cmos5l_antennanp
XFILLER_14_168 VPWR VGND sg13cmos5l_decap_4
XANTENNA__0919__X Tile_X0Y1_S4BEG[11] VPWR VGND sg13cmos5l_antennanp
X_1150_ _1150_/X Tile_X0Y1_EE4END[4] _0647_/Q _1198_/X _1199_/X _0516_/Q _0515_/Q
+ VPWR VGND sg13cmos5l_mux4_1
X_0101_ _0101_/Q Tile_X0Y0_FrameData[23] VGND VPWR Tile_X0Y1_FrameStrobe[0] latch
XFILLER_96_127 VPWR VGND sg13cmos5l_fill_1
XFILLER_96_116 VPWR VGND sg13cmos5l_decap_8
XFILLER_20_105 VPWR VGND sg13cmos5l_fill_2
XFILLER_45_271 VPWR VGND sg13cmos5l_fill_2
XFILLER_60_230 VPWR VGND sg13cmos5l_decap_8
X_1081_ _1081_/X _1113_/X Tile_X0Y1_N4END[6] Tile_X0Y0_S1END[2] Tile_X0Y0_S4END[2]
+ _0128_/Q _0127_/Q VPWR VGND sg13cmos5l_mux4_1
XFILLER_13_190 VPWR VGND sg13cmos5l_decap_8
X_0865_ Tile_X0Y0_FrameData_O[9] Tile_X0Y0_FrameData[9] VPWR VGND sg13cmos5l_buf_1
X_0934_ Tile_X0Y1_W2BEG[5] _1152_/X VPWR VGND sg13cmos5l_buf_1
XFILLER_9_172 VPWR VGND sg13cmos5l_decap_8
XANTENNA__0829__X Tile_X0Y1_FrameData_O[5] VPWR VGND sg13cmos5l_antennanp
XFILLER_114_254 VPWR VGND sg13cmos5l_decap_8
XFILLER_54_0 VPWR VGND sg13cmos5l_fill_2
X_0796_ Tile_X0Y0_N2BEG[5] _1008_/X VPWR VGND sg13cmos5l_buf_1
XFILLER_113_59 VPWR VGND sg13cmos5l_fill_1
XFILLER_28_216 VPWR VGND sg13cmos5l_decap_8
XFILLER_95_193 VPWR VGND sg13cmos5l_decap_8
XFILLER_11_149 VPWR VGND sg13cmos5l_decap_8
XFILLER_51_230 VPWR VGND sg13cmos5l_decap_8
XFILLER_105_232 VPWR VGND sg13cmos5l_decap_8
XFILLER_22_56 VPWR VGND sg13cmos5l_decap_4
XANTENNA__0739__X Tile_X0Y0_W6BEG[0] VPWR VGND sg13cmos5l_antennanp
XFILLER_19_216 VPWR VGND sg13cmos5l_decap_8
XFILLER_47_42 VPWR VGND sg13cmos5l_decap_8
XFILLER_78_127 VPWR VGND sg13cmos5l_decap_8
XFILLER_86_171 VPWR VGND sg13cmos5l_decap_8
XFILLER_34_208 VPWR VGND sg13cmos5l_decap_8
XFILLER_42_230 VPWR VGND sg13cmos5l_decap_8
XFILLER_47_75 VPWR VGND sg13cmos5l_decap_8
XFILLER_63_52 VPWR VGND sg13cmos5l_decap_8
XFILLER_111_235 VPWR VGND sg13cmos5l_decap_8
XFILLER_6_186 VPWR VGND sg13cmos5l_decap_8
X_0650_ _0650_/Q Tile_X0Y1_UserCLK NPU_ACT_RDATA6 _0658_/L_HI VPWR VGND sg13cmos5l_dfrbpq_1
X_0581_ _0581_/Q Tile_X0Y1_FrameData[21] VGND VPWR Tile_X0Y1_FrameStrobe[7] latch
XFILLER_111_268 VPWR VGND sg13cmos5l_decap_4
XFILLER_25_208 VPWR VGND sg13cmos5l_decap_8
XFILLER_77_182 VPWR VGND sg13cmos5l_decap_8
X_1064_ _1064_/X Tile_X0Y1_N4END[5] Tile_X0Y0_S4END[1] _1081_/X _1077_/X _0200_/Q
+ _0199_/Q VPWR VGND sg13cmos5l_mux4_1
X_1133_ _1133_/X Tile_X0Y1_E1END[2] Tile_X0Y1_E2MID[1] Tile_X0Y1_E2END[1] _1201_/X
+ _0546_/Q _0545_/Q VPWR VGND sg13cmos5l_mux4_1
X_1202_ _1202_/X Tile_X0Y1_N2MID[7] Tile_X0Y1_N2END[7] _1226_/X Tile_X0Y0_S2MID[7]
+ _0356_/Q _0355_/Q VPWR VGND sg13cmos5l_mux4_1
X_0917_ Tile_X0Y1_S4BEG[9] _0917_/A VPWR VGND sg13cmos5l_buf_1
X_0848_ Tile_X0Y1_FrameData_O[24] Tile_X0Y1_FrameData[24] VPWR VGND sg13cmos5l_buf_1
X_0779_ Tile_X0Y0_WW4BEG[12] _1059_/X VPWR VGND sg13cmos5l_buf_1
XFILLER_102_246 VPWR VGND sg13cmos5l_decap_8
XFILLER_68_171 VPWR VGND sg13cmos5l_decap_8
XFILLER_83_174 VPWR VGND sg13cmos5l_decap_8
XFILLER_33_11 VPWR VGND sg13cmos5l_decap_4
XFILLER_33_33 VPWR VGND sg13cmos5l_decap_8
XFILLER_3_101 VPWR VGND sg13cmos5l_decap_8
XFILLER_3_134 VPWR VGND sg13cmos5l_decap_8
XFILLER_3_145 VPWR VGND sg13cmos5l_fill_1
XFILLER_3_178 VPWR VGND sg13cmos5l_decap_8
XFILLER_59_182 VPWR VGND sg13cmos5l_decap_8
XFILLER_74_163 VPWR VGND sg13cmos5l_decap_8
XANTENNA__0932__X Tile_X0Y1_W2BEG[3] VPWR VGND sg13cmos5l_antennanp
XFILLER_74_196 VPWR VGND sg13cmos5l_decap_8
X_0702_ _1234_/A3 VPWR VGND sg13cmos5l_tielo
X_0633_ NPU_ACT_ADDR7 Tile_X0Y1_UserCLK _0980_/X _0688_/L_HI VPWR VGND sg13cmos5l_dfrbpq_1
X_0564_ _0564_/Q Tile_X0Y1_FrameData[6] VGND VPWR Tile_X0Y1_FrameStrobe[6] latch
X_0495_ _0495_/Q Tile_X0Y1_FrameData[11] VGND VPWR Tile_X0Y1_FrameStrobe[4] latch
XFILLER_97_222 VPWR VGND sg13cmos5l_decap_8
XFILLER_0_92 VPWR VGND sg13cmos5l_decap_4
XFILLER_17_0 VPWR VGND sg13cmos5l_fill_2
X_1047_ _1047_/X _0636_/Q _0640_/Q _1079_/X _1099_/X _0234_/Q _0233_/Q VPWR VGND sg13cmos5l_mux4_1
X_1116_ _1116_/X _1210_/X _1214_/X _1218_/X _1198_/X _0569_/Q _0568_/Q VPWR VGND sg13cmos5l_mux4_1
XANTENNA__0842__X Tile_X0Y1_FrameData_O[18] VPWR VGND sg13cmos5l_antennanp
XFILLER_21_222 VPWR VGND sg13cmos5l_decap_8
XFILLER_0_137 VPWR VGND sg13cmos5l_decap_8
XFILLER_28_11 VPWR VGND sg13cmos5l_fill_1
XFILLER_48_108 VPWR VGND sg13cmos5l_fill_2
XANTENNA__0752__X Tile_X0Y0_N4BEG[1] VPWR VGND sg13cmos5l_antennanp
XFILLER_12_233 VPWR VGND sg13cmos5l_decap_8
XFILLER_44_10 VPWR VGND sg13cmos5l_fill_1
XFILLER_44_98 VPWR VGND sg13cmos5l_decap_8
XFILLER_5_15 VPWR VGND sg13cmos5l_decap_8
XFILLER_8_248 VPWR VGND sg13cmos5l_decap_8
XFILLER_79_211 VPWR VGND sg13cmos5l_decap_8
XFILLER_79_266 VPWR VGND sg13cmos5l_decap_8
X_0280_ _0280_/Q Tile_X0Y0_FrameData[4] VGND VPWR Tile_X0Y1_FrameStrobe[5] latch
XFILLER_94_214 VPWR VGND sg13cmos5l_decap_8
XANTENNA__0927__X Tile_X0Y1_W1BEG[2] VPWR VGND sg13cmos5l_antennanp
XFILLER_47_174 VPWR VGND sg13cmos5l_decap_8
XFILLER_62_166 VPWR VGND sg13cmos5l_decap_8
XANTENNA__0611__Q NPU_WEIGHT_IN1 VPWR VGND sg13cmos5l_antennanp
X_0616_ NPU_WEIGHT_IN6 Tile_X0Y1_UserCLK _0996_/X _0679_/L_HI VPWR VGND sg13cmos5l_dfrbpq_1
XANTENNA__0837__X Tile_X0Y1_FrameData_O[13] VPWR VGND sg13cmos5l_antennanp
XFILLER_85_236 VPWR VGND sg13cmos5l_decap_8
X_0547_ _0547_/Q Tile_X0Y1_FrameData[23] VGND VPWR Tile_X0Y1_FrameStrobe[6] latch
X_0478_ _0478_/Q Tile_X0Y1_FrameData[28] VGND VPWR Tile_X0Y1_FrameStrobe[4] latch
XFILLER_5_218 VPWR VGND sg13cmos5l_decap_8
XFILLER_107_157 VPWR VGND sg13cmos5l_decap_8
XFILLER_76_225 VPWR VGND sg13cmos5l_decap_8
XANTENNA__0747__X Tile_X0Y0_W6BEG[8] VPWR VGND sg13cmos5l_antennanp
XFILLER_29_152 VPWR VGND sg13cmos5l_decap_8
XFILLER_39_98 VPWR VGND sg13cmos5l_fill_1
XFILLER_55_42 VPWR VGND sg13cmos5l_decap_8
XFILLER_55_86 VPWR VGND sg13cmos5l_decap_8
XFILLER_91_239 VPWR VGND sg13cmos5l_decap_8
XFILLER_44_188 VPWR VGND sg13cmos5l_decap_8
XFILLER_71_41 VPWR VGND sg13cmos5l_decap_8
XFILLER_71_63 VPWR VGND sg13cmos5l_fill_1
XFILLER_113_138 VPWR VGND sg13cmos5l_decap_8
XFILLER_4_240 VPWR VGND sg13cmos5l_decap_8
XFILLER_106_190 VPWR VGND sg13cmos5l_decap_8
XFILLER_67_269 VPWR VGND sg13cmos5l_decap_4
X_0401_ _0401_/Q Tile_X0Y1_FrameData[9] VGND VPWR Tile_X0Y1_FrameStrobe[1] latch
X_0332_ _0332_/Q Tile_X0Y0_FrameData[16] VGND VPWR Tile_X0Y1_FrameStrobe[7] latch
X_0263_ _0263_/Q Tile_X0Y0_FrameData[21] VGND VPWR Tile_X0Y1_FrameStrobe[5] latch
XFILLER_35_111 VPWR VGND sg13cmos5l_fill_2
X_0194_ _0194_/Q Tile_X0Y0_FrameData[26] VGND VPWR Tile_X0Y1_FrameStrobe[3] latch
XFILLER_50_169 VPWR VGND sg13cmos5l_decap_8
XFILLER_112_160 VPWR VGND sg13cmos5l_decap_8
XFILLER_116_37 VPWR VGND sg13cmos5l_fill_2
XFILLER_58_214 VPWR VGND sg13cmos5l_decap_8
XFILLER_58_225 VPWR VGND sg13cmos5l_fill_1
XFILLER_26_177 VPWR VGND sg13cmos5l_decap_8
XFILLER_17_111 VPWR VGND sg13cmos5l_decap_8
XFILLER_72_272 VPWR VGND sg13cmos5l_fill_1
XANTENNA__0940__X Tile_X0Y1_W2BEGb[3] VPWR VGND sg13cmos5l_antennanp
XFILLER_32_169 VPWR VGND sg13cmos5l_decap_8
X_0881_ Tile_X0Y0_FrameData_O[25] Tile_X0Y0_FrameData[25] VPWR VGND sg13cmos5l_buf_1
X_0950_ Tile_X0Y1_W6BEG[5] _1184_/X VPWR VGND sg13cmos5l_buf_1
X_0315_ _0315_/Q Tile_X0Y0_FrameData[1] VGND VPWR Tile_X0Y1_FrameStrobe[6] latch
X_0246_ _0246_/Q Tile_X0Y0_FrameData[6] VGND VPWR Tile_X0Y1_FrameStrobe[4] latch
X_0177_ _0177_/Q Tile_X0Y0_FrameData[11] VGND VPWR Tile_X0Y1_FrameStrobe[2] latch
XANTENNA__0850__X Tile_X0Y1_FrameData_O[26] VPWR VGND sg13cmos5l_antennanp
XFILLER_109_219 VPWR VGND sg13cmos5l_decap_8
XFILLER_98_180 VPWR VGND sg13cmos5l_decap_8
XFILLER_100_196 VPWR VGND sg13cmos5l_decap_8
XFILLER_14_114 VPWR VGND sg13cmos5l_decap_8
XFILLER_54_261 VPWR VGND sg13cmos5l_fill_1
XANTENNA__0760__X Tile_X0Y0_N4BEG[9] VPWR VGND sg13cmos5l_antennanp
XFILLER_52_87 VPWR VGND sg13cmos5l_decap_8
XFILLER_108_263 VPWR VGND sg13cmos5l_fill_2
XFILLER_117_91 VPWR VGND sg13cmos5l_fill_2
XFILLER_37_206 VPWR VGND sg13cmos5l_decap_8
XFILLER_77_62 VPWR VGND sg13cmos5l_decap_4
XFILLER_89_191 VPWR VGND sg13cmos5l_decap_8
X_1080_ _1080_/X _1114_/X Tile_X0Y1_N4END[7] Tile_X0Y0_S1END[3] Tile_X0Y0_S4END[3]
+ _0126_/Q _0125_/Q VPWR VGND sg13cmos5l_mux4_1
X_0100_ _0100_/Q Tile_X0Y0_FrameData[24] VGND VPWR Tile_X0Y1_FrameStrobe[0] latch
XANTENNA__0935__X Tile_X0Y1_W2BEG[6] VPWR VGND sg13cmos5l_antennanp
X_0864_ Tile_X0Y0_FrameData_O[8] Tile_X0Y0_FrameData[8] VPWR VGND sg13cmos5l_buf_1
X_0933_ Tile_X0Y1_W2BEG[4] _1151_/X VPWR VGND sg13cmos5l_buf_1
X_0795_ Tile_X0Y0_N2BEG[4] _1007_/X VPWR VGND sg13cmos5l_buf_1
XFILLER_114_233 VPWR VGND sg13cmos5l_decap_8
XFILLER_47_0 VPWR VGND sg13cmos5l_decap_8
XANTENNA__0845__X Tile_X0Y1_FrameData_O[21] VPWR VGND sg13cmos5l_antennanp
XFILLER_36_261 VPWR VGND sg13cmos5l_decap_8
XFILLER_36_272 VPWR VGND sg13cmos5l_fill_1
XFILLER_43_209 VPWR VGND sg13cmos5l_decap_8
X_0229_ _0229_/Q Tile_X0Y0_FrameData[23] VGND VPWR Tile_X0Y1_FrameStrobe[4] latch
XFILLER_95_172 VPWR VGND sg13cmos5l_decap_8
XFILLER_11_106 VPWR VGND sg13cmos5l_fill_2
XFILLER_105_211 VPWR VGND sg13cmos5l_decap_8
XFILLER_78_106 VPWR VGND sg13cmos5l_decap_8
XANTENNA__0755__X Tile_X0Y0_N4BEG[4] VPWR VGND sg13cmos5l_antennanp
XFILLER_6_143 VPWR VGND sg13cmos5l_decap_4
XFILLER_6_165 VPWR VGND sg13cmos5l_decap_8
XFILLER_111_225 VPWR VGND sg13cmos5l_decap_4
XFILLER_88_61 VPWR VGND sg13cmos5l_decap_8
XFILLER_88_83 VPWR VGND sg13cmos5l_decap_8
X_1201_ _1201_/X Tile_X0Y1_N2MID[6] Tile_X0Y1_N2END[6] _1225_/X Tile_X0Y0_S2MID[6]
+ _0358_/Q _0357_/Q VPWR VGND sg13cmos5l_mux4_1
X_0580_ _0580_/Q Tile_X0Y1_FrameData[22] VGND VPWR Tile_X0Y1_FrameStrobe[7] latch
XFILLER_18_272 VPWR VGND sg13cmos5l_fill_1
XFILLER_77_161 VPWR VGND sg13cmos5l_decap_8
X_1063_ _1063_/X Tile_X0Y1_N4END[4] Tile_X0Y0_S4END[0] _1080_/X _1079_/X _0202_/Q
+ _0201_/Q VPWR VGND sg13cmos5l_mux4_1
X_1132_ _1132_/X Tile_X0Y1_E1END[1] Tile_X0Y1_E2MID[2] Tile_X0Y1_E2END[2] _1200_/X
+ _0548_/Q _0547_/Q VPWR VGND sg13cmos5l_mux4_1
XFILLER_92_197 VPWR VGND sg13cmos5l_decap_8
XANTENNA__0614__Q NPU_WEIGHT_IN4 VPWR VGND sg13cmos5l_antennanp
XFILLER_33_253 VPWR VGND sg13cmos5l_decap_8
X_0916_ Tile_X0Y1_S4BEG[8] _0916_/A VPWR VGND sg13cmos5l_buf_1
X_0847_ Tile_X0Y1_FrameData_O[23] Tile_X0Y1_FrameData[23] VPWR VGND sg13cmos5l_buf_1
X_0778_ Tile_X0Y0_WW4BEG[11] _1058_/X VPWR VGND sg13cmos5l_buf_1
XFILLER_102_225 VPWR VGND sg13cmos5l_decap_8
XFILLER_68_150 VPWR VGND sg13cmos5l_decap_8
XFILLER_83_120 VPWR VGND sg13cmos5l_decap_8
XFILLER_16_209 VPWR VGND sg13cmos5l_decap_8
XFILLER_83_186 VPWR VGND sg13cmos5l_decap_4
XFILLER_3_157 VPWR VGND sg13cmos5l_decap_8
XFILLER_58_31 VPWR VGND sg13cmos5l_fill_2
XFILLER_59_161 VPWR VGND sg13cmos5l_decap_8
XFILLER_74_85 VPWR VGND sg13cmos5l_decap_8
XFILLER_15_264 VPWR VGND sg13cmos5l_fill_1
XFILLER_30_201 VPWR VGND sg13cmos5l_decap_8
XFILLER_90_62 VPWR VGND sg13cmos5l_fill_1
X_0701_ _1102_/A3 VPWR VGND sg13cmos5l_tielo
X_0632_ NPU_ACT_ADDR6 Tile_X0Y1_UserCLK _0979_/X _0689_/L_HI VPWR VGND sg13cmos5l_dfrbpq_1
X_0563_ _0563_/Q Tile_X0Y1_FrameData[7] VGND VPWR Tile_X0Y1_FrameStrobe[6] latch
XFILLER_97_201 VPWR VGND sg13cmos5l_decap_8
X_0494_ _0494_/Q Tile_X0Y1_FrameData[12] VGND VPWR Tile_X0Y1_FrameStrobe[4] latch
XFILLER_21_201 VPWR VGND sg13cmos5l_decap_8
XFILLER_65_186 VPWR VGND sg13cmos5l_decap_8
XFILLER_80_156 VPWR VGND sg13cmos5l_decap_8
X_1046_ _1046_/X Tile_X0Y0_EE4END[14] _0643_/Q _1092_/X _1099_/X _0236_/Q _0235_/Q
+ VPWR VGND sg13cmos5l_mux4_1
X_1115_ _1115_/X Tile_X0Y1_E1END[3] Tile_X0Y1_EE4END[3] Tile_X0Y1_E6END[11] _1206_/X
+ _0569_/Q _0568_/Q VPWR VGND sg13cmos5l_mux4_1
XFILLER_79_19 VPWR VGND sg13cmos5l_fill_1
XFILLER_88_223 VPWR VGND sg13cmos5l_decap_8
XFILLER_28_56 VPWR VGND sg13cmos5l_fill_1
XFILLER_28_89 VPWR VGND sg13cmos5l_fill_2
XFILLER_56_186 VPWR VGND sg13cmos5l_decap_8
XFILLER_71_123 VPWR VGND sg13cmos5l_decap_8
XFILLER_12_212 VPWR VGND sg13cmos5l_decap_8
XFILLER_44_33 VPWR VGND sg13cmos5l_fill_1
XFILLER_71_145 VPWR VGND sg13cmos5l_decap_4
XFILLER_71_156 VPWR VGND sg13cmos5l_decap_8
XFILLER_8_227 VPWR VGND sg13cmos5l_decap_8
XFILLER_100_83 VPWR VGND sg13cmos5l_fill_1
XFILLER_114_0 VPWR VGND sg13cmos5l_decap_8
XFILLER_79_245 VPWR VGND sg13cmos5l_decap_8
XANTENNA__0943__X Tile_X0Y1_W2BEGb[6] VPWR VGND sg13cmos5l_antennanp
XFILLER_47_153 VPWR VGND sg13cmos5l_decap_8
XFILLER_62_145 VPWR VGND sg13cmos5l_decap_8
XFILLER_116_136 VPWR VGND sg13cmos5l_decap_8
XFILLER_116_169 VPWR VGND sg13cmos5l_decap_8
X_0615_ NPU_WEIGHT_IN5 Tile_X0Y1_UserCLK _0995_/X _0656_/L_HI VPWR VGND sg13cmos5l_dfrbpq_1
X_0546_ _0546_/Q Tile_X0Y1_FrameData[24] VGND VPWR Tile_X0Y1_FrameStrobe[6] latch
XFILLER_105_39 VPWR VGND sg13cmos5l_fill_2
XFILLER_38_142 VPWR VGND sg13cmos5l_decap_4
XFILLER_85_215 VPWR VGND sg13cmos5l_decap_8
X_0477_ _0477_/Q Tile_X0Y1_FrameData[29] VGND VPWR Tile_X0Y1_FrameStrobe[4] latch
XANTENNA__0853__X Tile_X0Y1_FrameData_O[29] VPWR VGND sg13cmos5l_antennanp
XFILLER_14_25 VPWR VGND sg13cmos5l_decap_8
XFILLER_14_58 VPWR VGND sg13cmos5l_decap_8
X_1029_ _1029_/X _1113_/X Tile_X0Y0_S1END[2] _0636_/Q _0641_/Q _0270_/Q _0269_/Q VPWR
+ VGND sg13cmos5l_mux4_1
XFILLER_107_136 VPWR VGND sg13cmos5l_decap_8
XFILLER_30_79 VPWR VGND sg13cmos5l_decap_8
XFILLER_76_204 VPWR VGND sg13cmos5l_decap_8
XANTENNA__0763__X Tile_X0Y0_N4BEG[12] VPWR VGND sg13cmos5l_antennanp
XFILLER_29_186 VPWR VGND sg13cmos5l_decap_8
XFILLER_44_167 VPWR VGND sg13cmos5l_decap_8
XFILLER_55_21 VPWR VGND sg13cmos5l_decap_8
XFILLER_91_229 VPWR VGND sg13cmos5l_decap_4
XFILLER_111_60 VPWR VGND sg13cmos5l_decap_8
XFILLER_111_71 VPWR VGND sg13cmos5l_fill_1
X_0400_ _0400_/Q Tile_X0Y1_FrameData[10] VGND VPWR Tile_X0Y1_FrameStrobe[1] latch
XANTENNA__0938__X Tile_X0Y1_W2BEGb[1] VPWR VGND sg13cmos5l_antennanp
XFILLER_67_248 VPWR VGND sg13cmos5l_decap_8
X_0331_ _0331_/Q Tile_X0Y0_FrameData[17] VGND VPWR Tile_X0Y1_FrameStrobe[7] latch
X_0262_ _0262_/Q Tile_X0Y0_FrameData[22] VGND VPWR Tile_X0Y1_FrameStrobe[5] latch
X_0193_ _0193_/Q Tile_X0Y0_FrameData[27] VGND VPWR Tile_X0Y1_FrameStrobe[3] latch
XFILLER_35_189 VPWR VGND sg13cmos5l_decap_8
XFILLER_90_262 VPWR VGND sg13cmos5l_decap_8
XANTENNA__0622__Q NPU_ACT_WDATA4 VPWR VGND sg13cmos5l_antennanp
XFILLER_77_0 VPWR VGND sg13cmos5l_fill_1
XANTENNA__0848__X Tile_X0Y1_FrameData_O[24] VPWR VGND sg13cmos5l_antennanp
XFILLER_104_106 VPWR VGND sg13cmos5l_decap_4
X_0529_ _0529_/Q Tile_X0Y1_FrameData[9] VGND VPWR Tile_X0Y1_FrameStrobe[5] latch
XANTENNA__0758__X Tile_X0Y0_N4BEG[7] VPWR VGND sg13cmos5l_antennanp
XFILLER_2_39 VPWR VGND sg13cmos5l_decap_8
XFILLER_32_115 VPWR VGND sg13cmos5l_decap_8
XFILLER_32_126 VPWR VGND sg13cmos5l_fill_1
XFILLER_72_251 VPWR VGND sg13cmos5l_decap_8
XFILLER_82_96 VPWR VGND sg13cmos5l_decap_8
X_0880_ Tile_X0Y0_FrameData_O[24] Tile_X0Y0_FrameData[24] VPWR VGND sg13cmos5l_buf_1
XFILLER_49_4 VPWR VGND sg13cmos5l_fill_1
XANTENNA__0617__Q NPU_WEIGHT_IN7 VPWR VGND sg13cmos5l_antennanp
X_0314_ _0314_/Q Tile_X0Y0_FrameData[2] VGND VPWR Tile_X0Y1_FrameStrobe[6] latch
X_0245_ _0245_/Q Tile_X0Y0_FrameData[7] VGND VPWR Tile_X0Y1_FrameStrobe[4] latch
X_0176_ _0176_/Q Tile_X0Y0_FrameData[12] VGND VPWR Tile_X0Y1_FrameStrobe[2] latch
XFILLER_23_126 VPWR VGND sg13cmos5l_fill_2
XFILLER_100_175 VPWR VGND sg13cmos5l_decap_8
XFILLER_46_229 VPWR VGND sg13cmos5l_decap_8
XFILLER_36_34 VPWR VGND sg13cmos5l_decap_8
XFILLER_36_56 VPWR VGND sg13cmos5l_decap_8
XFILLER_54_240 VPWR VGND sg13cmos5l_fill_1
XFILLER_108_242 VPWR VGND sg13cmos5l_decap_8
XFILLER_7_0 VPWR VGND sg13cmos5l_fill_1
XFILLER_89_170 VPWR VGND sg13cmos5l_decap_8
XANTENNA__0951__X Tile_X0Y1_W6BEG[6] VPWR VGND sg13cmos5l_antennanp
XFILLER_60_265 VPWR VGND sg13cmos5l_decap_8
X_0932_ Tile_X0Y1_W2BEG[3] _1150_/X VPWR VGND sg13cmos5l_buf_1
XFILLER_114_212 VPWR VGND sg13cmos5l_decap_8
X_0863_ Tile_X0Y0_FrameData_O[7] Tile_X0Y0_FrameData[7] VPWR VGND sg13cmos5l_buf_1
X_0794_ Tile_X0Y0_N2BEG[3] _1006_/X VPWR VGND sg13cmos5l_buf_1
XFILLER_95_151 VPWR VGND sg13cmos5l_decap_8
XFILLER_36_240 VPWR VGND sg13cmos5l_fill_2
X_0228_ _0228_/Q Tile_X0Y0_FrameData[24] VGND VPWR Tile_X0Y1_FrameStrobe[4] latch
X_0159_ _0159_/Q Tile_X0Y0_FrameData[29] VGND VPWR Tile_X0Y1_FrameStrobe[2] latch
XANTENNA__0861__X Tile_X0Y0_FrameData_O[5] VPWR VGND sg13cmos5l_antennanp
XFILLER_118_7 VPWR VGND sg13cmos5l_decap_4
XFILLER_0_7 VPWR VGND sg13cmos5l_decap_8
XFILLER_105_267 VPWR VGND sg13cmos5l_decap_4
XFILLER_98_29 VPWR VGND sg13cmos5l_decap_8
XANTENNA__0771__X Tile_X0Y0_WW4BEG[4] VPWR VGND sg13cmos5l_antennanp
XFILLER_63_87 VPWR VGND sg13cmos5l_decap_4
XFILLER_63_98 VPWR VGND sg13cmos5l_decap_4
XFILLER_10_140 VPWR VGND sg13cmos5l_fill_2
XFILLER_10_184 VPWR VGND sg13cmos5l_decap_8
XFILLER_6_122 VPWR VGND sg13cmos5l_decap_8
XFILLER_111_204 VPWR VGND sg13cmos5l_decap_8
XFILLER_40_8 VPWR VGND sg13cmos5l_fill_2
XFILLER_69_118 VPWR VGND sg13cmos5l_decap_8
X_1200_ _1200_/X Tile_X0Y1_N2MID[5] Tile_X0Y1_N2END[5] _1224_/X Tile_X0Y0_S2MID[5]
+ _0360_/Q _0359_/Q VPWR VGND sg13cmos5l_mux4_1
XANTENNA__0946__X Tile_X0Y1_W6BEG[1] VPWR VGND sg13cmos5l_antennanp
XFILLER_33_232 VPWR VGND sg13cmos5l_decap_8
X_1062_ _1062_/X _0639_/Q _0643_/Q _1088_/X _1092_/X _0204_/Q _0203_/Q VPWR VGND sg13cmos5l_mux4_1
X_1131_ _1131_/X Tile_X0Y1_E1END[0] Tile_X0Y1_E2MID[3] Tile_X0Y1_E2END[3] _1199_/X
+ _0550_/Q _0549_/Q VPWR VGND sg13cmos5l_mux4_1
XFILLER_92_176 VPWR VGND sg13cmos5l_decap_8
XFILLER_92_143 VPWR VGND sg13cmos5l_fill_1
XFILLER_92_132 VPWR VGND sg13cmos5l_decap_8
X_0915_ Tile_X0Y1_S4BEG[7] Tile_X0Y0_S4END[15] VPWR VGND sg13cmos5l_buf_1
XANTENNA__0630__Q NPU_ACT_ADDR4 VPWR VGND sg13cmos5l_antennanp
XFILLER_102_204 VPWR VGND sg13cmos5l_decap_8
X_0846_ Tile_X0Y1_FrameData_O[22] Tile_X0Y1_FrameData[22] VPWR VGND sg13cmos5l_buf_1
X_0777_ Tile_X0Y0_WW4BEG[10] _1057_/X VPWR VGND sg13cmos5l_buf_1
XANTENNA__0856__X Tile_X0Y0_FrameData_O[0] VPWR VGND sg13cmos5l_antennanp
XFILLER_24_254 VPWR VGND sg13cmos5l_decap_8
XFILLER_58_65 VPWR VGND sg13cmos5l_fill_1
XFILLER_59_140 VPWR VGND sg13cmos5l_decap_8
XANTENNA__0766__X Tile_X0Y0_N4BEG[15] VPWR VGND sg13cmos5l_antennanp
XFILLER_15_243 VPWR VGND sg13cmos5l_decap_8
XFILLER_74_132 VPWR VGND sg13cmos5l_fill_2
XFILLER_23_90 VPWR VGND sg13cmos5l_fill_1
XFILLER_30_235 VPWR VGND sg13cmos5l_decap_8
X_0700_ _1101_/A3 VPWR VGND sg13cmos5l_tielo
X_0631_ NPU_ACT_ADDR5 Tile_X0Y1_UserCLK _0978_/X _0686_/L_HI VPWR VGND sg13cmos5l_dfrbpq_1
X_0562_ _0562_/Q Tile_X0Y1_FrameData[8] VGND VPWR Tile_X0Y1_FrameStrobe[6] latch
XFILLER_65_132 VPWR VGND sg13cmos5l_fill_2
XFILLER_65_165 VPWR VGND sg13cmos5l_decap_8
X_1114_ _1114_/X Tile_X0Y1_E1END[3] Tile_X0Y1_E6END[7] _1218_/X _1194_/X _0596_/Q
+ _0595_/Q VPWR VGND sg13cmos5l_mux4_1
X_0493_ _0493_/Q Tile_X0Y1_FrameData[13] VGND VPWR Tile_X0Y1_FrameStrobe[4] latch
XFILLER_97_257 VPWR VGND sg13cmos5l_decap_8
XANTENNA__0625__Q NPU_ACT_WDATA7 VPWR VGND sg13cmos5l_antennanp
XFILLER_80_135 VPWR VGND sg13cmos5l_decap_8
X_1045_ _1045_/X Tile_X0Y0_EE4END[13] _0642_/Q _1093_/X _1098_/X _0238_/Q _0237_/Q
+ VPWR VGND sg13cmos5l_mux4_1
X_0829_ Tile_X0Y1_FrameData_O[5] Tile_X0Y1_FrameData[5] VPWR VGND sg13cmos5l_buf_1
XFILLER_0_106 VPWR VGND sg13cmos5l_decap_4
XFILLER_88_202 VPWR VGND sg13cmos5l_decap_4
XFILLER_88_257 VPWR VGND sg13cmos5l_decap_8
XFILLER_28_35 VPWR VGND sg13cmos5l_fill_2
XFILLER_56_165 VPWR VGND sg13cmos5l_decap_8
XFILLER_100_62 VPWR VGND sg13cmos5l_decap_8
XFILLER_12_268 VPWR VGND sg13cmos5l_decap_4
XFILLER_60_11 VPWR VGND sg13cmos5l_fill_1
XFILLER_60_33 VPWR VGND sg13cmos5l_decap_8
XFILLER_60_44 VPWR VGND sg13cmos5l_fill_2
XFILLER_8_206 VPWR VGND sg13cmos5l_decap_8
XFILLER_107_0 VPWR VGND sg13cmos5l_fill_2
XFILLER_109_93 VPWR VGND sg13cmos5l_decap_8
XFILLER_47_132 VPWR VGND sg13cmos5l_decap_8
XFILLER_94_249 VPWR VGND sg13cmos5l_decap_8
XFILLER_18_90 VPWR VGND sg13cmos5l_fill_2
XFILLER_62_124 VPWR VGND sg13cmos5l_decap_8
XFILLER_70_190 VPWR VGND sg13cmos5l_decap_8
XFILLER_85_96 VPWR VGND sg13cmos5l_decap_8
XFILLER_116_115 VPWR VGND sg13cmos5l_decap_8
XFILLER_79_4 VPWR VGND sg13cmos5l_fill_1
XFILLER_7_272 VPWR VGND sg13cmos5l_fill_1
XFILLER_116_148 VPWR VGND sg13cmos5l_decap_8
XFILLER_22_0 VPWR VGND sg13cmos5l_fill_2
X_0614_ NPU_WEIGHT_IN4 Tile_X0Y1_UserCLK _0994_/X _0653_/L_HI VPWR VGND sg13cmos5l_dfrbpq_1
X_0545_ _0545_/Q Tile_X0Y1_FrameData[25] VGND VPWR Tile_X0Y1_FrameStrobe[6] latch
X_0476_ _0476_/Q Tile_X0Y1_FrameData[30] VGND VPWR Tile_X0Y1_FrameStrobe[4] latch
XFILLER_38_121 VPWR VGND sg13cmos5l_decap_8
XFILLER_38_187 VPWR VGND sg13cmos5l_decap_8
XFILLER_93_271 VPWR VGND sg13cmos5l_fill_2
XFILLER_53_179 VPWR VGND sg13cmos5l_decap_8
X_1028_ _1028_/X _1112_/X Tile_X0Y0_S1END[1] _0639_/Q _0642_/Q _0272_/Q _0271_/Q VPWR
+ VGND sg13cmos5l_mux4_1
XANTENNA__0090__Q NPU_XBAR_SEL0 VPWR VGND sg13cmos5l_antennanp
XFILLER_107_115 VPWR VGND sg13cmos5l_fill_2
XFILLER_91_208 VPWR VGND sg13cmos5l_decap_8
XFILLER_44_146 VPWR VGND sg13cmos5l_decap_8
X_0330_ _0330_/Q Tile_X0Y0_FrameData[18] VGND VPWR Tile_X0Y1_FrameStrobe[7] latch
XFILLER_96_40 VPWR VGND sg13cmos5l_fill_2
XANTENNA__0954__X Tile_X0Y1_W6BEG[9] VPWR VGND sg13cmos5l_antennanp
XFILLER_67_227 VPWR VGND sg13cmos5l_decap_8
XFILLER_82_219 VPWR VGND sg13cmos5l_decap_8
X_0261_ _0261_/Q Tile_X0Y0_FrameData[23] VGND VPWR Tile_X0Y1_FrameStrobe[5] latch
X_0192_ _0192_/Q Tile_X0Y0_FrameData[28] VGND VPWR Tile_X0Y1_FrameStrobe[3] latch
XFILLER_96_95 VPWR VGND sg13cmos5l_decap_8
XFILLER_90_241 VPWR VGND sg13cmos5l_decap_8
XFILLER_6_71 VPWR VGND sg13cmos5l_decap_4
XFILLER_112_195 VPWR VGND sg13cmos5l_decap_8
XFILLER_116_28 VPWR VGND sg13cmos5l_fill_1
X_0528_ _0528_/Q Tile_X0Y1_FrameData[10] VGND VPWR Tile_X0Y1_FrameStrobe[5] latch
X_0459_ _0459_/Q Tile_X0Y1_FrameData[15] VGND VPWR Tile_X0Y1_FrameStrobe[3] latch
XANTENNA__0864__X Tile_X0Y0_FrameData_O[8] VPWR VGND sg13cmos5l_antennanp
XFILLER_41_105 VPWR VGND sg13cmos5l_decap_4
XFILLER_41_138 VPWR VGND sg13cmos5l_fill_1
XFILLER_73_219 VPWR VGND sg13cmos5l_decap_8
XFILLER_1_234 VPWR VGND sg13cmos5l_decap_8
XANTENNA__0774__X Tile_X0Y0_WW4BEG[7] VPWR VGND sg13cmos5l_antennanp
XFILLER_103_184 VPWR VGND sg13cmos5l_decap_8
XFILLER_49_216 VPWR VGND sg13cmos5l_decap_8
XFILLER_49_227 VPWR VGND sg13cmos5l_fill_2
XFILLER_57_271 VPWR VGND sg13cmos5l_fill_2
XFILLER_64_219 VPWR VGND sg13cmos5l_decap_8
XFILLER_72_230 VPWR VGND sg13cmos5l_decap_8
XFILLER_17_157 VPWR VGND sg13cmos5l_decap_8
XFILLER_82_75 VPWR VGND sg13cmos5l_fill_2
XFILLER_31_90 VPWR VGND sg13cmos5l_decap_8
XFILLER_40_182 VPWR VGND sg13cmos5l_decap_8
XANTENNA__0949__X Tile_X0Y1_W6BEG[4] VPWR VGND sg13cmos5l_antennanp
X_0313_ _0313_/Q Tile_X0Y0_FrameData[3] VGND VPWR Tile_X0Y1_FrameStrobe[6] latch
XFILLER_99_149 VPWR VGND sg13cmos5l_decap_8
XFILLER_48_271 VPWR VGND sg13cmos5l_fill_2
XFILLER_55_219 VPWR VGND sg13cmos5l_decap_8
X_0244_ _0244_/Q Tile_X0Y0_FrameData[8] VGND VPWR Tile_X0Y1_FrameStrobe[4] latch
X_0175_ _0175_/Q Tile_X0Y0_FrameData[13] VGND VPWR Tile_X0Y1_FrameStrobe[2] latch
XANTENNA__0633__Q NPU_ACT_ADDR7 VPWR VGND sg13cmos5l_antennanp
XFILLER_31_193 VPWR VGND sg13cmos5l_decap_8
XANTENNA__0859__X Tile_X0Y0_FrameData_O[3] VPWR VGND sg13cmos5l_antennanp
XFILLER_117_265 VPWR VGND sg13cmos5l_decap_8
XFILLER_11_49 VPWR VGND sg13cmos5l_decap_4
XFILLER_100_132 VPWR VGND sg13cmos5l_fill_1
XFILLER_39_260 VPWR VGND sg13cmos5l_decap_8
XFILLER_39_271 VPWR VGND sg13cmos5l_fill_2
XFILLER_46_208 VPWR VGND sg13cmos5l_decap_8
XFILLER_14_127 VPWR VGND sg13cmos5l_decap_8
XFILLER_52_12 VPWR VGND sg13cmos5l_fill_1
XFILLER_54_252 VPWR VGND sg13cmos5l_decap_8
XFILLER_108_221 VPWR VGND sg13cmos5l_decap_8
XFILLER_22_193 VPWR VGND sg13cmos5l_decap_8
XANTENNA__0769__X Tile_X0Y0_WW4BEG[2] VPWR VGND sg13cmos5l_antennanp
XFILLER_77_97 VPWR VGND sg13cmos5l_decap_8
XFILLER_93_63 VPWR VGND sg13cmos5l_decap_8
XFILLER_60_244 VPWR VGND sg13cmos5l_decap_8
X_0862_ Tile_X0Y0_FrameData_O[6] Tile_X0Y0_FrameData[6] VPWR VGND sg13cmos5l_buf_1
X_0931_ Tile_X0Y1_W2BEG[2] _1149_/X VPWR VGND sg13cmos5l_buf_1
XFILLER_114_268 VPWR VGND sg13cmos5l_decap_4
X_0793_ Tile_X0Y0_N2BEG[2] _1005_/X VPWR VGND sg13cmos5l_buf_1
XFILLER_9_186 VPWR VGND sg13cmos5l_decap_8
XANTENNA__0628__Q NPU_ACT_ADDR2 VPWR VGND sg13cmos5l_antennanp
XFILLER_3_94 VPWR VGND sg13cmos5l_decap_8
XFILLER_11_108 VPWR VGND sg13cmos5l_fill_1
XFILLER_51_244 VPWR VGND sg13cmos5l_decap_8
X_0227_ _0227_/Q Tile_X0Y0_FrameData[25] VGND VPWR Tile_X0Y1_FrameStrobe[4] latch
X_0158_ _0158_/Q Tile_X0Y0_FrameData[30] VGND VPWR Tile_X0Y1_FrameStrobe[2] latch
X_0089_ NPU_ACT_WE Tile_X0Y1_UserCLK _0089_/D _0697_/L_HI VPWR VGND sg13cmos5l_dfrbpq_1
XFILLER_22_15 VPWR VGND sg13cmos5l_decap_4
XFILLER_22_26 VPWR VGND sg13cmos5l_fill_2
XFILLER_105_246 VPWR VGND sg13cmos5l_decap_8
XFILLER_27_241 VPWR VGND sg13cmos5l_decap_4
XFILLER_47_56 VPWR VGND sg13cmos5l_decap_4
XFILLER_47_89 VPWR VGND sg13cmos5l_decap_8
XFILLER_86_152 VPWR VGND sg13cmos5l_decap_8
XFILLER_86_185 VPWR VGND sg13cmos5l_decap_8
XFILLER_42_244 VPWR VGND sg13cmos5l_decap_8
XFILLER_6_101 VPWR VGND sg13cmos5l_fill_1
XFILLER_10_163 VPWR VGND sg13cmos5l_decap_8
XFILLER_111_249 VPWR VGND sg13cmos5l_decap_8
XFILLER_77_196 VPWR VGND sg13cmos5l_decap_8
X_1130_ _1130_/X Tile_X0Y1_E2MID[4] Tile_X0Y1_E2END[4] Tile_X0Y1_E6END[11] _1198_/X
+ _0552_/Q _0551_/Q VPWR VGND sg13cmos5l_mux4_1
XFILLER_92_122 VPWR VGND sg13cmos5l_fill_2
XANTENNA__0962__X Tile_X0Y1_WW4BEG[5] VPWR VGND sg13cmos5l_antennanp
XFILLER_18_263 VPWR VGND sg13cmos5l_fill_2
XFILLER_33_211 VPWR VGND sg13cmos5l_decap_8
X_1061_ _1061_/X _0638_/Q _0642_/Q _1089_/X _1093_/X _0206_/Q _0205_/Q VPWR VGND sg13cmos5l_mux4_1
XFILLER_92_155 VPWR VGND sg13cmos5l_decap_8
X_0914_ Tile_X0Y1_S4BEG[6] Tile_X0Y0_S4END[14] VPWR VGND sg13cmos5l_buf_1
X_0845_ Tile_X0Y1_FrameData_O[21] Tile_X0Y1_FrameData[21] VPWR VGND sg13cmos5l_buf_1
XFILLER_52_0 VPWR VGND sg13cmos5l_decap_4
X_0776_ Tile_X0Y0_WW4BEG[9] _1056_/X VPWR VGND sg13cmos5l_buf_1
XFILLER_110_271 VPWR VGND sg13cmos5l_fill_2
XFILLER_68_185 VPWR VGND sg13cmos5l_decap_8
XFILLER_83_155 VPWR VGND sg13cmos5l_fill_2
XANTENNA__0093__Q NPU_XBAR_SEL3 VPWR VGND sg13cmos5l_antennanp
XANTENNA__0872__X Tile_X0Y0_FrameData_O[16] VPWR VGND sg13cmos5l_antennanp
XFILLER_24_233 VPWR VGND sg13cmos5l_decap_8
XFILLER_3_115 VPWR VGND sg13cmos5l_decap_8
XFILLER_114_61 VPWR VGND sg13cmos5l_fill_1
XFILLER_59_196 VPWR VGND sg13cmos5l_decap_8
XANTENNA__0782__X Tile_X0Y0_WW4BEG[15] VPWR VGND sg13cmos5l_antennanp
XFILLER_15_222 VPWR VGND sg13cmos5l_decap_8
XFILLER_74_177 VPWR VGND sg13cmos5l_decap_4
XFILLER_74_43 VPWR VGND sg13cmos5l_decap_8
XFILLER_2_181 VPWR VGND sg13cmos5l_fill_2
X_0630_ NPU_ACT_ADDR4 Tile_X0Y1_UserCLK _0977_/X _0687_/L_HI VPWR VGND sg13cmos5l_dfrbpq_1
X_0561_ _0561_/Q Tile_X0Y1_FrameData[9] VGND VPWR Tile_X0Y1_FrameStrobe[6] latch
X_0492_ _0492_/Q Tile_X0Y1_FrameData[14] VGND VPWR Tile_X0Y1_FrameStrobe[4] latch
XFILLER_97_236 VPWR VGND sg13cmos5l_decap_8
XANTENNA__0957__X Tile_X0Y1_WW4BEG[0] VPWR VGND sg13cmos5l_antennanp
XFILLER_0_51 VPWR VGND sg13cmos5l_fill_1
XFILLER_65_144 VPWR VGND sg13cmos5l_decap_8
X_1044_ _1044_/X Tile_X0Y0_EE4END[12] _0641_/Q _1094_/X _1097_/X _0240_/Q _0239_/Q
+ VPWR VGND sg13cmos5l_mux4_1
X_1113_ _1113_/X Tile_X0Y1_E1END[2] Tile_X0Y1_E6END[6] _1217_/X _1193_/X _0598_/Q
+ _0597_/Q VPWR VGND sg13cmos5l_mux4_1
XFILLER_21_236 VPWR VGND sg13cmos5l_decap_8
XFILLER_80_169 VPWR VGND sg13cmos5l_decap_8
X_0828_ Tile_X0Y1_FrameData_O[4] Tile_X0Y1_FrameData[4] VPWR VGND sg13cmos5l_buf_1
X_0759_ Tile_X0Y0_N4BEG[8] _0759_/A VPWR VGND sg13cmos5l_buf_1
XANTENNA__0867__X Tile_X0Y0_FrameData_O[11] VPWR VGND sg13cmos5l_antennanp
XFILLER_28_47 VPWR VGND sg13cmos5l_decap_8
XFILLER_100_30 VPWR VGND sg13cmos5l_decap_8
XFILLER_12_247 VPWR VGND sg13cmos5l_decap_8
XFILLER_12_258 VPWR VGND sg13cmos5l_fill_2
XFILLER_60_67 VPWR VGND sg13cmos5l_fill_1
XFILLER_60_89 VPWR VGND sg13cmos5l_fill_1
XFILLER_109_61 VPWR VGND sg13cmos5l_decap_8
XFILLER_69_65 VPWR VGND sg13cmos5l_fill_2
XFILLER_79_225 VPWR VGND sg13cmos5l_fill_2
XANTENNA__0777__X Tile_X0Y0_WW4BEG[10] VPWR VGND sg13cmos5l_antennanp
XFILLER_47_188 VPWR VGND sg13cmos5l_decap_8
XFILLER_85_64 VPWR VGND sg13cmos5l_decap_4
XFILLER_94_228 VPWR VGND sg13cmos5l_decap_8
XFILLER_7_251 VPWR VGND sg13cmos5l_decap_8
X_0613_ NPU_WEIGHT_IN3 Tile_X0Y1_UserCLK _0993_/X _0694_/L_HI VPWR VGND sg13cmos5l_dfrbpq_1
X_0544_ _0544_/Q Tile_X0Y1_FrameData[26] VGND VPWR Tile_X0Y1_FrameStrobe[6] latch
X_0475_ _0475_/Q Tile_X0Y1_FrameData[31] VGND VPWR Tile_X0Y1_FrameStrobe[4] latch
XFILLER_15_0 VPWR VGND sg13cmos5l_fill_2
XFILLER_53_158 VPWR VGND sg13cmos5l_decap_8
X_1027_ _1027_/X _1111_/X Tile_X0Y0_S1END[0] _0638_/Q _0643_/Q _0274_/Q _0273_/Q VPWR
+ VGND sg13cmos5l_mux4_1
XFILLER_93_250 VPWR VGND sg13cmos5l_decap_8
XFILLER_100_8 VPWR VGND sg13cmos5l_fill_1
XFILLER_115_193 VPWR VGND sg13cmos5l_decap_8
XFILLER_29_122 VPWR VGND sg13cmos5l_fill_2
XFILLER_29_166 VPWR VGND sg13cmos5l_fill_2
XFILLER_76_239 VPWR VGND sg13cmos5l_decap_8
XFILLER_84_272 VPWR VGND sg13cmos5l_fill_1
XFILLER_55_56 VPWR VGND sg13cmos5l_fill_2
XFILLER_4_254 VPWR VGND sg13cmos5l_decap_8
XFILLER_67_206 VPWR VGND sg13cmos5l_decap_8
X_0260_ _0260_/Q Tile_X0Y0_FrameData[24] VGND VPWR Tile_X0Y1_FrameStrobe[5] latch
XFILLER_35_103 VPWR VGND sg13cmos5l_fill_1
XFILLER_35_169 VPWR VGND sg13cmos5l_decap_8
XFILLER_75_261 VPWR VGND sg13cmos5l_decap_8
XFILLER_75_272 VPWR VGND sg13cmos5l_fill_1
X_0191_ _0191_/Q Tile_X0Y0_FrameData[29] VGND VPWR Tile_X0Y1_FrameStrobe[3] latch
XFILLER_90_220 VPWR VGND sg13cmos5l_decap_8
XANTENNA__0970__X Tile_X0Y1_WW4BEG[13] VPWR VGND sg13cmos5l_antennanp
XFILLER_112_174 VPWR VGND sg13cmos5l_decap_8
X_0527_ _0527_/Q Tile_X0Y1_FrameData[11] VGND VPWR Tile_X0Y1_FrameStrobe[5] latch
X_0458_ _0458_/Q Tile_X0Y1_FrameData[16] VGND VPWR Tile_X0Y1_FrameStrobe[3] latch
X_0389_ _0389_/Q Tile_X0Y1_FrameData[21] VGND VPWR Tile_X0Y1_FrameStrobe[1] latch
XFILLER_25_15 VPWR VGND sg13cmos5l_decap_8
XFILLER_81_253 VPWR VGND sg13cmos5l_decap_8
XANTENNA__0880__X Tile_X0Y0_FrameData_O[24] VPWR VGND sg13cmos5l_antennanp
XFILLER_41_14 VPWR VGND sg13cmos5l_fill_2
XFILLER_103_163 VPWR VGND sg13cmos5l_decap_8
XFILLER_1_213 VPWR VGND sg13cmos5l_decap_8
XFILLER_17_125 VPWR VGND sg13cmos5l_decap_8
XFILLER_82_21 VPWR VGND sg13cmos5l_decap_4
XANTENNA__0790__X Tile_X0Y0_N2BEGb[7] VPWR VGND sg13cmos5l_antennanp
XFILLER_15_92 VPWR VGND sg13cmos5l_decap_8
XFILLER_25_180 VPWR VGND sg13cmos5l_decap_8
XFILLER_40_161 VPWR VGND sg13cmos5l_decap_8
XFILLER_82_54 VPWR VGND sg13cmos5l_decap_8
XFILLER_31_80 VPWR VGND sg13cmos5l_fill_2
XFILLER_56_7 VPWR VGND sg13cmos5l_decap_8
XFILLER_99_106 VPWR VGND sg13cmos5l_decap_4
XANTENNA__0965__X Tile_X0Y1_WW4BEG[8] VPWR VGND sg13cmos5l_antennanp
XFILLER_48_250 VPWR VGND sg13cmos5l_decap_8
XFILLER_48_261 VPWR VGND sg13cmos5l_fill_1
X_0312_ _0312_/Q Tile_X0Y0_FrameData[4] VGND VPWR Tile_X0Y1_FrameStrobe[6] latch
X_0243_ _0243_/Q Tile_X0Y0_FrameData[9] VGND VPWR Tile_X0Y1_FrameStrobe[4] latch
XFILLER_63_253 VPWR VGND sg13cmos5l_decap_8
X_0174_ _0174_/Q Tile_X0Y0_FrameData[14] VGND VPWR Tile_X0Y1_FrameStrobe[2] latch
XFILLER_117_222 VPWR VGND sg13cmos5l_decap_4
XFILLER_31_172 VPWR VGND sg13cmos5l_decap_8
XFILLER_82_0 VPWR VGND sg13cmos5l_fill_2
XANTENNA__0875__X Tile_X0Y0_FrameData_O[19] VPWR VGND sg13cmos5l_antennanp
XFILLER_98_194 VPWR VGND sg13cmos5l_decap_8
XFILLER_22_150 VPWR VGND sg13cmos5l_fill_1
XFILLER_22_172 VPWR VGND sg13cmos5l_decap_8
XFILLER_52_24 VPWR VGND sg13cmos5l_decap_4
XFILLER_52_57 VPWR VGND sg13cmos5l_fill_2
XFILLER_108_200 VPWR VGND sg13cmos5l_decap_8
XANTENNA__0785__X Tile_X0Y0_N2BEGb[2] VPWR VGND sg13cmos5l_antennanp
XFILLER_96_109 VPWR VGND sg13cmos5l_decap_8
XFILLER_45_220 VPWR VGND sg13cmos5l_decap_8
XFILLER_45_231 VPWR VGND sg13cmos5l_fill_2
XFILLER_45_264 VPWR VGND sg13cmos5l_decap_8
XFILLER_60_223 VPWR VGND sg13cmos5l_decap_8
XFILLER_93_20 VPWR VGND sg13cmos5l_fill_1
XFILLER_13_183 VPWR VGND sg13cmos5l_decap_8
X_0861_ Tile_X0Y0_FrameData_O[5] Tile_X0Y0_FrameData[5] VPWR VGND sg13cmos5l_buf_1
X_0930_ Tile_X0Y1_W2BEG[1] _1148_/X VPWR VGND sg13cmos5l_buf_1
X_0792_ Tile_X0Y0_N2BEG[1] _1004_/X VPWR VGND sg13cmos5l_buf_1
XFILLER_9_165 VPWR VGND sg13cmos5l_decap_8
XFILLER_114_247 VPWR VGND sg13cmos5l_decap_8
XFILLER_28_209 VPWR VGND sg13cmos5l_decap_8
XFILLER_36_242 VPWR VGND sg13cmos5l_fill_1
X_0226_ _0226_/Q Tile_X0Y0_FrameData[26] VGND VPWR Tile_X0Y1_FrameStrobe[4] latch
XFILLER_95_186 VPWR VGND sg13cmos5l_decap_8
X_0157_ _0157_/Q Tile_X0Y0_FrameData[31] VGND VPWR Tile_X0Y1_FrameStrobe[2] latch
X_0088_ _0093_/D _0998_/X _0609_/Q VPWR VGND sg13cmos5l_or2_1
XFILLER_105_225 VPWR VGND sg13cmos5l_decap_8
XFILLER_19_209 VPWR VGND sg13cmos5l_decap_8
XFILLER_47_35 VPWR VGND sg13cmos5l_decap_8
XFILLER_86_164 VPWR VGND sg13cmos5l_decap_8
XFILLER_103_30 VPWR VGND sg13cmos5l_decap_8
XFILLER_27_220 VPWR VGND sg13cmos5l_decap_8
XFILLER_42_223 VPWR VGND sg13cmos5l_decap_8
XFILLER_47_68 VPWR VGND sg13cmos5l_decap_8
XFILLER_63_45 VPWR VGND sg13cmos5l_decap_8
XFILLER_8_29 VPWR VGND sg13cmos5l_decap_4
XFILLER_12_71 VPWR VGND sg13cmos5l_decap_8
XFILLER_6_179 VPWR VGND sg13cmos5l_decap_8
XFILLER_88_75 VPWR VGND sg13cmos5l_fill_1
XFILLER_88_97 VPWR VGND sg13cmos5l_fill_2
XFILLER_18_242 VPWR VGND sg13cmos5l_decap_8
XFILLER_77_142 VPWR VGND sg13cmos5l_fill_1
XFILLER_77_175 VPWR VGND sg13cmos5l_decap_8
X_1060_ _1060_/X _0637_/Q _0641_/Q _1090_/X _1094_/X _0208_/Q _0207_/Q VPWR VGND sg13cmos5l_mux4_1
XFILLER_92_101 VPWR VGND sg13cmos5l_decap_8
XFILLER_33_267 VPWR VGND sg13cmos5l_decap_4
X_0913_ Tile_X0Y1_S4BEG[5] Tile_X0Y0_S4END[13] VPWR VGND sg13cmos5l_buf_1
X_0844_ Tile_X0Y1_FrameData_O[20] Tile_X0Y1_FrameData[20] VPWR VGND sg13cmos5l_buf_1
X_0775_ Tile_X0Y0_WW4BEG[8] _1055_/X VPWR VGND sg13cmos5l_buf_1
XFILLER_102_239 VPWR VGND sg13cmos5l_decap_8
XFILLER_110_250 VPWR VGND sg13cmos5l_decap_8
XFILLER_5_190 VPWR VGND sg13cmos5l_decap_8
XFILLER_68_164 VPWR VGND sg13cmos5l_decap_8
XFILLER_17_27 VPWR VGND sg13cmos5l_decap_4
XFILLER_24_212 VPWR VGND sg13cmos5l_decap_8
XFILLER_83_112 VPWR VGND sg13cmos5l_fill_1
XFILLER_83_167 VPWR VGND sg13cmos5l_decap_8
X_1189_ _1189_/X _0646_/Q _1204_/X _1208_/X _1201_/X _0438_/Q _0437_/Q VPWR VGND sg13cmos5l_mux4_1
X_0209_ _0209_/Q Tile_X0Y0_FrameData[11] VGND VPWR Tile_X0Y1_FrameStrobe[3] latch
XFILLER_33_26 VPWR VGND sg13cmos5l_decap_8
XFILLER_3_127 VPWR VGND sg13cmos5l_decap_8
XFILLER_101_272 VPWR VGND sg13cmos5l_fill_1
XFILLER_59_175 VPWR VGND sg13cmos5l_decap_8
XFILLER_74_134 VPWR VGND sg13cmos5l_fill_1
XFILLER_74_189 VPWR VGND sg13cmos5l_decap_8
XFILLER_74_99 VPWR VGND sg13cmos5l_decap_8
XFILLER_90_43 VPWR VGND sg13cmos5l_decap_4
XFILLER_99_63 VPWR VGND sg13cmos5l_fill_1
XFILLER_2_160 VPWR VGND sg13cmos5l_decap_8
X_0560_ _0560_/Q Tile_X0Y1_FrameData[10] VGND VPWR Tile_X0Y1_FrameStrobe[6] latch
X_0491_ _0491_/Q Tile_X0Y1_FrameData[15] VGND VPWR Tile_X0Y1_FrameStrobe[4] latch
XFILLER_97_215 VPWR VGND sg13cmos5l_decap_8
XFILLER_0_41 VPWR VGND sg13cmos5l_decap_8
XFILLER_0_85 VPWR VGND sg13cmos5l_decap_8
XFILLER_0_96 VPWR VGND sg13cmos5l_fill_1
XFILLER_80_126 VPWR VGND sg13cmos5l_fill_2
X_1043_ _1043_/X Tile_X0Y0_EE4END[11] _0640_/Q _1095_/X _1096_/X _0242_/Q _0241_/Q
+ VPWR VGND sg13cmos5l_mux4_1
X_1112_ _1112_/X Tile_X0Y1_E1END[1] Tile_X0Y1_E6END[5] _1216_/X _1192_/X _0600_/Q
+ _0599_/Q VPWR VGND sg13cmos5l_mux4_1
XFILLER_21_215 VPWR VGND sg13cmos5l_decap_8
X_0827_ Tile_X0Y1_FrameData_O[3] Tile_X0Y1_FrameData[3] VPWR VGND sg13cmos5l_buf_1
X_0758_ Tile_X0Y0_N4BEG[7] Tile_X0Y1_N4END[15] VPWR VGND sg13cmos5l_buf_1
XFILLER_28_37 VPWR VGND sg13cmos5l_fill_1
XFILLER_88_237 VPWR VGND sg13cmos5l_fill_2
X_0689_ _0689_/L_HI VPWR VGND sg13cmos5l_tiehi
XANTENNA__0883__X Tile_X0Y0_FrameData_O[27] VPWR VGND sg13cmos5l_antennanp
XFILLER_12_226 VPWR VGND sg13cmos5l_decap_8
XFILLER_44_69 VPWR VGND sg13cmos5l_fill_1
XFILLER_69_88 VPWR VGND sg13cmos5l_fill_2
XFILLER_79_204 VPWR VGND sg13cmos5l_decap_8
XFILLER_79_259 VPWR VGND sg13cmos5l_decap_8
XFILLER_94_207 VPWR VGND sg13cmos5l_decap_8
XANTENNA__0793__X Tile_X0Y0_N2BEG[2] VPWR VGND sg13cmos5l_antennanp
XFILLER_18_92 VPWR VGND sg13cmos5l_fill_1
XFILLER_47_167 VPWR VGND sg13cmos5l_decap_8
XFILLER_34_91 VPWR VGND sg13cmos5l_decap_8
XFILLER_62_159 VPWR VGND sg13cmos5l_decap_8
XANTENNA__0968__X Tile_X0Y1_WW4BEG[11] VPWR VGND sg13cmos5l_antennanp
XFILLER_109_191 VPWR VGND sg13cmos5l_decap_8
XFILLER_11_270 VPWR VGND sg13cmos5l_fill_2
XFILLER_7_230 VPWR VGND sg13cmos5l_decap_8
X_0612_ NPU_WEIGHT_IN2 Tile_X0Y1_UserCLK _0992_/X _0695_/L_HI VPWR VGND sg13cmos5l_dfrbpq_1
XFILLER_85_229 VPWR VGND sg13cmos5l_decap_8
X_0543_ _0543_/Q Tile_X0Y1_FrameData[27] VGND VPWR Tile_X0Y1_FrameStrobe[6] latch
X_0474_ _0474_/Q Tile_X0Y1_FrameData[0] VGND VPWR Tile_X0Y1_FrameStrobe[3] latch
X_1026_ _1026_/X _1084_/X _1080_/X _1079_/X _1099_/X _0277_/Q _0276_/Q VPWR VGND sg13cmos5l_mux4_1
XFILLER_107_117 VPWR VGND sg13cmos5l_fill_1
XANTENNA__0878__X Tile_X0Y0_FrameData_O[22] VPWR VGND sg13cmos5l_antennanp
XFILLER_115_172 VPWR VGND sg13cmos5l_decap_8
XFILLER_29_145 VPWR VGND sg13cmos5l_decap_8
XFILLER_55_35 VPWR VGND sg13cmos5l_decap_8
XFILLER_76_218 VPWR VGND sg13cmos5l_decap_8
XFILLER_84_251 VPWR VGND sg13cmos5l_decap_8
XFILLER_55_79 VPWR VGND sg13cmos5l_decap_8
XFILLER_71_34 VPWR VGND sg13cmos5l_decap_8
XFILLER_71_78 VPWR VGND sg13cmos5l_decap_4
XFILLER_71_89 VPWR VGND sg13cmos5l_decap_4
XFILLER_112_0 VPWR VGND sg13cmos5l_fill_2
XFILLER_20_60 VPWR VGND sg13cmos5l_decap_4
XFILLER_4_233 VPWR VGND sg13cmos5l_decap_8
XANTENNA__0788__X Tile_X0Y0_N2BEGb[5] VPWR VGND sg13cmos5l_antennanp
XFILLER_106_183 VPWR VGND sg13cmos5l_decap_8
XFILLER_96_53 VPWR VGND sg13cmos5l_decap_8
XFILLER_75_240 VPWR VGND sg13cmos5l_decap_8
X_0190_ _0190_/Q Tile_X0Y0_FrameData[30] VGND VPWR Tile_X0Y1_FrameStrobe[3] latch
XFILLER_43_181 VPWR VGND sg13cmos5l_decap_8
X_0526_ _0526_/Q Tile_X0Y1_FrameData[12] VGND VPWR Tile_X0Y1_FrameStrobe[5] latch
XFILLER_112_153 VPWR VGND sg13cmos5l_decap_8
XFILLER_58_207 VPWR VGND sg13cmos5l_decap_8
XFILLER_66_262 VPWR VGND sg13cmos5l_decap_8
XFILLER_81_210 VPWR VGND sg13cmos5l_decap_8
X_0457_ _0457_/Q Tile_X0Y1_FrameData[17] VGND VPWR Tile_X0Y1_FrameStrobe[3] latch
X_0388_ _0388_/Q Tile_X0Y1_FrameData[22] VGND VPWR Tile_X0Y1_FrameStrobe[1] latch
X_1009_ _1009_/X Tile_X0Y0_E2MID[1] Tile_X0Y0_E2END[1] Tile_X0Y0_E6END[1] _1098_/X
+ _0326_/Q _0325_/Q VPWR VGND sg13cmos5l_mux4_1
XFILLER_41_59 VPWR VGND sg13cmos5l_decap_4
XFILLER_103_120 VPWR VGND sg13cmos5l_decap_4
XFILLER_106_63 VPWR VGND sg13cmos5l_fill_2
XFILLER_1_247 VPWR VGND sg13cmos5l_fill_2
XFILLER_17_104 VPWR VGND sg13cmos5l_decap_8
XFILLER_72_265 VPWR VGND sg13cmos5l_decap_8
XFILLER_15_60 VPWR VGND sg13cmos5l_decap_4
XFILLER_82_77 VPWR VGND sg13cmos5l_fill_1
X_0311_ _0311_/Q Tile_X0Y0_FrameData[5] VGND VPWR Tile_X0Y1_FrameStrobe[6] latch
X_0242_ _0242_/Q Tile_X0Y0_FrameData[10] VGND VPWR Tile_X0Y1_FrameStrobe[4] latch
X_0173_ _0173_/Q Tile_X0Y0_FrameData[15] VGND VPWR Tile_X0Y1_FrameStrobe[2] latch
XFILLER_31_151 VPWR VGND sg13cmos5l_decap_8
XFILLER_63_232 VPWR VGND sg13cmos5l_decap_8
XFILLER_117_201 VPWR VGND sg13cmos5l_decap_8
XFILLER_75_0 VPWR VGND sg13cmos5l_decap_8
X_0509_ _0509_/Q Tile_X0Y1_FrameData[29] VGND VPWR Tile_X0Y1_FrameStrobe[5] latch
XFILLER_98_173 VPWR VGND sg13cmos5l_decap_8
XFILLER_100_189 VPWR VGND sg13cmos5l_decap_8
XFILLER_36_48 VPWR VGND sg13cmos5l_fill_1
XANTENNA__0891__X Tile_X0Y1_S1BEG[3] VPWR VGND sg13cmos5l_antennanp
XFILLER_108_256 VPWR VGND sg13cmos5l_decap_8
XFILLER_77_22 VPWR VGND sg13cmos5l_decap_8
XFILLER_89_184 VPWR VGND sg13cmos5l_fill_2
XFILLER_13_140 VPWR VGND sg13cmos5l_fill_1
XFILLER_26_81 VPWR VGND sg13cmos5l_decap_4
XFILLER_60_202 VPWR VGND sg13cmos5l_decap_8
X_0860_ Tile_X0Y0_FrameData_O[4] Tile_X0Y0_FrameData[4] VPWR VGND sg13cmos5l_buf_1
X_0791_ Tile_X0Y0_N2BEG[0] _1003_/X VPWR VGND sg13cmos5l_buf_1
XFILLER_114_226 VPWR VGND sg13cmos5l_decap_8
XFILLER_36_254 VPWR VGND sg13cmos5l_decap_8
X_0225_ _0225_/Q Tile_X0Y0_FrameData[27] VGND VPWR Tile_X0Y1_FrameStrobe[4] latch
X_0156_ _0156_/Q Tile_X0Y0_FrameData[0] VGND VPWR Tile_X0Y1_FrameStrobe[1] latch
XFILLER_95_165 VPWR VGND sg13cmos5l_decap_8
XFILLER_51_268 VPWR VGND sg13cmos5l_decap_4
X_0087_ _0089_/D _0604_/Q _1235_/X VPWR VGND sg13cmos5l_nor2b_1
XFILLER_105_204 VPWR VGND sg13cmos5l_decap_8
X_0989_ _0989_/X Tile_X0Y1_EE4END[7] Tile_X0Y1_EE4END[15] Tile_X0Y1_E6END[7] _1210_/X
+ _0420_/Q _0419_/Q VPWR VGND sg13cmos5l_mux4_1
XANTENNA__0886__X Tile_X0Y0_FrameData_O[30] VPWR VGND sg13cmos5l_antennanp
XFILLER_47_14 VPWR VGND sg13cmos5l_decap_8
XFILLER_42_202 VPWR VGND sg13cmos5l_decap_8
XFILLER_42_268 VPWR VGND sg13cmos5l_decap_4
XFILLER_10_198 VPWR VGND sg13cmos5l_decap_8
XFILLER_6_136 VPWR VGND sg13cmos5l_decap_8
XFILLER_6_158 VPWR VGND sg13cmos5l_decap_8
XANTENNA__0796__X Tile_X0Y0_N2BEG[5] VPWR VGND sg13cmos5l_antennanp
XFILLER_111_218 VPWR VGND sg13cmos5l_decap_8
XFILLER_111_229 VPWR VGND sg13cmos5l_fill_2
XFILLER_5_0 VPWR VGND sg13cmos5l_fill_2
XFILLER_77_121 VPWR VGND sg13cmos5l_decap_8
XFILLER_88_54 VPWR VGND sg13cmos5l_decap_8
XFILLER_18_221 VPWR VGND sg13cmos5l_decap_8
XFILLER_77_154 VPWR VGND sg13cmos5l_decap_8
XFILLER_92_124 VPWR VGND sg13cmos5l_fill_1
XFILLER_33_246 VPWR VGND sg13cmos5l_decap_8
X_0912_ Tile_X0Y1_S4BEG[4] Tile_X0Y0_S4END[12] VPWR VGND sg13cmos5l_buf_1
X_0843_ Tile_X0Y1_FrameData_O[19] Tile_X0Y1_FrameData[19] VPWR VGND sg13cmos5l_buf_1
X_0774_ Tile_X0Y0_WW4BEG[7] _1054_/X VPWR VGND sg13cmos5l_buf_1
XFILLER_102_218 VPWR VGND sg13cmos5l_decap_8
XFILLER_38_0 VPWR VGND sg13cmos5l_fill_1
XFILLER_24_268 VPWR VGND sg13cmos5l_decap_4
X_1188_ _1188_/X _0645_/Q _1205_/X _1209_/X _1200_/X _0440_/Q _0439_/Q VPWR VGND sg13cmos5l_mux4_1
X_0208_ _0208_/Q Tile_X0Y0_FrameData[12] VGND VPWR Tile_X0Y1_FrameStrobe[3] latch
X_0139_ _0139_/Q Tile_X0Y0_FrameData[17] VGND VPWR Tile_X0Y1_FrameStrobe[1] latch
XFILLER_116_7 VPWR VGND sg13cmos5l_fill_2
XFILLER_101_251 VPWR VGND sg13cmos5l_decap_8
XFILLER_114_41 VPWR VGND sg13cmos5l_decap_8
XFILLER_114_52 VPWR VGND sg13cmos5l_decap_8
XFILLER_59_154 VPWR VGND sg13cmos5l_decap_8
XFILLER_74_113 VPWR VGND sg13cmos5l_fill_2
XFILLER_15_257 VPWR VGND sg13cmos5l_decap_8
XFILLER_15_268 VPWR VGND sg13cmos5l_decap_4
XFILLER_74_78 VPWR VGND sg13cmos5l_decap_8
XFILLER_90_77 VPWR VGND sg13cmos5l_decap_4
XFILLER_90_55 VPWR VGND sg13cmos5l_decap_8
XFILLER_2_183 VPWR VGND sg13cmos5l_fill_1
X_0490_ _0490_/Q Tile_X0Y1_FrameData[16] VGND VPWR Tile_X0Y1_FrameStrobe[4] latch
XFILLER_0_31 VPWR VGND sg13cmos5l_fill_2
XFILLER_65_179 VPWR VGND sg13cmos5l_decap_8
XFILLER_80_149 VPWR VGND sg13cmos5l_decap_8
X_1042_ _1042_/X Tile_X0Y0_EE4END[10] _0639_/Q _1095_/X _1096_/X _0244_/Q _0243_/Q
+ VPWR VGND sg13cmos5l_mux4_1
X_1111_ _1111_/X Tile_X0Y1_E1END[0] Tile_X0Y1_E6END[4] _1215_/X _1191_/X _0602_/Q
+ _0601_/Q VPWR VGND sg13cmos5l_mux4_1
XFILLER_88_216 VPWR VGND sg13cmos5l_decap_8
X_0826_ Tile_X0Y1_FrameData_O[2] Tile_X0Y1_FrameData[2] VPWR VGND sg13cmos5l_buf_1
X_0757_ Tile_X0Y0_N4BEG[6] Tile_X0Y1_N4END[14] VPWR VGND sg13cmos5l_buf_1
X_0688_ _0688_/L_HI VPWR VGND sg13cmos5l_tiehi
XFILLER_56_179 VPWR VGND sg13cmos5l_decap_8
XFILLER_12_205 VPWR VGND sg13cmos5l_decap_8
XFILLER_44_15 VPWR VGND sg13cmos5l_decap_4
XFILLER_44_26 VPWR VGND sg13cmos5l_decap_8
XFILLER_71_138 VPWR VGND sg13cmos5l_decap_8
XFILLER_100_76 VPWR VGND sg13cmos5l_decap_8
XFILLER_118_192 VPWR VGND sg13cmos5l_decap_8
XFILLER_79_238 VPWR VGND sg13cmos5l_decap_8
XFILLER_47_146 VPWR VGND sg13cmos5l_decap_8
XFILLER_62_138 VPWR VGND sg13cmos5l_decap_8
XFILLER_109_170 VPWR VGND sg13cmos5l_decap_8
XFILLER_116_129 VPWR VGND sg13cmos5l_decap_8
X_0611_ NPU_WEIGHT_IN1 Tile_X0Y1_UserCLK _0991_/X _0696_/L_HI VPWR VGND sg13cmos5l_dfrbpq_1
X_0542_ _0542_/Q Tile_X0Y1_FrameData[28] VGND VPWR Tile_X0Y1_FrameStrobe[6] latch
XFILLER_38_102 VPWR VGND sg13cmos5l_fill_1
XFILLER_38_135 VPWR VGND sg13cmos5l_decap_8
XFILLER_85_208 VPWR VGND sg13cmos5l_decap_8
X_0473_ _0473_/Q Tile_X0Y1_FrameData[1] VGND VPWR Tile_X0Y1_FrameStrobe[3] latch
XFILLER_61_193 VPWR VGND sg13cmos5l_decap_8
X_1025_ _1025_/X Tile_X0Y0_E1END[3] Tile_X0Y0_EE4END[15] Tile_X0Y0_E6END[7] _1091_/X
+ _0277_/Q _0276_/Q VPWR VGND sg13cmos5l_mux4_1
XFILLER_107_129 VPWR VGND sg13cmos5l_decap_8
X_0809_ Tile_X0Y0_FrameStrobe_O[6] Tile_X0Y1_FrameStrobe[6] VPWR VGND sg13cmos5l_buf_1
XFILLER_115_151 VPWR VGND sg13cmos5l_decap_8
XFILLER_39_15 VPWR VGND sg13cmos5l_decap_4
XFILLER_69_271 VPWR VGND sg13cmos5l_fill_2
XANTENNA__0894__X Tile_X0Y1_S2BEG[2] VPWR VGND sg13cmos5l_antennanp
XFILLER_29_179 VPWR VGND sg13cmos5l_decap_8
XFILLER_44_105 VPWR VGND sg13cmos5l_decap_4
XFILLER_55_14 VPWR VGND sg13cmos5l_decap_8
XFILLER_84_230 VPWR VGND sg13cmos5l_decap_8
XFILLER_111_42 VPWR VGND sg13cmos5l_decap_8
XFILLER_52_182 VPWR VGND sg13cmos5l_decap_8
XFILLER_105_0 VPWR VGND sg13cmos5l_fill_2
XFILLER_106_162 VPWR VGND sg13cmos5l_decap_8
XFILLER_20_72 VPWR VGND sg13cmos5l_fill_1
XFILLER_4_212 VPWR VGND sg13cmos5l_decap_8
XFILLER_43_160 VPWR VGND sg13cmos5l_decap_8
XFILLER_90_255 VPWR VGND sg13cmos5l_decap_8
XANTENNA_1 NPU_OUT_ACT2 VPWR VGND sg13cmos5l_antennanp
XFILLER_112_110 VPWR VGND sg13cmos5l_decap_8
XFILLER_112_132 VPWR VGND sg13cmos5l_decap_8
XFILLER_6_63 VPWR VGND sg13cmos5l_fill_1
X_0525_ _0525_/Q Tile_X0Y1_FrameData[13] VGND VPWR Tile_X0Y1_FrameStrobe[5] latch
X_0456_ _0456_/Q Tile_X0Y1_FrameData[18] VGND VPWR Tile_X0Y1_FrameStrobe[3] latch
XFILLER_20_0 VPWR VGND sg13cmos5l_decap_4
XFILLER_26_149 VPWR VGND sg13cmos5l_fill_1
XFILLER_66_241 VPWR VGND sg13cmos5l_decap_8
XFILLER_81_233 VPWR VGND sg13cmos5l_fill_2
X_0387_ _0387_/Q Tile_X0Y1_FrameData[23] VGND VPWR Tile_X0Y1_FrameStrobe[1] latch
X_1008_ _1008_/X Tile_X0Y0_E2MID[2] Tile_X0Y0_E2END[2] Tile_X0Y0_E6END[2] _1097_/X
+ _0328_/Q _0327_/Q VPWR VGND sg13cmos5l_mux4_1
XANTENNA__0889__X Tile_X0Y1_S1BEG[1] VPWR VGND sg13cmos5l_antennanp
XFILLER_103_198 VPWR VGND sg13cmos5l_decap_8
XFILLER_106_31 VPWR VGND sg13cmos5l_decap_8
XFILLER_66_35 VPWR VGND sg13cmos5l_decap_8
XFILLER_72_244 VPWR VGND sg13cmos5l_decap_8
XFILLER_82_89 VPWR VGND sg13cmos5l_decap_8
XFILLER_40_196 VPWR VGND sg13cmos5l_decap_8
XANTENNA__0799__X Tile_X0Y0_N1BEG[0] VPWR VGND sg13cmos5l_antennanp
XFILLER_31_82 VPWR VGND sg13cmos5l_fill_1
X_0310_ _0310_/Q Tile_X0Y0_FrameData[6] VGND VPWR Tile_X0Y1_FrameStrobe[6] latch
XFILLER_63_211 VPWR VGND sg13cmos5l_decap_8
X_0241_ _0241_/Q Tile_X0Y0_FrameData[11] VGND VPWR Tile_X0Y1_FrameStrobe[4] latch
X_0172_ _0172_/Q Tile_X0Y0_FrameData[16] VGND VPWR Tile_X0Y1_FrameStrobe[2] latch
XFILLER_16_171 VPWR VGND sg13cmos5l_decap_8
XFILLER_16_182 VPWR VGND sg13cmos5l_fill_2
XFILLER_23_119 VPWR VGND sg13cmos5l_decap_8
XFILLER_100_168 VPWR VGND sg13cmos5l_decap_8
X_0508_ _0508_/Q Tile_X0Y1_FrameData[30] VGND VPWR Tile_X0Y1_FrameStrobe[5] latch
X_0439_ _0439_/Q Tile_X0Y1_FrameData[3] VGND VPWR Tile_X0Y1_FrameStrobe[2] latch
XFILLER_98_152 VPWR VGND sg13cmos5l_decap_8
XFILLER_54_211 VPWR VGND sg13cmos5l_decap_8
XFILLER_108_235 VPWR VGND sg13cmos5l_decap_8
XFILLER_108_268 VPWR VGND sg13cmos5l_decap_4
XFILLER_117_52 VPWR VGND sg13cmos5l_fill_1
XFILLER_117_63 VPWR VGND sg13cmos5l_decap_8
XFILLER_89_163 VPWR VGND sg13cmos5l_decap_8
XFILLER_93_11 VPWR VGND sg13cmos5l_decap_8
XFILLER_60_258 VPWR VGND sg13cmos5l_decap_8
XFILLER_114_205 VPWR VGND sg13cmos5l_decap_8
X_0790_ Tile_X0Y0_N2BEGb[7] _1110_/X VPWR VGND sg13cmos5l_buf_1
XFILLER_36_233 VPWR VGND sg13cmos5l_decap_8
X_0224_ _0224_/Q Tile_X0Y0_FrameData[28] VGND VPWR Tile_X0Y1_FrameStrobe[4] latch
X_0155_ _0155_/Q Tile_X0Y0_FrameData[1] VGND VPWR Tile_X0Y1_FrameStrobe[1] latch
X_0086_ _0917_/A _1021_/X _1022_/X _0281_/Q VPWR VGND sg13cmos5l_mux2_1
XFILLER_51_258 VPWR VGND sg13cmos5l_decap_8
X_0988_ _0988_/X Tile_X0Y1_EE4END[6] Tile_X0Y1_EE4END[14] Tile_X0Y1_E6END[6] _1209_/X
+ _0422_/Q _0421_/Q VPWR VGND sg13cmos5l_mux4_1
XFILLER_86_122 VPWR VGND sg13cmos5l_fill_2
XFILLER_86_199 VPWR VGND sg13cmos5l_decap_8
XFILLER_103_65 VPWR VGND sg13cmos5l_decap_4
XFILLER_42_258 VPWR VGND sg13cmos5l_decap_8
XFILLER_10_177 VPWR VGND sg13cmos5l_decap_8
XFILLER_6_115 VPWR VGND sg13cmos5l_decap_8
XFILLER_104_271 VPWR VGND sg13cmos5l_fill_2
XFILLER_77_111 VPWR VGND sg13cmos5l_fill_2
XFILLER_18_200 VPWR VGND sg13cmos5l_decap_8
XFILLER_19_9 VPWR VGND sg13cmos5l_decap_8
XFILLER_33_225 VPWR VGND sg13cmos5l_decap_8
XFILLER_37_70 VPWR VGND sg13cmos5l_decap_8
XFILLER_92_169 VPWR VGND sg13cmos5l_decap_8
X_0911_ Tile_X0Y1_S4BEG[3] Tile_X0Y0_S4END[11] VPWR VGND sg13cmos5l_buf_1
X_0842_ Tile_X0Y1_FrameData_O[18] Tile_X0Y1_FrameData[18] VPWR VGND sg13cmos5l_buf_1
X_0773_ Tile_X0Y0_WW4BEG[6] _1053_/X VPWR VGND sg13cmos5l_buf_1
XFILLER_68_100 VPWR VGND sg13cmos5l_decap_8
XFILLER_68_199 VPWR VGND sg13cmos5l_decap_8
XFILLER_24_247 VPWR VGND sg13cmos5l_decap_8
X_1187_ _1187_/X _0644_/Q _1206_/X _1210_/X _1199_/X _0442_/Q _0441_/Q VPWR VGND sg13cmos5l_mux4_1
X_0207_ _0207_/Q Tile_X0Y0_FrameData[13] VGND VPWR Tile_X0Y1_FrameStrobe[3] latch
X_0138_ _0138_/Q Tile_X0Y0_FrameData[18] VGND VPWR Tile_X0Y1_FrameStrobe[1] latch
X_0069_ _0919_/A _1025_/X _1026_/X _0275_/Q VPWR VGND sg13cmos5l_mux2_1
XFILLER_91_180 VPWR VGND sg13cmos5l_decap_8
XANTENNA__0897__X Tile_X0Y1_S2BEG[5] VPWR VGND sg13cmos5l_antennanp
XFILLER_101_230 VPWR VGND sg13cmos5l_decap_8
XFILLER_58_58 VPWR VGND sg13cmos5l_decap_8
XFILLER_59_133 VPWR VGND sg13cmos5l_decap_8
XFILLER_15_236 VPWR VGND sg13cmos5l_decap_8
XFILLER_82_191 VPWR VGND sg13cmos5l_decap_8
XFILLER_31_8 VPWR VGND sg13cmos5l_decap_8
X_1110_ _1110_/X Tile_X0Y1_E2MID[0] Tile_X0Y1_E2END[0] Tile_X0Y1_E6END[0] _1202_/X
+ _0580_/Q _0579_/Q VPWR VGND sg13cmos5l_mux4_1
XFILLER_0_21 VPWR VGND sg13cmos5l_decap_4
XFILLER_65_158 VPWR VGND sg13cmos5l_decap_8
XFILLER_73_191 VPWR VGND sg13cmos5l_decap_8
X_1041_ _1041_/X Tile_X0Y0_EE4END[9] _0638_/Q _1094_/X _1097_/X _0246_/Q _0245_/Q
+ VPWR VGND sg13cmos5l_mux4_1
X_0825_ Tile_X0Y1_FrameData_O[1] Tile_X0Y1_FrameData[1] VPWR VGND sg13cmos5l_buf_1
XFILLER_9_85 VPWR VGND sg13cmos5l_decap_4
X_0756_ Tile_X0Y0_N4BEG[5] Tile_X0Y1_N4END[13] VPWR VGND sg13cmos5l_buf_1
X_0687_ _0687_/L_HI VPWR VGND sg13cmos5l_tiehi
XFILLER_28_28 VPWR VGND sg13cmos5l_decap_8
XFILLER_56_125 VPWR VGND sg13cmos5l_fill_2
XFILLER_56_158 VPWR VGND sg13cmos5l_decap_8
XFILLER_100_44 VPWR VGND sg13cmos5l_decap_8
XFILLER_100_55 VPWR VGND sg13cmos5l_decap_8
XFILLER_20_250 VPWR VGND sg13cmos5l_decap_8
XFILLER_60_26 VPWR VGND sg13cmos5l_decap_8
XFILLER_64_191 VPWR VGND sg13cmos5l_decap_8
XFILLER_100_99 VPWR VGND sg13cmos5l_fill_1
XFILLER_109_42 VPWR VGND sg13cmos5l_decap_8
XFILLER_109_53 VPWR VGND sg13cmos5l_fill_1
XFILLER_109_86 VPWR VGND sg13cmos5l_decap_8
XFILLER_118_171 VPWR VGND sg13cmos5l_decap_8
XFILLER_20_272 VPWR VGND sg13cmos5l_fill_1
XFILLER_85_12 VPWR VGND sg13cmos5l_fill_2
XFILLER_87_261 VPWR VGND sg13cmos5l_decap_8
XFILLER_87_272 VPWR VGND sg13cmos5l_fill_1
XFILLER_18_83 VPWR VGND sg13cmos5l_decap_8
XFILLER_55_191 VPWR VGND sg13cmos5l_decap_8
XFILLER_116_108 VPWR VGND sg13cmos5l_decap_8
XFILLER_11_272 VPWR VGND sg13cmos5l_fill_1
XFILLER_70_183 VPWR VGND sg13cmos5l_decap_8
XFILLER_79_8 VPWR VGND sg13cmos5l_decap_8
X_0610_ NPU_WEIGHT_IN0 Tile_X0Y1_UserCLK _0990_/X _0693_/L_HI VPWR VGND sg13cmos5l_dfrbpq_1
X_0541_ _0541_/Q Tile_X0Y1_FrameData[29] VGND VPWR Tile_X0Y1_FrameStrobe[6] latch
X_0472_ _0472_/Q Tile_X0Y1_FrameData[2] VGND VPWR Tile_X0Y1_FrameStrobe[3] latch
XFILLER_38_114 VPWR VGND sg13cmos5l_decap_8
X_1024_ _1024_/X _1085_/X _1081_/X _1077_/X _1098_/X _0280_/Q _0279_/Q VPWR VGND sg13cmos5l_mux4_1
XFILLER_93_264 VPWR VGND sg13cmos5l_decap_8
XFILLER_46_180 VPWR VGND sg13cmos5l_decap_8
XFILLER_61_172 VPWR VGND sg13cmos5l_decap_8
XFILLER_98_0 VPWR VGND sg13cmos5l_fill_2
X_0808_ Tile_X0Y0_FrameStrobe_O[5] Tile_X0Y1_FrameStrobe[5] VPWR VGND sg13cmos5l_buf_1
XFILLER_69_250 VPWR VGND sg13cmos5l_decap_8
X_0739_ Tile_X0Y0_W6BEG[0] _1063_/X VPWR VGND sg13cmos5l_buf_1
XFILLER_111_21 VPWR VGND sg13cmos5l_decap_8
XFILLER_52_161 VPWR VGND sg13cmos5l_decap_8
XFILLER_106_141 VPWR VGND sg13cmos5l_decap_8
XFILLER_4_268 VPWR VGND sg13cmos5l_decap_4
XFILLER_29_93 VPWR VGND sg13cmos5l_decap_4
XFILLER_35_117 VPWR VGND sg13cmos5l_fill_1
XFILLER_45_70 VPWR VGND sg13cmos5l_decap_8
XFILLER_90_234 VPWR VGND sg13cmos5l_decap_8
XANTENNA_2 NPU_OUT_ACT3 VPWR VGND sg13cmos5l_antennanp
XFILLER_112_188 VPWR VGND sg13cmos5l_decap_8
XFILLER_66_220 VPWR VGND sg13cmos5l_decap_8
X_0524_ _0524_/Q Tile_X0Y1_FrameData[14] VGND VPWR Tile_X0Y1_FrameStrobe[5] latch
X_0455_ _0455_/Q Tile_X0Y1_FrameData[19] VGND VPWR Tile_X0Y1_FrameStrobe[3] latch
XFILLER_13_0 VPWR VGND sg13cmos5l_decap_4
XFILLER_34_150 VPWR VGND sg13cmos5l_decap_8
XFILLER_41_109 VPWR VGND sg13cmos5l_fill_1
XFILLER_81_267 VPWR VGND sg13cmos5l_decap_4
X_1007_ _1007_/X Tile_X0Y0_E2MID[3] Tile_X0Y0_E2END[3] Tile_X0Y0_E6END[3] _1096_/X
+ _0330_/Q _0329_/Q VPWR VGND sg13cmos5l_mux4_1
X_0386_ _0386_/Q Tile_X0Y1_FrameData[24] VGND VPWR Tile_X0Y1_FrameStrobe[1] latch
XFILLER_34_194 VPWR VGND sg13cmos5l_decap_8
XFILLER_1_227 VPWR VGND sg13cmos5l_decap_8
XFILLER_1_249 VPWR VGND sg13cmos5l_fill_1
XFILLER_103_177 VPWR VGND sg13cmos5l_decap_8
XFILLER_49_209 VPWR VGND sg13cmos5l_decap_8
XFILLER_66_14 VPWR VGND sg13cmos5l_decap_8
XFILLER_17_139 VPWR VGND sg13cmos5l_decap_8
XFILLER_25_194 VPWR VGND sg13cmos5l_decap_8
XFILLER_72_223 VPWR VGND sg13cmos5l_decap_8
XFILLER_82_68 VPWR VGND sg13cmos5l_decap_8
XFILLER_40_175 VPWR VGND sg13cmos5l_decap_8
X_0240_ _0240_/Q Tile_X0Y0_FrameData[12] VGND VPWR Tile_X0Y1_FrameStrobe[4] latch
XFILLER_63_267 VPWR VGND sg13cmos5l_decap_4
X_0171_ _0171_/Q Tile_X0Y0_FrameData[17] VGND VPWR Tile_X0Y1_FrameStrobe[2] latch
XFILLER_31_186 VPWR VGND sg13cmos5l_decap_8
XFILLER_72_90 VPWR VGND sg13cmos5l_decap_8
XFILLER_117_258 VPWR VGND sg13cmos5l_decap_8
XFILLER_98_131 VPWR VGND sg13cmos5l_decap_8
XFILLER_100_103 VPWR VGND sg13cmos5l_decap_4
XFILLER_39_253 VPWR VGND sg13cmos5l_decap_8
X_0507_ _0507_/Q Tile_X0Y1_FrameData[31] VGND VPWR Tile_X0Y1_FrameStrobe[5] latch
X_0438_ _0438_/Q Tile_X0Y1_FrameData[4] VGND VPWR Tile_X0Y1_FrameStrobe[2] latch
X_0369_ _0369_/Q Tile_X0Y1_FrameData[9] VGND VPWR Tile_X0Y1_FrameStrobe[0] latch
XFILLER_54_245 VPWR VGND sg13cmos5l_decap_8
XFILLER_108_214 VPWR VGND sg13cmos5l_decap_8
XFILLER_22_186 VPWR VGND sg13cmos5l_decap_8
XFILLER_89_131 VPWR VGND sg13cmos5l_decap_4
XFILLER_89_142 VPWR VGND sg13cmos5l_decap_8
XFILLER_89_186 VPWR VGND sg13cmos5l_fill_1
XFILLER_26_50 VPWR VGND sg13cmos5l_fill_1
XFILLER_13_131 VPWR VGND sg13cmos5l_decap_8
XFILLER_13_197 VPWR VGND sg13cmos5l_decap_8
XFILLER_60_237 VPWR VGND sg13cmos5l_fill_2
XFILLER_42_82 VPWR VGND sg13cmos5l_decap_8
XFILLER_9_179 VPWR VGND sg13cmos5l_decap_8
XFILLER_3_10 VPWR VGND sg13cmos5l_fill_1
XFILLER_3_32 VPWR VGND sg13cmos5l_decap_4
XFILLER_3_87 VPWR VGND sg13cmos5l_decap_8
X_0223_ _0223_/Q Tile_X0Y0_FrameData[29] VGND VPWR Tile_X0Y1_FrameStrobe[4] latch
XFILLER_36_212 VPWR VGND sg13cmos5l_decap_8
XFILLER_51_237 VPWR VGND sg13cmos5l_decap_8
X_0154_ _0154_/Q Tile_X0Y0_FrameData[2] VGND VPWR Tile_X0Y1_FrameStrobe[1] latch
X_0085_ _0765_/A _1015_/X _1016_/X _0314_/Q VPWR VGND sg13cmos5l_mux2_1
X_0987_ _0987_/X Tile_X0Y1_EE4END[5] Tile_X0Y1_EE4END[13] Tile_X0Y1_E6END[5] _1208_/X
+ _0424_/Q _0423_/Q VPWR VGND sg13cmos5l_mux4_1
XFILLER_105_239 VPWR VGND sg13cmos5l_decap_8
XFILLER_113_250 VPWR VGND sg13cmos5l_decap_8
XFILLER_113_272 VPWR VGND sg13cmos5l_fill_1
XFILLER_27_234 VPWR VGND sg13cmos5l_decap_8
XFILLER_27_245 VPWR VGND sg13cmos5l_fill_1
XFILLER_47_49 VPWR VGND sg13cmos5l_decap_8
XFILLER_86_178 VPWR VGND sg13cmos5l_decap_8
XFILLER_10_123 VPWR VGND sg13cmos5l_fill_2
XFILLER_42_237 VPWR VGND sg13cmos5l_decap_8
XFILLER_63_59 VPWR VGND sg13cmos5l_fill_2
XFILLER_10_156 VPWR VGND sg13cmos5l_decap_8
XFILLER_77_189 VPWR VGND sg13cmos5l_decap_8
XFILLER_92_115 VPWR VGND sg13cmos5l_decap_8
XFILLER_18_256 VPWR VGND sg13cmos5l_fill_2
XFILLER_33_204 VPWR VGND sg13cmos5l_decap_8
XFILLER_92_148 VPWR VGND sg13cmos5l_decap_8
X_0910_ Tile_X0Y1_S4BEG[2] Tile_X0Y0_S4END[10] VPWR VGND sg13cmos5l_buf_1
X_0841_ Tile_X0Y1_FrameData_O[17] Tile_X0Y1_FrameData[17] VPWR VGND sg13cmos5l_buf_1
X_0772_ Tile_X0Y0_WW4BEG[5] _1052_/X VPWR VGND sg13cmos5l_buf_1
XFILLER_52_4 VPWR VGND sg13cmos5l_fill_1
XFILLER_110_264 VPWR VGND sg13cmos5l_decap_8
XFILLER_68_123 VPWR VGND sg13cmos5l_decap_4
XFILLER_68_178 VPWR VGND sg13cmos5l_decap_8
X_1186_ _1186_/X _0651_/Q _1207_/X _1211_/X _1198_/X _0444_/Q _0443_/Q VPWR VGND sg13cmos5l_mux4_1
X_0206_ _0206_/Q Tile_X0Y0_FrameData[14] VGND VPWR Tile_X0Y1_FrameStrobe[3] latch
XFILLER_24_226 VPWR VGND sg13cmos5l_decap_8
X_0137_ _0137_/Q Tile_X0Y0_FrameData[19] VGND VPWR Tile_X0Y1_FrameStrobe[1] latch
X_0068_ _0918_/A _1023_/X _1024_/X _0278_/Q VPWR VGND sg13cmos5l_mux2_1
XFILLER_116_9 VPWR VGND sg13cmos5l_fill_1
XFILLER_3_108 VPWR VGND sg13cmos5l_decap_8
XFILLER_114_21 VPWR VGND sg13cmos5l_decap_4
XFILLER_114_76 VPWR VGND sg13cmos5l_decap_4
XFILLER_59_189 VPWR VGND sg13cmos5l_decap_8
XFILLER_74_36 VPWR VGND sg13cmos5l_decap_8
XFILLER_2_141 VPWR VGND sg13cmos5l_fill_1
XFILLER_2_174 VPWR VGND sg13cmos5l_decap_8
XFILLER_99_99 VPWR VGND sg13cmos5l_decap_8
XFILLER_97_229 VPWR VGND sg13cmos5l_decap_8
XFILLER_0_33 VPWR VGND sg13cmos5l_fill_1
XFILLER_24_8 VPWR VGND sg13cmos5l_fill_2
X_1040_ _1040_/X Tile_X0Y0_EE4END[7] _0637_/Q _1093_/X _1098_/X _0248_/Q _0247_/Q
+ VPWR VGND sg13cmos5l_mux4_1
XFILLER_21_229 VPWR VGND sg13cmos5l_decap_8
XFILLER_73_170 VPWR VGND sg13cmos5l_decap_8
X_0824_ Tile_X0Y1_FrameData_O[0] Tile_X0Y1_FrameData[0] VPWR VGND sg13cmos5l_buf_1
X_0755_ Tile_X0Y0_N4BEG[4] Tile_X0Y1_N4END[12] VPWR VGND sg13cmos5l_buf_1
XFILLER_43_0 VPWR VGND sg13cmos5l_fill_2
X_0686_ _0686_/L_HI VPWR VGND sg13cmos5l_tiehi
XFILLER_96_262 VPWR VGND sg13cmos5l_decap_8
XFILLER_64_170 VPWR VGND sg13cmos5l_decap_8
X_1169_ _1169_/X _0646_/Q _0650_/Q _1212_/X _1196_/X _0478_/Q _0477_/Q VPWR VGND sg13cmos5l_mux4_1
XFILLER_118_150 VPWR VGND sg13cmos5l_decap_8
XFILLER_69_58 VPWR VGND sg13cmos5l_decap_8
XFILLER_79_218 VPWR VGND sg13cmos5l_decap_8
XFILLER_85_57 VPWR VGND sg13cmos5l_decap_8
XFILLER_87_240 VPWR VGND sg13cmos5l_decap_8
XFILLER_55_170 VPWR VGND sg13cmos5l_decap_8
XFILLER_70_162 VPWR VGND sg13cmos5l_decap_8
XFILLER_50_82 VPWR VGND sg13cmos5l_fill_2
XFILLER_7_244 VPWR VGND sg13cmos5l_decap_8
X_0540_ _0540_/Q Tile_X0Y1_FrameData[30] VGND VPWR Tile_X0Y1_FrameStrobe[6] latch
X_0471_ _0471_/Q Tile_X0Y1_FrameData[3] VGND VPWR Tile_X0Y1_FrameStrobe[3] latch
XFILLER_75_90 VPWR VGND sg13cmos5l_decap_8
X_1023_ _1023_/X Tile_X0Y0_E1END[2] Tile_X0Y0_EE4END[14] Tile_X0Y0_E6END[6] _1090_/X
+ _0280_/Q _0279_/Q VPWR VGND sg13cmos5l_mux4_1
XFILLER_93_243 VPWR VGND sg13cmos5l_decap_8
XFILLER_61_151 VPWR VGND sg13cmos5l_decap_8
XFILLER_115_131 VPWR VGND sg13cmos5l_fill_2
X_0807_ Tile_X0Y0_FrameStrobe_O[4] Tile_X0Y1_FrameStrobe[4] VPWR VGND sg13cmos5l_buf_1
X_0738_ Tile_X0Y0_W2BEGb[7] _1046_/X VPWR VGND sg13cmos5l_buf_1
XFILLER_115_186 VPWR VGND sg13cmos5l_decap_8
XFILLER_29_159 VPWR VGND sg13cmos5l_decap_8
X_0669_ _0669_/L_HI VPWR VGND sg13cmos5l_tiehi
XFILLER_37_192 VPWR VGND sg13cmos5l_decap_8
XFILLER_55_49 VPWR VGND sg13cmos5l_decap_8
XFILLER_84_265 VPWR VGND sg13cmos5l_decap_8
XFILLER_71_48 VPWR VGND sg13cmos5l_decap_4
XFILLER_71_59 VPWR VGND sg13cmos5l_decap_4
XFILLER_106_120 VPWR VGND sg13cmos5l_decap_8
XFILLER_106_197 VPWR VGND sg13cmos5l_decap_8
XFILLER_4_247 VPWR VGND sg13cmos5l_decap_8
XFILLER_28_181 VPWR VGND sg13cmos5l_decap_8
XFILLER_29_61 VPWR VGND sg13cmos5l_decap_8
XFILLER_75_254 VPWR VGND sg13cmos5l_decap_8
XFILLER_90_213 VPWR VGND sg13cmos5l_decap_8
XFILLER_43_195 VPWR VGND sg13cmos5l_decap_8
XFILLER_91_8 VPWR VGND sg13cmos5l_decap_8
XANTENNA_3 Tile_X0Y0_FrameData[22] VPWR VGND sg13cmos5l_antennanp
XFILLER_61_92 VPWR VGND sg13cmos5l_decap_8
XFILLER_112_167 VPWR VGND sg13cmos5l_decap_8
X_0523_ _0523_/Q Tile_X0Y1_FrameData[15] VGND VPWR Tile_X0Y1_FrameStrobe[5] latch
X_0454_ _0454_/Q Tile_X0Y1_FrameData[20] VGND VPWR Tile_X0Y1_FrameStrobe[3] latch
X_0385_ _0385_/Q Tile_X0Y1_FrameData[25] VGND VPWR Tile_X0Y1_FrameStrobe[1] latch
XFILLER_19_181 VPWR VGND sg13cmos5l_decap_8
XFILLER_81_224 VPWR VGND sg13cmos5l_decap_4
XFILLER_81_235 VPWR VGND sg13cmos5l_fill_1
XFILLER_81_246 VPWR VGND sg13cmos5l_decap_8
X_1006_ _1006_/X Tile_X0Y0_E2MID[4] Tile_X0Y0_E2END[4] Tile_X0Y0_E6END[4] _1095_/X
+ _0332_/Q _0331_/Q VPWR VGND sg13cmos5l_mux4_1
XFILLER_103_156 VPWR VGND sg13cmos5l_decap_8
XFILLER_17_118 VPWR VGND sg13cmos5l_decap_8
XFILLER_57_221 VPWR VGND sg13cmos5l_decap_4
XFILLER_72_202 VPWR VGND sg13cmos5l_decap_8
XFILLER_15_30 VPWR VGND sg13cmos5l_fill_2
XFILLER_25_162 VPWR VGND sg13cmos5l_decap_8
XFILLER_25_173 VPWR VGND sg13cmos5l_decap_8
XFILLER_40_154 VPWR VGND sg13cmos5l_decap_8
XFILLER_82_25 VPWR VGND sg13cmos5l_fill_1
XFILLER_110_0 VPWR VGND sg13cmos5l_fill_2
XFILLER_31_73 VPWR VGND sg13cmos5l_decap_8
XFILLER_0_272 VPWR VGND sg13cmos5l_fill_1
XFILLER_48_243 VPWR VGND sg13cmos5l_decap_8
XFILLER_16_184 VPWR VGND sg13cmos5l_fill_1
XFILLER_63_246 VPWR VGND sg13cmos5l_decap_8
X_0170_ _0170_/Q Tile_X0Y0_FrameData[18] VGND VPWR Tile_X0Y1_FrameStrobe[2] latch
XFILLER_117_215 VPWR VGND sg13cmos5l_decap_8
XFILLER_117_226 VPWR VGND sg13cmos5l_fill_1
XFILLER_16_195 VPWR VGND sg13cmos5l_decap_8
XFILLER_31_165 VPWR VGND sg13cmos5l_decap_8
X_0506_ _0506_/Q Tile_X0Y1_FrameData[0] VGND VPWR Tile_X0Y1_FrameStrobe[4] latch
XFILLER_39_232 VPWR VGND sg13cmos5l_decap_8
X_0437_ _0437_/Q Tile_X0Y1_FrameData[5] VGND VPWR Tile_X0Y1_FrameStrobe[2] latch
X_0368_ _0368_/Q Tile_X0Y1_FrameData[10] VGND VPWR Tile_X0Y1_FrameStrobe[0] latch
XFILLER_98_187 VPWR VGND sg13cmos5l_decap_8
XFILLER_22_132 VPWR VGND sg13cmos5l_decap_8
XFILLER_22_165 VPWR VGND sg13cmos5l_decap_8
XFILLER_52_17 VPWR VGND sg13cmos5l_decap_8
XFILLER_52_28 VPWR VGND sg13cmos5l_fill_1
X_0299_ _0299_/Q Tile_X0Y0_FrameData[17] VGND VPWR Tile_X0Y1_FrameStrobe[6] latch
XFILLER_89_198 VPWR VGND sg13cmos5l_decap_8
XFILLER_45_213 VPWR VGND sg13cmos5l_decap_8
XFILLER_60_216 VPWR VGND sg13cmos5l_decap_8
XFILLER_42_61 VPWR VGND sg13cmos5l_decap_8
XFILLER_9_158 VPWR VGND sg13cmos5l_decap_8
XFILLER_9_125 VPWR VGND sg13cmos5l_fill_2
XFILLER_47_7 VPWR VGND sg13cmos5l_fill_2
X_0222_ _0222_/Q Tile_X0Y0_FrameData[30] VGND VPWR Tile_X0Y1_FrameStrobe[4] latch
X_0153_ _0153_/Q Tile_X0Y0_FrameData[3] VGND VPWR Tile_X0Y1_FrameStrobe[1] latch
XFILLER_95_179 VPWR VGND sg13cmos5l_decap_8
XFILLER_36_268 VPWR VGND sg13cmos5l_decap_4
X_0084_ _0766_/A _1017_/X _1018_/X _0311_/Q VPWR VGND sg13cmos5l_mux2_1
XFILLER_73_0 VPWR VGND sg13cmos5l_decap_8
X_0986_ _0986_/X Tile_X0Y1_EE4END[4] Tile_X0Y1_EE4END[12] Tile_X0Y1_E6END[4] _1207_/X
+ _0426_/Q _0425_/Q VPWR VGND sg13cmos5l_mux4_1
XFILLER_105_218 VPWR VGND sg13cmos5l_decap_8
XFILLER_47_28 VPWR VGND sg13cmos5l_decap_8
XFILLER_86_102 VPWR VGND sg13cmos5l_decap_8
XFILLER_86_113 VPWR VGND sg13cmos5l_fill_2
XFILLER_27_213 VPWR VGND sg13cmos5l_decap_8
XFILLER_42_216 VPWR VGND sg13cmos5l_decap_8
XFILLER_63_38 VPWR VGND sg13cmos5l_decap_8
XFILLER_10_102 VPWR VGND sg13cmos5l_decap_4
XFILLER_50_271 VPWR VGND sg13cmos5l_fill_2
XFILLER_6_106 VPWR VGND sg13cmos5l_fill_2
XFILLER_104_240 VPWR VGND sg13cmos5l_decap_8
XFILLER_88_68 VPWR VGND sg13cmos5l_decap_8
XFILLER_77_113 VPWR VGND sg13cmos5l_fill_1
XFILLER_77_135 VPWR VGND sg13cmos5l_decap_8
XFILLER_77_168 VPWR VGND sg13cmos5l_decap_8
XFILLER_18_235 VPWR VGND sg13cmos5l_decap_8
XFILLER_18_268 VPWR VGND sg13cmos5l_decap_4
X_0840_ Tile_X0Y1_FrameData_O[16] Tile_X0Y1_FrameData[16] VPWR VGND sg13cmos5l_buf_1
X_0771_ Tile_X0Y0_WW4BEG[4] _1051_/X VPWR VGND sg13cmos5l_buf_1
XFILLER_5_183 VPWR VGND sg13cmos5l_decap_8
XFILLER_110_243 VPWR VGND sg13cmos5l_decap_8
XFILLER_24_205 VPWR VGND sg13cmos5l_decap_8
XFILLER_68_157 VPWR VGND sg13cmos5l_decap_8
XFILLER_76_190 VPWR VGND sg13cmos5l_decap_8
XFILLER_83_105 VPWR VGND sg13cmos5l_decap_4
XFILLER_83_127 VPWR VGND sg13cmos5l_decap_8
X_1185_ _1185_/X _0650_/Q _1208_/X _1212_/X _1197_/X _0446_/Q _0445_/Q VPWR VGND sg13cmos5l_mux4_1
X_0205_ _0205_/Q Tile_X0Y0_FrameData[15] VGND VPWR Tile_X0Y1_FrameStrobe[3] latch
X_0136_ _0136_/Q Tile_X0Y0_FrameData[20] VGND VPWR Tile_X0Y1_FrameStrobe[1] latch
XFILLER_32_260 VPWR VGND sg13cmos5l_decap_8
XFILLER_32_271 VPWR VGND sg13cmos5l_fill_2
X_0969_ Tile_X0Y1_WW4BEG[12] _1175_/X VPWR VGND sg13cmos5l_buf_1
XFILLER_101_265 VPWR VGND sg13cmos5l_decap_8
XFILLER_58_27 VPWR VGND sg13cmos5l_decap_4
XFILLER_59_168 VPWR VGND sg13cmos5l_decap_8
XFILLER_90_36 VPWR VGND sg13cmos5l_decap_8
XFILLER_99_56 VPWR VGND sg13cmos5l_decap_8
XFILLER_90_47 VPWR VGND sg13cmos5l_fill_1
XFILLER_2_153 VPWR VGND sg13cmos5l_decap_8
XFILLER_3_0 VPWR VGND sg13cmos5l_fill_2
XFILLER_97_208 VPWR VGND sg13cmos5l_decap_8
XFILLER_0_67 VPWR VGND sg13cmos5l_fill_1
XFILLER_65_138 VPWR VGND sg13cmos5l_fill_2
XFILLER_21_208 VPWR VGND sg13cmos5l_decap_8
X_0823_ FAB_USER_CLK Tile_X0Y1_UserCLK VPWR VGND sg13cmos5l_buf_1
X_0754_ Tile_X0Y0_N4BEG[3] Tile_X0Y1_N4END[11] VPWR VGND sg13cmos5l_buf_1
X_0685_ _0685_/L_HI VPWR VGND sg13cmos5l_tiehi
XFILLER_28_19 VPWR VGND sg13cmos5l_fill_2
XFILLER_36_0 VPWR VGND sg13cmos5l_fill_2
XFILLER_96_241 VPWR VGND sg13cmos5l_decap_8
X_1099_ _1099_/X _1110_/X Tile_X0Y1_N2MID[7] Tile_X0Y0_S2MID[7] Tile_X0Y0_S2END[7]
+ _0102_/Q _0101_/Q VPWR VGND sg13cmos5l_mux4_1
X_1168_ _1168_/X _0645_/Q _0649_/Q _1213_/X _1197_/X _0480_/Q _0479_/Q VPWR VGND sg13cmos5l_mux4_1
X_0119_ _0119_/Q Tile_X0Y0_FrameData[5] VGND VPWR Tile_X0Y1_FrameStrobe[0] latch
XFILLER_109_11 VPWR VGND sg13cmos5l_decap_8
XFILLER_12_219 VPWR VGND sg13cmos5l_decap_8
XFILLER_20_263 VPWR VGND sg13cmos5l_fill_2
XFILLER_114_7 VPWR VGND sg13cmos5l_decap_8
XFILLER_85_25 VPWR VGND sg13cmos5l_decap_4
XFILLER_109_184 VPWR VGND sg13cmos5l_decap_8
XFILLER_11_263 VPWR VGND sg13cmos5l_decap_8
XFILLER_50_61 VPWR VGND sg13cmos5l_decap_8
XFILLER_7_223 VPWR VGND sg13cmos5l_decap_8
XFILLER_78_252 VPWR VGND sg13cmos5l_decap_8
X_0470_ _0470_/Q Tile_X0Y1_FrameData[4] VGND VPWR Tile_X0Y1_FrameStrobe[3] latch
XFILLER_93_222 VPWR VGND sg13cmos5l_decap_8
XFILLER_53_119 VPWR VGND sg13cmos5l_fill_2
XFILLER_61_130 VPWR VGND sg13cmos5l_decap_8
X_1022_ _1022_/X _1086_/X _1082_/X _1076_/X _1097_/X _0283_/Q _0282_/Q VPWR VGND sg13cmos5l_mux4_1
XANTENNA__0802__X Tile_X0Y0_N1BEG[3] VPWR VGND sg13cmos5l_antennanp
XFILLER_115_165 VPWR VGND sg13cmos5l_decap_8
X_0806_ Tile_X0Y0_FrameStrobe_O[3] Tile_X0Y1_FrameStrobe[3] VPWR VGND sg13cmos5l_buf_1
X_0737_ Tile_X0Y0_W2BEGb[6] _1045_/X VPWR VGND sg13cmos5l_buf_1
X_0668_ _0668_/L_HI VPWR VGND sg13cmos5l_tiehi
XFILLER_37_160 VPWR VGND sg13cmos5l_decap_4
XFILLER_55_28 VPWR VGND sg13cmos5l_decap_8
XFILLER_84_244 VPWR VGND sg13cmos5l_decap_8
X_0599_ _0599_/Q Tile_X0Y1_FrameData[3] VGND VPWR Tile_X0Y1_FrameStrobe[7] latch
XFILLER_111_67 VPWR VGND sg13cmos5l_decap_4
XFILLER_52_196 VPWR VGND sg13cmos5l_decap_8
XFILLER_4_226 VPWR VGND sg13cmos5l_decap_8
XFILLER_106_176 VPWR VGND sg13cmos5l_decap_8
XFILLER_20_53 VPWR VGND sg13cmos5l_decap_8
XFILLER_20_64 VPWR VGND sg13cmos5l_fill_1
XFILLER_29_84 VPWR VGND sg13cmos5l_fill_2
XFILLER_75_233 VPWR VGND sg13cmos5l_decap_8
XFILLER_90_269 VPWR VGND sg13cmos5l_decap_4
XFILLER_43_174 VPWR VGND sg13cmos5l_decap_8
XANTENNA_4 Tile_X0Y0_FrameData[22] VPWR VGND sg13cmos5l_antennanp
XFILLER_6_99 VPWR VGND sg13cmos5l_fill_2
X_0522_ _0522_/Q Tile_X0Y1_FrameData[16] VGND VPWR Tile_X0Y1_FrameStrobe[5] latch
XFILLER_112_146 VPWR VGND sg13cmos5l_decap_8
XFILLER_66_255 VPWR VGND sg13cmos5l_decap_8
XFILLER_81_203 VPWR VGND sg13cmos5l_decap_8
X_0453_ _0453_/Q Tile_X0Y1_FrameData[21] VGND VPWR Tile_X0Y1_FrameStrobe[3] latch
X_0384_ _0384_/Q Tile_X0Y1_FrameData[26] VGND VPWR Tile_X0Y1_FrameStrobe[1] latch
XFILLER_19_160 VPWR VGND sg13cmos5l_decap_8
X_1005_ _1005_/X Tile_X0Y0_E2MID[5] Tile_X0Y0_E2END[5] Tile_X0Y0_E6END[5] _1094_/X
+ _0334_/Q _0333_/Q VPWR VGND sg13cmos5l_mux4_1
XFILLER_57_200 VPWR VGND sg13cmos5l_decap_8
XFILLER_111_190 VPWR VGND sg13cmos5l_decap_8
XFILLER_25_141 VPWR VGND sg13cmos5l_decap_8
XFILLER_72_258 VPWR VGND sg13cmos5l_decap_8
XFILLER_15_53 VPWR VGND sg13cmos5l_decap_8
XFILLER_103_0 VPWR VGND sg13cmos5l_fill_2
XFILLER_31_41 VPWR VGND sg13cmos5l_decap_8
XFILLER_102_190 VPWR VGND sg13cmos5l_decap_8
XFILLER_48_222 VPWR VGND sg13cmos5l_decap_8
XFILLER_48_233 VPWR VGND sg13cmos5l_fill_2
XFILLER_31_111 VPWR VGND sg13cmos5l_decap_8
XFILLER_63_225 VPWR VGND sg13cmos5l_decap_8
XFILLER_31_144 VPWR VGND sg13cmos5l_fill_2
X_0505_ _0505_/Q Tile_X0Y1_FrameData[1] VGND VPWR Tile_X0Y1_FrameStrobe[4] latch
X_0436_ _0436_/Q Tile_X0Y1_FrameData[6] VGND VPWR Tile_X0Y1_FrameStrobe[2] latch
XFILLER_98_166 VPWR VGND sg13cmos5l_decap_8
.ends
