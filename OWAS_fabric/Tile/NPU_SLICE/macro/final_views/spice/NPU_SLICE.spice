* NGSPICE file created from NPU_SLICE.ext - technology: ihp-sg13cmos5l

* Black-box entry subcircuit for latch abstract view
.subckt latch Q D VSS VDD GATE
.ends

* Black-box entry subcircuit for sg13cmos5l_fill_2 abstract view
.subckt sg13cmos5l_fill_2 VDD VSS
.ends

* Black-box entry subcircuit for sg13cmos5l_fill_1 abstract view
.subckt sg13cmos5l_fill_1 VDD VSS
.ends

* Black-box entry subcircuit for sg13cmos5l_decap_8 abstract view
.subckt sg13cmos5l_decap_8 VDD VSS
.ends

* Black-box entry subcircuit for sg13cmos5l_antennanp abstract view
.subckt sg13cmos5l_antennanp A VDD VSS
.ends

* Black-box entry subcircuit for sg13cmos5l_mux2_1 abstract view
.subckt sg13cmos5l_mux2_1 X A0 A1 S VDD VSS
.ends

* Black-box entry subcircuit for sg13cmos5l_mux4_1 abstract view
.subckt sg13cmos5l_mux4_1 X A0 A1 A2 A3 S0 S1 VDD VSS
.ends

* Black-box entry subcircuit for sg13cmos5l_decap_4 abstract view
.subckt sg13cmos5l_decap_4 VDD VSS
.ends

* Black-box entry subcircuit for sg13cmos5l_buf_1 abstract view
.subckt sg13cmos5l_buf_1 X A VDD VSS
.ends

* Black-box entry subcircuit for sg13cmos5l_tiehi abstract view
.subckt sg13cmos5l_tiehi L_HI VDD VSS
.ends

* Black-box entry subcircuit for sg13cmos5l_dfrbpq_1 abstract view
.subckt sg13cmos5l_dfrbpq_1 Q CLK D RESET_B VDD VSS
.ends

* Black-box entry subcircuit for sg13cmos5l_tielo abstract view
.subckt sg13cmos5l_tielo L_LO VDD VSS
.ends

* Black-box entry subcircuit for sg13cmos5l_or2_1 abstract view
.subckt sg13cmos5l_or2_1 X A B VDD VSS
.ends

* Black-box entry subcircuit for sg13cmos5l_nor2b_1 abstract view
.subckt sg13cmos5l_nor2b_1 Y A B_N VDD VSS
.ends

.subckt NPU_SLICE FAB_USER_CLK NPU_ACT_ADDR0 NPU_ACT_ADDR1 NPU_ACT_ADDR2 NPU_ACT_ADDR3
+ NPU_ACT_ADDR4 NPU_ACT_ADDR5 NPU_ACT_ADDR6 NPU_ACT_ADDR7 NPU_ACT_ADDR8 NPU_ACT_RDATA0
+ NPU_ACT_RDATA1 NPU_ACT_RDATA2 NPU_ACT_RDATA3 NPU_ACT_RDATA4 NPU_ACT_RDATA5 NPU_ACT_RDATA6
+ NPU_ACT_RDATA7 NPU_ACT_WDATA0 NPU_ACT_WDATA1 NPU_ACT_WDATA2 NPU_ACT_WDATA3 NPU_ACT_WDATA4
+ NPU_ACT_WDATA5 NPU_ACT_WDATA6 NPU_ACT_WDATA7 NPU_ACT_WE NPU_OUT_ACT0 NPU_OUT_ACT1
+ NPU_OUT_ACT2 NPU_OUT_ACT3 NPU_OUT_ACT4 NPU_OUT_ACT5 NPU_OUT_ACT6 NPU_OUT_ACT7 NPU_WEIGHT_IN0
+ NPU_WEIGHT_IN1 NPU_WEIGHT_IN2 NPU_WEIGHT_IN3 NPU_WEIGHT_IN4 NPU_WEIGHT_IN5 NPU_WEIGHT_IN6
+ NPU_WEIGHT_IN7 NPU_WEIGHT_SHIFT_EN NPU_XBAR_SEL0 NPU_XBAR_SEL1 NPU_XBAR_SEL2 NPU_XBAR_SEL3
+ Tile_X0Y0_E1END[0] Tile_X0Y0_E1END[1] Tile_X0Y0_E1END[2] Tile_X0Y0_E1END[3] Tile_X0Y0_E2END[0]
+ Tile_X0Y0_E2END[1] Tile_X0Y0_E2END[2] Tile_X0Y0_E2END[3] Tile_X0Y0_E2END[4] Tile_X0Y0_E2END[5]
+ Tile_X0Y0_E2END[6] Tile_X0Y0_E2END[7] Tile_X0Y0_E2MID[0] Tile_X0Y0_E2MID[1] Tile_X0Y0_E2MID[2]
+ Tile_X0Y0_E2MID[3] Tile_X0Y0_E2MID[4] Tile_X0Y0_E2MID[5] Tile_X0Y0_E2MID[6] Tile_X0Y0_E2MID[7]
+ Tile_X0Y0_E6END[0] Tile_X0Y0_E6END[10] Tile_X0Y0_E6END[11] Tile_X0Y0_E6END[1] Tile_X0Y0_E6END[2]
+ Tile_X0Y0_E6END[3] Tile_X0Y0_E6END[4] Tile_X0Y0_E6END[5] Tile_X0Y0_E6END[6] Tile_X0Y0_E6END[7]
+ Tile_X0Y0_E6END[8] Tile_X0Y0_E6END[9] Tile_X0Y0_EE4END[0] Tile_X0Y0_EE4END[10] Tile_X0Y0_EE4END[11]
+ Tile_X0Y0_EE4END[12] Tile_X0Y0_EE4END[13] Tile_X0Y0_EE4END[14] Tile_X0Y0_EE4END[15]
+ Tile_X0Y0_EE4END[1] Tile_X0Y0_EE4END[2] Tile_X0Y0_EE4END[3] Tile_X0Y0_EE4END[4]
+ Tile_X0Y0_EE4END[5] Tile_X0Y0_EE4END[6] Tile_X0Y0_EE4END[7] Tile_X0Y0_EE4END[8]
+ Tile_X0Y0_EE4END[9] Tile_X0Y0_FrameData[0] Tile_X0Y0_FrameData[10] Tile_X0Y0_FrameData[11]
+ Tile_X0Y0_FrameData[12] Tile_X0Y0_FrameData[13] Tile_X0Y0_FrameData[14] Tile_X0Y0_FrameData[15]
+ Tile_X0Y0_FrameData[16] Tile_X0Y0_FrameData[17] Tile_X0Y0_FrameData[18] Tile_X0Y0_FrameData[19]
+ Tile_X0Y0_FrameData[1] Tile_X0Y0_FrameData[20] Tile_X0Y0_FrameData[21] Tile_X0Y0_FrameData[22]
+ Tile_X0Y0_FrameData[23] Tile_X0Y0_FrameData[24] Tile_X0Y0_FrameData[25] Tile_X0Y0_FrameData[26]
+ Tile_X0Y0_FrameData[27] Tile_X0Y0_FrameData[28] Tile_X0Y0_FrameData[29] Tile_X0Y0_FrameData[2]
+ Tile_X0Y0_FrameData[30] Tile_X0Y0_FrameData[31] Tile_X0Y0_FrameData[3] Tile_X0Y0_FrameData[4]
+ Tile_X0Y0_FrameData[5] Tile_X0Y0_FrameData[6] Tile_X0Y0_FrameData[7] Tile_X0Y0_FrameData[8]
+ Tile_X0Y0_FrameData[9] Tile_X0Y0_FrameData_O[0] Tile_X0Y0_FrameData_O[10] Tile_X0Y0_FrameData_O[11]
+ Tile_X0Y0_FrameData_O[12] Tile_X0Y0_FrameData_O[13] Tile_X0Y0_FrameData_O[14] Tile_X0Y0_FrameData_O[15]
+ Tile_X0Y0_FrameData_O[16] Tile_X0Y0_FrameData_O[17] Tile_X0Y0_FrameData_O[18] Tile_X0Y0_FrameData_O[19]
+ Tile_X0Y0_FrameData_O[1] Tile_X0Y0_FrameData_O[20] Tile_X0Y0_FrameData_O[21] Tile_X0Y0_FrameData_O[22]
+ Tile_X0Y0_FrameData_O[23] Tile_X0Y0_FrameData_O[24] Tile_X0Y0_FrameData_O[25] Tile_X0Y0_FrameData_O[26]
+ Tile_X0Y0_FrameData_O[27] Tile_X0Y0_FrameData_O[28] Tile_X0Y0_FrameData_O[29] Tile_X0Y0_FrameData_O[2]
+ Tile_X0Y0_FrameData_O[30] Tile_X0Y0_FrameData_O[31] Tile_X0Y0_FrameData_O[3] Tile_X0Y0_FrameData_O[4]
+ Tile_X0Y0_FrameData_O[5] Tile_X0Y0_FrameData_O[6] Tile_X0Y0_FrameData_O[7] Tile_X0Y0_FrameData_O[8]
+ Tile_X0Y0_FrameData_O[9] Tile_X0Y0_FrameStrobe_O[0] Tile_X0Y0_FrameStrobe_O[10]
+ Tile_X0Y0_FrameStrobe_O[11] Tile_X0Y0_FrameStrobe_O[12] Tile_X0Y0_FrameStrobe_O[13]
+ Tile_X0Y0_FrameStrobe_O[14] Tile_X0Y0_FrameStrobe_O[15] Tile_X0Y0_FrameStrobe_O[16]
+ Tile_X0Y0_FrameStrobe_O[17] Tile_X0Y0_FrameStrobe_O[18] Tile_X0Y0_FrameStrobe_O[19]
+ Tile_X0Y0_FrameStrobe_O[1] Tile_X0Y0_FrameStrobe_O[2] Tile_X0Y0_FrameStrobe_O[3]
+ Tile_X0Y0_FrameStrobe_O[4] Tile_X0Y0_FrameStrobe_O[5] Tile_X0Y0_FrameStrobe_O[6]
+ Tile_X0Y0_FrameStrobe_O[7] Tile_X0Y0_FrameStrobe_O[8] Tile_X0Y0_FrameStrobe_O[9]
+ Tile_X0Y0_N1BEG[0] Tile_X0Y0_N1BEG[1] Tile_X0Y0_N1BEG[2] Tile_X0Y0_N1BEG[3] Tile_X0Y0_N2BEG[0]
+ Tile_X0Y0_N2BEG[1] Tile_X0Y0_N2BEG[2] Tile_X0Y0_N2BEG[3] Tile_X0Y0_N2BEG[4] Tile_X0Y0_N2BEG[5]
+ Tile_X0Y0_N2BEG[6] Tile_X0Y0_N2BEG[7] Tile_X0Y0_N2BEGb[0] Tile_X0Y0_N2BEGb[1] Tile_X0Y0_N2BEGb[2]
+ Tile_X0Y0_N2BEGb[3] Tile_X0Y0_N2BEGb[4] Tile_X0Y0_N2BEGb[5] Tile_X0Y0_N2BEGb[6]
+ Tile_X0Y0_N2BEGb[7] Tile_X0Y0_N4BEG[0] Tile_X0Y0_N4BEG[10] Tile_X0Y0_N4BEG[11] Tile_X0Y0_N4BEG[12]
+ Tile_X0Y0_N4BEG[13] Tile_X0Y0_N4BEG[14] Tile_X0Y0_N4BEG[15] Tile_X0Y0_N4BEG[1] Tile_X0Y0_N4BEG[2]
+ Tile_X0Y0_N4BEG[3] Tile_X0Y0_N4BEG[4] Tile_X0Y0_N4BEG[5] Tile_X0Y0_N4BEG[6] Tile_X0Y0_N4BEG[7]
+ Tile_X0Y0_N4BEG[8] Tile_X0Y0_N4BEG[9] Tile_X0Y0_S1END[0] Tile_X0Y0_S1END[1] Tile_X0Y0_S1END[2]
+ Tile_X0Y0_S1END[3] Tile_X0Y0_S2END[0] Tile_X0Y0_S2END[1] Tile_X0Y0_S2END[2] Tile_X0Y0_S2END[3]
+ Tile_X0Y0_S2END[4] Tile_X0Y0_S2END[5] Tile_X0Y0_S2END[6] Tile_X0Y0_S2END[7] Tile_X0Y0_S2MID[0]
+ Tile_X0Y0_S2MID[1] Tile_X0Y0_S2MID[2] Tile_X0Y0_S2MID[3] Tile_X0Y0_S2MID[4] Tile_X0Y0_S2MID[5]
+ Tile_X0Y0_S2MID[6] Tile_X0Y0_S2MID[7] Tile_X0Y0_S4END[0] Tile_X0Y0_S4END[10] Tile_X0Y0_S4END[11]
+ Tile_X0Y0_S4END[12] Tile_X0Y0_S4END[13] Tile_X0Y0_S4END[14] Tile_X0Y0_S4END[15]
+ Tile_X0Y0_S4END[1] Tile_X0Y0_S4END[2] Tile_X0Y0_S4END[3] Tile_X0Y0_S4END[4] Tile_X0Y0_S4END[5]
+ Tile_X0Y0_S4END[6] Tile_X0Y0_S4END[7] Tile_X0Y0_S4END[8] Tile_X0Y0_S4END[9] Tile_X0Y0_UserCLK
+ Tile_X0Y0_UserCLKo Tile_X0Y0_W1BEG[0] Tile_X0Y0_W1BEG[1] Tile_X0Y0_W1BEG[2] Tile_X0Y0_W1BEG[3]
+ Tile_X0Y0_W2BEG[0] Tile_X0Y0_W2BEG[1] Tile_X0Y0_W2BEG[2] Tile_X0Y0_W2BEG[3] Tile_X0Y0_W2BEG[4]
+ Tile_X0Y0_W2BEG[5] Tile_X0Y0_W2BEG[6] Tile_X0Y0_W2BEG[7] Tile_X0Y0_W2BEGb[0] Tile_X0Y0_W2BEGb[1]
+ Tile_X0Y0_W2BEGb[2] Tile_X0Y0_W2BEGb[3] Tile_X0Y0_W2BEGb[4] Tile_X0Y0_W2BEGb[5]
+ Tile_X0Y0_W2BEGb[6] Tile_X0Y0_W2BEGb[7] Tile_X0Y0_W6BEG[0] Tile_X0Y0_W6BEG[10] Tile_X0Y0_W6BEG[11]
+ Tile_X0Y0_W6BEG[1] Tile_X0Y0_W6BEG[2] Tile_X0Y0_W6BEG[3] Tile_X0Y0_W6BEG[4] Tile_X0Y0_W6BEG[5]
+ Tile_X0Y0_W6BEG[6] Tile_X0Y0_W6BEG[7] Tile_X0Y0_W6BEG[8] Tile_X0Y0_W6BEG[9] Tile_X0Y0_WW4BEG[0]
+ Tile_X0Y0_WW4BEG[10] Tile_X0Y0_WW4BEG[11] Tile_X0Y0_WW4BEG[12] Tile_X0Y0_WW4BEG[13]
+ Tile_X0Y0_WW4BEG[14] Tile_X0Y0_WW4BEG[15] Tile_X0Y0_WW4BEG[1] Tile_X0Y0_WW4BEG[2]
+ Tile_X0Y0_WW4BEG[3] Tile_X0Y0_WW4BEG[4] Tile_X0Y0_WW4BEG[5] Tile_X0Y0_WW4BEG[6]
+ Tile_X0Y0_WW4BEG[7] Tile_X0Y0_WW4BEG[8] Tile_X0Y0_WW4BEG[9] Tile_X0Y1_E1END[0] Tile_X0Y1_E1END[1]
+ Tile_X0Y1_E1END[2] Tile_X0Y1_E1END[3] Tile_X0Y1_E2END[0] Tile_X0Y1_E2END[1] Tile_X0Y1_E2END[2]
+ Tile_X0Y1_E2END[3] Tile_X0Y1_E2END[4] Tile_X0Y1_E2END[5] Tile_X0Y1_E2END[6] Tile_X0Y1_E2END[7]
+ Tile_X0Y1_E2MID[0] Tile_X0Y1_E2MID[1] Tile_X0Y1_E2MID[2] Tile_X0Y1_E2MID[3] Tile_X0Y1_E2MID[4]
+ Tile_X0Y1_E2MID[5] Tile_X0Y1_E2MID[6] Tile_X0Y1_E2MID[7] Tile_X0Y1_E6END[0] Tile_X0Y1_E6END[10]
+ Tile_X0Y1_E6END[11] Tile_X0Y1_E6END[1] Tile_X0Y1_E6END[2] Tile_X0Y1_E6END[3] Tile_X0Y1_E6END[4]
+ Tile_X0Y1_E6END[5] Tile_X0Y1_E6END[6] Tile_X0Y1_E6END[7] Tile_X0Y1_E6END[8] Tile_X0Y1_E6END[9]
+ Tile_X0Y1_EE4END[0] Tile_X0Y1_EE4END[10] Tile_X0Y1_EE4END[11] Tile_X0Y1_EE4END[12]
+ Tile_X0Y1_EE4END[13] Tile_X0Y1_EE4END[14] Tile_X0Y1_EE4END[15] Tile_X0Y1_EE4END[1]
+ Tile_X0Y1_EE4END[2] Tile_X0Y1_EE4END[3] Tile_X0Y1_EE4END[4] Tile_X0Y1_EE4END[5]
+ Tile_X0Y1_EE4END[6] Tile_X0Y1_EE4END[7] Tile_X0Y1_EE4END[8] Tile_X0Y1_EE4END[9]
+ Tile_X0Y1_FrameData[0] Tile_X0Y1_FrameData[10] Tile_X0Y1_FrameData[11] Tile_X0Y1_FrameData[12]
+ Tile_X0Y1_FrameData[13] Tile_X0Y1_FrameData[14] Tile_X0Y1_FrameData[15] Tile_X0Y1_FrameData[16]
+ Tile_X0Y1_FrameData[17] Tile_X0Y1_FrameData[18] Tile_X0Y1_FrameData[19] Tile_X0Y1_FrameData[1]
+ Tile_X0Y1_FrameData[20] Tile_X0Y1_FrameData[21] Tile_X0Y1_FrameData[22] Tile_X0Y1_FrameData[23]
+ Tile_X0Y1_FrameData[24] Tile_X0Y1_FrameData[25] Tile_X0Y1_FrameData[26] Tile_X0Y1_FrameData[27]
+ Tile_X0Y1_FrameData[28] Tile_X0Y1_FrameData[29] Tile_X0Y1_FrameData[2] Tile_X0Y1_FrameData[30]
+ Tile_X0Y1_FrameData[31] Tile_X0Y1_FrameData[3] Tile_X0Y1_FrameData[4] Tile_X0Y1_FrameData[5]
+ Tile_X0Y1_FrameData[6] Tile_X0Y1_FrameData[7] Tile_X0Y1_FrameData[8] Tile_X0Y1_FrameData[9]
+ Tile_X0Y1_FrameData_O[0] Tile_X0Y1_FrameData_O[10] Tile_X0Y1_FrameData_O[11] Tile_X0Y1_FrameData_O[12]
+ Tile_X0Y1_FrameData_O[13] Tile_X0Y1_FrameData_O[14] Tile_X0Y1_FrameData_O[15] Tile_X0Y1_FrameData_O[16]
+ Tile_X0Y1_FrameData_O[17] Tile_X0Y1_FrameData_O[18] Tile_X0Y1_FrameData_O[19] Tile_X0Y1_FrameData_O[1]
+ Tile_X0Y1_FrameData_O[20] Tile_X0Y1_FrameData_O[21] Tile_X0Y1_FrameData_O[22] Tile_X0Y1_FrameData_O[23]
+ Tile_X0Y1_FrameData_O[24] Tile_X0Y1_FrameData_O[25] Tile_X0Y1_FrameData_O[26] Tile_X0Y1_FrameData_O[27]
+ Tile_X0Y1_FrameData_O[28] Tile_X0Y1_FrameData_O[29] Tile_X0Y1_FrameData_O[2] Tile_X0Y1_FrameData_O[30]
+ Tile_X0Y1_FrameData_O[31] Tile_X0Y1_FrameData_O[3] Tile_X0Y1_FrameData_O[4] Tile_X0Y1_FrameData_O[5]
+ Tile_X0Y1_FrameData_O[6] Tile_X0Y1_FrameData_O[7] Tile_X0Y1_FrameData_O[8] Tile_X0Y1_FrameData_O[9]
+ Tile_X0Y1_FrameStrobe[0] Tile_X0Y1_FrameStrobe[10] Tile_X0Y1_FrameStrobe[11] Tile_X0Y1_FrameStrobe[12]
+ Tile_X0Y1_FrameStrobe[13] Tile_X0Y1_FrameStrobe[14] Tile_X0Y1_FrameStrobe[15] Tile_X0Y1_FrameStrobe[16]
+ Tile_X0Y1_FrameStrobe[17] Tile_X0Y1_FrameStrobe[18] Tile_X0Y1_FrameStrobe[19] Tile_X0Y1_FrameStrobe[1]
+ Tile_X0Y1_FrameStrobe[2] Tile_X0Y1_FrameStrobe[3] Tile_X0Y1_FrameStrobe[4] Tile_X0Y1_FrameStrobe[5]
+ Tile_X0Y1_FrameStrobe[6] Tile_X0Y1_FrameStrobe[7] Tile_X0Y1_FrameStrobe[8] Tile_X0Y1_FrameStrobe[9]
+ Tile_X0Y1_N1END[0] Tile_X0Y1_N1END[1] Tile_X0Y1_N1END[2] Tile_X0Y1_N1END[3] Tile_X0Y1_N2END[0]
+ Tile_X0Y1_N2END[1] Tile_X0Y1_N2END[2] Tile_X0Y1_N2END[3] Tile_X0Y1_N2END[4] Tile_X0Y1_N2END[5]
+ Tile_X0Y1_N2END[6] Tile_X0Y1_N2END[7] Tile_X0Y1_N2MID[0] Tile_X0Y1_N2MID[1] Tile_X0Y1_N2MID[2]
+ Tile_X0Y1_N2MID[3] Tile_X0Y1_N2MID[4] Tile_X0Y1_N2MID[5] Tile_X0Y1_N2MID[6] Tile_X0Y1_N2MID[7]
+ Tile_X0Y1_N4END[0] Tile_X0Y1_N4END[10] Tile_X0Y1_N4END[11] Tile_X0Y1_N4END[12] Tile_X0Y1_N4END[13]
+ Tile_X0Y1_N4END[14] Tile_X0Y1_N4END[15] Tile_X0Y1_N4END[1] Tile_X0Y1_N4END[2] Tile_X0Y1_N4END[3]
+ Tile_X0Y1_N4END[4] Tile_X0Y1_N4END[5] Tile_X0Y1_N4END[6] Tile_X0Y1_N4END[7] Tile_X0Y1_N4END[8]
+ Tile_X0Y1_N4END[9] Tile_X0Y1_S1BEG[0] Tile_X0Y1_S1BEG[1] Tile_X0Y1_S1BEG[2] Tile_X0Y1_S1BEG[3]
+ Tile_X0Y1_S2BEG[0] Tile_X0Y1_S2BEG[1] Tile_X0Y1_S2BEG[2] Tile_X0Y1_S2BEG[3] Tile_X0Y1_S2BEG[4]
+ Tile_X0Y1_S2BEG[5] Tile_X0Y1_S2BEG[6] Tile_X0Y1_S2BEG[7] Tile_X0Y1_S2BEGb[0] Tile_X0Y1_S2BEGb[1]
+ Tile_X0Y1_S2BEGb[2] Tile_X0Y1_S2BEGb[3] Tile_X0Y1_S2BEGb[4] Tile_X0Y1_S2BEGb[5]
+ Tile_X0Y1_S2BEGb[6] Tile_X0Y1_S2BEGb[7] Tile_X0Y1_S4BEG[0] Tile_X0Y1_S4BEG[10] Tile_X0Y1_S4BEG[11]
+ Tile_X0Y1_S4BEG[12] Tile_X0Y1_S4BEG[13] Tile_X0Y1_S4BEG[14] Tile_X0Y1_S4BEG[15]
+ Tile_X0Y1_S4BEG[1] Tile_X0Y1_S4BEG[2] Tile_X0Y1_S4BEG[3] Tile_X0Y1_S4BEG[4] Tile_X0Y1_S4BEG[5]
+ Tile_X0Y1_S4BEG[6] Tile_X0Y1_S4BEG[7] Tile_X0Y1_S4BEG[8] Tile_X0Y1_S4BEG[9] Tile_X0Y1_UserCLK
+ Tile_X0Y1_UserCLKo Tile_X0Y1_W1BEG[0] Tile_X0Y1_W1BEG[1] Tile_X0Y1_W1BEG[2] Tile_X0Y1_W1BEG[3]
+ Tile_X0Y1_W2BEG[0] Tile_X0Y1_W2BEG[1] Tile_X0Y1_W2BEG[2] Tile_X0Y1_W2BEG[3] Tile_X0Y1_W2BEG[4]
+ Tile_X0Y1_W2BEG[5] Tile_X0Y1_W2BEG[6] Tile_X0Y1_W2BEG[7] Tile_X0Y1_W2BEGb[0] Tile_X0Y1_W2BEGb[1]
+ Tile_X0Y1_W2BEGb[2] Tile_X0Y1_W2BEGb[3] Tile_X0Y1_W2BEGb[4] Tile_X0Y1_W2BEGb[5]
+ Tile_X0Y1_W2BEGb[6] Tile_X0Y1_W2BEGb[7] Tile_X0Y1_W6BEG[0] Tile_X0Y1_W6BEG[10] Tile_X0Y1_W6BEG[11]
+ Tile_X0Y1_W6BEG[1] Tile_X0Y1_W6BEG[2] Tile_X0Y1_W6BEG[3] Tile_X0Y1_W6BEG[4] Tile_X0Y1_W6BEG[5]
+ Tile_X0Y1_W6BEG[6] Tile_X0Y1_W6BEG[7] Tile_X0Y1_W6BEG[8] Tile_X0Y1_W6BEG[9] Tile_X0Y1_WW4BEG[0]
+ Tile_X0Y1_WW4BEG[10] Tile_X0Y1_WW4BEG[11] Tile_X0Y1_WW4BEG[12] Tile_X0Y1_WW4BEG[13]
+ Tile_X0Y1_WW4BEG[14] Tile_X0Y1_WW4BEG[15] Tile_X0Y1_WW4BEG[1] Tile_X0Y1_WW4BEG[2]
+ Tile_X0Y1_WW4BEG[3] Tile_X0Y1_WW4BEG[4] Tile_X0Y1_WW4BEG[5] Tile_X0Y1_WW4BEG[6]
+ Tile_X0Y1_WW4BEG[7] Tile_X0Y1_WW4BEG[8] Tile_X0Y1_WW4BEG[9] VGND VPWR
X_0367_ _0367_/Q Tile_X0Y1_FrameData[11] VGND VPWR Tile_X0Y1_FrameStrobe[0] latch
X_0298_ _0298_/Q Tile_X0Y0_FrameData[18] VGND VPWR Tile_X0Y1_FrameStrobe[6] latch
XFILLER_22_177 VPWR VGND sg13cmos5l_fill_2
XFILLER_117_11 VPWR VGND sg13cmos5l_fill_1
XFILLER_89_199 VPWR VGND sg13cmos5l_decap_8
XFILLER_89_155 VPWR VGND sg13cmos5l_fill_2
XFILLER_26_85 VPWR VGND sg13cmos5l_decap_8
XFILLER_93_25 VPWR VGND sg13cmos5l_fill_2
XANTENNA__0900__X Tile_X0Y1_S2BEGb[0] VPWR VGND sg13cmos5l_antennanp
XFILLER_3_56 VPWR VGND sg13cmos5l_decap_8
XFILLER_95_114 VPWR VGND sg13cmos5l_decap_8
X_0221_ _0221_/Q Tile_X0Y0_FrameData[31] VGND VPWR Tile_X0Y1_FrameStrobe[4] latch
X_0152_ _0152_/Q Tile_X0Y0_FrameData[4] VGND VPWR Tile_X0Y1_FrameStrobe[1] latch
XFILLER_51_217 VPWR VGND sg13cmos5l_fill_1
X_0083_ _0916_/A _1019_/X _1020_/X _0284_/Q VPWR VGND sg13cmos5l_mux2_1
XANTENNA__0810__X Tile_X0Y0_FrameStrobe_O[7] VPWR VGND sg13cmos5l_antennanp
XFILLER_66_0 VPWR VGND sg13cmos5l_decap_8
X_0985_ _0985_/X Tile_X0Y1_EE4END[3] Tile_X0Y1_EE4END[11] Tile_X0Y1_E6END[3] _1206_/X
+ _0428_/Q _0427_/Q VPWR VGND sg13cmos5l_mux4_1
X_0419_ _0419_/Q Tile_X0Y1_FrameData[23] VGND VPWR Tile_X0Y1_FrameStrobe[2] latch
XFILLER_103_13 VPWR VGND sg13cmos5l_decap_8
XFILLER_103_57 VPWR VGND sg13cmos5l_decap_8
XFILLER_27_203 VPWR VGND sg13cmos5l_decap_4
XFILLER_63_28 VPWR VGND sg13cmos5l_fill_2
XFILLER_63_39 VPWR VGND sg13cmos5l_fill_2
XFILLER_10_103 VPWR VGND sg13cmos5l_decap_4
XFILLER_10_125 VPWR VGND sg13cmos5l_decap_8
XFILLER_10_169 VPWR VGND sg13cmos5l_decap_8
XFILLER_128_21 VPWR VGND sg13cmos5l_decap_8
XANTENNA__0720__X Tile_X0Y0_W1BEG[1] VPWR VGND sg13cmos5l_antennanp
XFILLER_128_54 VPWR VGND sg13cmos5l_fill_1
XFILLER_77_125 VPWR VGND sg13cmos5l_decap_8
XFILLER_77_136 VPWR VGND sg13cmos5l_fill_1
XFILLER_92_117 VPWR VGND sg13cmos5l_decap_8
XFILLER_33_217 VPWR VGND sg13cmos5l_fill_1
XFILLER_53_72 VPWR VGND sg13cmos5l_decap_8
XFILLER_139_182 VPWR VGND sg13cmos5l_fill_2
XFILLER_5_162 VPWR VGND sg13cmos5l_decap_8
X_0770_ Tile_X0Y0_WW4BEG[3] _1050_/X VPWR VGND sg13cmos5l_buf_1
XFILLER_110_200 VPWR VGND sg13cmos5l_decap_8
XFILLER_68_147 VPWR VGND sg13cmos5l_decap_8
XFILLER_24_206 VPWR VGND sg13cmos5l_fill_1
XFILLER_24_217 VPWR VGND sg13cmos5l_fill_1
X_1184_ _1184_/X _0649_/Q _1209_/X _1213_/X _1196_/X _0448_/Q _0447_/Q VPWR VGND sg13cmos5l_mux4_1
X_0204_ _0204_/Q Tile_X0Y0_FrameData[16] VGND VPWR Tile_X0Y1_FrameStrobe[3] latch
X_0135_ _0135_/Q Tile_X0Y0_FrameData[21] VGND VPWR Tile_X0Y1_FrameStrobe[1] latch
XANTENNA__0805__X Tile_X0Y0_FrameStrobe_O[2] VPWR VGND sg13cmos5l_antennanp
XFILLER_137_119 VPWR VGND sg13cmos5l_decap_8
X_0968_ Tile_X0Y1_WW4BEG[11] _1174_/X VPWR VGND sg13cmos5l_buf_1
X_0899_ Tile_X0Y1_S2BEG[7] _1134_/X VPWR VGND sg13cmos5l_buf_1
XFILLER_114_89 VPWR VGND sg13cmos5l_decap_8
XFILLER_15_217 VPWR VGND sg13cmos5l_fill_1
XFILLER_82_194 VPWR VGND sg13cmos5l_decap_4
XFILLER_128_2 VPWR VGND sg13cmos5l_fill_1
XFILLER_136_185 VPWR VGND sg13cmos5l_decap_8
XFILLER_99_68 VPWR VGND sg13cmos5l_decap_8
XFILLER_2_154 VPWR VGND sg13cmos5l_fill_1
XFILLER_2_176 VPWR VGND sg13cmos5l_fill_2
XFILLER_0_35 VPWR VGND sg13cmos5l_decap_8
XFILLER_65_117 VPWR VGND sg13cmos5l_decap_8
XFILLER_73_172 VPWR VGND sg13cmos5l_decap_8
X_0822_ Tile_X0Y0_FrameStrobe_O[19] Tile_X0Y1_FrameStrobe[19] VPWR VGND sg13cmos5l_buf_1
XFILLER_127_163 VPWR VGND sg13cmos5l_decap_8
X_0753_ Tile_X0Y0_N4BEG[2] Tile_X0Y1_N4END[10] VPWR VGND sg13cmos5l_buf_1
X_0684_ _0684_/L_HI VPWR VGND sg13cmos5l_tiehi
XFILLER_29_0 VPWR VGND sg13cmos5l_fill_2
X_1098_ _1098_/X _1109_/X Tile_X0Y1_N2MID[6] Tile_X0Y0_S2MID[6] Tile_X0Y0_S2END[6]
+ _0104_/Q _0103_/Q VPWR VGND sg13cmos5l_mux4_1
X_1167_ _1167_/X _0644_/Q _0648_/Q _1214_/X _1198_/X _0482_/Q _0481_/Q VPWR VGND sg13cmos5l_mux4_1
X_0118_ _0118_/Q Tile_X0Y0_FrameData[6] VGND VPWR Tile_X0Y1_FrameStrobe[0] latch
XFILLER_118_163 VPWR VGND sg13cmos5l_decap_8
XFILLER_109_89 VPWR VGND sg13cmos5l_fill_2
XFILLER_125_77 VPWR VGND sg13cmos5l_decap_8
XFILLER_133_144 VPWR VGND sg13cmos5l_decap_8
XFILLER_69_49 VPWR VGND sg13cmos5l_decap_8
XFILLER_125_88 VPWR VGND sg13cmos5l_fill_1
XFILLER_141_87 VPWR VGND sg13cmos5l_decap_8
XFILLER_18_75 VPWR VGND sg13cmos5l_decap_8
XFILLER_47_128 VPWR VGND sg13cmos5l_decap_8
XFILLER_55_161 VPWR VGND sg13cmos5l_fill_1
XFILLER_133_0 VPWR VGND sg13cmos5l_decap_8
XFILLER_70_175 VPWR VGND sg13cmos5l_decap_8
XFILLER_109_152 VPWR VGND sg13cmos5l_decap_8
XFILLER_109_185 VPWR VGND sg13cmos5l_decap_8
XFILLER_124_133 VPWR VGND sg13cmos5l_decap_8
XFILLER_61_131 VPWR VGND sg13cmos5l_decap_8
XFILLER_75_70 VPWR VGND sg13cmos5l_decap_8
X_1021_ _1021_/X Tile_X0Y0_E1END[1] Tile_X0Y0_EE4END[13] Tile_X0Y0_E6END[5] _1089_/X
+ _0283_/Q _0282_/Q VPWR VGND sg13cmos5l_mux4_1
X_0805_ Tile_X0Y0_FrameStrobe_O[2] Tile_X0Y1_FrameStrobe[2] VPWR VGND sg13cmos5l_buf_1
XFILLER_115_188 VPWR VGND sg13cmos5l_decap_8
XFILLER_130_114 VPWR VGND sg13cmos5l_decap_8
X_0736_ Tile_X0Y0_W2BEGb[5] _1044_/X VPWR VGND sg13cmos5l_buf_1
X_0667_ _0667_/L_HI VPWR VGND sg13cmos5l_tiehi
X_0598_ _0598_/Q Tile_X0Y1_FrameData[4] VGND VPWR Tile_X0Y1_FrameStrobe[7] latch
XFILLER_29_139 VPWR VGND sg13cmos5l_decap_8
XFILLER_84_201 VPWR VGND sg13cmos5l_decap_8
X_1219_ _1219_/X Tile_X0Y0_E2MID[7] Tile_X0Y0_E2END[7] Tile_X0Y0_E6END[8] _1092_/X
+ _0302_/Q _0301_/Q VPWR VGND sg13cmos5l_mux4_1
XFILLER_52_153 VPWR VGND sg13cmos5l_decap_8
XFILLER_71_28 VPWR VGND sg13cmos5l_decap_8
XFILLER_106_111 VPWR VGND sg13cmos5l_decap_4
XFILLER_106_144 VPWR VGND sg13cmos5l_decap_8
XFILLER_136_21 VPWR VGND sg13cmos5l_decap_8
XFILLER_121_114 VPWR VGND sg13cmos5l_decap_8
XFILLER_136_98 VPWR VGND sg13cmos5l_decap_8
XFILLER_29_41 VPWR VGND sg13cmos5l_decap_4
XFILLER_29_85 VPWR VGND sg13cmos5l_decap_8
XFILLER_96_36 VPWR VGND sg13cmos5l_decap_8
XFILLER_28_194 VPWR VGND sg13cmos5l_decap_8
XFILLER_90_204 VPWR VGND sg13cmos5l_decap_8
XANTENNA__0903__X Tile_X0Y1_S2BEGb[3] VPWR VGND sg13cmos5l_antennanp
XFILLER_129_203 VPWR VGND sg13cmos5l_decap_4
XFILLER_61_50 VPWR VGND sg13cmos5l_decap_8
XANTENNA_5 NPU_OUT_ACT6 VPWR VGND sg13cmos5l_antennanp
XFILLER_112_125 VPWR VGND sg13cmos5l_decap_8
XFILLER_6_45 VPWR VGND sg13cmos5l_decap_8
X_0521_ _0521_/Q Tile_X0Y1_FrameData[17] VGND VPWR Tile_X0Y1_FrameStrobe[5] latch
X_0452_ _0452_/Q Tile_X0Y1_FrameData[22] VGND VPWR Tile_X0Y1_FrameStrobe[3] latch
XFILLER_120_191 VPWR VGND sg13cmos5l_decap_8
XFILLER_20_4 VPWR VGND sg13cmos5l_fill_2
X_0383_ _0383_/Q Tile_X0Y1_FrameData[27] VGND VPWR Tile_X0Y1_FrameStrobe[1] latch
XFILLER_34_153 VPWR VGND sg13cmos5l_decap_8
X_1004_ _1004_/X Tile_X0Y0_E2MID[6] Tile_X0Y0_E2END[6] Tile_X0Y0_E6END[6] _1093_/X
+ _0336_/Q _0335_/Q VPWR VGND sg13cmos5l_mux4_1
XFILLER_96_0 VPWR VGND sg13cmos5l_fill_1
XANTENNA__0813__X Tile_X0Y0_FrameStrobe_O[10] VPWR VGND sg13cmos5l_antennanp
XFILLER_106_35 VPWR VGND sg13cmos5l_decap_8
XFILLER_111_180 VPWR VGND sg13cmos5l_decap_8
XFILLER_66_28 VPWR VGND sg13cmos5l_decap_4
X_0719_ Tile_X0Y0_W1BEG[0] _1027_/X VPWR VGND sg13cmos5l_buf_1
XFILLER_25_142 VPWR VGND sg13cmos5l_decap_8
XFILLER_25_153 VPWR VGND sg13cmos5l_fill_2
XANTENNA__0723__X Tile_X0Y0_W2BEG[0] VPWR VGND sg13cmos5l_antennanp
XFILLER_40_145 VPWR VGND sg13cmos5l_decap_8
XFILLER_48_201 VPWR VGND sg13cmos5l_fill_2
XFILLER_56_61 VPWR VGND sg13cmos5l_decap_8
XFILLER_16_175 VPWR VGND sg13cmos5l_fill_1
XFILLER_16_197 VPWR VGND sg13cmos5l_fill_2
XFILLER_31_112 VPWR VGND sg13cmos5l_decap_8
XFILLER_31_123 VPWR VGND sg13cmos5l_fill_2
XFILLER_31_167 VPWR VGND sg13cmos5l_decap_8
XFILLER_72_82 VPWR VGND sg13cmos5l_decap_8
XFILLER_72_93 VPWR VGND sg13cmos5l_fill_1
XFILLER_117_217 VPWR VGND sg13cmos5l_fill_1
X_0504_ _0504_/Q Tile_X0Y1_FrameData[2] VGND VPWR Tile_X0Y1_FrameStrobe[4] latch
X_0435_ _0435_/Q Tile_X0Y1_FrameData[7] VGND VPWR Tile_X0Y1_FrameStrobe[2] latch
XANTENNA__0808__X Tile_X0Y0_FrameStrobe_O[5] VPWR VGND sg13cmos5l_antennanp
X_0366_ _0366_/Q Tile_X0Y1_FrameData[12] VGND VPWR Tile_X0Y1_FrameStrobe[0] latch
X_0297_ _0297_/Q Tile_X0Y0_FrameData[19] VGND VPWR Tile_X0Y1_FrameStrobe[6] latch
XFILLER_108_206 VPWR VGND sg13cmos5l_decap_8
XFILLER_22_156 VPWR VGND sg13cmos5l_decap_8
XFILLER_108_217 VPWR VGND sg13cmos5l_fill_1
XFILLER_77_27 VPWR VGND sg13cmos5l_decap_8
XFILLER_89_101 VPWR VGND sg13cmos5l_decap_8
XANTENNA__0718__X Tile_X0Y0_UserCLKo VPWR VGND sg13cmos5l_antennanp
XFILLER_133_88 VPWR VGND sg13cmos5l_decap_8
XFILLER_26_20 VPWR VGND sg13cmos5l_fill_1
XFILLER_3_35 VPWR VGND sg13cmos5l_decap_8
XFILLER_83_70 VPWR VGND sg13cmos5l_decap_8
X_0220_ _0220_/Q Tile_X0Y0_FrameData[0] VGND VPWR Tile_X0Y1_FrameStrobe[3] latch
X_0151_ _0151_/Q Tile_X0Y0_FrameData[5] VGND VPWR Tile_X0Y1_FrameStrobe[1] latch
X_0082_ _0763_/A _1011_/X _1012_/X _0320_/Q VPWR VGND sg13cmos5l_mux2_1
X_0984_ _0984_/X Tile_X0Y1_EE4END[2] Tile_X0Y1_EE4END[10] Tile_X0Y1_E6END[2] _1205_/X
+ _0430_/Q _0429_/Q VPWR VGND sg13cmos5l_mux4_1
XFILLER_59_0 VPWR VGND sg13cmos5l_decap_8
X_0418_ _0418_/Q Tile_X0Y1_FrameData[24] VGND VPWR Tile_X0Y1_FrameStrobe[2] latch
X_0349_ _0349_/Q Tile_X0Y1_FrameData[29] VGND VPWR Tile_X0Y1_FrameStrobe[0] latch
XFILLER_10_148 VPWR VGND sg13cmos5l_decap_8
XFILLER_137_7 VPWR VGND sg13cmos5l_decap_8
XFILLER_6_119 VPWR VGND sg13cmos5l_decap_8
XFILLER_77_104 VPWR VGND sg13cmos5l_decap_8
XANTENNA__0911__X Tile_X0Y1_S4BEG[3] VPWR VGND sg13cmos5l_antennanp
XFILLER_52_7 VPWR VGND sg13cmos5l_decap_8
XFILLER_5_141 VPWR VGND sg13cmos5l_decap_8
XFILLER_83_129 VPWR VGND sg13cmos5l_decap_8
X_0203_ _0203_/Q Tile_X0Y0_FrameData[17] VGND VPWR Tile_X0Y1_FrameStrobe[3] latch
XFILLER_76_192 VPWR VGND sg13cmos5l_decap_8
X_1183_ _1183_/X _0648_/Q _1210_/X _1214_/X _1195_/X _0450_/Q _0449_/Q VPWR VGND sg13cmos5l_mux4_1
X_0134_ _0134_/Q Tile_X0Y0_FrameData[22] VGND VPWR Tile_X0Y1_FrameStrobe[1] latch
XFILLER_91_195 VPWR VGND sg13cmos5l_fill_2
XANTENNA__0821__X Tile_X0Y0_FrameStrobe_O[18] VPWR VGND sg13cmos5l_antennanp
X_0967_ Tile_X0Y1_WW4BEG[10] _1173_/X VPWR VGND sg13cmos5l_buf_1
XFILLER_59_104 VPWR VGND sg13cmos5l_decap_8
X_0898_ Tile_X0Y1_S2BEG[6] _1133_/X VPWR VGND sg13cmos5l_buf_1
XFILLER_114_57 VPWR VGND sg13cmos5l_decap_8
XFILLER_74_107 VPWR VGND sg13cmos5l_decap_4
XFILLER_130_34 VPWR VGND sg13cmos5l_fill_2
XANTENNA__0731__X Tile_X0Y0_W2BEGb[0] VPWR VGND sg13cmos5l_antennanp
XFILLER_23_65 VPWR VGND sg13cmos5l_decap_8
XFILLER_23_87 VPWR VGND sg13cmos5l_decap_8
XFILLER_99_47 VPWR VGND sg13cmos5l_decap_8
XFILLER_2_166 VPWR VGND sg13cmos5l_fill_2
XFILLER_2_188 VPWR VGND sg13cmos5l_decap_8
XANTENNA__0906__X Tile_X0Y1_S2BEGb[6] VPWR VGND sg13cmos5l_antennanp
XFILLER_0_14 VPWR VGND sg13cmos5l_decap_8
XFILLER_58_170 VPWR VGND sg13cmos5l_decap_4
XFILLER_64_50 VPWR VGND sg13cmos5l_decap_8
XFILLER_64_94 VPWR VGND sg13cmos5l_decap_8
XFILLER_73_151 VPWR VGND sg13cmos5l_decap_8
XFILLER_127_142 VPWR VGND sg13cmos5l_decap_8
XFILLER_80_93 VPWR VGND sg13cmos5l_decap_8
X_0821_ Tile_X0Y0_FrameStrobe_O[18] Tile_X0Y1_FrameStrobe[18] VPWR VGND sg13cmos5l_buf_1
X_0752_ Tile_X0Y0_N4BEG[1] Tile_X0Y1_N4END[9] VPWR VGND sg13cmos5l_buf_1
XFILLER_9_34 VPWR VGND sg13cmos5l_fill_2
X_0683_ _0683_/L_HI VPWR VGND sg13cmos5l_tiehi
X_1235_ _1235_/X Tile_X0Y0_E1END[1] Tile_X0Y0_E6END[1] _1101_/X _1235_/A3 _0152_/Q
+ _0151_/Q VPWR VGND sg13cmos5l_mux4_1
X_1166_ _1166_/X _0647_/Q _0651_/Q _1215_/X _1199_/X _0484_/Q _0483_/Q VPWR VGND sg13cmos5l_mux4_1
XANTENNA__0816__X Tile_X0Y0_FrameStrobe_O[13] VPWR VGND sg13cmos5l_antennanp
XFILLER_100_15 VPWR VGND sg13cmos5l_fill_1
X_1097_ _1097_/X _1108_/X Tile_X0Y1_N2MID[5] Tile_X0Y0_S2MID[5] Tile_X0Y0_S2END[5]
+ _0106_/Q _0105_/Q VPWR VGND sg13cmos5l_mux4_1
X_0117_ _0117_/Q Tile_X0Y0_FrameData[7] VGND VPWR Tile_X0Y1_FrameStrobe[0] latch
XFILLER_109_68 VPWR VGND sg13cmos5l_decap_8
XFILLER_133_123 VPWR VGND sg13cmos5l_decap_8
XFILLER_69_28 VPWR VGND sg13cmos5l_decap_8
XFILLER_125_56 VPWR VGND sg13cmos5l_decap_8
XFILLER_85_27 VPWR VGND sg13cmos5l_decap_8
XFILLER_87_210 VPWR VGND sg13cmos5l_decap_8
XANTENNA__0726__X Tile_X0Y0_W2BEG[3] VPWR VGND sg13cmos5l_antennanp
XFILLER_141_66 VPWR VGND sg13cmos5l_decap_8
XFILLER_18_54 VPWR VGND sg13cmos5l_decap_8
XFILLER_70_154 VPWR VGND sg13cmos5l_decap_8
XFILLER_109_131 VPWR VGND sg13cmos5l_decap_8
XFILLER_11_210 VPWR VGND sg13cmos5l_decap_8
XFILLER_126_0 VPWR VGND sg13cmos5l_decap_8
XFILLER_34_86 VPWR VGND sg13cmos5l_decap_8
XFILLER_124_189 VPWR VGND sg13cmos5l_decap_8
XFILLER_38_118 VPWR VGND sg13cmos5l_decap_4
XFILLER_59_72 VPWR VGND sg13cmos5l_decap_8
XFILLER_75_60 VPWR VGND sg13cmos5l_fill_2
X_1020_ _1020_/X _1087_/X _1083_/X _1075_/X _1096_/X _0286_/Q _0285_/Q VPWR VGND sg13cmos5l_mux4_1
XFILLER_46_184 VPWR VGND sg13cmos5l_decap_8
XFILLER_61_110 VPWR VGND sg13cmos5l_decap_8
X_0804_ Tile_X0Y0_FrameStrobe_O[1] Tile_X0Y1_FrameStrobe[1] VPWR VGND sg13cmos5l_buf_1
X_0735_ Tile_X0Y0_W2BEGb[4] _1043_/X VPWR VGND sg13cmos5l_buf_1
X_0666_ _0666_/L_HI VPWR VGND sg13cmos5l_tiehi
X_0597_ _0597_/Q Tile_X0Y1_FrameData[5] VGND VPWR Tile_X0Y1_FrameStrobe[7] latch
XFILLER_111_14 VPWR VGND sg13cmos5l_fill_2
XFILLER_52_132 VPWR VGND sg13cmos5l_decap_8
X_1218_ _1218_/X Tile_X0Y1_N1END[3] Tile_X0Y1_N4END[3] _1230_/X Tile_X0Y0_S4END[7]
+ _0372_/Q _0371_/Q VPWR VGND sg13cmos5l_mux4_1
X_1149_ _1149_/X Tile_X0Y1_E2END[2] _0646_/Q _1197_/X _1200_/X _0518_/Q _0517_/Q VPWR
+ VGND sg13cmos5l_mux4_1
XFILLER_138_215 VPWR VGND sg13cmos5l_fill_2
XFILLER_136_77 VPWR VGND sg13cmos5l_decap_8
XFILLER_20_88 VPWR VGND sg13cmos5l_fill_1
XFILLER_4_217 VPWR VGND sg13cmos5l_fill_1
XFILLER_28_173 VPWR VGND sg13cmos5l_decap_8
XFILLER_43_165 VPWR VGND sg13cmos5l_decap_4
XFILLER_43_187 VPWR VGND sg13cmos5l_decap_8
XANTENNA_6 Tile_X0Y0_S2MID[0] VPWR VGND sg13cmos5l_antennanp
X_0520_ _0520_/Q Tile_X0Y1_FrameData[18] VGND VPWR Tile_X0Y1_FrameStrobe[5] latch
X_0451_ _0451_/Q Tile_X0Y1_FrameData[23] VGND VPWR Tile_X0Y1_FrameStrobe[3] latch
X_0382_ _0382_/Q Tile_X0Y1_FrameData[28] VGND VPWR Tile_X0Y1_FrameStrobe[1] latch
XFILLER_120_170 VPWR VGND sg13cmos5l_decap_8
XFILLER_19_195 VPWR VGND sg13cmos5l_fill_1
XFILLER_34_132 VPWR VGND sg13cmos5l_decap_8
X_1003_ _1003_/X Tile_X0Y0_E2MID[7] Tile_X0Y0_E2END[7] Tile_X0Y0_E6END[7] _1092_/X
+ _0338_/Q _0337_/Q VPWR VGND sg13cmos5l_mux4_1
XFILLER_34_176 VPWR VGND sg13cmos5l_decap_4
XFILLER_89_0 VPWR VGND sg13cmos5l_decap_4
XFILLER_135_207 VPWR VGND sg13cmos5l_decap_8
X_0718_ Tile_X0Y0_UserCLKo Tile_X0Y0_UserCLK VPWR VGND sg13cmos5l_buf_1
XFILLER_103_137 VPWR VGND sg13cmos5l_decap_8
XFILLER_57_202 VPWR VGND sg13cmos5l_fill_2
X_0649_ _0649_/Q Tile_X0Y1_UserCLK NPU_ACT_RDATA5 _0657_/L_HI VPWR VGND sg13cmos5l_dfrbpq_1
XFILLER_122_46 VPWR VGND sg13cmos5l_decap_8
XFILLER_122_68 VPWR VGND sg13cmos5l_fill_2
XFILLER_25_121 VPWR VGND sg13cmos5l_decap_8
XFILLER_40_124 VPWR VGND sg13cmos5l_decap_8
XFILLER_31_32 VPWR VGND sg13cmos5l_fill_1
XFILLER_40_179 VPWR VGND sg13cmos5l_decap_8
XFILLER_31_98 VPWR VGND sg13cmos5l_decap_8
XANTENNA__0914__X Tile_X0Y1_S4BEG[6] VPWR VGND sg13cmos5l_antennanp
XFILLER_31_146 VPWR VGND sg13cmos5l_decap_8
XFILLER_98_113 VPWR VGND sg13cmos5l_decap_8
XFILLER_98_102 VPWR VGND sg13cmos5l_decap_8
XFILLER_100_107 VPWR VGND sg13cmos5l_fill_1
X_0503_ _0503_/Q Tile_X0Y1_FrameData[3] VGND VPWR Tile_X0Y1_FrameStrobe[4] latch
X_0434_ _0434_/Q Tile_X0Y1_FrameData[8] VGND VPWR Tile_X0Y1_FrameStrobe[2] latch
X_0365_ _0365_/Q Tile_X0Y1_FrameData[13] VGND VPWR Tile_X0Y1_FrameStrobe[0] latch
XANTENNA__0824__X Tile_X0Y1_FrameData_O[0] VPWR VGND sg13cmos5l_antennanp
XFILLER_22_102 VPWR VGND sg13cmos5l_fill_2
X_0296_ _0296_/Q Tile_X0Y0_FrameData[20] VGND VPWR Tile_X0Y1_FrameStrobe[6] latch
XFILLER_22_179 VPWR VGND sg13cmos5l_fill_1
XFILLER_30_190 VPWR VGND sg13cmos5l_decap_8
XFILLER_131_210 VPWR VGND sg13cmos5l_decap_8
XFILLER_133_45 VPWR VGND sg13cmos5l_decap_8
XFILLER_45_205 VPWR VGND sg13cmos5l_fill_2
XFILLER_93_27 VPWR VGND sg13cmos5l_fill_1
XANTENNA__0734__X Tile_X0Y0_W2BEGb[3] VPWR VGND sg13cmos5l_antennanp
XFILLER_26_65 VPWR VGND sg13cmos5l_fill_2
XANTENNA__0909__X Tile_X0Y1_S4BEG[1] VPWR VGND sg13cmos5l_antennanp
XFILLER_3_14 VPWR VGND sg13cmos5l_decap_8
XFILLER_95_149 VPWR VGND sg13cmos5l_decap_8
XFILLER_36_216 VPWR VGND sg13cmos5l_fill_2
XFILLER_67_94 VPWR VGND sg13cmos5l_decap_4
X_0150_ _0150_/Q Tile_X0Y0_FrameData[6] VGND VPWR Tile_X0Y1_FrameStrobe[1] latch
X_0081_ _0764_/A _1013_/X _1014_/X _0317_/Q VPWR VGND sg13cmos5l_mux2_1
XFILLER_80_4 VPWR VGND sg13cmos5l_fill_1
X_0983_ _0983_/X Tile_X0Y1_EE4END[1] Tile_X0Y1_EE4END[9] Tile_X0Y1_E6END[1] _1204_/X
+ _0432_/Q _0431_/Q VPWR VGND sg13cmos5l_mux4_1
XFILLER_113_210 VPWR VGND sg13cmos5l_decap_8
XFILLER_8_183 VPWR VGND sg13cmos5l_decap_8
XANTENNA__0819__X Tile_X0Y0_FrameStrobe_O[16] VPWR VGND sg13cmos5l_antennanp
XFILLER_86_116 VPWR VGND sg13cmos5l_fill_1
XFILLER_86_138 VPWR VGND sg13cmos5l_decap_8
X_0417_ _0417_/Q Tile_X0Y1_FrameData[25] VGND VPWR Tile_X0Y1_FrameStrobe[2] latch
X_0348_ _0348_/Q Tile_X0Y1_FrameData[30] VGND VPWR Tile_X0Y1_FrameStrobe[0] latch
XFILLER_94_193 VPWR VGND sg13cmos5l_decap_8
X_0279_ _0279_/Q Tile_X0Y0_FrameData[5] VGND VPWR Tile_X0Y1_FrameStrobe[5] latch
XFILLER_128_45 VPWR VGND sg13cmos5l_decap_8
XFILLER_6_109 VPWR VGND sg13cmos5l_fill_2
XANTENNA__0729__X Tile_X0Y0_W2BEG[6] VPWR VGND sg13cmos5l_antennanp
XFILLER_88_38 VPWR VGND sg13cmos5l_fill_2
XFILLER_18_216 VPWR VGND sg13cmos5l_fill_2
XFILLER_37_31 VPWR VGND sg13cmos5l_decap_8
XFILLER_85_193 VPWR VGND sg13cmos5l_decap_8
XFILLER_139_184 VPWR VGND sg13cmos5l_fill_1
XFILLER_53_30 VPWR VGND sg13cmos5l_decap_8
XFILLER_5_120 VPWR VGND sg13cmos5l_decap_8
XFILLER_5_197 VPWR VGND sg13cmos5l_decap_8
XFILLER_76_171 VPWR VGND sg13cmos5l_decap_8
XFILLER_83_108 VPWR VGND sg13cmos5l_decap_8
X_1182_ _1182_/X Tile_X0Y1_N4END[3] Tile_X0Y0_S4END[7] _1211_/X _1215_/X _0452_/Q
+ _0451_/Q VPWR VGND sg13cmos5l_mux4_1
X_0202_ _0202_/Q Tile_X0Y0_FrameData[18] VGND VPWR Tile_X0Y1_FrameStrobe[3] latch
X_0133_ _0133_/Q Tile_X0Y0_FrameData[23] VGND VPWR Tile_X0Y1_FrameStrobe[1] latch
XFILLER_94_92 VPWR VGND sg13cmos5l_decap_8
XFILLER_91_174 VPWR VGND sg13cmos5l_decap_8
XFILLER_71_0 VPWR VGND sg13cmos5l_decap_8
X_0897_ Tile_X0Y1_S2BEG[5] _1132_/X VPWR VGND sg13cmos5l_buf_1
X_0966_ Tile_X0Y1_WW4BEG[9] _1172_/X VPWR VGND sg13cmos5l_buf_1
XFILLER_101_202 VPWR VGND sg13cmos5l_decap_8
XFILLER_82_163 VPWR VGND sg13cmos5l_decap_8
XFILLER_130_79 VPWR VGND sg13cmos5l_decap_8
XFILLER_23_11 VPWR VGND sg13cmos5l_fill_1
XFILLER_23_44 VPWR VGND sg13cmos5l_decap_8
XFILLER_90_39 VPWR VGND sg13cmos5l_decap_8
XFILLER_136_154 VPWR VGND sg13cmos5l_decap_8
XFILLER_139_99 VPWR VGND sg13cmos5l_decap_4
XFILLER_2_134 VPWR VGND sg13cmos5l_decap_4
XFILLER_2_145 VPWR VGND sg13cmos5l_fill_1
XFILLER_48_96 VPWR VGND sg13cmos5l_decap_8
XFILLER_104_91 VPWR VGND sg13cmos5l_decap_8
XFILLER_64_73 VPWR VGND sg13cmos5l_decap_8
XFILLER_73_130 VPWR VGND sg13cmos5l_decap_8
XANTENNA__0922__X Tile_X0Y1_S4BEG[14] VPWR VGND sg13cmos5l_antennanp
X_0820_ Tile_X0Y0_FrameStrobe_O[17] Tile_X0Y1_FrameStrobe[17] VPWR VGND sg13cmos5l_buf_1
X_0751_ Tile_X0Y0_N4BEG[0] Tile_X0Y1_N4END[8] VPWR VGND sg13cmos5l_buf_1
XFILLER_9_68 VPWR VGND sg13cmos5l_decap_4
XFILLER_9_46 VPWR VGND sg13cmos5l_decap_4
XFILLER_29_2 VPWR VGND sg13cmos5l_fill_1
X_0682_ _0682_/L_HI VPWR VGND sg13cmos5l_tiehi
XFILLER_96_211 VPWR VGND sg13cmos5l_decap_8
X_1096_ _1096_/X _1107_/X Tile_X0Y1_N2MID[4] Tile_X0Y0_S2MID[4] Tile_X0Y0_S2END[4]
+ _0108_/Q _0107_/Q VPWR VGND sg13cmos5l_mux4_1
X_1234_ _1234_/X Tile_X0Y0_E1END[2] Tile_X0Y0_E6END[2] _1102_/X _1234_/A3 _0150_/Q
+ _0149_/Q VPWR VGND sg13cmos5l_mux4_1
X_1165_ _1165_/X _0646_/Q _0650_/Q _1216_/X _1200_/X _0486_/Q _0485_/Q VPWR VGND sg13cmos5l_mux4_1
X_0116_ _0116_/Q Tile_X0Y0_FrameData[8] VGND VPWR Tile_X0Y1_FrameStrobe[0] latch
XANTENNA__0832__X Tile_X0Y1_FrameData_O[8] VPWR VGND sg13cmos5l_antennanp
XFILLER_100_27 VPWR VGND sg13cmos5l_decap_8
XFILLER_109_14 VPWR VGND sg13cmos5l_fill_1
XFILLER_109_47 VPWR VGND sg13cmos5l_decap_8
XFILLER_118_198 VPWR VGND sg13cmos5l_decap_8
XFILLER_133_102 VPWR VGND sg13cmos5l_decap_8
X_0949_ Tile_X0Y1_W6BEG[4] _1183_/X VPWR VGND sg13cmos5l_buf_1
XFILLER_133_179 VPWR VGND sg13cmos5l_decap_8
XFILLER_141_12 VPWR VGND sg13cmos5l_decap_8
XFILLER_141_45 VPWR VGND sg13cmos5l_decap_8
XFILLER_70_133 VPWR VGND sg13cmos5l_decap_8
XANTENNA__0742__X Tile_X0Y0_W6BEG[3] VPWR VGND sg13cmos5l_antennanp
XFILLER_119_0 VPWR VGND sg13cmos5l_decap_4
XFILLER_50_53 VPWR VGND sg13cmos5l_fill_1
XFILLER_7_204 VPWR VGND sg13cmos5l_fill_2
XFILLER_109_176 VPWR VGND sg13cmos5l_fill_2
XFILLER_124_168 VPWR VGND sg13cmos5l_decap_8
XFILLER_1_0 VPWR VGND sg13cmos5l_decap_8
XFILLER_78_211 VPWR VGND sg13cmos5l_decap_8
XANTENNA__0917__X Tile_X0Y1_S4BEG[9] VPWR VGND sg13cmos5l_antennanp
XFILLER_61_166 VPWR VGND sg13cmos5l_decap_8
X_0803_ Tile_X0Y0_FrameStrobe_O[0] Tile_X0Y1_FrameStrobe[0] VPWR VGND sg13cmos5l_buf_1
X_0734_ Tile_X0Y0_W2BEGb[3] _1042_/X VPWR VGND sg13cmos5l_buf_1
X_0665_ _0665_/L_HI VPWR VGND sg13cmos5l_tiehi
XFILLER_130_149 VPWR VGND sg13cmos5l_decap_8
X_0596_ _0596_/Q Tile_X0Y1_FrameData[6] VGND VPWR Tile_X0Y1_FrameStrobe[7] latch
XANTENNA__0827__X Tile_X0Y1_FrameData_O[3] VPWR VGND sg13cmos5l_antennanp
XFILLER_52_111 VPWR VGND sg13cmos5l_decap_8
X_1079_ _1079_/X _1114_/X Tile_X0Y1_N4END[7] Tile_X0Y0_S1END[3] Tile_X0Y0_S4END[3]
+ _0118_/Q _0117_/Q VPWR VGND sg13cmos5l_mux4_1
X_1217_ _1217_/X Tile_X0Y1_N1END[2] Tile_X0Y1_N4END[2] _1229_/X Tile_X0Y0_S4END[6]
+ _0374_/Q _0373_/Q VPWR VGND sg13cmos5l_mux4_1
X_1148_ _1148_/X Tile_X0Y1_E2MID[3] _0645_/Q _1196_/X _1201_/X _0520_/Q _0519_/Q VPWR
+ VGND sg13cmos5l_mux4_1
XFILLER_136_56 VPWR VGND sg13cmos5l_decap_8
XFILLER_20_34 VPWR VGND sg13cmos5l_decap_8
XANTENNA__0737__X Tile_X0Y0_W2BEGb[6] VPWR VGND sg13cmos5l_antennanp
XFILLER_28_130 VPWR VGND sg13cmos5l_fill_1
XFILLER_43_100 VPWR VGND sg13cmos5l_decap_8
XFILLER_75_214 VPWR VGND sg13cmos5l_decap_4
XFILLER_43_111 VPWR VGND sg13cmos5l_fill_2
XFILLER_45_53 VPWR VGND sg13cmos5l_decap_4
XANTENNA_7 Tile_X0Y0_S2MID[0] VPWR VGND sg13cmos5l_antennanp
XFILLER_61_96 VPWR VGND sg13cmos5l_decap_8
XFILLER_112_116 VPWR VGND sg13cmos5l_fill_2
XFILLER_112_149 VPWR VGND sg13cmos5l_decap_8
XFILLER_86_71 VPWR VGND sg13cmos5l_decap_8
X_0450_ _0450_/Q Tile_X0Y1_FrameData[24] VGND VPWR Tile_X0Y1_FrameStrobe[3] latch
X_0381_ _0381_/Q Tile_X0Y1_FrameData[29] VGND VPWR Tile_X0Y1_FrameStrobe[1] latch
XFILLER_19_130 VPWR VGND sg13cmos5l_fill_2
XFILLER_19_174 VPWR VGND sg13cmos5l_decap_8
XFILLER_34_100 VPWR VGND sg13cmos5l_decap_8
XFILLER_81_217 VPWR VGND sg13cmos5l_fill_1
X_1002_ _1002_/X Tile_X0Y0_E1END[3] Tile_X0Y0_E6END[7] _1079_/X _1078_/X _0340_/Q
+ _0339_/Q VPWR VGND sg13cmos5l_mux4_1
X_0717_ _0974_/A3 VPWR VGND sg13cmos5l_tielo
X_0648_ _0648_/Q Tile_X0Y1_UserCLK NPU_ACT_RDATA4 _0675_/L_HI VPWR VGND sg13cmos5l_dfrbpq_1
XFILLER_111_171 VPWR VGND sg13cmos5l_decap_4
XFILLER_122_25 VPWR VGND sg13cmos5l_decap_8
XFILLER_72_217 VPWR VGND sg13cmos5l_fill_1
X_0579_ _0579_/Q Tile_X0Y1_FrameData[23] VGND VPWR Tile_X0Y1_FrameStrobe[7] latch
XFILLER_15_34 VPWR VGND sg13cmos5l_fill_2
XFILLER_40_103 VPWR VGND sg13cmos5l_decap_8
XFILLER_31_11 VPWR VGND sg13cmos5l_fill_2
XFILLER_31_77 VPWR VGND sg13cmos5l_decap_8
XFILLER_48_203 VPWR VGND sg13cmos5l_fill_1
XFILLER_102_193 VPWR VGND sg13cmos5l_decap_8
XFILLER_63_217 VPWR VGND sg13cmos5l_fill_1
XANTENNA__0930__X Tile_X0Y1_W2BEG[1] VPWR VGND sg13cmos5l_antennanp
X_0502_ _0502_/Q Tile_X0Y1_FrameData[4] VGND VPWR Tile_X0Y1_FrameStrobe[4] latch
XFILLER_54_217 VPWR VGND sg13cmos5l_fill_1
X_0433_ _0433_/Q Tile_X0Y1_FrameData[9] VGND VPWR Tile_X0Y1_FrameStrobe[2] latch
X_0364_ _0364_/Q Tile_X0Y1_FrameData[14] VGND VPWR Tile_X0Y1_FrameStrobe[0] latch
X_0295_ _0295_/Q Tile_X0Y0_FrameData[21] VGND VPWR Tile_X0Y1_FrameStrobe[6] latch
XANTENNA__0840__X Tile_X0Y1_FrameData_O[16] VPWR VGND sg13cmos5l_antennanp
XFILLER_117_47 VPWR VGND sg13cmos5l_decap_8
XFILLER_45_217 VPWR VGND sg13cmos5l_fill_1
XFILLER_13_125 VPWR VGND sg13cmos5l_fill_1
XFILLER_13_136 VPWR VGND sg13cmos5l_decap_8
XFILLER_26_99 VPWR VGND sg13cmos5l_decap_8
XFILLER_42_65 VPWR VGND sg13cmos5l_fill_2
XANTENNA__0750__X Tile_X0Y0_W6BEG[11] VPWR VGND sg13cmos5l_antennanp
XFILLER_101_0 VPWR VGND sg13cmos5l_decap_8
XFILLER_95_128 VPWR VGND sg13cmos5l_decap_8
XFILLER_88_180 VPWR VGND sg13cmos5l_decap_8
XANTENNA__0925__X Tile_X0Y1_W1BEG[0] VPWR VGND sg13cmos5l_antennanp
XFILLER_83_94 VPWR VGND sg13cmos5l_decap_8
X_0080_ _0923_/A _1141_/X _1142_/X _0531_/Q VPWR VGND sg13cmos5l_mux2_1
X_0982_ _0982_/X Tile_X0Y1_EE4END[0] Tile_X0Y1_EE4END[8] Tile_X0Y1_E6END[0] _1203_/X
+ _0434_/Q _0433_/Q VPWR VGND sg13cmos5l_mux4_1
XFILLER_8_162 VPWR VGND sg13cmos5l_decap_8
XANTENNA__0835__X Tile_X0Y1_FrameData_O[11] VPWR VGND sg13cmos5l_antennanp
XFILLER_27_217 VPWR VGND sg13cmos5l_fill_1
X_0416_ _0416_/Q Tile_X0Y1_FrameData[26] VGND VPWR Tile_X0Y1_FrameStrobe[2] latch
X_0347_ _0347_/Q Tile_X0Y0_FrameData[31] VGND VPWR Tile_X0Y1_FrameStrobe[0] latch
X_0278_ _0278_/Q Tile_X0Y0_FrameData[6] VGND VPWR Tile_X0Y1_FrameStrobe[5] latch
XFILLER_10_139 VPWR VGND sg13cmos5l_decap_4
XFILLER_128_13 VPWR VGND sg13cmos5l_decap_4
XFILLER_128_35 VPWR VGND sg13cmos5l_decap_8
XFILLER_85_150 VPWR VGND sg13cmos5l_decap_8
XANTENNA__0745__X Tile_X0Y0_W6BEG[6] VPWR VGND sg13cmos5l_antennanp
XFILLER_139_141 VPWR VGND sg13cmos5l_fill_1
XFILLER_53_86 VPWR VGND sg13cmos5l_decap_8
XFILLER_110_214 VPWR VGND sg13cmos5l_decap_4
XFILLER_38_7 VPWR VGND sg13cmos5l_fill_1
XFILLER_5_176 VPWR VGND sg13cmos5l_decap_8
X_1181_ _1181_/X Tile_X0Y1_N4END[2] Tile_X0Y0_S4END[6] _1212_/X _1216_/X _0454_/Q
+ _0453_/Q VPWR VGND sg13cmos5l_mux4_1
X_0201_ _0201_/Q Tile_X0Y0_FrameData[19] VGND VPWR Tile_X0Y1_FrameStrobe[3] latch
X_0132_ _0132_/Q Tile_X0Y0_FrameData[24] VGND VPWR Tile_X0Y1_FrameStrobe[1] latch
XFILLER_91_153 VPWR VGND sg13cmos5l_decap_8
XFILLER_91_197 VPWR VGND sg13cmos5l_fill_1
XFILLER_64_0 VPWR VGND sg13cmos5l_decap_8
X_0896_ Tile_X0Y1_S2BEG[4] _1131_/X VPWR VGND sg13cmos5l_buf_1
X_0965_ Tile_X0Y1_WW4BEG[8] _1171_/X VPWR VGND sg13cmos5l_buf_1
XFILLER_114_15 VPWR VGND sg13cmos5l_decap_8
XFILLER_114_26 VPWR VGND sg13cmos5l_decap_8
XFILLER_4_91 VPWR VGND sg13cmos5l_decap_4
XFILLER_130_36 VPWR VGND sg13cmos5l_fill_1
XFILLER_67_161 VPWR VGND sg13cmos5l_fill_2
XFILLER_82_142 VPWR VGND sg13cmos5l_decap_8
XFILLER_136_133 VPWR VGND sg13cmos5l_decap_8
XFILLER_139_78 VPWR VGND sg13cmos5l_decap_8
XFILLER_23_23 VPWR VGND sg13cmos5l_decap_8
XFILLER_99_38 VPWR VGND sg13cmos5l_fill_2
XFILLER_136_199 VPWR VGND sg13cmos5l_decap_8
XFILLER_0_49 VPWR VGND sg13cmos5l_decap_4
XFILLER_104_70 VPWR VGND sg13cmos5l_decap_8
XFILLER_48_42 VPWR VGND sg13cmos5l_decap_8
XFILLER_48_53 VPWR VGND sg13cmos5l_decap_8
XFILLER_48_75 VPWR VGND sg13cmos5l_fill_2
XFILLER_73_186 VPWR VGND sg13cmos5l_decap_8
XFILLER_80_40 VPWR VGND sg13cmos5l_decap_4
XFILLER_127_177 VPWR VGND sg13cmos5l_decap_8
XFILLER_127_188 VPWR VGND sg13cmos5l_fill_1
X_0750_ Tile_X0Y0_W6BEG[11] _1074_/X VPWR VGND sg13cmos5l_buf_1
X_0681_ _0681_/L_HI VPWR VGND sg13cmos5l_tiehi
XFILLER_1_190 VPWR VGND sg13cmos5l_fill_1
XFILLER_56_109 VPWR VGND sg13cmos5l_decap_8
X_1233_ _1233_/X Tile_X0Y0_EE4END[2] Tile_X0Y0_EE4END[10] Tile_X0Y0_E6END[2] _1090_/X
+ _0174_/Q _0173_/Q VPWR VGND sg13cmos5l_mux4_1
XFILLER_64_153 VPWR VGND sg13cmos5l_decap_4
X_1095_ _1095_/X _1106_/X Tile_X0Y1_N2MID[3] Tile_X0Y0_S2MID[3] Tile_X0Y0_S2END[3]
+ _0110_/Q _0109_/Q VPWR VGND sg13cmos5l_mux4_1
X_1164_ _1164_/X _0645_/Q _0649_/Q _1217_/X _1201_/X _0488_/Q _0487_/Q VPWR VGND sg13cmos5l_mux4_1
X_0115_ _0115_/Q Tile_X0Y0_FrameData[9] VGND VPWR Tile_X0Y1_FrameStrobe[0] latch
X_0948_ Tile_X0Y1_W6BEG[3] _1182_/X VPWR VGND sg13cmos5l_buf_1
XFILLER_109_26 VPWR VGND sg13cmos5l_decap_8
XFILLER_118_177 VPWR VGND sg13cmos5l_decap_8
XFILLER_133_158 VPWR VGND sg13cmos5l_decap_8
X_0879_ Tile_X0Y0_FrameData_O[23] Tile_X0Y0_FrameData[23] VPWR VGND sg13cmos5l_buf_1
XFILLER_18_89 VPWR VGND sg13cmos5l_fill_2
XFILLER_34_55 VPWR VGND sg13cmos5l_decap_8
XFILLER_34_66 VPWR VGND sg13cmos5l_fill_2
XFILLER_70_112 VPWR VGND sg13cmos5l_decap_8
XFILLER_124_147 VPWR VGND sg13cmos5l_decap_8
XFILLER_93_204 VPWR VGND sg13cmos5l_fill_2
XFILLER_75_62 VPWR VGND sg13cmos5l_fill_1
XANTENNA__0933__X Tile_X0Y1_W2BEG[4] VPWR VGND sg13cmos5l_antennanp
XFILLER_61_145 VPWR VGND sg13cmos5l_decap_8
X_0802_ Tile_X0Y0_N1BEG[3] _1002_/X VPWR VGND sg13cmos5l_buf_1
XFILLER_91_83 VPWR VGND sg13cmos5l_decap_8
X_0733_ Tile_X0Y0_W2BEGb[2] _1041_/X VPWR VGND sg13cmos5l_buf_1
X_0664_ _0664_/L_HI VPWR VGND sg13cmos5l_tiehi
XFILLER_130_128 VPWR VGND sg13cmos5l_decap_8
XFILLER_27_0 VPWR VGND sg13cmos5l_decap_4
XFILLER_84_215 VPWR VGND sg13cmos5l_fill_2
X_1216_ _1216_/X Tile_X0Y1_N1END[1] Tile_X0Y1_N4END[1] _1228_/X Tile_X0Y0_S4END[5]
+ _0376_/Q _0375_/Q VPWR VGND sg13cmos5l_mux4_1
X_0595_ _0595_/Q Tile_X0Y1_FrameData[7] VGND VPWR Tile_X0Y1_FrameStrobe[7] latch
XANTENNA__0843__X Tile_X0Y1_FrameData_O[19] VPWR VGND sg13cmos5l_antennanp
XFILLER_111_16 VPWR VGND sg13cmos5l_fill_1
XFILLER_111_38 VPWR VGND sg13cmos5l_decap_8
XFILLER_37_186 VPWR VGND sg13cmos5l_fill_1
XFILLER_52_167 VPWR VGND sg13cmos5l_decap_4
X_1078_ _1078_/X _1114_/X Tile_X0Y0_E6END[3] Tile_X0Y0_S1END[3] _1078_/A3 _0094_/Q
+ _0347_/Q VPWR VGND sg13cmos5l_mux4_1
X_1147_ _1147_/X Tile_X0Y1_E2MID[0] _0644_/Q _1195_/X _1202_/X _0522_/Q _0521_/Q VPWR
+ VGND sg13cmos5l_mux4_1
XFILLER_138_217 VPWR VGND sg13cmos5l_fill_1
XFILLER_20_13 VPWR VGND sg13cmos5l_decap_8
XFILLER_105_7 VPWR VGND sg13cmos5l_fill_1
XFILLER_106_158 VPWR VGND sg13cmos5l_decap_4
XFILLER_121_128 VPWR VGND sg13cmos5l_decap_8
XFILLER_121_139 VPWR VGND sg13cmos5l_decap_8
XFILLER_43_123 VPWR VGND sg13cmos5l_decap_8
XANTENNA__0753__X Tile_X0Y0_N4BEG[2] VPWR VGND sg13cmos5l_antennanp
XFILLER_101_60 VPWR VGND sg13cmos5l_decap_8
XFILLER_101_93 VPWR VGND sg13cmos5l_decap_8
XFILLER_129_217 VPWR VGND sg13cmos5l_fill_1
XFILLER_131_0 VPWR VGND sg13cmos5l_decap_8
XFILLER_61_64 VPWR VGND sg13cmos5l_decap_8
XANTENNA_8 Tile_X0Y0_S2MID[1] VPWR VGND sg13cmos5l_antennanp
XFILLER_6_59 VPWR VGND sg13cmos5l_decap_8
XANTENNA__0928__X Tile_X0Y1_W1BEG[3] VPWR VGND sg13cmos5l_antennanp
XFILLER_86_50 VPWR VGND sg13cmos5l_decap_8
X_0380_ _0380_/Q Tile_X0Y1_FrameData[30] VGND VPWR Tile_X0Y1_FrameStrobe[1] latch
XFILLER_19_153 VPWR VGND sg13cmos5l_decap_8
XFILLER_34_167 VPWR VGND sg13cmos5l_fill_2
X_1001_ _1001_/X Tile_X0Y0_E1END[2] Tile_X0Y0_E6END[6] _1077_/X _1102_/X _0342_/Q
+ _0341_/Q VPWR VGND sg13cmos5l_mux4_1
XANTENNA__0612__Q NPU_WEIGHT_IN2 VPWR VGND sg13cmos5l_antennanp
XFILLER_103_106 VPWR VGND sg13cmos5l_fill_2
X_0716_ _0975_/A3 VPWR VGND sg13cmos5l_tielo
X_0647_ _0647_/Q Tile_X0Y1_UserCLK NPU_ACT_RDATA3 _0677_/L_HI VPWR VGND sg13cmos5l_dfrbpq_1
X_0578_ _0578_/Q Tile_X0Y1_FrameData[24] VGND VPWR Tile_X0Y1_FrameStrobe[7] latch
XANTENNA__0838__X Tile_X0Y1_FrameData_O[14] VPWR VGND sg13cmos5l_antennanp
XFILLER_111_194 VPWR VGND sg13cmos5l_fill_2
XFILLER_15_46 VPWR VGND sg13cmos5l_decap_8
XFILLER_40_159 VPWR VGND sg13cmos5l_fill_2
XFILLER_103_4 VPWR VGND sg13cmos5l_fill_2
XFILLER_31_56 VPWR VGND sg13cmos5l_decap_8
XANTENNA__0748__X Tile_X0Y0_W6BEG[9] VPWR VGND sg13cmos5l_antennanp
XFILLER_56_75 VPWR VGND sg13cmos5l_decap_8
XFILLER_68_7 VPWR VGND sg13cmos5l_decap_8
X_0501_ _0501_/Q Tile_X0Y1_FrameData[5] VGND VPWR Tile_X0Y1_FrameStrobe[4] latch
X_0432_ _0432_/Q Tile_X0Y1_FrameData[10] VGND VPWR Tile_X0Y1_FrameStrobe[2] latch
X_0363_ _0363_/Q Tile_X0Y1_FrameData[15] VGND VPWR Tile_X0Y1_FrameStrobe[0] latch
X_0294_ _0294_/Q Tile_X0Y0_FrameData[22] VGND VPWR Tile_X0Y1_FrameStrobe[6] latch
XFILLER_94_0 VPWR VGND sg13cmos5l_decap_4
XFILLER_131_201 VPWR VGND sg13cmos5l_decap_4
XFILLER_97_192 VPWR VGND sg13cmos5l_decap_8
XFILLER_26_56 VPWR VGND sg13cmos5l_fill_2
XFILLER_26_78 VPWR VGND sg13cmos5l_decap_8
XFILLER_42_88 VPWR VGND sg13cmos5l_decap_4
XFILLER_9_108 VPWR VGND sg13cmos5l_decap_8
XFILLER_122_201 VPWR VGND sg13cmos5l_decap_8
XFILLER_107_81 VPWR VGND sg13cmos5l_fill_1
XFILLER_107_92 VPWR VGND sg13cmos5l_fill_2
XFILLER_3_49 VPWR VGND sg13cmos5l_decap_8
XFILLER_95_107 VPWR VGND sg13cmos5l_decap_8
X_0981_ _0981_/X Tile_X0Y0_E1END[0] Tile_X0Y0_E6END[0] _1100_/X _0981_/A3 _0154_/Q
+ _0153_/Q VPWR VGND sg13cmos5l_mux4_1
XANTENNA__0941__X Tile_X0Y1_W2BEGb[4] VPWR VGND sg13cmos5l_antennanp
XFILLER_12_181 VPWR VGND sg13cmos5l_decap_8
X_0415_ _0415_/Q Tile_X0Y1_FrameData[27] VGND VPWR Tile_X0Y1_FrameStrobe[2] latch
X_0346_ _0346_/Q Tile_X0Y0_FrameData[2] VGND VPWR Tile_X0Y1_FrameStrobe[7] latch
X_0277_ _0277_/Q Tile_X0Y0_FrameData[7] VGND VPWR Tile_X0Y1_FrameStrobe[5] latch
XANTENNA__0851__X Tile_X0Y1_FrameData_O[27] VPWR VGND sg13cmos5l_antennanp
XFILLER_10_107 VPWR VGND sg13cmos5l_fill_1
XFILLER_10_118 VPWR VGND sg13cmos5l_decap_8
XFILLER_50_210 VPWR VGND sg13cmos5l_decap_8
XFILLER_104_212 VPWR VGND sg13cmos5l_decap_4
XFILLER_77_118 VPWR VGND sg13cmos5l_decap_8
XANTENNA__0761__X Tile_X0Y0_N4BEG[10] VPWR VGND sg13cmos5l_antennanp
XFILLER_139_175 VPWR VGND sg13cmos5l_decap_8
XFILLER_139_197 VPWR VGND sg13cmos5l_fill_2
XFILLER_5_155 VPWR VGND sg13cmos5l_fill_2
XFILLER_68_107 VPWR VGND sg13cmos5l_fill_2
XANTENNA__0936__X Tile_X0Y1_W2BEG[7] VPWR VGND sg13cmos5l_antennanp
X_1180_ _1180_/X Tile_X0Y1_N4END[1] Tile_X0Y0_S4END[5] _1213_/X _1217_/X _0456_/Q
+ _0455_/Q VPWR VGND sg13cmos5l_mux4_1
X_0200_ _0200_/Q Tile_X0Y0_FrameData[20] VGND VPWR Tile_X0Y1_FrameStrobe[3] latch
X_0131_ _0131_/Q Tile_X0Y0_FrameData[25] VGND VPWR Tile_X0Y1_FrameStrobe[1] latch
XFILLER_91_132 VPWR VGND sg13cmos5l_decap_8
X_0964_ Tile_X0Y1_WW4BEG[7] _1170_/X VPWR VGND sg13cmos5l_buf_1
XANTENNA__0620__Q NPU_ACT_WDATA2 VPWR VGND sg13cmos5l_antennanp
XFILLER_57_0 VPWR VGND sg13cmos5l_fill_2
X_0895_ Tile_X0Y1_S2BEG[3] _1130_/X VPWR VGND sg13cmos5l_buf_1
XFILLER_99_210 VPWR VGND sg13cmos5l_decap_8
XANTENNA__0846__X Tile_X0Y1_FrameData_O[22] VPWR VGND sg13cmos5l_antennanp
XFILLER_4_70 VPWR VGND sg13cmos5l_decap_8
XFILLER_59_118 VPWR VGND sg13cmos5l_decap_8
XFILLER_67_140 VPWR VGND sg13cmos5l_decap_8
X_0329_ _0329_/Q Tile_X0Y0_FrameData[19] VGND VPWR Tile_X0Y1_FrameStrobe[7] latch
XFILLER_23_210 VPWR VGND sg13cmos5l_decap_8
XFILLER_82_121 VPWR VGND sg13cmos5l_decap_8
XFILLER_82_187 VPWR VGND sg13cmos5l_decap_8
XFILLER_82_198 VPWR VGND sg13cmos5l_fill_2
XFILLER_135_7 VPWR VGND sg13cmos5l_decap_8
XFILLER_136_112 VPWR VGND sg13cmos5l_decap_8
XFILLER_136_178 VPWR VGND sg13cmos5l_decap_8
XFILLER_2_103 VPWR VGND sg13cmos5l_fill_2
XFILLER_2_125 VPWR VGND sg13cmos5l_decap_4
XFILLER_48_21 VPWR VGND sg13cmos5l_decap_8
XANTENNA__0756__X Tile_X0Y0_N4BEG[5] VPWR VGND sg13cmos5l_antennanp
XFILLER_0_28 VPWR VGND sg13cmos5l_decap_8
XFILLER_48_65 VPWR VGND sg13cmos5l_fill_2
XFILLER_73_165 VPWR VGND sg13cmos5l_decap_8
XFILLER_127_156 VPWR VGND sg13cmos5l_decap_8
X_0680_ _0680_/L_HI VPWR VGND sg13cmos5l_tiehi
XFILLER_49_173 VPWR VGND sg13cmos5l_fill_2
X_1232_ _1232_/X Tile_X0Y0_EE4END[1] Tile_X0Y0_EE4END[9] Tile_X0Y0_E6END[1] _1089_/X
+ _0176_/Q _0175_/Q VPWR VGND sg13cmos5l_mux4_1
X_1094_ _1094_/X _1105_/X Tile_X0Y1_N2MID[2] Tile_X0Y0_S2MID[2] Tile_X0Y0_S2END[2]
+ _0112_/Q _0111_/Q VPWR VGND sg13cmos5l_mux4_1
X_1163_ _1163_/X _0644_/Q _0648_/Q _1218_/X _1202_/X _0490_/Q _0489_/Q VPWR VGND sg13cmos5l_mux4_1
X_0114_ _0114_/Q Tile_X0Y0_FrameData[10] VGND VPWR Tile_X0Y1_FrameStrobe[0] latch
XANTENNA__0615__Q NPU_WEIGHT_IN5 VPWR VGND sg13cmos5l_antennanp
XFILLER_118_101 VPWR VGND sg13cmos5l_fill_1
XFILLER_118_156 VPWR VGND sg13cmos5l_decap_8
XFILLER_20_213 VPWR VGND sg13cmos5l_decap_4
X_0947_ Tile_X0Y1_W6BEG[2] _1181_/X VPWR VGND sg13cmos5l_buf_1
XFILLER_133_137 VPWR VGND sg13cmos5l_decap_8
X_0878_ Tile_X0Y0_FrameData_O[22] Tile_X0Y0_FrameData[22] VPWR VGND sg13cmos5l_buf_1
XFILLER_18_13 VPWR VGND sg13cmos5l_fill_2
XFILLER_18_46 VPWR VGND sg13cmos5l_fill_1
XFILLER_18_68 VPWR VGND sg13cmos5l_decap_8
XFILLER_55_154 VPWR VGND sg13cmos5l_decap_8
XFILLER_70_168 VPWR VGND sg13cmos5l_decap_8
XFILLER_109_112 VPWR VGND sg13cmos5l_decap_8
XFILLER_109_145 VPWR VGND sg13cmos5l_decap_8
XFILLER_124_115 VPWR VGND sg13cmos5l_decap_4
XFILLER_124_126 VPWR VGND sg13cmos5l_decap_8
XFILLER_7_206 VPWR VGND sg13cmos5l_fill_1
XFILLER_7_217 VPWR VGND sg13cmos5l_fill_1
XFILLER_132_192 VPWR VGND sg13cmos5l_decap_8
XFILLER_59_64 VPWR VGND sg13cmos5l_fill_1
XFILLER_59_86 VPWR VGND sg13cmos5l_decap_4
XFILLER_59_97 VPWR VGND sg13cmos5l_decap_8
XFILLER_46_198 VPWR VGND sg13cmos5l_decap_8
XFILLER_61_124 VPWR VGND sg13cmos5l_decap_8
X_0801_ Tile_X0Y0_N1BEG[2] _1001_/X VPWR VGND sg13cmos5l_buf_1
XFILLER_98_7 VPWR VGND sg13cmos5l_fill_1
XFILLER_123_181 VPWR VGND sg13cmos5l_decap_8
XFILLER_130_107 VPWR VGND sg13cmos5l_decap_8
X_0732_ Tile_X0Y0_W2BEGb[1] _1040_/X VPWR VGND sg13cmos5l_buf_1
X_0663_ _0663_/L_HI VPWR VGND sg13cmos5l_tiehi
X_0594_ _0594_/Q Tile_X0Y1_FrameData[8] VGND VPWR Tile_X0Y1_FrameStrobe[7] latch
X_1215_ _1215_/X Tile_X0Y1_N1END[0] Tile_X0Y1_N4END[0] _1227_/X Tile_X0Y0_S4END[4]
+ _0378_/Q _0377_/Q VPWR VGND sg13cmos5l_mux4_1
X_1146_ _1146_/X Tile_X0Y1_N1END[3] _1230_/X _0645_/Q _0648_/Q _0524_/Q _0523_/Q VPWR
+ VGND sg13cmos5l_mux4_1
XFILLER_52_146 VPWR VGND sg13cmos5l_decap_8
X_1077_ _1077_/X _1113_/X Tile_X0Y1_N4END[6] Tile_X0Y0_S1END[2] Tile_X0Y0_S4END[2]
+ _0120_/Q _0119_/Q VPWR VGND sg13cmos5l_mux4_1
XFILLER_106_115 VPWR VGND sg13cmos5l_fill_1
XFILLER_136_14 VPWR VGND sg13cmos5l_decap_8
XFILLER_114_192 VPWR VGND sg13cmos5l_decap_8
XFILLER_29_56 VPWR VGND sg13cmos5l_fill_1
XFILLER_96_29 VPWR VGND sg13cmos5l_decap_8
XFILLER_28_187 VPWR VGND sg13cmos5l_decap_8
XFILLER_43_157 VPWR VGND sg13cmos5l_decap_4
XFILLER_124_0 VPWR VGND sg13cmos5l_decap_4
XFILLER_61_43 VPWR VGND sg13cmos5l_decap_8
XANTENNA_9 Tile_X0Y0_S2MID[1] VPWR VGND sg13cmos5l_antennanp
XFILLER_6_38 VPWR VGND sg13cmos5l_decap_8
XFILLER_120_184 VPWR VGND sg13cmos5l_decap_8
XFILLER_86_95 VPWR VGND sg13cmos5l_decap_8
X_1000_ _1000_/X Tile_X0Y0_E1END[1] Tile_X0Y0_E6END[5] _1076_/X _1101_/X _0344_/Q
+ _0343_/Q VPWR VGND sg13cmos5l_mux4_1
XANTENNA__0944__X Tile_X0Y1_W2BEGb[7] VPWR VGND sg13cmos5l_antennanp
XFILLER_34_146 VPWR VGND sg13cmos5l_decap_8
XFILLER_42_190 VPWR VGND sg13cmos5l_decap_8
X_0715_ _0976_/A3 VPWR VGND sg13cmos5l_tielo
XFILLER_106_28 VPWR VGND sg13cmos5l_decap_8
X_0646_ _0646_/Q Tile_X0Y1_UserCLK NPU_ACT_RDATA2 _0678_/L_HI VPWR VGND sg13cmos5l_dfrbpq_1
X_0577_ _0577_/Q Tile_X0Y1_FrameData[25] VGND VPWR Tile_X0Y1_FrameStrobe[7] latch
XANTENNA__0854__X Tile_X0Y1_FrameData_O[30] VPWR VGND sg13cmos5l_antennanp
XFILLER_25_135 VPWR VGND sg13cmos5l_decap_8
X_1129_ _1129_/X Tile_X0Y1_E2MID[5] Tile_X0Y1_E2END[5] Tile_X0Y1_E6END[10] _1197_/X
+ _0554_/Q _0553_/Q VPWR VGND sg13cmos5l_mux4_1
XFILLER_31_13 VPWR VGND sg13cmos5l_fill_1
XFILLER_40_138 VPWR VGND sg13cmos5l_decap_8
XFILLER_56_54 VPWR VGND sg13cmos5l_decap_8
XANTENNA__0764__X Tile_X0Y0_N4BEG[13] VPWR VGND sg13cmos5l_antennanp
XFILLER_31_105 VPWR VGND sg13cmos5l_decap_8
XFILLER_72_75 VPWR VGND sg13cmos5l_decap_8
XFILLER_125_210 VPWR VGND sg13cmos5l_decap_8
XANTENNA__0939__X Tile_X0Y1_W2BEGb[2] VPWR VGND sg13cmos5l_antennanp
X_0500_ _0500_/Q Tile_X0Y1_FrameData[6] VGND VPWR Tile_X0Y1_FrameStrobe[4] latch
X_0431_ _0431_/Q Tile_X0Y1_FrameData[11] VGND VPWR Tile_X0Y1_FrameStrobe[2] latch
X_0362_ _0362_/Q Tile_X0Y1_FrameData[16] VGND VPWR Tile_X0Y1_FrameStrobe[0] latch
XFILLER_97_50 VPWR VGND sg13cmos5l_fill_2
X_0293_ _0293_/Q Tile_X0Y0_FrameData[23] VGND VPWR Tile_X0Y1_FrameStrobe[6] latch
XANTENNA__0623__Q NPU_ACT_WDATA5 VPWR VGND sg13cmos5l_antennanp
XFILLER_22_149 VPWR VGND sg13cmos5l_decap_8
XFILLER_87_0 VPWR VGND sg13cmos5l_decap_8
XANTENNA__0849__X Tile_X0Y1_FrameData_O[25] VPWR VGND sg13cmos5l_antennanp
XFILLER_133_59 VPWR VGND sg13cmos5l_fill_1
X_0629_ NPU_ACT_ADDR3 Tile_X0Y1_UserCLK _0976_/X _0682_/L_HI VPWR VGND sg13cmos5l_dfrbpq_1
XFILLER_89_138 VPWR VGND sg13cmos5l_fill_2
XFILLER_26_13 VPWR VGND sg13cmos5l_fill_2
XFILLER_107_210 VPWR VGND sg13cmos5l_decap_8
XANTENNA__0759__X Tile_X0Y0_N4BEG[8] VPWR VGND sg13cmos5l_antennanp
XFILLER_3_28 VPWR VGND sg13cmos5l_decap_8
XFILLER_88_160 VPWR VGND sg13cmos5l_decap_8
XFILLER_67_42 VPWR VGND sg13cmos5l_decap_8
XFILLER_83_41 VPWR VGND sg13cmos5l_fill_1
X_0980_ _0980_/X Tile_X0Y0_E2MID[7] Tile_X0Y0_E2END[7] _1099_/X _0980_/A3 _0156_/Q
+ _0155_/Q VPWR VGND sg13cmos5l_mux4_1
XFILLER_8_197 VPWR VGND sg13cmos5l_fill_2
XFILLER_79_193 VPWR VGND sg13cmos5l_decap_4
X_0414_ _0414_/Q Tile_X0Y1_FrameData[28] VGND VPWR Tile_X0Y1_FrameStrobe[2] latch
X_0345_ _0345_/Q Tile_X0Y0_FrameData[3] VGND VPWR Tile_X0Y1_FrameStrobe[7] latch
XANTENNA__0618__Q NPU_ACT_WDATA0 VPWR VGND sg13cmos5l_antennanp
X_0276_ _0276_/Q Tile_X0Y0_FrameData[8] VGND VPWR Tile_X0Y1_FrameStrobe[5] latch
XFILLER_41_211 VPWR VGND sg13cmos5l_decap_8
XFILLER_53_44 VPWR VGND sg13cmos5l_decap_8
XFILLER_139_165 VPWR VGND sg13cmos5l_fill_2
XFILLER_5_134 VPWR VGND sg13cmos5l_decap_8
XFILLER_118_92 VPWR VGND sg13cmos5l_decap_8
XFILLER_76_185 VPWR VGND sg13cmos5l_decap_8
X_0130_ _0130_/Q Tile_X0Y0_FrameData[26] VGND VPWR Tile_X0Y1_FrameStrobe[1] latch
XFILLER_94_62 VPWR VGND sg13cmos5l_decap_8
XFILLER_91_188 VPWR VGND sg13cmos5l_decap_8
XFILLER_91_111 VPWR VGND sg13cmos5l_decap_8
XANTENNA__0952__X Tile_X0Y1_W6BEG[7] VPWR VGND sg13cmos5l_antennanp
X_0894_ Tile_X0Y1_S2BEG[2] _1129_/X VPWR VGND sg13cmos5l_buf_1
X_0963_ Tile_X0Y1_WW4BEG[6] _1169_/X VPWR VGND sg13cmos5l_buf_1
XFILLER_99_200 VPWR VGND sg13cmos5l_decap_8
XFILLER_101_216 VPWR VGND sg13cmos5l_fill_2
XFILLER_67_163 VPWR VGND sg13cmos5l_fill_1
XFILLER_67_185 VPWR VGND sg13cmos5l_decap_4
XFILLER_82_100 VPWR VGND sg13cmos5l_decap_8
X_0328_ _0328_/Q Tile_X0Y0_FrameData[20] VGND VPWR Tile_X0Y1_FrameStrobe[7] latch
XANTENNA__0862__X Tile_X0Y0_FrameData_O[6] VPWR VGND sg13cmos5l_antennanp
XFILLER_82_177 VPWR VGND sg13cmos5l_fill_2
X_0259_ _0259_/Q Tile_X0Y0_FrameData[25] VGND VPWR Tile_X0Y1_FrameStrobe[5] latch
XFILLER_136_168 VPWR VGND sg13cmos5l_decap_4
XFILLER_139_25 VPWR VGND sg13cmos5l_fill_2
XFILLER_23_58 VPWR VGND sg13cmos5l_decap_8
XFILLER_2_159 VPWR VGND sg13cmos5l_decap_8
XFILLER_48_77 VPWR VGND sg13cmos5l_fill_1
XFILLER_58_174 VPWR VGND sg13cmos5l_fill_1
XFILLER_64_21 VPWR VGND sg13cmos5l_decap_8
XFILLER_64_32 VPWR VGND sg13cmos5l_fill_1
XFILLER_64_87 VPWR VGND sg13cmos5l_decap_8
XFILLER_73_144 VPWR VGND sg13cmos5l_decap_8
XANTENNA__0772__X Tile_X0Y0_WW4BEG[5] VPWR VGND sg13cmos5l_antennanp
XFILLER_120_93 VPWR VGND sg13cmos5l_decap_8
XFILLER_80_86 VPWR VGND sg13cmos5l_decap_8
XFILLER_127_135 VPWR VGND sg13cmos5l_decap_8
XFILLER_43_7 VPWR VGND sg13cmos5l_fill_1
XFILLER_89_62 VPWR VGND sg13cmos5l_decap_8
XANTENNA__0947__X Tile_X0Y1_W6BEG[2] VPWR VGND sg13cmos5l_antennanp
X_1231_ _1231_/X Tile_X0Y0_EE4END[0] Tile_X0Y0_EE4END[8] Tile_X0Y0_E6END[0] _1088_/X
+ _0178_/Q _0177_/Q VPWR VGND sg13cmos5l_mux4_1
X_1162_ _1162_/X Tile_X0Y1_E2MID[5] _0651_/Q _1195_/X _1202_/X _0492_/Q _0491_/Q VPWR
+ VGND sg13cmos5l_mux4_1
X_1093_ _1093_/X _1104_/X Tile_X0Y1_N2MID[1] Tile_X0Y0_S2MID[1] Tile_X0Y0_S2END[1]
+ _0114_/Q _0113_/Q VPWR VGND sg13cmos5l_mux4_1
X_0113_ _0113_/Q Tile_X0Y0_FrameData[11] VGND VPWR Tile_X0Y1_FrameStrobe[0] latch
XANTENNA__0631__Q NPU_ACT_ADDR5 VPWR VGND sg13cmos5l_antennanp
XFILLER_118_113 VPWR VGND sg13cmos5l_decap_4
XFILLER_133_116 VPWR VGND sg13cmos5l_decap_8
X_0877_ Tile_X0Y0_FrameData_O[21] Tile_X0Y0_FrameData[21] VPWR VGND sg13cmos5l_buf_1
X_0946_ Tile_X0Y1_W6BEG[1] _1180_/X VPWR VGND sg13cmos5l_buf_1
XANTENNA__0857__X Tile_X0Y0_FrameData_O[1] VPWR VGND sg13cmos5l_antennanp
XFILLER_125_49 VPWR VGND sg13cmos5l_decap_8
XFILLER_126_190 VPWR VGND sg13cmos5l_decap_8
XFILLER_141_193 VPWR VGND sg13cmos5l_decap_8
XFILLER_141_26 VPWR VGND sg13cmos5l_fill_2
XFILLER_141_59 VPWR VGND sg13cmos5l_decap_8
XFILLER_34_13 VPWR VGND sg13cmos5l_fill_1
XFILLER_55_144 VPWR VGND sg13cmos5l_fill_2
XFILLER_34_35 VPWR VGND sg13cmos5l_decap_4
XFILLER_34_79 VPWR VGND sg13cmos5l_decap_8
XFILLER_70_147 VPWR VGND sg13cmos5l_decap_8
XFILLER_59_21 VPWR VGND sg13cmos5l_decap_8
XANTENNA__0767__X Tile_X0Y0_WW4BEG[0] VPWR VGND sg13cmos5l_antennanp
XFILLER_132_171 VPWR VGND sg13cmos5l_decap_8
XFILLER_75_53 VPWR VGND sg13cmos5l_decap_8
XFILLER_93_217 VPWR VGND sg13cmos5l_fill_1
XFILLER_93_206 VPWR VGND sg13cmos5l_fill_1
XFILLER_46_144 VPWR VGND sg13cmos5l_decap_4
XFILLER_46_177 VPWR VGND sg13cmos5l_decap_8
XFILLER_61_103 VPWR VGND sg13cmos5l_decap_8
X_0800_ Tile_X0Y0_N1BEG[1] _1000_/X VPWR VGND sg13cmos5l_buf_1
X_0731_ Tile_X0Y0_W2BEGb[0] _1039_/X VPWR VGND sg13cmos5l_buf_1
XFILLER_123_160 VPWR VGND sg13cmos5l_decap_8
X_0662_ _0662_/L_HI VPWR VGND sg13cmos5l_tiehi
X_0593_ _0593_/Q Tile_X0Y1_FrameData[9] VGND VPWR Tile_X0Y1_FrameStrobe[7] latch
XFILLER_52_125 VPWR VGND sg13cmos5l_decap_8
XFILLER_84_217 VPWR VGND sg13cmos5l_fill_1
X_1214_ _1214_/X Tile_X0Y1_N1END[3] Tile_X0Y1_N4END[3] _1230_/X Tile_X0Y0_S4END[7]
+ _0380_/Q _0379_/Q VPWR VGND sg13cmos5l_mux4_1
X_1145_ _1145_/X Tile_X0Y1_N1END[2] _1229_/X _0644_/Q _0649_/Q _0526_/Q _0525_/Q VPWR
+ VGND sg13cmos5l_mux4_1
XANTENNA__0626__Q NPU_ACT_ADDR0 VPWR VGND sg13cmos5l_antennanp
XFILLER_138_208 VPWR VGND sg13cmos5l_decap_8
XFILLER_60_180 VPWR VGND sg13cmos5l_fill_1
X_1076_ _1076_/X _1112_/X Tile_X0Y1_N4END[5] Tile_X0Y0_S1END[1] Tile_X0Y0_S4END[1]
+ _0122_/Q _0121_/Q VPWR VGND sg13cmos5l_mux4_1
X_0929_ Tile_X0Y1_W2BEG[0] _1147_/X VPWR VGND sg13cmos5l_buf_1
XFILLER_28_100 VPWR VGND sg13cmos5l_decap_4
XFILLER_28_166 VPWR VGND sg13cmos5l_decap_8
XFILLER_117_0 VPWR VGND sg13cmos5l_decap_8
XFILLER_105_182 VPWR VGND sg13cmos5l_decap_8
XFILLER_120_163 VPWR VGND sg13cmos5l_decap_8
XFILLER_19_188 VPWR VGND sg13cmos5l_decap_8
XFILLER_19_90 VPWR VGND sg13cmos5l_fill_1
XFILLER_34_114 VPWR VGND sg13cmos5l_fill_1
XFILLER_66_217 VPWR VGND sg13cmos5l_fill_1
XFILLER_86_85 VPWR VGND sg13cmos5l_decap_4
XANTENNA__0960__X Tile_X0Y1_WW4BEG[3] VPWR VGND sg13cmos5l_antennanp
XFILLER_34_125 VPWR VGND sg13cmos5l_decap_8
XFILLER_89_4 VPWR VGND sg13cmos5l_fill_2
X_0714_ _0977_/A3 VPWR VGND sg13cmos5l_tielo
X_0645_ _0645_/Q Tile_X0Y1_UserCLK NPU_ACT_RDATA1 _0676_/L_HI VPWR VGND sg13cmos5l_dfrbpq_1
XFILLER_103_108 VPWR VGND sg13cmos5l_fill_1
XFILLER_32_0 VPWR VGND sg13cmos5l_fill_2
XFILLER_57_217 VPWR VGND sg13cmos5l_fill_1
X_0576_ _0576_/Q Tile_X0Y1_FrameData[26] VGND VPWR Tile_X0Y1_FrameStrobe[7] latch
XFILLER_122_39 VPWR VGND sg13cmos5l_decap_8
XFILLER_25_114 VPWR VGND sg13cmos5l_decap_8
XFILLER_40_117 VPWR VGND sg13cmos5l_decap_8
X_1059_ _1059_/X _0636_/Q _0640_/Q _1091_/X _1095_/X _0210_/Q _0209_/Q VPWR VGND sg13cmos5l_mux4_1
X_1128_ _1128_/X Tile_X0Y1_E2MID[6] Tile_X0Y1_E2END[6] Tile_X0Y1_E6END[9] _1196_/X
+ _0556_/Q _0555_/Q VPWR VGND sg13cmos5l_mux4_1
XANTENNA__0091__Q NPU_XBAR_SEL1 VPWR VGND sg13cmos5l_antennanp
XANTENNA__0870__X Tile_X0Y0_FrameData_O[14] VPWR VGND sg13cmos5l_antennanp
XFILLER_31_25 VPWR VGND sg13cmos5l_decap_8
XFILLER_31_47 VPWR VGND sg13cmos5l_fill_2
XFILLER_48_217 VPWR VGND sg13cmos5l_fill_1
XANTENNA__0780__X Tile_X0Y0_WW4BEG[13] VPWR VGND sg13cmos5l_antennanp
XFILLER_112_83 VPWR VGND sg13cmos5l_fill_2
XFILLER_24_191 VPWR VGND sg13cmos5l_decap_8
XFILLER_31_139 VPWR VGND sg13cmos5l_decap_8
XFILLER_72_32 VPWR VGND sg13cmos5l_fill_1
XFILLER_72_98 VPWR VGND sg13cmos5l_decap_8
XFILLER_137_91 VPWR VGND sg13cmos5l_decap_8
XFILLER_39_217 VPWR VGND sg13cmos5l_fill_1
X_0430_ _0430_/Q Tile_X0Y1_FrameData[12] VGND VPWR Tile_X0Y1_FrameStrobe[2] latch
X_0361_ _0361_/Q Tile_X0Y1_FrameData[17] VGND VPWR Tile_X0Y1_FrameStrobe[0] latch
XANTENNA__0955__X Tile_X0Y1_W6BEG[10] VPWR VGND sg13cmos5l_antennanp
X_0292_ _0292_/Q Tile_X0Y0_FrameData[24] VGND VPWR Tile_X0Y1_FrameStrobe[6] latch
XFILLER_30_183 VPWR VGND sg13cmos5l_decap_8
XFILLER_7_82 VPWR VGND sg13cmos5l_decap_8
XFILLER_7_93 VPWR VGND sg13cmos5l_fill_1
X_0628_ NPU_ACT_ADDR2 Tile_X0Y1_UserCLK _0975_/X _0683_/L_HI VPWR VGND sg13cmos5l_dfrbpq_1
XANTENNA__0865__X Tile_X0Y0_FrameData_O[9] VPWR VGND sg13cmos5l_antennanp
XFILLER_133_38 VPWR VGND sg13cmos5l_fill_1
X_0559_ _0559_/Q Tile_X0Y1_FrameData[11] VGND VPWR Tile_X0Y1_FrameStrobe[6] latch
XFILLER_42_24 VPWR VGND sg13cmos5l_fill_2
XFILLER_67_21 VPWR VGND sg13cmos5l_decap_8
XFILLER_88_194 VPWR VGND sg13cmos5l_decap_8
XANTENNA__0775__X Tile_X0Y0_WW4BEG[8] VPWR VGND sg13cmos5l_antennanp
XFILLER_123_71 VPWR VGND sg13cmos5l_fill_1
XFILLER_67_87 VPWR VGND sg13cmos5l_decap_8
XFILLER_12_161 VPWR VGND sg13cmos5l_decap_8
XFILLER_12_172 VPWR VGND sg13cmos5l_fill_2
XFILLER_8_176 VPWR VGND sg13cmos5l_decap_8
XFILLER_79_172 VPWR VGND sg13cmos5l_decap_8
XFILLER_86_109 VPWR VGND sg13cmos5l_decap_8
X_0413_ _0413_/Q Tile_X0Y1_FrameData[29] VGND VPWR Tile_X0Y1_FrameStrobe[2] latch
X_0344_ _0344_/Q Tile_X0Y0_FrameData[4] VGND VPWR Tile_X0Y1_FrameStrobe[7] latch
X_0275_ _0275_/Q Tile_X0Y0_FrameData[9] VGND VPWR Tile_X0Y1_FrameStrobe[5] latch
XFILLER_94_186 VPWR VGND sg13cmos5l_decap_8
XANTENNA__0634__Q NPU_ACT_ADDR8 VPWR VGND sg13cmos5l_antennanp
XFILLER_85_186 VPWR VGND sg13cmos5l_decap_8
XFILLER_139_122 VPWR VGND sg13cmos5l_fill_2
XFILLER_5_157 VPWR VGND sg13cmos5l_fill_1
XFILLER_94_41 VPWR VGND sg13cmos5l_decap_8
XFILLER_94_85 VPWR VGND sg13cmos5l_decap_8
XFILLER_91_167 VPWR VGND sg13cmos5l_decap_8
X_0893_ Tile_X0Y1_S2BEG[1] _1128_/X VPWR VGND sg13cmos5l_buf_1
X_0962_ Tile_X0Y1_WW4BEG[5] _1168_/X VPWR VGND sg13cmos5l_buf_1
XANTENNA__0629__Q NPU_ACT_ADDR3 VPWR VGND sg13cmos5l_antennanp
XFILLER_82_156 VPWR VGND sg13cmos5l_decap_8
X_0327_ _0327_/Q Tile_X0Y0_FrameData[21] VGND VPWR Tile_X0Y1_FrameStrobe[7] latch
X_0258_ _0258_/Q Tile_X0Y0_FrameData[26] VGND VPWR Tile_X0Y1_FrameStrobe[5] latch
XFILLER_23_37 VPWR VGND sg13cmos5l_decap_8
X_0189_ _0189_/Q Tile_X0Y0_FrameData[31] VGND VPWR Tile_X0Y1_FrameStrobe[3] latch
XFILLER_136_147 VPWR VGND sg13cmos5l_decap_8
XFILLER_139_48 VPWR VGND sg13cmos5l_decap_4
XFILLER_2_116 VPWR VGND sg13cmos5l_fill_1
XFILLER_3_7 VPWR VGND sg13cmos5l_decap_8
XFILLER_48_67 VPWR VGND sg13cmos5l_fill_1
XFILLER_48_89 VPWR VGND sg13cmos5l_decap_8
XFILLER_104_84 VPWR VGND sg13cmos5l_decap_8
XFILLER_14_212 VPWR VGND sg13cmos5l_decap_4
XFILLER_64_66 VPWR VGND sg13cmos5l_decap_8
XFILLER_73_123 VPWR VGND sg13cmos5l_decap_8
XFILLER_129_81 VPWR VGND sg13cmos5l_decap_8
XFILLER_36_7 VPWR VGND sg13cmos5l_fill_1
XFILLER_96_204 VPWR VGND sg13cmos5l_decap_8
XFILLER_89_52 VPWR VGND sg13cmos5l_decap_4
XFILLER_64_101 VPWR VGND sg13cmos5l_decap_8
X_1092_ _1092_/X _1103_/X Tile_X0Y1_N2MID[0] Tile_X0Y0_S2MID[0] Tile_X0Y0_S2END[0]
+ _0116_/Q _0115_/Q VPWR VGND sg13cmos5l_mux4_1
X_1230_ _1230_/X Tile_X0Y0_E1END[3] Tile_X0Y0_E6END[11] _1079_/X _1078_/X _0304_/Q
+ _0303_/Q VPWR VGND sg13cmos5l_mux4_1
X_1161_ _1161_/X Tile_X0Y1_E2MID[2] _0650_/Q _1196_/X _1201_/X _0494_/Q _0493_/Q VPWR
+ VGND sg13cmos5l_mux4_1
X_0112_ _0112_/Q Tile_X0Y0_FrameData[12] VGND VPWR Tile_X0Y1_FrameStrobe[0] latch
XANTENNA__0963__X Tile_X0Y1_WW4BEG[6] VPWR VGND sg13cmos5l_antennanp
XFILLER_62_0 VPWR VGND sg13cmos5l_decap_8
X_0876_ Tile_X0Y0_FrameData_O[20] Tile_X0Y0_FrameData[20] VPWR VGND sg13cmos5l_buf_1
X_0945_ Tile_X0Y1_W6BEG[0] _1179_/X VPWR VGND sg13cmos5l_buf_1
XFILLER_141_150 VPWR VGND sg13cmos5l_fill_2
XFILLER_141_172 VPWR VGND sg13cmos5l_decap_8
XFILLER_87_204 VPWR VGND sg13cmos5l_fill_2
XANTENNA__0873__X Tile_X0Y0_FrameData_O[17] VPWR VGND sg13cmos5l_antennanp
XFILLER_141_38 VPWR VGND sg13cmos5l_decap_8
XFILLER_70_126 VPWR VGND sg13cmos5l_decap_8
XFILLER_109_169 VPWR VGND sg13cmos5l_decap_8
XFILLER_117_180 VPWR VGND sg13cmos5l_decap_8
XFILLER_132_150 VPWR VGND sg13cmos5l_decap_8
XFILLER_78_204 VPWR VGND sg13cmos5l_decap_8
XFILLER_115_72 VPWR VGND sg13cmos5l_fill_2
XANTENNA__0783__X Tile_X0Y0_N2BEGb[0] VPWR VGND sg13cmos5l_antennanp
XFILLER_131_82 VPWR VGND sg13cmos5l_decap_8
XFILLER_61_159 VPWR VGND sg13cmos5l_decap_8
XFILLER_91_97 VPWR VGND sg13cmos5l_decap_8
X_0730_ Tile_X0Y0_W2BEG[7] _1038_/X VPWR VGND sg13cmos5l_buf_1
X_0661_ _0661_/L_HI VPWR VGND sg13cmos5l_tiehi
XANTENNA__0958__X Tile_X0Y1_WW4BEG[1] VPWR VGND sg13cmos5l_antennanp
XFILLER_69_215 VPWR VGND sg13cmos5l_fill_2
X_1213_ _1213_/X Tile_X0Y1_N1END[2] Tile_X0Y1_N4END[2] _1229_/X Tile_X0Y0_S4END[6]
+ _0382_/Q _0381_/Q VPWR VGND sg13cmos5l_mux4_1
X_0592_ _0592_/Q Tile_X0Y1_FrameData[10] VGND VPWR Tile_X0Y1_FrameStrobe[7] latch
XFILLER_37_156 VPWR VGND sg13cmos5l_fill_2
XFILLER_52_104 VPWR VGND sg13cmos5l_decap_8
X_1075_ _1075_/X _1111_/X Tile_X0Y1_N4END[4] Tile_X0Y0_S1END[0] Tile_X0Y0_S4END[0]
+ _0124_/Q _0123_/Q VPWR VGND sg13cmos5l_mux4_1
X_1144_ _1144_/X Tile_X0Y1_N1END[1] _1228_/X _0647_/Q _0650_/Q _0528_/Q _0527_/Q VPWR
+ VGND sg13cmos5l_mux4_1
XANTENNA__0868__X Tile_X0Y0_FrameData_O[12] VPWR VGND sg13cmos5l_antennanp
XFILLER_121_109 VPWR VGND sg13cmos5l_fill_2
XFILLER_20_27 VPWR VGND sg13cmos5l_decap_8
X_0859_ Tile_X0Y0_FrameData_O[3] Tile_X0Y0_FrameData[3] VPWR VGND sg13cmos5l_buf_1
X_0928_ Tile_X0Y1_W1BEG[3] _1146_/X VPWR VGND sg13cmos5l_buf_1
XANTENNA__0089__Q NPU_ACT_WE VPWR VGND sg13cmos5l_antennanp
XFILLER_75_207 VPWR VGND sg13cmos5l_decap_8
XFILLER_101_74 VPWR VGND sg13cmos5l_fill_1
XFILLER_43_137 VPWR VGND sg13cmos5l_decap_4
XFILLER_45_46 VPWR VGND sg13cmos5l_decap_8
XFILLER_45_57 VPWR VGND sg13cmos5l_fill_1
XANTENNA__0778__X Tile_X0Y0_WW4BEG[11] VPWR VGND sg13cmos5l_antennanp
XFILLER_10_82 VPWR VGND sg13cmos5l_decap_4
XFILLER_112_109 VPWR VGND sg13cmos5l_decap_8
XFILLER_120_142 VPWR VGND sg13cmos5l_fill_2
XFILLER_126_82 VPWR VGND sg13cmos5l_decap_8
XFILLER_66_207 VPWR VGND sg13cmos5l_decap_8
XFILLER_86_64 VPWR VGND sg13cmos5l_decap_8
XFILLER_19_123 VPWR VGND sg13cmos5l_decap_8
XFILLER_19_167 VPWR VGND sg13cmos5l_decap_8
XFILLER_35_90 VPWR VGND sg13cmos5l_decap_8
X_0713_ _0978_/A3 VPWR VGND sg13cmos5l_tielo
X_0644_ _0644_/Q Tile_X0Y1_UserCLK NPU_ACT_RDATA0 _0671_/L_HI VPWR VGND sg13cmos5l_dfrbpq_1
XFILLER_106_19 VPWR VGND sg13cmos5l_fill_2
XFILLER_111_164 VPWR VGND sg13cmos5l_decap_8
XFILLER_111_175 VPWR VGND sg13cmos5l_fill_1
XFILLER_122_18 VPWR VGND sg13cmos5l_decap_8
XFILLER_25_0 VPWR VGND sg13cmos5l_fill_2
X_0575_ _0575_/Q Tile_X0Y1_FrameData[27] VGND VPWR Tile_X0Y1_FrameStrobe[7] latch
XFILLER_15_27 VPWR VGND sg13cmos5l_decap_8
XFILLER_33_181 VPWR VGND sg13cmos5l_decap_4
X_1058_ _1058_/X _0639_/Q _0643_/Q _1087_/X _1096_/X _0212_/Q _0211_/Q VPWR VGND sg13cmos5l_mux4_1
X_1127_ _1127_/X Tile_X0Y1_E2MID[7] Tile_X0Y1_E2END[7] Tile_X0Y1_E6END[8] _1195_/X
+ _0558_/Q _0557_/Q VPWR VGND sg13cmos5l_mux4_1
XFILLER_134_212 VPWR VGND sg13cmos5l_decap_4
XFILLER_0_203 VPWR VGND sg13cmos5l_fill_2
XFILLER_0_214 VPWR VGND sg13cmos5l_decap_4
XFILLER_102_186 VPWR VGND sg13cmos5l_decap_8
XFILLER_56_89 VPWR VGND sg13cmos5l_fill_2
XFILLER_71_210 VPWR VGND sg13cmos5l_decap_8
XFILLER_137_70 VPWR VGND sg13cmos5l_decap_8
X_0360_ _0360_/Q Tile_X0Y1_FrameData[18] VGND VPWR Tile_X0Y1_FrameStrobe[0] latch
X_0291_ _0291_/Q Tile_X0Y0_FrameData[25] VGND VPWR Tile_X0Y1_FrameStrobe[6] latch
XFILLER_97_52 VPWR VGND sg13cmos5l_fill_1
XANTENNA__0971__X Tile_X0Y1_WW4BEG[14] VPWR VGND sg13cmos5l_antennanp
XFILLER_22_118 VPWR VGND sg13cmos5l_fill_2
XFILLER_116_212 VPWR VGND sg13cmos5l_decap_4
XFILLER_15_192 VPWR VGND sg13cmos5l_decap_8
XFILLER_30_162 VPWR VGND sg13cmos5l_decap_8
X_0627_ NPU_ACT_ADDR1 Tile_X0Y1_UserCLK _0974_/X _0684_/L_HI VPWR VGND sg13cmos5l_dfrbpq_1
X_0558_ _0558_/Q Tile_X0Y1_FrameData[12] VGND VPWR Tile_X0Y1_FrameStrobe[6] latch
XFILLER_97_151 VPWR VGND sg13cmos5l_fill_1
XFILLER_97_140 VPWR VGND sg13cmos5l_decap_8
XFILLER_26_15 VPWR VGND sg13cmos5l_fill_1
X_0489_ _0489_/Q Tile_X0Y1_FrameData[17] VGND VPWR Tile_X0Y1_FrameStrobe[4] latch
XANTENNA__0881__X Tile_X0Y0_FrameData_O[25] VPWR VGND sg13cmos5l_antennanp
XFILLER_42_14 VPWR VGND sg13cmos5l_fill_2
XFILLER_122_215 VPWR VGND sg13cmos5l_fill_2
XFILLER_88_151 VPWR VGND sg13cmos5l_decap_4
XANTENNA__0791__X Tile_X0Y0_N2BEG[0] VPWR VGND sg13cmos5l_antennanp
XFILLER_83_87 VPWR VGND sg13cmos5l_decap_8
XFILLER_12_195 VPWR VGND sg13cmos5l_decap_8
XFILLER_32_80 VPWR VGND sg13cmos5l_decap_8
XFILLER_66_7 VPWR VGND sg13cmos5l_decap_8
XFILLER_8_155 VPWR VGND sg13cmos5l_decap_8
XFILLER_113_204 VPWR VGND sg13cmos5l_fill_2
XFILLER_79_151 VPWR VGND sg13cmos5l_decap_8
X_0412_ _0412_/Q Tile_X0Y1_FrameData[30] VGND VPWR Tile_X0Y1_FrameStrobe[2] latch
XFILLER_8_199 VPWR VGND sg13cmos5l_fill_1
XANTENNA__0966__X Tile_X0Y1_WW4BEG[9] VPWR VGND sg13cmos5l_antennanp
X_0343_ _0343_/Q Tile_X0Y0_FrameData[5] VGND VPWR Tile_X0Y1_FrameStrobe[7] latch
X_0274_ _0274_/Q Tile_X0Y0_FrameData[10] VGND VPWR Tile_X0Y1_FrameStrobe[5] latch
XFILLER_92_0 VPWR VGND sg13cmos5l_decap_4
XFILLER_128_28 VPWR VGND sg13cmos5l_decap_8
XANTENNA__0876__X Tile_X0Y0_FrameData_O[20] VPWR VGND sg13cmos5l_antennanp
XFILLER_85_143 VPWR VGND sg13cmos5l_decap_8
XFILLER_139_134 VPWR VGND sg13cmos5l_decap_8
XFILLER_53_79 VPWR VGND sg13cmos5l_decap_8
XFILLER_5_169 VPWR VGND sg13cmos5l_decap_8
XFILLER_78_32 VPWR VGND sg13cmos5l_decap_4
XANTENNA__0786__X Tile_X0Y0_N2BEGb[3] VPWR VGND sg13cmos5l_antennanp
XFILLER_110_207 VPWR VGND sg13cmos5l_decap_8
XFILLER_134_93 VPWR VGND sg13cmos5l_decap_8
XFILLER_17_210 VPWR VGND sg13cmos5l_decap_8
XFILLER_94_20 VPWR VGND sg13cmos5l_decap_8
X_0961_ Tile_X0Y1_WW4BEG[4] _1167_/X VPWR VGND sg13cmos5l_buf_1
XFILLER_91_146 VPWR VGND sg13cmos5l_decap_8
X_0892_ Tile_X0Y1_S2BEG[0] _1127_/X VPWR VGND sg13cmos5l_buf_1
XFILLER_4_84 VPWR VGND sg13cmos5l_decap_8
XFILLER_4_95 VPWR VGND sg13cmos5l_fill_1
XFILLER_23_202 VPWR VGND sg13cmos5l_fill_2
XFILLER_67_154 VPWR VGND sg13cmos5l_decap_8
XFILLER_82_135 VPWR VGND sg13cmos5l_decap_8
XFILLER_82_179 VPWR VGND sg13cmos5l_fill_1
X_0326_ _0326_/Q Tile_X0Y0_FrameData[22] VGND VPWR Tile_X0Y1_FrameStrobe[7] latch
X_0257_ _0257_/Q Tile_X0Y0_FrameData[27] VGND VPWR Tile_X0Y1_FrameStrobe[5] latch
X_0188_ _0188_/Q Tile_X0Y0_FrameData[0] VGND VPWR Tile_X0Y1_FrameStrobe[2] latch
XFILLER_139_27 VPWR VGND sg13cmos5l_fill_1
XFILLER_90_190 VPWR VGND sg13cmos5l_decap_8
XFILLER_136_126 VPWR VGND sg13cmos5l_decap_8
XFILLER_104_63 VPWR VGND sg13cmos5l_decap_8
XFILLER_48_35 VPWR VGND sg13cmos5l_decap_8
XFILLER_73_102 VPWR VGND sg13cmos5l_decap_8
XFILLER_73_179 VPWR VGND sg13cmos5l_decap_8
XFILLER_80_33 VPWR VGND sg13cmos5l_decap_8
XFILLER_89_31 VPWR VGND sg13cmos5l_decap_8
XFILLER_1_172 VPWR VGND sg13cmos5l_decap_8
XFILLER_49_110 VPWR VGND sg13cmos5l_fill_2
XFILLER_64_157 VPWR VGND sg13cmos5l_fill_1
X_1091_ _1091_/X _1114_/X Tile_X0Y1_N4END[7] Tile_X0Y0_S1END[3] Tile_X0Y0_S4END[3]
+ _0142_/Q _0141_/Q VPWR VGND sg13cmos5l_mux4_1
X_1160_ _1160_/X _0649_/Q _1197_/X _1200_/X _1194_/X _0496_/Q _0495_/Q VPWR VGND sg13cmos5l_mux4_1
X_0111_ _0111_/Q Tile_X0Y0_FrameData[13] VGND VPWR Tile_X0Y1_FrameStrobe[0] latch
XFILLER_20_205 VPWR VGND sg13cmos5l_fill_2
X_0944_ Tile_X0Y1_W2BEGb[7] _1162_/X VPWR VGND sg13cmos5l_buf_1
XFILLER_109_19 VPWR VGND sg13cmos5l_decap_8
XFILLER_55_0 VPWR VGND sg13cmos5l_fill_2
X_0875_ Tile_X0Y0_FrameData_O[19] Tile_X0Y0_FrameData[19] VPWR VGND sg13cmos5l_buf_1
XFILLER_11_205 VPWR VGND sg13cmos5l_fill_2
XFILLER_55_146 VPWR VGND sg13cmos5l_fill_1
XFILLER_70_105 VPWR VGND sg13cmos5l_decap_8
X_0309_ _0309_/Q Tile_X0Y0_FrameData[7] VGND VPWR Tile_X0Y1_FrameStrobe[6] latch
XFILLER_109_126 VPWR VGND sg13cmos5l_fill_2
XFILLER_109_159 VPWR VGND sg13cmos5l_fill_2
XFILLER_133_7 VPWR VGND sg13cmos5l_fill_2
XFILLER_75_77 VPWR VGND sg13cmos5l_fill_1
XFILLER_131_61 VPWR VGND sg13cmos5l_decap_8
XFILLER_61_138 VPWR VGND sg13cmos5l_decap_8
XFILLER_91_76 VPWR VGND sg13cmos5l_decap_8
XFILLER_91_21 VPWR VGND sg13cmos5l_decap_8
XFILLER_108_192 VPWR VGND sg13cmos5l_decap_8
XFILLER_40_80 VPWR VGND sg13cmos5l_decap_8
X_0660_ _0660_/L_HI VPWR VGND sg13cmos5l_tiehi
X_0591_ _0591_/Q Tile_X0Y1_FrameData[11] VGND VPWR Tile_X0Y1_FrameStrobe[7] latch
XFILLER_123_195 VPWR VGND sg13cmos5l_fill_1
XFILLER_27_4 VPWR VGND sg13cmos5l_fill_1
XFILLER_84_208 VPWR VGND sg13cmos5l_decap_8
X_1212_ _1212_/X Tile_X0Y1_N1END[1] Tile_X0Y1_N4END[1] _1228_/X Tile_X0Y0_S4END[5]
+ _0384_/Q _0383_/Q VPWR VGND sg13cmos5l_mux4_1
XFILLER_1_74 VPWR VGND sg13cmos5l_fill_2
XFILLER_37_179 VPWR VGND sg13cmos5l_decap_8
X_1074_ _1074_/X _0639_/Q _1088_/X _1087_/X _1099_/X _0180_/Q _0179_/Q VPWR VGND sg13cmos5l_mux4_1
X_1143_ _1143_/X Tile_X0Y1_N1END[0] _1227_/X _0646_/Q _0651_/Q _0530_/Q _0529_/Q VPWR
+ VGND sg13cmos5l_mux4_1
X_0927_ Tile_X0Y1_W1BEG[2] _1145_/X VPWR VGND sg13cmos5l_buf_1
XFILLER_114_140 VPWR VGND sg13cmos5l_decap_8
XFILLER_136_28 VPWR VGND sg13cmos5l_decap_4
X_0858_ Tile_X0Y0_FrameData_O[2] Tile_X0Y0_FrameData[2] VPWR VGND sg13cmos5l_buf_1
X_0789_ Tile_X0Y0_N2BEGb[6] _1109_/X VPWR VGND sg13cmos5l_buf_1
XANTENNA__0884__X Tile_X0Y0_FrameData_O[28] VPWR VGND sg13cmos5l_antennanp
XFILLER_101_53 VPWR VGND sg13cmos5l_decap_8
XFILLER_101_86 VPWR VGND sg13cmos5l_decap_8
XFILLER_61_57 VPWR VGND sg13cmos5l_decap_8
XFILLER_137_210 VPWR VGND sg13cmos5l_decap_8
XFILLER_105_162 VPWR VGND sg13cmos5l_decap_8
XFILLER_105_173 VPWR VGND sg13cmos5l_fill_2
XFILLER_120_121 VPWR VGND sg13cmos5l_decap_8
XFILLER_120_198 VPWR VGND sg13cmos5l_decap_8
XFILLER_126_61 VPWR VGND sg13cmos5l_decap_8
XFILLER_19_102 VPWR VGND sg13cmos5l_decap_8
XFILLER_86_43 VPWR VGND sg13cmos5l_decap_8
XANTENNA__0794__X Tile_X0Y0_N2BEG[3] VPWR VGND sg13cmos5l_antennanp
XFILLER_19_146 VPWR VGND sg13cmos5l_decap_8
XANTENNA__0969__X Tile_X0Y1_WW4BEG[12] VPWR VGND sg13cmos5l_antennanp
XFILLER_32_2 VPWR VGND sg13cmos5l_fill_1
X_0712_ _1191_/A3 VPWR VGND sg13cmos5l_tielo
X_0643_ _0643_/Q Tile_X0Y1_UserCLK NPU_OUT_ACT7 _0673_/L_HI VPWR VGND sg13cmos5l_dfrbpq_1
X_0574_ _0574_/Q Tile_X0Y1_FrameData[28] VGND VPWR Tile_X0Y1_FrameStrobe[7] latch
XFILLER_111_187 VPWR VGND sg13cmos5l_decap_8
XFILLER_18_0 VPWR VGND sg13cmos5l_fill_2
X_1126_ _1126_/X Tile_X0Y1_E1END[3] Tile_X0Y1_E6END[11] _1218_/X _1194_/X _0560_/Q
+ _0559_/Q VPWR VGND sg13cmos5l_mux4_1
XFILLER_15_39 VPWR VGND sg13cmos5l_decap_8
XFILLER_25_149 VPWR VGND sg13cmos5l_decap_4
X_1057_ _1057_/X _0638_/Q _0642_/Q _1086_/X _1097_/X _0214_/Q _0213_/Q VPWR VGND sg13cmos5l_mux4_1
XANTENNA__0879__X Tile_X0Y0_FrameData_O[23] VPWR VGND sg13cmos5l_antennanp
XFILLER_119_210 VPWR VGND sg13cmos5l_decap_8
XFILLER_112_85 VPWR VGND sg13cmos5l_fill_1
XFILLER_56_68 VPWR VGND sg13cmos5l_decap_8
XFILLER_122_0 VPWR VGND sg13cmos5l_decap_8
XFILLER_31_119 VPWR VGND sg13cmos5l_decap_4
XFILLER_72_89 VPWR VGND sg13cmos5l_decap_4
XANTENNA__0789__X Tile_X0Y0_N2BEGb[6] VPWR VGND sg13cmos5l_antennanp
XFILLER_125_202 VPWR VGND sg13cmos5l_decap_4
XFILLER_21_93 VPWR VGND sg13cmos5l_decap_4
X_0290_ _0290_/Q Tile_X0Y0_FrameData[26] VGND VPWR Tile_X0Y1_FrameStrobe[6] latch
XFILLER_15_171 VPWR VGND sg13cmos5l_decap_8
XFILLER_94_4 VPWR VGND sg13cmos5l_fill_2
XFILLER_30_141 VPWR VGND sg13cmos5l_decap_8
XFILLER_131_205 VPWR VGND sg13cmos5l_fill_2
X_0626_ NPU_ACT_ADDR0 Tile_X0Y1_UserCLK _0973_/X _0685_/L_HI VPWR VGND sg13cmos5l_dfrbpq_1
X_0557_ _0557_/Q Tile_X0Y1_FrameData[13] VGND VPWR Tile_X0Y1_FrameStrobe[6] latch
XFILLER_97_185 VPWR VGND sg13cmos5l_decap_8
XFILLER_89_108 VPWR VGND sg13cmos5l_fill_2
XFILLER_53_211 VPWR VGND sg13cmos5l_decap_8
X_1109_ _1109_/X Tile_X0Y1_E2MID[1] Tile_X0Y1_E2END[1] Tile_X0Y1_E6END[1] _1201_/X
+ _0582_/Q _0581_/Q VPWR VGND sg13cmos5l_mux4_1
X_0488_ _0488_/Q Tile_X0Y1_FrameData[18] VGND VPWR Tile_X0Y1_FrameStrobe[4] latch
XFILLER_107_85 VPWR VGND sg13cmos5l_decap_8
XFILLER_123_40 VPWR VGND sg13cmos5l_fill_2
XFILLER_88_174 VPWR VGND sg13cmos5l_fill_2
XFILLER_16_60 VPWR VGND sg13cmos5l_decap_4
XFILLER_44_211 VPWR VGND sg13cmos5l_decap_8
XFILLER_83_77 VPWR VGND sg13cmos5l_fill_2
XFILLER_59_7 VPWR VGND sg13cmos5l_decap_8
XFILLER_79_130 VPWR VGND sg13cmos5l_decap_8
X_0411_ _0411_/Q Tile_X0Y1_FrameData[31] VGND VPWR Tile_X0Y1_FrameStrobe[2] latch
X_0342_ _0342_/Q Tile_X0Y0_FrameData[6] VGND VPWR Tile_X0Y1_FrameStrobe[7] latch
X_0273_ _0273_/Q Tile_X0Y0_FrameData[11] VGND VPWR Tile_X0Y1_FrameStrobe[5] latch
XFILLER_94_144 VPWR VGND sg13cmos5l_decap_8
XFILLER_50_203 VPWR VGND sg13cmos5l_fill_1
XFILLER_85_0 VPWR VGND sg13cmos5l_fill_2
XFILLER_104_205 VPWR VGND sg13cmos5l_decap_8
XFILLER_104_216 VPWR VGND sg13cmos5l_fill_2
X_0609_ _0609_/Q Tile_X0Y1_FrameData[31] VGND VPWR Tile_X0Y1_FrameStrobe[8] latch
XANTENNA__0892__X Tile_X0Y1_S2BEG[0] VPWR VGND sg13cmos5l_antennanp
XFILLER_139_124 VPWR VGND sg13cmos5l_fill_1
XFILLER_5_148 VPWR VGND sg13cmos5l_decap_8
XFILLER_78_66 VPWR VGND sg13cmos5l_fill_2
XFILLER_134_72 VPWR VGND sg13cmos5l_decap_8
XFILLER_27_81 VPWR VGND sg13cmos5l_decap_8
XFILLER_76_199 VPWR VGND sg13cmos5l_decap_8
XFILLER_91_125 VPWR VGND sg13cmos5l_decap_8
X_0960_ Tile_X0Y1_WW4BEG[3] _1166_/X VPWR VGND sg13cmos5l_buf_1
X_0891_ Tile_X0Y1_S1BEG[3] _1126_/X VPWR VGND sg13cmos5l_buf_1
XFILLER_4_63 VPWR VGND sg13cmos5l_decap_8
XFILLER_67_133 VPWR VGND sg13cmos5l_decap_8
X_0325_ _0325_/Q Tile_X0Y0_FrameData[23] VGND VPWR Tile_X0Y1_FrameStrobe[7] latch
XFILLER_82_114 VPWR VGND sg13cmos5l_decap_8
X_0256_ _0256_/Q Tile_X0Y0_FrameData[28] VGND VPWR Tile_X0Y1_FrameStrobe[5] latch
X_0187_ _0187_/Q Tile_X0Y0_FrameData[1] VGND VPWR Tile_X0Y1_FrameStrobe[2] latch
XFILLER_136_105 VPWR VGND sg13cmos5l_decap_8
XANTENNA__0887__X Tile_X0Y0_FrameData_O[31] VPWR VGND sg13cmos5l_antennanp
XFILLER_2_129 VPWR VGND sg13cmos5l_fill_1
XFILLER_48_14 VPWR VGND sg13cmos5l_fill_2
XFILLER_104_42 VPWR VGND sg13cmos5l_decap_8
XFILLER_58_133 VPWR VGND sg13cmos5l_fill_2
XFILLER_73_158 VPWR VGND sg13cmos5l_decap_8
XFILLER_64_57 VPWR VGND sg13cmos5l_fill_2
XFILLER_127_149 VPWR VGND sg13cmos5l_decap_8
XFILLER_135_171 VPWR VGND sg13cmos5l_decap_8
XFILLER_89_76 VPWR VGND sg13cmos5l_decap_4
XANTENNA__0797__X Tile_X0Y0_N2BEG[6] VPWR VGND sg13cmos5l_antennanp
XFILLER_135_193 VPWR VGND sg13cmos5l_decap_8
XFILLER_49_122 VPWR VGND sg13cmos5l_fill_2
X_1090_ _1090_/X _1113_/X Tile_X0Y1_N4END[6] Tile_X0Y0_S1END[2] Tile_X0Y0_S4END[2]
+ _0144_/Q _0143_/Q VPWR VGND sg13cmos5l_mux4_1
X_0110_ _0110_/Q Tile_X0Y0_FrameData[14] VGND VPWR Tile_X0Y1_FrameStrobe[0] latch
XFILLER_20_217 VPWR VGND sg13cmos5l_fill_1
X_0874_ Tile_X0Y0_FrameData_O[18] Tile_X0Y0_FrameData[18] VPWR VGND sg13cmos5l_buf_1
X_0943_ Tile_X0Y1_W2BEGb[6] _1161_/X VPWR VGND sg13cmos5l_buf_1
XFILLER_118_149 VPWR VGND sg13cmos5l_decap_8
XFILLER_48_0 VPWR VGND sg13cmos5l_decap_8
XFILLER_87_206 VPWR VGND sg13cmos5l_fill_1
XFILLER_87_217 VPWR VGND sg13cmos5l_fill_1
XFILLER_18_39 VPWR VGND sg13cmos5l_decap_8
X_0308_ _0308_/Q Tile_X0Y0_FrameData[8] VGND VPWR Tile_X0Y1_FrameStrobe[6] latch
XFILLER_11_217 VPWR VGND sg13cmos5l_fill_1
XFILLER_55_169 VPWR VGND sg13cmos5l_fill_2
XFILLER_63_180 VPWR VGND sg13cmos5l_fill_2
X_0239_ _0239_/Q Tile_X0Y0_FrameData[13] VGND VPWR Tile_X0Y1_FrameStrobe[4] latch
XFILLER_109_138 VPWR VGND sg13cmos5l_decap_8
XFILLER_124_108 VPWR VGND sg13cmos5l_decap_8
XFILLER_126_7 VPWR VGND sg13cmos5l_decap_8
XFILLER_132_185 VPWR VGND sg13cmos5l_decap_8
XFILLER_59_35 VPWR VGND sg13cmos5l_decap_8
XFILLER_59_57 VPWR VGND sg13cmos5l_decap_8
XFILLER_59_79 VPWR VGND sg13cmos5l_decap_8
XFILLER_115_74 VPWR VGND sg13cmos5l_fill_1
XFILLER_115_85 VPWR VGND sg13cmos5l_fill_1
XFILLER_61_117 VPWR VGND sg13cmos5l_decap_8
XFILLER_6_210 VPWR VGND sg13cmos5l_decap_8
XFILLER_108_171 VPWR VGND sg13cmos5l_decap_8
XFILLER_69_217 VPWR VGND sg13cmos5l_fill_1
X_0590_ _0590_/Q Tile_X0Y1_FrameData[12] VGND VPWR Tile_X0Y1_FrameStrobe[7] latch
XFILLER_123_174 VPWR VGND sg13cmos5l_decap_8
XFILLER_1_42 VPWR VGND sg13cmos5l_decap_4
X_1211_ _1211_/X Tile_X0Y1_N1END[0] Tile_X0Y1_N4END[0] _1227_/X Tile_X0Y0_S4END[4]
+ _0386_/Q _0385_/Q VPWR VGND sg13cmos5l_mux4_1
X_1142_ _1142_/X _1210_/X _1214_/X _1218_/X _1202_/X _0533_/Q _0532_/Q VPWR VGND sg13cmos5l_mux4_1
XFILLER_45_180 VPWR VGND sg13cmos5l_decap_8
XFILLER_52_139 VPWR VGND sg13cmos5l_decap_8
X_1073_ _1073_/X _0638_/Q _1089_/X _1086_/X _1098_/X _0182_/Q _0181_/Q VPWR VGND sg13cmos5l_mux4_1
X_0857_ Tile_X0Y0_FrameData_O[1] Tile_X0Y0_FrameData[1] VPWR VGND sg13cmos5l_buf_1
X_0926_ Tile_X0Y1_W1BEG[1] _1144_/X VPWR VGND sg13cmos5l_buf_1
XFILLER_114_185 VPWR VGND sg13cmos5l_decap_8
X_0788_ Tile_X0Y0_N2BEGb[5] _1108_/X VPWR VGND sg13cmos5l_buf_1
XFILLER_101_32 VPWR VGND sg13cmos5l_decap_8
XFILLER_51_161 VPWR VGND sg13cmos5l_decap_8
XFILLER_61_36 VPWR VGND sg13cmos5l_decap_8
XFILLER_10_73 VPWR VGND sg13cmos5l_decap_4
XFILLER_124_4 VPWR VGND sg13cmos5l_fill_1
XFILLER_3_213 VPWR VGND sg13cmos5l_decap_4
XFILLER_105_196 VPWR VGND sg13cmos5l_decap_8
XFILLER_120_100 VPWR VGND sg13cmos5l_decap_8
XFILLER_120_111 VPWR VGND sg13cmos5l_fill_2
XFILLER_120_144 VPWR VGND sg13cmos5l_fill_1
XFILLER_120_177 VPWR VGND sg13cmos5l_decap_8
XFILLER_19_60 VPWR VGND sg13cmos5l_decap_8
XFILLER_19_71 VPWR VGND sg13cmos5l_fill_1
XFILLER_86_22 VPWR VGND sg13cmos5l_decap_8
XFILLER_34_139 VPWR VGND sg13cmos5l_decap_8
XFILLER_42_183 VPWR VGND sg13cmos5l_decap_8
X_0711_ _0980_/A3 VPWR VGND sg13cmos5l_tielo
X_0642_ _0642_/Q Tile_X0Y1_UserCLK NPU_OUT_ACT6 _0674_/L_HI VPWR VGND sg13cmos5l_dfrbpq_1
X_0573_ _0573_/Q Tile_X0Y1_FrameData[29] VGND VPWR Tile_X0Y1_FrameStrobe[7] latch
XFILLER_25_128 VPWR VGND sg13cmos5l_decap_8
XFILLER_25_2 VPWR VGND sg13cmos5l_fill_1
XFILLER_80_212 VPWR VGND sg13cmos5l_decap_4
X_1125_ _1125_/X Tile_X0Y1_E1END[2] Tile_X0Y1_E6END[10] _1217_/X _1193_/X _0562_/Q
+ _0561_/Q VPWR VGND sg13cmos5l_mux4_1
XFILLER_18_180 VPWR VGND sg13cmos5l_fill_2
X_1056_ _1056_/X _0637_/Q _0641_/Q _1085_/X _1098_/X _0216_/Q _0215_/Q VPWR VGND sg13cmos5l_mux4_1
X_0909_ Tile_X0Y1_S4BEG[1] Tile_X0Y0_S4END[9] VPWR VGND sg13cmos5l_buf_1
XANTENNA__0895__X Tile_X0Y1_S2BEG[3] VPWR VGND sg13cmos5l_antennanp
XFILLER_0_205 VPWR VGND sg13cmos5l_fill_1
XFILLER_56_47 VPWR VGND sg13cmos5l_decap_8
XFILLER_112_53 VPWR VGND sg13cmos5l_fill_2
XFILLER_72_68 VPWR VGND sg13cmos5l_decap_8
XFILLER_115_0 VPWR VGND sg13cmos5l_decap_8
XFILLER_97_43 VPWR VGND sg13cmos5l_decap_8
XFILLER_30_120 VPWR VGND sg13cmos5l_decap_8
XFILLER_46_91 VPWR VGND sg13cmos5l_decap_8
XFILLER_30_197 VPWR VGND sg13cmos5l_decap_8
XFILLER_7_63 VPWR VGND sg13cmos5l_decap_4
X_0625_ NPU_ACT_WDATA7 Tile_X0Y1_UserCLK _0989_/X _0690_/L_HI VPWR VGND sg13cmos5l_dfrbpq_1
XFILLER_131_217 VPWR VGND sg13cmos5l_fill_1
XFILLER_30_0 VPWR VGND sg13cmos5l_fill_2
X_0556_ _0556_/Q Tile_X0Y1_FrameData[14] VGND VPWR Tile_X0Y1_FrameStrobe[6] latch
X_0487_ _0487_/Q Tile_X0Y1_FrameData[19] VGND VPWR Tile_X0Y1_FrameStrobe[4] latch
XFILLER_97_164 VPWR VGND sg13cmos5l_decap_8
X_1039_ _1039_/X Tile_X0Y0_EE4END[6] _0636_/Q _1092_/X _1099_/X _0250_/Q _0249_/Q
+ VPWR VGND sg13cmos5l_mux4_1
X_1108_ _1108_/X Tile_X0Y1_E2MID[2] Tile_X0Y1_E2END[2] Tile_X0Y1_E6END[2] _1200_/X
+ _0584_/Q _0583_/Q VPWR VGND sg13cmos5l_mux4_1
XFILLER_42_16 VPWR VGND sg13cmos5l_fill_1
XFILLER_122_217 VPWR VGND sg13cmos5l_fill_1
XFILLER_67_35 VPWR VGND sg13cmos5l_decap_8
XFILLER_12_131 VPWR VGND sg13cmos5l_fill_2
XFILLER_16_94 VPWR VGND sg13cmos5l_fill_2
XFILLER_83_56 VPWR VGND sg13cmos5l_fill_2
XFILLER_8_135 VPWR VGND sg13cmos5l_decap_4
XFILLER_113_206 VPWR VGND sg13cmos5l_fill_1
XFILLER_113_217 VPWR VGND sg13cmos5l_fill_1
XFILLER_79_186 VPWR VGND sg13cmos5l_decap_8
X_0410_ _0410_/Q Tile_X0Y1_FrameData[0] VGND VPWR Tile_X0Y1_FrameStrobe[1] latch
X_0341_ _0341_/Q Tile_X0Y0_FrameData[7] VGND VPWR Tile_X0Y1_FrameStrobe[7] latch
X_0272_ _0272_/Q Tile_X0Y0_FrameData[12] VGND VPWR Tile_X0Y1_FrameStrobe[5] latch
XFILLER_78_0 VPWR VGND sg13cmos5l_decap_4
X_0608_ _0608_/Q Tile_X0Y1_FrameData[30] VGND VPWR Tile_X0Y1_FrameStrobe[8] latch
XFILLER_37_38 VPWR VGND sg13cmos5l_fill_2
X_0539_ _0539_/Q Tile_X0Y1_FrameData[31] VGND VPWR Tile_X0Y1_FrameStrobe[6] latch
XFILLER_139_103 VPWR VGND sg13cmos5l_fill_1
XFILLER_41_204 VPWR VGND sg13cmos5l_decap_8
XFILLER_53_37 VPWR VGND sg13cmos5l_decap_8
XFILLER_5_127 VPWR VGND sg13cmos5l_decap_8
XFILLER_27_60 VPWR VGND sg13cmos5l_decap_8
XFILLER_76_178 VPWR VGND sg13cmos5l_decap_8
XFILLER_94_99 VPWR VGND sg13cmos5l_fill_2
XFILLER_94_55 VPWR VGND sg13cmos5l_decap_8
XFILLER_91_104 VPWR VGND sg13cmos5l_decap_8
XFILLER_71_7 VPWR VGND sg13cmos5l_decap_8
X_0890_ Tile_X0Y1_S1BEG[2] _1125_/X VPWR VGND sg13cmos5l_buf_1
XFILLER_138_180 VPWR VGND sg13cmos5l_decap_8
XFILLER_4_182 VPWR VGND sg13cmos5l_decap_8
XFILLER_4_42 VPWR VGND sg13cmos5l_decap_8
XFILLER_101_209 VPWR VGND sg13cmos5l_decap_8
XFILLER_67_189 VPWR VGND sg13cmos5l_fill_1
X_0324_ _0324_/Q Tile_X0Y0_FrameData[24] VGND VPWR Tile_X0Y1_FrameStrobe[7] latch
X_0255_ _0255_/Q Tile_X0Y0_FrameData[29] VGND VPWR Tile_X0Y1_FrameStrobe[5] latch
X_0186_ _0186_/Q Tile_X0Y0_FrameData[2] VGND VPWR Tile_X0Y1_FrameStrobe[2] latch
XFILLER_129_180 VPWR VGND sg13cmos5l_decap_8
XFILLER_104_98 VPWR VGND sg13cmos5l_decap_8
XFILLER_64_14 VPWR VGND sg13cmos5l_decap_8
XFILLER_64_36 VPWR VGND sg13cmos5l_decap_8
XFILLER_73_137 VPWR VGND sg13cmos5l_decap_8
XFILLER_120_86 VPWR VGND sg13cmos5l_decap_8
XFILLER_80_79 VPWR VGND sg13cmos5l_decap_8
XFILLER_127_128 VPWR VGND sg13cmos5l_decap_8
XFILLER_129_40 VPWR VGND sg13cmos5l_decap_4
XFILLER_135_150 VPWR VGND sg13cmos5l_decap_8
XFILLER_8_0 VPWR VGND sg13cmos5l_decap_4
XFILLER_38_70 VPWR VGND sg13cmos5l_decap_8
XFILLER_38_81 VPWR VGND sg13cmos5l_fill_1
XFILLER_49_101 VPWR VGND sg13cmos5l_fill_1
XFILLER_64_115 VPWR VGND sg13cmos5l_decap_8
XFILLER_118_106 VPWR VGND sg13cmos5l_decap_8
X_0873_ Tile_X0Y0_FrameData_O[17] Tile_X0Y0_FrameData[17] VPWR VGND sg13cmos5l_buf_1
X_0942_ Tile_X0Y1_W2BEGb[5] _1160_/X VPWR VGND sg13cmos5l_buf_1
XFILLER_126_183 VPWR VGND sg13cmos5l_decap_8
XFILLER_133_109 VPWR VGND sg13cmos5l_decap_8
XFILLER_141_186 VPWR VGND sg13cmos5l_decap_8
XFILLER_141_19 VPWR VGND sg13cmos5l_decap_8
XFILLER_55_115 VPWR VGND sg13cmos5l_fill_1
X_0307_ _0307_/Q Tile_X0Y0_FrameData[9] VGND VPWR Tile_X0Y1_FrameStrobe[6] latch
X_0238_ _0238_/Q Tile_X0Y0_FrameData[14] VGND VPWR Tile_X0Y1_FrameStrobe[4] latch
XFILLER_133_9 VPWR VGND sg13cmos5l_fill_1
XFILLER_34_39 VPWR VGND sg13cmos5l_fill_1
X_0169_ _0169_/Q Tile_X0Y0_FrameData[19] VGND VPWR Tile_X0Y1_FrameStrobe[2] latch
XANTENNA__0898__X Tile_X0Y1_S2BEG[6] VPWR VGND sg13cmos5l_antennanp
XFILLER_117_194 VPWR VGND sg13cmos5l_decap_8
XFILLER_59_14 VPWR VGND sg13cmos5l_decap_8
XFILLER_132_164 VPWR VGND sg13cmos5l_decap_8
XFILLER_1_7 VPWR VGND sg13cmos5l_decap_8
XFILLER_46_115 VPWR VGND sg13cmos5l_fill_1
XFILLER_75_46 VPWR VGND sg13cmos5l_decap_8
XFILLER_131_96 VPWR VGND sg13cmos5l_decap_8
XFILLER_46_148 VPWR VGND sg13cmos5l_fill_1
XFILLER_108_161 VPWR VGND sg13cmos5l_decap_8
XFILLER_123_153 VPWR VGND sg13cmos5l_decap_8
XFILLER_1_21 VPWR VGND sg13cmos5l_decap_8
X_1072_ _1072_/X _0637_/Q _1090_/X _1085_/X _1097_/X _0184_/Q _0183_/Q VPWR VGND sg13cmos5l_mux4_1
X_1210_ _1210_/X Tile_X0Y1_N1END[3] Tile_X0Y1_N4END[3] _1230_/X Tile_X0Y0_S4END[7]
+ _0388_/Q _0387_/Q VPWR VGND sg13cmos5l_mux4_1
X_1141_ _1141_/X Tile_X0Y1_E1END[3] Tile_X0Y1_EE4END[15] Tile_X0Y1_E6END[7] _1206_/X
+ _0533_/Q _0532_/Q VPWR VGND sg13cmos5l_mux4_1
XFILLER_52_118 VPWR VGND sg13cmos5l_decap_8
XFILLER_60_151 VPWR VGND sg13cmos5l_fill_1
XFILLER_60_173 VPWR VGND sg13cmos5l_fill_1
XFILLER_60_0 VPWR VGND sg13cmos5l_fill_2
X_0856_ Tile_X0Y0_FrameData_O[0] Tile_X0Y0_FrameData[0] VPWR VGND sg13cmos5l_buf_1
X_0925_ Tile_X0Y1_W1BEG[0] _1143_/X VPWR VGND sg13cmos5l_buf_1
X_0787_ Tile_X0Y0_N2BEGb[4] _1107_/X VPWR VGND sg13cmos5l_buf_1
XFILLER_28_104 VPWR VGND sg13cmos5l_fill_1
XFILLER_101_11 VPWR VGND sg13cmos5l_decap_8
XFILLER_28_126 VPWR VGND sg13cmos5l_decap_4
XFILLER_43_107 VPWR VGND sg13cmos5l_decap_4
XFILLER_83_210 VPWR VGND sg13cmos5l_decap_8
XFILLER_10_52 VPWR VGND sg13cmos5l_decap_8
XFILLER_10_96 VPWR VGND sg13cmos5l_decap_8
XFILLER_120_156 VPWR VGND sg13cmos5l_decap_8
XFILLER_126_96 VPWR VGND sg13cmos5l_decap_8
XFILLER_86_78 VPWR VGND sg13cmos5l_decap_8
XFILLER_86_89 VPWR VGND sg13cmos5l_fill_2
XFILLER_34_107 VPWR VGND sg13cmos5l_decap_8
XFILLER_34_118 VPWR VGND sg13cmos5l_decap_8
X_0710_ _0979_/A3 VPWR VGND sg13cmos5l_tielo
X_0641_ _0641_/Q Tile_X0Y1_UserCLK NPU_OUT_ACT5 _0672_/L_HI VPWR VGND sg13cmos5l_dfrbpq_1
X_0572_ _0572_/Q Tile_X0Y1_FrameData[30] VGND VPWR Tile_X0Y1_FrameStrobe[7] latch
X_1055_ _1055_/X _0636_/Q _0640_/Q _1084_/X _1099_/X _0218_/Q _0217_/Q VPWR VGND sg13cmos5l_mux4_1
X_1124_ _1124_/X Tile_X0Y1_E1END[1] Tile_X0Y1_E6END[9] _1216_/X _1192_/X _0564_/Q
+ _0563_/Q VPWR VGND sg13cmos5l_mux4_1
XFILLER_119_201 VPWR VGND sg13cmos5l_decap_4
XFILLER_31_18 VPWR VGND sg13cmos5l_decap_8
XFILLER_102_101 VPWR VGND sg13cmos5l_fill_1
X_0908_ Tile_X0Y1_S4BEG[0] Tile_X0Y0_S4END[8] VPWR VGND sg13cmos5l_buf_1
X_0839_ Tile_X0Y1_FrameData_O[15] Tile_X0Y1_FrameData[15] VPWR VGND sg13cmos5l_buf_1
XFILLER_112_32 VPWR VGND sg13cmos5l_decap_8
XFILLER_112_76 VPWR VGND sg13cmos5l_decap_8
XFILLER_24_140 VPWR VGND sg13cmos5l_decap_8
XFILLER_24_184 VPWR VGND sg13cmos5l_decap_8
XFILLER_108_0 VPWR VGND sg13cmos5l_decap_4
XFILLER_137_84 VPWR VGND sg13cmos5l_decap_8
XFILLER_97_22 VPWR VGND sg13cmos5l_decap_8
XFILLER_47_210 VPWR VGND sg13cmos5l_decap_8
XFILLER_15_140 VPWR VGND sg13cmos5l_decap_8
XFILLER_30_176 VPWR VGND sg13cmos5l_decap_8
XFILLER_62_80 VPWR VGND sg13cmos5l_decap_8
XFILLER_62_91 VPWR VGND sg13cmos5l_decap_8
X_0624_ NPU_ACT_WDATA6 Tile_X0Y1_UserCLK _0988_/X _0691_/L_HI VPWR VGND sg13cmos5l_dfrbpq_1
XFILLER_23_0 VPWR VGND sg13cmos5l_decap_8
X_0555_ _0555_/Q Tile_X0Y1_FrameData[15] VGND VPWR Tile_X0Y1_FrameStrobe[6] latch
X_0486_ _0486_/Q Tile_X0Y1_FrameData[20] VGND VPWR Tile_X0Y1_FrameStrobe[4] latch
X_1038_ _1038_/X Tile_X0Y0_EE4END[5] _0643_/Q _1092_/X _1099_/X _0252_/Q _0251_/Q
+ VPWR VGND sg13cmos5l_mux4_1
X_1107_ _1107_/X Tile_X0Y1_E2MID[3] Tile_X0Y1_E2END[3] Tile_X0Y1_E6END[3] _1199_/X
+ _0586_/Q _0585_/Q VPWR VGND sg13cmos5l_mux4_1
XFILLER_107_204 VPWR VGND sg13cmos5l_fill_2
XFILLER_101_7 VPWR VGND sg13cmos5l_fill_1
XFILLER_67_14 VPWR VGND sg13cmos5l_decap_8
XFILLER_123_42 VPWR VGND sg13cmos5l_fill_1
XFILLER_88_187 VPWR VGND sg13cmos5l_decap_8
XFILLER_83_79 VPWR VGND sg13cmos5l_fill_1
XFILLER_32_61 VPWR VGND sg13cmos5l_decap_4
XFILLER_32_94 VPWR VGND sg13cmos5l_fill_1
XFILLER_8_169 VPWR VGND sg13cmos5l_decap_8
XFILLER_79_165 VPWR VGND sg13cmos5l_decap_8
X_0340_ _0340_/Q Tile_X0Y0_FrameData[8] VGND VPWR Tile_X0Y1_FrameStrobe[7] latch
X_0271_ _0271_/Q Tile_X0Y0_FrameData[13] VGND VPWR Tile_X0Y1_FrameStrobe[5] latch
XFILLER_94_179 VPWR VGND sg13cmos5l_decap_8
XFILLER_85_2 VPWR VGND sg13cmos5l_fill_1
X_0607_ _0607_/Q Tile_X0Y1_FrameData[29] VGND VPWR Tile_X0Y1_FrameStrobe[8] latch
X_0538_ _0538_/Q Tile_X0Y1_FrameData[0] VGND VPWR Tile_X0Y1_FrameStrobe[5] latch
XFILLER_26_213 VPWR VGND sg13cmos5l_decap_4
XFILLER_85_102 VPWR VGND sg13cmos5l_fill_2
XFILLER_85_157 VPWR VGND sg13cmos5l_fill_1
XFILLER_85_179 VPWR VGND sg13cmos5l_decap_8
X_0469_ _0469_/Q Tile_X0Y1_FrameData[5] VGND VPWR Tile_X0Y1_FrameStrobe[3] latch
XFILLER_139_115 VPWR VGND sg13cmos5l_decap_8
XFILLER_118_42 VPWR VGND sg13cmos5l_fill_1
XFILLER_78_13 VPWR VGND sg13cmos5l_decap_4
XFILLER_78_68 VPWR VGND sg13cmos5l_fill_1
XFILLER_94_34 VPWR VGND sg13cmos5l_decap_8
XFILLER_84_190 VPWR VGND sg13cmos5l_decap_8
XFILLER_94_78 VPWR VGND sg13cmos5l_decap_8
XFILLER_43_93 VPWR VGND sg13cmos5l_decap_8
XFILLER_4_161 VPWR VGND sg13cmos5l_decap_8
XFILLER_4_21 VPWR VGND sg13cmos5l_decap_8
XFILLER_64_7 VPWR VGND sg13cmos5l_decap_8
XFILLER_82_149 VPWR VGND sg13cmos5l_decap_8
X_0323_ _0323_/Q Tile_X0Y0_FrameData[25] VGND VPWR Tile_X0Y1_FrameStrobe[7] latch
X_0254_ _0254_/Q Tile_X0Y0_FrameData[30] VGND VPWR Tile_X0Y1_FrameStrobe[5] latch
X_0185_ _0185_/Q Tile_X0Y0_FrameData[3] VGND VPWR Tile_X0Y1_FrameStrobe[2] latch
XFILLER_90_0 VPWR VGND sg13cmos5l_fill_2
XFILLER_2_109 VPWR VGND sg13cmos5l_decap_8
XFILLER_100_210 VPWR VGND sg13cmos5l_decap_8
XFILLER_48_16 VPWR VGND sg13cmos5l_fill_1
XFILLER_48_49 VPWR VGND sg13cmos5l_fill_1
XFILLER_104_77 VPWR VGND sg13cmos5l_decap_8
XFILLER_14_205 VPWR VGND sg13cmos5l_decap_8
XFILLER_14_216 VPWR VGND sg13cmos5l_fill_2
XFILLER_58_179 VPWR VGND sg13cmos5l_decap_4
XFILLER_73_116 VPWR VGND sg13cmos5l_decap_8
XFILLER_13_30 VPWR VGND sg13cmos5l_decap_4
XFILLER_13_52 VPWR VGND sg13cmos5l_decap_8
XFILLER_13_63 VPWR VGND sg13cmos5l_fill_2
XFILLER_129_63 VPWR VGND sg13cmos5l_decap_4
XFILLER_129_74 VPWR VGND sg13cmos5l_decap_8
XFILLER_13_96 VPWR VGND sg13cmos5l_fill_1
XFILLER_1_142 VPWR VGND sg13cmos5l_decap_4
XFILLER_89_56 VPWR VGND sg13cmos5l_fill_2
XFILLER_89_45 VPWR VGND sg13cmos5l_decap_8
XFILLER_1_186 VPWR VGND sg13cmos5l_decap_4
XFILLER_72_182 VPWR VGND sg13cmos5l_decap_8
X_0941_ Tile_X0Y1_W2BEGb[4] _1159_/X VPWR VGND sg13cmos5l_buf_1
XFILLER_70_91 VPWR VGND sg13cmos5l_decap_8
X_0872_ Tile_X0Y0_FrameData_O[16] Tile_X0Y0_FrameData[16] VPWR VGND sg13cmos5l_buf_1
XFILLER_126_173 VPWR VGND sg13cmos5l_decap_4
XFILLER_141_143 VPWR VGND sg13cmos5l_decap_8
XFILLER_141_165 VPWR VGND sg13cmos5l_decap_8
XFILLER_63_171 VPWR VGND sg13cmos5l_fill_2
XFILLER_63_182 VPWR VGND sg13cmos5l_fill_1
XFILLER_70_119 VPWR VGND sg13cmos5l_decap_8
X_0306_ _0306_/Q Tile_X0Y0_FrameData[10] VGND VPWR Tile_X0Y1_FrameStrobe[6] latch
X_0237_ _0237_/Q Tile_X0Y0_FrameData[15] VGND VPWR Tile_X0Y1_FrameStrobe[4] latch
X_0168_ _0168_/Q Tile_X0Y0_FrameData[20] VGND VPWR Tile_X0Y1_FrameStrobe[2] latch
XFILLER_50_39 VPWR VGND sg13cmos5l_decap_8
X_0099_ _0099_/Q Tile_X0Y0_FrameData[25] VGND VPWR Tile_X0Y1_FrameStrobe[0] latch
XFILLER_117_173 VPWR VGND sg13cmos5l_decap_8
XFILLER_132_143 VPWR VGND sg13cmos5l_decap_8
XFILLER_46_105 VPWR VGND sg13cmos5l_decap_8
XFILLER_131_42 VPWR VGND sg13cmos5l_fill_2
XFILLER_131_75 VPWR VGND sg13cmos5l_decap_8
XFILLER_24_51 VPWR VGND sg13cmos5l_decap_8
XFILLER_91_35 VPWR VGND sg13cmos5l_decap_4
XFILLER_138_0 VPWR VGND sg13cmos5l_decap_8
XFILLER_24_84 VPWR VGND sg13cmos5l_fill_2
XFILLER_123_121 VPWR VGND sg13cmos5l_fill_1
XFILLER_123_132 VPWR VGND sg13cmos5l_decap_8
XFILLER_40_94 VPWR VGND sg13cmos5l_decap_4
XFILLER_49_81 VPWR VGND sg13cmos5l_decap_8
XFILLER_49_92 VPWR VGND sg13cmos5l_fill_2
X_1071_ _1071_/X _0636_/Q _1091_/X _1084_/X _1096_/X _0186_/Q _0185_/Q VPWR VGND sg13cmos5l_mux4_1
X_1140_ _1140_/X _1209_/X _1213_/X _1217_/X _1201_/X _0536_/Q _0535_/Q VPWR VGND sg13cmos5l_mux4_1
X_0924_ Tile_X0Y1_UserCLKo Tile_X0Y1_UserCLK VPWR VGND sg13cmos5l_buf_1
XFILLER_114_132 VPWR VGND sg13cmos5l_fill_1
XFILLER_114_154 VPWR VGND sg13cmos5l_fill_2
XFILLER_53_0 VPWR VGND sg13cmos5l_fill_2
X_0855_ Tile_X0Y1_FrameData_O[31] Tile_X0Y1_FrameData[31] VPWR VGND sg13cmos5l_buf_1
X_0786_ Tile_X0Y0_N2BEGb[3] _1106_/X VPWR VGND sg13cmos5l_buf_1
XFILLER_101_67 VPWR VGND sg13cmos5l_decap_8
XFILLER_36_171 VPWR VGND sg13cmos5l_decap_8
XFILLER_45_39 VPWR VGND sg13cmos5l_decap_8
XFILLER_131_7 VPWR VGND sg13cmos5l_fill_1
XFILLER_120_135 VPWR VGND sg13cmos5l_decap_8
XFILLER_126_42 VPWR VGND sg13cmos5l_fill_2
XFILLER_126_75 VPWR VGND sg13cmos5l_decap_8
XFILLER_19_116 VPWR VGND sg13cmos5l_decap_8
XFILLER_27_171 VPWR VGND sg13cmos5l_decap_8
XFILLER_74_200 VPWR VGND sg13cmos5l_decap_8
XFILLER_86_57 VPWR VGND sg13cmos5l_decap_8
XFILLER_27_193 VPWR VGND sg13cmos5l_decap_4
XFILLER_35_83 VPWR VGND sg13cmos5l_decap_8
XFILLER_128_213 VPWR VGND sg13cmos5l_decap_4
XFILLER_51_93 VPWR VGND sg13cmos5l_decap_8
X_0640_ _0640_/Q Tile_X0Y1_UserCLK NPU_OUT_ACT4 _0667_/L_HI VPWR VGND sg13cmos5l_dfrbpq_1
X_0571_ _0571_/Q Tile_X0Y1_FrameData[31] VGND VPWR Tile_X0Y1_FrameStrobe[7] latch
XFILLER_33_141 VPWR VGND sg13cmos5l_decap_4
XFILLER_76_90 VPWR VGND sg13cmos5l_decap_4
X_1054_ _1054_/X _0639_/Q _0643_/Q _1083_/X _1092_/X _0220_/Q _0219_/Q VPWR VGND sg13cmos5l_mux4_1
X_1123_ _1123_/X Tile_X0Y1_E1END[0] Tile_X0Y1_E6END[8] _1215_/X _1191_/X _0566_/Q
+ _0565_/Q VPWR VGND sg13cmos5l_mux4_1
XFILLER_134_205 VPWR VGND sg13cmos5l_decap_8
XFILLER_33_174 VPWR VGND sg13cmos5l_decap_8
XFILLER_33_185 VPWR VGND sg13cmos5l_fill_1
X_0907_ Tile_X0Y1_S2BEGb[7] _1226_/X VPWR VGND sg13cmos5l_buf_1
XFILLER_134_216 VPWR VGND sg13cmos5l_fill_2
X_0838_ Tile_X0Y1_FrameData_O[14] Tile_X0Y1_FrameData[14] VPWR VGND sg13cmos5l_buf_1
X_0769_ Tile_X0Y0_WW4BEG[2] _1049_/X VPWR VGND sg13cmos5l_buf_1
XFILLER_71_203 VPWR VGND sg13cmos5l_decap_8
XFILLER_112_99 VPWR VGND sg13cmos5l_fill_2
XFILLER_137_63 VPWR VGND sg13cmos5l_decap_8
XFILLER_15_185 VPWR VGND sg13cmos5l_decap_8
XFILLER_30_155 VPWR VGND sg13cmos5l_decap_8
XFILLER_116_205 VPWR VGND sg13cmos5l_decap_8
XFILLER_116_216 VPWR VGND sg13cmos5l_fill_2
XFILLER_7_76 VPWR VGND sg13cmos5l_fill_2
X_0623_ NPU_ACT_WDATA5 Tile_X0Y1_UserCLK _0987_/X _0692_/L_HI VPWR VGND sg13cmos5l_dfrbpq_1
X_0554_ _0554_/Q Tile_X0Y1_FrameData[16] VGND VPWR Tile_X0Y1_FrameStrobe[6] latch
XFILLER_97_133 VPWR VGND sg13cmos5l_fill_2
XFILLER_16_0 VPWR VGND sg13cmos5l_decap_4
X_1106_ _1106_/X Tile_X0Y1_E2MID[4] Tile_X0Y1_E2END[4] Tile_X0Y1_E6END[4] _1198_/X
+ _0588_/Q _0587_/Q VPWR VGND sg13cmos5l_mux4_1
X_0485_ _0485_/Q Tile_X0Y1_FrameData[21] VGND VPWR Tile_X0Y1_FrameStrobe[4] latch
X_1037_ _1037_/X Tile_X0Y0_EE4END[4] _0642_/Q _1093_/X _1098_/X _0254_/Q _0253_/Q
+ VPWR VGND sg13cmos5l_mux4_1
XFILLER_107_77 VPWR VGND sg13cmos5l_decap_4
XFILLER_122_208 VPWR VGND sg13cmos5l_decap_8
XFILLER_88_155 VPWR VGND sg13cmos5l_fill_1
XFILLER_88_144 VPWR VGND sg13cmos5l_decap_8
XFILLER_123_21 VPWR VGND sg13cmos5l_fill_1
XFILLER_83_58 VPWR VGND sg13cmos5l_fill_1
XFILLER_120_0 VPWR VGND sg13cmos5l_decap_8
XFILLER_12_188 VPWR VGND sg13cmos5l_decap_8
XFILLER_8_148 VPWR VGND sg13cmos5l_decap_8
XFILLER_57_70 VPWR VGND sg13cmos5l_fill_2
XFILLER_57_92 VPWR VGND sg13cmos5l_decap_8
XFILLER_79_144 VPWR VGND sg13cmos5l_decap_8
X_0270_ _0270_/Q Tile_X0Y0_FrameData[14] VGND VPWR Tile_X0Y1_FrameStrobe[5] latch
XFILLER_50_217 VPWR VGND sg13cmos5l_fill_1
XFILLER_92_4 VPWR VGND sg13cmos5l_fill_2
XFILLER_7_192 VPWR VGND sg13cmos5l_decap_8
XANTENNA__0800__X Tile_X0Y0_N1BEG[1] VPWR VGND sg13cmos5l_antennanp
X_0606_ _0606_/Q Tile_X0Y1_FrameData[28] VGND VPWR Tile_X0Y1_FrameStrobe[8] latch
X_0537_ _0537_/Q Tile_X0Y1_FrameData[1] VGND VPWR Tile_X0Y1_FrameStrobe[5] latch
X_0468_ _0468_/Q Tile_X0Y1_FrameData[6] VGND VPWR Tile_X0Y1_FrameStrobe[3] latch
X_0399_ _0399_/Q Tile_X0Y1_FrameData[11] VGND VPWR Tile_X0Y1_FrameStrobe[1] latch
XFILLER_118_21 VPWR VGND sg13cmos5l_decap_8
XFILLER_78_25 VPWR VGND sg13cmos5l_decap_8
XFILLER_78_36 VPWR VGND sg13cmos5l_fill_2
XFILLER_134_86 VPWR VGND sg13cmos5l_decap_8
XFILLER_94_13 VPWR VGND sg13cmos5l_decap_8
XFILLER_27_95 VPWR VGND sg13cmos5l_decap_8
XFILLER_32_217 VPWR VGND sg13cmos5l_fill_1
XFILLER_91_139 VPWR VGND sg13cmos5l_decap_8
XFILLER_4_77 VPWR VGND sg13cmos5l_decap_8
X_0322_ _0322_/Q Tile_X0Y0_FrameData[26] VGND VPWR Tile_X0Y1_FrameStrobe[7] latch
XFILLER_99_217 VPWR VGND sg13cmos5l_fill_1
XFILLER_67_147 VPWR VGND sg13cmos5l_decap_8
XFILLER_82_128 VPWR VGND sg13cmos5l_decap_8
X_0253_ _0253_/Q Tile_X0Y0_FrameData[31] VGND VPWR Tile_X0Y1_FrameStrobe[5] latch
X_0184_ _0184_/Q Tile_X0Y0_FrameData[4] VGND VPWR Tile_X0Y1_FrameStrobe[2] latch
XFILLER_23_217 VPWR VGND sg13cmos5l_fill_1
XFILLER_83_0 VPWR VGND sg13cmos5l_decap_4
XFILLER_90_183 VPWR VGND sg13cmos5l_decap_8
XFILLER_136_119 VPWR VGND sg13cmos5l_decap_8
XFILLER_48_28 VPWR VGND sg13cmos5l_decap_8
XFILLER_104_56 VPWR VGND sg13cmos5l_decap_8
XFILLER_57_191 VPWR VGND sg13cmos5l_decap_8
XFILLER_72_161 VPWR VGND sg13cmos5l_decap_8
X_0940_ Tile_X0Y1_W2BEGb[3] _1158_/X VPWR VGND sg13cmos5l_buf_1
XFILLER_126_152 VPWR VGND sg13cmos5l_decap_8
XFILLER_70_70 VPWR VGND sg13cmos5l_decap_8
X_0871_ Tile_X0Y0_FrameData_O[15] Tile_X0Y0_FrameData[15] VPWR VGND sg13cmos5l_buf_1
XFILLER_141_122 VPWR VGND sg13cmos5l_decap_8
XFILLER_141_155 VPWR VGND sg13cmos5l_decap_8
X_0305_ _0305_/Q Tile_X0Y0_FrameData[11] VGND VPWR Tile_X0Y1_FrameStrobe[6] latch
XFILLER_48_180 VPWR VGND sg13cmos5l_decap_8
X_0236_ _0236_/Q Tile_X0Y0_FrameData[16] VGND VPWR Tile_X0Y1_FrameStrobe[4] latch
X_0167_ _0167_/Q Tile_X0Y0_FrameData[21] VGND VPWR Tile_X0Y1_FrameStrobe[2] latch
X_0098_ _0098_/Q Tile_X0Y0_FrameData[26] VGND VPWR Tile_X0Y1_FrameStrobe[0] latch
XFILLER_109_119 VPWR VGND sg13cmos5l_decap_8
XFILLER_115_11 VPWR VGND sg13cmos5l_decap_4
XFILLER_117_152 VPWR VGND sg13cmos5l_decap_8
XFILLER_132_122 VPWR VGND sg13cmos5l_decap_8
XFILLER_59_49 VPWR VGND sg13cmos5l_fill_1
XFILLER_132_199 VPWR VGND sg13cmos5l_decap_8
XFILLER_39_191 VPWR VGND sg13cmos5l_decap_8
XFILLER_24_30 VPWR VGND sg13cmos5l_decap_8
XFILLER_91_14 VPWR VGND sg13cmos5l_decap_8
XFILLER_108_185 VPWR VGND sg13cmos5l_decap_8
XFILLER_40_62 VPWR VGND sg13cmos5l_decap_8
XFILLER_40_73 VPWR VGND sg13cmos5l_decap_8
XFILLER_123_188 VPWR VGND sg13cmos5l_decap_8
XFILLER_49_60 VPWR VGND sg13cmos5l_decap_4
XFILLER_45_161 VPWR VGND sg13cmos5l_fill_1
XFILLER_45_194 VPWR VGND sg13cmos5l_decap_8
X_1070_ _1070_/X _0643_/Q _1087_/X _1083_/X _1095_/X _0188_/Q _0187_/Q VPWR VGND sg13cmos5l_mux4_1
XFILLER_92_201 VPWR VGND sg13cmos5l_decap_8
X_0854_ Tile_X0Y1_FrameData_O[30] Tile_X0Y1_FrameData[30] VPWR VGND sg13cmos5l_buf_1
X_0923_ Tile_X0Y1_S4BEG[15] _0923_/A VPWR VGND sg13cmos5l_buf_1
XFILLER_46_0 VPWR VGND sg13cmos5l_decap_4
X_0785_ Tile_X0Y0_N2BEGb[2] _1105_/X VPWR VGND sg13cmos5l_buf_1
XFILLER_114_199 VPWR VGND sg13cmos5l_decap_8
XFILLER_101_46 VPWR VGND sg13cmos5l_decap_4
XFILLER_101_79 VPWR VGND sg13cmos5l_decap_8
XFILLER_36_150 VPWR VGND sg13cmos5l_decap_8
X_1199_ _1199_/X Tile_X0Y1_N2MID[4] Tile_X0Y1_N2END[4] _1223_/X Tile_X0Y0_S2MID[4]
+ _0362_/Q _0361_/Q VPWR VGND sg13cmos5l_mux4_1
X_0219_ _0219_/Q Tile_X0Y0_FrameData[1] VGND VPWR Tile_X0Y1_FrameStrobe[3] latch
XFILLER_105_100 VPWR VGND sg13cmos5l_fill_1
XFILLER_105_122 VPWR VGND sg13cmos5l_decap_4
XFILLER_105_155 VPWR VGND sg13cmos5l_decap_8
XFILLER_10_32 VPWR VGND sg13cmos5l_fill_2
XFILLER_126_21 VPWR VGND sg13cmos5l_decap_8
XFILLER_126_54 VPWR VGND sg13cmos5l_decap_8
XFILLER_86_36 VPWR VGND sg13cmos5l_decap_8
XFILLER_19_139 VPWR VGND sg13cmos5l_decap_8
XFILLER_42_120 VPWR VGND sg13cmos5l_fill_1
XFILLER_35_62 VPWR VGND sg13cmos5l_decap_8
XFILLER_42_142 VPWR VGND sg13cmos5l_decap_4
XFILLER_42_197 VPWR VGND sg13cmos5l_decap_8
XFILLER_51_72 VPWR VGND sg13cmos5l_decap_8
X_0570_ _0570_/Q Tile_X0Y1_FrameData[0] VGND VPWR Tile_X0Y1_FrameStrobe[6] latch
X_1122_ _1122_/X _1207_/X _1211_/X _1215_/X _1195_/X _0578_/Q _0577_/Q VPWR VGND sg13cmos5l_mux4_1
X_1053_ _1053_/X _0638_/Q _0642_/Q _1082_/X _1093_/X _0222_/Q _0221_/Q VPWR VGND sg13cmos5l_mux4_1
XANTENNA__0803__X Tile_X0Y0_FrameStrobe_O[0] VPWR VGND sg13cmos5l_antennanp
X_0906_ Tile_X0Y1_S2BEGb[6] _1225_/X VPWR VGND sg13cmos5l_buf_1
X_0837_ Tile_X0Y1_FrameData_O[13] Tile_X0Y1_FrameData[13] VPWR VGND sg13cmos5l_buf_1
X_0768_ Tile_X0Y0_WW4BEG[1] _1048_/X VPWR VGND sg13cmos5l_buf_1
X_0699_ _0981_/A3 VPWR VGND sg13cmos5l_tielo
XFILLER_56_212 VPWR VGND sg13cmos5l_decap_4
XFILLER_125_206 VPWR VGND sg13cmos5l_fill_1
XFILLER_125_217 VPWR VGND sg13cmos5l_fill_1
XFILLER_137_42 VPWR VGND sg13cmos5l_decap_8
XFILLER_21_31 VPWR VGND sg13cmos5l_fill_2
XFILLER_21_86 VPWR VGND sg13cmos5l_decap_8
XFILLER_21_97 VPWR VGND sg13cmos5l_fill_1
XFILLER_15_164 VPWR VGND sg13cmos5l_decap_8
XFILLER_46_83 VPWR VGND sg13cmos5l_decap_4
XFILLER_30_134 VPWR VGND sg13cmos5l_decap_8
XFILLER_87_7 VPWR VGND sg13cmos5l_decap_8
X_0622_ NPU_ACT_WDATA4 Tile_X0Y1_UserCLK _0986_/X _0663_/L_HI VPWR VGND sg13cmos5l_dfrbpq_1
X_0553_ _0553_/Q Tile_X0Y1_FrameData[17] VGND VPWR Tile_X0Y1_FrameStrobe[6] latch
X_0484_ _0484_/Q Tile_X0Y1_FrameData[22] VGND VPWR Tile_X0Y1_FrameStrobe[4] latch
XFILLER_53_204 VPWR VGND sg13cmos5l_decap_8
X_1105_ _1105_/X Tile_X0Y1_E2MID[5] Tile_X0Y1_E2END[5] Tile_X0Y1_E6END[5] _1197_/X
+ _0590_/Q _0589_/Q VPWR VGND sg13cmos5l_mux4_1
XFILLER_97_178 VPWR VGND sg13cmos5l_decap_8
XFILLER_21_123 VPWR VGND sg13cmos5l_fill_1
X_1036_ _1036_/X Tile_X0Y0_EE4END[15] _0641_/Q _1094_/X _1097_/X _0256_/Q _0255_/Q
+ VPWR VGND sg13cmos5l_mux4_1
XFILLER_107_206 VPWR VGND sg13cmos5l_fill_1
XFILLER_107_217 VPWR VGND sg13cmos5l_fill_1
XFILLER_107_67 VPWR VGND sg13cmos5l_fill_2
XFILLER_123_11 VPWR VGND sg13cmos5l_fill_2
XFILLER_123_33 VPWR VGND sg13cmos5l_decap_8
XFILLER_29_212 VPWR VGND sg13cmos5l_decap_4
XFILLER_67_49 VPWR VGND sg13cmos5l_decap_8
XFILLER_88_167 VPWR VGND sg13cmos5l_decap_8
XFILLER_16_64 VPWR VGND sg13cmos5l_fill_2
XFILLER_44_204 VPWR VGND sg13cmos5l_decap_8
XFILLER_32_30 VPWR VGND sg13cmos5l_fill_2
XFILLER_113_0 VPWR VGND sg13cmos5l_decap_4
XFILLER_73_70 VPWR VGND sg13cmos5l_decap_8
XFILLER_7_171 VPWR VGND sg13cmos5l_decap_8
XFILLER_85_104 VPWR VGND sg13cmos5l_fill_1
X_0605_ _0605_/Q Tile_X0Y1_FrameData[27] VGND VPWR Tile_X0Y1_FrameStrobe[8] latch
X_0536_ _0536_/Q Tile_X0Y1_FrameData[2] VGND VPWR Tile_X0Y1_FrameStrobe[5] latch
X_0467_ _0467_/Q Tile_X0Y1_FrameData[7] VGND VPWR Tile_X0Y1_FrameStrobe[3] latch
X_1019_ _1019_/X Tile_X0Y0_E1END[0] Tile_X0Y0_EE4END[12] Tile_X0Y0_E6END[4] _1088_/X
+ _0286_/Q _0285_/Q VPWR VGND sg13cmos5l_mux4_1
X_0398_ _0398_/Q Tile_X0Y1_FrameData[12] VGND VPWR Tile_X0Y1_FrameStrobe[1] latch
XFILLER_118_99 VPWR VGND sg13cmos5l_fill_2
XFILLER_78_59 VPWR VGND sg13cmos5l_decap_8
XFILLER_134_65 VPWR VGND sg13cmos5l_decap_8
XFILLER_17_204 VPWR VGND sg13cmos5l_fill_2
XFILLER_94_69 VPWR VGND sg13cmos5l_fill_2
XFILLER_91_118 VPWR VGND sg13cmos5l_decap_8
XFILLER_27_74 VPWR VGND sg13cmos5l_decap_8
XFILLER_43_73 VPWR VGND sg13cmos5l_fill_2
XANTENNA__0901__X Tile_X0Y1_S2BEGb[1] VPWR VGND sg13cmos5l_antennanp
XFILLER_138_194 VPWR VGND sg13cmos5l_decap_8
XFILLER_4_130 VPWR VGND sg13cmos5l_decap_8
XFILLER_4_196 VPWR VGND sg13cmos5l_decap_8
XFILLER_4_56 VPWR VGND sg13cmos5l_decap_8
X_0321_ _0321_/Q Tile_X0Y0_FrameData[27] VGND VPWR Tile_X0Y1_FrameStrobe[7] latch
XFILLER_82_107 VPWR VGND sg13cmos5l_decap_8
X_0252_ _0252_/Q Tile_X0Y0_FrameData[0] VGND VPWR Tile_X0Y1_FrameStrobe[4] latch
X_0183_ _0183_/Q Tile_X0Y0_FrameData[5] VGND VPWR Tile_X0Y1_FrameStrobe[2] latch
XFILLER_90_162 VPWR VGND sg13cmos5l_decap_8
XFILLER_76_0 VPWR VGND sg13cmos5l_fill_1
XFILLER_90_2 VPWR VGND sg13cmos5l_fill_1
XANTENNA__0811__X Tile_X0Y0_FrameStrobe_O[8] VPWR VGND sg13cmos5l_antennanp
XFILLER_129_194 VPWR VGND sg13cmos5l_decap_4
XFILLER_104_35 VPWR VGND sg13cmos5l_fill_2
X_0519_ _0519_/Q Tile_X0Y1_FrameData[19] VGND VPWR Tile_X0Y1_FrameStrobe[5] latch
XFILLER_120_78 VPWR VGND sg13cmos5l_fill_1
XFILLER_64_28 VPWR VGND sg13cmos5l_decap_4
XANTENNA__0721__X Tile_X0Y0_W1BEG[2] VPWR VGND sg13cmos5l_antennanp
XFILLER_129_54 VPWR VGND sg13cmos5l_fill_2
XFILLER_135_164 VPWR VGND sg13cmos5l_decap_8
XFILLER_135_186 VPWR VGND sg13cmos5l_decap_8
XFILLER_49_115 VPWR VGND sg13cmos5l_decap_8
XFILLER_89_69 VPWR VGND sg13cmos5l_decap_8
XFILLER_38_62 VPWR VGND sg13cmos5l_fill_1
XFILLER_49_159 VPWR VGND sg13cmos5l_decap_8
XFILLER_72_140 VPWR VGND sg13cmos5l_decap_8
X_0870_ Tile_X0Y0_FrameData_O[14] Tile_X0Y0_FrameData[14] VPWR VGND sg13cmos5l_buf_1
XFILLER_126_131 VPWR VGND sg13cmos5l_decap_8
XFILLER_126_197 VPWR VGND sg13cmos5l_decap_8
XFILLER_141_101 VPWR VGND sg13cmos5l_decap_8
X_0304_ _0304_/Q Tile_X0Y0_FrameData[12] VGND VPWR Tile_X0Y1_FrameStrobe[6] latch
X_0235_ _0235_/Q Tile_X0Y0_FrameData[17] VGND VPWR Tile_X0Y1_FrameStrobe[4] latch
XFILLER_95_90 VPWR VGND sg13cmos5l_fill_2
XFILLER_95_210 VPWR VGND sg13cmos5l_decap_8
XANTENNA__0806__X Tile_X0Y0_FrameStrobe_O[3] VPWR VGND sg13cmos5l_antennanp
X_0166_ _0166_/Q Tile_X0Y0_FrameData[22] VGND VPWR Tile_X0Y1_FrameStrobe[2] latch
X_0097_ _0097_/Q Tile_X0Y0_FrameData[27] VGND VPWR Tile_X0Y1_FrameStrobe[0] latch
X_0999_ _0999_/X Tile_X0Y0_E1END[0] Tile_X0Y0_E6END[4] _1075_/X _1100_/X _0346_/Q
+ _0345_/Q VPWR VGND sg13cmos5l_mux4_1
XFILLER_132_101 VPWR VGND sg13cmos5l_decap_8
XFILLER_132_178 VPWR VGND sg13cmos5l_decap_8
XFILLER_59_28 VPWR VGND sg13cmos5l_decap_8
XFILLER_86_210 VPWR VGND sg13cmos5l_decap_8
XFILLER_131_11 VPWR VGND sg13cmos5l_decap_8
XFILLER_24_86 VPWR VGND sg13cmos5l_fill_1
XFILLER_108_120 VPWR VGND sg13cmos5l_fill_2
XFILLER_40_41 VPWR VGND sg13cmos5l_decap_8
XFILLER_6_0 VPWR VGND sg13cmos5l_fill_2
XFILLER_6_203 VPWR VGND sg13cmos5l_decap_4
XFILLER_123_167 VPWR VGND sg13cmos5l_decap_8
XFILLER_1_35 VPWR VGND sg13cmos5l_decap_8
XFILLER_1_46 VPWR VGND sg13cmos5l_fill_1
XFILLER_49_72 VPWR VGND sg13cmos5l_fill_2
XFILLER_77_210 VPWR VGND sg13cmos5l_decap_8
XFILLER_45_173 VPWR VGND sg13cmos5l_decap_8
XFILLER_65_82 VPWR VGND sg13cmos5l_decap_8
X_0853_ Tile_X0Y1_FrameData_O[29] Tile_X0Y1_FrameData[29] VPWR VGND sg13cmos5l_buf_1
X_0922_ Tile_X0Y1_S4BEG[14] _0922_/A VPWR VGND sg13cmos5l_buf_1
XFILLER_114_156 VPWR VGND sg13cmos5l_fill_1
XFILLER_39_0 VPWR VGND sg13cmos5l_decap_8
X_0784_ Tile_X0Y0_N2BEGb[1] _1104_/X VPWR VGND sg13cmos5l_buf_1
X_1198_ _1198_/X Tile_X0Y1_N2MID[3] Tile_X0Y1_N2END[3] _1222_/X Tile_X0Y0_S2MID[3]
+ _0364_/Q _0363_/Q VPWR VGND sg13cmos5l_mux4_1
X_0218_ _0218_/Q Tile_X0Y0_FrameData[2] VGND VPWR Tile_X0Y1_FrameStrobe[3] latch
XFILLER_101_25 VPWR VGND sg13cmos5l_decap_8
XFILLER_137_204 VPWR VGND sg13cmos5l_fill_2
XFILLER_51_154 VPWR VGND sg13cmos5l_decap_8
XFILLER_61_29 VPWR VGND sg13cmos5l_decap_8
X_0149_ _0149_/Q Tile_X0Y0_FrameData[7] VGND VPWR Tile_X0Y1_FrameStrobe[1] latch
XFILLER_117_7 VPWR VGND sg13cmos5l_decap_4
XFILLER_3_206 VPWR VGND sg13cmos5l_decap_8
XFILLER_3_217 VPWR VGND sg13cmos5l_fill_1
XFILLER_105_189 VPWR VGND sg13cmos5l_decap_8
XFILLER_10_66 VPWR VGND sg13cmos5l_decap_8
XFILLER_10_77 VPWR VGND sg13cmos5l_fill_2
XFILLER_19_53 VPWR VGND sg13cmos5l_decap_8
XFILLER_19_86 VPWR VGND sg13cmos5l_decap_4
XFILLER_35_41 VPWR VGND sg13cmos5l_decap_8
XFILLER_42_176 VPWR VGND sg13cmos5l_decap_8
XFILLER_80_205 VPWR VGND sg13cmos5l_decap_8
XFILLER_80_216 VPWR VGND sg13cmos5l_fill_2
X_1052_ _1052_/X _0637_/Q _0641_/Q _1081_/X _1094_/X _0224_/Q _0223_/Q VPWR VGND sg13cmos5l_mux4_1
X_1121_ _1121_/X Tile_X0Y1_E1END[0] Tile_X0Y1_EE4END[0] Tile_X0Y1_E6END[8] _1203_/X
+ _0578_/Q _0577_/Q VPWR VGND sg13cmos5l_mux4_1
XFILLER_18_173 VPWR VGND sg13cmos5l_decap_8
X_0905_ Tile_X0Y1_S2BEGb[5] _1224_/X VPWR VGND sg13cmos5l_buf_1
X_0836_ Tile_X0Y1_FrameData_O[12] Tile_X0Y1_FrameData[12] VPWR VGND sg13cmos5l_buf_1
X_0767_ Tile_X0Y0_WW4BEG[0] _1047_/X VPWR VGND sg13cmos5l_buf_1
X_0698_ _0698_/L_HI VPWR VGND sg13cmos5l_tiehi
XFILLER_112_46 VPWR VGND sg13cmos5l_decap_8
XFILLER_72_28 VPWR VGND sg13cmos5l_decap_4
XANTENNA_50 Tile_X0Y1_N2MID[7] VPWR VGND sg13cmos5l_antennanp
XFILLER_24_198 VPWR VGND sg13cmos5l_fill_2
XFILLER_137_21 VPWR VGND sg13cmos5l_decap_8
XFILLER_137_98 VPWR VGND sg13cmos5l_decap_8
XFILLER_97_36 VPWR VGND sg13cmos5l_decap_8
XFILLER_97_14 VPWR VGND sg13cmos5l_fill_1
XFILLER_101_181 VPWR VGND sg13cmos5l_decap_8
XFILLER_47_202 VPWR VGND sg13cmos5l_fill_2
XANTENNA__0904__X Tile_X0Y1_S2BEGb[4] VPWR VGND sg13cmos5l_antennanp
XFILLER_15_154 VPWR VGND sg13cmos5l_fill_2
XFILLER_30_113 VPWR VGND sg13cmos5l_decap_8
XFILLER_46_62 VPWR VGND sg13cmos5l_decap_8
XFILLER_62_216 VPWR VGND sg13cmos5l_fill_2
XFILLER_62_72 VPWR VGND sg13cmos5l_fill_1
XFILLER_7_34 VPWR VGND sg13cmos5l_fill_2
XFILLER_7_56 VPWR VGND sg13cmos5l_decap_8
XFILLER_7_67 VPWR VGND sg13cmos5l_fill_2
XFILLER_7_78 VPWR VGND sg13cmos5l_fill_1
XFILLER_7_89 VPWR VGND sg13cmos5l_decap_4
X_0621_ NPU_ACT_WDATA3 Tile_X0Y1_UserCLK _0985_/X _0662_/L_HI VPWR VGND sg13cmos5l_dfrbpq_1
X_0552_ _0552_/Q Tile_X0Y1_FrameData[18] VGND VPWR Tile_X0Y1_FrameStrobe[6] latch
X_0483_ _0483_/Q Tile_X0Y1_FrameData[23] VGND VPWR Tile_X0Y1_FrameStrobe[4] latch
XFILLER_97_135 VPWR VGND sg13cmos5l_fill_1
XFILLER_87_91 VPWR VGND sg13cmos5l_decap_8
X_1035_ _1035_/X Tile_X0Y0_EE4END[8] _0640_/Q _1095_/X _1096_/X _0258_/Q _0257_/Q
+ VPWR VGND sg13cmos5l_mux4_1
X_1104_ _1104_/X Tile_X0Y1_E2MID[6] Tile_X0Y1_E2END[6] Tile_X0Y1_E6END[6] _1196_/X
+ _0592_/Q _0591_/Q VPWR VGND sg13cmos5l_mux4_1
XANTENNA__0814__X Tile_X0Y0_FrameStrobe_O[11] VPWR VGND sg13cmos5l_antennanp
X_0819_ Tile_X0Y0_FrameStrobe_O[16] Tile_X0Y1_FrameStrobe[16] VPWR VGND sg13cmos5l_buf_1
XFILLER_88_102 VPWR VGND sg13cmos5l_decap_8
XFILLER_67_28 VPWR VGND sg13cmos5l_decap_8
XFILLER_96_190 VPWR VGND sg13cmos5l_decap_8
XANTENNA__0724__X Tile_X0Y0_W2BEG[1] VPWR VGND sg13cmos5l_antennanp
XFILLER_83_49 VPWR VGND sg13cmos5l_decap_8
XFILLER_12_168 VPWR VGND sg13cmos5l_decap_4
XFILLER_32_53 VPWR VGND sg13cmos5l_fill_1
XFILLER_8_139 VPWR VGND sg13cmos5l_fill_2
XFILLER_8_128 VPWR VGND sg13cmos5l_decap_8
XFILLER_106_0 VPWR VGND sg13cmos5l_decap_8
XFILLER_79_179 VPWR VGND sg13cmos5l_decap_8
XFILLER_35_216 VPWR VGND sg13cmos5l_fill_2
XFILLER_57_72 VPWR VGND sg13cmos5l_fill_1
XFILLER_78_4 VPWR VGND sg13cmos5l_fill_2
XFILLER_7_150 VPWR VGND sg13cmos5l_decap_8
X_0604_ _0604_/Q Tile_X0Y1_FrameData[26] VGND VPWR Tile_X0Y1_FrameStrobe[8] latch
XANTENNA__0809__X Tile_X0Y0_FrameStrobe_O[6] VPWR VGND sg13cmos5l_antennanp
XFILLER_21_0 VPWR VGND sg13cmos5l_decap_4
XFILLER_78_190 VPWR VGND sg13cmos5l_decap_8
X_0535_ _0535_/Q Tile_X0Y1_FrameData[3] VGND VPWR Tile_X0Y1_FrameStrobe[5] latch
X_0466_ _0466_/Q Tile_X0Y1_FrameData[8] VGND VPWR Tile_X0Y1_FrameStrobe[3] latch
X_0397_ _0397_/Q Tile_X0Y1_FrameData[13] VGND VPWR Tile_X0Y1_FrameStrobe[1] latch
XFILLER_26_205 VPWR VGND sg13cmos5l_fill_2
X_1018_ _1018_/X _1084_/X _1080_/X _1079_/X _1095_/X _0313_/Q _0312_/Q VPWR VGND sg13cmos5l_mux4_1
XFILLER_139_129 VPWR VGND sg13cmos5l_fill_1
XFILLER_103_210 VPWR VGND sg13cmos5l_decap_8
XFILLER_134_33 VPWR VGND sg13cmos5l_decap_4
XANTENNA__0719__X Tile_X0Y0_W1BEG[0] VPWR VGND sg13cmos5l_antennanp
XFILLER_27_53 VPWR VGND sg13cmos5l_decap_8
XFILLER_76_138 VPWR VGND sg13cmos5l_fill_2
XFILLER_94_48 VPWR VGND sg13cmos5l_decap_8
XFILLER_138_140 VPWR VGND sg13cmos5l_decap_8
XFILLER_138_173 VPWR VGND sg13cmos5l_decap_8
XFILLER_4_175 VPWR VGND sg13cmos5l_decap_8
XFILLER_4_35 VPWR VGND sg13cmos5l_decap_8
X_0320_ _0320_/Q Tile_X0Y0_FrameData[28] VGND VPWR Tile_X0Y1_FrameStrobe[7] latch
X_0251_ _0251_/Q Tile_X0Y0_FrameData[1] VGND VPWR Tile_X0Y1_FrameStrobe[4] latch
XFILLER_75_193 VPWR VGND sg13cmos5l_decap_8
X_0182_ _0182_/Q Tile_X0Y0_FrameData[6] VGND VPWR Tile_X0Y1_FrameStrobe[2] latch
XFILLER_129_173 VPWR VGND sg13cmos5l_decap_8
XFILLER_69_0 VPWR VGND sg13cmos5l_decap_8
X_0518_ _0518_/Q Tile_X0Y1_FrameData[20] VGND VPWR Tile_X0Y1_FrameStrobe[5] latch
XFILLER_66_193 VPWR VGND sg13cmos5l_decap_8
X_0449_ _0449_/Q Tile_X0Y1_FrameData[25] VGND VPWR Tile_X0Y1_FrameStrobe[3] latch
XFILLER_120_35 VPWR VGND sg13cmos5l_fill_1
XFILLER_81_196 VPWR VGND sg13cmos5l_decap_8
XFILLER_129_88 VPWR VGND sg13cmos5l_fill_1
XFILLER_135_132 VPWR VGND sg13cmos5l_fill_1
XFILLER_135_143 VPWR VGND sg13cmos5l_decap_8
XFILLER_1_112 VPWR VGND sg13cmos5l_fill_2
XFILLER_8_4 VPWR VGND sg13cmos5l_fill_2
XFILLER_38_96 VPWR VGND sg13cmos5l_decap_8
XFILLER_64_108 VPWR VGND sg13cmos5l_decap_8
XFILLER_72_196 VPWR VGND sg13cmos5l_decap_8
XANTENNA__0912__X Tile_X0Y1_S4BEG[4] VPWR VGND sg13cmos5l_antennanp
XFILLER_126_110 VPWR VGND sg13cmos5l_decap_8
XFILLER_141_179 VPWR VGND sg13cmos5l_decap_8
XFILLER_62_7 VPWR VGND sg13cmos5l_fill_2
XFILLER_48_160 VPWR VGND sg13cmos5l_decap_8
X_0303_ _0303_/Q Tile_X0Y0_FrameData[13] VGND VPWR Tile_X0Y1_FrameStrobe[6] latch
X_0234_ _0234_/Q Tile_X0Y0_FrameData[18] VGND VPWR Tile_X0Y1_FrameStrobe[4] latch
X_0165_ _0165_/Q Tile_X0Y0_FrameData[23] VGND VPWR Tile_X0Y1_FrameStrobe[2] latch
X_0096_ _0096_/Q Tile_X0Y0_FrameData[28] VGND VPWR Tile_X0Y1_FrameStrobe[0] latch
XANTENNA__0822__X Tile_X0Y0_FrameStrobe_O[19] VPWR VGND sg13cmos5l_antennanp
XFILLER_117_110 VPWR VGND sg13cmos5l_decap_8
X_0998_ _0998_/X Tile_X0Y0_EE4END[3] Tile_X0Y0_EE4END[11] Tile_X0Y0_E6END[3] _1091_/X
+ _0172_/Q _0171_/Q VPWR VGND sg13cmos5l_mux4_1
XFILLER_117_187 VPWR VGND sg13cmos5l_decap_8
XFILLER_132_157 VPWR VGND sg13cmos5l_decap_8
XFILLER_131_89 VPWR VGND sg13cmos5l_decap_8
XFILLER_39_160 VPWR VGND sg13cmos5l_decap_8
XFILLER_54_152 VPWR VGND sg13cmos5l_fill_1
XANTENNA__0732__X Tile_X0Y0_W2BEGb[1] VPWR VGND sg13cmos5l_antennanp
XFILLER_10_211 VPWR VGND sg13cmos5l_decap_8
XFILLER_24_65 VPWR VGND sg13cmos5l_decap_4
XFILLER_40_20 VPWR VGND sg13cmos5l_decap_8
XFILLER_108_154 VPWR VGND sg13cmos5l_decap_8
XFILLER_123_146 VPWR VGND sg13cmos5l_decap_8
XFILLER_1_14 VPWR VGND sg13cmos5l_decap_8
XANTENNA__0907__X Tile_X0Y1_S2BEGb[7] VPWR VGND sg13cmos5l_antennanp
XFILLER_60_166 VPWR VGND sg13cmos5l_decap_8
XFILLER_65_61 VPWR VGND sg13cmos5l_decap_8
X_0921_ Tile_X0Y1_S4BEG[13] _0921_/A VPWR VGND sg13cmos5l_buf_1
X_0852_ Tile_X0Y1_FrameData_O[28] Tile_X0Y1_FrameData[28] VPWR VGND sg13cmos5l_buf_1
X_0783_ Tile_X0Y0_N2BEGb[0] _1103_/X VPWR VGND sg13cmos5l_buf_1
XANTENNA__0817__X Tile_X0Y0_FrameStrobe_O[14] VPWR VGND sg13cmos5l_antennanp
XFILLER_28_119 VPWR VGND sg13cmos5l_decap_8
XFILLER_36_141 VPWR VGND sg13cmos5l_fill_2
XFILLER_51_100 VPWR VGND sg13cmos5l_decap_8
X_1197_ _1197_/X Tile_X0Y1_N2MID[2] Tile_X0Y1_N2END[2] _1221_/X Tile_X0Y0_S2MID[2]
+ _0366_/Q _0365_/Q VPWR VGND sg13cmos5l_mux4_1
X_0217_ _0217_/Q Tile_X0Y0_FrameData[3] VGND VPWR Tile_X0Y1_FrameStrobe[3] latch
X_0148_ _0148_/Q Tile_X0Y0_FrameData[8] VGND VPWR Tile_X0Y1_FrameStrobe[1] latch
X_0079_ _0922_/A _1139_/X _1140_/X _0534_/Q VPWR VGND sg13cmos5l_mux2_1
XFILLER_10_34 VPWR VGND sg13cmos5l_fill_1
XFILLER_10_45 VPWR VGND sg13cmos5l_decap_8
XFILLER_10_89 VPWR VGND sg13cmos5l_decap_8
XFILLER_120_149 VPWR VGND sg13cmos5l_decap_8
XFILLER_126_89 VPWR VGND sg13cmos5l_decap_8
XFILLER_19_32 VPWR VGND sg13cmos5l_decap_4
XFILLER_19_98 VPWR VGND sg13cmos5l_fill_1
XFILLER_74_214 VPWR VGND sg13cmos5l_decap_4
XANTENNA__0727__X Tile_X0Y0_W2BEG[4] VPWR VGND sg13cmos5l_antennanp
XFILLER_27_185 VPWR VGND sg13cmos5l_decap_4
XFILLER_35_20 VPWR VGND sg13cmos5l_decap_8
XFILLER_35_97 VPWR VGND sg13cmos5l_decap_8
XFILLER_136_0 VPWR VGND sg13cmos5l_decap_8
XFILLER_76_60 VPWR VGND sg13cmos5l_fill_2
X_1051_ _1051_/X _0636_/Q _0640_/Q _1080_/X _1095_/X _0226_/Q _0225_/Q VPWR VGND sg13cmos5l_mux4_1
X_1120_ _1120_/X _1208_/X _1212_/X _1216_/X _1196_/X _0575_/Q _0574_/Q VPWR VGND sg13cmos5l_mux4_1
XFILLER_119_205 VPWR VGND sg13cmos5l_fill_2
X_0904_ Tile_X0Y1_S2BEGb[4] _1223_/X VPWR VGND sg13cmos5l_buf_1
XFILLER_51_0 VPWR VGND sg13cmos5l_decap_4
X_0835_ Tile_X0Y1_FrameData_O[11] Tile_X0Y1_FrameData[11] VPWR VGND sg13cmos5l_buf_1
X_0766_ Tile_X0Y0_N4BEG[15] _0766_/A VPWR VGND sg13cmos5l_buf_1
X_0697_ _0697_/L_HI VPWR VGND sg13cmos5l_tiehi
XFILLER_110_160 VPWR VGND sg13cmos5l_decap_4
XFILLER_110_193 VPWR VGND sg13cmos5l_decap_8
XFILLER_71_217 VPWR VGND sg13cmos5l_fill_1
XANTENNA_40 Tile_X0Y1_N2MID[3] VPWR VGND sg13cmos5l_antennanp
XANTENNA_51 NPU_OUT_ACT1 VPWR VGND sg13cmos5l_antennanp
XFILLER_108_4 VPWR VGND sg13cmos5l_fill_1
XFILLER_137_77 VPWR VGND sg13cmos5l_decap_8
XFILLER_46_41 VPWR VGND sg13cmos5l_decap_8
XFILLER_15_122 VPWR VGND sg13cmos5l_decap_8
XFILLER_15_199 VPWR VGND sg13cmos5l_decap_4
XFILLER_30_169 VPWR VGND sg13cmos5l_decap_8
XFILLER_62_40 VPWR VGND sg13cmos5l_decap_8
XANTENNA__0920__X Tile_X0Y1_S4BEG[12] VPWR VGND sg13cmos5l_antennanp
XFILLER_7_46 VPWR VGND sg13cmos5l_fill_2
X_0620_ NPU_ACT_WDATA2 Tile_X0Y1_UserCLK _0984_/X _0661_/L_HI VPWR VGND sg13cmos5l_dfrbpq_1
X_0551_ _0551_/Q Tile_X0Y1_FrameData[19] VGND VPWR Tile_X0Y1_FrameStrobe[6] latch
X_0482_ _0482_/Q Tile_X0Y1_FrameData[24] VGND VPWR Tile_X0Y1_FrameStrobe[4] latch
XFILLER_97_147 VPWR VGND sg13cmos5l_decap_4
XFILLER_87_70 VPWR VGND sg13cmos5l_decap_8
X_1034_ _1034_/X Tile_X0Y0_EE4END[7] _0639_/Q _1095_/X _1096_/X _0260_/Q _0259_/Q
+ VPWR VGND sg13cmos5l_mux4_1
X_1103_ _1103_/X Tile_X0Y1_E2MID[7] Tile_X0Y1_E2END[7] Tile_X0Y1_E6END[7] _1195_/X
+ _0594_/Q _0593_/Q VPWR VGND sg13cmos5l_mux4_1
XFILLER_99_0 VPWR VGND sg13cmos5l_fill_2
XANTENNA__0830__X Tile_X0Y1_FrameData_O[6] VPWR VGND sg13cmos5l_antennanp
XFILLER_107_36 VPWR VGND sg13cmos5l_fill_2
XFILLER_107_69 VPWR VGND sg13cmos5l_fill_1
X_0818_ Tile_X0Y0_FrameStrobe_O[15] Tile_X0Y1_FrameStrobe[15] VPWR VGND sg13cmos5l_buf_1
X_0749_ Tile_X0Y0_W6BEG[10] _1073_/X VPWR VGND sg13cmos5l_buf_1
XFILLER_83_39 VPWR VGND sg13cmos5l_fill_2
XFILLER_12_114 VPWR VGND sg13cmos5l_fill_2
XANTENNA__0740__X Tile_X0Y0_W6BEG[1] VPWR VGND sg13cmos5l_antennanp
XFILLER_32_65 VPWR VGND sg13cmos5l_fill_1
XFILLER_32_87 VPWR VGND sg13cmos5l_decap_8
XFILLER_57_40 VPWR VGND sg13cmos5l_decap_8
XFILLER_79_158 VPWR VGND sg13cmos5l_decap_8
XANTENNA__0915__X Tile_X0Y1_S4BEG[7] VPWR VGND sg13cmos5l_antennanp
X_0603_ _0603_/Q Tile_X0Y1_FrameData[31] VGND VPWR Tile_X0Y1_FrameStrobe[0] latch
X_0534_ _0534_/Q Tile_X0Y1_FrameData[4] VGND VPWR Tile_X0Y1_FrameStrobe[5] latch
XFILLER_14_0 VPWR VGND sg13cmos5l_decap_4
XFILLER_26_217 VPWR VGND sg13cmos5l_fill_1
X_0465_ _0465_/Q Tile_X0Y1_FrameData[9] VGND VPWR Tile_X0Y1_FrameStrobe[3] latch
X_0396_ _0396_/Q Tile_X0Y1_FrameData[14] VGND VPWR Tile_X0Y1_FrameStrobe[1] latch
XANTENNA__0825__X Tile_X0Y1_FrameData_O[1] VPWR VGND sg13cmos5l_antennanp
XFILLER_139_108 VPWR VGND sg13cmos5l_decap_8
X_1017_ _1017_/X Tile_X0Y0_E1END[3] Tile_X0Y0_EE4END[3] Tile_X0Y0_E6END[11] _1091_/X
+ _0313_/Q _0312_/Q VPWR VGND sg13cmos5l_mux4_1
XFILLER_118_35 VPWR VGND sg13cmos5l_decap_8
XFILLER_78_17 VPWR VGND sg13cmos5l_fill_1
XFILLER_94_27 VPWR VGND sg13cmos5l_decap_8
XANTENNA__0735__X Tile_X0Y0_W2BEGb[4] VPWR VGND sg13cmos5l_antennanp
XFILLER_17_206 VPWR VGND sg13cmos5l_fill_1
XFILLER_17_217 VPWR VGND sg13cmos5l_fill_1
XFILLER_27_21 VPWR VGND sg13cmos5l_decap_8
XFILLER_84_183 VPWR VGND sg13cmos5l_decap_8
XFILLER_43_86 VPWR VGND sg13cmos5l_decap_8
XFILLER_4_14 VPWR VGND sg13cmos5l_decap_8
XFILLER_4_154 VPWR VGND sg13cmos5l_decap_8
XFILLER_75_172 VPWR VGND sg13cmos5l_decap_8
X_0250_ _0250_/Q Tile_X0Y0_FrameData[2] VGND VPWR Tile_X0Y1_FrameStrobe[4] latch
X_0181_ _0181_/Q Tile_X0Y0_FrameData[7] VGND VPWR Tile_X0Y1_FrameStrobe[2] latch
XFILLER_90_197 VPWR VGND sg13cmos5l_fill_2
XFILLER_129_152 VPWR VGND sg13cmos5l_decap_8
XFILLER_100_203 VPWR VGND sg13cmos5l_decap_4
X_0517_ _0517_/Q Tile_X0Y1_FrameData[21] VGND VPWR Tile_X0Y1_FrameStrobe[5] latch
XFILLER_104_37 VPWR VGND sg13cmos5l_fill_1
XFILLER_73_109 VPWR VGND sg13cmos5l_decap_8
XFILLER_81_153 VPWR VGND sg13cmos5l_decap_4
X_0448_ _0448_/Q Tile_X0Y1_FrameData[26] VGND VPWR Tile_X0Y1_FrameStrobe[3] latch
X_0379_ _0379_/Q Tile_X0Y1_FrameData[31] VGND VPWR Tile_X0Y1_FrameStrobe[1] latch
XFILLER_13_34 VPWR VGND sg13cmos5l_fill_1
XFILLER_13_89 VPWR VGND sg13cmos5l_decap_8
XFILLER_1_124 VPWR VGND sg13cmos5l_fill_1
XFILLER_89_38 VPWR VGND sg13cmos5l_decap_8
XFILLER_1_135 VPWR VGND sg13cmos5l_decap_8
XFILLER_1_146 VPWR VGND sg13cmos5l_fill_2
XFILLER_1_179 VPWR VGND sg13cmos5l_decap_8
XFILLER_49_106 VPWR VGND sg13cmos5l_decap_4
XFILLER_54_85 VPWR VGND sg13cmos5l_fill_2
XFILLER_72_175 VPWR VGND sg13cmos5l_decap_8
XFILLER_70_84 VPWR VGND sg13cmos5l_decap_8
XFILLER_126_166 VPWR VGND sg13cmos5l_decap_8
XFILLER_126_177 VPWR VGND sg13cmos5l_fill_2
XFILLER_141_136 VPWR VGND sg13cmos5l_decap_8
X_0302_ _0302_/Q Tile_X0Y0_FrameData[14] VGND VPWR Tile_X0Y1_FrameStrobe[6] latch
XFILLER_0_190 VPWR VGND sg13cmos5l_decap_8
XFILLER_48_194 VPWR VGND sg13cmos5l_decap_8
XFILLER_63_164 VPWR VGND sg13cmos5l_decap_8
X_0233_ _0233_/Q Tile_X0Y0_FrameData[19] VGND VPWR Tile_X0Y1_FrameStrobe[4] latch
X_0164_ _0164_/Q Tile_X0Y0_FrameData[24] VGND VPWR Tile_X0Y1_FrameStrobe[2] latch
XFILLER_95_92 VPWR VGND sg13cmos5l_fill_1
XFILLER_81_0 VPWR VGND sg13cmos5l_decap_4
X_0095_ _0095_/Q Tile_X0Y0_FrameData[29] VGND VPWR Tile_X0Y1_FrameStrobe[0] latch
XFILLER_117_166 VPWR VGND sg13cmos5l_decap_8
XFILLER_132_136 VPWR VGND sg13cmos5l_decap_8
X_0997_ _0997_/X Tile_X0Y1_E1END[3] Tile_X0Y1_EE4END[7] Tile_X0Y1_EE4END[15] _1218_/X
+ _0404_/Q _0403_/Q VPWR VGND sg13cmos5l_mux4_1
XFILLER_115_36 VPWR VGND sg13cmos5l_fill_1
XFILLER_131_68 VPWR VGND sg13cmos5l_decap_8
XFILLER_91_39 VPWR VGND sg13cmos5l_fill_2
XFILLER_91_28 VPWR VGND sg13cmos5l_decap_8
XFILLER_108_111 VPWR VGND sg13cmos5l_fill_2
XFILLER_24_44 VPWR VGND sg13cmos5l_decap_8
XFILLER_24_77 VPWR VGND sg13cmos5l_decap_8
XFILLER_108_199 VPWR VGND sg13cmos5l_decap_8
XFILLER_40_87 VPWR VGND sg13cmos5l_decap_8
XFILLER_40_98 VPWR VGND sg13cmos5l_fill_2
XFILLER_6_2 VPWR VGND sg13cmos5l_fill_1
XFILLER_131_191 VPWR VGND sg13cmos5l_decap_4
XFILLER_45_131 VPWR VGND sg13cmos5l_decap_4
XFILLER_45_142 VPWR VGND sg13cmos5l_decap_4
XFILLER_92_215 VPWR VGND sg13cmos5l_fill_2
XANTENNA__0923__X Tile_X0Y1_S4BEG[15] VPWR VGND sg13cmos5l_antennanp
XFILLER_60_178 VPWR VGND sg13cmos5l_fill_2
X_0920_ Tile_X0Y1_S4BEG[12] _0920_/A VPWR VGND sg13cmos5l_buf_1
X_0851_ Tile_X0Y1_FrameData_O[27] Tile_X0Y1_FrameData[27] VPWR VGND sg13cmos5l_buf_1
X_0782_ Tile_X0Y0_WW4BEG[15] _1062_/X VPWR VGND sg13cmos5l_buf_1
XFILLER_122_180 VPWR VGND sg13cmos5l_decap_8
XFILLER_36_164 VPWR VGND sg13cmos5l_decap_8
XFILLER_51_134 VPWR VGND sg13cmos5l_decap_4
XFILLER_51_145 VPWR VGND sg13cmos5l_fill_2
X_1196_ _1196_/X Tile_X0Y1_N2MID[1] Tile_X0Y1_N2END[1] _1220_/X Tile_X0Y0_S2MID[1]
+ _0368_/Q _0367_/Q VPWR VGND sg13cmos5l_mux4_1
X_0216_ _0216_/Q Tile_X0Y0_FrameData[4] VGND VPWR Tile_X0Y1_FrameStrobe[3] latch
X_0147_ _0147_/Q Tile_X0Y0_FrameData[9] VGND VPWR Tile_X0Y1_FrameStrobe[1] latch
X_0078_ _0921_/A _1137_/X _1138_/X _0537_/Q VPWR VGND sg13cmos5l_mux2_1
XANTENNA__0833__X Tile_X0Y1_FrameData_O[9] VPWR VGND sg13cmos5l_antennanp
XFILLER_137_206 VPWR VGND sg13cmos5l_fill_1
XFILLER_137_217 VPWR VGND sg13cmos5l_fill_1
XFILLER_105_169 VPWR VGND sg13cmos5l_decap_4
XFILLER_120_128 VPWR VGND sg13cmos5l_decap_8
XFILLER_126_35 VPWR VGND sg13cmos5l_decap_8
XFILLER_126_68 VPWR VGND sg13cmos5l_decap_8
XFILLER_19_109 VPWR VGND sg13cmos5l_decap_8
XFILLER_27_131 VPWR VGND sg13cmos5l_decap_4
XANTENNA__0743__X Tile_X0Y0_W6BEG[4] VPWR VGND sg13cmos5l_antennanp
XFILLER_27_164 VPWR VGND sg13cmos5l_decap_8
XFILLER_27_197 VPWR VGND sg13cmos5l_fill_2
XFILLER_35_76 VPWR VGND sg13cmos5l_decap_8
XFILLER_128_206 VPWR VGND sg13cmos5l_decap_8
XFILLER_128_217 VPWR VGND sg13cmos5l_fill_1
XFILLER_129_0 VPWR VGND sg13cmos5l_decap_8
XFILLER_51_42 VPWR VGND sg13cmos5l_decap_8
XFILLER_51_86 VPWR VGND sg13cmos5l_decap_8
XFILLER_104_191 VPWR VGND sg13cmos5l_decap_8
XFILLER_111_117 VPWR VGND sg13cmos5l_fill_2
XANTENNA__0918__X Tile_X0Y1_S4BEG[10] VPWR VGND sg13cmos5l_antennanp
XFILLER_33_112 VPWR VGND sg13cmos5l_decap_8
XFILLER_33_134 VPWR VGND sg13cmos5l_decap_8
XFILLER_33_145 VPWR VGND sg13cmos5l_fill_1
XFILLER_76_83 VPWR VGND sg13cmos5l_decap_8
X_1050_ _1050_/X _0639_/Q _0643_/Q _1075_/X _1096_/X _0228_/Q _0227_/Q VPWR VGND sg13cmos5l_mux4_1
XFILLER_119_217 VPWR VGND sg13cmos5l_fill_1
X_0903_ Tile_X0Y1_S2BEGb[3] _1222_/X VPWR VGND sg13cmos5l_buf_1
X_0834_ Tile_X0Y1_FrameData_O[10] Tile_X0Y1_FrameData[10] VPWR VGND sg13cmos5l_buf_1
XFILLER_44_0 VPWR VGND sg13cmos5l_decap_8
X_0765_ Tile_X0Y0_N4BEG[14] _0765_/A VPWR VGND sg13cmos5l_buf_1
X_0696_ _0696_/L_HI VPWR VGND sg13cmos5l_tiehi
XANTENNA__0828__X Tile_X0Y1_FrameData_O[4] VPWR VGND sg13cmos5l_antennanp
X_1179_ _1179_/X Tile_X0Y1_N4END[0] Tile_X0Y0_S4END[4] _1214_/X _1218_/X _0458_/Q
+ _0457_/Q VPWR VGND sg13cmos5l_mux4_1
XANTENNA_30 Tile_X0Y1_N2END[5] VPWR VGND sg13cmos5l_antennanp
XANTENNA_41 Tile_X0Y1_N2MID[3] VPWR VGND sg13cmos5l_antennanp
XANTENNA_52 NPU_OUT_ACT5 VPWR VGND sg13cmos5l_antennanp
XFILLER_122_7 VPWR VGND sg13cmos5l_fill_1
XFILLER_137_56 VPWR VGND sg13cmos5l_decap_8
XANTENNA__0738__X Tile_X0Y0_W2BEGb[7] VPWR VGND sg13cmos5l_antennanp
XFILLER_15_156 VPWR VGND sg13cmos5l_fill_1
XFILLER_15_178 VPWR VGND sg13cmos5l_decap_8
XFILLER_30_148 VPWR VGND sg13cmos5l_decap_8
X_0550_ _0550_/Q Tile_X0Y1_FrameData[20] VGND VPWR Tile_X0Y1_FrameStrobe[6] latch
XFILLER_16_4 VPWR VGND sg13cmos5l_fill_2
X_1102_ _1102_/X _1113_/X Tile_X0Y0_E6END[2] Tile_X0Y0_S1END[2] _1102_/A3 _0096_/Q
+ _0095_/Q VPWR VGND sg13cmos5l_mux4_1
X_0481_ _0481_/Q Tile_X0Y1_FrameData[25] VGND VPWR Tile_X0Y1_FrameStrobe[4] latch
XFILLER_97_159 VPWR VGND sg13cmos5l_fill_2
X_1033_ _1033_/X Tile_X0Y0_EE4END[6] _0638_/Q _1094_/X _1097_/X _0262_/Q _0261_/Q
+ VPWR VGND sg13cmos5l_mux4_1
X_0817_ Tile_X0Y0_FrameStrobe_O[14] Tile_X0Y1_FrameStrobe[14] VPWR VGND sg13cmos5l_buf_1
XFILLER_130_212 VPWR VGND sg13cmos5l_decap_4
X_0748_ Tile_X0Y0_W6BEG[9] _1072_/X VPWR VGND sg13cmos5l_buf_1
X_0679_ _0679_/L_HI VPWR VGND sg13cmos5l_tiehi
XFILLER_20_192 VPWR VGND sg13cmos5l_decap_4
XFILLER_79_104 VPWR VGND sg13cmos5l_fill_1
XFILLER_57_63 VPWR VGND sg13cmos5l_decap_8
XFILLER_79_137 VPWR VGND sg13cmos5l_decap_8
XFILLER_87_192 VPWR VGND sg13cmos5l_decap_8
XFILLER_73_40 VPWR VGND sg13cmos5l_decap_8
XFILLER_73_51 VPWR VGND sg13cmos5l_fill_1
XFILLER_73_84 VPWR VGND sg13cmos5l_decap_4
XANTENNA__0931__X Tile_X0Y1_W2BEG[2] VPWR VGND sg13cmos5l_antennanp
XFILLER_11_181 VPWR VGND sg13cmos5l_decap_8
XFILLER_112_201 VPWR VGND sg13cmos5l_decap_8
XFILLER_7_185 VPWR VGND sg13cmos5l_decap_8
X_0602_ _0602_/Q Tile_X0Y1_FrameData[0] VGND VPWR Tile_X0Y1_FrameStrobe[7] latch
X_0533_ _0533_/Q Tile_X0Y1_FrameData[5] VGND VPWR Tile_X0Y1_FrameStrobe[5] latch
X_0464_ _0464_/Q Tile_X0Y1_FrameData[10] VGND VPWR Tile_X0Y1_FrameStrobe[3] latch
XFILLER_98_70 VPWR VGND sg13cmos5l_fill_1
X_0395_ _0395_/Q Tile_X0Y1_FrameData[15] VGND VPWR Tile_X0Y1_FrameStrobe[1] latch
X_1016_ _1016_/X _1085_/X _1081_/X _1077_/X _1094_/X _0316_/Q _0315_/Q VPWR VGND sg13cmos5l_mux4_1
XANTENNA__0841__X Tile_X0Y1_FrameData_O[17] VPWR VGND sg13cmos5l_antennanp
XFILLER_118_14 VPWR VGND sg13cmos5l_decap_8
XFILLER_134_13 VPWR VGND sg13cmos5l_decap_4
XFILLER_134_79 VPWR VGND sg13cmos5l_decap_8
XFILLER_27_11 VPWR VGND sg13cmos5l_decap_4
XFILLER_76_129 VPWR VGND sg13cmos5l_fill_2
XFILLER_27_88 VPWR VGND sg13cmos5l_decap_8
XFILLER_43_32 VPWR VGND sg13cmos5l_decap_8
XFILLER_84_162 VPWR VGND sg13cmos5l_decap_8
XANTENNA__0751__X Tile_X0Y0_N4BEG[0] VPWR VGND sg13cmos5l_antennanp
XFILLER_43_43 VPWR VGND sg13cmos5l_fill_2
XFILLER_108_80 VPWR VGND sg13cmos5l_decap_8
XFILLER_111_0 VPWR VGND sg13cmos5l_decap_8
XFILLER_4_144 VPWR VGND sg13cmos5l_decap_4
XFILLER_68_62 VPWR VGND sg13cmos5l_decap_8
XANTENNA__0926__X Tile_X0Y1_W1BEG[1] VPWR VGND sg13cmos5l_antennanp
X_0180_ _0180_/Q Tile_X0Y0_FrameData[8] VGND VPWR Tile_X0Y1_FrameStrobe[2] latch
XFILLER_90_132 VPWR VGND sg13cmos5l_fill_2
XFILLER_90_121 VPWR VGND sg13cmos5l_decap_8
XFILLER_90_176 VPWR VGND sg13cmos5l_decap_8
XFILLER_129_131 VPWR VGND sg13cmos5l_decap_8
XANTENNA__0610__Q NPU_WEIGHT_IN0 VPWR VGND sg13cmos5l_antennanp
X_0516_ _0516_/Q Tile_X0Y1_FrameData[22] VGND VPWR Tile_X0Y1_FrameStrobe[5] latch
X_0447_ _0447_/Q Tile_X0Y1_FrameData[27] VGND VPWR Tile_X0Y1_FrameStrobe[3] latch
XANTENNA__0836__X Tile_X0Y1_FrameData_O[12] VPWR VGND sg13cmos5l_antennanp
XFILLER_104_49 VPWR VGND sg13cmos5l_decap_8
XFILLER_66_173 VPWR VGND sg13cmos5l_fill_1
XFILLER_66_184 VPWR VGND sg13cmos5l_fill_1
X_0378_ _0378_/Q Tile_X0Y1_FrameData[0] VGND VPWR Tile_X0Y1_FrameStrobe[0] latch
XFILLER_13_79 VPWR VGND sg13cmos5l_decap_8
XFILLER_135_123 VPWR VGND sg13cmos5l_fill_1
XFILLER_135_178 VPWR VGND sg13cmos5l_decap_4
XFILLER_1_103 VPWR VGND sg13cmos5l_fill_2
XFILLER_89_210 VPWR VGND sg13cmos5l_decap_8
XANTENNA__0746__X Tile_X0Y0_W6BEG[7] VPWR VGND sg13cmos5l_antennanp
XFILLER_57_162 VPWR VGND sg13cmos5l_fill_2
XFILLER_54_42 VPWR VGND sg13cmos5l_fill_1
XFILLER_72_154 VPWR VGND sg13cmos5l_decap_8
XFILLER_9_214 VPWR VGND sg13cmos5l_decap_4
XFILLER_110_92 VPWR VGND sg13cmos5l_decap_4
XFILLER_126_145 VPWR VGND sg13cmos5l_decap_8
XFILLER_70_63 VPWR VGND sg13cmos5l_decap_8
XFILLER_141_115 VPWR VGND sg13cmos5l_decap_8
XFILLER_48_7 VPWR VGND sg13cmos5l_decap_8
XFILLER_79_83 VPWR VGND sg13cmos5l_decap_8
X_0301_ _0301_/Q Tile_X0Y0_FrameData[15] VGND VPWR Tile_X0Y1_FrameStrobe[6] latch
XFILLER_63_132 VPWR VGND sg13cmos5l_fill_2
X_0232_ _0232_/Q Tile_X0Y0_FrameData[20] VGND VPWR Tile_X0Y1_FrameStrobe[4] latch
X_0163_ _0163_/Q Tile_X0Y0_FrameData[25] VGND VPWR Tile_X0Y1_FrameStrobe[2] latch
X_0094_ _0094_/Q Tile_X0Y0_FrameData[30] VGND VPWR Tile_X0Y1_FrameStrobe[0] latch
XFILLER_74_0 VPWR VGND sg13cmos5l_decap_4
X_0996_ _0996_/X Tile_X0Y1_E1END[2] Tile_X0Y1_EE4END[6] Tile_X0Y1_EE4END[14] _1217_/X
+ _0406_/Q _0405_/Q VPWR VGND sg13cmos5l_mux4_1
XFILLER_117_145 VPWR VGND sg13cmos5l_decap_8
XFILLER_132_115 VPWR VGND sg13cmos5l_decap_8
XFILLER_5_80 VPWR VGND sg13cmos5l_decap_8
XFILLER_5_91 VPWR VGND sg13cmos5l_fill_1
XFILLER_140_170 VPWR VGND sg13cmos5l_decap_8
XFILLER_39_173 VPWR VGND sg13cmos5l_decap_4
XFILLER_39_184 VPWR VGND sg13cmos5l_decap_8
XFILLER_131_25 VPWR VGND sg13cmos5l_decap_4
XFILLER_131_47 VPWR VGND sg13cmos5l_decap_8
XFILLER_40_11 VPWR VGND sg13cmos5l_fill_1
XFILLER_40_55 VPWR VGND sg13cmos5l_decap_8
XFILLER_6_217 VPWR VGND sg13cmos5l_fill_1
XFILLER_108_178 VPWR VGND sg13cmos5l_decap_8
XFILLER_49_53 VPWR VGND sg13cmos5l_decap_8
XFILLER_49_64 VPWR VGND sg13cmos5l_fill_1
XFILLER_49_97 VPWR VGND sg13cmos5l_decap_4
XFILLER_77_202 VPWR VGND sg13cmos5l_decap_4
XFILLER_45_154 VPWR VGND sg13cmos5l_decap_8
XFILLER_45_187 VPWR VGND sg13cmos5l_decap_8
XFILLER_65_96 VPWR VGND sg13cmos5l_decap_8
X_0850_ Tile_X0Y1_FrameData_O[26] Tile_X0Y1_FrameData[26] VPWR VGND sg13cmos5l_buf_1
XFILLER_46_4 VPWR VGND sg13cmos5l_fill_1
X_0781_ Tile_X0Y0_WW4BEG[14] _1061_/X VPWR VGND sg13cmos5l_buf_1
X_0215_ _0215_/Q Tile_X0Y0_FrameData[5] VGND VPWR Tile_X0Y1_FrameStrobe[3] latch
XFILLER_101_39 VPWR VGND sg13cmos5l_decap_8
XFILLER_51_168 VPWR VGND sg13cmos5l_decap_4
X_1195_ _1195_/X Tile_X0Y1_N2MID[0] Tile_X0Y1_N2END[0] _1219_/X Tile_X0Y0_S2MID[0]
+ _0370_/Q _0369_/Q VPWR VGND sg13cmos5l_mux4_1
X_0146_ _0146_/Q Tile_X0Y0_FrameData[10] VGND VPWR Tile_X0Y1_FrameStrobe[1] latch
X_0077_ _0920_/A _1135_/X _1136_/X _0540_/Q VPWR VGND sg13cmos5l_mux2_1
X_0979_ _0979_/X Tile_X0Y0_E2MID[6] Tile_X0Y0_E2END[6] _1098_/X _0979_/A3 _0158_/Q
+ _0157_/Q VPWR VGND sg13cmos5l_mux4_1
XFILLER_105_104 VPWR VGND sg13cmos5l_decap_8
XFILLER_105_115 VPWR VGND sg13cmos5l_decap_8
XFILLER_105_126 VPWR VGND sg13cmos5l_fill_1
XFILLER_120_107 VPWR VGND sg13cmos5l_decap_4
XFILLER_126_14 VPWR VGND sg13cmos5l_decap_8
XFILLER_126_47 VPWR VGND sg13cmos5l_decap_8
XFILLER_86_29 VPWR VGND sg13cmos5l_decap_8
XFILLER_19_67 VPWR VGND sg13cmos5l_decap_4
XFILLER_35_11 VPWR VGND sg13cmos5l_decap_4
XFILLER_35_55 VPWR VGND sg13cmos5l_decap_8
XFILLER_42_146 VPWR VGND sg13cmos5l_fill_2
XFILLER_51_21 VPWR VGND sg13cmos5l_decap_8
XFILLER_4_0 VPWR VGND sg13cmos5l_decap_8
XFILLER_104_170 VPWR VGND sg13cmos5l_decap_8
XANTENNA__0934__X Tile_X0Y1_W2BEG[5] VPWR VGND sg13cmos5l_antennanp
XFILLER_92_94 VPWR VGND sg13cmos5l_decap_4
XFILLER_92_83 VPWR VGND sg13cmos5l_decap_4
XFILLER_41_190 VPWR VGND sg13cmos5l_decap_8
X_0902_ Tile_X0Y1_S2BEGb[2] _1221_/X VPWR VGND sg13cmos5l_buf_1
X_0833_ Tile_X0Y1_FrameData_O[9] Tile_X0Y1_FrameData[9] VPWR VGND sg13cmos5l_buf_1
XFILLER_37_0 VPWR VGND sg13cmos5l_fill_2
X_0764_ Tile_X0Y0_N4BEG[13] _0764_/A VPWR VGND sg13cmos5l_buf_1
X_0695_ _0695_/L_HI VPWR VGND sg13cmos5l_tiehi
XFILLER_56_216 VPWR VGND sg13cmos5l_fill_2
X_1178_ _1178_/X _0647_/Q _0651_/Q _1203_/X _1195_/X _0460_/Q _0459_/Q VPWR VGND sg13cmos5l_mux4_1
XANTENNA_20 Tile_X0Y0_S2MID[4] VPWR VGND sg13cmos5l_antennanp
XANTENNA_31 Tile_X0Y1_N2MID[0] VPWR VGND sg13cmos5l_antennanp
XANTENNA__0844__X Tile_X0Y1_FrameData_O[20] VPWR VGND sg13cmos5l_antennanp
X_0129_ _0129_/Q Tile_X0Y0_FrameData[27] VGND VPWR Tile_X0Y1_FrameStrobe[1] latch
XANTENNA_42 Tile_X0Y1_N2MID[3] VPWR VGND sg13cmos5l_antennanp
XANTENNA_53 _1008_/X VPWR VGND sg13cmos5l_antennanp
XFILLER_115_7 VPWR VGND sg13cmos5l_fill_1
XFILLER_133_210 VPWR VGND sg13cmos5l_decap_8
XFILLER_137_35 VPWR VGND sg13cmos5l_decap_4
XANTENNA__0754__X Tile_X0Y0_N4BEG[3] VPWR VGND sg13cmos5l_antennanp
XFILLER_101_195 VPWR VGND sg13cmos5l_decap_8
XFILLER_46_76 VPWR VGND sg13cmos5l_decap_8
XFILLER_46_98 VPWR VGND sg13cmos5l_decap_8
XFILLER_141_0 VPWR VGND sg13cmos5l_decap_4
XFILLER_30_127 VPWR VGND sg13cmos5l_decap_8
XFILLER_7_48 VPWR VGND sg13cmos5l_fill_1
XANTENNA__0929__X Tile_X0Y1_W2BEG[0] VPWR VGND sg13cmos5l_antennanp
XFILLER_124_210 VPWR VGND sg13cmos5l_decap_8
X_0480_ _0480_/Q Tile_X0Y1_FrameData[26] VGND VPWR Tile_X0Y1_FrameStrobe[4] latch
XFILLER_38_216 VPWR VGND sg13cmos5l_fill_2
X_1032_ _1032_/X Tile_X0Y0_EE4END[5] _0637_/Q _1093_/X _1098_/X _0264_/Q _0263_/Q
+ VPWR VGND sg13cmos5l_mux4_1
X_1101_ _1101_/X _1112_/X Tile_X0Y0_E6END[1] Tile_X0Y0_S1END[1] _1101_/A3 _0098_/Q
+ _0097_/Q VPWR VGND sg13cmos5l_mux4_1
XFILLER_99_2 VPWR VGND sg13cmos5l_fill_1
XANTENNA__0613__Q NPU_WEIGHT_IN3 VPWR VGND sg13cmos5l_antennanp
XFILLER_115_210 VPWR VGND sg13cmos5l_decap_8
X_0816_ Tile_X0Y0_FrameStrobe_O[13] Tile_X0Y1_FrameStrobe[13] VPWR VGND sg13cmos5l_buf_1
X_0747_ Tile_X0Y0_W6BEG[8] _1071_/X VPWR VGND sg13cmos5l_buf_1
XANTENNA__0839__X Tile_X0Y1_FrameData_O[15] VPWR VGND sg13cmos5l_antennanp
XFILLER_107_38 VPWR VGND sg13cmos5l_fill_1
XFILLER_123_26 VPWR VGND sg13cmos5l_decap_8
XFILLER_29_205 VPWR VGND sg13cmos5l_decap_8
XFILLER_29_216 VPWR VGND sg13cmos5l_fill_2
X_0678_ _0678_/L_HI VPWR VGND sg13cmos5l_tiehi
XFILLER_88_116 VPWR VGND sg13cmos5l_decap_8
XFILLER_16_35 VPWR VGND sg13cmos5l_fill_1
XFILLER_12_116 VPWR VGND sg13cmos5l_fill_1
XFILLER_113_4 VPWR VGND sg13cmos5l_fill_2
XFILLER_121_202 VPWR VGND sg13cmos5l_decap_8
XANTENNA__0749__X Tile_X0Y0_W6BEG[10] VPWR VGND sg13cmos5l_antennanp
XFILLER_94_108 VPWR VGND sg13cmos5l_fill_1
XFILLER_73_63 VPWR VGND sg13cmos5l_decap_8
XFILLER_11_160 VPWR VGND sg13cmos5l_decap_8
XFILLER_7_164 VPWR VGND sg13cmos5l_decap_8
X_0601_ _0601_/Q Tile_X0Y1_FrameData[1] VGND VPWR Tile_X0Y1_FrameStrobe[7] latch
X_0532_ _0532_/Q Tile_X0Y1_FrameData[6] VGND VPWR Tile_X0Y1_FrameStrobe[5] latch
X_0463_ _0463_/Q Tile_X0Y1_FrameData[11] VGND VPWR Tile_X0Y1_FrameStrobe[3] latch
X_0394_ _0394_/Q Tile_X0Y1_FrameData[16] VGND VPWR Tile_X0Y1_FrameStrobe[1] latch
XFILLER_98_82 VPWR VGND sg13cmos5l_decap_8
X_1015_ _1015_/X Tile_X0Y0_E1END[2] Tile_X0Y0_EE4END[2] Tile_X0Y0_E6END[10] _1090_/X
+ _0316_/Q _0315_/Q VPWR VGND sg13cmos5l_mux4_1
XFILLER_93_196 VPWR VGND sg13cmos5l_decap_4
XFILLER_134_58 VPWR VGND sg13cmos5l_decap_8
XFILLER_69_160 VPWR VGND sg13cmos5l_decap_8
XFILLER_84_141 VPWR VGND sg13cmos5l_decap_8
XFILLER_27_67 VPWR VGND sg13cmos5l_decap_8
XFILLER_40_200 VPWR VGND sg13cmos5l_decap_8
XFILLER_43_11 VPWR VGND sg13cmos5l_decap_8
XFILLER_138_187 VPWR VGND sg13cmos5l_decap_8
XFILLER_43_66 VPWR VGND sg13cmos5l_decap_8
XFILLER_4_123 VPWR VGND sg13cmos5l_decap_8
XFILLER_104_0 VPWR VGND sg13cmos5l_fill_1
XFILLER_4_189 VPWR VGND sg13cmos5l_decap_8
XFILLER_4_49 VPWR VGND sg13cmos5l_decap_8
XFILLER_68_30 VPWR VGND sg13cmos5l_fill_1
XFILLER_75_141 VPWR VGND sg13cmos5l_decap_8
XFILLER_75_152 VPWR VGND sg13cmos5l_fill_2
XFILLER_90_155 VPWR VGND sg13cmos5l_decap_8
XFILLER_90_100 VPWR VGND sg13cmos5l_decap_8
XANTENNA__0942__X Tile_X0Y1_W2BEGb[5] VPWR VGND sg13cmos5l_antennanp
XFILLER_90_199 VPWR VGND sg13cmos5l_fill_1
XFILLER_129_187 VPWR VGND sg13cmos5l_decap_8
XFILLER_129_198 VPWR VGND sg13cmos5l_fill_1
X_0515_ _0515_/Q Tile_X0Y1_FrameData[23] VGND VPWR Tile_X0Y1_FrameStrobe[5] latch
X_0446_ _0446_/Q Tile_X0Y1_FrameData[28] VGND VPWR Tile_X0Y1_FrameStrobe[3] latch
X_0377_ _0377_/Q Tile_X0Y1_FrameData[1] VGND VPWR Tile_X0Y1_FrameStrobe[0] latch
XANTENNA__0852__X Tile_X0Y1_FrameData_O[28] VPWR VGND sg13cmos5l_antennanp
XFILLER_129_47 VPWR VGND sg13cmos5l_decap_8
XFILLER_135_102 VPWR VGND sg13cmos5l_decap_8
XFILLER_135_157 VPWR VGND sg13cmos5l_decap_8
XFILLER_38_11 VPWR VGND sg13cmos5l_decap_8
XFILLER_38_55 VPWR VGND sg13cmos5l_decap_8
XFILLER_38_77 VPWR VGND sg13cmos5l_decap_4
XFILLER_54_21 VPWR VGND sg13cmos5l_decap_8
XFILLER_57_130 VPWR VGND sg13cmos5l_decap_8
XFILLER_72_133 VPWR VGND sg13cmos5l_decap_8
XANTENNA__0762__X Tile_X0Y0_N4BEG[11] VPWR VGND sg13cmos5l_antennanp
XFILLER_110_71 VPWR VGND sg13cmos5l_decap_8
XFILLER_70_42 VPWR VGND sg13cmos5l_decap_8
XFILLER_126_124 VPWR VGND sg13cmos5l_decap_8
XANTENNA__0937__X Tile_X0Y1_W2BEGb[0] VPWR VGND sg13cmos5l_antennanp
X_0300_ _0300_/Q Tile_X0Y0_FrameData[16] VGND VPWR Tile_X0Y1_FrameStrobe[6] latch
X_0231_ _0231_/Q Tile_X0Y0_FrameData[21] VGND VPWR Tile_X0Y1_FrameStrobe[4] latch
XFILLER_95_83 VPWR VGND sg13cmos5l_decap_8
XFILLER_95_50 VPWR VGND sg13cmos5l_fill_1
XFILLER_48_174 VPWR VGND sg13cmos5l_fill_2
X_0162_ _0162_/Q Tile_X0Y0_FrameData[26] VGND VPWR Tile_X0Y1_FrameStrobe[2] latch
X_0093_ NPU_XBAR_SEL3 Tile_X0Y1_UserCLK _0093_/D _0652_/L_HI VPWR VGND sg13cmos5l_dfrbpq_1
XFILLER_67_0 VPWR VGND sg13cmos5l_decap_8
X_0995_ _0995_/X Tile_X0Y1_E1END[1] Tile_X0Y1_EE4END[5] Tile_X0Y1_EE4END[13] _1216_/X
+ _0408_/Q _0407_/Q VPWR VGND sg13cmos5l_mux4_1
XANTENNA__0621__Q NPU_ACT_WDATA3 VPWR VGND sg13cmos5l_antennanp
XFILLER_86_203 VPWR VGND sg13cmos5l_decap_8
XANTENNA__0847__X Tile_X0Y1_FrameData_O[23] VPWR VGND sg13cmos5l_antennanp
X_0429_ _0429_/Q Tile_X0Y1_FrameData[13] VGND VPWR Tile_X0Y1_FrameStrobe[2] latch
XFILLER_40_34 VPWR VGND sg13cmos5l_decap_8
XANTENNA__0757__X Tile_X0Y0_N4BEG[6] VPWR VGND sg13cmos5l_antennanp
XFILLER_1_28 VPWR VGND sg13cmos5l_decap_8
XFILLER_105_93 VPWR VGND sg13cmos5l_decap_8
XFILLER_45_100 VPWR VGND sg13cmos5l_fill_2
XFILLER_45_166 VPWR VGND sg13cmos5l_decap_8
XFILLER_65_75 VPWR VGND sg13cmos5l_decap_8
XFILLER_92_217 VPWR VGND sg13cmos5l_fill_1
XFILLER_60_147 VPWR VGND sg13cmos5l_decap_4
X_0780_ Tile_X0Y0_WW4BEG[13] _1060_/X VPWR VGND sg13cmos5l_buf_1
XFILLER_83_206 VPWR VGND sg13cmos5l_fill_1
XFILLER_83_217 VPWR VGND sg13cmos5l_fill_1
X_1194_ _1194_/X Tile_X0Y1_N1END[3] Tile_X0Y1_E6END[3] _1230_/X _1194_/A3 _0348_/Q
+ _0603_/Q VPWR VGND sg13cmos5l_mux4_1
X_0214_ _0214_/Q Tile_X0Y0_FrameData[6] VGND VPWR Tile_X0Y1_FrameStrobe[3] latch
XANTENNA__0616__Q NPU_WEIGHT_IN6 VPWR VGND sg13cmos5l_antennanp
XFILLER_101_18 VPWR VGND sg13cmos5l_decap_8
XFILLER_51_114 VPWR VGND sg13cmos5l_decap_4
X_0145_ _0145_/Q Tile_X0Y0_FrameData[11] VGND VPWR Tile_X0Y1_FrameStrobe[1] latch
X_0076_ _0762_/A _1115_/X _1116_/X _0567_/Q VPWR VGND sg13cmos5l_mux2_1
X_0978_ _0978_/X Tile_X0Y0_E2MID[5] Tile_X0Y0_E2END[5] _1097_/X _0978_/A3 _0160_/Q
+ _0159_/Q VPWR VGND sg13cmos5l_mux4_1
XFILLER_10_59 VPWR VGND sg13cmos5l_decap_8
XFILLER_113_193 VPWR VGND sg13cmos5l_decap_8
XFILLER_19_46 VPWR VGND sg13cmos5l_decap_8
XFILLER_19_79 VPWR VGND sg13cmos5l_decap_8
XFILLER_35_34 VPWR VGND sg13cmos5l_decap_8
XFILLER_51_11 VPWR VGND sg13cmos5l_decap_4
XFILLER_2_210 VPWR VGND sg13cmos5l_decap_8
XFILLER_116_70 VPWR VGND sg13cmos5l_decap_8
XFILLER_116_81 VPWR VGND sg13cmos5l_fill_1
XFILLER_65_217 VPWR VGND sg13cmos5l_fill_1
XFILLER_18_166 VPWR VGND sg13cmos5l_decap_8
XFILLER_92_62 VPWR VGND sg13cmos5l_decap_8
XANTENNA__0950__X Tile_X0Y1_W6BEG[5] VPWR VGND sg13cmos5l_antennanp
X_0901_ Tile_X0Y1_S2BEGb[1] _1220_/X VPWR VGND sg13cmos5l_buf_1
X_0832_ Tile_X0Y1_FrameData_O[8] Tile_X0Y1_FrameData[8] VPWR VGND sg13cmos5l_buf_1
X_0763_ Tile_X0Y0_N4BEG[12] _0763_/A VPWR VGND sg13cmos5l_buf_1
XFILLER_110_130 VPWR VGND sg13cmos5l_fill_1
X_0694_ _0694_/L_HI VPWR VGND sg13cmos5l_tiehi
XFILLER_112_39 VPWR VGND sg13cmos5l_decap_8
XFILLER_2_71 VPWR VGND sg13cmos5l_decap_8
XFILLER_2_93 VPWR VGND sg13cmos5l_decap_4
X_1177_ _1177_/X _0646_/Q _0650_/Q _1204_/X _1196_/X _0462_/Q _0461_/Q VPWR VGND sg13cmos5l_mux4_1
X_0128_ _0128_/Q Tile_X0Y0_FrameData[28] VGND VPWR Tile_X0Y1_FrameStrobe[1] latch
XANTENNA_10 Tile_X0Y0_S2MID[1] VPWR VGND sg13cmos5l_antennanp
XANTENNA_21 Tile_X0Y0_S2MID[4] VPWR VGND sg13cmos5l_antennanp
XANTENNA_32 Tile_X0Y1_N2MID[0] VPWR VGND sg13cmos5l_antennanp
XANTENNA_43 Tile_X0Y1_N2MID[5] VPWR VGND sg13cmos5l_antennanp
XANTENNA_54 Tile_X0Y0_S4END[6] VPWR VGND sg13cmos5l_antennanp
XANTENNA__0860__X Tile_X0Y0_FrameData_O[4] VPWR VGND sg13cmos5l_antennanp
XFILLER_24_147 VPWR VGND sg13cmos5l_fill_2
XFILLER_137_14 VPWR VGND sg13cmos5l_decap_8
XFILLER_97_29 VPWR VGND sg13cmos5l_decap_8
XFILLER_46_33 VPWR VGND sg13cmos5l_fill_1
XFILLER_47_217 VPWR VGND sg13cmos5l_fill_1
XFILLER_102_94 VPWR VGND sg13cmos5l_decap_8
XFILLER_15_147 VPWR VGND sg13cmos5l_decap_8
XFILLER_30_106 VPWR VGND sg13cmos5l_decap_8
XFILLER_46_55 VPWR VGND sg13cmos5l_decap_8
XANTENNA__0770__X Tile_X0Y0_WW4BEG[3] VPWR VGND sg13cmos5l_antennanp
XFILLER_134_0 VPWR VGND sg13cmos5l_decap_4
XFILLER_62_98 VPWR VGND sg13cmos5l_decap_8
XFILLER_127_91 VPWR VGND sg13cmos5l_fill_2
XFILLER_23_7 VPWR VGND sg13cmos5l_decap_4
XFILLER_97_128 VPWR VGND sg13cmos5l_fill_2
XFILLER_97_117 VPWR VGND sg13cmos5l_decap_4
XFILLER_87_84 VPWR VGND sg13cmos5l_decap_8
XANTENNA__0945__X Tile_X0Y1_W6BEG[0] VPWR VGND sg13cmos5l_antennanp
X_1031_ _1031_/X Tile_X0Y0_EE4END[4] _0636_/Q _1092_/X _1099_/X _0266_/Q _0265_/Q
+ VPWR VGND sg13cmos5l_mux4_1
X_1100_ _1100_/X _1111_/X Tile_X0Y0_E6END[0] Tile_X0Y0_S1END[0] _1100_/A3 _0100_/Q
+ _0099_/Q VPWR VGND sg13cmos5l_mux4_1
XFILLER_14_191 VPWR VGND sg13cmos5l_decap_8
X_0815_ Tile_X0Y0_FrameStrobe_O[12] Tile_X0Y1_FrameStrobe[12] VPWR VGND sg13cmos5l_buf_1
X_0746_ Tile_X0Y0_W6BEG[7] _1070_/X VPWR VGND sg13cmos5l_buf_1
X_0677_ _0677_/L_HI VPWR VGND sg13cmos5l_tiehi
XFILLER_96_183 VPWR VGND sg13cmos5l_decap_8
XANTENNA__0855__X Tile_X0Y1_FrameData_O[31] VPWR VGND sg13cmos5l_antennanp
X_1229_ _1229_/X Tile_X0Y0_E1END[2] Tile_X0Y0_E6END[10] _1077_/X _1102_/X _0306_/Q
+ _0305_/Q VPWR VGND sg13cmos5l_mux4_1
XFILLER_20_150 VPWR VGND sg13cmos5l_decap_8
XFILLER_20_172 VPWR VGND sg13cmos5l_decap_4
XFILLER_106_211 VPWR VGND sg13cmos5l_decap_8
XANTENNA__0765__X Tile_X0Y0_N4BEG[14] VPWR VGND sg13cmos5l_antennanp
XFILLER_113_71 VPWR VGND sg13cmos5l_fill_1
XFILLER_113_82 VPWR VGND sg13cmos5l_decap_4
XFILLER_57_54 VPWR VGND sg13cmos5l_fill_2
XFILLER_57_87 VPWR VGND sg13cmos5l_fill_1
XFILLER_7_143 VPWR VGND sg13cmos5l_decap_8
X_0600_ _0600_/Q Tile_X0Y1_FrameData[2] VGND VPWR Tile_X0Y1_FrameStrobe[7] latch
X_0531_ _0531_/Q Tile_X0Y1_FrameData[7] VGND VPWR Tile_X0Y1_FrameStrobe[5] latch
XFILLER_21_4 VPWR VGND sg13cmos5l_fill_2
XFILLER_78_183 VPWR VGND sg13cmos5l_decap_8
X_0462_ _0462_/Q Tile_X0Y1_FrameData[12] VGND VPWR Tile_X0Y1_FrameStrobe[3] latch
X_0393_ _0393_/Q Tile_X0Y1_FrameData[17] VGND VPWR Tile_X0Y1_FrameStrobe[1] latch
X_1014_ _1014_/X _1086_/X _1082_/X _1076_/X _1093_/X _0319_/Q _0318_/Q VPWR VGND sg13cmos5l_mux4_1
XFILLER_93_153 VPWR VGND sg13cmos5l_fill_1
XANTENNA__0624__Q NPU_ACT_WDATA6 VPWR VGND sg13cmos5l_antennanp
XFILLER_97_0 VPWR VGND sg13cmos5l_decap_8
XFILLER_103_203 VPWR VGND sg13cmos5l_decap_4
XFILLER_134_26 VPWR VGND sg13cmos5l_decap_8
X_0729_ Tile_X0Y0_W2BEG[6] _1037_/X VPWR VGND sg13cmos5l_buf_1
XFILLER_27_35 VPWR VGND sg13cmos5l_decap_8
XFILLER_138_133 VPWR VGND sg13cmos5l_decap_8
XFILLER_138_166 VPWR VGND sg13cmos5l_decap_8
XFILLER_4_102 VPWR VGND sg13cmos5l_decap_8
XFILLER_108_60 VPWR VGND sg13cmos5l_decap_4
XFILLER_4_168 VPWR VGND sg13cmos5l_decap_8
XFILLER_4_28 VPWR VGND sg13cmos5l_decap_8
XFILLER_75_186 VPWR VGND sg13cmos5l_decap_8
XFILLER_84_96 VPWR VGND sg13cmos5l_fill_2
XFILLER_129_166 VPWR VGND sg13cmos5l_decap_8
X_0514_ _0514_/Q Tile_X0Y1_FrameData[24] VGND VPWR Tile_X0Y1_FrameStrobe[5] latch
XFILLER_98_212 VPWR VGND sg13cmos5l_decap_4
XANTENNA__0619__Q NPU_ACT_WDATA1 VPWR VGND sg13cmos5l_antennanp
XFILLER_100_217 VPWR VGND sg13cmos5l_fill_1
XFILLER_66_120 VPWR VGND sg13cmos5l_decap_8
XFILLER_81_101 VPWR VGND sg13cmos5l_fill_2
X_0445_ _0445_/Q Tile_X0Y1_FrameData[29] VGND VPWR Tile_X0Y1_FrameStrobe[3] latch
X_0376_ _0376_/Q Tile_X0Y1_FrameData[2] VGND VPWR Tile_X0Y1_FrameStrobe[0] latch
XFILLER_81_189 VPWR VGND sg13cmos5l_decap_8
XFILLER_135_136 VPWR VGND sg13cmos5l_decap_8
XFILLER_13_59 VPWR VGND sg13cmos5l_decap_4
XFILLER_1_105 VPWR VGND sg13cmos5l_fill_1
XFILLER_57_120 VPWR VGND sg13cmos5l_fill_2
XFILLER_38_89 VPWR VGND sg13cmos5l_decap_8
XFILLER_72_112 VPWR VGND sg13cmos5l_decap_8
XFILLER_72_189 VPWR VGND sg13cmos5l_decap_8
XFILLER_110_50 VPWR VGND sg13cmos5l_decap_8
XFILLER_70_21 VPWR VGND sg13cmos5l_decap_8
XFILLER_126_103 VPWR VGND sg13cmos5l_decap_8
XFILLER_134_191 VPWR VGND sg13cmos5l_decap_8
XFILLER_70_98 VPWR VGND sg13cmos5l_decap_8
XFILLER_48_131 VPWR VGND sg13cmos5l_decap_8
XFILLER_48_153 VPWR VGND sg13cmos5l_decap_8
XFILLER_63_101 VPWR VGND sg13cmos5l_fill_1
X_0230_ _0230_/Q Tile_X0Y0_FrameData[22] VGND VPWR Tile_X0Y1_FrameStrobe[4] latch
X_0161_ _0161_/Q Tile_X0Y0_FrameData[27] VGND VPWR Tile_X0Y1_FrameStrobe[2] latch
XFILLER_95_62 VPWR VGND sg13cmos5l_decap_8
XANTENNA__0953__X Tile_X0Y1_W6BEG[8] VPWR VGND sg13cmos5l_antennanp
X_0092_ NPU_XBAR_SEL2 Tile_X0Y1_UserCLK _0092_/D _0698_/L_HI VPWR VGND sg13cmos5l_dfrbpq_1
X_0994_ _0994_/X Tile_X0Y1_E1END[0] Tile_X0Y1_EE4END[4] Tile_X0Y1_EE4END[12] _1215_/X
+ _0410_/Q _0409_/Q VPWR VGND sg13cmos5l_mux4_1
XANTENNA__0863__X Tile_X0Y0_FrameData_O[7] VPWR VGND sg13cmos5l_antennanp
XFILLER_131_38 VPWR VGND sg13cmos5l_decap_4
XFILLER_39_131 VPWR VGND sg13cmos5l_decap_8
X_0428_ _0428_/Q Tile_X0Y1_FrameData[14] VGND VPWR Tile_X0Y1_FrameStrobe[2] latch
X_0359_ _0359_/Q Tile_X0Y1_FrameData[19] VGND VPWR Tile_X0Y1_FrameStrobe[0] latch
XFILLER_10_204 VPWR VGND sg13cmos5l_decap_8
XFILLER_138_7 VPWR VGND sg13cmos5l_decap_8
XFILLER_24_58 VPWR VGND sg13cmos5l_decap_8
XFILLER_24_69 VPWR VGND sg13cmos5l_fill_1
XFILLER_108_147 VPWR VGND sg13cmos5l_decap_8
XFILLER_116_191 VPWR VGND sg13cmos5l_decap_8
XFILLER_123_139 VPWR VGND sg13cmos5l_decap_8
XFILLER_105_61 VPWR VGND sg13cmos5l_decap_4
XFILLER_49_88 VPWR VGND sg13cmos5l_decap_4
XFILLER_65_21 VPWR VGND sg13cmos5l_decap_4
XANTENNA__0773__X Tile_X0Y0_WW4BEG[6] VPWR VGND sg13cmos5l_antennanp
XFILLER_121_82 VPWR VGND sg13cmos5l_decap_8
XFILLER_60_159 VPWR VGND sg13cmos5l_decap_8
XFILLER_65_54 VPWR VGND sg13cmos5l_decap_8
XFILLER_81_42 VPWR VGND sg13cmos5l_decap_8
XFILLER_14_80 VPWR VGND sg13cmos5l_decap_8
XANTENNA__0948__X Tile_X0Y1_W6BEG[3] VPWR VGND sg13cmos5l_antennanp
XFILLER_114_128 VPWR VGND sg13cmos5l_decap_4
XFILLER_122_194 VPWR VGND sg13cmos5l_decap_8
XFILLER_36_178 VPWR VGND sg13cmos5l_decap_8
X_1193_ _1193_/X Tile_X0Y1_N1END[2] Tile_X0Y1_E6END[2] _1229_/X _1193_/A3 _0350_/Q
+ _0349_/Q VPWR VGND sg13cmos5l_mux4_1
X_0213_ _0213_/Q Tile_X0Y0_FrameData[7] VGND VPWR Tile_X0Y1_FrameStrobe[3] latch
X_0144_ _0144_/Q Tile_X0Y0_FrameData[12] VGND VPWR Tile_X0Y1_FrameStrobe[1] latch
X_0075_ _0761_/A _1117_/X _1118_/X _0570_/Q VPWR VGND sg13cmos5l_mux2_1
XANTENNA__0632__Q NPU_ACT_ADDR6 VPWR VGND sg13cmos5l_antennanp
X_0977_ _0977_/X Tile_X0Y0_E2MID[4] Tile_X0Y0_E2END[4] _1096_/X _0977_/A3 _0162_/Q
+ _0161_/Q VPWR VGND sg13cmos5l_mux4_1
XANTENNA__0858__X Tile_X0Y0_FrameData_O[2] VPWR VGND sg13cmos5l_antennanp
XFILLER_113_172 VPWR VGND sg13cmos5l_decap_8
XFILLER_74_207 VPWR VGND sg13cmos5l_decap_8
XFILLER_27_178 VPWR VGND sg13cmos5l_decap_8
XFILLER_50_170 VPWR VGND sg13cmos5l_fill_2
XANTENNA__0768__X Tile_X0Y0_WW4BEG[1] VPWR VGND sg13cmos5l_antennanp
XFILLER_116_93 VPWR VGND sg13cmos5l_fill_1
XFILLER_132_70 VPWR VGND sg13cmos5l_decap_4
XFILLER_18_134 VPWR VGND sg13cmos5l_decap_4
XFILLER_76_53 VPWR VGND sg13cmos5l_decap_8
X_0900_ Tile_X0Y1_S2BEGb[0] _1219_/X VPWR VGND sg13cmos5l_buf_1
XFILLER_92_41 VPWR VGND sg13cmos5l_decap_8
XFILLER_51_4 VPWR VGND sg13cmos5l_fill_1
X_0831_ Tile_X0Y1_FrameData_O[7] Tile_X0Y1_FrameData[7] VPWR VGND sg13cmos5l_buf_1
X_0762_ Tile_X0Y0_N4BEG[11] _0762_/A VPWR VGND sg13cmos5l_buf_1
X_0693_ _0693_/L_HI VPWR VGND sg13cmos5l_tiehi
XFILLER_110_142 VPWR VGND sg13cmos5l_decap_8
XFILLER_110_164 VPWR VGND sg13cmos5l_fill_1
XFILLER_37_2 VPWR VGND sg13cmos5l_fill_1
XANTENNA__0627__Q NPU_ACT_ADDR1 VPWR VGND sg13cmos5l_antennanp
XFILLER_110_186 VPWR VGND sg13cmos5l_decap_8
XFILLER_24_115 VPWR VGND sg13cmos5l_decap_4
XFILLER_24_126 VPWR VGND sg13cmos5l_decap_8
X_1176_ _1176_/X _0645_/Q _0649_/Q _1205_/X _1197_/X _0464_/Q _0463_/Q VPWR VGND sg13cmos5l_mux4_1
X_0127_ _0127_/Q Tile_X0Y0_FrameData[29] VGND VPWR Tile_X0Y1_FrameStrobe[1] latch
XANTENNA_11 Tile_X0Y0_S2MID[1] VPWR VGND sg13cmos5l_antennanp
XANTENNA_22 Tile_X0Y0_S2MID[6] VPWR VGND sg13cmos5l_antennanp
XANTENNA_33 Tile_X0Y1_N2MID[0] VPWR VGND sg13cmos5l_antennanp
XANTENNA_44 Tile_X0Y1_N2MID[5] VPWR VGND sg13cmos5l_antennanp
XANTENNA_55 Tile_X0Y0_S4END[6] VPWR VGND sg13cmos5l_antennanp
XFILLER_62_33 VPWR VGND sg13cmos5l_decap_8
XFILLER_127_0 VPWR VGND sg13cmos5l_decap_8
XFILLER_87_63 VPWR VGND sg13cmos5l_decap_8
X_1030_ _1030_/X _1114_/X Tile_X0Y0_S1END[3] _0637_/Q _0640_/Q _0268_/Q _0267_/Q VPWR
+ VGND sg13cmos5l_mux4_1
XANTENNA__0961__X Tile_X0Y1_WW4BEG[4] VPWR VGND sg13cmos5l_antennanp
XFILLER_14_170 VPWR VGND sg13cmos5l_fill_2
X_0814_ Tile_X0Y0_FrameStrobe_O[11] Tile_X0Y1_FrameStrobe[11] VPWR VGND sg13cmos5l_buf_1
XFILLER_107_29 VPWR VGND sg13cmos5l_decap_8
XFILLER_42_0 VPWR VGND sg13cmos5l_decap_4
X_0745_ Tile_X0Y0_W6BEG[6] _1069_/X VPWR VGND sg13cmos5l_buf_1
X_0676_ _0676_/L_HI VPWR VGND sg13cmos5l_tiehi
XFILLER_123_17 VPWR VGND sg13cmos5l_decap_4
X_1228_ _1228_/X Tile_X0Y0_E1END[1] Tile_X0Y0_E6END[9] _1076_/X _1101_/X _0308_/Q
+ _0307_/Q VPWR VGND sg13cmos5l_mux4_1
XFILLER_96_162 VPWR VGND sg13cmos5l_decap_8
XANTENNA__0871__X Tile_X0Y0_FrameData_O[15] VPWR VGND sg13cmos5l_antennanp
XFILLER_12_107 VPWR VGND sg13cmos5l_decap_8
X_1159_ _1159_/X Tile_X0Y1_EE4END[9] _0648_/Q _1198_/X _1199_/X _0498_/Q _0497_/Q
+ VPWR VGND sg13cmos5l_mux4_1
XANTENNA__0092__Q NPU_XBAR_SEL2 VPWR VGND sg13cmos5l_antennanp
XFILLER_57_33 VPWR VGND sg13cmos5l_fill_2
XFILLER_87_140 VPWR VGND sg13cmos5l_decap_8
XFILLER_57_99 VPWR VGND sg13cmos5l_decap_8
XANTENNA__0781__X Tile_X0Y0_WW4BEG[14] VPWR VGND sg13cmos5l_antennanp
XFILLER_11_151 VPWR VGND sg13cmos5l_fill_2
XFILLER_7_122 VPWR VGND sg13cmos5l_decap_8
XFILLER_112_215 VPWR VGND sg13cmos5l_fill_2
XFILLER_11_195 VPWR VGND sg13cmos5l_fill_2
XFILLER_138_91 VPWR VGND sg13cmos5l_decap_8
XFILLER_7_199 VPWR VGND sg13cmos5l_fill_1
X_0530_ _0530_/Q Tile_X0Y1_FrameData[8] VGND VPWR Tile_X0Y1_FrameStrobe[5] latch
XANTENNA__0956__X Tile_X0Y1_W6BEG[11] VPWR VGND sg13cmos5l_antennanp
XFILLER_14_4 VPWR VGND sg13cmos5l_fill_1
XFILLER_78_162 VPWR VGND sg13cmos5l_decap_8
X_0461_ _0461_/Q Tile_X0Y1_FrameData[13] VGND VPWR Tile_X0Y1_FrameStrobe[3] latch
X_0392_ _0392_/Q Tile_X0Y1_FrameData[18] VGND VPWR Tile_X0Y1_FrameStrobe[1] latch
X_1013_ _1013_/X Tile_X0Y0_E1END[1] Tile_X0Y0_EE4END[1] Tile_X0Y0_E6END[9] _1089_/X
+ _0319_/Q _0318_/Q VPWR VGND sg13cmos5l_mux4_1
XFILLER_118_28 VPWR VGND sg13cmos5l_decap_8
XFILLER_8_82 VPWR VGND sg13cmos5l_decap_8
X_0728_ Tile_X0Y0_W2BEG[5] _1036_/X VPWR VGND sg13cmos5l_buf_1
X_0659_ _0659_/L_HI VPWR VGND sg13cmos5l_tiehi
XANTENNA__0866__X Tile_X0Y0_FrameData_O[10] VPWR VGND sg13cmos5l_antennanp
XFILLER_25_210 VPWR VGND sg13cmos5l_decap_8
XFILLER_84_176 VPWR VGND sg13cmos5l_decap_8
XFILLER_138_112 VPWR VGND sg13cmos5l_decap_8
XFILLER_43_79 VPWR VGND sg13cmos5l_decap_8
XANTENNA__0776__X Tile_X0Y0_WW4BEG[9] VPWR VGND sg13cmos5l_antennanp
XFILLER_108_94 VPWR VGND sg13cmos5l_decap_8
XFILLER_68_21 VPWR VGND sg13cmos5l_decap_8
XFILLER_68_76 VPWR VGND sg13cmos5l_fill_1
XFILLER_75_165 VPWR VGND sg13cmos5l_decap_8
XFILLER_129_145 VPWR VGND sg13cmos5l_decap_8
X_0513_ _0513_/Q Tile_X0Y1_FrameData[25] VGND VPWR Tile_X0Y1_FrameStrobe[5] latch
X_0444_ _0444_/Q Tile_X0Y1_FrameData[30] VGND VPWR Tile_X0Y1_FrameStrobe[3] latch
X_0375_ _0375_/Q Tile_X0Y1_FrameData[3] VGND VPWR Tile_X0Y1_FrameStrobe[0] latch
XANTENNA__0635__Q NPU_WEIGHT_SHIFT_EN VPWR VGND sg13cmos5l_antennanp
XFILLER_81_157 VPWR VGND sg13cmos5l_fill_1
XFILLER_1_117 VPWR VGND sg13cmos5l_decap_4
XFILLER_1_128 VPWR VGND sg13cmos5l_decap_8
XFILLER_13_213 VPWR VGND sg13cmos5l_decap_4
XFILLER_54_78 VPWR VGND sg13cmos5l_decap_8
XFILLER_57_198 VPWR VGND sg13cmos5l_decap_4
XFILLER_72_168 VPWR VGND sg13cmos5l_decap_8
XFILLER_70_77 VPWR VGND sg13cmos5l_decap_8
XFILLER_126_159 VPWR VGND sg13cmos5l_decap_8
XFILLER_134_170 VPWR VGND sg13cmos5l_decap_8
XFILLER_141_129 VPWR VGND sg13cmos5l_decap_8
XFILLER_0_150 VPWR VGND sg13cmos5l_decap_8
XFILLER_0_183 VPWR VGND sg13cmos5l_decap_8
XFILLER_135_81 VPWR VGND sg13cmos5l_decap_8
XFILLER_28_90 VPWR VGND sg13cmos5l_fill_2
XFILLER_48_110 VPWR VGND sg13cmos5l_decap_8
XFILLER_48_187 VPWR VGND sg13cmos5l_decap_8
X_0160_ _0160_/Q Tile_X0Y0_FrameData[28] VGND VPWR Tile_X0Y1_FrameStrobe[2] latch
X_0091_ NPU_XBAR_SEL1 Tile_X0Y1_UserCLK _0091_/D _0654_/L_HI VPWR VGND sg13cmos5l_dfrbpq_1
XFILLER_81_4 VPWR VGND sg13cmos5l_fill_2
X_0993_ _0993_/X Tile_X0Y1_EE4END[3] Tile_X0Y1_EE4END[11] Tile_X0Y1_E6END[11] _1214_/X
+ _0412_/Q _0411_/Q VPWR VGND sg13cmos5l_mux4_1
XFILLER_117_159 VPWR VGND sg13cmos5l_decap_8
XFILLER_125_181 VPWR VGND sg13cmos5l_decap_8
XFILLER_132_129 VPWR VGND sg13cmos5l_decap_8
X_0427_ _0427_/Q Tile_X0Y1_FrameData[15] VGND VPWR Tile_X0Y1_FrameStrobe[2] latch
XFILLER_39_198 VPWR VGND sg13cmos5l_decap_4
X_0358_ _0358_/Q Tile_X0Y1_FrameData[20] VGND VPWR Tile_X0Y1_FrameStrobe[0] latch
X_0289_ _0289_/Q Tile_X0Y0_FrameData[27] VGND VPWR Tile_X0Y1_FrameStrobe[6] latch
XFILLER_108_104 VPWR VGND sg13cmos5l_decap_8
XFILLER_24_37 VPWR VGND sg13cmos5l_decap_8
XFILLER_40_69 VPWR VGND sg13cmos5l_fill_1
XFILLER_105_40 VPWR VGND sg13cmos5l_decap_8
XFILLER_105_84 VPWR VGND sg13cmos5l_decap_4
XFILLER_131_173 VPWR VGND sg13cmos5l_decap_8
XFILLER_131_184 VPWR VGND sg13cmos5l_decap_8
XFILLER_131_195 VPWR VGND sg13cmos5l_fill_2
XFILLER_45_102 VPWR VGND sg13cmos5l_fill_1
XFILLER_45_113 VPWR VGND sg13cmos5l_decap_8
XFILLER_45_124 VPWR VGND sg13cmos5l_decap_8
XFILLER_92_208 VPWR VGND sg13cmos5l_decap_8
XFILLER_45_146 VPWR VGND sg13cmos5l_fill_1
XFILLER_81_21 VPWR VGND sg13cmos5l_decap_8
XFILLER_81_65 VPWR VGND sg13cmos5l_fill_1
XFILLER_107_192 VPWR VGND sg13cmos5l_decap_8
XFILLER_122_173 VPWR VGND sg13cmos5l_decap_8
XANTENNA__0964__X Tile_X0Y1_WW4BEG[7] VPWR VGND sg13cmos5l_antennanp
XFILLER_36_157 VPWR VGND sg13cmos5l_decap_8
XFILLER_51_127 VPWR VGND sg13cmos5l_decap_8
X_1192_ _1192_/X Tile_X0Y1_N1END[1] Tile_X0Y1_E6END[1] _1228_/X _1192_/A3 _0352_/Q
+ _0351_/Q VPWR VGND sg13cmos5l_mux4_1
X_0212_ _0212_/Q Tile_X0Y0_FrameData[8] VGND VPWR Tile_X0Y1_FrameStrobe[3] latch
X_0143_ _0143_/Q Tile_X0Y0_FrameData[13] VGND VPWR Tile_X0Y1_FrameStrobe[1] latch
X_0074_ _0760_/A _1119_/X _1120_/X _0573_/Q VPWR VGND sg13cmos5l_mux2_1
XFILLER_44_190 VPWR VGND sg13cmos5l_decap_8
XFILLER_72_0 VPWR VGND sg13cmos5l_decap_8
X_0976_ _0976_/X Tile_X0Y0_E2MID[3] Tile_X0Y0_E2END[3] _1095_/X _0976_/A3 _0164_/Q
+ _0163_/Q VPWR VGND sg13cmos5l_mux4_1
XFILLER_126_28 VPWR VGND sg13cmos5l_decap_8
XANTENNA__0874__X Tile_X0Y0_FrameData_O[18] VPWR VGND sg13cmos5l_antennanp
XFILLER_113_151 VPWR VGND sg13cmos5l_decap_8
XFILLER_27_102 VPWR VGND sg13cmos5l_decap_8
XFILLER_27_135 VPWR VGND sg13cmos5l_fill_1
XFILLER_59_216 VPWR VGND sg13cmos5l_fill_2
XFILLER_27_157 VPWR VGND sg13cmos5l_decap_8
XFILLER_35_69 VPWR VGND sg13cmos5l_decap_8
XFILLER_51_35 VPWR VGND sg13cmos5l_decap_8
XFILLER_51_79 VPWR VGND sg13cmos5l_decap_8
XFILLER_104_140 VPWR VGND sg13cmos5l_fill_2
XFILLER_104_184 VPWR VGND sg13cmos5l_decap_8
XANTENNA__0784__X Tile_X0Y0_N2BEGb[1] VPWR VGND sg13cmos5l_antennanp
XFILLER_33_105 VPWR VGND sg13cmos5l_decap_8
XFILLER_33_127 VPWR VGND sg13cmos5l_decap_8
XFILLER_92_20 VPWR VGND sg13cmos5l_decap_8
X_0830_ Tile_X0Y1_FrameData_O[6] Tile_X0Y1_FrameData[6] VPWR VGND sg13cmos5l_buf_1
XANTENNA__0959__X Tile_X0Y1_WW4BEG[2] VPWR VGND sg13cmos5l_antennanp
XFILLER_127_210 VPWR VGND sg13cmos5l_decap_8
X_0761_ Tile_X0Y0_N4BEG[10] _0761_/A VPWR VGND sg13cmos5l_buf_1
X_0692_ _0692_/L_HI VPWR VGND sg13cmos5l_tiehi
XFILLER_110_110 VPWR VGND sg13cmos5l_fill_2
X_1175_ _1175_/X _0644_/Q _0648_/Q _1206_/X _1198_/X _0466_/Q _0465_/Q VPWR VGND sg13cmos5l_mux4_1
X_0126_ _0126_/Q Tile_X0Y0_FrameData[30] VGND VPWR Tile_X0Y1_FrameStrobe[1] latch
XANTENNA_12 Tile_X0Y0_S2MID[2] VPWR VGND sg13cmos5l_antennanp
XANTENNA_23 Tile_X0Y0_S2MID[6] VPWR VGND sg13cmos5l_antennanp
XANTENNA_34 Tile_X0Y1_N2MID[0] VPWR VGND sg13cmos5l_antennanp
XANTENNA_45 Tile_X0Y1_N2MID[6] VPWR VGND sg13cmos5l_antennanp
XANTENNA_56 Tile_X0Y0_S4END[6] VPWR VGND sg13cmos5l_antennanp
XFILLER_21_27 VPWR VGND sg13cmos5l_decap_4
XFILLER_32_182 VPWR VGND sg13cmos5l_decap_8
X_0959_ Tile_X0Y1_WW4BEG[2] _1165_/X VPWR VGND sg13cmos5l_buf_1
XANTENNA__0869__X Tile_X0Y0_FrameData_O[13] VPWR VGND sg13cmos5l_antennanp
XFILLER_133_202 VPWR VGND sg13cmos5l_decap_4
XFILLER_137_49 VPWR VGND sg13cmos5l_decap_8
XFILLER_99_193 VPWR VGND sg13cmos5l_decap_8
XFILLER_102_41 VPWR VGND sg13cmos5l_decap_8
XFILLER_23_171 VPWR VGND sg13cmos5l_decap_8
XANTENNA__0779__X Tile_X0Y0_WW4BEG[12] VPWR VGND sg13cmos5l_antennanp
XFILLER_109_210 VPWR VGND sg13cmos5l_decap_8
XFILLER_2_0 VPWR VGND sg13cmos5l_decap_8
XFILLER_87_42 VPWR VGND sg13cmos5l_decap_8
XFILLER_21_119 VPWR VGND sg13cmos5l_decap_4
X_0813_ Tile_X0Y0_FrameStrobe_O[10] Tile_X0Y1_FrameStrobe[10] VPWR VGND sg13cmos5l_buf_1
XFILLER_130_205 VPWR VGND sg13cmos5l_decap_8
XFILLER_130_216 VPWR VGND sg13cmos5l_fill_2
XFILLER_35_0 VPWR VGND sg13cmos5l_decap_8
X_0744_ Tile_X0Y0_W6BEG[5] _1068_/X VPWR VGND sg13cmos5l_buf_1
X_0675_ _0675_/L_HI VPWR VGND sg13cmos5l_tiehi
X_1227_ _1227_/X Tile_X0Y0_E1END[0] Tile_X0Y0_E6END[8] _1075_/X _1100_/X _0310_/Q
+ _0309_/Q VPWR VGND sg13cmos5l_mux4_1
X_1158_ _1158_/X Tile_X0Y1_EE4END[5] _0647_/Q _1198_/X _1199_/X _0500_/Q _0499_/Q
+ VPWR VGND sg13cmos5l_mux4_1
XFILLER_96_141 VPWR VGND sg13cmos5l_decap_8
XFILLER_16_27 VPWR VGND sg13cmos5l_fill_1
X_1089_ _1089_/X _1112_/X Tile_X0Y1_N4END[5] Tile_X0Y0_S1END[1] Tile_X0Y0_S4END[1]
+ _0146_/Q _0145_/Q VPWR VGND sg13cmos5l_mux4_1
X_0109_ _0109_/Q Tile_X0Y0_FrameData[15] VGND VPWR Tile_X0Y1_FrameStrobe[0] latch
XFILLER_20_185 VPWR VGND sg13cmos5l_decap_8
XFILLER_20_196 VPWR VGND sg13cmos5l_fill_1
XFILLER_121_216 VPWR VGND sg13cmos5l_fill_2
XFILLER_113_62 VPWR VGND sg13cmos5l_decap_8
XFILLER_73_33 VPWR VGND sg13cmos5l_decap_8
XFILLER_73_77 VPWR VGND sg13cmos5l_decap_8
XFILLER_11_174 VPWR VGND sg13cmos5l_decap_8
XFILLER_7_101 VPWR VGND sg13cmos5l_decap_8
XFILLER_138_70 VPWR VGND sg13cmos5l_decap_8
XFILLER_7_178 VPWR VGND sg13cmos5l_decap_8
X_0460_ _0460_/Q Tile_X0Y1_FrameData[14] VGND VPWR Tile_X0Y1_FrameStrobe[3] latch
XFILLER_98_96 VPWR VGND sg13cmos5l_fill_2
XFILLER_98_63 VPWR VGND sg13cmos5l_fill_2
XFILLER_98_52 VPWR VGND sg13cmos5l_decap_8
X_1012_ _1012_/X _1087_/X _1083_/X _1075_/X _1092_/X _0322_/Q _0321_/Q VPWR VGND sg13cmos5l_mux4_1
X_0391_ _0391_/Q Tile_X0Y1_FrameData[19] VGND VPWR Tile_X0Y1_FrameStrobe[1] latch
XANTENNA__0972__X Tile_X0Y1_WW4BEG[15] VPWR VGND sg13cmos5l_antennanp
X_0727_ Tile_X0Y0_W2BEG[4] _1035_/X VPWR VGND sg13cmos5l_buf_1
XFILLER_134_17 VPWR VGND sg13cmos5l_fill_2
X_0658_ _0658_/L_HI VPWR VGND sg13cmos5l_tiehi
X_0589_ _0589_/Q Tile_X0Y1_FrameData[13] VGND VPWR Tile_X0Y1_FrameStrobe[7] latch
XANTENNA__0882__X Tile_X0Y0_FrameData_O[26] VPWR VGND sg13cmos5l_antennanp
XFILLER_27_15 VPWR VGND sg13cmos5l_fill_2
XFILLER_84_155 VPWR VGND sg13cmos5l_decap_8
XFILLER_40_214 VPWR VGND sg13cmos5l_decap_4
XFILLER_43_25 VPWR VGND sg13cmos5l_decap_8
XFILLER_108_73 VPWR VGND sg13cmos5l_decap_8
XFILLER_4_137 VPWR VGND sg13cmos5l_decap_8
XFILLER_4_148 VPWR VGND sg13cmos5l_fill_2
XFILLER_124_72 VPWR VGND sg13cmos5l_fill_1
XFILLER_84_43 VPWR VGND sg13cmos5l_decap_4
XFILLER_90_114 VPWR VGND sg13cmos5l_decap_8
XANTENNA__0792__X Tile_X0Y0_N2BEG[1] VPWR VGND sg13cmos5l_antennanp
XFILLER_140_93 VPWR VGND sg13cmos5l_fill_2
XFILLER_90_169 VPWR VGND sg13cmos5l_decap_8
XFILLER_129_124 VPWR VGND sg13cmos5l_decap_8
XANTENNA__0967__X Tile_X0Y1_WW4BEG[10] VPWR VGND sg13cmos5l_antennanp
XFILLER_3_192 VPWR VGND sg13cmos5l_decap_8
X_0512_ _0512_/Q Tile_X0Y1_FrameData[26] VGND VPWR Tile_X0Y1_FrameStrobe[5] latch
X_0443_ _0443_/Q Tile_X0Y1_FrameData[31] VGND VPWR Tile_X0Y1_FrameStrobe[3] latch
X_0374_ _0374_/Q Tile_X0Y1_FrameData[4] VGND VPWR Tile_X0Y1_FrameStrobe[0] latch
XFILLER_81_103 VPWR VGND sg13cmos5l_fill_1
XFILLER_22_214 VPWR VGND sg13cmos5l_decap_4
XFILLER_135_116 VPWR VGND sg13cmos5l_decap_8
XANTENNA__0877__X Tile_X0Y0_FrameData_O[21] VPWR VGND sg13cmos5l_antennanp
XFILLER_38_25 VPWR VGND sg13cmos5l_fill_2
XFILLER_57_122 VPWR VGND sg13cmos5l_fill_1
XFILLER_57_144 VPWR VGND sg13cmos5l_decap_8
XFILLER_54_35 VPWR VGND sg13cmos5l_decap_8
XFILLER_72_147 VPWR VGND sg13cmos5l_decap_8
XFILLER_80_191 VPWR VGND sg13cmos5l_decap_8
XFILLER_9_207 VPWR VGND sg13cmos5l_decap_8
XFILLER_110_85 VPWR VGND sg13cmos5l_decap_8
XFILLER_126_138 VPWR VGND sg13cmos5l_decap_8
XFILLER_70_56 VPWR VGND sg13cmos5l_decap_8
XANTENNA__0787__X Tile_X0Y0_N2BEGb[4] VPWR VGND sg13cmos5l_antennanp
XFILLER_0_162 VPWR VGND sg13cmos5l_decap_8
XFILLER_102_0 VPWR VGND sg13cmos5l_decap_4
XFILLER_141_108 VPWR VGND sg13cmos5l_decap_8
XFILLER_79_76 VPWR VGND sg13cmos5l_decap_8
XFILLER_95_217 VPWR VGND sg13cmos5l_fill_1
XFILLER_95_206 VPWR VGND sg13cmos5l_fill_1
X_0090_ NPU_XBAR_SEL0 Tile_X0Y1_UserCLK _0090_/D _0655_/L_HI VPWR VGND sg13cmos5l_dfrbpq_1
X_0992_ _0992_/X Tile_X0Y1_EE4END[2] Tile_X0Y1_EE4END[10] Tile_X0Y1_E6END[10] _1213_/X
+ _0414_/Q _0413_/Q VPWR VGND sg13cmos5l_mux4_1
XFILLER_117_127 VPWR VGND sg13cmos5l_decap_8
XFILLER_117_138 VPWR VGND sg13cmos5l_decap_8
XFILLER_132_108 VPWR VGND sg13cmos5l_decap_8
XFILLER_5_73 VPWR VGND sg13cmos5l_decap_8
XFILLER_74_4 VPWR VGND sg13cmos5l_fill_2
XFILLER_86_217 VPWR VGND sg13cmos5l_fill_1
X_0426_ _0426_/Q Tile_X0Y1_FrameData[16] VGND VPWR Tile_X0Y1_FrameStrobe[2] latch
X_0357_ _0357_/Q Tile_X0Y1_FrameData[21] VGND VPWR Tile_X0Y1_FrameStrobe[0] latch
XFILLER_131_18 VPWR VGND sg13cmos5l_decap_8
XFILLER_131_29 VPWR VGND sg13cmos5l_fill_2
X_0288_ _0288_/Q Tile_X0Y0_FrameData[28] VGND VPWR Tile_X0Y1_FrameStrobe[6] latch
XFILLER_40_48 VPWR VGND sg13cmos5l_decap_8
XFILLER_116_160 VPWR VGND sg13cmos5l_fill_2
XFILLER_131_152 VPWR VGND sg13cmos5l_decap_8
XFILLER_49_46 VPWR VGND sg13cmos5l_decap_8
XFILLER_77_206 VPWR VGND sg13cmos5l_fill_1
XFILLER_77_217 VPWR VGND sg13cmos5l_fill_1
XFILLER_65_89 VPWR VGND sg13cmos5l_decap_8
XFILLER_30_70 VPWR VGND sg13cmos5l_decap_4
XFILLER_30_92 VPWR VGND sg13cmos5l_decap_8
XFILLER_5_210 VPWR VGND sg13cmos5l_decap_8
XFILLER_122_152 VPWR VGND sg13cmos5l_decap_8
XFILLER_39_7 VPWR VGND sg13cmos5l_fill_1
XFILLER_68_217 VPWR VGND sg13cmos5l_fill_1
X_1191_ _1191_/X Tile_X0Y1_N1END[0] Tile_X0Y1_E6END[0] _1227_/X _1191_/A3 _0354_/Q
+ _0353_/Q VPWR VGND sg13cmos5l_mux4_1
X_0211_ _0211_/Q Tile_X0Y0_FrameData[9] VGND VPWR Tile_X0Y1_FrameStrobe[3] latch
X_0142_ _0142_/Q Tile_X0Y0_FrameData[14] VGND VPWR Tile_X0Y1_FrameStrobe[1] latch
X_0073_ _0759_/A _1121_/X _1122_/X _0576_/Q VPWR VGND sg13cmos5l_mux2_1
XFILLER_65_0 VPWR VGND sg13cmos5l_decap_8
X_0975_ _0975_/X Tile_X0Y0_E2MID[2] Tile_X0Y0_E2END[2] _1094_/X _0975_/A3 _0166_/Q
+ _0165_/Q VPWR VGND sg13cmos5l_mux4_1
XFILLER_113_130 VPWR VGND sg13cmos5l_decap_8
XFILLER_35_15 VPWR VGND sg13cmos5l_fill_1
X_0409_ _0409_/Q Tile_X0Y1_FrameData[1] VGND VPWR Tile_X0Y1_FrameStrobe[1] latch
XANTENNA__0890__X Tile_X0Y1_S1BEG[2] VPWR VGND sg13cmos5l_antennanp
XFILLER_35_48 VPWR VGND sg13cmos5l_decap_8
XFILLER_104_163 VPWR VGND sg13cmos5l_decap_8
XFILLER_76_22 VPWR VGND sg13cmos5l_fill_2
XFILLER_132_94 VPWR VGND sg13cmos5l_decap_8
XFILLER_92_76 VPWR VGND sg13cmos5l_decap_8
XFILLER_127_200 VPWR VGND sg13cmos5l_decap_8
XFILLER_41_183 VPWR VGND sg13cmos5l_decap_8
X_0760_ Tile_X0Y0_N4BEG[9] _0760_/A VPWR VGND sg13cmos5l_buf_1
XFILLER_92_98 VPWR VGND sg13cmos5l_fill_1
X_0691_ _0691_/L_HI VPWR VGND sg13cmos5l_tiehi
XFILLER_2_41 VPWR VGND sg13cmos5l_decap_4
X_1174_ _1174_/X _0647_/Q _0651_/Q _1207_/X _1199_/X _0468_/Q _0467_/Q VPWR VGND sg13cmos5l_mux4_1
XANTENNA_13 Tile_X0Y0_S2MID[2] VPWR VGND sg13cmos5l_antennanp
XFILLER_17_191 VPWR VGND sg13cmos5l_decap_8
X_0125_ _0125_/Q Tile_X0Y0_FrameData[31] VGND VPWR Tile_X0Y1_FrameStrobe[1] latch
XANTENNA_24 Tile_X0Y0_S2MID[6] VPWR VGND sg13cmos5l_antennanp
XANTENNA_35 Tile_X0Y1_N2MID[1] VPWR VGND sg13cmos5l_antennanp
XANTENNA_46 Tile_X0Y1_N2MID[6] VPWR VGND sg13cmos5l_antennanp
XANTENNA_57 Tile_X0Y0_S4END[6] VPWR VGND sg13cmos5l_antennanp
XFILLER_137_28 VPWR VGND sg13cmos5l_decap_8
X_0889_ Tile_X0Y1_S1BEG[1] _1124_/X VPWR VGND sg13cmos5l_buf_1
X_0958_ Tile_X0Y1_WW4BEG[1] _1164_/X VPWR VGND sg13cmos5l_buf_1
XANTENNA__0885__X Tile_X0Y0_FrameData_O[29] VPWR VGND sg13cmos5l_antennanp
XFILLER_101_100 VPWR VGND sg13cmos5l_fill_2
XFILLER_99_172 VPWR VGND sg13cmos5l_decap_8
XFILLER_99_150 VPWR VGND sg13cmos5l_decap_8
XFILLER_101_188 VPWR VGND sg13cmos5l_decap_8
XFILLER_102_20 VPWR VGND sg13cmos5l_decap_8
XFILLER_46_69 VPWR VGND sg13cmos5l_decap_8
XFILLER_141_4 VPWR VGND sg13cmos5l_fill_2
XFILLER_23_150 VPWR VGND sg13cmos5l_decap_8
XFILLER_62_68 VPWR VGND sg13cmos5l_decap_4
XFILLER_124_203 VPWR VGND sg13cmos5l_decap_8
XFILLER_97_109 VPWR VGND sg13cmos5l_fill_1
XFILLER_87_21 VPWR VGND sg13cmos5l_decap_8
XANTENNA__0795__X Tile_X0Y0_N2BEG[4] VPWR VGND sg13cmos5l_antennanp
XFILLER_87_98 VPWR VGND sg13cmos5l_decap_8
XFILLER_14_172 VPWR VGND sg13cmos5l_fill_1
XFILLER_115_203 VPWR VGND sg13cmos5l_decap_4
XFILLER_52_90 VPWR VGND sg13cmos5l_decap_8
X_0812_ Tile_X0Y0_FrameStrobe_O[9] Tile_X0Y1_FrameStrobe[9] VPWR VGND sg13cmos5l_buf_1
X_0743_ Tile_X0Y0_W6BEG[4] _1067_/X VPWR VGND sg13cmos5l_buf_1
XFILLER_28_0 VPWR VGND sg13cmos5l_fill_2
X_0674_ _0674_/L_HI VPWR VGND sg13cmos5l_tiehi
XFILLER_96_120 VPWR VGND sg13cmos5l_decap_8
XFILLER_88_109 VPWR VGND sg13cmos5l_decap_8
X_1226_ _1226_/X Tile_X0Y0_E1END[3] Tile_X0Y0_E2MID[0] Tile_X0Y0_E2END[0] _1099_/X
+ _0288_/Q _0287_/Q VPWR VGND sg13cmos5l_mux4_1
X_1157_ _1157_/X Tile_X0Y1_E2END[3] _0646_/Q _1197_/X _1200_/X _0502_/Q _0501_/Q VPWR
+ VGND sg13cmos5l_mux4_1
X_0108_ _0108_/Q Tile_X0Y0_FrameData[16] VGND VPWR Tile_X0Y1_FrameStrobe[0] latch
XFILLER_96_197 VPWR VGND sg13cmos5l_decap_8
XFILLER_20_131 VPWR VGND sg13cmos5l_fill_1
X_1088_ _1088_/X _1111_/X Tile_X0Y1_N4END[4] Tile_X0Y0_S1END[0] Tile_X0Y0_S4END[0]
+ _0148_/Q _0147_/Q VPWR VGND sg13cmos5l_mux4_1
XFILLER_106_7 VPWR VGND sg13cmos5l_fill_1
XFILLER_57_35 VPWR VGND sg13cmos5l_fill_1
XFILLER_113_41 VPWR VGND sg13cmos5l_decap_8
XFILLER_113_96 VPWR VGND sg13cmos5l_fill_2
XFILLER_43_201 VPWR VGND sg13cmos5l_decap_8
XFILLER_132_0 VPWR VGND sg13cmos5l_decap_8
XFILLER_7_157 VPWR VGND sg13cmos5l_decap_8
XFILLER_112_217 VPWR VGND sg13cmos5l_fill_1
XFILLER_78_153 VPWR VGND sg13cmos5l_fill_2
X_0390_ _0390_/Q Tile_X0Y1_FrameData[20] VGND VPWR Tile_X0Y1_FrameStrobe[1] latch
XFILLER_98_75 VPWR VGND sg13cmos5l_decap_8
XFILLER_98_31 VPWR VGND sg13cmos5l_decap_8
XFILLER_78_197 VPWR VGND sg13cmos5l_decap_8
X_1011_ _1011_/X Tile_X0Y0_E1END[0] Tile_X0Y0_EE4END[0] Tile_X0Y0_E6END[8] _1088_/X
+ _0322_/Q _0321_/Q VPWR VGND sg13cmos5l_mux4_1
XFILLER_93_189 VPWR VGND sg13cmos5l_decap_8
X_0726_ Tile_X0Y0_W2BEG[3] _1034_/X VPWR VGND sg13cmos5l_buf_1
XFILLER_103_217 VPWR VGND sg13cmos5l_fill_1
XFILLER_84_112 VPWR VGND sg13cmos5l_decap_8
X_0657_ _0657_/L_HI VPWR VGND sg13cmos5l_tiehi
X_0588_ _0588_/Q Tile_X0Y1_FrameData[14] VGND VPWR Tile_X0Y1_FrameStrobe[7] latch
X_1209_ _1209_/X Tile_X0Y1_N1END[2] Tile_X0Y1_N4END[2] _1229_/X Tile_X0Y0_S4END[6]
+ _0390_/Q _0389_/Q VPWR VGND sg13cmos5l_mux4_1
XFILLER_138_147 VPWR VGND sg13cmos5l_fill_2
XFILLER_43_59 VPWR VGND sg13cmos5l_decap_8
XFILLER_4_116 VPWR VGND sg13cmos5l_decap_8
XFILLER_124_51 VPWR VGND sg13cmos5l_decap_8
XFILLER_75_134 VPWR VGND sg13cmos5l_decap_8
XFILLER_84_22 VPWR VGND sg13cmos5l_decap_8
XFILLER_17_82 VPWR VGND sg13cmos5l_decap_8
XFILLER_90_148 VPWR VGND sg13cmos5l_decap_8
XFILLER_137_180 VPWR VGND sg13cmos5l_decap_8
XFILLER_69_7 VPWR VGND sg13cmos5l_decap_8
X_0511_ _0511_/Q Tile_X0Y1_FrameData[27] VGND VPWR Tile_X0Y1_FrameStrobe[5] latch
XFILLER_3_171 VPWR VGND sg13cmos5l_decap_8
XFILLER_66_134 VPWR VGND sg13cmos5l_decap_4
X_0442_ _0442_/Q Tile_X0Y1_FrameData[0] VGND VPWR Tile_X0Y1_FrameStrobe[2] latch
X_0373_ _0373_/Q Tile_X0Y1_FrameData[5] VGND VPWR Tile_X0Y1_FrameStrobe[0] latch
XFILLER_66_189 VPWR VGND sg13cmos5l_fill_1
XFILLER_95_0 VPWR VGND sg13cmos5l_decap_4
XFILLER_135_128 VPWR VGND sg13cmos5l_decap_4
X_0709_ _1192_/A3 VPWR VGND sg13cmos5l_tielo
XANTENNA__0893__X Tile_X0Y1_S2BEG[1] VPWR VGND sg13cmos5l_antennanp
XFILLER_54_14 VPWR VGND sg13cmos5l_decap_8
XFILLER_72_126 VPWR VGND sg13cmos5l_decap_8
XFILLER_110_64 VPWR VGND sg13cmos5l_decap_8
XFILLER_70_35 VPWR VGND sg13cmos5l_decap_8
XFILLER_119_180 VPWR VGND sg13cmos5l_decap_8
XFILLER_126_117 VPWR VGND sg13cmos5l_decap_8
XFILLER_28_70 VPWR VGND sg13cmos5l_decap_4
XFILLER_28_92 VPWR VGND sg13cmos5l_fill_1
XFILLER_48_145 VPWR VGND sg13cmos5l_fill_1
XFILLER_48_167 VPWR VGND sg13cmos5l_decap_8
XFILLER_95_76 VPWR VGND sg13cmos5l_decap_8
XFILLER_117_117 VPWR VGND sg13cmos5l_decap_8
XFILLER_44_91 VPWR VGND sg13cmos5l_decap_4
X_0991_ _0991_/X Tile_X0Y1_EE4END[1] Tile_X0Y1_EE4END[9] Tile_X0Y1_E6END[9] _1212_/X
+ _0416_/Q _0415_/Q VPWR VGND sg13cmos5l_mux4_1
XFILLER_125_172 VPWR VGND sg13cmos5l_decap_4
XFILLER_140_142 VPWR VGND sg13cmos5l_decap_4
XFILLER_5_52 VPWR VGND sg13cmos5l_decap_8
XFILLER_10_0 VPWR VGND sg13cmos5l_decap_4
XFILLER_39_167 VPWR VGND sg13cmos5l_fill_2
XFILLER_54_115 VPWR VGND sg13cmos5l_fill_2
X_0425_ _0425_/Q Tile_X0Y1_FrameData[17] VGND VPWR Tile_X0Y1_FrameStrobe[2] latch
X_0356_ _0356_/Q Tile_X0Y1_FrameData[22] VGND VPWR Tile_X0Y1_FrameStrobe[0] latch
X_0287_ _0287_/Q Tile_X0Y0_FrameData[29] VGND VPWR Tile_X0Y1_FrameStrobe[6] latch
XFILLER_62_170 VPWR VGND sg13cmos5l_fill_1
XFILLER_40_27 VPWR VGND sg13cmos5l_decap_8
XANTENNA__0888__X Tile_X0Y1_S1BEG[0] VPWR VGND sg13cmos5l_antennanp
XFILLER_131_131 VPWR VGND sg13cmos5l_decap_8
XFILLER_65_68 VPWR VGND sg13cmos5l_decap_8
XFILLER_14_94 VPWR VGND sg13cmos5l_decap_8
XFILLER_53_170 VPWR VGND sg13cmos5l_fill_2
XFILLER_81_56 VPWR VGND sg13cmos5l_fill_2
XANTENNA__0798__X Tile_X0Y0_N2BEG[7] VPWR VGND sg13cmos5l_antennanp
X_1190_ _1190_/X _0647_/Q _1203_/X _1207_/X _1202_/X _0436_/Q _0435_/Q VPWR VGND sg13cmos5l_mux4_1
X_0210_ _0210_/Q Tile_X0Y0_FrameData[10] VGND VPWR Tile_X0Y1_FrameStrobe[3] latch
X_0141_ _0141_/Q Tile_X0Y0_FrameData[15] VGND VPWR Tile_X0Y1_FrameStrobe[1] latch
XFILLER_91_210 VPWR VGND sg13cmos5l_decap_8
XFILLER_36_137 VPWR VGND sg13cmos5l_decap_4
XFILLER_51_107 VPWR VGND sg13cmos5l_decap_8
XFILLER_51_118 VPWR VGND sg13cmos5l_fill_2
X_0072_ _0092_/D _1233_/X _0605_/Q _0608_/Q VPWR VGND sg13cmos5l_mux2_1
X_0974_ _0974_/X Tile_X0Y0_E2MID[1] Tile_X0Y0_E2END[1] _1093_/X _0974_/A3 _0168_/Q
+ _0167_/Q VPWR VGND sg13cmos5l_mux4_1
XFILLER_113_186 VPWR VGND sg13cmos5l_decap_8
XFILLER_58_0 VPWR VGND sg13cmos5l_decap_4
XFILLER_35_27 VPWR VGND sg13cmos5l_decap_8
X_0408_ _0408_/Q Tile_X0Y1_FrameData[2] VGND VPWR Tile_X0Y1_FrameStrobe[1] latch
X_0339_ _0339_/Q Tile_X0Y0_FrameData[9] VGND VPWR Tile_X0Y1_FrameStrobe[7] latch
XFILLER_136_7 VPWR VGND sg13cmos5l_decap_8
XFILLER_35_181 VPWR VGND sg13cmos5l_decap_4
XFILLER_51_15 VPWR VGND sg13cmos5l_fill_2
XFILLER_116_63 VPWR VGND sg13cmos5l_decap_8
XFILLER_116_85 VPWR VGND sg13cmos5l_fill_1
XFILLER_73_210 VPWR VGND sg13cmos5l_decap_8
XFILLER_132_40 VPWR VGND sg13cmos5l_fill_2
XFILLER_26_181 VPWR VGND sg13cmos5l_fill_1
XFILLER_26_192 VPWR VGND sg13cmos5l_decap_4
XFILLER_92_55 VPWR VGND sg13cmos5l_decap_8
XFILLER_41_162 VPWR VGND sg13cmos5l_decap_8
XFILLER_41_70 VPWR VGND sg13cmos5l_decap_8
XFILLER_41_81 VPWR VGND sg13cmos5l_decap_4
XFILLER_41_92 VPWR VGND sg13cmos5l_decap_4
X_0690_ _0690_/L_HI VPWR VGND sg13cmos5l_tiehi
XFILLER_2_97 VPWR VGND sg13cmos5l_fill_2
X_1173_ _1173_/X _0646_/Q _0650_/Q _1208_/X _1200_/X _0470_/Q _0469_/Q VPWR VGND sg13cmos5l_mux4_1
X_0124_ _0124_/Q Tile_X0Y0_FrameData[0] VGND VPWR Tile_X0Y1_FrameStrobe[0] latch
XANTENNA_14 Tile_X0Y0_S2MID[2] VPWR VGND sg13cmos5l_antennanp
XANTENNA_25 Tile_X0Y0_S2MID[6] VPWR VGND sg13cmos5l_antennanp
XANTENNA_36 Tile_X0Y1_N2MID[1] VPWR VGND sg13cmos5l_antennanp
XANTENNA_47 Tile_X0Y1_N2MID[6] VPWR VGND sg13cmos5l_antennanp
XANTENNA_58 Tile_X0Y0_S4END[6] VPWR VGND sg13cmos5l_antennanp
XFILLER_118_212 VPWR VGND sg13cmos5l_decap_4
X_0888_ Tile_X0Y1_S1BEG[0] _1123_/X VPWR VGND sg13cmos5l_buf_1
X_0957_ Tile_X0Y1_WW4BEG[0] _1163_/X VPWR VGND sg13cmos5l_buf_1
XFILLER_101_145 VPWR VGND sg13cmos5l_fill_1
XFILLER_15_129 VPWR VGND sg13cmos5l_decap_4
XFILLER_46_48 VPWR VGND sg13cmos5l_decap_8
XFILLER_55_210 VPWR VGND sg13cmos5l_decap_8
XFILLER_134_4 VPWR VGND sg13cmos5l_fill_2
XFILLER_11_84 VPWR VGND sg13cmos5l_fill_2
XFILLER_127_84 VPWR VGND sg13cmos5l_decap_8
XFILLER_87_77 VPWR VGND sg13cmos5l_decap_8
XFILLER_46_210 VPWR VGND sg13cmos5l_decap_8
XFILLER_14_184 VPWR VGND sg13cmos5l_decap_8
XFILLER_36_92 VPWR VGND sg13cmos5l_decap_8
X_0811_ Tile_X0Y0_FrameStrobe_O[8] Tile_X0Y1_FrameStrobe[8] VPWR VGND sg13cmos5l_buf_1
X_0742_ Tile_X0Y0_W6BEG[3] _1066_/X VPWR VGND sg13cmos5l_buf_1
X_0673_ _0673_/L_HI VPWR VGND sg13cmos5l_tiehi
XFILLER_96_176 VPWR VGND sg13cmos5l_decap_8
XFILLER_52_213 VPWR VGND sg13cmos5l_decap_4
X_1087_ _1087_/X _1111_/X Tile_X0Y1_N4END[4] Tile_X0Y0_S1END[0] Tile_X0Y0_S4END[0]
+ _0140_/Q _0139_/Q VPWR VGND sg13cmos5l_mux4_1
X_1225_ _1225_/X Tile_X0Y0_E1END[2] Tile_X0Y0_E2MID[1] Tile_X0Y0_E2END[1] _1098_/X
+ _0290_/Q _0289_/Q VPWR VGND sg13cmos5l_mux4_1
X_1156_ _1156_/X Tile_X0Y1_E2MID[4] _0645_/Q _1196_/X _1201_/X _0504_/Q _0503_/Q VPWR
+ VGND sg13cmos5l_mux4_1
X_0107_ _0107_/Q Tile_X0Y0_FrameData[17] VGND VPWR Tile_X0Y1_FrameStrobe[0] latch
XFILLER_20_176 VPWR VGND sg13cmos5l_fill_2
XANTENNA__0896__X Tile_X0Y1_S2BEG[4] VPWR VGND sg13cmos5l_antennanp
XFILLER_106_204 VPWR VGND sg13cmos5l_decap_8
XFILLER_113_20 VPWR VGND sg13cmos5l_decap_8
XFILLER_57_47 VPWR VGND sg13cmos5l_decap_8
XFILLER_87_154 VPWR VGND sg13cmos5l_fill_2
XFILLER_11_132 VPWR VGND sg13cmos5l_decap_8
XFILLER_125_0 VPWR VGND sg13cmos5l_decap_8
XFILLER_7_136 VPWR VGND sg13cmos5l_decap_8
XFILLER_78_132 VPWR VGND sg13cmos5l_decap_8
XFILLER_78_176 VPWR VGND sg13cmos5l_decap_8
XFILLER_19_210 VPWR VGND sg13cmos5l_decap_8
X_1010_ _1010_/X Tile_X0Y0_E2MID[0] Tile_X0Y0_E2END[0] Tile_X0Y0_E6END[0] _1099_/X
+ _0324_/Q _0323_/Q VPWR VGND sg13cmos5l_mux4_1
XFILLER_93_146 VPWR VGND sg13cmos5l_decap_8
XFILLER_8_30 VPWR VGND sg13cmos5l_decap_4
XFILLER_40_0 VPWR VGND sg13cmos5l_decap_8
X_0725_ Tile_X0Y0_W2BEG[2] _1033_/X VPWR VGND sg13cmos5l_buf_1
X_0656_ _0656_/L_HI VPWR VGND sg13cmos5l_tiehi
XFILLER_27_28 VPWR VGND sg13cmos5l_decap_8
X_1208_ _1208_/X Tile_X0Y1_N1END[1] Tile_X0Y1_N4END[1] _1228_/X Tile_X0Y0_S4END[5]
+ _0392_/Q _0391_/Q VPWR VGND sg13cmos5l_mux4_1
X_0587_ _0587_/Q Tile_X0Y1_FrameData[15] VGND VPWR Tile_X0Y1_FrameStrobe[7] latch
X_1139_ _1139_/X Tile_X0Y1_E1END[2] Tile_X0Y1_EE4END[14] Tile_X0Y1_E6END[6] _1205_/X
+ _0536_/Q _0535_/Q VPWR VGND sg13cmos5l_mux4_1
XFILLER_138_126 VPWR VGND sg13cmos5l_decap_8
XFILLER_138_159 VPWR VGND sg13cmos5l_decap_8
XFILLER_108_53 VPWR VGND sg13cmos5l_decap_8
XFILLER_108_64 VPWR VGND sg13cmos5l_fill_2
XFILLER_75_179 VPWR VGND sg13cmos5l_decap_8
XFILLER_84_89 VPWR VGND sg13cmos5l_decap_8
XFILLER_129_159 VPWR VGND sg13cmos5l_decap_8
X_0510_ _0510_/Q Tile_X0Y1_FrameData[28] VGND VPWR Tile_X0Y1_FrameStrobe[5] latch
XFILLER_98_216 VPWR VGND sg13cmos5l_fill_2
XFILLER_98_205 VPWR VGND sg13cmos5l_decap_8
XFILLER_66_113 VPWR VGND sg13cmos5l_decap_8
X_0441_ _0441_/Q Tile_X0Y1_FrameData[1] VGND VPWR Tile_X0Y1_FrameStrobe[2] latch
X_0372_ _0372_/Q Tile_X0Y1_FrameData[6] VGND VPWR Tile_X0Y1_FrameStrobe[0] latch
XFILLER_88_0 VPWR VGND sg13cmos5l_fill_2
XFILLER_128_192 VPWR VGND sg13cmos5l_decap_8
X_0708_ _1193_/A3 VPWR VGND sg13cmos5l_tielo
X_0639_ _0639_/Q Tile_X0Y1_UserCLK NPU_OUT_ACT3 _0669_/L_HI VPWR VGND sg13cmos5l_dfrbpq_1
XFILLER_57_113 VPWR VGND sg13cmos5l_decap_8
XFILLER_72_105 VPWR VGND sg13cmos5l_decap_8
XFILLER_110_43 VPWR VGND sg13cmos5l_decap_8
XFILLER_13_205 VPWR VGND sg13cmos5l_fill_2
XFILLER_70_14 VPWR VGND sg13cmos5l_decap_8
XFILLER_79_67 VPWR VGND sg13cmos5l_fill_2
XFILLER_0_197 VPWR VGND sg13cmos5l_fill_2
XFILLER_134_184 VPWR VGND sg13cmos5l_decap_8
XFILLER_135_95 VPWR VGND sg13cmos5l_decap_8
XFILLER_48_124 VPWR VGND sg13cmos5l_decap_8
XFILLER_44_70 VPWR VGND sg13cmos5l_decap_8
XFILLER_71_182 VPWR VGND sg13cmos5l_decap_8
X_0990_ _0990_/X Tile_X0Y1_EE4END[0] Tile_X0Y1_EE4END[8] Tile_X0Y1_E6END[8] _1211_/X
+ _0418_/Q _0417_/Q VPWR VGND sg13cmos5l_mux4_1
XFILLER_125_195 VPWR VGND sg13cmos5l_decap_8
X_0424_ _0424_/Q Tile_X0Y1_FrameData[18] VGND VPWR Tile_X0Y1_FrameStrobe[2] latch
XFILLER_39_113 VPWR VGND sg13cmos5l_decap_8
XFILLER_39_124 VPWR VGND sg13cmos5l_decap_8
XFILLER_39_146 VPWR VGND sg13cmos5l_decap_8
X_0355_ _0355_/Q Tile_X0Y1_FrameData[23] VGND VPWR Tile_X0Y1_FrameStrobe[0] latch
X_0286_ _0286_/Q Tile_X0Y0_FrameData[30] VGND VPWR Tile_X0Y1_FrameStrobe[6] latch
XFILLER_108_129 VPWR VGND sg13cmos5l_decap_8
XFILLER_105_54 VPWR VGND sg13cmos5l_decap_8
XFILLER_105_65 VPWR VGND sg13cmos5l_fill_2
XFILLER_116_184 VPWR VGND sg13cmos5l_decap_8
XFILLER_131_110 VPWR VGND sg13cmos5l_decap_8
XFILLER_65_14 VPWR VGND sg13cmos5l_decap_8
XFILLER_121_75 VPWR VGND sg13cmos5l_decap_8
XFILLER_65_25 VPWR VGND sg13cmos5l_fill_1
XFILLER_81_13 VPWR VGND sg13cmos5l_fill_1
XFILLER_81_35 VPWR VGND sg13cmos5l_decap_8
XFILLER_14_40 VPWR VGND sg13cmos5l_fill_2
XFILLER_107_173 VPWR VGND sg13cmos5l_fill_1
XFILLER_122_187 VPWR VGND sg13cmos5l_decap_8
XFILLER_39_92 VPWR VGND sg13cmos5l_decap_8
X_0140_ _0140_/Q Tile_X0Y0_FrameData[16] VGND VPWR Tile_X0Y1_FrameStrobe[1] latch
X_0071_ _0091_/D _1232_/X _0606_/Q _0608_/Q VPWR VGND sg13cmos5l_mux2_1
X_0973_ _0973_/X Tile_X0Y0_E2MID[0] Tile_X0Y0_E2END[0] _1092_/X _0973_/A3 _0170_/Q
+ _0169_/Q VPWR VGND sg13cmos5l_mux4_1
XFILLER_113_165 VPWR VGND sg13cmos5l_decap_8
X_0407_ _0407_/Q Tile_X0Y1_FrameData[3] VGND VPWR Tile_X0Y1_FrameStrobe[1] latch
XFILLER_35_160 VPWR VGND sg13cmos5l_decap_8
XFILLER_82_211 VPWR VGND sg13cmos5l_decap_8
X_0338_ _0338_/Q Tile_X0Y0_FrameData[10] VGND VPWR Tile_X0Y1_FrameStrobe[7] latch
X_0269_ _0269_/Q Tile_X0Y0_FrameData[15] VGND VPWR Tile_X0Y1_FrameStrobe[5] latch
XFILLER_129_7 VPWR VGND sg13cmos5l_fill_1
XFILLER_136_213 VPWR VGND sg13cmos5l_decap_4
XFILLER_51_49 VPWR VGND sg13cmos5l_fill_2
XANTENNA__0899__X Tile_X0Y1_S2BEG[7] VPWR VGND sg13cmos5l_antennanp
XFILLER_116_42 VPWR VGND sg13cmos5l_decap_8
XFILLER_104_198 VPWR VGND sg13cmos5l_decap_8
XFILLER_132_63 VPWR VGND sg13cmos5l_decap_8
XFILLER_18_127 VPWR VGND sg13cmos5l_decap_8
XFILLER_73_200 VPWR VGND sg13cmos5l_decap_8
XFILLER_76_24 VPWR VGND sg13cmos5l_fill_1
XFILLER_132_74 VPWR VGND sg13cmos5l_fill_2
XFILLER_33_119 VPWR VGND sg13cmos5l_decap_4
XFILLER_92_34 VPWR VGND sg13cmos5l_decap_8
XFILLER_41_60 VPWR VGND sg13cmos5l_fill_2
XFILLER_2_21 VPWR VGND sg13cmos5l_decap_4
XFILLER_44_7 VPWR VGND sg13cmos5l_decap_4
XFILLER_17_160 VPWR VGND sg13cmos5l_fill_2
X_1172_ _1172_/X _0645_/Q _0649_/Q _1209_/X _1201_/X _0472_/Q _0471_/Q VPWR VGND sg13cmos5l_mux4_1
X_0123_ _0123_/Q Tile_X0Y0_FrameData[1] VGND VPWR Tile_X0Y1_FrameStrobe[0] latch
XANTENNA_15 Tile_X0Y0_S2MID[2] VPWR VGND sg13cmos5l_antennanp
XANTENNA_26 Tile_X0Y0_S2MID[7] VPWR VGND sg13cmos5l_antennanp
XANTENNA_37 Tile_X0Y1_N2MID[1] VPWR VGND sg13cmos5l_antennanp
XANTENNA_48 Tile_X0Y1_N2MID[6] VPWR VGND sg13cmos5l_antennanp
XANTENNA_59 Tile_X0Y0_S4END[6] VPWR VGND sg13cmos5l_antennanp
XFILLER_32_163 VPWR VGND sg13cmos5l_fill_1
XFILLER_70_0 VPWR VGND sg13cmos5l_decap_8
X_0956_ Tile_X0Y1_W6BEG[11] _1190_/X VPWR VGND sg13cmos5l_buf_1
X_0887_ Tile_X0Y0_FrameData_O[31] Tile_X0Y0_FrameData[31] VPWR VGND sg13cmos5l_buf_1
XFILLER_101_102 VPWR VGND sg13cmos5l_fill_1
XFILLER_102_55 VPWR VGND sg13cmos5l_decap_4
XFILLER_23_185 VPWR VGND sg13cmos5l_decap_4
XFILLER_11_52 VPWR VGND sg13cmos5l_fill_1
XFILLER_11_74 VPWR VGND sg13cmos5l_fill_2
XFILLER_11_96 VPWR VGND sg13cmos5l_fill_1
XFILLER_87_56 VPWR VGND sg13cmos5l_decap_8
XFILLER_36_60 VPWR VGND sg13cmos5l_decap_4
XFILLER_36_71 VPWR VGND sg13cmos5l_decap_8
XFILLER_14_163 VPWR VGND sg13cmos5l_decap_8
X_0810_ Tile_X0Y0_FrameStrobe_O[7] Tile_X0Y1_FrameStrobe[7] VPWR VGND sg13cmos5l_buf_1
XFILLER_42_4 VPWR VGND sg13cmos5l_fill_1
X_0741_ Tile_X0Y0_W6BEG[2] _1065_/X VPWR VGND sg13cmos5l_buf_1
X_0672_ _0672_/L_HI VPWR VGND sg13cmos5l_tiehi
XFILLER_28_2 VPWR VGND sg13cmos5l_fill_1
X_1224_ _1224_/X Tile_X0Y0_E1END[1] Tile_X0Y0_E2MID[2] Tile_X0Y0_E2END[2] _1097_/X
+ _0292_/Q _0291_/Q VPWR VGND sg13cmos5l_mux4_1
XFILLER_96_155 VPWR VGND sg13cmos5l_decap_8
XFILLER_52_203 VPWR VGND sg13cmos5l_fill_1
X_1086_ _1086_/X _1112_/X Tile_X0Y1_N4END[5] Tile_X0Y0_S1END[1] Tile_X0Y0_S4END[1]
+ _0138_/Q _0137_/Q VPWR VGND sg13cmos5l_mux4_1
X_1155_ _1155_/X Tile_X0Y1_E2MID[1] _0644_/Q _1195_/X _1202_/X _0506_/Q _0505_/Q VPWR
+ VGND sg13cmos5l_mux4_1
X_0106_ _0106_/Q Tile_X0Y0_FrameData[18] VGND VPWR Tile_X0Y1_FrameStrobe[0] latch
X_0939_ Tile_X0Y1_W2BEGb[2] _1157_/X VPWR VGND sg13cmos5l_buf_1
XFILLER_57_26 VPWR VGND sg13cmos5l_decap_8
XFILLER_87_133 VPWR VGND sg13cmos5l_decap_8
XFILLER_73_47 VPWR VGND sg13cmos5l_decap_4
XFILLER_87_199 VPWR VGND sg13cmos5l_fill_1
XFILLER_11_111 VPWR VGND sg13cmos5l_decap_8
XFILLER_118_0 VPWR VGND sg13cmos5l_decap_8
XFILLER_11_188 VPWR VGND sg13cmos5l_decap_8
XFILLER_138_84 VPWR VGND sg13cmos5l_decap_8
XFILLER_22_95 VPWR VGND sg13cmos5l_decap_8
XFILLER_7_115 VPWR VGND sg13cmos5l_decap_8
XFILLER_98_11 VPWR VGND sg13cmos5l_fill_2
XFILLER_0_0 VPWR VGND sg13cmos5l_decap_8
XFILLER_112_208 VPWR VGND sg13cmos5l_decap_8
XFILLER_8_97 VPWR VGND sg13cmos5l_fill_2
XFILLER_8_20 VPWR VGND sg13cmos5l_fill_2
XFILLER_33_0 VPWR VGND sg13cmos5l_fill_1
XFILLER_69_111 VPWR VGND sg13cmos5l_decap_8
X_0724_ Tile_X0Y0_W2BEG[1] _1032_/X VPWR VGND sg13cmos5l_buf_1
X_0655_ _0655_/L_HI VPWR VGND sg13cmos5l_tiehi
X_0586_ _0586_/Q Tile_X0Y1_FrameData[16] VGND VPWR Tile_X0Y1_FrameStrobe[7] latch
XFILLER_84_169 VPWR VGND sg13cmos5l_decap_8
X_1207_ _1207_/X Tile_X0Y1_N1END[0] Tile_X0Y1_N4END[0] _1227_/X Tile_X0Y0_S4END[4]
+ _0394_/Q _0393_/Q VPWR VGND sg13cmos5l_mux4_1
XFILLER_138_105 VPWR VGND sg13cmos5l_decap_8
XFILLER_43_39 VPWR VGND sg13cmos5l_decap_4
X_1069_ _1069_/X _0642_/Q _1086_/X _1082_/X _1094_/X _0190_/Q _0189_/Q VPWR VGND sg13cmos5l_mux4_1
X_1138_ _1138_/X _1208_/X _1212_/X _1216_/X _1200_/X _0539_/Q _0538_/Q VPWR VGND sg13cmos5l_mux4_1
XFILLER_92_180 VPWR VGND sg13cmos5l_decap_8
XFILLER_108_32 VPWR VGND sg13cmos5l_decap_8
XFILLER_111_7 VPWR VGND sg13cmos5l_decap_8
XFILLER_138_149 VPWR VGND sg13cmos5l_fill_1
XFILLER_108_87 VPWR VGND sg13cmos5l_decap_8
XFILLER_68_14 VPWR VGND sg13cmos5l_decap_8
XFILLER_68_69 VPWR VGND sg13cmos5l_decap_8
XFILLER_84_13 VPWR VGND sg13cmos5l_fill_1
XFILLER_31_217 VPWR VGND sg13cmos5l_fill_1
XFILLER_75_158 VPWR VGND sg13cmos5l_decap_8
XFILLER_90_128 VPWR VGND sg13cmos5l_decap_4
XFILLER_129_138 VPWR VGND sg13cmos5l_decap_8
X_0440_ _0440_/Q Tile_X0Y1_FrameData[2] VGND VPWR Tile_X0Y1_FrameStrobe[2] latch
XFILLER_66_169 VPWR VGND sg13cmos5l_decap_4
X_0371_ _0371_/Q Tile_X0Y1_FrameData[7] VGND VPWR Tile_X0Y1_FrameStrobe[0] latch
XFILLER_81_139 VPWR VGND sg13cmos5l_decap_8
XFILLER_128_171 VPWR VGND sg13cmos5l_decap_8
X_0707_ _1194_/A3 VPWR VGND sg13cmos5l_tielo
X_0638_ _0638_/Q Tile_X0Y1_UserCLK NPU_OUT_ACT2 _0670_/L_HI VPWR VGND sg13cmos5l_dfrbpq_1
X_0569_ _0569_/Q Tile_X0Y1_FrameData[1] VGND VPWR Tile_X0Y1_FrameStrobe[6] latch
XFILLER_89_217 VPWR VGND sg13cmos5l_fill_1
XFILLER_89_206 VPWR VGND sg13cmos5l_fill_1
XFILLER_57_158 VPWR VGND sg13cmos5l_decap_4
XFILLER_110_99 VPWR VGND sg13cmos5l_decap_8
XFILLER_13_217 VPWR VGND sg13cmos5l_fill_1
XFILLER_119_86 VPWR VGND sg13cmos5l_fill_1
XFILLER_134_163 VPWR VGND sg13cmos5l_decap_8
XFILLER_79_24 VPWR VGND sg13cmos5l_decap_4
XFILLER_0_143 VPWR VGND sg13cmos5l_decap_8
XFILLER_0_176 VPWR VGND sg13cmos5l_decap_8
XFILLER_135_74 VPWR VGND sg13cmos5l_decap_8
XFILLER_28_83 VPWR VGND sg13cmos5l_decap_8
XFILLER_48_103 VPWR VGND sg13cmos5l_decap_8
XFILLER_71_161 VPWR VGND sg13cmos5l_decap_8
XFILLER_8_210 VPWR VGND sg13cmos5l_decap_8
XFILLER_125_152 VPWR VGND sg13cmos5l_decap_8
XFILLER_140_177 VPWR VGND sg13cmos5l_fill_2
XFILLER_5_32 VPWR VGND sg13cmos5l_decap_4
XFILLER_5_87 VPWR VGND sg13cmos5l_decap_4
X_0423_ _0423_/Q Tile_X0Y1_FrameData[19] VGND VPWR Tile_X0Y1_FrameStrobe[2] latch
XFILLER_47_191 VPWR VGND sg13cmos5l_decap_8
X_0354_ _0354_/Q Tile_X0Y1_FrameData[24] VGND VPWR Tile_X0Y1_FrameStrobe[0] latch
X_0285_ _0285_/Q Tile_X0Y0_FrameData[31] VGND VPWR Tile_X0Y1_FrameStrobe[6] latch
XFILLER_116_141 VPWR VGND sg13cmos5l_decap_8
XFILLER_105_11 VPWR VGND sg13cmos5l_decap_4
XFILLER_105_33 VPWR VGND sg13cmos5l_decap_8
XFILLER_105_88 VPWR VGND sg13cmos5l_fill_1
XFILLER_131_166 VPWR VGND sg13cmos5l_decap_8
XFILLER_121_21 VPWR VGND sg13cmos5l_fill_1
XFILLER_121_43 VPWR VGND sg13cmos5l_decap_4
XFILLER_121_98 VPWR VGND sg13cmos5l_decap_4
XFILLER_53_172 VPWR VGND sg13cmos5l_fill_1
XFILLER_14_52 VPWR VGND sg13cmos5l_decap_8
XFILLER_100_0 VPWR VGND sg13cmos5l_decap_8
XFILLER_107_185 VPWR VGND sg13cmos5l_decap_8
XFILLER_122_166 VPWR VGND sg13cmos5l_decap_8
XFILLER_39_71 VPWR VGND sg13cmos5l_decap_8
XFILLER_55_70 VPWR VGND sg13cmos5l_decap_8
X_0070_ _0090_/D _1231_/X _0607_/Q _0608_/Q VPWR VGND sg13cmos5l_mux2_1
XFILLER_44_183 VPWR VGND sg13cmos5l_decap_8
XFILLER_71_91 VPWR VGND sg13cmos5l_decap_8
X_0972_ Tile_X0Y1_WW4BEG[15] _1178_/X VPWR VGND sg13cmos5l_buf_1
XFILLER_113_144 VPWR VGND sg13cmos5l_decap_8
X_0406_ _0406_/Q Tile_X0Y1_FrameData[4] VGND VPWR Tile_X0Y1_FrameStrobe[1] latch
X_0337_ _0337_/Q Tile_X0Y0_FrameData[11] VGND VPWR Tile_X0Y1_FrameStrobe[7] latch
XFILLER_50_120 VPWR VGND sg13cmos5l_decap_4
X_0268_ _0268_/Q Tile_X0Y0_FrameData[16] VGND VPWR Tile_X0Y1_FrameStrobe[5] latch
X_0199_ _0199_/Q Tile_X0Y0_FrameData[21] VGND VPWR Tile_X0Y1_FrameStrobe[3] latch
XFILLER_51_28 VPWR VGND sg13cmos5l_decap_8
XFILLER_104_133 VPWR VGND sg13cmos5l_decap_8
XFILLER_104_177 VPWR VGND sg13cmos5l_decap_8
XFILLER_116_21 VPWR VGND sg13cmos5l_decap_8
XFILLER_4_7 VPWR VGND sg13cmos5l_decap_8
XFILLER_92_13 VPWR VGND sg13cmos5l_decap_8
XFILLER_26_150 VPWR VGND sg13cmos5l_decap_8
XFILLER_26_172 VPWR VGND sg13cmos5l_decap_8
XFILLER_41_197 VPWR VGND sg13cmos5l_decap_8
X_1171_ _1171_/X _0644_/Q _0648_/Q _1210_/X _1202_/X _0474_/Q _0473_/Q VPWR VGND sg13cmos5l_mux4_1
X_0122_ _0122_/Q Tile_X0Y0_FrameData[2] VGND VPWR Tile_X0Y1_FrameStrobe[0] latch
XANTENNA_16 Tile_X0Y0_S2MID[3] VPWR VGND sg13cmos5l_antennanp
XANTENNA_27 Tile_X0Y0_S2MID[7] VPWR VGND sg13cmos5l_antennanp
XANTENNA_38 Tile_X0Y1_N2MID[1] VPWR VGND sg13cmos5l_antennanp
XANTENNA_49 Tile_X0Y1_N2MID[7] VPWR VGND sg13cmos5l_antennanp
XFILLER_32_142 VPWR VGND sg13cmos5l_decap_8
XFILLER_32_175 VPWR VGND sg13cmos5l_decap_8
X_0886_ Tile_X0Y0_FrameData_O[30] Tile_X0Y0_FrameData[30] VPWR VGND sg13cmos5l_buf_1
X_0955_ Tile_X0Y1_W6BEG[10] _1189_/X VPWR VGND sg13cmos5l_buf_1
XFILLER_133_206 VPWR VGND sg13cmos5l_fill_1
XFILLER_133_217 VPWR VGND sg13cmos5l_fill_1
XFILLER_63_0 VPWR VGND sg13cmos5l_decap_8
XFILLER_99_186 VPWR VGND sg13cmos5l_fill_2
XFILLER_99_164 VPWR VGND sg13cmos5l_decap_4
XFILLER_102_34 VPWR VGND sg13cmos5l_decap_8
XFILLER_23_164 VPWR VGND sg13cmos5l_decap_8
XFILLER_70_215 VPWR VGND sg13cmos5l_fill_2
XFILLER_109_203 VPWR VGND sg13cmos5l_decap_4
XFILLER_124_217 VPWR VGND sg13cmos5l_fill_1
XFILLER_87_35 VPWR VGND sg13cmos5l_decap_8
XFILLER_14_142 VPWR VGND sg13cmos5l_decap_8
X_0740_ Tile_X0Y0_W6BEG[1] _1064_/X VPWR VGND sg13cmos5l_buf_1
XFILLER_115_217 VPWR VGND sg13cmos5l_fill_1
X_0671_ _0671_/L_HI VPWR VGND sg13cmos5l_tiehi
XFILLER_77_90 VPWR VGND sg13cmos5l_decap_8
X_1223_ _1223_/X Tile_X0Y0_E1END[0] Tile_X0Y0_E2MID[3] Tile_X0Y0_E2END[3] _1096_/X
+ _0294_/Q _0293_/Q VPWR VGND sg13cmos5l_mux4_1
X_1154_ _1154_/X _0651_/Q _1195_/X _1202_/X _1193_/X _0508_/Q _0507_/Q VPWR VGND sg13cmos5l_mux4_1
XFILLER_96_134 VPWR VGND sg13cmos5l_decap_8
X_1085_ _1085_/X _1113_/X Tile_X0Y1_N4END[6] Tile_X0Y0_S1END[2] Tile_X0Y0_S4END[2]
+ _0136_/Q _0135_/Q VPWR VGND sg13cmos5l_mux4_1
X_0105_ _0105_/Q Tile_X0Y0_FrameData[19] VGND VPWR Tile_X0Y1_FrameStrobe[0] latch
X_0869_ Tile_X0Y0_FrameData_O[13] Tile_X0Y0_FrameData[13] VPWR VGND sg13cmos5l_buf_1
X_0938_ Tile_X0Y1_W2BEGb[1] _1156_/X VPWR VGND sg13cmos5l_buf_1
XFILLER_121_209 VPWR VGND sg13cmos5l_decap_8
XFILLER_87_112 VPWR VGND sg13cmos5l_decap_8
XFILLER_87_156 VPWR VGND sg13cmos5l_fill_1
XFILLER_113_55 VPWR VGND sg13cmos5l_decap_8
XFILLER_28_201 VPWR VGND sg13cmos5l_decap_8
XFILLER_43_215 VPWR VGND sg13cmos5l_fill_2
XFILLER_11_167 VPWR VGND sg13cmos5l_decap_8
XFILLER_22_52 VPWR VGND sg13cmos5l_fill_1
XFILLER_138_63 VPWR VGND sg13cmos5l_decap_8
XFILLER_98_89 VPWR VGND sg13cmos5l_decap_8
XFILLER_98_45 VPWR VGND sg13cmos5l_decap_8
XFILLER_63_92 VPWR VGND sg13cmos5l_decap_8
X_0723_ Tile_X0Y0_W2BEG[0] _1031_/X VPWR VGND sg13cmos5l_buf_1
XFILLER_26_0 VPWR VGND sg13cmos5l_decap_4
XFILLER_69_167 VPWR VGND sg13cmos5l_fill_2
XFILLER_6_182 VPWR VGND sg13cmos5l_decap_8
X_0654_ _0654_/L_HI VPWR VGND sg13cmos5l_tiehi
X_0585_ _0585_/Q Tile_X0Y1_FrameData[17] VGND VPWR Tile_X0Y1_FrameStrobe[7] latch
XFILLER_25_204 VPWR VGND sg13cmos5l_fill_2
XFILLER_84_126 VPWR VGND sg13cmos5l_fill_1
XFILLER_84_148 VPWR VGND sg13cmos5l_decap_8
X_1137_ _1137_/X Tile_X0Y1_E1END[1] Tile_X0Y1_EE4END[13] Tile_X0Y1_E6END[5] _1204_/X
+ _0539_/Q _0538_/Q VPWR VGND sg13cmos5l_mux4_1
X_1206_ _1206_/X Tile_X0Y1_N1END[3] Tile_X0Y1_N4END[3] _1230_/X Tile_X0Y0_S4END[7]
+ _0396_/Q _0395_/Q VPWR VGND sg13cmos5l_mux4_1
XFILLER_40_207 VPWR VGND sg13cmos5l_decap_8
XFILLER_43_18 VPWR VGND sg13cmos5l_decap_8
X_1068_ _1068_/X _0641_/Q _1085_/X _1081_/X _1093_/X _0192_/Q _0191_/Q VPWR VGND sg13cmos5l_mux4_1
XFILLER_108_11 VPWR VGND sg13cmos5l_decap_8
XFILLER_124_65 VPWR VGND sg13cmos5l_decap_8
XFILLER_75_148 VPWR VGND sg13cmos5l_decap_4
XFILLER_84_36 VPWR VGND sg13cmos5l_decap_8
XFILLER_140_86 VPWR VGND sg13cmos5l_decap_8
XFILLER_83_192 VPWR VGND sg13cmos5l_decap_8
XFILLER_90_107 VPWR VGND sg13cmos5l_decap_8
XFILLER_129_117 VPWR VGND sg13cmos5l_decap_8
XFILLER_130_0 VPWR VGND sg13cmos5l_decap_4
XFILLER_137_161 VPWR VGND sg13cmos5l_decap_8
XFILLER_137_194 VPWR VGND sg13cmos5l_decap_4
XFILLER_3_141 VPWR VGND sg13cmos5l_decap_8
XFILLER_3_185 VPWR VGND sg13cmos5l_decap_8
X_0370_ _0370_/Q Tile_X0Y1_FrameData[8] VGND VPWR Tile_X0Y1_FrameStrobe[0] latch
XFILLER_88_2 VPWR VGND sg13cmos5l_fill_1
XANTENNA__0801__X Tile_X0Y0_N1BEG[2] VPWR VGND sg13cmos5l_antennanp
XFILLER_128_150 VPWR VGND sg13cmos5l_decap_8
XFILLER_135_109 VPWR VGND sg13cmos5l_decap_8
X_0706_ _1078_/A3 VPWR VGND sg13cmos5l_tielo
XFILLER_38_18 VPWR VGND sg13cmos5l_decap_8
XFILLER_57_137 VPWR VGND sg13cmos5l_decap_8
X_0637_ _0637_/Q Tile_X0Y1_UserCLK NPU_OUT_ACT1 _0668_/L_HI VPWR VGND sg13cmos5l_dfrbpq_1
X_0568_ _0568_/Q Tile_X0Y1_FrameData[2] VGND VPWR Tile_X0Y1_FrameStrobe[6] latch
X_0499_ _0499_/Q Tile_X0Y1_FrameData[7] VGND VPWR Tile_X0Y1_FrameStrobe[4] latch
XFILLER_54_28 VPWR VGND sg13cmos5l_decap_8
XFILLER_80_184 VPWR VGND sg13cmos5l_decap_8
XFILLER_110_78 VPWR VGND sg13cmos5l_decap_8
XFILLER_70_49 VPWR VGND sg13cmos5l_decap_8
XFILLER_0_122 VPWR VGND sg13cmos5l_decap_8
XFILLER_102_4 VPWR VGND sg13cmos5l_fill_1
XFILLER_119_194 VPWR VGND sg13cmos5l_decap_8
XFILLER_134_142 VPWR VGND sg13cmos5l_decap_8
XFILLER_95_46 VPWR VGND sg13cmos5l_decap_4
XFILLER_71_140 VPWR VGND sg13cmos5l_decap_8
XFILLER_125_131 VPWR VGND sg13cmos5l_decap_8
XFILLER_67_7 VPWR VGND sg13cmos5l_decap_8
XFILLER_140_112 VPWR VGND sg13cmos5l_decap_8
XFILLER_140_123 VPWR VGND sg13cmos5l_fill_2
XFILLER_5_66 VPWR VGND sg13cmos5l_decap_8
X_0422_ _0422_/Q Tile_X0Y1_FrameData[20] VGND VPWR Tile_X0Y1_FrameStrobe[2] latch
X_0353_ _0353_/Q Tile_X0Y1_FrameData[25] VGND VPWR Tile_X0Y1_FrameStrobe[0] latch
XFILLER_47_170 VPWR VGND sg13cmos5l_decap_8
X_0284_ _0284_/Q Tile_X0Y0_FrameData[0] VGND VPWR Tile_X0Y1_FrameStrobe[5] latch
XFILLER_93_0 VPWR VGND sg13cmos5l_decap_4
XFILLER_131_145 VPWR VGND sg13cmos5l_decap_8
XFILLER_49_39 VPWR VGND sg13cmos5l_decap_8
XFILLER_121_11 VPWR VGND sg13cmos5l_fill_2
XFILLER_45_107 VPWR VGND sg13cmos5l_fill_2
XFILLER_85_210 VPWR VGND sg13cmos5l_decap_8
XFILLER_30_30 VPWR VGND sg13cmos5l_decap_8
XFILLER_122_145 VPWR VGND sg13cmos5l_fill_2
XFILLER_30_85 VPWR VGND sg13cmos5l_decap_8
XFILLER_36_107 VPWR VGND sg13cmos5l_fill_2
XFILLER_44_162 VPWR VGND sg13cmos5l_decap_8
XFILLER_91_202 VPWR VGND sg13cmos5l_decap_4
XFILLER_71_70 VPWR VGND sg13cmos5l_decap_8
X_0971_ Tile_X0Y1_WW4BEG[14] _1177_/X VPWR VGND sg13cmos5l_buf_1
XFILLER_113_123 VPWR VGND sg13cmos5l_decap_8
X_0405_ _0405_/Q Tile_X0Y1_FrameData[5] VGND VPWR Tile_X0Y1_FrameStrobe[1] latch
X_0336_ _0336_/Q Tile_X0Y0_FrameData[12] VGND VPWR Tile_X0Y1_FrameStrobe[7] latch
X_0267_ _0267_/Q Tile_X0Y0_FrameData[17] VGND VPWR Tile_X0Y1_FrameStrobe[5] latch
X_0198_ _0198_/Q Tile_X0Y0_FrameData[22] VGND VPWR Tile_X0Y1_FrameStrobe[3] latch
XFILLER_104_112 VPWR VGND sg13cmos5l_decap_8
XFILLER_104_156 VPWR VGND sg13cmos5l_decap_8
XFILLER_116_77 VPWR VGND sg13cmos5l_decap_4
XFILLER_2_217 VPWR VGND sg13cmos5l_fill_1
XFILLER_132_87 VPWR VGND sg13cmos5l_decap_8
XFILLER_92_69 VPWR VGND sg13cmos5l_decap_8
XFILLER_25_96 VPWR VGND sg13cmos5l_decap_4
XFILLER_41_154 VPWR VGND sg13cmos5l_decap_4
XFILLER_41_176 VPWR VGND sg13cmos5l_decap_8
XFILLER_41_62 VPWR VGND sg13cmos5l_fill_1
XFILLER_110_126 VPWR VGND sg13cmos5l_decap_4
XFILLER_2_45 VPWR VGND sg13cmos5l_fill_1
XFILLER_2_78 VPWR VGND sg13cmos5l_decap_4
XFILLER_49_210 VPWR VGND sg13cmos5l_decap_8
X_1170_ _1170_/X _0647_/Q _0651_/Q _1211_/X _1195_/X _0476_/Q _0475_/Q VPWR VGND sg13cmos5l_mux4_1
X_0121_ _0121_/Q Tile_X0Y0_FrameData[3] VGND VPWR Tile_X0Y1_FrameStrobe[0] latch
XFILLER_17_162 VPWR VGND sg13cmos5l_fill_1
XFILLER_17_184 VPWR VGND sg13cmos5l_decap_8
XANTENNA_17 Tile_X0Y0_S2MID[3] VPWR VGND sg13cmos5l_antennanp
XANTENNA_28 Tile_X0Y0_S2MID[7] VPWR VGND sg13cmos5l_antennanp
XANTENNA_39 Tile_X0Y1_N2MID[3] VPWR VGND sg13cmos5l_antennanp
X_0885_ Tile_X0Y0_FrameData_O[29] Tile_X0Y0_FrameData[29] VPWR VGND sg13cmos5l_buf_1
X_0954_ Tile_X0Y1_W6BEG[9] _1188_/X VPWR VGND sg13cmos5l_buf_1
XFILLER_56_0 VPWR VGND sg13cmos5l_decap_4
XFILLER_99_143 VPWR VGND sg13cmos5l_decap_8
XFILLER_99_121 VPWR VGND sg13cmos5l_fill_1
X_0319_ _0319_/Q Tile_X0Y0_FrameData[29] VGND VPWR Tile_X0Y1_FrameStrobe[7] latch
XFILLER_23_143 VPWR VGND sg13cmos5l_decap_8
XFILLER_11_76 VPWR VGND sg13cmos5l_fill_1
XFILLER_127_32 VPWR VGND sg13cmos5l_decap_8
XFILLER_127_43 VPWR VGND sg13cmos5l_fill_1
XFILLER_87_14 VPWR VGND sg13cmos5l_decap_8
XFILLER_36_40 VPWR VGND sg13cmos5l_decap_4
XFILLER_61_216 VPWR VGND sg13cmos5l_fill_2
XFILLER_14_198 VPWR VGND sg13cmos5l_decap_8
XFILLER_52_83 VPWR VGND sg13cmos5l_decap_8
X_0670_ _0670_/L_HI VPWR VGND sg13cmos5l_tiehi
X_1084_ _1084_/X _1114_/X Tile_X0Y1_N4END[7] Tile_X0Y0_S1END[3] Tile_X0Y0_S4END[3]
+ _0134_/Q _0133_/Q VPWR VGND sg13cmos5l_mux4_1
X_1222_ _1222_/X Tile_X0Y0_E2MID[4] Tile_X0Y0_E2END[4] Tile_X0Y0_E6END[11] _1095_/X
+ _0296_/Q _0295_/Q VPWR VGND sg13cmos5l_mux4_1
X_1153_ _1153_/X _0650_/Q _1196_/X _1201_/X _1192_/X _0510_/Q _0509_/Q VPWR VGND sg13cmos5l_mux4_1
X_0104_ _0104_/Q Tile_X0Y0_FrameData[20] VGND VPWR Tile_X0Y1_FrameStrobe[0] latch
XANTENNA__0804__X Tile_X0Y0_FrameStrobe_O[1] VPWR VGND sg13cmos5l_antennanp
XFILLER_20_124 VPWR VGND sg13cmos5l_decap_8
XFILLER_20_157 VPWR VGND sg13cmos5l_fill_1
X_0868_ Tile_X0Y0_FrameData_O[12] Tile_X0Y0_FrameData[12] VPWR VGND sg13cmos5l_buf_1
X_0937_ Tile_X0Y1_W2BEGb[0] _1155_/X VPWR VGND sg13cmos5l_buf_1
X_0799_ Tile_X0Y0_N1BEG[0] _0999_/X VPWR VGND sg13cmos5l_buf_1
XFILLER_113_34 VPWR VGND sg13cmos5l_decap_8
XFILLER_113_89 VPWR VGND sg13cmos5l_decap_8
XFILLER_11_146 VPWR VGND sg13cmos5l_fill_1
XFILLER_138_20 VPWR VGND sg13cmos5l_decap_4
XFILLER_138_42 VPWR VGND sg13cmos5l_decap_8
XFILLER_120_210 VPWR VGND sg13cmos5l_decap_8
XFILLER_98_68 VPWR VGND sg13cmos5l_fill_2
XFILLER_98_24 VPWR VGND sg13cmos5l_decap_8
XFILLER_34_216 VPWR VGND sg13cmos5l_fill_2
XFILLER_47_83 VPWR VGND sg13cmos5l_fill_2
XFILLER_78_146 VPWR VGND sg13cmos5l_decap_8
XFILLER_97_7 VPWR VGND sg13cmos5l_decap_8
XFILLER_8_22 VPWR VGND sg13cmos5l_fill_1
XFILLER_10_190 VPWR VGND sg13cmos5l_decap_8
XFILLER_6_161 VPWR VGND sg13cmos5l_decap_8
X_0722_ Tile_X0Y0_W1BEG[3] _1030_/X VPWR VGND sg13cmos5l_buf_1
X_0653_ _0653_/L_HI VPWR VGND sg13cmos5l_tiehi
XFILLER_8_99 VPWR VGND sg13cmos5l_fill_1
XFILLER_111_210 VPWR VGND sg13cmos5l_decap_8
XFILLER_84_105 VPWR VGND sg13cmos5l_decap_8
X_0584_ _0584_/Q Tile_X0Y1_FrameData[18] VGND VPWR Tile_X0Y1_FrameStrobe[7] latch
XFILLER_19_0 VPWR VGND sg13cmos5l_fill_1
X_1067_ _1067_/X _0640_/Q _1084_/X _1080_/X _1092_/X _0194_/Q _0193_/Q VPWR VGND sg13cmos5l_mux4_1
X_1136_ _1136_/X _1207_/X _1211_/X _1215_/X _1199_/X _0542_/Q _0541_/Q VPWR VGND sg13cmos5l_mux4_1
X_1205_ _1205_/X Tile_X0Y1_N1END[2] Tile_X0Y1_N4END[2] _1229_/X Tile_X0Y0_S4END[6]
+ _0398_/Q _0397_/Q VPWR VGND sg13cmos5l_mux4_1
XFILLER_4_109 VPWR VGND sg13cmos5l_decap_8
XFILLER_124_44 VPWR VGND sg13cmos5l_decap_8
XFILLER_17_31 VPWR VGND sg13cmos5l_decap_4
XFILLER_75_127 VPWR VGND sg13cmos5l_decap_8
XFILLER_140_98 VPWR VGND sg13cmos5l_decap_8
XFILLER_17_64 VPWR VGND sg13cmos5l_decap_8
XFILLER_17_75 VPWR VGND sg13cmos5l_decap_8
XFILLER_17_97 VPWR VGND sg13cmos5l_fill_2
XFILLER_83_171 VPWR VGND sg13cmos5l_decap_8
XFILLER_123_0 VPWR VGND sg13cmos5l_decap_8
XFILLER_137_140 VPWR VGND sg13cmos5l_decap_8
XFILLER_3_164 VPWR VGND sg13cmos5l_decap_8
XFILLER_66_127 VPWR VGND sg13cmos5l_decap_8
XFILLER_66_138 VPWR VGND sg13cmos5l_fill_1
XFILLER_74_193 VPWR VGND sg13cmos5l_decap_8
X_0705_ _0973_/A3 VPWR VGND sg13cmos5l_tielo
X_0636_ _0636_/Q Tile_X0Y1_UserCLK NPU_OUT_ACT0 _0664_/L_HI VPWR VGND sg13cmos5l_dfrbpq_1
XFILLER_72_119 VPWR VGND sg13cmos5l_decap_8
X_0567_ _0567_/Q Tile_X0Y1_FrameData[3] VGND VPWR Tile_X0Y1_FrameStrobe[6] latch
X_0498_ _0498_/Q Tile_X0Y1_FrameData[8] VGND VPWR Tile_X0Y1_FrameStrobe[4] latch
XFILLER_110_57 VPWR VGND sg13cmos5l_decap_8
X_1119_ _1119_/X Tile_X0Y1_E1END[1] Tile_X0Y1_EE4END[1] Tile_X0Y1_E6END[9] _1204_/X
+ _0575_/Q _0574_/Q VPWR VGND sg13cmos5l_mux4_1
XFILLER_119_173 VPWR VGND sg13cmos5l_decap_8
XFILLER_134_121 VPWR VGND sg13cmos5l_decap_8
XFILLER_70_28 VPWR VGND sg13cmos5l_decap_8
XFILLER_0_101 VPWR VGND sg13cmos5l_decap_8
XFILLER_134_198 VPWR VGND sg13cmos5l_decap_8
XFILLER_135_21 VPWR VGND sg13cmos5l_decap_8
XFILLER_95_25 VPWR VGND sg13cmos5l_decap_4
XFILLER_28_63 VPWR VGND sg13cmos5l_decap_8
XFILLER_28_74 VPWR VGND sg13cmos5l_fill_2
XFILLER_48_138 VPWR VGND sg13cmos5l_decap_8
XFILLER_95_69 VPWR VGND sg13cmos5l_decap_8
XFILLER_44_84 VPWR VGND sg13cmos5l_decap_8
XFILLER_44_95 VPWR VGND sg13cmos5l_fill_1
XFILLER_71_196 VPWR VGND sg13cmos5l_decap_8
XANTENNA__0902__X Tile_X0Y1_S2BEGb[2] VPWR VGND sg13cmos5l_antennanp
XFILLER_125_110 VPWR VGND sg13cmos5l_decap_8
XFILLER_125_176 VPWR VGND sg13cmos5l_fill_1
XFILLER_5_45 VPWR VGND sg13cmos5l_decap_8
XFILLER_60_83 VPWR VGND sg13cmos5l_decap_4
XFILLER_140_135 VPWR VGND sg13cmos5l_decap_8
XFILLER_39_138 VPWR VGND sg13cmos5l_decap_4
XFILLER_54_108 VPWR VGND sg13cmos5l_decap_8
X_0421_ _0421_/Q Tile_X0Y1_FrameData[21] VGND VPWR Tile_X0Y1_FrameStrobe[2] latch
X_0352_ _0352_/Q Tile_X0Y1_FrameData[26] VGND VPWR Tile_X0Y1_FrameStrobe[0] latch
X_0283_ _0283_/Q Tile_X0Y0_FrameData[1] VGND VPWR Tile_X0Y1_FrameStrobe[5] latch
XFILLER_94_200 VPWR VGND sg13cmos5l_decap_8
XFILLER_62_141 VPWR VGND sg13cmos5l_decap_8
XANTENNA__0812__X Tile_X0Y0_FrameStrobe_O[9] VPWR VGND sg13cmos5l_antennanp
XFILLER_86_0 VPWR VGND sg13cmos5l_fill_1
XFILLER_116_198 VPWR VGND sg13cmos5l_decap_8
XFILLER_131_124 VPWR VGND sg13cmos5l_decap_8
X_0619_ NPU_ACT_WDATA1 Tile_X0Y1_UserCLK _0983_/X _0660_/L_HI VPWR VGND sg13cmos5l_dfrbpq_1
XFILLER_121_89 VPWR VGND sg13cmos5l_fill_2
XFILLER_139_213 VPWR VGND sg13cmos5l_decap_4
XFILLER_14_87 VPWR VGND sg13cmos5l_decap_8
XFILLER_81_49 VPWR VGND sg13cmos5l_decap_8
XANTENNA__0722__X Tile_X0Y0_W1BEG[3] VPWR VGND sg13cmos5l_antennanp
XFILLER_5_204 VPWR VGND sg13cmos5l_fill_2
XFILLER_122_135 VPWR VGND sg13cmos5l_fill_2
XFILLER_44_141 VPWR VGND sg13cmos5l_decap_8
X_0970_ Tile_X0Y1_WW4BEG[13] _1176_/X VPWR VGND sg13cmos5l_buf_1
XFILLER_113_102 VPWR VGND sg13cmos5l_decap_8
XFILLER_58_4 VPWR VGND sg13cmos5l_fill_2
X_0404_ _0404_/Q Tile_X0Y1_FrameData[6] VGND VPWR Tile_X0Y1_FrameStrobe[1] latch
XANTENNA__0807__X Tile_X0Y0_FrameStrobe_O[4] VPWR VGND sg13cmos5l_antennanp
X_0335_ _0335_/Q Tile_X0Y0_FrameData[13] VGND VPWR Tile_X0Y1_FrameStrobe[7] latch
X_0266_ _0266_/Q Tile_X0Y0_FrameData[18] VGND VPWR Tile_X0Y1_FrameStrobe[5] latch
XFILLER_96_90 VPWR VGND sg13cmos5l_fill_2
XFILLER_35_174 VPWR VGND sg13cmos5l_decap_8
X_0197_ _0197_/Q Tile_X0Y0_FrameData[23] VGND VPWR Tile_X0Y1_FrameStrobe[3] latch
XFILLER_116_56 VPWR VGND sg13cmos5l_decap_8
XFILLER_132_11 VPWR VGND sg13cmos5l_decap_4
XFILLER_26_185 VPWR VGND sg13cmos5l_decap_8
XFILLER_26_196 VPWR VGND sg13cmos5l_fill_1
XFILLER_41_100 VPWR VGND sg13cmos5l_decap_8
XFILLER_92_48 VPWR VGND sg13cmos5l_decap_8
XFILLER_25_86 VPWR VGND sg13cmos5l_fill_2
XFILLER_41_133 VPWR VGND sg13cmos5l_fill_1
XFILLER_110_149 VPWR VGND sg13cmos5l_decap_4
XFILLER_17_130 VPWR VGND sg13cmos5l_decap_8
X_0120_ _0120_/Q Tile_X0Y0_FrameData[4] VGND VPWR Tile_X0Y1_FrameStrobe[0] latch
XANTENNA_18 Tile_X0Y0_S2MID[4] VPWR VGND sg13cmos5l_antennanp
XANTENNA_29 Tile_X0Y0_S2MID[7] VPWR VGND sg13cmos5l_antennanp
XFILLER_118_205 VPWR VGND sg13cmos5l_decap_8
XFILLER_118_216 VPWR VGND sg13cmos5l_fill_2
X_0884_ Tile_X0Y0_FrameData_O[28] Tile_X0Y0_FrameData[28] VPWR VGND sg13cmos5l_buf_1
X_0953_ Tile_X0Y1_W6BEG[8] _1187_/X VPWR VGND sg13cmos5l_buf_1
XFILLER_99_100 VPWR VGND sg13cmos5l_decap_8
XFILLER_49_0 VPWR VGND sg13cmos5l_fill_1
XFILLER_99_188 VPWR VGND sg13cmos5l_fill_1
XFILLER_102_14 VPWR VGND sg13cmos5l_fill_2
XFILLER_23_122 VPWR VGND sg13cmos5l_decap_8
XFILLER_55_203 VPWR VGND sg13cmos5l_decap_8
XFILLER_70_217 VPWR VGND sg13cmos5l_fill_1
X_0318_ _0318_/Q Tile_X0Y0_FrameData[30] VGND VPWR Tile_X0Y1_FrameStrobe[7] latch
X_0249_ _0249_/Q Tile_X0Y0_FrameData[3] VGND VPWR Tile_X0Y1_FrameStrobe[4] latch
XFILLER_127_7 VPWR VGND sg13cmos5l_fill_1
XFILLER_127_11 VPWR VGND sg13cmos5l_decap_8
XFILLER_100_182 VPWR VGND sg13cmos5l_decap_8
XFILLER_14_177 VPWR VGND sg13cmos5l_decap_8
XANTENNA__0910__X Tile_X0Y1_S4BEG[2] VPWR VGND sg13cmos5l_antennanp
XFILLER_52_62 VPWR VGND sg13cmos5l_decap_8
XFILLER_77_81 VPWR VGND sg13cmos5l_decap_4
X_1221_ _1221_/X Tile_X0Y0_E2MID[5] Tile_X0Y0_E2END[5] Tile_X0Y0_E6END[10] _1094_/X
+ _0298_/Q _0297_/Q VPWR VGND sg13cmos5l_mux4_1
XFILLER_96_169 VPWR VGND sg13cmos5l_decap_8
XFILLER_52_217 VPWR VGND sg13cmos5l_fill_1
X_1083_ _1083_/X _1111_/X Tile_X0Y1_N4END[4] Tile_X0Y0_S1END[0] Tile_X0Y0_S4END[0]
+ _0132_/Q _0131_/Q VPWR VGND sg13cmos5l_mux4_1
X_1152_ _1152_/X _0649_/Q _1197_/X _1200_/X _1191_/X _0512_/Q _0511_/Q VPWR VGND sg13cmos5l_mux4_1
X_0103_ _0103_/Q Tile_X0Y0_FrameData[21] VGND VPWR Tile_X0Y1_FrameStrobe[0] latch
X_0936_ Tile_X0Y1_W2BEG[7] _1154_/X VPWR VGND sg13cmos5l_buf_1
XANTENNA__0820__X Tile_X0Y0_FrameStrobe_O[17] VPWR VGND sg13cmos5l_antennanp
X_0867_ Tile_X0Y0_FrameData_O[11] Tile_X0Y0_FrameData[11] VPWR VGND sg13cmos5l_buf_1
X_0798_ Tile_X0Y0_N2BEG[7] _1010_/X VPWR VGND sg13cmos5l_buf_1
XFILLER_9_192 VPWR VGND sg13cmos5l_decap_8
XFILLER_113_13 VPWR VGND sg13cmos5l_decap_8
XFILLER_87_147 VPWR VGND sg13cmos5l_decap_8
XFILLER_43_217 VPWR VGND sg13cmos5l_fill_1
XANTENNA__0730__X Tile_X0Y0_W2BEG[7] VPWR VGND sg13cmos5l_antennanp
XFILLER_11_125 VPWR VGND sg13cmos5l_decap_8
XFILLER_7_129 VPWR VGND sg13cmos5l_decap_8
XFILLER_138_98 VPWR VGND sg13cmos5l_decap_8
XFILLER_78_125 VPWR VGND sg13cmos5l_decap_8
XFILLER_78_169 VPWR VGND sg13cmos5l_decap_8
XFILLER_93_139 VPWR VGND sg13cmos5l_decap_8
XANTENNA__0905__X Tile_X0Y1_S2BEGb[5] VPWR VGND sg13cmos5l_antennanp
XFILLER_8_34 VPWR VGND sg13cmos5l_fill_2
XFILLER_6_140 VPWR VGND sg13cmos5l_decap_8
X_0721_ Tile_X0Y0_W1BEG[2] _1029_/X VPWR VGND sg13cmos5l_buf_1
X_0652_ _0652_/L_HI VPWR VGND sg13cmos5l_tiehi
X_0583_ _0583_/Q Tile_X0Y1_FrameData[19] VGND VPWR Tile_X0Y1_FrameStrobe[7] latch
XFILLER_8_89 VPWR VGND sg13cmos5l_fill_1
XFILLER_8_78 VPWR VGND sg13cmos5l_fill_1
XFILLER_111_200 VPWR VGND sg13cmos5l_decap_8
XFILLER_69_125 VPWR VGND sg13cmos5l_decap_4
X_1204_ _1204_/X Tile_X0Y1_N1END[1] Tile_X0Y1_N4END[1] _1228_/X Tile_X0Y0_S4END[5]
+ _0400_/Q _0399_/Q VPWR VGND sg13cmos5l_mux4_1
XFILLER_88_91 VPWR VGND sg13cmos5l_decap_4
XANTENNA__0815__X Tile_X0Y0_FrameStrobe_O[12] VPWR VGND sg13cmos5l_antennanp
XFILLER_25_206 VPWR VGND sg13cmos5l_fill_1
XFILLER_25_217 VPWR VGND sg13cmos5l_fill_1
X_1066_ _1066_/X Tile_X0Y1_N4END[7] Tile_X0Y0_S4END[3] _1083_/X _1075_/X _0196_/Q
+ _0195_/Q VPWR VGND sg13cmos5l_mux4_1
X_1135_ _1135_/X Tile_X0Y1_E1END[0] Tile_X0Y1_EE4END[12] Tile_X0Y1_E6END[4] _1203_/X
+ _0542_/Q _0541_/Q VPWR VGND sg13cmos5l_mux4_1
XFILLER_92_194 VPWR VGND sg13cmos5l_decap_8
XFILLER_138_119 VPWR VGND sg13cmos5l_decap_8
X_0919_ Tile_X0Y1_S4BEG[11] _0919_/A VPWR VGND sg13cmos5l_buf_1
XFILLER_102_200 VPWR VGND sg13cmos5l_decap_8
XFILLER_108_46 VPWR VGND sg13cmos5l_decap_8
XFILLER_68_28 VPWR VGND sg13cmos5l_fill_2
XFILLER_16_217 VPWR VGND sg13cmos5l_fill_1
XFILLER_83_150 VPWR VGND sg13cmos5l_decap_8
XANTENNA__0725__X Tile_X0Y0_W2BEG[2] VPWR VGND sg13cmos5l_antennanp
XFILLER_116_0 VPWR VGND sg13cmos5l_fill_2
XFILLER_66_106 VPWR VGND sg13cmos5l_decap_8
XFILLER_74_172 VPWR VGND sg13cmos5l_decap_8
XFILLER_90_81 VPWR VGND sg13cmos5l_decap_8
XFILLER_128_185 VPWR VGND sg13cmos5l_decap_8
XFILLER_31_0 VPWR VGND sg13cmos5l_decap_8
X_0704_ _1235_/A3 VPWR VGND sg13cmos5l_tielo
X_0635_ NPU_WEIGHT_SHIFT_EN Tile_X0Y1_UserCLK _1234_/X _0665_/L_HI VPWR VGND sg13cmos5l_dfrbpq_1
X_0566_ _0566_/Q Tile_X0Y1_FrameData[4] VGND VPWR Tile_X0Y1_FrameStrobe[6] latch
XFILLER_57_106 VPWR VGND sg13cmos5l_decap_8
XFILLER_65_183 VPWR VGND sg13cmos5l_decap_4
X_0497_ _0497_/Q Tile_X0Y1_FrameData[9] VGND VPWR Tile_X0Y1_FrameStrobe[4] latch
XFILLER_110_36 VPWR VGND sg13cmos5l_decap_8
XFILLER_80_142 VPWR VGND sg13cmos5l_decap_8
X_1049_ _1049_/X _0638_/Q _0642_/Q _1076_/X _1097_/X _0230_/Q _0229_/Q VPWR VGND sg13cmos5l_mux4_1
X_1118_ _1118_/X _1209_/X _1213_/X _1217_/X _1197_/X _0572_/Q _0571_/Q VPWR VGND sg13cmos5l_mux4_1
XFILLER_119_152 VPWR VGND sg13cmos5l_decap_8
XFILLER_134_100 VPWR VGND sg13cmos5l_decap_8
XFILLER_0_157 VPWR VGND sg13cmos5l_fill_2
XFILLER_134_177 VPWR VGND sg13cmos5l_decap_8
XFILLER_135_88 VPWR VGND sg13cmos5l_decap_8
XFILLER_28_20 VPWR VGND sg13cmos5l_fill_1
XFILLER_48_117 VPWR VGND sg13cmos5l_decap_8
XFILLER_95_37 VPWR VGND sg13cmos5l_fill_2
XFILLER_28_42 VPWR VGND sg13cmos5l_decap_8
XFILLER_71_175 VPWR VGND sg13cmos5l_decap_8
XFILLER_100_80 VPWR VGND sg13cmos5l_fill_2
XFILLER_44_63 VPWR VGND sg13cmos5l_decap_8
XFILLER_60_40 VPWR VGND sg13cmos5l_decap_8
XFILLER_125_166 VPWR VGND sg13cmos5l_fill_2
XFILLER_125_188 VPWR VGND sg13cmos5l_decap_8
XFILLER_60_95 VPWR VGND sg13cmos5l_decap_8
X_0420_ _0420_/Q Tile_X0Y1_FrameData[22] VGND VPWR Tile_X0Y1_FrameStrobe[2] latch
XFILLER_39_106 VPWR VGND sg13cmos5l_decap_8
X_0351_ _0351_/Q Tile_X0Y1_FrameData[27] VGND VPWR Tile_X0Y1_FrameStrobe[0] latch
X_0282_ _0282_/Q Tile_X0Y0_FrameData[2] VGND VPWR Tile_X0Y1_FrameStrobe[5] latch
XFILLER_79_0 VPWR VGND sg13cmos5l_fill_2
XFILLER_105_47 VPWR VGND sg13cmos5l_decap_8
XFILLER_116_177 VPWR VGND sg13cmos5l_decap_8
XFILLER_131_103 VPWR VGND sg13cmos5l_decap_8
X_0618_ NPU_ACT_WDATA0 Tile_X0Y1_UserCLK _0982_/X _0681_/L_HI VPWR VGND sg13cmos5l_dfrbpq_1
X_0549_ _0549_/Q Tile_X0Y1_FrameData[21] VGND VPWR Tile_X0Y1_FrameStrobe[6] latch
XFILLER_53_142 VPWR VGND sg13cmos5l_decap_8
XFILLER_139_203 VPWR VGND sg13cmos5l_fill_1
XFILLER_14_33 VPWR VGND sg13cmos5l_decap_8
XFILLER_81_28 VPWR VGND sg13cmos5l_decap_8
XFILLER_107_122 VPWR VGND sg13cmos5l_decap_4
XFILLER_107_166 VPWR VGND sg13cmos5l_decap_8
XFILLER_107_199 VPWR VGND sg13cmos5l_fill_1
XFILLER_122_147 VPWR VGND sg13cmos5l_fill_1
XFILLER_30_65 VPWR VGND sg13cmos5l_fill_2
XFILLER_130_191 VPWR VGND sg13cmos5l_decap_8
XFILLER_39_85 VPWR VGND sg13cmos5l_decap_8
XFILLER_44_120 VPWR VGND sg13cmos5l_decap_8
XFILLER_44_197 VPWR VGND sg13cmos5l_decap_8
XANTENNA__0913__X Tile_X0Y1_S4BEG[5] VPWR VGND sg13cmos5l_antennanp
XFILLER_113_158 VPWR VGND sg13cmos5l_decap_8
X_0403_ _0403_/Q Tile_X0Y1_FrameData[7] VGND VPWR Tile_X0Y1_FrameStrobe[1] latch
XFILLER_27_109 VPWR VGND sg13cmos5l_fill_1
XFILLER_35_153 VPWR VGND sg13cmos5l_decap_8
XFILLER_82_204 VPWR VGND sg13cmos5l_decap_8
X_0334_ _0334_/Q Tile_X0Y0_FrameData[14] VGND VPWR Tile_X0Y1_FrameStrobe[7] latch
X_0265_ _0265_/Q Tile_X0Y0_FrameData[19] VGND VPWR Tile_X0Y1_FrameStrobe[5] latch
X_0196_ _0196_/Q Tile_X0Y0_FrameData[24] VGND VPWR Tile_X0Y1_FrameStrobe[3] latch
XANTENNA__0823__X FAB_USER_CLK VPWR VGND sg13cmos5l_antennanp
XFILLER_136_206 VPWR VGND sg13cmos5l_decap_8
XFILLER_50_145 VPWR VGND sg13cmos5l_decap_4
XFILLER_116_13 VPWR VGND sg13cmos5l_decap_4
XFILLER_136_217 VPWR VGND sg13cmos5l_fill_1
XFILLER_112_180 VPWR VGND sg13cmos5l_decap_8
XFILLER_116_35 VPWR VGND sg13cmos5l_decap_8
XFILLER_26_120 VPWR VGND sg13cmos5l_fill_2
XFILLER_41_112 VPWR VGND sg13cmos5l_decap_4
XFILLER_41_145 VPWR VGND sg13cmos5l_decap_4
XFILLER_92_27 VPWR VGND sg13cmos5l_decap_8
XANTENNA__0733__X Tile_X0Y0_W2BEGb[2] VPWR VGND sg13cmos5l_antennanp
XFILLER_127_217 VPWR VGND sg13cmos5l_fill_1
XFILLER_41_53 VPWR VGND sg13cmos5l_decap_8
XFILLER_110_106 VPWR VGND sg13cmos5l_decap_4
XFILLER_2_14 VPWR VGND sg13cmos5l_decap_8
XFILLER_9_0 VPWR VGND sg13cmos5l_decap_4
XANTENNA__0908__X Tile_X0Y1_S4BEG[0] VPWR VGND sg13cmos5l_antennanp
XFILLER_2_58 VPWR VGND sg13cmos5l_fill_1
XFILLER_66_50 VPWR VGND sg13cmos5l_decap_8
XANTENNA_19 Tile_X0Y0_S2MID[4] VPWR VGND sg13cmos5l_antennanp
XFILLER_32_189 VPWR VGND sg13cmos5l_fill_1
XFILLER_82_93 VPWR VGND sg13cmos5l_decap_8
X_0952_ Tile_X0Y1_W6BEG[7] _1186_/X VPWR VGND sg13cmos5l_buf_1
X_0883_ Tile_X0Y0_FrameData_O[27] Tile_X0Y0_FrameData[27] VPWR VGND sg13cmos5l_buf_1
XANTENNA__0818__X Tile_X0Y0_FrameStrobe_O[15] VPWR VGND sg13cmos5l_antennanp
X_0317_ _0317_/Q Tile_X0Y0_FrameData[31] VGND VPWR Tile_X0Y1_FrameStrobe[7] latch
XFILLER_102_48 VPWR VGND sg13cmos5l_decap_8
X_0248_ _0248_/Q Tile_X0Y0_FrameData[4] VGND VPWR Tile_X0Y1_FrameStrobe[4] latch
X_0179_ _0179_/Q Tile_X0Y0_FrameData[9] VGND VPWR Tile_X0Y1_FrameStrobe[2] latch
XFILLER_109_217 VPWR VGND sg13cmos5l_fill_1
XFILLER_23_178 VPWR VGND sg13cmos5l_decap_8
XFILLER_23_189 VPWR VGND sg13cmos5l_fill_1
XFILLER_11_45 VPWR VGND sg13cmos5l_decap_8
XFILLER_11_67 VPWR VGND sg13cmos5l_decap_8
XFILLER_2_7 VPWR VGND sg13cmos5l_decap_8
XFILLER_87_49 VPWR VGND sg13cmos5l_decap_8
XANTENNA__0728__X Tile_X0Y0_W2BEG[5] VPWR VGND sg13cmos5l_antennanp
XFILLER_36_53 VPWR VGND sg13cmos5l_decap_8
XFILLER_14_101 VPWR VGND sg13cmos5l_decap_4
XFILLER_14_156 VPWR VGND sg13cmos5l_decap_8
XFILLER_52_41 VPWR VGND sg13cmos5l_decap_8
XFILLER_35_7 VPWR VGND sg13cmos5l_fill_1
X_1220_ _1220_/X Tile_X0Y0_E2MID[6] Tile_X0Y0_E2END[6] Tile_X0Y0_E6END[9] _1093_/X
+ _0300_/Q _0299_/Q VPWR VGND sg13cmos5l_mux4_1
X_1151_ _1151_/X Tile_X0Y1_EE4END[8] _0648_/Q _1198_/X _1199_/X _0514_/Q _0513_/Q
+ VPWR VGND sg13cmos5l_mux4_1
XFILLER_96_148 VPWR VGND sg13cmos5l_decap_8
X_1082_ _1082_/X _1112_/X Tile_X0Y1_N4END[5] Tile_X0Y0_S1END[1] Tile_X0Y0_S4END[1]
+ _0130_/Q _0129_/Q VPWR VGND sg13cmos5l_mux4_1
X_0102_ _0102_/Q Tile_X0Y0_FrameData[22] VGND VPWR Tile_X0Y1_FrameStrobe[0] latch
X_0866_ Tile_X0Y0_FrameData_O[10] Tile_X0Y0_FrameData[10] VPWR VGND sg13cmos5l_buf_1
X_0935_ Tile_X0Y1_W2BEG[6] _1153_/X VPWR VGND sg13cmos5l_buf_1
XFILLER_9_171 VPWR VGND sg13cmos5l_decap_8
XFILLER_61_0 VPWR VGND sg13cmos5l_fill_1
XFILLER_87_126 VPWR VGND sg13cmos5l_decap_8
X_0797_ Tile_X0Y0_N2BEG[6] _1009_/X VPWR VGND sg13cmos5l_buf_1
XFILLER_113_69 VPWR VGND sg13cmos5l_fill_2
XFILLER_28_215 VPWR VGND sg13cmos5l_fill_2
XFILLER_95_192 VPWR VGND sg13cmos5l_fill_2
XFILLER_11_104 VPWR VGND sg13cmos5l_decap_8
XFILLER_138_33 VPWR VGND sg13cmos5l_decap_4
XFILLER_138_77 VPWR VGND sg13cmos5l_decap_8
XFILLER_22_88 VPWR VGND sg13cmos5l_decap_8
XFILLER_7_108 VPWR VGND sg13cmos5l_decap_8
XFILLER_98_59 VPWR VGND sg13cmos5l_decap_4
XFILLER_47_41 VPWR VGND sg13cmos5l_decap_8
XFILLER_47_85 VPWR VGND sg13cmos5l_fill_1
XANTENNA__0921__X Tile_X0Y1_S4BEG[13] VPWR VGND sg13cmos5l_antennanp
X_0720_ Tile_X0Y0_W1BEG[1] _1028_/X VPWR VGND sg13cmos5l_buf_1
XFILLER_69_104 VPWR VGND sg13cmos5l_decap_8
XFILLER_6_196 VPWR VGND sg13cmos5l_decap_8
X_0651_ _0651_/Q Tile_X0Y1_UserCLK NPU_ACT_RDATA7 _0659_/L_HI VPWR VGND sg13cmos5l_dfrbpq_1
X_0582_ _0582_/Q Tile_X0Y1_FrameData[20] VGND VPWR Tile_X0Y1_FrameStrobe[7] latch
X_1134_ _1134_/X Tile_X0Y1_E1END[3] Tile_X0Y1_E2MID[0] Tile_X0Y1_E2END[0] _1202_/X
+ _0544_/Q _0543_/Q VPWR VGND sg13cmos5l_mux4_1
X_1203_ _1203_/X Tile_X0Y1_N1END[0] Tile_X0Y1_N4END[0] _1227_/X Tile_X0Y0_S4END[4]
+ _0402_/Q _0401_/Q VPWR VGND sg13cmos5l_mux4_1
X_1065_ _1065_/X Tile_X0Y1_N4END[6] Tile_X0Y0_S4END[2] _1082_/X _1076_/X _0198_/Q
+ _0197_/Q VPWR VGND sg13cmos5l_mux4_1
XFILLER_92_173 VPWR VGND sg13cmos5l_decap_8
XANTENNA__0831__X Tile_X0Y1_FrameData_O[7] VPWR VGND sg13cmos5l_antennanp
XFILLER_108_25 VPWR VGND sg13cmos5l_decap_8
X_0918_ Tile_X0Y1_S4BEG[10] _0918_/A VPWR VGND sg13cmos5l_buf_1
X_0849_ Tile_X0Y1_FrameData_O[25] Tile_X0Y1_FrameData[25] VPWR VGND sg13cmos5l_buf_1
XANTENNA__0741__X Tile_X0Y0_W6BEG[2] VPWR VGND sg13cmos5l_antennanp
XFILLER_33_32 VPWR VGND sg13cmos5l_fill_2
XFILLER_33_98 VPWR VGND sg13cmos5l_decap_8
XFILLER_109_0 VPWR VGND sg13cmos5l_decap_8
XFILLER_137_175 VPWR VGND sg13cmos5l_fill_2
XFILLER_3_155 VPWR VGND sg13cmos5l_decap_4
XFILLER_3_199 VPWR VGND sg13cmos5l_decap_8
XANTENNA__0916__X Tile_X0Y1_S4BEG[8] VPWR VGND sg13cmos5l_antennanp
XFILLER_74_151 VPWR VGND sg13cmos5l_decap_8
XFILLER_128_164 VPWR VGND sg13cmos5l_decap_8
X_0703_ _1100_/A3 VPWR VGND sg13cmos5l_tielo
XFILLER_90_93 VPWR VGND sg13cmos5l_decap_8
XFILLER_90_60 VPWR VGND sg13cmos5l_decap_8
XFILLER_24_0 VPWR VGND sg13cmos5l_decap_4
X_0634_ NPU_ACT_ADDR8 Tile_X0Y1_UserCLK _0981_/X _0666_/L_HI VPWR VGND sg13cmos5l_dfrbpq_1
X_0565_ _0565_/Q Tile_X0Y1_FrameData[5] VGND VPWR Tile_X0Y1_FrameStrobe[6] latch
X_0496_ _0496_/Q Tile_X0Y1_FrameData[10] VGND VPWR Tile_X0Y1_FrameStrobe[4] latch
XFILLER_97_210 VPWR VGND sg13cmos5l_decap_8
XANTENNA__0826__X Tile_X0Y1_FrameData_O[2] VPWR VGND sg13cmos5l_antennanp
XFILLER_0_80 VPWR VGND sg13cmos5l_decap_8
XFILLER_80_121 VPWR VGND sg13cmos5l_decap_8
X_1117_ _1117_/X Tile_X0Y1_E1END[2] Tile_X0Y1_EE4END[2] Tile_X0Y1_E6END[10] _1205_/X
+ _0572_/Q _0571_/Q VPWR VGND sg13cmos5l_mux4_1
XFILLER_80_198 VPWR VGND sg13cmos5l_decap_8
X_1048_ _1048_/X _0637_/Q _0641_/Q _1077_/X _1098_/X _0232_/Q _0231_/Q VPWR VGND sg13cmos5l_mux4_1
XFILLER_119_35 VPWR VGND sg13cmos5l_fill_2
XFILLER_134_156 VPWR VGND sg13cmos5l_decap_8
XFILLER_0_136 VPWR VGND sg13cmos5l_decap_8
XFILLER_0_169 VPWR VGND sg13cmos5l_decap_8
XFILLER_135_67 VPWR VGND sg13cmos5l_decap_8
XANTENNA__0736__X Tile_X0Y0_W2BEGb[5] VPWR VGND sg13cmos5l_antennanp
XFILLER_12_210 VPWR VGND sg13cmos5l_decap_8
XFILLER_44_42 VPWR VGND sg13cmos5l_decap_8
XFILLER_71_154 VPWR VGND sg13cmos5l_decap_8
XFILLER_125_145 VPWR VGND sg13cmos5l_decap_8
XFILLER_5_36 VPWR VGND sg13cmos5l_fill_1
XFILLER_79_210 VPWR VGND sg13cmos5l_decap_8
X_0350_ _0350_/Q Tile_X0Y1_FrameData[28] VGND VPWR Tile_X0Y1_FrameStrobe[0] latch
XFILLER_47_184 VPWR VGND sg13cmos5l_decap_8
X_0281_ _0281_/Q Tile_X0Y0_FrameData[3] VGND VPWR Tile_X0Y1_FrameStrobe[5] latch
XFILLER_116_134 VPWR VGND sg13cmos5l_decap_8
XFILLER_105_26 VPWR VGND sg13cmos5l_decap_8
XFILLER_131_159 VPWR VGND sg13cmos5l_decap_8
X_0617_ NPU_WEIGHT_IN7 Tile_X0Y1_UserCLK _0997_/X _0680_/L_HI VPWR VGND sg13cmos5l_dfrbpq_1
X_0548_ _0548_/Q Tile_X0Y1_FrameData[22] VGND VPWR Tile_X0Y1_FrameStrobe[6] latch
X_0479_ _0479_/Q Tile_X0Y1_FrameData[27] VGND VPWR Tile_X0Y1_FrameStrobe[4] latch
XFILLER_121_36 VPWR VGND sg13cmos5l_decap_8
XFILLER_53_121 VPWR VGND sg13cmos5l_decap_8
XFILLER_14_45 VPWR VGND sg13cmos5l_decap_8
XFILLER_5_206 VPWR VGND sg13cmos5l_fill_1
XFILLER_5_217 VPWR VGND sg13cmos5l_fill_1
XFILLER_107_156 VPWR VGND sg13cmos5l_fill_2
XFILLER_107_178 VPWR VGND sg13cmos5l_decap_8
XFILLER_122_137 VPWR VGND sg13cmos5l_fill_1
XFILLER_122_159 VPWR VGND sg13cmos5l_decap_8
XFILLER_30_99 VPWR VGND sg13cmos5l_decap_8
XFILLER_130_170 VPWR VGND sg13cmos5l_decap_8
XFILLER_39_53 VPWR VGND sg13cmos5l_decap_8
XFILLER_39_64 VPWR VGND sg13cmos5l_decap_8
XFILLER_55_30 VPWR VGND sg13cmos5l_decap_8
XFILLER_55_52 VPWR VGND sg13cmos5l_decap_8
XFILLER_76_213 VPWR VGND sg13cmos5l_decap_4
XFILLER_44_176 VPWR VGND sg13cmos5l_decap_8
XFILLER_65_7 VPWR VGND sg13cmos5l_decap_8
XFILLER_71_84 VPWR VGND sg13cmos5l_decap_8
XFILLER_113_137 VPWR VGND sg13cmos5l_decap_8
XFILLER_121_181 VPWR VGND sg13cmos5l_decap_8
X_0402_ _0402_/Q Tile_X0Y1_FrameData[8] VGND VPWR Tile_X0Y1_FrameStrobe[1] latch
X_0333_ _0333_/Q Tile_X0Y0_FrameData[15] VGND VPWR Tile_X0Y1_FrameStrobe[7] latch
XFILLER_35_132 VPWR VGND sg13cmos5l_decap_8
X_0264_ _0264_/Q Tile_X0Y0_FrameData[20] VGND VPWR Tile_X0Y1_FrameStrobe[5] latch
X_0195_ _0195_/Q Tile_X0Y0_FrameData[25] VGND VPWR Tile_X0Y1_FrameStrobe[3] latch
XFILLER_91_0 VPWR VGND sg13cmos5l_decap_8
XFILLER_104_126 VPWR VGND sg13cmos5l_decap_8
XFILLER_58_213 VPWR VGND sg13cmos5l_decap_4
XFILLER_25_88 VPWR VGND sg13cmos5l_fill_1
XFILLER_26_143 VPWR VGND sg13cmos5l_decap_8
XFILLER_26_165 VPWR VGND sg13cmos5l_decap_8
XFILLER_41_124 VPWR VGND sg13cmos5l_fill_1
XFILLER_103_181 VPWR VGND sg13cmos5l_decap_8
XFILLER_49_202 VPWR VGND sg13cmos5l_decap_4
XFILLER_17_121 VPWR VGND sg13cmos5l_decap_4
XFILLER_32_102 VPWR VGND sg13cmos5l_decap_4
XANTENNA__0924__X Tile_X0Y1_UserCLKo VPWR VGND sg13cmos5l_antennanp
XFILLER_17_198 VPWR VGND sg13cmos5l_fill_2
XFILLER_32_135 VPWR VGND sg13cmos5l_decap_8
XFILLER_32_168 VPWR VGND sg13cmos5l_decap_8
XFILLER_82_72 VPWR VGND sg13cmos5l_decap_8
X_0882_ Tile_X0Y0_FrameData_O[26] Tile_X0Y0_FrameData[26] VPWR VGND sg13cmos5l_buf_1
X_0951_ Tile_X0Y1_W6BEG[6] _1185_/X VPWR VGND sg13cmos5l_buf_1
XFILLER_99_157 VPWR VGND sg13cmos5l_decap_8
X_0316_ _0316_/Q Tile_X0Y0_FrameData[0] VGND VPWR Tile_X0Y1_FrameStrobe[6] latch
XFILLER_99_179 VPWR VGND sg13cmos5l_decap_8
XANTENNA__0834__X Tile_X0Y1_FrameData_O[10] VPWR VGND sg13cmos5l_antennanp
XFILLER_102_27 VPWR VGND sg13cmos5l_decap_8
XFILLER_23_157 VPWR VGND sg13cmos5l_decap_8
X_0247_ _0247_/Q Tile_X0Y0_FrameData[5] VGND VPWR Tile_X0Y1_FrameStrobe[4] latch
X_0178_ _0178_/Q Tile_X0Y0_FrameData[10] VGND VPWR Tile_X0Y1_FrameStrobe[2] latch
XFILLER_87_28 VPWR VGND sg13cmos5l_decap_8
XFILLER_100_140 VPWR VGND sg13cmos5l_decap_8
XFILLER_46_205 VPWR VGND sg13cmos5l_fill_2
XANTENNA__0744__X Tile_X0Y0_W6BEG[5] VPWR VGND sg13cmos5l_antennanp
XFILLER_139_0 VPWR VGND sg13cmos5l_fill_2
XFILLER_14_135 VPWR VGND sg13cmos5l_decap_8
XFILLER_52_97 VPWR VGND sg13cmos5l_decap_8
XFILLER_123_210 VPWR VGND sg13cmos5l_decap_8
XANTENNA__0919__X Tile_X0Y1_S4BEG[11] VPWR VGND sg13cmos5l_antennanp
X_1150_ _1150_/X Tile_X0Y1_EE4END[4] _0647_/Q _1198_/X _1199_/X _0516_/Q _0515_/Q
+ VPWR VGND sg13cmos5l_mux4_1
X_0101_ _0101_/Q Tile_X0Y0_FrameData[23] VGND VPWR Tile_X0Y1_FrameStrobe[0] latch
XFILLER_96_127 VPWR VGND sg13cmos5l_decap_8
X_1081_ _1081_/X _1113_/X Tile_X0Y1_N4END[6] Tile_X0Y0_S1END[2] Tile_X0Y0_S4END[2]
+ _0128_/Q _0127_/Q VPWR VGND sg13cmos5l_mux4_1
XFILLER_13_190 VPWR VGND sg13cmos5l_decap_8
X_0865_ Tile_X0Y0_FrameData_O[9] Tile_X0Y0_FrameData[9] VPWR VGND sg13cmos5l_buf_1
X_0934_ Tile_X0Y1_W2BEG[5] _1152_/X VPWR VGND sg13cmos5l_buf_1
XFILLER_9_150 VPWR VGND sg13cmos5l_decap_8
XANTENNA__0829__X Tile_X0Y1_FrameData_O[5] VPWR VGND sg13cmos5l_antennanp
XFILLER_54_0 VPWR VGND sg13cmos5l_decap_8
XFILLER_87_105 VPWR VGND sg13cmos5l_decap_8
X_0796_ Tile_X0Y0_N2BEG[5] _1008_/X VPWR VGND sg13cmos5l_buf_1
XFILLER_113_48 VPWR VGND sg13cmos5l_decap_8
XFILLER_3_91 VPWR VGND sg13cmos5l_decap_8
XFILLER_43_208 VPWR VGND sg13cmos5l_decap_8
XFILLER_132_7 VPWR VGND sg13cmos5l_fill_1
XFILLER_105_210 VPWR VGND sg13cmos5l_decap_8
XFILLER_138_56 VPWR VGND sg13cmos5l_decap_8
XFILLER_22_45 VPWR VGND sg13cmos5l_decap_8
XFILLER_98_38 VPWR VGND sg13cmos5l_decap_8
XANTENNA__0739__X Tile_X0Y0_W6BEG[0] VPWR VGND sg13cmos5l_antennanp
XFILLER_47_20 VPWR VGND sg13cmos5l_decap_8
XFILLER_86_160 VPWR VGND sg13cmos5l_decap_8
XFILLER_86_182 VPWR VGND sg13cmos5l_decap_8
XFILLER_103_92 VPWR VGND sg13cmos5l_decap_8
XFILLER_63_30 VPWR VGND sg13cmos5l_fill_1
XFILLER_63_85 VPWR VGND sg13cmos5l_decap_8
XFILLER_6_175 VPWR VGND sg13cmos5l_decap_8
X_0650_ _0650_/Q Tile_X0Y1_UserCLK NPU_ACT_RDATA6 _0658_/L_HI VPWR VGND sg13cmos5l_dfrbpq_1
X_0581_ _0581_/Q Tile_X0Y1_FrameData[21] VGND VPWR Tile_X0Y1_FrameStrobe[7] latch
XFILLER_26_4 VPWR VGND sg13cmos5l_fill_2
XFILLER_77_193 VPWR VGND sg13cmos5l_decap_4
XFILLER_84_119 VPWR VGND sg13cmos5l_decap_8
X_1064_ _1064_/X Tile_X0Y1_N4END[5] Tile_X0Y0_S4END[1] _1081_/X _1077_/X _0200_/Q
+ _0199_/Q VPWR VGND sg13cmos5l_mux4_1
X_1133_ _1133_/X Tile_X0Y1_E1END[2] Tile_X0Y1_E2MID[1] Tile_X0Y1_E2END[1] _1201_/X
+ _0546_/Q _0545_/Q VPWR VGND sg13cmos5l_mux4_1
X_1202_ _1202_/X Tile_X0Y1_N2MID[7] Tile_X0Y1_N2END[7] _1226_/X Tile_X0Y0_S2MID[7]
+ _0356_/Q _0355_/Q VPWR VGND sg13cmos5l_mux4_1
XFILLER_92_152 VPWR VGND sg13cmos5l_decap_8
X_0917_ Tile_X0Y1_S4BEG[9] _0917_/A VPWR VGND sg13cmos5l_buf_1
X_0848_ Tile_X0Y1_FrameData_O[24] Tile_X0Y1_FrameData[24] VPWR VGND sg13cmos5l_buf_1
X_0779_ Tile_X0Y0_WW4BEG[12] _1059_/X VPWR VGND sg13cmos5l_buf_1
XFILLER_124_58 VPWR VGND sg13cmos5l_decap_8
XFILLER_84_29 VPWR VGND sg13cmos5l_decap_8
XFILLER_17_89 VPWR VGND sg13cmos5l_fill_1
XFILLER_83_185 VPWR VGND sg13cmos5l_decap_8
XFILLER_130_4 VPWR VGND sg13cmos5l_fill_2
XFILLER_137_154 VPWR VGND sg13cmos5l_decap_8
XFILLER_116_2 VPWR VGND sg13cmos5l_fill_1
XFILLER_137_187 VPWR VGND sg13cmos5l_decap_8
XFILLER_137_198 VPWR VGND sg13cmos5l_fill_2
XFILLER_3_112 VPWR VGND sg13cmos5l_decap_8
XFILLER_3_134 VPWR VGND sg13cmos5l_decap_8
XFILLER_3_178 VPWR VGND sg13cmos5l_decap_8
XFILLER_74_130 VPWR VGND sg13cmos5l_decap_8
XANTENNA__0932__X Tile_X0Y1_W2BEG[3] VPWR VGND sg13cmos5l_antennanp
XFILLER_30_211 VPWR VGND sg13cmos5l_decap_8
XFILLER_128_143 VPWR VGND sg13cmos5l_decap_8
X_0702_ _1234_/A3 VPWR VGND sg13cmos5l_tielo
X_0633_ NPU_ACT_ADDR7 Tile_X0Y1_UserCLK _0980_/X _0688_/L_HI VPWR VGND sg13cmos5l_dfrbpq_1
X_0564_ _0564_/Q Tile_X0Y1_FrameData[6] VGND VPWR Tile_X0Y1_FrameStrobe[6] latch
X_0495_ _0495_/Q Tile_X0Y1_FrameData[11] VGND VPWR Tile_X0Y1_FrameStrobe[4] latch
XFILLER_17_0 VPWR VGND sg13cmos5l_fill_2
XFILLER_80_100 VPWR VGND sg13cmos5l_decap_8
X_1047_ _1047_/X _0636_/Q _0640_/Q _1079_/X _1099_/X _0234_/Q _0233_/Q VPWR VGND sg13cmos5l_mux4_1
X_1116_ _1116_/X _1210_/X _1214_/X _1218_/X _1198_/X _0569_/Q _0568_/Q VPWR VGND sg13cmos5l_mux4_1
XANTENNA__0842__X Tile_X0Y1_FrameData_O[18] VPWR VGND sg13cmos5l_antennanp
XFILLER_0_115 VPWR VGND sg13cmos5l_decap_8
XFILLER_119_187 VPWR VGND sg13cmos5l_decap_8
XFILLER_134_135 VPWR VGND sg13cmos5l_decap_8
XFILLER_56_130 VPWR VGND sg13cmos5l_decap_4
XFILLER_56_163 VPWR VGND sg13cmos5l_decap_4
XANTENNA__0752__X Tile_X0Y0_N4BEG[1] VPWR VGND sg13cmos5l_antennanp
XFILLER_44_21 VPWR VGND sg13cmos5l_decap_8
XFILLER_71_133 VPWR VGND sg13cmos5l_decap_8
XFILLER_121_0 VPWR VGND sg13cmos5l_decap_4
XFILLER_125_124 VPWR VGND sg13cmos5l_decap_8
XFILLER_140_105 VPWR VGND sg13cmos5l_decap_8
XFILLER_5_59 VPWR VGND sg13cmos5l_decap_8
X_0280_ _0280_/Q Tile_X0Y0_FrameData[4] VGND VPWR Tile_X0Y1_FrameStrobe[5] latch
XFILLER_94_214 VPWR VGND sg13cmos5l_decap_4
XANTENNA__0927__X Tile_X0Y1_W1BEG[2] VPWR VGND sg13cmos5l_antennanp
XFILLER_47_163 VPWR VGND sg13cmos5l_decap_8
XFILLER_62_166 VPWR VGND sg13cmos5l_decap_4
XFILLER_79_2 VPWR VGND sg13cmos5l_fill_1
XANTENNA__0611__Q NPU_WEIGHT_IN1 VPWR VGND sg13cmos5l_antennanp
XFILLER_131_138 VPWR VGND sg13cmos5l_decap_8
X_0616_ NPU_WEIGHT_IN6 Tile_X0Y1_UserCLK _0996_/X _0679_/L_HI VPWR VGND sg13cmos5l_dfrbpq_1
XANTENNA__0837__X Tile_X0Y1_FrameData_O[13] VPWR VGND sg13cmos5l_antennanp
X_0547_ _0547_/Q Tile_X0Y1_FrameData[23] VGND VPWR Tile_X0Y1_FrameStrobe[6] latch
X_0478_ _0478_/Q Tile_X0Y1_FrameData[28] VGND VPWR Tile_X0Y1_FrameStrobe[4] latch
XFILLER_38_185 VPWR VGND sg13cmos5l_decap_4
XFILLER_53_100 VPWR VGND sg13cmos5l_decap_8
XFILLER_30_78 VPWR VGND sg13cmos5l_decap_8
XFILLER_39_32 VPWR VGND sg13cmos5l_decap_8
XANTENNA__0747__X Tile_X0Y0_W6BEG[8] VPWR VGND sg13cmos5l_antennanp
XFILLER_44_155 VPWR VGND sg13cmos5l_decap_8
XFILLER_91_217 VPWR VGND sg13cmos5l_fill_1
XFILLER_91_206 VPWR VGND sg13cmos5l_fill_1
XFILLER_111_81 VPWR VGND sg13cmos5l_decap_8
XFILLER_71_63 VPWR VGND sg13cmos5l_decap_8
XFILLER_113_116 VPWR VGND sg13cmos5l_decap_8
XFILLER_106_190 VPWR VGND sg13cmos5l_decap_8
XFILLER_121_160 VPWR VGND sg13cmos5l_decap_8
X_0401_ _0401_/Q Tile_X0Y1_FrameData[9] VGND VPWR Tile_X0Y1_FrameStrobe[1] latch
X_0332_ _0332_/Q Tile_X0Y0_FrameData[16] VGND VPWR Tile_X0Y1_FrameStrobe[7] latch
X_0263_ _0263_/Q Tile_X0Y0_FrameData[21] VGND VPWR Tile_X0Y1_FrameStrobe[5] latch
XFILLER_35_111 VPWR VGND sg13cmos5l_decap_8
X_0194_ _0194_/Q Tile_X0Y0_FrameData[26] VGND VPWR Tile_X0Y1_FrameStrobe[3] latch
XFILLER_84_0 VPWR VGND sg13cmos5l_decap_4
XFILLER_104_105 VPWR VGND sg13cmos5l_decap_8
XFILLER_6_80 VPWR VGND sg13cmos5l_decap_8
XFILLER_73_217 VPWR VGND sg13cmos5l_fill_1
XFILLER_25_45 VPWR VGND sg13cmos5l_decap_4
XFILLER_41_169 VPWR VGND sg13cmos5l_decap_8
XFILLER_106_70 VPWR VGND sg13cmos5l_fill_1
XFILLER_110_119 VPWR VGND sg13cmos5l_decap_8
XFILLER_82_51 VPWR VGND sg13cmos5l_decap_8
XANTENNA__0940__X Tile_X0Y1_W2BEGb[3] VPWR VGND sg13cmos5l_antennanp
X_0881_ Tile_X0Y0_FrameData_O[25] Tile_X0Y0_FrameData[25] VPWR VGND sg13cmos5l_buf_1
X_0950_ Tile_X0Y1_W6BEG[5] _1184_/X VPWR VGND sg13cmos5l_buf_1
XFILLER_141_200 VPWR VGND sg13cmos5l_fill_2
XFILLER_56_4 VPWR VGND sg13cmos5l_fill_1
XFILLER_99_136 VPWR VGND sg13cmos5l_decap_8
XFILLER_99_114 VPWR VGND sg13cmos5l_decap_8
XFILLER_55_217 VPWR VGND sg13cmos5l_fill_1
X_0315_ _0315_/Q Tile_X0Y0_FrameData[1] VGND VPWR Tile_X0Y1_FrameStrobe[6] latch
X_0246_ _0246_/Q Tile_X0Y0_FrameData[6] VGND VPWR Tile_X0Y1_FrameStrobe[4] latch
XFILLER_23_136 VPWR VGND sg13cmos5l_decap_8
X_0177_ _0177_/Q Tile_X0Y0_FrameData[11] VGND VPWR Tile_X0Y1_FrameStrobe[2] latch
XANTENNA__0850__X Tile_X0Y1_FrameData_O[26] VPWR VGND sg13cmos5l_antennanp
XFILLER_127_25 VPWR VGND sg13cmos5l_decap_8
XFILLER_127_47 VPWR VGND sg13cmos5l_fill_2
XFILLER_98_191 VPWR VGND sg13cmos5l_decap_8
XFILLER_100_196 VPWR VGND sg13cmos5l_decap_8
XFILLER_36_11 VPWR VGND sg13cmos5l_decap_4
XFILLER_36_33 VPWR VGND sg13cmos5l_decap_8
XFILLER_36_44 VPWR VGND sg13cmos5l_fill_2
XFILLER_36_99 VPWR VGND sg13cmos5l_fill_1
XFILLER_46_217 VPWR VGND sg13cmos5l_fill_1
XANTENNA__0760__X Tile_X0Y0_N4BEG[9] VPWR VGND sg13cmos5l_antennanp
XFILLER_52_76 VPWR VGND sg13cmos5l_decap_8
XFILLER_77_62 VPWR VGND sg13cmos5l_decap_8
XFILLER_77_73 VPWR VGND sg13cmos5l_fill_1
X_1080_ _1080_/X _1114_/X Tile_X0Y1_N4END[7] Tile_X0Y0_S1END[3] Tile_X0Y0_S4END[3]
+ _0126_/Q _0125_/Q VPWR VGND sg13cmos5l_mux4_1
X_0100_ _0100_/Q Tile_X0Y0_FrameData[24] VGND VPWR Tile_X0Y1_FrameStrobe[0] latch
XANTENNA__0935__X Tile_X0Y1_W2BEG[6] VPWR VGND sg13cmos5l_antennanp
XFILLER_20_117 VPWR VGND sg13cmos5l_decap_8
XFILLER_20_139 VPWR VGND sg13cmos5l_fill_1
X_0864_ Tile_X0Y0_FrameData_O[8] Tile_X0Y0_FrameData[8] VPWR VGND sg13cmos5l_buf_1
X_0933_ Tile_X0Y1_W2BEG[4] _1151_/X VPWR VGND sg13cmos5l_buf_1
X_0795_ Tile_X0Y0_N2BEG[4] _1007_/X VPWR VGND sg13cmos5l_buf_1
XFILLER_3_70 VPWR VGND sg13cmos5l_decap_8
XFILLER_47_0 VPWR VGND sg13cmos5l_decap_4
XANTENNA__0845__X Tile_X0Y1_FrameData_O[21] VPWR VGND sg13cmos5l_antennanp
XFILLER_113_27 VPWR VGND sg13cmos5l_decap_8
XFILLER_28_217 VPWR VGND sg13cmos5l_fill_1
X_0229_ _0229_/Q Tile_X0Y0_FrameData[23] VGND VPWR Tile_X0Y1_FrameStrobe[4] latch
XFILLER_95_194 VPWR VGND sg13cmos5l_fill_1
XFILLER_11_139 VPWR VGND sg13cmos5l_decap_8
XFILLER_98_17 VPWR VGND sg13cmos5l_decap_8
XFILLER_19_217 VPWR VGND sg13cmos5l_fill_1
XFILLER_78_139 VPWR VGND sg13cmos5l_decap_8
XANTENNA__0755__X Tile_X0Y0_N4BEG[4] VPWR VGND sg13cmos5l_antennanp
XFILLER_103_71 VPWR VGND sg13cmos5l_decap_8
XFILLER_10_183 VPWR VGND sg13cmos5l_decap_8
XFILLER_6_154 VPWR VGND sg13cmos5l_decap_8
XFILLER_40_7 VPWR VGND sg13cmos5l_fill_1
X_1201_ _1201_/X Tile_X0Y1_N2MID[6] Tile_X0Y1_N2END[6] _1225_/X Tile_X0Y0_S2MID[6]
+ _0358_/Q _0357_/Q VPWR VGND sg13cmos5l_mux4_1
X_0580_ _0580_/Q Tile_X0Y1_FrameData[22] VGND VPWR Tile_X0Y1_FrameStrobe[7] latch
XFILLER_77_172 VPWR VGND sg13cmos5l_decap_8
X_1063_ _1063_/X Tile_X0Y1_N4END[4] Tile_X0Y0_S4END[0] _1080_/X _1079_/X _0202_/Q
+ _0201_/Q VPWR VGND sg13cmos5l_mux4_1
X_1132_ _1132_/X Tile_X0Y1_E1END[1] Tile_X0Y1_E2MID[2] Tile_X0Y1_E2END[2] _1200_/X
+ _0548_/Q _0547_/Q VPWR VGND sg13cmos5l_mux4_1
XFILLER_92_131 VPWR VGND sg13cmos5l_decap_8
XANTENNA__0614__Q NPU_WEIGHT_IN4 VPWR VGND sg13cmos5l_antennanp
X_0916_ Tile_X0Y1_S4BEG[8] _0916_/A VPWR VGND sg13cmos5l_buf_1
X_0847_ Tile_X0Y1_FrameData_O[23] Tile_X0Y1_FrameData[23] VPWR VGND sg13cmos5l_buf_1
X_0778_ Tile_X0Y0_WW4BEG[11] _1058_/X VPWR VGND sg13cmos5l_buf_1
XFILLER_102_214 VPWR VGND sg13cmos5l_decap_4
XFILLER_124_15 VPWR VGND sg13cmos5l_fill_1
XFILLER_68_161 VPWR VGND sg13cmos5l_decap_8
XFILLER_68_172 VPWR VGND sg13cmos5l_fill_2
XFILLER_140_69 VPWR VGND sg13cmos5l_fill_2
XFILLER_17_35 VPWR VGND sg13cmos5l_fill_1
XFILLER_33_34 VPWR VGND sg13cmos5l_fill_1
XFILLER_83_164 VPWR VGND sg13cmos5l_decap_8
XFILLER_137_133 VPWR VGND sg13cmos5l_decap_8
XFILLER_58_20 VPWR VGND sg13cmos5l_decap_4
XFILLER_58_53 VPWR VGND sg13cmos5l_fill_2
XFILLER_74_186 VPWR VGND sg13cmos5l_decap_8
XFILLER_128_100 VPWR VGND sg13cmos5l_decap_8
XFILLER_128_122 VPWR VGND sg13cmos5l_decap_8
XFILLER_128_199 VPWR VGND sg13cmos5l_decap_8
X_0701_ _1102_/A3 VPWR VGND sg13cmos5l_tielo
X_0632_ NPU_ACT_ADDR6 Tile_X0Y1_UserCLK _0979_/X _0689_/L_HI VPWR VGND sg13cmos5l_dfrbpq_1
X_0563_ _0563_/Q Tile_X0Y1_FrameData[7] VGND VPWR Tile_X0Y1_FrameStrobe[6] latch
XFILLER_65_131 VPWR VGND sg13cmos5l_fill_2
X_0494_ _0494_/Q Tile_X0Y1_FrameData[12] VGND VPWR Tile_X0Y1_FrameStrobe[4] latch
XFILLER_65_164 VPWR VGND sg13cmos5l_decap_4
X_1046_ _1046_/X Tile_X0Y0_EE4END[14] _0643_/Q _1092_/X _1099_/X _0236_/Q _0235_/Q
+ VPWR VGND sg13cmos5l_mux4_1
X_1115_ _1115_/X Tile_X0Y1_E1END[3] Tile_X0Y1_EE4END[3] Tile_X0Y1_E6END[11] _1206_/X
+ _0569_/Q _0568_/Q VPWR VGND sg13cmos5l_mux4_1
XFILLER_119_122 VPWR VGND sg13cmos5l_fill_2
XFILLER_119_166 VPWR VGND sg13cmos5l_decap_8
XFILLER_134_114 VPWR VGND sg13cmos5l_decap_8
XFILLER_135_14 VPWR VGND sg13cmos5l_decap_8
XFILLER_95_29 VPWR VGND sg13cmos5l_fill_1
XFILLER_88_201 VPWR VGND sg13cmos5l_decap_8
XFILLER_28_56 VPWR VGND sg13cmos5l_decap_8
XFILLER_56_142 VPWR VGND sg13cmos5l_decap_8
XFILLER_71_112 VPWR VGND sg13cmos5l_decap_8
XFILLER_44_11 VPWR VGND sg13cmos5l_fill_2
XFILLER_44_77 VPWR VGND sg13cmos5l_decap_8
XFILLER_44_99 VPWR VGND sg13cmos5l_decap_8
XFILLER_71_189 VPWR VGND sg13cmos5l_decap_8
XFILLER_114_0 VPWR VGND sg13cmos5l_decap_4
XFILLER_125_103 VPWR VGND sg13cmos5l_decap_8
XFILLER_60_76 VPWR VGND sg13cmos5l_decap_8
XFILLER_60_87 VPWR VGND sg13cmos5l_fill_1
XFILLER_140_128 VPWR VGND sg13cmos5l_decap_8
XFILLER_69_63 VPWR VGND sg13cmos5l_fill_2
XFILLER_79_201 VPWR VGND sg13cmos5l_decap_4
XANTENNA__0943__X Tile_X0Y1_W2BEGb[6] VPWR VGND sg13cmos5l_antennanp
XFILLER_47_142 VPWR VGND sg13cmos5l_decap_8
XFILLER_62_112 VPWR VGND sg13cmos5l_decap_8
XFILLER_62_134 VPWR VGND sg13cmos5l_decap_8
XFILLER_85_73 VPWR VGND sg13cmos5l_fill_1
XFILLER_116_169 VPWR VGND sg13cmos5l_fill_1
XFILLER_131_117 VPWR VGND sg13cmos5l_decap_8
X_0615_ NPU_WEIGHT_IN5 Tile_X0Y1_UserCLK _0995_/X _0656_/L_HI VPWR VGND sg13cmos5l_dfrbpq_1
X_0546_ _0546_/Q Tile_X0Y1_FrameData[24] VGND VPWR Tile_X0Y1_FrameStrobe[6] latch
XFILLER_85_204 VPWR VGND sg13cmos5l_fill_2
X_0477_ _0477_/Q Tile_X0Y1_FrameData[29] VGND VPWR Tile_X0Y1_FrameStrobe[4] latch
XANTENNA__0853__X Tile_X0Y1_FrameData_O[29] VPWR VGND sg13cmos5l_antennanp
XFILLER_139_217 VPWR VGND sg13cmos5l_fill_1
X_1029_ _1029_/X _1113_/X Tile_X0Y0_S1END[2] _0636_/Q _0641_/Q _0270_/Q _0269_/Q VPWR
+ VGND sg13cmos5l_mux4_1
XFILLER_107_158 VPWR VGND sg13cmos5l_fill_1
XFILLER_122_128 VPWR VGND sg13cmos5l_decap_8
XFILLER_29_120 VPWR VGND sg13cmos5l_decap_8
XFILLER_39_11 VPWR VGND sg13cmos5l_decap_8
XFILLER_39_99 VPWR VGND sg13cmos5l_decap_8
XANTENNA__0763__X Tile_X0Y0_N4BEG[12] VPWR VGND sg13cmos5l_antennanp
XFILLER_29_131 VPWR VGND sg13cmos5l_fill_1
XFILLER_29_164 VPWR VGND sg13cmos5l_decap_4
XFILLER_44_134 VPWR VGND sg13cmos5l_decap_8
XFILLER_71_42 VPWR VGND sg13cmos5l_decap_8
X_0400_ _0400_/Q Tile_X0Y1_FrameData[10] VGND VPWR Tile_X0Y1_FrameStrobe[1] latch
XANTENNA__0938__X Tile_X0Y1_W2BEGb[1] VPWR VGND sg13cmos5l_antennanp
X_0331_ _0331_/Q Tile_X0Y0_FrameData[17] VGND VPWR Tile_X0Y1_FrameStrobe[7] latch
X_0262_ _0262_/Q Tile_X0Y0_FrameData[22] VGND VPWR Tile_X0Y1_FrameStrobe[5] latch
X_0193_ _0193_/Q Tile_X0Y0_FrameData[27] VGND VPWR Tile_X0Y1_FrameStrobe[3] latch
XFILLER_35_167 VPWR VGND sg13cmos5l_decap_8
XANTENNA__0622__Q NPU_ACT_WDATA4 VPWR VGND sg13cmos5l_antennanp
XFILLER_77_0 VPWR VGND sg13cmos5l_decap_4
XANTENNA__0848__X Tile_X0Y1_FrameData_O[24] VPWR VGND sg13cmos5l_antennanp
XFILLER_112_194 VPWR VGND sg13cmos5l_decap_8
XFILLER_116_49 VPWR VGND sg13cmos5l_decap_8
X_0529_ _0529_/Q Tile_X0Y1_FrameData[9] VGND VPWR Tile_X0Y1_FrameStrobe[5] latch
XFILLER_132_26 VPWR VGND sg13cmos5l_decap_4
XFILLER_25_79 VPWR VGND sg13cmos5l_decap_8
XFILLER_41_137 VPWR VGND sg13cmos5l_fill_1
XANTENNA__0758__X Tile_X0Y0_N4BEG[7] VPWR VGND sg13cmos5l_antennanp
XFILLER_66_64 VPWR VGND sg13cmos5l_decap_4
XFILLER_122_70 VPWR VGND sg13cmos5l_fill_1
XFILLER_32_159 VPWR VGND sg13cmos5l_decap_4
XFILLER_82_30 VPWR VGND sg13cmos5l_decap_8
XFILLER_70_7 VPWR VGND sg13cmos5l_decap_8
X_0880_ Tile_X0Y0_FrameData_O[24] Tile_X0Y0_FrameData[24] VPWR VGND sg13cmos5l_buf_1
XANTENNA__0617__Q NPU_WEIGHT_IN7 VPWR VGND sg13cmos5l_antennanp
X_0314_ _0314_/Q Tile_X0Y0_FrameData[2] VGND VPWR Tile_X0Y1_FrameStrobe[6] latch
X_0245_ _0245_/Q Tile_X0Y0_FrameData[7] VGND VPWR Tile_X0Y1_FrameStrobe[4] latch
X_0176_ _0176_/Q Tile_X0Y0_FrameData[12] VGND VPWR Tile_X0Y1_FrameStrobe[2] latch
XFILLER_23_115 VPWR VGND sg13cmos5l_decap_8
XFILLER_31_181 VPWR VGND sg13cmos5l_decap_8
XFILLER_100_175 VPWR VGND sg13cmos5l_decap_8
XFILLER_36_78 VPWR VGND sg13cmos5l_decap_8
XFILLER_22_170 VPWR VGND sg13cmos5l_decap_8
XFILLER_52_55 VPWR VGND sg13cmos5l_decap_8
XFILLER_7_0 VPWR VGND sg13cmos5l_decap_4
XFILLER_89_192 VPWR VGND sg13cmos5l_decap_8
XFILLER_77_85 VPWR VGND sg13cmos5l_fill_1
XFILLER_93_84 VPWR VGND sg13cmos5l_decap_4
XANTENNA__0951__X Tile_X0Y1_W6BEG[6] VPWR VGND sg13cmos5l_antennanp
X_0932_ Tile_X0Y1_W2BEG[3] _1150_/X VPWR VGND sg13cmos5l_buf_1
X_0863_ Tile_X0Y0_FrameData_O[7] Tile_X0Y0_FrameData[7] VPWR VGND sg13cmos5l_buf_1
X_0794_ Tile_X0Y0_N2BEG[3] _1006_/X VPWR VGND sg13cmos5l_buf_1
XFILLER_9_185 VPWR VGND sg13cmos5l_decap_8
XFILLER_51_210 VPWR VGND sg13cmos5l_decap_8
X_0228_ _0228_/Q Tile_X0Y0_FrameData[24] VGND VPWR Tile_X0Y1_FrameStrobe[4] latch
X_0159_ _0159_/Q Tile_X0Y0_FrameData[29] VGND VPWR Tile_X0Y1_FrameStrobe[2] latch
XANTENNA__0861__X Tile_X0Y0_FrameData_O[5] VPWR VGND sg13cmos5l_antennanp
XFILLER_118_7 VPWR VGND sg13cmos5l_decap_8
XFILLER_11_118 VPWR VGND sg13cmos5l_decap_8
XFILLER_138_14 VPWR VGND sg13cmos5l_fill_2
XFILLER_0_7 VPWR VGND sg13cmos5l_decap_8
XANTENNA__0771__X Tile_X0Y0_WW4BEG[4] VPWR VGND sg13cmos5l_antennanp
XFILLER_63_21 VPWR VGND sg13cmos5l_decap_8
XFILLER_10_162 VPWR VGND sg13cmos5l_decap_8
XFILLER_6_111 VPWR VGND sg13cmos5l_fill_1
XFILLER_6_133 VPWR VGND sg13cmos5l_decap_8
XFILLER_88_40 VPWR VGND sg13cmos5l_fill_1
XFILLER_69_118 VPWR VGND sg13cmos5l_decap_8
X_1200_ _1200_/X Tile_X0Y1_N2MID[5] Tile_X0Y1_N2END[5] _1224_/X Tile_X0Y0_S2MID[5]
+ _0360_/Q _0359_/Q VPWR VGND sg13cmos5l_mux4_1
XFILLER_88_84 VPWR VGND sg13cmos5l_decap_8
XANTENNA__0946__X Tile_X0Y1_W6BEG[1] VPWR VGND sg13cmos5l_antennanp
X_1062_ _1062_/X _0639_/Q _0643_/Q _1088_/X _1092_/X _0204_/Q _0203_/Q VPWR VGND sg13cmos5l_mux4_1
X_1131_ _1131_/X Tile_X0Y1_E1END[0] Tile_X0Y1_E2MID[3] Tile_X0Y1_E2END[3] _1199_/X
+ _0550_/Q _0549_/Q VPWR VGND sg13cmos5l_mux4_1
XFILLER_92_187 VPWR VGND sg13cmos5l_decap_8
XFILLER_92_110 VPWR VGND sg13cmos5l_decap_8
X_0915_ Tile_X0Y1_S4BEG[7] Tile_X0Y0_S4END[15] VPWR VGND sg13cmos5l_buf_1
XANTENNA__0630__Q NPU_ACT_ADDR4 VPWR VGND sg13cmos5l_antennanp
XFILLER_108_39 VPWR VGND sg13cmos5l_decap_8
X_0846_ Tile_X0Y1_FrameData_O[22] Tile_X0Y1_FrameData[22] VPWR VGND sg13cmos5l_buf_1
X_0777_ Tile_X0Y0_WW4BEG[10] _1057_/X VPWR VGND sg13cmos5l_buf_1
XANTENNA__0856__X Tile_X0Y0_FrameData_O[0] VPWR VGND sg13cmos5l_antennanp
XFILLER_68_140 VPWR VGND sg13cmos5l_decap_8
XFILLER_83_143 VPWR VGND sg13cmos5l_decap_8
XFILLER_140_26 VPWR VGND sg13cmos5l_fill_1
XFILLER_24_210 VPWR VGND sg13cmos5l_decap_8
XFILLER_137_112 VPWR VGND sg13cmos5l_decap_8
XFILLER_58_98 VPWR VGND sg13cmos5l_decap_4
XANTENNA__0766__X Tile_X0Y0_N4BEG[15] VPWR VGND sg13cmos5l_antennanp
XFILLER_114_82 VPWR VGND sg13cmos5l_decap_4
XFILLER_15_210 VPWR VGND sg13cmos5l_decap_8
XFILLER_74_165 VPWR VGND sg13cmos5l_decap_8
XFILLER_74_31 VPWR VGND sg13cmos5l_decap_4
XFILLER_74_64 VPWR VGND sg13cmos5l_decap_4
X_0700_ _1101_/A3 VPWR VGND sg13cmos5l_tielo
XFILLER_90_74 VPWR VGND sg13cmos5l_decap_8
XFILLER_128_178 VPWR VGND sg13cmos5l_decap_8
X_0631_ NPU_ACT_ADDR5 Tile_X0Y1_UserCLK _0978_/X _0686_/L_HI VPWR VGND sg13cmos5l_dfrbpq_1
X_0562_ _0562_/Q Tile_X0Y1_FrameData[8] VGND VPWR Tile_X0Y1_FrameStrobe[6] latch
XFILLER_99_61 VPWR VGND sg13cmos5l_decap_8
XFILLER_17_2 VPWR VGND sg13cmos5l_fill_1
XFILLER_65_110 VPWR VGND sg13cmos5l_decap_8
X_1114_ _1114_/X Tile_X0Y1_E1END[3] Tile_X0Y1_E6END[7] _1218_/X _1194_/X _0596_/Q
+ _0595_/Q VPWR VGND sg13cmos5l_mux4_1
X_0493_ _0493_/Q Tile_X0Y1_FrameData[13] VGND VPWR Tile_X0Y1_FrameStrobe[4] latch
XANTENNA__0625__Q NPU_ACT_WDATA7 VPWR VGND sg13cmos5l_antennanp
XFILLER_0_94 VPWR VGND sg13cmos5l_decap_8
XFILLER_80_135 VPWR VGND sg13cmos5l_decap_8
X_1045_ _1045_/X Tile_X0Y0_EE4END[13] _0642_/Q _1093_/X _1098_/X _0238_/Q _0237_/Q
+ VPWR VGND sg13cmos5l_mux4_1
XFILLER_119_145 VPWR VGND sg13cmos5l_decap_8
X_0829_ Tile_X0Y1_FrameData_O[5] Tile_X0Y1_FrameData[5] VPWR VGND sg13cmos5l_buf_1
XFILLER_28_13 VPWR VGND sg13cmos5l_fill_2
XFILLER_28_35 VPWR VGND sg13cmos5l_decap_8
XFILLER_56_176 VPWR VGND sg13cmos5l_fill_2
XFILLER_100_73 VPWR VGND sg13cmos5l_decap_8
XFILLER_12_202 VPWR VGND sg13cmos5l_decap_4
XFILLER_44_56 VPWR VGND sg13cmos5l_decap_8
XFILLER_60_33 VPWR VGND sg13cmos5l_decap_8
XFILLER_71_168 VPWR VGND sg13cmos5l_decap_8
XFILLER_8_217 VPWR VGND sg13cmos5l_fill_1
XFILLER_107_0 VPWR VGND sg13cmos5l_fill_1
XFILLER_109_82 VPWR VGND sg13cmos5l_decap_8
XFILLER_125_159 VPWR VGND sg13cmos5l_decap_8
XFILLER_69_42 VPWR VGND sg13cmos5l_decap_8
XFILLER_125_70 VPWR VGND sg13cmos5l_decap_8
XFILLER_47_121 VPWR VGND sg13cmos5l_decap_8
XFILLER_69_97 VPWR VGND sg13cmos5l_decap_8
XFILLER_85_41 VPWR VGND sg13cmos5l_decap_8
XFILLER_141_80 VPWR VGND sg13cmos5l_decap_8
XFILLER_47_198 VPWR VGND sg13cmos5l_decap_4
XFILLER_116_115 VPWR VGND sg13cmos5l_fill_1
XFILLER_116_148 VPWR VGND sg13cmos5l_fill_2
XFILLER_22_0 VPWR VGND sg13cmos5l_fill_2
X_0614_ NPU_WEIGHT_IN4 Tile_X0Y1_UserCLK _0994_/X _0653_/L_HI VPWR VGND sg13cmos5l_dfrbpq_1
X_0545_ _0545_/Q Tile_X0Y1_FrameData[25] VGND VPWR Tile_X0Y1_FrameStrobe[6] latch
X_0476_ _0476_/Q Tile_X0Y1_FrameData[30] VGND VPWR Tile_X0Y1_FrameStrobe[4] latch
XFILLER_38_143 VPWR VGND sg13cmos5l_decap_8
XFILLER_53_135 VPWR VGND sg13cmos5l_decap_8
X_1028_ _1028_/X _1112_/X Tile_X0Y0_S1END[1] _0639_/Q _0642_/Q _0272_/Q _0271_/Q VPWR
+ VGND sg13cmos5l_mux4_1
XANTENNA__0090__Q NPU_XBAR_SEL0 VPWR VGND sg13cmos5l_antennanp
XFILLER_100_7 VPWR VGND sg13cmos5l_fill_1
XFILLER_107_126 VPWR VGND sg13cmos5l_fill_2
XFILLER_30_58 VPWR VGND sg13cmos5l_decap_8
XFILLER_115_181 VPWR VGND sg13cmos5l_decap_8
XFILLER_130_184 VPWR VGND sg13cmos5l_decap_8
XFILLER_39_78 VPWR VGND sg13cmos5l_decap_8
XFILLER_44_113 VPWR VGND sg13cmos5l_decap_8
XFILLER_55_44 VPWR VGND sg13cmos5l_fill_1
XFILLER_55_77 VPWR VGND sg13cmos5l_fill_2
XFILLER_71_21 VPWR VGND sg13cmos5l_decap_8
XFILLER_71_98 VPWR VGND sg13cmos5l_decap_8
XFILLER_136_91 VPWR VGND sg13cmos5l_decap_8
X_0330_ _0330_/Q Tile_X0Y0_FrameData[18] VGND VPWR Tile_X0Y1_FrameStrobe[7] latch
XANTENNA__0954__X Tile_X0Y1_W6BEG[9] VPWR VGND sg13cmos5l_antennanp
XFILLER_121_195 VPWR VGND sg13cmos5l_decap_8
XFILLER_35_146 VPWR VGND sg13cmos5l_decap_8
X_0261_ _0261_/Q Tile_X0Y0_FrameData[23] VGND VPWR Tile_X0Y1_FrameStrobe[5] latch
X_0192_ _0192_/Q Tile_X0Y0_FrameData[28] VGND VPWR Tile_X0Y1_FrameStrobe[3] latch
XFILLER_112_173 VPWR VGND sg13cmos5l_decap_8
XFILLER_116_28 VPWR VGND sg13cmos5l_decap_8
X_0528_ _0528_/Q Tile_X0Y1_FrameData[10] VGND VPWR Tile_X0Y1_FrameStrobe[5] latch
X_0459_ _0459_/Q Tile_X0Y1_FrameData[15] VGND VPWR Tile_X0Y1_FrameStrobe[3] latch
XANTENNA__0864__X Tile_X0Y0_FrameData_O[8] VPWR VGND sg13cmos5l_antennanp
XFILLER_26_113 VPWR VGND sg13cmos5l_decap_8
XFILLER_26_157 VPWR VGND sg13cmos5l_decap_4
XFILLER_26_179 VPWR VGND sg13cmos5l_fill_2
XFILLER_41_116 VPWR VGND sg13cmos5l_fill_1
XFILLER_41_149 VPWR VGND sg13cmos5l_fill_2
XFILLER_9_4 VPWR VGND sg13cmos5l_fill_2
XANTENNA__0774__X Tile_X0Y0_WW4BEG[7] VPWR VGND sg13cmos5l_antennanp
XFILLER_103_195 VPWR VGND sg13cmos5l_decap_4
XFILLER_17_113 VPWR VGND sg13cmos5l_fill_1
XFILLER_66_21 VPWR VGND sg13cmos5l_decap_8
XFILLER_66_32 VPWR VGND sg13cmos5l_fill_1
XFILLER_66_43 VPWR VGND sg13cmos5l_decap_8
XFILLER_32_149 VPWR VGND sg13cmos5l_decap_8
XFILLER_82_86 VPWR VGND sg13cmos5l_decap_8
XFILLER_141_202 VPWR VGND sg13cmos5l_fill_1
XFILLER_40_193 VPWR VGND sg13cmos5l_decap_8
XFILLER_63_7 VPWR VGND sg13cmos5l_decap_8
XANTENNA__0949__X Tile_X0Y1_W6BEG[4] VPWR VGND sg13cmos5l_antennanp
X_0313_ _0313_/Q Tile_X0Y0_FrameData[3] VGND VPWR Tile_X0Y1_FrameStrobe[6] latch
X_0244_ _0244_/Q Tile_X0Y0_FrameData[8] VGND VPWR Tile_X0Y1_FrameStrobe[4] latch
X_0175_ _0175_/Q Tile_X0Y0_FrameData[13] VGND VPWR Tile_X0Y1_FrameStrobe[2] latch
XANTENNA__0633__Q NPU_ACT_ADDR7 VPWR VGND sg13cmos5l_antennanp
XFILLER_117_210 VPWR VGND sg13cmos5l_decap_8
XFILLER_16_190 VPWR VGND sg13cmos5l_decap_8
XFILLER_31_160 VPWR VGND sg13cmos5l_decap_8
XANTENNA__0859__X Tile_X0Y0_FrameData_O[3] VPWR VGND sg13cmos5l_antennanp
XFILLER_132_213 VPWR VGND sg13cmos5l_decap_4
XFILLER_14_105 VPWR VGND sg13cmos5l_fill_2
XFILLER_14_149 VPWR VGND sg13cmos5l_decap_8
XFILLER_52_34 VPWR VGND sg13cmos5l_decap_8
XANTENNA__0769__X Tile_X0Y0_WW4BEG[2] VPWR VGND sg13cmos5l_antennanp
XFILLER_77_97 VPWR VGND sg13cmos5l_decap_8
XFILLER_60_211 VPWR VGND sg13cmos5l_decap_8
X_0862_ Tile_X0Y0_FrameData_O[6] Tile_X0Y0_FrameData[6] VPWR VGND sg13cmos5l_buf_1
X_0931_ Tile_X0Y1_W2BEG[2] _1149_/X VPWR VGND sg13cmos5l_buf_1
XFILLER_9_164 VPWR VGND sg13cmos5l_decap_8
XFILLER_114_213 VPWR VGND sg13cmos5l_decap_4
X_0793_ Tile_X0Y0_N2BEG[2] _1005_/X VPWR VGND sg13cmos5l_buf_1
XANTENNA__0628__Q NPU_ACT_ADDR2 VPWR VGND sg13cmos5l_antennanp
XFILLER_28_208 VPWR VGND sg13cmos5l_decap_8
XFILLER_87_119 VPWR VGND sg13cmos5l_decap_8
XFILLER_95_185 VPWR VGND sg13cmos5l_decap_8
XFILLER_95_163 VPWR VGND sg13cmos5l_decap_4
X_0227_ _0227_/Q Tile_X0Y0_FrameData[25] VGND VPWR Tile_X0Y1_FrameStrobe[4] latch
X_0158_ _0158_/Q Tile_X0Y0_FrameData[30] VGND VPWR Tile_X0Y1_FrameStrobe[2] latch
X_0089_ NPU_ACT_WE Tile_X0Y1_UserCLK _0089_/D _0697_/L_HI VPWR VGND sg13cmos5l_dfrbpq_1
XFILLER_138_37 VPWR VGND sg13cmos5l_fill_2
XFILLER_120_205 VPWR VGND sg13cmos5l_fill_2
XFILLER_42_211 VPWR VGND sg13cmos5l_decap_8
XFILLER_47_34 VPWR VGND sg13cmos5l_decap_8
XFILLER_47_56 VPWR VGND sg13cmos5l_fill_1
XFILLER_47_78 VPWR VGND sg13cmos5l_fill_2
XFILLER_86_152 VPWR VGND sg13cmos5l_fill_1
XFILLER_86_174 VPWR VGND sg13cmos5l_fill_1
XFILLER_86_196 VPWR VGND sg13cmos5l_decap_8
XFILLER_137_0 VPWR VGND sg13cmos5l_decap_8
XFILLER_63_99 VPWR VGND sg13cmos5l_fill_2
XFILLER_6_189 VPWR VGND sg13cmos5l_decap_8
X_1130_ _1130_/X Tile_X0Y1_E2MID[4] Tile_X0Y1_E2END[4] Tile_X0Y1_E6END[11] _1198_/X
+ _0552_/Q _0551_/Q VPWR VGND sg13cmos5l_mux4_1
XANTENNA__0962__X Tile_X0Y1_WW4BEG[5] VPWR VGND sg13cmos5l_antennanp
X_1061_ _1061_/X _0638_/Q _0642_/Q _1089_/X _1093_/X _0206_/Q _0205_/Q VPWR VGND sg13cmos5l_mux4_1
XFILLER_92_166 VPWR VGND sg13cmos5l_decap_8
X_0914_ Tile_X0Y1_S4BEG[6] Tile_X0Y0_S4END[14] VPWR VGND sg13cmos5l_buf_1
X_0845_ Tile_X0Y1_FrameData_O[21] Tile_X0Y1_FrameData[21] VPWR VGND sg13cmos5l_buf_1
XFILLER_108_18 VPWR VGND sg13cmos5l_decap_8
XFILLER_52_0 VPWR VGND sg13cmos5l_decap_8
X_0776_ Tile_X0Y0_WW4BEG[9] _1056_/X VPWR VGND sg13cmos5l_buf_1
XFILLER_83_122 VPWR VGND sg13cmos5l_decap_8
XFILLER_83_199 VPWR VGND sg13cmos5l_decap_8
XANTENNA__0093__Q NPU_XBAR_SEL3 VPWR VGND sg13cmos5l_antennanp
XANTENNA__0872__X Tile_X0Y0_FrameData_O[16] VPWR VGND sg13cmos5l_antennanp
XFILLER_137_168 VPWR VGND sg13cmos5l_decap_8
XFILLER_3_126 VPWR VGND sg13cmos5l_decap_4
XFILLER_3_148 VPWR VGND sg13cmos5l_decap_8
XFILLER_3_159 VPWR VGND sg13cmos5l_fill_2
XFILLER_58_55 VPWR VGND sg13cmos5l_fill_1
XFILLER_74_111 VPWR VGND sg13cmos5l_fill_1
XANTENNA__0782__X Tile_X0Y0_WW4BEG[15] VPWR VGND sg13cmos5l_antennanp
XFILLER_74_144 VPWR VGND sg13cmos5l_decap_8
XFILLER_128_157 VPWR VGND sg13cmos5l_decap_8
XFILLER_130_93 VPWR VGND sg13cmos5l_decap_8
XFILLER_23_80 VPWR VGND sg13cmos5l_decap_8
XFILLER_90_53 VPWR VGND sg13cmos5l_decap_8
XFILLER_2_181 VPWR VGND sg13cmos5l_decap_8
X_0630_ NPU_ACT_ADDR4 Tile_X0Y1_UserCLK _0977_/X _0687_/L_HI VPWR VGND sg13cmos5l_dfrbpq_1
X_0561_ _0561_/Q Tile_X0Y1_FrameData[9] VGND VPWR Tile_X0Y1_FrameStrobe[6] latch
X_0492_ _0492_/Q Tile_X0Y1_FrameData[14] VGND VPWR Tile_X0Y1_FrameStrobe[4] latch
XFILLER_97_203 VPWR VGND sg13cmos5l_decap_4
XANTENNA__0957__X Tile_X0Y1_WW4BEG[0] VPWR VGND sg13cmos5l_antennanp
XFILLER_24_4 VPWR VGND sg13cmos5l_fill_2
X_1044_ _1044_/X Tile_X0Y0_EE4END[12] _0641_/Q _1094_/X _1097_/X _0240_/Q _0239_/Q
+ VPWR VGND sg13cmos5l_mux4_1
X_1113_ _1113_/X Tile_X0Y1_E1END[2] Tile_X0Y1_E6END[6] _1217_/X _1193_/X _0598_/Q
+ _0597_/Q VPWR VGND sg13cmos5l_mux4_1
XFILLER_0_73 VPWR VGND sg13cmos5l_decap_8
XFILLER_9_60 VPWR VGND sg13cmos5l_decap_4
XFILLER_134_149 VPWR VGND sg13cmos5l_decap_8
X_0828_ Tile_X0Y1_FrameData_O[4] Tile_X0Y1_FrameData[4] VPWR VGND sg13cmos5l_buf_1
X_0759_ Tile_X0Y0_N4BEG[8] _0759_/A VPWR VGND sg13cmos5l_buf_1
XANTENNA__0867__X Tile_X0Y0_FrameData_O[11] VPWR VGND sg13cmos5l_antennanp
XFILLER_0_129 VPWR VGND sg13cmos5l_decap_8
XFILLER_44_35 VPWR VGND sg13cmos5l_decap_8
XFILLER_71_147 VPWR VGND sg13cmos5l_decap_8
XFILLER_100_41 VPWR VGND sg13cmos5l_decap_4
XFILLER_109_61 VPWR VGND sg13cmos5l_decap_8
XFILLER_125_138 VPWR VGND sg13cmos5l_decap_8
XFILLER_133_193 VPWR VGND sg13cmos5l_decap_4
XFILLER_140_119 VPWR VGND sg13cmos5l_decap_4
XFILLER_69_21 VPWR VGND sg13cmos5l_decap_8
XFILLER_69_65 VPWR VGND sg13cmos5l_fill_1
XANTENNA__0777__X Tile_X0Y0_WW4BEG[10] VPWR VGND sg13cmos5l_antennanp
XFILLER_47_177 VPWR VGND sg13cmos5l_decap_8
XFILLER_85_20 VPWR VGND sg13cmos5l_decap_8
XFILLER_18_91 VPWR VGND sg13cmos5l_fill_1
XFILLER_116_127 VPWR VGND sg13cmos5l_decap_8
X_0613_ NPU_WEIGHT_IN3 Tile_X0Y1_UserCLK _0993_/X _0694_/L_HI VPWR VGND sg13cmos5l_dfrbpq_1
XFILLER_105_19 VPWR VGND sg13cmos5l_decap_8
XFILLER_124_182 VPWR VGND sg13cmos5l_decap_8
XFILLER_38_111 VPWR VGND sg13cmos5l_decap_8
XFILLER_85_206 VPWR VGND sg13cmos5l_fill_1
XFILLER_85_217 VPWR VGND sg13cmos5l_fill_1
X_0544_ _0544_/Q Tile_X0Y1_FrameData[26] VGND VPWR Tile_X0Y1_FrameStrobe[6] latch
X_0475_ _0475_/Q Tile_X0Y1_FrameData[31] VGND VPWR Tile_X0Y1_FrameStrobe[4] latch
XFILLER_15_0 VPWR VGND sg13cmos5l_decap_4
XFILLER_53_114 VPWR VGND sg13cmos5l_decap_8
X_1027_ _1027_/X _1111_/X Tile_X0Y0_S1END[0] _0638_/Q _0643_/Q _0274_/Q _0273_/Q VPWR
+ VGND sg13cmos5l_mux4_1
XFILLER_130_163 VPWR VGND sg13cmos5l_decap_8
XFILLER_76_206 VPWR VGND sg13cmos5l_decap_8
XFILLER_76_217 VPWR VGND sg13cmos5l_fill_1
XFILLER_44_169 VPWR VGND sg13cmos5l_decap_8
XFILLER_4_210 VPWR VGND sg13cmos5l_decap_8
XFILLER_71_77 VPWR VGND sg13cmos5l_decap_8
XFILLER_121_174 VPWR VGND sg13cmos5l_decap_8
XFILLER_136_70 VPWR VGND sg13cmos5l_decap_8
XFILLER_20_81 VPWR VGND sg13cmos5l_decap_8
XFILLER_67_217 VPWR VGND sg13cmos5l_fill_1
X_0260_ _0260_/Q Tile_X0Y0_FrameData[24] VGND VPWR Tile_X0Y1_FrameStrobe[5] latch
XFILLER_35_125 VPWR VGND sg13cmos5l_decap_8
X_0191_ _0191_/Q Tile_X0Y0_FrameData[29] VGND VPWR Tile_X0Y1_FrameStrobe[3] latch
XANTENNA__0970__X Tile_X0Y1_WW4BEG[13] VPWR VGND sg13cmos5l_antennanp
XFILLER_43_180 VPWR VGND sg13cmos5l_decap_8
XFILLER_104_119 VPWR VGND sg13cmos5l_decap_8
XFILLER_6_94 VPWR VGND sg13cmos5l_decap_4
XFILLER_112_163 VPWR VGND sg13cmos5l_decap_8
XFILLER_58_217 VPWR VGND sg13cmos5l_fill_1
X_0527_ _0527_/Q Tile_X0Y1_FrameData[11] VGND VPWR Tile_X0Y1_FrameStrobe[5] latch
X_0458_ _0458_/Q Tile_X0Y1_FrameData[16] VGND VPWR Tile_X0Y1_FrameStrobe[3] latch
X_0389_ _0389_/Q Tile_X0Y1_FrameData[21] VGND VPWR Tile_X0Y1_FrameStrobe[1] latch
XFILLER_26_136 VPWR VGND sg13cmos5l_decap_8
XFILLER_34_180 VPWR VGND sg13cmos5l_fill_1
XANTENNA__0880__X Tile_X0Y0_FrameData_O[24] VPWR VGND sg13cmos5l_antennanp
XFILLER_135_200 VPWR VGND sg13cmos5l_decap_8
XFILLER_49_206 VPWR VGND sg13cmos5l_fill_1
XFILLER_49_217 VPWR VGND sg13cmos5l_fill_1
XFILLER_17_125 VPWR VGND sg13cmos5l_fill_1
XFILLER_66_99 VPWR VGND sg13cmos5l_decap_8
XANTENNA__0790__X Tile_X0Y0_N2BEGb[7] VPWR VGND sg13cmos5l_antennanp
XFILLER_15_92 VPWR VGND sg13cmos5l_fill_2
XFILLER_32_106 VPWR VGND sg13cmos5l_fill_1
XFILLER_40_161 VPWR VGND sg13cmos5l_fill_1
XFILLER_40_172 VPWR VGND sg13cmos5l_decap_8
XFILLER_82_65 VPWR VGND sg13cmos5l_decap_8
XFILLER_126_211 VPWR VGND sg13cmos5l_decap_8
XFILLER_31_91 VPWR VGND sg13cmos5l_decap_8
XANTENNA__0965__X Tile_X0Y1_WW4BEG[8] VPWR VGND sg13cmos5l_antennanp
X_0312_ _0312_/Q Tile_X0Y0_FrameData[4] VGND VPWR Tile_X0Y1_FrameStrobe[6] latch
X_0243_ _0243_/Q Tile_X0Y0_FrameData[9] VGND VPWR Tile_X0Y1_FrameStrobe[4] latch
X_0174_ _0174_/Q Tile_X0Y0_FrameData[14] VGND VPWR Tile_X0Y1_FrameStrobe[2] latch
XFILLER_82_0 VPWR VGND sg13cmos5l_fill_2
XFILLER_127_39 VPWR VGND sg13cmos5l_decap_4
XFILLER_98_150 VPWR VGND sg13cmos5l_decap_4
XANTENNA__0875__X Tile_X0Y0_FrameData_O[19] VPWR VGND sg13cmos5l_antennanp
XFILLER_100_133 VPWR VGND sg13cmos5l_decap_8
XFILLER_14_128 VPWR VGND sg13cmos5l_decap_8
XANTENNA__0785__X Tile_X0Y0_N2BEGb[2] VPWR VGND sg13cmos5l_antennanp
XFILLER_93_42 VPWR VGND sg13cmos5l_decap_8
XFILLER_13_150 VPWR VGND sg13cmos5l_decap_4
XFILLER_13_183 VPWR VGND sg13cmos5l_decap_8
X_0861_ Tile_X0Y0_FrameData_O[5] Tile_X0Y0_FrameData[5] VPWR VGND sg13cmos5l_buf_1
X_0930_ Tile_X0Y1_W2BEG[1] _1148_/X VPWR VGND sg13cmos5l_buf_1
X_0792_ Tile_X0Y0_N2BEG[1] _1004_/X VPWR VGND sg13cmos5l_buf_1
XFILLER_3_84 VPWR VGND sg13cmos5l_decap_8
X_0226_ _0226_/Q Tile_X0Y0_FrameData[26] VGND VPWR Tile_X0Y1_FrameStrobe[4] latch
XFILLER_95_142 VPWR VGND sg13cmos5l_decap_8
X_0157_ _0157_/Q Tile_X0Y0_FrameData[31] VGND VPWR Tile_X0Y1_FrameStrobe[2] latch
X_0088_ _0093_/D _0998_/X _0609_/Q VPWR VGND sg13cmos5l_or2_1
XFILLER_105_203 VPWR VGND sg13cmos5l_decap_4
XFILLER_138_49 VPWR VGND sg13cmos5l_decap_8
XFILLER_22_38 VPWR VGND sg13cmos5l_decap_8
XFILLER_120_217 VPWR VGND sg13cmos5l_fill_1
XFILLER_47_13 VPWR VGND sg13cmos5l_decap_8
XFILLER_103_85 VPWR VGND sg13cmos5l_decap_8
XFILLER_6_102 VPWR VGND sg13cmos5l_decap_8
XFILLER_10_197 VPWR VGND sg13cmos5l_decap_8
XFILLER_111_217 VPWR VGND sg13cmos5l_fill_1
XFILLER_128_93 VPWR VGND sg13cmos5l_decap_8
XFILLER_6_168 VPWR VGND sg13cmos5l_decap_8
XFILLER_77_186 VPWR VGND sg13cmos5l_decap_8
XFILLER_77_197 VPWR VGND sg13cmos5l_fill_1
X_1060_ _1060_/X _0637_/Q _0641_/Q _1090_/X _1094_/X _0208_/Q _0207_/Q VPWR VGND sg13cmos5l_mux4_1
XFILLER_92_145 VPWR VGND sg13cmos5l_decap_8
X_0913_ Tile_X0Y1_S4BEG[5] Tile_X0Y0_S4END[13] VPWR VGND sg13cmos5l_buf_1
X_0844_ Tile_X0Y1_FrameData_O[20] Tile_X0Y1_FrameData[20] VPWR VGND sg13cmos5l_buf_1
X_0775_ Tile_X0Y0_WW4BEG[8] _1055_/X VPWR VGND sg13cmos5l_buf_1
XFILLER_45_0 VPWR VGND sg13cmos5l_decap_4
XFILLER_5_190 VPWR VGND sg13cmos5l_decap_8
XFILLER_83_101 VPWR VGND sg13cmos5l_decap_8
XFILLER_83_178 VPWR VGND sg13cmos5l_decap_8
X_1189_ _1189_/X _0646_/Q _1204_/X _1208_/X _1201_/X _0438_/Q _0437_/Q VPWR VGND sg13cmos5l_mux4_1
X_0209_ _0209_/Q Tile_X0Y0_FrameData[11] VGND VPWR Tile_X0Y1_FrameStrobe[3] latch
XFILLER_123_7 VPWR VGND sg13cmos5l_fill_1
XFILLER_137_147 VPWR VGND sg13cmos5l_decap_8
XFILLER_3_105 VPWR VGND sg13cmos5l_decap_8
XFILLER_114_51 VPWR VGND sg13cmos5l_fill_2
XFILLER_74_123 VPWR VGND sg13cmos5l_decap_8
XFILLER_130_72 VPWR VGND sg13cmos5l_decap_8
XFILLER_30_204 VPWR VGND sg13cmos5l_decap_8
XFILLER_90_32 VPWR VGND sg13cmos5l_decap_8
XFILLER_128_136 VPWR VGND sg13cmos5l_decap_8
XFILLER_139_92 VPWR VGND sg13cmos5l_decap_8
X_0560_ _0560_/Q Tile_X0Y1_FrameData[10] VGND VPWR Tile_X0Y1_FrameStrobe[6] latch
X_0491_ _0491_/Q Tile_X0Y1_FrameData[15] VGND VPWR Tile_X0Y1_FrameStrobe[4] latch
XFILLER_99_85 VPWR VGND sg13cmos5l_decap_4
X_1043_ _1043_/X Tile_X0Y0_EE4END[11] _0640_/Q _1095_/X _1096_/X _0242_/Q _0241_/Q
+ VPWR VGND sg13cmos5l_mux4_1
X_1112_ _1112_/X Tile_X0Y1_E1END[1] Tile_X0Y1_E6END[5] _1216_/X _1192_/X _0600_/Q
+ _0599_/Q VPWR VGND sg13cmos5l_mux4_1
XFILLER_0_108 VPWR VGND sg13cmos5l_decap_8
XFILLER_134_128 VPWR VGND sg13cmos5l_decap_8
XFILLER_135_28 VPWR VGND sg13cmos5l_decap_4
X_0827_ Tile_X0Y1_FrameData_O[3] Tile_X0Y1_FrameData[3] VPWR VGND sg13cmos5l_buf_1
X_0758_ Tile_X0Y0_N4BEG[7] Tile_X0Y1_N4END[15] VPWR VGND sg13cmos5l_buf_1
XFILLER_88_215 VPWR VGND sg13cmos5l_fill_2
XFILLER_28_15 VPWR VGND sg13cmos5l_fill_1
XFILLER_56_123 VPWR VGND sg13cmos5l_decap_8
XFILLER_56_134 VPWR VGND sg13cmos5l_fill_1
XFILLER_56_156 VPWR VGND sg13cmos5l_decap_8
X_0689_ _0689_/L_HI VPWR VGND sg13cmos5l_tiehi
XANTENNA__0883__X Tile_X0Y0_FrameData_O[27] VPWR VGND sg13cmos5l_antennanp
XFILLER_100_20 VPWR VGND sg13cmos5l_decap_8
XFILLER_56_167 VPWR VGND sg13cmos5l_fill_1
XFILLER_56_178 VPWR VGND sg13cmos5l_fill_1
XFILLER_71_126 VPWR VGND sg13cmos5l_decap_8
XFILLER_109_40 VPWR VGND sg13cmos5l_decap_8
XFILLER_121_4 VPWR VGND sg13cmos5l_fill_1
XFILLER_125_117 VPWR VGND sg13cmos5l_decap_8
XFILLER_118_191 VPWR VGND sg13cmos5l_decap_8
XFILLER_133_172 VPWR VGND sg13cmos5l_decap_8
XFILLER_94_207 VPWR VGND sg13cmos5l_decap_8
XANTENNA__0793__X Tile_X0Y0_N2BEG[2] VPWR VGND sg13cmos5l_antennanp
XFILLER_47_156 VPWR VGND sg13cmos5l_decap_8
XFILLER_62_148 VPWR VGND sg13cmos5l_decap_8
XFILLER_62_159 VPWR VGND sg13cmos5l_decap_8
XANTENNA__0968__X Tile_X0Y1_WW4BEG[11] VPWR VGND sg13cmos5l_antennanp
XFILLER_124_161 VPWR VGND sg13cmos5l_decap_8
X_0612_ NPU_WEIGHT_IN2 Tile_X0Y1_UserCLK _0992_/X _0695_/L_HI VPWR VGND sg13cmos5l_dfrbpq_1
XFILLER_22_2 VPWR VGND sg13cmos5l_fill_1
X_0543_ _0543_/Q Tile_X0Y1_FrameData[27] VGND VPWR Tile_X0Y1_FrameStrobe[6] latch
X_0474_ _0474_/Q Tile_X0Y1_FrameData[0] VGND VPWR Tile_X0Y1_FrameStrobe[3] latch
X_1026_ _1026_/X _1084_/X _1080_/X _1079_/X _1099_/X _0277_/Q _0276_/Q VPWR VGND sg13cmos5l_mux4_1
XFILLER_61_181 VPWR VGND sg13cmos5l_decap_4
XANTENNA__0878__X Tile_X0Y0_FrameData_O[22] VPWR VGND sg13cmos5l_antennanp
XFILLER_130_142 VPWR VGND sg13cmos5l_decap_8
XFILLER_39_25 VPWR VGND sg13cmos5l_decap_8
XFILLER_44_148 VPWR VGND sg13cmos5l_decap_8
XFILLER_55_79 VPWR VGND sg13cmos5l_fill_1
XFILLER_71_56 VPWR VGND sg13cmos5l_decap_8
XFILLER_112_0 VPWR VGND sg13cmos5l_decap_4
XFILLER_113_109 VPWR VGND sg13cmos5l_decap_8
XANTENNA__0788__X Tile_X0Y0_N2BEGb[5] VPWR VGND sg13cmos5l_antennanp
XFILLER_106_183 VPWR VGND sg13cmos5l_decap_8
XFILLER_121_153 VPWR VGND sg13cmos5l_decap_8
XFILLER_96_86 VPWR VGND sg13cmos5l_decap_4
XFILLER_35_104 VPWR VGND sg13cmos5l_decap_8
X_0190_ _0190_/Q Tile_X0Y0_FrameData[30] VGND VPWR Tile_X0Y1_FrameStrobe[3] latch
XFILLER_84_4 VPWR VGND sg13cmos5l_fill_2
XFILLER_112_142 VPWR VGND sg13cmos5l_decap_8
XFILLER_6_73 VPWR VGND sg13cmos5l_decap_8
X_0526_ _0526_/Q Tile_X0Y1_FrameData[12] VGND VPWR Tile_X0Y1_FrameStrobe[5] latch
XFILLER_81_210 VPWR VGND sg13cmos5l_decap_8
X_0457_ _0457_/Q Tile_X0Y1_FrameData[17] VGND VPWR Tile_X0Y1_FrameStrobe[3] latch
X_0388_ _0388_/Q Tile_X0Y1_FrameData[22] VGND VPWR Tile_X0Y1_FrameStrobe[1] latch
XFILLER_25_38 VPWR VGND sg13cmos5l_decap_8
XFILLER_25_49 VPWR VGND sg13cmos5l_fill_2
XFILLER_41_107 VPWR VGND sg13cmos5l_fill_1
XFILLER_41_129 VPWR VGND sg13cmos5l_decap_4
X_1009_ _1009_/X Tile_X0Y0_E2MID[1] Tile_X0Y0_E2END[1] Tile_X0Y0_E6END[1] _1098_/X
+ _0326_/Q _0325_/Q VPWR VGND sg13cmos5l_mux4_1
XFILLER_17_137 VPWR VGND sg13cmos5l_fill_2
XFILLER_72_210 VPWR VGND sg13cmos5l_decap_8
XFILLER_82_44 VPWR VGND sg13cmos5l_decap_8
XFILLER_141_215 VPWR VGND sg13cmos5l_fill_2
XFILLER_31_70 VPWR VGND sg13cmos5l_decap_8
XFILLER_99_129 VPWR VGND sg13cmos5l_decap_8
XFILLER_99_107 VPWR VGND sg13cmos5l_decap_8
X_0311_ _0311_/Q Tile_X0Y0_FrameData[5] VGND VPWR Tile_X0Y1_FrameStrobe[6] latch
X_0242_ _0242_/Q Tile_X0Y0_FrameData[10] VGND VPWR Tile_X0Y1_FrameStrobe[4] latch
X_0173_ _0173_/Q Tile_X0Y0_FrameData[15] VGND VPWR Tile_X0Y1_FrameStrobe[2] latch
XFILLER_23_129 VPWR VGND sg13cmos5l_decap_8
XFILLER_117_201 VPWR VGND sg13cmos5l_decap_4
XFILLER_127_18 VPWR VGND sg13cmos5l_decap_8
XFILLER_75_0 VPWR VGND sg13cmos5l_decap_4
X_0509_ _0509_/Q Tile_X0Y1_FrameData[29] VGND VPWR Tile_X0Y1_FrameStrobe[5] latch
XFILLER_98_184 VPWR VGND sg13cmos5l_decap_8
XFILLER_100_189 VPWR VGND sg13cmos5l_decap_8
XFILLER_36_26 VPWR VGND sg13cmos5l_decap_8
XANTENNA__0891__X Tile_X0Y1_S1BEG[3] VPWR VGND sg13cmos5l_antennanp
XFILLER_52_14 VPWR VGND sg13cmos5l_fill_2
XFILLER_52_69 VPWR VGND sg13cmos5l_decap_8
XFILLER_117_40 VPWR VGND sg13cmos5l_decap_8
XFILLER_123_204 VPWR VGND sg13cmos5l_fill_2
XFILLER_89_140 VPWR VGND sg13cmos5l_fill_1
XFILLER_45_210 VPWR VGND sg13cmos5l_decap_8
XFILLER_77_55 VPWR VGND sg13cmos5l_decap_8
XFILLER_89_151 VPWR VGND sg13cmos5l_decap_4
XFILLER_26_92 VPWR VGND sg13cmos5l_decap_8
XFILLER_9_100 VPWR VGND sg13cmos5l_decap_4
X_0860_ Tile_X0Y0_FrameData_O[4] Tile_X0Y0_FrameData[4] VPWR VGND sg13cmos5l_buf_1
X_0791_ Tile_X0Y0_N2BEG[0] _1003_/X VPWR VGND sg13cmos5l_buf_1
XFILLER_3_63 VPWR VGND sg13cmos5l_decap_8
XFILLER_47_4 VPWR VGND sg13cmos5l_fill_2
XFILLER_95_121 VPWR VGND sg13cmos5l_decap_8
X_0225_ _0225_/Q Tile_X0Y0_FrameData[27] VGND VPWR Tile_X0Y1_FrameStrobe[4] latch
X_0156_ _0156_/Q Tile_X0Y0_FrameData[0] VGND VPWR Tile_X0Y1_FrameStrobe[1] latch
X_0087_ _0089_/D _0604_/Q _1235_/X VPWR VGND sg13cmos5l_nor2b_1
XFILLER_138_28 VPWR VGND sg13cmos5l_fill_1
X_0989_ _0989_/X Tile_X0Y1_EE4END[7] Tile_X0Y1_EE4END[15] Tile_X0Y1_E6END[7] _1210_/X
+ _0420_/Q _0419_/Q VPWR VGND sg13cmos5l_mux4_1
XANTENNA__0886__X Tile_X0Y0_FrameData_O[30] VPWR VGND sg13cmos5l_antennanp
XFILLER_27_210 VPWR VGND sg13cmos5l_decap_8
XFILLER_103_20 VPWR VGND sg13cmos5l_fill_2
XFILLER_103_64 VPWR VGND sg13cmos5l_decap_8
XFILLER_63_35 VPWR VGND sg13cmos5l_decap_4
XFILLER_10_132 VPWR VGND sg13cmos5l_fill_2
XFILLER_10_143 VPWR VGND sg13cmos5l_fill_2
XFILLER_10_176 VPWR VGND sg13cmos5l_decap_8
XFILLER_6_147 VPWR VGND sg13cmos5l_fill_2
XANTENNA__0796__X Tile_X0Y0_N2BEG[5] VPWR VGND sg13cmos5l_antennanp
XFILLER_5_0 VPWR VGND sg13cmos5l_decap_4
XFILLER_88_76 VPWR VGND sg13cmos5l_fill_1
XFILLER_77_132 VPWR VGND sg13cmos5l_decap_4
XFILLER_77_165 VPWR VGND sg13cmos5l_decap_8
XFILLER_92_124 VPWR VGND sg13cmos5l_decap_8
X_0912_ Tile_X0Y1_S4BEG[4] Tile_X0Y0_S4END[12] VPWR VGND sg13cmos5l_buf_1
X_0843_ Tile_X0Y1_FrameData_O[19] Tile_X0Y1_FrameData[19] VPWR VGND sg13cmos5l_buf_1
X_0774_ Tile_X0Y0_WW4BEG[7] _1054_/X VPWR VGND sg13cmos5l_buf_1
XFILLER_102_207 VPWR VGND sg13cmos5l_decap_8
XFILLER_38_0 VPWR VGND sg13cmos5l_decap_8
XFILLER_68_154 VPWR VGND sg13cmos5l_decap_8
XFILLER_83_157 VPWR VGND sg13cmos5l_decap_8
X_1188_ _1188_/X _0645_/Q _1205_/X _1209_/X _1200_/X _0440_/Q _0439_/Q VPWR VGND sg13cmos5l_mux4_1
X_0208_ _0208_/Q Tile_X0Y0_FrameData[12] VGND VPWR Tile_X0Y1_FrameStrobe[3] latch
X_0139_ _0139_/Q Tile_X0Y0_FrameData[17] VGND VPWR Tile_X0Y1_FrameStrobe[1] latch
XFILLER_137_126 VPWR VGND sg13cmos5l_decap_8
XFILLER_58_13 VPWR VGND sg13cmos5l_decap_8
XFILLER_58_24 VPWR VGND sg13cmos5l_fill_1
XFILLER_114_96 VPWR VGND sg13cmos5l_decap_4
XFILLER_74_179 VPWR VGND sg13cmos5l_decap_8
XFILLER_90_88 VPWR VGND sg13cmos5l_fill_1
XFILLER_128_115 VPWR VGND sg13cmos5l_decap_8
XFILLER_136_192 VPWR VGND sg13cmos5l_decap_8
XFILLER_99_75 VPWR VGND sg13cmos5l_fill_2
XFILLER_2_172 VPWR VGND sg13cmos5l_decap_4
XFILLER_31_7 VPWR VGND sg13cmos5l_fill_1
X_0490_ _0490_/Q Tile_X0Y1_FrameData[16] VGND VPWR Tile_X0Y1_FrameStrobe[4] latch
XFILLER_0_42 VPWR VGND sg13cmos5l_decap_8
XFILLER_0_53 VPWR VGND sg13cmos5l_fill_2
XFILLER_65_124 VPWR VGND sg13cmos5l_decap_8
XFILLER_65_168 VPWR VGND sg13cmos5l_fill_1
XFILLER_80_149 VPWR VGND sg13cmos5l_decap_8
X_1042_ _1042_/X Tile_X0Y0_EE4END[10] _0639_/Q _1095_/X _1096_/X _0244_/Q _0243_/Q
+ VPWR VGND sg13cmos5l_mux4_1
X_1111_ _1111_/X Tile_X0Y1_E1END[0] Tile_X0Y1_E6END[4] _1215_/X _1191_/X _0602_/Q
+ _0601_/Q VPWR VGND sg13cmos5l_mux4_1
XFILLER_119_115 VPWR VGND sg13cmos5l_decap_8
XFILLER_119_137 VPWR VGND sg13cmos5l_fill_1
XFILLER_119_159 VPWR VGND sg13cmos5l_decap_8
XFILLER_127_170 VPWR VGND sg13cmos5l_decap_8
XFILLER_134_107 VPWR VGND sg13cmos5l_decap_8
X_0826_ Tile_X0Y1_FrameData_O[2] Tile_X0Y1_FrameData[2] VPWR VGND sg13cmos5l_buf_1
X_0757_ Tile_X0Y0_N4BEG[6] Tile_X0Y1_N4END[14] VPWR VGND sg13cmos5l_buf_1
X_0688_ _0688_/L_HI VPWR VGND sg13cmos5l_tiehi
XFILLER_28_49 VPWR VGND sg13cmos5l_decap_8
XFILLER_71_105 VPWR VGND sg13cmos5l_decap_8
XFILLER_114_4 VPWR VGND sg13cmos5l_fill_1
XFILLER_118_170 VPWR VGND sg13cmos5l_decap_8
XFILLER_60_47 VPWR VGND sg13cmos5l_fill_1
XFILLER_60_69 VPWR VGND sg13cmos5l_decap_8
XFILLER_125_84 VPWR VGND sg13cmos5l_decap_4
XFILLER_133_151 VPWR VGND sg13cmos5l_decap_8
XFILLER_69_56 VPWR VGND sg13cmos5l_decap_8
XFILLER_79_205 VPWR VGND sg13cmos5l_fill_2
XFILLER_141_94 VPWR VGND sg13cmos5l_decap_8
XFILLER_18_82 VPWR VGND sg13cmos5l_decap_8
XFILLER_47_135 VPWR VGND sg13cmos5l_decap_8
XFILLER_62_105 VPWR VGND sg13cmos5l_decap_8
XFILLER_62_127 VPWR VGND sg13cmos5l_decap_8
XFILLER_85_55 VPWR VGND sg13cmos5l_decap_8
XFILLER_70_182 VPWR VGND sg13cmos5l_fill_2
XFILLER_109_192 VPWR VGND sg13cmos5l_decap_8
XFILLER_124_140 VPWR VGND sg13cmos5l_decap_8
X_0611_ NPU_WEIGHT_IN1 Tile_X0Y1_UserCLK _0991_/X _0696_/L_HI VPWR VGND sg13cmos5l_dfrbpq_1
X_0542_ _0542_/Q Tile_X0Y1_FrameData[28] VGND VPWR Tile_X0Y1_FrameStrobe[6] latch
X_0473_ _0473_/Q Tile_X0Y1_FrameData[1] VGND VPWR Tile_X0Y1_FrameStrobe[3] latch
X_1025_ _1025_/X Tile_X0Y0_E1END[3] Tile_X0Y0_EE4END[15] Tile_X0Y0_E6END[7] _1091_/X
+ _0277_/Q _0276_/Q VPWR VGND sg13cmos5l_mux4_1
X_0809_ Tile_X0Y0_FrameStrobe_O[6] Tile_X0Y1_FrameStrobe[6] VPWR VGND sg13cmos5l_buf_1
XFILLER_115_195 VPWR VGND sg13cmos5l_decap_4
XFILLER_130_121 VPWR VGND sg13cmos5l_decap_8
XANTENNA__0894__X Tile_X0Y1_S2BEG[2] VPWR VGND sg13cmos5l_antennanp
XFILLER_111_31 VPWR VGND sg13cmos5l_decap_8
XFILLER_130_198 VPWR VGND sg13cmos5l_decap_8
XFILLER_29_146 VPWR VGND sg13cmos5l_decap_4
XFILLER_29_157 VPWR VGND sg13cmos5l_decap_8
XFILLER_29_168 VPWR VGND sg13cmos5l_fill_2
XFILLER_44_127 VPWR VGND sg13cmos5l_decap_8
XFILLER_52_160 VPWR VGND sg13cmos5l_decap_8
XFILLER_52_171 VPWR VGND sg13cmos5l_fill_1
XFILLER_71_35 VPWR VGND sg13cmos5l_decap_8
XFILLER_105_0 VPWR VGND sg13cmos5l_decap_8
XFILLER_106_151 VPWR VGND sg13cmos5l_decap_8
XFILLER_20_50 VPWR VGND sg13cmos5l_fill_2
XFILLER_121_121 VPWR VGND sg13cmos5l_decap_8
XFILLER_29_92 VPWR VGND sg13cmos5l_decap_8
XFILLER_96_65 VPWR VGND sg13cmos5l_decap_8
XFILLER_96_43 VPWR VGND sg13cmos5l_fill_1
XFILLER_90_211 VPWR VGND sg13cmos5l_decap_8
XANTENNA_1 NPU_OUT_ACT0 VPWR VGND sg13cmos5l_antennanp
XFILLER_129_210 VPWR VGND sg13cmos5l_decap_8
XFILLER_6_52 VPWR VGND sg13cmos5l_decap_8
XFILLER_77_4 VPWR VGND sg13cmos5l_fill_2
XFILLER_112_132 VPWR VGND sg13cmos5l_fill_2
X_0525_ _0525_/Q Tile_X0Y1_FrameData[13] VGND VPWR Tile_X0Y1_FrameStrobe[5] latch
X_0456_ _0456_/Q Tile_X0Y1_FrameData[18] VGND VPWR Tile_X0Y1_FrameStrobe[3] latch
XFILLER_112_187 VPWR VGND sg13cmos5l_decap_8
XFILLER_132_19 VPWR VGND sg13cmos5l_decap_8
XFILLER_20_0 VPWR VGND sg13cmos5l_decap_4
X_0387_ _0387_/Q Tile_X0Y1_FrameData[23] VGND VPWR Tile_X0Y1_FrameStrobe[1] latch
XFILLER_34_160 VPWR VGND sg13cmos5l_decap_8
X_1008_ _1008_/X Tile_X0Y0_E2MID[2] Tile_X0Y0_E2END[2] Tile_X0Y0_E6END[2] _1097_/X
+ _0328_/Q _0327_/Q VPWR VGND sg13cmos5l_mux4_1
XANTENNA__0889__X Tile_X0Y1_S1BEG[1] VPWR VGND sg13cmos5l_antennanp
XFILLER_1_215 VPWR VGND sg13cmos5l_fill_2
XFILLER_106_42 VPWR VGND sg13cmos5l_decap_8
XFILLER_66_57 VPWR VGND sg13cmos5l_decap_8
XFILLER_25_193 VPWR VGND sg13cmos5l_decap_8
XFILLER_40_152 VPWR VGND sg13cmos5l_decap_8
XANTENNA__0799__X Tile_X0Y0_N1BEG[0] VPWR VGND sg13cmos5l_antennanp
X_0310_ _0310_/Q Tile_X0Y0_FrameData[6] VGND VPWR Tile_X0Y1_FrameStrobe[6] latch
X_0241_ _0241_/Q Tile_X0Y0_FrameData[11] VGND VPWR Tile_X0Y1_FrameStrobe[4] latch
X_0172_ _0172_/Q Tile_X0Y0_FrameData[16] VGND VPWR Tile_X0Y1_FrameStrobe[2] latch
XFILLER_31_174 VPWR VGND sg13cmos5l_decap_8
XFILLER_68_0 VPWR VGND sg13cmos5l_decap_8
X_0508_ _0508_/Q Tile_X0Y1_FrameData[30] VGND VPWR Tile_X0Y1_FrameStrobe[5] latch
X_0439_ _0439_/Q Tile_X0Y1_FrameData[3] VGND VPWR Tile_X0Y1_FrameStrobe[2] latch
XFILLER_108_213 VPWR VGND sg13cmos5l_decap_4
XFILLER_22_163 VPWR VGND sg13cmos5l_decap_8
XFILLER_52_48 VPWR VGND sg13cmos5l_decap_8
XFILLER_77_34 VPWR VGND sg13cmos5l_fill_2
XFILLER_7_4 VPWR VGND sg13cmos5l_fill_2
XFILLER_133_95 VPWR VGND sg13cmos5l_decap_8
XFILLER_26_71 VPWR VGND sg13cmos5l_decap_8
XFILLER_93_88 VPWR VGND sg13cmos5l_fill_2
XFILLER_93_77 VPWR VGND sg13cmos5l_decap_8
X_0790_ Tile_X0Y0_N2BEGb[7] _1110_/X VPWR VGND sg13cmos5l_buf_1
XFILLER_9_178 VPWR VGND sg13cmos5l_decap_8
XFILLER_3_42 VPWR VGND sg13cmos5l_decap_8
XFILLER_95_100 VPWR VGND sg13cmos5l_decap_8
XFILLER_51_203 VPWR VGND sg13cmos5l_fill_1
X_0224_ _0224_/Q Tile_X0Y0_FrameData[28] VGND VPWR Tile_X0Y1_FrameStrobe[4] latch
X_0155_ _0155_/Q Tile_X0Y0_FrameData[1] VGND VPWR Tile_X0Y1_FrameStrobe[1] latch
X_0086_ _0917_/A _1021_/X _1022_/X _0281_/Q VPWR VGND sg13cmos5l_mux2_1
XFILLER_95_199 VPWR VGND sg13cmos5l_decap_8
X_0988_ _0988_/X Tile_X0Y1_EE4END[6] Tile_X0Y1_EE4END[14] Tile_X0Y1_E6END[6] _1209_/X
+ _0422_/Q _0421_/Q VPWR VGND sg13cmos5l_mux4_1
XFILLER_47_48 VPWR VGND sg13cmos5l_fill_1
XFILLER_63_14 VPWR VGND sg13cmos5l_decap_8
XFILLER_10_111 VPWR VGND sg13cmos5l_decap_8
XFILLER_10_155 VPWR VGND sg13cmos5l_decap_8
XFILLER_6_126 VPWR VGND sg13cmos5l_decap_8
XFILLER_77_111 VPWR VGND sg13cmos5l_decap_8
X_0911_ Tile_X0Y1_S4BEG[3] Tile_X0Y0_S4END[11] VPWR VGND sg13cmos5l_buf_1
X_0842_ Tile_X0Y1_FrameData_O[18] Tile_X0Y1_FrameData[18] VPWR VGND sg13cmos5l_buf_1
X_0773_ Tile_X0Y0_WW4BEG[6] _1053_/X VPWR VGND sg13cmos5l_buf_1
XFILLER_83_136 VPWR VGND sg13cmos5l_decap_8
X_1187_ _1187_/X _0644_/Q _1206_/X _1210_/X _1199_/X _0442_/Q _0441_/Q VPWR VGND sg13cmos5l_mux4_1
X_0207_ _0207_/Q Tile_X0Y0_FrameData[13] VGND VPWR Tile_X0Y1_FrameStrobe[3] latch
X_0138_ _0138_/Q Tile_X0Y0_FrameData[18] VGND VPWR Tile_X0Y1_FrameStrobe[1] latch
X_0069_ _0919_/A _1025_/X _1026_/X _0275_/Q VPWR VGND sg13cmos5l_mux2_1
XFILLER_137_105 VPWR VGND sg13cmos5l_decap_8
XANTENNA__0897__X Tile_X0Y1_S2BEG[5] VPWR VGND sg13cmos5l_antennanp
XFILLER_109_7 VPWR VGND sg13cmos5l_decap_8
XFILLER_59_111 VPWR VGND sg13cmos5l_decap_8
XFILLER_114_64 VPWR VGND sg13cmos5l_decap_4
XFILLER_114_75 VPWR VGND sg13cmos5l_decap_8
XFILLER_15_203 VPWR VGND sg13cmos5l_fill_1
XFILLER_74_13 VPWR VGND sg13cmos5l_decap_4
XFILLER_74_158 VPWR VGND sg13cmos5l_decap_8
XFILLER_74_35 VPWR VGND sg13cmos5l_fill_1
XFILLER_135_0 VPWR VGND sg13cmos5l_decap_8
XFILLER_23_72 VPWR VGND sg13cmos5l_fill_1
XFILLER_90_67 VPWR VGND sg13cmos5l_decap_8
XFILLER_139_61 VPWR VGND sg13cmos5l_fill_1
XFILLER_99_54 VPWR VGND sg13cmos5l_decap_8
XFILLER_2_195 VPWR VGND sg13cmos5l_decap_8
XFILLER_65_103 VPWR VGND sg13cmos5l_decap_8
X_1110_ _1110_/X Tile_X0Y1_E2MID[0] Tile_X0Y1_E2END[0] Tile_X0Y1_E6END[0] _1202_/X
+ _0580_/Q _0579_/Q VPWR VGND sg13cmos5l_mux4_1
XFILLER_97_217 VPWR VGND sg13cmos5l_fill_1
XFILLER_0_21 VPWR VGND sg13cmos5l_decap_8
XFILLER_0_87 VPWR VGND sg13cmos5l_decap_4
XFILLER_21_217 VPWR VGND sg13cmos5l_fill_1
XFILLER_80_128 VPWR VGND sg13cmos5l_decap_8
X_1041_ _1041_/X Tile_X0Y0_EE4END[9] _0638_/Q _1094_/X _1097_/X _0246_/Q _0245_/Q
+ VPWR VGND sg13cmos5l_mux4_1
XFILLER_119_127 VPWR VGND sg13cmos5l_fill_2
X_0825_ Tile_X0Y1_FrameData_O[1] Tile_X0Y1_FrameData[1] VPWR VGND sg13cmos5l_buf_1
XFILLER_127_193 VPWR VGND sg13cmos5l_decap_8
XFILLER_50_0 VPWR VGND sg13cmos5l_decap_4
X_0756_ Tile_X0Y0_N4BEG[5] Tile_X0Y1_N4END[13] VPWR VGND sg13cmos5l_buf_1
X_0687_ _0687_/L_HI VPWR VGND sg13cmos5l_tiehi
XFILLER_88_217 VPWR VGND sg13cmos5l_fill_1
XFILLER_28_28 VPWR VGND sg13cmos5l_decap_8
XFILLER_100_11 VPWR VGND sg13cmos5l_decap_4
XFILLER_12_206 VPWR VGND sg13cmos5l_fill_1
XFILLER_12_217 VPWR VGND sg13cmos5l_fill_1
XFILLER_44_49 VPWR VGND sg13cmos5l_decap_8
XFILLER_60_26 VPWR VGND sg13cmos5l_decap_8
XFILLER_109_75 VPWR VGND sg13cmos5l_decap_8
XFILLER_133_130 VPWR VGND sg13cmos5l_decap_8
XFILLER_69_35 VPWR VGND sg13cmos5l_decap_8
XFILLER_125_63 VPWR VGND sg13cmos5l_decap_8
XFILLER_125_96 VPWR VGND sg13cmos5l_decap_8
XFILLER_79_217 VPWR VGND sg13cmos5l_fill_1
XFILLER_85_34 VPWR VGND sg13cmos5l_decap_8
XFILLER_141_73 VPWR VGND sg13cmos5l_decap_8
XFILLER_18_61 VPWR VGND sg13cmos5l_decap_8
XFILLER_70_161 VPWR VGND sg13cmos5l_decap_8
XFILLER_116_108 VPWR VGND sg13cmos5l_decap_8
XFILLER_34_93 VPWR VGND sg13cmos5l_decap_8
XFILLER_7_210 VPWR VGND sg13cmos5l_decap_8
XFILLER_124_196 VPWR VGND sg13cmos5l_decap_8
X_0610_ NPU_WEIGHT_IN0 Tile_X0Y1_UserCLK _0990_/X _0693_/L_HI VPWR VGND sg13cmos5l_dfrbpq_1
X_0541_ _0541_/Q Tile_X0Y1_FrameData[29] VGND VPWR Tile_X0Y1_FrameStrobe[6] latch
X_0472_ _0472_/Q Tile_X0Y1_FrameData[2] VGND VPWR Tile_X0Y1_FrameStrobe[3] latch
XFILLER_38_103 VPWR VGND sg13cmos5l_fill_1
XFILLER_38_136 VPWR VGND sg13cmos5l_decap_8
XFILLER_53_128 VPWR VGND sg13cmos5l_decap_8
X_1024_ _1024_/X _1085_/X _1081_/X _1077_/X _1098_/X _0280_/Q _0279_/Q VPWR VGND sg13cmos5l_mux4_1
XFILLER_46_191 VPWR VGND sg13cmos5l_decap_8
XFILLER_98_0 VPWR VGND sg13cmos5l_decap_8
X_0808_ Tile_X0Y0_FrameStrobe_O[5] Tile_X0Y1_FrameStrobe[5] VPWR VGND sg13cmos5l_buf_1
XFILLER_130_100 VPWR VGND sg13cmos5l_decap_8
XFILLER_130_177 VPWR VGND sg13cmos5l_decap_8
X_0739_ Tile_X0Y0_W6BEG[0] _1063_/X VPWR VGND sg13cmos5l_buf_1
XFILLER_111_21 VPWR VGND sg13cmos5l_fill_2
XFILLER_44_106 VPWR VGND sg13cmos5l_decap_8
XFILLER_55_59 VPWR VGND sg13cmos5l_decap_4
XFILLER_71_14 VPWR VGND sg13cmos5l_decap_8
XFILLER_136_84 VPWR VGND sg13cmos5l_decap_8
XFILLER_121_188 VPWR VGND sg13cmos5l_decap_8
XFILLER_28_180 VPWR VGND sg13cmos5l_decap_8
XFILLER_35_139 VPWR VGND sg13cmos5l_decap_8
XFILLER_43_150 VPWR VGND sg13cmos5l_decap_8
XFILLER_43_161 VPWR VGND sg13cmos5l_fill_1
XFILLER_43_194 VPWR VGND sg13cmos5l_decap_8
XFILLER_91_7 VPWR VGND sg13cmos5l_decap_8
XANTENNA_2 NPU_OUT_ACT2 VPWR VGND sg13cmos5l_antennanp
X_0524_ _0524_/Q Tile_X0Y1_FrameData[14] VGND VPWR Tile_X0Y1_FrameStrobe[5] latch
X_0455_ _0455_/Q Tile_X0Y1_FrameData[19] VGND VPWR Tile_X0Y1_FrameStrobe[3] latch
XFILLER_13_0 VPWR VGND sg13cmos5l_fill_2
XFILLER_26_106 VPWR VGND sg13cmos5l_decap_8
X_1007_ _1007_/X Tile_X0Y0_E2MID[3] Tile_X0Y0_E2END[3] Tile_X0Y0_E6END[3] _1096_/X
+ _0330_/Q _0329_/Q VPWR VGND sg13cmos5l_mux4_1
X_0386_ _0386_/Q Tile_X0Y1_FrameData[24] VGND VPWR Tile_X0Y1_FrameStrobe[1] latch
XFILLER_41_28 VPWR VGND sg13cmos5l_decap_4
XFILLER_135_214 VPWR VGND sg13cmos5l_decap_4
XFILLER_103_144 VPWR VGND sg13cmos5l_fill_2
XFILLER_103_188 VPWR VGND sg13cmos5l_decap_8
XFILLER_17_106 VPWR VGND sg13cmos5l_decap_8
XFILLER_66_14 VPWR VGND sg13cmos5l_decap_8
XFILLER_66_36 VPWR VGND sg13cmos5l_decap_8
XFILLER_122_53 VPWR VGND sg13cmos5l_decap_4
XFILLER_40_131 VPWR VGND sg13cmos5l_decap_8
XFILLER_82_79 VPWR VGND sg13cmos5l_decap_8
XFILLER_40_186 VPWR VGND sg13cmos5l_decap_8
XFILLER_141_217 VPWR VGND sg13cmos5l_fill_1
X_0240_ _0240_/Q Tile_X0Y0_FrameData[12] VGND VPWR Tile_X0Y1_FrameStrobe[4] latch
XFILLER_56_91 VPWR VGND sg13cmos5l_fill_1
X_0171_ _0171_/Q Tile_X0Y0_FrameData[17] VGND VPWR Tile_X0Y1_FrameStrobe[2] latch
XFILLER_16_183 VPWR VGND sg13cmos5l_decap_8
XFILLER_31_153 VPWR VGND sg13cmos5l_decap_8
XFILLER_132_206 VPWR VGND sg13cmos5l_decap_8
XFILLER_132_217 VPWR VGND sg13cmos5l_fill_1
XFILLER_98_120 VPWR VGND sg13cmos5l_fill_2
XFILLER_100_103 VPWR VGND sg13cmos5l_decap_4
XFILLER_100_147 VPWR VGND sg13cmos5l_decap_8
X_0507_ _0507_/Q Tile_X0Y1_FrameData[31] VGND VPWR Tile_X0Y1_FrameStrobe[5] latch
X_0438_ _0438_/Q Tile_X0Y1_FrameData[4] VGND VPWR Tile_X0Y1_FrameStrobe[2] latch
X_0369_ _0369_/Q Tile_X0Y1_FrameData[9] VGND VPWR Tile_X0Y1_FrameStrobe[0] latch
XFILLER_22_120 VPWR VGND sg13cmos5l_fill_1
XFILLER_52_27 VPWR VGND sg13cmos5l_decap_8
XFILLER_123_206 VPWR VGND sg13cmos5l_fill_1
XFILLER_123_217 VPWR VGND sg13cmos5l_fill_1
XFILLER_133_52 VPWR VGND sg13cmos5l_decap_8
XFILLER_45_201 VPWR VGND sg13cmos5l_decap_4
XFILLER_26_61 VPWR VGND sg13cmos5l_decap_4
XFILLER_9_157 VPWR VGND sg13cmos5l_decap_8
XFILLER_114_206 VPWR VGND sg13cmos5l_decap_8
XFILLER_114_217 VPWR VGND sg13cmos5l_fill_1
XFILLER_54_7 VPWR VGND sg13cmos5l_decap_8
XFILLER_3_21 VPWR VGND sg13cmos5l_decap_8
XFILLER_3_98 VPWR VGND sg13cmos5l_fill_1
X_0223_ _0223_/Q Tile_X0Y0_FrameData[29] VGND VPWR Tile_X0Y1_FrameStrobe[4] latch
XFILLER_95_178 VPWR VGND sg13cmos5l_decap_8
XFILLER_95_156 VPWR VGND sg13cmos5l_decap_8
X_0154_ _0154_/Q Tile_X0Y0_FrameData[2] VGND VPWR Tile_X0Y1_FrameStrobe[1] latch
X_0085_ _0765_/A _1015_/X _1016_/X _0314_/Q VPWR VGND sg13cmos5l_mux2_1
XFILLER_80_0 VPWR VGND sg13cmos5l_decap_4
X_0987_ _0987_/X Tile_X0Y1_EE4END[5] Tile_X0Y1_EE4END[13] Tile_X0Y1_E6END[5] _1208_/X
+ _0424_/Q _0423_/Q VPWR VGND sg13cmos5l_mux4_1
XFILLER_8_190 VPWR VGND sg13cmos5l_decap_8
XFILLER_105_217 VPWR VGND sg13cmos5l_fill_1
XFILLER_47_27 VPWR VGND sg13cmos5l_decap_8
XFILLER_86_145 VPWR VGND sg13cmos5l_decap_8
XFILLER_86_167 VPWR VGND sg13cmos5l_decap_8
XFILLER_86_189 VPWR VGND sg13cmos5l_decap_8
XFILLER_103_99 VPWR VGND sg13cmos5l_decap_8
XFILLER_10_134 VPWR VGND sg13cmos5l_fill_1
XFILLER_42_204 VPWR VGND sg13cmos5l_decap_8
XFILLER_63_48 VPWR VGND sg13cmos5l_fill_2
XFILLER_128_52 VPWR VGND sg13cmos5l_fill_2
XFILLER_12_63 VPWR VGND sg13cmos5l_fill_2
XFILLER_6_149 VPWR VGND sg13cmos5l_fill_1
XFILLER_92_159 VPWR VGND sg13cmos5l_decap_8
X_0910_ Tile_X0Y1_S4BEG[2] Tile_X0Y0_S4END[10] VPWR VGND sg13cmos5l_buf_1
X_0841_ Tile_X0Y1_FrameData_O[17] Tile_X0Y1_FrameData[17] VPWR VGND sg13cmos5l_buf_1
X_0772_ Tile_X0Y0_WW4BEG[5] _1052_/X VPWR VGND sg13cmos5l_buf_1
XFILLER_83_115 VPWR VGND sg13cmos5l_decap_8
X_1186_ _1186_/X _0651_/Q _1207_/X _1211_/X _1198_/X _0444_/Q _0443_/Q VPWR VGND sg13cmos5l_mux4_1
X_0206_ _0206_/Q Tile_X0Y0_FrameData[14] VGND VPWR Tile_X0Y1_FrameStrobe[3] latch
XFILLER_24_204 VPWR VGND sg13cmos5l_fill_2
X_0137_ _0137_/Q Tile_X0Y0_FrameData[19] VGND VPWR Tile_X0Y1_FrameStrobe[1] latch
X_0068_ _0918_/A _1023_/X _1024_/X _0278_/Q VPWR VGND sg13cmos5l_mux2_1
XFILLER_91_181 VPWR VGND sg13cmos5l_decap_8
XFILLER_3_119 VPWR VGND sg13cmos5l_decap_8
XFILLER_74_137 VPWR VGND sg13cmos5l_decap_8
XFILLER_82_170 VPWR VGND sg13cmos5l_decap_8
XFILLER_128_0 VPWR VGND sg13cmos5l_fill_2
XFILLER_130_86 VPWR VGND sg13cmos5l_decap_8
XFILLER_23_51 VPWR VGND sg13cmos5l_decap_8
XFILLER_90_46 VPWR VGND sg13cmos5l_decap_8
XFILLER_90_13 VPWR VGND sg13cmos5l_fill_1
XFILLER_136_161 VPWR VGND sg13cmos5l_decap_8
XFILLER_136_172 VPWR VGND sg13cmos5l_fill_2
XFILLER_99_77 VPWR VGND sg13cmos5l_fill_1
X_1040_ _1040_/X Tile_X0Y0_EE4END[7] _0637_/Q _1093_/X _1098_/X _0248_/Q _0247_/Q
+ VPWR VGND sg13cmos5l_mux4_1
XFILLER_0_66 VPWR VGND sg13cmos5l_decap_8
XFILLER_64_80 VPWR VGND sg13cmos5l_decap_8
X_0824_ Tile_X0Y1_FrameData_O[0] Tile_X0Y1_FrameData[0] VPWR VGND sg13cmos5l_buf_1
X_0755_ Tile_X0Y0_N4BEG[4] Tile_X0Y1_N4END[12] VPWR VGND sg13cmos5l_buf_1
XFILLER_43_0 VPWR VGND sg13cmos5l_decap_8
X_0686_ _0686_/L_HI VPWR VGND sg13cmos5l_tiehi
XFILLER_44_28 VPWR VGND sg13cmos5l_decap_8
X_1169_ _1169_/X _0646_/Q _0650_/Q _1212_/X _1196_/X _0478_/Q _0477_/Q VPWR VGND sg13cmos5l_mux4_1
XFILLER_100_34 VPWR VGND sg13cmos5l_decap_8
XFILLER_109_54 VPWR VGND sg13cmos5l_decap_8
XFILLER_133_186 VPWR VGND sg13cmos5l_decap_8
XFILLER_69_14 VPWR VGND sg13cmos5l_decap_8
XFILLER_125_42 VPWR VGND sg13cmos5l_decap_8
XFILLER_133_197 VPWR VGND sg13cmos5l_fill_1
XFILLER_141_52 VPWR VGND sg13cmos5l_decap_4
XFILLER_34_72 VPWR VGND sg13cmos5l_decap_8
XFILLER_70_140 VPWR VGND sg13cmos5l_decap_8
XFILLER_109_161 VPWR VGND sg13cmos5l_fill_1
XFILLER_124_175 VPWR VGND sg13cmos5l_decap_8
X_0540_ _0540_/Q Tile_X0Y1_FrameData[30] VGND VPWR Tile_X0Y1_FrameStrobe[6] latch
X_0471_ _0471_/Q Tile_X0Y1_FrameData[3] VGND VPWR Tile_X0Y1_FrameStrobe[3] latch
XFILLER_15_4 VPWR VGND sg13cmos5l_fill_2
XFILLER_53_107 VPWR VGND sg13cmos5l_decap_8
X_1023_ _1023_/X Tile_X0Y0_E1END[2] Tile_X0Y0_EE4END[14] Tile_X0Y0_E6END[6] _1090_/X
+ _0280_/Q _0279_/Q VPWR VGND sg13cmos5l_mux4_1
XFILLER_93_210 VPWR VGND sg13cmos5l_decap_8
XFILLER_61_173 VPWR VGND sg13cmos5l_decap_4
X_0807_ Tile_X0Y0_FrameStrobe_O[4] Tile_X0Y1_FrameStrobe[4] VPWR VGND sg13cmos5l_buf_1
X_0738_ Tile_X0Y0_W2BEGb[7] _1046_/X VPWR VGND sg13cmos5l_buf_1
XFILLER_130_156 VPWR VGND sg13cmos5l_decap_8
XFILLER_39_39 VPWR VGND sg13cmos5l_decap_8
X_0669_ _0669_/L_HI VPWR VGND sg13cmos5l_tiehi
XFILLER_111_88 VPWR VGND sg13cmos5l_fill_1
XFILLER_138_201 VPWR VGND sg13cmos5l_decap_8
XFILLER_4_203 VPWR VGND sg13cmos5l_decap_4
XFILLER_106_197 VPWR VGND sg13cmos5l_decap_8
XFILLER_121_167 VPWR VGND sg13cmos5l_decap_8
XFILLER_136_63 VPWR VGND sg13cmos5l_decap_8
XFILLER_20_41 VPWR VGND sg13cmos5l_fill_2
XFILLER_20_52 VPWR VGND sg13cmos5l_fill_1
XFILLER_35_118 VPWR VGND sg13cmos5l_decap_8
XFILLER_43_173 VPWR VGND sg13cmos5l_decap_8
XFILLER_45_93 VPWR VGND sg13cmos5l_decap_8
XANTENNA_3 NPU_OUT_ACT3 VPWR VGND sg13cmos5l_antennanp
XFILLER_6_87 VPWR VGND sg13cmos5l_decap_8
XFILLER_6_98 VPWR VGND sg13cmos5l_fill_1
XFILLER_112_101 VPWR VGND sg13cmos5l_fill_1
XFILLER_112_134 VPWR VGND sg13cmos5l_fill_1
XFILLER_112_156 VPWR VGND sg13cmos5l_decap_8
X_0523_ _0523_/Q Tile_X0Y1_FrameData[15] VGND VPWR Tile_X0Y1_FrameStrobe[5] latch
X_0454_ _0454_/Q Tile_X0Y1_FrameData[20] VGND VPWR Tile_X0Y1_FrameStrobe[3] latch
X_0385_ _0385_/Q Tile_X0Y1_FrameData[25] VGND VPWR Tile_X0Y1_FrameStrobe[1] latch
XFILLER_19_181 VPWR VGND sg13cmos5l_decap_8
XFILLER_26_129 VPWR VGND sg13cmos5l_decap_8
X_1006_ _1006_/X Tile_X0Y0_E2MID[4] Tile_X0Y0_E2END[4] Tile_X0Y0_E6END[4] _1095_/X
+ _0332_/Q _0331_/Q VPWR VGND sg13cmos5l_mux4_1
XFILLER_106_11 VPWR VGND sg13cmos5l_decap_4
XFILLER_1_217 VPWR VGND sg13cmos5l_fill_1
XFILLER_106_99 VPWR VGND sg13cmos5l_fill_2
XFILLER_122_32 VPWR VGND sg13cmos5l_decap_8
XFILLER_57_210 VPWR VGND sg13cmos5l_decap_8
XFILLER_40_110 VPWR VGND sg13cmos5l_decap_8
XFILLER_40_165 VPWR VGND sg13cmos5l_decap_8
XFILLER_82_58 VPWR VGND sg13cmos5l_decap_8
XFILLER_110_0 VPWR VGND sg13cmos5l_fill_1
XFILLER_126_204 VPWR VGND sg13cmos5l_decap_8
XFILLER_31_40 VPWR VGND sg13cmos5l_decap_8
XFILLER_31_84 VPWR VGND sg13cmos5l_decap_8
XFILLER_48_210 VPWR VGND sg13cmos5l_decap_8
XFILLER_16_173 VPWR VGND sg13cmos5l_fill_2
XFILLER_63_213 VPWR VGND sg13cmos5l_fill_1
X_0170_ _0170_/Q Tile_X0Y0_FrameData[18] VGND VPWR Tile_X0Y1_FrameStrobe[2] latch
XFILLER_31_132 VPWR VGND sg13cmos5l_decap_8
X_0506_ _0506_/Q Tile_X0Y1_FrameData[0] VGND VPWR Tile_X0Y1_FrameStrobe[4] latch
XFILLER_98_154 VPWR VGND sg13cmos5l_fill_2
XFILLER_39_210 VPWR VGND sg13cmos5l_decap_8
X_0437_ _0437_/Q Tile_X0Y1_FrameData[5] VGND VPWR Tile_X0Y1_FrameStrobe[2] latch
X_0368_ _0368_/Q Tile_X0Y1_FrameData[10] VGND VPWR Tile_X0Y1_FrameStrobe[0] latch
XFILLER_98_198 VPWR VGND sg13cmos5l_decap_8
X_0299_ _0299_/Q Tile_X0Y0_FrameData[17] VGND VPWR Tile_X0Y1_FrameStrobe[6] latch
XFILLER_117_54 VPWR VGND sg13cmos5l_decap_8
XFILLER_133_31 VPWR VGND sg13cmos5l_decap_8
XFILLER_77_36 VPWR VGND sg13cmos5l_fill_1
XFILLER_77_69 VPWR VGND sg13cmos5l_decap_4
XFILLER_93_35 VPWR VGND sg13cmos5l_decap_8
XFILLER_13_143 VPWR VGND sg13cmos5l_decap_8
XFILLER_13_154 VPWR VGND sg13cmos5l_fill_1
XFILLER_42_61 VPWR VGND sg13cmos5l_decap_4
XFILLER_3_77 VPWR VGND sg13cmos5l_decap_8
X_0222_ _0222_/Q Tile_X0Y0_FrameData[30] VGND VPWR Tile_X0Y1_FrameStrobe[4] latch
X_0153_ _0153_/Q Tile_X0Y0_FrameData[3] VGND VPWR Tile_X0Y1_FrameStrobe[1] latch
XFILLER_95_135 VPWR VGND sg13cmos5l_decap_8
X_0084_ _0766_/A _1017_/X _1018_/X _0311_/Q VPWR VGND sg13cmos5l_mux2_1
XFILLER_73_0 VPWR VGND sg13cmos5l_fill_1
X_0986_ _0986_/X Tile_X0Y1_EE4END[4] Tile_X0Y1_EE4END[12] Tile_X0Y1_E6END[4] _1207_/X
+ _0426_/Q _0425_/Q VPWR VGND sg13cmos5l_mux4_1
XFILLER_86_102 VPWR VGND sg13cmos5l_decap_8
XFILLER_103_78 VPWR VGND sg13cmos5l_decap_8
XFILLER_128_86 VPWR VGND sg13cmos5l_decap_8
XFILLER_77_179 VPWR VGND sg13cmos5l_decap_8
XFILLER_92_138 VPWR VGND sg13cmos5l_decap_8
XFILLER_53_93 VPWR VGND sg13cmos5l_decap_8
X_0840_ Tile_X0Y1_FrameData_O[16] Tile_X0Y1_FrameData[16] VPWR VGND sg13cmos5l_buf_1
X_0771_ Tile_X0Y0_WW4BEG[4] _1051_/X VPWR VGND sg13cmos5l_buf_1
XFILLER_45_4 VPWR VGND sg13cmos5l_fill_1
XFILLER_5_183 VPWR VGND sg13cmos5l_decap_8
XFILLER_68_168 VPWR VGND sg13cmos5l_decap_4
XFILLER_68_179 VPWR VGND sg13cmos5l_decap_8
X_1185_ _1185_/X _0650_/Q _1208_/X _1212_/X _1197_/X _0446_/Q _0445_/Q VPWR VGND sg13cmos5l_mux4_1
X_0205_ _0205_/Q Tile_X0Y0_FrameData[15] VGND VPWR Tile_X0Y1_FrameStrobe[3] latch
X_0136_ _0136_/Q Tile_X0Y0_FrameData[20] VGND VPWR Tile_X0Y1_FrameStrobe[1] latch
XFILLER_91_160 VPWR VGND sg13cmos5l_decap_8
X_0969_ Tile_X0Y1_WW4BEG[12] _1175_/X VPWR VGND sg13cmos5l_buf_1
XFILLER_114_33 VPWR VGND sg13cmos5l_decap_4
XFILLER_114_44 VPWR VGND sg13cmos5l_decap_8
XFILLER_130_65 VPWR VGND sg13cmos5l_decap_8
XFILLER_90_25 VPWR VGND sg13cmos5l_decap_8
XFILLER_128_107 VPWR VGND sg13cmos5l_fill_1
XFILLER_128_129 VPWR VGND sg13cmos5l_decap_8
XFILLER_136_140 VPWR VGND sg13cmos5l_decap_8
XFILLER_139_52 VPWR VGND sg13cmos5l_fill_2
XFILLER_139_85 VPWR VGND sg13cmos5l_decap_8
XFILLER_3_0 VPWR VGND sg13cmos5l_decap_8
XFILLER_48_60 VPWR VGND sg13cmos5l_fill_1
XFILLER_48_82 VPWR VGND sg13cmos5l_decap_8
XFILLER_73_193 VPWR VGND sg13cmos5l_decap_8
XFILLER_119_129 VPWR VGND sg13cmos5l_fill_1
XFILLER_127_184 VPWR VGND sg13cmos5l_decap_4
X_0823_ FAB_USER_CLK Tile_X0Y1_UserCLK VPWR VGND sg13cmos5l_buf_1
X_0754_ Tile_X0Y0_N4BEG[3] Tile_X0Y1_N4END[11] VPWR VGND sg13cmos5l_buf_1
X_0685_ _0685_/L_HI VPWR VGND sg13cmos5l_tiehi
XFILLER_36_0 VPWR VGND sg13cmos5l_decap_8
XFILLER_56_116 VPWR VGND sg13cmos5l_decap_8
XFILLER_88_208 VPWR VGND sg13cmos5l_decap_8
XFILLER_56_149 VPWR VGND sg13cmos5l_decap_8
XFILLER_71_119 VPWR VGND sg13cmos5l_decap_8
X_1099_ _1099_/X _1110_/X Tile_X0Y1_N2MID[7] Tile_X0Y0_S2MID[7] Tile_X0Y0_S2END[7]
+ _0102_/Q _0101_/Q VPWR VGND sg13cmos5l_mux4_1
X_1168_ _1168_/X _0645_/Q _0649_/Q _1213_/X _1197_/X _0480_/Q _0479_/Q VPWR VGND sg13cmos5l_mux4_1
X_0119_ _0119_/Q Tile_X0Y0_FrameData[5] VGND VPWR Tile_X0Y1_FrameStrobe[0] latch
XFILLER_109_33 VPWR VGND sg13cmos5l_decap_8
XFILLER_118_184 VPWR VGND sg13cmos5l_decap_8
XFILLER_133_165 VPWR VGND sg13cmos5l_decap_8
XFILLER_141_31 VPWR VGND sg13cmos5l_decap_4
XFILLER_47_149 VPWR VGND sg13cmos5l_decap_8
XFILLER_62_119 VPWR VGND sg13cmos5l_decap_4
XFILLER_85_69 VPWR VGND sg13cmos5l_decap_4
XFILLER_140_0 VPWR VGND sg13cmos5l_fill_1
XFILLER_34_62 VPWR VGND sg13cmos5l_decap_4
XFILLER_55_171 VPWR VGND sg13cmos5l_fill_1
XFILLER_124_154 VPWR VGND sg13cmos5l_decap_8
X_0470_ _0470_/Q Tile_X0Y1_FrameData[4] VGND VPWR Tile_X0Y1_FrameStrobe[3] latch
XFILLER_61_152 VPWR VGND sg13cmos5l_decap_8
X_1022_ _1022_/X _1086_/X _1082_/X _1076_/X _1097_/X _0283_/Q _0282_/Q VPWR VGND sg13cmos5l_mux4_1
XFILLER_61_185 VPWR VGND sg13cmos5l_fill_1
XFILLER_91_90 VPWR VGND sg13cmos5l_decap_8
XANTENNA__0802__X Tile_X0Y0_N1BEG[3] VPWR VGND sg13cmos5l_antennanp
XFILLER_130_135 VPWR VGND sg13cmos5l_decap_8
XFILLER_39_18 VPWR VGND sg13cmos5l_decap_8
X_0806_ Tile_X0Y0_FrameStrobe_O[3] Tile_X0Y1_FrameStrobe[3] VPWR VGND sg13cmos5l_buf_1
X_0737_ Tile_X0Y0_W2BEGb[6] _1045_/X VPWR VGND sg13cmos5l_buf_1
X_0668_ _0668_/L_HI VPWR VGND sg13cmos5l_tiehi
XFILLER_29_127 VPWR VGND sg13cmos5l_decap_4
X_0599_ _0599_/Q Tile_X0Y1_FrameData[3] VGND VPWR Tile_X0Y1_FrameStrobe[7] latch
XFILLER_111_23 VPWR VGND sg13cmos5l_fill_1
XFILLER_111_45 VPWR VGND sg13cmos5l_fill_1
XFILLER_71_49 VPWR VGND sg13cmos5l_decap_8
XFILLER_112_4 VPWR VGND sg13cmos5l_fill_1
XFILLER_20_20 VPWR VGND sg13cmos5l_decap_8
XFILLER_121_135 VPWR VGND sg13cmos5l_fill_1
XFILLER_121_146 VPWR VGND sg13cmos5l_decap_8
XFILLER_136_42 VPWR VGND sg13cmos5l_decap_8
XFILLER_75_200 VPWR VGND sg13cmos5l_decap_8
XFILLER_96_79 VPWR VGND sg13cmos5l_decap_8
XFILLER_43_130 VPWR VGND sg13cmos5l_decap_8
XFILLER_43_141 VPWR VGND sg13cmos5l_fill_2
XFILLER_61_71 VPWR VGND sg13cmos5l_fill_1
XANTENNA_4 NPU_OUT_ACT4 VPWR VGND sg13cmos5l_antennanp
XFILLER_6_66 VPWR VGND sg13cmos5l_decap_8
X_0522_ _0522_/Q Tile_X0Y1_FrameData[16] VGND VPWR Tile_X0Y1_FrameStrobe[5] latch
XFILLER_66_200 VPWR VGND sg13cmos5l_decap_8
XFILLER_81_203 VPWR VGND sg13cmos5l_decap_4
X_0453_ _0453_/Q Tile_X0Y1_FrameData[21] VGND VPWR Tile_X0Y1_FrameStrobe[3] latch
X_0384_ _0384_/Q Tile_X0Y1_FrameData[26] VGND VPWR Tile_X0Y1_FrameStrobe[1] latch
XFILLER_19_160 VPWR VGND sg13cmos5l_decap_8
X_1005_ _1005_/X Tile_X0Y0_E2MID[5] Tile_X0Y0_E2END[5] Tile_X0Y0_E6END[5] _1094_/X
+ _0334_/Q _0333_/Q VPWR VGND sg13cmos5l_mux4_1
XFILLER_122_11 VPWR VGND sg13cmos5l_decap_8
XFILLER_122_99 VPWR VGND sg13cmos5l_fill_1
XFILLER_72_203 VPWR VGND sg13cmos5l_decap_8
XFILLER_82_37 VPWR VGND sg13cmos5l_decap_8
XFILLER_15_53 VPWR VGND sg13cmos5l_fill_1
XFILLER_103_0 VPWR VGND sg13cmos5l_decap_4
XFILLER_31_63 VPWR VGND sg13cmos5l_decap_8
XFILLER_56_82 VPWR VGND sg13cmos5l_decap_8
XFILLER_117_205 VPWR VGND sg13cmos5l_fill_2
XFILLER_31_188 VPWR VGND sg13cmos5l_fill_2
X_0505_ _0505_/Q Tile_X0Y1_FrameData[1] VGND VPWR Tile_X0Y1_FrameStrobe[4] latch
X_0436_ _0436_/Q Tile_X0Y1_FrameData[6] VGND VPWR Tile_X0Y1_FrameStrobe[2] latch
XFILLER_98_177 VPWR VGND sg13cmos5l_decap_8
.ends
