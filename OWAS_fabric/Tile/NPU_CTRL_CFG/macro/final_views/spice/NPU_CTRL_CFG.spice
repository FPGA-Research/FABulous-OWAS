* NGSPICE file created from NPU_CTRL_CFG.ext - technology: ihp-sg13cmos5l

* Black-box entry subcircuit for sg13cmos5l_antennanp abstract view
.subckt sg13cmos5l_antennanp A VDD VSS
.ends

* Black-box entry subcircuit for sg13cmos5l_decap_8 abstract view
.subckt sg13cmos5l_decap_8 VDD VSS
.ends

* Black-box entry subcircuit for sg13cmos5l_buf_1 abstract view
.subckt sg13cmos5l_buf_1 X A VDD VSS
.ends

* Black-box entry subcircuit for sg13cmos5l_decap_4 abstract view
.subckt sg13cmos5l_decap_4 VDD VSS
.ends

* Black-box entry subcircuit for latch abstract view
.subckt latch Q D VSS VDD GATE
.ends

* Black-box entry subcircuit for sg13cmos5l_dfrbpq_1 abstract view
.subckt sg13cmos5l_dfrbpq_1 Q CLK D RESET_B VDD VSS
.ends

* Black-box entry subcircuit for sg13cmos5l_fill_1 abstract view
.subckt sg13cmos5l_fill_1 VDD VSS
.ends

* Black-box entry subcircuit for sg13cmos5l_fill_2 abstract view
.subckt sg13cmos5l_fill_2 VDD VSS
.ends

* Black-box entry subcircuit for sg13cmos5l_tiehi abstract view
.subckt sg13cmos5l_tiehi L_HI VDD VSS
.ends

* Black-box entry subcircuit for sg13cmos5l_mux4_1 abstract view
.subckt sg13cmos5l_mux4_1 X A0 A1 A2 A3 S0 S1 VDD VSS
.ends

* Black-box entry subcircuit for sg13cmos5l_or2_1 abstract view
.subckt sg13cmos5l_or2_1 X A B VDD VSS
.ends

.subckt NPU_CTRL_CFG NPU_ARRAY_EN NPU_COMPUTE_BANK_SWAP NPU_PSUM_LUT_EN NPU_PSUM_SKEW_EN
+ NPU_PSUM_SYSTOLIC_EN NPU_QUANT_SHIFT_EN NPU_QUANT_SHIFT_IN0 NPU_QUANT_SHIFT_IN1
+ NPU_QUANT_SHIFT_IN10 NPU_QUANT_SHIFT_IN11 NPU_QUANT_SHIFT_IN12 NPU_QUANT_SHIFT_IN13
+ NPU_QUANT_SHIFT_IN14 NPU_QUANT_SHIFT_IN15 NPU_QUANT_SHIFT_IN16 NPU_QUANT_SHIFT_IN17
+ NPU_QUANT_SHIFT_IN18 NPU_QUANT_SHIFT_IN19 NPU_QUANT_SHIFT_IN2 NPU_QUANT_SHIFT_IN20
+ NPU_QUANT_SHIFT_IN21 NPU_QUANT_SHIFT_IN22 NPU_QUANT_SHIFT_IN23 NPU_QUANT_SHIFT_IN24
+ NPU_QUANT_SHIFT_IN25 NPU_QUANT_SHIFT_IN26 NPU_QUANT_SHIFT_IN27 NPU_QUANT_SHIFT_IN28
+ NPU_QUANT_SHIFT_IN29 NPU_QUANT_SHIFT_IN3 NPU_QUANT_SHIFT_IN4 NPU_QUANT_SHIFT_IN5
+ NPU_QUANT_SHIFT_IN6 NPU_QUANT_SHIFT_IN7 NPU_QUANT_SHIFT_IN8 NPU_QUANT_SHIFT_IN9
+ NPU_SWAP_WEIGHTS Tile_X0Y0_Ci Tile_X0Y0_FrameData[0] Tile_X0Y0_FrameData[10] Tile_X0Y0_FrameData[11]
+ Tile_X0Y0_FrameData[12] Tile_X0Y0_FrameData[13] Tile_X0Y0_FrameData[14] Tile_X0Y0_FrameData[15]
+ Tile_X0Y0_FrameData[16] Tile_X0Y0_FrameData[17] Tile_X0Y0_FrameData[18] Tile_X0Y0_FrameData[19]
+ Tile_X0Y0_FrameData[1] Tile_X0Y0_FrameData[20] Tile_X0Y0_FrameData[21] Tile_X0Y0_FrameData[22]
+ Tile_X0Y0_FrameData[23] Tile_X0Y0_FrameData[24] Tile_X0Y0_FrameData[25] Tile_X0Y0_FrameData[26]
+ Tile_X0Y0_FrameData[27] Tile_X0Y0_FrameData[28] Tile_X0Y0_FrameData[29] Tile_X0Y0_FrameData[2]
+ Tile_X0Y0_FrameData[30] Tile_X0Y0_FrameData[31] Tile_X0Y0_FrameData[3] Tile_X0Y0_FrameData[4]
+ Tile_X0Y0_FrameData[5] Tile_X0Y0_FrameData[6] Tile_X0Y0_FrameData[7] Tile_X0Y0_FrameData[8]
+ Tile_X0Y0_FrameData[9] Tile_X0Y0_FrameStrobe[0] Tile_X0Y0_FrameStrobe[10] Tile_X0Y0_FrameStrobe[11]
+ Tile_X0Y0_FrameStrobe[12] Tile_X0Y0_FrameStrobe[13] Tile_X0Y0_FrameStrobe[14] Tile_X0Y0_FrameStrobe[15]
+ Tile_X0Y0_FrameStrobe[16] Tile_X0Y0_FrameStrobe[17] Tile_X0Y0_FrameStrobe[18] Tile_X0Y0_FrameStrobe[19]
+ Tile_X0Y0_FrameStrobe[1] Tile_X0Y0_FrameStrobe[2] Tile_X0Y0_FrameStrobe[3] Tile_X0Y0_FrameStrobe[4]
+ Tile_X0Y0_FrameStrobe[5] Tile_X0Y0_FrameStrobe[6] Tile_X0Y0_FrameStrobe[7] Tile_X0Y0_FrameStrobe[8]
+ Tile_X0Y0_FrameStrobe[9] Tile_X0Y0_FrameStrobe_O[0] Tile_X0Y0_FrameStrobe_O[10]
+ Tile_X0Y0_FrameStrobe_O[11] Tile_X0Y0_FrameStrobe_O[12] Tile_X0Y0_FrameStrobe_O[13]
+ Tile_X0Y0_FrameStrobe_O[14] Tile_X0Y0_FrameStrobe_O[15] Tile_X0Y0_FrameStrobe_O[16]
+ Tile_X0Y0_FrameStrobe_O[17] Tile_X0Y0_FrameStrobe_O[18] Tile_X0Y0_FrameStrobe_O[19]
+ Tile_X0Y0_FrameStrobe_O[1] Tile_X0Y0_FrameStrobe_O[2] Tile_X0Y0_FrameStrobe_O[3]
+ Tile_X0Y0_FrameStrobe_O[4] Tile_X0Y0_FrameStrobe_O[5] Tile_X0Y0_FrameStrobe_O[6]
+ Tile_X0Y0_FrameStrobe_O[7] Tile_X0Y0_FrameStrobe_O[8] Tile_X0Y0_FrameStrobe_O[9]
+ Tile_X0Y0_N1END[0] Tile_X0Y0_N1END[1] Tile_X0Y0_N1END[2] Tile_X0Y0_N1END[3] Tile_X0Y0_N2END[0]
+ Tile_X0Y0_N2END[1] Tile_X0Y0_N2END[2] Tile_X0Y0_N2END[3] Tile_X0Y0_N2END[4] Tile_X0Y0_N2END[5]
+ Tile_X0Y0_N2END[6] Tile_X0Y0_N2END[7] Tile_X0Y0_N2MID[0] Tile_X0Y0_N2MID[1] Tile_X0Y0_N2MID[2]
+ Tile_X0Y0_N2MID[3] Tile_X0Y0_N2MID[4] Tile_X0Y0_N2MID[5] Tile_X0Y0_N2MID[6] Tile_X0Y0_N2MID[7]
+ Tile_X0Y0_N4END[0] Tile_X0Y0_N4END[10] Tile_X0Y0_N4END[11] Tile_X0Y0_N4END[12] Tile_X0Y0_N4END[13]
+ Tile_X0Y0_N4END[14] Tile_X0Y0_N4END[15] Tile_X0Y0_N4END[1] Tile_X0Y0_N4END[2] Tile_X0Y0_N4END[3]
+ Tile_X0Y0_N4END[4] Tile_X0Y0_N4END[5] Tile_X0Y0_N4END[6] Tile_X0Y0_N4END[7] Tile_X0Y0_N4END[8]
+ Tile_X0Y0_N4END[9] Tile_X0Y0_NN4END[0] Tile_X0Y0_NN4END[10] Tile_X0Y0_NN4END[11]
+ Tile_X0Y0_NN4END[12] Tile_X0Y0_NN4END[13] Tile_X0Y0_NN4END[14] Tile_X0Y0_NN4END[15]
+ Tile_X0Y0_NN4END[1] Tile_X0Y0_NN4END[2] Tile_X0Y0_NN4END[3] Tile_X0Y0_NN4END[4]
+ Tile_X0Y0_NN4END[5] Tile_X0Y0_NN4END[6] Tile_X0Y0_NN4END[7] Tile_X0Y0_NN4END[8]
+ Tile_X0Y0_NN4END[9] Tile_X0Y0_S1BEG[0] Tile_X0Y0_S1BEG[1] Tile_X0Y0_S1BEG[2] Tile_X0Y0_S1BEG[3]
+ Tile_X0Y0_S2BEG[0] Tile_X0Y0_S2BEG[1] Tile_X0Y0_S2BEG[2] Tile_X0Y0_S2BEG[3] Tile_X0Y0_S2BEG[4]
+ Tile_X0Y0_S2BEG[5] Tile_X0Y0_S2BEG[6] Tile_X0Y0_S2BEG[7] Tile_X0Y0_S2BEGb[0] Tile_X0Y0_S2BEGb[1]
+ Tile_X0Y0_S2BEGb[2] Tile_X0Y0_S2BEGb[3] Tile_X0Y0_S2BEGb[4] Tile_X0Y0_S2BEGb[5]
+ Tile_X0Y0_S2BEGb[6] Tile_X0Y0_S2BEGb[7] Tile_X0Y0_S4BEG[0] Tile_X0Y0_S4BEG[10] Tile_X0Y0_S4BEG[11]
+ Tile_X0Y0_S4BEG[12] Tile_X0Y0_S4BEG[13] Tile_X0Y0_S4BEG[14] Tile_X0Y0_S4BEG[15]
+ Tile_X0Y0_S4BEG[1] Tile_X0Y0_S4BEG[2] Tile_X0Y0_S4BEG[3] Tile_X0Y0_S4BEG[4] Tile_X0Y0_S4BEG[5]
+ Tile_X0Y0_S4BEG[6] Tile_X0Y0_S4BEG[7] Tile_X0Y0_S4BEG[8] Tile_X0Y0_S4BEG[9] Tile_X0Y0_SS4BEG[0]
+ Tile_X0Y0_SS4BEG[10] Tile_X0Y0_SS4BEG[11] Tile_X0Y0_SS4BEG[12] Tile_X0Y0_SS4BEG[13]
+ Tile_X0Y0_SS4BEG[14] Tile_X0Y0_SS4BEG[15] Tile_X0Y0_SS4BEG[1] Tile_X0Y0_SS4BEG[2]
+ Tile_X0Y0_SS4BEG[3] Tile_X0Y0_SS4BEG[4] Tile_X0Y0_SS4BEG[5] Tile_X0Y0_SS4BEG[6]
+ Tile_X0Y0_SS4BEG[7] Tile_X0Y0_SS4BEG[8] Tile_X0Y0_SS4BEG[9] Tile_X0Y0_UserCLK Tile_X1Y0_Ci
+ Tile_X1Y0_FrameData_O[0] Tile_X1Y0_FrameData_O[10] Tile_X1Y0_FrameData_O[11] Tile_X1Y0_FrameData_O[12]
+ Tile_X1Y0_FrameData_O[13] Tile_X1Y0_FrameData_O[14] Tile_X1Y0_FrameData_O[15] Tile_X1Y0_FrameData_O[16]
+ Tile_X1Y0_FrameData_O[17] Tile_X1Y0_FrameData_O[18] Tile_X1Y0_FrameData_O[19] Tile_X1Y0_FrameData_O[1]
+ Tile_X1Y0_FrameData_O[20] Tile_X1Y0_FrameData_O[21] Tile_X1Y0_FrameData_O[22] Tile_X1Y0_FrameData_O[23]
+ Tile_X1Y0_FrameData_O[24] Tile_X1Y0_FrameData_O[25] Tile_X1Y0_FrameData_O[26] Tile_X1Y0_FrameData_O[27]
+ Tile_X1Y0_FrameData_O[28] Tile_X1Y0_FrameData_O[29] Tile_X1Y0_FrameData_O[2] Tile_X1Y0_FrameData_O[30]
+ Tile_X1Y0_FrameData_O[31] Tile_X1Y0_FrameData_O[3] Tile_X1Y0_FrameData_O[4] Tile_X1Y0_FrameData_O[5]
+ Tile_X1Y0_FrameData_O[6] Tile_X1Y0_FrameData_O[7] Tile_X1Y0_FrameData_O[8] Tile_X1Y0_FrameData_O[9]
+ Tile_X1Y0_FrameStrobe[0] Tile_X1Y0_FrameStrobe[10] Tile_X1Y0_FrameStrobe[11] Tile_X1Y0_FrameStrobe[12]
+ Tile_X1Y0_FrameStrobe[13] Tile_X1Y0_FrameStrobe[14] Tile_X1Y0_FrameStrobe[15] Tile_X1Y0_FrameStrobe[16]
+ Tile_X1Y0_FrameStrobe[17] Tile_X1Y0_FrameStrobe[18] Tile_X1Y0_FrameStrobe[19] Tile_X1Y0_FrameStrobe[1]
+ Tile_X1Y0_FrameStrobe[2] Tile_X1Y0_FrameStrobe[3] Tile_X1Y0_FrameStrobe[4] Tile_X1Y0_FrameStrobe[5]
+ Tile_X1Y0_FrameStrobe[6] Tile_X1Y0_FrameStrobe[7] Tile_X1Y0_FrameStrobe[8] Tile_X1Y0_FrameStrobe[9]
+ Tile_X1Y0_FrameStrobe_O[0] Tile_X1Y0_FrameStrobe_O[10] Tile_X1Y0_FrameStrobe_O[11]
+ Tile_X1Y0_FrameStrobe_O[12] Tile_X1Y0_FrameStrobe_O[13] Tile_X1Y0_FrameStrobe_O[14]
+ Tile_X1Y0_FrameStrobe_O[15] Tile_X1Y0_FrameStrobe_O[16] Tile_X1Y0_FrameStrobe_O[17]
+ Tile_X1Y0_FrameStrobe_O[18] Tile_X1Y0_FrameStrobe_O[19] Tile_X1Y0_FrameStrobe_O[1]
+ Tile_X1Y0_FrameStrobe_O[2] Tile_X1Y0_FrameStrobe_O[3] Tile_X1Y0_FrameStrobe_O[4]
+ Tile_X1Y0_FrameStrobe_O[5] Tile_X1Y0_FrameStrobe_O[6] Tile_X1Y0_FrameStrobe_O[7]
+ Tile_X1Y0_FrameStrobe_O[8] Tile_X1Y0_FrameStrobe_O[9] Tile_X1Y0_N1END[0] Tile_X1Y0_N1END[1]
+ Tile_X1Y0_N1END[2] Tile_X1Y0_N1END[3] Tile_X1Y0_N2END[0] Tile_X1Y0_N2END[1] Tile_X1Y0_N2END[2]
+ Tile_X1Y0_N2END[3] Tile_X1Y0_N2END[4] Tile_X1Y0_N2END[5] Tile_X1Y0_N2END[6] Tile_X1Y0_N2END[7]
+ Tile_X1Y0_N2MID[0] Tile_X1Y0_N2MID[1] Tile_X1Y0_N2MID[2] Tile_X1Y0_N2MID[3] Tile_X1Y0_N2MID[4]
+ Tile_X1Y0_N2MID[5] Tile_X1Y0_N2MID[6] Tile_X1Y0_N2MID[7] Tile_X1Y0_N4END[0] Tile_X1Y0_N4END[10]
+ Tile_X1Y0_N4END[11] Tile_X1Y0_N4END[12] Tile_X1Y0_N4END[13] Tile_X1Y0_N4END[14]
+ Tile_X1Y0_N4END[15] Tile_X1Y0_N4END[1] Tile_X1Y0_N4END[2] Tile_X1Y0_N4END[3] Tile_X1Y0_N4END[4]
+ Tile_X1Y0_N4END[5] Tile_X1Y0_N4END[6] Tile_X1Y0_N4END[7] Tile_X1Y0_N4END[8] Tile_X1Y0_N4END[9]
+ Tile_X1Y0_NN4END[0] Tile_X1Y0_NN4END[10] Tile_X1Y0_NN4END[11] Tile_X1Y0_NN4END[12]
+ Tile_X1Y0_NN4END[13] Tile_X1Y0_NN4END[14] Tile_X1Y0_NN4END[15] Tile_X1Y0_NN4END[1]
+ Tile_X1Y0_NN4END[2] Tile_X1Y0_NN4END[3] Tile_X1Y0_NN4END[4] Tile_X1Y0_NN4END[5]
+ Tile_X1Y0_NN4END[6] Tile_X1Y0_NN4END[7] Tile_X1Y0_NN4END[8] Tile_X1Y0_NN4END[9]
+ Tile_X1Y0_S1BEG[0] Tile_X1Y0_S1BEG[1] Tile_X1Y0_S1BEG[2] Tile_X1Y0_S1BEG[3] Tile_X1Y0_S2BEG[0]
+ Tile_X1Y0_S2BEG[1] Tile_X1Y0_S2BEG[2] Tile_X1Y0_S2BEG[3] Tile_X1Y0_S2BEG[4] Tile_X1Y0_S2BEG[5]
+ Tile_X1Y0_S2BEG[6] Tile_X1Y0_S2BEG[7] Tile_X1Y0_S2BEGb[0] Tile_X1Y0_S2BEGb[1] Tile_X1Y0_S2BEGb[2]
+ Tile_X1Y0_S2BEGb[3] Tile_X1Y0_S2BEGb[4] Tile_X1Y0_S2BEGb[5] Tile_X1Y0_S2BEGb[6]
+ Tile_X1Y0_S2BEGb[7] Tile_X1Y0_S4BEG[0] Tile_X1Y0_S4BEG[10] Tile_X1Y0_S4BEG[11] Tile_X1Y0_S4BEG[12]
+ Tile_X1Y0_S4BEG[13] Tile_X1Y0_S4BEG[14] Tile_X1Y0_S4BEG[15] Tile_X1Y0_S4BEG[1] Tile_X1Y0_S4BEG[2]
+ Tile_X1Y0_S4BEG[3] Tile_X1Y0_S4BEG[4] Tile_X1Y0_S4BEG[5] Tile_X1Y0_S4BEG[6] Tile_X1Y0_S4BEG[7]
+ Tile_X1Y0_S4BEG[8] Tile_X1Y0_S4BEG[9] Tile_X1Y0_SS4BEG[0] Tile_X1Y0_SS4BEG[10] Tile_X1Y0_SS4BEG[11]
+ Tile_X1Y0_SS4BEG[12] Tile_X1Y0_SS4BEG[13] Tile_X1Y0_SS4BEG[14] Tile_X1Y0_SS4BEG[15]
+ Tile_X1Y0_SS4BEG[1] Tile_X1Y0_SS4BEG[2] Tile_X1Y0_SS4BEG[3] Tile_X1Y0_SS4BEG[4]
+ Tile_X1Y0_SS4BEG[5] Tile_X1Y0_SS4BEG[6] Tile_X1Y0_SS4BEG[7] Tile_X1Y0_SS4BEG[8]
+ Tile_X1Y0_SS4BEG[9] Tile_X1Y0_UserCLKo VGND VPWR
XANTENNA__308__X Tile_X1Y0_FrameData_O[4] VPWR VGND sg13cmos5l_antennanp
XFILLER_11_818 VPWR VGND sg13cmos5l_decap_8
XFILLER_11_1020 VPWR VGND sg13cmos5l_decap_8
XFILLER_11_1097 VPWR VGND sg13cmos5l_decap_8
XFILLER_7_7 VPWR VGND sg13cmos5l_decap_8
XANTENNA_202 Tile_X0Y0_N4END[3] VPWR VGND sg13cmos5l_antennanp
XANTENNA_213 Tile_X0Y0_N4END[5] VPWR VGND sg13cmos5l_antennanp
XANTENNA_224 Tile_X0Y0_NN4END[2] VPWR VGND sg13cmos5l_antennanp
XANTENNA_235 Tile_X1Y0_FrameStrobe[18] VPWR VGND sg13cmos5l_antennanp
XANTENNA_246 Tile_X0Y0_FrameData[31] VPWR VGND sg13cmos5l_antennanp
XANTENNA_257 Tile_X0Y0_FrameData[31] VPWR VGND sg13cmos5l_antennanp
XANTENNA_268 Tile_X0Y0_FrameData[28] VPWR VGND sg13cmos5l_antennanp
XANTENNA_279 Tile_X0Y0_FrameData[30] VPWR VGND sg13cmos5l_antennanp
XANTENNA__218__X Tile_X1Y0_S2BEG[7] VPWR VGND sg13cmos5l_antennanp
XFILLER_13_133 VPWR VGND sg13cmos5l_decap_8
XFILLER_10_895 VPWR VGND sg13cmos5l_decap_8
XFILLER_14_678 VPWR VGND sg13cmos5l_decap_8
X_294_ Tile_X0Y0_SS4BEG[10] Tile_X0Y0_NN4END[5] VPWR VGND sg13cmos5l_buf_1
X_363_ Tile_X1Y0_FrameStrobe_O[7] Tile_X1Y0_FrameStrobe[7] VPWR VGND sg13cmos5l_buf_1
XFILLER_9_137 VPWR VGND sg13cmos5l_decap_8
XFILLER_3_56 VPWR VGND sg13cmos5l_decap_8
XFILLER_1_560 VPWR VGND sg13cmos5l_decap_8
XFILLER_3_1018 VPWR VGND sg13cmos5l_decap_8
XFILLER_9_660 VPWR VGND sg13cmos5l_decap_8
XFILLER_8_170 VPWR VGND sg13cmos5l_decap_8
XFILLER_10_147 VPWR VGND sg13cmos5l_decap_8
XFILLER_11_615 VPWR VGND sg13cmos5l_decap_8
XFILLER_12_21 VPWR VGND sg13cmos5l_decap_8
XFILLER_12_98 VPWR VGND sg13cmos5l_decap_8
XFILLER_3_814 VPWR VGND sg13cmos5l_decap_8
XFILLER_2_302 VPWR VGND sg13cmos5l_decap_8
XFILLER_14_464 VPWR VGND sg13cmos5l_decap_8
X_346_ Tile_X0Y0_FrameStrobe_O[10] Tile_X0Y0_FrameStrobe[10] VPWR VGND sg13cmos5l_buf_1
XFILLER_2_1073 VPWR VGND sg13cmos5l_decap_8
X_277_ Tile_X0Y0_S4BEG[9] Tile_X0Y0_N4END[6] VPWR VGND sg13cmos5l_buf_1
XFILLER_5_140 VPWR VGND sg13cmos5l_decap_8
XANTENNA__321__X Tile_X1Y0_FrameData_O[17] VPWR VGND sg13cmos5l_antennanp
XFILLER_0_828 VPWR VGND sg13cmos5l_decap_8
XFILLER_12_913 VPWR VGND sg13cmos5l_decap_8
XFILLER_15_217 VPWR VGND sg13cmos5l_decap_8
XFILLER_16_729 VPWR VGND sg13cmos5l_decap_4
X_200_ Tile_X0Y0_S2BEG[1] Tile_X0Y0_N2MID[6] VPWR VGND sg13cmos5l_buf_1
XFILLER_11_434 VPWR VGND sg13cmos5l_decap_8
XFILLER_11_489 VPWR VGND sg13cmos5l_decap_8
X_062_ _062_/Q Tile_X0Y0_FrameData[8] VGND VPWR Tile_X0Y0_FrameStrobe[0] latch
X_131_ NPU_QUANT_SHIFT_IN16 Tile_X0Y0_UserCLK _381_/X _153_/L_HI VPWR VGND sg13cmos5l_dfrbpq_1
XANTENNA__231__X Tile_X1Y0_S4BEG[4] VPWR VGND sg13cmos5l_antennanp
XFILLER_3_633 VPWR VGND sg13cmos5l_decap_8
XFILLER_2_187 VPWR VGND sg13cmos5l_fill_1
XFILLER_2_176 VPWR VGND sg13cmos5l_decap_8
XFILLER_14_294 VPWR VGND sg13cmos5l_decap_8
XFILLER_15_784 VPWR VGND sg13cmos5l_decap_8
X_329_ Tile_X1Y0_FrameData_O[25] Tile_X0Y0_FrameData[25] VPWR VGND sg13cmos5l_buf_1
XFILLER_9_77 VPWR VGND sg13cmos5l_decap_8
XFILLER_7_972 VPWR VGND sg13cmos5l_fill_1
XFILLER_6_493 VPWR VGND sg13cmos5l_decap_8
XFILLER_9_1024 VPWR VGND sg13cmos5l_decap_8
XANTENNA__316__X Tile_X1Y0_FrameData_O[12] VPWR VGND sg13cmos5l_antennanp
XFILLER_0_647 VPWR VGND sg13cmos5l_fill_1
XFILLER_0_669 VPWR VGND sg13cmos5l_decap_8
XFILLER_16_504 VPWR VGND sg13cmos5l_decap_8
XANTENNA__226__X Tile_X1Y0_S2BEGb[7] VPWR VGND sg13cmos5l_antennanp
XFILLER_11_231 VPWR VGND sg13cmos5l_decap_8
XFILLER_12_798 VPWR VGND sg13cmos5l_decap_8
XFILLER_15_1029 VPWR VGND sg13cmos5l_decap_8
XFILLER_8_714 VPWR VGND sg13cmos5l_decap_8
X_045_ _045_/Q Tile_X0Y0_FrameData[25] VGND VPWR Tile_X0Y0_FrameStrobe[0] latch
X_114_ _114_/Q Tile_X0Y0_FrameData[25] VGND VPWR Tile_X1Y0_FrameStrobe[1] latch
XFILLER_7_224 VPWR VGND sg13cmos5l_decap_8
XFILLER_15_581 VPWR VGND sg13cmos5l_decap_8
XFILLER_14_1040 VPWR VGND sg13cmos5l_decap_8
XFILLER_5_728 VPWR VGND sg13cmos5l_decap_8
XFILLER_4_227 VPWR VGND sg13cmos5l_decap_8
XFILLER_4_205 VPWR VGND sg13cmos5l_decap_8
XFILLER_16_367 VPWR VGND sg13cmos5l_decap_8
XFILLER_12_573 VPWR VGND sg13cmos5l_decap_8
XFILLER_8_588 VPWR VGND sg13cmos5l_decap_8
XFILLER_8_511 VPWR VGND sg13cmos5l_decap_8
XANTENNA_5 Tile_X0Y0_FrameData[0] VPWR VGND sg13cmos5l_antennanp
XFILLER_6_56 VPWR VGND sg13cmos5l_decap_8
XFILLER_4_794 VPWR VGND sg13cmos5l_decap_4
XFILLER_4_761 VPWR VGND sg13cmos5l_fill_2
XFILLER_4_750 VPWR VGND sg13cmos5l_fill_1
XFILLER_6_1016 VPWR VGND sg13cmos5l_decap_8
XFILLER_13_315 VPWR VGND sg13cmos5l_decap_8
XFILLER_15_21 VPWR VGND sg13cmos5l_decap_8
XFILLER_15_98 VPWR VGND sg13cmos5l_decap_8
XFILLER_9_319 VPWR VGND sg13cmos5l_decap_8
XFILLER_5_525 VPWR VGND sg13cmos5l_decap_8
XFILLER_1_720 VPWR VGND sg13cmos5l_decap_4
XFILLER_5_1071 VPWR VGND sg13cmos5l_fill_2
XFILLER_16_164 VPWR VGND sg13cmos5l_decap_8
XFILLER_9_842 VPWR VGND sg13cmos5l_decap_8
XFILLER_11_0 VPWR VGND sg13cmos5l_decap_8
XFILLER_10_329 VPWR VGND sg13cmos5l_decap_8
XANTENNA__324__X Tile_X1Y0_FrameData_O[20] VPWR VGND sg13cmos5l_antennanp
XFILLER_11_1076 VPWR VGND sg13cmos5l_decap_8
XANTENNA_203 Tile_X0Y0_N4END[3] VPWR VGND sg13cmos5l_antennanp
XANTENNA_214 Tile_X0Y0_N4END[5] VPWR VGND sg13cmos5l_antennanp
XANTENNA_225 Tile_X0Y0_NN4END[2] VPWR VGND sg13cmos5l_antennanp
XANTENNA_236 Tile_X1Y0_FrameStrobe[19] VPWR VGND sg13cmos5l_antennanp
XANTENNA_247 Tile_X0Y0_FrameData[31] VPWR VGND sg13cmos5l_antennanp
XANTENNA_258 Tile_X0Y0_FrameData[31] VPWR VGND sg13cmos5l_antennanp
XANTENNA_269 Tile_X0Y0_FrameData[28] VPWR VGND sg13cmos5l_antennanp
XFILLER_13_112 VPWR VGND sg13cmos5l_decap_8
X_362_ Tile_X1Y0_FrameStrobe_O[6] Tile_X1Y0_FrameStrobe[6] VPWR VGND sg13cmos5l_buf_1
XFILLER_9_105 VPWR VGND sg13cmos5l_decap_8
XANTENNA__234__X Tile_X1Y0_S4BEG[7] VPWR VGND sg13cmos5l_antennanp
XFILLER_10_863 VPWR VGND sg13cmos5l_decap_8
XFILLER_13_189 VPWR VGND sg13cmos5l_decap_8
X_293_ Tile_X0Y0_SS4BEG[9] Tile_X0Y0_NN4END[6] VPWR VGND sg13cmos5l_buf_1
XFILLER_6_878 VPWR VGND sg13cmos5l_fill_2
XFILLER_6_834 VPWR VGND sg13cmos5l_decap_8
XFILLER_3_35 VPWR VGND sg13cmos5l_decap_8
XANTENNA__319__X Tile_X1Y0_FrameData_O[15] VPWR VGND sg13cmos5l_antennanp
XFILLER_10_126 VPWR VGND sg13cmos5l_decap_8
XFILLER_12_77 VPWR VGND sg13cmos5l_decap_8
XFILLER_6_119 VPWR VGND sg13cmos5l_decap_8
XANTENNA__229__X Tile_X1Y0_S4BEG[2] VPWR VGND sg13cmos5l_antennanp
XFILLER_2_1052 VPWR VGND sg13cmos5l_decap_8
XFILLER_14_443 VPWR VGND sg13cmos5l_decap_8
XFILLER_15_977 VPWR VGND sg13cmos5l_fill_2
X_276_ Tile_X0Y0_S4BEG[8] Tile_X0Y0_N4END[7] VPWR VGND sg13cmos5l_buf_1
X_345_ Tile_X0Y0_FrameStrobe_O[9] Tile_X0Y0_FrameStrobe[9] VPWR VGND sg13cmos5l_buf_1
XFILLER_6_697 VPWR VGND sg13cmos5l_decap_8
XFILLER_5_196 VPWR VGND sg13cmos5l_decap_8
XFILLER_0_807 VPWR VGND sg13cmos5l_decap_8
XFILLER_12_936 VPWR VGND sg13cmos5l_fill_2
XFILLER_12_969 VPWR VGND sg13cmos5l_decap_8
X_130_ NPU_QUANT_SHIFT_IN15 Tile_X0Y0_UserCLK _380_/X _154_/L_HI VPWR VGND sg13cmos5l_dfrbpq_1
XFILLER_8_907 VPWR VGND sg13cmos5l_fill_2
XFILLER_11_468 VPWR VGND sg13cmos5l_decap_8
X_061_ _061_/Q Tile_X0Y0_FrameData[9] VGND VPWR Tile_X0Y0_FrameStrobe[0] latch
XFILLER_2_133 VPWR VGND sg13cmos5l_decap_8
XFILLER_0_69 VPWR VGND sg13cmos5l_decap_8
XFILLER_15_763 VPWR VGND sg13cmos5l_decap_8
XFILLER_14_273 VPWR VGND sg13cmos5l_decap_8
X_259_ Tile_X1Y0_UserCLKo Tile_X0Y0_UserCLK VPWR VGND sg13cmos5l_buf_1
X_328_ Tile_X1Y0_FrameData_O[24] Tile_X0Y0_FrameData[24] VPWR VGND sg13cmos5l_buf_1
XFILLER_9_56 VPWR VGND sg13cmos5l_decap_8
XFILLER_9_1003 VPWR VGND sg13cmos5l_decap_8
XFILLER_6_472 VPWR VGND sg13cmos5l_decap_8
XFILLER_6_461 VPWR VGND sg13cmos5l_decap_8
XANTENNA__332__X Tile_X1Y0_FrameData_O[28] VPWR VGND sg13cmos5l_antennanp
XFILLER_0_626 VPWR VGND sg13cmos5l_fill_2
XFILLER_0_659 VPWR VGND sg13cmos5l_fill_2
XFILLER_11_210 VPWR VGND sg13cmos5l_decap_8
XFILLER_11_287 VPWR VGND sg13cmos5l_decap_8
XFILLER_12_777 VPWR VGND sg13cmos5l_decap_8
XFILLER_15_1008 VPWR VGND sg13cmos5l_decap_8
X_113_ _113_/Q Tile_X0Y0_FrameData[31] VGND VPWR Tile_X1Y0_FrameStrobe[0] latch
XFILLER_7_203 VPWR VGND sg13cmos5l_decap_8
XANTENNA__242__X Tile_X1Y0_S4BEG[15] VPWR VGND sg13cmos5l_antennanp
X_044_ _044_/Q Tile_X0Y0_FrameData[26] VGND VPWR Tile_X0Y0_FrameStrobe[0] latch
XFILLER_4_932 VPWR VGND sg13cmos5l_fill_1
XFILLER_15_7 VPWR VGND sg13cmos5l_decap_8
XFILLER_15_560 VPWR VGND sg13cmos5l_decap_8
XFILLER_7_792 VPWR VGND sg13cmos5l_decap_8
XFILLER_6_291 VPWR VGND sg13cmos5l_decap_8
XANTENNA__327__X Tile_X1Y0_FrameData_O[23] VPWR VGND sg13cmos5l_antennanp
XFILLER_13_519 VPWR VGND sg13cmos5l_decap_8
XFILLER_14_1096 VPWR VGND sg13cmos5l_decap_8
XFILLER_5_707 VPWR VGND sg13cmos5l_decap_8
XANTENNA__237__X Tile_X1Y0_S4BEG[10] VPWR VGND sg13cmos5l_antennanp
XFILLER_16_335 VPWR VGND sg13cmos5l_decap_8
XANTENNA_6 Tile_X0Y0_FrameData[0] VPWR VGND sg13cmos5l_antennanp
XFILLER_12_552 VPWR VGND sg13cmos5l_decap_8
XFILLER_8_567 VPWR VGND sg13cmos5l_decap_8
XFILLER_6_35 VPWR VGND sg13cmos5l_decap_8
XFILLER_3_261 VPWR VGND sg13cmos5l_decap_8
XFILLER_16_891 VPWR VGND sg13cmos5l_decap_8
XFILLER_15_77 VPWR VGND sg13cmos5l_decap_8
XFILLER_5_504 VPWR VGND sg13cmos5l_decap_8
XFILLER_0_253 VPWR VGND sg13cmos5l_decap_4
XFILLER_1_743 VPWR VGND sg13cmos5l_fill_2
XFILLER_1_732 VPWR VGND sg13cmos5l_decap_8
XFILLER_0_275 VPWR VGND sg13cmos5l_fill_1
XFILLER_5_1050 VPWR VGND sg13cmos5l_decap_8
XFILLER_12_371 VPWR VGND sg13cmos5l_fill_2
XFILLER_13_883 VPWR VGND sg13cmos5l_fill_2
XFILLER_16_143 VPWR VGND sg13cmos5l_decap_8
XFILLER_9_821 VPWR VGND sg13cmos5l_decap_8
XFILLER_9_898 VPWR VGND sg13cmos5l_decap_8
XFILLER_8_331 VPWR VGND sg13cmos5l_decap_8
XFILLER_4_581 VPWR VGND sg13cmos5l_decap_8
XFILLER_10_308 VPWR VGND sg13cmos5l_decap_8
XANTENNA__340__X Tile_X0Y0_FrameStrobe_O[4] VPWR VGND sg13cmos5l_antennanp
XFILLER_11_1055 VPWR VGND sg13cmos5l_decap_8
XFILLER_2_529 VPWR VGND sg13cmos5l_decap_8
XANTENNA_204 Tile_X0Y0_N4END[4] VPWR VGND sg13cmos5l_antennanp
XANTENNA_215 Tile_X0Y0_N4END[5] VPWR VGND sg13cmos5l_antennanp
XANTENNA_226 Tile_X0Y0_NN4END[2] VPWR VGND sg13cmos5l_antennanp
XANTENNA_237 Tile_X1Y0_FrameStrobe[3] VPWR VGND sg13cmos5l_antennanp
XANTENNA_248 Tile_X0Y0_FrameData[31] VPWR VGND sg13cmos5l_antennanp
XANTENNA_259 Tile_X0Y0_FrameData[31] VPWR VGND sg13cmos5l_antennanp
XFILLER_13_168 VPWR VGND sg13cmos5l_decap_8
XFILLER_14_625 VPWR VGND sg13cmos5l_decap_4
XFILLER_14_669 VPWR VGND sg13cmos5l_fill_2
X_292_ Tile_X0Y0_SS4BEG[8] Tile_X0Y0_NN4END[7] VPWR VGND sg13cmos5l_buf_1
X_361_ Tile_X1Y0_FrameStrobe_O[5] Tile_X1Y0_FrameStrobe[5] VPWR VGND sg13cmos5l_buf_1
XFILLER_5_323 VPWR VGND sg13cmos5l_fill_1
XANTENNA__250__X Tile_X1Y0_SS4BEG[7] VPWR VGND sg13cmos5l_antennanp
XFILLER_7_1112 VPWR VGND sg13cmos5l_fill_2
XFILLER_3_14 VPWR VGND sg13cmos5l_decap_8
XFILLER_1_595 VPWR VGND sg13cmos5l_decap_8
XFILLER_13_680 VPWR VGND sg13cmos5l_decap_8
XFILLER_9_695 VPWR VGND sg13cmos5l_decap_8
XFILLER_5_890 VPWR VGND sg13cmos5l_fill_2
XFILLER_10_105 VPWR VGND sg13cmos5l_decap_8
XANTENNA__335__X Tile_X1Y0_FrameData_O[31] VPWR VGND sg13cmos5l_antennanp
XFILLER_12_56 VPWR VGND sg13cmos5l_decap_8
XFILLER_14_422 VPWR VGND sg13cmos5l_decap_8
XFILLER_15_945 VPWR VGND sg13cmos5l_fill_1
XFILLER_2_1031 VPWR VGND sg13cmos5l_decap_8
XANTENNA__245__X Tile_X1Y0_SS4BEG[2] VPWR VGND sg13cmos5l_antennanp
XFILLER_14_499 VPWR VGND sg13cmos5l_decap_8
X_275_ Tile_X0Y0_S4BEG[7] Tile_X0Y0_N4END[8] VPWR VGND sg13cmos5l_buf_1
X_344_ Tile_X0Y0_FrameStrobe_O[8] Tile_X0Y0_FrameStrobe[8] VPWR VGND sg13cmos5l_buf_1
XFILLER_6_676 VPWR VGND sg13cmos5l_decap_8
XFILLER_6_654 VPWR VGND sg13cmos5l_decap_4
XFILLER_5_175 VPWR VGND sg13cmos5l_decap_8
XFILLER_1_392 VPWR VGND sg13cmos5l_fill_2
XFILLER_9_481 VPWR VGND sg13cmos5l_decap_8
XFILLER_16_709 VPWR VGND sg13cmos5l_fill_1
XFILLER_8_919 VPWR VGND sg13cmos5l_fill_2
X_060_ _060_/Q Tile_X0Y0_FrameData[10] VGND VPWR Tile_X0Y0_FrameStrobe[0] latch
XFILLER_2_112 VPWR VGND sg13cmos5l_decap_8
XFILLER_0_48 VPWR VGND sg13cmos5l_decap_8
XFILLER_14_252 VPWR VGND sg13cmos5l_decap_8
XFILLER_15_742 VPWR VGND sg13cmos5l_decap_8
XFILLER_9_35 VPWR VGND sg13cmos5l_decap_8
XFILLER_10_491 VPWR VGND sg13cmos5l_decap_8
XFILLER_11_992 VPWR VGND sg13cmos5l_decap_8
X_189_ Tile_X1Y0_FrameStrobe_O[10] Tile_X1Y0_FrameStrobe[10] VPWR VGND sg13cmos5l_buf_1
X_258_ Tile_X1Y0_SS4BEG[15] Tile_X1Y0_NN4END[0] VPWR VGND sg13cmos5l_buf_1
X_327_ Tile_X1Y0_FrameData_O[23] Tile_X0Y0_FrameData[23] VPWR VGND sg13cmos5l_buf_1
XFILLER_7_963 VPWR VGND sg13cmos5l_decap_8
XFILLER_9_1059 VPWR VGND sg13cmos5l_decap_8
XFILLER_0_605 VPWR VGND sg13cmos5l_fill_1
XFILLER_16_528 VPWR VGND sg13cmos5l_decap_8
XFILLER_16_539 VPWR VGND sg13cmos5l_fill_2
XFILLER_11_266 VPWR VGND sg13cmos5l_decap_8
XFILLER_12_756 VPWR VGND sg13cmos5l_decap_8
X_043_ _043_/Q Tile_X0Y0_FrameData[27] VGND VPWR Tile_X0Y0_FrameStrobe[0] latch
X_112_ _112_/Q Tile_X0Y0_FrameData[26] VGND VPWR Tile_X1Y0_FrameStrobe[1] latch
XFILLER_8_749 VPWR VGND sg13cmos5l_decap_8
XFILLER_7_259 VPWR VGND sg13cmos5l_decap_8
XFILLER_4_944 VPWR VGND sg13cmos5l_fill_1
XFILLER_1_0 VPWR VGND sg13cmos5l_decap_8
XFILLER_8_1070 VPWR VGND sg13cmos5l_decap_4
XFILLER_7_771 VPWR VGND sg13cmos5l_decap_8
XFILLER_6_270 VPWR VGND sg13cmos5l_decap_8
XFILLER_1_91 VPWR VGND sg13cmos5l_decap_8
XANTENNA__343__X Tile_X0Y0_FrameStrobe_O[7] VPWR VGND sg13cmos5l_antennanp
XFILLER_14_1075 VPWR VGND sg13cmos5l_decap_8
XFILLER_1_947 VPWR VGND sg13cmos5l_decap_8
XFILLER_1_903 VPWR VGND sg13cmos5l_decap_8
XFILLER_16_314 VPWR VGND sg13cmos5l_decap_8
XFILLER_12_531 VPWR VGND sg13cmos5l_decap_8
XANTENNA_7 Tile_X0Y0_FrameData[0] VPWR VGND sg13cmos5l_antennanp
XANTENNA__253__X Tile_X1Y0_SS4BEG[10] VPWR VGND sg13cmos5l_antennanp
XFILLER_8_546 VPWR VGND sg13cmos5l_decap_8
XFILLER_6_14 VPWR VGND sg13cmos5l_decap_8
XFILLER_4_763 VPWR VGND sg13cmos5l_fill_1
XFILLER_3_284 VPWR VGND sg13cmos5l_decap_8
XFILLER_3_273 VPWR VGND sg13cmos5l_fill_1
XFILLER_16_870 VPWR VGND sg13cmos5l_decap_4
XANTENNA__338__X Tile_X0Y0_FrameStrobe_O[2] VPWR VGND sg13cmos5l_antennanp
XFILLER_14_829 VPWR VGND sg13cmos5l_fill_2
XFILLER_15_56 VPWR VGND sg13cmos5l_decap_8
XFILLER_0_232 VPWR VGND sg13cmos5l_decap_8
XFILLER_0_265 VPWR VGND sg13cmos5l_decap_4
XFILLER_1_777 VPWR VGND sg13cmos5l_fill_1
XFILLER_1_766 VPWR VGND sg13cmos5l_decap_8
XANTENNA__248__X Tile_X1Y0_SS4BEG[5] VPWR VGND sg13cmos5l_antennanp
XFILLER_16_122 VPWR VGND sg13cmos5l_decap_4
XFILLER_12_350 VPWR VGND sg13cmos5l_decap_8
XFILLER_16_199 VPWR VGND sg13cmos5l_decap_8
XFILLER_9_877 VPWR VGND sg13cmos5l_decap_8
XFILLER_9_800 VPWR VGND sg13cmos5l_decap_8
XFILLER_8_310 VPWR VGND sg13cmos5l_decap_8
XFILLER_4_560 VPWR VGND sg13cmos5l_decap_8
XFILLER_11_1034 VPWR VGND sg13cmos5l_decap_8
XFILLER_2_508 VPWR VGND sg13cmos5l_decap_8
XANTENNA_205 Tile_X0Y0_N4END[4] VPWR VGND sg13cmos5l_antennanp
XANTENNA_216 Tile_X0Y0_N4END[5] VPWR VGND sg13cmos5l_antennanp
XANTENNA_227 Tile_X0Y0_NN4END[2] VPWR VGND sg13cmos5l_antennanp
XANTENNA_238 Tile_X1Y0_FrameStrobe[5] VPWR VGND sg13cmos5l_antennanp
XANTENNA_249 Tile_X0Y0_FrameData[31] VPWR VGND sg13cmos5l_antennanp
XFILLER_14_604 VPWR VGND sg13cmos5l_decap_8
XFILLER_10_843 VPWR VGND sg13cmos5l_decap_8
XFILLER_13_147 VPWR VGND sg13cmos5l_decap_8
X_291_ Tile_X0Y0_SS4BEG[7] Tile_X0Y0_NN4END[8] VPWR VGND sg13cmos5l_buf_1
X_360_ Tile_X1Y0_FrameStrobe_O[4] Tile_X1Y0_FrameStrobe[4] VPWR VGND sg13cmos5l_buf_1
XFILLER_10_876 VPWR VGND sg13cmos5l_fill_2
XFILLER_5_302 VPWR VGND sg13cmos5l_decap_8
XFILLER_1_574 VPWR VGND sg13cmos5l_decap_8
XFILLER_9_674 VPWR VGND sg13cmos5l_decap_8
XFILLER_8_184 VPWR VGND sg13cmos5l_decap_8
XFILLER_11_629 VPWR VGND sg13cmos5l_decap_8
XANTENNA__351__X Tile_X0Y0_FrameStrobe_O[15] VPWR VGND sg13cmos5l_antennanp
XFILLER_12_35 VPWR VGND sg13cmos5l_decap_8
XFILLER_5_7 VPWR VGND sg13cmos5l_decap_8
XFILLER_3_839 VPWR VGND sg13cmos5l_decap_8
XFILLER_2_316 VPWR VGND sg13cmos5l_fill_1
XFILLER_14_401 VPWR VGND sg13cmos5l_decap_8
XFILLER_15_902 VPWR VGND sg13cmos5l_decap_8
XFILLER_15_913 VPWR VGND sg13cmos5l_fill_2
XFILLER_15_979 VPWR VGND sg13cmos5l_fill_1
XFILLER_2_1087 VPWR VGND sg13cmos5l_fill_1
XFILLER_2_1010 VPWR VGND sg13cmos5l_decap_8
XFILLER_10_673 VPWR VGND sg13cmos5l_decap_8
XFILLER_14_478 VPWR VGND sg13cmos5l_decap_8
X_274_ Tile_X0Y0_S4BEG[6] Tile_X0Y0_N4END[9] VPWR VGND sg13cmos5l_buf_1
X_343_ Tile_X0Y0_FrameStrobe_O[7] Tile_X0Y0_FrameStrobe[7] VPWR VGND sg13cmos5l_buf_1
XFILLER_6_633 VPWR VGND sg13cmos5l_decap_8
XANTENNA__261__X Tile_X0Y0_S2BEGb[1] VPWR VGND sg13cmos5l_antennanp
XFILLER_5_154 VPWR VGND sg13cmos5l_decap_8
XFILLER_9_460 VPWR VGND sg13cmos5l_decap_8
XANTENNA__120__Q NPU_QUANT_SHIFT_IN5 VPWR VGND sg13cmos5l_antennanp
XFILLER_4_91 VPWR VGND sg13cmos5l_decap_8
XANTENNA__346__X Tile_X0Y0_FrameStrobe_O[10] VPWR VGND sg13cmos5l_antennanp
XFILLER_11_448 VPWR VGND sg13cmos5l_fill_2
XFILLER_12_927 VPWR VGND sg13cmos5l_decap_4
XFILLER_3_647 VPWR VGND sg13cmos5l_decap_8
XANTENNA__256__X Tile_X1Y0_SS4BEG[13] VPWR VGND sg13cmos5l_antennanp
XFILLER_14_231 VPWR VGND sg13cmos5l_decap_8
XFILLER_15_798 VPWR VGND sg13cmos5l_decap_8
X_326_ Tile_X1Y0_FrameData_O[22] Tile_X0Y0_FrameData[22] VPWR VGND sg13cmos5l_buf_1
XFILLER_9_14 VPWR VGND sg13cmos5l_decap_8
XFILLER_10_470 VPWR VGND sg13cmos5l_decap_8
X_188_ Tile_X1Y0_FrameStrobe_O[9] Tile_X1Y0_FrameStrobe[9] VPWR VGND sg13cmos5l_buf_1
X_257_ Tile_X1Y0_SS4BEG[14] Tile_X1Y0_NN4END[1] VPWR VGND sg13cmos5l_buf_1
XFILLER_9_1038 VPWR VGND sg13cmos5l_decap_8
XFILLER_1_190 VPWR VGND sg13cmos5l_fill_2
XANTENNA__115__Q NPU_QUANT_SHIFT_IN0 VPWR VGND sg13cmos5l_antennanp
XFILLER_12_713 VPWR VGND sg13cmos5l_decap_8
XFILLER_12_724 VPWR VGND sg13cmos5l_fill_1
XFILLER_12_735 VPWR VGND sg13cmos5l_decap_8
XFILLER_11_245 VPWR VGND sg13cmos5l_decap_8
X_042_ _042_/Q Tile_X0Y0_FrameData[28] VGND VPWR Tile_X0Y0_FrameStrobe[0] latch
X_111_ _111_/Q Tile_X0Y0_FrameData[27] VGND VPWR Tile_X1Y0_FrameStrobe[1] latch
XFILLER_8_728 VPWR VGND sg13cmos5l_decap_8
XFILLER_7_238 VPWR VGND sg13cmos5l_decap_8
XFILLER_8_1060 VPWR VGND sg13cmos5l_decap_8
XFILLER_4_989 VPWR VGND sg13cmos5l_decap_8
XFILLER_15_595 VPWR VGND sg13cmos5l_decap_8
X_309_ Tile_X1Y0_FrameData_O[5] Tile_X0Y0_FrameData[5] VPWR VGND sg13cmos5l_buf_1
XFILLER_11_790 VPWR VGND sg13cmos5l_decap_8
XFILLER_7_750 VPWR VGND sg13cmos5l_decap_8
XFILLER_1_70 VPWR VGND sg13cmos5l_decap_8
XFILLER_14_1054 VPWR VGND sg13cmos5l_decap_8
XFILLER_4_219 VPWR VGND sg13cmos5l_fill_1
XFILLER_12_510 VPWR VGND sg13cmos5l_decap_8
XFILLER_12_587 VPWR VGND sg13cmos5l_decap_8
XFILLER_8_525 VPWR VGND sg13cmos5l_decap_8
XANTENNA_8 Tile_X0Y0_FrameData[0] VPWR VGND sg13cmos5l_antennanp
XFILLER_15_392 VPWR VGND sg13cmos5l_decap_8
XANTENNA__354__X Tile_X0Y0_FrameStrobe_O[18] VPWR VGND sg13cmos5l_antennanp
XFILLER_13_329 VPWR VGND sg13cmos5l_decap_8
XFILLER_14_808 VPWR VGND sg13cmos5l_decap_8
XFILLER_15_35 VPWR VGND sg13cmos5l_decap_8
XFILLER_5_539 VPWR VGND sg13cmos5l_decap_8
XFILLER_0_211 VPWR VGND sg13cmos5l_decap_8
XFILLER_1_756 VPWR VGND sg13cmos5l_fill_2
XFILLER_1_745 VPWR VGND sg13cmos5l_fill_1
XFILLER_16_101 VPWR VGND sg13cmos5l_decap_8
XFILLER_16_178 VPWR VGND sg13cmos5l_decap_4
XANTENNA__264__X Tile_X0Y0_S2BEGb[4] VPWR VGND sg13cmos5l_antennanp
XFILLER_12_373 VPWR VGND sg13cmos5l_fill_1
XFILLER_13_841 VPWR VGND sg13cmos5l_decap_8
XFILLER_13_885 VPWR VGND sg13cmos5l_fill_1
XFILLER_9_856 VPWR VGND sg13cmos5l_decap_8
XFILLER_8_388 VPWR VGND sg13cmos5l_fill_1
XFILLER_16_690 VPWR VGND sg13cmos5l_decap_4
XANTENNA__123__Q NPU_QUANT_SHIFT_IN8 VPWR VGND sg13cmos5l_antennanp
XFILLER_11_1013 VPWR VGND sg13cmos5l_decap_8
XFILLER_7_91 VPWR VGND sg13cmos5l_decap_8
XANTENNA_206 Tile_X0Y0_N4END[4] VPWR VGND sg13cmos5l_antennanp
XANTENNA_217 Tile_X0Y0_N4END[5] VPWR VGND sg13cmos5l_antennanp
XANTENNA_228 Tile_X0Y0_NN4END[2] VPWR VGND sg13cmos5l_antennanp
XANTENNA_239 Tile_X1Y0_FrameStrobe[6] VPWR VGND sg13cmos5l_antennanp
XANTENNA__349__X Tile_X0Y0_FrameStrobe_O[13] VPWR VGND sg13cmos5l_antennanp
XFILLER_10_822 VPWR VGND sg13cmos5l_decap_8
XFILLER_10_888 VPWR VGND sg13cmos5l_decap_8
XFILLER_13_126 VPWR VGND sg13cmos5l_decap_8
X_290_ Tile_X0Y0_SS4BEG[6] Tile_X0Y0_NN4END[9] VPWR VGND sg13cmos5l_buf_1
XFILLER_9_119 VPWR VGND sg13cmos5l_fill_1
XFILLER_6_859 VPWR VGND sg13cmos5l_decap_4
XFILLER_1_553 VPWR VGND sg13cmos5l_decap_8
XANTENNA__259__X Tile_X1Y0_UserCLKo VPWR VGND sg13cmos5l_antennanp
XFILLER_3_49 VPWR VGND sg13cmos5l_decap_8
XFILLER_9_653 VPWR VGND sg13cmos5l_decap_8
XFILLER_8_163 VPWR VGND sg13cmos5l_decap_8
XANTENNA__118__Q NPU_QUANT_SHIFT_IN3 VPWR VGND sg13cmos5l_antennanp
XFILLER_11_608 VPWR VGND sg13cmos5l_decap_8
XFILLER_12_14 VPWR VGND sg13cmos5l_decap_8
XFILLER_3_807 VPWR VGND sg13cmos5l_decap_8
XFILLER_14_457 VPWR VGND sg13cmos5l_decap_8
X_342_ Tile_X0Y0_FrameStrobe_O[6] Tile_X0Y0_FrameStrobe[6] VPWR VGND sg13cmos5l_buf_1
XFILLER_2_1066 VPWR VGND sg13cmos5l_decap_8
XFILLER_10_652 VPWR VGND sg13cmos5l_decap_8
XFILLER_10_696 VPWR VGND sg13cmos5l_decap_8
X_273_ Tile_X0Y0_S4BEG[5] Tile_X0Y0_N4END[10] VPWR VGND sg13cmos5l_buf_1
XFILLER_6_612 VPWR VGND sg13cmos5l_decap_8
XFILLER_5_133 VPWR VGND sg13cmos5l_decap_8
XFILLER_2_862 VPWR VGND sg13cmos5l_fill_2
XFILLER_2_851 VPWR VGND sg13cmos5l_decap_8
XFILLER_4_70 VPWR VGND sg13cmos5l_decap_8
XFILLER_12_906 VPWR VGND sg13cmos5l_decap_8
XANTENNA__362__X Tile_X1Y0_FrameStrobe_O[6] VPWR VGND sg13cmos5l_antennanp
XFILLER_2_169 VPWR VGND sg13cmos5l_decap_8
XFILLER_14_210 VPWR VGND sg13cmos5l_decap_8
XFILLER_14_287 VPWR VGND sg13cmos5l_decap_8
XFILLER_15_777 VPWR VGND sg13cmos5l_decap_8
X_325_ Tile_X1Y0_FrameData_O[21] Tile_X0Y0_FrameData[21] VPWR VGND sg13cmos5l_buf_1
XANTENNA__272__X Tile_X0Y0_S4BEG[4] VPWR VGND sg13cmos5l_antennanp
X_187_ _187_/L_HI VPWR VGND sg13cmos5l_tiehi
X_256_ Tile_X1Y0_SS4BEG[13] Tile_X1Y0_NN4END[2] VPWR VGND sg13cmos5l_buf_1
XFILLER_6_486 VPWR VGND sg13cmos5l_decap_8
XFILLER_9_1017 VPWR VGND sg13cmos5l_decap_8
XFILLER_9_291 VPWR VGND sg13cmos5l_decap_8
XANTENNA__131__Q NPU_QUANT_SHIFT_IN16 VPWR VGND sg13cmos5l_antennanp
XANTENNA__357__X Tile_X1Y0_FrameStrobe_O[1] VPWR VGND sg13cmos5l_antennanp
XFILLER_11_224 VPWR VGND sg13cmos5l_decap_8
X_110_ _110_/Q Tile_X0Y0_FrameData[28] VGND VPWR Tile_X1Y0_FrameStrobe[1] latch
XFILLER_8_707 VPWR VGND sg13cmos5l_decap_8
X_041_ _041_/Q Tile_X0Y0_FrameData[29] VGND VPWR Tile_X0Y0_FrameStrobe[0] latch
XFILLER_7_217 VPWR VGND sg13cmos5l_decap_8
XFILLER_4_902 VPWR VGND sg13cmos5l_decap_8
XFILLER_3_412 VPWR VGND sg13cmos5l_fill_1
XANTENNA__267__X Tile_X0Y0_S2BEGb[7] VPWR VGND sg13cmos5l_antennanp
XFILLER_15_574 VPWR VGND sg13cmos5l_decap_8
X_239_ Tile_X1Y0_S4BEG[12] Tile_X1Y0_N4END[3] VPWR VGND sg13cmos5l_buf_1
X_308_ Tile_X1Y0_FrameData_O[4] Tile_X0Y0_FrameData[4] VPWR VGND sg13cmos5l_buf_1
XFILLER_3_990 VPWR VGND sg13cmos5l_decap_8
XANTENNA__126__Q NPU_QUANT_SHIFT_IN11 VPWR VGND sg13cmos5l_antennanp
XFILLER_14_1033 VPWR VGND sg13cmos5l_decap_8
XFILLER_16_349 VPWR VGND sg13cmos5l_fill_1
XFILLER_12_566 VPWR VGND sg13cmos5l_decap_8
XFILLER_8_504 VPWR VGND sg13cmos5l_decap_8
XANTENNA_9 Tile_X0Y0_FrameData[0] VPWR VGND sg13cmos5l_antennanp
XFILLER_10_91 VPWR VGND sg13cmos5l_decap_8
XFILLER_6_49 VPWR VGND sg13cmos5l_decap_8
XFILLER_4_798 VPWR VGND sg13cmos5l_fill_2
XFILLER_4_787 VPWR VGND sg13cmos5l_fill_2
XFILLER_4_754 VPWR VGND sg13cmos5l_decap_8
XFILLER_4_743 VPWR VGND sg13cmos5l_decap_8
XFILLER_4_721 VPWR VGND sg13cmos5l_fill_1
XFILLER_4_710 VPWR VGND sg13cmos5l_decap_4
XFILLER_0_993 VPWR VGND sg13cmos5l_fill_2
XFILLER_13_7 VPWR VGND sg13cmos5l_decap_8
XFILLER_6_1009 VPWR VGND sg13cmos5l_decap_8
XFILLER_15_371 VPWR VGND sg13cmos5l_decap_8
XFILLER_15_14 VPWR VGND sg13cmos5l_decap_8
XFILLER_13_308 VPWR VGND sg13cmos5l_decap_8
XFILLER_5_518 VPWR VGND sg13cmos5l_decap_8
XFILLER_1_713 VPWR VGND sg13cmos5l_decap_8
XFILLER_1_702 VPWR VGND sg13cmos5l_decap_8
XFILLER_5_1064 VPWR VGND sg13cmos5l_decap_8
XFILLER_13_831 VPWR VGND sg13cmos5l_fill_1
XFILLER_16_157 VPWR VGND sg13cmos5l_decap_8
XFILLER_9_835 VPWR VGND sg13cmos5l_decap_8
XFILLER_8_345 VPWR VGND sg13cmos5l_fill_1
XANTENNA__280__X Tile_X0Y0_S4BEG[12] VPWR VGND sg13cmos5l_antennanp
XFILLER_4_595 VPWR VGND sg13cmos5l_decap_8
XANTENNA__190__X Tile_X1Y0_FrameStrobe_O[11] VPWR VGND sg13cmos5l_antennanp
XFILLER_11_1069 VPWR VGND sg13cmos5l_decap_8
XFILLER_7_70 VPWR VGND sg13cmos5l_decap_8
XANTENNA_207 Tile_X0Y0_N4END[4] VPWR VGND sg13cmos5l_antennanp
XANTENNA_218 Tile_X0Y0_N4END[5] VPWR VGND sg13cmos5l_antennanp
XANTENNA_229 Tile_X0Y0_NN4END[2] VPWR VGND sg13cmos5l_antennanp
XFILLER_13_105 VPWR VGND sg13cmos5l_decap_8
XFILLER_10_801 VPWR VGND sg13cmos5l_decap_8
XFILLER_6_827 VPWR VGND sg13cmos5l_decap_8
XFILLER_3_28 VPWR VGND sg13cmos5l_decap_8
XFILLER_1_532 VPWR VGND sg13cmos5l_decap_8
XFILLER_1_521 VPWR VGND sg13cmos5l_fill_1
XFILLER_1_510 VPWR VGND sg13cmos5l_decap_8
XANTENNA__275__X Tile_X0Y0_S4BEG[7] VPWR VGND sg13cmos5l_antennanp
XFILLER_13_694 VPWR VGND sg13cmos5l_fill_2
XFILLER_9_632 VPWR VGND sg13cmos5l_decap_8
XFILLER_12_182 VPWR VGND sg13cmos5l_decap_8
XFILLER_8_142 VPWR VGND sg13cmos5l_decap_8
XANTENNA__134__Q NPU_QUANT_SHIFT_IN19 VPWR VGND sg13cmos5l_antennanp
XFILLER_10_119 VPWR VGND sg13cmos5l_decap_8
XFILLER_2_1045 VPWR VGND sg13cmos5l_decap_8
XFILLER_14_436 VPWR VGND sg13cmos5l_decap_8
X_272_ Tile_X0Y0_S4BEG[4] Tile_X0Y0_N4END[11] VPWR VGND sg13cmos5l_buf_1
X_341_ Tile_X0Y0_FrameStrobe_O[5] Tile_X0Y0_FrameStrobe[5] VPWR VGND sg13cmos5l_buf_1
XFILLER_10_631 VPWR VGND sg13cmos5l_decap_8
XFILLER_5_189 VPWR VGND sg13cmos5l_decap_8
XFILLER_5_112 VPWR VGND sg13cmos5l_decap_8
XFILLER_2_885 VPWR VGND sg13cmos5l_decap_4
XFILLER_1_384 VPWR VGND sg13cmos5l_fill_1
XFILLER_13_491 VPWR VGND sg13cmos5l_decap_8
XFILLER_9_495 VPWR VGND sg13cmos5l_decap_8
XANTENNA__129__Q NPU_QUANT_SHIFT_IN14 VPWR VGND sg13cmos5l_antennanp
XFILLER_3_605 VPWR VGND sg13cmos5l_decap_8
XFILLER_2_126 VPWR VGND sg13cmos5l_decap_8
XANTENNA__039__Q NPU_PSUM_SKEW_EN VPWR VGND sg13cmos5l_antennanp
XFILLER_0_18 VPWR VGND sg13cmos5l_fill_2
XFILLER_15_701 VPWR VGND sg13cmos5l_fill_1
XFILLER_15_734 VPWR VGND sg13cmos5l_fill_1
XFILLER_11_973 VPWR VGND sg13cmos5l_fill_1
XFILLER_14_266 VPWR VGND sg13cmos5l_decap_8
XFILLER_15_756 VPWR VGND sg13cmos5l_decap_8
X_255_ Tile_X1Y0_SS4BEG[12] Tile_X1Y0_NN4END[3] VPWR VGND sg13cmos5l_buf_1
X_324_ Tile_X1Y0_FrameData_O[20] Tile_X0Y0_FrameData[20] VPWR VGND sg13cmos5l_buf_1
XFILLER_9_49 VPWR VGND sg13cmos5l_decap_8
XFILLER_13_91 VPWR VGND sg13cmos5l_decap_8
X_186_ _186_/L_HI VPWR VGND sg13cmos5l_tiehi
XFILLER_2_682 VPWR VGND sg13cmos5l_decap_8
XFILLER_9_270 VPWR VGND sg13cmos5l_decap_8
XFILLER_11_203 VPWR VGND sg13cmos5l_decap_8
X_040_ _040_/Q Tile_X0Y0_FrameData[30] VGND VPWR Tile_X0Y0_FrameStrobe[0] latch
XFILLER_15_553 VPWR VGND sg13cmos5l_decap_8
XANTENNA__283__X Tile_X0Y0_S4BEG[15] VPWR VGND sg13cmos5l_antennanp
XFILLER_10_280 VPWR VGND sg13cmos5l_decap_8
X_169_ _169_/L_HI VPWR VGND sg13cmos5l_tiehi
X_238_ Tile_X1Y0_S4BEG[11] Tile_X1Y0_N4END[4] VPWR VGND sg13cmos5l_buf_1
X_307_ Tile_X1Y0_FrameData_O[3] Tile_X0Y0_FrameData[3] VPWR VGND sg13cmos5l_buf_1
XFILLER_7_785 VPWR VGND sg13cmos5l_decap_8
XFILLER_6_284 VPWR VGND sg13cmos5l_decap_8
XANTENNA__193__X Tile_X1Y0_FrameStrobe_O[14] VPWR VGND sg13cmos5l_antennanp
XFILLER_14_1012 VPWR VGND sg13cmos5l_decap_8
XANTENNA__142__Q NPU_QUANT_SHIFT_IN27 VPWR VGND sg13cmos5l_antennanp
XFILLER_14_1089 VPWR VGND sg13cmos5l_decap_8
XFILLER_1_917 VPWR VGND sg13cmos5l_decap_4
XFILLER_1_939 VPWR VGND sg13cmos5l_decap_4
XFILLER_16_328 VPWR VGND sg13cmos5l_decap_8
XFILLER_12_545 VPWR VGND sg13cmos5l_decap_8
XFILLER_6_28 VPWR VGND sg13cmos5l_decap_8
XFILLER_10_70 VPWR VGND sg13cmos5l_decap_8
XFILLER_3_298 VPWR VGND sg13cmos5l_decap_8
XFILLER_3_254 VPWR VGND sg13cmos5l_decap_8
XANTENNA__278__X Tile_X0Y0_S4BEG[10] VPWR VGND sg13cmos5l_antennanp
XFILLER_15_350 VPWR VGND sg13cmos5l_decap_8
XFILLER_16_884 VPWR VGND sg13cmos5l_decap_8
XFILLER_7_582 VPWR VGND sg13cmos5l_decap_8
XANTENNA__188__X Tile_X1Y0_FrameStrobe_O[9] VPWR VGND sg13cmos5l_antennanp
XANTENNA__137__Q NPU_QUANT_SHIFT_IN22 VPWR VGND sg13cmos5l_antennanp
XFILLER_0_246 VPWR VGND sg13cmos5l_decap_8
XFILLER_1_758 VPWR VGND sg13cmos5l_fill_1
XFILLER_0_279 VPWR VGND sg13cmos5l_fill_2
XFILLER_5_1043 VPWR VGND sg13cmos5l_decap_8
XFILLER_13_810 VPWR VGND sg13cmos5l_decap_8
XFILLER_16_136 VPWR VGND sg13cmos5l_decap_8
XFILLER_9_814 VPWR VGND sg13cmos5l_decap_8
XFILLER_12_364 VPWR VGND sg13cmos5l_decap_8
XFILLER_8_324 VPWR VGND sg13cmos5l_decap_8
XFILLER_4_574 VPWR VGND sg13cmos5l_decap_8
XFILLER_16_681 VPWR VGND sg13cmos5l_decap_4
XFILLER_11_1048 VPWR VGND sg13cmos5l_decap_8
XANTENNA_208 Tile_X0Y0_N4END[4] VPWR VGND sg13cmos5l_antennanp
XANTENNA_219 Tile_X0Y0_N4END[5] VPWR VGND sg13cmos5l_antennanp
XFILLER_14_618 VPWR VGND sg13cmos5l_decap_8
XFILLER_14_629 VPWR VGND sg13cmos5l_fill_2
XFILLER_5_349 VPWR VGND sg13cmos5l_fill_2
XFILLER_5_316 VPWR VGND sg13cmos5l_decap_8
XFILLER_1_588 VPWR VGND sg13cmos5l_decap_8
XANTENNA__291__X Tile_X0Y0_SS4BEG[7] VPWR VGND sg13cmos5l_antennanp
XFILLER_12_161 VPWR VGND sg13cmos5l_decap_8
XFILLER_13_673 VPWR VGND sg13cmos5l_decap_8
XFILLER_9_611 VPWR VGND sg13cmos5l_decap_8
XFILLER_16_80 VPWR VGND sg13cmos5l_decap_8
XFILLER_9_688 VPWR VGND sg13cmos5l_decap_8
XFILLER_8_198 VPWR VGND sg13cmos5l_decap_8
XFILLER_5_861 VPWR VGND sg13cmos5l_fill_1
XFILLER_12_49 VPWR VGND sg13cmos5l_decap_8
XANTENNA__150__Q NPU_QUANT_SHIFT_EN VPWR VGND sg13cmos5l_antennanp
XFILLER_2_1024 VPWR VGND sg13cmos5l_decap_8
XFILLER_10_610 VPWR VGND sg13cmos5l_decap_8
XFILLER_14_415 VPWR VGND sg13cmos5l_decap_8
X_271_ Tile_X0Y0_S4BEG[3] Tile_X0Y0_N4END[12] VPWR VGND sg13cmos5l_buf_1
X_340_ Tile_X0Y0_FrameStrobe_O[4] Tile_X0Y0_FrameStrobe[4] VPWR VGND sg13cmos5l_buf_1
XFILLER_10_687 VPWR VGND sg13cmos5l_decap_4
XFILLER_6_669 VPWR VGND sg13cmos5l_decap_8
XFILLER_6_647 VPWR VGND sg13cmos5l_decap_8
XFILLER_5_168 VPWR VGND sg13cmos5l_decap_8
XFILLER_2_820 VPWR VGND sg13cmos5l_decap_4
XANTENNA__286__X Tile_X0Y0_SS4BEG[2] VPWR VGND sg13cmos5l_antennanp
XFILLER_13_470 VPWR VGND sg13cmos5l_decap_8
XFILLER_9_474 VPWR VGND sg13cmos5l_decap_8
XANTENNA__196__X Tile_X1Y0_FrameStrobe_O[17] VPWR VGND sg13cmos5l_antennanp
XANTENNA__145__Q NPU_COMPUTE_BANK_SWAP VPWR VGND sg13cmos5l_antennanp
XFILLER_11_429 VPWR VGND sg13cmos5l_fill_2
XFILLER_3_7 VPWR VGND sg13cmos5l_decap_8
XFILLER_2_105 VPWR VGND sg13cmos5l_decap_8
XFILLER_14_245 VPWR VGND sg13cmos5l_decap_8
XFILLER_15_713 VPWR VGND sg13cmos5l_fill_1
XFILLER_10_484 VPWR VGND sg13cmos5l_decap_8
XFILLER_11_952 VPWR VGND sg13cmos5l_decap_8
XFILLER_11_985 VPWR VGND sg13cmos5l_decap_8
XFILLER_13_70 VPWR VGND sg13cmos5l_decap_8
X_185_ _185_/L_HI VPWR VGND sg13cmos5l_tiehi
X_254_ Tile_X1Y0_SS4BEG[11] Tile_X1Y0_NN4END[4] VPWR VGND sg13cmos5l_buf_1
X_323_ Tile_X1Y0_FrameData_O[19] Tile_X0Y0_FrameData[19] VPWR VGND sg13cmos5l_buf_1
XFILLER_9_28 VPWR VGND sg13cmos5l_decap_8
XFILLER_7_956 VPWR VGND sg13cmos5l_decap_8
XFILLER_2_650 VPWR VGND sg13cmos5l_decap_4
XFILLER_1_171 VPWR VGND sg13cmos5l_decap_4
XFILLER_11_259 VPWR VGND sg13cmos5l_decap_8
XFILLER_12_749 VPWR VGND sg13cmos5l_decap_8
XFILLER_8_1074 VPWR VGND sg13cmos5l_fill_2
XFILLER_15_532 VPWR VGND sg13cmos5l_decap_8
X_306_ Tile_X1Y0_FrameData_O[2] Tile_X0Y0_FrameData[2] VPWR VGND sg13cmos5l_buf_1
X_168_ _168_/L_HI VPWR VGND sg13cmos5l_tiehi
X_237_ Tile_X1Y0_S4BEG[10] Tile_X1Y0_N4END[5] VPWR VGND sg13cmos5l_buf_1
XFILLER_7_764 VPWR VGND sg13cmos5l_decap_8
XFILLER_6_263 VPWR VGND sg13cmos5l_decap_8
X_099_ _099_/Q Tile_X0Y0_FrameData[7] VGND VPWR Tile_X1Y0_FrameStrobe[0] latch
XFILLER_1_84 VPWR VGND sg13cmos5l_decap_8
XFILLER_14_1068 VPWR VGND sg13cmos5l_decap_8
XFILLER_1_929 VPWR VGND sg13cmos5l_fill_2
XFILLER_12_524 VPWR VGND sg13cmos5l_decap_8
XFILLER_16_307 VPWR VGND sg13cmos5l_decap_8
XFILLER_8_539 VPWR VGND sg13cmos5l_decap_8
XFILLER_0_940 VPWR VGND sg13cmos5l_decap_4
XFILLER_4_789 VPWR VGND sg13cmos5l_fill_1
XFILLER_3_277 VPWR VGND sg13cmos5l_decap_8
XANTENNA__294__X Tile_X0Y0_SS4BEG[10] VPWR VGND sg13cmos5l_antennanp
XFILLER_16_863 VPWR VGND sg13cmos5l_decap_8
XFILLER_7_561 VPWR VGND sg13cmos5l_decap_8
XFILLER_15_49 VPWR VGND sg13cmos5l_decap_8
XFILLER_0_225 VPWR VGND sg13cmos5l_decap_8
XFILLER_0_269 VPWR VGND sg13cmos5l_fill_2
XFILLER_16_115 VPWR VGND sg13cmos5l_decap_8
XFILLER_5_1022 VPWR VGND sg13cmos5l_decap_8
XFILLER_12_343 VPWR VGND sg13cmos5l_decap_8
XFILLER_8_303 VPWR VGND sg13cmos5l_decap_8
XFILLER_4_553 VPWR VGND sg13cmos5l_decap_8
XANTENNA__289__X Tile_X0Y0_SS4BEG[5] VPWR VGND sg13cmos5l_antennanp
XFILLER_16_671 VPWR VGND sg13cmos5l_decap_8
XFILLER_11_1027 VPWR VGND sg13cmos5l_decap_8
XANTENNA__199__X Tile_X0Y0_S2BEG[0] VPWR VGND sg13cmos5l_antennanp
XANTENNA_209 Tile_X0Y0_N4END[4] VPWR VGND sg13cmos5l_antennanp
XANTENNA__148__Q NPU_PSUM_SYSTOLIC_EN VPWR VGND sg13cmos5l_antennanp
XFILLER_10_836 VPWR VGND sg13cmos5l_decap_8
XFILLER_10_858 VPWR VGND sg13cmos5l_fill_2
XFILLER_1_567 VPWR VGND sg13cmos5l_decap_8
XFILLER_12_140 VPWR VGND sg13cmos5l_decap_8
XFILLER_13_652 VPWR VGND sg13cmos5l_decap_8
XFILLER_13_696 VPWR VGND sg13cmos5l_fill_1
XFILLER_9_667 VPWR VGND sg13cmos5l_decap_8
XFILLER_8_177 VPWR VGND sg13cmos5l_decap_8
XFILLER_10_1093 VPWR VGND sg13cmos5l_decap_8
XFILLER_12_28 VPWR VGND sg13cmos5l_decap_8
XFILLER_2_309 VPWR VGND sg13cmos5l_decap_8
XFILLER_2_1003 VPWR VGND sg13cmos5l_decap_8
XFILLER_10_666 VPWR VGND sg13cmos5l_decap_8
X_270_ Tile_X0Y0_S4BEG[2] Tile_X0Y0_N4END[13] VPWR VGND sg13cmos5l_buf_1
XFILLER_6_626 VPWR VGND sg13cmos5l_decap_8
XFILLER_5_147 VPWR VGND sg13cmos5l_decap_8
X_399_ _399_/X Tile_X0Y0_N1END[2] Tile_X0Y0_N2MID[2] Tile_X0Y0_N2MID[5] Tile_X0Y0_N2END[5]
+ _040_/Q _075_/Q VPWR VGND sg13cmos5l_mux4_1
XFILLER_9_453 VPWR VGND sg13cmos5l_decap_8
XFILLER_4_84 VPWR VGND sg13cmos5l_decap_8
XFILLER_4_191 VPWR VGND sg13cmos5l_decap_8
XFILLER_14_224 VPWR VGND sg13cmos5l_decap_8
X_322_ Tile_X1Y0_FrameData_O[18] Tile_X0Y0_FrameData[18] VPWR VGND sg13cmos5l_buf_1
XFILLER_10_463 VPWR VGND sg13cmos5l_decap_8
XFILLER_11_931 VPWR VGND sg13cmos5l_decap_8
X_184_ _184_/L_HI VPWR VGND sg13cmos5l_tiehi
X_253_ Tile_X1Y0_SS4BEG[10] Tile_X1Y0_NN4END[5] VPWR VGND sg13cmos5l_buf_1
XANTENNA__297__X Tile_X0Y0_SS4BEG[13] VPWR VGND sg13cmos5l_antennanp
XFILLER_14_780 VPWR VGND sg13cmos5l_decap_8
XFILLER_12_706 VPWR VGND sg13cmos5l_decap_8
XFILLER_12_728 VPWR VGND sg13cmos5l_decap_8
XFILLER_11_238 VPWR VGND sg13cmos5l_decap_8
XFILLER_15_511 VPWR VGND sg13cmos5l_decap_8
XFILLER_8_1053 VPWR VGND sg13cmos5l_decap_8
XFILLER_15_588 VPWR VGND sg13cmos5l_decap_8
X_305_ Tile_X1Y0_FrameData_O[1] Tile_X0Y0_FrameData[1] VPWR VGND sg13cmos5l_buf_1
XFILLER_11_783 VPWR VGND sg13cmos5l_decap_8
X_098_ _098_/Q Tile_X0Y0_FrameData[8] VGND VPWR Tile_X1Y0_FrameStrobe[0] latch
X_167_ _167_/L_HI VPWR VGND sg13cmos5l_tiehi
X_236_ Tile_X1Y0_S4BEG[9] Tile_X1Y0_N4END[6] VPWR VGND sg13cmos5l_buf_1
XFILLER_7_743 VPWR VGND sg13cmos5l_decap_8
XFILLER_6_242 VPWR VGND sg13cmos5l_decap_8
XFILLER_1_63 VPWR VGND sg13cmos5l_decap_8
XFILLER_14_1047 VPWR VGND sg13cmos5l_decap_8
XFILLER_12_503 VPWR VGND sg13cmos5l_decap_8
XFILLER_8_518 VPWR VGND sg13cmos5l_decap_8
XFILLER_3_223 VPWR VGND sg13cmos5l_fill_2
XFILLER_0_985 VPWR VGND sg13cmos5l_fill_1
XFILLER_16_842 VPWR VGND sg13cmos5l_decap_8
XFILLER_11_580 VPWR VGND sg13cmos5l_decap_8
XFILLER_15_385 VPWR VGND sg13cmos5l_decap_8
X_219_ Tile_X1Y0_S2BEGb[0] Tile_X1Y0_N2END[7] VPWR VGND sg13cmos5l_buf_1
XFILLER_7_540 VPWR VGND sg13cmos5l_decap_8
XFILLER_0_1101 VPWR VGND sg13cmos5l_fill_2
XFILLER_0_1112 VPWR VGND sg13cmos5l_fill_2
XFILLER_15_28 VPWR VGND sg13cmos5l_decap_8
XFILLER_0_204 VPWR VGND sg13cmos5l_decap_8
XFILLER_1_749 VPWR VGND sg13cmos5l_decap_8
XFILLER_12_322 VPWR VGND sg13cmos5l_decap_8
XFILLER_9_849 VPWR VGND sg13cmos5l_decap_8
XFILLER_4_532 VPWR VGND sg13cmos5l_decap_8
XFILLER_0_793 VPWR VGND sg13cmos5l_decap_8
XFILLER_11_7 VPWR VGND sg13cmos5l_decap_8
XFILLER_15_182 VPWR VGND sg13cmos5l_decap_8
XFILLER_11_1006 VPWR VGND sg13cmos5l_decap_8
XFILLER_8_882 VPWR VGND sg13cmos5l_decap_8
XFILLER_7_84 VPWR VGND sg13cmos5l_decap_8
XFILLER_10_815 VPWR VGND sg13cmos5l_decap_8
XFILLER_13_119 VPWR VGND sg13cmos5l_decap_8
XFILLER_1_546 VPWR VGND sg13cmos5l_decap_8
XFILLER_13_631 VPWR VGND sg13cmos5l_decap_8
XFILLER_12_196 VPWR VGND sg13cmos5l_decap_8
XFILLER_9_646 VPWR VGND sg13cmos5l_decap_8
XFILLER_8_156 VPWR VGND sg13cmos5l_decap_8
XFILLER_8_123 VPWR VGND sg13cmos5l_fill_1
XFILLER_8_112 VPWR VGND sg13cmos5l_decap_8
XFILLER_10_1072 VPWR VGND sg13cmos5l_decap_8
XFILLER_4_351 VPWR VGND sg13cmos5l_fill_2
XFILLER_16_480 VPWR VGND sg13cmos5l_fill_1
XFILLER_2_1059 VPWR VGND sg13cmos5l_decap_8
XFILLER_10_645 VPWR VGND sg13cmos5l_decap_8
XFILLER_6_605 VPWR VGND sg13cmos5l_decap_8
XFILLER_5_126 VPWR VGND sg13cmos5l_decap_8
XFILLER_2_844 VPWR VGND sg13cmos5l_decap_8
XFILLER_2_800 VPWR VGND sg13cmos5l_decap_8
XFILLER_14_962 VPWR VGND sg13cmos5l_decap_8
X_398_ _398_/X Tile_X1Y0_N1END[0] Tile_X1Y0_N2MID[0] Tile_X1Y0_N2MID[7] Tile_X1Y0_N2END[7]
+ _082_/Q _081_/Q VPWR VGND sg13cmos5l_mux4_1
XFILLER_9_432 VPWR VGND sg13cmos5l_decap_8
XFILLER_5_693 VPWR VGND sg13cmos5l_decap_8
XFILLER_4_63 VPWR VGND sg13cmos5l_decap_8
XFILLER_1_1081 VPWR VGND sg13cmos5l_decap_8
XFILLER_11_910 VPWR VGND sg13cmos5l_decap_8
XFILLER_14_203 VPWR VGND sg13cmos5l_decap_8
XFILLER_15_726 VPWR VGND sg13cmos5l_fill_1
X_252_ Tile_X1Y0_SS4BEG[9] Tile_X1Y0_NN4END[6] VPWR VGND sg13cmos5l_buf_1
X_321_ Tile_X1Y0_FrameData_O[17] Tile_X0Y0_FrameData[17] VPWR VGND sg13cmos5l_buf_1
X_183_ _183_/L_HI VPWR VGND sg13cmos5l_tiehi
XFILLER_6_479 VPWR VGND sg13cmos5l_decap_8
XFILLER_6_468 VPWR VGND sg13cmos5l_fill_1
XFILLER_2_696 VPWR VGND sg13cmos5l_decap_4
XFILLER_2_641 VPWR VGND sg13cmos5l_decap_4
XFILLER_13_280 VPWR VGND sg13cmos5l_decap_8
XFILLER_9_284 VPWR VGND sg13cmos5l_decap_8
XFILLER_5_490 VPWR VGND sg13cmos5l_decap_8
XFILLER_11_217 VPWR VGND sg13cmos5l_decap_8
XFILLER_8_1032 VPWR VGND sg13cmos5l_decap_8
XFILLER_11_762 VPWR VGND sg13cmos5l_decap_8
XFILLER_15_567 VPWR VGND sg13cmos5l_decap_8
X_235_ Tile_X1Y0_S4BEG[8] Tile_X1Y0_N4END[7] VPWR VGND sg13cmos5l_buf_1
X_304_ Tile_X1Y0_FrameData_O[0] Tile_X0Y0_FrameData[0] VPWR VGND sg13cmos5l_buf_1
XFILLER_7_722 VPWR VGND sg13cmos5l_decap_8
XFILLER_6_210 VPWR VGND sg13cmos5l_decap_8
XFILLER_10_294 VPWR VGND sg13cmos5l_decap_8
X_097_ _097_/Q Tile_X0Y0_FrameData[9] VGND VPWR Tile_X1Y0_FrameStrobe[0] latch
X_166_ _166_/L_HI VPWR VGND sg13cmos5l_tiehi
XFILLER_7_799 VPWR VGND sg13cmos5l_decap_8
XFILLER_6_298 VPWR VGND sg13cmos5l_decap_8
XFILLER_6_221 VPWR VGND sg13cmos5l_decap_8
XFILLER_3_983 VPWR VGND sg13cmos5l_decap_8
XFILLER_1_42 VPWR VGND sg13cmos5l_decap_8
XANTENNA_190 Tile_X0Y0_FrameData[9] VPWR VGND sg13cmos5l_antennanp
XFILLER_14_1026 VPWR VGND sg13cmos5l_decap_8
XFILLER_12_559 VPWR VGND sg13cmos5l_decap_8
XFILLER_4_703 VPWR VGND sg13cmos5l_decap_8
XFILLER_3_268 VPWR VGND sg13cmos5l_fill_1
XFILLER_10_84 VPWR VGND sg13cmos5l_decap_8
XFILLER_15_364 VPWR VGND sg13cmos5l_decap_8
XFILLER_16_898 VPWR VGND sg13cmos5l_decap_8
XFILLER_16_821 VPWR VGND sg13cmos5l_decap_8
X_149_ NPU_ARRAY_EN Tile_X0Y0_UserCLK _400_/X _164_/L_HI VPWR VGND sg13cmos5l_dfrbpq_1
X_218_ Tile_X1Y0_S2BEG[7] Tile_X1Y0_N2MID[0] VPWR VGND sg13cmos5l_buf_1
XFILLER_7_596 VPWR VGND sg13cmos5l_decap_8
XFILLER_5_1057 VPWR VGND sg13cmos5l_decap_8
XFILLER_1_728 VPWR VGND sg13cmos5l_fill_1
XFILLER_12_301 VPWR VGND sg13cmos5l_decap_8
XFILLER_13_824 VPWR VGND sg13cmos5l_decap_8
XANTENNA_90 Tile_X0Y0_FrameData[25] VPWR VGND sg13cmos5l_antennanp
XFILLER_9_828 VPWR VGND sg13cmos5l_decap_8
XFILLER_8_338 VPWR VGND sg13cmos5l_decap_8
XFILLER_4_588 VPWR VGND sg13cmos5l_decap_8
XFILLER_4_511 VPWR VGND sg13cmos5l_decap_8
XFILLER_0_772 VPWR VGND sg13cmos5l_decap_8
XFILLER_15_161 VPWR VGND sg13cmos5l_decap_8
XFILLER_8_861 VPWR VGND sg13cmos5l_decap_8
XFILLER_7_63 VPWR VGND sg13cmos5l_decap_8
XFILLER_1_525 VPWR VGND sg13cmos5l_decap_8
XFILLER_1_503 VPWR VGND sg13cmos5l_decap_8
XFILLER_13_610 VPWR VGND sg13cmos5l_decap_8
XFILLER_9_625 VPWR VGND sg13cmos5l_decap_8
XFILLER_16_94 VPWR VGND sg13cmos5l_decap_4
XFILLER_10_1051 VPWR VGND sg13cmos5l_decap_8
XFILLER_12_175 VPWR VGND sg13cmos5l_decap_8
XFILLER_13_687 VPWR VGND sg13cmos5l_decap_8
XFILLER_8_135 VPWR VGND sg13cmos5l_decap_8
XFILLER_0_580 VPWR VGND sg13cmos5l_decap_8
XFILLER_2_1038 VPWR VGND sg13cmos5l_decap_8
XFILLER_14_429 VPWR VGND sg13cmos5l_decap_8
XFILLER_10_624 VPWR VGND sg13cmos5l_decap_8
XFILLER_5_105 VPWR VGND sg13cmos5l_decap_8
XFILLER_2_889 VPWR VGND sg13cmos5l_fill_2
XFILLER_12_1102 VPWR VGND sg13cmos5l_decap_8
XFILLER_13_484 VPWR VGND sg13cmos5l_decap_8
X_397_ _397_/X Tile_X1Y0_N1END[1] Tile_X1Y0_N2MID[1] Tile_X1Y0_N2MID[6] Tile_X1Y0_N2END[6]
+ _080_/Q _079_/Q VPWR VGND sg13cmos5l_mux4_1
XFILLER_12_1113 VPWR VGND sg13cmos5l_fill_1
XFILLER_9_488 VPWR VGND sg13cmos5l_decap_8
XFILLER_5_672 VPWR VGND sg13cmos5l_decap_8
XFILLER_4_42 VPWR VGND sg13cmos5l_decap_8
XFILLER_4_182 VPWR VGND sg13cmos5l_decap_4
XFILLER_1_1060 VPWR VGND sg13cmos5l_decap_8
XFILLER_2_119 VPWR VGND sg13cmos5l_decap_8
XFILLER_11_966 VPWR VGND sg13cmos5l_decap_8
XFILLER_14_259 VPWR VGND sg13cmos5l_decap_8
XFILLER_15_749 VPWR VGND sg13cmos5l_decap_8
X_182_ _182_/L_HI VPWR VGND sg13cmos5l_tiehi
X_251_ Tile_X1Y0_SS4BEG[8] Tile_X1Y0_NN4END[7] VPWR VGND sg13cmos5l_buf_1
X_320_ Tile_X1Y0_FrameData_O[16] Tile_X0Y0_FrameData[16] VPWR VGND sg13cmos5l_buf_1
XFILLER_10_498 VPWR VGND sg13cmos5l_decap_8
XFILLER_11_999 VPWR VGND sg13cmos5l_decap_8
XFILLER_13_84 VPWR VGND sg13cmos5l_decap_8
XFILLER_8_0 VPWR VGND sg13cmos5l_decap_8
XFILLER_2_620 VPWR VGND sg13cmos5l_decap_8
XFILLER_2_675 VPWR VGND sg13cmos5l_decap_8
XFILLER_2_664 VPWR VGND sg13cmos5l_fill_1
XFILLER_9_263 VPWR VGND sg13cmos5l_decap_8
XFILLER_8_1011 VPWR VGND sg13cmos5l_decap_8
XFILLER_1_7 VPWR VGND sg13cmos5l_decap_8
XFILLER_15_546 VPWR VGND sg13cmos5l_decap_8
XFILLER_10_273 VPWR VGND sg13cmos5l_decap_8
XFILLER_11_741 VPWR VGND sg13cmos5l_decap_8
X_165_ _165_/L_HI VPWR VGND sg13cmos5l_tiehi
X_234_ Tile_X1Y0_S4BEG[7] Tile_X1Y0_N4END[8] VPWR VGND sg13cmos5l_buf_1
X_303_ Tile_X0Y0_S1BEG[3] Tile_X0Y0_N1END[0] VPWR VGND sg13cmos5l_buf_1
XFILLER_7_701 VPWR VGND sg13cmos5l_decap_8
X_096_ _096_/Q Tile_X0Y0_FrameData[10] VGND VPWR Tile_X1Y0_FrameStrobe[0] latch
XFILLER_7_778 VPWR VGND sg13cmos5l_decap_8
XFILLER_6_277 VPWR VGND sg13cmos5l_decap_8
XFILLER_3_962 VPWR VGND sg13cmos5l_decap_8
XFILLER_2_494 VPWR VGND sg13cmos5l_decap_8
XFILLER_1_98 VPWR VGND sg13cmos5l_decap_8
XFILLER_1_21 VPWR VGND sg13cmos5l_decap_8
XANTENNA_180 Tile_X0Y0_FrameData[8] VPWR VGND sg13cmos5l_antennanp
XANTENNA_191 Tile_X0Y0_N4END[12] VPWR VGND sg13cmos5l_antennanp
XFILLER_14_1005 VPWR VGND sg13cmos5l_decap_8
XFILLER_14_590 VPWR VGND sg13cmos5l_decap_8
XFILLER_12_538 VPWR VGND sg13cmos5l_decap_8
XFILLER_10_63 VPWR VGND sg13cmos5l_decap_8
XFILLER_3_247 VPWR VGND sg13cmos5l_decap_8
XFILLER_3_225 VPWR VGND sg13cmos5l_fill_1
XANTENNA__202__X Tile_X0Y0_S2BEG[3] VPWR VGND sg13cmos5l_antennanp
XFILLER_16_800 VPWR VGND sg13cmos5l_decap_8
XFILLER_15_343 VPWR VGND sg13cmos5l_decap_8
XFILLER_16_877 VPWR VGND sg13cmos5l_decap_8
XFILLER_13_1082 VPWR VGND sg13cmos5l_decap_8
X_148_ NPU_PSUM_SYSTOLIC_EN Tile_X0Y0_UserCLK _399_/X _168_/L_HI VPWR VGND sg13cmos5l_dfrbpq_1
X_217_ Tile_X1Y0_S2BEG[6] Tile_X1Y0_N2MID[1] VPWR VGND sg13cmos5l_buf_1
XFILLER_7_575 VPWR VGND sg13cmos5l_decap_8
X_079_ _079_/Q Tile_X0Y0_FrameData[27] VGND VPWR Tile_X1Y0_FrameStrobe[0] latch
XFILLER_2_280 VPWR VGND sg13cmos5l_fill_1
XFILLER_0_239 VPWR VGND sg13cmos5l_decap_8
XFILLER_5_1036 VPWR VGND sg13cmos5l_decap_8
XFILLER_13_803 VPWR VGND sg13cmos5l_decap_8
XFILLER_13_836 VPWR VGND sg13cmos5l_fill_2
XFILLER_16_129 VPWR VGND sg13cmos5l_decap_8
XFILLER_9_807 VPWR VGND sg13cmos5l_decap_8
XANTENNA_80 Tile_X0Y0_FrameData[1] VPWR VGND sg13cmos5l_antennanp
XANTENNA_91 Tile_X0Y0_FrameData[25] VPWR VGND sg13cmos5l_antennanp
XFILLER_12_357 VPWR VGND sg13cmos5l_decap_8
XFILLER_8_317 VPWR VGND sg13cmos5l_decap_8
XFILLER_0_751 VPWR VGND sg13cmos5l_decap_8
XFILLER_4_567 VPWR VGND sg13cmos5l_decap_8
XFILLER_16_641 VPWR VGND sg13cmos5l_decap_4
XFILLER_16_652 VPWR VGND sg13cmos5l_fill_2
XFILLER_15_140 VPWR VGND sg13cmos5l_decap_8
XFILLER_16_685 VPWR VGND sg13cmos5l_fill_2
XFILLER_8_840 VPWR VGND sg13cmos5l_decap_8
XFILLER_7_42 VPWR VGND sg13cmos5l_decap_8
XFILLER_4_1080 VPWR VGND sg13cmos5l_fill_2
XFILLER_5_309 VPWR VGND sg13cmos5l_decap_8
XFILLER_12_154 VPWR VGND sg13cmos5l_decap_8
XFILLER_13_666 VPWR VGND sg13cmos5l_decap_8
XFILLER_16_51 VPWR VGND sg13cmos5l_decap_8
XFILLER_16_73 VPWR VGND sg13cmos5l_decap_8
XFILLER_9_604 VPWR VGND sg13cmos5l_decap_8
XFILLER_10_1030 VPWR VGND sg13cmos5l_decap_8
XFILLER_4_353 VPWR VGND sg13cmos5l_fill_1
XFILLER_16_493 VPWR VGND sg13cmos5l_fill_1
XANTENNA__300__X Tile_X0Y0_S1BEG[0] VPWR VGND sg13cmos5l_antennanp
XFILLER_15_909 VPWR VGND sg13cmos5l_decap_4
XFILLER_2_1017 VPWR VGND sg13cmos5l_decap_8
XFILLER_10_603 VPWR VGND sg13cmos5l_decap_8
XFILLER_14_408 VPWR VGND sg13cmos5l_decap_8
XFILLER_2_824 VPWR VGND sg13cmos5l_fill_1
XFILLER_1_301 VPWR VGND sg13cmos5l_fill_1
XANTENNA__210__X Tile_X1Y0_S1BEG[3] VPWR VGND sg13cmos5l_antennanp
XFILLER_2_868 VPWR VGND sg13cmos5l_fill_1
XFILLER_2_835 VPWR VGND sg13cmos5l_decap_4
XFILLER_14_931 VPWR VGND sg13cmos5l_decap_8
XFILLER_13_463 VPWR VGND sg13cmos5l_decap_8
X_396_ _396_/X Tile_X1Y0_N1END[2] Tile_X1Y0_N2MID[2] Tile_X1Y0_N2MID[5] Tile_X1Y0_N2END[5]
+ _078_/Q _077_/Q VPWR VGND sg13cmos5l_mux4_1
XFILLER_9_467 VPWR VGND sg13cmos5l_decap_8
XFILLER_9_412 VPWR VGND sg13cmos5l_fill_1
XFILLER_5_651 VPWR VGND sg13cmos5l_decap_8
XFILLER_4_21 VPWR VGND sg13cmos5l_decap_8
XFILLER_4_161 VPWR VGND sg13cmos5l_decap_8
XFILLER_4_98 VPWR VGND sg13cmos5l_decap_8
XFILLER_14_238 VPWR VGND sg13cmos5l_decap_8
XFILLER_10_400 VPWR VGND sg13cmos5l_decap_4
XFILLER_10_477 VPWR VGND sg13cmos5l_decap_8
XFILLER_11_945 VPWR VGND sg13cmos5l_decap_8
XFILLER_11_978 VPWR VGND sg13cmos5l_decap_8
XFILLER_13_63 VPWR VGND sg13cmos5l_decap_8
X_181_ _181_/L_HI VPWR VGND sg13cmos5l_tiehi
X_250_ Tile_X1Y0_SS4BEG[7] Tile_X1Y0_NN4END[8] VPWR VGND sg13cmos5l_buf_1
XANTENNA__205__X Tile_X0Y0_S2BEG[6] VPWR VGND sg13cmos5l_antennanp
XFILLER_1_186 VPWR VGND sg13cmos5l_decap_4
XFILLER_14_794 VPWR VGND sg13cmos5l_decap_8
X_379_ _379_/X Tile_X0Y0_N4END[14] Tile_X0Y0_N4END[15] Tile_X0Y0_NN4END[12] Tile_X0Y0_NN4END[14]
+ _046_/Q _045_/Q VPWR VGND sg13cmos5l_mux4_1
XFILLER_9_242 VPWR VGND sg13cmos5l_decap_8
XFILLER_6_971 VPWR VGND sg13cmos5l_decap_8
XFILLER_15_525 VPWR VGND sg13cmos5l_decap_8
X_302_ Tile_X0Y0_S1BEG[2] Tile_X0Y0_N1END[1] VPWR VGND sg13cmos5l_buf_1
XFILLER_10_252 VPWR VGND sg13cmos5l_decap_8
XFILLER_11_720 VPWR VGND sg13cmos5l_decap_8
XFILLER_11_797 VPWR VGND sg13cmos5l_decap_8
X_095_ _095_/Q Tile_X0Y0_FrameData[11] VGND VPWR Tile_X1Y0_FrameStrobe[0] latch
X_164_ _164_/L_HI VPWR VGND sg13cmos5l_tiehi
X_233_ Tile_X1Y0_S4BEG[6] Tile_X1Y0_N4END[9] VPWR VGND sg13cmos5l_buf_1
XFILLER_7_757 VPWR VGND sg13cmos5l_decap_8
XFILLER_6_256 VPWR VGND sg13cmos5l_decap_8
XFILLER_1_77 VPWR VGND sg13cmos5l_decap_8
XANTENNA_170 Tile_X0Y0_FrameData[7] VPWR VGND sg13cmos5l_antennanp
XANTENNA_181 Tile_X0Y0_FrameData[8] VPWR VGND sg13cmos5l_antennanp
XANTENNA_192 Tile_X0Y0_N4END[12] VPWR VGND sg13cmos5l_antennanp
XFILLER_12_517 VPWR VGND sg13cmos5l_decap_8
XFILLER_0_933 VPWR VGND sg13cmos5l_decap_8
XFILLER_0_944 VPWR VGND sg13cmos5l_fill_1
XFILLER_10_42 VPWR VGND sg13cmos5l_decap_8
XFILLER_15_322 VPWR VGND sg13cmos5l_decap_8
XFILLER_15_399 VPWR VGND sg13cmos5l_decap_8
XFILLER_16_856 VPWR VGND sg13cmos5l_decap_8
XFILLER_11_594 VPWR VGND sg13cmos5l_decap_8
XFILLER_13_1061 VPWR VGND sg13cmos5l_decap_8
X_078_ _078_/Q Tile_X0Y0_FrameData[28] VGND VPWR Tile_X1Y0_FrameStrobe[0] latch
X_147_ NPU_PSUM_LUT_EN Tile_X0Y0_UserCLK _398_/X _169_/L_HI VPWR VGND sg13cmos5l_dfrbpq_1
X_216_ Tile_X1Y0_S2BEG[5] Tile_X1Y0_N2MID[2] VPWR VGND sg13cmos5l_buf_1
XFILLER_7_554 VPWR VGND sg13cmos5l_decap_8
XFILLER_3_793 VPWR VGND sg13cmos5l_decap_8
XANTENNA__303__X Tile_X0Y0_S1BEG[3] VPWR VGND sg13cmos5l_antennanp
XFILLER_0_218 VPWR VGND sg13cmos5l_decap_8
XFILLER_16_108 VPWR VGND sg13cmos5l_decap_8
XFILLER_12_336 VPWR VGND sg13cmos5l_decap_8
XFILLER_13_848 VPWR VGND sg13cmos5l_decap_4
XANTENNA_70 Tile_X0Y0_FrameData[17] VPWR VGND sg13cmos5l_antennanp
XANTENNA_81 Tile_X0Y0_FrameData[1] VPWR VGND sg13cmos5l_antennanp
XANTENNA_92 Tile_X0Y0_FrameData[25] VPWR VGND sg13cmos5l_antennanp
XANTENNA__213__X Tile_X1Y0_S2BEG[2] VPWR VGND sg13cmos5l_antennanp
XFILLER_4_546 VPWR VGND sg13cmos5l_decap_8
XFILLER_0_730 VPWR VGND sg13cmos5l_decap_8
XFILLER_16_664 VPWR VGND sg13cmos5l_decap_8
XFILLER_12_892 VPWR VGND sg13cmos5l_decap_8
XFILLER_15_196 VPWR VGND sg13cmos5l_decap_8
XFILLER_16_697 VPWR VGND sg13cmos5l_decap_4
XFILLER_7_21 VPWR VGND sg13cmos5l_decap_8
XFILLER_8_896 VPWR VGND sg13cmos5l_decap_8
XFILLER_7_98 VPWR VGND sg13cmos5l_decap_8
XFILLER_16_0 VPWR VGND sg13cmos5l_decap_8
XFILLER_10_829 VPWR VGND sg13cmos5l_decap_8
XANTENNA__208__X Tile_X1Y0_S1BEG[1] VPWR VGND sg13cmos5l_antennanp
XFILLER_12_133 VPWR VGND sg13cmos5l_decap_8
XFILLER_13_645 VPWR VGND sg13cmos5l_decap_8
XFILLER_10_1086 VPWR VGND sg13cmos5l_decap_8
XFILLER_5_822 VPWR VGND sg13cmos5l_fill_2
XFILLER_5_811 VPWR VGND sg13cmos5l_decap_8
XFILLER_16_450 VPWR VGND sg13cmos5l_decap_8
XFILLER_16_472 VPWR VGND sg13cmos5l_decap_4
XFILLER_8_693 VPWR VGND sg13cmos5l_decap_8
XFILLER_10_659 VPWR VGND sg13cmos5l_decap_8
XFILLER_6_619 VPWR VGND sg13cmos5l_decap_8
XFILLER_2_858 VPWR VGND sg13cmos5l_decap_4
XFILLER_2_814 VPWR VGND sg13cmos5l_fill_2
XFILLER_13_442 VPWR VGND sg13cmos5l_decap_8
X_395_ _395_/X Tile_X1Y0_N1END[3] Tile_X1Y0_N2MID[3] Tile_X1Y0_N2MID[4] Tile_X1Y0_N2END[4]
+ _076_/Q _113_/Q VPWR VGND sg13cmos5l_mux4_1
XFILLER_9_446 VPWR VGND sg13cmos5l_decap_8
XFILLER_5_630 VPWR VGND sg13cmos5l_decap_8
XFILLER_4_77 VPWR VGND sg13cmos5l_decap_8
XFILLER_4_140 VPWR VGND sg13cmos5l_decap_8
XFILLER_1_1095 VPWR VGND sg13cmos5l_fill_2
XFILLER_8_490 VPWR VGND sg13cmos5l_decap_8
XANTENNA__311__X Tile_X1Y0_FrameData_O[7] VPWR VGND sg13cmos5l_antennanp
XFILLER_14_217 VPWR VGND sg13cmos5l_decap_8
XFILLER_15_718 VPWR VGND sg13cmos5l_fill_1
XFILLER_10_456 VPWR VGND sg13cmos5l_decap_8
XFILLER_11_924 VPWR VGND sg13cmos5l_decap_8
XFILLER_13_42 VPWR VGND sg13cmos5l_decap_8
X_180_ _180_/L_HI VPWR VGND sg13cmos5l_tiehi
XANTENNA__221__X Tile_X1Y0_S2BEGb[2] VPWR VGND sg13cmos5l_antennanp
XFILLER_1_165 VPWR VGND sg13cmos5l_fill_2
XFILLER_13_294 VPWR VGND sg13cmos5l_decap_8
XFILLER_14_740 VPWR VGND sg13cmos5l_fill_2
XFILLER_14_773 VPWR VGND sg13cmos5l_decap_8
X_378_ _378_/X Tile_X0Y0_N4END[13] Tile_X0Y0_N4END[14] Tile_X0Y0_NN4END[13] Tile_X0Y0_NN4END[15]
+ _048_/Q _047_/Q VPWR VGND sg13cmos5l_mux4_1
XFILLER_9_221 VPWR VGND sg13cmos5l_decap_8
XFILLER_9_298 VPWR VGND sg13cmos5l_decap_8
XANTENNA__306__X Tile_X1Y0_FrameData_O[2] VPWR VGND sg13cmos5l_antennanp
XFILLER_4_909 VPWR VGND sg13cmos5l_decap_8
XFILLER_8_1046 VPWR VGND sg13cmos5l_decap_8
XFILLER_15_504 VPWR VGND sg13cmos5l_decap_8
X_232_ Tile_X1Y0_S4BEG[5] Tile_X1Y0_N4END[10] VPWR VGND sg13cmos5l_buf_1
X_301_ Tile_X0Y0_S1BEG[1] Tile_X0Y0_N1END[2] VPWR VGND sg13cmos5l_buf_1
XANTENNA__216__X Tile_X1Y0_S2BEG[5] VPWR VGND sg13cmos5l_antennanp
XFILLER_10_231 VPWR VGND sg13cmos5l_decap_8
XFILLER_11_776 VPWR VGND sg13cmos5l_decap_8
X_094_ _094_/Q Tile_X0Y0_FrameData[12] VGND VPWR Tile_X1Y0_FrameStrobe[0] latch
X_163_ _163_/L_HI VPWR VGND sg13cmos5l_tiehi
XFILLER_7_736 VPWR VGND sg13cmos5l_decap_8
XFILLER_6_235 VPWR VGND sg13cmos5l_decap_8
XFILLER_3_997 VPWR VGND sg13cmos5l_decap_8
XANTENNA_160 Tile_X0Y0_FrameData[6] VPWR VGND sg13cmos5l_antennanp
XFILLER_1_56 VPWR VGND sg13cmos5l_decap_8
XANTENNA_171 Tile_X0Y0_FrameData[7] VPWR VGND sg13cmos5l_antennanp
XANTENNA_182 Tile_X0Y0_FrameData[9] VPWR VGND sg13cmos5l_antennanp
XANTENNA_193 Tile_X0Y0_N4END[12] VPWR VGND sg13cmos5l_antennanp
XFILLER_10_21 VPWR VGND sg13cmos5l_decap_8
XFILLER_3_216 VPWR VGND sg13cmos5l_decap_8
XFILLER_0_912 VPWR VGND sg13cmos5l_decap_8
XFILLER_10_98 VPWR VGND sg13cmos5l_decap_8
XFILLER_15_301 VPWR VGND sg13cmos5l_decap_8
XFILLER_16_835 VPWR VGND sg13cmos5l_decap_8
XFILLER_11_573 VPWR VGND sg13cmos5l_decap_8
XFILLER_15_378 VPWR VGND sg13cmos5l_decap_8
X_215_ Tile_X1Y0_S2BEG[4] Tile_X1Y0_N2MID[3] VPWR VGND sg13cmos5l_buf_1
XFILLER_7_533 VPWR VGND sg13cmos5l_decap_8
XFILLER_13_1040 VPWR VGND sg13cmos5l_decap_8
X_077_ _077_/Q Tile_X0Y0_FrameData[29] VGND VPWR Tile_X1Y0_FrameStrobe[0] latch
X_146_ NPU_SWAP_WEIGHTS Tile_X0Y0_UserCLK _397_/X _170_/L_HI VPWR VGND sg13cmos5l_dfrbpq_1
XFILLER_1_709 VPWR VGND sg13cmos5l_fill_1
XFILLER_12_315 VPWR VGND sg13cmos5l_decap_8
XANTENNA_60 Tile_X0Y0_FrameData[15] VPWR VGND sg13cmos5l_antennanp
XANTENNA_71 Tile_X0Y0_FrameData[17] VPWR VGND sg13cmos5l_antennanp
XANTENNA_82 Tile_X0Y0_FrameData[1] VPWR VGND sg13cmos5l_antennanp
XANTENNA_93 Tile_X0Y0_FrameData[25] VPWR VGND sg13cmos5l_antennanp
XFILLER_4_525 VPWR VGND sg13cmos5l_decap_8
XFILLER_0_786 VPWR VGND sg13cmos5l_decap_8
XFILLER_15_175 VPWR VGND sg13cmos5l_decap_8
XFILLER_11_392 VPWR VGND sg13cmos5l_decap_4
XFILLER_12_882 VPWR VGND sg13cmos5l_decap_4
XFILLER_15_1113 VPWR VGND sg13cmos5l_fill_1
XFILLER_8_875 VPWR VGND sg13cmos5l_decap_8
XFILLER_7_77 VPWR VGND sg13cmos5l_decap_8
X_129_ NPU_QUANT_SHIFT_IN14 Tile_X0Y0_UserCLK _379_/X _155_/L_HI VPWR VGND sg13cmos5l_dfrbpq_1
XFILLER_3_591 VPWR VGND sg13cmos5l_decap_8
XFILLER_10_808 VPWR VGND sg13cmos5l_decap_8
XANTENNA__314__X Tile_X1Y0_FrameData_O[10] VPWR VGND sg13cmos5l_antennanp
XFILLER_1_517 VPWR VGND sg13cmos5l_decap_4
XFILLER_1_539 VPWR VGND sg13cmos5l_decap_8
XFILLER_13_624 VPWR VGND sg13cmos5l_decap_8
XANTENNA__224__X Tile_X1Y0_S2BEGb[5] VPWR VGND sg13cmos5l_antennanp
XFILLER_12_112 VPWR VGND sg13cmos5l_decap_8
XFILLER_12_189 VPWR VGND sg13cmos5l_decap_8
XFILLER_9_639 VPWR VGND sg13cmos5l_decap_8
XFILLER_8_149 VPWR VGND sg13cmos5l_decap_8
XFILLER_8_105 VPWR VGND sg13cmos5l_decap_8
XFILLER_10_1065 VPWR VGND sg13cmos5l_decap_8
XFILLER_0_594 VPWR VGND sg13cmos5l_decap_8
XFILLER_8_672 VPWR VGND sg13cmos5l_decap_8
XFILLER_7_182 VPWR VGND sg13cmos5l_decap_8
XANTENNA__309__X Tile_X1Y0_FrameData_O[5] VPWR VGND sg13cmos5l_antennanp
XFILLER_10_638 VPWR VGND sg13cmos5l_decap_8
XFILLER_5_119 VPWR VGND sg13cmos5l_decap_8
XANTENNA__219__X Tile_X1Y0_S2BEGb[0] VPWR VGND sg13cmos5l_antennanp
XFILLER_13_421 VPWR VGND sg13cmos5l_decap_8
XFILLER_14_955 VPWR VGND sg13cmos5l_decap_8
X_394_ _394_/X Tile_X1Y0_N4END[14] Tile_X1Y0_N4END[15] Tile_X1Y0_NN4END[12] Tile_X1Y0_NN4END[14]
+ _084_/Q _083_/Q VPWR VGND sg13cmos5l_mux4_1
XFILLER_9_425 VPWR VGND sg13cmos5l_decap_8
XFILLER_9_403 VPWR VGND sg13cmos5l_fill_1
XFILLER_13_498 VPWR VGND sg13cmos5l_decap_8
XFILLER_5_686 VPWR VGND sg13cmos5l_decap_8
XFILLER_4_56 VPWR VGND sg13cmos5l_decap_8
XFILLER_1_1074 VPWR VGND sg13cmos5l_decap_8
XFILLER_9_981 VPWR VGND sg13cmos5l_decap_8
XFILLER_9_992 VPWR VGND sg13cmos5l_fill_2
XFILLER_11_903 VPWR VGND sg13cmos5l_decap_8
XFILLER_13_21 VPWR VGND sg13cmos5l_decap_8
XFILLER_13_98 VPWR VGND sg13cmos5l_decap_8
XFILLER_2_689 VPWR VGND sg13cmos5l_decap_8
XFILLER_2_645 VPWR VGND sg13cmos5l_fill_1
XFILLER_2_634 VPWR VGND sg13cmos5l_decap_8
XFILLER_1_199 VPWR VGND sg13cmos5l_decap_8
XFILLER_13_273 VPWR VGND sg13cmos5l_decap_8
XFILLER_16_1060 VPWR VGND sg13cmos5l_decap_8
XFILLER_16_1071 VPWR VGND sg13cmos5l_decap_8
X_377_ _377_/X Tile_X0Y0_N4END[12] Tile_X0Y0_N4END[13] Tile_X0Y0_NN4END[12] Tile_X0Y0_NN4END[14]
+ _050_/Q _049_/Q VPWR VGND sg13cmos5l_mux4_1
XFILLER_9_277 VPWR VGND sg13cmos5l_decap_8
XFILLER_9_200 VPWR VGND sg13cmos5l_decap_8
XFILLER_5_483 VPWR VGND sg13cmos5l_decap_8
XANTENNA__322__X Tile_X1Y0_FrameData_O[18] VPWR VGND sg13cmos5l_antennanp
XFILLER_8_1025 VPWR VGND sg13cmos5l_decap_8
XFILLER_10_210 VPWR VGND sg13cmos5l_decap_8
XFILLER_11_755 VPWR VGND sg13cmos5l_decap_8
X_162_ _162_/L_HI VPWR VGND sg13cmos5l_tiehi
X_231_ Tile_X1Y0_S4BEG[4] Tile_X1Y0_N4END[11] VPWR VGND sg13cmos5l_buf_1
X_300_ Tile_X0Y0_S1BEG[0] Tile_X0Y0_N1END[3] VPWR VGND sg13cmos5l_buf_1
XFILLER_7_715 VPWR VGND sg13cmos5l_decap_8
XANTENNA__232__X Tile_X1Y0_S4BEG[5] VPWR VGND sg13cmos5l_antennanp
XFILLER_10_287 VPWR VGND sg13cmos5l_decap_8
X_093_ _093_/Q Tile_X0Y0_FrameData[13] VGND VPWR Tile_X1Y0_FrameStrobe[0] latch
XFILLER_6_203 VPWR VGND sg13cmos5l_decap_8
XFILLER_6_0 VPWR VGND sg13cmos5l_decap_8
XFILLER_3_976 VPWR VGND sg13cmos5l_decap_8
XFILLER_1_35 VPWR VGND sg13cmos5l_decap_8
XANTENNA_150 Tile_X0Y0_FrameData[5] VPWR VGND sg13cmos5l_antennanp
XANTENNA_161 Tile_X0Y0_FrameData[6] VPWR VGND sg13cmos5l_antennanp
XANTENNA_172 Tile_X0Y0_FrameData[7] VPWR VGND sg13cmos5l_antennanp
XANTENNA_183 Tile_X0Y0_FrameData[9] VPWR VGND sg13cmos5l_antennanp
XANTENNA_194 Tile_X0Y0_N4END[12] VPWR VGND sg13cmos5l_antennanp
XFILLER_14_1019 VPWR VGND sg13cmos5l_decap_8
XANTENNA__317__X Tile_X1Y0_FrameData_O[13] VPWR VGND sg13cmos5l_antennanp
XFILLER_0_979 VPWR VGND sg13cmos5l_fill_2
XFILLER_10_77 VPWR VGND sg13cmos5l_decap_8
XFILLER_15_357 VPWR VGND sg13cmos5l_decap_8
XFILLER_16_814 VPWR VGND sg13cmos5l_decap_8
XANTENNA__227__X Tile_X1Y0_S4BEG[0] VPWR VGND sg13cmos5l_antennanp
XFILLER_11_552 VPWR VGND sg13cmos5l_decap_8
X_145_ NPU_COMPUTE_BANK_SWAP Tile_X0Y0_UserCLK _395_/X _171_/L_HI VPWR VGND sg13cmos5l_dfrbpq_1
X_214_ Tile_X1Y0_S2BEG[3] Tile_X1Y0_N2MID[4] VPWR VGND sg13cmos5l_buf_1
XFILLER_7_512 VPWR VGND sg13cmos5l_decap_8
XFILLER_13_1096 VPWR VGND sg13cmos5l_decap_8
X_076_ _076_/Q Tile_X0Y0_FrameData[30] VGND VPWR Tile_X1Y0_FrameStrobe[0] latch
XFILLER_7_589 VPWR VGND sg13cmos5l_decap_8
XFILLER_15_880 VPWR VGND sg13cmos5l_fill_1
XFILLER_13_817 VPWR VGND sg13cmos5l_decap_8
XANTENNA_50 Tile_X0Y0_FrameData[14] VPWR VGND sg13cmos5l_antennanp
XANTENNA_61 Tile_X0Y0_FrameData[16] VPWR VGND sg13cmos5l_antennanp
XANTENNA_72 Tile_X0Y0_FrameData[17] VPWR VGND sg13cmos5l_antennanp
XANTENNA_83 Tile_X0Y0_FrameData[1] VPWR VGND sg13cmos5l_antennanp
XANTENNA_94 Tile_X0Y0_FrameData[25] VPWR VGND sg13cmos5l_antennanp
XFILLER_4_504 VPWR VGND sg13cmos5l_decap_8
XFILLER_0_765 VPWR VGND sg13cmos5l_decap_8
XFILLER_15_154 VPWR VGND sg13cmos5l_decap_8
XFILLER_11_371 VPWR VGND sg13cmos5l_fill_2
XFILLER_12_850 VPWR VGND sg13cmos5l_fill_2
XFILLER_12_861 VPWR VGND sg13cmos5l_decap_8
X_128_ NPU_QUANT_SHIFT_IN13 Tile_X0Y0_UserCLK _378_/X _162_/L_HI VPWR VGND sg13cmos5l_dfrbpq_1
XFILLER_8_854 VPWR VGND sg13cmos5l_decap_8
XFILLER_7_56 VPWR VGND sg13cmos5l_decap_8
X_059_ _059_/Q Tile_X0Y0_FrameData[11] VGND VPWR Tile_X0Y0_FrameStrobe[0] latch
XFILLER_3_570 VPWR VGND sg13cmos5l_decap_8
XANTENNA__330__X Tile_X1Y0_FrameData_O[26] VPWR VGND sg13cmos5l_antennanp
XFILLER_13_603 VPWR VGND sg13cmos5l_decap_8
XFILLER_16_21 VPWR VGND sg13cmos5l_decap_8
XFILLER_16_65 VPWR VGND sg13cmos5l_decap_4
XFILLER_16_87 VPWR VGND sg13cmos5l_decap_8
XFILLER_12_168 VPWR VGND sg13cmos5l_decap_8
XFILLER_9_618 VPWR VGND sg13cmos5l_decap_8
XFILLER_8_128 VPWR VGND sg13cmos5l_decap_8
XANTENNA__240__X Tile_X1Y0_S4BEG[13] VPWR VGND sg13cmos5l_antennanp
XFILLER_0_573 VPWR VGND sg13cmos5l_decap_8
XFILLER_10_1044 VPWR VGND sg13cmos5l_decap_8
XFILLER_16_430 VPWR VGND sg13cmos5l_fill_2
XFILLER_8_651 VPWR VGND sg13cmos5l_decap_8
XFILLER_7_161 VPWR VGND sg13cmos5l_decap_8
XFILLER_6_1112 VPWR VGND sg13cmos5l_fill_2
XANTENNA__325__X Tile_X1Y0_FrameData_O[21] VPWR VGND sg13cmos5l_antennanp
XFILLER_10_617 VPWR VGND sg13cmos5l_decap_8
XFILLER_2_816 VPWR VGND sg13cmos5l_fill_1
XANTENNA__235__X Tile_X1Y0_S4BEG[8] VPWR VGND sg13cmos5l_antennanp
XFILLER_13_477 VPWR VGND sg13cmos5l_decap_8
XFILLER_14_945 VPWR VGND sg13cmos5l_fill_2
X_393_ _393_/X Tile_X1Y0_N4END[13] Tile_X1Y0_N4END[14] Tile_X1Y0_NN4END[13] Tile_X1Y0_NN4END[15]
+ _086_/Q _085_/Q VPWR VGND sg13cmos5l_mux4_1
XFILLER_5_665 VPWR VGND sg13cmos5l_decap_8
XFILLER_4_175 VPWR VGND sg13cmos5l_decap_8
XFILLER_4_35 VPWR VGND sg13cmos5l_decap_8
XFILLER_4_186 VPWR VGND sg13cmos5l_fill_2
XFILLER_16_293 VPWR VGND sg13cmos5l_decap_8
XFILLER_1_1053 VPWR VGND sg13cmos5l_decap_8
XFILLER_15_709 VPWR VGND sg13cmos5l_decap_4
XFILLER_10_414 VPWR VGND sg13cmos5l_decap_4
XFILLER_11_959 VPWR VGND sg13cmos5l_decap_8
XFILLER_13_77 VPWR VGND sg13cmos5l_decap_8
XFILLER_6_429 VPWR VGND sg13cmos5l_fill_1
XFILLER_2_613 VPWR VGND sg13cmos5l_decap_8
XFILLER_2_668 VPWR VGND sg13cmos5l_decap_8
XFILLER_2_657 VPWR VGND sg13cmos5l_decap_8
XFILLER_1_167 VPWR VGND sg13cmos5l_fill_1
XFILLER_1_112 VPWR VGND sg13cmos5l_decap_8
XFILLER_13_252 VPWR VGND sg13cmos5l_decap_8
X_376_ _376_/X Tile_X0Y0_N4END[8] Tile_X0Y0_N4END[11] Tile_X0Y0_NN4END[9] Tile_X0Y0_NN4END[11]
+ _052_/Q _051_/Q VPWR VGND sg13cmos5l_mux4_1
XFILLER_9_256 VPWR VGND sg13cmos5l_decap_8
XFILLER_1_690 VPWR VGND sg13cmos5l_fill_1
XFILLER_8_1004 VPWR VGND sg13cmos5l_decap_8
XFILLER_15_539 VPWR VGND sg13cmos5l_decap_8
XFILLER_10_266 VPWR VGND sg13cmos5l_decap_8
XFILLER_11_734 VPWR VGND sg13cmos5l_decap_8
X_161_ _161_/L_HI VPWR VGND sg13cmos5l_tiehi
X_230_ Tile_X1Y0_S4BEG[3] Tile_X1Y0_N4END[12] VPWR VGND sg13cmos5l_buf_1
X_092_ _092_/Q Tile_X0Y0_FrameData[14] VGND VPWR Tile_X1Y0_FrameStrobe[0] latch
XFILLER_1_14 VPWR VGND sg13cmos5l_decap_8
XANTENNA_140 Tile_X0Y0_FrameData[4] VPWR VGND sg13cmos5l_antennanp
XANTENNA_151 Tile_X0Y0_FrameData[5] VPWR VGND sg13cmos5l_antennanp
XANTENNA_162 Tile_X0Y0_FrameData[6] VPWR VGND sg13cmos5l_antennanp
XANTENNA_173 Tile_X0Y0_FrameData[8] VPWR VGND sg13cmos5l_antennanp
XANTENNA_184 Tile_X0Y0_FrameData[9] VPWR VGND sg13cmos5l_antennanp
XANTENNA_195 Tile_X0Y0_N4END[3] VPWR VGND sg13cmos5l_antennanp
XFILLER_14_583 VPWR VGND sg13cmos5l_decap_8
X_359_ Tile_X1Y0_FrameStrobe_O[3] Tile_X1Y0_FrameStrobe[3] VPWR VGND sg13cmos5l_buf_1
XFILLER_6_760 VPWR VGND sg13cmos5l_decap_8
XFILLER_5_281 VPWR VGND sg13cmos5l_decap_8
XANTENNA__333__X Tile_X1Y0_FrameData_O[29] VPWR VGND sg13cmos5l_antennanp
XFILLER_10_56 VPWR VGND sg13cmos5l_decap_8
XFILLER_15_336 VPWR VGND sg13cmos5l_decap_8
XANTENNA__243__X Tile_X1Y0_SS4BEG[0] VPWR VGND sg13cmos5l_antennanp
XFILLER_11_531 VPWR VGND sg13cmos5l_decap_8
XFILLER_13_1075 VPWR VGND sg13cmos5l_decap_8
X_075_ _075_/Q Tile_X0Y0_FrameData[31] VGND VPWR Tile_X0Y0_FrameStrobe[0] latch
X_144_ NPU_QUANT_SHIFT_IN29 Tile_X0Y0_UserCLK _394_/X _172_/L_HI VPWR VGND sg13cmos5l_dfrbpq_1
X_213_ Tile_X1Y0_S2BEG[2] Tile_X1Y0_N2MID[5] VPWR VGND sg13cmos5l_buf_1
XFILLER_7_568 VPWR VGND sg13cmos5l_decap_8
XFILLER_2_295 VPWR VGND sg13cmos5l_decap_8
XFILLER_2_273 VPWR VGND sg13cmos5l_decap_8
XFILLER_5_1029 VPWR VGND sg13cmos5l_decap_8
XANTENNA__328__X Tile_X1Y0_FrameData_O[24] VPWR VGND sg13cmos5l_antennanp
XANTENNA_40 Tile_X0Y0_FrameData[13] VPWR VGND sg13cmos5l_antennanp
XANTENNA_51 Tile_X0Y0_FrameData[14] VPWR VGND sg13cmos5l_antennanp
XANTENNA_62 Tile_X0Y0_FrameData[16] VPWR VGND sg13cmos5l_antennanp
XANTENNA_73 Tile_X0Y0_FrameData[17] VPWR VGND sg13cmos5l_antennanp
XANTENNA_84 Tile_X0Y0_FrameData[1] VPWR VGND sg13cmos5l_antennanp
XANTENNA_95 Tile_X0Y0_FrameData[25] VPWR VGND sg13cmos5l_antennanp
XFILLER_0_744 VPWR VGND sg13cmos5l_decap_8
XFILLER_16_601 VPWR VGND sg13cmos5l_decap_4
XFILLER_16_623 VPWR VGND sg13cmos5l_fill_1
XFILLER_16_634 VPWR VGND sg13cmos5l_decap_4
XANTENNA__238__X Tile_X1Y0_S4BEG[11] VPWR VGND sg13cmos5l_antennanp
XFILLER_11_350 VPWR VGND sg13cmos5l_decap_8
XFILLER_15_133 VPWR VGND sg13cmos5l_decap_8
X_058_ _058_/Q Tile_X0Y0_FrameData[12] VGND VPWR Tile_X0Y0_FrameStrobe[0] latch
X_127_ NPU_QUANT_SHIFT_IN12 Tile_X0Y0_UserCLK _377_/X _178_/L_HI VPWR VGND sg13cmos5l_dfrbpq_1
XFILLER_8_833 VPWR VGND sg13cmos5l_decap_8
XFILLER_7_398 VPWR VGND sg13cmos5l_fill_2
XFILLER_7_35 VPWR VGND sg13cmos5l_decap_8
XFILLER_4_1073 VPWR VGND sg13cmos5l_decap_8
XFILLER_12_147 VPWR VGND sg13cmos5l_decap_8
XFILLER_13_659 VPWR VGND sg13cmos5l_decap_8
XFILLER_16_44 VPWR VGND sg13cmos5l_decap_8
XFILLER_10_1023 VPWR VGND sg13cmos5l_decap_8
XFILLER_0_552 VPWR VGND sg13cmos5l_decap_8
XFILLER_16_442 VPWR VGND sg13cmos5l_decap_4
XFILLER_12_692 VPWR VGND sg13cmos5l_decap_8
XFILLER_16_497 VPWR VGND sg13cmos5l_decap_8
XFILLER_8_630 VPWR VGND sg13cmos5l_decap_8
XFILLER_7_140 VPWR VGND sg13cmos5l_decap_8
XFILLER_14_0 VPWR VGND sg13cmos5l_decap_8
XANTENNA__341__X Tile_X0Y0_FrameStrobe_O[5] VPWR VGND sg13cmos5l_antennanp
XFILLER_2_839 VPWR VGND sg13cmos5l_fill_1
XFILLER_2_828 VPWR VGND sg13cmos5l_decap_8
XFILLER_14_924 VPWR VGND sg13cmos5l_decap_8
XFILLER_13_456 VPWR VGND sg13cmos5l_decap_8
X_392_ _392_/X Tile_X1Y0_N4END[12] Tile_X1Y0_N4END[13] Tile_X1Y0_NN4END[12] Tile_X1Y0_NN4END[14]
+ _088_/Q _087_/Q VPWR VGND sg13cmos5l_mux4_1
XANTENNA__251__X Tile_X1Y0_SS4BEG[8] VPWR VGND sg13cmos5l_antennanp
XFILLER_5_644 VPWR VGND sg13cmos5l_decap_8
XFILLER_4_198 VPWR VGND sg13cmos5l_decap_8
XFILLER_4_154 VPWR VGND sg13cmos5l_decap_8
XFILLER_4_14 VPWR VGND sg13cmos5l_decap_8
XFILLER_1_861 VPWR VGND sg13cmos5l_fill_1
XFILLER_16_261 VPWR VGND sg13cmos5l_decap_4
XFILLER_1_1032 VPWR VGND sg13cmos5l_decap_8
XFILLER_9_961 VPWR VGND sg13cmos5l_fill_1
XANTENNA__336__X Tile_X0Y0_FrameStrobe_O[0] VPWR VGND sg13cmos5l_antennanp
XFILLER_11_938 VPWR VGND sg13cmos5l_decap_8
XFILLER_13_56 VPWR VGND sg13cmos5l_decap_8
XFILLER_1_179 VPWR VGND sg13cmos5l_decap_8
XANTENNA_300 Tile_X0Y0_NN4END[1] VPWR VGND sg13cmos5l_antennanp
XANTENNA__246__X Tile_X1Y0_SS4BEG[3] VPWR VGND sg13cmos5l_antennanp
XFILLER_13_231 VPWR VGND sg13cmos5l_decap_8
XFILLER_14_787 VPWR VGND sg13cmos5l_decap_8
X_375_ _375_/X Tile_X0Y0_N4END[10] Tile_X0Y0_N4END[11] Tile_X0Y0_NN4END[8] Tile_X0Y0_NN4END[10]
+ _054_/Q _053_/Q VPWR VGND sg13cmos5l_mux4_1
XFILLER_9_235 VPWR VGND sg13cmos5l_decap_8
XFILLER_0_190 VPWR VGND sg13cmos5l_decap_8
XFILLER_15_518 VPWR VGND sg13cmos5l_decap_8
XFILLER_10_245 VPWR VGND sg13cmos5l_decap_8
XFILLER_11_713 VPWR VGND sg13cmos5l_decap_8
X_091_ _091_/Q Tile_X0Y0_FrameData[15] VGND VPWR Tile_X1Y0_FrameStrobe[0] latch
X_160_ _160_/L_HI VPWR VGND sg13cmos5l_tiehi
XFILLER_6_249 VPWR VGND sg13cmos5l_decap_8
XANTENNA_130 Tile_X0Y0_FrameData[3] VPWR VGND sg13cmos5l_antennanp
XANTENNA_141 Tile_X0Y0_FrameData[4] VPWR VGND sg13cmos5l_antennanp
XANTENNA_152 Tile_X0Y0_FrameData[5] VPWR VGND sg13cmos5l_antennanp
XANTENNA_163 Tile_X0Y0_FrameData[6] VPWR VGND sg13cmos5l_antennanp
XANTENNA_174 Tile_X0Y0_FrameData[8] VPWR VGND sg13cmos5l_antennanp
XANTENNA_185 Tile_X0Y0_FrameData[9] VPWR VGND sg13cmos5l_antennanp
XANTENNA_196 Tile_X0Y0_N4END[3] VPWR VGND sg13cmos5l_antennanp
XFILLER_14_562 VPWR VGND sg13cmos5l_decap_8
X_358_ Tile_X1Y0_FrameStrobe_O[2] Tile_X1Y0_FrameStrobe[2] VPWR VGND sg13cmos5l_buf_1
X_289_ Tile_X0Y0_SS4BEG[5] Tile_X0Y0_NN4END[10] VPWR VGND sg13cmos5l_buf_1
XFILLER_7_1082 VPWR VGND sg13cmos5l_decap_8
XFILLER_0_926 VPWR VGND sg13cmos5l_decap_8
XFILLER_0_948 VPWR VGND sg13cmos5l_fill_2
XFILLER_10_35 VPWR VGND sg13cmos5l_decap_8
XFILLER_11_510 VPWR VGND sg13cmos5l_decap_8
XFILLER_15_315 VPWR VGND sg13cmos5l_decap_8
X_212_ Tile_X1Y0_S2BEG[1] Tile_X1Y0_N2MID[6] VPWR VGND sg13cmos5l_buf_1
XFILLER_16_849 VPWR VGND sg13cmos5l_decap_8
XFILLER_11_587 VPWR VGND sg13cmos5l_decap_8
XFILLER_13_1054 VPWR VGND sg13cmos5l_decap_8
X_074_ _074_/Q Tile_X0Y0_FrameData[28] VGND VPWR Tile_X0Y0_FrameStrobe[1] latch
X_143_ NPU_QUANT_SHIFT_IN28 Tile_X0Y0_UserCLK _393_/X _173_/L_HI VPWR VGND sg13cmos5l_dfrbpq_1
XFILLER_7_547 VPWR VGND sg13cmos5l_decap_8
XFILLER_3_786 VPWR VGND sg13cmos5l_decap_8
XFILLER_6_591 VPWR VGND sg13cmos5l_fill_2
XFILLER_2_91 VPWR VGND sg13cmos5l_decap_8
XFILLER_12_329 VPWR VGND sg13cmos5l_decap_8
XANTENNA_30 Tile_X0Y0_FrameData[12] VPWR VGND sg13cmos5l_antennanp
XANTENNA_41 Tile_X0Y0_FrameData[13] VPWR VGND sg13cmos5l_antennanp
XANTENNA_52 Tile_X0Y0_FrameData[15] VPWR VGND sg13cmos5l_antennanp
XANTENNA_63 Tile_X0Y0_FrameData[16] VPWR VGND sg13cmos5l_antennanp
XANTENNA_74 Tile_X0Y0_FrameData[17] VPWR VGND sg13cmos5l_antennanp
XANTENNA_85 Tile_X0Y0_FrameData[1] VPWR VGND sg13cmos5l_antennanp
XANTENNA_96 Tile_X0Y0_FrameData[25] VPWR VGND sg13cmos5l_antennanp
XANTENNA__344__X Tile_X0Y0_FrameStrobe_O[8] VPWR VGND sg13cmos5l_antennanp
XFILLER_4_539 VPWR VGND sg13cmos5l_decap_8
XFILLER_0_723 VPWR VGND sg13cmos5l_decap_8
XFILLER_15_112 VPWR VGND sg13cmos5l_decap_8
XFILLER_16_657 VPWR VGND sg13cmos5l_decap_4
XANTENNA__254__X Tile_X1Y0_SS4BEG[11] VPWR VGND sg13cmos5l_antennanp
XFILLER_11_373 VPWR VGND sg13cmos5l_fill_1
XFILLER_12_830 VPWR VGND sg13cmos5l_fill_1
XFILLER_15_189 VPWR VGND sg13cmos5l_decap_8
XFILLER_8_812 VPWR VGND sg13cmos5l_decap_8
XFILLER_7_322 VPWR VGND sg13cmos5l_decap_4
XFILLER_7_14 VPWR VGND sg13cmos5l_decap_8
X_057_ _057_/Q Tile_X0Y0_FrameData[13] VGND VPWR Tile_X0Y0_FrameStrobe[0] latch
X_126_ NPU_QUANT_SHIFT_IN11 Tile_X0Y0_UserCLK _376_/X _151_/L_HI VPWR VGND sg13cmos5l_dfrbpq_1
XFILLER_8_889 VPWR VGND sg13cmos5l_decap_8
XFILLER_7_366 VPWR VGND sg13cmos5l_decap_4
XFILLER_4_1052 VPWR VGND sg13cmos5l_decap_8
XANTENNA__339__X Tile_X0Y0_FrameStrobe_O[3] VPWR VGND sg13cmos5l_antennanp
XFILLER_12_126 VPWR VGND sg13cmos5l_decap_8
XFILLER_13_638 VPWR VGND sg13cmos5l_decap_8
XFILLER_8_119 VPWR VGND sg13cmos5l_decap_4
XFILLER_10_1002 VPWR VGND sg13cmos5l_decap_8
XFILLER_10_1079 VPWR VGND sg13cmos5l_decap_8
XFILLER_5_859 VPWR VGND sg13cmos5l_fill_2
XFILLER_5_804 VPWR VGND sg13cmos5l_decap_8
XFILLER_4_358 VPWR VGND sg13cmos5l_fill_1
XANTENNA__249__X Tile_X1Y0_SS4BEG[6] VPWR VGND sg13cmos5l_antennanp
XFILLER_16_465 VPWR VGND sg13cmos5l_decap_8
XFILLER_16_476 VPWR VGND sg13cmos5l_fill_1
XFILLER_16_487 VPWR VGND sg13cmos5l_fill_2
XFILLER_12_671 VPWR VGND sg13cmos5l_decap_8
XFILLER_8_686 VPWR VGND sg13cmos5l_decap_8
X_109_ _109_/Q Tile_X0Y0_FrameData[29] VGND VPWR Tile_X1Y0_FrameStrobe[1] latch
XFILLER_7_196 VPWR VGND sg13cmos5l_decap_8
XFILLER_2_807 VPWR VGND sg13cmos5l_decap_8
XFILLER_14_947 VPWR VGND sg13cmos5l_fill_1
X_391_ _391_/X Tile_X1Y0_N4END[8] Tile_X1Y0_N4END[11] Tile_X1Y0_NN4END[9] Tile_X1Y0_NN4END[11]
+ _090_/Q _089_/Q VPWR VGND sg13cmos5l_mux4_1
XFILLER_13_435 VPWR VGND sg13cmos5l_decap_8
XFILLER_14_969 VPWR VGND sg13cmos5l_fill_2
XFILLER_9_439 VPWR VGND sg13cmos5l_decap_8
XFILLER_5_623 VPWR VGND sg13cmos5l_decap_8
XFILLER_4_133 VPWR VGND sg13cmos5l_decap_8
XFILLER_1_895 VPWR VGND sg13cmos5l_fill_1
XFILLER_1_884 VPWR VGND sg13cmos5l_fill_1
XFILLER_1_1011 VPWR VGND sg13cmos5l_decap_8
XFILLER_1_1088 VPWR VGND sg13cmos5l_decap_8
XFILLER_13_991 VPWR VGND sg13cmos5l_decap_8
XFILLER_9_940 VPWR VGND sg13cmos5l_decap_8
XFILLER_8_483 VPWR VGND sg13cmos5l_decap_8
XFILLER_10_449 VPWR VGND sg13cmos5l_decap_8
XFILLER_11_917 VPWR VGND sg13cmos5l_decap_8
XFILLER_13_35 VPWR VGND sg13cmos5l_decap_8
XANTENNA__352__X Tile_X0Y0_FrameStrobe_O[16] VPWR VGND sg13cmos5l_antennanp
XFILLER_1_158 VPWR VGND sg13cmos5l_decap_8
XANTENNA_301 Tile_X0Y0_NN4END[1] VPWR VGND sg13cmos5l_antennanp
XFILLER_13_210 VPWR VGND sg13cmos5l_decap_8
XFILLER_14_722 VPWR VGND sg13cmos5l_decap_4
X_374_ _374_/X Tile_X0Y0_N4END[9] Tile_X0Y0_N4END[10] Tile_X0Y0_NN4END[9] Tile_X0Y0_NN4END[11]
+ _056_/Q _055_/Q VPWR VGND sg13cmos5l_mux4_1
XFILLER_9_214 VPWR VGND sg13cmos5l_decap_8
XANTENNA__262__X Tile_X0Y0_S2BEGb[2] VPWR VGND sg13cmos5l_antennanp
XFILLER_13_287 VPWR VGND sg13cmos5l_decap_8
XFILLER_16_1085 VPWR VGND sg13cmos5l_decap_8
XFILLER_5_497 VPWR VGND sg13cmos5l_decap_8
XFILLER_5_91 VPWR VGND sg13cmos5l_decap_8
XANTENNA__121__Q NPU_QUANT_SHIFT_IN6 VPWR VGND sg13cmos5l_antennanp
XFILLER_8_1039 VPWR VGND sg13cmos5l_decap_8
XANTENNA__347__X Tile_X0Y0_FrameStrobe_O[11] VPWR VGND sg13cmos5l_antennanp
XFILLER_10_224 VPWR VGND sg13cmos5l_decap_8
XFILLER_11_769 VPWR VGND sg13cmos5l_decap_8
X_090_ _090_/Q Tile_X0Y0_FrameData[16] VGND VPWR Tile_X1Y0_FrameStrobe[0] latch
XFILLER_7_729 VPWR VGND sg13cmos5l_decap_8
XFILLER_6_228 VPWR VGND sg13cmos5l_decap_8
XFILLER_3_957 VPWR VGND sg13cmos5l_fill_1
XANTENNA_120 Tile_X0Y0_FrameData[2] VPWR VGND sg13cmos5l_antennanp
XANTENNA_131 Tile_X0Y0_FrameData[3] VPWR VGND sg13cmos5l_antennanp
XANTENNA_142 Tile_X0Y0_FrameData[4] VPWR VGND sg13cmos5l_antennanp
XANTENNA__257__X Tile_X1Y0_SS4BEG[14] VPWR VGND sg13cmos5l_antennanp
XFILLER_1_49 VPWR VGND sg13cmos5l_decap_8
XANTENNA_153 Tile_X0Y0_FrameData[5] VPWR VGND sg13cmos5l_antennanp
XANTENNA_164 Tile_X0Y0_FrameData[7] VPWR VGND sg13cmos5l_antennanp
XANTENNA_175 Tile_X0Y0_FrameData[8] VPWR VGND sg13cmos5l_antennanp
XANTENNA_186 Tile_X0Y0_FrameData[9] VPWR VGND sg13cmos5l_antennanp
XANTENNA_197 Tile_X0Y0_N4END[3] VPWR VGND sg13cmos5l_antennanp
XFILLER_14_541 VPWR VGND sg13cmos5l_decap_8
X_357_ Tile_X1Y0_FrameStrobe_O[1] Tile_X1Y0_FrameStrobe[1] VPWR VGND sg13cmos5l_buf_1
XFILLER_10_780 VPWR VGND sg13cmos5l_decap_8
X_288_ Tile_X0Y0_SS4BEG[4] Tile_X0Y0_NN4END[11] VPWR VGND sg13cmos5l_buf_1
XANTENNA__116__Q NPU_QUANT_SHIFT_IN1 VPWR VGND sg13cmos5l_antennanp
XFILLER_0_905 VPWR VGND sg13cmos5l_decap_8
XFILLER_10_14 VPWR VGND sg13cmos5l_decap_8
XFILLER_16_828 VPWR VGND sg13cmos5l_decap_8
XFILLER_11_566 VPWR VGND sg13cmos5l_decap_8
X_142_ NPU_QUANT_SHIFT_IN27 Tile_X0Y0_UserCLK _392_/X _174_/L_HI VPWR VGND sg13cmos5l_dfrbpq_1
X_211_ Tile_X1Y0_S2BEG[0] Tile_X1Y0_N2MID[7] VPWR VGND sg13cmos5l_buf_1
XFILLER_13_1033 VPWR VGND sg13cmos5l_decap_8
X_073_ _073_/Q Tile_X0Y0_FrameData[29] VGND VPWR Tile_X0Y0_FrameStrobe[1] latch
XFILLER_7_526 VPWR VGND sg13cmos5l_decap_8
XFILLER_4_0 VPWR VGND sg13cmos5l_decap_8
XFILLER_3_721 VPWR VGND sg13cmos5l_decap_8
XFILLER_6_570 VPWR VGND sg13cmos5l_decap_8
XFILLER_2_70 VPWR VGND sg13cmos5l_decap_8
XANTENNA_20 Tile_X0Y0_FrameData[11] VPWR VGND sg13cmos5l_antennanp
XANTENNA_31 Tile_X0Y0_FrameData[12] VPWR VGND sg13cmos5l_antennanp
XFILLER_12_308 VPWR VGND sg13cmos5l_decap_8
XANTENNA_42 Tile_X0Y0_FrameData[13] VPWR VGND sg13cmos5l_antennanp
XANTENNA_53 Tile_X0Y0_FrameData[15] VPWR VGND sg13cmos5l_antennanp
XANTENNA_64 Tile_X0Y0_FrameData[16] VPWR VGND sg13cmos5l_antennanp
XANTENNA_75 Tile_X0Y0_FrameData[17] VPWR VGND sg13cmos5l_antennanp
XANTENNA_86 Tile_X0Y0_FrameData[1] VPWR VGND sg13cmos5l_antennanp
XANTENNA_97 Tile_X0Y0_FrameData[25] VPWR VGND sg13cmos5l_antennanp
XANTENNA__360__X Tile_X1Y0_FrameStrobe_O[4] VPWR VGND sg13cmos5l_antennanp
XFILLER_4_518 VPWR VGND sg13cmos5l_decap_8
XFILLER_0_702 VPWR VGND sg13cmos5l_decap_8
XFILLER_0_779 VPWR VGND sg13cmos5l_decap_8
XFILLER_15_168 VPWR VGND sg13cmos5l_decap_8
XFILLER_11_385 VPWR VGND sg13cmos5l_decap_8
XFILLER_11_396 VPWR VGND sg13cmos5l_fill_2
XFILLER_12_875 VPWR VGND sg13cmos5l_decap_8
XFILLER_12_886 VPWR VGND sg13cmos5l_fill_2
XFILLER_15_1106 VPWR VGND sg13cmos5l_decap_8
X_125_ NPU_QUANT_SHIFT_IN10 Tile_X0Y0_UserCLK _375_/X _159_/L_HI VPWR VGND sg13cmos5l_dfrbpq_1
XFILLER_8_868 VPWR VGND sg13cmos5l_decap_8
XFILLER_7_301 VPWR VGND sg13cmos5l_decap_8
XANTENNA__270__X Tile_X0Y0_S4BEG[2] VPWR VGND sg13cmos5l_antennanp
X_056_ _056_/Q Tile_X0Y0_FrameData[14] VGND VPWR Tile_X0Y0_FrameStrobe[0] latch
XFILLER_3_584 VPWR VGND sg13cmos5l_decap_8
XFILLER_4_1031 VPWR VGND sg13cmos5l_decap_8
XFILLER_13_617 VPWR VGND sg13cmos5l_decap_8
XFILLER_16_35 VPWR VGND sg13cmos5l_decap_4
XANTENNA__355__X Tile_X0Y0_FrameStrobe_O[19] VPWR VGND sg13cmos5l_antennanp
XFILLER_12_105 VPWR VGND sg13cmos5l_decap_8
XFILLER_10_1058 VPWR VGND sg13cmos5l_decap_8
XFILLER_0_543 VPWR VGND sg13cmos5l_decap_4
XFILLER_0_587 VPWR VGND sg13cmos5l_decap_8
XANTENNA__265__X Tile_X0Y0_S2BEGb[5] VPWR VGND sg13cmos5l_antennanp
XFILLER_11_182 VPWR VGND sg13cmos5l_decap_8
XFILLER_12_650 VPWR VGND sg13cmos5l_decap_8
X_108_ _108_/Q Tile_X0Y0_FrameData[30] VGND VPWR Tile_X1Y0_FrameStrobe[1] latch
XFILLER_8_665 VPWR VGND sg13cmos5l_decap_8
XFILLER_7_175 VPWR VGND sg13cmos5l_decap_8
X_039_ NPU_PSUM_SKEW_EN Tile_X0Y0_UserCLK _039_/D _161_/L_HI VPWR VGND sg13cmos5l_dfrbpq_1
XANTENNA__124__Q NPU_QUANT_SHIFT_IN9 VPWR VGND sg13cmos5l_antennanp
XFILLER_8_91 VPWR VGND sg13cmos5l_decap_8
XFILLER_13_403 VPWR VGND sg13cmos5l_fill_1
XFILLER_13_414 VPWR VGND sg13cmos5l_decap_8
X_390_ _390_/X Tile_X1Y0_N4END[10] Tile_X1Y0_N4END[11] Tile_X1Y0_NN4END[8] Tile_X1Y0_NN4END[10]
+ _092_/Q _091_/Q VPWR VGND sg13cmos5l_mux4_1
XFILLER_12_1109 VPWR VGND sg13cmos5l_decap_4
XFILLER_5_602 VPWR VGND sg13cmos5l_decap_8
XFILLER_4_112 VPWR VGND sg13cmos5l_decap_8
XFILLER_5_679 VPWR VGND sg13cmos5l_decap_8
XFILLER_4_49 VPWR VGND sg13cmos5l_decap_8
XFILLER_16_241 VPWR VGND sg13cmos5l_fill_2
XFILLER_1_1067 VPWR VGND sg13cmos5l_decap_8
XFILLER_8_462 VPWR VGND sg13cmos5l_decap_8
XANTENNA__119__Q NPU_QUANT_SHIFT_IN4 VPWR VGND sg13cmos5l_antennanp
XFILLER_13_14 VPWR VGND sg13cmos5l_decap_8
XFILLER_8_7 VPWR VGND sg13cmos5l_decap_8
XFILLER_2_627 VPWR VGND sg13cmos5l_decap_8
XFILLER_1_126 VPWR VGND sg13cmos5l_fill_1
XANTENNA_302 Tile_X0Y0_NN4END[1] VPWR VGND sg13cmos5l_antennanp
XFILLER_13_266 VPWR VGND sg13cmos5l_decap_8
XFILLER_16_1053 VPWR VGND sg13cmos5l_decap_8
X_373_ _373_/X Tile_X0Y0_N4END[8] Tile_X0Y0_N4END[9] Tile_X0Y0_NN4END[8] Tile_X0Y0_NN4END[10]
+ _058_/Q _057_/Q VPWR VGND sg13cmos5l_mux4_1
XFILLER_6_922 VPWR VGND sg13cmos5l_decap_4
XFILLER_5_454 VPWR VGND sg13cmos5l_fill_2
XFILLER_9_793 VPWR VGND sg13cmos5l_decap_8
XFILLER_8_1018 VPWR VGND sg13cmos5l_decap_8
XFILLER_5_70 VPWR VGND sg13cmos5l_decap_8
XFILLER_10_203 VPWR VGND sg13cmos5l_decap_8
XFILLER_11_748 VPWR VGND sg13cmos5l_decap_8
XANTENNA__363__X Tile_X1Y0_FrameStrobe_O[7] VPWR VGND sg13cmos5l_antennanp
XFILLER_7_708 VPWR VGND sg13cmos5l_decap_8
XFILLER_3_969 VPWR VGND sg13cmos5l_decap_8
XFILLER_1_28 VPWR VGND sg13cmos5l_decap_8
XANTENNA_110 Tile_X0Y0_FrameData[29] VPWR VGND sg13cmos5l_antennanp
XANTENNA_121 Tile_X0Y0_FrameData[2] VPWR VGND sg13cmos5l_antennanp
XANTENNA_132 Tile_X0Y0_FrameData[3] VPWR VGND sg13cmos5l_antennanp
XANTENNA_143 Tile_X0Y0_FrameData[4] VPWR VGND sg13cmos5l_antennanp
XANTENNA_154 Tile_X0Y0_FrameData[5] VPWR VGND sg13cmos5l_antennanp
XANTENNA_165 Tile_X0Y0_FrameData[7] VPWR VGND sg13cmos5l_antennanp
XANTENNA_176 Tile_X0Y0_FrameData[8] VPWR VGND sg13cmos5l_antennanp
XFILLER_14_520 VPWR VGND sg13cmos5l_decap_8
XANTENNA_187 Tile_X0Y0_FrameData[9] VPWR VGND sg13cmos5l_antennanp
XANTENNA_198 Tile_X0Y0_N4END[3] VPWR VGND sg13cmos5l_antennanp
XANTENNA__273__X Tile_X0Y0_S4BEG[5] VPWR VGND sg13cmos5l_antennanp
XFILLER_14_597 VPWR VGND sg13cmos5l_decap_8
X_287_ Tile_X0Y0_SS4BEG[3] Tile_X0Y0_NN4END[12] VPWR VGND sg13cmos5l_buf_1
X_356_ Tile_X1Y0_FrameStrobe_O[0] Tile_X1Y0_FrameStrobe[0] VPWR VGND sg13cmos5l_buf_1
XFILLER_6_774 VPWR VGND sg13cmos5l_decap_8
XFILLER_5_295 VPWR VGND sg13cmos5l_decap_8
XFILLER_9_590 VPWR VGND sg13cmos5l_decap_8
XANTENNA__132__Q NPU_QUANT_SHIFT_IN17 VPWR VGND sg13cmos5l_antennanp
XANTENNA__358__X Tile_X1Y0_FrameStrobe_O[2] VPWR VGND sg13cmos5l_antennanp
XFILLER_16_807 VPWR VGND sg13cmos5l_decap_8
XFILLER_11_545 VPWR VGND sg13cmos5l_decap_8
XFILLER_13_1012 VPWR VGND sg13cmos5l_decap_8
X_141_ NPU_QUANT_SHIFT_IN26 Tile_X0Y0_UserCLK _391_/X _175_/L_HI VPWR VGND sg13cmos5l_dfrbpq_1
X_210_ Tile_X1Y0_S1BEG[3] Tile_X1Y0_N1END[0] VPWR VGND sg13cmos5l_buf_1
XFILLER_7_505 VPWR VGND sg13cmos5l_decap_8
XFILLER_13_1089 VPWR VGND sg13cmos5l_decap_8
X_072_ _072_/Q Tile_X0Y0_FrameData[30] VGND VPWR Tile_X0Y0_FrameStrobe[1] latch
XFILLER_3_700 VPWR VGND sg13cmos5l_decap_8
XANTENNA__268__X Tile_X0Y0_S4BEG[0] VPWR VGND sg13cmos5l_antennanp
XFILLER_14_372 VPWR VGND sg13cmos5l_decap_8
XFILLER_14_383 VPWR VGND sg13cmos5l_fill_1
XFILLER_15_884 VPWR VGND sg13cmos5l_fill_1
XFILLER_15_895 VPWR VGND sg13cmos5l_decap_8
XFILLER_14_394 VPWR VGND sg13cmos5l_decap_8
X_339_ Tile_X0Y0_FrameStrobe_O[3] Tile_X0Y0_FrameStrobe[3] VPWR VGND sg13cmos5l_buf_1
XFILLER_6_593 VPWR VGND sg13cmos5l_fill_1
XANTENNA_10 Tile_X0Y0_FrameData[10] VPWR VGND sg13cmos5l_antennanp
XANTENNA_21 Tile_X0Y0_FrameData[11] VPWR VGND sg13cmos5l_antennanp
XANTENNA_32 Tile_X0Y0_FrameData[12] VPWR VGND sg13cmos5l_antennanp
XANTENNA_43 Tile_X0Y0_FrameData[14] VPWR VGND sg13cmos5l_antennanp
XANTENNA_54 Tile_X0Y0_FrameData[15] VPWR VGND sg13cmos5l_antennanp
XANTENNA_65 Tile_X0Y0_FrameData[16] VPWR VGND sg13cmos5l_antennanp
XANTENNA__127__Q NPU_QUANT_SHIFT_IN12 VPWR VGND sg13cmos5l_antennanp
XANTENNA_76 Tile_X0Y0_FrameData[17] VPWR VGND sg13cmos5l_antennanp
XANTENNA_87 Tile_X0Y0_FrameData[1] VPWR VGND sg13cmos5l_antennanp
XANTENNA_98 Tile_X0Y0_FrameData[25] VPWR VGND sg13cmos5l_antennanp
XFILLER_0_758 VPWR VGND sg13cmos5l_decap_8
XFILLER_15_147 VPWR VGND sg13cmos5l_decap_8
XFILLER_16_648 VPWR VGND sg13cmos5l_decap_4
XFILLER_11_364 VPWR VGND sg13cmos5l_decap_8
X_055_ _055_/Q Tile_X0Y0_FrameData[15] VGND VPWR Tile_X0Y0_FrameStrobe[0] latch
X_124_ NPU_QUANT_SHIFT_IN9 Tile_X0Y0_UserCLK _374_/X _187_/L_HI VPWR VGND sg13cmos5l_dfrbpq_1
XFILLER_7_49 VPWR VGND sg13cmos5l_decap_8
XFILLER_11_91 VPWR VGND sg13cmos5l_decap_8
XFILLER_3_563 VPWR VGND sg13cmos5l_decap_8
XFILLER_4_1010 VPWR VGND sg13cmos5l_decap_8
XFILLER_16_14 VPWR VGND sg13cmos5l_decap_8
XFILLER_16_58 VPWR VGND sg13cmos5l_decap_8
XFILLER_16_69 VPWR VGND sg13cmos5l_fill_1
XFILLER_10_1037 VPWR VGND sg13cmos5l_decap_8
XFILLER_0_566 VPWR VGND sg13cmos5l_decap_8
XFILLER_16_423 VPWR VGND sg13cmos5l_decap_8
XFILLER_16_489 VPWR VGND sg13cmos5l_fill_1
XANTENNA__281__X Tile_X0Y0_S4BEG[13] VPWR VGND sg13cmos5l_antennanp
XFILLER_11_161 VPWR VGND sg13cmos5l_decap_8
X_038_ _039_/D _396_/X _114_/Q VPWR VGND sg13cmos5l_or2_1
X_107_ _107_/Q Tile_X0Y0_FrameData[31] VGND VPWR Tile_X1Y0_FrameStrobe[1] latch
XFILLER_8_644 VPWR VGND sg13cmos5l_decap_8
XFILLER_7_154 VPWR VGND sg13cmos5l_decap_8
XANTENNA__191__X Tile_X1Y0_FrameStrobe_O[12] VPWR VGND sg13cmos5l_antennanp
XFILLER_8_70 VPWR VGND sg13cmos5l_decap_8
XANTENNA__140__Q NPU_QUANT_SHIFT_IN25 VPWR VGND sg13cmos5l_antennanp
XFILLER_14_916 VPWR VGND sg13cmos5l_fill_1
XFILLER_14_938 VPWR VGND sg13cmos5l_decap_4
XFILLER_5_658 VPWR VGND sg13cmos5l_decap_8
XFILLER_4_28 VPWR VGND sg13cmos5l_decap_8
XFILLER_4_168 VPWR VGND sg13cmos5l_decap_8
XFILLER_1_875 VPWR VGND sg13cmos5l_decap_4
XFILLER_1_831 VPWR VGND sg13cmos5l_decap_8
XANTENNA__276__X Tile_X0Y0_S4BEG[8] VPWR VGND sg13cmos5l_antennanp
XFILLER_16_220 VPWR VGND sg13cmos5l_decap_8
XFILLER_1_1046 VPWR VGND sg13cmos5l_decap_8
XFILLER_1_1002 VPWR VGND sg13cmos5l_fill_2
XFILLER_16_286 VPWR VGND sg13cmos5l_decap_8
XFILLER_9_997 VPWR VGND sg13cmos5l_fill_2
XFILLER_8_441 VPWR VGND sg13cmos5l_decap_8
XFILLER_12_0 VPWR VGND sg13cmos5l_decap_8
XFILLER_10_407 VPWR VGND sg13cmos5l_decap_8
XANTENNA__135__Q NPU_QUANT_SHIFT_IN20 VPWR VGND sg13cmos5l_antennanp
XFILLER_2_606 VPWR VGND sg13cmos5l_decap_8
XFILLER_1_105 VPWR VGND sg13cmos5l_decap_8
XANTENNA_303 Tile_X0Y0_NN4END[1] VPWR VGND sg13cmos5l_antennanp
XFILLER_14_702 VPWR VGND sg13cmos5l_fill_2
XFILLER_10_930 VPWR VGND sg13cmos5l_decap_8
XFILLER_13_245 VPWR VGND sg13cmos5l_decap_8
XFILLER_16_1021 VPWR VGND sg13cmos5l_fill_1
XFILLER_16_1032 VPWR VGND sg13cmos5l_decap_8
X_372_ _372_/X Tile_X0Y0_N4END[4] Tile_X0Y0_N4END[7] Tile_X0Y0_NN4END[5] Tile_X0Y0_NN4END[7]
+ _060_/Q _059_/Q VPWR VGND sg13cmos5l_mux4_1
XFILLER_9_249 VPWR VGND sg13cmos5l_decap_8
XFILLER_1_683 VPWR VGND sg13cmos5l_decap_8
XFILLER_1_661 VPWR VGND sg13cmos5l_decap_8
XFILLER_9_772 VPWR VGND sg13cmos5l_decap_8
XFILLER_8_282 VPWR VGND sg13cmos5l_decap_8
XFILLER_10_259 VPWR VGND sg13cmos5l_decap_8
XFILLER_11_727 VPWR VGND sg13cmos5l_decap_8
XANTENNA_100 Tile_X0Y0_FrameData[25] VPWR VGND sg13cmos5l_antennanp
XANTENNA_111 Tile_X0Y0_FrameData[29] VPWR VGND sg13cmos5l_antennanp
XANTENNA_122 Tile_X0Y0_FrameData[2] VPWR VGND sg13cmos5l_antennanp
XANTENNA_133 Tile_X0Y0_FrameData[3] VPWR VGND sg13cmos5l_antennanp
XANTENNA_144 Tile_X0Y0_FrameData[4] VPWR VGND sg13cmos5l_antennanp
XANTENNA_155 Tile_X0Y0_FrameData[6] VPWR VGND sg13cmos5l_antennanp
XANTENNA_166 Tile_X0Y0_FrameData[7] VPWR VGND sg13cmos5l_antennanp
XANTENNA_177 Tile_X0Y0_FrameData[8] VPWR VGND sg13cmos5l_antennanp
XANTENNA_188 Tile_X0Y0_FrameData[9] VPWR VGND sg13cmos5l_antennanp
XANTENNA_199 Tile_X0Y0_N4END[3] VPWR VGND sg13cmos5l_antennanp
XFILLER_14_576 VPWR VGND sg13cmos5l_decap_8
XFILLER_14_91 VPWR VGND sg13cmos5l_decap_8
X_286_ Tile_X0Y0_SS4BEG[2] Tile_X0Y0_NN4END[13] VPWR VGND sg13cmos5l_buf_1
X_355_ Tile_X0Y0_FrameStrobe_O[19] Tile_X0Y0_FrameStrobe[19] VPWR VGND sg13cmos5l_buf_1
XFILLER_6_753 VPWR VGND sg13cmos5l_decap_8
XFILLER_6_786 VPWR VGND sg13cmos5l_fill_2
XFILLER_10_49 VPWR VGND sg13cmos5l_decap_8
XFILLER_15_329 VPWR VGND sg13cmos5l_decap_8
XFILLER_11_524 VPWR VGND sg13cmos5l_decap_8
XFILLER_13_1068 VPWR VGND sg13cmos5l_decap_8
X_071_ _071_/Q Tile_X0Y0_FrameData[31] VGND VPWR Tile_X0Y0_FrameStrobe[1] latch
X_140_ NPU_QUANT_SHIFT_IN25 Tile_X0Y0_UserCLK _390_/X _165_/L_HI VPWR VGND sg13cmos5l_dfrbpq_1
XFILLER_2_288 VPWR VGND sg13cmos5l_decap_8
XFILLER_2_266 VPWR VGND sg13cmos5l_decap_8
XFILLER_2_233 VPWR VGND sg13cmos5l_fill_2
XANTENNA__284__X Tile_X0Y0_SS4BEG[0] VPWR VGND sg13cmos5l_antennanp
XFILLER_15_830 VPWR VGND sg13cmos5l_fill_1
XFILLER_15_841 VPWR VGND sg13cmos5l_decap_4
X_338_ Tile_X0Y0_FrameStrobe_O[2] Tile_X0Y0_FrameStrobe[2] VPWR VGND sg13cmos5l_buf_1
X_269_ Tile_X0Y0_S4BEG[1] Tile_X0Y0_N4END[14] VPWR VGND sg13cmos5l_buf_1
XANTENNA_11 Tile_X0Y0_FrameData[10] VPWR VGND sg13cmos5l_antennanp
XANTENNA_22 Tile_X0Y0_FrameData[11] VPWR VGND sg13cmos5l_antennanp
XANTENNA_33 Tile_X0Y0_FrameData[12] VPWR VGND sg13cmos5l_antennanp
XANTENNA_44 Tile_X0Y0_FrameData[14] VPWR VGND sg13cmos5l_antennanp
XANTENNA_55 Tile_X0Y0_FrameData[15] VPWR VGND sg13cmos5l_antennanp
XANTENNA_66 Tile_X0Y0_FrameData[16] VPWR VGND sg13cmos5l_antennanp
XANTENNA_77 Tile_X0Y0_FrameData[17] VPWR VGND sg13cmos5l_antennanp
XANTENNA_88 Tile_X0Y0_FrameData[25] VPWR VGND sg13cmos5l_antennanp
XANTENNA_99 Tile_X0Y0_FrameData[25] VPWR VGND sg13cmos5l_antennanp
XANTENNA__194__X Tile_X1Y0_FrameStrobe_O[15] VPWR VGND sg13cmos5l_antennanp
XANTENNA__143__Q NPU_QUANT_SHIFT_IN28 VPWR VGND sg13cmos5l_antennanp
XFILLER_0_737 VPWR VGND sg13cmos5l_decap_8
XFILLER_16_605 VPWR VGND sg13cmos5l_fill_1
XFILLER_16_616 VPWR VGND sg13cmos5l_decap_8
XFILLER_15_126 VPWR VGND sg13cmos5l_decap_8
XFILLER_16_627 VPWR VGND sg13cmos5l_decap_4
XFILLER_11_343 VPWR VGND sg13cmos5l_decap_8
XFILLER_12_899 VPWR VGND sg13cmos5l_decap_8
X_054_ _054_/Q Tile_X0Y0_FrameData[16] VGND VPWR Tile_X0Y0_FrameStrobe[0] latch
X_123_ NPU_QUANT_SHIFT_IN8 Tile_X0Y0_UserCLK _373_/X _186_/L_HI VPWR VGND sg13cmos5l_dfrbpq_1
XFILLER_8_826 VPWR VGND sg13cmos5l_decap_8
XFILLER_7_28 VPWR VGND sg13cmos5l_decap_8
XANTENNA__279__X Tile_X0Y0_S4BEG[11] VPWR VGND sg13cmos5l_antennanp
XFILLER_11_70 VPWR VGND sg13cmos5l_decap_8
XFILLER_3_542 VPWR VGND sg13cmos5l_decap_8
XFILLER_16_7 VPWR VGND sg13cmos5l_decap_8
XFILLER_4_1066 VPWR VGND sg13cmos5l_decap_8
XANTENNA__189__X Tile_X1Y0_FrameStrobe_O[10] VPWR VGND sg13cmos5l_antennanp
XANTENNA__138__Q NPU_QUANT_SHIFT_IN23 VPWR VGND sg13cmos5l_antennanp
XFILLER_10_1016 VPWR VGND sg13cmos5l_decap_8
XFILLER_5_818 VPWR VGND sg13cmos5l_decap_4
XFILLER_4_328 VPWR VGND sg13cmos5l_fill_2
XFILLER_16_402 VPWR VGND sg13cmos5l_decap_4
XFILLER_16_435 VPWR VGND sg13cmos5l_decap_8
XFILLER_16_446 VPWR VGND sg13cmos5l_fill_1
XFILLER_16_457 VPWR VGND sg13cmos5l_fill_2
XFILLER_11_140 VPWR VGND sg13cmos5l_decap_8
XFILLER_12_685 VPWR VGND sg13cmos5l_decap_8
XFILLER_8_623 VPWR VGND sg13cmos5l_decap_8
X_106_ _106_/Q Tile_X0Y0_FrameData[0] VGND VPWR Tile_X1Y0_FrameStrobe[0] latch
XFILLER_7_133 VPWR VGND sg13cmos5l_decap_8
XFILLER_15_490 VPWR VGND sg13cmos5l_decap_8
XFILLER_13_449 VPWR VGND sg13cmos5l_decap_8
XFILLER_5_637 VPWR VGND sg13cmos5l_decap_8
XFILLER_4_147 VPWR VGND sg13cmos5l_decap_8
XFILLER_1_865 VPWR VGND sg13cmos5l_fill_2
XFILLER_16_243 VPWR VGND sg13cmos5l_fill_1
XFILLER_16_254 VPWR VGND sg13cmos5l_decap_8
XFILLER_16_265 VPWR VGND sg13cmos5l_fill_1
XFILLER_16_276 VPWR VGND sg13cmos5l_decap_8
XFILLER_1_1025 VPWR VGND sg13cmos5l_decap_8
XANTENNA__292__X Tile_X0Y0_SS4BEG[8] VPWR VGND sg13cmos5l_antennanp
XFILLER_12_482 VPWR VGND sg13cmos5l_decap_8
XFILLER_9_954 VPWR VGND sg13cmos5l_decap_8
XFILLER_8_497 VPWR VGND sg13cmos5l_decap_8
XFILLER_11_1111 VPWR VGND sg13cmos5l_fill_2
XFILLER_13_49 VPWR VGND sg13cmos5l_decap_8
XFILLER_0_1080 VPWR VGND sg13cmos5l_decap_8
XFILLER_13_224 VPWR VGND sg13cmos5l_decap_8
XFILLER_14_736 VPWR VGND sg13cmos5l_decap_4
X_371_ _371_/X Tile_X0Y0_N4END[6] Tile_X0Y0_N4END[7] Tile_X0Y0_NN4END[4] Tile_X0Y0_NN4END[6]
+ _062_/Q _061_/Q VPWR VGND sg13cmos5l_mux4_1
XFILLER_9_228 VPWR VGND sg13cmos5l_decap_8
XANTENNA__287__X Tile_X0Y0_SS4BEG[3] VPWR VGND sg13cmos5l_antennanp
XFILLER_0_183 VPWR VGND sg13cmos5l_decap_8
XFILLER_1_695 VPWR VGND sg13cmos5l_decap_8
XFILLER_9_751 VPWR VGND sg13cmos5l_decap_8
XFILLER_8_261 VPWR VGND sg13cmos5l_decap_8
XANTENNA__197__X Tile_X1Y0_FrameStrobe_O[18] VPWR VGND sg13cmos5l_antennanp
XANTENNA__146__Q NPU_SWAP_WEIGHTS VPWR VGND sg13cmos5l_antennanp
XFILLER_10_238 VPWR VGND sg13cmos5l_decap_8
XFILLER_11_706 VPWR VGND sg13cmos5l_decap_8
XANTENNA_101 Tile_X0Y0_FrameData[25] VPWR VGND sg13cmos5l_antennanp
XANTENNA_112 Tile_X0Y0_FrameData[29] VPWR VGND sg13cmos5l_antennanp
XANTENNA_123 Tile_X0Y0_FrameData[2] VPWR VGND sg13cmos5l_antennanp
XANTENNA_134 Tile_X0Y0_FrameData[3] VPWR VGND sg13cmos5l_antennanp
XANTENNA_145 Tile_X0Y0_FrameData[4] VPWR VGND sg13cmos5l_antennanp
XANTENNA_156 Tile_X0Y0_FrameData[6] VPWR VGND sg13cmos5l_antennanp
XANTENNA_167 Tile_X0Y0_FrameData[7] VPWR VGND sg13cmos5l_antennanp
XANTENNA_178 Tile_X0Y0_FrameData[8] VPWR VGND sg13cmos5l_antennanp
XANTENNA_189 Tile_X0Y0_FrameData[9] VPWR VGND sg13cmos5l_antennanp
XFILLER_14_555 VPWR VGND sg13cmos5l_decap_8
X_354_ Tile_X0Y0_FrameStrobe_O[18] Tile_X0Y0_FrameStrobe[18] VPWR VGND sg13cmos5l_buf_1
XFILLER_10_794 VPWR VGND sg13cmos5l_decap_8
XFILLER_14_70 VPWR VGND sg13cmos5l_decap_8
X_285_ Tile_X0Y0_SS4BEG[1] Tile_X0Y0_NN4END[14] VPWR VGND sg13cmos5l_buf_1
XFILLER_6_732 VPWR VGND sg13cmos5l_decap_8
XFILLER_7_1053 VPWR VGND sg13cmos5l_fill_2
XFILLER_7_1042 VPWR VGND sg13cmos5l_decap_8
XFILLER_2_982 VPWR VGND sg13cmos5l_decap_8
XFILLER_2_960 VPWR VGND sg13cmos5l_fill_2
XFILLER_7_1075 VPWR VGND sg13cmos5l_decap_8
XFILLER_0_919 VPWR VGND sg13cmos5l_decap_8
XFILLER_10_28 VPWR VGND sg13cmos5l_decap_8
XFILLER_9_581 VPWR VGND sg13cmos5l_fill_1
XFILLER_11_503 VPWR VGND sg13cmos5l_decap_8
XFILLER_15_308 VPWR VGND sg13cmos5l_decap_8
XFILLER_13_1047 VPWR VGND sg13cmos5l_decap_8
X_070_ _070_/Q Tile_X0Y0_FrameData[0] VGND VPWR Tile_X0Y0_FrameStrobe[0] latch
XFILLER_3_779 VPWR VGND sg13cmos5l_decap_8
XFILLER_2_256 VPWR VGND sg13cmos5l_fill_2
XFILLER_2_212 VPWR VGND sg13cmos5l_decap_8
X_337_ Tile_X0Y0_FrameStrobe_O[1] Tile_X0Y0_FrameStrobe[1] VPWR VGND sg13cmos5l_buf_1
X_199_ Tile_X0Y0_S2BEG[0] Tile_X0Y0_N2MID[7] VPWR VGND sg13cmos5l_buf_1
X_268_ Tile_X0Y0_S4BEG[0] Tile_X0Y0_N4END[15] VPWR VGND sg13cmos5l_buf_1
XFILLER_6_584 VPWR VGND sg13cmos5l_decap_8
XFILLER_2_84 VPWR VGND sg13cmos5l_decap_8
XANTENNA_12 Tile_X0Y0_FrameData[10] VPWR VGND sg13cmos5l_antennanp
XANTENNA_23 Tile_X0Y0_FrameData[11] VPWR VGND sg13cmos5l_antennanp
XANTENNA_34 Tile_X0Y0_FrameData[13] VPWR VGND sg13cmos5l_antennanp
XANTENNA_45 Tile_X0Y0_FrameData[14] VPWR VGND sg13cmos5l_antennanp
XANTENNA_56 Tile_X0Y0_FrameData[15] VPWR VGND sg13cmos5l_antennanp
XANTENNA_67 Tile_X0Y0_FrameData[16] VPWR VGND sg13cmos5l_antennanp
XANTENNA_78 Tile_X0Y0_FrameData[17] VPWR VGND sg13cmos5l_antennanp
XANTENNA_89 Tile_X0Y0_FrameData[25] VPWR VGND sg13cmos5l_antennanp
XFILLER_0_716 VPWR VGND sg13cmos5l_decap_8
XFILLER_15_105 VPWR VGND sg13cmos5l_decap_8
XFILLER_11_322 VPWR VGND sg13cmos5l_decap_8
XFILLER_12_812 VPWR VGND sg13cmos5l_decap_8
XFILLER_12_834 VPWR VGND sg13cmos5l_fill_1
XFILLER_12_856 VPWR VGND sg13cmos5l_fill_2
XFILLER_8_805 VPWR VGND sg13cmos5l_decap_8
XFILLER_7_315 VPWR VGND sg13cmos5l_decap_8
X_053_ _053_/Q Tile_X0Y0_FrameData[17] VGND VPWR Tile_X0Y0_FrameStrobe[0] latch
X_122_ NPU_QUANT_SHIFT_IN7 Tile_X0Y0_UserCLK _372_/X _185_/L_HI VPWR VGND sg13cmos5l_dfrbpq_1
XFILLER_7_359 VPWR VGND sg13cmos5l_decap_8
XFILLER_7_326 VPWR VGND sg13cmos5l_fill_1
XFILLER_3_521 VPWR VGND sg13cmos5l_decap_8
XFILLER_2_0 VPWR VGND sg13cmos5l_decap_8
XFILLER_3_598 VPWR VGND sg13cmos5l_decap_8
XANTENNA__295__X Tile_X0Y0_SS4BEG[11] VPWR VGND sg13cmos5l_antennanp
XFILLER_4_1045 VPWR VGND sg13cmos5l_decap_8
XFILLER_14_182 VPWR VGND sg13cmos5l_decap_8
XFILLER_15_694 VPWR VGND sg13cmos5l_decap_8
XFILLER_12_119 VPWR VGND sg13cmos5l_decap_8
XFILLER_11_196 VPWR VGND sg13cmos5l_decap_8
XFILLER_12_664 VPWR VGND sg13cmos5l_decap_8
X_105_ _105_/Q Tile_X0Y0_FrameData[1] VGND VPWR Tile_X1Y0_FrameStrobe[0] latch
XFILLER_8_679 VPWR VGND sg13cmos5l_decap_8
XFILLER_8_602 VPWR VGND sg13cmos5l_decap_8
XFILLER_7_112 VPWR VGND sg13cmos5l_decap_8
XFILLER_7_189 VPWR VGND sg13cmos5l_decap_8
XFILLER_16_981 VPWR VGND sg13cmos5l_decap_8
XANTENNA__149__Q NPU_ARRAY_EN VPWR VGND sg13cmos5l_antennanp
XFILLER_13_428 VPWR VGND sg13cmos5l_decap_8
XFILLER_5_616 VPWR VGND sg13cmos5l_decap_8
XFILLER_4_126 VPWR VGND sg13cmos5l_decap_8
XFILLER_1_811 VPWR VGND sg13cmos5l_decap_8
XFILLER_1_888 VPWR VGND sg13cmos5l_decap_8
XFILLER_12_461 VPWR VGND sg13cmos5l_decap_8
XFILLER_13_984 VPWR VGND sg13cmos5l_decap_8
XFILLER_9_933 VPWR VGND sg13cmos5l_decap_8
XFILLER_9_988 VPWR VGND sg13cmos5l_decap_4
XFILLER_9_999 VPWR VGND sg13cmos5l_fill_1
XFILLER_8_476 VPWR VGND sg13cmos5l_decap_8
XFILLER_13_28 VPWR VGND sg13cmos5l_decap_8
XFILLER_13_203 VPWR VGND sg13cmos5l_decap_8
XFILLER_14_704 VPWR VGND sg13cmos5l_fill_1
XFILLER_14_715 VPWR VGND sg13cmos5l_decap_8
X_370_ _370_/X Tile_X0Y0_N4END[5] Tile_X0Y0_N4END[6] Tile_X0Y0_NN4END[5] Tile_X0Y0_NN4END[7]
+ _064_/Q _063_/Q VPWR VGND sg13cmos5l_mux4_1
XFILLER_9_207 VPWR VGND sg13cmos5l_decap_8
XFILLER_16_1067 VPWR VGND sg13cmos5l_fill_1
XFILLER_16_1078 VPWR VGND sg13cmos5l_decap_8
XFILLER_6_947 VPWR VGND sg13cmos5l_fill_2
XFILLER_0_140 VPWR VGND sg13cmos5l_decap_4
XFILLER_0_162 VPWR VGND sg13cmos5l_decap_8
XFILLER_12_280 VPWR VGND sg13cmos5l_decap_8
XFILLER_13_770 VPWR VGND sg13cmos5l_decap_8
XFILLER_9_730 VPWR VGND sg13cmos5l_decap_8
XFILLER_8_240 VPWR VGND sg13cmos5l_decap_8
XFILLER_5_84 VPWR VGND sg13cmos5l_decap_8
XFILLER_4_490 VPWR VGND sg13cmos5l_decap_8
XFILLER_10_217 VPWR VGND sg13cmos5l_decap_8
XFILLER_6_7 VPWR VGND sg13cmos5l_decap_8
XFILLER_3_917 VPWR VGND sg13cmos5l_fill_2
XFILLER_2_427 VPWR VGND sg13cmos5l_fill_1
XANTENNA_102 Tile_X0Y0_FrameData[25] VPWR VGND sg13cmos5l_antennanp
XANTENNA_113 Tile_X0Y0_FrameData[29] VPWR VGND sg13cmos5l_antennanp
XANTENNA_124 Tile_X0Y0_FrameData[2] VPWR VGND sg13cmos5l_antennanp
XANTENNA_135 Tile_X0Y0_FrameData[3] VPWR VGND sg13cmos5l_antennanp
XANTENNA_146 Tile_X0Y0_FrameData[5] VPWR VGND sg13cmos5l_antennanp
XANTENNA_157 Tile_X0Y0_FrameData[6] VPWR VGND sg13cmos5l_antennanp
XANTENNA_168 Tile_X0Y0_FrameData[7] VPWR VGND sg13cmos5l_antennanp
XANTENNA_179 Tile_X0Y0_FrameData[8] VPWR VGND sg13cmos5l_antennanp
XFILLER_14_534 VPWR VGND sg13cmos5l_decap_8
X_284_ Tile_X0Y0_SS4BEG[0] Tile_X0Y0_NN4END[15] VPWR VGND sg13cmos5l_buf_1
X_353_ Tile_X0Y0_FrameStrobe_O[17] Tile_X0Y0_FrameStrobe[17] VPWR VGND sg13cmos5l_buf_1
XFILLER_10_773 VPWR VGND sg13cmos5l_decap_8
XFILLER_6_788 VPWR VGND sg13cmos5l_fill_1
XFILLER_6_711 VPWR VGND sg13cmos5l_decap_8
XFILLER_5_243 VPWR VGND sg13cmos5l_decap_8
XFILLER_5_210 VPWR VGND sg13cmos5l_decap_4
XANTENNA__298__X Tile_X0Y0_SS4BEG[14] VPWR VGND sg13cmos5l_antennanp
XFILLER_7_1021 VPWR VGND sg13cmos5l_decap_8
XFILLER_2_972 VPWR VGND sg13cmos5l_fill_2
XFILLER_11_559 VPWR VGND sg13cmos5l_decap_8
XFILLER_13_1026 VPWR VGND sg13cmos5l_decap_8
XFILLER_7_519 VPWR VGND sg13cmos5l_decap_8
XFILLER_3_714 VPWR VGND sg13cmos5l_decap_8
XFILLER_3_747 VPWR VGND sg13cmos5l_decap_4
X_267_ Tile_X0Y0_S2BEGb[7] Tile_X0Y0_N2END[0] VPWR VGND sg13cmos5l_buf_1
X_336_ Tile_X0Y0_FrameStrobe_O[0] Tile_X0Y0_FrameStrobe[0] VPWR VGND sg13cmos5l_buf_1
X_198_ Tile_X1Y0_FrameStrobe_O[19] Tile_X1Y0_FrameStrobe[19] VPWR VGND sg13cmos5l_buf_1
XFILLER_6_563 VPWR VGND sg13cmos5l_decap_8
XFILLER_2_63 VPWR VGND sg13cmos5l_decap_8
XANTENNA_13 Tile_X0Y0_FrameData[10] VPWR VGND sg13cmos5l_antennanp
XANTENNA_24 Tile_X0Y0_FrameData[11] VPWR VGND sg13cmos5l_antennanp
XANTENNA_35 Tile_X0Y0_FrameData[13] VPWR VGND sg13cmos5l_antennanp
XANTENNA_46 Tile_X0Y0_FrameData[14] VPWR VGND sg13cmos5l_antennanp
XANTENNA_57 Tile_X0Y0_FrameData[15] VPWR VGND sg13cmos5l_antennanp
XANTENNA_68 Tile_X0Y0_FrameData[16] VPWR VGND sg13cmos5l_antennanp
XANTENNA_79 Tile_X0Y0_FrameData[1] VPWR VGND sg13cmos5l_antennanp
XFILLER_12_1081 VPWR VGND sg13cmos5l_decap_8
XFILLER_11_301 VPWR VGND sg13cmos5l_decap_8
XFILLER_11_378 VPWR VGND sg13cmos5l_decap_8
XFILLER_12_846 VPWR VGND sg13cmos5l_decap_4
XFILLER_12_868 VPWR VGND sg13cmos5l_decap_8
X_121_ NPU_QUANT_SHIFT_IN6 Tile_X0Y0_UserCLK _371_/X _184_/L_HI VPWR VGND sg13cmos5l_dfrbpq_1
X_052_ _052_/Q Tile_X0Y0_FrameData[18] VGND VPWR Tile_X0Y0_FrameStrobe[0] latch
XFILLER_3_577 VPWR VGND sg13cmos5l_decap_8
XFILLER_3_500 VPWR VGND sg13cmos5l_decap_8
XFILLER_4_1024 VPWR VGND sg13cmos5l_decap_8
XFILLER_14_161 VPWR VGND sg13cmos5l_decap_8
XFILLER_15_651 VPWR VGND sg13cmos5l_decap_8
XFILLER_15_673 VPWR VGND sg13cmos5l_decap_8
X_319_ Tile_X1Y0_FrameData_O[15] Tile_X0Y0_FrameData[15] VPWR VGND sg13cmos5l_buf_1
XFILLER_16_28 VPWR VGND sg13cmos5l_decap_8
XFILLER_16_39 VPWR VGND sg13cmos5l_fill_2
XFILLER_14_1110 VPWR VGND sg13cmos5l_decap_4
XFILLER_0_547 VPWR VGND sg13cmos5l_fill_1
XFILLER_11_175 VPWR VGND sg13cmos5l_decap_8
XFILLER_12_643 VPWR VGND sg13cmos5l_decap_8
X_104_ _104_/Q Tile_X0Y0_FrameData[2] VGND VPWR Tile_X1Y0_FrameStrobe[0] latch
XFILLER_8_658 VPWR VGND sg13cmos5l_decap_8
XFILLER_7_168 VPWR VGND sg13cmos5l_decap_8
XFILLER_8_84 VPWR VGND sg13cmos5l_decap_8
XFILLER_7_680 VPWR VGND sg13cmos5l_decap_8
XFILLER_13_407 VPWR VGND sg13cmos5l_decap_8
XFILLER_4_105 VPWR VGND sg13cmos5l_decap_8
XFILLER_1_867 VPWR VGND sg13cmos5l_fill_1
XFILLER_1_845 VPWR VGND sg13cmos5l_decap_8
XFILLER_1_823 VPWR VGND sg13cmos5l_fill_2
XFILLER_1_801 VPWR VGND sg13cmos5l_fill_2
XFILLER_12_440 VPWR VGND sg13cmos5l_decap_8
XFILLER_16_234 VPWR VGND sg13cmos5l_decap_4
XFILLER_9_912 VPWR VGND sg13cmos5l_decap_8
XFILLER_8_455 VPWR VGND sg13cmos5l_decap_8
XFILLER_11_1113 VPWR VGND sg13cmos5l_fill_1
XFILLER_1_119 VPWR VGND sg13cmos5l_decap_8
XFILLER_13_259 VPWR VGND sg13cmos5l_decap_8
XFILLER_16_1002 VPWR VGND sg13cmos5l_decap_8
XFILLER_16_1046 VPWR VGND sg13cmos5l_decap_8
XFILLER_9_786 VPWR VGND sg13cmos5l_decap_8
XFILLER_8_296 VPWR VGND sg13cmos5l_decap_8
XFILLER_5_970 VPWR VGND sg13cmos5l_decap_8
XFILLER_5_63 VPWR VGND sg13cmos5l_decap_8
XFILLER_10_0 VPWR VGND sg13cmos5l_decap_8
XANTENNA_103 Tile_X0Y0_FrameData[25] VPWR VGND sg13cmos5l_antennanp
XANTENNA_114 Tile_X0Y0_FrameData[29] VPWR VGND sg13cmos5l_antennanp
XANTENNA_125 Tile_X0Y0_FrameData[2] VPWR VGND sg13cmos5l_antennanp
XANTENNA_136 Tile_X0Y0_FrameData[3] VPWR VGND sg13cmos5l_antennanp
XANTENNA_147 Tile_X0Y0_FrameData[5] VPWR VGND sg13cmos5l_antennanp
XANTENNA_158 Tile_X0Y0_FrameData[6] VPWR VGND sg13cmos5l_antennanp
XFILLER_14_513 VPWR VGND sg13cmos5l_decap_8
XANTENNA_169 Tile_X0Y0_FrameData[7] VPWR VGND sg13cmos5l_antennanp
XFILLER_10_752 VPWR VGND sg13cmos5l_decap_8
X_283_ Tile_X0Y0_S4BEG[15] Tile_X0Y0_N4END[0] VPWR VGND sg13cmos5l_buf_1
X_352_ Tile_X0Y0_FrameStrobe_O[16] Tile_X0Y0_FrameStrobe[16] VPWR VGND sg13cmos5l_buf_1
XFILLER_6_767 VPWR VGND sg13cmos5l_decap_8
XFILLER_5_288 VPWR VGND sg13cmos5l_decap_8
XFILLER_7_1000 VPWR VGND sg13cmos5l_decap_8
XFILLER_9_572 VPWR VGND sg13cmos5l_decap_8
XFILLER_11_538 VPWR VGND sg13cmos5l_decap_8
XFILLER_13_1005 VPWR VGND sg13cmos5l_decap_8
XFILLER_2_258 VPWR VGND sg13cmos5l_fill_1
XFILLER_14_365 VPWR VGND sg13cmos5l_decap_8
XFILLER_15_888 VPWR VGND sg13cmos5l_decap_8
XFILLER_10_582 VPWR VGND sg13cmos5l_decap_8
XFILLER_14_387 VPWR VGND sg13cmos5l_decap_8
X_197_ Tile_X1Y0_FrameStrobe_O[18] Tile_X1Y0_FrameStrobe[18] VPWR VGND sg13cmos5l_buf_1
X_266_ Tile_X0Y0_S2BEGb[6] Tile_X0Y0_N2END[1] VPWR VGND sg13cmos5l_buf_1
X_335_ Tile_X1Y0_FrameData_O[31] Tile_X0Y0_FrameData[31] VPWR VGND sg13cmos5l_buf_1
XFILLER_6_542 VPWR VGND sg13cmos5l_decap_8
XFILLER_2_42 VPWR VGND sg13cmos5l_decap_8
XFILLER_1_291 VPWR VGND sg13cmos5l_decap_4
XANTENNA_14 Tile_X0Y0_FrameData[10] VPWR VGND sg13cmos5l_antennanp
XANTENNA_25 Tile_X0Y0_FrameData[12] VPWR VGND sg13cmos5l_antennanp
XANTENNA_36 Tile_X0Y0_FrameData[13] VPWR VGND sg13cmos5l_antennanp
XANTENNA_47 Tile_X0Y0_FrameData[14] VPWR VGND sg13cmos5l_antennanp
XANTENNA_58 Tile_X0Y0_FrameData[15] VPWR VGND sg13cmos5l_antennanp
XANTENNA_69 Tile_X0Y0_FrameData[16] VPWR VGND sg13cmos5l_antennanp
XFILLER_12_1060 VPWR VGND sg13cmos5l_decap_8
XFILLER_11_357 VPWR VGND sg13cmos5l_decap_8
X_051_ _051_/Q Tile_X0Y0_FrameData[19] VGND VPWR Tile_X0Y0_FrameStrobe[0] latch
X_120_ NPU_QUANT_SHIFT_IN5 Tile_X0Y0_UserCLK _370_/X _156_/L_HI VPWR VGND sg13cmos5l_dfrbpq_1
XFILLER_11_84 VPWR VGND sg13cmos5l_decap_8
XFILLER_3_556 VPWR VGND sg13cmos5l_decap_8
XFILLER_4_1003 VPWR VGND sg13cmos5l_decap_8
XFILLER_14_140 VPWR VGND sg13cmos5l_decap_8
XFILLER_15_630 VPWR VGND sg13cmos5l_decap_8
XFILLER_11_880 VPWR VGND sg13cmos5l_decap_8
X_249_ Tile_X1Y0_SS4BEG[6] Tile_X1Y0_NN4END[9] VPWR VGND sg13cmos5l_buf_1
X_318_ Tile_X1Y0_FrameData_O[14] Tile_X0Y0_FrameData[14] VPWR VGND sg13cmos5l_buf_1
XFILLER_0_559 VPWR VGND sg13cmos5l_decap_8
XFILLER_12_622 VPWR VGND sg13cmos5l_decap_8
XFILLER_16_416 VPWR VGND sg13cmos5l_decap_8
XFILLER_11_154 VPWR VGND sg13cmos5l_decap_8
XFILLER_12_699 VPWR VGND sg13cmos5l_decap_8
X_103_ _103_/Q Tile_X0Y0_FrameData[3] VGND VPWR Tile_X1Y0_FrameStrobe[0] latch
XFILLER_8_637 VPWR VGND sg13cmos5l_decap_8
XFILLER_7_147 VPWR VGND sg13cmos5l_decap_8
XFILLER_4_810 VPWR VGND sg13cmos5l_fill_1
XFILLER_4_898 VPWR VGND sg13cmos5l_fill_1
XFILLER_4_876 VPWR VGND sg13cmos5l_fill_2
XFILLER_14_7 VPWR VGND sg13cmos5l_decap_8
XFILLER_16_961 VPWR VGND sg13cmos5l_fill_2
XFILLER_8_63 VPWR VGND sg13cmos5l_decap_8
XFILLER_1_879 VPWR VGND sg13cmos5l_fill_1
XANTENNA__200__X Tile_X0Y0_S2BEG[1] VPWR VGND sg13cmos5l_antennanp
XFILLER_16_213 VPWR VGND sg13cmos5l_decap_8
XFILLER_1_1039 VPWR VGND sg13cmos5l_decap_8
XFILLER_12_496 VPWR VGND sg13cmos5l_decap_8
XFILLER_4_673 VPWR VGND sg13cmos5l_fill_1
XFILLER_0_1094 VPWR VGND sg13cmos5l_decap_8
XFILLER_10_923 VPWR VGND sg13cmos5l_decap_8
XFILLER_13_238 VPWR VGND sg13cmos5l_decap_8
XFILLER_16_1014 VPWR VGND sg13cmos5l_decap_8
XFILLER_16_1025 VPWR VGND sg13cmos5l_decap_8
XFILLER_6_949 VPWR VGND sg13cmos5l_fill_1
XFILLER_0_197 VPWR VGND sg13cmos5l_decap_8
XFILLER_9_765 VPWR VGND sg13cmos5l_decap_8
XFILLER_8_275 VPWR VGND sg13cmos5l_decap_8
XFILLER_5_42 VPWR VGND sg13cmos5l_decap_8
XFILLER_3_919 VPWR VGND sg13cmos5l_fill_1
XANTENNA_104 Tile_X0Y0_FrameData[29] VPWR VGND sg13cmos5l_antennanp
XANTENNA_115 Tile_X0Y0_FrameData[29] VPWR VGND sg13cmos5l_antennanp
XANTENNA_126 Tile_X0Y0_FrameData[2] VPWR VGND sg13cmos5l_antennanp
XANTENNA_137 Tile_X0Y0_FrameData[4] VPWR VGND sg13cmos5l_antennanp
XANTENNA_148 Tile_X0Y0_FrameData[5] VPWR VGND sg13cmos5l_antennanp
XANTENNA_159 Tile_X0Y0_FrameData[6] VPWR VGND sg13cmos5l_antennanp
X_351_ Tile_X0Y0_FrameStrobe_O[15] Tile_X0Y0_FrameStrobe[15] VPWR VGND sg13cmos5l_buf_1
XFILLER_10_731 VPWR VGND sg13cmos5l_decap_8
XFILLER_14_569 VPWR VGND sg13cmos5l_decap_8
XFILLER_14_84 VPWR VGND sg13cmos5l_decap_8
X_282_ Tile_X0Y0_S4BEG[14] Tile_X0Y0_N4END[1] VPWR VGND sg13cmos5l_buf_1
XFILLER_6_746 VPWR VGND sg13cmos5l_decap_8
XFILLER_7_1089 VPWR VGND sg13cmos5l_fill_2
XFILLER_2_996 VPWR VGND sg13cmos5l_decap_8
XFILLER_9_551 VPWR VGND sg13cmos5l_decap_8
XFILLER_5_790 VPWR VGND sg13cmos5l_decap_8
XFILLER_11_517 VPWR VGND sg13cmos5l_decap_8
XFILLER_2_226 VPWR VGND sg13cmos5l_decap_8
XFILLER_14_322 VPWR VGND sg13cmos5l_decap_4
XFILLER_15_812 VPWR VGND sg13cmos5l_decap_8
XFILLER_15_834 VPWR VGND sg13cmos5l_decap_8
XFILLER_15_845 VPWR VGND sg13cmos5l_fill_2
XFILLER_15_867 VPWR VGND sg13cmos5l_decap_8
XFILLER_15_878 VPWR VGND sg13cmos5l_fill_2
X_334_ Tile_X1Y0_FrameData_O[30] Tile_X0Y0_FrameData[30] VPWR VGND sg13cmos5l_buf_1
XFILLER_10_561 VPWR VGND sg13cmos5l_decap_8
X_196_ Tile_X1Y0_FrameStrobe_O[17] Tile_X1Y0_FrameStrobe[17] VPWR VGND sg13cmos5l_buf_1
X_265_ Tile_X0Y0_S2BEGb[5] Tile_X0Y0_N2END[2] VPWR VGND sg13cmos5l_buf_1
XFILLER_6_521 VPWR VGND sg13cmos5l_decap_8
XFILLER_6_598 VPWR VGND sg13cmos5l_decap_8
XFILLER_2_782 VPWR VGND sg13cmos5l_decap_8
XFILLER_2_21 VPWR VGND sg13cmos5l_decap_8
XFILLER_1_270 VPWR VGND sg13cmos5l_decap_8
XFILLER_2_98 VPWR VGND sg13cmos5l_decap_8
XANTENNA_15 Tile_X0Y0_FrameData[10] VPWR VGND sg13cmos5l_antennanp
XANTENNA_26 Tile_X0Y0_FrameData[12] VPWR VGND sg13cmos5l_antennanp
XANTENNA_37 Tile_X0Y0_FrameData[13] VPWR VGND sg13cmos5l_antennanp
XANTENNA_48 Tile_X0Y0_FrameData[14] VPWR VGND sg13cmos5l_antennanp
XANTENNA_59 Tile_X0Y0_FrameData[15] VPWR VGND sg13cmos5l_antennanp
XFILLER_12_826 VPWR VGND sg13cmos5l_decap_4
XFILLER_15_119 VPWR VGND sg13cmos5l_decap_8
XFILLER_16_609 VPWR VGND sg13cmos5l_decap_4
XFILLER_11_336 VPWR VGND sg13cmos5l_decap_8
X_050_ _050_/Q Tile_X0Y0_FrameData[20] VGND VPWR Tile_X0Y0_FrameStrobe[0] latch
XFILLER_8_819 VPWR VGND sg13cmos5l_decap_8
XANTENNA__203__X Tile_X0Y0_S2BEG[4] VPWR VGND sg13cmos5l_antennanp
XFILLER_11_63 VPWR VGND sg13cmos5l_decap_8
XFILLER_3_535 VPWR VGND sg13cmos5l_decap_8
XFILLER_4_1059 VPWR VGND sg13cmos5l_decap_8
XFILLER_14_196 VPWR VGND sg13cmos5l_decap_8
X_317_ Tile_X1Y0_FrameData_O[13] Tile_X0Y0_FrameData[13] VPWR VGND sg13cmos5l_buf_1
XFILLER_11_892 VPWR VGND sg13cmos5l_fill_1
X_179_ _179_/L_HI VPWR VGND sg13cmos5l_tiehi
X_248_ Tile_X1Y0_SS4BEG[5] Tile_X1Y0_NN4END[10] VPWR VGND sg13cmos5l_buf_1
XFILLER_7_896 VPWR VGND sg13cmos5l_fill_2
XFILLER_10_1009 VPWR VGND sg13cmos5l_decap_8
XFILLER_3_1081 VPWR VGND sg13cmos5l_decap_8
XFILLER_11_133 VPWR VGND sg13cmos5l_decap_8
XFILLER_12_601 VPWR VGND sg13cmos5l_decap_8
XFILLER_12_678 VPWR VGND sg13cmos5l_decap_8
XFILLER_8_616 VPWR VGND sg13cmos5l_decap_8
X_102_ _102_/Q Tile_X0Y0_FrameData[4] VGND VPWR Tile_X1Y0_FrameStrobe[0] latch
XFILLER_7_126 VPWR VGND sg13cmos5l_decap_8
XFILLER_0_0 VPWR VGND sg13cmos5l_decap_8
XFILLER_16_995 VPWR VGND sg13cmos5l_decap_8
XFILLER_16_940 VPWR VGND sg13cmos5l_decap_8
XFILLER_15_483 VPWR VGND sg13cmos5l_decap_8
XFILLER_8_42 VPWR VGND sg13cmos5l_decap_8
XFILLER_0_368 VPWR VGND sg13cmos5l_fill_1
XFILLER_16_247 VPWR VGND sg13cmos5l_decap_8
XFILLER_16_269 VPWR VGND sg13cmos5l_decap_8
XFILLER_1_1018 VPWR VGND sg13cmos5l_decap_8
XFILLER_1_1007 VPWR VGND sg13cmos5l_fill_1
XFILLER_12_475 VPWR VGND sg13cmos5l_decap_8
XFILLER_13_998 VPWR VGND sg13cmos5l_decap_8
XFILLER_9_947 VPWR VGND sg13cmos5l_decap_8
XFILLER_4_696 VPWR VGND sg13cmos5l_decap_8
XFILLER_4_652 VPWR VGND sg13cmos5l_decap_8
XFILLER_3_195 VPWR VGND sg13cmos5l_fill_2
XFILLER_3_140 VPWR VGND sg13cmos5l_decap_8
XFILLER_0_891 VPWR VGND sg13cmos5l_decap_8
XFILLER_15_280 VPWR VGND sg13cmos5l_decap_8
XFILLER_11_1104 VPWR VGND sg13cmos5l_decap_8
XANTENNA__301__X Tile_X0Y0_S1BEG[1] VPWR VGND sg13cmos5l_antennanp
XFILLER_14_729 VPWR VGND sg13cmos5l_decap_8
XFILLER_0_1073 VPWR VGND sg13cmos5l_decap_8
XFILLER_10_902 VPWR VGND sg13cmos5l_decap_8
XFILLER_13_217 VPWR VGND sg13cmos5l_decap_8
XANTENNA__211__X Tile_X1Y0_S2BEG[0] VPWR VGND sg13cmos5l_antennanp
XFILLER_0_176 VPWR VGND sg13cmos5l_decap_4
XFILLER_1_655 VPWR VGND sg13cmos5l_fill_2
XFILLER_12_294 VPWR VGND sg13cmos5l_decap_8
XFILLER_9_744 VPWR VGND sg13cmos5l_decap_8
XFILLER_8_254 VPWR VGND sg13cmos5l_decap_8
XFILLER_5_21 VPWR VGND sg13cmos5l_decap_8
XFILLER_5_98 VPWR VGND sg13cmos5l_decap_8
XFILLER_15_1092 VPWR VGND sg13cmos5l_decap_8
XANTENNA_105 Tile_X0Y0_FrameData[29] VPWR VGND sg13cmos5l_antennanp
XANTENNA_116 Tile_X0Y0_FrameData[29] VPWR VGND sg13cmos5l_antennanp
XANTENNA_127 Tile_X0Y0_FrameData[2] VPWR VGND sg13cmos5l_antennanp
XANTENNA_138 Tile_X0Y0_FrameData[4] VPWR VGND sg13cmos5l_antennanp
XANTENNA_149 Tile_X0Y0_FrameData[5] VPWR VGND sg13cmos5l_antennanp
XFILLER_14_548 VPWR VGND sg13cmos5l_decap_8
X_350_ Tile_X0Y0_FrameStrobe_O[14] Tile_X0Y0_FrameStrobe[14] VPWR VGND sg13cmos5l_buf_1
XANTENNA__206__X Tile_X0Y0_S2BEG[7] VPWR VGND sg13cmos5l_antennanp
XFILLER_10_710 VPWR VGND sg13cmos5l_decap_8
XFILLER_10_787 VPWR VGND sg13cmos5l_decap_8
XFILLER_14_63 VPWR VGND sg13cmos5l_decap_8
X_281_ Tile_X0Y0_S4BEG[13] Tile_X0Y0_N4END[2] VPWR VGND sg13cmos5l_buf_1
XFILLER_6_725 VPWR VGND sg13cmos5l_decap_8
XFILLER_7_1035 VPWR VGND sg13cmos5l_decap_8
XFILLER_2_953 VPWR VGND sg13cmos5l_decap_8
XFILLER_7_1068 VPWR VGND sg13cmos5l_decap_8
XFILLER_9_530 VPWR VGND sg13cmos5l_decap_8
XFILLER_9_585 VPWR VGND sg13cmos5l_fill_1
XFILLER_4_7 VPWR VGND sg13cmos5l_decap_8
XFILLER_2_249 VPWR VGND sg13cmos5l_decap_8
XFILLER_14_301 VPWR VGND sg13cmos5l_decap_8
X_264_ Tile_X0Y0_S2BEGb[4] Tile_X0Y0_N2END[3] VPWR VGND sg13cmos5l_buf_1
X_333_ Tile_X1Y0_FrameData_O[29] Tile_X0Y0_FrameData[29] VPWR VGND sg13cmos5l_buf_1
XFILLER_10_540 VPWR VGND sg13cmos5l_decap_8
X_195_ Tile_X1Y0_FrameStrobe_O[16] Tile_X1Y0_FrameStrobe[16] VPWR VGND sg13cmos5l_buf_1
XFILLER_6_577 VPWR VGND sg13cmos5l_decap_8
XFILLER_6_500 VPWR VGND sg13cmos5l_decap_8
XFILLER_2_77 VPWR VGND sg13cmos5l_decap_8
XFILLER_2_761 VPWR VGND sg13cmos5l_decap_8
XANTENNA_16 Tile_X0Y0_FrameData[11] VPWR VGND sg13cmos5l_antennanp
XANTENNA_27 Tile_X0Y0_FrameData[12] VPWR VGND sg13cmos5l_antennanp
XANTENNA_38 Tile_X0Y0_FrameData[13] VPWR VGND sg13cmos5l_antennanp
XANTENNA_49 Tile_X0Y0_FrameData[14] VPWR VGND sg13cmos5l_antennanp
XFILLER_9_382 VPWR VGND sg13cmos5l_decap_8
XFILLER_0_709 VPWR VGND sg13cmos5l_decap_8
XFILLER_12_1095 VPWR VGND sg13cmos5l_decap_8
XFILLER_11_315 VPWR VGND sg13cmos5l_decap_8
XFILLER_12_805 VPWR VGND sg13cmos5l_decap_8
XFILLER_11_42 VPWR VGND sg13cmos5l_decap_8
XFILLER_7_308 VPWR VGND sg13cmos5l_decap_8
XFILLER_3_514 VPWR VGND sg13cmos5l_decap_8
XFILLER_4_1038 VPWR VGND sg13cmos5l_decap_8
XFILLER_14_175 VPWR VGND sg13cmos5l_decap_8
XFILLER_15_665 VPWR VGND sg13cmos5l_decap_4
XFILLER_15_687 VPWR VGND sg13cmos5l_decap_8
X_247_ Tile_X1Y0_SS4BEG[4] Tile_X1Y0_NN4END[11] VPWR VGND sg13cmos5l_buf_1
X_316_ Tile_X1Y0_FrameData_O[12] Tile_X0Y0_FrameData[12] VPWR VGND sg13cmos5l_buf_1
XFILLER_7_820 VPWR VGND sg13cmos5l_decap_4
X_178_ _178_/L_HI VPWR VGND sg13cmos5l_tiehi
XFILLER_6_374 VPWR VGND sg13cmos5l_fill_1
XANTENNA__304__X Tile_X1Y0_FrameData_O[0] VPWR VGND sg13cmos5l_antennanp
XFILLER_3_1060 VPWR VGND sg13cmos5l_decap_8
XFILLER_11_112 VPWR VGND sg13cmos5l_decap_8
XFILLER_11_189 VPWR VGND sg13cmos5l_decap_8
XFILLER_12_657 VPWR VGND sg13cmos5l_decap_8
X_101_ _101_/Q Tile_X0Y0_FrameData[5] VGND VPWR Tile_X1Y0_FrameStrobe[0] latch
XFILLER_7_105 VPWR VGND sg13cmos5l_decap_8
XANTENNA__214__X Tile_X1Y0_S2BEG[3] VPWR VGND sg13cmos5l_antennanp
XFILLER_4_878 VPWR VGND sg13cmos5l_fill_1
XFILLER_4_823 VPWR VGND sg13cmos5l_fill_2
XFILLER_3_355 VPWR VGND sg13cmos5l_fill_2
XFILLER_15_462 VPWR VGND sg13cmos5l_decap_8
XFILLER_16_974 VPWR VGND sg13cmos5l_decap_8
XFILLER_16_963 VPWR VGND sg13cmos5l_fill_1
XFILLER_8_98 VPWR VGND sg13cmos5l_decap_8
XFILLER_8_21 VPWR VGND sg13cmos5l_decap_8
XFILLER_7_694 VPWR VGND sg13cmos5l_decap_8
XFILLER_6_182 VPWR VGND sg13cmos5l_decap_8
XFILLER_5_609 VPWR VGND sg13cmos5l_decap_8
XFILLER_4_119 VPWR VGND sg13cmos5l_decap_8
XFILLER_1_859 VPWR VGND sg13cmos5l_fill_2
XANTENNA__209__X Tile_X1Y0_S1BEG[2] VPWR VGND sg13cmos5l_antennanp
XFILLER_12_454 VPWR VGND sg13cmos5l_decap_8
XFILLER_13_977 VPWR VGND sg13cmos5l_decap_8
XFILLER_9_926 VPWR VGND sg13cmos5l_decap_8
XFILLER_8_469 VPWR VGND sg13cmos5l_decap_8
XFILLER_4_631 VPWR VGND sg13cmos5l_decap_8
XFILLER_0_870 VPWR VGND sg13cmos5l_decap_8
XFILLER_16_793 VPWR VGND sg13cmos5l_decap_8
XFILLER_7_491 VPWR VGND sg13cmos5l_decap_8
XFILLER_0_1052 VPWR VGND sg13cmos5l_decap_8
XFILLER_14_708 VPWR VGND sg13cmos5l_decap_8
XFILLER_0_111 VPWR VGND sg13cmos5l_decap_8
XFILLER_0_133 VPWR VGND sg13cmos5l_decap_8
XFILLER_1_634 VPWR VGND sg13cmos5l_fill_1
XFILLER_0_155 VPWR VGND sg13cmos5l_decap_8
XFILLER_13_763 VPWR VGND sg13cmos5l_decap_8
XFILLER_13_796 VPWR VGND sg13cmos5l_decap_8
XFILLER_9_723 VPWR VGND sg13cmos5l_decap_8
XFILLER_12_273 VPWR VGND sg13cmos5l_decap_8
XFILLER_8_233 VPWR VGND sg13cmos5l_decap_8
XFILLER_5_77 VPWR VGND sg13cmos5l_decap_8
XFILLER_15_1071 VPWR VGND sg13cmos5l_decap_8
XANTENNA__312__X Tile_X1Y0_FrameData_O[8] VPWR VGND sg13cmos5l_antennanp
XANTENNA_106 Tile_X0Y0_FrameData[29] VPWR VGND sg13cmos5l_antennanp
XANTENNA_117 Tile_X0Y0_FrameData[29] VPWR VGND sg13cmos5l_antennanp
XANTENNA_128 Tile_X0Y0_FrameData[3] VPWR VGND sg13cmos5l_antennanp
XANTENNA_139 Tile_X0Y0_FrameData[4] VPWR VGND sg13cmos5l_antennanp
XFILLER_14_42 VPWR VGND sg13cmos5l_decap_8
XFILLER_14_527 VPWR VGND sg13cmos5l_decap_8
X_280_ Tile_X0Y0_S4BEG[12] Tile_X0Y0_N4END[3] VPWR VGND sg13cmos5l_buf_1
XFILLER_10_766 VPWR VGND sg13cmos5l_decap_8
XFILLER_6_704 VPWR VGND sg13cmos5l_decap_8
XFILLER_5_214 VPWR VGND sg13cmos5l_fill_2
XFILLER_5_203 VPWR VGND sg13cmos5l_decap_8
XANTENNA__222__X Tile_X1Y0_S2BEGb[3] VPWR VGND sg13cmos5l_antennanp
XFILLER_7_1014 VPWR VGND sg13cmos5l_decap_8
XFILLER_13_582 VPWR VGND sg13cmos5l_decap_8
XFILLER_9_597 VPWR VGND sg13cmos5l_decap_8
XFILLER_5_770 VPWR VGND sg13cmos5l_fill_1
XFILLER_4_280 VPWR VGND sg13cmos5l_decap_8
XANTENNA__307__X Tile_X1Y0_FrameData_O[3] VPWR VGND sg13cmos5l_antennanp
XFILLER_13_1019 VPWR VGND sg13cmos5l_decap_8
XFILLER_3_707 VPWR VGND sg13cmos5l_decap_8
XFILLER_2_239 VPWR VGND sg13cmos5l_decap_8
X_401_ _401_/X Tile_X0Y0_N1END[0] Tile_X0Y0_N2MID[0] Tile_X0Y0_N2MID[7] Tile_X0Y0_N2END[7]
+ _044_/Q _043_/Q VPWR VGND sg13cmos5l_mux4_1
XANTENNA__217__X Tile_X1Y0_S2BEG[6] VPWR VGND sg13cmos5l_antennanp
XFILLER_14_379 VPWR VGND sg13cmos5l_decap_4
X_263_ Tile_X0Y0_S2BEGb[3] Tile_X0Y0_N2END[4] VPWR VGND sg13cmos5l_buf_1
X_332_ Tile_X1Y0_FrameData_O[28] Tile_X0Y0_FrameData[28] VPWR VGND sg13cmos5l_buf_1
XFILLER_10_596 VPWR VGND sg13cmos5l_decap_8
X_194_ Tile_X1Y0_FrameStrobe_O[15] Tile_X1Y0_FrameStrobe[15] VPWR VGND sg13cmos5l_buf_1
XFILLER_6_556 VPWR VGND sg13cmos5l_decap_8
XFILLER_2_56 VPWR VGND sg13cmos5l_decap_8
XANTENNA_17 Tile_X0Y0_FrameData[11] VPWR VGND sg13cmos5l_antennanp
XANTENNA_28 Tile_X0Y0_FrameData[12] VPWR VGND sg13cmos5l_antennanp
XANTENNA_39 Tile_X0Y0_FrameData[13] VPWR VGND sg13cmos5l_antennanp
XFILLER_9_361 VPWR VGND sg13cmos5l_decap_8
XFILLER_12_1074 VPWR VGND sg13cmos5l_decap_8
XFILLER_12_839 VPWR VGND sg13cmos5l_decap_8
XFILLER_11_21 VPWR VGND sg13cmos5l_decap_8
XFILLER_11_98 VPWR VGND sg13cmos5l_decap_8
XFILLER_4_1017 VPWR VGND sg13cmos5l_decap_8
XFILLER_14_154 VPWR VGND sg13cmos5l_decap_8
XFILLER_15_644 VPWR VGND sg13cmos5l_decap_8
X_177_ _177_/L_HI VPWR VGND sg13cmos5l_tiehi
X_246_ Tile_X1Y0_SS4BEG[3] Tile_X1Y0_NN4END[12] VPWR VGND sg13cmos5l_buf_1
X_315_ Tile_X1Y0_FrameData_O[11] Tile_X0Y0_FrameData[11] VPWR VGND sg13cmos5l_buf_1
XFILLER_7_898 VPWR VGND sg13cmos5l_fill_1
XFILLER_2_592 VPWR VGND sg13cmos5l_decap_8
XFILLER_14_1103 VPWR VGND sg13cmos5l_decap_8
XANTENNA__320__X Tile_X1Y0_FrameData_O[16] VPWR VGND sg13cmos5l_antennanp
XFILLER_11_168 VPWR VGND sg13cmos5l_decap_8
XFILLER_12_636 VPWR VGND sg13cmos5l_decap_8
X_100_ _100_/Q Tile_X0Y0_FrameData[6] VGND VPWR Tile_X1Y0_FrameStrobe[0] latch
XANTENNA__230__X Tile_X1Y0_S4BEG[3] VPWR VGND sg13cmos5l_antennanp
XFILLER_15_441 VPWR VGND sg13cmos5l_decap_8
X_229_ Tile_X1Y0_S4BEG[2] Tile_X1Y0_N4END[13] VPWR VGND sg13cmos5l_buf_1
XFILLER_8_77 VPWR VGND sg13cmos5l_decap_8
XFILLER_7_673 VPWR VGND sg13cmos5l_decap_8
XFILLER_6_161 VPWR VGND sg13cmos5l_decap_8
XANTENNA__315__X Tile_X1Y0_FrameData_O[11] VPWR VGND sg13cmos5l_antennanp
XFILLER_5_1112 VPWR VGND sg13cmos5l_fill_2
XFILLER_12_433 VPWR VGND sg13cmos5l_decap_8
XFILLER_16_227 VPWR VGND sg13cmos5l_decap_8
XFILLER_9_905 VPWR VGND sg13cmos5l_decap_8
XANTENNA__225__X Tile_X1Y0_S2BEGb[6] VPWR VGND sg13cmos5l_antennanp
XFILLER_8_448 VPWR VGND sg13cmos5l_decap_8
XFILLER_4_621 VPWR VGND sg13cmos5l_fill_2
XFILLER_12_7 VPWR VGND sg13cmos5l_decap_8
XFILLER_16_772 VPWR VGND sg13cmos5l_decap_8
XFILLER_7_470 VPWR VGND sg13cmos5l_decap_8
XFILLER_0_1031 VPWR VGND sg13cmos5l_decap_8
XFILLER_10_937 VPWR VGND sg13cmos5l_decap_8
XFILLER_16_1039 VPWR VGND sg13cmos5l_decap_8
XFILLER_1_679 VPWR VGND sg13cmos5l_fill_1
XFILLER_1_668 VPWR VGND sg13cmos5l_decap_8
XFILLER_1_657 VPWR VGND sg13cmos5l_fill_1
XFILLER_1_624 VPWR VGND sg13cmos5l_fill_2
XFILLER_1_613 VPWR VGND sg13cmos5l_fill_2
XFILLER_12_252 VPWR VGND sg13cmos5l_decap_8
XFILLER_13_742 VPWR VGND sg13cmos5l_decap_8
XFILLER_9_702 VPWR VGND sg13cmos5l_decap_8
XFILLER_8_212 VPWR VGND sg13cmos5l_decap_8
XFILLER_9_779 VPWR VGND sg13cmos5l_decap_8
XFILLER_8_289 VPWR VGND sg13cmos5l_decap_8
XFILLER_5_930 VPWR VGND sg13cmos5l_decap_8
XFILLER_5_56 VPWR VGND sg13cmos5l_decap_8
XFILLER_0_690 VPWR VGND sg13cmos5l_decap_4
XFILLER_15_1050 VPWR VGND sg13cmos5l_decap_8
XANTENNA_107 Tile_X0Y0_FrameData[29] VPWR VGND sg13cmos5l_antennanp
XANTENNA_118 Tile_X0Y0_FrameData[29] VPWR VGND sg13cmos5l_antennanp
XANTENNA_129 Tile_X0Y0_FrameData[3] VPWR VGND sg13cmos5l_antennanp
XFILLER_10_745 VPWR VGND sg13cmos5l_decap_8
XFILLER_14_21 VPWR VGND sg13cmos5l_decap_8
XFILLER_14_506 VPWR VGND sg13cmos5l_decap_8
XFILLER_14_98 VPWR VGND sg13cmos5l_decap_8
XFILLER_13_561 VPWR VGND sg13cmos5l_decap_8
XFILLER_9_565 VPWR VGND sg13cmos5l_decap_8
XANTENNA__323__X Tile_X1Y0_FrameData_O[19] VPWR VGND sg13cmos5l_antennanp
XFILLER_15_826 VPWR VGND sg13cmos5l_decap_4
X_400_ _400_/X Tile_X0Y0_N1END[1] Tile_X0Y0_N2MID[1] Tile_X0Y0_N2MID[6] Tile_X0Y0_N2END[6]
+ _042_/Q _041_/Q VPWR VGND sg13cmos5l_mux4_1
X_331_ Tile_X1Y0_FrameData_O[27] Tile_X0Y0_FrameData[27] VPWR VGND sg13cmos5l_buf_1
XFILLER_10_575 VPWR VGND sg13cmos5l_decap_8
X_193_ Tile_X1Y0_FrameStrobe_O[14] Tile_X1Y0_FrameStrobe[14] VPWR VGND sg13cmos5l_buf_1
X_262_ Tile_X0Y0_S2BEGb[2] Tile_X0Y0_N2END[5] VPWR VGND sg13cmos5l_buf_1
XFILLER_6_535 VPWR VGND sg13cmos5l_decap_8
XANTENNA__233__X Tile_X1Y0_S4BEG[6] VPWR VGND sg13cmos5l_antennanp
XFILLER_2_730 VPWR VGND sg13cmos5l_decap_8
XFILLER_2_35 VPWR VGND sg13cmos5l_decap_8
XFILLER_1_295 VPWR VGND sg13cmos5l_fill_1
XFILLER_1_284 VPWR VGND sg13cmos5l_decap_8
XANTENNA_18 Tile_X0Y0_FrameData[11] VPWR VGND sg13cmos5l_antennanp
XANTENNA_29 Tile_X0Y0_FrameData[12] VPWR VGND sg13cmos5l_antennanp
XFILLER_12_1053 VPWR VGND sg13cmos5l_decap_8
XFILLER_9_340 VPWR VGND sg13cmos5l_decap_8
XANTENNA__318__X Tile_X1Y0_FrameData_O[14] VPWR VGND sg13cmos5l_antennanp
XFILLER_11_77 VPWR VGND sg13cmos5l_decap_8
XFILLER_3_549 VPWR VGND sg13cmos5l_decap_8
XANTENNA__228__X Tile_X1Y0_S4BEG[1] VPWR VGND sg13cmos5l_antennanp
XFILLER_14_133 VPWR VGND sg13cmos5l_decap_8
XFILLER_15_623 VPWR VGND sg13cmos5l_decap_8
X_314_ Tile_X1Y0_FrameData_O[10] Tile_X0Y0_FrameData[10] VPWR VGND sg13cmos5l_buf_1
XFILLER_10_350 VPWR VGND sg13cmos5l_decap_8
XFILLER_11_851 VPWR VGND sg13cmos5l_decap_8
X_176_ _176_/L_HI VPWR VGND sg13cmos5l_tiehi
X_245_ Tile_X1Y0_SS4BEG[2] Tile_X1Y0_NN4END[13] VPWR VGND sg13cmos5l_buf_1
XFILLER_6_321 VPWR VGND sg13cmos5l_fill_1
XFILLER_2_571 VPWR VGND sg13cmos5l_decap_8
XANTENNA_290 Tile_X0Y0_NN4END[6] VPWR VGND sg13cmos5l_antennanp
XFILLER_12_615 VPWR VGND sg13cmos5l_decap_8
XFILLER_16_409 VPWR VGND sg13cmos5l_decap_8
XFILLER_11_147 VPWR VGND sg13cmos5l_decap_8
XFILLER_4_803 VPWR VGND sg13cmos5l_decap_8
XFILLER_4_869 VPWR VGND sg13cmos5l_decap_8
XFILLER_15_420 VPWR VGND sg13cmos5l_decap_8
XFILLER_15_497 VPWR VGND sg13cmos5l_decap_8
XFILLER_8_56 VPWR VGND sg13cmos5l_decap_8
XFILLER_16_954 VPWR VGND sg13cmos5l_decap_8
XFILLER_11_692 VPWR VGND sg13cmos5l_decap_8
X_159_ _159_/L_HI VPWR VGND sg13cmos5l_tiehi
X_228_ Tile_X1Y0_S4BEG[1] Tile_X1Y0_N4END[14] VPWR VGND sg13cmos5l_buf_1
XFILLER_7_652 VPWR VGND sg13cmos5l_decap_8
XFILLER_6_140 VPWR VGND sg13cmos5l_decap_8
XANTENNA__331__X Tile_X1Y0_FrameData_O[27] VPWR VGND sg13cmos5l_antennanp
XFILLER_16_206 VPWR VGND sg13cmos5l_decap_4
XFILLER_12_401 VPWR VGND sg13cmos5l_fill_1
XFILLER_12_412 VPWR VGND sg13cmos5l_decap_8
XFILLER_13_913 VPWR VGND sg13cmos5l_decap_4
XFILLER_12_489 VPWR VGND sg13cmos5l_decap_8
XFILLER_4_666 VPWR VGND sg13cmos5l_decap_8
XFILLER_3_154 VPWR VGND sg13cmos5l_fill_2
XANTENNA__241__X Tile_X1Y0_S4BEG[14] VPWR VGND sg13cmos5l_antennanp
XFILLER_16_751 VPWR VGND sg13cmos5l_decap_8
XFILLER_12_990 VPWR VGND sg13cmos5l_decap_8
XFILLER_15_294 VPWR VGND sg13cmos5l_decap_8
XANTENNA__326__X Tile_X1Y0_FrameData_O[22] VPWR VGND sg13cmos5l_antennanp
XFILLER_0_1087 VPWR VGND sg13cmos5l_decap_8
XFILLER_0_90 VPWR VGND sg13cmos5l_decap_8
XFILLER_10_916 VPWR VGND sg13cmos5l_decap_8
XANTENNA__236__X Tile_X1Y0_S4BEG[9] VPWR VGND sg13cmos5l_antennanp
XFILLER_12_231 VPWR VGND sg13cmos5l_decap_8
XFILLER_9_758 VPWR VGND sg13cmos5l_decap_8
XFILLER_8_268 VPWR VGND sg13cmos5l_decap_8
XFILLER_5_35 VPWR VGND sg13cmos5l_decap_8
XFILLER_8_791 VPWR VGND sg13cmos5l_decap_8
XANTENNA_108 Tile_X0Y0_FrameData[29] VPWR VGND sg13cmos5l_antennanp
XANTENNA_119 Tile_X0Y0_FrameData[2] VPWR VGND sg13cmos5l_antennanp
XFILLER_10_724 VPWR VGND sg13cmos5l_decap_8
XFILLER_14_77 VPWR VGND sg13cmos5l_decap_8
XFILLER_6_739 VPWR VGND sg13cmos5l_decap_8
XFILLER_2_923 VPWR VGND sg13cmos5l_fill_2
XFILLER_7_1049 VPWR VGND sg13cmos5l_decap_4
XFILLER_2_989 VPWR VGND sg13cmos5l_decap_8
XFILLER_2_978 VPWR VGND sg13cmos5l_fill_1
XFILLER_13_540 VPWR VGND sg13cmos5l_decap_8
XFILLER_9_544 VPWR VGND sg13cmos5l_decap_8
XFILLER_2_219 VPWR VGND sg13cmos5l_decap_8
XFILLER_14_315 VPWR VGND sg13cmos5l_decap_8
XFILLER_14_326 VPWR VGND sg13cmos5l_fill_1
XFILLER_15_805 VPWR VGND sg13cmos5l_decap_8
X_330_ Tile_X1Y0_FrameData_O[26] Tile_X0Y0_FrameData[26] VPWR VGND sg13cmos5l_buf_1
XFILLER_10_554 VPWR VGND sg13cmos5l_decap_8
X_192_ Tile_X1Y0_FrameStrobe_O[13] Tile_X1Y0_FrameStrobe[13] VPWR VGND sg13cmos5l_buf_1
X_261_ Tile_X0Y0_S2BEGb[1] Tile_X0Y0_N2END[6] VPWR VGND sg13cmos5l_buf_1
XFILLER_6_514 VPWR VGND sg13cmos5l_decap_8
XFILLER_9_0 VPWR VGND sg13cmos5l_decap_8
XFILLER_2_775 VPWR VGND sg13cmos5l_decap_8
XFILLER_2_14 VPWR VGND sg13cmos5l_decap_8
XFILLER_1_263 VPWR VGND sg13cmos5l_decap_8
XANTENNA_19 Tile_X0Y0_FrameData[11] VPWR VGND sg13cmos5l_antennanp
XFILLER_12_1032 VPWR VGND sg13cmos5l_decap_8
XFILLER_12_819 VPWR VGND sg13cmos5l_decap_8
XANTENNA__334__X Tile_X1Y0_FrameData_O[30] VPWR VGND sg13cmos5l_antennanp
XFILLER_11_329 VPWR VGND sg13cmos5l_decap_8
XFILLER_11_56 VPWR VGND sg13cmos5l_decap_8
XFILLER_3_528 VPWR VGND sg13cmos5l_decap_8
XFILLER_2_7 VPWR VGND sg13cmos5l_decap_8
XFILLER_15_602 VPWR VGND sg13cmos5l_decap_8
XFILLER_14_112 VPWR VGND sg13cmos5l_decap_8
XFILLER_14_189 VPWR VGND sg13cmos5l_decap_8
X_244_ Tile_X1Y0_SS4BEG[1] Tile_X1Y0_NN4END[14] VPWR VGND sg13cmos5l_buf_1
X_313_ Tile_X1Y0_FrameData_O[9] Tile_X0Y0_FrameData[9] VPWR VGND sg13cmos5l_buf_1
XANTENNA__244__X Tile_X1Y0_SS4BEG[1] VPWR VGND sg13cmos5l_antennanp
XFILLER_11_896 VPWR VGND sg13cmos5l_decap_8
X_175_ _175_/L_HI VPWR VGND sg13cmos5l_tiehi
XFILLER_2_550 VPWR VGND sg13cmos5l_decap_8
XANTENNA_280 Tile_X0Y0_FrameData[30] VPWR VGND sg13cmos5l_antennanp
XANTENNA_291 Tile_X0Y0_NN4END[6] VPWR VGND sg13cmos5l_antennanp
XFILLER_9_193 VPWR VGND sg13cmos5l_decap_8
XANTENNA__329__X Tile_X1Y0_FrameData_O[25] VPWR VGND sg13cmos5l_antennanp
XFILLER_11_126 VPWR VGND sg13cmos5l_decap_8
XFILLER_8_609 VPWR VGND sg13cmos5l_decap_8
XFILLER_3_1074 VPWR VGND sg13cmos5l_decap_8
XFILLER_7_119 VPWR VGND sg13cmos5l_decap_8
XFILLER_4_815 VPWR VGND sg13cmos5l_fill_1
XANTENNA__239__X Tile_X1Y0_S4BEG[12] VPWR VGND sg13cmos5l_antennanp
XFILLER_16_933 VPWR VGND sg13cmos5l_decap_8
XFILLER_11_671 VPWR VGND sg13cmos5l_decap_8
XFILLER_15_476 VPWR VGND sg13cmos5l_decap_8
X_227_ Tile_X1Y0_S4BEG[0] Tile_X1Y0_N4END[15] VPWR VGND sg13cmos5l_buf_1
XFILLER_8_35 VPWR VGND sg13cmos5l_decap_8
XFILLER_7_631 VPWR VGND sg13cmos5l_decap_8
XFILLER_16_988 VPWR VGND sg13cmos5l_decap_8
X_089_ _089_/Q Tile_X0Y0_FrameData[17] VGND VPWR Tile_X1Y0_FrameStrobe[0] latch
X_158_ _158_/L_HI VPWR VGND sg13cmos5l_tiehi
XFILLER_6_196 VPWR VGND sg13cmos5l_decap_8
XFILLER_1_818 VPWR VGND sg13cmos5l_fill_1
XFILLER_1_807 VPWR VGND sg13cmos5l_fill_1
XFILLER_12_468 VPWR VGND sg13cmos5l_decap_8
XFILLER_4_645 VPWR VGND sg13cmos5l_decap_8
XFILLER_4_623 VPWR VGND sg13cmos5l_fill_1
XFILLER_3_133 VPWR VGND sg13cmos5l_decap_8
XFILLER_0_884 VPWR VGND sg13cmos5l_decap_8
XFILLER_15_273 VPWR VGND sg13cmos5l_decap_8
XFILLER_8_995 VPWR VGND sg13cmos5l_decap_4
XFILLER_0_1066 VPWR VGND sg13cmos5l_decap_8
XANTENNA__342__X Tile_X0Y0_FrameStrobe_O[6] VPWR VGND sg13cmos5l_antennanp
XFILLER_1_626 VPWR VGND sg13cmos5l_fill_1
XFILLER_1_615 VPWR VGND sg13cmos5l_fill_1
XFILLER_0_125 VPWR VGND sg13cmos5l_decap_4
XFILLER_0_169 VPWR VGND sg13cmos5l_decap_8
XFILLER_9_1080 VPWR VGND sg13cmos5l_decap_8
XFILLER_1_648 VPWR VGND sg13cmos5l_decap_8
XFILLER_12_210 VPWR VGND sg13cmos5l_decap_8
XANTENNA__252__X Tile_X1Y0_SS4BEG[9] VPWR VGND sg13cmos5l_antennanp
XFILLER_12_287 VPWR VGND sg13cmos5l_decap_8
XFILLER_9_737 VPWR VGND sg13cmos5l_decap_8
XFILLER_8_247 VPWR VGND sg13cmos5l_decap_8
XFILLER_5_14 VPWR VGND sg13cmos5l_decap_8
XFILLER_4_497 VPWR VGND sg13cmos5l_decap_8
XFILLER_16_593 VPWR VGND sg13cmos5l_decap_4
XFILLER_15_1085 VPWR VGND sg13cmos5l_decap_8
XFILLER_8_770 VPWR VGND sg13cmos5l_decap_8
XFILLER_7_280 VPWR VGND sg13cmos5l_decap_8
XANTENNA_109 Tile_X0Y0_FrameData[29] VPWR VGND sg13cmos5l_antennanp
XANTENNA__337__X Tile_X0Y0_FrameStrobe_O[1] VPWR VGND sg13cmos5l_antennanp
XFILLER_10_703 VPWR VGND sg13cmos5l_decap_8
XFILLER_14_56 VPWR VGND sg13cmos5l_decap_8
XFILLER_6_718 VPWR VGND sg13cmos5l_decap_8
XFILLER_7_1028 VPWR VGND sg13cmos5l_decap_8
XANTENNA__247__X Tile_X1Y0_SS4BEG[4] VPWR VGND sg13cmos5l_antennanp
XFILLER_9_523 VPWR VGND sg13cmos5l_decap_8
XFILLER_13_596 VPWR VGND sg13cmos5l_decap_8
XFILLER_4_294 VPWR VGND sg13cmos5l_decap_4
XFILLER_6_1072 VPWR VGND sg13cmos5l_decap_8
X_260_ Tile_X0Y0_S2BEGb[0] Tile_X0Y0_N2END[7] VPWR VGND sg13cmos5l_buf_1
XFILLER_10_533 VPWR VGND sg13cmos5l_decap_8
X_191_ Tile_X1Y0_FrameStrobe_O[12] Tile_X1Y0_FrameStrobe[12] VPWR VGND sg13cmos5l_buf_1
XFILLER_2_754 VPWR VGND sg13cmos5l_decap_8
XFILLER_12_1011 VPWR VGND sg13cmos5l_decap_8
XFILLER_13_382 VPWR VGND sg13cmos5l_decap_8
XFILLER_14_883 VPWR VGND sg13cmos5l_fill_2
X_389_ _389_/X Tile_X1Y0_N4END[9] Tile_X1Y0_N4END[10] Tile_X1Y0_NN4END[9] Tile_X1Y0_NN4END[11]
+ _094_/Q _093_/Q VPWR VGND sg13cmos5l_mux4_1
XFILLER_9_375 VPWR VGND sg13cmos5l_decap_8
XFILLER_12_1088 VPWR VGND sg13cmos5l_decap_8
XFILLER_5_581 VPWR VGND sg13cmos5l_decap_8
XFILLER_11_308 VPWR VGND sg13cmos5l_decap_8
XFILLER_11_35 VPWR VGND sg13cmos5l_decap_8
XFILLER_3_507 VPWR VGND sg13cmos5l_decap_8
XANTENNA__350__X Tile_X0Y0_FrameStrobe_O[14] VPWR VGND sg13cmos5l_antennanp
XFILLER_8_1112 VPWR VGND sg13cmos5l_fill_2
XFILLER_11_875 VPWR VGND sg13cmos5l_fill_2
XFILLER_14_168 VPWR VGND sg13cmos5l_decap_8
XFILLER_15_658 VPWR VGND sg13cmos5l_decap_8
XFILLER_15_669 VPWR VGND sg13cmos5l_fill_1
X_243_ Tile_X1Y0_SS4BEG[0] Tile_X1Y0_NN4END[15] VPWR VGND sg13cmos5l_buf_1
X_312_ Tile_X1Y0_FrameData_O[8] Tile_X0Y0_FrameData[8] VPWR VGND sg13cmos5l_buf_1
XFILLER_7_824 VPWR VGND sg13cmos5l_fill_2
XFILLER_7_813 VPWR VGND sg13cmos5l_decap_8
XANTENNA__260__X Tile_X0Y0_S2BEGb[0] VPWR VGND sg13cmos5l_antennanp
XFILLER_10_396 VPWR VGND sg13cmos5l_fill_1
X_174_ _174_/L_HI VPWR VGND sg13cmos5l_tiehi
XFILLER_6_312 VPWR VGND sg13cmos5l_decap_8
XANTENNA_270 Tile_X0Y0_FrameData[28] VPWR VGND sg13cmos5l_antennanp
XANTENNA_281 Tile_X0Y0_FrameData[30] VPWR VGND sg13cmos5l_antennanp
XANTENNA_292 Tile_X1Y0_FrameStrobe[11] VPWR VGND sg13cmos5l_antennanp
XFILLER_9_172 VPWR VGND sg13cmos5l_decap_8
XFILLER_3_91 VPWR VGND sg13cmos5l_decap_8
XFILLER_3_1053 VPWR VGND sg13cmos5l_decap_8
XANTENNA__345__X Tile_X0Y0_FrameStrobe_O[9] VPWR VGND sg13cmos5l_antennanp
XFILLER_11_105 VPWR VGND sg13cmos5l_decap_8
XFILLER_15_455 VPWR VGND sg13cmos5l_decap_8
XFILLER_16_967 VPWR VGND sg13cmos5l_decap_8
XFILLER_16_912 VPWR VGND sg13cmos5l_decap_8
XANTENNA__255__X Tile_X1Y0_SS4BEG[12] VPWR VGND sg13cmos5l_antennanp
XFILLER_10_182 VPWR VGND sg13cmos5l_decap_8
XFILLER_11_650 VPWR VGND sg13cmos5l_decap_8
X_157_ _157_/L_HI VPWR VGND sg13cmos5l_tiehi
X_226_ Tile_X1Y0_S2BEGb[7] Tile_X1Y0_N2END[0] VPWR VGND sg13cmos5l_buf_1
XFILLER_8_14 VPWR VGND sg13cmos5l_decap_8
XFILLER_7_610 VPWR VGND sg13cmos5l_decap_8
X_088_ _088_/Q Tile_X0Y0_FrameData[18] VGND VPWR Tile_X1Y0_FrameStrobe[0] latch
XFILLER_7_687 VPWR VGND sg13cmos5l_decap_8
XFILLER_6_175 VPWR VGND sg13cmos5l_decap_8
XFILLER_2_381 VPWR VGND sg13cmos5l_fill_2
XFILLER_12_447 VPWR VGND sg13cmos5l_decap_8
XFILLER_9_919 VPWR VGND sg13cmos5l_decap_8
XFILLER_4_602 VPWR VGND sg13cmos5l_decap_4
XFILLER_3_156 VPWR VGND sg13cmos5l_fill_1
XFILLER_3_112 VPWR VGND sg13cmos5l_decap_8
XFILLER_0_863 VPWR VGND sg13cmos5l_decap_8
XFILLER_15_252 VPWR VGND sg13cmos5l_decap_8
XFILLER_16_786 VPWR VGND sg13cmos5l_decap_8
X_209_ Tile_X1Y0_S1BEG[2] Tile_X1Y0_N1END[1] VPWR VGND sg13cmos5l_buf_1
XFILLER_7_484 VPWR VGND sg13cmos5l_decap_8
XFILLER_0_1023 VPWR VGND sg13cmos5l_decap_4
XFILLER_0_1045 VPWR VGND sg13cmos5l_decap_8
XFILLER_16_1009 VPWR VGND sg13cmos5l_fill_2
XFILLER_0_104 VPWR VGND sg13cmos5l_decap_8
XFILLER_0_148 VPWR VGND sg13cmos5l_decap_8
XFILLER_13_756 VPWR VGND sg13cmos5l_decap_8
XFILLER_9_716 VPWR VGND sg13cmos5l_decap_8
XFILLER_12_266 VPWR VGND sg13cmos5l_decap_8
XFILLER_8_226 VPWR VGND sg13cmos5l_decap_8
XFILLER_5_988 VPWR VGND sg13cmos5l_decap_8
XFILLER_5_977 VPWR VGND sg13cmos5l_decap_8
XFILLER_10_7 VPWR VGND sg13cmos5l_decap_8
XFILLER_15_1064 VPWR VGND sg13cmos5l_decap_8
XFILLER_16_572 VPWR VGND sg13cmos5l_decap_8
XFILLER_14_35 VPWR VGND sg13cmos5l_decap_8
XANTENNA__353__X Tile_X0Y0_FrameStrobe_O[17] VPWR VGND sg13cmos5l_antennanp
XFILLER_10_759 VPWR VGND sg13cmos5l_decap_8
XFILLER_7_1007 VPWR VGND sg13cmos5l_decap_8
XFILLER_2_925 VPWR VGND sg13cmos5l_fill_1
XANTENNA__263__X Tile_X0Y0_S2BEGb[3] VPWR VGND sg13cmos5l_antennanp
XFILLER_13_575 VPWR VGND sg13cmos5l_decap_8
XFILLER_9_502 VPWR VGND sg13cmos5l_decap_8
XFILLER_9_579 VPWR VGND sg13cmos5l_fill_2
XFILLER_5_763 VPWR VGND sg13cmos5l_decap_8
XFILLER_4_273 VPWR VGND sg13cmos5l_decap_8
XFILLER_1_980 VPWR VGND sg13cmos5l_fill_1
XANTENNA__122__Q NPU_QUANT_SHIFT_IN7 VPWR VGND sg13cmos5l_antennanp
XFILLER_6_91 VPWR VGND sg13cmos5l_decap_8
XANTENNA__348__X Tile_X0Y0_FrameStrobe_O[12] VPWR VGND sg13cmos5l_antennanp
XFILLER_6_1051 VPWR VGND sg13cmos5l_decap_8
XFILLER_10_512 VPWR VGND sg13cmos5l_decap_8
X_190_ Tile_X1Y0_FrameStrobe_O[11] Tile_X1Y0_FrameStrobe[11] VPWR VGND sg13cmos5l_buf_1
XFILLER_10_589 VPWR VGND sg13cmos5l_decap_8
XFILLER_6_549 VPWR VGND sg13cmos5l_decap_8
XFILLER_2_700 VPWR VGND sg13cmos5l_fill_2
XFILLER_2_744 VPWR VGND sg13cmos5l_decap_8
XFILLER_2_49 VPWR VGND sg13cmos5l_decap_8
XFILLER_1_232 VPWR VGND sg13cmos5l_decap_8
XANTENNA__258__X Tile_X1Y0_SS4BEG[15] VPWR VGND sg13cmos5l_antennanp
XFILLER_14_840 VPWR VGND sg13cmos5l_decap_8
XFILLER_13_350 VPWR VGND sg13cmos5l_decap_4
X_388_ _388_/X Tile_X1Y0_N4END[8] Tile_X1Y0_N4END[9] Tile_X1Y0_NN4END[8] Tile_X1Y0_NN4END[10]
+ _096_/Q _095_/Q VPWR VGND sg13cmos5l_mux4_1
XFILLER_9_354 VPWR VGND sg13cmos5l_decap_8
XFILLER_12_1067 VPWR VGND sg13cmos5l_decap_8
XFILLER_5_560 VPWR VGND sg13cmos5l_decap_8
XANTENNA__117__Q NPU_QUANT_SHIFT_IN2 VPWR VGND sg13cmos5l_antennanp
XFILLER_11_14 VPWR VGND sg13cmos5l_decap_8
XFILLER_15_637 VPWR VGND sg13cmos5l_decap_8
XFILLER_10_364 VPWR VGND sg13cmos5l_fill_1
XFILLER_11_832 VPWR VGND sg13cmos5l_decap_8
XFILLER_11_865 VPWR VGND sg13cmos5l_decap_4
XFILLER_11_887 VPWR VGND sg13cmos5l_fill_1
XFILLER_14_147 VPWR VGND sg13cmos5l_decap_8
X_173_ _173_/L_HI VPWR VGND sg13cmos5l_tiehi
X_242_ Tile_X1Y0_S4BEG[15] Tile_X1Y0_N4END[0] VPWR VGND sg13cmos5l_buf_1
X_311_ Tile_X1Y0_FrameData_O[7] Tile_X0Y0_FrameData[7] VPWR VGND sg13cmos5l_buf_1
XFILLER_2_585 VPWR VGND sg13cmos5l_decap_8
XANTENNA_260 Tile_X0Y0_FrameData[31] VPWR VGND sg13cmos5l_antennanp
XANTENNA_271 Tile_X0Y0_FrameData[28] VPWR VGND sg13cmos5l_antennanp
XANTENNA_282 Tile_X0Y0_FrameData[30] VPWR VGND sg13cmos5l_antennanp
XANTENNA_293 Tile_X1Y0_FrameStrobe[15] VPWR VGND sg13cmos5l_antennanp
XFILLER_14_692 VPWR VGND sg13cmos5l_decap_4
XFILLER_9_151 VPWR VGND sg13cmos5l_decap_8
XFILLER_3_70 VPWR VGND sg13cmos5l_decap_8
XFILLER_3_1032 VPWR VGND sg13cmos5l_decap_8
XFILLER_12_629 VPWR VGND sg13cmos5l_decap_8
XANTENNA__361__X Tile_X1Y0_FrameStrobe_O[5] VPWR VGND sg13cmos5l_antennanp
XFILLER_3_305 VPWR VGND sg13cmos5l_decap_4
XFILLER_15_434 VPWR VGND sg13cmos5l_decap_8
XANTENNA__271__X Tile_X0Y0_S4BEG[3] VPWR VGND sg13cmos5l_antennanp
XFILLER_10_161 VPWR VGND sg13cmos5l_decap_8
X_087_ _087_/Q Tile_X0Y0_FrameData[19] VGND VPWR Tile_X1Y0_FrameStrobe[0] latch
X_156_ _156_/L_HI VPWR VGND sg13cmos5l_tiehi
X_225_ Tile_X1Y0_S2BEGb[6] Tile_X1Y0_N2END[1] VPWR VGND sg13cmos5l_buf_1
XFILLER_7_666 VPWR VGND sg13cmos5l_decap_8
XFILLER_6_154 VPWR VGND sg13cmos5l_decap_8
XFILLER_3_894 VPWR VGND sg13cmos5l_decap_4
XFILLER_15_990 VPWR VGND sg13cmos5l_decap_8
XANTENNA__130__Q NPU_QUANT_SHIFT_IN15 VPWR VGND sg13cmos5l_antennanp
XANTENNA__356__X Tile_X1Y0_FrameStrobe_O[0] VPWR VGND sg13cmos5l_antennanp
XFILLER_12_426 VPWR VGND sg13cmos5l_decap_8
XFILLER_4_614 VPWR VGND sg13cmos5l_decap_8
XFILLER_0_842 VPWR VGND sg13cmos5l_decap_8
XFILLER_16_721 VPWR VGND sg13cmos5l_decap_4
XANTENNA__266__X Tile_X0Y0_S2BEGb[6] VPWR VGND sg13cmos5l_antennanp
XFILLER_15_231 VPWR VGND sg13cmos5l_decap_8
XFILLER_16_765 VPWR VGND sg13cmos5l_decap_8
X_139_ NPU_QUANT_SHIFT_IN24 Tile_X0Y0_UserCLK _389_/X _166_/L_HI VPWR VGND sg13cmos5l_dfrbpq_1
X_208_ Tile_X1Y0_S1BEG[1] Tile_X1Y0_N1END[2] VPWR VGND sg13cmos5l_buf_1
XFILLER_7_463 VPWR VGND sg13cmos5l_decap_8
XANTENNA__125__Q NPU_QUANT_SHIFT_IN10 VPWR VGND sg13cmos5l_antennanp
XFILLER_9_91 VPWR VGND sg13cmos5l_decap_8
XFILLER_1_606 VPWR VGND sg13cmos5l_decap_8
XFILLER_12_245 VPWR VGND sg13cmos5l_decap_8
XFILLER_13_735 VPWR VGND sg13cmos5l_decap_8
XFILLER_8_205 VPWR VGND sg13cmos5l_decap_8
XFILLER_5_923 VPWR VGND sg13cmos5l_decap_8
XFILLER_5_49 VPWR VGND sg13cmos5l_decap_8
XFILLER_0_661 VPWR VGND sg13cmos5l_fill_1
XFILLER_0_683 VPWR VGND sg13cmos5l_decap_8
XFILLER_0_694 VPWR VGND sg13cmos5l_fill_1
XFILLER_16_551 VPWR VGND sg13cmos5l_decap_8
XFILLER_15_1043 VPWR VGND sg13cmos5l_decap_8
XFILLER_14_14 VPWR VGND sg13cmos5l_decap_8
XFILLER_10_738 VPWR VGND sg13cmos5l_decap_8
XFILLER_13_554 VPWR VGND sg13cmos5l_decap_8
XFILLER_9_558 VPWR VGND sg13cmos5l_decap_8
XFILLER_5_797 VPWR VGND sg13cmos5l_decap_8
XFILLER_5_742 VPWR VGND sg13cmos5l_decap_8
XFILLER_4_252 VPWR VGND sg13cmos5l_decap_8
XFILLER_16_381 VPWR VGND sg13cmos5l_decap_8
XFILLER_6_70 VPWR VGND sg13cmos5l_decap_8
XFILLER_6_1030 VPWR VGND sg13cmos5l_decap_8
XFILLER_15_819 VPWR VGND sg13cmos5l_decap_8
XANTENNA__364__X Tile_X1Y0_FrameStrobe_O[8] VPWR VGND sg13cmos5l_antennanp
XFILLER_10_568 VPWR VGND sg13cmos5l_decap_8
XFILLER_6_528 VPWR VGND sg13cmos5l_decap_8
XFILLER_2_723 VPWR VGND sg13cmos5l_decap_8
XFILLER_1_222 VPWR VGND sg13cmos5l_fill_2
XFILLER_1_211 VPWR VGND sg13cmos5l_fill_1
XFILLER_2_789 VPWR VGND sg13cmos5l_decap_8
XFILLER_2_28 VPWR VGND sg13cmos5l_decap_8
XFILLER_1_299 VPWR VGND sg13cmos5l_fill_2
XFILLER_1_277 VPWR VGND sg13cmos5l_decap_8
XANTENNA__274__X Tile_X0Y0_S4BEG[6] VPWR VGND sg13cmos5l_antennanp
XFILLER_14_852 VPWR VGND sg13cmos5l_fill_1
XFILLER_12_1046 VPWR VGND sg13cmos5l_decap_8
X_387_ _387_/X Tile_X1Y0_N4END[4] Tile_X1Y0_N4END[7] Tile_X1Y0_NN4END[5] Tile_X1Y0_NN4END[7]
+ _098_/Q _097_/Q VPWR VGND sg13cmos5l_mux4_1
XFILLER_9_333 VPWR VGND sg13cmos5l_decap_8
XANTENNA__133__Q NPU_QUANT_SHIFT_IN18 VPWR VGND sg13cmos5l_antennanp
XANTENNA__359__X Tile_X1Y0_FrameStrobe_O[3] VPWR VGND sg13cmos5l_antennanp
XFILLER_14_126 VPWR VGND sg13cmos5l_decap_8
XFILLER_15_616 VPWR VGND sg13cmos5l_decap_8
X_310_ Tile_X1Y0_FrameData_O[6] Tile_X0Y0_FrameData[6] VPWR VGND sg13cmos5l_buf_1
XFILLER_10_343 VPWR VGND sg13cmos5l_decap_8
XFILLER_11_811 VPWR VGND sg13cmos5l_decap_8
XFILLER_11_844 VPWR VGND sg13cmos5l_decap_8
X_172_ _172_/L_HI VPWR VGND sg13cmos5l_tiehi
X_241_ Tile_X1Y0_S4BEG[14] Tile_X1Y0_N4END[1] VPWR VGND sg13cmos5l_buf_1
XFILLER_11_1090 VPWR VGND sg13cmos5l_decap_8
XFILLER_7_0 VPWR VGND sg13cmos5l_decap_8
XFILLER_2_564 VPWR VGND sg13cmos5l_decap_8
XANTENNA__269__X Tile_X0Y0_S4BEG[1] VPWR VGND sg13cmos5l_antennanp
XANTENNA_250 Tile_X0Y0_FrameData[31] VPWR VGND sg13cmos5l_antennanp
XANTENNA_261 Tile_X0Y0_FrameData[31] VPWR VGND sg13cmos5l_antennanp
XANTENNA_272 Tile_X0Y0_FrameData[28] VPWR VGND sg13cmos5l_antennanp
XANTENNA_283 Tile_X0Y0_NN4END[6] VPWR VGND sg13cmos5l_antennanp
XANTENNA_294 Tile_X1Y0_FrameStrobe[15] VPWR VGND sg13cmos5l_antennanp
XFILLER_9_130 VPWR VGND sg13cmos5l_decap_8
XFILLER_3_1011 VPWR VGND sg13cmos5l_decap_8
XANTENNA__128__Q NPU_QUANT_SHIFT_IN13 VPWR VGND sg13cmos5l_antennanp
XFILLER_12_608 VPWR VGND sg13cmos5l_decap_8
XFILLER_0_7 VPWR VGND sg13cmos5l_decap_8
XFILLER_15_413 VPWR VGND sg13cmos5l_decap_8
X_224_ Tile_X1Y0_S2BEGb[5] Tile_X1Y0_N2END[2] VPWR VGND sg13cmos5l_buf_1
XFILLER_8_49 VPWR VGND sg13cmos5l_decap_8
XFILLER_16_947 VPWR VGND sg13cmos5l_decap_8
XFILLER_10_140 VPWR VGND sg13cmos5l_decap_8
XFILLER_11_685 VPWR VGND sg13cmos5l_decap_8
XFILLER_12_91 VPWR VGND sg13cmos5l_decap_8
X_086_ _086_/Q Tile_X0Y0_FrameData[20] VGND VPWR Tile_X1Y0_FrameStrobe[0] latch
X_155_ _155_/L_HI VPWR VGND sg13cmos5l_tiehi
XFILLER_7_645 VPWR VGND sg13cmos5l_decap_8
XFILLER_6_133 VPWR VGND sg13cmos5l_decap_8
XFILLER_12_405 VPWR VGND sg13cmos5l_decap_8
XFILLER_13_917 VPWR VGND sg13cmos5l_fill_2
XFILLER_4_659 VPWR VGND sg13cmos5l_decap_8
XFILLER_0_821 VPWR VGND sg13cmos5l_decap_4
XFILLER_0_898 VPWR VGND sg13cmos5l_decap_8
XFILLER_3_147 VPWR VGND sg13cmos5l_decap_8
XFILLER_15_210 VPWR VGND sg13cmos5l_decap_8
XFILLER_16_733 VPWR VGND sg13cmos5l_fill_1
XFILLER_16_744 VPWR VGND sg13cmos5l_decap_8
XANTENNA__282__X Tile_X0Y0_S4BEG[14] VPWR VGND sg13cmos5l_antennanp
XFILLER_11_482 VPWR VGND sg13cmos5l_decap_8
XFILLER_12_983 VPWR VGND sg13cmos5l_decap_8
XFILLER_15_287 VPWR VGND sg13cmos5l_decap_8
X_207_ Tile_X1Y0_S1BEG[0] Tile_X1Y0_N1END[3] VPWR VGND sg13cmos5l_buf_1
XFILLER_8_921 VPWR VGND sg13cmos5l_fill_1
X_069_ _069_/Q Tile_X0Y0_FrameData[1] VGND VPWR Tile_X0Y0_FrameStrobe[0] latch
X_138_ NPU_QUANT_SHIFT_IN23 Tile_X0Y0_UserCLK _388_/X _167_/L_HI VPWR VGND sg13cmos5l_dfrbpq_1
XFILLER_0_1003 VPWR VGND sg13cmos5l_fill_1
XFILLER_0_83 VPWR VGND sg13cmos5l_decap_8
XFILLER_10_909 VPWR VGND sg13cmos5l_decap_8
XANTENNA__192__X Tile_X1Y0_FrameStrobe_O[13] VPWR VGND sg13cmos5l_antennanp
XFILLER_9_70 VPWR VGND sg13cmos5l_decap_8
XANTENNA__141__Q NPU_QUANT_SHIFT_IN26 VPWR VGND sg13cmos5l_antennanp
XFILLER_12_224 VPWR VGND sg13cmos5l_decap_8
XFILLER_10_1100 VPWR VGND sg13cmos5l_fill_2
XFILLER_5_28 VPWR VGND sg13cmos5l_decap_8
XANTENNA__277__X Tile_X0Y0_S4BEG[9] VPWR VGND sg13cmos5l_antennanp
XFILLER_12_791 VPWR VGND sg13cmos5l_decap_8
XFILLER_15_1022 VPWR VGND sg13cmos5l_decap_8
XFILLER_15_1099 VPWR VGND sg13cmos5l_decap_8
XFILLER_8_784 VPWR VGND sg13cmos5l_decap_8
XFILLER_7_294 VPWR VGND sg13cmos5l_decap_8
XANTENNA__136__Q NPU_QUANT_SHIFT_IN21 VPWR VGND sg13cmos5l_antennanp
XFILLER_10_717 VPWR VGND sg13cmos5l_decap_8
XFILLER_1_415 VPWR VGND sg13cmos5l_fill_1
XFILLER_13_533 VPWR VGND sg13cmos5l_decap_8
XFILLER_9_537 VPWR VGND sg13cmos5l_decap_8
XFILLER_5_721 VPWR VGND sg13cmos5l_decap_8
XFILLER_16_360 VPWR VGND sg13cmos5l_decap_8
XFILLER_8_581 VPWR VGND sg13cmos5l_decap_8
XFILLER_14_308 VPWR VGND sg13cmos5l_decap_8
XFILLER_10_547 VPWR VGND sg13cmos5l_decap_8
XFILLER_6_507 VPWR VGND sg13cmos5l_decap_8
XFILLER_2_768 VPWR VGND sg13cmos5l_decap_8
XFILLER_1_256 VPWR VGND sg13cmos5l_decap_8
XFILLER_1_245 VPWR VGND sg13cmos5l_fill_1
XFILLER_15_91 VPWR VGND sg13cmos5l_decap_8
X_386_ _386_/X Tile_X1Y0_N4END[6] Tile_X1Y0_N4END[7] Tile_X1Y0_NN4END[4] Tile_X1Y0_NN4END[6]
+ _100_/Q _099_/Q VPWR VGND sg13cmos5l_mux4_1
XFILLER_9_312 VPWR VGND sg13cmos5l_decap_8
XANTENNA__290__X Tile_X0Y0_SS4BEG[6] VPWR VGND sg13cmos5l_antennanp
XFILLER_12_1025 VPWR VGND sg13cmos5l_decap_8
XFILLER_13_396 VPWR VGND sg13cmos5l_decap_8
XFILLER_9_389 VPWR VGND sg13cmos5l_decap_8
XFILLER_5_595 VPWR VGND sg13cmos5l_decap_8
XFILLER_11_49 VPWR VGND sg13cmos5l_decap_8
XFILLER_14_105 VPWR VGND sg13cmos5l_decap_8
X_240_ Tile_X1Y0_S4BEG[13] Tile_X1Y0_N4END[2] VPWR VGND sg13cmos5l_buf_1
XFILLER_10_322 VPWR VGND sg13cmos5l_decap_8
X_171_ _171_/L_HI VPWR VGND sg13cmos5l_tiehi
XFILLER_2_543 VPWR VGND sg13cmos5l_decap_8
XANTENNA_240 Tile_X0Y0_FrameData[31] VPWR VGND sg13cmos5l_antennanp
XANTENNA_251 Tile_X0Y0_FrameData[31] VPWR VGND sg13cmos5l_antennanp
XANTENNA__285__X Tile_X0Y0_SS4BEG[1] VPWR VGND sg13cmos5l_antennanp
XANTENNA_262 Tile_X0Y0_FrameData[31] VPWR VGND sg13cmos5l_antennanp
XANTENNA_273 Tile_X0Y0_FrameData[28] VPWR VGND sg13cmos5l_antennanp
XANTENNA_284 Tile_X0Y0_NN4END[6] VPWR VGND sg13cmos5l_antennanp
XANTENNA_295 Tile_X0Y0_NN4END[1] VPWR VGND sg13cmos5l_antennanp
XFILLER_13_182 VPWR VGND sg13cmos5l_decap_8
X_369_ _369_/X Tile_X0Y0_N4END[4] Tile_X0Y0_N4END[5] Tile_X0Y0_NN4END[4] Tile_X0Y0_NN4END[6]
+ _066_/Q _065_/Q VPWR VGND sg13cmos5l_mux4_1
XFILLER_9_186 VPWR VGND sg13cmos5l_decap_8
XANTENNA__195__X Tile_X1Y0_FrameStrobe_O[16] VPWR VGND sg13cmos5l_antennanp
XFILLER_11_119 VPWR VGND sg13cmos5l_decap_8
XFILLER_3_1067 VPWR VGND sg13cmos5l_decap_8
XANTENNA__144__Q NPU_QUANT_SHIFT_IN29 VPWR VGND sg13cmos5l_antennanp
XFILLER_4_819 VPWR VGND sg13cmos5l_decap_4
XFILLER_16_926 VPWR VGND sg13cmos5l_decap_8
XFILLER_11_664 VPWR VGND sg13cmos5l_decap_8
XFILLER_15_469 VPWR VGND sg13cmos5l_decap_8
X_223_ Tile_X1Y0_S2BEGb[4] Tile_X1Y0_N2END[3] VPWR VGND sg13cmos5l_buf_1
XFILLER_8_28 VPWR VGND sg13cmos5l_decap_8
XFILLER_7_624 VPWR VGND sg13cmos5l_decap_8
XFILLER_10_196 VPWR VGND sg13cmos5l_decap_8
XFILLER_12_70 VPWR VGND sg13cmos5l_decap_8
X_085_ _085_/Q Tile_X0Y0_FrameData[21] VGND VPWR Tile_X1Y0_FrameStrobe[0] latch
X_154_ _154_/L_HI VPWR VGND sg13cmos5l_tiehi
XFILLER_6_189 VPWR VGND sg13cmos5l_decap_8
XFILLER_6_112 VPWR VGND sg13cmos5l_decap_8
XFILLER_6_690 VPWR VGND sg13cmos5l_decap_8
XANTENNA__139__Q NPU_QUANT_SHIFT_IN24 VPWR VGND sg13cmos5l_antennanp
XFILLER_4_638 VPWR VGND sg13cmos5l_decap_8
XFILLER_3_126 VPWR VGND sg13cmos5l_decap_8
XFILLER_0_800 VPWR VGND sg13cmos5l_decap_8
XFILLER_0_877 VPWR VGND sg13cmos5l_decap_8
XFILLER_15_266 VPWR VGND sg13cmos5l_decap_8
XFILLER_16_701 VPWR VGND sg13cmos5l_fill_1
XFILLER_11_450 VPWR VGND sg13cmos5l_fill_1
XFILLER_11_461 VPWR VGND sg13cmos5l_decap_8
X_137_ NPU_QUANT_SHIFT_IN22 Tile_X0Y0_UserCLK _387_/X _152_/L_HI VPWR VGND sg13cmos5l_dfrbpq_1
X_206_ Tile_X0Y0_S2BEG[7] Tile_X0Y0_N2MID[0] VPWR VGND sg13cmos5l_buf_1
XFILLER_8_999 VPWR VGND sg13cmos5l_fill_1
XFILLER_8_988 VPWR VGND sg13cmos5l_decap_8
XFILLER_8_944 VPWR VGND sg13cmos5l_fill_2
X_068_ _068_/Q Tile_X0Y0_FrameData[2] VGND VPWR Tile_X0Y0_FrameStrobe[0] latch
XFILLER_7_498 VPWR VGND sg13cmos5l_decap_8
XFILLER_3_693 VPWR VGND sg13cmos5l_decap_8
XFILLER_0_40 VPWR VGND sg13cmos5l_fill_2
XFILLER_0_62 VPWR VGND sg13cmos5l_decap_8
XFILLER_0_1059 VPWR VGND sg13cmos5l_decap_8
XFILLER_0_118 VPWR VGND sg13cmos5l_decap_8
XFILLER_0_129 VPWR VGND sg13cmos5l_fill_1
XFILLER_9_1073 VPWR VGND sg13cmos5l_decap_8
XFILLER_12_203 VPWR VGND sg13cmos5l_decap_8
XFILLER_10_1112 VPWR VGND sg13cmos5l_fill_2
XFILLER_0_652 VPWR VGND sg13cmos5l_decap_8
XANTENNA__293__X Tile_X0Y0_SS4BEG[9] VPWR VGND sg13cmos5l_antennanp
XFILLER_16_586 VPWR VGND sg13cmos5l_decap_4
XFILLER_16_597 VPWR VGND sg13cmos5l_fill_1
XFILLER_11_280 VPWR VGND sg13cmos5l_decap_8
XFILLER_12_770 VPWR VGND sg13cmos5l_decap_8
XFILLER_15_1078 VPWR VGND sg13cmos5l_decap_8
XFILLER_8_763 VPWR VGND sg13cmos5l_decap_8
XFILLER_7_273 VPWR VGND sg13cmos5l_decap_8
XFILLER_15_0 VPWR VGND sg13cmos5l_decap_8
XFILLER_14_49 VPWR VGND sg13cmos5l_decap_8
XFILLER_13_512 VPWR VGND sg13cmos5l_decap_8
XFILLER_9_516 VPWR VGND sg13cmos5l_decap_8
XFILLER_13_589 VPWR VGND sg13cmos5l_decap_8
XFILLER_5_700 VPWR VGND sg13cmos5l_decap_8
XFILLER_4_298 VPWR VGND sg13cmos5l_fill_2
XFILLER_4_287 VPWR VGND sg13cmos5l_decap_8
XFILLER_1_961 VPWR VGND sg13cmos5l_fill_2
XANTENNA__288__X Tile_X0Y0_SS4BEG[4] VPWR VGND sg13cmos5l_antennanp
XFILLER_8_560 VPWR VGND sg13cmos5l_decap_8
XANTENNA__198__X Tile_X1Y0_FrameStrobe_O[19] VPWR VGND sg13cmos5l_antennanp
XFILLER_6_1065 VPWR VGND sg13cmos5l_decap_8
XANTENNA__147__Q NPU_PSUM_LUT_EN VPWR VGND sg13cmos5l_antennanp
XFILLER_10_526 VPWR VGND sg13cmos5l_decap_8
XFILLER_1_224 VPWR VGND sg13cmos5l_fill_1
XFILLER_15_70 VPWR VGND sg13cmos5l_decap_8
X_385_ _385_/X Tile_X1Y0_N4END[5] Tile_X1Y0_N4END[6] Tile_X1Y0_NN4END[5] Tile_X1Y0_NN4END[7]
+ _102_/Q _101_/Q VPWR VGND sg13cmos5l_mux4_1
XFILLER_9_368 VPWR VGND sg13cmos5l_decap_8
XFILLER_12_1004 VPWR VGND sg13cmos5l_decap_8
XFILLER_5_574 VPWR VGND sg13cmos5l_decap_8
XFILLER_11_28 VPWR VGND sg13cmos5l_decap_8
XFILLER_9_891 VPWR VGND sg13cmos5l_decap_8
XFILLER_10_301 VPWR VGND sg13cmos5l_decap_8
X_170_ _170_/L_HI VPWR VGND sg13cmos5l_tiehi
XFILLER_7_806 VPWR VGND sg13cmos5l_decap_8
XFILLER_6_305 VPWR VGND sg13cmos5l_decap_8
XFILLER_2_522 VPWR VGND sg13cmos5l_decap_8
XFILLER_2_599 VPWR VGND sg13cmos5l_decap_8
XANTENNA_230 Tile_X0Y0_NN4END[2] VPWR VGND sg13cmos5l_antennanp
XANTENNA_241 Tile_X0Y0_FrameData[31] VPWR VGND sg13cmos5l_antennanp
XANTENNA_252 Tile_X0Y0_FrameData[31] VPWR VGND sg13cmos5l_antennanp
XANTENNA_263 Tile_X0Y0_FrameData[31] VPWR VGND sg13cmos5l_antennanp
XANTENNA_274 Tile_X0Y0_FrameData[28] VPWR VGND sg13cmos5l_antennanp
XANTENNA_285 Tile_X0Y0_NN4END[6] VPWR VGND sg13cmos5l_antennanp
XANTENNA_296 Tile_X0Y0_NN4END[1] VPWR VGND sg13cmos5l_antennanp
XFILLER_13_161 VPWR VGND sg13cmos5l_decap_8
X_299_ Tile_X0Y0_SS4BEG[15] Tile_X0Y0_NN4END[0] VPWR VGND sg13cmos5l_buf_1
X_368_ _368_/X Tile_X0Y0_N4END[0] Tile_X0Y0_N4END[3] Tile_X0Y0_NN4END[1] Tile_X0Y0_NN4END[3]
+ _068_/Q _067_/Q VPWR VGND sg13cmos5l_mux4_1
XFILLER_9_165 VPWR VGND sg13cmos5l_decap_8
XFILLER_3_84 VPWR VGND sg13cmos5l_decap_8
XFILLER_3_1046 VPWR VGND sg13cmos5l_decap_8
XFILLER_15_448 VPWR VGND sg13cmos5l_decap_8
XFILLER_16_905 VPWR VGND sg13cmos5l_decap_8
XFILLER_10_175 VPWR VGND sg13cmos5l_decap_8
XFILLER_11_643 VPWR VGND sg13cmos5l_decap_8
XFILLER_13_1110 VPWR VGND sg13cmos5l_decap_4
X_153_ _153_/L_HI VPWR VGND sg13cmos5l_tiehi
X_222_ Tile_X1Y0_S2BEGb[3] Tile_X1Y0_N2END[4] VPWR VGND sg13cmos5l_buf_1
XFILLER_7_603 VPWR VGND sg13cmos5l_decap_8
X_084_ _084_/Q Tile_X0Y0_FrameData[22] VGND VPWR Tile_X1Y0_FrameStrobe[0] latch
XFILLER_6_168 VPWR VGND sg13cmos5l_decap_8
XANTENNA__296__X Tile_X0Y0_SS4BEG[12] VPWR VGND sg13cmos5l_antennanp
XFILLER_14_492 VPWR VGND sg13cmos5l_decap_8
XFILLER_4_606 VPWR VGND sg13cmos5l_fill_1
XFILLER_3_105 VPWR VGND sg13cmos5l_decap_8
XFILLER_0_856 VPWR VGND sg13cmos5l_decap_8
XFILLER_15_245 VPWR VGND sg13cmos5l_decap_8
XFILLER_16_713 VPWR VGND sg13cmos5l_decap_4
XFILLER_16_779 VPWR VGND sg13cmos5l_decap_8
X_136_ NPU_QUANT_SHIFT_IN21 Tile_X0Y0_UserCLK _386_/X _183_/L_HI VPWR VGND sg13cmos5l_dfrbpq_1
X_205_ Tile_X0Y0_S2BEG[6] Tile_X0Y0_N2MID[1] VPWR VGND sg13cmos5l_buf_1
XFILLER_8_912 VPWR VGND sg13cmos5l_decap_8
XFILLER_7_477 VPWR VGND sg13cmos5l_decap_8
X_067_ _067_/Q Tile_X0Y0_FrameData[3] VGND VPWR Tile_X0Y0_FrameStrobe[0] latch
XFILLER_3_661 VPWR VGND sg13cmos5l_decap_4
XFILLER_0_1038 VPWR VGND sg13cmos5l_decap_8
XFILLER_0_30 VPWR VGND sg13cmos5l_fill_2
XFILLER_9_1052 VPWR VGND sg13cmos5l_decap_8
XFILLER_13_749 VPWR VGND sg13cmos5l_decap_8
XFILLER_9_709 VPWR VGND sg13cmos5l_decap_8
XFILLER_10_1102 VPWR VGND sg13cmos5l_fill_1
XFILLER_12_259 VPWR VGND sg13cmos5l_decap_8
XFILLER_8_219 VPWR VGND sg13cmos5l_decap_8
XFILLER_5_937 VPWR VGND sg13cmos5l_fill_1
XFILLER_16_521 VPWR VGND sg13cmos5l_decap_8
XFILLER_16_565 VPWR VGND sg13cmos5l_decap_8
XFILLER_15_1057 VPWR VGND sg13cmos5l_decap_8
X_119_ NPU_QUANT_SHIFT_IN4 Tile_X0Y0_UserCLK _369_/X _157_/L_HI VPWR VGND sg13cmos5l_dfrbpq_1
XFILLER_8_742 VPWR VGND sg13cmos5l_decap_8
XFILLER_7_252 VPWR VGND sg13cmos5l_decap_8
XFILLER_14_28 VPWR VGND sg13cmos5l_decap_8
XFILLER_13_568 VPWR VGND sg13cmos5l_decap_8
XFILLER_5_756 VPWR VGND sg13cmos5l_decap_8
XFILLER_4_266 VPWR VGND sg13cmos5l_decap_8
XFILLER_1_984 VPWR VGND sg13cmos5l_decap_4
XFILLER_1_973 VPWR VGND sg13cmos5l_decap_8
XFILLER_16_395 VPWR VGND sg13cmos5l_decap_8
XFILLER_6_84 VPWR VGND sg13cmos5l_decap_8
XFILLER_6_1044 VPWR VGND sg13cmos5l_decap_8
XFILLER_10_505 VPWR VGND sg13cmos5l_decap_8
XFILLER_2_737 VPWR VGND sg13cmos5l_decap_8
XFILLER_14_822 VPWR VGND sg13cmos5l_decap_8
XFILLER_13_343 VPWR VGND sg13cmos5l_decap_8
XFILLER_13_354 VPWR VGND sg13cmos5l_fill_1
X_384_ _384_/X Tile_X1Y0_N4END[4] Tile_X1Y0_N4END[5] Tile_X1Y0_NN4END[4] Tile_X1Y0_NN4END[6]
+ _104_/Q _103_/Q VPWR VGND sg13cmos5l_mux4_1
XFILLER_9_347 VPWR VGND sg13cmos5l_decap_8
XFILLER_5_553 VPWR VGND sg13cmos5l_decap_8
XANTENNA__299__X Tile_X0Y0_SS4BEG[15] VPWR VGND sg13cmos5l_antennanp
XFILLER_1_781 VPWR VGND sg13cmos5l_decap_4
XFILLER_16_192 VPWR VGND sg13cmos5l_decap_8
XFILLER_9_870 VPWR VGND sg13cmos5l_decap_8
XFILLER_10_357 VPWR VGND sg13cmos5l_decap_8
XFILLER_11_825 VPWR VGND sg13cmos5l_decap_8
XFILLER_11_858 VPWR VGND sg13cmos5l_decap_8
XFILLER_11_869 VPWR VGND sg13cmos5l_fill_2
XFILLER_2_501 VPWR VGND sg13cmos5l_decap_8
XFILLER_2_578 VPWR VGND sg13cmos5l_decap_8
XANTENNA_220 Tile_X0Y0_N4END[5] VPWR VGND sg13cmos5l_antennanp
XANTENNA_231 Tile_X1Y0_FrameStrobe[10] VPWR VGND sg13cmos5l_antennanp
XANTENNA_242 Tile_X0Y0_FrameData[31] VPWR VGND sg13cmos5l_antennanp
XANTENNA_253 Tile_X0Y0_FrameData[31] VPWR VGND sg13cmos5l_antennanp
XANTENNA_264 Tile_X0Y0_FrameData[31] VPWR VGND sg13cmos5l_antennanp
XANTENNA_275 Tile_X0Y0_FrameData[28] VPWR VGND sg13cmos5l_antennanp
XANTENNA_286 Tile_X0Y0_NN4END[6] VPWR VGND sg13cmos5l_antennanp
XANTENNA_297 Tile_X0Y0_NN4END[1] VPWR VGND sg13cmos5l_antennanp
XFILLER_13_140 VPWR VGND sg13cmos5l_decap_8
XFILLER_14_685 VPWR VGND sg13cmos5l_decap_8
XFILLER_14_696 VPWR VGND sg13cmos5l_fill_2
X_298_ Tile_X0Y0_SS4BEG[14] Tile_X0Y0_NN4END[1] VPWR VGND sg13cmos5l_buf_1
X_367_ _367_/X Tile_X0Y0_N4END[2] Tile_X0Y0_N4END[3] Tile_X0Y0_NN4END[0] Tile_X0Y0_NN4END[2]
+ _070_/Q _069_/Q VPWR VGND sg13cmos5l_mux4_1
XFILLER_9_144 VPWR VGND sg13cmos5l_decap_8
XFILLER_3_63 VPWR VGND sg13cmos5l_decap_8
XFILLER_3_1025 VPWR VGND sg13cmos5l_decap_8
XFILLER_15_427 VPWR VGND sg13cmos5l_decap_8
XFILLER_10_154 VPWR VGND sg13cmos5l_decap_8
XFILLER_11_622 VPWR VGND sg13cmos5l_decap_8
XFILLER_11_699 VPWR VGND sg13cmos5l_decap_8
X_083_ _083_/Q Tile_X0Y0_FrameData[23] VGND VPWR Tile_X1Y0_FrameStrobe[0] latch
X_152_ _152_/L_HI VPWR VGND sg13cmos5l_tiehi
X_221_ Tile_X1Y0_S2BEGb[2] Tile_X1Y0_N2END[5] VPWR VGND sg13cmos5l_buf_1
XFILLER_7_659 VPWR VGND sg13cmos5l_decap_8
XFILLER_6_147 VPWR VGND sg13cmos5l_decap_8
XFILLER_5_0 VPWR VGND sg13cmos5l_decap_8
XFILLER_3_887 VPWR VGND sg13cmos5l_decap_8
XFILLER_3_832 VPWR VGND sg13cmos5l_decap_8
XFILLER_3_821 VPWR VGND sg13cmos5l_decap_4
XFILLER_2_320 VPWR VGND sg13cmos5l_fill_1
XFILLER_14_471 VPWR VGND sg13cmos5l_decap_8
XFILLER_15_983 VPWR VGND sg13cmos5l_decap_8
XFILLER_2_1080 VPWR VGND sg13cmos5l_decap_8
XFILLER_12_419 VPWR VGND sg13cmos5l_decap_8
XFILLER_0_835 VPWR VGND sg13cmos5l_decap_8
XFILLER_16_725 VPWR VGND sg13cmos5l_fill_1
XFILLER_11_441 VPWR VGND sg13cmos5l_decap_8
XFILLER_12_920 VPWR VGND sg13cmos5l_decap_8
XFILLER_12_931 VPWR VGND sg13cmos5l_fill_2
XFILLER_15_224 VPWR VGND sg13cmos5l_decap_8
XFILLER_16_758 VPWR VGND sg13cmos5l_decap_8
X_204_ Tile_X0Y0_S2BEG[5] Tile_X0Y0_N2MID[2] VPWR VGND sg13cmos5l_buf_1
XFILLER_11_496 VPWR VGND sg13cmos5l_decap_8
XFILLER_12_997 VPWR VGND sg13cmos5l_decap_8
X_066_ _066_/Q Tile_X0Y0_FrameData[4] VGND VPWR Tile_X0Y0_FrameStrobe[0] latch
X_135_ NPU_QUANT_SHIFT_IN20 Tile_X0Y0_UserCLK _385_/X _182_/L_HI VPWR VGND sg13cmos5l_dfrbpq_1
XFILLER_7_456 VPWR VGND sg13cmos5l_decap_8
XFILLER_3_640 VPWR VGND sg13cmos5l_decap_8
XFILLER_2_183 VPWR VGND sg13cmos5l_decap_4
XFILLER_0_97 VPWR VGND sg13cmos5l_decap_8
XFILLER_15_791 VPWR VGND sg13cmos5l_decap_8
XFILLER_9_84 VPWR VGND sg13cmos5l_decap_8
XFILLER_9_1031 VPWR VGND sg13cmos5l_decap_8
XFILLER_12_238 VPWR VGND sg13cmos5l_decap_8
XFILLER_13_728 VPWR VGND sg13cmos5l_decap_8
XFILLER_0_621 VPWR VGND sg13cmos5l_fill_1
XFILLER_0_676 VPWR VGND sg13cmos5l_decap_8
XFILLER_16_511 VPWR VGND sg13cmos5l_decap_8
XFILLER_16_544 VPWR VGND sg13cmos5l_decap_8
XFILLER_15_1036 VPWR VGND sg13cmos5l_decap_8
XFILLER_8_721 VPWR VGND sg13cmos5l_decap_8
XFILLER_7_231 VPWR VGND sg13cmos5l_decap_8
X_049_ _049_/Q Tile_X0Y0_FrameData[21] VGND VPWR Tile_X0Y0_FrameStrobe[0] latch
X_118_ NPU_QUANT_SHIFT_IN3 Tile_X0Y0_UserCLK _368_/X _158_/L_HI VPWR VGND sg13cmos5l_dfrbpq_1
XFILLER_8_798 VPWR VGND sg13cmos5l_decap_8
XFILLER_4_982 VPWR VGND sg13cmos5l_decap_8
XFILLER_13_547 VPWR VGND sg13cmos5l_decap_8
XFILLER_5_735 VPWR VGND sg13cmos5l_decap_8
XFILLER_4_245 VPWR VGND sg13cmos5l_decap_8
XFILLER_4_234 VPWR VGND sg13cmos5l_decap_4
XFILLER_4_212 VPWR VGND sg13cmos5l_decap_8
XFILLER_16_374 VPWR VGND sg13cmos5l_decap_4
XFILLER_1_1112 VPWR VGND sg13cmos5l_fill_2
XANTENNA_1 Tile_X0Y0_FrameData[0] VPWR VGND sg13cmos5l_antennanp
XFILLER_12_580 VPWR VGND sg13cmos5l_decap_8
XFILLER_8_595 VPWR VGND sg13cmos5l_decap_8
XFILLER_6_63 VPWR VGND sg13cmos5l_decap_8
XFILLER_6_1023 VPWR VGND sg13cmos5l_decap_8
XFILLER_9_7 VPWR VGND sg13cmos5l_decap_8
XFILLER_2_716 VPWR VGND sg13cmos5l_decap_8
XFILLER_1_215 VPWR VGND sg13cmos5l_decap_8
XFILLER_13_322 VPWR VGND sg13cmos5l_decap_8
XFILLER_14_801 VPWR VGND sg13cmos5l_decap_8
X_383_ _383_/X Tile_X1Y0_N4END[0] Tile_X1Y0_N4END[3] Tile_X1Y0_NN4END[1] Tile_X1Y0_NN4END[3]
+ _106_/Q _105_/Q VPWR VGND sg13cmos5l_mux4_1
XFILLER_12_1039 VPWR VGND sg13cmos5l_decap_8
XFILLER_9_326 VPWR VGND sg13cmos5l_decap_8
XFILLER_5_532 VPWR VGND sg13cmos5l_decap_8
XFILLER_16_171 VPWR VGND sg13cmos5l_decap_8
XFILLER_14_119 VPWR VGND sg13cmos5l_decap_8
XFILLER_15_609 VPWR VGND sg13cmos5l_decap_8
XFILLER_10_336 VPWR VGND sg13cmos5l_decap_8
XFILLER_11_804 VPWR VGND sg13cmos5l_decap_8
XFILLER_11_1083 VPWR VGND sg13cmos5l_decap_8
XFILLER_2_557 VPWR VGND sg13cmos5l_decap_8
XANTENNA_210 Tile_X0Y0_N4END[4] VPWR VGND sg13cmos5l_antennanp
XANTENNA_221 Tile_X0Y0_N4END[5] VPWR VGND sg13cmos5l_antennanp
XANTENNA_232 Tile_X1Y0_FrameStrobe[12] VPWR VGND sg13cmos5l_antennanp
XANTENNA_243 Tile_X0Y0_FrameData[31] VPWR VGND sg13cmos5l_antennanp
XANTENNA_254 Tile_X0Y0_FrameData[31] VPWR VGND sg13cmos5l_antennanp
XANTENNA_265 Tile_X0Y0_FrameData[28] VPWR VGND sg13cmos5l_antennanp
XANTENNA_276 Tile_X0Y0_FrameData[28] VPWR VGND sg13cmos5l_antennanp
XANTENNA_287 Tile_X0Y0_NN4END[6] VPWR VGND sg13cmos5l_antennanp
XANTENNA_298 Tile_X0Y0_NN4END[1] VPWR VGND sg13cmos5l_antennanp
X_366_ _366_/X Tile_X0Y0_N4END[1] Tile_X0Y0_N4END[2] Tile_X0Y0_NN4END[1] Tile_X0Y0_NN4END[3]
+ _072_/Q _071_/Q VPWR VGND sg13cmos5l_mux4_1
XFILLER_9_123 VPWR VGND sg13cmos5l_decap_8
XFILLER_9_112 VPWR VGND sg13cmos5l_decap_8
XFILLER_10_870 VPWR VGND sg13cmos5l_fill_2
XFILLER_10_881 VPWR VGND sg13cmos5l_decap_8
XFILLER_13_196 VPWR VGND sg13cmos5l_decap_8
X_297_ Tile_X0Y0_SS4BEG[13] Tile_X0Y0_NN4END[2] VPWR VGND sg13cmos5l_buf_1
XFILLER_6_863 VPWR VGND sg13cmos5l_fill_1
XFILLER_6_852 VPWR VGND sg13cmos5l_decap_8
XFILLER_6_841 VPWR VGND sg13cmos5l_decap_4
XFILLER_3_42 VPWR VGND sg13cmos5l_decap_8
XFILLER_3_1004 VPWR VGND sg13cmos5l_decap_8
XFILLER_11_601 VPWR VGND sg13cmos5l_decap_8
XFILLER_15_406 VPWR VGND sg13cmos5l_decap_8
X_220_ Tile_X1Y0_S2BEGb[1] Tile_X1Y0_N2END[6] VPWR VGND sg13cmos5l_buf_1
XFILLER_10_133 VPWR VGND sg13cmos5l_decap_8
XFILLER_11_678 VPWR VGND sg13cmos5l_decap_8
XFILLER_12_84 VPWR VGND sg13cmos5l_decap_8
X_082_ _082_/Q Tile_X0Y0_FrameData[24] VGND VPWR Tile_X1Y0_FrameStrobe[0] latch
X_151_ _151_/L_HI VPWR VGND sg13cmos5l_tiehi
XFILLER_7_638 VPWR VGND sg13cmos5l_decap_8
XFILLER_6_126 VPWR VGND sg13cmos5l_decap_8
XFILLER_3_800 VPWR VGND sg13cmos5l_decap_8
XFILLER_14_450 VPWR VGND sg13cmos5l_decap_8
X_349_ Tile_X0Y0_FrameStrobe_O[13] Tile_X0Y0_FrameStrobe[13] VPWR VGND sg13cmos5l_buf_1
XFILLER_0_814 VPWR VGND sg13cmos5l_decap_8
XFILLER_15_203 VPWR VGND sg13cmos5l_decap_8
XFILLER_16_737 VPWR VGND sg13cmos5l_decap_8
XFILLER_11_475 VPWR VGND sg13cmos5l_decap_8
XFILLER_12_976 VPWR VGND sg13cmos5l_decap_8
X_203_ Tile_X0Y0_S2BEG[4] Tile_X0Y0_N2MID[3] VPWR VGND sg13cmos5l_buf_1
XFILLER_8_903 VPWR VGND sg13cmos5l_decap_4
X_065_ _065_/Q Tile_X0Y0_FrameData[5] VGND VPWR Tile_X0Y0_FrameStrobe[0] latch
X_134_ NPU_QUANT_SHIFT_IN19 Tile_X0Y0_UserCLK _384_/X _177_/L_HI VPWR VGND sg13cmos5l_dfrbpq_1
XFILLER_2_162 VPWR VGND sg13cmos5l_decap_8
XFILLER_0_76 VPWR VGND sg13cmos5l_decap_8
XFILLER_15_770 VPWR VGND sg13cmos5l_decap_4
XFILLER_14_280 VPWR VGND sg13cmos5l_decap_8
XFILLER_9_63 VPWR VGND sg13cmos5l_decap_8
XFILLER_9_1010 VPWR VGND sg13cmos5l_decap_8
XFILLER_9_1087 VPWR VGND sg13cmos5l_fill_1
XFILLER_12_217 VPWR VGND sg13cmos5l_decap_8
XANTENNA__201__X Tile_X0Y0_S2BEG[2] VPWR VGND sg13cmos5l_antennanp
XFILLER_11_294 VPWR VGND sg13cmos5l_decap_8
XFILLER_12_784 VPWR VGND sg13cmos5l_decap_8
XFILLER_15_1004 VPWR VGND sg13cmos5l_fill_1
XFILLER_15_1015 VPWR VGND sg13cmos5l_decap_8
X_117_ NPU_QUANT_SHIFT_IN2 Tile_X0Y0_UserCLK _367_/X _160_/L_HI VPWR VGND sg13cmos5l_dfrbpq_1
XFILLER_8_777 VPWR VGND sg13cmos5l_decap_8
XFILLER_8_700 VPWR VGND sg13cmos5l_decap_8
XFILLER_7_210 VPWR VGND sg13cmos5l_decap_8
X_048_ _048_/Q Tile_X0Y0_FrameData[22] VGND VPWR Tile_X0Y0_FrameStrobe[0] latch
XFILLER_7_287 VPWR VGND sg13cmos5l_decap_8
XFILLER_3_493 VPWR VGND sg13cmos5l_decap_8
XFILLER_13_526 VPWR VGND sg13cmos5l_decap_8
XFILLER_5_714 VPWR VGND sg13cmos5l_decap_8
XFILLER_1_931 VPWR VGND sg13cmos5l_fill_1
XFILLER_0_452 VPWR VGND sg13cmos5l_fill_1
XFILLER_0_474 VPWR VGND sg13cmos5l_fill_1
XFILLER_16_342 VPWR VGND sg13cmos5l_decap_8
XFILLER_16_353 VPWR VGND sg13cmos5l_decap_8
XANTENNA_2 Tile_X0Y0_FrameData[0] VPWR VGND sg13cmos5l_antennanp
XFILLER_8_574 VPWR VGND sg13cmos5l_decap_8
XFILLER_6_42 VPWR VGND sg13cmos5l_decap_8
XFILLER_4_780 VPWR VGND sg13cmos5l_decap_8
XFILLER_13_0 VPWR VGND sg13cmos5l_decap_8
XFILLER_2_706 VPWR VGND sg13cmos5l_decap_8
XFILLER_1_249 VPWR VGND sg13cmos5l_decap_8
XFILLER_13_301 VPWR VGND sg13cmos5l_decap_8
XFILLER_14_835 VPWR VGND sg13cmos5l_fill_2
XFILLER_15_84 VPWR VGND sg13cmos5l_decap_8
X_382_ _382_/X Tile_X1Y0_N4END[2] Tile_X1Y0_N4END[3] Tile_X1Y0_NN4END[0] Tile_X1Y0_NN4END[2]
+ _108_/Q _107_/Q VPWR VGND sg13cmos5l_mux4_1
XFILLER_9_305 VPWR VGND sg13cmos5l_decap_8
XFILLER_12_1018 VPWR VGND sg13cmos5l_decap_8
XFILLER_13_389 VPWR VGND sg13cmos5l_decap_8
XFILLER_5_511 VPWR VGND sg13cmos5l_decap_8
XFILLER_5_588 VPWR VGND sg13cmos5l_decap_8
XFILLER_1_794 VPWR VGND sg13cmos5l_decap_8
XFILLER_16_150 VPWR VGND sg13cmos5l_decap_4
XFILLER_10_315 VPWR VGND sg13cmos5l_decap_8
XFILLER_6_319 VPWR VGND sg13cmos5l_fill_2
XFILLER_11_1062 VPWR VGND sg13cmos5l_decap_8
XFILLER_2_536 VPWR VGND sg13cmos5l_decap_8
XANTENNA_200 Tile_X0Y0_N4END[3] VPWR VGND sg13cmos5l_antennanp
XANTENNA_211 Tile_X0Y0_N4END[4] VPWR VGND sg13cmos5l_antennanp
XANTENNA_222 Tile_X0Y0_NN4END[2] VPWR VGND sg13cmos5l_antennanp
XANTENNA_233 Tile_X1Y0_FrameStrobe[14] VPWR VGND sg13cmos5l_antennanp
XANTENNA_244 Tile_X0Y0_FrameData[31] VPWR VGND sg13cmos5l_antennanp
XANTENNA_255 Tile_X0Y0_FrameData[31] VPWR VGND sg13cmos5l_antennanp
XANTENNA_266 Tile_X0Y0_FrameData[28] VPWR VGND sg13cmos5l_antennanp
XANTENNA_277 Tile_X0Y0_FrameData[30] VPWR VGND sg13cmos5l_antennanp
XANTENNA_288 Tile_X0Y0_NN4END[6] VPWR VGND sg13cmos5l_antennanp
XANTENNA_299 Tile_X0Y0_NN4END[1] VPWR VGND sg13cmos5l_antennanp
XFILLER_13_175 VPWR VGND sg13cmos5l_decap_8
XFILLER_14_665 VPWR VGND sg13cmos5l_decap_4
X_296_ Tile_X0Y0_SS4BEG[12] Tile_X0Y0_NN4END[3] VPWR VGND sg13cmos5l_buf_1
X_365_ _365_/X Tile_X0Y0_N4END[0] Tile_X0Y0_N4END[1] Tile_X0Y0_NN4END[0] Tile_X0Y0_NN4END[2]
+ _074_/Q _073_/Q VPWR VGND sg13cmos5l_mux4_1
XFILLER_9_179 VPWR VGND sg13cmos5l_decap_8
XFILLER_6_820 VPWR VGND sg13cmos5l_decap_8
XFILLER_3_98 VPWR VGND sg13cmos5l_decap_8
XFILLER_3_21 VPWR VGND sg13cmos5l_decap_8
XFILLER_16_919 VPWR VGND sg13cmos5l_decap_8
XFILLER_10_112 VPWR VGND sg13cmos5l_decap_8
XFILLER_11_657 VPWR VGND sg13cmos5l_decap_8
X_150_ NPU_QUANT_SHIFT_EN Tile_X0Y0_UserCLK _401_/X _163_/L_HI VPWR VGND sg13cmos5l_dfrbpq_1
XANTENNA__204__X Tile_X0Y0_S2BEG[5] VPWR VGND sg13cmos5l_antennanp
XFILLER_10_189 VPWR VGND sg13cmos5l_decap_8
XFILLER_12_63 VPWR VGND sg13cmos5l_decap_8
X_081_ _081_/Q Tile_X0Y0_FrameData[25] VGND VPWR Tile_X1Y0_FrameStrobe[0] latch
XFILLER_7_617 VPWR VGND sg13cmos5l_decap_8
XFILLER_6_105 VPWR VGND sg13cmos5l_decap_8
XFILLER_2_399 VPWR VGND sg13cmos5l_fill_2
X_279_ Tile_X0Y0_S4BEG[11] Tile_X0Y0_N4END[4] VPWR VGND sg13cmos5l_buf_1
X_348_ Tile_X0Y0_FrameStrobe_O[12] Tile_X0Y0_FrameStrobe[12] VPWR VGND sg13cmos5l_buf_1
XFILLER_6_683 VPWR VGND sg13cmos5l_decap_8
XFILLER_5_182 VPWR VGND sg13cmos5l_decap_8
XFILLER_3_119 VPWR VGND sg13cmos5l_decap_8
XFILLER_15_259 VPWR VGND sg13cmos5l_decap_8
XFILLER_16_705 VPWR VGND sg13cmos5l_decap_4
XFILLER_11_454 VPWR VGND sg13cmos5l_decap_8
X_133_ NPU_QUANT_SHIFT_IN18 Tile_X0Y0_UserCLK _383_/X _179_/L_HI VPWR VGND sg13cmos5l_dfrbpq_1
X_202_ Tile_X0Y0_S2BEG[3] Tile_X0Y0_N2MID[4] VPWR VGND sg13cmos5l_buf_1
XFILLER_7_447 VPWR VGND sg13cmos5l_fill_1
X_064_ _064_/Q Tile_X0Y0_FrameData[6] VGND VPWR Tile_X0Y0_FrameStrobe[0] latch
XFILLER_0_1008 VPWR VGND sg13cmos5l_fill_1
XFILLER_0_55 VPWR VGND sg13cmos5l_decap_8
XFILLER_9_42 VPWR VGND sg13cmos5l_decap_8
XFILLER_7_970 VPWR VGND sg13cmos5l_fill_2
XFILLER_9_1066 VPWR VGND sg13cmos5l_decap_8
XFILLER_16_535 VPWR VGND sg13cmos5l_decap_4
XFILLER_16_579 VPWR VGND sg13cmos5l_decap_8
XFILLER_11_273 VPWR VGND sg13cmos5l_decap_8
XFILLER_12_763 VPWR VGND sg13cmos5l_decap_8
X_116_ NPU_QUANT_SHIFT_IN1 Tile_X0Y0_UserCLK _366_/X _176_/L_HI VPWR VGND sg13cmos5l_dfrbpq_1
XFILLER_8_756 VPWR VGND sg13cmos5l_decap_8
XFILLER_7_266 VPWR VGND sg13cmos5l_decap_8
X_047_ _047_/Q Tile_X0Y0_FrameData[23] VGND VPWR Tile_X0Y0_FrameStrobe[0] latch
XFILLER_4_940 VPWR VGND sg13cmos5l_decap_4
XANTENNA__302__X Tile_X0Y0_S1BEG[2] VPWR VGND sg13cmos5l_antennanp
XFILLER_13_505 VPWR VGND sg13cmos5l_decap_8
XFILLER_14_1082 VPWR VGND sg13cmos5l_decap_8
XFILLER_9_509 VPWR VGND sg13cmos5l_decap_8
XANTENNA__212__X Tile_X1Y0_S2BEG[1] VPWR VGND sg13cmos5l_antennanp
XFILLER_1_954 VPWR VGND sg13cmos5l_decap_8
XFILLER_1_921 VPWR VGND sg13cmos5l_fill_1
XFILLER_16_321 VPWR VGND sg13cmos5l_decap_8
XFILLER_1_998 VPWR VGND sg13cmos5l_fill_1
XANTENNA_3 Tile_X0Y0_FrameData[0] VPWR VGND sg13cmos5l_antennanp
XFILLER_8_553 VPWR VGND sg13cmos5l_decap_8
XFILLER_6_98 VPWR VGND sg13cmos5l_decap_8
XFILLER_6_21 VPWR VGND sg13cmos5l_decap_8
XFILLER_6_1058 VPWR VGND sg13cmos5l_decap_8
XFILLER_3_291 VPWR VGND sg13cmos5l_decap_4
XFILLER_10_519 VPWR VGND sg13cmos5l_decap_8
XFILLER_1_239 VPWR VGND sg13cmos5l_fill_2
XFILLER_1_206 VPWR VGND sg13cmos5l_fill_1
XANTENNA__207__X Tile_X1Y0_S1BEG[0] VPWR VGND sg13cmos5l_antennanp
XFILLER_14_847 VPWR VGND sg13cmos5l_fill_1
XFILLER_15_63 VPWR VGND sg13cmos5l_decap_8
X_381_ _381_/X Tile_X1Y0_N4END[1] Tile_X1Y0_N4END[2] Tile_X1Y0_NN4END[1] Tile_X1Y0_NN4END[3]
+ _110_/Q _109_/Q VPWR VGND sg13cmos5l_mux4_1
XFILLER_5_567 VPWR VGND sg13cmos5l_decap_8
XFILLER_0_261 VPWR VGND sg13cmos5l_fill_1
XFILLER_9_884 VPWR VGND sg13cmos5l_decap_8
XFILLER_11_839 VPWR VGND sg13cmos5l_fill_2
XFILLER_11_1041 VPWR VGND sg13cmos5l_decap_8
XFILLER_2_515 VPWR VGND sg13cmos5l_decap_8
XANTENNA_201 Tile_X0Y0_N4END[3] VPWR VGND sg13cmos5l_antennanp
XANTENNA_212 Tile_X0Y0_N4END[4] VPWR VGND sg13cmos5l_antennanp
XANTENNA_223 Tile_X0Y0_NN4END[2] VPWR VGND sg13cmos5l_antennanp
XANTENNA_234 Tile_X1Y0_FrameStrobe[17] VPWR VGND sg13cmos5l_antennanp
XANTENNA_245 Tile_X0Y0_FrameData[31] VPWR VGND sg13cmos5l_antennanp
XANTENNA_256 Tile_X0Y0_FrameData[31] VPWR VGND sg13cmos5l_antennanp
XANTENNA_267 Tile_X0Y0_FrameData[28] VPWR VGND sg13cmos5l_antennanp
XFILLER_14_611 VPWR VGND sg13cmos5l_decap_8
XANTENNA_278 Tile_X0Y0_FrameData[30] VPWR VGND sg13cmos5l_antennanp
XANTENNA_289 Tile_X0Y0_NN4END[6] VPWR VGND sg13cmos5l_antennanp
XFILLER_10_850 VPWR VGND sg13cmos5l_decap_4
XFILLER_13_154 VPWR VGND sg13cmos5l_decap_8
X_295_ Tile_X0Y0_SS4BEG[11] Tile_X0Y0_NN4END[4] VPWR VGND sg13cmos5l_buf_1
X_364_ Tile_X1Y0_FrameStrobe_O[8] Tile_X1Y0_FrameStrobe[8] VPWR VGND sg13cmos5l_buf_1
XFILLER_9_158 VPWR VGND sg13cmos5l_decap_8
XFILLER_5_331 VPWR VGND sg13cmos5l_decap_4
XFILLER_3_77 VPWR VGND sg13cmos5l_decap_8
XFILLER_3_1039 VPWR VGND sg13cmos5l_decap_8
XFILLER_1_581 VPWR VGND sg13cmos5l_decap_8
XFILLER_9_681 VPWR VGND sg13cmos5l_decap_8
XFILLER_8_191 VPWR VGND sg13cmos5l_decap_8
XANTENNA__310__X Tile_X1Y0_FrameData_O[6] VPWR VGND sg13cmos5l_antennanp
XFILLER_10_168 VPWR VGND sg13cmos5l_decap_8
XFILLER_11_636 VPWR VGND sg13cmos5l_decap_8
XFILLER_13_1103 VPWR VGND sg13cmos5l_decap_8
X_080_ _080_/Q Tile_X0Y0_FrameData[26] VGND VPWR Tile_X1Y0_FrameStrobe[0] latch
XFILLER_12_42 VPWR VGND sg13cmos5l_decap_8
XFILLER_3_846 VPWR VGND sg13cmos5l_decap_4
XANTENNA__220__X Tile_X1Y0_S2BEGb[1] VPWR VGND sg13cmos5l_antennanp
XFILLER_15_997 VPWR VGND sg13cmos5l_decap_8
XFILLER_10_680 VPWR VGND sg13cmos5l_decap_8
XFILLER_10_691 VPWR VGND sg13cmos5l_fill_1
XFILLER_14_485 VPWR VGND sg13cmos5l_decap_8
X_278_ Tile_X0Y0_S4BEG[10] Tile_X0Y0_N4END[5] VPWR VGND sg13cmos5l_buf_1
X_347_ Tile_X0Y0_FrameStrobe_O[11] Tile_X0Y0_FrameStrobe[11] VPWR VGND sg13cmos5l_buf_1
XFILLER_6_662 VPWR VGND sg13cmos5l_decap_8
XFILLER_6_640 VPWR VGND sg13cmos5l_decap_8
XFILLER_5_161 VPWR VGND sg13cmos5l_decap_8
XANTENNA__305__X Tile_X1Y0_FrameData_O[1] VPWR VGND sg13cmos5l_antennanp
XFILLER_0_849 VPWR VGND sg13cmos5l_decap_8
XFILLER_15_238 VPWR VGND sg13cmos5l_decap_8
XFILLER_16_717 VPWR VGND sg13cmos5l_fill_1
XANTENNA__215__X Tile_X1Y0_S2BEG[4] VPWR VGND sg13cmos5l_antennanp
X_063_ _063_/Q Tile_X0Y0_FrameData[7] VGND VPWR Tile_X0Y0_FrameStrobe[0] latch
X_132_ NPU_QUANT_SHIFT_IN17 Tile_X0Y0_UserCLK _382_/X _181_/L_HI VPWR VGND sg13cmos5l_dfrbpq_1
X_201_ Tile_X0Y0_S2BEG[2] Tile_X0Y0_N2MID[5] VPWR VGND sg13cmos5l_buf_1
XFILLER_7_437 VPWR VGND sg13cmos5l_fill_1
XFILLER_3_654 VPWR VGND sg13cmos5l_decap_8
XFILLER_3_0 VPWR VGND sg13cmos5l_decap_8
XFILLER_0_23 VPWR VGND sg13cmos5l_decap_8
XFILLER_9_21 VPWR VGND sg13cmos5l_decap_8
XFILLER_9_98 VPWR VGND sg13cmos5l_decap_8
XFILLER_9_1045 VPWR VGND sg13cmos5l_decap_8
XFILLER_0_613 VPWR VGND sg13cmos5l_decap_4
XFILLER_0_635 VPWR VGND sg13cmos5l_fill_1
XFILLER_12_720 VPWR VGND sg13cmos5l_decap_4
XFILLER_12_742 VPWR VGND sg13cmos5l_decap_8
XFILLER_16_558 VPWR VGND sg13cmos5l_decap_8
XFILLER_11_252 VPWR VGND sg13cmos5l_decap_8
X_046_ _046_/Q Tile_X0Y0_FrameData[24] VGND VPWR Tile_X0Y0_FrameStrobe[0] latch
X_115_ NPU_QUANT_SHIFT_IN0 Tile_X0Y0_UserCLK _365_/X _180_/L_HI VPWR VGND sg13cmos5l_dfrbpq_1
XFILLER_8_735 VPWR VGND sg13cmos5l_decap_8
XFILLER_7_245 VPWR VGND sg13cmos5l_decap_8
XFILLER_4_996 VPWR VGND sg13cmos5l_decap_8
XFILLER_14_1061 VPWR VGND sg13cmos5l_decap_8
XFILLER_5_749 VPWR VGND sg13cmos5l_decap_8
XFILLER_4_259 VPWR VGND sg13cmos5l_decap_8
XFILLER_1_966 VPWR VGND sg13cmos5l_decap_8
XFILLER_16_300 VPWR VGND sg13cmos5l_decap_8
XFILLER_12_594 VPWR VGND sg13cmos5l_decap_8
XFILLER_16_388 VPWR VGND sg13cmos5l_decap_8
XFILLER_8_532 VPWR VGND sg13cmos5l_decap_8
XANTENNA_4 Tile_X0Y0_FrameData[0] VPWR VGND sg13cmos5l_antennanp
XFILLER_6_77 VPWR VGND sg13cmos5l_decap_8
XFILLER_6_1037 VPWR VGND sg13cmos5l_decap_8
XANTENNA__313__X Tile_X1Y0_FrameData_O[9] VPWR VGND sg13cmos5l_antennanp
XFILLER_14_815 VPWR VGND sg13cmos5l_decap_8
XFILLER_13_336 VPWR VGND sg13cmos5l_decap_8
XFILLER_15_42 VPWR VGND sg13cmos5l_decap_8
X_380_ _380_/X Tile_X1Y0_N4END[0] Tile_X1Y0_N4END[1] Tile_X1Y0_NN4END[0] Tile_X1Y0_NN4END[2]
+ _112_/Q _111_/Q VPWR VGND sg13cmos5l_mux4_1
XANTENNA__223__X Tile_X1Y0_S2BEGb[4] VPWR VGND sg13cmos5l_antennanp
XFILLER_5_546 VPWR VGND sg13cmos5l_decap_8
XFILLER_0_295 VPWR VGND sg13cmos5l_fill_2
XFILLER_1_785 VPWR VGND sg13cmos5l_fill_2
XFILLER_16_185 VPWR VGND sg13cmos5l_decap_4
XFILLER_9_863 VPWR VGND sg13cmos5l_decap_8
.ends
