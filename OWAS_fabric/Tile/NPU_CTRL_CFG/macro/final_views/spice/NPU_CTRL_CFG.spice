* NGSPICE file created from NPU_CTRL_CFG.ext - technology: ihp-sg13cmos5l

* Black-box entry subcircuit for sg13cmos5l_antennanp abstract view
.subckt sg13cmos5l_antennanp A VDD VSS
.ends

* Black-box entry subcircuit for sg13cmos5l_fill_2 abstract view
.subckt sg13cmos5l_fill_2 VDD VSS
.ends

* Black-box entry subcircuit for sg13cmos5l_decap_8 abstract view
.subckt sg13cmos5l_decap_8 VDD VSS
.ends

* Black-box entry subcircuit for sg13cmos5l_decap_4 abstract view
.subckt sg13cmos5l_decap_4 VDD VSS
.ends

* Black-box entry subcircuit for sg13cmos5l_buf_1 abstract view
.subckt sg13cmos5l_buf_1 X A VDD VSS
.ends

* Black-box entry subcircuit for sg13cmos5l_fill_1 abstract view
.subckt sg13cmos5l_fill_1 VDD VSS
.ends

* Black-box entry subcircuit for latch abstract view
.subckt latch Q D VSS VDD GATE
.ends

* Black-box entry subcircuit for sg13cmos5l_dfrbpq_1 abstract view
.subckt sg13cmos5l_dfrbpq_1 Q CLK D RESET_B VDD VSS
.ends

* Black-box entry subcircuit for sg13cmos5l_tiehi abstract view
.subckt sg13cmos5l_tiehi L_HI VDD VSS
.ends

* Black-box entry subcircuit for sg13cmos5l_mux4_1 abstract view
.subckt sg13cmos5l_mux4_1 X A0 A1 A2 A3 S0 S1 VDD VSS
.ends

* Black-box entry subcircuit for sg13cmos5l_or2_1 abstract view
.subckt sg13cmos5l_or2_1 X A B VDD VSS
.ends

.subckt NPU_CTRL_CFG NPU_ARRAY_EN NPU_COMPUTE_BANK_SWAP NPU_PSUM_LUT_EN NPU_PSUM_SKEW_EN
+ NPU_PSUM_SYSTOLIC_EN NPU_QUANT_SHIFT_EN NPU_QUANT_SHIFT_IN0 NPU_QUANT_SHIFT_IN1
+ NPU_QUANT_SHIFT_IN10 NPU_QUANT_SHIFT_IN11 NPU_QUANT_SHIFT_IN12 NPU_QUANT_SHIFT_IN13
+ NPU_QUANT_SHIFT_IN14 NPU_QUANT_SHIFT_IN15 NPU_QUANT_SHIFT_IN16 NPU_QUANT_SHIFT_IN17
+ NPU_QUANT_SHIFT_IN18 NPU_QUANT_SHIFT_IN19 NPU_QUANT_SHIFT_IN2 NPU_QUANT_SHIFT_IN20
+ NPU_QUANT_SHIFT_IN21 NPU_QUANT_SHIFT_IN22 NPU_QUANT_SHIFT_IN23 NPU_QUANT_SHIFT_IN24
+ NPU_QUANT_SHIFT_IN25 NPU_QUANT_SHIFT_IN26 NPU_QUANT_SHIFT_IN27 NPU_QUANT_SHIFT_IN28
+ NPU_QUANT_SHIFT_IN29 NPU_QUANT_SHIFT_IN3 NPU_QUANT_SHIFT_IN4 NPU_QUANT_SHIFT_IN5
+ NPU_QUANT_SHIFT_IN6 NPU_QUANT_SHIFT_IN7 NPU_QUANT_SHIFT_IN8 NPU_QUANT_SHIFT_IN9
+ NPU_SWAP_WEIGHTS Tile_X0Y0_Ci Tile_X0Y0_FrameData[0] Tile_X0Y0_FrameData[10] Tile_X0Y0_FrameData[11]
+ Tile_X0Y0_FrameData[12] Tile_X0Y0_FrameData[13] Tile_X0Y0_FrameData[14] Tile_X0Y0_FrameData[15]
+ Tile_X0Y0_FrameData[16] Tile_X0Y0_FrameData[17] Tile_X0Y0_FrameData[18] Tile_X0Y0_FrameData[19]
+ Tile_X0Y0_FrameData[1] Tile_X0Y0_FrameData[20] Tile_X0Y0_FrameData[21] Tile_X0Y0_FrameData[22]
+ Tile_X0Y0_FrameData[23] Tile_X0Y0_FrameData[24] Tile_X0Y0_FrameData[25] Tile_X0Y0_FrameData[26]
+ Tile_X0Y0_FrameData[27] Tile_X0Y0_FrameData[28] Tile_X0Y0_FrameData[29] Tile_X0Y0_FrameData[2]
+ Tile_X0Y0_FrameData[30] Tile_X0Y0_FrameData[31] Tile_X0Y0_FrameData[3] Tile_X0Y0_FrameData[4]
+ Tile_X0Y0_FrameData[5] Tile_X0Y0_FrameData[6] Tile_X0Y0_FrameData[7] Tile_X0Y0_FrameData[8]
+ Tile_X0Y0_FrameData[9] Tile_X0Y0_FrameStrobe[0] Tile_X0Y0_FrameStrobe[10] Tile_X0Y0_FrameStrobe[11]
+ Tile_X0Y0_FrameStrobe[12] Tile_X0Y0_FrameStrobe[13] Tile_X0Y0_FrameStrobe[14] Tile_X0Y0_FrameStrobe[15]
+ Tile_X0Y0_FrameStrobe[16] Tile_X0Y0_FrameStrobe[17] Tile_X0Y0_FrameStrobe[18] Tile_X0Y0_FrameStrobe[19]
+ Tile_X0Y0_FrameStrobe[1] Tile_X0Y0_FrameStrobe[2] Tile_X0Y0_FrameStrobe[3] Tile_X0Y0_FrameStrobe[4]
+ Tile_X0Y0_FrameStrobe[5] Tile_X0Y0_FrameStrobe[6] Tile_X0Y0_FrameStrobe[7] Tile_X0Y0_FrameStrobe[8]
+ Tile_X0Y0_FrameStrobe[9] Tile_X0Y0_FrameStrobe_O[0] Tile_X0Y0_FrameStrobe_O[10]
+ Tile_X0Y0_FrameStrobe_O[11] Tile_X0Y0_FrameStrobe_O[12] Tile_X0Y0_FrameStrobe_O[13]
+ Tile_X0Y0_FrameStrobe_O[14] Tile_X0Y0_FrameStrobe_O[15] Tile_X0Y0_FrameStrobe_O[16]
+ Tile_X0Y0_FrameStrobe_O[17] Tile_X0Y0_FrameStrobe_O[18] Tile_X0Y0_FrameStrobe_O[19]
+ Tile_X0Y0_FrameStrobe_O[1] Tile_X0Y0_FrameStrobe_O[2] Tile_X0Y0_FrameStrobe_O[3]
+ Tile_X0Y0_FrameStrobe_O[4] Tile_X0Y0_FrameStrobe_O[5] Tile_X0Y0_FrameStrobe_O[6]
+ Tile_X0Y0_FrameStrobe_O[7] Tile_X0Y0_FrameStrobe_O[8] Tile_X0Y0_FrameStrobe_O[9]
+ Tile_X0Y0_N1END[0] Tile_X0Y0_N1END[1] Tile_X0Y0_N1END[2] Tile_X0Y0_N1END[3] Tile_X0Y0_N2END[0]
+ Tile_X0Y0_N2END[1] Tile_X0Y0_N2END[2] Tile_X0Y0_N2END[3] Tile_X0Y0_N2END[4] Tile_X0Y0_N2END[5]
+ Tile_X0Y0_N2END[6] Tile_X0Y0_N2END[7] Tile_X0Y0_N2MID[0] Tile_X0Y0_N2MID[1] Tile_X0Y0_N2MID[2]
+ Tile_X0Y0_N2MID[3] Tile_X0Y0_N2MID[4] Tile_X0Y0_N2MID[5] Tile_X0Y0_N2MID[6] Tile_X0Y0_N2MID[7]
+ Tile_X0Y0_N4END[0] Tile_X0Y0_N4END[10] Tile_X0Y0_N4END[11] Tile_X0Y0_N4END[12] Tile_X0Y0_N4END[13]
+ Tile_X0Y0_N4END[14] Tile_X0Y0_N4END[15] Tile_X0Y0_N4END[1] Tile_X0Y0_N4END[2] Tile_X0Y0_N4END[3]
+ Tile_X0Y0_N4END[4] Tile_X0Y0_N4END[5] Tile_X0Y0_N4END[6] Tile_X0Y0_N4END[7] Tile_X0Y0_N4END[8]
+ Tile_X0Y0_N4END[9] Tile_X0Y0_NN4END[0] Tile_X0Y0_NN4END[10] Tile_X0Y0_NN4END[11]
+ Tile_X0Y0_NN4END[12] Tile_X0Y0_NN4END[13] Tile_X0Y0_NN4END[14] Tile_X0Y0_NN4END[15]
+ Tile_X0Y0_NN4END[1] Tile_X0Y0_NN4END[2] Tile_X0Y0_NN4END[3] Tile_X0Y0_NN4END[4]
+ Tile_X0Y0_NN4END[5] Tile_X0Y0_NN4END[6] Tile_X0Y0_NN4END[7] Tile_X0Y0_NN4END[8]
+ Tile_X0Y0_NN4END[9] Tile_X0Y0_S1BEG[0] Tile_X0Y0_S1BEG[1] Tile_X0Y0_S1BEG[2] Tile_X0Y0_S1BEG[3]
+ Tile_X0Y0_S2BEG[0] Tile_X0Y0_S2BEG[1] Tile_X0Y0_S2BEG[2] Tile_X0Y0_S2BEG[3] Tile_X0Y0_S2BEG[4]
+ Tile_X0Y0_S2BEG[5] Tile_X0Y0_S2BEG[6] Tile_X0Y0_S2BEG[7] Tile_X0Y0_S2BEGb[0] Tile_X0Y0_S2BEGb[1]
+ Tile_X0Y0_S2BEGb[2] Tile_X0Y0_S2BEGb[3] Tile_X0Y0_S2BEGb[4] Tile_X0Y0_S2BEGb[5]
+ Tile_X0Y0_S2BEGb[6] Tile_X0Y0_S2BEGb[7] Tile_X0Y0_S4BEG[0] Tile_X0Y0_S4BEG[10] Tile_X0Y0_S4BEG[11]
+ Tile_X0Y0_S4BEG[12] Tile_X0Y0_S4BEG[13] Tile_X0Y0_S4BEG[14] Tile_X0Y0_S4BEG[15]
+ Tile_X0Y0_S4BEG[1] Tile_X0Y0_S4BEG[2] Tile_X0Y0_S4BEG[3] Tile_X0Y0_S4BEG[4] Tile_X0Y0_S4BEG[5]
+ Tile_X0Y0_S4BEG[6] Tile_X0Y0_S4BEG[7] Tile_X0Y0_S4BEG[8] Tile_X0Y0_S4BEG[9] Tile_X0Y0_SS4BEG[0]
+ Tile_X0Y0_SS4BEG[10] Tile_X0Y0_SS4BEG[11] Tile_X0Y0_SS4BEG[12] Tile_X0Y0_SS4BEG[13]
+ Tile_X0Y0_SS4BEG[14] Tile_X0Y0_SS4BEG[15] Tile_X0Y0_SS4BEG[1] Tile_X0Y0_SS4BEG[2]
+ Tile_X0Y0_SS4BEG[3] Tile_X0Y0_SS4BEG[4] Tile_X0Y0_SS4BEG[5] Tile_X0Y0_SS4BEG[6]
+ Tile_X0Y0_SS4BEG[7] Tile_X0Y0_SS4BEG[8] Tile_X0Y0_SS4BEG[9] Tile_X0Y0_UserCLK Tile_X1Y0_Ci
+ Tile_X1Y0_FrameData_O[0] Tile_X1Y0_FrameData_O[10] Tile_X1Y0_FrameData_O[11] Tile_X1Y0_FrameData_O[12]
+ Tile_X1Y0_FrameData_O[13] Tile_X1Y0_FrameData_O[14] Tile_X1Y0_FrameData_O[15] Tile_X1Y0_FrameData_O[16]
+ Tile_X1Y0_FrameData_O[17] Tile_X1Y0_FrameData_O[18] Tile_X1Y0_FrameData_O[19] Tile_X1Y0_FrameData_O[1]
+ Tile_X1Y0_FrameData_O[20] Tile_X1Y0_FrameData_O[21] Tile_X1Y0_FrameData_O[22] Tile_X1Y0_FrameData_O[23]
+ Tile_X1Y0_FrameData_O[24] Tile_X1Y0_FrameData_O[25] Tile_X1Y0_FrameData_O[26] Tile_X1Y0_FrameData_O[27]
+ Tile_X1Y0_FrameData_O[28] Tile_X1Y0_FrameData_O[29] Tile_X1Y0_FrameData_O[2] Tile_X1Y0_FrameData_O[30]
+ Tile_X1Y0_FrameData_O[31] Tile_X1Y0_FrameData_O[3] Tile_X1Y0_FrameData_O[4] Tile_X1Y0_FrameData_O[5]
+ Tile_X1Y0_FrameData_O[6] Tile_X1Y0_FrameData_O[7] Tile_X1Y0_FrameData_O[8] Tile_X1Y0_FrameData_O[9]
+ Tile_X1Y0_FrameStrobe[0] Tile_X1Y0_FrameStrobe[10] Tile_X1Y0_FrameStrobe[11] Tile_X1Y0_FrameStrobe[12]
+ Tile_X1Y0_FrameStrobe[13] Tile_X1Y0_FrameStrobe[14] Tile_X1Y0_FrameStrobe[15] Tile_X1Y0_FrameStrobe[16]
+ Tile_X1Y0_FrameStrobe[17] Tile_X1Y0_FrameStrobe[18] Tile_X1Y0_FrameStrobe[19] Tile_X1Y0_FrameStrobe[1]
+ Tile_X1Y0_FrameStrobe[2] Tile_X1Y0_FrameStrobe[3] Tile_X1Y0_FrameStrobe[4] Tile_X1Y0_FrameStrobe[5]
+ Tile_X1Y0_FrameStrobe[6] Tile_X1Y0_FrameStrobe[7] Tile_X1Y0_FrameStrobe[8] Tile_X1Y0_FrameStrobe[9]
+ Tile_X1Y0_FrameStrobe_O[0] Tile_X1Y0_FrameStrobe_O[10] Tile_X1Y0_FrameStrobe_O[11]
+ Tile_X1Y0_FrameStrobe_O[12] Tile_X1Y0_FrameStrobe_O[13] Tile_X1Y0_FrameStrobe_O[14]
+ Tile_X1Y0_FrameStrobe_O[15] Tile_X1Y0_FrameStrobe_O[16] Tile_X1Y0_FrameStrobe_O[17]
+ Tile_X1Y0_FrameStrobe_O[18] Tile_X1Y0_FrameStrobe_O[19] Tile_X1Y0_FrameStrobe_O[1]
+ Tile_X1Y0_FrameStrobe_O[2] Tile_X1Y0_FrameStrobe_O[3] Tile_X1Y0_FrameStrobe_O[4]
+ Tile_X1Y0_FrameStrobe_O[5] Tile_X1Y0_FrameStrobe_O[6] Tile_X1Y0_FrameStrobe_O[7]
+ Tile_X1Y0_FrameStrobe_O[8] Tile_X1Y0_FrameStrobe_O[9] Tile_X1Y0_N1END[0] Tile_X1Y0_N1END[1]
+ Tile_X1Y0_N1END[2] Tile_X1Y0_N1END[3] Tile_X1Y0_N2END[0] Tile_X1Y0_N2END[1] Tile_X1Y0_N2END[2]
+ Tile_X1Y0_N2END[3] Tile_X1Y0_N2END[4] Tile_X1Y0_N2END[5] Tile_X1Y0_N2END[6] Tile_X1Y0_N2END[7]
+ Tile_X1Y0_N2MID[0] Tile_X1Y0_N2MID[1] Tile_X1Y0_N2MID[2] Tile_X1Y0_N2MID[3] Tile_X1Y0_N2MID[4]
+ Tile_X1Y0_N2MID[5] Tile_X1Y0_N2MID[6] Tile_X1Y0_N2MID[7] Tile_X1Y0_N4END[0] Tile_X1Y0_N4END[10]
+ Tile_X1Y0_N4END[11] Tile_X1Y0_N4END[12] Tile_X1Y0_N4END[13] Tile_X1Y0_N4END[14]
+ Tile_X1Y0_N4END[15] Tile_X1Y0_N4END[1] Tile_X1Y0_N4END[2] Tile_X1Y0_N4END[3] Tile_X1Y0_N4END[4]
+ Tile_X1Y0_N4END[5] Tile_X1Y0_N4END[6] Tile_X1Y0_N4END[7] Tile_X1Y0_N4END[8] Tile_X1Y0_N4END[9]
+ Tile_X1Y0_NN4END[0] Tile_X1Y0_NN4END[10] Tile_X1Y0_NN4END[11] Tile_X1Y0_NN4END[12]
+ Tile_X1Y0_NN4END[13] Tile_X1Y0_NN4END[14] Tile_X1Y0_NN4END[15] Tile_X1Y0_NN4END[1]
+ Tile_X1Y0_NN4END[2] Tile_X1Y0_NN4END[3] Tile_X1Y0_NN4END[4] Tile_X1Y0_NN4END[5]
+ Tile_X1Y0_NN4END[6] Tile_X1Y0_NN4END[7] Tile_X1Y0_NN4END[8] Tile_X1Y0_NN4END[9]
+ Tile_X1Y0_S1BEG[0] Tile_X1Y0_S1BEG[1] Tile_X1Y0_S1BEG[2] Tile_X1Y0_S1BEG[3] Tile_X1Y0_S2BEG[0]
+ Tile_X1Y0_S2BEG[1] Tile_X1Y0_S2BEG[2] Tile_X1Y0_S2BEG[3] Tile_X1Y0_S2BEG[4] Tile_X1Y0_S2BEG[5]
+ Tile_X1Y0_S2BEG[6] Tile_X1Y0_S2BEG[7] Tile_X1Y0_S2BEGb[0] Tile_X1Y0_S2BEGb[1] Tile_X1Y0_S2BEGb[2]
+ Tile_X1Y0_S2BEGb[3] Tile_X1Y0_S2BEGb[4] Tile_X1Y0_S2BEGb[5] Tile_X1Y0_S2BEGb[6]
+ Tile_X1Y0_S2BEGb[7] Tile_X1Y0_S4BEG[0] Tile_X1Y0_S4BEG[10] Tile_X1Y0_S4BEG[11] Tile_X1Y0_S4BEG[12]
+ Tile_X1Y0_S4BEG[13] Tile_X1Y0_S4BEG[14] Tile_X1Y0_S4BEG[15] Tile_X1Y0_S4BEG[1] Tile_X1Y0_S4BEG[2]
+ Tile_X1Y0_S4BEG[3] Tile_X1Y0_S4BEG[4] Tile_X1Y0_S4BEG[5] Tile_X1Y0_S4BEG[6] Tile_X1Y0_S4BEG[7]
+ Tile_X1Y0_S4BEG[8] Tile_X1Y0_S4BEG[9] Tile_X1Y0_SS4BEG[0] Tile_X1Y0_SS4BEG[10] Tile_X1Y0_SS4BEG[11]
+ Tile_X1Y0_SS4BEG[12] Tile_X1Y0_SS4BEG[13] Tile_X1Y0_SS4BEG[14] Tile_X1Y0_SS4BEG[15]
+ Tile_X1Y0_SS4BEG[1] Tile_X1Y0_SS4BEG[2] Tile_X1Y0_SS4BEG[3] Tile_X1Y0_SS4BEG[4]
+ Tile_X1Y0_SS4BEG[5] Tile_X1Y0_SS4BEG[6] Tile_X1Y0_SS4BEG[7] Tile_X1Y0_SS4BEG[8]
+ Tile_X1Y0_SS4BEG[9] Tile_X1Y0_UserCLKo VGND VPWR
XANTENNA__308__X Tile_X1Y0_FrameData_O[4] VPWR VGND sg13cmos5l_antennanp
XFILLER_10_317 VPWR VGND sg13cmos5l_fill_2
XFILLER_7_7 VPWR VGND sg13cmos5l_decap_8
XFILLER_18_417 VPWR VGND sg13cmos5l_decap_4
XANTENNA_202 Tile_X0Y0_FrameData[13] VPWR VGND sg13cmos5l_antennanp
XANTENNA_213 Tile_X0Y0_FrameData[24] VPWR VGND sg13cmos5l_antennanp
XANTENNA_224 Tile_X0Y0_FrameData[30] VPWR VGND sg13cmos5l_antennanp
XANTENNA__218__X Tile_X1Y0_S2BEG[7] VPWR VGND sg13cmos5l_antennanp
XFILLER_13_133 VPWR VGND sg13cmos5l_decap_8
XFILLER_10_873 VPWR VGND sg13cmos5l_decap_8
X_294_ Tile_X0Y0_SS4BEG[10] Tile_X0Y0_NN4END[5] VPWR VGND sg13cmos5l_buf_1
X_363_ Tile_X1Y0_FrameStrobe_O[7] Tile_X1Y0_FrameStrobe[7] VPWR VGND sg13cmos5l_buf_1
XFILLER_9_148 VPWR VGND sg13cmos5l_decap_8
XFILLER_3_56 VPWR VGND sg13cmos5l_decap_8
XFILLER_1_560 VPWR VGND sg13cmos5l_fill_1
XFILLER_18_951 VPWR VGND sg13cmos5l_decap_8
XFILLER_17_483 VPWR VGND sg13cmos5l_decap_8
XFILLER_10_114 VPWR VGND sg13cmos5l_decap_8
XFILLER_11_648 VPWR VGND sg13cmos5l_decap_8
XFILLER_12_21 VPWR VGND sg13cmos5l_decap_8
XFILLER_7_619 VPWR VGND sg13cmos5l_decap_8
XFILLER_12_98 VPWR VGND sg13cmos5l_decap_8
XFILLER_3_803 VPWR VGND sg13cmos5l_fill_2
XFILLER_14_420 VPWR VGND sg13cmos5l_decap_8
XFILLER_14_497 VPWR VGND sg13cmos5l_decap_8
X_346_ Tile_X0Y0_FrameStrobe_O[10] Tile_X0Y0_FrameStrobe[10] VPWR VGND sg13cmos5l_buf_1
XFILLER_10_681 VPWR VGND sg13cmos5l_decap_8
X_277_ Tile_X0Y0_S4BEG[9] Tile_X0Y0_N4END[6] VPWR VGND sg13cmos5l_buf_1
XFILLER_6_652 VPWR VGND sg13cmos5l_decap_8
XFILLER_5_140 VPWR VGND sg13cmos5l_decap_8
XFILLER_17_280 VPWR VGND sg13cmos5l_decap_8
XANTENNA__321__X Tile_X1Y0_FrameData_O[17] VPWR VGND sg13cmos5l_antennanp
XFILLER_15_217 VPWR VGND sg13cmos5l_decap_8
XFILLER_16_718 VPWR VGND sg13cmos5l_decap_8
X_200_ Tile_X0Y0_S2BEG[1] Tile_X0Y0_N2MID[6] VPWR VGND sg13cmos5l_buf_1
XFILLER_11_467 VPWR VGND sg13cmos5l_decap_8
X_062_ _062_/Q Tile_X0Y0_FrameData[8] VGND VPWR Tile_X0Y0_FrameStrobe[0] latch
X_131_ NPU_QUANT_SHIFT_IN16 Tile_X0Y0_UserCLK _381_/X _153_/L_HI VPWR VGND sg13cmos5l_dfrbpq_1
XFILLER_8_906 VPWR VGND sg13cmos5l_decap_8
XFILLER_7_405 VPWR VGND sg13cmos5l_decap_8
XANTENNA__231__X Tile_X1Y0_S4BEG[4] VPWR VGND sg13cmos5l_antennanp
XFILLER_2_176 VPWR VGND sg13cmos5l_decap_4
XFILLER_14_294 VPWR VGND sg13cmos5l_decap_8
XFILLER_15_740 VPWR VGND sg13cmos5l_decap_8
XFILLER_9_99 VPWR VGND sg13cmos5l_decap_8
X_329_ Tile_X1Y0_FrameData_O[25] Tile_X0Y0_FrameData[25] VPWR VGND sg13cmos5l_buf_1
XFILLER_9_22 VPWR VGND sg13cmos5l_decap_8
XANTENNA__316__X Tile_X1Y0_FrameData_O[12] VPWR VGND sg13cmos5l_antennanp
XFILLER_16_504 VPWR VGND sg13cmos5l_decap_8
XFILLER_18_42 VPWR VGND sg13cmos5l_decap_8
XANTENNA__226__X Tile_X1Y0_S2BEGb[7] VPWR VGND sg13cmos5l_antennanp
XFILLER_11_231 VPWR VGND sg13cmos5l_decap_8
XFILLER_12_776 VPWR VGND sg13cmos5l_decap_8
X_045_ _045_/Q Tile_X0Y0_FrameData[25] VGND VPWR Tile_X0Y0_FrameStrobe[0] latch
X_114_ _114_/Q Tile_X0Y0_FrameData[25] VGND VPWR Tile_X1Y0_FrameStrobe[1] latch
XFILLER_7_224 VPWR VGND sg13cmos5l_decap_8
XFILLER_3_485 VPWR VGND sg13cmos5l_decap_4
XFILLER_13_518 VPWR VGND sg13cmos5l_decap_8
XFILLER_5_706 VPWR VGND sg13cmos5l_fill_2
XFILLER_1_901 VPWR VGND sg13cmos5l_decap_8
XFILLER_0_466 VPWR VGND sg13cmos5l_decap_8
XFILLER_16_301 VPWR VGND sg13cmos5l_decap_8
XFILLER_16_378 VPWR VGND sg13cmos5l_decap_8
XFILLER_17_879 VPWR VGND sg13cmos5l_decap_8
XFILLER_17_802 VPWR VGND sg13cmos5l_decap_8
XFILLER_8_522 VPWR VGND sg13cmos5l_decap_8
XANTENNA_5 Tile_X0Y0_FrameData[0] VPWR VGND sg13cmos5l_antennanp
XFILLER_8_599 VPWR VGND sg13cmos5l_decap_8
XFILLER_6_56 VPWR VGND sg13cmos5l_decap_8
XFILLER_13_315 VPWR VGND sg13cmos5l_decap_8
XFILLER_14_816 VPWR VGND sg13cmos5l_decap_8
XFILLER_15_21 VPWR VGND sg13cmos5l_decap_8
XFILLER_15_98 VPWR VGND sg13cmos5l_decap_8
XFILLER_1_731 VPWR VGND sg13cmos5l_decap_4
XFILLER_1_775 VPWR VGND sg13cmos5l_fill_1
XFILLER_16_175 VPWR VGND sg13cmos5l_decap_8
XFILLER_17_676 VPWR VGND sg13cmos5l_decap_8
XFILLER_12_392 VPWR VGND sg13cmos5l_decap_8
XFILLER_11_0 VPWR VGND sg13cmos5l_decap_8
XFILLER_10_329 VPWR VGND sg13cmos5l_decap_8
XFILLER_11_808 VPWR VGND sg13cmos5l_fill_2
XANTENNA__324__X Tile_X1Y0_FrameData_O[20] VPWR VGND sg13cmos5l_antennanp
XFILLER_2_539 VPWR VGND sg13cmos5l_decap_8
XANTENNA_203 Tile_X0Y0_FrameData[13] VPWR VGND sg13cmos5l_antennanp
XANTENNA_214 Tile_X0Y0_FrameData[24] VPWR VGND sg13cmos5l_antennanp
XANTENNA_225 Tile_X0Y0_FrameData[30] VPWR VGND sg13cmos5l_antennanp
XFILLER_13_112 VPWR VGND sg13cmos5l_decap_8
XFILLER_14_602 VPWR VGND sg13cmos5l_decap_8
XFILLER_14_613 VPWR VGND sg13cmos5l_fill_1
XFILLER_14_624 VPWR VGND sg13cmos5l_decap_8
X_362_ Tile_X1Y0_FrameStrobe_O[6] Tile_X1Y0_FrameStrobe[6] VPWR VGND sg13cmos5l_buf_1
XANTENNA__234__X Tile_X1Y0_S4BEG[7] VPWR VGND sg13cmos5l_antennanp
XFILLER_10_863 VPWR VGND sg13cmos5l_decap_8
XFILLER_13_189 VPWR VGND sg13cmos5l_decap_8
X_293_ Tile_X0Y0_SS4BEG[9] Tile_X0Y0_NN4END[6] VPWR VGND sg13cmos5l_buf_1
XFILLER_9_127 VPWR VGND sg13cmos5l_decap_8
XFILLER_3_35 VPWR VGND sg13cmos5l_decap_8
XFILLER_17_462 VPWR VGND sg13cmos5l_decap_8
XFILLER_8_182 VPWR VGND sg13cmos5l_decap_8
XANTENNA__319__X Tile_X1Y0_FrameData_O[15] VPWR VGND sg13cmos5l_antennanp
XFILLER_11_627 VPWR VGND sg13cmos5l_decap_8
XFILLER_12_77 VPWR VGND sg13cmos5l_decap_8
XFILLER_6_119 VPWR VGND sg13cmos5l_decap_8
XANTENNA__229__X Tile_X1Y0_S4BEG[2] VPWR VGND sg13cmos5l_antennanp
XFILLER_15_922 VPWR VGND sg13cmos5l_decap_8
XFILLER_14_476 VPWR VGND sg13cmos5l_decap_8
X_276_ Tile_X0Y0_S4BEG[8] Tile_X0Y0_N4END[7] VPWR VGND sg13cmos5l_buf_1
X_345_ Tile_X0Y0_FrameStrobe_O[9] Tile_X0Y0_FrameStrobe[9] VPWR VGND sg13cmos5l_buf_1
XFILLER_10_660 VPWR VGND sg13cmos5l_decap_8
XFILLER_6_686 VPWR VGND sg13cmos5l_decap_8
XFILLER_5_196 VPWR VGND sg13cmos5l_decap_8
XFILLER_11_446 VPWR VGND sg13cmos5l_decap_8
XFILLER_12_925 VPWR VGND sg13cmos5l_fill_2
XFILLER_12_958 VPWR VGND sg13cmos5l_fill_2
X_130_ NPU_QUANT_SHIFT_IN15 Tile_X0Y0_UserCLK _380_/X _154_/L_HI VPWR VGND sg13cmos5l_dfrbpq_1
X_061_ _061_/Q Tile_X0Y0_FrameData[9] VGND VPWR Tile_X0Y0_FrameStrobe[0] latch
XFILLER_3_601 VPWR VGND sg13cmos5l_fill_2
XFILLER_0_25 VPWR VGND sg13cmos5l_fill_2
XFILLER_0_36 VPWR VGND sg13cmos5l_fill_1
XFILLER_0_47 VPWR VGND sg13cmos5l_fill_2
XFILLER_14_273 VPWR VGND sg13cmos5l_decap_8
XFILLER_15_796 VPWR VGND sg13cmos5l_decap_8
XFILLER_9_78 VPWR VGND sg13cmos5l_decap_8
X_259_ Tile_X1Y0_UserCLKo Tile_X0Y0_UserCLK VPWR VGND sg13cmos5l_buf_1
X_328_ Tile_X1Y0_FrameData_O[24] Tile_X0Y0_FrameData[24] VPWR VGND sg13cmos5l_buf_1
XFILLER_6_494 VPWR VGND sg13cmos5l_decap_4
XFILLER_18_590 VPWR VGND sg13cmos5l_decap_4
XANTENNA__332__X Tile_X1Y0_FrameData_O[28] VPWR VGND sg13cmos5l_antennanp
XFILLER_18_98 VPWR VGND sg13cmos5l_decap_8
XFILLER_18_21 VPWR VGND sg13cmos5l_decap_8
XFILLER_11_210 VPWR VGND sg13cmos5l_decap_8
XFILLER_11_287 VPWR VGND sg13cmos5l_decap_8
XFILLER_12_755 VPWR VGND sg13cmos5l_decap_8
X_113_ _113_/Q Tile_X0Y0_FrameData[31] VGND VPWR Tile_X1Y0_FrameStrobe[0] latch
XFILLER_8_748 VPWR VGND sg13cmos5l_decap_8
XFILLER_8_704 VPWR VGND sg13cmos5l_decap_4
XFILLER_7_203 VPWR VGND sg13cmos5l_decap_8
XANTENNA__242__X Tile_X1Y0_S4BEG[15] VPWR VGND sg13cmos5l_antennanp
X_044_ _044_/Q Tile_X0Y0_FrameData[26] VGND VPWR Tile_X0Y0_FrameStrobe[0] latch
XFILLER_15_7 VPWR VGND sg13cmos5l_decap_8
XFILLER_15_560 VPWR VGND sg13cmos5l_decap_8
XFILLER_6_280 VPWR VGND sg13cmos5l_decap_8
XANTENNA__327__X Tile_X1Y0_FrameData_O[23] VPWR VGND sg13cmos5l_antennanp
XFILLER_1_957 VPWR VGND sg13cmos5l_fill_2
XANTENNA__237__X Tile_X1Y0_S4BEG[10] VPWR VGND sg13cmos5l_antennanp
XFILLER_16_357 VPWR VGND sg13cmos5l_decap_8
XFILLER_17_858 VPWR VGND sg13cmos5l_decap_8
XANTENNA_6 Tile_X0Y0_FrameData[0] VPWR VGND sg13cmos5l_antennanp
XFILLER_12_574 VPWR VGND sg13cmos5l_decap_8
XFILLER_12_585 VPWR VGND sg13cmos5l_decap_4
XFILLER_8_578 VPWR VGND sg13cmos5l_decap_8
XFILLER_8_501 VPWR VGND sg13cmos5l_decap_8
XFILLER_6_35 VPWR VGND sg13cmos5l_decap_8
XFILLER_4_795 VPWR VGND sg13cmos5l_fill_2
XFILLER_4_784 VPWR VGND sg13cmos5l_decap_8
XFILLER_3_250 VPWR VGND sg13cmos5l_decap_4
XFILLER_15_77 VPWR VGND sg13cmos5l_decap_8
XFILLER_1_710 VPWR VGND sg13cmos5l_decap_4
XFILLER_17_655 VPWR VGND sg13cmos5l_decap_8
XFILLER_12_371 VPWR VGND sg13cmos5l_decap_8
XFILLER_13_883 VPWR VGND sg13cmos5l_decap_8
XFILLER_16_154 VPWR VGND sg13cmos5l_decap_8
XFILLER_9_843 VPWR VGND sg13cmos5l_fill_1
XFILLER_4_592 VPWR VGND sg13cmos5l_decap_8
XANTENNA__340__X Tile_X0Y0_FrameStrobe_O[4] VPWR VGND sg13cmos5l_antennanp
XFILLER_2_518 VPWR VGND sg13cmos5l_decap_8
XFILLER_2_507 VPWR VGND sg13cmos5l_decap_4
XANTENNA_204 Tile_X0Y0_FrameData[13] VPWR VGND sg13cmos5l_antennanp
XANTENNA_215 Tile_X0Y0_FrameData[24] VPWR VGND sg13cmos5l_antennanp
XANTENNA_226 Tile_X0Y0_FrameData[30] VPWR VGND sg13cmos5l_antennanp
XFILLER_13_168 VPWR VGND sg13cmos5l_decap_8
XFILLER_14_669 VPWR VGND sg13cmos5l_decap_8
X_292_ Tile_X0Y0_SS4BEG[8] Tile_X0Y0_NN4END[7] VPWR VGND sg13cmos5l_buf_1
X_361_ Tile_X1Y0_FrameStrobe_O[5] Tile_X1Y0_FrameStrobe[5] VPWR VGND sg13cmos5l_buf_1
XFILLER_9_106 VPWR VGND sg13cmos5l_decap_8
XFILLER_10_842 VPWR VGND sg13cmos5l_fill_2
XANTENNA__250__X Tile_X1Y0_SS4BEG[7] VPWR VGND sg13cmos5l_antennanp
XFILLER_3_14 VPWR VGND sg13cmos5l_decap_8
XFILLER_1_573 VPWR VGND sg13cmos5l_decap_8
XFILLER_17_441 VPWR VGND sg13cmos5l_decap_8
XFILLER_8_161 VPWR VGND sg13cmos5l_decap_8
XFILLER_11_606 VPWR VGND sg13cmos5l_decap_8
XANTENNA__335__X Tile_X1Y0_FrameData_O[31] VPWR VGND sg13cmos5l_antennanp
XFILLER_10_149 VPWR VGND sg13cmos5l_decap_8
XFILLER_12_56 VPWR VGND sg13cmos5l_decap_8
XFILLER_15_901 VPWR VGND sg13cmos5l_decap_8
XFILLER_18_249 VPWR VGND sg13cmos5l_decap_8
XFILLER_18_238 VPWR VGND sg13cmos5l_fill_1
XFILLER_18_227 VPWR VGND sg13cmos5l_decap_8
XANTENNA__245__X Tile_X1Y0_SS4BEG[2] VPWR VGND sg13cmos5l_antennanp
XFILLER_14_455 VPWR VGND sg13cmos5l_decap_8
X_275_ Tile_X0Y0_S4BEG[7] Tile_X0Y0_N4END[8] VPWR VGND sg13cmos5l_buf_1
X_344_ Tile_X0Y0_FrameStrobe_O[8] Tile_X0Y0_FrameStrobe[8] VPWR VGND sg13cmos5l_buf_1
XFILLER_5_175 VPWR VGND sg13cmos5l_decap_8
XFILLER_2_893 VPWR VGND sg13cmos5l_decap_8
XFILLER_18_794 VPWR VGND sg13cmos5l_decap_8
XFILLER_0_808 VPWR VGND sg13cmos5l_fill_1
XFILLER_4_90 VPWR VGND sg13cmos5l_decap_8
XFILLER_11_425 VPWR VGND sg13cmos5l_decap_8
XFILLER_12_904 VPWR VGND sg13cmos5l_decap_8
X_060_ _060_/Q Tile_X0Y0_FrameData[10] VGND VPWR Tile_X0Y0_FrameStrobe[0] latch
XFILLER_3_624 VPWR VGND sg13cmos5l_decap_8
XFILLER_2_101 VPWR VGND sg13cmos5l_decap_8
XFILLER_14_252 VPWR VGND sg13cmos5l_decap_8
XFILLER_15_775 VPWR VGND sg13cmos5l_decap_8
X_189_ Tile_X1Y0_FrameStrobe_O[10] Tile_X1Y0_FrameStrobe[10] VPWR VGND sg13cmos5l_buf_1
X_258_ Tile_X1Y0_SS4BEG[15] Tile_X1Y0_NN4END[0] VPWR VGND sg13cmos5l_buf_1
X_327_ Tile_X1Y0_FrameData_O[23] Tile_X0Y0_FrameData[23] VPWR VGND sg13cmos5l_buf_1
XFILLER_9_57 VPWR VGND sg13cmos5l_decap_8
XFILLER_6_473 VPWR VGND sg13cmos5l_decap_8
XFILLER_0_638 VPWR VGND sg13cmos5l_decap_8
XFILLER_16_528 VPWR VGND sg13cmos5l_fill_1
XFILLER_18_77 VPWR VGND sg13cmos5l_decap_8
XFILLER_11_266 VPWR VGND sg13cmos5l_decap_8
XFILLER_12_734 VPWR VGND sg13cmos5l_decap_8
X_043_ _043_/Q Tile_X0Y0_FrameData[27] VGND VPWR Tile_X0Y0_FrameStrobe[0] latch
X_112_ _112_/Q Tile_X0Y0_FrameData[26] VGND VPWR Tile_X1Y0_FrameStrobe[1] latch
XFILLER_8_727 VPWR VGND sg13cmos5l_fill_1
XFILLER_7_259 VPWR VGND sg13cmos5l_decap_8
XFILLER_1_0 VPWR VGND sg13cmos5l_decap_8
XANTENNA__343__X Tile_X0Y0_FrameStrobe_O[7] VPWR VGND sg13cmos5l_antennanp
XFILLER_4_229 VPWR VGND sg13cmos5l_decap_8
XFILLER_1_936 VPWR VGND sg13cmos5l_decap_4
XFILLER_17_837 VPWR VGND sg13cmos5l_decap_8
XFILLER_12_553 VPWR VGND sg13cmos5l_decap_8
XFILLER_16_336 VPWR VGND sg13cmos5l_decap_8
XANTENNA_7 Tile_X0Y0_FrameData[0] VPWR VGND sg13cmos5l_antennanp
XANTENNA__253__X Tile_X1Y0_SS4BEG[10] VPWR VGND sg13cmos5l_antennanp
XFILLER_8_557 VPWR VGND sg13cmos5l_decap_8
XFILLER_6_14 VPWR VGND sg13cmos5l_decap_8
XFILLER_4_774 VPWR VGND sg13cmos5l_fill_2
XANTENNA__338__X Tile_X0Y0_FrameStrobe_O[2] VPWR VGND sg13cmos5l_antennanp
XFILLER_15_56 VPWR VGND sg13cmos5l_decap_8
XFILLER_5_538 VPWR VGND sg13cmos5l_decap_8
XFILLER_0_210 VPWR VGND sg13cmos5l_decap_8
XFILLER_0_232 VPWR VGND sg13cmos5l_fill_2
XFILLER_1_799 VPWR VGND sg13cmos5l_decap_8
XANTENNA__248__X Tile_X1Y0_SS4BEG[5] VPWR VGND sg13cmos5l_antennanp
XFILLER_16_133 VPWR VGND sg13cmos5l_decap_8
XFILLER_17_634 VPWR VGND sg13cmos5l_decap_4
XFILLER_12_350 VPWR VGND sg13cmos5l_decap_8
XFILLER_13_862 VPWR VGND sg13cmos5l_decap_8
XFILLER_9_888 VPWR VGND sg13cmos5l_decap_8
XFILLER_4_571 VPWR VGND sg13cmos5l_decap_8
XANTENNA_205 Tile_X0Y0_FrameData[13] VPWR VGND sg13cmos5l_antennanp
XANTENNA_216 Tile_X0Y0_FrameData[29] VPWR VGND sg13cmos5l_antennanp
XANTENNA_227 Tile_X0Y0_FrameData[30] VPWR VGND sg13cmos5l_antennanp
XFILLER_13_147 VPWR VGND sg13cmos5l_decap_8
XFILLER_14_648 VPWR VGND sg13cmos5l_decap_4
X_291_ Tile_X0Y0_SS4BEG[7] Tile_X0Y0_NN4END[8] VPWR VGND sg13cmos5l_buf_1
X_360_ Tile_X1Y0_FrameStrobe_O[4] Tile_X1Y0_FrameStrobe[4] VPWR VGND sg13cmos5l_buf_1
XFILLER_10_887 VPWR VGND sg13cmos5l_decap_8
XFILLER_1_541 VPWR VGND sg13cmos5l_fill_2
XFILLER_1_530 VPWR VGND sg13cmos5l_decap_4
XFILLER_18_921 VPWR VGND sg13cmos5l_decap_8
XFILLER_17_497 VPWR VGND sg13cmos5l_decap_8
XFILLER_17_420 VPWR VGND sg13cmos5l_decap_8
XFILLER_9_652 VPWR VGND sg13cmos5l_decap_8
XFILLER_8_140 VPWR VGND sg13cmos5l_decap_8
XFILLER_10_128 VPWR VGND sg13cmos5l_decap_8
XANTENNA__351__X Tile_X0Y0_FrameStrobe_O[15] VPWR VGND sg13cmos5l_antennanp
XFILLER_12_35 VPWR VGND sg13cmos5l_decap_8
XFILLER_5_7 VPWR VGND sg13cmos5l_decap_8
XFILLER_18_206 VPWR VGND sg13cmos5l_decap_8
XFILLER_14_434 VPWR VGND sg13cmos5l_decap_8
XFILLER_10_695 VPWR VGND sg13cmos5l_decap_8
X_274_ Tile_X0Y0_S4BEG[6] Tile_X0Y0_N4END[9] VPWR VGND sg13cmos5l_buf_1
X_343_ Tile_X0Y0_FrameStrobe_O[7] Tile_X0Y0_FrameStrobe[7] VPWR VGND sg13cmos5l_buf_1
XANTENNA__261__X Tile_X0Y0_S2BEGb[1] VPWR VGND sg13cmos5l_antennanp
XFILLER_6_666 VPWR VGND sg13cmos5l_fill_2
XFILLER_5_154 VPWR VGND sg13cmos5l_decap_8
XFILLER_2_872 VPWR VGND sg13cmos5l_decap_8
XFILLER_1_382 VPWR VGND sg13cmos5l_fill_1
XFILLER_18_773 VPWR VGND sg13cmos5l_decap_8
XFILLER_17_294 VPWR VGND sg13cmos5l_decap_8
XFILLER_9_493 VPWR VGND sg13cmos5l_fill_1
XANTENNA__120__Q NPU_QUANT_SHIFT_IN5 VPWR VGND sg13cmos5l_antennanp
XANTENNA__346__X Tile_X0Y0_FrameStrobe_O[10] VPWR VGND sg13cmos5l_antennanp
XFILLER_11_404 VPWR VGND sg13cmos5l_decap_8
XFILLER_12_927 VPWR VGND sg13cmos5l_fill_1
XFILLER_7_419 VPWR VGND sg13cmos5l_decap_8
XFILLER_3_636 VPWR VGND sg13cmos5l_decap_8
XFILLER_2_157 VPWR VGND sg13cmos5l_fill_2
XFILLER_2_135 VPWR VGND sg13cmos5l_decap_8
XFILLER_2_124 VPWR VGND sg13cmos5l_fill_1
XFILLER_2_113 VPWR VGND sg13cmos5l_decap_8
XFILLER_0_27 VPWR VGND sg13cmos5l_fill_1
XANTENNA__256__X Tile_X1Y0_SS4BEG[13] VPWR VGND sg13cmos5l_antennanp
XFILLER_14_231 VPWR VGND sg13cmos5l_decap_8
XFILLER_15_754 VPWR VGND sg13cmos5l_decap_8
X_326_ Tile_X1Y0_FrameData_O[22] Tile_X0Y0_FrameData[22] VPWR VGND sg13cmos5l_buf_1
XFILLER_9_36 VPWR VGND sg13cmos5l_decap_8
XFILLER_9_14 VPWR VGND sg13cmos5l_decap_4
XFILLER_10_492 VPWR VGND sg13cmos5l_decap_8
X_188_ Tile_X1Y0_FrameStrobe_O[9] Tile_X1Y0_FrameStrobe[9] VPWR VGND sg13cmos5l_buf_1
X_257_ Tile_X1Y0_SS4BEG[14] Tile_X1Y0_NN4END[1] VPWR VGND sg13cmos5l_buf_1
XFILLER_6_452 VPWR VGND sg13cmos5l_decap_8
XANTENNA__115__Q NPU_QUANT_SHIFT_IN0 VPWR VGND sg13cmos5l_antennanp
XFILLER_18_56 VPWR VGND sg13cmos5l_decap_8
XFILLER_12_713 VPWR VGND sg13cmos5l_decap_8
XFILLER_16_518 VPWR VGND sg13cmos5l_fill_2
XFILLER_11_245 VPWR VGND sg13cmos5l_decap_8
X_042_ _042_/Q Tile_X0Y0_FrameData[28] VGND VPWR Tile_X0Y0_FrameStrobe[0] latch
X_111_ _111_/Q Tile_X0Y0_FrameData[27] VGND VPWR Tile_X1Y0_FrameStrobe[1] latch
XFILLER_7_238 VPWR VGND sg13cmos5l_decap_8
XFILLER_4_923 VPWR VGND sg13cmos5l_decap_4
XFILLER_3_422 VPWR VGND sg13cmos5l_fill_2
XFILLER_15_584 VPWR VGND sg13cmos5l_decap_8
X_309_ Tile_X1Y0_FrameData_O[5] Tile_X0Y0_FrameData[5] VPWR VGND sg13cmos5l_buf_1
XFILLER_11_790 VPWR VGND sg13cmos5l_fill_1
XFILLER_4_208 VPWR VGND sg13cmos5l_decap_8
XFILLER_1_959 VPWR VGND sg13cmos5l_fill_1
XFILLER_1_948 VPWR VGND sg13cmos5l_decap_4
XFILLER_1_915 VPWR VGND sg13cmos5l_decap_8
XFILLER_16_315 VPWR VGND sg13cmos5l_decap_8
XFILLER_17_816 VPWR VGND sg13cmos5l_decap_8
XFILLER_12_532 VPWR VGND sg13cmos5l_decap_8
XFILLER_8_536 VPWR VGND sg13cmos5l_decap_8
XANTENNA_8 Tile_X0Y0_FrameData[0] VPWR VGND sg13cmos5l_antennanp
XFILLER_16_893 VPWR VGND sg13cmos5l_decap_8
XFILLER_15_392 VPWR VGND sg13cmos5l_decap_8
XFILLER_7_591 VPWR VGND sg13cmos5l_decap_8
XANTENNA__354__X Tile_X0Y0_FrameStrobe_O[18] VPWR VGND sg13cmos5l_antennanp
XFILLER_13_329 VPWR VGND sg13cmos5l_decap_8
XFILLER_15_35 VPWR VGND sg13cmos5l_decap_8
XFILLER_16_112 VPWR VGND sg13cmos5l_decap_8
XFILLER_16_189 VPWR VGND sg13cmos5l_decap_8
XFILLER_17_613 VPWR VGND sg13cmos5l_decap_8
XANTENNA__264__X Tile_X0Y0_S2BEGb[4] VPWR VGND sg13cmos5l_antennanp
XFILLER_13_841 VPWR VGND sg13cmos5l_decap_8
XFILLER_16_690 VPWR VGND sg13cmos5l_decap_8
XANTENNA__123__Q NPU_QUANT_SHIFT_IN8 VPWR VGND sg13cmos5l_antennanp
XFILLER_7_91 VPWR VGND sg13cmos5l_decap_8
XANTENNA_206 Tile_X0Y0_FrameData[13] VPWR VGND sg13cmos5l_antennanp
XANTENNA_217 Tile_X0Y0_FrameData[29] VPWR VGND sg13cmos5l_antennanp
XANTENNA_228 Tile_X1Y0_FrameStrobe[2] VPWR VGND sg13cmos5l_antennanp
XANTENNA__349__X Tile_X0Y0_FrameStrobe_O[13] VPWR VGND sg13cmos5l_antennanp
XFILLER_14_638 VPWR VGND sg13cmos5l_decap_4
XFILLER_10_844 VPWR VGND sg13cmos5l_fill_1
XFILLER_13_126 VPWR VGND sg13cmos5l_decap_8
X_290_ Tile_X0Y0_SS4BEG[6] Tile_X0Y0_NN4END[9] VPWR VGND sg13cmos5l_buf_1
XFILLER_1_553 VPWR VGND sg13cmos5l_decap_8
XANTENNA__259__X Tile_X1Y0_UserCLKo VPWR VGND sg13cmos5l_antennanp
XFILLER_3_49 VPWR VGND sg13cmos5l_decap_8
XFILLER_1_564 VPWR VGND sg13cmos5l_fill_2
XFILLER_18_944 VPWR VGND sg13cmos5l_decap_8
XFILLER_18_900 VPWR VGND sg13cmos5l_decap_8
XFILLER_17_476 VPWR VGND sg13cmos5l_decap_8
XFILLER_13_693 VPWR VGND sg13cmos5l_decap_8
XFILLER_9_697 VPWR VGND sg13cmos5l_decap_8
XFILLER_9_631 VPWR VGND sg13cmos5l_decap_8
XFILLER_8_196 VPWR VGND sg13cmos5l_decap_8
XFILLER_5_892 VPWR VGND sg13cmos5l_decap_8
XANTENNA__118__Q NPU_QUANT_SHIFT_IN3 VPWR VGND sg13cmos5l_antennanp
XFILLER_10_107 VPWR VGND sg13cmos5l_decap_8
XFILLER_12_14 VPWR VGND sg13cmos5l_decap_8
XFILLER_3_829 VPWR VGND sg13cmos5l_decap_4
XFILLER_14_413 VPWR VGND sg13cmos5l_decap_8
XFILLER_15_936 VPWR VGND sg13cmos5l_fill_1
XFILLER_15_958 VPWR VGND sg13cmos5l_fill_2
X_342_ Tile_X0Y0_FrameStrobe_O[6] Tile_X0Y0_FrameStrobe[6] VPWR VGND sg13cmos5l_buf_1
XFILLER_10_674 VPWR VGND sg13cmos5l_decap_8
X_273_ Tile_X0Y0_S4BEG[5] Tile_X0Y0_N4END[10] VPWR VGND sg13cmos5l_buf_1
XFILLER_6_645 VPWR VGND sg13cmos5l_decap_8
XFILLER_5_133 VPWR VGND sg13cmos5l_decap_8
XFILLER_18_752 VPWR VGND sg13cmos5l_decap_8
XFILLER_17_273 VPWR VGND sg13cmos5l_decap_8
XFILLER_13_490 VPWR VGND sg13cmos5l_decap_8
XFILLER_9_472 VPWR VGND sg13cmos5l_decap_8
XANTENNA__362__X Tile_X1Y0_FrameStrobe_O[6] VPWR VGND sg13cmos5l_antennanp
XFILLER_2_169 VPWR VGND sg13cmos5l_decap_8
XFILLER_14_210 VPWR VGND sg13cmos5l_decap_8
XFILLER_14_287 VPWR VGND sg13cmos5l_decap_8
XFILLER_15_733 VPWR VGND sg13cmos5l_decap_8
X_325_ Tile_X1Y0_FrameData_O[21] Tile_X0Y0_FrameData[21] VPWR VGND sg13cmos5l_buf_1
XANTENNA__272__X Tile_X0Y0_S4BEG[4] VPWR VGND sg13cmos5l_antennanp
XFILLER_10_471 VPWR VGND sg13cmos5l_decap_8
X_187_ _187_/L_HI VPWR VGND sg13cmos5l_tiehi
X_256_ Tile_X1Y0_SS4BEG[13] Tile_X1Y0_NN4END[2] VPWR VGND sg13cmos5l_buf_1
XFILLER_6_431 VPWR VGND sg13cmos5l_decap_8
XANTENNA__131__Q NPU_QUANT_SHIFT_IN16 VPWR VGND sg13cmos5l_antennanp
XFILLER_0_618 VPWR VGND sg13cmos5l_fill_2
XANTENNA__357__X Tile_X1Y0_FrameStrobe_O[1] VPWR VGND sg13cmos5l_antennanp
XFILLER_18_35 VPWR VGND sg13cmos5l_decap_8
XFILLER_11_224 VPWR VGND sg13cmos5l_decap_8
XFILLER_12_769 VPWR VGND sg13cmos5l_decap_8
X_110_ _110_/Q Tile_X0Y0_FrameData[28] VGND VPWR Tile_X1Y0_FrameStrobe[1] latch
X_041_ _041_/Q Tile_X0Y0_FrameData[29] VGND VPWR Tile_X0Y0_FrameStrobe[0] latch
XFILLER_7_217 VPWR VGND sg13cmos5l_decap_8
XFILLER_4_902 VPWR VGND sg13cmos5l_decap_8
XFILLER_3_489 VPWR VGND sg13cmos5l_fill_1
XFILLER_3_478 VPWR VGND sg13cmos5l_decap_8
XANTENNA__267__X Tile_X0Y0_S2BEGb[7] VPWR VGND sg13cmos5l_antennanp
XFILLER_15_574 VPWR VGND sg13cmos5l_decap_4
X_239_ Tile_X1Y0_S4BEG[12] Tile_X1Y0_N4END[3] VPWR VGND sg13cmos5l_buf_1
X_308_ Tile_X1Y0_FrameData_O[4] Tile_X0Y0_FrameData[4] VPWR VGND sg13cmos5l_buf_1
XFILLER_7_751 VPWR VGND sg13cmos5l_decap_8
XANTENNA__126__Q NPU_QUANT_SHIFT_IN11 VPWR VGND sg13cmos5l_antennanp
XFILLER_12_511 VPWR VGND sg13cmos5l_decap_8
XFILLER_8_515 VPWR VGND sg13cmos5l_decap_8
XANTENNA_9 Tile_X0Y0_FrameData[0] VPWR VGND sg13cmos5l_antennanp
XFILLER_6_49 VPWR VGND sg13cmos5l_decap_8
XFILLER_4_776 VPWR VGND sg13cmos5l_fill_1
XFILLER_13_7 VPWR VGND sg13cmos5l_decap_8
XFILLER_15_371 VPWR VGND sg13cmos5l_decap_8
XFILLER_16_872 VPWR VGND sg13cmos5l_decap_8
XFILLER_7_570 VPWR VGND sg13cmos5l_decap_8
XFILLER_14_809 VPWR VGND sg13cmos5l_decap_8
XFILLER_15_14 VPWR VGND sg13cmos5l_decap_8
XFILLER_13_308 VPWR VGND sg13cmos5l_decap_8
XFILLER_1_724 VPWR VGND sg13cmos5l_decap_8
XFILLER_13_820 VPWR VGND sg13cmos5l_decap_8
XFILLER_16_168 VPWR VGND sg13cmos5l_decap_8
XFILLER_17_669 VPWR VGND sg13cmos5l_decap_8
XFILLER_12_385 VPWR VGND sg13cmos5l_decap_8
XFILLER_13_897 VPWR VGND sg13cmos5l_decap_8
XANTENNA__280__X Tile_X0Y0_S4BEG[12] VPWR VGND sg13cmos5l_antennanp
XFILLER_4_540 VPWR VGND sg13cmos5l_decap_8
XFILLER_0_790 VPWR VGND sg13cmos5l_decap_8
XANTENNA__190__X Tile_X1Y0_FrameStrobe_O[11] VPWR VGND sg13cmos5l_antennanp
XFILLER_7_70 VPWR VGND sg13cmos5l_decap_8
XANTENNA_207 Tile_X0Y0_FrameData[14] VPWR VGND sg13cmos5l_antennanp
XANTENNA_218 Tile_X0Y0_FrameData[29] VPWR VGND sg13cmos5l_antennanp
XANTENNA_229 Tile_X1Y0_FrameStrobe[3] VPWR VGND sg13cmos5l_antennanp
XFILLER_13_105 VPWR VGND sg13cmos5l_decap_8
XFILLER_14_617 VPWR VGND sg13cmos5l_decap_8
XFILLER_10_856 VPWR VGND sg13cmos5l_decap_8
XFILLER_5_315 VPWR VGND sg13cmos5l_fill_1
XFILLER_3_28 VPWR VGND sg13cmos5l_decap_8
XFILLER_1_587 VPWR VGND sg13cmos5l_decap_8
XFILLER_17_455 VPWR VGND sg13cmos5l_decap_8
XANTENNA__275__X Tile_X0Y0_S4BEG[7] VPWR VGND sg13cmos5l_antennanp
XFILLER_13_672 VPWR VGND sg13cmos5l_decap_8
XFILLER_9_610 VPWR VGND sg13cmos5l_decap_8
XFILLER_12_182 VPWR VGND sg13cmos5l_decap_8
XFILLER_8_175 VPWR VGND sg13cmos5l_decap_8
XFILLER_4_392 VPWR VGND sg13cmos5l_fill_2
XANTENNA__134__Q NPU_QUANT_SHIFT_IN19 VPWR VGND sg13cmos5l_antennanp
XFILLER_14_469 VPWR VGND sg13cmos5l_decap_8
XFILLER_15_915 VPWR VGND sg13cmos5l_decap_8
X_272_ Tile_X0Y0_S4BEG[4] Tile_X0Y0_N4END[11] VPWR VGND sg13cmos5l_buf_1
X_341_ Tile_X0Y0_FrameStrobe_O[5] Tile_X0Y0_FrameStrobe[5] VPWR VGND sg13cmos5l_buf_1
XFILLER_10_653 VPWR VGND sg13cmos5l_decap_8
XFILLER_6_679 VPWR VGND sg13cmos5l_decap_8
XFILLER_5_189 VPWR VGND sg13cmos5l_decap_8
XFILLER_5_112 VPWR VGND sg13cmos5l_decap_8
XFILLER_2_841 VPWR VGND sg13cmos5l_decap_8
XFILLER_18_731 VPWR VGND sg13cmos5l_decap_8
XFILLER_17_252 VPWR VGND sg13cmos5l_decap_8
XFILLER_9_451 VPWR VGND sg13cmos5l_decap_8
XANTENNA__129__Q NPU_QUANT_SHIFT_IN14 VPWR VGND sg13cmos5l_antennanp
XFILLER_11_439 VPWR VGND sg13cmos5l_decap_8
XFILLER_12_918 VPWR VGND sg13cmos5l_decap_8
XANTENNA__039__Q NPU_PSUM_SKEW_EN VPWR VGND sg13cmos5l_antennanp
XFILLER_0_18 VPWR VGND sg13cmos5l_decap_4
XFILLER_15_712 VPWR VGND sg13cmos5l_decap_4
XFILLER_10_450 VPWR VGND sg13cmos5l_decap_8
XFILLER_14_266 VPWR VGND sg13cmos5l_decap_8
XFILLER_15_789 VPWR VGND sg13cmos5l_decap_8
X_255_ Tile_X1Y0_SS4BEG[12] Tile_X1Y0_NN4END[3] VPWR VGND sg13cmos5l_buf_1
X_324_ Tile_X1Y0_FrameData_O[20] Tile_X0Y0_FrameData[20] VPWR VGND sg13cmos5l_buf_1
XFILLER_7_922 VPWR VGND sg13cmos5l_decap_8
XFILLER_13_91 VPWR VGND sg13cmos5l_decap_8
X_186_ _186_/L_HI VPWR VGND sg13cmos5l_tiehi
XFILLER_6_487 VPWR VGND sg13cmos5l_decap_8
XFILLER_18_594 VPWR VGND sg13cmos5l_fill_1
XFILLER_18_583 VPWR VGND sg13cmos5l_decap_8
XFILLER_9_281 VPWR VGND sg13cmos5l_decap_8
XFILLER_0_608 VPWR VGND sg13cmos5l_decap_4
XFILLER_18_14 VPWR VGND sg13cmos5l_decap_8
XFILLER_11_203 VPWR VGND sg13cmos5l_decap_8
XFILLER_12_748 VPWR VGND sg13cmos5l_decap_8
XFILLER_8_708 VPWR VGND sg13cmos5l_fill_1
X_040_ _040_/Q Tile_X0Y0_FrameData[30] VGND VPWR Tile_X0Y0_FrameStrobe[0] latch
XFILLER_4_958 VPWR VGND sg13cmos5l_fill_2
XFILLER_15_553 VPWR VGND sg13cmos5l_decap_8
XANTENNA__283__X Tile_X0Y0_S4BEG[15] VPWR VGND sg13cmos5l_antennanp
XFILLER_11_781 VPWR VGND sg13cmos5l_fill_1
X_169_ _169_/L_HI VPWR VGND sg13cmos5l_tiehi
X_238_ Tile_X1Y0_S4BEG[11] Tile_X1Y0_N4END[4] VPWR VGND sg13cmos5l_buf_1
X_307_ Tile_X1Y0_FrameData_O[3] Tile_X0Y0_FrameData[3] VPWR VGND sg13cmos5l_buf_1
XFILLER_7_774 VPWR VGND sg13cmos5l_fill_2
XFILLER_6_273 VPWR VGND sg13cmos5l_decap_8
XFILLER_18_380 VPWR VGND sg13cmos5l_decap_8
XANTENNA__193__X Tile_X1Y0_FrameStrobe_O[14] VPWR VGND sg13cmos5l_antennanp
XANTENNA__142__Q NPU_QUANT_SHIFT_IN27 VPWR VGND sg13cmos5l_antennanp
XFILLER_12_567 VPWR VGND sg13cmos5l_decap_8
XFILLER_12_589 VPWR VGND sg13cmos5l_fill_1
XFILLER_6_28 VPWR VGND sg13cmos5l_decap_8
XFILLER_3_254 VPWR VGND sg13cmos5l_fill_2
XFILLER_3_243 VPWR VGND sg13cmos5l_decap_8
XANTENNA__278__X Tile_X0Y0_S4BEG[10] VPWR VGND sg13cmos5l_antennanp
XFILLER_15_350 VPWR VGND sg13cmos5l_decap_8
XFILLER_16_851 VPWR VGND sg13cmos5l_decap_8
XANTENNA__188__X Tile_X1Y0_FrameStrobe_O[9] VPWR VGND sg13cmos5l_antennanp
XANTENNA__137__Q NPU_QUANT_SHIFT_IN22 VPWR VGND sg13cmos5l_antennanp
XFILLER_1_703 VPWR VGND sg13cmos5l_decap_8
XFILLER_13_876 VPWR VGND sg13cmos5l_decap_8
XFILLER_16_147 VPWR VGND sg13cmos5l_decap_8
XFILLER_17_648 VPWR VGND sg13cmos5l_fill_2
XFILLER_12_364 VPWR VGND sg13cmos5l_decap_8
XFILLER_4_585 VPWR VGND sg13cmos5l_decap_8
XANTENNA_208 Tile_X0Y0_FrameData[14] VPWR VGND sg13cmos5l_antennanp
XANTENNA_219 Tile_X0Y0_FrameData[29] VPWR VGND sg13cmos5l_antennanp
XFILLER_18_935 VPWR VGND sg13cmos5l_decap_4
XFILLER_17_434 VPWR VGND sg13cmos5l_decap_8
XANTENNA__291__X Tile_X0Y0_SS4BEG[7] VPWR VGND sg13cmos5l_antennanp
XFILLER_12_161 VPWR VGND sg13cmos5l_decap_8
XFILLER_13_651 VPWR VGND sg13cmos5l_decap_4
XFILLER_16_91 VPWR VGND sg13cmos5l_decap_8
XFILLER_8_154 VPWR VGND sg13cmos5l_decap_8
XFILLER_12_49 VPWR VGND sg13cmos5l_decap_8
XANTENNA__150__Q NPU_QUANT_SHIFT_EN VPWR VGND sg13cmos5l_antennanp
XFILLER_10_632 VPWR VGND sg13cmos5l_decap_8
XFILLER_14_448 VPWR VGND sg13cmos5l_decap_8
X_271_ Tile_X0Y0_S4BEG[3] Tile_X0Y0_N4END[12] VPWR VGND sg13cmos5l_buf_1
X_340_ Tile_X0Y0_FrameStrobe_O[4] Tile_X0Y0_FrameStrobe[4] VPWR VGND sg13cmos5l_buf_1
XFILLER_5_168 VPWR VGND sg13cmos5l_decap_8
XFILLER_2_886 VPWR VGND sg13cmos5l_decap_8
XFILLER_18_710 VPWR VGND sg13cmos5l_decap_8
XANTENNA__286__X Tile_X0Y0_SS4BEG[2] VPWR VGND sg13cmos5l_antennanp
XFILLER_18_787 VPWR VGND sg13cmos5l_decap_8
XFILLER_17_231 VPWR VGND sg13cmos5l_decap_8
XFILLER_9_430 VPWR VGND sg13cmos5l_decap_8
XFILLER_4_83 VPWR VGND sg13cmos5l_decap_8
XANTENNA__196__X Tile_X1Y0_FrameStrobe_O[17] VPWR VGND sg13cmos5l_antennanp
XANTENNA__145__Q NPU_COMPUTE_BANK_SWAP VPWR VGND sg13cmos5l_antennanp
XFILLER_11_418 VPWR VGND sg13cmos5l_decap_8
XFILLER_3_7 VPWR VGND sg13cmos5l_decap_8
XFILLER_3_617 VPWR VGND sg13cmos5l_decap_8
XFILLER_14_245 VPWR VGND sg13cmos5l_decap_8
XFILLER_15_768 VPWR VGND sg13cmos5l_decap_8
XFILLER_13_70 VPWR VGND sg13cmos5l_decap_8
X_185_ _185_/L_HI VPWR VGND sg13cmos5l_tiehi
X_254_ Tile_X1Y0_SS4BEG[11] Tile_X1Y0_NN4END[4] VPWR VGND sg13cmos5l_buf_1
X_323_ Tile_X1Y0_FrameData_O[19] Tile_X0Y0_FrameData[19] VPWR VGND sg13cmos5l_buf_1
XFILLER_7_901 VPWR VGND sg13cmos5l_decap_8
XFILLER_6_466 VPWR VGND sg13cmos5l_decap_8
XFILLER_18_562 VPWR VGND sg13cmos5l_decap_4
XFILLER_9_260 VPWR VGND sg13cmos5l_decap_8
XFILLER_11_259 VPWR VGND sg13cmos5l_decap_8
XFILLER_12_727 VPWR VGND sg13cmos5l_decap_8
XFILLER_15_532 VPWR VGND sg13cmos5l_decap_8
XFILLER_15_598 VPWR VGND sg13cmos5l_decap_8
X_306_ Tile_X1Y0_FrameData_O[2] Tile_X0Y0_FrameData[2] VPWR VGND sg13cmos5l_buf_1
XFILLER_11_760 VPWR VGND sg13cmos5l_decap_8
X_168_ _168_/L_HI VPWR VGND sg13cmos5l_tiehi
X_237_ Tile_X1Y0_S4BEG[10] Tile_X1Y0_N4END[5] VPWR VGND sg13cmos5l_buf_1
XFILLER_7_742 VPWR VGND sg13cmos5l_fill_2
XFILLER_6_252 VPWR VGND sg13cmos5l_decap_8
X_099_ _099_/Q Tile_X0Y0_FrameData[7] VGND VPWR Tile_X1Y0_FrameStrobe[0] latch
XFILLER_1_929 VPWR VGND sg13cmos5l_decap_8
XFILLER_12_546 VPWR VGND sg13cmos5l_decap_8
XFILLER_16_329 VPWR VGND sg13cmos5l_decap_8
XFILLER_0_951 VPWR VGND sg13cmos5l_decap_8
XFILLER_10_93 VPWR VGND sg13cmos5l_decap_8
XFILLER_4_767 VPWR VGND sg13cmos5l_decap_8
XFILLER_16_830 VPWR VGND sg13cmos5l_decap_8
XANTENNA__294__X Tile_X0Y0_SS4BEG[10] VPWR VGND sg13cmos5l_antennanp
XFILLER_15_49 VPWR VGND sg13cmos5l_decap_8
XFILLER_0_203 VPWR VGND sg13cmos5l_decap_8
XFILLER_0_225 VPWR VGND sg13cmos5l_decap_8
XFILLER_1_759 VPWR VGND sg13cmos5l_decap_4
XFILLER_16_126 VPWR VGND sg13cmos5l_decap_8
XFILLER_17_627 VPWR VGND sg13cmos5l_decap_8
XFILLER_12_343 VPWR VGND sg13cmos5l_decap_8
XFILLER_13_855 VPWR VGND sg13cmos5l_decap_8
XFILLER_4_564 VPWR VGND sg13cmos5l_decap_8
XANTENNA__289__X Tile_X0Y0_SS4BEG[5] VPWR VGND sg13cmos5l_antennanp
XFILLER_8_892 VPWR VGND sg13cmos5l_decap_8
XANTENNA__199__X Tile_X0Y0_S2BEG[0] VPWR VGND sg13cmos5l_antennanp
XANTENNA_209 Tile_X0Y0_FrameData[14] VPWR VGND sg13cmos5l_antennanp
XANTENNA__148__Q NPU_PSUM_SYSTOLIC_EN VPWR VGND sg13cmos5l_antennanp
XFILLER_1_501 VPWR VGND sg13cmos5l_decap_8
XFILLER_1_523 VPWR VGND sg13cmos5l_decap_8
XFILLER_16_70 VPWR VGND sg13cmos5l_decap_8
XFILLER_18_958 VPWR VGND sg13cmos5l_fill_2
XFILLER_18_914 VPWR VGND sg13cmos5l_decap_8
XFILLER_17_413 VPWR VGND sg13cmos5l_decap_8
XFILLER_12_140 VPWR VGND sg13cmos5l_decap_8
XFILLER_9_645 VPWR VGND sg13cmos5l_decap_8
XFILLER_8_133 VPWR VGND sg13cmos5l_decap_8
XFILLER_4_394 VPWR VGND sg13cmos5l_fill_1
XFILLER_16_490 VPWR VGND sg13cmos5l_decap_8
XFILLER_12_28 VPWR VGND sg13cmos5l_decap_8
XFILLER_14_427 VPWR VGND sg13cmos5l_decap_8
XFILLER_10_611 VPWR VGND sg13cmos5l_decap_8
X_270_ Tile_X0Y0_S4BEG[2] Tile_X0Y0_N4END[13] VPWR VGND sg13cmos5l_buf_1
XFILLER_10_688 VPWR VGND sg13cmos5l_decap_8
XFILLER_6_659 VPWR VGND sg13cmos5l_decap_4
XFILLER_5_147 VPWR VGND sg13cmos5l_decap_8
XFILLER_2_865 VPWR VGND sg13cmos5l_decap_8
XFILLER_17_210 VPWR VGND sg13cmos5l_decap_8
XFILLER_18_766 VPWR VGND sg13cmos5l_decap_8
XFILLER_17_287 VPWR VGND sg13cmos5l_decap_8
X_399_ _399_/X Tile_X0Y0_N1END[2] Tile_X0Y0_N2MID[2] Tile_X0Y0_N2MID[5] Tile_X0Y0_N2END[5]
+ _040_/Q _075_/Q VPWR VGND sg13cmos5l_mux4_1
XFILLER_9_486 VPWR VGND sg13cmos5l_decap_8
XFILLER_5_692 VPWR VGND sg13cmos5l_decap_4
XFILLER_5_670 VPWR VGND sg13cmos5l_decap_8
XFILLER_4_62 VPWR VGND sg13cmos5l_decap_8
XFILLER_14_224 VPWR VGND sg13cmos5l_decap_8
XFILLER_15_703 VPWR VGND sg13cmos5l_fill_2
XFILLER_15_747 VPWR VGND sg13cmos5l_decap_8
X_322_ Tile_X1Y0_FrameData_O[18] Tile_X0Y0_FrameData[18] VPWR VGND sg13cmos5l_buf_1
XFILLER_9_29 VPWR VGND sg13cmos5l_decap_8
XFILLER_10_485 VPWR VGND sg13cmos5l_decap_8
X_184_ _184_/L_HI VPWR VGND sg13cmos5l_tiehi
X_253_ Tile_X1Y0_SS4BEG[10] Tile_X1Y0_NN4END[5] VPWR VGND sg13cmos5l_buf_1
XFILLER_6_445 VPWR VGND sg13cmos5l_decap_8
XFILLER_2_673 VPWR VGND sg13cmos5l_fill_2
XFILLER_1_194 VPWR VGND sg13cmos5l_decap_4
XFILLER_1_161 VPWR VGND sg13cmos5l_fill_2
XANTENNA__297__X Tile_X0Y0_SS4BEG[13] VPWR VGND sg13cmos5l_antennanp
XFILLER_18_541 VPWR VGND sg13cmos5l_fill_1
XFILLER_18_530 VPWR VGND sg13cmos5l_decap_4
XFILLER_18_49 VPWR VGND sg13cmos5l_decap_8
XFILLER_12_706 VPWR VGND sg13cmos5l_decap_8
XFILLER_11_238 VPWR VGND sg13cmos5l_decap_8
XFILLER_4_916 VPWR VGND sg13cmos5l_decap_8
XFILLER_4_927 VPWR VGND sg13cmos5l_fill_2
XFILLER_15_511 VPWR VGND sg13cmos5l_decap_8
X_305_ Tile_X1Y0_FrameData_O[1] Tile_X0Y0_FrameData[1] VPWR VGND sg13cmos5l_buf_1
XFILLER_10_282 VPWR VGND sg13cmos5l_decap_8
XFILLER_11_794 VPWR VGND sg13cmos5l_decap_8
X_098_ _098_/Q Tile_X0Y0_FrameData[8] VGND VPWR Tile_X1Y0_FrameStrobe[0] latch
X_167_ _167_/L_HI VPWR VGND sg13cmos5l_tiehi
X_236_ Tile_X1Y0_S4BEG[9] Tile_X1Y0_N4END[6] VPWR VGND sg13cmos5l_buf_1
XFILLER_7_776 VPWR VGND sg13cmos5l_fill_1
XFILLER_7_765 VPWR VGND sg13cmos5l_fill_2
XFILLER_6_231 VPWR VGND sg13cmos5l_decap_8
XFILLER_1_74 VPWR VGND sg13cmos5l_fill_1
XFILLER_1_908 VPWR VGND sg13cmos5l_decap_8
XFILLER_16_308 VPWR VGND sg13cmos5l_decap_8
XFILLER_17_809 VPWR VGND sg13cmos5l_decap_8
XFILLER_12_525 VPWR VGND sg13cmos5l_decap_8
XFILLER_8_529 VPWR VGND sg13cmos5l_decap_8
XFILLER_3_201 VPWR VGND sg13cmos5l_fill_1
XFILLER_10_72 VPWR VGND sg13cmos5l_decap_8
XFILLER_16_886 VPWR VGND sg13cmos5l_decap_8
XFILLER_11_591 VPWR VGND sg13cmos5l_decap_4
XFILLER_15_385 VPWR VGND sg13cmos5l_decap_8
X_219_ Tile_X1Y0_S2BEGb[0] Tile_X1Y0_N2END[7] VPWR VGND sg13cmos5l_buf_1
XFILLER_7_584 VPWR VGND sg13cmos5l_decap_8
XFILLER_3_790 VPWR VGND sg13cmos5l_decap_4
XFILLER_18_0 VPWR VGND sg13cmos5l_decap_8
XFILLER_15_28 VPWR VGND sg13cmos5l_decap_8
XFILLER_16_105 VPWR VGND sg13cmos5l_decap_8
XFILLER_17_606 VPWR VGND sg13cmos5l_decap_8
XFILLER_12_322 VPWR VGND sg13cmos5l_decap_8
XFILLER_12_399 VPWR VGND sg13cmos5l_decap_8
XFILLER_13_812 VPWR VGND sg13cmos5l_decap_4
XFILLER_13_834 VPWR VGND sg13cmos5l_decap_8
XFILLER_11_7 VPWR VGND sg13cmos5l_decap_8
XFILLER_15_182 VPWR VGND sg13cmos5l_decap_8
XFILLER_16_683 VPWR VGND sg13cmos5l_decap_8
XFILLER_8_871 VPWR VGND sg13cmos5l_decap_8
XFILLER_7_84 VPWR VGND sg13cmos5l_decap_8
XFILLER_14_609 VPWR VGND sg13cmos5l_decap_4
XFILLER_13_119 VPWR VGND sg13cmos5l_decap_8
XFILLER_13_631 VPWR VGND sg13cmos5l_decap_8
XFILLER_13_642 VPWR VGND sg13cmos5l_fill_2
XFILLER_17_469 VPWR VGND sg13cmos5l_decap_8
XFILLER_12_196 VPWR VGND sg13cmos5l_decap_8
XFILLER_13_686 VPWR VGND sg13cmos5l_decap_8
XFILLER_9_624 VPWR VGND sg13cmos5l_decap_8
XFILLER_8_189 VPWR VGND sg13cmos5l_decap_8
XFILLER_8_112 VPWR VGND sg13cmos5l_decap_8
XFILLER_8_690 VPWR VGND sg13cmos5l_decap_8
XFILLER_14_406 VPWR VGND sg13cmos5l_decap_8
XFILLER_15_929 VPWR VGND sg13cmos5l_decap_8
XFILLER_10_667 VPWR VGND sg13cmos5l_decap_8
XFILLER_5_126 VPWR VGND sg13cmos5l_decap_8
XFILLER_2_822 VPWR VGND sg13cmos5l_decap_4
XFILLER_2_811 VPWR VGND sg13cmos5l_decap_4
XFILLER_2_800 VPWR VGND sg13cmos5l_fill_1
XFILLER_18_745 VPWR VGND sg13cmos5l_decap_8
XFILLER_13_483 VPWR VGND sg13cmos5l_decap_8
XFILLER_14_940 VPWR VGND sg13cmos5l_fill_1
XFILLER_14_951 VPWR VGND sg13cmos5l_decap_8
X_398_ _398_/X Tile_X1Y0_N1END[0] Tile_X1Y0_N2MID[0] Tile_X1Y0_N2MID[7] Tile_X1Y0_N2END[7]
+ _082_/Q _081_/Q VPWR VGND sg13cmos5l_mux4_1
XFILLER_17_266 VPWR VGND sg13cmos5l_decap_8
XFILLER_9_498 VPWR VGND sg13cmos5l_decap_8
XFILLER_9_465 VPWR VGND sg13cmos5l_decap_8
XFILLER_4_41 VPWR VGND sg13cmos5l_decap_8
XFILLER_14_203 VPWR VGND sg13cmos5l_decap_8
XFILLER_15_726 VPWR VGND sg13cmos5l_decap_8
X_252_ Tile_X1Y0_SS4BEG[9] Tile_X1Y0_NN4END[6] VPWR VGND sg13cmos5l_buf_1
X_321_ Tile_X1Y0_FrameData_O[17] Tile_X0Y0_FrameData[17] VPWR VGND sg13cmos5l_buf_1
XFILLER_10_464 VPWR VGND sg13cmos5l_decap_8
X_183_ _183_/L_HI VPWR VGND sg13cmos5l_tiehi
XFILLER_7_958 VPWR VGND sg13cmos5l_fill_2
XFILLER_7_936 VPWR VGND sg13cmos5l_fill_2
XFILLER_13_280 VPWR VGND sg13cmos5l_decap_8
XFILLER_14_781 VPWR VGND sg13cmos5l_decap_8
XFILLER_9_295 VPWR VGND sg13cmos5l_fill_1
XFILLER_5_490 VPWR VGND sg13cmos5l_decap_8
XFILLER_18_28 VPWR VGND sg13cmos5l_decap_8
XFILLER_11_217 VPWR VGND sg13cmos5l_decap_8
XFILLER_10_261 VPWR VGND sg13cmos5l_decap_8
XFILLER_15_567 VPWR VGND sg13cmos5l_decap_8
XFILLER_15_578 VPWR VGND sg13cmos5l_fill_2
X_235_ Tile_X1Y0_S4BEG[8] Tile_X1Y0_N4END[7] VPWR VGND sg13cmos5l_buf_1
X_304_ Tile_X1Y0_FrameData_O[0] Tile_X0Y0_FrameData[0] VPWR VGND sg13cmos5l_buf_1
XFILLER_6_210 VPWR VGND sg13cmos5l_decap_8
X_097_ _097_/Q Tile_X0Y0_FrameData[9] VGND VPWR Tile_X1Y0_FrameStrobe[0] latch
X_166_ _166_/L_HI VPWR VGND sg13cmos5l_tiehi
XFILLER_6_287 VPWR VGND sg13cmos5l_fill_1
XFILLER_2_493 VPWR VGND sg13cmos5l_decap_8
XFILLER_1_42 VPWR VGND sg13cmos5l_decap_8
XANTENNA_190 Tile_X0Y0_N4END[3] VPWR VGND sg13cmos5l_antennanp
XFILLER_18_394 VPWR VGND sg13cmos5l_decap_8
XFILLER_18_350 VPWR VGND sg13cmos5l_decap_4
XFILLER_12_504 VPWR VGND sg13cmos5l_decap_8
XFILLER_8_508 VPWR VGND sg13cmos5l_decap_8
XFILLER_10_51 VPWR VGND sg13cmos5l_decap_8
XFILLER_0_920 VPWR VGND sg13cmos5l_decap_8
XFILLER_15_364 VPWR VGND sg13cmos5l_decap_8
XFILLER_16_865 VPWR VGND sg13cmos5l_decap_8
X_149_ NPU_ARRAY_EN Tile_X0Y0_UserCLK _400_/X _164_/L_HI VPWR VGND sg13cmos5l_dfrbpq_1
X_218_ Tile_X1Y0_S2BEG[7] Tile_X1Y0_N2MID[0] VPWR VGND sg13cmos5l_buf_1
XFILLER_7_563 VPWR VGND sg13cmos5l_decap_8
XFILLER_1_717 VPWR VGND sg13cmos5l_decap_8
XFILLER_12_301 VPWR VGND sg13cmos5l_decap_8
XANTENNA_90 Tile_X0Y0_FrameData[3] VPWR VGND sg13cmos5l_antennanp
XFILLER_12_378 VPWR VGND sg13cmos5l_decap_8
XFILLER_4_599 VPWR VGND sg13cmos5l_fill_2
XFILLER_4_522 VPWR VGND sg13cmos5l_decap_8
XFILLER_0_783 VPWR VGND sg13cmos5l_decap_8
XFILLER_15_161 VPWR VGND sg13cmos5l_decap_8
XFILLER_16_640 VPWR VGND sg13cmos5l_decap_4
XFILLER_16_662 VPWR VGND sg13cmos5l_decap_8
XFILLER_12_890 VPWR VGND sg13cmos5l_decap_8
XFILLER_7_63 VPWR VGND sg13cmos5l_decap_8
XFILLER_7_393 VPWR VGND sg13cmos5l_fill_2
XFILLER_7_360 VPWR VGND sg13cmos5l_fill_2
XFILLER_10_849 VPWR VGND sg13cmos5l_decap_4
XFILLER_13_665 VPWR VGND sg13cmos5l_decap_8
XFILLER_9_603 VPWR VGND sg13cmos5l_decap_8
XFILLER_17_448 VPWR VGND sg13cmos5l_decap_8
XFILLER_12_175 VPWR VGND sg13cmos5l_decap_8
XFILLER_8_168 VPWR VGND sg13cmos5l_decap_8
XFILLER_4_385 VPWR VGND sg13cmos5l_decap_8
XFILLER_15_908 VPWR VGND sg13cmos5l_decap_8
XFILLER_10_646 VPWR VGND sg13cmos5l_decap_8
XFILLER_5_105 VPWR VGND sg13cmos5l_decap_8
XFILLER_18_724 VPWR VGND sg13cmos5l_decap_8
XFILLER_17_245 VPWR VGND sg13cmos5l_decap_8
XFILLER_13_462 VPWR VGND sg13cmos5l_decap_8
X_397_ _397_/X Tile_X1Y0_N1END[1] Tile_X1Y0_N2MID[1] Tile_X1Y0_N2MID[6] Tile_X1Y0_N2END[6]
+ _080_/Q _079_/Q VPWR VGND sg13cmos5l_mux4_1
XFILLER_9_444 VPWR VGND sg13cmos5l_decap_8
XFILLER_4_171 VPWR VGND sg13cmos5l_decap_4
XFILLER_4_97 VPWR VGND sg13cmos5l_decap_8
XFILLER_2_108 VPWR VGND sg13cmos5l_fill_2
XFILLER_10_443 VPWR VGND sg13cmos5l_decap_8
XFILLER_14_259 VPWR VGND sg13cmos5l_decap_8
X_182_ _182_/L_HI VPWR VGND sg13cmos5l_tiehi
X_251_ Tile_X1Y0_SS4BEG[8] Tile_X1Y0_NN4END[7] VPWR VGND sg13cmos5l_buf_1
X_320_ Tile_X1Y0_FrameData_O[16] Tile_X0Y0_FrameData[16] VPWR VGND sg13cmos5l_buf_1
XFILLER_7_915 VPWR VGND sg13cmos5l_decap_8
XFILLER_13_84 VPWR VGND sg13cmos5l_decap_8
XFILLER_8_0 VPWR VGND sg13cmos5l_decap_8
XFILLER_2_653 VPWR VGND sg13cmos5l_decap_8
XFILLER_1_174 VPWR VGND sg13cmos5l_fill_2
XFILLER_1_163 VPWR VGND sg13cmos5l_fill_1
XFILLER_14_760 VPWR VGND sg13cmos5l_decap_8
XFILLER_18_598 VPWR VGND sg13cmos5l_decap_8
XFILLER_18_576 VPWR VGND sg13cmos5l_decap_8
XFILLER_18_554 VPWR VGND sg13cmos5l_decap_4
XFILLER_18_521 VPWR VGND sg13cmos5l_decap_4
XFILLER_9_274 VPWR VGND sg13cmos5l_decap_8
XFILLER_1_7 VPWR VGND sg13cmos5l_decap_8
XFILLER_15_546 VPWR VGND sg13cmos5l_decap_8
XFILLER_10_240 VPWR VGND sg13cmos5l_decap_8
XFILLER_11_774 VPWR VGND sg13cmos5l_decap_8
XFILLER_11_785 VPWR VGND sg13cmos5l_fill_1
X_165_ _165_/L_HI VPWR VGND sg13cmos5l_tiehi
X_234_ Tile_X1Y0_S4BEG[7] Tile_X1Y0_N4END[8] VPWR VGND sg13cmos5l_buf_1
X_303_ Tile_X0Y0_S1BEG[3] Tile_X0Y0_N1END[0] VPWR VGND sg13cmos5l_buf_1
X_096_ _096_/Q Tile_X0Y0_FrameData[10] VGND VPWR Tile_X1Y0_FrameStrobe[0] latch
XFILLER_6_266 VPWR VGND sg13cmos5l_decap_8
XFILLER_2_472 VPWR VGND sg13cmos5l_decap_8
XFILLER_1_21 VPWR VGND sg13cmos5l_decap_8
XANTENNA_180 Tile_X0Y0_FrameData[4] VPWR VGND sg13cmos5l_antennanp
XANTENNA_191 Tile_X0Y0_N4END[3] VPWR VGND sg13cmos5l_antennanp
XFILLER_18_373 VPWR VGND sg13cmos5l_decap_8
XFILLER_10_30 VPWR VGND sg13cmos5l_decap_8
XFILLER_3_236 VPWR VGND sg13cmos5l_decap_8
XANTENNA__202__X Tile_X0Y0_S2BEG[3] VPWR VGND sg13cmos5l_antennanp
XFILLER_0_943 VPWR VGND sg13cmos5l_decap_4
XFILLER_15_343 VPWR VGND sg13cmos5l_decap_8
XFILLER_16_844 VPWR VGND sg13cmos5l_decap_8
X_148_ NPU_PSUM_SYSTOLIC_EN Tile_X0Y0_UserCLK _399_/X _168_/L_HI VPWR VGND sg13cmos5l_dfrbpq_1
X_217_ Tile_X1Y0_S2BEG[6] Tile_X1Y0_N2MID[1] VPWR VGND sg13cmos5l_buf_1
XFILLER_7_542 VPWR VGND sg13cmos5l_decap_8
X_079_ _079_/Q Tile_X0Y0_FrameData[27] VGND VPWR Tile_X1Y0_FrameStrobe[0] latch
XFILLER_18_192 VPWR VGND sg13cmos5l_decap_8
XFILLER_0_217 VPWR VGND sg13cmos5l_decap_4
XFILLER_13_869 VPWR VGND sg13cmos5l_decap_8
XANTENNA_80 Tile_X0Y0_FrameData[2] VPWR VGND sg13cmos5l_antennanp
XANTENNA_91 Tile_X0Y0_FrameData[3] VPWR VGND sg13cmos5l_antennanp
XFILLER_12_357 VPWR VGND sg13cmos5l_decap_8
XFILLER_4_501 VPWR VGND sg13cmos5l_decap_8
XFILLER_0_762 VPWR VGND sg13cmos5l_decap_8
XFILLER_4_578 VPWR VGND sg13cmos5l_decap_8
XFILLER_15_140 VPWR VGND sg13cmos5l_decap_8
XFILLER_11_390 VPWR VGND sg13cmos5l_decap_8
XFILLER_7_42 VPWR VGND sg13cmos5l_decap_8
XFILLER_18_939 VPWR VGND sg13cmos5l_fill_2
XFILLER_18_928 VPWR VGND sg13cmos5l_decap_8
XFILLER_17_427 VPWR VGND sg13cmos5l_decap_8
XFILLER_12_154 VPWR VGND sg13cmos5l_decap_8
XFILLER_13_611 VPWR VGND sg13cmos5l_fill_1
XFILLER_16_84 VPWR VGND sg13cmos5l_decap_8
XFILLER_9_659 VPWR VGND sg13cmos5l_decap_8
XFILLER_8_147 VPWR VGND sg13cmos5l_decap_8
XANTENNA__300__X Tile_X0Y0_S1BEG[0] VPWR VGND sg13cmos5l_antennanp
XFILLER_10_625 VPWR VGND sg13cmos5l_decap_8
XANTENNA__210__X Tile_X1Y0_S1BEG[3] VPWR VGND sg13cmos5l_antennanp
XFILLER_2_879 VPWR VGND sg13cmos5l_decap_8
XFILLER_1_389 VPWR VGND sg13cmos5l_fill_2
XFILLER_18_703 VPWR VGND sg13cmos5l_decap_8
XFILLER_17_224 VPWR VGND sg13cmos5l_decap_8
XFILLER_13_441 VPWR VGND sg13cmos5l_decap_8
X_396_ _396_/X Tile_X1Y0_N1END[2] Tile_X1Y0_N2MID[2] Tile_X1Y0_N2MID[5] Tile_X1Y0_N2END[5]
+ _078_/Q _077_/Q VPWR VGND sg13cmos5l_mux4_1
XFILLER_9_423 VPWR VGND sg13cmos5l_decap_8
XFILLER_4_76 VPWR VGND sg13cmos5l_decap_8
XFILLER_4_21 VPWR VGND sg13cmos5l_decap_8
XFILLER_4_194 VPWR VGND sg13cmos5l_decap_8
XFILLER_14_238 VPWR VGND sg13cmos5l_decap_8
XFILLER_10_422 VPWR VGND sg13cmos5l_decap_8
XFILLER_11_912 VPWR VGND sg13cmos5l_decap_8
XFILLER_11_923 VPWR VGND sg13cmos5l_fill_2
XFILLER_13_63 VPWR VGND sg13cmos5l_decap_8
X_181_ _181_/L_HI VPWR VGND sg13cmos5l_tiehi
X_250_ Tile_X1Y0_SS4BEG[7] Tile_X1Y0_NN4END[8] VPWR VGND sg13cmos5l_buf_1
XANTENNA__205__X Tile_X0Y0_S2BEG[6] VPWR VGND sg13cmos5l_antennanp
XFILLER_10_499 VPWR VGND sg13cmos5l_decap_8
XFILLER_6_459 VPWR VGND sg13cmos5l_decap_8
XFILLER_1_120 VPWR VGND sg13cmos5l_decap_8
XFILLER_2_698 VPWR VGND sg13cmos5l_decap_8
X_379_ _379_/X Tile_X0Y0_N4END[14] Tile_X0Y0_N4END[15] Tile_X0Y0_NN4END[12] Tile_X0Y0_NN4END[14]
+ _046_/Q _045_/Q VPWR VGND sg13cmos5l_mux4_1
XFILLER_9_253 VPWR VGND sg13cmos5l_decap_8
XFILLER_15_525 VPWR VGND sg13cmos5l_decap_8
X_302_ Tile_X0Y0_S1BEG[2] Tile_X0Y0_N1END[1] VPWR VGND sg13cmos5l_buf_1
XFILLER_10_296 VPWR VGND sg13cmos5l_decap_8
XFILLER_11_753 VPWR VGND sg13cmos5l_decap_8
X_095_ _095_/Q Tile_X0Y0_FrameData[11] VGND VPWR Tile_X1Y0_FrameStrobe[0] latch
X_164_ _164_/L_HI VPWR VGND sg13cmos5l_tiehi
X_233_ Tile_X1Y0_S4BEG[6] Tile_X1Y0_N4END[9] VPWR VGND sg13cmos5l_buf_1
XFILLER_7_735 VPWR VGND sg13cmos5l_decap_8
XFILLER_6_245 VPWR VGND sg13cmos5l_decap_8
XFILLER_2_451 VPWR VGND sg13cmos5l_fill_2
XANTENNA_170 Tile_X0Y0_FrameData[25] VPWR VGND sg13cmos5l_antennanp
XANTENNA_181 Tile_X0Y0_FrameData[4] VPWR VGND sg13cmos5l_antennanp
XANTENNA_192 Tile_X0Y0_N4END[3] VPWR VGND sg13cmos5l_antennanp
XFILLER_6_790 VPWR VGND sg13cmos5l_decap_8
XFILLER_12_539 VPWR VGND sg13cmos5l_decap_8
XFILLER_10_86 VPWR VGND sg13cmos5l_decap_8
XFILLER_16_823 VPWR VGND sg13cmos5l_decap_8
XFILLER_15_322 VPWR VGND sg13cmos5l_decap_8
XFILLER_15_399 VPWR VGND sg13cmos5l_decap_8
XFILLER_11_572 VPWR VGND sg13cmos5l_decap_8
X_078_ _078_/Q Tile_X0Y0_FrameData[28] VGND VPWR Tile_X1Y0_FrameStrobe[0] latch
X_147_ NPU_PSUM_LUT_EN Tile_X0Y0_UserCLK _398_/X _169_/L_HI VPWR VGND sg13cmos5l_dfrbpq_1
X_216_ Tile_X1Y0_S2BEG[5] Tile_X1Y0_N2MID[2] VPWR VGND sg13cmos5l_buf_1
XFILLER_7_598 VPWR VGND sg13cmos5l_decap_8
XFILLER_7_521 VPWR VGND sg13cmos5l_decap_8
XANTENNA__303__X Tile_X0Y0_S1BEG[3] VPWR VGND sg13cmos5l_antennanp
XFILLER_16_119 VPWR VGND sg13cmos5l_decap_8
XFILLER_12_336 VPWR VGND sg13cmos5l_decap_8
XFILLER_13_848 VPWR VGND sg13cmos5l_decap_8
XANTENNA_70 Tile_X0Y0_FrameData[23] VPWR VGND sg13cmos5l_antennanp
XANTENNA_81 Tile_X0Y0_FrameData[2] VPWR VGND sg13cmos5l_antennanp
XANTENNA_92 Tile_X0Y0_FrameData[3] VPWR VGND sg13cmos5l_antennanp
XANTENNA__213__X Tile_X1Y0_S2BEG[2] VPWR VGND sg13cmos5l_antennanp
XFILLER_4_557 VPWR VGND sg13cmos5l_decap_8
XFILLER_0_741 VPWR VGND sg13cmos5l_decap_8
XFILLER_16_620 VPWR VGND sg13cmos5l_fill_2
XFILLER_15_196 VPWR VGND sg13cmos5l_decap_8
XFILLER_16_697 VPWR VGND sg13cmos5l_decap_8
XFILLER_7_21 VPWR VGND sg13cmos5l_decap_8
XFILLER_8_885 VPWR VGND sg13cmos5l_decap_8
XFILLER_7_98 VPWR VGND sg13cmos5l_decap_8
XFILLER_16_0 VPWR VGND sg13cmos5l_decap_8
XFILLER_1_516 VPWR VGND sg13cmos5l_decap_8
XFILLER_13_601 VPWR VGND sg13cmos5l_decap_4
XFILLER_18_907 VPWR VGND sg13cmos5l_decap_8
XFILLER_17_406 VPWR VGND sg13cmos5l_decap_8
XANTENNA__208__X Tile_X1Y0_S1BEG[1] VPWR VGND sg13cmos5l_antennanp
XFILLER_12_133 VPWR VGND sg13cmos5l_decap_8
XFILLER_16_63 VPWR VGND sg13cmos5l_decap_8
XFILLER_9_638 VPWR VGND sg13cmos5l_decap_8
XFILLER_8_126 VPWR VGND sg13cmos5l_decap_8
XFILLER_5_899 VPWR VGND sg13cmos5l_decap_8
XFILLER_0_582 VPWR VGND sg13cmos5l_decap_8
XFILLER_16_483 VPWR VGND sg13cmos5l_decap_8
XFILLER_17_951 VPWR VGND sg13cmos5l_decap_8
XFILLER_10_604 VPWR VGND sg13cmos5l_decap_8
XFILLER_17_203 VPWR VGND sg13cmos5l_decap_8
XFILLER_13_420 VPWR VGND sg13cmos5l_decap_8
XFILLER_14_921 VPWR VGND sg13cmos5l_decap_8
XFILLER_18_759 VPWR VGND sg13cmos5l_decap_8
XFILLER_13_497 VPWR VGND sg13cmos5l_decap_8
X_395_ _395_/X Tile_X1Y0_N1END[3] Tile_X1Y0_N2MID[3] Tile_X1Y0_N2MID[4] Tile_X1Y0_N2END[4]
+ _076_/Q _113_/Q VPWR VGND sg13cmos5l_mux4_1
XFILLER_9_479 VPWR VGND sg13cmos5l_decap_8
XFILLER_9_402 VPWR VGND sg13cmos5l_decap_8
XFILLER_4_55 VPWR VGND sg13cmos5l_decap_8
XFILLER_1_880 VPWR VGND sg13cmos5l_decap_8
XFILLER_16_280 VPWR VGND sg13cmos5l_decap_8
XFILLER_17_781 VPWR VGND sg13cmos5l_decap_8
XANTENNA__311__X Tile_X1Y0_FrameData_O[7] VPWR VGND sg13cmos5l_antennanp
XFILLER_14_217 VPWR VGND sg13cmos5l_decap_8
XFILLER_10_401 VPWR VGND sg13cmos5l_decap_8
XFILLER_10_478 VPWR VGND sg13cmos5l_decap_8
XFILLER_11_957 VPWR VGND sg13cmos5l_fill_2
XFILLER_13_42 VPWR VGND sg13cmos5l_decap_8
X_180_ _180_/L_HI VPWR VGND sg13cmos5l_tiehi
XFILLER_6_438 VPWR VGND sg13cmos5l_decap_8
XANTENNA__221__X Tile_X1Y0_S2BEGb[2] VPWR VGND sg13cmos5l_antennanp
XFILLER_2_666 VPWR VGND sg13cmos5l_decap_8
XFILLER_1_110 VPWR VGND sg13cmos5l_fill_1
XFILLER_1_198 VPWR VGND sg13cmos5l_fill_2
XFILLER_1_187 VPWR VGND sg13cmos5l_decap_8
XFILLER_18_545 VPWR VGND sg13cmos5l_decap_4
XFILLER_13_294 VPWR VGND sg13cmos5l_decap_8
XFILLER_14_795 VPWR VGND sg13cmos5l_decap_8
X_378_ _378_/X Tile_X0Y0_N4END[13] Tile_X0Y0_N4END[14] Tile_X0Y0_NN4END[13] Tile_X0Y0_NN4END[15]
+ _048_/Q _047_/Q VPWR VGND sg13cmos5l_mux4_1
XFILLER_9_232 VPWR VGND sg13cmos5l_decap_8
XANTENNA__306__X Tile_X1Y0_FrameData_O[2] VPWR VGND sg13cmos5l_antennanp
XFILLER_4_909 VPWR VGND sg13cmos5l_decap_8
XFILLER_11_732 VPWR VGND sg13cmos5l_decap_8
XFILLER_15_504 VPWR VGND sg13cmos5l_decap_8
X_232_ Tile_X1Y0_S4BEG[5] Tile_X1Y0_N4END[10] VPWR VGND sg13cmos5l_buf_1
X_301_ Tile_X0Y0_S1BEG[1] Tile_X0Y0_N1END[2] VPWR VGND sg13cmos5l_buf_1
XANTENNA__216__X Tile_X1Y0_S2BEG[5] VPWR VGND sg13cmos5l_antennanp
XFILLER_10_275 VPWR VGND sg13cmos5l_decap_8
X_094_ _094_/Q Tile_X0Y0_FrameData[12] VGND VPWR Tile_X1Y0_FrameStrobe[0] latch
X_163_ _163_/L_HI VPWR VGND sg13cmos5l_tiehi
XFILLER_7_758 VPWR VGND sg13cmos5l_decap_8
XFILLER_6_224 VPWR VGND sg13cmos5l_decap_8
XFILLER_3_931 VPWR VGND sg13cmos5l_decap_4
XANTENNA_160 Tile_X1Y0_NN4END[12] VPWR VGND sg13cmos5l_antennanp
XFILLER_1_67 VPWR VGND sg13cmos5l_decap_8
XANTENNA_171 Tile_X0Y0_FrameData[25] VPWR VGND sg13cmos5l_antennanp
XANTENNA_182 Tile_X0Y0_FrameData[4] VPWR VGND sg13cmos5l_antennanp
XANTENNA_193 Tile_X0Y0_N4END[3] VPWR VGND sg13cmos5l_antennanp
XFILLER_14_581 VPWR VGND sg13cmos5l_decap_8
XFILLER_12_518 VPWR VGND sg13cmos5l_decap_8
XFILLER_0_934 VPWR VGND sg13cmos5l_decap_4
XFILLER_10_65 VPWR VGND sg13cmos5l_decap_8
XFILLER_15_301 VPWR VGND sg13cmos5l_decap_8
XFILLER_16_802 VPWR VGND sg13cmos5l_decap_8
XFILLER_11_551 VPWR VGND sg13cmos5l_decap_8
XFILLER_15_378 VPWR VGND sg13cmos5l_decap_8
XFILLER_16_879 VPWR VGND sg13cmos5l_decap_8
X_215_ Tile_X1Y0_S2BEG[4] Tile_X1Y0_N2MID[3] VPWR VGND sg13cmos5l_buf_1
XFILLER_7_500 VPWR VGND sg13cmos5l_decap_8
X_077_ _077_/Q Tile_X0Y0_FrameData[29] VGND VPWR Tile_X1Y0_FrameStrobe[0] latch
X_146_ NPU_SWAP_WEIGHTS Tile_X0Y0_UserCLK _397_/X _170_/L_HI VPWR VGND sg13cmos5l_dfrbpq_1
XFILLER_7_577 VPWR VGND sg13cmos5l_decap_8
XFILLER_3_794 VPWR VGND sg13cmos5l_fill_2
XFILLER_3_783 VPWR VGND sg13cmos5l_decap_8
XFILLER_18_183 VPWR VGND sg13cmos5l_decap_4
XFILLER_12_315 VPWR VGND sg13cmos5l_decap_8
XFILLER_13_805 VPWR VGND sg13cmos5l_decap_8
XFILLER_13_816 VPWR VGND sg13cmos5l_fill_1
XFILLER_13_827 VPWR VGND sg13cmos5l_decap_8
XANTENNA_60 Tile_X0Y0_FrameData[22] VPWR VGND sg13cmos5l_antennanp
XANTENNA_71 Tile_X0Y0_FrameData[23] VPWR VGND sg13cmos5l_antennanp
XANTENNA_82 Tile_X0Y0_FrameData[2] VPWR VGND sg13cmos5l_antennanp
XANTENNA_93 Tile_X0Y0_FrameData[3] VPWR VGND sg13cmos5l_antennanp
XFILLER_4_547 VPWR VGND sg13cmos5l_fill_2
XFILLER_0_720 VPWR VGND sg13cmos5l_decap_8
XFILLER_0_797 VPWR VGND sg13cmos5l_decap_8
XFILLER_15_175 VPWR VGND sg13cmos5l_decap_8
XFILLER_16_676 VPWR VGND sg13cmos5l_decap_8
XFILLER_8_864 VPWR VGND sg13cmos5l_decap_8
XFILLER_7_77 VPWR VGND sg13cmos5l_decap_8
X_129_ NPU_QUANT_SHIFT_IN14 Tile_X0Y0_UserCLK _379_/X _155_/L_HI VPWR VGND sg13cmos5l_dfrbpq_1
XANTENNA__314__X Tile_X1Y0_FrameData_O[10] VPWR VGND sg13cmos5l_antennanp
XFILLER_13_624 VPWR VGND sg13cmos5l_decap_8
XFILLER_16_42 VPWR VGND sg13cmos5l_decap_8
XANTENNA__224__X Tile_X1Y0_S2BEGb[5] VPWR VGND sg13cmos5l_antennanp
XFILLER_12_112 VPWR VGND sg13cmos5l_decap_8
XFILLER_12_189 VPWR VGND sg13cmos5l_decap_8
XFILLER_13_679 VPWR VGND sg13cmos5l_decap_8
XFILLER_9_617 VPWR VGND sg13cmos5l_decap_8
XFILLER_8_105 VPWR VGND sg13cmos5l_decap_8
XFILLER_4_399 VPWR VGND sg13cmos5l_decap_8
XFILLER_0_561 VPWR VGND sg13cmos5l_fill_1
XFILLER_16_462 VPWR VGND sg13cmos5l_decap_8
XFILLER_8_683 VPWR VGND sg13cmos5l_decap_8
XFILLER_7_182 VPWR VGND sg13cmos5l_decap_8
XANTENNA__309__X Tile_X1Y0_FrameData_O[5] VPWR VGND sg13cmos5l_antennanp
XFILLER_5_119 VPWR VGND sg13cmos5l_decap_8
XFILLER_2_848 VPWR VGND sg13cmos5l_decap_4
XFILLER_2_826 VPWR VGND sg13cmos5l_fill_1
XFILLER_2_804 VPWR VGND sg13cmos5l_decap_8
XFILLER_18_738 VPWR VGND sg13cmos5l_decap_8
XANTENNA__219__X Tile_X1Y0_S2BEGb[0] VPWR VGND sg13cmos5l_antennanp
XFILLER_13_476 VPWR VGND sg13cmos5l_decap_8
XFILLER_14_900 VPWR VGND sg13cmos5l_decap_8
X_394_ _394_/X Tile_X1Y0_N4END[14] Tile_X1Y0_N4END[15] Tile_X1Y0_NN4END[12] Tile_X1Y0_NN4END[14]
+ _084_/Q _083_/Q VPWR VGND sg13cmos5l_mux4_1
XFILLER_17_259 VPWR VGND sg13cmos5l_decap_8
XFILLER_9_458 VPWR VGND sg13cmos5l_decap_8
XFILLER_5_642 VPWR VGND sg13cmos5l_decap_8
XFILLER_0_391 VPWR VGND sg13cmos5l_fill_2
XFILLER_17_760 VPWR VGND sg13cmos5l_decap_8
XFILLER_8_480 VPWR VGND sg13cmos5l_decap_8
XFILLER_15_719 VPWR VGND sg13cmos5l_decap_8
XFILLER_10_457 VPWR VGND sg13cmos5l_decap_8
XFILLER_13_21 VPWR VGND sg13cmos5l_decap_8
XFILLER_13_98 VPWR VGND sg13cmos5l_decap_8
XFILLER_7_929 VPWR VGND sg13cmos5l_decap_8
XFILLER_2_623 VPWR VGND sg13cmos5l_fill_2
XFILLER_2_612 VPWR VGND sg13cmos5l_decap_8
XFILLER_1_155 VPWR VGND sg13cmos5l_fill_2
XFILLER_18_502 VPWR VGND sg13cmos5l_fill_2
XFILLER_13_273 VPWR VGND sg13cmos5l_decap_8
XFILLER_14_774 VPWR VGND sg13cmos5l_decap_8
X_377_ _377_/X Tile_X0Y0_N4END[12] Tile_X0Y0_N4END[13] Tile_X0Y0_NN4END[12] Tile_X0Y0_NN4END[14]
+ _050_/Q _049_/Q VPWR VGND sg13cmos5l_mux4_1
XFILLER_9_211 VPWR VGND sg13cmos5l_decap_8
XFILLER_9_299 VPWR VGND sg13cmos5l_fill_2
XFILLER_9_288 VPWR VGND sg13cmos5l_decap_8
XFILLER_5_483 VPWR VGND sg13cmos5l_decap_8
XANTENNA__322__X Tile_X1Y0_FrameData_O[18] VPWR VGND sg13cmos5l_antennanp
XFILLER_11_711 VPWR VGND sg13cmos5l_decap_8
X_162_ _162_/L_HI VPWR VGND sg13cmos5l_tiehi
X_231_ Tile_X1Y0_S4BEG[4] Tile_X1Y0_N4END[11] VPWR VGND sg13cmos5l_buf_1
X_300_ Tile_X0Y0_S1BEG[0] Tile_X0Y0_N1END[3] VPWR VGND sg13cmos5l_buf_1
XFILLER_7_715 VPWR VGND sg13cmos5l_decap_4
XANTENNA__232__X Tile_X1Y0_S4BEG[5] VPWR VGND sg13cmos5l_antennanp
XFILLER_10_254 VPWR VGND sg13cmos5l_decap_8
X_093_ _093_/Q Tile_X0Y0_FrameData[13] VGND VPWR Tile_X1Y0_FrameStrobe[0] latch
XFILLER_6_203 VPWR VGND sg13cmos5l_decap_8
XFILLER_6_0 VPWR VGND sg13cmos5l_decap_8
XFILLER_3_910 VPWR VGND sg13cmos5l_decap_8
XFILLER_2_486 VPWR VGND sg13cmos5l_decap_8
XFILLER_2_453 VPWR VGND sg13cmos5l_fill_1
XFILLER_1_35 VPWR VGND sg13cmos5l_decap_8
XANTENNA_150 Tile_X1Y0_N4END[8] VPWR VGND sg13cmos5l_antennanp
XANTENNA_161 Tile_X1Y0_NN4END[12] VPWR VGND sg13cmos5l_antennanp
XANTENNA_172 Tile_X0Y0_FrameData[25] VPWR VGND sg13cmos5l_antennanp
XANTENNA_183 Tile_X0Y0_FrameData[4] VPWR VGND sg13cmos5l_antennanp
XANTENNA_194 Tile_X0Y0_N4END[3] VPWR VGND sg13cmos5l_antennanp
XFILLER_1_57 VPWR VGND sg13cmos5l_fill_1
XFILLER_18_387 VPWR VGND sg13cmos5l_decap_8
XFILLER_18_354 VPWR VGND sg13cmos5l_fill_2
XFILLER_18_343 VPWR VGND sg13cmos5l_decap_8
XFILLER_14_560 VPWR VGND sg13cmos5l_decap_8
XANTENNA__317__X Tile_X1Y0_FrameData_O[13] VPWR VGND sg13cmos5l_antennanp
XFILLER_10_11 VPWR VGND sg13cmos5l_fill_2
XFILLER_10_44 VPWR VGND sg13cmos5l_decap_8
XFILLER_0_913 VPWR VGND sg13cmos5l_decap_8
XFILLER_15_357 VPWR VGND sg13cmos5l_decap_8
XFILLER_16_858 VPWR VGND sg13cmos5l_decap_8
XANTENNA__227__X Tile_X1Y0_S4BEG[0] VPWR VGND sg13cmos5l_antennanp
XFILLER_11_530 VPWR VGND sg13cmos5l_decap_8
X_145_ NPU_COMPUTE_BANK_SWAP Tile_X0Y0_UserCLK _395_/X _171_/L_HI VPWR VGND sg13cmos5l_dfrbpq_1
X_214_ Tile_X1Y0_S2BEG[3] Tile_X1Y0_N2MID[4] VPWR VGND sg13cmos5l_buf_1
XFILLER_7_556 VPWR VGND sg13cmos5l_decap_8
X_076_ _076_/Q Tile_X0Y0_FrameData[30] VGND VPWR Tile_X1Y0_FrameStrobe[0] latch
XFILLER_2_250 VPWR VGND sg13cmos5l_fill_2
XFILLER_15_880 VPWR VGND sg13cmos5l_decap_8
XFILLER_18_162 VPWR VGND sg13cmos5l_decap_8
XANTENNA_50 Tile_X0Y0_FrameData[20] VPWR VGND sg13cmos5l_antennanp
XANTENNA_61 Tile_X0Y0_FrameData[22] VPWR VGND sg13cmos5l_antennanp
XANTENNA_72 Tile_X0Y0_FrameData[23] VPWR VGND sg13cmos5l_antennanp
XANTENNA_83 Tile_X0Y0_FrameData[2] VPWR VGND sg13cmos5l_antennanp
XANTENNA_94 Tile_X0Y0_FrameData[3] VPWR VGND sg13cmos5l_antennanp
XFILLER_4_515 VPWR VGND sg13cmos5l_decap_8
XFILLER_0_776 VPWR VGND sg13cmos5l_decap_8
XFILLER_15_154 VPWR VGND sg13cmos5l_decap_8
XFILLER_16_622 VPWR VGND sg13cmos5l_fill_1
XFILLER_16_633 VPWR VGND sg13cmos5l_decap_8
XFILLER_16_655 VPWR VGND sg13cmos5l_decap_8
XFILLER_12_883 VPWR VGND sg13cmos5l_decap_8
X_128_ NPU_QUANT_SHIFT_IN13 Tile_X0Y0_UserCLK _378_/X _162_/L_HI VPWR VGND sg13cmos5l_dfrbpq_1
XFILLER_7_56 VPWR VGND sg13cmos5l_decap_8
X_059_ _059_/Q Tile_X0Y0_FrameData[11] VGND VPWR Tile_X0Y0_FrameStrobe[0] latch
XFILLER_3_581 VPWR VGND sg13cmos5l_decap_4
XANTENNA__330__X Tile_X1Y0_FrameData_O[26] VPWR VGND sg13cmos5l_antennanp
XFILLER_13_658 VPWR VGND sg13cmos5l_decap_8
XFILLER_16_21 VPWR VGND sg13cmos5l_decap_8
XFILLER_16_98 VPWR VGND sg13cmos5l_decap_8
XFILLER_12_168 VPWR VGND sg13cmos5l_decap_8
XANTENNA__240__X Tile_X1Y0_S4BEG[13] VPWR VGND sg13cmos5l_antennanp
XFILLER_16_441 VPWR VGND sg13cmos5l_decap_8
XFILLER_8_662 VPWR VGND sg13cmos5l_decap_8
XFILLER_7_161 VPWR VGND sg13cmos5l_decap_8
XANTENNA__325__X Tile_X1Y0_FrameData_O[21] VPWR VGND sg13cmos5l_antennanp
XFILLER_10_639 VPWR VGND sg13cmos5l_decap_8
XFILLER_18_717 VPWR VGND sg13cmos5l_decap_8
XFILLER_17_238 VPWR VGND sg13cmos5l_decap_8
XANTENNA__235__X Tile_X1Y0_S4BEG[8] VPWR VGND sg13cmos5l_antennanp
XFILLER_13_455 VPWR VGND sg13cmos5l_decap_8
X_393_ _393_/X Tile_X1Y0_N4END[13] Tile_X1Y0_N4END[14] Tile_X1Y0_NN4END[13] Tile_X1Y0_NN4END[15]
+ _086_/Q _085_/Q VPWR VGND sg13cmos5l_mux4_1
XFILLER_9_437 VPWR VGND sg13cmos5l_decap_8
XFILLER_5_621 VPWR VGND sg13cmos5l_decap_8
XFILLER_4_175 VPWR VGND sg13cmos5l_fill_2
XFILLER_4_164 VPWR VGND sg13cmos5l_decap_8
XFILLER_4_153 VPWR VGND sg13cmos5l_decap_8
XFILLER_4_35 VPWR VGND sg13cmos5l_fill_2
XFILLER_11_959 VPWR VGND sg13cmos5l_fill_1
XFILLER_7_908 VPWR VGND sg13cmos5l_decap_8
XFILLER_10_436 VPWR VGND sg13cmos5l_decap_8
XFILLER_13_77 VPWR VGND sg13cmos5l_decap_8
XFILLER_2_646 VPWR VGND sg13cmos5l_decap_8
XFILLER_1_167 VPWR VGND sg13cmos5l_decap_8
XFILLER_18_569 VPWR VGND sg13cmos5l_decap_8
XFILLER_18_558 VPWR VGND sg13cmos5l_fill_1
XFILLER_18_525 VPWR VGND sg13cmos5l_fill_2
XFILLER_18_514 VPWR VGND sg13cmos5l_decap_8
XFILLER_13_252 VPWR VGND sg13cmos5l_decap_8
XFILLER_14_753 VPWR VGND sg13cmos5l_decap_8
X_376_ _376_/X Tile_X0Y0_N4END[8] Tile_X0Y0_N4END[11] Tile_X0Y0_NN4END[9] Tile_X0Y0_NN4END[11]
+ _052_/Q _051_/Q VPWR VGND sg13cmos5l_mux4_1
XFILLER_9_267 VPWR VGND sg13cmos5l_decap_8
XFILLER_5_462 VPWR VGND sg13cmos5l_decap_8
XFILLER_15_539 VPWR VGND sg13cmos5l_decap_8
XFILLER_10_233 VPWR VGND sg13cmos5l_decap_8
XFILLER_11_767 VPWR VGND sg13cmos5l_decap_8
X_161_ _161_/L_HI VPWR VGND sg13cmos5l_tiehi
X_230_ Tile_X1Y0_S4BEG[3] Tile_X1Y0_N4END[12] VPWR VGND sg13cmos5l_buf_1
XFILLER_7_705 VPWR VGND sg13cmos5l_decap_8
X_092_ _092_/Q Tile_X0Y0_FrameData[14] VGND VPWR Tile_X1Y0_FrameStrobe[0] latch
XFILLER_6_259 VPWR VGND sg13cmos5l_decap_8
XFILLER_2_465 VPWR VGND sg13cmos5l_decap_8
XFILLER_1_14 VPWR VGND sg13cmos5l_decap_8
XANTENNA_140 Tile_X1Y0_N4END[13] VPWR VGND sg13cmos5l_antennanp
XANTENNA_151 Tile_X1Y0_N4END[8] VPWR VGND sg13cmos5l_antennanp
XANTENNA_162 Tile_X0Y0_FrameData[25] VPWR VGND sg13cmos5l_antennanp
XANTENNA_173 Tile_X0Y0_FrameData[25] VPWR VGND sg13cmos5l_antennanp
XANTENNA_184 Tile_X0Y0_FrameData[4] VPWR VGND sg13cmos5l_antennanp
XANTENNA_195 Tile_X0Y0_N4END[3] VPWR VGND sg13cmos5l_antennanp
XFILLER_18_366 VPWR VGND sg13cmos5l_decap_8
X_359_ Tile_X1Y0_FrameStrobe_O[3] Tile_X1Y0_FrameStrobe[3] VPWR VGND sg13cmos5l_buf_1
XFILLER_6_760 VPWR VGND sg13cmos5l_decap_8
XANTENNA__333__X Tile_X1Y0_FrameData_O[29] VPWR VGND sg13cmos5l_antennanp
XFILLER_10_23 VPWR VGND sg13cmos5l_decap_8
XFILLER_0_947 VPWR VGND sg13cmos5l_fill_1
XFILLER_0_958 VPWR VGND sg13cmos5l_fill_2
XFILLER_15_336 VPWR VGND sg13cmos5l_decap_8
XFILLER_16_837 VPWR VGND sg13cmos5l_decap_8
XANTENNA__243__X Tile_X1Y0_SS4BEG[0] VPWR VGND sg13cmos5l_antennanp
XFILLER_11_586 VPWR VGND sg13cmos5l_fill_1
X_075_ _075_/Q Tile_X0Y0_FrameData[31] VGND VPWR Tile_X0Y0_FrameStrobe[0] latch
X_144_ NPU_QUANT_SHIFT_IN29 Tile_X0Y0_UserCLK _394_/X _172_/L_HI VPWR VGND sg13cmos5l_dfrbpq_1
X_213_ Tile_X1Y0_S2BEG[2] Tile_X1Y0_N2MID[5] VPWR VGND sg13cmos5l_buf_1
XFILLER_7_535 VPWR VGND sg13cmos5l_decap_8
XFILLER_3_763 VPWR VGND sg13cmos5l_fill_2
XFILLER_2_240 VPWR VGND sg13cmos5l_fill_1
XFILLER_18_141 VPWR VGND sg13cmos5l_decap_8
XANTENNA__328__X Tile_X1Y0_FrameData_O[24] VPWR VGND sg13cmos5l_antennanp
XANTENNA_40 Tile_X0Y0_FrameData[1] VPWR VGND sg13cmos5l_antennanp
XANTENNA_51 Tile_X0Y0_FrameData[20] VPWR VGND sg13cmos5l_antennanp
XANTENNA_62 Tile_X0Y0_FrameData[22] VPWR VGND sg13cmos5l_antennanp
XANTENNA_73 Tile_X0Y0_FrameData[28] VPWR VGND sg13cmos5l_antennanp
XANTENNA_84 Tile_X0Y0_FrameData[2] VPWR VGND sg13cmos5l_antennanp
XANTENNA_95 Tile_X0Y0_FrameData[3] VPWR VGND sg13cmos5l_antennanp
XFILLER_0_755 VPWR VGND sg13cmos5l_decap_8
XFILLER_4_549 VPWR VGND sg13cmos5l_fill_1
XANTENNA__238__X Tile_X1Y0_S4BEG[11] VPWR VGND sg13cmos5l_antennanp
XFILLER_12_862 VPWR VGND sg13cmos5l_decap_8
XFILLER_15_133 VPWR VGND sg13cmos5l_decap_8
XFILLER_11_383 VPWR VGND sg13cmos5l_decap_8
X_058_ _058_/Q Tile_X0Y0_FrameData[12] VGND VPWR Tile_X0Y0_FrameStrobe[0] latch
X_127_ NPU_QUANT_SHIFT_IN12 Tile_X0Y0_UserCLK _377_/X _178_/L_HI VPWR VGND sg13cmos5l_dfrbpq_1
XFILLER_8_899 VPWR VGND sg13cmos5l_decap_8
XFILLER_7_398 VPWR VGND sg13cmos5l_decap_8
XFILLER_7_35 VPWR VGND sg13cmos5l_decap_8
XFILLER_1_508 VPWR VGND sg13cmos5l_fill_1
XFILLER_12_147 VPWR VGND sg13cmos5l_decap_8
XFILLER_16_77 VPWR VGND sg13cmos5l_decap_8
XFILLER_5_814 VPWR VGND sg13cmos5l_fill_2
XFILLER_0_596 VPWR VGND sg13cmos5l_fill_2
XFILLER_16_420 VPWR VGND sg13cmos5l_decap_8
XFILLER_17_921 VPWR VGND sg13cmos5l_decap_8
XFILLER_12_692 VPWR VGND sg13cmos5l_decap_8
XFILLER_16_497 VPWR VGND sg13cmos5l_decap_8
XFILLER_8_641 VPWR VGND sg13cmos5l_decap_8
XFILLER_7_140 VPWR VGND sg13cmos5l_decap_8
XFILLER_14_0 VPWR VGND sg13cmos5l_decap_8
XFILLER_10_618 VPWR VGND sg13cmos5l_decap_8
XANTENNA__341__X Tile_X0Y0_FrameStrobe_O[5] VPWR VGND sg13cmos5l_antennanp
XFILLER_17_217 VPWR VGND sg13cmos5l_decap_8
XFILLER_13_434 VPWR VGND sg13cmos5l_decap_8
X_392_ _392_/X Tile_X1Y0_N4END[12] Tile_X1Y0_N4END[13] Tile_X1Y0_NN4END[12] Tile_X1Y0_NN4END[14]
+ _088_/Q _087_/Q VPWR VGND sg13cmos5l_mux4_1
XFILLER_9_416 VPWR VGND sg13cmos5l_decap_8
XANTENNA__251__X Tile_X1Y0_SS4BEG[8] VPWR VGND sg13cmos5l_antennanp
XFILLER_5_677 VPWR VGND sg13cmos5l_decap_4
XFILLER_4_187 VPWR VGND sg13cmos5l_decap_8
XFILLER_4_14 VPWR VGND sg13cmos5l_decap_8
XFILLER_4_132 VPWR VGND sg13cmos5l_decap_8
XFILLER_4_69 VPWR VGND sg13cmos5l_decap_8
XFILLER_1_894 VPWR VGND sg13cmos5l_decap_8
XFILLER_1_861 VPWR VGND sg13cmos5l_decap_4
XFILLER_16_294 VPWR VGND sg13cmos5l_decap_8
XFILLER_17_795 VPWR VGND sg13cmos5l_decap_8
XANTENNA__336__X Tile_X0Y0_FrameStrobe_O[0] VPWR VGND sg13cmos5l_antennanp
XFILLER_10_415 VPWR VGND sg13cmos5l_decap_8
XFILLER_11_905 VPWR VGND sg13cmos5l_decap_8
XFILLER_13_56 VPWR VGND sg13cmos5l_decap_8
XANTENNA__246__X Tile_X1Y0_SS4BEG[3] VPWR VGND sg13cmos5l_antennanp
XFILLER_13_231 VPWR VGND sg13cmos5l_decap_8
XFILLER_14_732 VPWR VGND sg13cmos5l_decap_8
XFILLER_18_537 VPWR VGND sg13cmos5l_decap_4
X_375_ _375_/X Tile_X0Y0_N4END[10] Tile_X0Y0_N4END[11] Tile_X0Y0_NN4END[8] Tile_X0Y0_NN4END[10]
+ _054_/Q _053_/Q VPWR VGND sg13cmos5l_mux4_1
XFILLER_9_246 VPWR VGND sg13cmos5l_decap_8
XFILLER_6_953 VPWR VGND sg13cmos5l_fill_2
XFILLER_1_680 VPWR VGND sg13cmos5l_decap_8
XFILLER_1_691 VPWR VGND sg13cmos5l_fill_2
XFILLER_17_592 VPWR VGND sg13cmos5l_decap_8
XFILLER_15_518 VPWR VGND sg13cmos5l_decap_8
XFILLER_10_212 VPWR VGND sg13cmos5l_decap_8
XFILLER_10_289 VPWR VGND sg13cmos5l_decap_8
XFILLER_11_746 VPWR VGND sg13cmos5l_decap_8
X_091_ _091_/Q Tile_X0Y0_FrameData[15] VGND VPWR Tile_X1Y0_FrameStrobe[0] latch
X_160_ _160_/L_HI VPWR VGND sg13cmos5l_tiehi
XFILLER_6_238 VPWR VGND sg13cmos5l_decap_8
XFILLER_2_444 VPWR VGND sg13cmos5l_decap_8
XFILLER_18_312 VPWR VGND sg13cmos5l_decap_8
XANTENNA_130 Tile_X0Y0_N4END[2] VPWR VGND sg13cmos5l_antennanp
XANTENNA_141 Tile_X1Y0_N4END[13] VPWR VGND sg13cmos5l_antennanp
XANTENNA_152 Tile_X1Y0_N4END[8] VPWR VGND sg13cmos5l_antennanp
XANTENNA_163 Tile_X0Y0_FrameData[25] VPWR VGND sg13cmos5l_antennanp
XANTENNA_174 Tile_X0Y0_FrameData[25] VPWR VGND sg13cmos5l_antennanp
XANTENNA_185 Tile_X0Y0_FrameData[4] VPWR VGND sg13cmos5l_antennanp
XANTENNA_196 Tile_X1Y0_FrameStrobe[4] VPWR VGND sg13cmos5l_antennanp
XFILLER_14_595 VPWR VGND sg13cmos5l_decap_8
X_358_ Tile_X1Y0_FrameStrobe_O[2] Tile_X1Y0_FrameStrobe[2] VPWR VGND sg13cmos5l_buf_1
X_289_ Tile_X0Y0_SS4BEG[5] Tile_X0Y0_NN4END[10] VPWR VGND sg13cmos5l_buf_1
XFILLER_6_783 VPWR VGND sg13cmos5l_decap_8
XFILLER_10_79 VPWR VGND sg13cmos5l_decap_8
XFILLER_16_816 VPWR VGND sg13cmos5l_decap_8
XFILLER_15_315 VPWR VGND sg13cmos5l_decap_8
X_212_ Tile_X1Y0_S2BEG[1] Tile_X1Y0_N2MID[6] VPWR VGND sg13cmos5l_buf_1
XFILLER_11_565 VPWR VGND sg13cmos5l_decap_8
X_074_ _074_/Q Tile_X0Y0_FrameData[28] VGND VPWR Tile_X0Y0_FrameStrobe[1] latch
X_143_ NPU_QUANT_SHIFT_IN28 Tile_X0Y0_UserCLK _393_/X _173_/L_HI VPWR VGND sg13cmos5l_dfrbpq_1
XFILLER_7_514 VPWR VGND sg13cmos5l_decap_8
XFILLER_2_252 VPWR VGND sg13cmos5l_fill_1
XFILLER_18_7 VPWR VGND sg13cmos5l_decap_8
XFILLER_14_392 VPWR VGND sg13cmos5l_decap_8
XFILLER_12_329 VPWR VGND sg13cmos5l_decap_8
XANTENNA_30 Tile_X0Y0_FrameData[19] VPWR VGND sg13cmos5l_antennanp
XANTENNA_41 Tile_X0Y0_FrameData[1] VPWR VGND sg13cmos5l_antennanp
XANTENNA_52 Tile_X0Y0_FrameData[21] VPWR VGND sg13cmos5l_antennanp
XANTENNA_63 Tile_X0Y0_FrameData[22] VPWR VGND sg13cmos5l_antennanp
XANTENNA_74 Tile_X0Y0_FrameData[28] VPWR VGND sg13cmos5l_antennanp
XANTENNA_85 Tile_X0Y0_FrameData[2] VPWR VGND sg13cmos5l_antennanp
XANTENNA_96 Tile_X0Y0_FrameData[5] VPWR VGND sg13cmos5l_antennanp
XANTENNA__344__X Tile_X0Y0_FrameStrobe_O[8] VPWR VGND sg13cmos5l_antennanp
XFILLER_0_734 VPWR VGND sg13cmos5l_decap_8
XFILLER_15_112 VPWR VGND sg13cmos5l_decap_8
XFILLER_16_613 VPWR VGND sg13cmos5l_decap_8
XANTENNA__254__X Tile_X1Y0_SS4BEG[11] VPWR VGND sg13cmos5l_antennanp
XFILLER_11_362 VPWR VGND sg13cmos5l_decap_8
XFILLER_12_841 VPWR VGND sg13cmos5l_decap_8
XFILLER_15_189 VPWR VGND sg13cmos5l_decap_8
XFILLER_7_14 VPWR VGND sg13cmos5l_decap_8
X_057_ _057_/Q Tile_X0Y0_FrameData[13] VGND VPWR Tile_X0Y0_FrameStrobe[0] latch
X_126_ NPU_QUANT_SHIFT_IN11 Tile_X0Y0_UserCLK _376_/X _151_/L_HI VPWR VGND sg13cmos5l_dfrbpq_1
XFILLER_8_878 VPWR VGND sg13cmos5l_decap_8
XFILLER_3_594 VPWR VGND sg13cmos5l_decap_8
XANTENNA__339__X Tile_X0Y0_FrameStrobe_O[3] VPWR VGND sg13cmos5l_antennanp
XFILLER_12_126 VPWR VGND sg13cmos5l_decap_8
XFILLER_13_605 VPWR VGND sg13cmos5l_fill_1
XFILLER_13_616 VPWR VGND sg13cmos5l_decap_4
XFILLER_13_638 VPWR VGND sg13cmos5l_decap_4
XFILLER_16_56 VPWR VGND sg13cmos5l_decap_8
XFILLER_8_119 VPWR VGND sg13cmos5l_decap_8
XANTENNA__249__X Tile_X1Y0_SS4BEG[6] VPWR VGND sg13cmos5l_antennanp
XFILLER_16_476 VPWR VGND sg13cmos5l_decap_8
XFILLER_17_944 VPWR VGND sg13cmos5l_decap_8
XFILLER_17_900 VPWR VGND sg13cmos5l_decap_8
XFILLER_12_671 VPWR VGND sg13cmos5l_decap_8
XFILLER_8_697 VPWR VGND sg13cmos5l_decap_8
XFILLER_8_620 VPWR VGND sg13cmos5l_decap_8
X_109_ _109_/Q Tile_X0Y0_FrameData[29] VGND VPWR Tile_X1Y0_FrameStrobe[1] latch
XFILLER_7_196 VPWR VGND sg13cmos5l_decap_8
XFILLER_4_881 VPWR VGND sg13cmos5l_decap_8
XFILLER_13_413 VPWR VGND sg13cmos5l_decap_8
XFILLER_14_914 VPWR VGND sg13cmos5l_decap_8
XFILLER_14_958 VPWR VGND sg13cmos5l_fill_2
X_391_ _391_/X Tile_X1Y0_N4END[8] Tile_X1Y0_N4END[11] Tile_X1Y0_NN4END[9] Tile_X1Y0_NN4END[11]
+ _090_/Q _089_/Q VPWR VGND sg13cmos5l_mux4_1
XFILLER_5_612 VPWR VGND sg13cmos5l_decap_4
XFILLER_5_656 VPWR VGND sg13cmos5l_decap_8
XFILLER_4_48 VPWR VGND sg13cmos5l_decap_8
XFILLER_4_37 VPWR VGND sg13cmos5l_fill_1
XFILLER_4_111 VPWR VGND sg13cmos5l_decap_8
XFILLER_1_873 VPWR VGND sg13cmos5l_decap_8
XFILLER_16_273 VPWR VGND sg13cmos5l_decap_8
XFILLER_17_774 VPWR VGND sg13cmos5l_decap_8
XFILLER_12_490 VPWR VGND sg13cmos5l_decap_8
XFILLER_8_494 VPWR VGND sg13cmos5l_decap_8
XFILLER_13_35 VPWR VGND sg13cmos5l_decap_8
XANTENNA__352__X Tile_X0Y0_FrameStrobe_O[16] VPWR VGND sg13cmos5l_antennanp
XFILLER_1_103 VPWR VGND sg13cmos5l_decap_8
XFILLER_18_549 VPWR VGND sg13cmos5l_fill_2
XFILLER_13_210 VPWR VGND sg13cmos5l_decap_8
XFILLER_14_711 VPWR VGND sg13cmos5l_decap_8
XFILLER_14_788 VPWR VGND sg13cmos5l_decap_8
X_374_ _374_/X Tile_X0Y0_N4END[9] Tile_X0Y0_N4END[10] Tile_X0Y0_NN4END[9] Tile_X0Y0_NN4END[11]
+ _056_/Q _055_/Q VPWR VGND sg13cmos5l_mux4_1
XFILLER_9_225 VPWR VGND sg13cmos5l_decap_8
XANTENNA__262__X Tile_X0Y0_S2BEGb[2] VPWR VGND sg13cmos5l_antennanp
XFILLER_13_287 VPWR VGND sg13cmos5l_decap_8
XFILLER_17_571 VPWR VGND sg13cmos5l_decap_8
XFILLER_8_280 VPWR VGND sg13cmos5l_decap_8
XFILLER_5_91 VPWR VGND sg13cmos5l_decap_8
XANTENNA__121__Q NPU_QUANT_SHIFT_IN6 VPWR VGND sg13cmos5l_antennanp
XANTENNA__347__X Tile_X0Y0_FrameStrobe_O[11] VPWR VGND sg13cmos5l_antennanp
XFILLER_11_725 VPWR VGND sg13cmos5l_decap_8
XFILLER_10_268 VPWR VGND sg13cmos5l_decap_8
X_090_ _090_/Q Tile_X0Y0_FrameData[16] VGND VPWR Tile_X1Y0_FrameStrobe[0] latch
XFILLER_6_217 VPWR VGND sg13cmos5l_decap_8
XFILLER_3_935 VPWR VGND sg13cmos5l_fill_1
XFILLER_3_924 VPWR VGND sg13cmos5l_decap_8
XANTENNA_120 Tile_X0Y0_FrameData[7] VPWR VGND sg13cmos5l_antennanp
XANTENNA_131 Tile_X0Y0_N4END[2] VPWR VGND sg13cmos5l_antennanp
XANTENNA_142 Tile_X1Y0_N4END[13] VPWR VGND sg13cmos5l_antennanp
XANTENNA__257__X Tile_X1Y0_SS4BEG[14] VPWR VGND sg13cmos5l_antennanp
XFILLER_1_49 VPWR VGND sg13cmos5l_decap_4
XANTENNA_153 Tile_X1Y0_NN4END[12] VPWR VGND sg13cmos5l_antennanp
XANTENNA_164 Tile_X0Y0_FrameData[25] VPWR VGND sg13cmos5l_antennanp
XANTENNA_175 Tile_X0Y0_FrameData[25] VPWR VGND sg13cmos5l_antennanp
XANTENNA_186 Tile_X0Y0_FrameData[4] VPWR VGND sg13cmos5l_antennanp
XANTENNA_197 Tile_X0Y0_FrameData[13] VPWR VGND sg13cmos5l_antennanp
XFILLER_14_574 VPWR VGND sg13cmos5l_decap_8
X_357_ Tile_X1Y0_FrameStrobe_O[1] Tile_X1Y0_FrameStrobe[1] VPWR VGND sg13cmos5l_buf_1
X_288_ Tile_X0Y0_SS4BEG[4] Tile_X0Y0_NN4END[11] VPWR VGND sg13cmos5l_buf_1
XFILLER_5_272 VPWR VGND sg13cmos5l_decap_4
XFILLER_5_261 VPWR VGND sg13cmos5l_fill_1
XANTENNA__116__Q NPU_QUANT_SHIFT_IN1 VPWR VGND sg13cmos5l_antennanp
XFILLER_0_927 VPWR VGND sg13cmos5l_decap_8
XFILLER_0_938 VPWR VGND sg13cmos5l_fill_1
XFILLER_10_58 VPWR VGND sg13cmos5l_decap_8
XFILLER_11_544 VPWR VGND sg13cmos5l_decap_8
X_142_ NPU_QUANT_SHIFT_IN27 Tile_X0Y0_UserCLK _392_/X _174_/L_HI VPWR VGND sg13cmos5l_dfrbpq_1
X_211_ Tile_X1Y0_S2BEG[0] Tile_X1Y0_N2MID[7] VPWR VGND sg13cmos5l_buf_1
XFILLER_11_599 VPWR VGND sg13cmos5l_decap_8
X_073_ _073_/Q Tile_X0Y0_FrameData[29] VGND VPWR Tile_X0Y0_FrameStrobe[1] latch
XFILLER_4_0 VPWR VGND sg13cmos5l_decap_8
XFILLER_3_776 VPWR VGND sg13cmos5l_decap_8
XFILLER_18_187 VPWR VGND sg13cmos5l_fill_2
XFILLER_18_176 VPWR VGND sg13cmos5l_decap_8
XFILLER_14_371 VPWR VGND sg13cmos5l_decap_8
XFILLER_15_894 VPWR VGND sg13cmos5l_decap_8
XFILLER_2_92 VPWR VGND sg13cmos5l_fill_2
XFILLER_2_70 VPWR VGND sg13cmos5l_fill_2
XANTENNA_20 Tile_X0Y0_FrameData[17] VPWR VGND sg13cmos5l_antennanp
XANTENNA_31 Tile_X0Y0_FrameData[19] VPWR VGND sg13cmos5l_antennanp
XFILLER_12_308 VPWR VGND sg13cmos5l_decap_8
XANTENNA_42 Tile_X0Y0_FrameData[1] VPWR VGND sg13cmos5l_antennanp
XANTENNA_53 Tile_X0Y0_FrameData[21] VPWR VGND sg13cmos5l_antennanp
XANTENNA_64 Tile_X0Y0_FrameData[23] VPWR VGND sg13cmos5l_antennanp
XANTENNA_75 Tile_X0Y0_FrameData[28] VPWR VGND sg13cmos5l_antennanp
XANTENNA_86 Tile_X0Y0_FrameData[2] VPWR VGND sg13cmos5l_antennanp
XANTENNA_97 Tile_X0Y0_FrameData[5] VPWR VGND sg13cmos5l_antennanp
XANTENNA__360__X Tile_X1Y0_FrameStrobe_O[4] VPWR VGND sg13cmos5l_antennanp
XFILLER_4_529 VPWR VGND sg13cmos5l_decap_4
XFILLER_0_713 VPWR VGND sg13cmos5l_decap_8
XFILLER_15_168 VPWR VGND sg13cmos5l_decap_8
XFILLER_16_669 VPWR VGND sg13cmos5l_decap_8
XFILLER_11_341 VPWR VGND sg13cmos5l_decap_8
XFILLER_12_820 VPWR VGND sg13cmos5l_decap_8
XFILLER_12_897 VPWR VGND sg13cmos5l_decap_8
X_125_ NPU_QUANT_SHIFT_IN10 Tile_X0Y0_UserCLK _375_/X _159_/L_HI VPWR VGND sg13cmos5l_dfrbpq_1
XFILLER_7_356 VPWR VGND sg13cmos5l_decap_4
XANTENNA__270__X Tile_X0Y0_S4BEG[2] VPWR VGND sg13cmos5l_antennanp
X_056_ _056_/Q Tile_X0Y0_FrameData[14] VGND VPWR Tile_X0Y0_FrameStrobe[0] latch
XFILLER_7_389 VPWR VGND sg13cmos5l_decap_4
XFILLER_3_573 VPWR VGND sg13cmos5l_decap_4
XFILLER_7_890 VPWR VGND sg13cmos5l_fill_1
XFILLER_16_35 VPWR VGND sg13cmos5l_decap_8
XANTENNA__355__X Tile_X0Y0_FrameStrobe_O[19] VPWR VGND sg13cmos5l_antennanp
XFILLER_12_105 VPWR VGND sg13cmos5l_decap_8
XFILLER_0_510 VPWR VGND sg13cmos5l_fill_1
XFILLER_0_521 VPWR VGND sg13cmos5l_decap_8
XFILLER_0_532 VPWR VGND sg13cmos5l_fill_2
XANTENNA__265__X Tile_X0Y0_S2BEGb[5] VPWR VGND sg13cmos5l_antennanp
XFILLER_16_455 VPWR VGND sg13cmos5l_decap_8
XFILLER_11_182 VPWR VGND sg13cmos5l_decap_8
XFILLER_12_650 VPWR VGND sg13cmos5l_decap_8
X_108_ _108_/Q Tile_X0Y0_FrameData[30] VGND VPWR Tile_X1Y0_FrameStrobe[1] latch
XFILLER_8_676 VPWR VGND sg13cmos5l_decap_8
XFILLER_7_175 VPWR VGND sg13cmos5l_decap_8
X_039_ NPU_PSUM_SKEW_EN Tile_X0Y0_UserCLK _039_/D _161_/L_HI VPWR VGND sg13cmos5l_dfrbpq_1
XANTENNA__124__Q NPU_QUANT_SHIFT_IN9 VPWR VGND sg13cmos5l_antennanp
XFILLER_8_91 VPWR VGND sg13cmos5l_decap_8
X_390_ _390_/X Tile_X1Y0_N4END[10] Tile_X1Y0_N4END[11] Tile_X1Y0_NN4END[8] Tile_X1Y0_NN4END[10]
+ _092_/Q _091_/Q VPWR VGND sg13cmos5l_mux4_1
XFILLER_13_469 VPWR VGND sg13cmos5l_decap_8
XFILLER_5_635 VPWR VGND sg13cmos5l_decap_8
XFILLER_1_841 VPWR VGND sg13cmos5l_fill_2
XFILLER_17_753 VPWR VGND sg13cmos5l_decap_8
XFILLER_16_252 VPWR VGND sg13cmos5l_decap_8
XFILLER_9_930 VPWR VGND sg13cmos5l_decap_4
XFILLER_8_473 VPWR VGND sg13cmos5l_decap_8
XFILLER_4_690 VPWR VGND sg13cmos5l_decap_8
XANTENNA__119__Q NPU_QUANT_SHIFT_IN4 VPWR VGND sg13cmos5l_antennanp
XFILLER_13_14 VPWR VGND sg13cmos5l_decap_8
XFILLER_8_7 VPWR VGND sg13cmos5l_decap_8
XFILLER_1_115 VPWR VGND sg13cmos5l_fill_2
XFILLER_13_266 VPWR VGND sg13cmos5l_decap_8
XFILLER_14_767 VPWR VGND sg13cmos5l_decap_8
X_373_ _373_/X Tile_X0Y0_N4END[8] Tile_X0Y0_N4END[9] Tile_X0Y0_NN4END[8] Tile_X0Y0_NN4END[10]
+ _058_/Q _057_/Q VPWR VGND sg13cmos5l_mux4_1
XFILLER_9_204 VPWR VGND sg13cmos5l_decap_8
XFILLER_5_476 VPWR VGND sg13cmos5l_decap_8
XFILLER_5_410 VPWR VGND sg13cmos5l_decap_8
XFILLER_17_550 VPWR VGND sg13cmos5l_decap_8
XFILLER_5_70 VPWR VGND sg13cmos5l_decap_8
XFILLER_11_704 VPWR VGND sg13cmos5l_decap_8
XANTENNA__363__X Tile_X1Y0_FrameStrobe_O[7] VPWR VGND sg13cmos5l_antennanp
XFILLER_10_247 VPWR VGND sg13cmos5l_decap_8
XFILLER_3_903 VPWR VGND sg13cmos5l_decap_8
XFILLER_3_958 VPWR VGND sg13cmos5l_fill_2
XFILLER_2_479 VPWR VGND sg13cmos5l_decap_8
XFILLER_1_28 VPWR VGND sg13cmos5l_decap_8
XANTENNA_110 Tile_X0Y0_FrameData[6] VPWR VGND sg13cmos5l_antennanp
XANTENNA_121 Tile_X0Y0_FrameData[7] VPWR VGND sg13cmos5l_antennanp
XANTENNA_132 Tile_X1Y0_FrameStrobe[6] VPWR VGND sg13cmos5l_antennanp
XANTENNA_143 Tile_X1Y0_N4END[13] VPWR VGND sg13cmos5l_antennanp
XANTENNA_154 Tile_X1Y0_NN4END[12] VPWR VGND sg13cmos5l_antennanp
XANTENNA_165 Tile_X0Y0_FrameData[25] VPWR VGND sg13cmos5l_antennanp
XANTENNA_176 Tile_X0Y0_FrameData[25] VPWR VGND sg13cmos5l_antennanp
XFILLER_18_336 VPWR VGND sg13cmos5l_decap_8
XANTENNA_187 Tile_X0Y0_N4END[3] VPWR VGND sg13cmos5l_antennanp
XANTENNA_198 Tile_X0Y0_FrameData[13] VPWR VGND sg13cmos5l_antennanp
XANTENNA__273__X Tile_X0Y0_S4BEG[5] VPWR VGND sg13cmos5l_antennanp
XFILLER_14_553 VPWR VGND sg13cmos5l_decap_8
X_287_ Tile_X0Y0_SS4BEG[3] Tile_X0Y0_NN4END[12] VPWR VGND sg13cmos5l_buf_1
X_356_ Tile_X1Y0_FrameStrobe_O[0] Tile_X1Y0_FrameStrobe[0] VPWR VGND sg13cmos5l_buf_1
XFILLER_10_37 VPWR VGND sg13cmos5l_decap_8
XANTENNA__132__Q NPU_QUANT_SHIFT_IN17 VPWR VGND sg13cmos5l_antennanp
XFILLER_0_906 VPWR VGND sg13cmos5l_decap_8
XANTENNA__358__X Tile_X1Y0_FrameStrobe_O[2] VPWR VGND sg13cmos5l_antennanp
XFILLER_11_523 VPWR VGND sg13cmos5l_decap_8
X_141_ NPU_QUANT_SHIFT_IN26 Tile_X0Y0_UserCLK _391_/X _175_/L_HI VPWR VGND sg13cmos5l_dfrbpq_1
X_210_ Tile_X1Y0_S1BEG[3] Tile_X1Y0_N1END[0] VPWR VGND sg13cmos5l_buf_1
XFILLER_7_549 VPWR VGND sg13cmos5l_decap_8
X_072_ _072_/Q Tile_X0Y0_FrameData[30] VGND VPWR Tile_X0Y0_FrameStrobe[1] latch
XFILLER_3_711 VPWR VGND sg13cmos5l_fill_1
XFILLER_2_210 VPWR VGND sg13cmos5l_decap_8
XANTENNA__268__X Tile_X0Y0_S4BEG[0] VPWR VGND sg13cmos5l_antennanp
XFILLER_18_133 VPWR VGND sg13cmos5l_decap_4
XFILLER_14_350 VPWR VGND sg13cmos5l_decap_8
XFILLER_15_873 VPWR VGND sg13cmos5l_decap_8
XFILLER_18_199 VPWR VGND sg13cmos5l_decap_8
XFILLER_18_155 VPWR VGND sg13cmos5l_decap_8
X_339_ Tile_X0Y0_FrameStrobe_O[3] Tile_X0Y0_FrameStrobe[3] VPWR VGND sg13cmos5l_buf_1
XFILLER_2_82 VPWR VGND sg13cmos5l_fill_2
XANTENNA_10 Tile_X0Y0_FrameData[11] VPWR VGND sg13cmos5l_antennanp
XANTENNA_21 Tile_X0Y0_FrameData[17] VPWR VGND sg13cmos5l_antennanp
XANTENNA_32 Tile_X0Y0_FrameData[19] VPWR VGND sg13cmos5l_antennanp
XANTENNA_43 Tile_X0Y0_FrameData[20] VPWR VGND sg13cmos5l_antennanp
XANTENNA_54 Tile_X0Y0_FrameData[21] VPWR VGND sg13cmos5l_antennanp
XANTENNA_65 Tile_X0Y0_FrameData[23] VPWR VGND sg13cmos5l_antennanp
XANTENNA__127__Q NPU_QUANT_SHIFT_IN12 VPWR VGND sg13cmos5l_antennanp
XANTENNA_76 Tile_X0Y0_FrameData[28] VPWR VGND sg13cmos5l_antennanp
XANTENNA_87 Tile_X0Y0_FrameData[3] VPWR VGND sg13cmos5l_antennanp
XANTENNA_98 Tile_X0Y0_FrameData[5] VPWR VGND sg13cmos5l_antennanp
XFILLER_4_508 VPWR VGND sg13cmos5l_decap_8
XFILLER_0_769 VPWR VGND sg13cmos5l_decap_8
XFILLER_15_147 VPWR VGND sg13cmos5l_decap_8
XFILLER_16_626 VPWR VGND sg13cmos5l_decap_4
XFILLER_16_648 VPWR VGND sg13cmos5l_decap_8
XFILLER_11_320 VPWR VGND sg13cmos5l_decap_8
XFILLER_11_397 VPWR VGND sg13cmos5l_decap_8
XFILLER_12_876 VPWR VGND sg13cmos5l_decap_8
X_055_ _055_/Q Tile_X0Y0_FrameData[15] VGND VPWR Tile_X0Y0_FrameStrobe[0] latch
X_124_ NPU_QUANT_SHIFT_IN9 Tile_X0Y0_UserCLK _374_/X _187_/L_HI VPWR VGND sg13cmos5l_dfrbpq_1
XFILLER_7_49 VPWR VGND sg13cmos5l_decap_8
XFILLER_7_324 VPWR VGND sg13cmos5l_fill_1
XFILLER_11_91 VPWR VGND sg13cmos5l_decap_8
XFILLER_3_585 VPWR VGND sg13cmos5l_fill_2
XFILLER_16_14 VPWR VGND sg13cmos5l_decap_8
XFILLER_17_935 VPWR VGND sg13cmos5l_decap_4
XFILLER_16_434 VPWR VGND sg13cmos5l_decap_8
XANTENNA__281__X Tile_X0Y0_S4BEG[13] VPWR VGND sg13cmos5l_antennanp
XFILLER_11_161 VPWR VGND sg13cmos5l_decap_8
X_038_ _039_/D _396_/X _114_/Q VPWR VGND sg13cmos5l_or2_1
X_107_ _107_/Q Tile_X0Y0_FrameData[31] VGND VPWR Tile_X1Y0_FrameStrobe[1] latch
XFILLER_8_655 VPWR VGND sg13cmos5l_decap_8
XFILLER_7_154 VPWR VGND sg13cmos5l_decap_8
XANTENNA__191__X Tile_X1Y0_FrameStrobe_O[12] VPWR VGND sg13cmos5l_antennanp
XFILLER_8_70 VPWR VGND sg13cmos5l_decap_8
XANTENNA__140__Q NPU_QUANT_SHIFT_IN25 VPWR VGND sg13cmos5l_antennanp
XFILLER_13_448 VPWR VGND sg13cmos5l_decap_8
XFILLER_14_938 VPWR VGND sg13cmos5l_fill_2
XFILLER_4_146 VPWR VGND sg13cmos5l_decap_8
XFILLER_0_396 VPWR VGND sg13cmos5l_fill_1
XFILLER_4_28 VPWR VGND sg13cmos5l_decap_8
XANTENNA__276__X Tile_X0Y0_S4BEG[8] VPWR VGND sg13cmos5l_antennanp
XFILLER_16_231 VPWR VGND sg13cmos5l_decap_8
XFILLER_17_732 VPWR VGND sg13cmos5l_decap_8
XFILLER_8_452 VPWR VGND sg13cmos5l_decap_8
XFILLER_12_0 VPWR VGND sg13cmos5l_decap_8
XFILLER_11_919 VPWR VGND sg13cmos5l_decap_4
XANTENNA__135__Q NPU_QUANT_SHIFT_IN20 VPWR VGND sg13cmos5l_antennanp
XFILLER_10_429 VPWR VGND sg13cmos5l_decap_8
XFILLER_1_127 VPWR VGND sg13cmos5l_fill_2
XFILLER_18_507 VPWR VGND sg13cmos5l_decap_8
XFILLER_13_245 VPWR VGND sg13cmos5l_decap_8
XFILLER_14_746 VPWR VGND sg13cmos5l_decap_8
X_372_ _372_/X Tile_X0Y0_N4END[4] Tile_X0Y0_N4END[7] Tile_X0Y0_NN4END[5] Tile_X0Y0_NN4END[7]
+ _060_/Q _059_/Q VPWR VGND sg13cmos5l_mux4_1
XFILLER_6_912 VPWR VGND sg13cmos5l_decap_8
XFILLER_5_455 VPWR VGND sg13cmos5l_decap_8
XFILLER_0_182 VPWR VGND sg13cmos5l_decap_8
XFILLER_1_672 VPWR VGND sg13cmos5l_decap_4
XFILLER_9_783 VPWR VGND sg13cmos5l_fill_2
XFILLER_10_226 VPWR VGND sg13cmos5l_decap_8
XFILLER_2_458 VPWR VGND sg13cmos5l_decap_8
XANTENNA_100 Tile_X0Y0_FrameData[5] VPWR VGND sg13cmos5l_antennanp
XANTENNA_111 Tile_X0Y0_FrameData[6] VPWR VGND sg13cmos5l_antennanp
XANTENNA_122 Tile_X0Y0_FrameData[7] VPWR VGND sg13cmos5l_antennanp
XANTENNA_133 Tile_X1Y0_FrameStrobe[8] VPWR VGND sg13cmos5l_antennanp
XANTENNA_144 Tile_X1Y0_N4END[8] VPWR VGND sg13cmos5l_antennanp
XANTENNA_155 Tile_X1Y0_NN4END[12] VPWR VGND sg13cmos5l_antennanp
XANTENNA_166 Tile_X0Y0_FrameData[25] VPWR VGND sg13cmos5l_antennanp
XANTENNA_177 Tile_X0Y0_FrameData[25] VPWR VGND sg13cmos5l_antennanp
XANTENNA_188 Tile_X0Y0_N4END[3] VPWR VGND sg13cmos5l_antennanp
XANTENNA_199 Tile_X0Y0_FrameData[13] VPWR VGND sg13cmos5l_antennanp
XFILLER_14_532 VPWR VGND sg13cmos5l_decap_8
XFILLER_18_359 VPWR VGND sg13cmos5l_decap_8
XFILLER_14_91 VPWR VGND sg13cmos5l_decap_8
X_286_ Tile_X0Y0_SS4BEG[2] Tile_X0Y0_NN4END[13] VPWR VGND sg13cmos5l_buf_1
X_355_ Tile_X0Y0_FrameStrobe_O[19] Tile_X0Y0_FrameStrobe[19] VPWR VGND sg13cmos5l_buf_1
XFILLER_6_753 VPWR VGND sg13cmos5l_decap_8
XFILLER_6_797 VPWR VGND sg13cmos5l_fill_1
XFILLER_5_252 VPWR VGND sg13cmos5l_decap_8
XFILLER_18_871 VPWR VGND sg13cmos5l_decap_4
XFILLER_18_893 VPWR VGND sg13cmos5l_decap_8
XFILLER_17_392 VPWR VGND sg13cmos5l_decap_8
XFILLER_10_16 VPWR VGND sg13cmos5l_decap_8
XFILLER_15_329 VPWR VGND sg13cmos5l_decap_8
XFILLER_11_502 VPWR VGND sg13cmos5l_decap_8
XFILLER_11_579 VPWR VGND sg13cmos5l_decap_8
X_071_ _071_/Q Tile_X0Y0_FrameData[31] VGND VPWR Tile_X0Y0_FrameStrobe[1] latch
X_140_ NPU_QUANT_SHIFT_IN25 Tile_X0Y0_UserCLK _390_/X _165_/L_HI VPWR VGND sg13cmos5l_dfrbpq_1
XFILLER_7_528 VPWR VGND sg13cmos5l_decap_8
XFILLER_2_233 VPWR VGND sg13cmos5l_decap_8
XFILLER_18_112 VPWR VGND sg13cmos5l_decap_8
XANTENNA__284__X Tile_X0Y0_SS4BEG[0] VPWR VGND sg13cmos5l_antennanp
XFILLER_15_852 VPWR VGND sg13cmos5l_decap_8
X_338_ Tile_X0Y0_FrameStrobe_O[2] Tile_X0Y0_FrameStrobe[2] VPWR VGND sg13cmos5l_buf_1
XFILLER_10_590 VPWR VGND sg13cmos5l_decap_8
X_269_ Tile_X0Y0_S4BEG[1] Tile_X0Y0_N4END[14] VPWR VGND sg13cmos5l_buf_1
XANTENNA_11 Tile_X0Y0_FrameData[11] VPWR VGND sg13cmos5l_antennanp
XANTENNA_22 Tile_X0Y0_FrameData[17] VPWR VGND sg13cmos5l_antennanp
XANTENNA_33 Tile_X0Y0_FrameData[19] VPWR VGND sg13cmos5l_antennanp
XANTENNA_44 Tile_X0Y0_FrameData[20] VPWR VGND sg13cmos5l_antennanp
XANTENNA_55 Tile_X0Y0_FrameData[22] VPWR VGND sg13cmos5l_antennanp
XANTENNA_66 Tile_X0Y0_FrameData[23] VPWR VGND sg13cmos5l_antennanp
XANTENNA_77 Tile_X0Y0_FrameData[28] VPWR VGND sg13cmos5l_antennanp
XANTENNA_88 Tile_X0Y0_FrameData[3] VPWR VGND sg13cmos5l_antennanp
XANTENNA_99 Tile_X0Y0_FrameData[5] VPWR VGND sg13cmos5l_antennanp
XANTENNA__194__X Tile_X1Y0_FrameStrobe_O[15] VPWR VGND sg13cmos5l_antennanp
XANTENNA__143__Q NPU_QUANT_SHIFT_IN28 VPWR VGND sg13cmos5l_antennanp
XFILLER_0_748 VPWR VGND sg13cmos5l_decap_8
XFILLER_12_811 VPWR VGND sg13cmos5l_decap_4
XFILLER_12_855 VPWR VGND sg13cmos5l_decap_8
XFILLER_15_126 VPWR VGND sg13cmos5l_decap_8
XFILLER_11_376 VPWR VGND sg13cmos5l_decap_8
X_054_ _054_/Q Tile_X0Y0_FrameData[16] VGND VPWR Tile_X0Y0_FrameStrobe[0] latch
X_123_ NPU_QUANT_SHIFT_IN8 Tile_X0Y0_UserCLK _373_/X _186_/L_HI VPWR VGND sg13cmos5l_dfrbpq_1
XFILLER_7_28 VPWR VGND sg13cmos5l_decap_8
XANTENNA__279__X Tile_X0Y0_S4BEG[11] VPWR VGND sg13cmos5l_antennanp
XFILLER_11_70 VPWR VGND sg13cmos5l_decap_8
XFILLER_16_7 VPWR VGND sg13cmos5l_decap_8
XFILLER_15_682 VPWR VGND sg13cmos5l_decap_8
XANTENNA__189__X Tile_X1Y0_FrameStrobe_O[10] VPWR VGND sg13cmos5l_antennanp
XANTENNA__138__Q NPU_QUANT_SHIFT_IN23 VPWR VGND sg13cmos5l_antennanp
XFILLER_0_501 VPWR VGND sg13cmos5l_decap_8
XFILLER_0_589 VPWR VGND sg13cmos5l_decap_8
XFILLER_16_413 VPWR VGND sg13cmos5l_decap_8
XFILLER_17_958 VPWR VGND sg13cmos5l_fill_2
XFILLER_17_914 VPWR VGND sg13cmos5l_decap_8
XFILLER_11_140 VPWR VGND sg13cmos5l_decap_8
XFILLER_12_685 VPWR VGND sg13cmos5l_decap_8
XFILLER_8_634 VPWR VGND sg13cmos5l_decap_8
X_106_ _106_/Q Tile_X0Y0_FrameData[0] VGND VPWR Tile_X1Y0_FrameStrobe[0] latch
XFILLER_7_133 VPWR VGND sg13cmos5l_decap_8
XFILLER_4_895 VPWR VGND sg13cmos5l_decap_8
XFILLER_15_490 VPWR VGND sg13cmos5l_decap_8
XFILLER_13_427 VPWR VGND sg13cmos5l_decap_8
XFILLER_14_928 VPWR VGND sg13cmos5l_decap_8
XFILLER_9_409 VPWR VGND sg13cmos5l_decap_8
XFILLER_4_125 VPWR VGND sg13cmos5l_decap_8
XFILLER_1_887 VPWR VGND sg13cmos5l_decap_8
XFILLER_1_854 VPWR VGND sg13cmos5l_decap_8
XFILLER_1_832 VPWR VGND sg13cmos5l_fill_2
XFILLER_16_210 VPWR VGND sg13cmos5l_decap_8
XFILLER_16_287 VPWR VGND sg13cmos5l_decap_8
XFILLER_17_91 VPWR VGND sg13cmos5l_decap_8
XFILLER_17_788 VPWR VGND sg13cmos5l_decap_8
XFILLER_17_711 VPWR VGND sg13cmos5l_decap_8
XANTENNA__292__X Tile_X0Y0_SS4BEG[8] VPWR VGND sg13cmos5l_antennanp
XFILLER_8_431 VPWR VGND sg13cmos5l_decap_8
XFILLER_10_408 VPWR VGND sg13cmos5l_decap_8
XFILLER_13_49 VPWR VGND sg13cmos5l_decap_8
XFILLER_2_629 VPWR VGND sg13cmos5l_decap_8
XFILLER_13_224 VPWR VGND sg13cmos5l_decap_8
XFILLER_14_725 VPWR VGND sg13cmos5l_decap_8
X_371_ _371_/X Tile_X0Y0_N4END[6] Tile_X0Y0_N4END[7] Tile_X0Y0_NN4END[4] Tile_X0Y0_NN4END[6]
+ _062_/Q _061_/Q VPWR VGND sg13cmos5l_mux4_1
XFILLER_9_239 VPWR VGND sg13cmos5l_decap_8
XANTENNA__287__X Tile_X0Y0_SS4BEG[3] VPWR VGND sg13cmos5l_antennanp
XFILLER_0_161 VPWR VGND sg13cmos5l_decap_8
XFILLER_17_585 VPWR VGND sg13cmos5l_decap_8
XFILLER_13_791 VPWR VGND sg13cmos5l_decap_8
XFILLER_8_294 VPWR VGND sg13cmos5l_decap_4
XANTENNA__197__X Tile_X1Y0_FrameStrobe_O[18] VPWR VGND sg13cmos5l_antennanp
XANTENNA__146__Q NPU_SWAP_WEIGHTS VPWR VGND sg13cmos5l_antennanp
XFILLER_10_205 VPWR VGND sg13cmos5l_decap_8
XFILLER_11_739 VPWR VGND sg13cmos5l_decap_8
XFILLER_18_305 VPWR VGND sg13cmos5l_decap_8
XANTENNA_101 Tile_X0Y0_FrameData[5] VPWR VGND sg13cmos5l_antennanp
XANTENNA_112 Tile_X0Y0_FrameData[6] VPWR VGND sg13cmos5l_antennanp
XANTENNA_123 Tile_X0Y0_N4END[2] VPWR VGND sg13cmos5l_antennanp
XANTENNA_134 Tile_X1Y0_FrameStrobe[9] VPWR VGND sg13cmos5l_antennanp
XANTENNA_145 Tile_X1Y0_N4END[8] VPWR VGND sg13cmos5l_antennanp
XANTENNA_156 Tile_X1Y0_NN4END[12] VPWR VGND sg13cmos5l_antennanp
XANTENNA_167 Tile_X0Y0_FrameData[25] VPWR VGND sg13cmos5l_antennanp
XANTENNA_178 Tile_X0Y0_FrameData[4] VPWR VGND sg13cmos5l_antennanp
XANTENNA_189 Tile_X0Y0_N4END[3] VPWR VGND sg13cmos5l_antennanp
XFILLER_14_511 VPWR VGND sg13cmos5l_decap_8
XFILLER_14_588 VPWR VGND sg13cmos5l_decap_8
X_354_ Tile_X0Y0_FrameStrobe_O[18] Tile_X0Y0_FrameStrobe[18] VPWR VGND sg13cmos5l_buf_1
XFILLER_14_70 VPWR VGND sg13cmos5l_decap_8
X_285_ Tile_X0Y0_SS4BEG[1] Tile_X0Y0_NN4END[14] VPWR VGND sg13cmos5l_buf_1
XFILLER_6_732 VPWR VGND sg13cmos5l_decap_8
XFILLER_5_231 VPWR VGND sg13cmos5l_decap_8
XFILLER_1_481 VPWR VGND sg13cmos5l_decap_4
XFILLER_18_850 VPWR VGND sg13cmos5l_decap_8
XFILLER_17_371 VPWR VGND sg13cmos5l_decap_8
XFILLER_15_308 VPWR VGND sg13cmos5l_decap_8
XFILLER_16_809 VPWR VGND sg13cmos5l_decap_8
XFILLER_11_558 VPWR VGND sg13cmos5l_decap_8
X_070_ _070_/Q Tile_X0Y0_FrameData[0] VGND VPWR Tile_X0Y0_FrameStrobe[0] latch
XFILLER_7_507 VPWR VGND sg13cmos5l_decap_8
XFILLER_2_245 VPWR VGND sg13cmos5l_fill_2
XFILLER_15_831 VPWR VGND sg13cmos5l_decap_8
XFILLER_14_385 VPWR VGND sg13cmos5l_decap_8
X_337_ Tile_X0Y0_FrameStrobe_O[1] Tile_X0Y0_FrameStrobe[1] VPWR VGND sg13cmos5l_buf_1
X_199_ Tile_X0Y0_S2BEG[0] Tile_X0Y0_N2MID[7] VPWR VGND sg13cmos5l_buf_1
X_268_ Tile_X0Y0_S4BEG[0] Tile_X0Y0_N4END[15] VPWR VGND sg13cmos5l_buf_1
XFILLER_2_84 VPWR VGND sg13cmos5l_fill_1
XANTENNA_12 Tile_X0Y0_FrameData[11] VPWR VGND sg13cmos5l_antennanp
XANTENNA_23 Tile_X0Y0_FrameData[17] VPWR VGND sg13cmos5l_antennanp
XANTENNA_34 Tile_X0Y0_FrameData[1] VPWR VGND sg13cmos5l_antennanp
XANTENNA_45 Tile_X0Y0_FrameData[20] VPWR VGND sg13cmos5l_antennanp
XANTENNA_56 Tile_X0Y0_FrameData[22] VPWR VGND sg13cmos5l_antennanp
XANTENNA_67 Tile_X0Y0_FrameData[23] VPWR VGND sg13cmos5l_antennanp
XANTENNA_78 Tile_X0Y0_FrameData[2] VPWR VGND sg13cmos5l_antennanp
XANTENNA_89 Tile_X0Y0_FrameData[3] VPWR VGND sg13cmos5l_antennanp
XFILLER_0_705 VPWR VGND sg13cmos5l_decap_4
XFILLER_0_727 VPWR VGND sg13cmos5l_decap_8
XFILLER_15_105 VPWR VGND sg13cmos5l_decap_8
XFILLER_16_606 VPWR VGND sg13cmos5l_decap_8
XFILLER_11_355 VPWR VGND sg13cmos5l_decap_8
XFILLER_12_834 VPWR VGND sg13cmos5l_decap_8
X_053_ _053_/Q Tile_X0Y0_FrameData[17] VGND VPWR Tile_X0Y0_FrameStrobe[0] latch
X_122_ NPU_QUANT_SHIFT_IN7 Tile_X0Y0_UserCLK _372_/X _185_/L_HI VPWR VGND sg13cmos5l_dfrbpq_1
XFILLER_3_532 VPWR VGND sg13cmos5l_fill_1
XFILLER_3_521 VPWR VGND sg13cmos5l_decap_8
XFILLER_2_0 VPWR VGND sg13cmos5l_decap_8
XANTENNA__295__X Tile_X0Y0_SS4BEG[11] VPWR VGND sg13cmos5l_antennanp
XFILLER_15_661 VPWR VGND sg13cmos5l_decap_8
XFILLER_14_182 VPWR VGND sg13cmos5l_decap_8
XFILLER_7_871 VPWR VGND sg13cmos5l_decap_4
XFILLER_12_119 VPWR VGND sg13cmos5l_decap_8
XFILLER_13_609 VPWR VGND sg13cmos5l_fill_2
XFILLER_16_49 VPWR VGND sg13cmos5l_decap_8
XFILLER_16_469 VPWR VGND sg13cmos5l_decap_8
XFILLER_11_196 VPWR VGND sg13cmos5l_decap_8
XFILLER_12_664 VPWR VGND sg13cmos5l_decap_8
X_105_ _105_/Q Tile_X0Y0_FrameData[1] VGND VPWR Tile_X1Y0_FrameStrobe[0] latch
XFILLER_8_613 VPWR VGND sg13cmos5l_decap_8
XFILLER_7_112 VPWR VGND sg13cmos5l_decap_8
XFILLER_7_189 VPWR VGND sg13cmos5l_decap_8
XFILLER_4_874 VPWR VGND sg13cmos5l_decap_8
XANTENNA__149__Q NPU_ARRAY_EN VPWR VGND sg13cmos5l_antennanp
XFILLER_13_406 VPWR VGND sg13cmos5l_decap_8
XFILLER_14_907 VPWR VGND sg13cmos5l_decap_8
XFILLER_5_605 VPWR VGND sg13cmos5l_decap_8
XFILLER_5_649 VPWR VGND sg13cmos5l_decap_8
XFILLER_5_616 VPWR VGND sg13cmos5l_fill_1
XFILLER_4_104 VPWR VGND sg13cmos5l_decap_8
XFILLER_16_266 VPWR VGND sg13cmos5l_decap_8
XFILLER_17_767 VPWR VGND sg13cmos5l_decap_8
XFILLER_17_70 VPWR VGND sg13cmos5l_decap_8
XFILLER_12_483 VPWR VGND sg13cmos5l_decap_8
XFILLER_8_487 VPWR VGND sg13cmos5l_decap_8
XFILLER_8_410 VPWR VGND sg13cmos5l_decap_8
XFILLER_13_28 VPWR VGND sg13cmos5l_decap_8
XFILLER_2_619 VPWR VGND sg13cmos5l_decap_4
XFILLER_1_129 VPWR VGND sg13cmos5l_fill_1
XFILLER_13_203 VPWR VGND sg13cmos5l_decap_8
XFILLER_14_704 VPWR VGND sg13cmos5l_decap_8
X_370_ _370_/X Tile_X0Y0_N4END[5] Tile_X0Y0_N4END[6] Tile_X0Y0_NN4END[5] Tile_X0Y0_NN4END[7]
+ _064_/Q _063_/Q VPWR VGND sg13cmos5l_mux4_1
XFILLER_9_218 VPWR VGND sg13cmos5l_decap_8
XFILLER_6_958 VPWR VGND sg13cmos5l_fill_2
XFILLER_0_140 VPWR VGND sg13cmos5l_decap_8
XFILLER_1_696 VPWR VGND sg13cmos5l_decap_8
XFILLER_17_564 VPWR VGND sg13cmos5l_decap_8
XFILLER_12_280 VPWR VGND sg13cmos5l_decap_8
XFILLER_13_770 VPWR VGND sg13cmos5l_decap_8
XFILLER_9_785 VPWR VGND sg13cmos5l_fill_1
XFILLER_8_273 VPWR VGND sg13cmos5l_decap_8
XFILLER_5_84 VPWR VGND sg13cmos5l_decap_8
XFILLER_11_718 VPWR VGND sg13cmos5l_decap_8
XFILLER_6_7 VPWR VGND sg13cmos5l_decap_8
XFILLER_3_917 VPWR VGND sg13cmos5l_decap_8
XANTENNA_102 Tile_X0Y0_FrameData[5] VPWR VGND sg13cmos5l_antennanp
XANTENNA_113 Tile_X0Y0_FrameData[6] VPWR VGND sg13cmos5l_antennanp
XANTENNA_124 Tile_X0Y0_N4END[2] VPWR VGND sg13cmos5l_antennanp
XANTENNA_135 Tile_X1Y0_N4END[13] VPWR VGND sg13cmos5l_antennanp
XANTENNA_146 Tile_X1Y0_N4END[8] VPWR VGND sg13cmos5l_antennanp
XANTENNA_157 Tile_X1Y0_NN4END[12] VPWR VGND sg13cmos5l_antennanp
XANTENNA_168 Tile_X0Y0_FrameData[25] VPWR VGND sg13cmos5l_antennanp
XANTENNA_179 Tile_X0Y0_FrameData[4] VPWR VGND sg13cmos5l_antennanp
XFILLER_14_567 VPWR VGND sg13cmos5l_decap_8
X_284_ Tile_X0Y0_SS4BEG[0] Tile_X0Y0_NN4END[15] VPWR VGND sg13cmos5l_buf_1
X_353_ Tile_X0Y0_FrameStrobe_O[17] Tile_X0Y0_FrameStrobe[17] VPWR VGND sg13cmos5l_buf_1
XFILLER_10_751 VPWR VGND sg13cmos5l_decap_4
XFILLER_5_276 VPWR VGND sg13cmos5l_fill_1
XFILLER_5_265 VPWR VGND sg13cmos5l_decap_8
XFILLER_5_210 VPWR VGND sg13cmos5l_decap_8
XANTENNA__298__X Tile_X0Y0_SS4BEG[14] VPWR VGND sg13cmos5l_antennanp
XFILLER_17_350 VPWR VGND sg13cmos5l_decap_8
XFILLER_9_582 VPWR VGND sg13cmos5l_decap_8
XFILLER_11_537 VPWR VGND sg13cmos5l_decap_8
XFILLER_3_769 VPWR VGND sg13cmos5l_decap_8
XFILLER_2_224 VPWR VGND sg13cmos5l_decap_4
XFILLER_15_810 VPWR VGND sg13cmos5l_decap_8
XFILLER_18_169 VPWR VGND sg13cmos5l_decap_8
XFILLER_14_364 VPWR VGND sg13cmos5l_decap_8
XFILLER_15_887 VPWR VGND sg13cmos5l_decap_8
X_267_ Tile_X0Y0_S2BEGb[7] Tile_X0Y0_N2END[0] VPWR VGND sg13cmos5l_buf_1
X_336_ Tile_X0Y0_FrameStrobe_O[0] Tile_X0Y0_FrameStrobe[0] VPWR VGND sg13cmos5l_buf_1
X_198_ Tile_X1Y0_FrameStrobe_O[19] Tile_X1Y0_FrameStrobe[19] VPWR VGND sg13cmos5l_buf_1
XFILLER_6_541 VPWR VGND sg13cmos5l_decap_8
XFILLER_2_791 VPWR VGND sg13cmos5l_decap_8
XFILLER_2_63 VPWR VGND sg13cmos5l_decap_8
XANTENNA_13 Tile_X0Y0_FrameData[11] VPWR VGND sg13cmos5l_antennanp
XANTENNA_24 Tile_X0Y0_FrameData[17] VPWR VGND sg13cmos5l_antennanp
XANTENNA_35 Tile_X0Y0_FrameData[1] VPWR VGND sg13cmos5l_antennanp
XANTENNA_46 Tile_X0Y0_FrameData[20] VPWR VGND sg13cmos5l_antennanp
XANTENNA_57 Tile_X0Y0_FrameData[22] VPWR VGND sg13cmos5l_antennanp
XANTENNA_68 Tile_X0Y0_FrameData[23] VPWR VGND sg13cmos5l_antennanp
XANTENNA_79 Tile_X0Y0_FrameData[2] VPWR VGND sg13cmos5l_antennanp
XFILLER_11_301 VPWR VGND sg13cmos5l_decap_8
XFILLER_11_334 VPWR VGND sg13cmos5l_decap_8
X_121_ NPU_QUANT_SHIFT_IN6 Tile_X0Y0_UserCLK _371_/X _184_/L_HI VPWR VGND sg13cmos5l_dfrbpq_1
X_052_ _052_/Q Tile_X0Y0_FrameData[18] VGND VPWR Tile_X0Y0_FrameStrobe[0] latch
XFILLER_3_566 VPWR VGND sg13cmos5l_decap_8
XFILLER_14_161 VPWR VGND sg13cmos5l_decap_8
XFILLER_15_640 VPWR VGND sg13cmos5l_decap_8
X_319_ Tile_X1Y0_FrameData_O[15] Tile_X0Y0_FrameData[15] VPWR VGND sg13cmos5l_buf_1
XFILLER_7_894 VPWR VGND sg13cmos5l_decap_8
XFILLER_6_393 VPWR VGND sg13cmos5l_decap_8
XFILLER_16_28 VPWR VGND sg13cmos5l_decap_8
XFILLER_16_448 VPWR VGND sg13cmos5l_decap_8
XFILLER_11_175 VPWR VGND sg13cmos5l_decap_8
XFILLER_12_643 VPWR VGND sg13cmos5l_decap_4
X_104_ _104_/Q Tile_X0Y0_FrameData[2] VGND VPWR Tile_X1Y0_FrameStrobe[0] latch
XFILLER_8_669 VPWR VGND sg13cmos5l_decap_8
XFILLER_7_168 VPWR VGND sg13cmos5l_decap_8
XFILLER_8_84 VPWR VGND sg13cmos5l_decap_8
XFILLER_5_628 VPWR VGND sg13cmos5l_decap_8
XFILLER_0_322 VPWR VGND sg13cmos5l_fill_2
XFILLER_17_746 VPWR VGND sg13cmos5l_decap_8
XFILLER_12_462 VPWR VGND sg13cmos5l_decap_8
XFILLER_16_245 VPWR VGND sg13cmos5l_decap_8
XFILLER_9_923 VPWR VGND sg13cmos5l_decap_8
XFILLER_8_466 VPWR VGND sg13cmos5l_decap_8
XFILLER_3_193 VPWR VGND sg13cmos5l_fill_1
XFILLER_13_259 VPWR VGND sg13cmos5l_decap_8
XFILLER_10_922 VPWR VGND sg13cmos5l_decap_8
XFILLER_6_926 VPWR VGND sg13cmos5l_fill_2
XFILLER_5_469 VPWR VGND sg13cmos5l_decap_8
XFILLER_5_403 VPWR VGND sg13cmos5l_decap_8
XFILLER_0_196 VPWR VGND sg13cmos5l_decap_8
XFILLER_1_642 VPWR VGND sg13cmos5l_fill_2
XFILLER_17_543 VPWR VGND sg13cmos5l_decap_8
XFILLER_17_521 VPWR VGND sg13cmos5l_decap_4
XFILLER_8_252 VPWR VGND sg13cmos5l_decap_8
XFILLER_5_63 VPWR VGND sg13cmos5l_decap_8
XFILLER_4_480 VPWR VGND sg13cmos5l_decap_8
XFILLER_10_0 VPWR VGND sg13cmos5l_decap_8
XANTENNA_103 Tile_X0Y0_FrameData[5] VPWR VGND sg13cmos5l_antennanp
XANTENNA_114 Tile_X0Y0_FrameData[7] VPWR VGND sg13cmos5l_antennanp
XANTENNA_125 Tile_X0Y0_N4END[2] VPWR VGND sg13cmos5l_antennanp
XANTENNA_136 Tile_X1Y0_N4END[13] VPWR VGND sg13cmos5l_antennanp
XANTENNA_147 Tile_X1Y0_N4END[8] VPWR VGND sg13cmos5l_antennanp
XANTENNA_158 Tile_X1Y0_NN4END[12] VPWR VGND sg13cmos5l_antennanp
XFILLER_18_329 VPWR VGND sg13cmos5l_decap_8
XANTENNA_169 Tile_X0Y0_FrameData[25] VPWR VGND sg13cmos5l_antennanp
XFILLER_10_730 VPWR VGND sg13cmos5l_decap_8
XFILLER_14_546 VPWR VGND sg13cmos5l_decap_8
X_283_ Tile_X0Y0_S4BEG[15] Tile_X0Y0_N4END[0] VPWR VGND sg13cmos5l_buf_1
X_352_ Tile_X0Y0_FrameStrobe_O[16] Tile_X0Y0_FrameStrobe[16] VPWR VGND sg13cmos5l_buf_1
XFILLER_1_494 VPWR VGND sg13cmos5l_decap_8
XFILLER_9_561 VPWR VGND sg13cmos5l_decap_8
XFILLER_11_516 VPWR VGND sg13cmos5l_decap_8
XFILLER_3_759 VPWR VGND sg13cmos5l_decap_4
XFILLER_3_704 VPWR VGND sg13cmos5l_decap_8
XFILLER_2_203 VPWR VGND sg13cmos5l_decap_8
XFILLER_14_343 VPWR VGND sg13cmos5l_decap_8
XFILLER_15_866 VPWR VGND sg13cmos5l_decap_8
XFILLER_18_148 VPWR VGND sg13cmos5l_decap_8
XFILLER_18_137 VPWR VGND sg13cmos5l_fill_1
XFILLER_18_126 VPWR VGND sg13cmos5l_decap_8
X_197_ Tile_X1Y0_FrameStrobe_O[18] Tile_X1Y0_FrameStrobe[18] VPWR VGND sg13cmos5l_buf_1
X_266_ Tile_X0Y0_S2BEGb[6] Tile_X0Y0_N2END[1] VPWR VGND sg13cmos5l_buf_1
X_335_ Tile_X1Y0_FrameData_O[31] Tile_X0Y0_FrameData[31] VPWR VGND sg13cmos5l_buf_1
XFILLER_6_520 VPWR VGND sg13cmos5l_decap_8
XFILLER_2_770 VPWR VGND sg13cmos5l_decap_8
XFILLER_2_42 VPWR VGND sg13cmos5l_decap_8
XANTENNA_14 Tile_X0Y0_FrameData[11] VPWR VGND sg13cmos5l_antennanp
XANTENNA_25 Tile_X0Y0_FrameData[19] VPWR VGND sg13cmos5l_antennanp
XANTENNA_36 Tile_X0Y0_FrameData[1] VPWR VGND sg13cmos5l_antennanp
XANTENNA_47 Tile_X0Y0_FrameData[20] VPWR VGND sg13cmos5l_antennanp
XFILLER_18_693 VPWR VGND sg13cmos5l_decap_8
XANTENNA_58 Tile_X0Y0_FrameData[22] VPWR VGND sg13cmos5l_antennanp
XANTENNA_69 Tile_X0Y0_FrameData[23] VPWR VGND sg13cmos5l_antennanp
XFILLER_9_391 VPWR VGND sg13cmos5l_fill_1
XFILLER_9_380 VPWR VGND sg13cmos5l_decap_8
XFILLER_11_313 VPWR VGND sg13cmos5l_decap_8
XFILLER_12_869 VPWR VGND sg13cmos5l_decap_8
X_051_ _051_/Q Tile_X0Y0_FrameData[19] VGND VPWR Tile_X0Y0_FrameStrobe[0] latch
X_120_ NPU_QUANT_SHIFT_IN5 Tile_X0Y0_UserCLK _370_/X _156_/L_HI VPWR VGND sg13cmos5l_dfrbpq_1
XFILLER_11_84 VPWR VGND sg13cmos5l_decap_8
XFILLER_14_140 VPWR VGND sg13cmos5l_decap_8
XFILLER_15_696 VPWR VGND sg13cmos5l_decap_8
XFILLER_11_891 VPWR VGND sg13cmos5l_decap_8
X_249_ Tile_X1Y0_SS4BEG[6] Tile_X1Y0_NN4END[9] VPWR VGND sg13cmos5l_buf_1
X_318_ Tile_X1Y0_FrameData_O[14] Tile_X0Y0_FrameData[14] VPWR VGND sg13cmos5l_buf_1
XFILLER_17_939 VPWR VGND sg13cmos5l_fill_2
XFILLER_17_928 VPWR VGND sg13cmos5l_decap_8
XFILLER_12_600 VPWR VGND sg13cmos5l_decap_4
XFILLER_12_622 VPWR VGND sg13cmos5l_decap_8
XFILLER_16_427 VPWR VGND sg13cmos5l_decap_8
XFILLER_11_154 VPWR VGND sg13cmos5l_decap_8
XFILLER_12_699 VPWR VGND sg13cmos5l_decap_8
X_103_ _103_/Q Tile_X0Y0_FrameData[3] VGND VPWR Tile_X1Y0_FrameStrobe[0] latch
XFILLER_8_648 VPWR VGND sg13cmos5l_decap_8
XFILLER_7_147 VPWR VGND sg13cmos5l_decap_8
XFILLER_3_375 VPWR VGND sg13cmos5l_fill_1
XFILLER_14_7 VPWR VGND sg13cmos5l_decap_8
XFILLER_8_63 VPWR VGND sg13cmos5l_decap_8
XFILLER_4_139 VPWR VGND sg13cmos5l_decap_8
XFILLER_1_868 VPWR VGND sg13cmos5l_fill_1
XFILLER_1_813 VPWR VGND sg13cmos5l_fill_2
XANTENNA__200__X Tile_X0Y0_S2BEG[1] VPWR VGND sg13cmos5l_antennanp
XFILLER_16_224 VPWR VGND sg13cmos5l_decap_8
XFILLER_17_725 VPWR VGND sg13cmos5l_decap_8
XFILLER_12_441 VPWR VGND sg13cmos5l_decap_8
XFILLER_9_902 VPWR VGND sg13cmos5l_decap_8
XFILLER_8_445 VPWR VGND sg13cmos5l_decap_8
XFILLER_10_901 VPWR VGND sg13cmos5l_decap_8
XFILLER_13_238 VPWR VGND sg13cmos5l_decap_8
XFILLER_14_739 VPWR VGND sg13cmos5l_decap_8
XFILLER_6_905 VPWR VGND sg13cmos5l_decap_8
XFILLER_0_175 VPWR VGND sg13cmos5l_decap_8
XFILLER_1_687 VPWR VGND sg13cmos5l_decap_4
XFILLER_1_665 VPWR VGND sg13cmos5l_decap_8
XFILLER_17_599 VPWR VGND sg13cmos5l_decap_8
XFILLER_17_511 VPWR VGND sg13cmos5l_decap_8
XFILLER_8_231 VPWR VGND sg13cmos5l_decap_8
XFILLER_5_42 VPWR VGND sg13cmos5l_decap_8
XFILLER_10_219 VPWR VGND sg13cmos5l_decap_8
XFILLER_2_407 VPWR VGND sg13cmos5l_fill_1
XANTENNA_104 Tile_X0Y0_FrameData[5] VPWR VGND sg13cmos5l_antennanp
XANTENNA_115 Tile_X0Y0_FrameData[7] VPWR VGND sg13cmos5l_antennanp
XANTENNA_126 Tile_X0Y0_N4END[2] VPWR VGND sg13cmos5l_antennanp
XANTENNA_137 Tile_X1Y0_N4END[13] VPWR VGND sg13cmos5l_antennanp
XANTENNA_148 Tile_X1Y0_N4END[8] VPWR VGND sg13cmos5l_antennanp
XANTENNA_159 Tile_X1Y0_NN4END[12] VPWR VGND sg13cmos5l_antennanp
XFILLER_14_525 VPWR VGND sg13cmos5l_decap_8
X_351_ Tile_X0Y0_FrameStrobe_O[15] Tile_X0Y0_FrameStrobe[15] VPWR VGND sg13cmos5l_buf_1
XFILLER_18_319 VPWR VGND sg13cmos5l_decap_8
XFILLER_14_84 VPWR VGND sg13cmos5l_decap_8
X_282_ Tile_X0Y0_S4BEG[14] Tile_X0Y0_N4END[1] VPWR VGND sg13cmos5l_buf_1
XFILLER_6_746 VPWR VGND sg13cmos5l_decap_8
XFILLER_5_245 VPWR VGND sg13cmos5l_decap_8
XFILLER_2_952 VPWR VGND sg13cmos5l_fill_2
XFILLER_1_462 VPWR VGND sg13cmos5l_decap_4
XFILLER_18_886 VPWR VGND sg13cmos5l_decap_8
XFILLER_18_875 VPWR VGND sg13cmos5l_fill_1
XFILLER_18_864 VPWR VGND sg13cmos5l_decap_8
XFILLER_17_385 VPWR VGND sg13cmos5l_decap_8
XFILLER_9_540 VPWR VGND sg13cmos5l_decap_8
XFILLER_18_105 VPWR VGND sg13cmos5l_decap_8
XFILLER_14_322 VPWR VGND sg13cmos5l_decap_8
XFILLER_14_399 VPWR VGND sg13cmos5l_decap_8
XFILLER_15_845 VPWR VGND sg13cmos5l_decap_8
X_334_ Tile_X1Y0_FrameData_O[30] Tile_X0Y0_FrameData[30] VPWR VGND sg13cmos5l_buf_1
XFILLER_10_583 VPWR VGND sg13cmos5l_decap_8
X_196_ Tile_X1Y0_FrameStrobe_O[17] Tile_X1Y0_FrameStrobe[17] VPWR VGND sg13cmos5l_buf_1
X_265_ Tile_X0Y0_S2BEGb[5] Tile_X0Y0_N2END[2] VPWR VGND sg13cmos5l_buf_1
XFILLER_2_21 VPWR VGND sg13cmos5l_decap_8
XFILLER_18_672 VPWR VGND sg13cmos5l_decap_8
XFILLER_17_182 VPWR VGND sg13cmos5l_decap_8
XANTENNA_15 Tile_X0Y0_FrameData[11] VPWR VGND sg13cmos5l_antennanp
XANTENNA_26 Tile_X0Y0_FrameData[19] VPWR VGND sg13cmos5l_antennanp
XANTENNA_37 Tile_X0Y0_FrameData[1] VPWR VGND sg13cmos5l_antennanp
XANTENNA_48 Tile_X0Y0_FrameData[20] VPWR VGND sg13cmos5l_antennanp
XANTENNA_59 Tile_X0Y0_FrameData[22] VPWR VGND sg13cmos5l_antennanp
XFILLER_12_804 VPWR VGND sg13cmos5l_decap_8
XFILLER_12_815 VPWR VGND sg13cmos5l_fill_2
XFILLER_15_119 VPWR VGND sg13cmos5l_decap_8
XFILLER_11_369 VPWR VGND sg13cmos5l_decap_8
XFILLER_12_848 VPWR VGND sg13cmos5l_decap_8
X_050_ _050_/Q Tile_X0Y0_FrameData[20] VGND VPWR Tile_X0Y0_FrameStrobe[0] latch
XANTENNA__203__X Tile_X0Y0_S2BEG[4] VPWR VGND sg13cmos5l_antennanp
XFILLER_11_63 VPWR VGND sg13cmos5l_decap_8
XFILLER_11_870 VPWR VGND sg13cmos5l_decap_8
XFILLER_14_196 VPWR VGND sg13cmos5l_decap_8
XFILLER_15_675 VPWR VGND sg13cmos5l_decap_8
X_317_ Tile_X1Y0_FrameData_O[13] Tile_X0Y0_FrameData[13] VPWR VGND sg13cmos5l_buf_1
XFILLER_10_380 VPWR VGND sg13cmos5l_decap_8
X_179_ _179_/L_HI VPWR VGND sg13cmos5l_tiehi
X_248_ Tile_X1Y0_SS4BEG[5] Tile_X1Y0_NN4END[10] VPWR VGND sg13cmos5l_buf_1
XFILLER_2_590 VPWR VGND sg13cmos5l_fill_1
XFILLER_16_406 VPWR VGND sg13cmos5l_decap_8
XFILLER_17_907 VPWR VGND sg13cmos5l_decap_8
XFILLER_11_133 VPWR VGND sg13cmos5l_decap_8
XFILLER_12_678 VPWR VGND sg13cmos5l_decap_8
XFILLER_8_627 VPWR VGND sg13cmos5l_decap_8
X_102_ _102_/Q Tile_X0Y0_FrameData[4] VGND VPWR Tile_X1Y0_FrameStrobe[0] latch
XFILLER_7_126 VPWR VGND sg13cmos5l_decap_8
XFILLER_0_0 VPWR VGND sg13cmos5l_decap_8
XFILLER_4_888 VPWR VGND sg13cmos5l_decap_8
XFILLER_16_951 VPWR VGND sg13cmos5l_decap_8
XFILLER_15_483 VPWR VGND sg13cmos5l_decap_8
XFILLER_8_42 VPWR VGND sg13cmos5l_decap_8
XFILLER_7_693 VPWR VGND sg13cmos5l_fill_1
XFILLER_4_118 VPWR VGND sg13cmos5l_decap_8
XFILLER_1_847 VPWR VGND sg13cmos5l_decap_8
XFILLER_1_825 VPWR VGND sg13cmos5l_decap_8
XFILLER_16_203 VPWR VGND sg13cmos5l_decap_8
XFILLER_17_84 VPWR VGND sg13cmos5l_decap_8
XFILLER_17_704 VPWR VGND sg13cmos5l_decap_8
XFILLER_12_420 VPWR VGND sg13cmos5l_decap_8
XFILLER_12_497 VPWR VGND sg13cmos5l_decap_8
XFILLER_13_954 VPWR VGND sg13cmos5l_decap_4
XFILLER_9_958 VPWR VGND sg13cmos5l_fill_2
XFILLER_8_424 VPWR VGND sg13cmos5l_decap_8
XFILLER_15_280 VPWR VGND sg13cmos5l_decap_8
XFILLER_16_781 VPWR VGND sg13cmos5l_decap_8
XANTENNA__301__X Tile_X0Y0_S1BEG[1] VPWR VGND sg13cmos5l_antennanp
XFILLER_14_718 VPWR VGND sg13cmos5l_decap_8
XFILLER_10_957 VPWR VGND sg13cmos5l_fill_2
XFILLER_13_217 VPWR VGND sg13cmos5l_decap_8
XFILLER_6_928 VPWR VGND sg13cmos5l_fill_1
XANTENNA__211__X Tile_X1Y0_S2BEG[0] VPWR VGND sg13cmos5l_antennanp
XFILLER_0_154 VPWR VGND sg13cmos5l_decap_8
XFILLER_9_711 VPWR VGND sg13cmos5l_decap_8
XFILLER_17_578 VPWR VGND sg13cmos5l_decap_8
XFILLER_12_294 VPWR VGND sg13cmos5l_decap_8
XFILLER_13_784 VPWR VGND sg13cmos5l_decap_8
XFILLER_8_287 VPWR VGND sg13cmos5l_decap_8
XFILLER_8_210 VPWR VGND sg13cmos5l_decap_8
XFILLER_5_21 VPWR VGND sg13cmos5l_decap_8
XFILLER_5_98 VPWR VGND sg13cmos5l_decap_8
XANTENNA_105 Tile_X0Y0_FrameData[6] VPWR VGND sg13cmos5l_antennanp
XANTENNA_116 Tile_X0Y0_FrameData[7] VPWR VGND sg13cmos5l_antennanp
XANTENNA_127 Tile_X0Y0_N4END[2] VPWR VGND sg13cmos5l_antennanp
XANTENNA_138 Tile_X1Y0_N4END[13] VPWR VGND sg13cmos5l_antennanp
XANTENNA_149 Tile_X1Y0_N4END[8] VPWR VGND sg13cmos5l_antennanp
XFILLER_14_504 VPWR VGND sg13cmos5l_decap_8
X_350_ Tile_X0Y0_FrameStrobe_O[14] Tile_X0Y0_FrameStrobe[14] VPWR VGND sg13cmos5l_buf_1
XANTENNA__206__X Tile_X0Y0_S2BEG[7] VPWR VGND sg13cmos5l_antennanp
XFILLER_14_63 VPWR VGND sg13cmos5l_decap_8
X_281_ Tile_X0Y0_S4BEG[13] Tile_X0Y0_N4END[2] VPWR VGND sg13cmos5l_buf_1
XFILLER_6_725 VPWR VGND sg13cmos5l_decap_8
XFILLER_5_224 VPWR VGND sg13cmos5l_decap_8
XFILLER_1_485 VPWR VGND sg13cmos5l_fill_2
XFILLER_1_474 VPWR VGND sg13cmos5l_decap_8
XFILLER_18_843 VPWR VGND sg13cmos5l_decap_8
XFILLER_17_364 VPWR VGND sg13cmos5l_decap_8
XFILLER_13_581 VPWR VGND sg13cmos5l_decap_8
XFILLER_9_596 VPWR VGND sg13cmos5l_decap_8
XFILLER_4_7 VPWR VGND sg13cmos5l_decap_8
XFILLER_14_301 VPWR VGND sg13cmos5l_decap_8
XFILLER_14_378 VPWR VGND sg13cmos5l_decap_8
XFILLER_15_824 VPWR VGND sg13cmos5l_decap_8
X_264_ Tile_X0Y0_S2BEGb[4] Tile_X0Y0_N2END[3] VPWR VGND sg13cmos5l_buf_1
X_333_ Tile_X1Y0_FrameData_O[29] Tile_X0Y0_FrameData[29] VPWR VGND sg13cmos5l_buf_1
XFILLER_10_562 VPWR VGND sg13cmos5l_decap_8
X_195_ Tile_X1Y0_FrameStrobe_O[16] Tile_X1Y0_FrameStrobe[16] VPWR VGND sg13cmos5l_buf_1
XFILLER_6_555 VPWR VGND sg13cmos5l_decap_4
XFILLER_17_161 VPWR VGND sg13cmos5l_decap_8
XFILLER_2_88 VPWR VGND sg13cmos5l_decap_4
XFILLER_18_651 VPWR VGND sg13cmos5l_decap_8
XFILLER_18_640 VPWR VGND sg13cmos5l_decap_4
XANTENNA_16 Tile_X0Y0_FrameData[17] VPWR VGND sg13cmos5l_antennanp
XANTENNA_27 Tile_X0Y0_FrameData[19] VPWR VGND sg13cmos5l_antennanp
XANTENNA_38 Tile_X0Y0_FrameData[1] VPWR VGND sg13cmos5l_antennanp
XANTENNA_49 Tile_X0Y0_FrameData[20] VPWR VGND sg13cmos5l_antennanp
XFILLER_11_348 VPWR VGND sg13cmos5l_decap_8
XFILLER_12_827 VPWR VGND sg13cmos5l_decap_8
XFILLER_11_42 VPWR VGND sg13cmos5l_decap_8
XFILLER_3_536 VPWR VGND sg13cmos5l_fill_2
XFILLER_15_632 VPWR VGND sg13cmos5l_decap_4
XFILLER_15_654 VPWR VGND sg13cmos5l_decap_8
XFILLER_14_175 VPWR VGND sg13cmos5l_decap_8
X_247_ Tile_X1Y0_SS4BEG[4] Tile_X1Y0_NN4END[11] VPWR VGND sg13cmos5l_buf_1
X_316_ Tile_X1Y0_FrameData_O[12] Tile_X0Y0_FrameData[12] VPWR VGND sg13cmos5l_buf_1
X_178_ _178_/L_HI VPWR VGND sg13cmos5l_tiehi
XFILLER_7_886 VPWR VGND sg13cmos5l_decap_4
XANTENNA__304__X Tile_X1Y0_FrameData_O[0] VPWR VGND sg13cmos5l_antennanp
XFILLER_9_190 VPWR VGND sg13cmos5l_decap_8
XFILLER_0_528 VPWR VGND sg13cmos5l_decap_4
XFILLER_11_112 VPWR VGND sg13cmos5l_decap_8
XFILLER_11_189 VPWR VGND sg13cmos5l_decap_8
XFILLER_12_657 VPWR VGND sg13cmos5l_decap_8
X_101_ _101_/Q Tile_X0Y0_FrameData[5] VGND VPWR Tile_X1Y0_FrameStrobe[0] latch
XFILLER_8_606 VPWR VGND sg13cmos5l_decap_8
XFILLER_7_105 VPWR VGND sg13cmos5l_decap_8
XANTENNA__214__X Tile_X1Y0_S2BEG[3] VPWR VGND sg13cmos5l_antennanp
XFILLER_4_867 VPWR VGND sg13cmos5l_decap_8
XFILLER_15_462 VPWR VGND sg13cmos5l_decap_8
XFILLER_11_690 VPWR VGND sg13cmos5l_decap_8
XFILLER_8_98 VPWR VGND sg13cmos5l_decap_8
XFILLER_8_21 VPWR VGND sg13cmos5l_decap_8
XFILLER_7_661 VPWR VGND sg13cmos5l_decap_4
XFILLER_6_182 VPWR VGND sg13cmos5l_decap_8
XANTENNA__209__X Tile_X1Y0_S1BEG[2] VPWR VGND sg13cmos5l_antennanp
XFILLER_13_911 VPWR VGND sg13cmos5l_decap_8
XFILLER_16_259 VPWR VGND sg13cmos5l_decap_8
XFILLER_17_63 VPWR VGND sg13cmos5l_decap_8
XFILLER_12_476 VPWR VGND sg13cmos5l_decap_8
XFILLER_8_403 VPWR VGND sg13cmos5l_decap_8
XFILLER_4_697 VPWR VGND sg13cmos5l_decap_4
XFILLER_4_631 VPWR VGND sg13cmos5l_fill_2
XFILLER_0_892 VPWR VGND sg13cmos5l_decap_8
XFILLER_16_760 VPWR VGND sg13cmos5l_decap_8
XFILLER_5_417 VPWR VGND sg13cmos5l_decap_8
XFILLER_0_133 VPWR VGND sg13cmos5l_decap_4
XFILLER_1_623 VPWR VGND sg13cmos5l_fill_2
XFILLER_13_763 VPWR VGND sg13cmos5l_decap_8
XFILLER_17_557 VPWR VGND sg13cmos5l_decap_8
XFILLER_12_273 VPWR VGND sg13cmos5l_decap_8
XFILLER_8_266 VPWR VGND sg13cmos5l_decap_8
XFILLER_5_77 VPWR VGND sg13cmos5l_decap_8
XFILLER_4_494 VPWR VGND sg13cmos5l_decap_8
XANTENNA__312__X Tile_X1Y0_FrameData_O[8] VPWR VGND sg13cmos5l_antennanp
XANTENNA_106 Tile_X0Y0_FrameData[6] VPWR VGND sg13cmos5l_antennanp
XANTENNA_117 Tile_X0Y0_FrameData[7] VPWR VGND sg13cmos5l_antennanp
XANTENNA_128 Tile_X0Y0_N4END[2] VPWR VGND sg13cmos5l_antennanp
XANTENNA_139 Tile_X1Y0_N4END[13] VPWR VGND sg13cmos5l_antennanp
XFILLER_14_42 VPWR VGND sg13cmos5l_decap_8
X_280_ Tile_X0Y0_S4BEG[12] Tile_X0Y0_N4END[3] VPWR VGND sg13cmos5l_buf_1
XFILLER_10_744 VPWR VGND sg13cmos5l_decap_8
XFILLER_10_755 VPWR VGND sg13cmos5l_fill_2
XFILLER_5_203 VPWR VGND sg13cmos5l_decap_8
XANTENNA__222__X Tile_X1Y0_S2BEGb[3] VPWR VGND sg13cmos5l_antennanp
XFILLER_2_921 VPWR VGND sg13cmos5l_decap_8
XFILLER_1_453 VPWR VGND sg13cmos5l_decap_4
XFILLER_18_822 VPWR VGND sg13cmos5l_decap_8
XFILLER_17_343 VPWR VGND sg13cmos5l_decap_8
XFILLER_13_560 VPWR VGND sg13cmos5l_decap_8
XFILLER_9_575 VPWR VGND sg13cmos5l_decap_8
XANTENNA__307__X Tile_X1Y0_FrameData_O[3] VPWR VGND sg13cmos5l_antennanp
XFILLER_2_228 VPWR VGND sg13cmos5l_fill_2
XFILLER_2_217 VPWR VGND sg13cmos5l_decap_8
XFILLER_15_803 VPWR VGND sg13cmos5l_decap_8
X_401_ _401_/X Tile_X0Y0_N1END[0] Tile_X0Y0_N2MID[0] Tile_X0Y0_N2MID[7] Tile_X0Y0_N2END[7]
+ _044_/Q _043_/Q VPWR VGND sg13cmos5l_mux4_1
XANTENNA__217__X Tile_X1Y0_S2BEG[6] VPWR VGND sg13cmos5l_antennanp
XFILLER_10_541 VPWR VGND sg13cmos5l_decap_8
XFILLER_14_357 VPWR VGND sg13cmos5l_decap_8
X_263_ Tile_X0Y0_S2BEGb[3] Tile_X0Y0_N2END[4] VPWR VGND sg13cmos5l_buf_1
X_332_ Tile_X1Y0_FrameData_O[28] Tile_X0Y0_FrameData[28] VPWR VGND sg13cmos5l_buf_1
X_194_ Tile_X1Y0_FrameStrobe_O[15] Tile_X1Y0_FrameStrobe[15] VPWR VGND sg13cmos5l_buf_1
XFILLER_6_534 VPWR VGND sg13cmos5l_decap_8
XFILLER_2_784 VPWR VGND sg13cmos5l_decap_8
XFILLER_2_56 VPWR VGND sg13cmos5l_decap_8
XFILLER_17_140 VPWR VGND sg13cmos5l_decap_8
XANTENNA_17 Tile_X0Y0_FrameData[17] VPWR VGND sg13cmos5l_antennanp
XANTENNA_28 Tile_X0Y0_FrameData[19] VPWR VGND sg13cmos5l_antennanp
XANTENNA_39 Tile_X0Y0_FrameData[1] VPWR VGND sg13cmos5l_antennanp
XFILLER_11_327 VPWR VGND sg13cmos5l_decap_8
XFILLER_11_21 VPWR VGND sg13cmos5l_decap_8
XFILLER_11_98 VPWR VGND sg13cmos5l_decap_8
XFILLER_3_559 VPWR VGND sg13cmos5l_decap_8
XFILLER_14_154 VPWR VGND sg13cmos5l_decap_8
X_177_ _177_/L_HI VPWR VGND sg13cmos5l_tiehi
X_246_ Tile_X1Y0_SS4BEG[3] Tile_X1Y0_NN4END[12] VPWR VGND sg13cmos5l_buf_1
X_315_ Tile_X1Y0_FrameData_O[11] Tile_X0Y0_FrameData[11] VPWR VGND sg13cmos5l_buf_1
XANTENNA__320__X Tile_X1Y0_FrameData_O[16] VPWR VGND sg13cmos5l_antennanp
XFILLER_11_168 VPWR VGND sg13cmos5l_decap_8
XFILLER_12_636 VPWR VGND sg13cmos5l_decap_8
X_100_ _100_/Q Tile_X0Y0_FrameData[6] VGND VPWR Tile_X1Y0_FrameStrobe[0] latch
XANTENNA__230__X Tile_X1Y0_S4BEG[3] VPWR VGND sg13cmos5l_antennanp
XFILLER_15_441 VPWR VGND sg13cmos5l_decap_8
X_229_ Tile_X1Y0_S4BEG[2] Tile_X1Y0_N4END[13] VPWR VGND sg13cmos5l_buf_1
XFILLER_8_77 VPWR VGND sg13cmos5l_decap_8
XFILLER_7_640 VPWR VGND sg13cmos5l_decap_8
XFILLER_6_161 VPWR VGND sg13cmos5l_decap_8
XANTENNA__315__X Tile_X1Y0_FrameData_O[11] VPWR VGND sg13cmos5l_antennanp
XFILLER_12_455 VPWR VGND sg13cmos5l_decap_8
XFILLER_16_238 VPWR VGND sg13cmos5l_decap_8
XFILLER_9_916 VPWR VGND sg13cmos5l_decap_8
XFILLER_17_739 VPWR VGND sg13cmos5l_decap_8
XFILLER_17_42 VPWR VGND sg13cmos5l_decap_8
XANTENNA__225__X Tile_X1Y0_S2BEGb[6] VPWR VGND sg13cmos5l_antennanp
XFILLER_8_459 VPWR VGND sg13cmos5l_decap_8
XFILLER_4_621 VPWR VGND sg13cmos5l_decap_8
XFILLER_3_186 VPWR VGND sg13cmos5l_decap_8
XFILLER_12_7 VPWR VGND sg13cmos5l_decap_8
XFILLER_10_915 VPWR VGND sg13cmos5l_decap_8
XFILLER_10_959 VPWR VGND sg13cmos5l_fill_1
XFILLER_6_919 VPWR VGND sg13cmos5l_decap_8
XFILLER_0_112 VPWR VGND sg13cmos5l_decap_8
XFILLER_1_602 VPWR VGND sg13cmos5l_decap_8
XFILLER_0_189 VPWR VGND sg13cmos5l_decap_8
XFILLER_17_536 VPWR VGND sg13cmos5l_decap_8
XFILLER_17_525 VPWR VGND sg13cmos5l_fill_1
XFILLER_12_252 VPWR VGND sg13cmos5l_decap_8
XFILLER_13_742 VPWR VGND sg13cmos5l_decap_8
XFILLER_8_245 VPWR VGND sg13cmos5l_decap_8
XFILLER_5_56 VPWR VGND sg13cmos5l_decap_8
XFILLER_4_473 VPWR VGND sg13cmos5l_decap_8
XANTENNA_107 Tile_X0Y0_FrameData[6] VPWR VGND sg13cmos5l_antennanp
XANTENNA_118 Tile_X0Y0_FrameData[7] VPWR VGND sg13cmos5l_antennanp
XANTENNA_129 Tile_X0Y0_N4END[2] VPWR VGND sg13cmos5l_antennanp
XFILLER_10_723 VPWR VGND sg13cmos5l_decap_8
XFILLER_14_21 VPWR VGND sg13cmos5l_decap_8
XFILLER_14_539 VPWR VGND sg13cmos5l_decap_8
XFILLER_14_98 VPWR VGND sg13cmos5l_decap_8
XFILLER_5_259 VPWR VGND sg13cmos5l_fill_2
XFILLER_2_900 VPWR VGND sg13cmos5l_decap_8
XFILLER_18_801 VPWR VGND sg13cmos5l_decap_8
XFILLER_17_399 VPWR VGND sg13cmos5l_decap_8
XFILLER_17_322 VPWR VGND sg13cmos5l_decap_8
XFILLER_9_554 VPWR VGND sg13cmos5l_decap_8
XFILLER_11_509 VPWR VGND sg13cmos5l_decap_8
XANTENNA__323__X Tile_X1Y0_FrameData_O[19] VPWR VGND sg13cmos5l_antennanp
XFILLER_3_719 VPWR VGND sg13cmos5l_fill_2
XFILLER_14_336 VPWR VGND sg13cmos5l_decap_8
XFILLER_15_859 VPWR VGND sg13cmos5l_decap_8
X_400_ _400_/X Tile_X0Y0_N1END[1] Tile_X0Y0_N2MID[1] Tile_X0Y0_N2MID[6] Tile_X0Y0_N2END[6]
+ _042_/Q _041_/Q VPWR VGND sg13cmos5l_mux4_1
X_331_ Tile_X1Y0_FrameData_O[27] Tile_X0Y0_FrameData[27] VPWR VGND sg13cmos5l_buf_1
XFILLER_18_119 VPWR VGND sg13cmos5l_decap_8
XFILLER_10_520 VPWR VGND sg13cmos5l_decap_8
X_193_ Tile_X1Y0_FrameStrobe_O[14] Tile_X1Y0_FrameStrobe[14] VPWR VGND sg13cmos5l_buf_1
X_262_ Tile_X0Y0_S2BEGb[2] Tile_X0Y0_N2END[5] VPWR VGND sg13cmos5l_buf_1
XFILLER_6_513 VPWR VGND sg13cmos5l_decap_8
XFILLER_6_502 VPWR VGND sg13cmos5l_decap_8
XANTENNA__233__X Tile_X1Y0_S4BEG[6] VPWR VGND sg13cmos5l_antennanp
XFILLER_10_597 VPWR VGND sg13cmos5l_decap_8
XFILLER_2_763 VPWR VGND sg13cmos5l_decap_4
XFILLER_2_35 VPWR VGND sg13cmos5l_decap_8
XANTENNA_18 Tile_X0Y0_FrameData[17] VPWR VGND sg13cmos5l_antennanp
XANTENNA_29 Tile_X0Y0_FrameData[19] VPWR VGND sg13cmos5l_antennanp
XFILLER_18_686 VPWR VGND sg13cmos5l_decap_8
XFILLER_17_196 VPWR VGND sg13cmos5l_decap_8
XFILLER_9_395 VPWR VGND sg13cmos5l_decap_8
XFILLER_9_373 VPWR VGND sg13cmos5l_decap_8
XANTENNA__318__X Tile_X1Y0_FrameData_O[14] VPWR VGND sg13cmos5l_antennanp
XFILLER_11_77 VPWR VGND sg13cmos5l_decap_8
XANTENNA__228__X Tile_X1Y0_S4BEG[1] VPWR VGND sg13cmos5l_antennanp
XFILLER_14_133 VPWR VGND sg13cmos5l_decap_8
XFILLER_15_612 VPWR VGND sg13cmos5l_decap_8
XFILLER_15_689 VPWR VGND sg13cmos5l_decap_8
X_314_ Tile_X1Y0_FrameData_O[10] Tile_X0Y0_FrameData[10] VPWR VGND sg13cmos5l_buf_1
XFILLER_10_350 VPWR VGND sg13cmos5l_decap_8
XFILLER_10_394 VPWR VGND sg13cmos5l_decap_8
XFILLER_11_884 VPWR VGND sg13cmos5l_decap_8
X_176_ _176_/L_HI VPWR VGND sg13cmos5l_tiehi
X_245_ Tile_X1Y0_SS4BEG[2] Tile_X1Y0_NN4END[13] VPWR VGND sg13cmos5l_buf_1
XFILLER_18_461 VPWR VGND sg13cmos5l_decap_8
XFILLER_0_508 VPWR VGND sg13cmos5l_fill_2
XFILLER_12_615 VPWR VGND sg13cmos5l_decap_8
XFILLER_11_147 VPWR VGND sg13cmos5l_decap_8
XFILLER_3_357 VPWR VGND sg13cmos5l_fill_2
XFILLER_15_420 VPWR VGND sg13cmos5l_decap_8
XFILLER_16_921 VPWR VGND sg13cmos5l_decap_8
XFILLER_15_497 VPWR VGND sg13cmos5l_decap_8
XFILLER_8_56 VPWR VGND sg13cmos5l_decap_8
XFILLER_10_191 VPWR VGND sg13cmos5l_decap_8
X_159_ _159_/L_HI VPWR VGND sg13cmos5l_tiehi
X_228_ Tile_X1Y0_S4BEG[1] Tile_X1Y0_N4END[14] VPWR VGND sg13cmos5l_buf_1
XFILLER_6_140 VPWR VGND sg13cmos5l_decap_8
XFILLER_18_291 VPWR VGND sg13cmos5l_decap_8
XANTENNA__331__X Tile_X1Y0_FrameData_O[27] VPWR VGND sg13cmos5l_antennanp
XFILLER_1_806 VPWR VGND sg13cmos5l_decap_8
XFILLER_16_217 VPWR VGND sg13cmos5l_decap_8
XFILLER_17_718 VPWR VGND sg13cmos5l_decap_8
XFILLER_17_21 VPWR VGND sg13cmos5l_decap_8
XFILLER_12_434 VPWR VGND sg13cmos5l_decap_8
XFILLER_17_98 VPWR VGND sg13cmos5l_decap_8
XFILLER_8_438 VPWR VGND sg13cmos5l_decap_8
XFILLER_4_633 VPWR VGND sg13cmos5l_fill_1
XANTENNA__241__X Tile_X1Y0_S4BEG[14] VPWR VGND sg13cmos5l_antennanp
XFILLER_0_883 VPWR VGND sg13cmos5l_fill_2
XFILLER_16_795 VPWR VGND sg13cmos5l_decap_8
XFILLER_15_294 VPWR VGND sg13cmos5l_decap_8
XFILLER_7_493 VPWR VGND sg13cmos5l_decap_8
XANTENNA__326__X Tile_X1Y0_FrameData_O[22] VPWR VGND sg13cmos5l_antennanp
XFILLER_0_168 VPWR VGND sg13cmos5l_decap_8
XFILLER_1_636 VPWR VGND sg13cmos5l_fill_2
XFILLER_1_625 VPWR VGND sg13cmos5l_fill_1
XFILLER_17_504 VPWR VGND sg13cmos5l_decap_8
XANTENNA__236__X Tile_X1Y0_S4BEG[9] VPWR VGND sg13cmos5l_antennanp
XFILLER_12_231 VPWR VGND sg13cmos5l_decap_8
XFILLER_13_721 VPWR VGND sg13cmos5l_decap_8
XFILLER_13_798 VPWR VGND sg13cmos5l_decap_8
XFILLER_8_224 VPWR VGND sg13cmos5l_decap_8
XFILLER_5_35 VPWR VGND sg13cmos5l_decap_8
XFILLER_4_452 VPWR VGND sg13cmos5l_decap_8
XFILLER_16_592 VPWR VGND sg13cmos5l_decap_8
XANTENNA_108 Tile_X0Y0_FrameData[6] VPWR VGND sg13cmos5l_antennanp
XANTENNA_119 Tile_X0Y0_FrameData[7] VPWR VGND sg13cmos5l_antennanp
XFILLER_14_518 VPWR VGND sg13cmos5l_decap_8
XFILLER_10_702 VPWR VGND sg13cmos5l_decap_8
XFILLER_14_77 VPWR VGND sg13cmos5l_decap_8
XFILLER_6_739 VPWR VGND sg13cmos5l_decap_8
XFILLER_5_238 VPWR VGND sg13cmos5l_decap_8
XFILLER_1_466 VPWR VGND sg13cmos5l_fill_1
XFILLER_17_301 VPWR VGND sg13cmos5l_decap_8
XFILLER_18_879 VPWR VGND sg13cmos5l_decap_8
XFILLER_18_857 VPWR VGND sg13cmos5l_decap_8
XFILLER_17_378 VPWR VGND sg13cmos5l_decap_8
XFILLER_13_595 VPWR VGND sg13cmos5l_fill_2
XFILLER_9_533 VPWR VGND sg13cmos5l_decap_8
XFILLER_5_772 VPWR VGND sg13cmos5l_decap_8
XFILLER_14_315 VPWR VGND sg13cmos5l_decap_8
XFILLER_15_838 VPWR VGND sg13cmos5l_decap_8
X_330_ Tile_X1Y0_FrameData_O[26] Tile_X0Y0_FrameData[26] VPWR VGND sg13cmos5l_buf_1
XFILLER_10_576 VPWR VGND sg13cmos5l_decap_8
X_192_ Tile_X1Y0_FrameStrobe_O[13] Tile_X1Y0_FrameStrobe[13] VPWR VGND sg13cmos5l_buf_1
X_261_ Tile_X0Y0_S2BEGb[1] Tile_X0Y0_N2END[6] VPWR VGND sg13cmos5l_buf_1
XFILLER_9_0 VPWR VGND sg13cmos5l_decap_8
XFILLER_2_14 VPWR VGND sg13cmos5l_decap_8
XFILLER_18_665 VPWR VGND sg13cmos5l_decap_8
XANTENNA_19 Tile_X0Y0_FrameData[17] VPWR VGND sg13cmos5l_antennanp
XFILLER_13_392 VPWR VGND sg13cmos5l_decap_8
XFILLER_14_893 VPWR VGND sg13cmos5l_decap_8
XFILLER_17_175 VPWR VGND sg13cmos5l_decap_8
XFILLER_5_591 VPWR VGND sg13cmos5l_decap_8
XANTENNA__334__X Tile_X1Y0_FrameData_O[30] VPWR VGND sg13cmos5l_antennanp
XFILLER_11_56 VPWR VGND sg13cmos5l_decap_8
XFILLER_3_528 VPWR VGND sg13cmos5l_decap_4
XFILLER_2_7 VPWR VGND sg13cmos5l_decap_8
XFILLER_14_112 VPWR VGND sg13cmos5l_decap_8
XFILLER_14_189 VPWR VGND sg13cmos5l_decap_8
XFILLER_15_668 VPWR VGND sg13cmos5l_decap_8
X_244_ Tile_X1Y0_SS4BEG[1] Tile_X1Y0_NN4END[14] VPWR VGND sg13cmos5l_buf_1
X_313_ Tile_X1Y0_FrameData_O[9] Tile_X0Y0_FrameData[9] VPWR VGND sg13cmos5l_buf_1
XANTENNA__244__X Tile_X1Y0_SS4BEG[1] VPWR VGND sg13cmos5l_antennanp
XFILLER_10_340 VPWR VGND sg13cmos5l_fill_1
XFILLER_10_373 VPWR VGND sg13cmos5l_decap_8
XFILLER_11_863 VPWR VGND sg13cmos5l_decap_8
X_175_ _175_/L_HI VPWR VGND sg13cmos5l_tiehi
XFILLER_18_495 VPWR VGND sg13cmos5l_decap_8
XFILLER_18_451 VPWR VGND sg13cmos5l_fill_2
XFILLER_14_690 VPWR VGND sg13cmos5l_decap_8
XANTENNA__329__X Tile_X1Y0_FrameData_O[25] VPWR VGND sg13cmos5l_antennanp
XFILLER_11_126 VPWR VGND sg13cmos5l_decap_8
XFILLER_7_119 VPWR VGND sg13cmos5l_decap_8
XANTENNA__239__X Tile_X1Y0_S4BEG[12] VPWR VGND sg13cmos5l_antennanp
XFILLER_16_900 VPWR VGND sg13cmos5l_decap_8
XFILLER_10_170 VPWR VGND sg13cmos5l_decap_8
XFILLER_15_476 VPWR VGND sg13cmos5l_decap_8
X_227_ Tile_X1Y0_S4BEG[0] Tile_X1Y0_N4END[15] VPWR VGND sg13cmos5l_buf_1
XFILLER_8_35 VPWR VGND sg13cmos5l_decap_8
X_089_ _089_/Q Tile_X0Y0_FrameData[17] VGND VPWR Tile_X1Y0_FrameStrobe[0] latch
X_158_ _158_/L_HI VPWR VGND sg13cmos5l_tiehi
XFILLER_6_196 VPWR VGND sg13cmos5l_decap_8
XFILLER_18_270 VPWR VGND sg13cmos5l_decap_8
XFILLER_1_818 VPWR VGND sg13cmos5l_decap_8
XFILLER_17_77 VPWR VGND sg13cmos5l_decap_8
XFILLER_12_413 VPWR VGND sg13cmos5l_decap_8
XFILLER_13_958 VPWR VGND sg13cmos5l_fill_2
XFILLER_8_417 VPWR VGND sg13cmos5l_decap_8
XFILLER_15_273 VPWR VGND sg13cmos5l_decap_8
XFILLER_16_774 VPWR VGND sg13cmos5l_decap_8
XFILLER_8_951 VPWR VGND sg13cmos5l_fill_2
XFILLER_7_472 VPWR VGND sg13cmos5l_decap_8
XFILLER_0_80 VPWR VGND sg13cmos5l_decap_8
XANTENNA__342__X Tile_X0Y0_FrameStrobe_O[6] VPWR VGND sg13cmos5l_antennanp
XFILLER_0_147 VPWR VGND sg13cmos5l_decap_8
XFILLER_12_210 VPWR VGND sg13cmos5l_decap_8
XFILLER_13_700 VPWR VGND sg13cmos5l_decap_8
XANTENNA__252__X Tile_X1Y0_SS4BEG[9] VPWR VGND sg13cmos5l_antennanp
XFILLER_12_287 VPWR VGND sg13cmos5l_decap_8
XFILLER_13_777 VPWR VGND sg13cmos5l_decap_8
XFILLER_9_704 VPWR VGND sg13cmos5l_decap_8
XFILLER_8_203 VPWR VGND sg13cmos5l_decap_8
XFILLER_5_14 VPWR VGND sg13cmos5l_decap_8
XFILLER_4_431 VPWR VGND sg13cmos5l_decap_8
XFILLER_0_681 VPWR VGND sg13cmos5l_decap_8
XFILLER_0_692 VPWR VGND sg13cmos5l_fill_2
XFILLER_16_571 VPWR VGND sg13cmos5l_decap_4
XFILLER_8_770 VPWR VGND sg13cmos5l_fill_2
XFILLER_7_280 VPWR VGND sg13cmos5l_decap_4
XANTENNA_109 Tile_X0Y0_FrameData[6] VPWR VGND sg13cmos5l_antennanp
XANTENNA__337__X Tile_X0Y0_FrameStrobe_O[1] VPWR VGND sg13cmos5l_antennanp
XFILLER_14_56 VPWR VGND sg13cmos5l_decap_8
XFILLER_5_217 VPWR VGND sg13cmos5l_decap_8
XFILLER_2_935 VPWR VGND sg13cmos5l_fill_1
XFILLER_18_836 VPWR VGND sg13cmos5l_decap_8
XANTENNA__247__X Tile_X1Y0_SS4BEG[4] VPWR VGND sg13cmos5l_antennanp
XFILLER_13_574 VPWR VGND sg13cmos5l_decap_8
XFILLER_9_512 VPWR VGND sg13cmos5l_decap_8
XFILLER_17_357 VPWR VGND sg13cmos5l_decap_8
XFILLER_9_589 VPWR VGND sg13cmos5l_decap_8
XFILLER_4_250 VPWR VGND sg13cmos5l_decap_8
XFILLER_15_817 VPWR VGND sg13cmos5l_decap_8
X_260_ Tile_X0Y0_S2BEGb[0] Tile_X0Y0_N2END[7] VPWR VGND sg13cmos5l_buf_1
XFILLER_10_555 VPWR VGND sg13cmos5l_decap_8
X_191_ Tile_X1Y0_FrameStrobe_O[12] Tile_X1Y0_FrameStrobe[12] VPWR VGND sg13cmos5l_buf_1
XFILLER_6_559 VPWR VGND sg13cmos5l_fill_1
XFILLER_6_548 VPWR VGND sg13cmos5l_decap_8
XFILLER_2_798 VPWR VGND sg13cmos5l_fill_2
XFILLER_1_220 VPWR VGND sg13cmos5l_decap_4
XFILLER_17_154 VPWR VGND sg13cmos5l_decap_8
XFILLER_18_644 VPWR VGND sg13cmos5l_fill_1
XFILLER_18_633 VPWR VGND sg13cmos5l_decap_8
XFILLER_13_371 VPWR VGND sg13cmos5l_decap_8
XFILLER_14_872 VPWR VGND sg13cmos5l_decap_8
X_389_ _389_/X Tile_X1Y0_N4END[9] Tile_X1Y0_N4END[10] Tile_X1Y0_NN4END[9] Tile_X1Y0_NN4END[11]
+ _094_/Q _093_/Q VPWR VGND sg13cmos5l_mux4_1
XFILLER_11_308 VPWR VGND sg13cmos5l_fill_2
XFILLER_11_35 VPWR VGND sg13cmos5l_decap_8
XANTENNA__350__X Tile_X0Y0_FrameStrobe_O[14] VPWR VGND sg13cmos5l_antennanp
XFILLER_11_842 VPWR VGND sg13cmos5l_fill_1
XFILLER_14_168 VPWR VGND sg13cmos5l_decap_8
XFILLER_15_647 VPWR VGND sg13cmos5l_decap_8
X_243_ Tile_X1Y0_SS4BEG[0] Tile_X1Y0_NN4END[15] VPWR VGND sg13cmos5l_buf_1
X_312_ Tile_X1Y0_FrameData_O[8] Tile_X0Y0_FrameData[8] VPWR VGND sg13cmos5l_buf_1
XANTENNA__260__X Tile_X0Y0_S2BEGb[0] VPWR VGND sg13cmos5l_antennanp
X_174_ _174_/L_HI VPWR VGND sg13cmos5l_tiehi
XFILLER_7_879 VPWR VGND sg13cmos5l_decap_8
XFILLER_2_573 VPWR VGND sg13cmos5l_fill_2
XFILLER_18_485 VPWR VGND sg13cmos5l_decap_8
XFILLER_18_430 VPWR VGND sg13cmos5l_fill_2
XFILLER_9_183 VPWR VGND sg13cmos5l_decap_8
XFILLER_3_91 VPWR VGND sg13cmos5l_decap_8
XANTENNA__345__X Tile_X0Y0_FrameStrobe_O[9] VPWR VGND sg13cmos5l_antennanp
XFILLER_11_105 VPWR VGND sg13cmos5l_decap_8
XFILLER_15_455 VPWR VGND sg13cmos5l_decap_8
XANTENNA__255__X Tile_X1Y0_SS4BEG[12] VPWR VGND sg13cmos5l_antennanp
XFILLER_11_683 VPWR VGND sg13cmos5l_decap_8
X_157_ _157_/L_HI VPWR VGND sg13cmos5l_tiehi
X_226_ Tile_X1Y0_S2BEGb[7] Tile_X1Y0_N2END[0] VPWR VGND sg13cmos5l_buf_1
XFILLER_8_14 VPWR VGND sg13cmos5l_decap_8
XFILLER_7_665 VPWR VGND sg13cmos5l_fill_1
XFILLER_7_654 VPWR VGND sg13cmos5l_decap_8
X_088_ _088_/Q Tile_X0Y0_FrameData[18] VGND VPWR Tile_X1Y0_FrameStrobe[0] latch
XFILLER_7_698 VPWR VGND sg13cmos5l_decap_8
XFILLER_6_175 VPWR VGND sg13cmos5l_decap_8
XFILLER_3_882 VPWR VGND sg13cmos5l_decap_8
XFILLER_13_904 VPWR VGND sg13cmos5l_decap_8
XFILLER_17_56 VPWR VGND sg13cmos5l_decap_8
XFILLER_12_469 VPWR VGND sg13cmos5l_decap_8
XFILLER_3_156 VPWR VGND sg13cmos5l_fill_2
XFILLER_3_145 VPWR VGND sg13cmos5l_fill_1
XFILLER_15_252 VPWR VGND sg13cmos5l_decap_8
XFILLER_16_753 VPWR VGND sg13cmos5l_decap_8
X_209_ Tile_X1Y0_S1BEG[2] Tile_X1Y0_N1END[1] VPWR VGND sg13cmos5l_buf_1
XFILLER_7_451 VPWR VGND sg13cmos5l_decap_8
XFILLER_17_0 VPWR VGND sg13cmos5l_decap_8
XFILLER_10_929 VPWR VGND sg13cmos5l_fill_2
XFILLER_0_126 VPWR VGND sg13cmos5l_decap_8
XFILLER_1_638 VPWR VGND sg13cmos5l_fill_1
XFILLER_1_616 VPWR VGND sg13cmos5l_decap_8
XFILLER_13_756 VPWR VGND sg13cmos5l_decap_8
XFILLER_12_266 VPWR VGND sg13cmos5l_decap_8
XFILLER_8_259 VPWR VGND sg13cmos5l_decap_8
XFILLER_0_660 VPWR VGND sg13cmos5l_decap_8
XFILLER_4_487 VPWR VGND sg13cmos5l_decap_8
XFILLER_10_7 VPWR VGND sg13cmos5l_decap_4
XFILLER_16_550 VPWR VGND sg13cmos5l_decap_8
XFILLER_14_35 VPWR VGND sg13cmos5l_decap_8
XANTENNA__353__X Tile_X0Y0_FrameStrobe_O[17] VPWR VGND sg13cmos5l_antennanp
XFILLER_10_737 VPWR VGND sg13cmos5l_decap_8
XFILLER_2_914 VPWR VGND sg13cmos5l_decap_8
XFILLER_1_457 VPWR VGND sg13cmos5l_fill_2
XFILLER_1_435 VPWR VGND sg13cmos5l_fill_2
XFILLER_18_815 VPWR VGND sg13cmos5l_decap_8
XFILLER_17_336 VPWR VGND sg13cmos5l_decap_8
XANTENNA__263__X Tile_X0Y0_S2BEGb[3] VPWR VGND sg13cmos5l_antennanp
XFILLER_13_553 VPWR VGND sg13cmos5l_decap_8
XFILLER_13_597 VPWR VGND sg13cmos5l_fill_1
XFILLER_9_568 VPWR VGND sg13cmos5l_decap_8
XFILLER_4_295 VPWR VGND sg13cmos5l_fill_1
XANTENNA__122__Q NPU_QUANT_SHIFT_IN7 VPWR VGND sg13cmos5l_antennanp
XFILLER_6_91 VPWR VGND sg13cmos5l_decap_8
XANTENNA__348__X Tile_X0Y0_FrameStrobe_O[12] VPWR VGND sg13cmos5l_antennanp
XFILLER_10_534 VPWR VGND sg13cmos5l_decap_8
X_190_ Tile_X1Y0_FrameStrobe_O[11] Tile_X1Y0_FrameStrobe[11] VPWR VGND sg13cmos5l_buf_1
XFILLER_6_527 VPWR VGND sg13cmos5l_decap_8
XFILLER_2_777 VPWR VGND sg13cmos5l_decap_8
XFILLER_2_744 VPWR VGND sg13cmos5l_fill_2
XFILLER_2_49 VPWR VGND sg13cmos5l_decap_8
XFILLER_1_243 VPWR VGND sg13cmos5l_fill_1
XANTENNA__258__X Tile_X1Y0_SS4BEG[15] VPWR VGND sg13cmos5l_antennanp
XFILLER_14_851 VPWR VGND sg13cmos5l_decap_8
XFILLER_17_133 VPWR VGND sg13cmos5l_decap_8
XFILLER_18_612 VPWR VGND sg13cmos5l_decap_8
XFILLER_13_350 VPWR VGND sg13cmos5l_decap_8
X_388_ _388_/X Tile_X1Y0_N4END[8] Tile_X1Y0_N4END[9] Tile_X1Y0_NN4END[8] Tile_X1Y0_NN4END[10]
+ _096_/Q _095_/Q VPWR VGND sg13cmos5l_mux4_1
XFILLER_9_387 VPWR VGND sg13cmos5l_decap_4
XANTENNA__117__Q NPU_QUANT_SHIFT_IN2 VPWR VGND sg13cmos5l_antennanp
XFILLER_11_14 VPWR VGND sg13cmos5l_decap_8
XFILLER_15_626 VPWR VGND sg13cmos5l_fill_2
XFILLER_10_364 VPWR VGND sg13cmos5l_fill_1
XFILLER_11_898 VPWR VGND sg13cmos5l_decap_8
XFILLER_14_147 VPWR VGND sg13cmos5l_decap_8
X_173_ _173_/L_HI VPWR VGND sg13cmos5l_tiehi
X_242_ Tile_X1Y0_S4BEG[15] Tile_X1Y0_N4END[0] VPWR VGND sg13cmos5l_buf_1
X_311_ Tile_X1Y0_FrameData_O[7] Tile_X0Y0_FrameData[7] VPWR VGND sg13cmos5l_buf_1
XFILLER_7_814 VPWR VGND sg13cmos5l_fill_2
XFILLER_2_552 VPWR VGND sg13cmos5l_decap_8
XFILLER_18_442 VPWR VGND sg13cmos5l_fill_2
XFILLER_18_475 VPWR VGND sg13cmos5l_decap_8
XFILLER_9_162 VPWR VGND sg13cmos5l_decap_8
XFILLER_6_891 VPWR VGND sg13cmos5l_decap_8
XFILLER_3_70 VPWR VGND sg13cmos5l_decap_8
XFILLER_12_629 VPWR VGND sg13cmos5l_decap_8
XANTENNA__361__X Tile_X1Y0_FrameStrobe_O[5] VPWR VGND sg13cmos5l_antennanp
XFILLER_15_434 VPWR VGND sg13cmos5l_decap_8
XFILLER_16_935 VPWR VGND sg13cmos5l_fill_2
XANTENNA__271__X Tile_X0Y0_S4BEG[3] VPWR VGND sg13cmos5l_antennanp
XFILLER_11_662 VPWR VGND sg13cmos5l_decap_8
X_087_ _087_/Q Tile_X0Y0_FrameData[19] VGND VPWR Tile_X1Y0_FrameStrobe[0] latch
X_156_ _156_/L_HI VPWR VGND sg13cmos5l_tiehi
X_225_ Tile_X1Y0_S2BEGb[6] Tile_X1Y0_N2END[1] VPWR VGND sg13cmos5l_buf_1
XFILLER_7_633 VPWR VGND sg13cmos5l_decap_8
XFILLER_6_154 VPWR VGND sg13cmos5l_decap_8
XANTENNA__130__Q NPU_QUANT_SHIFT_IN15 VPWR VGND sg13cmos5l_antennanp
XANTENNA__356__X Tile_X1Y0_FrameStrobe_O[0] VPWR VGND sg13cmos5l_antennanp
XFILLER_9_909 VPWR VGND sg13cmos5l_decap_8
XFILLER_17_35 VPWR VGND sg13cmos5l_decap_8
XFILLER_12_448 VPWR VGND sg13cmos5l_decap_8
XFILLER_4_614 VPWR VGND sg13cmos5l_decap_8
XFILLER_3_102 VPWR VGND sg13cmos5l_fill_2
XFILLER_0_820 VPWR VGND sg13cmos5l_decap_8
XFILLER_16_732 VPWR VGND sg13cmos5l_decap_8
XANTENNA__266__X Tile_X0Y0_S2BEGb[6] VPWR VGND sg13cmos5l_antennanp
XFILLER_15_231 VPWR VGND sg13cmos5l_decap_8
XFILLER_8_920 VPWR VGND sg13cmos5l_decap_8
XFILLER_11_481 VPWR VGND sg13cmos5l_decap_8
X_139_ NPU_QUANT_SHIFT_IN24 Tile_X0Y0_UserCLK _389_/X _166_/L_HI VPWR VGND sg13cmos5l_dfrbpq_1
X_208_ Tile_X1Y0_S1BEG[1] Tile_X1Y0_N1END[2] VPWR VGND sg13cmos5l_buf_1
XANTENNA__125__Q NPU_QUANT_SHIFT_IN10 VPWR VGND sg13cmos5l_antennanp
XFILLER_10_908 VPWR VGND sg13cmos5l_decap_8
XFILLER_0_105 VPWR VGND sg13cmos5l_decap_8
XFILLER_17_529 VPWR VGND sg13cmos5l_decap_8
XFILLER_12_245 VPWR VGND sg13cmos5l_decap_8
XFILLER_13_735 VPWR VGND sg13cmos5l_decap_8
XFILLER_8_238 VPWR VGND sg13cmos5l_decap_8
XFILLER_5_49 VPWR VGND sg13cmos5l_decap_8
XFILLER_4_466 VPWR VGND sg13cmos5l_decap_8
XFILLER_0_694 VPWR VGND sg13cmos5l_fill_1
XFILLER_12_790 VPWR VGND sg13cmos5l_decap_8
XFILLER_8_772 VPWR VGND sg13cmos5l_fill_1
XFILLER_10_716 VPWR VGND sg13cmos5l_decap_8
XFILLER_14_14 VPWR VGND sg13cmos5l_decap_8
XFILLER_17_315 VPWR VGND sg13cmos5l_decap_8
XFILLER_13_532 VPWR VGND sg13cmos5l_decap_8
XFILLER_9_547 VPWR VGND sg13cmos5l_decap_8
XFILLER_0_480 VPWR VGND sg13cmos5l_decap_8
XFILLER_16_392 VPWR VGND sg13cmos5l_decap_8
XFILLER_17_893 VPWR VGND sg13cmos5l_decap_8
XFILLER_6_70 VPWR VGND sg13cmos5l_decap_8
XFILLER_14_329 VPWR VGND sg13cmos5l_decap_8
XANTENNA__364__X Tile_X1Y0_FrameStrobe_O[8] VPWR VGND sg13cmos5l_antennanp
XFILLER_10_513 VPWR VGND sg13cmos5l_decap_8
XFILLER_2_756 VPWR VGND sg13cmos5l_decap_8
XFILLER_2_712 VPWR VGND sg13cmos5l_fill_1
XFILLER_17_112 VPWR VGND sg13cmos5l_decap_8
XFILLER_2_28 VPWR VGND sg13cmos5l_decap_8
XFILLER_1_255 VPWR VGND sg13cmos5l_fill_2
XANTENNA__274__X Tile_X0Y0_S4BEG[6] VPWR VGND sg13cmos5l_antennanp
XFILLER_14_830 VPWR VGND sg13cmos5l_decap_8
XFILLER_18_679 VPWR VGND sg13cmos5l_decap_8
XFILLER_17_189 VPWR VGND sg13cmos5l_decap_8
X_387_ _387_/X Tile_X1Y0_N4END[4] Tile_X1Y0_N4END[7] Tile_X1Y0_NN4END[5] Tile_X1Y0_NN4END[7]
+ _098_/Q _097_/Q VPWR VGND sg13cmos5l_mux4_1
XFILLER_9_366 VPWR VGND sg13cmos5l_decap_8
XFILLER_17_690 VPWR VGND sg13cmos5l_decap_8
XANTENNA__133__Q NPU_QUANT_SHIFT_IN18 VPWR VGND sg13cmos5l_antennanp
XANTENNA__359__X Tile_X1Y0_FrameStrobe_O[3] VPWR VGND sg13cmos5l_antennanp
XFILLER_14_126 VPWR VGND sg13cmos5l_decap_8
XFILLER_15_605 VPWR VGND sg13cmos5l_decap_8
X_310_ Tile_X1Y0_FrameData_O[6] Tile_X0Y0_FrameData[6] VPWR VGND sg13cmos5l_buf_1
XFILLER_10_387 VPWR VGND sg13cmos5l_decap_8
XFILLER_11_877 VPWR VGND sg13cmos5l_decap_8
X_172_ _172_/L_HI VPWR VGND sg13cmos5l_tiehi
X_241_ Tile_X1Y0_S4BEG[14] Tile_X1Y0_N4END[1] VPWR VGND sg13cmos5l_buf_1
XFILLER_7_0 VPWR VGND sg13cmos5l_decap_8
XFILLER_2_586 VPWR VGND sg13cmos5l_decap_4
XFILLER_2_575 VPWR VGND sg13cmos5l_fill_1
XANTENNA__269__X Tile_X0Y0_S4BEG[1] VPWR VGND sg13cmos5l_antennanp
XFILLER_18_421 VPWR VGND sg13cmos5l_fill_2
XFILLER_18_410 VPWR VGND sg13cmos5l_decap_8
XFILLER_9_141 VPWR VGND sg13cmos5l_decap_8
XANTENNA__128__Q NPU_QUANT_SHIFT_IN13 VPWR VGND sg13cmos5l_antennanp
XFILLER_12_608 VPWR VGND sg13cmos5l_decap_8
XFILLER_0_7 VPWR VGND sg13cmos5l_decap_8
XFILLER_16_914 VPWR VGND sg13cmos5l_decap_8
XFILLER_11_641 VPWR VGND sg13cmos5l_decap_8
XFILLER_15_413 VPWR VGND sg13cmos5l_decap_8
XFILLER_16_958 VPWR VGND sg13cmos5l_fill_2
X_224_ Tile_X1Y0_S2BEGb[5] Tile_X1Y0_N2END[2] VPWR VGND sg13cmos5l_buf_1
XFILLER_8_49 VPWR VGND sg13cmos5l_decap_8
XFILLER_10_184 VPWR VGND sg13cmos5l_decap_8
XFILLER_12_91 VPWR VGND sg13cmos5l_decap_8
X_086_ _086_/Q Tile_X0Y0_FrameData[20] VGND VPWR Tile_X1Y0_FrameStrobe[0] latch
X_155_ _155_/L_HI VPWR VGND sg13cmos5l_tiehi
XFILLER_7_612 VPWR VGND sg13cmos5l_decap_8
XFILLER_6_133 VPWR VGND sg13cmos5l_decap_8
XFILLER_18_284 VPWR VGND sg13cmos5l_decap_8
XFILLER_14_490 VPWR VGND sg13cmos5l_decap_8
XFILLER_17_14 VPWR VGND sg13cmos5l_decap_8
XFILLER_12_427 VPWR VGND sg13cmos5l_decap_8
XFILLER_0_854 VPWR VGND sg13cmos5l_fill_1
XFILLER_3_158 VPWR VGND sg13cmos5l_fill_1
XFILLER_15_210 VPWR VGND sg13cmos5l_decap_8
XFILLER_16_711 VPWR VGND sg13cmos5l_decap_8
XANTENNA__282__X Tile_X0Y0_S4BEG[14] VPWR VGND sg13cmos5l_antennanp
XFILLER_11_460 VPWR VGND sg13cmos5l_decap_8
XFILLER_15_287 VPWR VGND sg13cmos5l_decap_8
XFILLER_16_788 VPWR VGND sg13cmos5l_decap_8
X_207_ Tile_X1Y0_S1BEG[0] Tile_X1Y0_N1END[3] VPWR VGND sg13cmos5l_buf_1
X_069_ _069_/Q Tile_X0Y0_FrameData[1] VGND VPWR Tile_X0Y0_FrameStrobe[0] latch
X_138_ NPU_QUANT_SHIFT_IN23 Tile_X0Y0_UserCLK _388_/X _167_/L_HI VPWR VGND sg13cmos5l_dfrbpq_1
XFILLER_7_486 VPWR VGND sg13cmos5l_decap_8
XFILLER_2_180 VPWR VGND sg13cmos5l_fill_2
XFILLER_0_94 VPWR VGND sg13cmos5l_fill_1
XANTENNA__192__X Tile_X1Y0_FrameStrobe_O[13] VPWR VGND sg13cmos5l_antennanp
XFILLER_9_92 VPWR VGND sg13cmos5l_decap_8
XANTENNA__141__Q NPU_QUANT_SHIFT_IN26 VPWR VGND sg13cmos5l_antennanp
XFILLER_1_629 VPWR VGND sg13cmos5l_decap_8
XFILLER_12_224 VPWR VGND sg13cmos5l_decap_8
XFILLER_13_714 VPWR VGND sg13cmos5l_decap_8
XFILLER_9_718 VPWR VGND sg13cmos5l_decap_8
XFILLER_8_217 VPWR VGND sg13cmos5l_decap_8
XFILLER_5_913 VPWR VGND sg13cmos5l_decap_4
XFILLER_5_28 VPWR VGND sg13cmos5l_decap_8
XFILLER_4_445 VPWR VGND sg13cmos5l_decap_8
XANTENNA__277__X Tile_X0Y0_S4BEG[9] VPWR VGND sg13cmos5l_antennanp
XFILLER_16_585 VPWR VGND sg13cmos5l_decap_8
XANTENNA__136__Q NPU_QUANT_SHIFT_IN21 VPWR VGND sg13cmos5l_antennanp
XFILLER_13_511 VPWR VGND sg13cmos5l_decap_8
XFILLER_13_588 VPWR VGND sg13cmos5l_decap_8
XFILLER_9_526 VPWR VGND sg13cmos5l_decap_8
XFILLER_16_371 VPWR VGND sg13cmos5l_decap_8
XFILLER_17_872 VPWR VGND sg13cmos5l_decap_8
XFILLER_8_592 VPWR VGND sg13cmos5l_decap_8
XFILLER_14_308 VPWR VGND sg13cmos5l_decap_8
XFILLER_10_569 VPWR VGND sg13cmos5l_decap_8
XFILLER_1_234 VPWR VGND sg13cmos5l_decap_4
XFILLER_18_658 VPWR VGND sg13cmos5l_decap_8
XFILLER_13_385 VPWR VGND sg13cmos5l_decap_8
XFILLER_14_886 VPWR VGND sg13cmos5l_decap_8
XFILLER_15_91 VPWR VGND sg13cmos5l_decap_8
XFILLER_17_168 VPWR VGND sg13cmos5l_decap_8
X_386_ _386_/X Tile_X1Y0_N4END[6] Tile_X1Y0_N4END[7] Tile_X1Y0_NN4END[4] Tile_X1Y0_NN4END[6]
+ _100_/Q _099_/Q VPWR VGND sg13cmos5l_mux4_1
XANTENNA__290__X Tile_X0Y0_SS4BEG[6] VPWR VGND sg13cmos5l_antennanp
XFILLER_11_49 VPWR VGND sg13cmos5l_decap_8
XFILLER_11_801 VPWR VGND sg13cmos5l_decap_8
XFILLER_11_834 VPWR VGND sg13cmos5l_decap_4
XFILLER_14_105 VPWR VGND sg13cmos5l_decap_8
X_240_ Tile_X1Y0_S4BEG[13] Tile_X1Y0_N4END[2] VPWR VGND sg13cmos5l_buf_1
XFILLER_10_322 VPWR VGND sg13cmos5l_decap_8
XFILLER_11_856 VPWR VGND sg13cmos5l_decap_8
X_171_ _171_/L_HI VPWR VGND sg13cmos5l_tiehi
XFILLER_7_838 VPWR VGND sg13cmos5l_fill_2
XFILLER_7_816 VPWR VGND sg13cmos5l_fill_1
XFILLER_2_532 VPWR VGND sg13cmos5l_decap_8
XANTENNA__285__X Tile_X0Y0_SS4BEG[1] VPWR VGND sg13cmos5l_antennanp
XFILLER_13_182 VPWR VGND sg13cmos5l_decap_8
XFILLER_14_683 VPWR VGND sg13cmos5l_decap_8
X_369_ _369_/X Tile_X0Y0_N4END[4] Tile_X0Y0_N4END[5] Tile_X0Y0_NN4END[4] Tile_X0Y0_NN4END[6]
+ _066_/Q _065_/Q VPWR VGND sg13cmos5l_mux4_1
XFILLER_9_120 VPWR VGND sg13cmos5l_decap_8
XFILLER_9_197 VPWR VGND sg13cmos5l_decap_8
XANTENNA__195__X Tile_X1Y0_FrameStrobe_O[16] VPWR VGND sg13cmos5l_antennanp
XFILLER_11_119 VPWR VGND sg13cmos5l_decap_8
XANTENNA__144__Q NPU_QUANT_SHIFT_IN29 VPWR VGND sg13cmos5l_antennanp
XFILLER_11_620 VPWR VGND sg13cmos5l_decap_8
XFILLER_15_469 VPWR VGND sg13cmos5l_decap_8
X_223_ Tile_X1Y0_S2BEGb[4] Tile_X1Y0_N2END[3] VPWR VGND sg13cmos5l_buf_1
XFILLER_8_28 VPWR VGND sg13cmos5l_decap_8
XFILLER_10_163 VPWR VGND sg13cmos5l_decap_8
XFILLER_11_697 VPWR VGND sg13cmos5l_decap_8
XFILLER_12_70 VPWR VGND sg13cmos5l_decap_8
X_085_ _085_/Q Tile_X0Y0_FrameData[21] VGND VPWR Tile_X1Y0_FrameStrobe[0] latch
X_154_ _154_/L_HI VPWR VGND sg13cmos5l_tiehi
XFILLER_6_189 VPWR VGND sg13cmos5l_decap_8
XFILLER_6_112 VPWR VGND sg13cmos5l_decap_8
XFILLER_3_896 VPWR VGND sg13cmos5l_decap_8
XFILLER_18_263 VPWR VGND sg13cmos5l_decap_8
XANTENNA__139__Q NPU_QUANT_SHIFT_IN24 VPWR VGND sg13cmos5l_antennanp
XFILLER_12_406 VPWR VGND sg13cmos5l_decap_8
XFILLER_13_918 VPWR VGND sg13cmos5l_decap_8
XFILLER_4_605 VPWR VGND sg13cmos5l_decap_4
XFILLER_0_899 VPWR VGND sg13cmos5l_decap_8
XFILLER_15_266 VPWR VGND sg13cmos5l_decap_8
XFILLER_16_767 VPWR VGND sg13cmos5l_decap_8
X_137_ NPU_QUANT_SHIFT_IN22 Tile_X0Y0_UserCLK _387_/X _152_/L_HI VPWR VGND sg13cmos5l_dfrbpq_1
X_206_ Tile_X0Y0_S2BEG[7] Tile_X0Y0_N2MID[0] VPWR VGND sg13cmos5l_buf_1
XFILLER_7_465 VPWR VGND sg13cmos5l_decap_8
X_068_ _068_/Q Tile_X0Y0_FrameData[2] VGND VPWR Tile_X0Y0_FrameStrobe[0] latch
XFILLER_0_73 VPWR VGND sg13cmos5l_decap_8
XFILLER_9_71 VPWR VGND sg13cmos5l_decap_8
XFILLER_12_203 VPWR VGND sg13cmos5l_decap_8
XFILLER_5_958 VPWR VGND sg13cmos5l_fill_2
XFILLER_4_424 VPWR VGND sg13cmos5l_decap_8
XFILLER_4_413 VPWR VGND sg13cmos5l_fill_2
XFILLER_0_674 VPWR VGND sg13cmos5l_decap_8
XANTENNA__293__X Tile_X0Y0_SS4BEG[9] VPWR VGND sg13cmos5l_antennanp
XFILLER_16_520 VPWR VGND sg13cmos5l_fill_1
XFILLER_16_564 VPWR VGND sg13cmos5l_decap_8
XFILLER_18_91 VPWR VGND sg13cmos5l_decap_8
XFILLER_11_280 VPWR VGND sg13cmos5l_decap_8
XFILLER_8_763 VPWR VGND sg13cmos5l_decap_8
XFILLER_8_741 VPWR VGND sg13cmos5l_decap_8
XFILLER_7_284 VPWR VGND sg13cmos5l_fill_2
XFILLER_7_273 VPWR VGND sg13cmos5l_decap_8
XFILLER_15_0 VPWR VGND sg13cmos5l_decap_8
XFILLER_14_49 VPWR VGND sg13cmos5l_decap_8
XFILLER_2_928 VPWR VGND sg13cmos5l_decap_8
XFILLER_18_829 VPWR VGND sg13cmos5l_decap_8
XFILLER_13_567 VPWR VGND sg13cmos5l_decap_8
XFILLER_9_505 VPWR VGND sg13cmos5l_decap_8
XFILLER_0_460 VPWR VGND sg13cmos5l_fill_2
XFILLER_4_243 VPWR VGND sg13cmos5l_decap_8
XANTENNA__288__X Tile_X0Y0_SS4BEG[4] VPWR VGND sg13cmos5l_antennanp
XFILLER_16_350 VPWR VGND sg13cmos5l_decap_8
XFILLER_17_851 VPWR VGND sg13cmos5l_decap_8
XFILLER_8_571 VPWR VGND sg13cmos5l_decap_8
XANTENNA__198__X Tile_X1Y0_FrameStrobe_O[19] VPWR VGND sg13cmos5l_antennanp
XANTENNA__147__Q NPU_PSUM_LUT_EN VPWR VGND sg13cmos5l_antennanp
XFILLER_10_548 VPWR VGND sg13cmos5l_decap_8
XFILLER_1_213 VPWR VGND sg13cmos5l_decap_8
XFILLER_17_147 VPWR VGND sg13cmos5l_decap_8
XFILLER_18_626 VPWR VGND sg13cmos5l_decap_8
XFILLER_13_364 VPWR VGND sg13cmos5l_decap_8
XFILLER_14_865 VPWR VGND sg13cmos5l_decap_8
XFILLER_15_70 VPWR VGND sg13cmos5l_decap_8
X_385_ _385_/X Tile_X1Y0_N4END[5] Tile_X1Y0_N4END[6] Tile_X1Y0_NN4END[5] Tile_X1Y0_NN4END[7]
+ _102_/Q _101_/Q VPWR VGND sg13cmos5l_mux4_1
XFILLER_5_552 VPWR VGND sg13cmos5l_decap_8
XFILLER_11_28 VPWR VGND sg13cmos5l_decap_8
XFILLER_11_846 VPWR VGND sg13cmos5l_decap_8
X_170_ _170_/L_HI VPWR VGND sg13cmos5l_tiehi
XFILLER_10_345 VPWR VGND sg13cmos5l_fill_2
XFILLER_2_500 VPWR VGND sg13cmos5l_decap_8
XFILLER_2_566 VPWR VGND sg13cmos5l_decap_8
XFILLER_18_401 VPWR VGND sg13cmos5l_fill_2
XANTENNA_230 Tile_X1Y0_FrameStrobe[7] VPWR VGND sg13cmos5l_antennanp
XFILLER_18_456 VPWR VGND sg13cmos5l_fill_2
XFILLER_13_161 VPWR VGND sg13cmos5l_decap_8
XFILLER_14_662 VPWR VGND sg13cmos5l_decap_8
X_299_ Tile_X0Y0_SS4BEG[15] Tile_X0Y0_NN4END[0] VPWR VGND sg13cmos5l_buf_1
X_368_ _368_/X Tile_X0Y0_N4END[0] Tile_X0Y0_N4END[3] Tile_X0Y0_NN4END[1] Tile_X0Y0_NN4END[3]
+ _068_/Q _067_/Q VPWR VGND sg13cmos5l_mux4_1
XFILLER_9_176 VPWR VGND sg13cmos5l_decap_8
XFILLER_5_371 VPWR VGND sg13cmos5l_decap_4
XFILLER_3_84 VPWR VGND sg13cmos5l_decap_8
XFILLER_15_448 VPWR VGND sg13cmos5l_decap_8
XFILLER_10_142 VPWR VGND sg13cmos5l_decap_8
XFILLER_11_676 VPWR VGND sg13cmos5l_decap_8
X_153_ _153_/L_HI VPWR VGND sg13cmos5l_tiehi
X_222_ Tile_X1Y0_S2BEGb[3] Tile_X1Y0_N2END[4] VPWR VGND sg13cmos5l_buf_1
XFILLER_7_647 VPWR VGND sg13cmos5l_decap_8
X_084_ _084_/Q Tile_X0Y0_FrameData[22] VGND VPWR Tile_X1Y0_FrameStrobe[0] latch
XFILLER_6_168 VPWR VGND sg13cmos5l_decap_8
XANTENNA__296__X Tile_X0Y0_SS4BEG[12] VPWR VGND sg13cmos5l_antennanp
XFILLER_18_242 VPWR VGND sg13cmos5l_decap_8
XFILLER_18_220 VPWR VGND sg13cmos5l_decap_8
XFILLER_17_49 VPWR VGND sg13cmos5l_decap_8
XFILLER_3_149 VPWR VGND sg13cmos5l_decap_8
XFILLER_3_138 VPWR VGND sg13cmos5l_decap_8
XFILLER_15_245 VPWR VGND sg13cmos5l_decap_8
XFILLER_16_746 VPWR VGND sg13cmos5l_decap_8
XFILLER_11_495 VPWR VGND sg13cmos5l_decap_8
X_136_ NPU_QUANT_SHIFT_IN21 Tile_X0Y0_UserCLK _386_/X _183_/L_HI VPWR VGND sg13cmos5l_dfrbpq_1
X_205_ Tile_X0Y0_S2BEG[6] Tile_X0Y0_N2MID[1] VPWR VGND sg13cmos5l_buf_1
XFILLER_8_956 VPWR VGND sg13cmos5l_decap_4
XFILLER_8_934 VPWR VGND sg13cmos5l_fill_2
XFILLER_7_444 VPWR VGND sg13cmos5l_decap_8
XFILLER_7_433 VPWR VGND sg13cmos5l_fill_1
X_067_ _067_/Q Tile_X0Y0_FrameData[3] VGND VPWR Tile_X0Y0_FrameStrobe[0] latch
XFILLER_9_50 VPWR VGND sg13cmos5l_decap_8
XFILLER_1_609 VPWR VGND sg13cmos5l_decap_8
XFILLER_0_119 VPWR VGND sg13cmos5l_decap_8
XFILLER_13_749 VPWR VGND sg13cmos5l_decap_8
XFILLER_12_259 VPWR VGND sg13cmos5l_decap_8
XFILLER_0_620 VPWR VGND sg13cmos5l_fill_1
XFILLER_0_631 VPWR VGND sg13cmos5l_decap_8
XFILLER_16_543 VPWR VGND sg13cmos5l_decap_8
XFILLER_18_70 VPWR VGND sg13cmos5l_decap_8
XFILLER_8_731 VPWR VGND sg13cmos5l_decap_8
XFILLER_8_720 VPWR VGND sg13cmos5l_decap_8
X_119_ NPU_QUANT_SHIFT_IN4 Tile_X0Y0_UserCLK _369_/X _157_/L_HI VPWR VGND sg13cmos5l_dfrbpq_1
XFILLER_7_252 VPWR VGND sg13cmos5l_decap_8
XFILLER_14_28 VPWR VGND sg13cmos5l_decap_8
XFILLER_2_907 VPWR VGND sg13cmos5l_decap_8
XFILLER_18_808 VPWR VGND sg13cmos5l_decap_8
XFILLER_17_329 VPWR VGND sg13cmos5l_decap_8
XFILLER_13_546 VPWR VGND sg13cmos5l_decap_8
XFILLER_4_222 VPWR VGND sg13cmos5l_decap_8
XFILLER_0_494 VPWR VGND sg13cmos5l_decap_8
XFILLER_1_940 VPWR VGND sg13cmos5l_fill_1
XFILLER_17_830 VPWR VGND sg13cmos5l_decap_8
XFILLER_8_550 VPWR VGND sg13cmos5l_decap_8
XFILLER_6_84 VPWR VGND sg13cmos5l_decap_8
XFILLER_10_527 VPWR VGND sg13cmos5l_decap_8
XFILLER_6_509 VPWR VGND sg13cmos5l_fill_1
XFILLER_17_126 VPWR VGND sg13cmos5l_decap_8
XFILLER_18_605 VPWR VGND sg13cmos5l_decap_8
XFILLER_13_343 VPWR VGND sg13cmos5l_decap_8
XFILLER_14_844 VPWR VGND sg13cmos5l_decap_8
X_384_ _384_/X Tile_X1Y0_N4END[4] Tile_X1Y0_N4END[5] Tile_X1Y0_NN4END[4] Tile_X1Y0_NN4END[6]
+ _104_/Q _103_/Q VPWR VGND sg13cmos5l_mux4_1
XFILLER_5_531 VPWR VGND sg13cmos5l_decap_8
XANTENNA__299__X Tile_X0Y0_SS4BEG[15] VPWR VGND sg13cmos5l_antennanp
XFILLER_9_881 VPWR VGND sg13cmos5l_decap_8
XFILLER_15_619 VPWR VGND sg13cmos5l_decap_8
XFILLER_10_313 VPWR VGND sg13cmos5l_decap_4
XFILLER_10_357 VPWR VGND sg13cmos5l_decap_8
XFILLER_10_368 VPWR VGND sg13cmos5l_fill_2
XFILLER_18_435 VPWR VGND sg13cmos5l_decap_8
XANTENNA_220 Tile_X0Y0_FrameData[29] VPWR VGND sg13cmos5l_antennanp
XANTENNA_231 Tile_X0Y0_FrameData[15] VPWR VGND sg13cmos5l_antennanp
XFILLER_13_140 VPWR VGND sg13cmos5l_decap_8
XFILLER_18_468 VPWR VGND sg13cmos5l_decap_8
XFILLER_10_880 VPWR VGND sg13cmos5l_decap_8
X_298_ Tile_X0Y0_SS4BEG[14] Tile_X0Y0_NN4END[1] VPWR VGND sg13cmos5l_buf_1
X_367_ _367_/X Tile_X0Y0_N4END[2] Tile_X0Y0_N4END[3] Tile_X0Y0_NN4END[0] Tile_X0Y0_NN4END[2]
+ _070_/Q _069_/Q VPWR VGND sg13cmos5l_mux4_1
XFILLER_9_155 VPWR VGND sg13cmos5l_decap_8
XFILLER_6_884 VPWR VGND sg13cmos5l_decap_8
XFILLER_3_63 VPWR VGND sg13cmos5l_decap_8
XFILLER_17_490 VPWR VGND sg13cmos5l_decap_8
XFILLER_15_427 VPWR VGND sg13cmos5l_decap_8
XFILLER_16_928 VPWR VGND sg13cmos5l_decap_8
XFILLER_10_121 VPWR VGND sg13cmos5l_decap_8
XFILLER_10_198 VPWR VGND sg13cmos5l_decap_8
XFILLER_11_655 VPWR VGND sg13cmos5l_decap_8
X_083_ _083_/Q Tile_X0Y0_FrameData[23] VGND VPWR Tile_X1Y0_FrameStrobe[0] latch
X_152_ _152_/L_HI VPWR VGND sg13cmos5l_tiehi
X_221_ Tile_X1Y0_S2BEGb[2] Tile_X1Y0_N2END[5] VPWR VGND sg13cmos5l_buf_1
XFILLER_7_626 VPWR VGND sg13cmos5l_decap_8
XFILLER_6_147 VPWR VGND sg13cmos5l_decap_8
XFILLER_5_0 VPWR VGND sg13cmos5l_decap_8
XFILLER_18_298 VPWR VGND sg13cmos5l_decap_8
XFILLER_17_28 VPWR VGND sg13cmos5l_decap_8
XFILLER_16_725 VPWR VGND sg13cmos5l_decap_8
XFILLER_15_224 VPWR VGND sg13cmos5l_decap_8
X_204_ Tile_X0Y0_S2BEG[5] Tile_X0Y0_N2MID[2] VPWR VGND sg13cmos5l_buf_1
XFILLER_8_913 VPWR VGND sg13cmos5l_decap_8
XFILLER_11_474 VPWR VGND sg13cmos5l_decap_8
X_066_ _066_/Q Tile_X0Y0_FrameData[4] VGND VPWR Tile_X0Y0_FrameStrobe[0] latch
X_135_ NPU_QUANT_SHIFT_IN20 Tile_X0Y0_UserCLK _385_/X _182_/L_HI VPWR VGND sg13cmos5l_dfrbpq_1
XFILLER_7_412 VPWR VGND sg13cmos5l_decap_8
XFILLER_12_238 VPWR VGND sg13cmos5l_decap_8
XFILLER_13_728 VPWR VGND sg13cmos5l_decap_8
XFILLER_4_415 VPWR VGND sg13cmos5l_fill_1
XFILLER_0_698 VPWR VGND sg13cmos5l_decap_8
XFILLER_4_459 VPWR VGND sg13cmos5l_decap_8
XFILLER_16_511 VPWR VGND sg13cmos5l_decap_8
XFILLER_12_783 VPWR VGND sg13cmos5l_decap_8
XFILLER_16_599 VPWR VGND sg13cmos5l_decap_8
XFILLER_7_231 VPWR VGND sg13cmos5l_decap_8
X_049_ _049_/Q Tile_X0Y0_FrameData[21] VGND VPWR Tile_X0Y0_FrameStrobe[0] latch
X_118_ NPU_QUANT_SHIFT_IN3 Tile_X0Y0_UserCLK _368_/X _158_/L_HI VPWR VGND sg13cmos5l_dfrbpq_1
XFILLER_10_709 VPWR VGND sg13cmos5l_decap_8
XFILLER_17_308 VPWR VGND sg13cmos5l_decap_8
XFILLER_13_525 VPWR VGND sg13cmos5l_decap_8
XFILLER_5_779 VPWR VGND sg13cmos5l_decap_8
XFILLER_4_201 VPWR VGND sg13cmos5l_decap_8
XFILLER_0_473 VPWR VGND sg13cmos5l_decap_8
XFILLER_1_952 VPWR VGND sg13cmos5l_fill_2
XFILLER_16_385 VPWR VGND sg13cmos5l_decap_8
XFILLER_17_886 VPWR VGND sg13cmos5l_decap_8
XANTENNA_1 Tile_X0Y0_FrameData[0] VPWR VGND sg13cmos5l_antennanp
XFILLER_6_63 VPWR VGND sg13cmos5l_decap_8
XFILLER_10_506 VPWR VGND sg13cmos5l_decap_8
XFILLER_9_7 VPWR VGND sg13cmos5l_decap_8
XFILLER_2_705 VPWR VGND sg13cmos5l_decap_8
XFILLER_1_204 VPWR VGND sg13cmos5l_fill_2
XFILLER_13_322 VPWR VGND sg13cmos5l_decap_8
XFILLER_14_823 VPWR VGND sg13cmos5l_decap_8
XFILLER_17_105 VPWR VGND sg13cmos5l_decap_8
X_383_ _383_/X Tile_X1Y0_N4END[0] Tile_X1Y0_N4END[3] Tile_X1Y0_NN4END[1] Tile_X1Y0_NN4END[3]
+ _106_/Q _105_/Q VPWR VGND sg13cmos5l_mux4_1
XFILLER_13_399 VPWR VGND sg13cmos5l_decap_8
XFILLER_9_337 VPWR VGND sg13cmos5l_fill_2
XFILLER_5_598 VPWR VGND sg13cmos5l_decap_8
XFILLER_1_771 VPWR VGND sg13cmos5l_decap_4
XFILLER_17_650 VPWR VGND sg13cmos5l_fill_1
XFILLER_16_182 VPWR VGND sg13cmos5l_decap_8
XFILLER_17_683 VPWR VGND sg13cmos5l_decap_8
XFILLER_14_119 VPWR VGND sg13cmos5l_decap_8
XFILLER_10_303 VPWR VGND sg13cmos5l_decap_8
XFILLER_10_336 VPWR VGND sg13cmos5l_decap_4
XFILLER_2_579 VPWR VGND sg13cmos5l_decap_8
XFILLER_2_546 VPWR VGND sg13cmos5l_fill_2
XFILLER_18_447 VPWR VGND sg13cmos5l_decap_4
XFILLER_18_403 VPWR VGND sg13cmos5l_fill_1
XANTENNA_210 Tile_X0Y0_FrameData[14] VPWR VGND sg13cmos5l_antennanp
XANTENNA_221 Tile_X0Y0_FrameData[29] VPWR VGND sg13cmos5l_antennanp
XANTENNA_232 Tile_X0Y0_FrameData[15] VPWR VGND sg13cmos5l_antennanp
XFILLER_14_631 VPWR VGND sg13cmos5l_decap_8
XFILLER_14_642 VPWR VGND sg13cmos5l_fill_2
XFILLER_14_697 VPWR VGND sg13cmos5l_decap_8
X_366_ _366_/X Tile_X0Y0_N4END[1] Tile_X0Y0_N4END[2] Tile_X0Y0_NN4END[1] Tile_X0Y0_NN4END[3]
+ _072_/Q _071_/Q VPWR VGND sg13cmos5l_mux4_1
XFILLER_9_134 VPWR VGND sg13cmos5l_decap_8
XFILLER_13_196 VPWR VGND sg13cmos5l_decap_8
X_297_ Tile_X0Y0_SS4BEG[13] Tile_X0Y0_NN4END[2] VPWR VGND sg13cmos5l_buf_1
XFILLER_3_42 VPWR VGND sg13cmos5l_decap_8
XFILLER_16_907 VPWR VGND sg13cmos5l_decap_8
XFILLER_10_100 VPWR VGND sg13cmos5l_decap_8
XFILLER_15_406 VPWR VGND sg13cmos5l_decap_8
X_220_ Tile_X1Y0_S2BEGb[1] Tile_X1Y0_N2END[6] VPWR VGND sg13cmos5l_buf_1
XFILLER_10_177 VPWR VGND sg13cmos5l_decap_8
XFILLER_11_634 VPWR VGND sg13cmos5l_decap_8
XFILLER_12_84 VPWR VGND sg13cmos5l_decap_8
X_082_ _082_/Q Tile_X0Y0_FrameData[24] VGND VPWR Tile_X1Y0_FrameStrobe[0] latch
X_151_ _151_/L_HI VPWR VGND sg13cmos5l_tiehi
XFILLER_7_605 VPWR VGND sg13cmos5l_decap_8
XFILLER_6_126 VPWR VGND sg13cmos5l_decap_8
XFILLER_3_844 VPWR VGND sg13cmos5l_decap_8
XFILLER_3_833 VPWR VGND sg13cmos5l_fill_1
XFILLER_2_354 VPWR VGND sg13cmos5l_fill_1
XFILLER_2_332 VPWR VGND sg13cmos5l_fill_2
XFILLER_15_940 VPWR VGND sg13cmos5l_fill_1
XFILLER_18_277 VPWR VGND sg13cmos5l_decap_8
XFILLER_14_483 VPWR VGND sg13cmos5l_decap_8
XFILLER_15_951 VPWR VGND sg13cmos5l_decap_8
X_349_ Tile_X0Y0_FrameStrobe_O[13] Tile_X0Y0_FrameStrobe[13] VPWR VGND sg13cmos5l_buf_1
XFILLER_6_693 VPWR VGND sg13cmos5l_fill_2
XFILLER_15_203 VPWR VGND sg13cmos5l_decap_8
XFILLER_16_704 VPWR VGND sg13cmos5l_decap_8
XFILLER_11_453 VPWR VGND sg13cmos5l_decap_8
XFILLER_12_954 VPWR VGND sg13cmos5l_decap_4
X_203_ Tile_X0Y0_S2BEG[4] Tile_X0Y0_N2MID[3] VPWR VGND sg13cmos5l_buf_1
XFILLER_8_936 VPWR VGND sg13cmos5l_fill_1
X_065_ _065_/Q Tile_X0Y0_FrameData[5] VGND VPWR Tile_X0Y0_FrameStrobe[0] latch
X_134_ NPU_QUANT_SHIFT_IN19 Tile_X0Y0_UserCLK _384_/X _177_/L_HI VPWR VGND sg13cmos5l_dfrbpq_1
XFILLER_7_479 VPWR VGND sg13cmos5l_decap_8
XFILLER_2_162 VPWR VGND sg13cmos5l_decap_8
XFILLER_0_43 VPWR VGND sg13cmos5l_decap_4
XFILLER_0_65 VPWR VGND sg13cmos5l_fill_2
XFILLER_0_87 VPWR VGND sg13cmos5l_decap_8
XFILLER_0_98 VPWR VGND sg13cmos5l_decap_8
XFILLER_14_280 VPWR VGND sg13cmos5l_decap_8
XFILLER_9_85 VPWR VGND sg13cmos5l_decap_8
XFILLER_12_217 VPWR VGND sg13cmos5l_decap_8
XFILLER_13_707 VPWR VGND sg13cmos5l_decap_8
XFILLER_5_917 VPWR VGND sg13cmos5l_fill_2
XFILLER_5_906 VPWR VGND sg13cmos5l_decap_8
XFILLER_4_438 VPWR VGND sg13cmos5l_decap_8
XANTENNA__201__X Tile_X0Y0_S2BEG[2] VPWR VGND sg13cmos5l_antennanp
XFILLER_16_578 VPWR VGND sg13cmos5l_decap_8
XFILLER_11_294 VPWR VGND sg13cmos5l_decap_8
XFILLER_12_762 VPWR VGND sg13cmos5l_decap_8
X_117_ NPU_QUANT_SHIFT_IN2 Tile_X0Y0_UserCLK _367_/X _160_/L_HI VPWR VGND sg13cmos5l_dfrbpq_1
XFILLER_8_755 VPWR VGND sg13cmos5l_fill_1
XFILLER_7_210 VPWR VGND sg13cmos5l_decap_8
X_048_ _048_/Q Tile_X0Y0_FrameData[22] VGND VPWR Tile_X0Y0_FrameStrobe[0] latch
XFILLER_13_504 VPWR VGND sg13cmos5l_decap_8
XFILLER_9_519 VPWR VGND sg13cmos5l_decap_8
XFILLER_4_257 VPWR VGND sg13cmos5l_decap_8
XFILLER_16_364 VPWR VGND sg13cmos5l_decap_8
XFILLER_17_865 VPWR VGND sg13cmos5l_decap_8
XANTENNA_2 Tile_X0Y0_FrameData[0] VPWR VGND sg13cmos5l_antennanp
XFILLER_12_581 VPWR VGND sg13cmos5l_fill_1
XFILLER_8_585 VPWR VGND sg13cmos5l_decap_8
XFILLER_6_42 VPWR VGND sg13cmos5l_decap_8
XFILLER_4_791 VPWR VGND sg13cmos5l_decap_4
XFILLER_13_0 VPWR VGND sg13cmos5l_decap_8
XFILLER_2_728 VPWR VGND sg13cmos5l_decap_8
XFILLER_2_717 VPWR VGND sg13cmos5l_fill_2
XFILLER_1_238 VPWR VGND sg13cmos5l_fill_2
XFILLER_13_301 VPWR VGND sg13cmos5l_decap_8
XFILLER_14_802 VPWR VGND sg13cmos5l_decap_8
XFILLER_14_879 VPWR VGND sg13cmos5l_decap_8
XFILLER_15_84 VPWR VGND sg13cmos5l_decap_8
X_382_ _382_/X Tile_X1Y0_N4END[2] Tile_X1Y0_N4END[3] Tile_X1Y0_NN4END[0] Tile_X1Y0_NN4END[2]
+ _108_/Q _107_/Q VPWR VGND sg13cmos5l_mux4_1
XFILLER_13_378 VPWR VGND sg13cmos5l_decap_8
XFILLER_17_662 VPWR VGND sg13cmos5l_decap_8
XFILLER_13_890 VPWR VGND sg13cmos5l_decap_8
XFILLER_16_161 VPWR VGND sg13cmos5l_decap_8
XFILLER_11_838 VPWR VGND sg13cmos5l_fill_1
XFILLER_2_525 VPWR VGND sg13cmos5l_decap_8
XANTENNA_200 Tile_X0Y0_FrameData[13] VPWR VGND sg13cmos5l_antennanp
XANTENNA_211 Tile_X0Y0_FrameData[24] VPWR VGND sg13cmos5l_antennanp
XANTENNA_222 Tile_X0Y0_FrameData[30] VPWR VGND sg13cmos5l_antennanp
XANTENNA_233 Tile_X0Y0_FrameData[15] VPWR VGND sg13cmos5l_antennanp
XFILLER_18_426 VPWR VGND sg13cmos5l_decap_4
XFILLER_13_175 VPWR VGND sg13cmos5l_decap_8
XFILLER_14_676 VPWR VGND sg13cmos5l_decap_8
X_296_ Tile_X0Y0_SS4BEG[12] Tile_X0Y0_NN4END[3] VPWR VGND sg13cmos5l_buf_1
X_365_ _365_/X Tile_X0Y0_N4END[0] Tile_X0Y0_N4END[1] Tile_X0Y0_NN4END[0] Tile_X0Y0_NN4END[2]
+ _074_/Q _073_/Q VPWR VGND sg13cmos5l_mux4_1
XFILLER_9_113 VPWR VGND sg13cmos5l_decap_8
XFILLER_3_98 VPWR VGND sg13cmos5l_decap_4
XFILLER_3_21 VPWR VGND sg13cmos5l_decap_8
XFILLER_1_580 VPWR VGND sg13cmos5l_decap_8
XFILLER_11_613 VPWR VGND sg13cmos5l_decap_8
X_150_ NPU_QUANT_SHIFT_EN Tile_X0Y0_UserCLK _401_/X _163_/L_HI VPWR VGND sg13cmos5l_dfrbpq_1
XANTENNA__204__X Tile_X0Y0_S2BEG[5] VPWR VGND sg13cmos5l_antennanp
XFILLER_10_156 VPWR VGND sg13cmos5l_decap_8
XFILLER_12_63 VPWR VGND sg13cmos5l_decap_8
X_081_ _081_/Q Tile_X0Y0_FrameData[25] VGND VPWR Tile_X1Y0_FrameStrobe[0] latch
XFILLER_6_105 VPWR VGND sg13cmos5l_decap_8
XFILLER_3_812 VPWR VGND sg13cmos5l_fill_1
XFILLER_3_889 VPWR VGND sg13cmos5l_decap_8
XFILLER_2_399 VPWR VGND sg13cmos5l_decap_4
XFILLER_18_256 VPWR VGND sg13cmos5l_decap_8
XFILLER_18_234 VPWR VGND sg13cmos5l_decap_4
XFILLER_14_462 VPWR VGND sg13cmos5l_decap_8
X_279_ Tile_X0Y0_S4BEG[11] Tile_X0Y0_N4END[4] VPWR VGND sg13cmos5l_buf_1
X_348_ Tile_X0Y0_FrameStrobe_O[12] Tile_X0Y0_FrameStrobe[12] VPWR VGND sg13cmos5l_buf_1
XFILLER_6_672 VPWR VGND sg13cmos5l_decap_8
XFILLER_5_182 VPWR VGND sg13cmos5l_decap_8
XFILLER_4_609 VPWR VGND sg13cmos5l_fill_2
XFILLER_0_804 VPWR VGND sg13cmos5l_decap_4
XFILLER_15_259 VPWR VGND sg13cmos5l_decap_8
XFILLER_11_432 VPWR VGND sg13cmos5l_decap_8
XFILLER_12_911 VPWR VGND sg13cmos5l_decap_8
X_133_ NPU_QUANT_SHIFT_IN18 Tile_X0Y0_UserCLK _383_/X _179_/L_HI VPWR VGND sg13cmos5l_dfrbpq_1
X_202_ Tile_X0Y0_S2BEG[3] Tile_X0Y0_N2MID[4] VPWR VGND sg13cmos5l_buf_1
XFILLER_7_458 VPWR VGND sg13cmos5l_decap_8
X_064_ _064_/Q Tile_X0Y0_FrameData[6] VGND VPWR Tile_X0Y0_FrameStrobe[0] latch
XFILLER_3_697 VPWR VGND sg13cmos5l_decap_8
XFILLER_3_631 VPWR VGND sg13cmos5l_fill_2
XFILLER_17_7 VPWR VGND sg13cmos5l_decap_8
XFILLER_15_782 VPWR VGND sg13cmos5l_decap_8
XFILLER_9_64 VPWR VGND sg13cmos5l_decap_8
XFILLER_6_480 VPWR VGND sg13cmos5l_decap_8
XFILLER_0_601 VPWR VGND sg13cmos5l_decap_8
XFILLER_0_612 VPWR VGND sg13cmos5l_fill_2
XFILLER_4_406 VPWR VGND sg13cmos5l_decap_8
XFILLER_0_656 VPWR VGND sg13cmos5l_fill_1
XFILLER_0_667 VPWR VGND sg13cmos5l_decap_8
XFILLER_16_557 VPWR VGND sg13cmos5l_decap_8
XFILLER_18_84 VPWR VGND sg13cmos5l_decap_8
XFILLER_11_273 VPWR VGND sg13cmos5l_decap_8
XFILLER_12_741 VPWR VGND sg13cmos5l_decap_8
X_116_ NPU_QUANT_SHIFT_IN1 Tile_X0Y0_UserCLK _366_/X _176_/L_HI VPWR VGND sg13cmos5l_dfrbpq_1
XFILLER_7_266 VPWR VGND sg13cmos5l_decap_8
X_047_ _047_/Q Tile_X0Y0_FrameData[23] VGND VPWR Tile_X0Y0_FrameStrobe[0] latch
XANTENNA__302__X Tile_X0Y0_S1BEG[2] VPWR VGND sg13cmos5l_antennanp
XANTENNA__212__X Tile_X1Y0_S2BEG[1] VPWR VGND sg13cmos5l_antennanp
XFILLER_0_453 VPWR VGND sg13cmos5l_decap_8
XFILLER_4_236 VPWR VGND sg13cmos5l_decap_8
XFILLER_17_844 VPWR VGND sg13cmos5l_decap_8
XFILLER_12_560 VPWR VGND sg13cmos5l_decap_8
XFILLER_16_343 VPWR VGND sg13cmos5l_decap_8
XANTENNA_3 Tile_X0Y0_FrameData[0] VPWR VGND sg13cmos5l_antennanp
XFILLER_12_593 VPWR VGND sg13cmos5l_decap_8
XFILLER_8_564 VPWR VGND sg13cmos5l_decap_8
XFILLER_6_98 VPWR VGND sg13cmos5l_decap_8
XFILLER_6_21 VPWR VGND sg13cmos5l_decap_8
XFILLER_1_206 VPWR VGND sg13cmos5l_fill_1
XFILLER_18_619 VPWR VGND sg13cmos5l_decap_8
XANTENNA__207__X Tile_X1Y0_S1BEG[0] VPWR VGND sg13cmos5l_antennanp
XFILLER_13_357 VPWR VGND sg13cmos5l_decap_8
XFILLER_14_858 VPWR VGND sg13cmos5l_decap_8
XFILLER_15_63 VPWR VGND sg13cmos5l_decap_8
X_381_ _381_/X Tile_X1Y0_N4END[1] Tile_X1Y0_N4END[2] Tile_X1Y0_NN4END[1] Tile_X1Y0_NN4END[3]
+ _110_/Q _109_/Q VPWR VGND sg13cmos5l_mux4_1
XFILLER_9_317 VPWR VGND sg13cmos5l_fill_2
XFILLER_5_545 VPWR VGND sg13cmos5l_decap_8
XFILLER_16_140 VPWR VGND sg13cmos5l_decap_8
XFILLER_17_641 VPWR VGND sg13cmos5l_decap_8
XFILLER_9_895 VPWR VGND sg13cmos5l_decap_8
XFILLER_11_828 VPWR VGND sg13cmos5l_fill_2
XFILLER_2_559 VPWR VGND sg13cmos5l_decap_8
XANTENNA_201 Tile_X0Y0_FrameData[13] VPWR VGND sg13cmos5l_antennanp
XANTENNA_212 Tile_X0Y0_FrameData[24] VPWR VGND sg13cmos5l_antennanp
XANTENNA_223 Tile_X0Y0_FrameData[30] VPWR VGND sg13cmos5l_antennanp
XANTENNA_234 Tile_X0Y0_FrameData[15] VPWR VGND sg13cmos5l_antennanp
XFILLER_13_154 VPWR VGND sg13cmos5l_decap_8
XFILLER_14_655 VPWR VGND sg13cmos5l_decap_8
X_295_ Tile_X0Y0_SS4BEG[11] Tile_X0Y0_NN4END[4] VPWR VGND sg13cmos5l_buf_1
X_364_ Tile_X1Y0_FrameStrobe_O[8] Tile_X1Y0_FrameStrobe[8] VPWR VGND sg13cmos5l_buf_1
XFILLER_9_169 VPWR VGND sg13cmos5l_decap_8
XFILLER_10_894 VPWR VGND sg13cmos5l_decap_8
XFILLER_6_898 VPWR VGND sg13cmos5l_decap_8
XFILLER_5_375 VPWR VGND sg13cmos5l_fill_1
XFILLER_3_77 VPWR VGND sg13cmos5l_decap_8
XANTENNA__310__X Tile_X1Y0_FrameData_O[6] VPWR VGND sg13cmos5l_antennanp
XFILLER_10_135 VPWR VGND sg13cmos5l_decap_8
XFILLER_11_669 VPWR VGND sg13cmos5l_decap_8
X_080_ _080_/Q Tile_X0Y0_FrameData[26] VGND VPWR Tile_X1Y0_FrameStrobe[0] latch
XFILLER_12_42 VPWR VGND sg13cmos5l_decap_8
XANTENNA__220__X Tile_X1Y0_S2BEGb[1] VPWR VGND sg13cmos5l_antennanp
XFILLER_18_213 VPWR VGND sg13cmos5l_decap_8
XFILLER_14_441 VPWR VGND sg13cmos5l_decap_8
X_278_ Tile_X0Y0_S4BEG[10] Tile_X0Y0_N4END[5] VPWR VGND sg13cmos5l_buf_1
X_347_ Tile_X0Y0_FrameStrobe_O[11] Tile_X0Y0_FrameStrobe[11] VPWR VGND sg13cmos5l_buf_1
XFILLER_5_161 VPWR VGND sg13cmos5l_decap_8
XFILLER_18_780 VPWR VGND sg13cmos5l_decap_8
XANTENNA__305__X Tile_X1Y0_FrameData_O[1] VPWR VGND sg13cmos5l_antennanp
XFILLER_0_827 VPWR VGND sg13cmos5l_fill_1
XFILLER_15_238 VPWR VGND sg13cmos5l_decap_8
XFILLER_16_739 VPWR VGND sg13cmos5l_decap_8
XANTENNA__215__X Tile_X1Y0_S2BEG[4] VPWR VGND sg13cmos5l_antennanp
XFILLER_11_411 VPWR VGND sg13cmos5l_decap_8
XFILLER_11_488 VPWR VGND sg13cmos5l_decap_8
X_063_ _063_/Q Tile_X0Y0_FrameData[7] VGND VPWR Tile_X0Y0_FrameStrobe[0] latch
X_132_ NPU_QUANT_SHIFT_IN17 Tile_X0Y0_UserCLK _382_/X _181_/L_HI VPWR VGND sg13cmos5l_dfrbpq_1
X_201_ Tile_X0Y0_S2BEG[2] Tile_X0Y0_N2MID[5] VPWR VGND sg13cmos5l_buf_1
XFILLER_8_927 VPWR VGND sg13cmos5l_decap_8
XFILLER_7_437 VPWR VGND sg13cmos5l_decap_8
XFILLER_7_426 VPWR VGND sg13cmos5l_decap_8
XFILLER_3_643 VPWR VGND sg13cmos5l_decap_4
XFILLER_3_610 VPWR VGND sg13cmos5l_decap_8
XFILLER_3_0 VPWR VGND sg13cmos5l_decap_8
XFILLER_2_153 VPWR VGND sg13cmos5l_decap_4
XFILLER_2_142 VPWR VGND sg13cmos5l_fill_1
XFILLER_2_120 VPWR VGND sg13cmos5l_decap_4
XFILLER_15_761 VPWR VGND sg13cmos5l_decap_8
XFILLER_9_43 VPWR VGND sg13cmos5l_decap_8
XFILLER_0_624 VPWR VGND sg13cmos5l_decap_8
XFILLER_18_63 VPWR VGND sg13cmos5l_decap_8
XFILLER_12_720 VPWR VGND sg13cmos5l_decap_8
XFILLER_16_536 VPWR VGND sg13cmos5l_decap_8
XFILLER_8_713 VPWR VGND sg13cmos5l_decap_8
XFILLER_11_252 VPWR VGND sg13cmos5l_decap_8
XFILLER_12_797 VPWR VGND sg13cmos5l_decap_8
X_046_ _046_/Q Tile_X0Y0_FrameData[24] VGND VPWR Tile_X0Y0_FrameStrobe[0] latch
X_115_ NPU_QUANT_SHIFT_IN0 Tile_X0Y0_UserCLK _365_/X _180_/L_HI VPWR VGND sg13cmos5l_dfrbpq_1
XFILLER_7_245 VPWR VGND sg13cmos5l_decap_8
XFILLER_15_591 VPWR VGND sg13cmos5l_decap_8
XFILLER_13_539 VPWR VGND sg13cmos5l_decap_8
XFILLER_5_738 VPWR VGND sg13cmos5l_fill_2
XFILLER_4_215 VPWR VGND sg13cmos5l_decap_8
XFILLER_0_487 VPWR VGND sg13cmos5l_decap_8
XFILLER_1_944 VPWR VGND sg13cmos5l_fill_1
XFILLER_1_922 VPWR VGND sg13cmos5l_decap_8
XFILLER_16_322 VPWR VGND sg13cmos5l_decap_8
XFILLER_17_823 VPWR VGND sg13cmos5l_decap_8
XFILLER_16_399 VPWR VGND sg13cmos5l_decap_8
XFILLER_8_543 VPWR VGND sg13cmos5l_decap_8
XANTENNA_4 Tile_X0Y0_FrameData[0] VPWR VGND sg13cmos5l_antennanp
XFILLER_6_77 VPWR VGND sg13cmos5l_decap_8
XANTENNA__313__X Tile_X1Y0_FrameData_O[9] VPWR VGND sg13cmos5l_antennanp
XFILLER_17_119 VPWR VGND sg13cmos5l_decap_8
XFILLER_13_336 VPWR VGND sg13cmos5l_decap_8
XFILLER_14_837 VPWR VGND sg13cmos5l_decap_8
XFILLER_15_42 VPWR VGND sg13cmos5l_decap_8
X_380_ _380_/X Tile_X1Y0_N4END[0] Tile_X1Y0_N4END[1] Tile_X1Y0_NN4END[0] Tile_X1Y0_NN4END[2]
+ _112_/Q _111_/Q VPWR VGND sg13cmos5l_mux4_1
XANTENNA__223__X Tile_X1Y0_S2BEGb[4] VPWR VGND sg13cmos5l_antennanp
XFILLER_5_524 VPWR VGND sg13cmos5l_decap_8
XFILLER_1_763 VPWR VGND sg13cmos5l_fill_1
XFILLER_1_752 VPWR VGND sg13cmos5l_decap_8
XFILLER_16_196 VPWR VGND sg13cmos5l_decap_8
XFILLER_17_697 VPWR VGND sg13cmos5l_decap_8
XFILLER_17_620 VPWR VGND sg13cmos5l_decap_8
XFILLER_9_841 VPWR VGND sg13cmos5l_fill_2
XFILLER_9_874 VPWR VGND sg13cmos5l_decap_8
XFILLER_8_362 VPWR VGND sg13cmos5l_fill_2
.ends
