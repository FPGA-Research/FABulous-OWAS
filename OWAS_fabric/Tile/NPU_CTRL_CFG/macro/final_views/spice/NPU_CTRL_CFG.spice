* NGSPICE file created from NPU_CTRL_CFG.ext - technology: ihp-sg13cmos5l

* Black-box entry subcircuit for sg13cmos5l_antennanp abstract view
.subckt sg13cmos5l_antennanp A VDD VSS
.ends

* Black-box entry subcircuit for sg13cmos5l_decap_8 abstract view
.subckt sg13cmos5l_decap_8 VDD VSS
.ends

* Black-box entry subcircuit for sg13cmos5l_buf_1 abstract view
.subckt sg13cmos5l_buf_1 X A VDD VSS
.ends

* Black-box entry subcircuit for sg13cmos5l_fill_2 abstract view
.subckt sg13cmos5l_fill_2 VDD VSS
.ends

* Black-box entry subcircuit for sg13cmos5l_decap_4 abstract view
.subckt sg13cmos5l_decap_4 VDD VSS
.ends

* Black-box entry subcircuit for sg13cmos5l_fill_1 abstract view
.subckt sg13cmos5l_fill_1 VDD VSS
.ends

* Black-box entry subcircuit for latch abstract view
.subckt latch Q D VSS VDD GATE
.ends

* Black-box entry subcircuit for sg13cmos5l_dfrbpq_1 abstract view
.subckt sg13cmos5l_dfrbpq_1 Q CLK D RESET_B VDD VSS
.ends

* Black-box entry subcircuit for sg13cmos5l_tiehi abstract view
.subckt sg13cmos5l_tiehi L_HI VDD VSS
.ends

* Black-box entry subcircuit for sg13cmos5l_mux4_1 abstract view
.subckt sg13cmos5l_mux4_1 X A0 A1 A2 A3 S0 S1 VDD VSS
.ends

* Black-box entry subcircuit for sg13cmos5l_or2_1 abstract view
.subckt sg13cmos5l_or2_1 X A B VDD VSS
.ends

.subckt NPU_CTRL_CFG NPU_ARRAY_EN NPU_COMPUTE_BANK_SWAP NPU_PSUM_LUT_EN NPU_PSUM_SKEW_EN
+ NPU_PSUM_SYSTOLIC_EN NPU_QUANT_SHIFT_EN NPU_QUANT_SHIFT_IN0 NPU_QUANT_SHIFT_IN1
+ NPU_QUANT_SHIFT_IN10 NPU_QUANT_SHIFT_IN11 NPU_QUANT_SHIFT_IN12 NPU_QUANT_SHIFT_IN13
+ NPU_QUANT_SHIFT_IN14 NPU_QUANT_SHIFT_IN15 NPU_QUANT_SHIFT_IN16 NPU_QUANT_SHIFT_IN17
+ NPU_QUANT_SHIFT_IN18 NPU_QUANT_SHIFT_IN19 NPU_QUANT_SHIFT_IN2 NPU_QUANT_SHIFT_IN20
+ NPU_QUANT_SHIFT_IN21 NPU_QUANT_SHIFT_IN22 NPU_QUANT_SHIFT_IN23 NPU_QUANT_SHIFT_IN24
+ NPU_QUANT_SHIFT_IN25 NPU_QUANT_SHIFT_IN26 NPU_QUANT_SHIFT_IN27 NPU_QUANT_SHIFT_IN28
+ NPU_QUANT_SHIFT_IN29 NPU_QUANT_SHIFT_IN3 NPU_QUANT_SHIFT_IN4 NPU_QUANT_SHIFT_IN5
+ NPU_QUANT_SHIFT_IN6 NPU_QUANT_SHIFT_IN7 NPU_QUANT_SHIFT_IN8 NPU_QUANT_SHIFT_IN9
+ NPU_SWAP_WEIGHTS Tile_X0Y0_Ci Tile_X0Y0_FrameData[0] Tile_X0Y0_FrameData[10] Tile_X0Y0_FrameData[11]
+ Tile_X0Y0_FrameData[12] Tile_X0Y0_FrameData[13] Tile_X0Y0_FrameData[14] Tile_X0Y0_FrameData[15]
+ Tile_X0Y0_FrameData[16] Tile_X0Y0_FrameData[17] Tile_X0Y0_FrameData[18] Tile_X0Y0_FrameData[19]
+ Tile_X0Y0_FrameData[1] Tile_X0Y0_FrameData[20] Tile_X0Y0_FrameData[21] Tile_X0Y0_FrameData[22]
+ Tile_X0Y0_FrameData[23] Tile_X0Y0_FrameData[24] Tile_X0Y0_FrameData[25] Tile_X0Y0_FrameData[26]
+ Tile_X0Y0_FrameData[27] Tile_X0Y0_FrameData[28] Tile_X0Y0_FrameData[29] Tile_X0Y0_FrameData[2]
+ Tile_X0Y0_FrameData[30] Tile_X0Y0_FrameData[31] Tile_X0Y0_FrameData[3] Tile_X0Y0_FrameData[4]
+ Tile_X0Y0_FrameData[5] Tile_X0Y0_FrameData[6] Tile_X0Y0_FrameData[7] Tile_X0Y0_FrameData[8]
+ Tile_X0Y0_FrameData[9] Tile_X0Y0_FrameStrobe[0] Tile_X0Y0_FrameStrobe[10] Tile_X0Y0_FrameStrobe[11]
+ Tile_X0Y0_FrameStrobe[12] Tile_X0Y0_FrameStrobe[13] Tile_X0Y0_FrameStrobe[14] Tile_X0Y0_FrameStrobe[15]
+ Tile_X0Y0_FrameStrobe[16] Tile_X0Y0_FrameStrobe[17] Tile_X0Y0_FrameStrobe[18] Tile_X0Y0_FrameStrobe[19]
+ Tile_X0Y0_FrameStrobe[1] Tile_X0Y0_FrameStrobe[2] Tile_X0Y0_FrameStrobe[3] Tile_X0Y0_FrameStrobe[4]
+ Tile_X0Y0_FrameStrobe[5] Tile_X0Y0_FrameStrobe[6] Tile_X0Y0_FrameStrobe[7] Tile_X0Y0_FrameStrobe[8]
+ Tile_X0Y0_FrameStrobe[9] Tile_X0Y0_FrameStrobe_O[0] Tile_X0Y0_FrameStrobe_O[10]
+ Tile_X0Y0_FrameStrobe_O[11] Tile_X0Y0_FrameStrobe_O[12] Tile_X0Y0_FrameStrobe_O[13]
+ Tile_X0Y0_FrameStrobe_O[14] Tile_X0Y0_FrameStrobe_O[15] Tile_X0Y0_FrameStrobe_O[16]
+ Tile_X0Y0_FrameStrobe_O[17] Tile_X0Y0_FrameStrobe_O[18] Tile_X0Y0_FrameStrobe_O[19]
+ Tile_X0Y0_FrameStrobe_O[1] Tile_X0Y0_FrameStrobe_O[2] Tile_X0Y0_FrameStrobe_O[3]
+ Tile_X0Y0_FrameStrobe_O[4] Tile_X0Y0_FrameStrobe_O[5] Tile_X0Y0_FrameStrobe_O[6]
+ Tile_X0Y0_FrameStrobe_O[7] Tile_X0Y0_FrameStrobe_O[8] Tile_X0Y0_FrameStrobe_O[9]
+ Tile_X0Y0_N1END[0] Tile_X0Y0_N1END[1] Tile_X0Y0_N1END[2] Tile_X0Y0_N1END[3] Tile_X0Y0_N2END[0]
+ Tile_X0Y0_N2END[1] Tile_X0Y0_N2END[2] Tile_X0Y0_N2END[3] Tile_X0Y0_N2END[4] Tile_X0Y0_N2END[5]
+ Tile_X0Y0_N2END[6] Tile_X0Y0_N2END[7] Tile_X0Y0_N2MID[0] Tile_X0Y0_N2MID[1] Tile_X0Y0_N2MID[2]
+ Tile_X0Y0_N2MID[3] Tile_X0Y0_N2MID[4] Tile_X0Y0_N2MID[5] Tile_X0Y0_N2MID[6] Tile_X0Y0_N2MID[7]
+ Tile_X0Y0_N4END[0] Tile_X0Y0_N4END[10] Tile_X0Y0_N4END[11] Tile_X0Y0_N4END[12] Tile_X0Y0_N4END[13]
+ Tile_X0Y0_N4END[14] Tile_X0Y0_N4END[15] Tile_X0Y0_N4END[1] Tile_X0Y0_N4END[2] Tile_X0Y0_N4END[3]
+ Tile_X0Y0_N4END[4] Tile_X0Y0_N4END[5] Tile_X0Y0_N4END[6] Tile_X0Y0_N4END[7] Tile_X0Y0_N4END[8]
+ Tile_X0Y0_N4END[9] Tile_X0Y0_NN4END[0] Tile_X0Y0_NN4END[10] Tile_X0Y0_NN4END[11]
+ Tile_X0Y0_NN4END[12] Tile_X0Y0_NN4END[13] Tile_X0Y0_NN4END[14] Tile_X0Y0_NN4END[15]
+ Tile_X0Y0_NN4END[1] Tile_X0Y0_NN4END[2] Tile_X0Y0_NN4END[3] Tile_X0Y0_NN4END[4]
+ Tile_X0Y0_NN4END[5] Tile_X0Y0_NN4END[6] Tile_X0Y0_NN4END[7] Tile_X0Y0_NN4END[8]
+ Tile_X0Y0_NN4END[9] Tile_X0Y0_S1BEG[0] Tile_X0Y0_S1BEG[1] Tile_X0Y0_S1BEG[2] Tile_X0Y0_S1BEG[3]
+ Tile_X0Y0_S2BEG[0] Tile_X0Y0_S2BEG[1] Tile_X0Y0_S2BEG[2] Tile_X0Y0_S2BEG[3] Tile_X0Y0_S2BEG[4]
+ Tile_X0Y0_S2BEG[5] Tile_X0Y0_S2BEG[6] Tile_X0Y0_S2BEG[7] Tile_X0Y0_S2BEGb[0] Tile_X0Y0_S2BEGb[1]
+ Tile_X0Y0_S2BEGb[2] Tile_X0Y0_S2BEGb[3] Tile_X0Y0_S2BEGb[4] Tile_X0Y0_S2BEGb[5]
+ Tile_X0Y0_S2BEGb[6] Tile_X0Y0_S2BEGb[7] Tile_X0Y0_S4BEG[0] Tile_X0Y0_S4BEG[10] Tile_X0Y0_S4BEG[11]
+ Tile_X0Y0_S4BEG[12] Tile_X0Y0_S4BEG[13] Tile_X0Y0_S4BEG[14] Tile_X0Y0_S4BEG[15]
+ Tile_X0Y0_S4BEG[1] Tile_X0Y0_S4BEG[2] Tile_X0Y0_S4BEG[3] Tile_X0Y0_S4BEG[4] Tile_X0Y0_S4BEG[5]
+ Tile_X0Y0_S4BEG[6] Tile_X0Y0_S4BEG[7] Tile_X0Y0_S4BEG[8] Tile_X0Y0_S4BEG[9] Tile_X0Y0_SS4BEG[0]
+ Tile_X0Y0_SS4BEG[10] Tile_X0Y0_SS4BEG[11] Tile_X0Y0_SS4BEG[12] Tile_X0Y0_SS4BEG[13]
+ Tile_X0Y0_SS4BEG[14] Tile_X0Y0_SS4BEG[15] Tile_X0Y0_SS4BEG[1] Tile_X0Y0_SS4BEG[2]
+ Tile_X0Y0_SS4BEG[3] Tile_X0Y0_SS4BEG[4] Tile_X0Y0_SS4BEG[5] Tile_X0Y0_SS4BEG[6]
+ Tile_X0Y0_SS4BEG[7] Tile_X0Y0_SS4BEG[8] Tile_X0Y0_SS4BEG[9] Tile_X0Y0_UserCLK Tile_X1Y0_Ci
+ Tile_X1Y0_FrameData_O[0] Tile_X1Y0_FrameData_O[10] Tile_X1Y0_FrameData_O[11] Tile_X1Y0_FrameData_O[12]
+ Tile_X1Y0_FrameData_O[13] Tile_X1Y0_FrameData_O[14] Tile_X1Y0_FrameData_O[15] Tile_X1Y0_FrameData_O[16]
+ Tile_X1Y0_FrameData_O[17] Tile_X1Y0_FrameData_O[18] Tile_X1Y0_FrameData_O[19] Tile_X1Y0_FrameData_O[1]
+ Tile_X1Y0_FrameData_O[20] Tile_X1Y0_FrameData_O[21] Tile_X1Y0_FrameData_O[22] Tile_X1Y0_FrameData_O[23]
+ Tile_X1Y0_FrameData_O[24] Tile_X1Y0_FrameData_O[25] Tile_X1Y0_FrameData_O[26] Tile_X1Y0_FrameData_O[27]
+ Tile_X1Y0_FrameData_O[28] Tile_X1Y0_FrameData_O[29] Tile_X1Y0_FrameData_O[2] Tile_X1Y0_FrameData_O[30]
+ Tile_X1Y0_FrameData_O[31] Tile_X1Y0_FrameData_O[3] Tile_X1Y0_FrameData_O[4] Tile_X1Y0_FrameData_O[5]
+ Tile_X1Y0_FrameData_O[6] Tile_X1Y0_FrameData_O[7] Tile_X1Y0_FrameData_O[8] Tile_X1Y0_FrameData_O[9]
+ Tile_X1Y0_FrameStrobe[0] Tile_X1Y0_FrameStrobe[10] Tile_X1Y0_FrameStrobe[11] Tile_X1Y0_FrameStrobe[12]
+ Tile_X1Y0_FrameStrobe[13] Tile_X1Y0_FrameStrobe[14] Tile_X1Y0_FrameStrobe[15] Tile_X1Y0_FrameStrobe[16]
+ Tile_X1Y0_FrameStrobe[17] Tile_X1Y0_FrameStrobe[18] Tile_X1Y0_FrameStrobe[19] Tile_X1Y0_FrameStrobe[1]
+ Tile_X1Y0_FrameStrobe[2] Tile_X1Y0_FrameStrobe[3] Tile_X1Y0_FrameStrobe[4] Tile_X1Y0_FrameStrobe[5]
+ Tile_X1Y0_FrameStrobe[6] Tile_X1Y0_FrameStrobe[7] Tile_X1Y0_FrameStrobe[8] Tile_X1Y0_FrameStrobe[9]
+ Tile_X1Y0_FrameStrobe_O[0] Tile_X1Y0_FrameStrobe_O[10] Tile_X1Y0_FrameStrobe_O[11]
+ Tile_X1Y0_FrameStrobe_O[12] Tile_X1Y0_FrameStrobe_O[13] Tile_X1Y0_FrameStrobe_O[14]
+ Tile_X1Y0_FrameStrobe_O[15] Tile_X1Y0_FrameStrobe_O[16] Tile_X1Y0_FrameStrobe_O[17]
+ Tile_X1Y0_FrameStrobe_O[18] Tile_X1Y0_FrameStrobe_O[19] Tile_X1Y0_FrameStrobe_O[1]
+ Tile_X1Y0_FrameStrobe_O[2] Tile_X1Y0_FrameStrobe_O[3] Tile_X1Y0_FrameStrobe_O[4]
+ Tile_X1Y0_FrameStrobe_O[5] Tile_X1Y0_FrameStrobe_O[6] Tile_X1Y0_FrameStrobe_O[7]
+ Tile_X1Y0_FrameStrobe_O[8] Tile_X1Y0_FrameStrobe_O[9] Tile_X1Y0_N1END[0] Tile_X1Y0_N1END[1]
+ Tile_X1Y0_N1END[2] Tile_X1Y0_N1END[3] Tile_X1Y0_N2END[0] Tile_X1Y0_N2END[1] Tile_X1Y0_N2END[2]
+ Tile_X1Y0_N2END[3] Tile_X1Y0_N2END[4] Tile_X1Y0_N2END[5] Tile_X1Y0_N2END[6] Tile_X1Y0_N2END[7]
+ Tile_X1Y0_N2MID[0] Tile_X1Y0_N2MID[1] Tile_X1Y0_N2MID[2] Tile_X1Y0_N2MID[3] Tile_X1Y0_N2MID[4]
+ Tile_X1Y0_N2MID[5] Tile_X1Y0_N2MID[6] Tile_X1Y0_N2MID[7] Tile_X1Y0_N4END[0] Tile_X1Y0_N4END[10]
+ Tile_X1Y0_N4END[11] Tile_X1Y0_N4END[12] Tile_X1Y0_N4END[13] Tile_X1Y0_N4END[14]
+ Tile_X1Y0_N4END[15] Tile_X1Y0_N4END[1] Tile_X1Y0_N4END[2] Tile_X1Y0_N4END[3] Tile_X1Y0_N4END[4]
+ Tile_X1Y0_N4END[5] Tile_X1Y0_N4END[6] Tile_X1Y0_N4END[7] Tile_X1Y0_N4END[8] Tile_X1Y0_N4END[9]
+ Tile_X1Y0_NN4END[0] Tile_X1Y0_NN4END[10] Tile_X1Y0_NN4END[11] Tile_X1Y0_NN4END[12]
+ Tile_X1Y0_NN4END[13] Tile_X1Y0_NN4END[14] Tile_X1Y0_NN4END[15] Tile_X1Y0_NN4END[1]
+ Tile_X1Y0_NN4END[2] Tile_X1Y0_NN4END[3] Tile_X1Y0_NN4END[4] Tile_X1Y0_NN4END[5]
+ Tile_X1Y0_NN4END[6] Tile_X1Y0_NN4END[7] Tile_X1Y0_NN4END[8] Tile_X1Y0_NN4END[9]
+ Tile_X1Y0_S1BEG[0] Tile_X1Y0_S1BEG[1] Tile_X1Y0_S1BEG[2] Tile_X1Y0_S1BEG[3] Tile_X1Y0_S2BEG[0]
+ Tile_X1Y0_S2BEG[1] Tile_X1Y0_S2BEG[2] Tile_X1Y0_S2BEG[3] Tile_X1Y0_S2BEG[4] Tile_X1Y0_S2BEG[5]
+ Tile_X1Y0_S2BEG[6] Tile_X1Y0_S2BEG[7] Tile_X1Y0_S2BEGb[0] Tile_X1Y0_S2BEGb[1] Tile_X1Y0_S2BEGb[2]
+ Tile_X1Y0_S2BEGb[3] Tile_X1Y0_S2BEGb[4] Tile_X1Y0_S2BEGb[5] Tile_X1Y0_S2BEGb[6]
+ Tile_X1Y0_S2BEGb[7] Tile_X1Y0_S4BEG[0] Tile_X1Y0_S4BEG[10] Tile_X1Y0_S4BEG[11] Tile_X1Y0_S4BEG[12]
+ Tile_X1Y0_S4BEG[13] Tile_X1Y0_S4BEG[14] Tile_X1Y0_S4BEG[15] Tile_X1Y0_S4BEG[1] Tile_X1Y0_S4BEG[2]
+ Tile_X1Y0_S4BEG[3] Tile_X1Y0_S4BEG[4] Tile_X1Y0_S4BEG[5] Tile_X1Y0_S4BEG[6] Tile_X1Y0_S4BEG[7]
+ Tile_X1Y0_S4BEG[8] Tile_X1Y0_S4BEG[9] Tile_X1Y0_SS4BEG[0] Tile_X1Y0_SS4BEG[10] Tile_X1Y0_SS4BEG[11]
+ Tile_X1Y0_SS4BEG[12] Tile_X1Y0_SS4BEG[13] Tile_X1Y0_SS4BEG[14] Tile_X1Y0_SS4BEG[15]
+ Tile_X1Y0_SS4BEG[1] Tile_X1Y0_SS4BEG[2] Tile_X1Y0_SS4BEG[3] Tile_X1Y0_SS4BEG[4]
+ Tile_X1Y0_SS4BEG[5] Tile_X1Y0_SS4BEG[6] Tile_X1Y0_SS4BEG[7] Tile_X1Y0_SS4BEG[8]
+ Tile_X1Y0_SS4BEG[9] Tile_X1Y0_UserCLKo VGND VPWR
XANTENNA__308__X Tile_X1Y0_FrameData_O[4] VPWR VGND sg13cmos5l_antennanp
XFILLER_11_829 VPWR VGND sg13cmos5l_decap_8
XFILLER_7_7 VPWR VGND sg13cmos5l_decap_8
XFILLER_2_505 VPWR VGND sg13cmos5l_decap_8
XANTENNA_202 Tile_X0Y0_FrameData[28] VPWR VGND sg13cmos5l_antennanp
XANTENNA_213 Tile_X0Y0_FrameData[31] VPWR VGND sg13cmos5l_antennanp
XANTENNA_224 Tile_X0Y0_FrameData[31] VPWR VGND sg13cmos5l_antennanp
XANTENNA_235 Tile_X0Y0_FrameData[9] VPWR VGND sg13cmos5l_antennanp
XANTENNA_246 Tile_X0Y0_NN4END[6] VPWR VGND sg13cmos5l_antennanp
XANTENNA_257 Tile_X0Y0_FrameData[30] VPWR VGND sg13cmos5l_antennanp
XANTENNA__218__X Tile_X1Y0_S2BEG[7] VPWR VGND sg13cmos5l_antennanp
XFILLER_13_133 VPWR VGND sg13cmos5l_decap_8
XFILLER_14_623 VPWR VGND sg13cmos5l_decap_8
X_294_ Tile_X0Y0_SS4BEG[10] Tile_X0Y0_NN4END[5] VPWR VGND sg13cmos5l_buf_1
X_363_ Tile_X1Y0_FrameStrobe_O[7] Tile_X1Y0_FrameStrobe[7] VPWR VGND sg13cmos5l_buf_1
XFILLER_9_126 VPWR VGND sg13cmos5l_decap_8
XFILLER_3_56 VPWR VGND sg13cmos5l_decap_8
XFILLER_1_560 VPWR VGND sg13cmos5l_fill_2
XFILLER_18_940 VPWR VGND sg13cmos5l_decap_8
XFILLER_17_483 VPWR VGND sg13cmos5l_decap_8
XFILLER_9_682 VPWR VGND sg13cmos5l_decap_8
XFILLER_10_114 VPWR VGND sg13cmos5l_decap_8
XFILLER_12_21 VPWR VGND sg13cmos5l_decap_8
XFILLER_7_619 VPWR VGND sg13cmos5l_decap_8
XFILLER_12_98 VPWR VGND sg13cmos5l_decap_8
XFILLER_18_247 VPWR VGND sg13cmos5l_decap_4
XFILLER_18_203 VPWR VGND sg13cmos5l_fill_1
XFILLER_14_420 VPWR VGND sg13cmos5l_decap_8
XFILLER_14_497 VPWR VGND sg13cmos5l_decap_8
XFILLER_15_910 VPWR VGND sg13cmos5l_decap_8
X_346_ Tile_X0Y0_FrameStrobe_O[10] Tile_X0Y0_FrameStrobe[10] VPWR VGND sg13cmos5l_buf_1
X_277_ Tile_X0Y0_S4BEG[9] Tile_X0Y0_N4END[6] VPWR VGND sg13cmos5l_buf_1
XFILLER_5_140 VPWR VGND sg13cmos5l_decap_8
XFILLER_17_280 VPWR VGND sg13cmos5l_decap_8
XFILLER_18_792 VPWR VGND sg13cmos5l_decap_8
XANTENNA__321__X Tile_X1Y0_FrameData_O[17] VPWR VGND sg13cmos5l_antennanp
XFILLER_16_707 VPWR VGND sg13cmos5l_decap_8
XFILLER_12_924 VPWR VGND sg13cmos5l_fill_2
XFILLER_15_217 VPWR VGND sg13cmos5l_decap_8
X_200_ Tile_X0Y0_S2BEG[1] Tile_X0Y0_N2MID[6] VPWR VGND sg13cmos5l_buf_1
XFILLER_11_467 VPWR VGND sg13cmos5l_decap_8
X_062_ _062_/Q Tile_X0Y0_FrameData[8] VGND VPWR Tile_X0Y0_FrameStrobe[0] latch
X_131_ NPU_QUANT_SHIFT_IN16 Tile_X0Y0_UserCLK _381_/X _153_/L_HI VPWR VGND sg13cmos5l_dfrbpq_1
XANTENNA__231__X Tile_X1Y0_S4BEG[4] VPWR VGND sg13cmos5l_antennanp
XFILLER_3_677 VPWR VGND sg13cmos5l_decap_8
XFILLER_3_655 VPWR VGND sg13cmos5l_decap_4
XFILLER_2_176 VPWR VGND sg13cmos5l_decap_8
XFILLER_14_294 VPWR VGND sg13cmos5l_decap_8
XFILLER_15_784 VPWR VGND sg13cmos5l_decap_8
X_329_ Tile_X1Y0_FrameData_O[25] Tile_X0Y0_FrameData[25] VPWR VGND sg13cmos5l_buf_1
XFILLER_9_77 VPWR VGND sg13cmos5l_decap_8
XANTENNA__316__X Tile_X1Y0_FrameData_O[12] VPWR VGND sg13cmos5l_antennanp
XFILLER_0_603 VPWR VGND sg13cmos5l_fill_1
XFILLER_16_504 VPWR VGND sg13cmos5l_decap_8
XFILLER_18_42 VPWR VGND sg13cmos5l_decap_8
XANTENNA__226__X Tile_X1Y0_S2BEGb[7] VPWR VGND sg13cmos5l_antennanp
XFILLER_11_231 VPWR VGND sg13cmos5l_decap_8
XFILLER_12_721 VPWR VGND sg13cmos5l_decap_8
XFILLER_12_798 VPWR VGND sg13cmos5l_decap_8
X_045_ _045_/Q Tile_X0Y0_FrameData[25] VGND VPWR Tile_X0Y0_FrameStrobe[0] latch
X_114_ _114_/Q Tile_X0Y0_FrameData[25] VGND VPWR Tile_X1Y0_FrameStrobe[1] latch
XFILLER_7_224 VPWR VGND sg13cmos5l_decap_8
XFILLER_15_581 VPWR VGND sg13cmos5l_decap_8
XFILLER_7_780 VPWR VGND sg13cmos5l_decap_4
XFILLER_13_518 VPWR VGND sg13cmos5l_decap_8
XFILLER_0_455 VPWR VGND sg13cmos5l_fill_1
XFILLER_0_488 VPWR VGND sg13cmos5l_decap_8
XFILLER_1_923 VPWR VGND sg13cmos5l_decap_8
XFILLER_16_301 VPWR VGND sg13cmos5l_decap_8
XFILLER_16_378 VPWR VGND sg13cmos5l_decap_8
XFILLER_17_868 VPWR VGND sg13cmos5l_decap_8
XFILLER_12_595 VPWR VGND sg13cmos5l_decap_8
XFILLER_8_511 VPWR VGND sg13cmos5l_decap_8
XANTENNA_5 Tile_X0Y0_FrameData[0] VPWR VGND sg13cmos5l_antennanp
XFILLER_6_56 VPWR VGND sg13cmos5l_decap_8
XFILLER_4_761 VPWR VGND sg13cmos5l_decap_8
XFILLER_3_260 VPWR VGND sg13cmos5l_decap_8
XFILLER_13_315 VPWR VGND sg13cmos5l_decap_8
XFILLER_14_827 VPWR VGND sg13cmos5l_decap_8
XFILLER_15_21 VPWR VGND sg13cmos5l_decap_8
XFILLER_15_98 VPWR VGND sg13cmos5l_decap_8
XFILLER_5_558 VPWR VGND sg13cmos5l_decap_4
XFILLER_1_720 VPWR VGND sg13cmos5l_decap_8
XFILLER_13_860 VPWR VGND sg13cmos5l_decap_8
XFILLER_16_175 VPWR VGND sg13cmos5l_decap_8
XFILLER_9_820 VPWR VGND sg13cmos5l_fill_2
XFILLER_17_665 VPWR VGND sg13cmos5l_decap_8
XFILLER_12_392 VPWR VGND sg13cmos5l_decap_8
XFILLER_9_886 VPWR VGND sg13cmos5l_decap_8
XFILLER_11_0 VPWR VGND sg13cmos5l_decap_8
XFILLER_10_307 VPWR VGND sg13cmos5l_fill_2
XFILLER_11_819 VPWR VGND sg13cmos5l_fill_2
XANTENNA__324__X Tile_X1Y0_FrameData_O[20] VPWR VGND sg13cmos5l_antennanp
XANTENNA_203 Tile_X0Y0_FrameData[28] VPWR VGND sg13cmos5l_antennanp
XANTENNA_214 Tile_X0Y0_FrameData[31] VPWR VGND sg13cmos5l_antennanp
XANTENNA_225 Tile_X0Y0_FrameData[31] VPWR VGND sg13cmos5l_antennanp
XANTENNA_236 Tile_X0Y0_FrameData[9] VPWR VGND sg13cmos5l_antennanp
XANTENNA_247 Tile_X1Y0_FrameStrobe[8] VPWR VGND sg13cmos5l_antennanp
XANTENNA_258 Tile_X0Y0_FrameData[30] VPWR VGND sg13cmos5l_antennanp
XFILLER_13_112 VPWR VGND sg13cmos5l_decap_8
XFILLER_14_602 VPWR VGND sg13cmos5l_decap_8
XFILLER_14_646 VPWR VGND sg13cmos5l_fill_1
X_362_ Tile_X1Y0_FrameStrobe_O[6] Tile_X1Y0_FrameStrobe[6] VPWR VGND sg13cmos5l_buf_1
XFILLER_9_105 VPWR VGND sg13cmos5l_decap_8
XANTENNA__234__X Tile_X1Y0_S4BEG[7] VPWR VGND sg13cmos5l_antennanp
XFILLER_10_896 VPWR VGND sg13cmos5l_decap_8
XFILLER_13_189 VPWR VGND sg13cmos5l_decap_8
X_293_ Tile_X0Y0_SS4BEG[9] Tile_X0Y0_NN4END[6] VPWR VGND sg13cmos5l_buf_1
XFILLER_6_812 VPWR VGND sg13cmos5l_decap_8
XFILLER_6_889 VPWR VGND sg13cmos5l_decap_8
XFILLER_3_35 VPWR VGND sg13cmos5l_decap_8
XFILLER_17_462 VPWR VGND sg13cmos5l_decap_8
XFILLER_9_661 VPWR VGND sg13cmos5l_decap_8
XFILLER_8_182 VPWR VGND sg13cmos5l_decap_8
XANTENNA__319__X Tile_X1Y0_FrameData_O[15] VPWR VGND sg13cmos5l_antennanp
XFILLER_11_649 VPWR VGND sg13cmos5l_decap_8
XFILLER_12_77 VPWR VGND sg13cmos5l_decap_8
XFILLER_6_119 VPWR VGND sg13cmos5l_decap_8
XFILLER_2_358 VPWR VGND sg13cmos5l_fill_1
XANTENNA__229__X Tile_X1Y0_S4BEG[2] VPWR VGND sg13cmos5l_antennanp
XFILLER_18_259 VPWR VGND sg13cmos5l_decap_8
XFILLER_14_476 VPWR VGND sg13cmos5l_decap_8
X_276_ Tile_X0Y0_S4BEG[8] Tile_X0Y0_N4END[7] VPWR VGND sg13cmos5l_buf_1
X_345_ Tile_X0Y0_FrameStrobe_O[9] Tile_X0Y0_FrameStrobe[9] VPWR VGND sg13cmos5l_buf_1
XFILLER_5_196 VPWR VGND sg13cmos5l_decap_8
XFILLER_2_881 VPWR VGND sg13cmos5l_decap_8
XFILLER_18_771 VPWR VGND sg13cmos5l_decap_8
XFILLER_11_446 VPWR VGND sg13cmos5l_decap_8
XFILLER_12_903 VPWR VGND sg13cmos5l_decap_8
XFILLER_12_958 VPWR VGND sg13cmos5l_fill_2
X_130_ NPU_QUANT_SHIFT_IN15 Tile_X0Y0_UserCLK _380_/X _154_/L_HI VPWR VGND sg13cmos5l_dfrbpq_1
XFILLER_8_929 VPWR VGND sg13cmos5l_decap_8
X_061_ _061_/Q Tile_X0Y0_FrameData[9] VGND VPWR Tile_X0Y0_FrameStrobe[0] latch
XFILLER_7_439 VPWR VGND sg13cmos5l_decap_8
XFILLER_3_634 VPWR VGND sg13cmos5l_decap_8
XFILLER_0_25 VPWR VGND sg13cmos5l_fill_2
XFILLER_0_36 VPWR VGND sg13cmos5l_fill_1
XFILLER_0_47 VPWR VGND sg13cmos5l_fill_2
XFILLER_15_763 VPWR VGND sg13cmos5l_decap_8
XFILLER_14_273 VPWR VGND sg13cmos5l_decap_8
X_259_ Tile_X1Y0_UserCLKo Tile_X0Y0_UserCLK VPWR VGND sg13cmos5l_buf_1
X_328_ Tile_X1Y0_FrameData_O[24] Tile_X0Y0_FrameData[24] VPWR VGND sg13cmos5l_buf_1
XFILLER_9_56 VPWR VGND sg13cmos5l_decap_8
XFILLER_10_490 VPWR VGND sg13cmos5l_decap_8
XANTENNA__332__X Tile_X1Y0_FrameData_O[28] VPWR VGND sg13cmos5l_antennanp
XFILLER_18_65 VPWR VGND sg13cmos5l_decap_8
XFILLER_18_21 VPWR VGND sg13cmos5l_decap_8
XFILLER_11_210 VPWR VGND sg13cmos5l_decap_8
XFILLER_11_287 VPWR VGND sg13cmos5l_decap_8
XFILLER_12_700 VPWR VGND sg13cmos5l_decap_8
XFILLER_12_777 VPWR VGND sg13cmos5l_decap_8
X_113_ _113_/Q Tile_X0Y0_FrameData[31] VGND VPWR Tile_X1Y0_FrameStrobe[0] latch
XFILLER_7_203 VPWR VGND sg13cmos5l_decap_8
XANTENNA__242__X Tile_X1Y0_S4BEG[15] VPWR VGND sg13cmos5l_antennanp
X_044_ _044_/Q Tile_X0Y0_FrameData[26] VGND VPWR Tile_X0Y0_FrameStrobe[0] latch
XFILLER_3_486 VPWR VGND sg13cmos5l_fill_2
XFILLER_15_7 VPWR VGND sg13cmos5l_decap_8
XFILLER_15_560 VPWR VGND sg13cmos5l_decap_8
XFILLER_6_280 VPWR VGND sg13cmos5l_decap_8
XANTENNA__327__X Tile_X1Y0_FrameData_O[23] VPWR VGND sg13cmos5l_antennanp
XFILLER_4_239 VPWR VGND sg13cmos5l_decap_8
XFILLER_1_902 VPWR VGND sg13cmos5l_decap_8
XFILLER_0_467 VPWR VGND sg13cmos5l_decap_8
XANTENNA__237__X Tile_X1Y0_S4BEG[10] VPWR VGND sg13cmos5l_antennanp
XFILLER_16_357 VPWR VGND sg13cmos5l_decap_8
XFILLER_17_847 VPWR VGND sg13cmos5l_decap_8
XANTENNA_6 Tile_X0Y0_FrameData[0] VPWR VGND sg13cmos5l_antennanp
XFILLER_12_574 VPWR VGND sg13cmos5l_decap_8
XFILLER_6_35 VPWR VGND sg13cmos5l_decap_8
XFILLER_1_209 VPWR VGND sg13cmos5l_fill_1
XFILLER_14_806 VPWR VGND sg13cmos5l_decap_8
XFILLER_15_77 VPWR VGND sg13cmos5l_decap_8
XFILLER_5_537 VPWR VGND sg13cmos5l_decap_8
XFILLER_5_515 VPWR VGND sg13cmos5l_decap_8
XFILLER_1_776 VPWR VGND sg13cmos5l_decap_8
XFILLER_1_710 VPWR VGND sg13cmos5l_decap_8
XFILLER_17_644 VPWR VGND sg13cmos5l_decap_8
XFILLER_12_371 VPWR VGND sg13cmos5l_decap_8
XFILLER_16_154 VPWR VGND sg13cmos5l_decap_8
XFILLER_9_854 VPWR VGND sg13cmos5l_decap_4
XFILLER_8_364 VPWR VGND sg13cmos5l_decap_4
XFILLER_10_319 VPWR VGND sg13cmos5l_decap_8
XANTENNA__340__X Tile_X0Y0_FrameStrobe_O[4] VPWR VGND sg13cmos5l_antennanp
XANTENNA_204 Tile_X0Y0_FrameData[31] VPWR VGND sg13cmos5l_antennanp
XANTENNA_215 Tile_X0Y0_FrameData[31] VPWR VGND sg13cmos5l_antennanp
XANTENNA_226 Tile_X0Y0_FrameData[31] VPWR VGND sg13cmos5l_antennanp
XANTENNA_237 Tile_X0Y0_FrameData[9] VPWR VGND sg13cmos5l_antennanp
XANTENNA_248 Tile_X0Y0_FrameData[13] VPWR VGND sg13cmos5l_antennanp
XANTENNA_259 Tile_X1Y0_FrameStrobe[16] VPWR VGND sg13cmos5l_antennanp
XFILLER_13_168 VPWR VGND sg13cmos5l_decap_8
X_292_ Tile_X0Y0_SS4BEG[8] Tile_X0Y0_NN4END[7] VPWR VGND sg13cmos5l_buf_1
X_361_ Tile_X1Y0_FrameStrobe_O[5] Tile_X1Y0_FrameStrobe[5] VPWR VGND sg13cmos5l_buf_1
XFILLER_10_842 VPWR VGND sg13cmos5l_fill_1
XFILLER_10_875 VPWR VGND sg13cmos5l_decap_8
XANTENNA__250__X Tile_X1Y0_SS4BEG[7] VPWR VGND sg13cmos5l_antennanp
XFILLER_3_14 VPWR VGND sg13cmos5l_decap_8
XFILLER_1_584 VPWR VGND sg13cmos5l_decap_8
XFILLER_1_540 VPWR VGND sg13cmos5l_fill_2
XFILLER_17_441 VPWR VGND sg13cmos5l_decap_8
XFILLER_9_640 VPWR VGND sg13cmos5l_decap_8
XFILLER_8_161 VPWR VGND sg13cmos5l_decap_8
XFILLER_5_890 VPWR VGND sg13cmos5l_decap_8
XFILLER_11_628 VPWR VGND sg13cmos5l_decap_8
XANTENNA__335__X Tile_X1Y0_FrameData_O[31] VPWR VGND sg13cmos5l_antennanp
XFILLER_10_149 VPWR VGND sg13cmos5l_decap_8
XFILLER_12_56 VPWR VGND sg13cmos5l_decap_8
XFILLER_3_849 VPWR VGND sg13cmos5l_decap_8
XANTENNA__245__X Tile_X1Y0_SS4BEG[2] VPWR VGND sg13cmos5l_antennanp
XFILLER_10_672 VPWR VGND sg13cmos5l_decap_8
XFILLER_14_455 VPWR VGND sg13cmos5l_decap_8
X_275_ Tile_X0Y0_S4BEG[7] Tile_X0Y0_N4END[8] VPWR VGND sg13cmos5l_buf_1
X_344_ Tile_X0Y0_FrameStrobe_O[8] Tile_X0Y0_FrameStrobe[8] VPWR VGND sg13cmos5l_buf_1
XFILLER_10_683 VPWR VGND sg13cmos5l_fill_1
XFILLER_6_632 VPWR VGND sg13cmos5l_decap_4
XFILLER_5_175 VPWR VGND sg13cmos5l_decap_8
XFILLER_18_750 VPWR VGND sg13cmos5l_decap_8
XFILLER_4_90 VPWR VGND sg13cmos5l_decap_8
XFILLER_11_425 VPWR VGND sg13cmos5l_decap_8
XFILLER_8_908 VPWR VGND sg13cmos5l_decap_8
XFILLER_7_418 VPWR VGND sg13cmos5l_decap_8
X_060_ _060_/Q Tile_X0Y0_FrameData[10] VGND VPWR Tile_X0Y0_FrameStrobe[0] latch
XFILLER_3_668 VPWR VGND sg13cmos5l_fill_2
XFILLER_3_613 VPWR VGND sg13cmos5l_decap_8
XFILLER_14_252 VPWR VGND sg13cmos5l_decap_8
XFILLER_15_742 VPWR VGND sg13cmos5l_decap_8
XFILLER_9_35 VPWR VGND sg13cmos5l_decap_8
X_189_ Tile_X1Y0_FrameStrobe_O[10] Tile_X1Y0_FrameStrobe[10] VPWR VGND sg13cmos5l_buf_1
X_258_ Tile_X1Y0_SS4BEG[15] Tile_X1Y0_NN4END[0] VPWR VGND sg13cmos5l_buf_1
X_327_ Tile_X1Y0_FrameData_O[23] Tile_X0Y0_FrameData[23] VPWR VGND sg13cmos5l_buf_1
XFILLER_7_930 VPWR VGND sg13cmos5l_decap_8
XFILLER_6_484 VPWR VGND sg13cmos5l_decap_8
XFILLER_0_627 VPWR VGND sg13cmos5l_fill_1
XFILLER_16_539 VPWR VGND sg13cmos5l_decap_8
XFILLER_11_266 VPWR VGND sg13cmos5l_decap_8
XFILLER_12_756 VPWR VGND sg13cmos5l_decap_8
X_043_ _043_/Q Tile_X0Y0_FrameData[27] VGND VPWR Tile_X0Y0_FrameStrobe[0] latch
X_112_ _112_/Q Tile_X0Y0_FrameData[26] VGND VPWR Tile_X1Y0_FrameStrobe[1] latch
XFILLER_7_259 VPWR VGND sg13cmos5l_decap_8
XFILLER_1_0 VPWR VGND sg13cmos5l_decap_8
XANTENNA__343__X Tile_X0Y0_FrameStrobe_O[7] VPWR VGND sg13cmos5l_antennanp
XFILLER_4_218 VPWR VGND sg13cmos5l_decap_8
XFILLER_1_958 VPWR VGND sg13cmos5l_fill_2
XFILLER_17_826 VPWR VGND sg13cmos5l_decap_8
XFILLER_12_553 VPWR VGND sg13cmos5l_decap_8
XFILLER_16_336 VPWR VGND sg13cmos5l_decap_8
XANTENNA_7 Tile_X0Y0_FrameData[0] VPWR VGND sg13cmos5l_antennanp
XANTENNA__253__X Tile_X1Y0_SS4BEG[10] VPWR VGND sg13cmos5l_antennanp
XFILLER_8_568 VPWR VGND sg13cmos5l_fill_1
XFILLER_6_14 VPWR VGND sg13cmos5l_decap_8
XANTENNA__338__X Tile_X0Y0_FrameStrobe_O[2] VPWR VGND sg13cmos5l_antennanp
XFILLER_15_56 VPWR VGND sg13cmos5l_decap_8
XFILLER_1_799 VPWR VGND sg13cmos5l_decap_8
XANTENNA__248__X Tile_X1Y0_SS4BEG[5] VPWR VGND sg13cmos5l_antennanp
XFILLER_16_133 VPWR VGND sg13cmos5l_decap_8
XFILLER_17_623 VPWR VGND sg13cmos5l_decap_8
XFILLER_12_350 VPWR VGND sg13cmos5l_decap_8
XFILLER_13_895 VPWR VGND sg13cmos5l_decap_8
XFILLER_9_822 VPWR VGND sg13cmos5l_fill_1
XFILLER_4_582 VPWR VGND sg13cmos5l_decap_4
XFILLER_4_571 VPWR VGND sg13cmos5l_decap_8
XANTENNA_205 Tile_X0Y0_FrameData[31] VPWR VGND sg13cmos5l_antennanp
XANTENNA_216 Tile_X0Y0_FrameData[31] VPWR VGND sg13cmos5l_antennanp
XANTENNA_227 Tile_X0Y0_FrameData[31] VPWR VGND sg13cmos5l_antennanp
XANTENNA_238 Tile_X0Y0_NN4END[6] VPWR VGND sg13cmos5l_antennanp
XANTENNA_249 Tile_X0Y0_FrameData[13] VPWR VGND sg13cmos5l_antennanp
XFILLER_10_854 VPWR VGND sg13cmos5l_decap_8
XFILLER_13_147 VPWR VGND sg13cmos5l_decap_8
XFILLER_14_637 VPWR VGND sg13cmos5l_decap_8
XFILLER_14_659 VPWR VGND sg13cmos5l_decap_8
X_291_ Tile_X0Y0_SS4BEG[7] Tile_X0Y0_NN4END[8] VPWR VGND sg13cmos5l_buf_1
X_360_ Tile_X1Y0_FrameStrobe_O[4] Tile_X1Y0_FrameStrobe[4] VPWR VGND sg13cmos5l_buf_1
XFILLER_6_836 VPWR VGND sg13cmos5l_fill_1
XFILLER_18_954 VPWR VGND sg13cmos5l_decap_4
XFILLER_17_497 VPWR VGND sg13cmos5l_decap_8
XFILLER_17_420 VPWR VGND sg13cmos5l_decap_8
XFILLER_13_692 VPWR VGND sg13cmos5l_decap_8
XFILLER_8_140 VPWR VGND sg13cmos5l_decap_8
XFILLER_10_128 VPWR VGND sg13cmos5l_decap_8
XFILLER_11_607 VPWR VGND sg13cmos5l_decap_8
XANTENNA__351__X Tile_X0Y0_FrameStrobe_O[15] VPWR VGND sg13cmos5l_antennanp
XFILLER_12_35 VPWR VGND sg13cmos5l_decap_8
XFILLER_5_7 VPWR VGND sg13cmos5l_decap_8
XFILLER_14_434 VPWR VGND sg13cmos5l_decap_8
XFILLER_15_924 VPWR VGND sg13cmos5l_decap_8
XFILLER_18_228 VPWR VGND sg13cmos5l_fill_2
XFILLER_18_217 VPWR VGND sg13cmos5l_decap_8
XFILLER_10_651 VPWR VGND sg13cmos5l_decap_8
X_274_ Tile_X0Y0_S4BEG[6] Tile_X0Y0_N4END[9] VPWR VGND sg13cmos5l_buf_1
X_343_ Tile_X0Y0_FrameStrobe_O[7] Tile_X0Y0_FrameStrobe[7] VPWR VGND sg13cmos5l_buf_1
XFILLER_6_611 VPWR VGND sg13cmos5l_decap_8
XANTENNA__261__X Tile_X0Y0_S2BEGb[1] VPWR VGND sg13cmos5l_antennanp
XFILLER_5_154 VPWR VGND sg13cmos5l_decap_8
XFILLER_17_294 VPWR VGND sg13cmos5l_decap_8
XFILLER_9_482 VPWR VGND sg13cmos5l_decap_8
XANTENNA__120__Q NPU_QUANT_SHIFT_IN5 VPWR VGND sg13cmos5l_antennanp
XANTENNA__346__X Tile_X0Y0_FrameStrobe_O[10] VPWR VGND sg13cmos5l_antennanp
XFILLER_11_404 VPWR VGND sg13cmos5l_decap_8
XFILLER_0_27 VPWR VGND sg13cmos5l_fill_1
XANTENNA__256__X Tile_X1Y0_SS4BEG[13] VPWR VGND sg13cmos5l_antennanp
XFILLER_14_231 VPWR VGND sg13cmos5l_decap_8
XFILLER_15_721 VPWR VGND sg13cmos5l_decap_8
XFILLER_15_798 VPWR VGND sg13cmos5l_decap_8
X_326_ Tile_X1Y0_FrameData_O[22] Tile_X0Y0_FrameData[22] VPWR VGND sg13cmos5l_buf_1
XFILLER_9_14 VPWR VGND sg13cmos5l_decap_8
X_188_ Tile_X1Y0_FrameStrobe_O[9] Tile_X1Y0_FrameStrobe[9] VPWR VGND sg13cmos5l_buf_1
X_257_ Tile_X1Y0_SS4BEG[14] Tile_X1Y0_NN4END[1] VPWR VGND sg13cmos5l_buf_1
XFILLER_6_463 VPWR VGND sg13cmos5l_decap_8
XFILLER_1_190 VPWR VGND sg13cmos5l_decap_8
XFILLER_18_581 VPWR VGND sg13cmos5l_fill_1
XANTENNA__115__Q NPU_QUANT_SHIFT_IN0 VPWR VGND sg13cmos5l_antennanp
XFILLER_18_56 VPWR VGND sg13cmos5l_decap_4
XFILLER_12_735 VPWR VGND sg13cmos5l_decap_8
XFILLER_16_518 VPWR VGND sg13cmos5l_decap_8
XFILLER_18_89 VPWR VGND sg13cmos5l_decap_8
XFILLER_11_245 VPWR VGND sg13cmos5l_decap_8
X_042_ _042_/Q Tile_X0Y0_FrameData[28] VGND VPWR Tile_X0Y0_FrameStrobe[0] latch
X_111_ _111_/Q Tile_X0Y0_FrameData[27] VGND VPWR Tile_X1Y0_FrameStrobe[1] latch
XFILLER_7_238 VPWR VGND sg13cmos5l_decap_8
XFILLER_4_901 VPWR VGND sg13cmos5l_decap_8
XFILLER_3_488 VPWR VGND sg13cmos5l_fill_1
XFILLER_15_595 VPWR VGND sg13cmos5l_decap_8
X_309_ Tile_X1Y0_FrameData_O[5] Tile_X0Y0_FrameData[5] VPWR VGND sg13cmos5l_buf_1
XFILLER_1_937 VPWR VGND sg13cmos5l_decap_8
XFILLER_16_315 VPWR VGND sg13cmos5l_decap_8
XFILLER_17_805 VPWR VGND sg13cmos5l_decap_8
XFILLER_12_532 VPWR VGND sg13cmos5l_decap_8
XFILLER_8_525 VPWR VGND sg13cmos5l_decap_8
XANTENNA_8 Tile_X0Y0_FrameData[0] VPWR VGND sg13cmos5l_antennanp
XFILLER_8_547 VPWR VGND sg13cmos5l_decap_8
XFILLER_4_786 VPWR VGND sg13cmos5l_decap_8
XFILLER_16_882 VPWR VGND sg13cmos5l_decap_8
XFILLER_15_392 VPWR VGND sg13cmos5l_decap_8
XFILLER_7_591 VPWR VGND sg13cmos5l_decap_8
XANTENNA__354__X Tile_X0Y0_FrameStrobe_O[18] VPWR VGND sg13cmos5l_antennanp
XFILLER_13_329 VPWR VGND sg13cmos5l_decap_8
XFILLER_15_35 VPWR VGND sg13cmos5l_decap_8
XFILLER_0_233 VPWR VGND sg13cmos5l_decap_8
XFILLER_0_244 VPWR VGND sg13cmos5l_fill_2
XFILLER_16_112 VPWR VGND sg13cmos5l_decap_8
XFILLER_16_189 VPWR VGND sg13cmos5l_decap_8
XFILLER_17_679 VPWR VGND sg13cmos5l_decap_8
XFILLER_17_602 VPWR VGND sg13cmos5l_decap_8
XANTENNA__264__X Tile_X0Y0_S2BEGb[4] VPWR VGND sg13cmos5l_antennanp
XFILLER_13_874 VPWR VGND sg13cmos5l_decap_8
XFILLER_9_867 VPWR VGND sg13cmos5l_fill_2
XFILLER_8_399 VPWR VGND sg13cmos5l_decap_8
XANTENNA__123__Q NPU_QUANT_SHIFT_IN8 VPWR VGND sg13cmos5l_antennanp
XFILLER_7_91 VPWR VGND sg13cmos5l_decap_8
XANTENNA_206 Tile_X0Y0_FrameData[31] VPWR VGND sg13cmos5l_antennanp
XANTENNA_217 Tile_X0Y0_FrameData[31] VPWR VGND sg13cmos5l_antennanp
XANTENNA_228 Tile_X0Y0_FrameData[31] VPWR VGND sg13cmos5l_antennanp
XANTENNA_239 Tile_X0Y0_NN4END[6] VPWR VGND sg13cmos5l_antennanp
XANTENNA__349__X Tile_X0Y0_FrameStrobe_O[13] VPWR VGND sg13cmos5l_antennanp
XFILLER_14_616 VPWR VGND sg13cmos5l_decap_8
XFILLER_13_126 VPWR VGND sg13cmos5l_decap_8
X_290_ Tile_X0Y0_SS4BEG[6] Tile_X0Y0_NN4END[9] VPWR VGND sg13cmos5l_buf_1
XFILLER_9_119 VPWR VGND sg13cmos5l_decap_8
XANTENNA__259__X Tile_X1Y0_UserCLKo VPWR VGND sg13cmos5l_antennanp
XFILLER_3_49 VPWR VGND sg13cmos5l_decap_8
XFILLER_1_575 VPWR VGND sg13cmos5l_decap_4
XFILLER_18_933 VPWR VGND sg13cmos5l_decap_4
XFILLER_13_671 VPWR VGND sg13cmos5l_decap_8
XFILLER_17_476 VPWR VGND sg13cmos5l_decap_8
XFILLER_9_675 VPWR VGND sg13cmos5l_fill_2
XFILLER_8_196 VPWR VGND sg13cmos5l_decap_8
XANTENNA__118__Q NPU_QUANT_SHIFT_IN3 VPWR VGND sg13cmos5l_antennanp
XFILLER_10_107 VPWR VGND sg13cmos5l_decap_8
XFILLER_12_14 VPWR VGND sg13cmos5l_decap_8
XFILLER_2_317 VPWR VGND sg13cmos5l_fill_1
XFILLER_14_413 VPWR VGND sg13cmos5l_decap_8
XFILLER_15_903 VPWR VGND sg13cmos5l_decap_8
XFILLER_15_958 VPWR VGND sg13cmos5l_fill_2
X_342_ Tile_X0Y0_FrameStrobe_O[6] Tile_X0Y0_FrameStrobe[6] VPWR VGND sg13cmos5l_buf_1
XFILLER_10_630 VPWR VGND sg13cmos5l_decap_8
X_273_ Tile_X0Y0_S4BEG[5] Tile_X0Y0_N4END[10] VPWR VGND sg13cmos5l_buf_1
XFILLER_5_133 VPWR VGND sg13cmos5l_decap_8
XFILLER_2_895 VPWR VGND sg13cmos5l_decap_8
XFILLER_17_273 VPWR VGND sg13cmos5l_decap_8
XFILLER_18_785 VPWR VGND sg13cmos5l_decap_8
XFILLER_13_490 VPWR VGND sg13cmos5l_decap_8
XFILLER_9_461 VPWR VGND sg13cmos5l_decap_8
XFILLER_12_917 VPWR VGND sg13cmos5l_decap_8
XANTENNA__362__X Tile_X1Y0_FrameStrobe_O[6] VPWR VGND sg13cmos5l_antennanp
XFILLER_3_659 VPWR VGND sg13cmos5l_fill_1
XFILLER_3_648 VPWR VGND sg13cmos5l_decap_4
XFILLER_2_169 VPWR VGND sg13cmos5l_decap_8
XFILLER_2_158 VPWR VGND sg13cmos5l_decap_4
XFILLER_15_700 VPWR VGND sg13cmos5l_decap_8
XFILLER_14_210 VPWR VGND sg13cmos5l_decap_8
XFILLER_14_287 VPWR VGND sg13cmos5l_decap_8
XFILLER_15_777 VPWR VGND sg13cmos5l_decap_8
X_325_ Tile_X1Y0_FrameData_O[21] Tile_X0Y0_FrameData[21] VPWR VGND sg13cmos5l_buf_1
XANTENNA__272__X Tile_X0Y0_S4BEG[4] VPWR VGND sg13cmos5l_antennanp
X_187_ _187_/L_HI VPWR VGND sg13cmos5l_tiehi
X_256_ Tile_X1Y0_SS4BEG[13] Tile_X1Y0_NN4END[2] VPWR VGND sg13cmos5l_buf_1
XFILLER_7_954 VPWR VGND sg13cmos5l_decap_4
XFILLER_2_692 VPWR VGND sg13cmos5l_decap_8
XFILLER_18_593 VPWR VGND sg13cmos5l_fill_2
XFILLER_9_280 VPWR VGND sg13cmos5l_decap_8
XANTENNA__131__Q NPU_QUANT_SHIFT_IN16 VPWR VGND sg13cmos5l_antennanp
XFILLER_0_618 VPWR VGND sg13cmos5l_fill_2
XANTENNA__357__X Tile_X1Y0_FrameStrobe_O[1] VPWR VGND sg13cmos5l_antennanp
XFILLER_18_79 VPWR VGND sg13cmos5l_decap_8
XFILLER_18_35 VPWR VGND sg13cmos5l_decap_8
XFILLER_11_224 VPWR VGND sg13cmos5l_decap_8
XFILLER_12_714 VPWR VGND sg13cmos5l_decap_8
X_110_ _110_/Q Tile_X0Y0_FrameData[28] VGND VPWR Tile_X1Y0_FrameStrobe[1] latch
X_041_ _041_/Q Tile_X0Y0_FrameData[29] VGND VPWR Tile_X0Y0_FrameStrobe[0] latch
XFILLER_7_217 VPWR VGND sg13cmos5l_decap_8
XANTENNA__267__X Tile_X0Y0_S2BEGb[7] VPWR VGND sg13cmos5l_antennanp
XFILLER_11_791 VPWR VGND sg13cmos5l_decap_8
XFILLER_15_574 VPWR VGND sg13cmos5l_decap_8
X_239_ Tile_X1Y0_S4BEG[12] Tile_X1Y0_N4END[3] VPWR VGND sg13cmos5l_buf_1
X_308_ Tile_X1Y0_FrameData_O[4] Tile_X0Y0_FrameData[4] VPWR VGND sg13cmos5l_buf_1
XFILLER_6_294 VPWR VGND sg13cmos5l_decap_8
XANTENNA__126__Q NPU_QUANT_SHIFT_IN11 VPWR VGND sg13cmos5l_antennanp
XFILLER_0_448 VPWR VGND sg13cmos5l_fill_1
XFILLER_1_916 VPWR VGND sg13cmos5l_decap_8
XFILLER_12_511 VPWR VGND sg13cmos5l_decap_8
XFILLER_12_588 VPWR VGND sg13cmos5l_decap_8
XFILLER_8_504 VPWR VGND sg13cmos5l_decap_8
XANTENNA_9 Tile_X0Y0_FrameData[0] VPWR VGND sg13cmos5l_antennanp
XFILLER_6_49 VPWR VGND sg13cmos5l_decap_8
XFILLER_3_253 VPWR VGND sg13cmos5l_decap_8
XFILLER_13_7 VPWR VGND sg13cmos5l_decap_8
XFILLER_15_371 VPWR VGND sg13cmos5l_decap_8
XFILLER_16_861 VPWR VGND sg13cmos5l_decap_8
XFILLER_7_570 VPWR VGND sg13cmos5l_decap_8
XFILLER_15_14 VPWR VGND sg13cmos5l_decap_8
XFILLER_13_308 VPWR VGND sg13cmos5l_decap_8
XFILLER_0_212 VPWR VGND sg13cmos5l_decap_8
XFILLER_5_529 VPWR VGND sg13cmos5l_fill_1
XFILLER_0_223 VPWR VGND sg13cmos5l_fill_2
XFILLER_13_853 VPWR VGND sg13cmos5l_decap_8
XFILLER_16_168 VPWR VGND sg13cmos5l_decap_8
XFILLER_17_658 VPWR VGND sg13cmos5l_decap_8
XFILLER_12_385 VPWR VGND sg13cmos5l_decap_8
XFILLER_9_879 VPWR VGND sg13cmos5l_decap_8
XFILLER_9_813 VPWR VGND sg13cmos5l_decap_8
XANTENNA__280__X Tile_X0Y0_S4BEG[12] VPWR VGND sg13cmos5l_antennanp
XANTENNA__190__X Tile_X1Y0_FrameStrobe_O[11] VPWR VGND sg13cmos5l_antennanp
XFILLER_7_70 VPWR VGND sg13cmos5l_decap_8
XANTENNA_207 Tile_X0Y0_FrameData[31] VPWR VGND sg13cmos5l_antennanp
XANTENNA_218 Tile_X0Y0_FrameData[31] VPWR VGND sg13cmos5l_antennanp
XANTENNA_229 Tile_X0Y0_FrameData[9] VPWR VGND sg13cmos5l_antennanp
XFILLER_13_105 VPWR VGND sg13cmos5l_decap_8
XFILLER_10_801 VPWR VGND sg13cmos5l_fill_1
XFILLER_10_889 VPWR VGND sg13cmos5l_decap_8
XFILLER_6_805 VPWR VGND sg13cmos5l_decap_8
XFILLER_3_28 VPWR VGND sg13cmos5l_decap_8
XFILLER_1_521 VPWR VGND sg13cmos5l_fill_1
XFILLER_1_510 VPWR VGND sg13cmos5l_decap_8
XFILLER_18_912 VPWR VGND sg13cmos5l_decap_8
XFILLER_17_455 VPWR VGND sg13cmos5l_decap_8
XANTENNA__275__X Tile_X0Y0_S4BEG[7] VPWR VGND sg13cmos5l_antennanp
XFILLER_13_650 VPWR VGND sg13cmos5l_decap_8
XFILLER_12_182 VPWR VGND sg13cmos5l_decap_8
XFILLER_9_654 VPWR VGND sg13cmos5l_decap_8
XFILLER_8_175 VPWR VGND sg13cmos5l_decap_8
XANTENNA__134__Q NPU_QUANT_SHIFT_IN19 VPWR VGND sg13cmos5l_antennanp
XFILLER_14_469 VPWR VGND sg13cmos5l_decap_8
X_272_ Tile_X0Y0_S4BEG[4] Tile_X0Y0_N4END[11] VPWR VGND sg13cmos5l_buf_1
X_341_ Tile_X0Y0_FrameStrobe_O[5] Tile_X0Y0_FrameStrobe[5] VPWR VGND sg13cmos5l_buf_1
XFILLER_5_189 VPWR VGND sg13cmos5l_decap_8
XFILLER_5_112 VPWR VGND sg13cmos5l_decap_8
XFILLER_2_874 VPWR VGND sg13cmos5l_decap_8
XFILLER_2_863 VPWR VGND sg13cmos5l_fill_1
XFILLER_17_252 VPWR VGND sg13cmos5l_decap_8
XFILLER_18_764 VPWR VGND sg13cmos5l_decap_8
XFILLER_9_440 VPWR VGND sg13cmos5l_decap_8
XFILLER_5_690 VPWR VGND sg13cmos5l_fill_2
XANTENNA__129__Q NPU_QUANT_SHIFT_IN14 VPWR VGND sg13cmos5l_antennanp
XFILLER_11_439 VPWR VGND sg13cmos5l_decap_8
XFILLER_3_627 VPWR VGND sg13cmos5l_decap_8
XANTENNA__039__Q NPU_PSUM_SKEW_EN VPWR VGND sg13cmos5l_antennanp
XFILLER_0_18 VPWR VGND sg13cmos5l_decap_4
XFILLER_14_266 VPWR VGND sg13cmos5l_decap_8
XFILLER_15_756 VPWR VGND sg13cmos5l_decap_8
X_255_ Tile_X1Y0_SS4BEG[12] Tile_X1Y0_NN4END[3] VPWR VGND sg13cmos5l_buf_1
X_324_ Tile_X1Y0_FrameData_O[20] Tile_X0Y0_FrameData[20] VPWR VGND sg13cmos5l_buf_1
XFILLER_9_49 VPWR VGND sg13cmos5l_decap_8
XFILLER_10_483 VPWR VGND sg13cmos5l_decap_8
XFILLER_13_91 VPWR VGND sg13cmos5l_decap_8
X_186_ _186_/L_HI VPWR VGND sg13cmos5l_tiehi
XFILLER_6_498 VPWR VGND sg13cmos5l_decap_8
XFILLER_0_608 VPWR VGND sg13cmos5l_fill_2
XFILLER_18_14 VPWR VGND sg13cmos5l_decap_8
XFILLER_11_203 VPWR VGND sg13cmos5l_decap_8
X_040_ _040_/Q Tile_X0Y0_FrameData[30] VGND VPWR Tile_X0Y0_FrameStrobe[0] latch
XFILLER_4_958 VPWR VGND sg13cmos5l_fill_2
XFILLER_3_479 VPWR VGND sg13cmos5l_decap_8
XFILLER_15_553 VPWR VGND sg13cmos5l_decap_8
XANTENNA__283__X Tile_X0Y0_S4BEG[15] VPWR VGND sg13cmos5l_antennanp
X_169_ _169_/L_HI VPWR VGND sg13cmos5l_tiehi
X_238_ Tile_X1Y0_S4BEG[11] Tile_X1Y0_N4END[4] VPWR VGND sg13cmos5l_buf_1
X_307_ Tile_X1Y0_FrameData_O[3] Tile_X0Y0_FrameData[3] VPWR VGND sg13cmos5l_buf_1
XFILLER_6_273 VPWR VGND sg13cmos5l_decap_8
XANTENNA__193__X Tile_X1Y0_FrameStrobe_O[14] VPWR VGND sg13cmos5l_antennanp
XFILLER_18_391 VPWR VGND sg13cmos5l_decap_8
XANTENNA__142__Q NPU_QUANT_SHIFT_IN27 VPWR VGND sg13cmos5l_antennanp
XFILLER_12_567 VPWR VGND sg13cmos5l_decap_8
XFILLER_6_28 VPWR VGND sg13cmos5l_decap_8
XFILLER_3_221 VPWR VGND sg13cmos5l_fill_1
XANTENNA__278__X Tile_X0Y0_S4BEG[10] VPWR VGND sg13cmos5l_antennanp
XFILLER_15_350 VPWR VGND sg13cmos5l_decap_8
XFILLER_16_840 VPWR VGND sg13cmos5l_decap_8
XANTENNA__188__X Tile_X1Y0_FrameStrobe_O[9] VPWR VGND sg13cmos5l_antennanp
XANTENNA__137__Q NPU_QUANT_SHIFT_IN22 VPWR VGND sg13cmos5l_antennanp
XFILLER_5_508 VPWR VGND sg13cmos5l_decap_8
XFILLER_1_769 VPWR VGND sg13cmos5l_decap_8
XFILLER_1_703 VPWR VGND sg13cmos5l_decap_8
XFILLER_17_637 VPWR VGND sg13cmos5l_decap_8
XFILLER_13_832 VPWR VGND sg13cmos5l_decap_8
XFILLER_16_147 VPWR VGND sg13cmos5l_decap_8
XFILLER_12_364 VPWR VGND sg13cmos5l_decap_8
XFILLER_9_858 VPWR VGND sg13cmos5l_fill_2
XFILLER_4_596 VPWR VGND sg13cmos5l_decap_4
XFILLER_8_880 VPWR VGND sg13cmos5l_decap_8
XANTENNA_208 Tile_X0Y0_FrameData[31] VPWR VGND sg13cmos5l_antennanp
XANTENNA_219 Tile_X0Y0_FrameData[31] VPWR VGND sg13cmos5l_antennanp
XFILLER_10_846 VPWR VGND sg13cmos5l_decap_4
XFILLER_10_868 VPWR VGND sg13cmos5l_decap_8
XFILLER_1_533 VPWR VGND sg13cmos5l_decap_8
XFILLER_17_434 VPWR VGND sg13cmos5l_decap_8
XANTENNA__291__X Tile_X0Y0_SS4BEG[7] VPWR VGND sg13cmos5l_antennanp
XFILLER_12_161 VPWR VGND sg13cmos5l_decap_8
XFILLER_16_91 VPWR VGND sg13cmos5l_decap_8
XFILLER_9_677 VPWR VGND sg13cmos5l_fill_1
XFILLER_9_633 VPWR VGND sg13cmos5l_decap_8
XFILLER_8_154 VPWR VGND sg13cmos5l_decap_8
XFILLER_12_49 VPWR VGND sg13cmos5l_decap_8
XANTENNA__150__Q NPU_QUANT_SHIFT_EN VPWR VGND sg13cmos5l_antennanp
XFILLER_14_448 VPWR VGND sg13cmos5l_decap_8
X_271_ Tile_X0Y0_S4BEG[3] Tile_X0Y0_N4END[12] VPWR VGND sg13cmos5l_buf_1
X_340_ Tile_X0Y0_FrameStrobe_O[4] Tile_X0Y0_FrameStrobe[4] VPWR VGND sg13cmos5l_buf_1
XFILLER_10_665 VPWR VGND sg13cmos5l_decap_8
XFILLER_6_636 VPWR VGND sg13cmos5l_fill_1
XFILLER_6_625 VPWR VGND sg13cmos5l_decap_8
XFILLER_5_168 VPWR VGND sg13cmos5l_decap_8
XANTENNA__286__X Tile_X0Y0_SS4BEG[2] VPWR VGND sg13cmos5l_antennanp
XFILLER_17_231 VPWR VGND sg13cmos5l_decap_8
XFILLER_18_743 VPWR VGND sg13cmos5l_decap_8
XFILLER_4_83 VPWR VGND sg13cmos5l_decap_8
XANTENNA__196__X Tile_X1Y0_FrameStrobe_O[17] VPWR VGND sg13cmos5l_antennanp
XANTENNA__145__Q NPU_COMPUTE_BANK_SWAP VPWR VGND sg13cmos5l_antennanp
XFILLER_11_418 VPWR VGND sg13cmos5l_decap_8
XFILLER_3_7 VPWR VGND sg13cmos5l_decap_8
XFILLER_3_606 VPWR VGND sg13cmos5l_decap_8
XFILLER_14_245 VPWR VGND sg13cmos5l_decap_8
XFILLER_15_735 VPWR VGND sg13cmos5l_decap_8
XFILLER_10_462 VPWR VGND sg13cmos5l_decap_8
XFILLER_13_70 VPWR VGND sg13cmos5l_decap_8
X_185_ _185_/L_HI VPWR VGND sg13cmos5l_tiehi
X_254_ Tile_X1Y0_SS4BEG[11] Tile_X1Y0_NN4END[4] VPWR VGND sg13cmos5l_buf_1
X_323_ Tile_X1Y0_FrameData_O[19] Tile_X0Y0_FrameData[19] VPWR VGND sg13cmos5l_buf_1
XFILLER_9_28 VPWR VGND sg13cmos5l_decap_8
XFILLER_7_923 VPWR VGND sg13cmos5l_decap_8
XFILLER_6_477 VPWR VGND sg13cmos5l_decap_8
XFILLER_18_562 VPWR VGND sg13cmos5l_decap_4
XFILLER_18_595 VPWR VGND sg13cmos5l_fill_1
XFILLER_18_573 VPWR VGND sg13cmos5l_fill_1
XFILLER_11_259 VPWR VGND sg13cmos5l_decap_8
XFILLER_12_749 VPWR VGND sg13cmos5l_decap_8
XFILLER_4_915 VPWR VGND sg13cmos5l_decap_4
XFILLER_15_532 VPWR VGND sg13cmos5l_decap_8
X_306_ Tile_X1Y0_FrameData_O[2] Tile_X0Y0_FrameData[2] VPWR VGND sg13cmos5l_buf_1
X_168_ _168_/L_HI VPWR VGND sg13cmos5l_tiehi
X_237_ Tile_X1Y0_S4BEG[10] Tile_X1Y0_N4END[5] VPWR VGND sg13cmos5l_buf_1
XFILLER_6_252 VPWR VGND sg13cmos5l_decap_8
X_099_ _099_/Q Tile_X0Y0_FrameData[7] VGND VPWR Tile_X1Y0_FrameStrobe[0] latch
XFILLER_2_491 VPWR VGND sg13cmos5l_decap_8
XFILLER_1_73 VPWR VGND sg13cmos5l_fill_2
XFILLER_0_406 VPWR VGND sg13cmos5l_fill_2
XFILLER_17_819 VPWR VGND sg13cmos5l_decap_8
XFILLER_12_546 VPWR VGND sg13cmos5l_decap_8
XFILLER_16_329 VPWR VGND sg13cmos5l_decap_8
XFILLER_8_539 VPWR VGND sg13cmos5l_decap_4
XFILLER_0_951 VPWR VGND sg13cmos5l_decap_8
XFILLER_10_93 VPWR VGND sg13cmos5l_decap_8
XANTENNA__294__X Tile_X0Y0_SS4BEG[10] VPWR VGND sg13cmos5l_antennanp
XFILLER_16_896 VPWR VGND sg13cmos5l_decap_8
XFILLER_7_561 VPWR VGND sg13cmos5l_decap_4
XFILLER_15_49 VPWR VGND sg13cmos5l_decap_8
XFILLER_1_748 VPWR VGND sg13cmos5l_decap_4
XFILLER_16_126 VPWR VGND sg13cmos5l_decap_8
XFILLER_17_616 VPWR VGND sg13cmos5l_decap_8
XFILLER_12_343 VPWR VGND sg13cmos5l_decap_8
XFILLER_13_811 VPWR VGND sg13cmos5l_decap_8
XFILLER_13_888 VPWR VGND sg13cmos5l_decap_8
XFILLER_4_564 VPWR VGND sg13cmos5l_decap_8
XANTENNA__289__X Tile_X0Y0_SS4BEG[5] VPWR VGND sg13cmos5l_antennanp
XFILLER_16_693 VPWR VGND sg13cmos5l_decap_8
XANTENNA__199__X Tile_X0Y0_S2BEG[0] VPWR VGND sg13cmos5l_antennanp
XANTENNA_209 Tile_X0Y0_FrameData[31] VPWR VGND sg13cmos5l_antennanp
XANTENNA__148__Q NPU_PSUM_SYSTOLIC_EN VPWR VGND sg13cmos5l_antennanp
XFILLER_16_70 VPWR VGND sg13cmos5l_decap_8
XFILLER_18_958 VPWR VGND sg13cmos5l_fill_2
XFILLER_18_947 VPWR VGND sg13cmos5l_decap_8
XFILLER_17_413 VPWR VGND sg13cmos5l_decap_8
XFILLER_12_140 VPWR VGND sg13cmos5l_decap_8
XFILLER_13_685 VPWR VGND sg13cmos5l_decap_8
XFILLER_9_689 VPWR VGND sg13cmos5l_fill_2
XFILLER_9_612 VPWR VGND sg13cmos5l_decap_8
XFILLER_8_133 VPWR VGND sg13cmos5l_decap_8
XFILLER_4_361 VPWR VGND sg13cmos5l_fill_2
XFILLER_16_490 VPWR VGND sg13cmos5l_decap_8
XFILLER_12_28 VPWR VGND sg13cmos5l_decap_8
XFILLER_14_427 VPWR VGND sg13cmos5l_decap_8
XFILLER_15_917 VPWR VGND sg13cmos5l_decap_8
XFILLER_10_644 VPWR VGND sg13cmos5l_decap_8
X_270_ Tile_X0Y0_S4BEG[2] Tile_X0Y0_N4END[13] VPWR VGND sg13cmos5l_buf_1
XFILLER_6_604 VPWR VGND sg13cmos5l_decap_8
XFILLER_5_147 VPWR VGND sg13cmos5l_decap_8
XFILLER_2_821 VPWR VGND sg13cmos5l_fill_2
XFILLER_17_210 VPWR VGND sg13cmos5l_decap_8
XFILLER_18_711 VPWR VGND sg13cmos5l_decap_8
XFILLER_17_287 VPWR VGND sg13cmos5l_decap_8
XFILLER_18_799 VPWR VGND sg13cmos5l_decap_8
X_399_ _399_/X Tile_X0Y0_N1END[2] Tile_X0Y0_N2MID[2] Tile_X0Y0_N2MID[5] Tile_X0Y0_N2END[5]
+ _040_/Q _075_/Q VPWR VGND sg13cmos5l_mux4_1
XFILLER_9_475 VPWR VGND sg13cmos5l_decap_8
XFILLER_4_62 VPWR VGND sg13cmos5l_decap_8
XFILLER_14_224 VPWR VGND sg13cmos5l_decap_8
XFILLER_15_714 VPWR VGND sg13cmos5l_decap_8
X_322_ Tile_X1Y0_FrameData_O[18] Tile_X0Y0_FrameData[18] VPWR VGND sg13cmos5l_buf_1
XFILLER_10_441 VPWR VGND sg13cmos5l_decap_8
X_184_ _184_/L_HI VPWR VGND sg13cmos5l_tiehi
X_253_ Tile_X1Y0_SS4BEG[10] Tile_X1Y0_NN4END[5] VPWR VGND sg13cmos5l_buf_1
XFILLER_7_946 VPWR VGND sg13cmos5l_fill_2
XFILLER_7_902 VPWR VGND sg13cmos5l_decap_8
XFILLER_6_456 VPWR VGND sg13cmos5l_decap_8
XFILLER_2_662 VPWR VGND sg13cmos5l_fill_1
XFILLER_1_183 VPWR VGND sg13cmos5l_decap_8
XFILLER_1_172 VPWR VGND sg13cmos5l_fill_2
XANTENNA__297__X Tile_X0Y0_SS4BEG[13] VPWR VGND sg13cmos5l_antennanp
XFILLER_18_585 VPWR VGND sg13cmos5l_decap_4
XFILLER_18_541 VPWR VGND sg13cmos5l_fill_1
XFILLER_9_294 VPWR VGND sg13cmos5l_decap_8
XFILLER_18_49 VPWR VGND sg13cmos5l_decap_8
XFILLER_12_728 VPWR VGND sg13cmos5l_decap_8
XFILLER_11_238 VPWR VGND sg13cmos5l_decap_8
XFILLER_15_511 VPWR VGND sg13cmos5l_decap_8
XFILLER_11_750 VPWR VGND sg13cmos5l_decap_8
XFILLER_15_588 VPWR VGND sg13cmos5l_decap_8
X_305_ Tile_X1Y0_FrameData_O[1] Tile_X0Y0_FrameData[1] VPWR VGND sg13cmos5l_buf_1
XFILLER_10_282 VPWR VGND sg13cmos5l_decap_8
XFILLER_11_772 VPWR VGND sg13cmos5l_decap_8
X_098_ _098_/Q Tile_X0Y0_FrameData[8] VGND VPWR Tile_X1Y0_FrameStrobe[0] latch
X_167_ _167_/L_HI VPWR VGND sg13cmos5l_tiehi
X_236_ Tile_X1Y0_S4BEG[9] Tile_X1Y0_N4END[6] VPWR VGND sg13cmos5l_buf_1
XFILLER_7_732 VPWR VGND sg13cmos5l_decap_8
XFILLER_6_231 VPWR VGND sg13cmos5l_decap_8
XFILLER_2_470 VPWR VGND sg13cmos5l_decap_8
XFILLER_18_360 VPWR VGND sg13cmos5l_decap_8
XFILLER_16_308 VPWR VGND sg13cmos5l_decap_8
XFILLER_12_525 VPWR VGND sg13cmos5l_decap_8
XFILLER_8_518 VPWR VGND sg13cmos5l_decap_8
XFILLER_4_768 VPWR VGND sg13cmos5l_decap_8
XFILLER_3_212 VPWR VGND sg13cmos5l_decap_8
XFILLER_0_941 VPWR VGND sg13cmos5l_fill_1
XFILLER_10_72 VPWR VGND sg13cmos5l_decap_8
XFILLER_4_779 VPWR VGND sg13cmos5l_decap_8
XFILLER_3_267 VPWR VGND sg13cmos5l_fill_1
XFILLER_16_875 VPWR VGND sg13cmos5l_decap_8
XFILLER_15_385 VPWR VGND sg13cmos5l_decap_8
X_219_ Tile_X1Y0_S2BEGb[0] Tile_X1Y0_N2END[7] VPWR VGND sg13cmos5l_buf_1
XFILLER_7_584 VPWR VGND sg13cmos5l_decap_8
XFILLER_18_0 VPWR VGND sg13cmos5l_decap_8
XFILLER_15_28 VPWR VGND sg13cmos5l_decap_8
XFILLER_1_727 VPWR VGND sg13cmos5l_decap_8
XFILLER_16_105 VPWR VGND sg13cmos5l_decap_8
XFILLER_12_322 VPWR VGND sg13cmos5l_decap_8
XFILLER_12_399 VPWR VGND sg13cmos5l_decap_8
XFILLER_13_867 VPWR VGND sg13cmos5l_decap_8
XFILLER_8_326 VPWR VGND sg13cmos5l_fill_2
XFILLER_4_521 VPWR VGND sg13cmos5l_decap_8
XFILLER_0_782 VPWR VGND sg13cmos5l_decap_8
XFILLER_11_7 VPWR VGND sg13cmos5l_decap_8
XFILLER_15_182 VPWR VGND sg13cmos5l_decap_8
XFILLER_16_672 VPWR VGND sg13cmos5l_decap_8
XFILLER_7_84 VPWR VGND sg13cmos5l_decap_8
XFILLER_7_392 VPWR VGND sg13cmos5l_fill_2
XFILLER_14_609 VPWR VGND sg13cmos5l_decap_8
XFILLER_13_119 VPWR VGND sg13cmos5l_decap_8
XFILLER_6_819 VPWR VGND sg13cmos5l_fill_1
XFILLER_1_502 VPWR VGND sg13cmos5l_fill_1
XFILLER_1_579 VPWR VGND sg13cmos5l_fill_1
XFILLER_18_926 VPWR VGND sg13cmos5l_decap_8
XFILLER_17_469 VPWR VGND sg13cmos5l_decap_8
XFILLER_12_196 VPWR VGND sg13cmos5l_decap_8
XFILLER_13_664 VPWR VGND sg13cmos5l_decap_8
XFILLER_9_668 VPWR VGND sg13cmos5l_decap_8
XFILLER_8_189 VPWR VGND sg13cmos5l_decap_8
XFILLER_8_112 VPWR VGND sg13cmos5l_decap_8
XFILLER_5_841 VPWR VGND sg13cmos5l_fill_1
XFILLER_14_406 VPWR VGND sg13cmos5l_decap_8
XFILLER_10_623 VPWR VGND sg13cmos5l_decap_8
XFILLER_5_126 VPWR VGND sg13cmos5l_decap_8
XFILLER_2_888 VPWR VGND sg13cmos5l_decap_8
XFILLER_18_778 VPWR VGND sg13cmos5l_decap_8
XFILLER_13_483 VPWR VGND sg13cmos5l_decap_8
XFILLER_17_266 VPWR VGND sg13cmos5l_decap_8
X_398_ _398_/X Tile_X1Y0_N1END[0] Tile_X1Y0_N2MID[0] Tile_X1Y0_N2MID[7] Tile_X1Y0_N2END[7]
+ _082_/Q _081_/Q VPWR VGND sg13cmos5l_mux4_1
XFILLER_9_454 VPWR VGND sg13cmos5l_decap_8
XFILLER_4_41 VPWR VGND sg13cmos5l_decap_8
XFILLER_10_420 VPWR VGND sg13cmos5l_decap_8
XFILLER_14_203 VPWR VGND sg13cmos5l_decap_8
X_252_ Tile_X1Y0_SS4BEG[9] Tile_X1Y0_NN4END[6] VPWR VGND sg13cmos5l_buf_1
X_321_ Tile_X1Y0_FrameData_O[17] Tile_X0Y0_FrameData[17] VPWR VGND sg13cmos5l_buf_1
XFILLER_10_497 VPWR VGND sg13cmos5l_decap_8
X_183_ _183_/L_HI VPWR VGND sg13cmos5l_tiehi
XFILLER_7_958 VPWR VGND sg13cmos5l_fill_2
XFILLER_2_685 VPWR VGND sg13cmos5l_decap_8
XFILLER_2_630 VPWR VGND sg13cmos5l_fill_2
XFILLER_1_140 VPWR VGND sg13cmos5l_decap_8
XFILLER_13_280 VPWR VGND sg13cmos5l_decap_8
XFILLER_14_792 VPWR VGND sg13cmos5l_decap_8
XFILLER_9_273 VPWR VGND sg13cmos5l_decap_8
XFILLER_18_28 VPWR VGND sg13cmos5l_decap_8
XFILLER_11_217 VPWR VGND sg13cmos5l_decap_8
XFILLER_12_707 VPWR VGND sg13cmos5l_decap_8
XFILLER_10_261 VPWR VGND sg13cmos5l_decap_8
XFILLER_15_567 VPWR VGND sg13cmos5l_decap_8
X_235_ Tile_X1Y0_S4BEG[8] Tile_X1Y0_N4END[7] VPWR VGND sg13cmos5l_buf_1
X_304_ Tile_X1Y0_FrameData_O[0] Tile_X0Y0_FrameData[0] VPWR VGND sg13cmos5l_buf_1
XFILLER_7_711 VPWR VGND sg13cmos5l_decap_8
XFILLER_6_210 VPWR VGND sg13cmos5l_decap_8
X_097_ _097_/Q Tile_X0Y0_FrameData[9] VGND VPWR Tile_X1Y0_FrameStrobe[0] latch
X_166_ _166_/L_HI VPWR VGND sg13cmos5l_tiehi
XFILLER_6_287 VPWR VGND sg13cmos5l_decap_8
XFILLER_1_53 VPWR VGND sg13cmos5l_fill_1
XFILLER_1_42 VPWR VGND sg13cmos5l_decap_8
XANTENNA_190 Tile_X0Y0_FrameData[28] VPWR VGND sg13cmos5l_antennanp
XFILLER_1_909 VPWR VGND sg13cmos5l_decap_8
XFILLER_12_504 VPWR VGND sg13cmos5l_decap_8
XFILLER_10_51 VPWR VGND sg13cmos5l_decap_8
XFILLER_15_364 VPWR VGND sg13cmos5l_decap_8
XFILLER_16_854 VPWR VGND sg13cmos5l_decap_8
X_149_ NPU_ARRAY_EN Tile_X0Y0_UserCLK _400_/X _164_/L_HI VPWR VGND sg13cmos5l_dfrbpq_1
X_218_ Tile_X1Y0_S2BEG[7] Tile_X1Y0_N2MID[0] VPWR VGND sg13cmos5l_buf_1
XFILLER_7_530 VPWR VGND sg13cmos5l_decap_8
XFILLER_3_780 VPWR VGND sg13cmos5l_decap_8
XFILLER_0_205 VPWR VGND sg13cmos5l_decap_8
XFILLER_12_301 VPWR VGND sg13cmos5l_decap_8
XANTENNA_90 Tile_X0Y0_FrameData[2] VPWR VGND sg13cmos5l_antennanp
XFILLER_12_378 VPWR VGND sg13cmos5l_decap_8
XFILLER_13_846 VPWR VGND sg13cmos5l_decap_8
XFILLER_8_316 VPWR VGND sg13cmos5l_fill_2
XFILLER_4_500 VPWR VGND sg13cmos5l_decap_8
XFILLER_0_761 VPWR VGND sg13cmos5l_decap_8
XFILLER_15_161 VPWR VGND sg13cmos5l_decap_8
XFILLER_16_651 VPWR VGND sg13cmos5l_decap_8
XFILLER_8_894 VPWR VGND sg13cmos5l_decap_8
XFILLER_7_63 VPWR VGND sg13cmos5l_decap_8
XFILLER_7_371 VPWR VGND sg13cmos5l_decap_8
XFILLER_10_805 VPWR VGND sg13cmos5l_decap_4
XFILLER_18_905 VPWR VGND sg13cmos5l_decap_8
XFILLER_13_643 VPWR VGND sg13cmos5l_decap_4
XFILLER_17_448 VPWR VGND sg13cmos5l_decap_8
XFILLER_12_175 VPWR VGND sg13cmos5l_decap_8
XFILLER_9_647 VPWR VGND sg13cmos5l_decap_8
XFILLER_8_168 VPWR VGND sg13cmos5l_decap_8
XFILLER_5_897 VPWR VGND sg13cmos5l_decap_8
XFILLER_10_602 VPWR VGND sg13cmos5l_decap_8
XFILLER_10_679 VPWR VGND sg13cmos5l_decap_4
XFILLER_5_105 VPWR VGND sg13cmos5l_decap_8
XFILLER_2_867 VPWR VGND sg13cmos5l_decap_8
XFILLER_2_856 VPWR VGND sg13cmos5l_decap_8
XFILLER_2_823 VPWR VGND sg13cmos5l_fill_1
XFILLER_1_388 VPWR VGND sg13cmos5l_fill_1
XFILLER_17_245 VPWR VGND sg13cmos5l_decap_8
XFILLER_18_757 VPWR VGND sg13cmos5l_decap_8
XFILLER_13_462 VPWR VGND sg13cmos5l_decap_8
X_397_ _397_/X Tile_X1Y0_N1END[1] Tile_X1Y0_N2MID[1] Tile_X1Y0_N2MID[6] Tile_X1Y0_N2END[6]
+ _080_/Q _079_/Q VPWR VGND sg13cmos5l_mux4_1
XFILLER_9_433 VPWR VGND sg13cmos5l_decap_8
XFILLER_5_683 VPWR VGND sg13cmos5l_decap_8
XFILLER_4_171 VPWR VGND sg13cmos5l_fill_2
XFILLER_4_160 VPWR VGND sg13cmos5l_decap_8
XFILLER_4_97 VPWR VGND sg13cmos5l_decap_8
XFILLER_11_911 VPWR VGND sg13cmos5l_decap_8
XFILLER_14_259 VPWR VGND sg13cmos5l_decap_8
XFILLER_15_749 VPWR VGND sg13cmos5l_decap_8
X_182_ _182_/L_HI VPWR VGND sg13cmos5l_tiehi
X_251_ Tile_X1Y0_SS4BEG[8] Tile_X1Y0_NN4END[7] VPWR VGND sg13cmos5l_buf_1
X_320_ Tile_X1Y0_FrameData_O[16] Tile_X0Y0_FrameData[16] VPWR VGND sg13cmos5l_buf_1
XFILLER_10_476 VPWR VGND sg13cmos5l_decap_8
XFILLER_13_84 VPWR VGND sg13cmos5l_decap_8
XFILLER_8_0 VPWR VGND sg13cmos5l_decap_8
XFILLER_7_937 VPWR VGND sg13cmos5l_fill_1
XFILLER_2_642 VPWR VGND sg13cmos5l_decap_8
XFILLER_2_653 VPWR VGND sg13cmos5l_fill_2
XFILLER_1_174 VPWR VGND sg13cmos5l_fill_1
XFILLER_18_554 VPWR VGND sg13cmos5l_decap_4
XFILLER_18_532 VPWR VGND sg13cmos5l_fill_2
XFILLER_18_521 VPWR VGND sg13cmos5l_decap_4
XFILLER_14_771 VPWR VGND sg13cmos5l_decap_8
XFILLER_9_252 VPWR VGND sg13cmos5l_decap_8
XFILLER_5_480 VPWR VGND sg13cmos5l_decap_8
XFILLER_1_7 VPWR VGND sg13cmos5l_decap_8
XFILLER_15_546 VPWR VGND sg13cmos5l_decap_8
XFILLER_10_240 VPWR VGND sg13cmos5l_decap_8
X_165_ _165_/L_HI VPWR VGND sg13cmos5l_tiehi
X_234_ Tile_X1Y0_S4BEG[7] Tile_X1Y0_N4END[8] VPWR VGND sg13cmos5l_buf_1
X_303_ Tile_X0Y0_S1BEG[3] Tile_X0Y0_N1END[0] VPWR VGND sg13cmos5l_buf_1
X_096_ _096_/Q Tile_X0Y0_FrameData[10] VGND VPWR Tile_X1Y0_FrameStrobe[0] latch
XFILLER_6_266 VPWR VGND sg13cmos5l_decap_8
XFILLER_1_21 VPWR VGND sg13cmos5l_decap_8
XFILLER_18_340 VPWR VGND sg13cmos5l_decap_8
XANTENNA_180 Tile_X0Y0_FrameData[28] VPWR VGND sg13cmos5l_antennanp
XANTENNA_191 Tile_X0Y0_FrameData[28] VPWR VGND sg13cmos5l_antennanp
XFILLER_18_384 VPWR VGND sg13cmos5l_decap_8
XFILLER_0_932 VPWR VGND sg13cmos5l_decap_8
XFILLER_10_30 VPWR VGND sg13cmos5l_decap_8
XANTENNA__202__X Tile_X0Y0_S2BEG[3] VPWR VGND sg13cmos5l_antennanp
XFILLER_15_343 VPWR VGND sg13cmos5l_decap_8
XFILLER_16_833 VPWR VGND sg13cmos5l_decap_8
XFILLER_11_593 VPWR VGND sg13cmos5l_decap_8
X_148_ NPU_PSUM_SYSTOLIC_EN Tile_X0Y0_UserCLK _399_/X _168_/L_HI VPWR VGND sg13cmos5l_dfrbpq_1
X_217_ Tile_X1Y0_S2BEG[6] Tile_X1Y0_N2MID[1] VPWR VGND sg13cmos5l_buf_1
X_079_ _079_/Q Tile_X0Y0_FrameData[27] VGND VPWR Tile_X1Y0_FrameStrobe[0] latch
XFILLER_3_770 VPWR VGND sg13cmos5l_decap_8
XFILLER_18_192 VPWR VGND sg13cmos5l_decap_8
XFILLER_13_825 VPWR VGND sg13cmos5l_decap_8
XANTENNA_80 Tile_X0Y0_FrameData[23] VPWR VGND sg13cmos5l_antennanp
XANTENNA_91 Tile_X0Y0_FrameData[2] VPWR VGND sg13cmos5l_antennanp
XFILLER_12_357 VPWR VGND sg13cmos5l_decap_8
XFILLER_8_328 VPWR VGND sg13cmos5l_fill_1
XFILLER_0_740 VPWR VGND sg13cmos5l_decap_8
XFILLER_4_589 VPWR VGND sg13cmos5l_decap_8
XFILLER_16_630 VPWR VGND sg13cmos5l_decap_8
XFILLER_15_140 VPWR VGND sg13cmos5l_decap_8
XFILLER_11_390 VPWR VGND sg13cmos5l_decap_8
XFILLER_8_862 VPWR VGND sg13cmos5l_decap_8
XFILLER_7_42 VPWR VGND sg13cmos5l_decap_8
XFILLER_1_526 VPWR VGND sg13cmos5l_decap_8
XFILLER_17_427 VPWR VGND sg13cmos5l_decap_8
XFILLER_12_154 VPWR VGND sg13cmos5l_decap_8
XFILLER_13_622 VPWR VGND sg13cmos5l_decap_8
XFILLER_13_699 VPWR VGND sg13cmos5l_decap_8
XFILLER_16_84 VPWR VGND sg13cmos5l_decap_8
XFILLER_9_626 VPWR VGND sg13cmos5l_decap_8
XFILLER_8_147 VPWR VGND sg13cmos5l_decap_8
XANTENNA__300__X Tile_X0Y0_S1BEG[0] VPWR VGND sg13cmos5l_antennanp
XFILLER_10_658 VPWR VGND sg13cmos5l_decap_8
XFILLER_6_618 VPWR VGND sg13cmos5l_decap_8
XANTENNA__210__X Tile_X1Y0_S1BEG[3] VPWR VGND sg13cmos5l_antennanp
XFILLER_17_224 VPWR VGND sg13cmos5l_decap_8
XFILLER_18_736 VPWR VGND sg13cmos5l_decap_8
XFILLER_18_725 VPWR VGND sg13cmos5l_fill_1
XFILLER_13_441 VPWR VGND sg13cmos5l_decap_8
X_396_ _396_/X Tile_X1Y0_N1END[2] Tile_X1Y0_N2MID[2] Tile_X1Y0_N2MID[5] Tile_X1Y0_N2END[5]
+ _078_/Q _077_/Q VPWR VGND sg13cmos5l_mux4_1
XFILLER_9_489 VPWR VGND sg13cmos5l_decap_8
XFILLER_9_412 VPWR VGND sg13cmos5l_decap_8
XFILLER_9_401 VPWR VGND sg13cmos5l_fill_1
XFILLER_5_662 VPWR VGND sg13cmos5l_decap_8
XFILLER_5_651 VPWR VGND sg13cmos5l_fill_1
XFILLER_5_640 VPWR VGND sg13cmos5l_decap_8
XFILLER_4_76 VPWR VGND sg13cmos5l_decap_8
XFILLER_4_21 VPWR VGND sg13cmos5l_decap_8
XFILLER_1_890 VPWR VGND sg13cmos5l_fill_1
XFILLER_17_791 VPWR VGND sg13cmos5l_decap_8
XFILLER_14_238 VPWR VGND sg13cmos5l_decap_8
XFILLER_15_728 VPWR VGND sg13cmos5l_decap_8
XFILLER_10_455 VPWR VGND sg13cmos5l_decap_8
XFILLER_13_63 VPWR VGND sg13cmos5l_decap_8
X_181_ _181_/L_HI VPWR VGND sg13cmos5l_tiehi
X_250_ Tile_X1Y0_SS4BEG[7] Tile_X1Y0_NN4END[8] VPWR VGND sg13cmos5l_buf_1
XFILLER_7_916 VPWR VGND sg13cmos5l_decap_8
XANTENNA__205__X Tile_X0Y0_S2BEG[6] VPWR VGND sg13cmos5l_antennanp
XFILLER_14_750 VPWR VGND sg13cmos5l_decap_8
XFILLER_18_577 VPWR VGND sg13cmos5l_decap_4
X_379_ _379_/X Tile_X0Y0_N4END[14] Tile_X0Y0_N4END[15] Tile_X0Y0_NN4END[12] Tile_X0Y0_NN4END[14]
+ _046_/Q _045_/Q VPWR VGND sg13cmos5l_mux4_1
XFILLER_9_231 VPWR VGND sg13cmos5l_decap_8
XFILLER_4_908 VPWR VGND sg13cmos5l_decap_8
XFILLER_15_525 VPWR VGND sg13cmos5l_decap_8
X_302_ Tile_X0Y0_S1BEG[2] Tile_X0Y0_N1END[1] VPWR VGND sg13cmos5l_buf_1
XFILLER_10_296 VPWR VGND sg13cmos5l_decap_8
XFILLER_11_764 VPWR VGND sg13cmos5l_decap_4
XFILLER_11_786 VPWR VGND sg13cmos5l_fill_1
X_095_ _095_/Q Tile_X0Y0_FrameData[11] VGND VPWR Tile_X1Y0_FrameStrobe[0] latch
X_164_ _164_/L_HI VPWR VGND sg13cmos5l_tiehi
X_233_ Tile_X1Y0_S4BEG[6] Tile_X1Y0_N4END[9] VPWR VGND sg13cmos5l_buf_1
XFILLER_7_746 VPWR VGND sg13cmos5l_fill_2
XFILLER_6_245 VPWR VGND sg13cmos5l_decap_8
XFILLER_2_484 VPWR VGND sg13cmos5l_decap_8
XFILLER_1_66 VPWR VGND sg13cmos5l_decap_8
XANTENNA_170 Tile_X0Y0_FrameData[25] VPWR VGND sg13cmos5l_antennanp
XANTENNA_181 Tile_X0Y0_FrameData[28] VPWR VGND sg13cmos5l_antennanp
XANTENNA_192 Tile_X0Y0_FrameData[28] VPWR VGND sg13cmos5l_antennanp
XFILLER_12_539 VPWR VGND sg13cmos5l_decap_8
XFILLER_0_911 VPWR VGND sg13cmos5l_decap_8
XFILLER_10_86 VPWR VGND sg13cmos5l_decap_8
XFILLER_16_812 VPWR VGND sg13cmos5l_decap_8
XFILLER_15_322 VPWR VGND sg13cmos5l_decap_8
XFILLER_15_399 VPWR VGND sg13cmos5l_decap_8
XFILLER_16_889 VPWR VGND sg13cmos5l_decap_8
XFILLER_11_572 VPWR VGND sg13cmos5l_decap_8
X_078_ _078_/Q Tile_X0Y0_FrameData[28] VGND VPWR Tile_X1Y0_FrameStrobe[0] latch
X_147_ NPU_PSUM_LUT_EN Tile_X0Y0_UserCLK _398_/X _169_/L_HI VPWR VGND sg13cmos5l_dfrbpq_1
X_216_ Tile_X1Y0_S2BEG[5] Tile_X1Y0_N2MID[2] VPWR VGND sg13cmos5l_buf_1
XFILLER_7_598 VPWR VGND sg13cmos5l_decap_8
XFILLER_7_565 VPWR VGND sg13cmos5l_fill_1
XFILLER_7_554 VPWR VGND sg13cmos5l_decap_8
XANTENNA__303__X Tile_X0Y0_S1BEG[3] VPWR VGND sg13cmos5l_antennanp
XFILLER_16_119 VPWR VGND sg13cmos5l_decap_8
XFILLER_17_609 VPWR VGND sg13cmos5l_decap_8
XFILLER_12_336 VPWR VGND sg13cmos5l_decap_8
XFILLER_13_804 VPWR VGND sg13cmos5l_decap_8
XFILLER_8_318 VPWR VGND sg13cmos5l_fill_1
XANTENNA_70 Tile_X0Y0_FrameData[21] VPWR VGND sg13cmos5l_antennanp
XANTENNA_81 Tile_X0Y0_FrameData[23] VPWR VGND sg13cmos5l_antennanp
XANTENNA_92 Tile_X0Y0_FrameData[2] VPWR VGND sg13cmos5l_antennanp
XANTENNA__213__X Tile_X1Y0_S2BEG[2] VPWR VGND sg13cmos5l_antennanp
XFILLER_4_557 VPWR VGND sg13cmos5l_decap_8
XFILLER_4_535 VPWR VGND sg13cmos5l_fill_1
XFILLER_0_796 VPWR VGND sg13cmos5l_decap_8
XFILLER_16_686 VPWR VGND sg13cmos5l_decap_8
XFILLER_15_196 VPWR VGND sg13cmos5l_decap_8
XFILLER_8_830 VPWR VGND sg13cmos5l_fill_1
XFILLER_7_21 VPWR VGND sg13cmos5l_decap_8
XFILLER_7_98 VPWR VGND sg13cmos5l_decap_8
XFILLER_16_0 VPWR VGND sg13cmos5l_decap_8
XFILLER_1_549 VPWR VGND sg13cmos5l_fill_1
XFILLER_13_601 VPWR VGND sg13cmos5l_decap_8
XFILLER_17_406 VPWR VGND sg13cmos5l_decap_8
XANTENNA__208__X Tile_X1Y0_S1BEG[1] VPWR VGND sg13cmos5l_antennanp
XFILLER_12_133 VPWR VGND sg13cmos5l_decap_8
XFILLER_13_678 VPWR VGND sg13cmos5l_decap_8
XFILLER_16_63 VPWR VGND sg13cmos5l_decap_8
XFILLER_9_605 VPWR VGND sg13cmos5l_decap_8
XFILLER_8_126 VPWR VGND sg13cmos5l_decap_8
XFILLER_4_398 VPWR VGND sg13cmos5l_decap_4
XFILLER_4_332 VPWR VGND sg13cmos5l_fill_1
XFILLER_16_483 VPWR VGND sg13cmos5l_decap_8
XFILLER_17_951 VPWR VGND sg13cmos5l_decap_8
XFILLER_10_637 VPWR VGND sg13cmos5l_decap_8
XFILLER_2_814 VPWR VGND sg13cmos5l_decap_8
XFILLER_2_803 VPWR VGND sg13cmos5l_fill_1
XFILLER_17_203 VPWR VGND sg13cmos5l_decap_8
XFILLER_18_704 VPWR VGND sg13cmos5l_decap_8
XFILLER_13_420 VPWR VGND sg13cmos5l_decap_8
XFILLER_14_932 VPWR VGND sg13cmos5l_fill_2
XFILLER_14_954 VPWR VGND sg13cmos5l_fill_1
XFILLER_13_497 VPWR VGND sg13cmos5l_decap_8
X_395_ _395_/X Tile_X1Y0_N1END[3] Tile_X1Y0_N2MID[3] Tile_X1Y0_N2MID[4] Tile_X1Y0_N2END[4]
+ _076_/Q _113_/Q VPWR VGND sg13cmos5l_mux4_1
XFILLER_9_468 VPWR VGND sg13cmos5l_decap_8
XFILLER_5_630 VPWR VGND sg13cmos5l_decap_8
XFILLER_4_55 VPWR VGND sg13cmos5l_decap_8
XFILLER_16_280 VPWR VGND sg13cmos5l_decap_8
XFILLER_17_770 VPWR VGND sg13cmos5l_decap_8
XFILLER_8_490 VPWR VGND sg13cmos5l_decap_8
XANTENNA__311__X Tile_X1Y0_FrameData_O[7] VPWR VGND sg13cmos5l_antennanp
XFILLER_14_217 VPWR VGND sg13cmos5l_decap_8
XFILLER_15_707 VPWR VGND sg13cmos5l_decap_8
XFILLER_10_434 VPWR VGND sg13cmos5l_decap_8
XFILLER_13_42 VPWR VGND sg13cmos5l_decap_8
X_180_ _180_/L_HI VPWR VGND sg13cmos5l_tiehi
XFILLER_6_449 VPWR VGND sg13cmos5l_decap_8
XFILLER_6_416 VPWR VGND sg13cmos5l_fill_2
XANTENNA__221__X Tile_X1Y0_S2BEGb[2] VPWR VGND sg13cmos5l_antennanp
XFILLER_2_699 VPWR VGND sg13cmos5l_decap_8
XFILLER_2_611 VPWR VGND sg13cmos5l_decap_8
XFILLER_18_545 VPWR VGND sg13cmos5l_decap_4
XFILLER_13_294 VPWR VGND sg13cmos5l_decap_8
X_378_ _378_/X Tile_X0Y0_N4END[13] Tile_X0Y0_N4END[14] Tile_X0Y0_NN4END[13] Tile_X0Y0_NN4END[15]
+ _048_/Q _047_/Q VPWR VGND sg13cmos5l_mux4_1
XFILLER_9_210 VPWR VGND sg13cmos5l_decap_8
XFILLER_18_589 VPWR VGND sg13cmos5l_fill_1
XFILLER_9_287 VPWR VGND sg13cmos5l_decap_8
XANTENNA__306__X Tile_X1Y0_FrameData_O[2] VPWR VGND sg13cmos5l_antennanp
XFILLER_3_408 VPWR VGND sg13cmos5l_fill_2
XFILLER_11_743 VPWR VGND sg13cmos5l_decap_8
XFILLER_15_504 VPWR VGND sg13cmos5l_decap_8
X_232_ Tile_X1Y0_S4BEG[5] Tile_X1Y0_N4END[10] VPWR VGND sg13cmos5l_buf_1
X_301_ Tile_X0Y0_S1BEG[1] Tile_X0Y0_N1END[2] VPWR VGND sg13cmos5l_buf_1
XANTENNA__216__X Tile_X1Y0_S2BEG[5] VPWR VGND sg13cmos5l_antennanp
XFILLER_10_275 VPWR VGND sg13cmos5l_decap_8
XFILLER_11_798 VPWR VGND sg13cmos5l_decap_8
X_094_ _094_/Q Tile_X0Y0_FrameData[12] VGND VPWR Tile_X1Y0_FrameStrobe[0] latch
X_163_ _163_/L_HI VPWR VGND sg13cmos5l_tiehi
XFILLER_7_725 VPWR VGND sg13cmos5l_fill_2
XFILLER_6_224 VPWR VGND sg13cmos5l_decap_8
XFILLER_2_463 VPWR VGND sg13cmos5l_decap_8
XANTENNA_160 Tile_X1Y0_FrameStrobe[9] VPWR VGND sg13cmos5l_antennanp
XFILLER_18_353 VPWR VGND sg13cmos5l_decap_4
XANTENNA_171 Tile_X0Y0_FrameData[25] VPWR VGND sg13cmos5l_antennanp
XANTENNA_182 Tile_X0Y0_FrameData[28] VPWR VGND sg13cmos5l_antennanp
XANTENNA_193 Tile_X0Y0_FrameData[28] VPWR VGND sg13cmos5l_antennanp
XFILLER_14_581 VPWR VGND sg13cmos5l_decap_8
XFILLER_12_518 VPWR VGND sg13cmos5l_decap_8
XFILLER_3_205 VPWR VGND sg13cmos5l_decap_8
XFILLER_10_65 VPWR VGND sg13cmos5l_decap_8
XFILLER_15_301 VPWR VGND sg13cmos5l_decap_8
XFILLER_16_868 VPWR VGND sg13cmos5l_decap_8
XFILLER_11_551 VPWR VGND sg13cmos5l_decap_8
XFILLER_15_378 VPWR VGND sg13cmos5l_decap_8
X_215_ Tile_X1Y0_S2BEG[4] Tile_X1Y0_N2MID[3] VPWR VGND sg13cmos5l_buf_1
X_077_ _077_/Q Tile_X0Y0_FrameData[29] VGND VPWR Tile_X1Y0_FrameStrobe[0] latch
X_146_ NPU_SWAP_WEIGHTS Tile_X0Y0_UserCLK _397_/X _170_/L_HI VPWR VGND sg13cmos5l_dfrbpq_1
XFILLER_7_577 VPWR VGND sg13cmos5l_decap_8
XFILLER_7_544 VPWR VGND sg13cmos5l_decap_4
XFILLER_3_794 VPWR VGND sg13cmos5l_fill_1
XFILLER_18_161 VPWR VGND sg13cmos5l_decap_8
XFILLER_0_219 VPWR VGND sg13cmos5l_decap_4
XFILLER_12_315 VPWR VGND sg13cmos5l_decap_8
XANTENNA_60 Tile_X0Y0_FrameData[20] VPWR VGND sg13cmos5l_antennanp
XANTENNA_71 Tile_X0Y0_FrameData[22] VPWR VGND sg13cmos5l_antennanp
XANTENNA_82 Tile_X0Y0_FrameData[23] VPWR VGND sg13cmos5l_antennanp
XANTENNA_93 Tile_X0Y0_FrameData[2] VPWR VGND sg13cmos5l_antennanp
XFILLER_4_514 VPWR VGND sg13cmos5l_decap_8
XFILLER_0_775 VPWR VGND sg13cmos5l_decap_8
XFILLER_15_175 VPWR VGND sg13cmos5l_decap_8
XFILLER_16_665 VPWR VGND sg13cmos5l_decap_8
XFILLER_12_882 VPWR VGND sg13cmos5l_decap_8
XFILLER_7_77 VPWR VGND sg13cmos5l_decap_8
X_129_ NPU_QUANT_SHIFT_IN14 Tile_X0Y0_UserCLK _379_/X _155_/L_HI VPWR VGND sg13cmos5l_dfrbpq_1
XFILLER_7_385 VPWR VGND sg13cmos5l_decap_8
XANTENNA__314__X Tile_X1Y0_FrameData_O[10] VPWR VGND sg13cmos5l_antennanp
XFILLER_1_517 VPWR VGND sg13cmos5l_decap_4
XFILLER_16_42 VPWR VGND sg13cmos5l_decap_8
XFILLER_18_919 VPWR VGND sg13cmos5l_decap_8
XANTENNA__224__X Tile_X1Y0_S2BEGb[5] VPWR VGND sg13cmos5l_antennanp
XFILLER_12_112 VPWR VGND sg13cmos5l_decap_8
XFILLER_12_189 VPWR VGND sg13cmos5l_decap_8
XFILLER_13_657 VPWR VGND sg13cmos5l_decap_8
XFILLER_8_105 VPWR VGND sg13cmos5l_decap_8
XFILLER_5_834 VPWR VGND sg13cmos5l_decap_8
XFILLER_0_550 VPWR VGND sg13cmos5l_fill_1
XFILLER_0_583 VPWR VGND sg13cmos5l_fill_1
XFILLER_0_594 VPWR VGND sg13cmos5l_fill_1
XFILLER_16_462 VPWR VGND sg13cmos5l_decap_8
XFILLER_7_182 VPWR VGND sg13cmos5l_decap_8
XANTENNA__309__X Tile_X1Y0_FrameData_O[5] VPWR VGND sg13cmos5l_antennanp
XFILLER_10_616 VPWR VGND sg13cmos5l_decap_8
XFILLER_5_119 VPWR VGND sg13cmos5l_decap_8
XANTENNA__219__X Tile_X1Y0_S2BEGb[0] VPWR VGND sg13cmos5l_antennanp
XFILLER_13_476 VPWR VGND sg13cmos5l_decap_8
XFILLER_14_911 VPWR VGND sg13cmos5l_decap_8
XFILLER_17_259 VPWR VGND sg13cmos5l_decap_8
X_394_ _394_/X Tile_X1Y0_N4END[14] Tile_X1Y0_N4END[15] Tile_X1Y0_NN4END[12] Tile_X1Y0_NN4END[14]
+ _084_/Q _083_/Q VPWR VGND sg13cmos5l_mux4_1
XFILLER_9_447 VPWR VGND sg13cmos5l_decap_8
XFILLER_11_925 VPWR VGND sg13cmos5l_decap_8
XFILLER_10_413 VPWR VGND sg13cmos5l_decap_8
XFILLER_11_958 VPWR VGND sg13cmos5l_fill_2
XFILLER_13_21 VPWR VGND sg13cmos5l_decap_8
XFILLER_13_98 VPWR VGND sg13cmos5l_decap_8
XFILLER_1_133 VPWR VGND sg13cmos5l_decap_8
XFILLER_18_513 VPWR VGND sg13cmos5l_decap_4
XFILLER_13_273 VPWR VGND sg13cmos5l_decap_8
XFILLER_14_785 VPWR VGND sg13cmos5l_decap_8
X_377_ _377_/X Tile_X0Y0_N4END[12] Tile_X0Y0_N4END[13] Tile_X0Y0_NN4END[12] Tile_X0Y0_NN4END[14]
+ _050_/Q _049_/Q VPWR VGND sg13cmos5l_mux4_1
XFILLER_9_266 VPWR VGND sg13cmos5l_decap_8
XFILLER_5_494 VPWR VGND sg13cmos5l_decap_8
XANTENNA__322__X Tile_X1Y0_FrameData_O[18] VPWR VGND sg13cmos5l_antennanp
XFILLER_11_700 VPWR VGND sg13cmos5l_decap_8
XFILLER_11_722 VPWR VGND sg13cmos5l_decap_8
X_162_ _162_/L_HI VPWR VGND sg13cmos5l_tiehi
X_231_ Tile_X1Y0_S4BEG[4] Tile_X1Y0_N4END[11] VPWR VGND sg13cmos5l_buf_1
X_300_ Tile_X0Y0_S1BEG[0] Tile_X0Y0_N1END[3] VPWR VGND sg13cmos5l_buf_1
XFILLER_7_704 VPWR VGND sg13cmos5l_decap_8
XANTENNA__232__X Tile_X1Y0_S4BEG[5] VPWR VGND sg13cmos5l_antennanp
XFILLER_10_254 VPWR VGND sg13cmos5l_decap_8
X_093_ _093_/Q Tile_X0Y0_FrameData[13] VGND VPWR Tile_X1Y0_FrameStrobe[0] latch
XFILLER_7_748 VPWR VGND sg13cmos5l_fill_1
XFILLER_6_203 VPWR VGND sg13cmos5l_decap_8
XFILLER_6_0 VPWR VGND sg13cmos5l_decap_8
XFILLER_3_921 VPWR VGND sg13cmos5l_decap_8
XFILLER_1_35 VPWR VGND sg13cmos5l_decap_8
XANTENNA_150 Tile_X1Y0_FrameStrobe[14] VPWR VGND sg13cmos5l_antennanp
XANTENNA_161 Tile_X1Y0_FrameStrobe[9] VPWR VGND sg13cmos5l_antennanp
XANTENNA_172 Tile_X0Y0_FrameData[25] VPWR VGND sg13cmos5l_antennanp
XANTENNA_183 Tile_X0Y0_FrameData[28] VPWR VGND sg13cmos5l_antennanp
XANTENNA_194 Tile_X0Y0_FrameData[28] VPWR VGND sg13cmos5l_antennanp
XFILLER_18_398 VPWR VGND sg13cmos5l_decap_8
XFILLER_14_560 VPWR VGND sg13cmos5l_decap_8
XFILLER_5_291 VPWR VGND sg13cmos5l_fill_1
XFILLER_5_280 VPWR VGND sg13cmos5l_decap_8
XANTENNA__317__X Tile_X1Y0_FrameData_O[13] VPWR VGND sg13cmos5l_antennanp
XFILLER_10_11 VPWR VGND sg13cmos5l_fill_2
XFILLER_10_44 VPWR VGND sg13cmos5l_decap_8
XFILLER_4_707 VPWR VGND sg13cmos5l_fill_2
XFILLER_0_946 VPWR VGND sg13cmos5l_fill_2
XFILLER_15_357 VPWR VGND sg13cmos5l_decap_8
XFILLER_16_847 VPWR VGND sg13cmos5l_decap_8
XANTENNA__227__X Tile_X1Y0_S4BEG[0] VPWR VGND sg13cmos5l_antennanp
XFILLER_11_530 VPWR VGND sg13cmos5l_decap_8
X_145_ NPU_COMPUTE_BANK_SWAP Tile_X0Y0_UserCLK _395_/X _171_/L_HI VPWR VGND sg13cmos5l_dfrbpq_1
X_214_ Tile_X1Y0_S2BEG[3] Tile_X1Y0_N2MID[4] VPWR VGND sg13cmos5l_buf_1
XFILLER_7_523 VPWR VGND sg13cmos5l_decap_8
X_076_ _076_/Q Tile_X0Y0_FrameData[30] VGND VPWR Tile_X1Y0_FrameStrobe[0] latch
XFILLER_2_261 VPWR VGND sg13cmos5l_fill_1
XANTENNA_50 Tile_X0Y0_FrameData[19] VPWR VGND sg13cmos5l_antennanp
XANTENNA_61 Tile_X0Y0_FrameData[20] VPWR VGND sg13cmos5l_antennanp
XANTENNA_72 Tile_X0Y0_FrameData[22] VPWR VGND sg13cmos5l_antennanp
XANTENNA_83 Tile_X0Y0_FrameData[23] VPWR VGND sg13cmos5l_antennanp
XFILLER_13_839 VPWR VGND sg13cmos5l_decap_8
XANTENNA_94 Tile_X0Y0_FrameData[2] VPWR VGND sg13cmos5l_antennanp
XFILLER_0_721 VPWR VGND sg13cmos5l_fill_2
XFILLER_0_754 VPWR VGND sg13cmos5l_decap_8
XFILLER_15_154 VPWR VGND sg13cmos5l_decap_8
XFILLER_16_644 VPWR VGND sg13cmos5l_decap_8
XFILLER_12_861 VPWR VGND sg13cmos5l_decap_8
X_128_ NPU_QUANT_SHIFT_IN13 Tile_X0Y0_UserCLK _378_/X _162_/L_HI VPWR VGND sg13cmos5l_dfrbpq_1
XFILLER_8_887 VPWR VGND sg13cmos5l_decap_8
XFILLER_8_876 VPWR VGND sg13cmos5l_fill_1
XFILLER_7_56 VPWR VGND sg13cmos5l_decap_8
XFILLER_7_397 VPWR VGND sg13cmos5l_decap_8
X_059_ _059_/Q Tile_X0Y0_FrameData[11] VGND VPWR Tile_X0Y0_FrameStrobe[0] latch
XFILLER_3_592 VPWR VGND sg13cmos5l_decap_8
XFILLER_10_809 VPWR VGND sg13cmos5l_fill_2
XANTENNA__330__X Tile_X1Y0_FrameData_O[26] VPWR VGND sg13cmos5l_antennanp
XFILLER_13_636 VPWR VGND sg13cmos5l_decap_8
XFILLER_16_21 VPWR VGND sg13cmos5l_decap_8
XFILLER_16_98 VPWR VGND sg13cmos5l_decap_8
XFILLER_12_168 VPWR VGND sg13cmos5l_decap_8
XANTENNA__240__X Tile_X1Y0_S4BEG[13] VPWR VGND sg13cmos5l_antennanp
XFILLER_16_441 VPWR VGND sg13cmos5l_decap_8
XFILLER_17_931 VPWR VGND sg13cmos5l_decap_8
XFILLER_7_161 VPWR VGND sg13cmos5l_decap_8
XANTENNA__325__X Tile_X1Y0_FrameData_O[21] VPWR VGND sg13cmos5l_antennanp
XFILLER_17_238 VPWR VGND sg13cmos5l_decap_8
XANTENNA__235__X Tile_X1Y0_S4BEG[8] VPWR VGND sg13cmos5l_antennanp
XFILLER_13_455 VPWR VGND sg13cmos5l_decap_8
XFILLER_14_934 VPWR VGND sg13cmos5l_fill_1
X_393_ _393_/X Tile_X1Y0_N4END[13] Tile_X1Y0_N4END[14] Tile_X1Y0_NN4END[13] Tile_X1Y0_NN4END[15]
+ _086_/Q _085_/Q VPWR VGND sg13cmos5l_mux4_1
XFILLER_9_426 VPWR VGND sg13cmos5l_decap_8
XFILLER_5_676 VPWR VGND sg13cmos5l_decap_8
XFILLER_4_153 VPWR VGND sg13cmos5l_decap_8
XFILLER_4_35 VPWR VGND sg13cmos5l_fill_2
XFILLER_11_904 VPWR VGND sg13cmos5l_decap_8
XFILLER_10_469 VPWR VGND sg13cmos5l_decap_8
XFILLER_13_77 VPWR VGND sg13cmos5l_decap_8
XFILLER_2_635 VPWR VGND sg13cmos5l_decap_8
XFILLER_18_569 VPWR VGND sg13cmos5l_decap_4
XFILLER_18_558 VPWR VGND sg13cmos5l_fill_1
XFILLER_13_252 VPWR VGND sg13cmos5l_decap_8
XFILLER_14_764 VPWR VGND sg13cmos5l_decap_8
X_376_ _376_/X Tile_X0Y0_N4END[8] Tile_X0Y0_N4END[11] Tile_X0Y0_NN4END[9] Tile_X0Y0_NN4END[11]
+ _052_/Q _051_/Q VPWR VGND sg13cmos5l_mux4_1
XFILLER_9_245 VPWR VGND sg13cmos5l_decap_8
XFILLER_5_473 VPWR VGND sg13cmos5l_decap_8
XFILLER_5_462 VPWR VGND sg13cmos5l_decap_8
XFILLER_15_539 VPWR VGND sg13cmos5l_decap_8
XFILLER_10_233 VPWR VGND sg13cmos5l_decap_8
X_161_ _161_/L_HI VPWR VGND sg13cmos5l_tiehi
X_230_ Tile_X1Y0_S4BEG[3] Tile_X1Y0_N4END[12] VPWR VGND sg13cmos5l_buf_1
XFILLER_7_727 VPWR VGND sg13cmos5l_fill_1
X_092_ _092_/Q Tile_X0Y0_FrameData[14] VGND VPWR Tile_X1Y0_FrameStrobe[0] latch
XFILLER_6_259 VPWR VGND sg13cmos5l_decap_8
XFILLER_3_900 VPWR VGND sg13cmos5l_decap_8
XFILLER_2_498 VPWR VGND sg13cmos5l_decap_8
XFILLER_1_58 VPWR VGND sg13cmos5l_fill_2
XFILLER_1_14 VPWR VGND sg13cmos5l_decap_8
XFILLER_18_333 VPWR VGND sg13cmos5l_decap_8
XANTENNA_140 Tile_X0Y0_NN4END[2] VPWR VGND sg13cmos5l_antennanp
XANTENNA_151 Tile_X1Y0_FrameStrobe[15] VPWR VGND sg13cmos5l_antennanp
XANTENNA_162 Tile_X1Y0_FrameStrobe[9] VPWR VGND sg13cmos5l_antennanp
XANTENNA_173 Tile_X0Y0_FrameData[25] VPWR VGND sg13cmos5l_antennanp
XANTENNA_184 Tile_X0Y0_FrameData[28] VPWR VGND sg13cmos5l_antennanp
XANTENNA_195 Tile_X0Y0_FrameData[28] VPWR VGND sg13cmos5l_antennanp
XFILLER_18_377 VPWR VGND sg13cmos5l_decap_8
X_359_ Tile_X1Y0_FrameStrobe_O[3] Tile_X1Y0_FrameStrobe[3] VPWR VGND sg13cmos5l_buf_1
XANTENNA__333__X Tile_X1Y0_FrameData_O[29] VPWR VGND sg13cmos5l_antennanp
XFILLER_10_23 VPWR VGND sg13cmos5l_decap_8
XFILLER_0_925 VPWR VGND sg13cmos5l_decap_8
XFILLER_0_958 VPWR VGND sg13cmos5l_fill_2
XFILLER_15_336 VPWR VGND sg13cmos5l_decap_8
XFILLER_16_826 VPWR VGND sg13cmos5l_decap_8
XANTENNA__243__X Tile_X1Y0_SS4BEG[0] VPWR VGND sg13cmos5l_antennanp
XFILLER_11_586 VPWR VGND sg13cmos5l_decap_8
X_075_ _075_/Q Tile_X0Y0_FrameData[31] VGND VPWR Tile_X0Y0_FrameStrobe[0] latch
X_144_ NPU_QUANT_SHIFT_IN29 Tile_X0Y0_UserCLK _394_/X _172_/L_HI VPWR VGND sg13cmos5l_dfrbpq_1
X_213_ Tile_X1Y0_S2BEG[2] Tile_X1Y0_N2MID[5] VPWR VGND sg13cmos5l_buf_1
XFILLER_7_502 VPWR VGND sg13cmos5l_decap_8
XFILLER_18_185 VPWR VGND sg13cmos5l_decap_8
XFILLER_18_141 VPWR VGND sg13cmos5l_fill_2
XANTENNA__328__X Tile_X1Y0_FrameData_O[24] VPWR VGND sg13cmos5l_antennanp
XFILLER_13_818 VPWR VGND sg13cmos5l_decap_8
XANTENNA_40 Tile_X0Y0_FrameData[18] VPWR VGND sg13cmos5l_antennanp
XANTENNA_51 Tile_X0Y0_FrameData[19] VPWR VGND sg13cmos5l_antennanp
XANTENNA_62 Tile_X0Y0_FrameData[21] VPWR VGND sg13cmos5l_antennanp
XANTENNA_73 Tile_X0Y0_FrameData[22] VPWR VGND sg13cmos5l_antennanp
XANTENNA_84 Tile_X0Y0_FrameData[23] VPWR VGND sg13cmos5l_antennanp
XANTENNA_95 Tile_X0Y0_FrameData[2] VPWR VGND sg13cmos5l_antennanp
XFILLER_0_700 VPWR VGND sg13cmos5l_fill_1
XFILLER_0_733 VPWR VGND sg13cmos5l_decap_8
XFILLER_16_623 VPWR VGND sg13cmos5l_decap_8
XANTENNA__238__X Tile_X1Y0_S4BEG[11] VPWR VGND sg13cmos5l_antennanp
XFILLER_11_350 VPWR VGND sg13cmos5l_fill_2
XFILLER_12_840 VPWR VGND sg13cmos5l_decap_8
XFILLER_15_133 VPWR VGND sg13cmos5l_decap_8
XFILLER_11_383 VPWR VGND sg13cmos5l_decap_8
X_058_ _058_/Q Tile_X0Y0_FrameData[12] VGND VPWR Tile_X0Y0_FrameStrobe[0] latch
X_127_ NPU_QUANT_SHIFT_IN12 Tile_X0Y0_UserCLK _377_/X _178_/L_HI VPWR VGND sg13cmos5l_dfrbpq_1
XFILLER_7_35 VPWR VGND sg13cmos5l_decap_8
XFILLER_7_343 VPWR VGND sg13cmos5l_fill_1
XFILLER_3_571 VPWR VGND sg13cmos5l_decap_4
XFILLER_12_147 VPWR VGND sg13cmos5l_decap_8
XFILLER_13_615 VPWR VGND sg13cmos5l_decap_8
XFILLER_16_77 VPWR VGND sg13cmos5l_decap_8
XFILLER_9_619 VPWR VGND sg13cmos5l_decap_8
XFILLER_5_858 VPWR VGND sg13cmos5l_fill_1
XFILLER_16_420 VPWR VGND sg13cmos5l_decap_8
XFILLER_17_910 VPWR VGND sg13cmos5l_decap_8
XFILLER_16_497 VPWR VGND sg13cmos5l_decap_8
XFILLER_8_663 VPWR VGND sg13cmos5l_decap_4
XFILLER_7_140 VPWR VGND sg13cmos5l_decap_8
XFILLER_14_0 VPWR VGND sg13cmos5l_decap_8
XANTENNA__341__X Tile_X0Y0_FrameStrobe_O[5] VPWR VGND sg13cmos5l_antennanp
XFILLER_17_217 VPWR VGND sg13cmos5l_decap_8
XFILLER_18_729 VPWR VGND sg13cmos5l_decap_8
XFILLER_18_718 VPWR VGND sg13cmos5l_decap_8
XFILLER_13_434 VPWR VGND sg13cmos5l_decap_8
XFILLER_14_946 VPWR VGND sg13cmos5l_fill_2
X_392_ _392_/X Tile_X1Y0_N4END[12] Tile_X1Y0_N4END[13] Tile_X1Y0_NN4END[12] Tile_X1Y0_NN4END[14]
+ _088_/Q _087_/Q VPWR VGND sg13cmos5l_mux4_1
XFILLER_9_405 VPWR VGND sg13cmos5l_decap_8
XANTENNA__251__X Tile_X1Y0_SS4BEG[8] VPWR VGND sg13cmos5l_antennanp
XFILLER_5_699 VPWR VGND sg13cmos5l_decap_4
XFILLER_4_14 VPWR VGND sg13cmos5l_decap_8
XFILLER_4_132 VPWR VGND sg13cmos5l_decap_8
XFILLER_4_69 VPWR VGND sg13cmos5l_decap_8
XFILLER_1_883 VPWR VGND sg13cmos5l_decap_8
XFILLER_16_294 VPWR VGND sg13cmos5l_decap_8
XFILLER_17_784 VPWR VGND sg13cmos5l_decap_8
XANTENNA__336__X Tile_X0Y0_FrameStrobe_O[0] VPWR VGND sg13cmos5l_antennanp
XFILLER_10_448 VPWR VGND sg13cmos5l_decap_8
XFILLER_13_56 VPWR VGND sg13cmos5l_decap_8
XFILLER_7_909 VPWR VGND sg13cmos5l_decap_8
XFILLER_1_113 VPWR VGND sg13cmos5l_decap_4
XFILLER_1_179 VPWR VGND sg13cmos5l_fill_1
XANTENNA__246__X Tile_X1Y0_SS4BEG[3] VPWR VGND sg13cmos5l_antennanp
XFILLER_13_231 VPWR VGND sg13cmos5l_decap_8
XFILLER_14_743 VPWR VGND sg13cmos5l_decap_8
XFILLER_18_537 VPWR VGND sg13cmos5l_decap_4
X_375_ _375_/X Tile_X0Y0_N4END[10] Tile_X0Y0_N4END[11] Tile_X0Y0_NN4END[8] Tile_X0Y0_NN4END[10]
+ _054_/Q _053_/Q VPWR VGND sg13cmos5l_mux4_1
XFILLER_9_224 VPWR VGND sg13cmos5l_decap_8
XFILLER_5_441 VPWR VGND sg13cmos5l_decap_8
XFILLER_1_691 VPWR VGND sg13cmos5l_fill_1
XFILLER_17_581 VPWR VGND sg13cmos5l_decap_8
XFILLER_15_518 VPWR VGND sg13cmos5l_decap_8
XFILLER_10_212 VPWR VGND sg13cmos5l_decap_8
XFILLER_10_289 VPWR VGND sg13cmos5l_decap_8
XFILLER_11_757 VPWR VGND sg13cmos5l_decap_8
XFILLER_11_768 VPWR VGND sg13cmos5l_fill_1
XFILLER_11_779 VPWR VGND sg13cmos5l_decap_8
X_091_ _091_/Q Tile_X0Y0_FrameData[15] VGND VPWR Tile_X1Y0_FrameStrobe[0] latch
X_160_ _160_/L_HI VPWR VGND sg13cmos5l_tiehi
XFILLER_7_739 VPWR VGND sg13cmos5l_decap_8
XFILLER_6_238 VPWR VGND sg13cmos5l_decap_8
XFILLER_2_477 VPWR VGND sg13cmos5l_decap_8
XFILLER_18_367 VPWR VGND sg13cmos5l_decap_8
XFILLER_18_312 VPWR VGND sg13cmos5l_decap_8
XANTENNA_130 Tile_X0Y0_FrameData[7] VPWR VGND sg13cmos5l_antennanp
XANTENNA_141 Tile_X0Y0_NN4END[2] VPWR VGND sg13cmos5l_antennanp
XANTENNA_152 Tile_X1Y0_FrameStrobe[18] VPWR VGND sg13cmos5l_antennanp
XANTENNA_163 Tile_X0Y0_FrameData[25] VPWR VGND sg13cmos5l_antennanp
XANTENNA_174 Tile_X0Y0_FrameData[25] VPWR VGND sg13cmos5l_antennanp
XANTENNA_185 Tile_X0Y0_FrameData[28] VPWR VGND sg13cmos5l_antennanp
XANTENNA_196 Tile_X0Y0_FrameData[28] VPWR VGND sg13cmos5l_antennanp
XFILLER_14_595 VPWR VGND sg13cmos5l_decap_8
X_358_ Tile_X1Y0_FrameStrobe_O[2] Tile_X1Y0_FrameStrobe[2] VPWR VGND sg13cmos5l_buf_1
X_289_ Tile_X0Y0_SS4BEG[5] Tile_X0Y0_NN4END[10] VPWR VGND sg13cmos5l_buf_1
XFILLER_0_904 VPWR VGND sg13cmos5l_decap_8
XFILLER_10_79 VPWR VGND sg13cmos5l_decap_8
XFILLER_3_219 VPWR VGND sg13cmos5l_fill_2
XFILLER_16_805 VPWR VGND sg13cmos5l_decap_8
XFILLER_15_315 VPWR VGND sg13cmos5l_decap_8
X_212_ Tile_X1Y0_S2BEG[1] Tile_X1Y0_N2MID[6] VPWR VGND sg13cmos5l_buf_1
XFILLER_11_565 VPWR VGND sg13cmos5l_decap_8
X_074_ _074_/Q Tile_X0Y0_FrameData[28] VGND VPWR Tile_X0Y0_FrameStrobe[1] latch
X_143_ NPU_QUANT_SHIFT_IN28 Tile_X0Y0_UserCLK _393_/X _173_/L_HI VPWR VGND sg13cmos5l_dfrbpq_1
XFILLER_2_252 VPWR VGND sg13cmos5l_decap_8
XFILLER_18_7 VPWR VGND sg13cmos5l_decap_8
XFILLER_18_175 VPWR VGND sg13cmos5l_decap_8
XFILLER_18_153 VPWR VGND sg13cmos5l_decap_4
XFILLER_18_120 VPWR VGND sg13cmos5l_decap_8
XFILLER_14_392 VPWR VGND sg13cmos5l_decap_8
XFILLER_15_882 VPWR VGND sg13cmos5l_decap_8
XFILLER_2_91 VPWR VGND sg13cmos5l_decap_8
XFILLER_12_329 VPWR VGND sg13cmos5l_decap_8
XANTENNA_30 Tile_X0Y0_FrameData[14] VPWR VGND sg13cmos5l_antennanp
XANTENNA_41 Tile_X0Y0_FrameData[18] VPWR VGND sg13cmos5l_antennanp
XANTENNA_52 Tile_X0Y0_FrameData[19] VPWR VGND sg13cmos5l_antennanp
XANTENNA_63 Tile_X0Y0_FrameData[21] VPWR VGND sg13cmos5l_antennanp
XANTENNA_74 Tile_X0Y0_FrameData[22] VPWR VGND sg13cmos5l_antennanp
XANTENNA_85 Tile_X0Y0_FrameData[23] VPWR VGND sg13cmos5l_antennanp
XANTENNA_96 Tile_X0Y0_FrameData[2] VPWR VGND sg13cmos5l_antennanp
XANTENNA__344__X Tile_X0Y0_FrameStrobe_O[8] VPWR VGND sg13cmos5l_antennanp
XFILLER_4_528 VPWR VGND sg13cmos5l_decap_8
XFILLER_0_789 VPWR VGND sg13cmos5l_decap_8
XFILLER_15_112 VPWR VGND sg13cmos5l_decap_8
XFILLER_16_602 VPWR VGND sg13cmos5l_decap_8
XANTENNA__254__X Tile_X1Y0_SS4BEG[11] VPWR VGND sg13cmos5l_antennanp
XFILLER_11_362 VPWR VGND sg13cmos5l_decap_8
XFILLER_12_896 VPWR VGND sg13cmos5l_decap_8
XFILLER_15_189 VPWR VGND sg13cmos5l_decap_8
XFILLER_16_679 VPWR VGND sg13cmos5l_decap_8
XFILLER_7_322 VPWR VGND sg13cmos5l_fill_1
XFILLER_7_14 VPWR VGND sg13cmos5l_decap_8
X_057_ _057_/Q Tile_X0Y0_FrameData[13] VGND VPWR Tile_X0Y0_FrameStrobe[0] latch
X_126_ NPU_QUANT_SHIFT_IN11 Tile_X0Y0_UserCLK _376_/X _151_/L_HI VPWR VGND sg13cmos5l_dfrbpq_1
XANTENNA__339__X Tile_X0Y0_FrameStrobe_O[3] VPWR VGND sg13cmos5l_antennanp
XFILLER_12_126 VPWR VGND sg13cmos5l_decap_8
XFILLER_16_56 VPWR VGND sg13cmos5l_decap_8
XFILLER_8_119 VPWR VGND sg13cmos5l_decap_8
XFILLER_4_314 VPWR VGND sg13cmos5l_fill_1
XANTENNA__249__X Tile_X1Y0_SS4BEG[6] VPWR VGND sg13cmos5l_antennanp
XFILLER_16_476 VPWR VGND sg13cmos5l_decap_8
XFILLER_12_693 VPWR VGND sg13cmos5l_decap_8
X_109_ _109_/Q Tile_X0Y0_FrameData[29] VGND VPWR Tile_X1Y0_FrameStrobe[1] latch
XFILLER_7_196 VPWR VGND sg13cmos5l_decap_8
XFILLER_2_807 VPWR VGND sg13cmos5l_decap_8
XFILLER_13_413 VPWR VGND sg13cmos5l_decap_8
XFILLER_14_925 VPWR VGND sg13cmos5l_decap_8
XFILLER_14_958 VPWR VGND sg13cmos5l_fill_2
X_391_ _391_/X Tile_X1Y0_N4END[8] Tile_X1Y0_N4END[11] Tile_X1Y0_NN4END[9] Tile_X1Y0_NN4END[11]
+ _090_/Q _089_/Q VPWR VGND sg13cmos5l_mux4_1
XFILLER_5_623 VPWR VGND sg13cmos5l_decap_8
XFILLER_4_48 VPWR VGND sg13cmos5l_decap_8
XFILLER_4_37 VPWR VGND sg13cmos5l_fill_1
XFILLER_4_111 VPWR VGND sg13cmos5l_decap_8
XFILLER_1_851 VPWR VGND sg13cmos5l_decap_8
XFILLER_1_895 VPWR VGND sg13cmos5l_decap_8
XFILLER_16_273 VPWR VGND sg13cmos5l_decap_8
XFILLER_17_763 VPWR VGND sg13cmos5l_decap_8
XFILLER_12_490 VPWR VGND sg13cmos5l_decap_8
XFILLER_8_483 VPWR VGND sg13cmos5l_decap_8
XFILLER_10_427 VPWR VGND sg13cmos5l_decap_8
XFILLER_13_35 VPWR VGND sg13cmos5l_decap_8
XFILLER_6_409 VPWR VGND sg13cmos5l_decap_8
XANTENNA__352__X Tile_X0Y0_FrameStrobe_O[16] VPWR VGND sg13cmos5l_antennanp
XFILLER_2_626 VPWR VGND sg13cmos5l_decap_4
XFILLER_2_604 VPWR VGND sg13cmos5l_decap_8
XFILLER_18_549 VPWR VGND sg13cmos5l_fill_2
XFILLER_13_210 VPWR VGND sg13cmos5l_decap_8
XFILLER_14_722 VPWR VGND sg13cmos5l_decap_8
XFILLER_14_799 VPWR VGND sg13cmos5l_decap_8
X_374_ _374_/X Tile_X0Y0_N4END[9] Tile_X0Y0_N4END[10] Tile_X0Y0_NN4END[9] Tile_X0Y0_NN4END[11]
+ _056_/Q _055_/Q VPWR VGND sg13cmos5l_mux4_1
XFILLER_9_203 VPWR VGND sg13cmos5l_decap_8
XANTENNA__262__X Tile_X0Y0_S2BEGb[2] VPWR VGND sg13cmos5l_antennanp
XFILLER_13_287 VPWR VGND sg13cmos5l_decap_8
XFILLER_6_910 VPWR VGND sg13cmos5l_decap_8
XFILLER_0_191 VPWR VGND sg13cmos5l_decap_8
XFILLER_17_560 VPWR VGND sg13cmos5l_decap_8
XFILLER_8_280 VPWR VGND sg13cmos5l_decap_4
XFILLER_5_91 VPWR VGND sg13cmos5l_decap_8
XANTENNA__121__Q NPU_QUANT_SHIFT_IN6 VPWR VGND sg13cmos5l_antennanp
XANTENNA__347__X Tile_X0Y0_FrameStrobe_O[11] VPWR VGND sg13cmos5l_antennanp
XFILLER_11_714 VPWR VGND sg13cmos5l_decap_4
XFILLER_10_268 VPWR VGND sg13cmos5l_decap_8
XFILLER_11_736 VPWR VGND sg13cmos5l_decap_8
X_090_ _090_/Q Tile_X0Y0_FrameData[16] VGND VPWR Tile_X1Y0_FrameStrobe[0] latch
XFILLER_7_718 VPWR VGND sg13cmos5l_decap_8
XFILLER_6_217 VPWR VGND sg13cmos5l_decap_8
XFILLER_2_456 VPWR VGND sg13cmos5l_decap_8
XANTENNA_120 Tile_X0Y0_FrameData[5] VPWR VGND sg13cmos5l_antennanp
XANTENNA_131 Tile_X0Y0_FrameData[7] VPWR VGND sg13cmos5l_antennanp
XANTENNA_142 Tile_X0Y0_NN4END[2] VPWR VGND sg13cmos5l_antennanp
XANTENNA__257__X Tile_X1Y0_SS4BEG[14] VPWR VGND sg13cmos5l_antennanp
XFILLER_1_49 VPWR VGND sg13cmos5l_decap_4
XANTENNA_153 Tile_X1Y0_FrameStrobe[19] VPWR VGND sg13cmos5l_antennanp
XANTENNA_164 Tile_X0Y0_FrameData[25] VPWR VGND sg13cmos5l_antennanp
XANTENNA_175 Tile_X0Y0_FrameData[25] VPWR VGND sg13cmos5l_antennanp
XANTENNA_186 Tile_X0Y0_FrameData[28] VPWR VGND sg13cmos5l_antennanp
XANTENNA_197 Tile_X0Y0_FrameData[28] VPWR VGND sg13cmos5l_antennanp
XFILLER_14_574 VPWR VGND sg13cmos5l_decap_8
X_357_ Tile_X1Y0_FrameStrobe_O[1] Tile_X1Y0_FrameStrobe[1] VPWR VGND sg13cmos5l_buf_1
X_288_ Tile_X0Y0_SS4BEG[4] Tile_X0Y0_NN4END[11] VPWR VGND sg13cmos5l_buf_1
XFILLER_18_891 VPWR VGND sg13cmos5l_decap_8
XANTENNA__116__Q NPU_QUANT_SHIFT_IN1 VPWR VGND sg13cmos5l_antennanp
XFILLER_10_58 VPWR VGND sg13cmos5l_decap_8
XFILLER_11_544 VPWR VGND sg13cmos5l_decap_8
X_142_ NPU_QUANT_SHIFT_IN27 Tile_X0Y0_UserCLK _392_/X _174_/L_HI VPWR VGND sg13cmos5l_dfrbpq_1
X_211_ Tile_X1Y0_S2BEG[0] Tile_X1Y0_N2MID[7] VPWR VGND sg13cmos5l_buf_1
X_073_ _073_/Q Tile_X0Y0_FrameData[29] VGND VPWR Tile_X0Y0_FrameStrobe[1] latch
XFILLER_7_548 VPWR VGND sg13cmos5l_fill_2
XFILLER_7_537 VPWR VGND sg13cmos5l_decap_8
XFILLER_4_0 VPWR VGND sg13cmos5l_decap_8
XFILLER_2_231 VPWR VGND sg13cmos5l_decap_8
XFILLER_3_787 VPWR VGND sg13cmos5l_decap_8
XFILLER_15_861 VPWR VGND sg13cmos5l_decap_8
XFILLER_14_371 VPWR VGND sg13cmos5l_decap_8
XFILLER_2_70 VPWR VGND sg13cmos5l_decap_8
XANTENNA_20 Tile_X0Y0_FrameData[12] VPWR VGND sg13cmos5l_antennanp
XANTENNA_31 Tile_X0Y0_FrameData[14] VPWR VGND sg13cmos5l_antennanp
XFILLER_12_308 VPWR VGND sg13cmos5l_decap_8
XANTENNA_42 Tile_X0Y0_FrameData[18] VPWR VGND sg13cmos5l_antennanp
XANTENNA_53 Tile_X0Y0_FrameData[20] VPWR VGND sg13cmos5l_antennanp
XANTENNA_64 Tile_X0Y0_FrameData[21] VPWR VGND sg13cmos5l_antennanp
XANTENNA_75 Tile_X0Y0_FrameData[22] VPWR VGND sg13cmos5l_antennanp
XANTENNA_86 Tile_X0Y0_FrameData[23] VPWR VGND sg13cmos5l_antennanp
XANTENNA_97 Tile_X0Y0_FrameData[2] VPWR VGND sg13cmos5l_antennanp
XANTENNA__360__X Tile_X1Y0_FrameStrobe_O[4] VPWR VGND sg13cmos5l_antennanp
XFILLER_4_507 VPWR VGND sg13cmos5l_decap_8
XFILLER_0_768 VPWR VGND sg13cmos5l_decap_8
XFILLER_15_168 VPWR VGND sg13cmos5l_decap_8
XFILLER_16_658 VPWR VGND sg13cmos5l_decap_8
XFILLER_12_875 VPWR VGND sg13cmos5l_decap_8
X_125_ NPU_QUANT_SHIFT_IN10 Tile_X0Y0_UserCLK _375_/X _159_/L_HI VPWR VGND sg13cmos5l_dfrbpq_1
XANTENNA__270__X Tile_X0Y0_S4BEG[2] VPWR VGND sg13cmos5l_antennanp
X_056_ _056_/Q Tile_X0Y0_FrameData[14] VGND VPWR Tile_X0Y0_FrameStrobe[0] latch
XFILLER_7_378 VPWR VGND sg13cmos5l_decap_8
XFILLER_7_890 VPWR VGND sg13cmos5l_fill_2
XFILLER_16_35 VPWR VGND sg13cmos5l_decap_8
XANTENNA__355__X Tile_X0Y0_FrameStrobe_O[19] VPWR VGND sg13cmos5l_antennanp
XFILLER_12_105 VPWR VGND sg13cmos5l_decap_8
XFILLER_5_827 VPWR VGND sg13cmos5l_decap_8
XFILLER_0_565 VPWR VGND sg13cmos5l_fill_1
XANTENNA__265__X Tile_X0Y0_S2BEGb[5] VPWR VGND sg13cmos5l_antennanp
XFILLER_16_455 VPWR VGND sg13cmos5l_decap_8
XFILLER_17_945 VPWR VGND sg13cmos5l_fill_2
XFILLER_11_182 VPWR VGND sg13cmos5l_decap_8
XFILLER_12_672 VPWR VGND sg13cmos5l_decap_8
X_108_ _108_/Q Tile_X0Y0_FrameData[30] VGND VPWR Tile_X1Y0_FrameStrobe[1] latch
XFILLER_8_698 VPWR VGND sg13cmos5l_fill_2
XFILLER_8_621 VPWR VGND sg13cmos5l_decap_4
XFILLER_7_175 VPWR VGND sg13cmos5l_decap_8
X_039_ NPU_PSUM_SKEW_EN Tile_X0Y0_UserCLK _039_/D _161_/L_HI VPWR VGND sg13cmos5l_dfrbpq_1
XFILLER_10_609 VPWR VGND sg13cmos5l_decap_8
XANTENNA__124__Q NPU_QUANT_SHIFT_IN9 VPWR VGND sg13cmos5l_antennanp
XFILLER_8_91 VPWR VGND sg13cmos5l_decap_8
XFILLER_14_904 VPWR VGND sg13cmos5l_decap_8
X_390_ _390_/X Tile_X1Y0_N4END[10] Tile_X1Y0_N4END[11] Tile_X1Y0_NN4END[8] Tile_X1Y0_NN4END[10]
+ _092_/Q _091_/Q VPWR VGND sg13cmos5l_mux4_1
XFILLER_13_469 VPWR VGND sg13cmos5l_decap_8
XFILLER_5_602 VPWR VGND sg13cmos5l_decap_8
XFILLER_4_167 VPWR VGND sg13cmos5l_decap_4
XFILLER_17_742 VPWR VGND sg13cmos5l_decap_8
XFILLER_16_252 VPWR VGND sg13cmos5l_decap_8
XFILLER_9_930 VPWR VGND sg13cmos5l_fill_1
XFILLER_8_462 VPWR VGND sg13cmos5l_decap_8
XANTENNA__119__Q NPU_QUANT_SHIFT_IN4 VPWR VGND sg13cmos5l_antennanp
XFILLER_10_406 VPWR VGND sg13cmos5l_decap_8
XFILLER_11_918 VPWR VGND sg13cmos5l_decap_8
XFILLER_13_14 VPWR VGND sg13cmos5l_decap_8
XFILLER_8_7 VPWR VGND sg13cmos5l_decap_8
XFILLER_2_649 VPWR VGND sg13cmos5l_decap_4
XFILLER_1_126 VPWR VGND sg13cmos5l_decap_4
XFILLER_18_528 VPWR VGND sg13cmos5l_decap_4
XFILLER_18_517 VPWR VGND sg13cmos5l_fill_1
XFILLER_18_506 VPWR VGND sg13cmos5l_decap_4
XFILLER_13_266 VPWR VGND sg13cmos5l_decap_8
XFILLER_14_701 VPWR VGND sg13cmos5l_decap_8
XFILLER_14_778 VPWR VGND sg13cmos5l_decap_8
X_373_ _373_/X Tile_X0Y0_N4END[8] Tile_X0Y0_N4END[9] Tile_X0Y0_NN4END[8] Tile_X0Y0_NN4END[10]
+ _058_/Q _057_/Q VPWR VGND sg13cmos5l_mux4_1
XFILLER_9_259 VPWR VGND sg13cmos5l_decap_8
XFILLER_5_487 VPWR VGND sg13cmos5l_decap_8
XFILLER_0_170 VPWR VGND sg13cmos5l_decap_8
XFILLER_5_70 VPWR VGND sg13cmos5l_decap_8
XANTENNA__363__X Tile_X1Y0_FrameStrobe_O[7] VPWR VGND sg13cmos5l_antennanp
XFILLER_10_247 VPWR VGND sg13cmos5l_decap_8
XFILLER_3_914 VPWR VGND sg13cmos5l_decap_8
XFILLER_3_958 VPWR VGND sg13cmos5l_fill_2
XFILLER_1_28 VPWR VGND sg13cmos5l_decap_8
XANTENNA_110 Tile_X0Y0_FrameData[4] VPWR VGND sg13cmos5l_antennanp
XANTENNA_121 Tile_X0Y0_FrameData[5] VPWR VGND sg13cmos5l_antennanp
XANTENNA_132 Tile_X0Y0_FrameData[7] VPWR VGND sg13cmos5l_antennanp
XANTENNA_143 Tile_X0Y0_NN4END[2] VPWR VGND sg13cmos5l_antennanp
XANTENNA_154 Tile_X1Y0_FrameStrobe[2] VPWR VGND sg13cmos5l_antennanp
XANTENNA_165 Tile_X0Y0_FrameData[25] VPWR VGND sg13cmos5l_antennanp
XANTENNA_176 Tile_X0Y0_FrameData[25] VPWR VGND sg13cmos5l_antennanp
XFILLER_18_347 VPWR VGND sg13cmos5l_fill_2
XANTENNA_187 Tile_X0Y0_FrameData[28] VPWR VGND sg13cmos5l_antennanp
XANTENNA_198 Tile_X0Y0_FrameData[28] VPWR VGND sg13cmos5l_antennanp
XANTENNA__273__X Tile_X0Y0_S4BEG[5] VPWR VGND sg13cmos5l_antennanp
XFILLER_14_553 VPWR VGND sg13cmos5l_decap_8
X_287_ Tile_X0Y0_SS4BEG[3] Tile_X0Y0_NN4END[12] VPWR VGND sg13cmos5l_buf_1
X_356_ Tile_X1Y0_FrameStrobe_O[0] Tile_X1Y0_FrameStrobe[0] VPWR VGND sg13cmos5l_buf_1
XFILLER_5_295 VPWR VGND sg13cmos5l_fill_1
XFILLER_5_273 VPWR VGND sg13cmos5l_decap_8
XFILLER_18_870 VPWR VGND sg13cmos5l_decap_8
XFILLER_10_37 VPWR VGND sg13cmos5l_decap_8
XANTENNA__132__Q NPU_QUANT_SHIFT_IN17 VPWR VGND sg13cmos5l_antennanp
XFILLER_0_939 VPWR VGND sg13cmos5l_fill_2
XANTENNA__358__X Tile_X1Y0_FrameStrobe_O[2] VPWR VGND sg13cmos5l_antennanp
XFILLER_11_523 VPWR VGND sg13cmos5l_decap_8
X_141_ NPU_QUANT_SHIFT_IN26 Tile_X0Y0_UserCLK _391_/X _175_/L_HI VPWR VGND sg13cmos5l_dfrbpq_1
X_210_ Tile_X1Y0_S1BEG[3] Tile_X1Y0_N1END[0] VPWR VGND sg13cmos5l_buf_1
XFILLER_7_516 VPWR VGND sg13cmos5l_decap_8
X_072_ _072_/Q Tile_X0Y0_FrameData[30] VGND VPWR Tile_X0Y0_FrameStrobe[1] latch
XANTENNA__268__X Tile_X0Y0_S4BEG[0] VPWR VGND sg13cmos5l_antennanp
XFILLER_3_799 VPWR VGND sg13cmos5l_fill_2
XFILLER_14_350 VPWR VGND sg13cmos5l_decap_8
XFILLER_15_840 VPWR VGND sg13cmos5l_decap_8
XFILLER_18_199 VPWR VGND sg13cmos5l_decap_4
X_339_ Tile_X0Y0_FrameStrobe_O[3] Tile_X0Y0_FrameStrobe[3] VPWR VGND sg13cmos5l_buf_1
XANTENNA_10 Tile_X0Y0_FrameData[0] VPWR VGND sg13cmos5l_antennanp
XANTENNA_21 Tile_X0Y0_FrameData[12] VPWR VGND sg13cmos5l_antennanp
XANTENNA_32 Tile_X0Y0_FrameData[14] VPWR VGND sg13cmos5l_antennanp
XANTENNA_43 Tile_X0Y0_FrameData[18] VPWR VGND sg13cmos5l_antennanp
XANTENNA_54 Tile_X0Y0_FrameData[20] VPWR VGND sg13cmos5l_antennanp
XANTENNA_65 Tile_X0Y0_FrameData[21] VPWR VGND sg13cmos5l_antennanp
XANTENNA__127__Q NPU_QUANT_SHIFT_IN12 VPWR VGND sg13cmos5l_antennanp
XANTENNA_76 Tile_X0Y0_FrameData[22] VPWR VGND sg13cmos5l_antennanp
XANTENNA_87 Tile_X0Y0_FrameData[23] VPWR VGND sg13cmos5l_antennanp
XANTENNA_98 Tile_X0Y0_FrameData[3] VPWR VGND sg13cmos5l_antennanp
XFILLER_0_714 VPWR VGND sg13cmos5l_decap_8
XFILLER_0_747 VPWR VGND sg13cmos5l_decap_8
XFILLER_15_147 VPWR VGND sg13cmos5l_decap_8
XFILLER_16_637 VPWR VGND sg13cmos5l_decap_8
XFILLER_11_397 VPWR VGND sg13cmos5l_decap_8
XFILLER_12_854 VPWR VGND sg13cmos5l_decap_8
X_055_ _055_/Q Tile_X0Y0_FrameData[15] VGND VPWR Tile_X0Y0_FrameStrobe[0] latch
X_124_ NPU_QUANT_SHIFT_IN9 Tile_X0Y0_UserCLK _374_/X _187_/L_HI VPWR VGND sg13cmos5l_dfrbpq_1
XFILLER_8_869 VPWR VGND sg13cmos5l_decap_8
XFILLER_7_49 VPWR VGND sg13cmos5l_decap_8
XFILLER_11_91 VPWR VGND sg13cmos5l_decap_8
XFILLER_3_585 VPWR VGND sg13cmos5l_decap_8
XFILLER_3_541 VPWR VGND sg13cmos5l_fill_1
XFILLER_13_629 VPWR VGND sg13cmos5l_decap_8
XFILLER_16_14 VPWR VGND sg13cmos5l_decap_8
XFILLER_0_511 VPWR VGND sg13cmos5l_fill_1
XFILLER_17_924 VPWR VGND sg13cmos5l_decap_8
XFILLER_12_651 VPWR VGND sg13cmos5l_decap_8
XFILLER_16_434 VPWR VGND sg13cmos5l_decap_8
XFILLER_8_600 VPWR VGND sg13cmos5l_decap_8
XANTENNA__281__X Tile_X0Y0_S4BEG[13] VPWR VGND sg13cmos5l_antennanp
XFILLER_11_161 VPWR VGND sg13cmos5l_decap_8
X_038_ _039_/D _396_/X _114_/Q VPWR VGND sg13cmos5l_or2_1
X_107_ _107_/Q Tile_X0Y0_FrameData[31] VGND VPWR Tile_X1Y0_FrameStrobe[1] latch
XFILLER_7_154 VPWR VGND sg13cmos5l_decap_8
XFILLER_4_894 VPWR VGND sg13cmos5l_decap_8
XANTENNA__191__X Tile_X1Y0_FrameStrobe_O[12] VPWR VGND sg13cmos5l_antennanp
XFILLER_8_70 VPWR VGND sg13cmos5l_decap_8
XANTENNA__140__Q NPU_QUANT_SHIFT_IN25 VPWR VGND sg13cmos5l_antennanp
XFILLER_13_448 VPWR VGND sg13cmos5l_decap_8
XFILLER_9_419 VPWR VGND sg13cmos5l_decap_8
XFILLER_5_669 VPWR VGND sg13cmos5l_decap_8
XFILLER_5_647 VPWR VGND sg13cmos5l_decap_4
XFILLER_4_146 VPWR VGND sg13cmos5l_decap_8
XFILLER_4_28 VPWR VGND sg13cmos5l_decap_8
XFILLER_1_820 VPWR VGND sg13cmos5l_decap_8
XANTENNA__276__X Tile_X0Y0_S4BEG[8] VPWR VGND sg13cmos5l_antennanp
XFILLER_16_231 VPWR VGND sg13cmos5l_decap_8
XFILLER_17_798 VPWR VGND sg13cmos5l_decap_8
XFILLER_17_721 VPWR VGND sg13cmos5l_decap_8
XFILLER_8_441 VPWR VGND sg13cmos5l_decap_8
XFILLER_12_0 VPWR VGND sg13cmos5l_decap_8
XANTENNA__135__Q NPU_QUANT_SHIFT_IN20 VPWR VGND sg13cmos5l_antennanp
XFILLER_13_245 VPWR VGND sg13cmos5l_decap_8
XFILLER_14_757 VPWR VGND sg13cmos5l_decap_8
X_372_ _372_/X Tile_X0Y0_N4END[4] Tile_X0Y0_N4END[7] Tile_X0Y0_NN4END[5] Tile_X0Y0_NN4END[7]
+ _060_/Q _059_/Q VPWR VGND sg13cmos5l_mux4_1
XFILLER_9_238 VPWR VGND sg13cmos5l_decap_8
XFILLER_5_455 VPWR VGND sg13cmos5l_decap_8
XFILLER_5_433 VPWR VGND sg13cmos5l_decap_4
XFILLER_17_595 VPWR VGND sg13cmos5l_decap_8
XFILLER_13_790 VPWR VGND sg13cmos5l_decap_8
XFILLER_10_226 VPWR VGND sg13cmos5l_decap_8
XFILLER_18_326 VPWR VGND sg13cmos5l_decap_8
XANTENNA_100 Tile_X0Y0_FrameData[3] VPWR VGND sg13cmos5l_antennanp
XANTENNA_111 Tile_X0Y0_FrameData[4] VPWR VGND sg13cmos5l_antennanp
XANTENNA_122 Tile_X0Y0_FrameData[5] VPWR VGND sg13cmos5l_antennanp
XANTENNA_133 Tile_X0Y0_FrameData[7] VPWR VGND sg13cmos5l_antennanp
XANTENNA_144 Tile_X0Y0_NN4END[2] VPWR VGND sg13cmos5l_antennanp
XANTENNA_155 Tile_X1Y0_FrameStrobe[3] VPWR VGND sg13cmos5l_antennanp
XANTENNA_166 Tile_X0Y0_FrameData[25] VPWR VGND sg13cmos5l_antennanp
XANTENNA_177 Tile_X0Y0_FrameData[25] VPWR VGND sg13cmos5l_antennanp
XANTENNA_188 Tile_X0Y0_FrameData[28] VPWR VGND sg13cmos5l_antennanp
XANTENNA_199 Tile_X0Y0_FrameData[28] VPWR VGND sg13cmos5l_antennanp
XFILLER_14_532 VPWR VGND sg13cmos5l_decap_8
XFILLER_14_91 VPWR VGND sg13cmos5l_decap_8
X_286_ Tile_X0Y0_SS4BEG[2] Tile_X0Y0_NN4END[13] VPWR VGND sg13cmos5l_buf_1
X_355_ Tile_X0Y0_FrameStrobe_O[19] Tile_X0Y0_FrameStrobe[19] VPWR VGND sg13cmos5l_buf_1
XFILLER_5_252 VPWR VGND sg13cmos5l_decap_8
XFILLER_1_491 VPWR VGND sg13cmos5l_decap_8
XFILLER_17_392 VPWR VGND sg13cmos5l_decap_8
XFILLER_10_16 VPWR VGND sg13cmos5l_decap_8
XFILLER_9_591 VPWR VGND sg13cmos5l_decap_8
XFILLER_0_918 VPWR VGND sg13cmos5l_decap_8
XFILLER_15_329 VPWR VGND sg13cmos5l_decap_8
XFILLER_16_819 VPWR VGND sg13cmos5l_decap_8
XFILLER_11_502 VPWR VGND sg13cmos5l_decap_8
XFILLER_11_579 VPWR VGND sg13cmos5l_decap_8
X_071_ _071_/Q Tile_X0Y0_FrameData[31] VGND VPWR Tile_X0Y0_FrameStrobe[1] latch
X_140_ NPU_QUANT_SHIFT_IN25 Tile_X0Y0_UserCLK _390_/X _165_/L_HI VPWR VGND sg13cmos5l_dfrbpq_1
XFILLER_3_756 VPWR VGND sg13cmos5l_decap_8
XANTENNA__284__X Tile_X0Y0_SS4BEG[0] VPWR VGND sg13cmos5l_antennanp
XFILLER_15_896 VPWR VGND sg13cmos5l_decap_8
X_338_ Tile_X0Y0_FrameStrobe_O[2] Tile_X0Y0_FrameStrobe[2] VPWR VGND sg13cmos5l_buf_1
X_269_ Tile_X0Y0_S4BEG[1] Tile_X0Y0_N4END[14] VPWR VGND sg13cmos5l_buf_1
XFILLER_18_690 VPWR VGND sg13cmos5l_decap_8
XANTENNA_11 Tile_X0Y0_FrameData[0] VPWR VGND sg13cmos5l_antennanp
XANTENNA_22 Tile_X0Y0_FrameData[12] VPWR VGND sg13cmos5l_antennanp
XANTENNA_33 Tile_X0Y0_FrameData[14] VPWR VGND sg13cmos5l_antennanp
XANTENNA_44 Tile_X0Y0_FrameData[19] VPWR VGND sg13cmos5l_antennanp
XANTENNA_55 Tile_X0Y0_FrameData[20] VPWR VGND sg13cmos5l_antennanp
XANTENNA_66 Tile_X0Y0_FrameData[21] VPWR VGND sg13cmos5l_antennanp
XANTENNA_77 Tile_X0Y0_FrameData[22] VPWR VGND sg13cmos5l_antennanp
XANTENNA_88 Tile_X0Y0_FrameData[23] VPWR VGND sg13cmos5l_antennanp
XANTENNA_99 Tile_X0Y0_FrameData[3] VPWR VGND sg13cmos5l_antennanp
XANTENNA__194__X Tile_X1Y0_FrameStrobe_O[15] VPWR VGND sg13cmos5l_antennanp
XANTENNA__143__Q NPU_QUANT_SHIFT_IN28 VPWR VGND sg13cmos5l_antennanp
XFILLER_0_726 VPWR VGND sg13cmos5l_decap_8
XFILLER_16_616 VPWR VGND sg13cmos5l_decap_8
XFILLER_12_833 VPWR VGND sg13cmos5l_decap_8
XFILLER_15_126 VPWR VGND sg13cmos5l_decap_8
XFILLER_11_343 VPWR VGND sg13cmos5l_decap_8
XFILLER_11_376 VPWR VGND sg13cmos5l_decap_8
X_054_ _054_/Q Tile_X0Y0_FrameData[16] VGND VPWR Tile_X0Y0_FrameStrobe[0] latch
X_123_ NPU_QUANT_SHIFT_IN8 Tile_X0Y0_UserCLK _373_/X _186_/L_HI VPWR VGND sg13cmos5l_dfrbpq_1
XFILLER_7_28 VPWR VGND sg13cmos5l_decap_8
XANTENNA__279__X Tile_X0Y0_S4BEG[11] VPWR VGND sg13cmos5l_antennanp
XFILLER_11_70 VPWR VGND sg13cmos5l_decap_8
XFILLER_3_564 VPWR VGND sg13cmos5l_decap_8
XFILLER_16_7 VPWR VGND sg13cmos5l_decap_8
XFILLER_15_693 VPWR VGND sg13cmos5l_decap_8
XANTENNA__189__X Tile_X1Y0_FrameStrobe_O[10] VPWR VGND sg13cmos5l_antennanp
XANTENNA__138__Q NPU_QUANT_SHIFT_IN23 VPWR VGND sg13cmos5l_antennanp
XFILLER_13_608 VPWR VGND sg13cmos5l_decap_8
XFILLER_0_534 VPWR VGND sg13cmos5l_fill_1
XFILLER_16_413 VPWR VGND sg13cmos5l_decap_8
XFILLER_17_958 VPWR VGND sg13cmos5l_fill_2
XFILLER_17_947 VPWR VGND sg13cmos5l_fill_1
XFILLER_17_903 VPWR VGND sg13cmos5l_decap_8
XFILLER_11_140 VPWR VGND sg13cmos5l_decap_8
XFILLER_12_630 VPWR VGND sg13cmos5l_decap_8
XFILLER_8_656 VPWR VGND sg13cmos5l_decap_8
X_106_ _106_/Q Tile_X0Y0_FrameData[0] VGND VPWR Tile_X1Y0_FrameStrobe[0] latch
XFILLER_7_133 VPWR VGND sg13cmos5l_decap_8
XFILLER_15_490 VPWR VGND sg13cmos5l_decap_8
XFILLER_13_427 VPWR VGND sg13cmos5l_decap_8
XFILLER_4_125 VPWR VGND sg13cmos5l_decap_8
XFILLER_1_876 VPWR VGND sg13cmos5l_decap_8
XFILLER_1_865 VPWR VGND sg13cmos5l_fill_2
XFILLER_16_210 VPWR VGND sg13cmos5l_decap_8
XFILLER_16_287 VPWR VGND sg13cmos5l_decap_8
XFILLER_17_91 VPWR VGND sg13cmos5l_decap_8
XFILLER_17_777 VPWR VGND sg13cmos5l_decap_8
XFILLER_17_700 VPWR VGND sg13cmos5l_decap_8
XANTENNA__292__X Tile_X0Y0_SS4BEG[8] VPWR VGND sg13cmos5l_antennanp
XFILLER_9_921 VPWR VGND sg13cmos5l_decap_8
XFILLER_8_497 VPWR VGND sg13cmos5l_decap_8
XFILLER_8_420 VPWR VGND sg13cmos5l_decap_8
XFILLER_13_49 VPWR VGND sg13cmos5l_decap_8
XFILLER_2_618 VPWR VGND sg13cmos5l_decap_4
XFILLER_1_106 VPWR VGND sg13cmos5l_decap_8
XFILLER_1_117 VPWR VGND sg13cmos5l_fill_1
XFILLER_13_224 VPWR VGND sg13cmos5l_decap_8
XFILLER_14_736 VPWR VGND sg13cmos5l_decap_8
X_371_ _371_/X Tile_X0Y0_N4END[6] Tile_X0Y0_N4END[7] Tile_X0Y0_NN4END[4] Tile_X0Y0_NN4END[6]
+ _062_/Q _061_/Q VPWR VGND sg13cmos5l_mux4_1
XFILLER_9_217 VPWR VGND sg13cmos5l_decap_8
XFILLER_6_924 VPWR VGND sg13cmos5l_decap_8
XFILLER_6_957 VPWR VGND sg13cmos5l_fill_2
XANTENNA__287__X Tile_X0Y0_SS4BEG[3] VPWR VGND sg13cmos5l_antennanp
XFILLER_1_684 VPWR VGND sg13cmos5l_decap_8
XFILLER_17_574 VPWR VGND sg13cmos5l_decap_8
XANTENNA__197__X Tile_X1Y0_FrameStrobe_O[18] VPWR VGND sg13cmos5l_antennanp
XANTENNA__146__Q NPU_SWAP_WEIGHTS VPWR VGND sg13cmos5l_antennanp
XFILLER_10_205 VPWR VGND sg13cmos5l_decap_8
XFILLER_18_349 VPWR VGND sg13cmos5l_fill_1
XFILLER_18_305 VPWR VGND sg13cmos5l_decap_8
XANTENNA_101 Tile_X0Y0_FrameData[3] VPWR VGND sg13cmos5l_antennanp
XANTENNA_112 Tile_X0Y0_FrameData[4] VPWR VGND sg13cmos5l_antennanp
XANTENNA_123 Tile_X0Y0_FrameData[5] VPWR VGND sg13cmos5l_antennanp
XANTENNA_134 Tile_X0Y0_FrameData[7] VPWR VGND sg13cmos5l_antennanp
XANTENNA_145 Tile_X0Y0_NN4END[2] VPWR VGND sg13cmos5l_antennanp
XANTENNA_156 Tile_X1Y0_FrameStrobe[4] VPWR VGND sg13cmos5l_antennanp
XANTENNA_167 Tile_X0Y0_FrameData[25] VPWR VGND sg13cmos5l_antennanp
XANTENNA_178 Tile_X0Y0_FrameData[25] VPWR VGND sg13cmos5l_antennanp
XANTENNA_189 Tile_X0Y0_FrameData[28] VPWR VGND sg13cmos5l_antennanp
XFILLER_14_511 VPWR VGND sg13cmos5l_decap_8
XFILLER_14_588 VPWR VGND sg13cmos5l_decap_8
X_354_ Tile_X0Y0_FrameStrobe_O[18] Tile_X0Y0_FrameStrobe[18] VPWR VGND sg13cmos5l_buf_1
XFILLER_14_70 VPWR VGND sg13cmos5l_decap_8
X_285_ Tile_X0Y0_SS4BEG[1] Tile_X0Y0_NN4END[14] VPWR VGND sg13cmos5l_buf_1
XFILLER_6_787 VPWR VGND sg13cmos5l_fill_2
XFILLER_6_776 VPWR VGND sg13cmos5l_decap_4
XFILLER_5_231 VPWR VGND sg13cmos5l_decap_8
XFILLER_1_470 VPWR VGND sg13cmos5l_fill_1
XFILLER_17_371 VPWR VGND sg13cmos5l_decap_8
XFILLER_9_570 VPWR VGND sg13cmos5l_decap_8
XFILLER_15_308 VPWR VGND sg13cmos5l_decap_8
XFILLER_11_558 VPWR VGND sg13cmos5l_decap_8
X_070_ _070_/Q Tile_X0Y0_FrameData[0] VGND VPWR Tile_X0Y0_FrameStrobe[0] latch
XFILLER_2_245 VPWR VGND sg13cmos5l_decap_8
XFILLER_18_168 VPWR VGND sg13cmos5l_decap_8
XFILLER_18_157 VPWR VGND sg13cmos5l_fill_1
XFILLER_18_146 VPWR VGND sg13cmos5l_decap_8
XFILLER_18_113 VPWR VGND sg13cmos5l_decap_8
XFILLER_14_385 VPWR VGND sg13cmos5l_decap_8
XFILLER_15_875 VPWR VGND sg13cmos5l_decap_8
X_337_ Tile_X0Y0_FrameStrobe_O[1] Tile_X0Y0_FrameStrobe[1] VPWR VGND sg13cmos5l_buf_1
X_199_ Tile_X0Y0_S2BEG[0] Tile_X0Y0_N2MID[7] VPWR VGND sg13cmos5l_buf_1
X_268_ Tile_X0Y0_S4BEG[0] Tile_X0Y0_N4END[15] VPWR VGND sg13cmos5l_buf_1
XFILLER_6_540 VPWR VGND sg13cmos5l_decap_8
XFILLER_2_84 VPWR VGND sg13cmos5l_decap_8
XANTENNA_12 Tile_X0Y0_FrameData[0] VPWR VGND sg13cmos5l_antennanp
XANTENNA_23 Tile_X0Y0_FrameData[12] VPWR VGND sg13cmos5l_antennanp
XANTENNA_34 Tile_X0Y0_FrameData[14] VPWR VGND sg13cmos5l_antennanp
XANTENNA_45 Tile_X0Y0_FrameData[19] VPWR VGND sg13cmos5l_antennanp
XANTENNA_56 Tile_X0Y0_FrameData[20] VPWR VGND sg13cmos5l_antennanp
XANTENNA_67 Tile_X0Y0_FrameData[21] VPWR VGND sg13cmos5l_antennanp
XANTENNA_78 Tile_X0Y0_FrameData[22] VPWR VGND sg13cmos5l_antennanp
XANTENNA_89 Tile_X0Y0_FrameData[2] VPWR VGND sg13cmos5l_antennanp
XFILLER_0_705 VPWR VGND sg13cmos5l_fill_2
XFILLER_15_105 VPWR VGND sg13cmos5l_decap_8
XFILLER_11_322 VPWR VGND sg13cmos5l_decap_8
XFILLER_11_355 VPWR VGND sg13cmos5l_decap_8
XFILLER_12_812 VPWR VGND sg13cmos5l_decap_8
XFILLER_12_889 VPWR VGND sg13cmos5l_decap_8
X_053_ _053_/Q Tile_X0Y0_FrameData[17] VGND VPWR Tile_X0Y0_FrameStrobe[0] latch
X_122_ NPU_QUANT_SHIFT_IN7 Tile_X0Y0_UserCLK _372_/X _185_/L_HI VPWR VGND sg13cmos5l_dfrbpq_1
XFILLER_3_532 VPWR VGND sg13cmos5l_decap_8
XFILLER_2_0 VPWR VGND sg13cmos5l_decap_8
XANTENNA__295__X Tile_X0Y0_SS4BEG[11] VPWR VGND sg13cmos5l_antennanp
XFILLER_15_672 VPWR VGND sg13cmos5l_decap_8
XFILLER_14_182 VPWR VGND sg13cmos5l_decap_8
XFILLER_6_381 VPWR VGND sg13cmos5l_fill_1
XFILLER_12_119 VPWR VGND sg13cmos5l_decap_8
XFILLER_16_49 VPWR VGND sg13cmos5l_decap_8
XFILLER_0_502 VPWR VGND sg13cmos5l_decap_8
XFILLER_16_469 VPWR VGND sg13cmos5l_decap_8
XFILLER_11_196 VPWR VGND sg13cmos5l_decap_8
XFILLER_12_686 VPWR VGND sg13cmos5l_decap_8
X_105_ _105_/Q Tile_X0Y0_FrameData[1] VGND VPWR Tile_X1Y0_FrameStrobe[0] latch
XFILLER_7_112 VPWR VGND sg13cmos5l_decap_8
XFILLER_7_189 VPWR VGND sg13cmos5l_decap_8
XANTENNA__149__Q NPU_ARRAY_EN VPWR VGND sg13cmos5l_antennanp
XFILLER_13_406 VPWR VGND sg13cmos5l_decap_8
XFILLER_14_918 VPWR VGND sg13cmos5l_decap_8
XFILLER_5_616 VPWR VGND sg13cmos5l_decap_8
XFILLER_4_104 VPWR VGND sg13cmos5l_decap_8
XFILLER_16_266 VPWR VGND sg13cmos5l_decap_8
XFILLER_9_900 VPWR VGND sg13cmos5l_decap_8
XFILLER_17_756 VPWR VGND sg13cmos5l_decap_8
XFILLER_17_70 VPWR VGND sg13cmos5l_decap_8
XFILLER_12_483 VPWR VGND sg13cmos5l_decap_8
XFILLER_8_476 VPWR VGND sg13cmos5l_decap_8
XFILLER_4_693 VPWR VGND sg13cmos5l_decap_4
XFILLER_13_28 VPWR VGND sg13cmos5l_decap_8
XFILLER_13_203 VPWR VGND sg13cmos5l_decap_8
XFILLER_14_715 VPWR VGND sg13cmos5l_decap_8
X_370_ _370_/X Tile_X0Y0_N4END[5] Tile_X0Y0_N4END[6] Tile_X0Y0_NN4END[5] Tile_X0Y0_NN4END[7]
+ _064_/Q _063_/Q VPWR VGND sg13cmos5l_mux4_1
XFILLER_10_910 VPWR VGND sg13cmos5l_decap_8
XFILLER_6_903 VPWR VGND sg13cmos5l_decap_8
XFILLER_1_696 VPWR VGND sg13cmos5l_decap_8
XFILLER_0_184 VPWR VGND sg13cmos5l_decap_8
XFILLER_17_553 VPWR VGND sg13cmos5l_decap_8
XFILLER_12_280 VPWR VGND sg13cmos5l_decap_8
XFILLER_9_785 VPWR VGND sg13cmos5l_fill_1
XFILLER_8_273 VPWR VGND sg13cmos5l_decap_8
XFILLER_5_84 VPWR VGND sg13cmos5l_decap_8
XFILLER_11_707 VPWR VGND sg13cmos5l_decap_8
XFILLER_11_718 VPWR VGND sg13cmos5l_fill_1
XFILLER_11_729 VPWR VGND sg13cmos5l_decap_8
XFILLER_6_7 VPWR VGND sg13cmos5l_decap_8
XFILLER_3_928 VPWR VGND sg13cmos5l_fill_1
XFILLER_2_449 VPWR VGND sg13cmos5l_decap_8
XFILLER_2_438 VPWR VGND sg13cmos5l_decap_8
XANTENNA_102 Tile_X0Y0_FrameData[3] VPWR VGND sg13cmos5l_antennanp
XANTENNA_113 Tile_X0Y0_FrameData[4] VPWR VGND sg13cmos5l_antennanp
XANTENNA_124 Tile_X0Y0_FrameData[5] VPWR VGND sg13cmos5l_antennanp
XANTENNA_135 Tile_X0Y0_FrameData[7] VPWR VGND sg13cmos5l_antennanp
XANTENNA_146 Tile_X0Y0_NN4END[2] VPWR VGND sg13cmos5l_antennanp
XANTENNA_157 Tile_X1Y0_FrameStrobe[5] VPWR VGND sg13cmos5l_antennanp
XANTENNA_168 Tile_X0Y0_FrameData[25] VPWR VGND sg13cmos5l_antennanp
XANTENNA_179 Tile_X0Y0_FrameData[28] VPWR VGND sg13cmos5l_antennanp
XFILLER_14_567 VPWR VGND sg13cmos5l_decap_8
X_284_ Tile_X0Y0_SS4BEG[0] Tile_X0Y0_NN4END[15] VPWR VGND sg13cmos5l_buf_1
X_353_ Tile_X0Y0_FrameStrobe_O[17] Tile_X0Y0_FrameStrobe[17] VPWR VGND sg13cmos5l_buf_1
XFILLER_6_744 VPWR VGND sg13cmos5l_decap_8
XFILLER_6_733 VPWR VGND sg13cmos5l_fill_1
XFILLER_5_287 VPWR VGND sg13cmos5l_decap_4
XFILLER_5_210 VPWR VGND sg13cmos5l_decap_8
XANTENNA__298__X Tile_X0Y0_SS4BEG[14] VPWR VGND sg13cmos5l_antennanp
XFILLER_1_482 VPWR VGND sg13cmos5l_fill_2
XFILLER_18_884 VPWR VGND sg13cmos5l_decap_8
XFILLER_17_350 VPWR VGND sg13cmos5l_decap_8
XFILLER_11_537 VPWR VGND sg13cmos5l_decap_8
XFILLER_3_714 VPWR VGND sg13cmos5l_fill_2
XFILLER_3_703 VPWR VGND sg13cmos5l_fill_1
XFILLER_2_224 VPWR VGND sg13cmos5l_decap_8
XFILLER_15_854 VPWR VGND sg13cmos5l_decap_8
XFILLER_18_103 VPWR VGND sg13cmos5l_decap_8
XFILLER_10_581 VPWR VGND sg13cmos5l_decap_8
XFILLER_14_364 VPWR VGND sg13cmos5l_decap_8
X_267_ Tile_X0Y0_S2BEGb[7] Tile_X0Y0_N2END[0] VPWR VGND sg13cmos5l_buf_1
X_336_ Tile_X0Y0_FrameStrobe_O[0] Tile_X0Y0_FrameStrobe[0] VPWR VGND sg13cmos5l_buf_1
X_198_ Tile_X1Y0_FrameStrobe_O[19] Tile_X1Y0_FrameStrobe[19] VPWR VGND sg13cmos5l_buf_1
XFILLER_2_791 VPWR VGND sg13cmos5l_decap_8
XFILLER_2_63 VPWR VGND sg13cmos5l_decap_8
XANTENNA_13 Tile_X0Y0_FrameData[0] VPWR VGND sg13cmos5l_antennanp
XANTENNA_24 Tile_X0Y0_FrameData[12] VPWR VGND sg13cmos5l_antennanp
XANTENNA_35 Tile_X0Y0_FrameData[18] VPWR VGND sg13cmos5l_antennanp
XANTENNA_46 Tile_X0Y0_FrameData[19] VPWR VGND sg13cmos5l_antennanp
XANTENNA_57 Tile_X0Y0_FrameData[20] VPWR VGND sg13cmos5l_antennanp
XANTENNA_68 Tile_X0Y0_FrameData[21] VPWR VGND sg13cmos5l_antennanp
XANTENNA_79 Tile_X0Y0_FrameData[22] VPWR VGND sg13cmos5l_antennanp
XFILLER_11_301 VPWR VGND sg13cmos5l_decap_8
XFILLER_12_868 VPWR VGND sg13cmos5l_decap_8
X_121_ NPU_QUANT_SHIFT_IN6 Tile_X0Y0_UserCLK _371_/X _184_/L_HI VPWR VGND sg13cmos5l_dfrbpq_1
XFILLER_8_828 VPWR VGND sg13cmos5l_fill_2
X_052_ _052_/Q Tile_X0Y0_FrameData[18] VGND VPWR Tile_X0Y0_FrameStrobe[0] latch
XFILLER_3_599 VPWR VGND sg13cmos5l_decap_8
XFILLER_14_161 VPWR VGND sg13cmos5l_decap_8
XFILLER_15_651 VPWR VGND sg13cmos5l_decap_8
XFILLER_11_890 VPWR VGND sg13cmos5l_decap_8
X_319_ Tile_X1Y0_FrameData_O[15] Tile_X0Y0_FrameData[15] VPWR VGND sg13cmos5l_buf_1
XFILLER_7_883 VPWR VGND sg13cmos5l_decap_8
XFILLER_16_28 VPWR VGND sg13cmos5l_decap_8
XFILLER_16_448 VPWR VGND sg13cmos5l_decap_8
XFILLER_17_938 VPWR VGND sg13cmos5l_decap_8
XFILLER_11_175 VPWR VGND sg13cmos5l_decap_8
XFILLER_12_665 VPWR VGND sg13cmos5l_decap_8
X_104_ _104_/Q Tile_X0Y0_FrameData[2] VGND VPWR Tile_X1Y0_FrameStrobe[0] latch
XFILLER_8_614 VPWR VGND sg13cmos5l_decap_8
XFILLER_7_168 VPWR VGND sg13cmos5l_decap_8
XFILLER_4_842 VPWR VGND sg13cmos5l_fill_1
XFILLER_4_831 VPWR VGND sg13cmos5l_decap_8
XFILLER_8_84 VPWR VGND sg13cmos5l_decap_8
XFILLER_17_735 VPWR VGND sg13cmos5l_decap_8
XFILLER_12_462 VPWR VGND sg13cmos5l_decap_8
XFILLER_16_245 VPWR VGND sg13cmos5l_decap_8
XFILLER_8_455 VPWR VGND sg13cmos5l_decap_8
XFILLER_3_182 VPWR VGND sg13cmos5l_decap_4
XFILLER_13_259 VPWR VGND sg13cmos5l_decap_8
XFILLER_6_959 VPWR VGND sg13cmos5l_fill_1
XFILLER_5_469 VPWR VGND sg13cmos5l_fill_1
XFILLER_0_163 VPWR VGND sg13cmos5l_decap_8
XFILLER_1_653 VPWR VGND sg13cmos5l_fill_2
XFILLER_1_631 VPWR VGND sg13cmos5l_decap_8
XFILLER_17_532 VPWR VGND sg13cmos5l_decap_8
XFILLER_9_753 VPWR VGND sg13cmos5l_fill_1
XFILLER_9_742 VPWR VGND sg13cmos5l_decap_8
XFILLER_8_252 VPWR VGND sg13cmos5l_decap_8
XFILLER_5_63 VPWR VGND sg13cmos5l_decap_8
XFILLER_10_0 VPWR VGND sg13cmos5l_decap_8
XFILLER_3_907 VPWR VGND sg13cmos5l_decap_8
XANTENNA_103 Tile_X0Y0_FrameData[3] VPWR VGND sg13cmos5l_antennanp
XANTENNA_114 Tile_X0Y0_FrameData[4] VPWR VGND sg13cmos5l_antennanp
XANTENNA_125 Tile_X0Y0_FrameData[5] VPWR VGND sg13cmos5l_antennanp
XANTENNA_136 Tile_X0Y0_N4END[6] VPWR VGND sg13cmos5l_antennanp
XANTENNA_147 Tile_X0Y0_NN4END[2] VPWR VGND sg13cmos5l_antennanp
XANTENNA_158 Tile_X1Y0_FrameStrobe[6] VPWR VGND sg13cmos5l_antennanp
XANTENNA_169 Tile_X0Y0_FrameData[25] VPWR VGND sg13cmos5l_antennanp
XFILLER_14_546 VPWR VGND sg13cmos5l_decap_8
X_283_ Tile_X0Y0_S4BEG[15] Tile_X0Y0_N4END[0] VPWR VGND sg13cmos5l_buf_1
X_352_ Tile_X0Y0_FrameStrobe_O[16] Tile_X0Y0_FrameStrobe[16] VPWR VGND sg13cmos5l_buf_1
XFILLER_6_767 VPWR VGND sg13cmos5l_fill_2
XFILLER_5_266 VPWR VGND sg13cmos5l_decap_8
XFILLER_18_863 VPWR VGND sg13cmos5l_decap_8
XFILLER_11_516 VPWR VGND sg13cmos5l_decap_8
XFILLER_7_509 VPWR VGND sg13cmos5l_decap_8
XFILLER_14_343 VPWR VGND sg13cmos5l_decap_8
XFILLER_15_833 VPWR VGND sg13cmos5l_decap_8
XFILLER_18_137 VPWR VGND sg13cmos5l_decap_4
XFILLER_10_560 VPWR VGND sg13cmos5l_decap_8
X_197_ Tile_X1Y0_FrameStrobe_O[18] Tile_X1Y0_FrameStrobe[18] VPWR VGND sg13cmos5l_buf_1
X_266_ Tile_X0Y0_S2BEGb[6] Tile_X0Y0_N2END[1] VPWR VGND sg13cmos5l_buf_1
X_335_ Tile_X1Y0_FrameData_O[31] Tile_X0Y0_FrameData[31] VPWR VGND sg13cmos5l_buf_1
XFILLER_6_597 VPWR VGND sg13cmos5l_decap_8
XFILLER_2_770 VPWR VGND sg13cmos5l_decap_8
XFILLER_2_42 VPWR VGND sg13cmos5l_decap_8
XANTENNA_14 Tile_X0Y0_FrameData[0] VPWR VGND sg13cmos5l_antennanp
XANTENNA_25 Tile_X0Y0_FrameData[12] VPWR VGND sg13cmos5l_antennanp
XANTENNA_36 Tile_X0Y0_FrameData[18] VPWR VGND sg13cmos5l_antennanp
XANTENNA_47 Tile_X0Y0_FrameData[19] VPWR VGND sg13cmos5l_antennanp
XANTENNA_58 Tile_X0Y0_FrameData[20] VPWR VGND sg13cmos5l_antennanp
XANTENNA_69 Tile_X0Y0_FrameData[21] VPWR VGND sg13cmos5l_antennanp
XFILLER_9_391 VPWR VGND sg13cmos5l_fill_2
XFILLER_12_847 VPWR VGND sg13cmos5l_decap_8
X_051_ _051_/Q Tile_X0Y0_FrameData[19] VGND VPWR Tile_X0Y0_FrameStrobe[0] latch
X_120_ NPU_QUANT_SHIFT_IN5 Tile_X0Y0_UserCLK _370_/X _156_/L_HI VPWR VGND sg13cmos5l_dfrbpq_1
XFILLER_7_339 VPWR VGND sg13cmos5l_decap_4
XFILLER_11_84 VPWR VGND sg13cmos5l_decap_8
XFILLER_14_140 VPWR VGND sg13cmos5l_decap_8
XFILLER_15_630 VPWR VGND sg13cmos5l_decap_8
X_249_ Tile_X1Y0_SS4BEG[6] Tile_X1Y0_NN4END[9] VPWR VGND sg13cmos5l_buf_1
X_318_ Tile_X1Y0_FrameData_O[14] Tile_X0Y0_FrameData[14] VPWR VGND sg13cmos5l_buf_1
XFILLER_7_895 VPWR VGND sg13cmos5l_decap_8
XFILLER_17_917 VPWR VGND sg13cmos5l_decap_8
XFILLER_12_644 VPWR VGND sg13cmos5l_decap_8
XFILLER_16_427 VPWR VGND sg13cmos5l_decap_8
XFILLER_11_154 VPWR VGND sg13cmos5l_decap_8
X_103_ _103_/Q Tile_X0Y0_FrameData[3] VGND VPWR Tile_X1Y0_FrameStrobe[0] latch
XFILLER_7_147 VPWR VGND sg13cmos5l_decap_8
XFILLER_4_887 VPWR VGND sg13cmos5l_decap_8
XFILLER_14_7 VPWR VGND sg13cmos5l_decap_8
XFILLER_8_63 VPWR VGND sg13cmos5l_decap_8
XFILLER_4_139 VPWR VGND sg13cmos5l_decap_8
XFILLER_1_813 VPWR VGND sg13cmos5l_decap_8
XANTENNA__200__X Tile_X0Y0_S2BEG[1] VPWR VGND sg13cmos5l_antennanp
XFILLER_16_224 VPWR VGND sg13cmos5l_decap_8
XFILLER_17_714 VPWR VGND sg13cmos5l_decap_8
XFILLER_12_441 VPWR VGND sg13cmos5l_decap_8
XFILLER_8_434 VPWR VGND sg13cmos5l_decap_8
XFILLER_3_161 VPWR VGND sg13cmos5l_decap_8
XFILLER_16_791 VPWR VGND sg13cmos5l_decap_8
XFILLER_13_238 VPWR VGND sg13cmos5l_decap_8
XFILLER_5_448 VPWR VGND sg13cmos5l_decap_8
XFILLER_5_437 VPWR VGND sg13cmos5l_fill_1
XFILLER_5_426 VPWR VGND sg13cmos5l_decap_8
XFILLER_0_142 VPWR VGND sg13cmos5l_decap_8
XFILLER_17_588 VPWR VGND sg13cmos5l_decap_8
XFILLER_17_511 VPWR VGND sg13cmos5l_decap_8
XFILLER_13_783 VPWR VGND sg13cmos5l_decap_8
XFILLER_8_231 VPWR VGND sg13cmos5l_decap_8
XFILLER_5_42 VPWR VGND sg13cmos5l_decap_8
XFILLER_10_219 VPWR VGND sg13cmos5l_decap_8
XANTENNA_104 Tile_X0Y0_FrameData[3] VPWR VGND sg13cmos5l_antennanp
XANTENNA_115 Tile_X0Y0_FrameData[4] VPWR VGND sg13cmos5l_antennanp
XANTENNA_126 Tile_X0Y0_FrameData[5] VPWR VGND sg13cmos5l_antennanp
XANTENNA_137 Tile_X0Y0_N4END[6] VPWR VGND sg13cmos5l_antennanp
XANTENNA_148 Tile_X1Y0_FrameStrobe[10] VPWR VGND sg13cmos5l_antennanp
XANTENNA_159 Tile_X1Y0_FrameStrobe[7] VPWR VGND sg13cmos5l_antennanp
XFILLER_14_525 VPWR VGND sg13cmos5l_decap_8
X_351_ Tile_X0Y0_FrameStrobe_O[15] Tile_X0Y0_FrameStrobe[15] VPWR VGND sg13cmos5l_buf_1
XFILLER_18_319 VPWR VGND sg13cmos5l_decap_8
XFILLER_14_84 VPWR VGND sg13cmos5l_decap_8
X_282_ Tile_X0Y0_S4BEG[14] Tile_X0Y0_N4END[1] VPWR VGND sg13cmos5l_buf_1
XFILLER_5_245 VPWR VGND sg13cmos5l_decap_8
XFILLER_2_941 VPWR VGND sg13cmos5l_decap_4
XFILLER_2_930 VPWR VGND sg13cmos5l_decap_8
XFILLER_1_451 VPWR VGND sg13cmos5l_decap_8
XFILLER_18_842 VPWR VGND sg13cmos5l_decap_8
XFILLER_13_580 VPWR VGND sg13cmos5l_decap_8
XFILLER_17_385 VPWR VGND sg13cmos5l_decap_8
XFILLER_9_584 VPWR VGND sg13cmos5l_decap_8
XFILLER_2_259 VPWR VGND sg13cmos5l_fill_2
XFILLER_18_127 VPWR VGND sg13cmos5l_decap_8
XFILLER_14_322 VPWR VGND sg13cmos5l_decap_8
XFILLER_14_399 VPWR VGND sg13cmos5l_decap_8
XFILLER_15_812 VPWR VGND sg13cmos5l_decap_8
XFILLER_15_889 VPWR VGND sg13cmos5l_decap_8
X_334_ Tile_X1Y0_FrameData_O[30] Tile_X0Y0_FrameData[30] VPWR VGND sg13cmos5l_buf_1
X_196_ Tile_X1Y0_FrameStrobe_O[17] Tile_X1Y0_FrameStrobe[17] VPWR VGND sg13cmos5l_buf_1
X_265_ Tile_X0Y0_S2BEGb[5] Tile_X0Y0_N2END[2] VPWR VGND sg13cmos5l_buf_1
XFILLER_2_21 VPWR VGND sg13cmos5l_decap_8
XFILLER_17_182 VPWR VGND sg13cmos5l_decap_8
XFILLER_2_98 VPWR VGND sg13cmos5l_decap_8
XFILLER_18_683 VPWR VGND sg13cmos5l_decap_8
XANTENNA_15 Tile_X0Y0_FrameData[0] VPWR VGND sg13cmos5l_antennanp
XANTENNA_26 Tile_X0Y0_FrameData[14] VPWR VGND sg13cmos5l_antennanp
XANTENNA_37 Tile_X0Y0_FrameData[18] VPWR VGND sg13cmos5l_antennanp
XANTENNA_48 Tile_X0Y0_FrameData[19] VPWR VGND sg13cmos5l_antennanp
XANTENNA_59 Tile_X0Y0_FrameData[20] VPWR VGND sg13cmos5l_antennanp
XFILLER_12_826 VPWR VGND sg13cmos5l_decap_8
XFILLER_15_119 VPWR VGND sg13cmos5l_decap_8
XFILLER_16_609 VPWR VGND sg13cmos5l_decap_8
XFILLER_11_336 VPWR VGND sg13cmos5l_decap_8
XFILLER_11_369 VPWR VGND sg13cmos5l_decap_8
X_050_ _050_/Q Tile_X0Y0_FrameData[20] VGND VPWR Tile_X0Y0_FrameStrobe[0] latch
XANTENNA__203__X Tile_X0Y0_S2BEG[4] VPWR VGND sg13cmos5l_antennanp
XFILLER_11_63 VPWR VGND sg13cmos5l_decap_8
XFILLER_14_196 VPWR VGND sg13cmos5l_decap_8
XFILLER_15_686 VPWR VGND sg13cmos5l_decap_8
X_317_ Tile_X1Y0_FrameData_O[13] Tile_X0Y0_FrameData[13] VPWR VGND sg13cmos5l_buf_1
X_179_ _179_/L_HI VPWR VGND sg13cmos5l_tiehi
X_248_ Tile_X1Y0_SS4BEG[5] Tile_X1Y0_NN4END[10] VPWR VGND sg13cmos5l_buf_1
XFILLER_16_406 VPWR VGND sg13cmos5l_decap_8
XFILLER_11_133 VPWR VGND sg13cmos5l_decap_8
XFILLER_12_623 VPWR VGND sg13cmos5l_decap_8
X_102_ _102_/Q Tile_X0Y0_FrameData[4] VGND VPWR Tile_X1Y0_FrameStrobe[0] latch
XFILLER_7_126 VPWR VGND sg13cmos5l_decap_8
XFILLER_0_0 VPWR VGND sg13cmos5l_decap_8
XFILLER_15_483 VPWR VGND sg13cmos5l_decap_8
XFILLER_8_42 VPWR VGND sg13cmos5l_decap_8
XFILLER_4_118 VPWR VGND sg13cmos5l_decap_8
XFILLER_1_858 VPWR VGND sg13cmos5l_decap_8
XFILLER_16_203 VPWR VGND sg13cmos5l_decap_8
XFILLER_17_84 VPWR VGND sg13cmos5l_decap_8
XFILLER_12_420 VPWR VGND sg13cmos5l_decap_8
XFILLER_12_497 VPWR VGND sg13cmos5l_decap_8
XFILLER_9_914 VPWR VGND sg13cmos5l_decap_8
XFILLER_9_958 VPWR VGND sg13cmos5l_fill_2
XFILLER_8_413 VPWR VGND sg13cmos5l_decap_8
XFILLER_4_630 VPWR VGND sg13cmos5l_decap_4
XFILLER_3_140 VPWR VGND sg13cmos5l_decap_8
XFILLER_15_280 VPWR VGND sg13cmos5l_decap_8
XFILLER_16_770 VPWR VGND sg13cmos5l_decap_8
XANTENNA__301__X Tile_X0Y0_S1BEG[1] VPWR VGND sg13cmos5l_antennanp
XFILLER_14_729 VPWR VGND sg13cmos5l_decap_8
XFILLER_10_924 VPWR VGND sg13cmos5l_decap_8
XFILLER_13_217 VPWR VGND sg13cmos5l_decap_8
XFILLER_6_917 VPWR VGND sg13cmos5l_decap_8
XFILLER_0_110 VPWR VGND sg13cmos5l_decap_8
XANTENNA__211__X Tile_X1Y0_S2BEG[0] VPWR VGND sg13cmos5l_antennanp
XFILLER_0_198 VPWR VGND sg13cmos5l_decap_8
XFILLER_13_762 VPWR VGND sg13cmos5l_decap_8
XFILLER_17_567 VPWR VGND sg13cmos5l_decap_8
XFILLER_12_294 VPWR VGND sg13cmos5l_decap_8
XFILLER_9_733 VPWR VGND sg13cmos5l_fill_2
XFILLER_9_722 VPWR VGND sg13cmos5l_decap_8
XFILLER_8_210 VPWR VGND sg13cmos5l_decap_8
XFILLER_5_21 VPWR VGND sg13cmos5l_decap_8
XFILLER_5_98 VPWR VGND sg13cmos5l_decap_8
XFILLER_4_493 VPWR VGND sg13cmos5l_decap_8
XANTENNA_105 Tile_X0Y0_FrameData[3] VPWR VGND sg13cmos5l_antennanp
XANTENNA_116 Tile_X0Y0_FrameData[4] VPWR VGND sg13cmos5l_antennanp
XANTENNA_127 Tile_X0Y0_FrameData[7] VPWR VGND sg13cmos5l_antennanp
XANTENNA_138 Tile_X0Y0_N4END[6] VPWR VGND sg13cmos5l_antennanp
XANTENNA_149 Tile_X1Y0_FrameStrobe[11] VPWR VGND sg13cmos5l_antennanp
XFILLER_14_504 VPWR VGND sg13cmos5l_decap_8
X_350_ Tile_X0Y0_FrameStrobe_O[14] Tile_X0Y0_FrameStrobe[14] VPWR VGND sg13cmos5l_buf_1
XANTENNA__206__X Tile_X0Y0_S2BEG[7] VPWR VGND sg13cmos5l_antennanp
XFILLER_14_63 VPWR VGND sg13cmos5l_decap_8
X_281_ Tile_X0Y0_S4BEG[13] Tile_X0Y0_N4END[2] VPWR VGND sg13cmos5l_buf_1
XFILLER_5_224 VPWR VGND sg13cmos5l_decap_8
XFILLER_18_821 VPWR VGND sg13cmos5l_decap_8
XFILLER_17_364 VPWR VGND sg13cmos5l_decap_8
XFILLER_18_898 VPWR VGND sg13cmos5l_decap_8
XFILLER_9_563 VPWR VGND sg13cmos5l_decap_8
XFILLER_4_7 VPWR VGND sg13cmos5l_decap_8
XFILLER_3_739 VPWR VGND sg13cmos5l_fill_1
XFILLER_2_238 VPWR VGND sg13cmos5l_decap_8
XFILLER_14_301 VPWR VGND sg13cmos5l_decap_8
XFILLER_14_378 VPWR VGND sg13cmos5l_decap_8
XFILLER_15_868 VPWR VGND sg13cmos5l_decap_8
X_264_ Tile_X0Y0_S2BEGb[4] Tile_X0Y0_N2END[3] VPWR VGND sg13cmos5l_buf_1
X_333_ Tile_X1Y0_FrameData_O[29] Tile_X0Y0_FrameData[29] VPWR VGND sg13cmos5l_buf_1
XFILLER_10_595 VPWR VGND sg13cmos5l_decap_8
X_195_ Tile_X1Y0_FrameStrobe_O[16] Tile_X1Y0_FrameStrobe[16] VPWR VGND sg13cmos5l_buf_1
XFILLER_6_533 VPWR VGND sg13cmos5l_decap_8
XFILLER_2_77 VPWR VGND sg13cmos5l_decap_8
XFILLER_17_161 VPWR VGND sg13cmos5l_decap_8
XFILLER_18_662 VPWR VGND sg13cmos5l_decap_8
XANTENNA_16 Tile_X0Y0_FrameData[0] VPWR VGND sg13cmos5l_antennanp
XANTENNA_27 Tile_X0Y0_FrameData[14] VPWR VGND sg13cmos5l_antennanp
XANTENNA_38 Tile_X0Y0_FrameData[18] VPWR VGND sg13cmos5l_antennanp
XANTENNA_49 Tile_X0Y0_FrameData[19] VPWR VGND sg13cmos5l_antennanp
XFILLER_14_890 VPWR VGND sg13cmos5l_decap_8
XFILLER_9_393 VPWR VGND sg13cmos5l_fill_1
XFILLER_11_315 VPWR VGND sg13cmos5l_decap_8
XFILLER_12_805 VPWR VGND sg13cmos5l_decap_8
XFILLER_11_42 VPWR VGND sg13cmos5l_decap_8
XFILLER_14_175 VPWR VGND sg13cmos5l_decap_8
XFILLER_15_665 VPWR VGND sg13cmos5l_decap_8
X_247_ Tile_X1Y0_SS4BEG[4] Tile_X1Y0_NN4END[11] VPWR VGND sg13cmos5l_buf_1
X_316_ Tile_X1Y0_FrameData_O[12] Tile_X0Y0_FrameData[12] VPWR VGND sg13cmos5l_buf_1
XFILLER_10_392 VPWR VGND sg13cmos5l_decap_8
X_178_ _178_/L_HI VPWR VGND sg13cmos5l_tiehi
XFILLER_18_481 VPWR VGND sg13cmos5l_decap_8
XFILLER_18_470 VPWR VGND sg13cmos5l_fill_1
XANTENNA__304__X Tile_X1Y0_FrameData_O[0] VPWR VGND sg13cmos5l_antennanp
XFILLER_11_112 VPWR VGND sg13cmos5l_decap_8
XFILLER_11_189 VPWR VGND sg13cmos5l_decap_8
XFILLER_12_602 VPWR VGND sg13cmos5l_decap_8
XFILLER_12_679 VPWR VGND sg13cmos5l_decap_8
X_101_ _101_/Q Tile_X0Y0_FrameData[5] VGND VPWR Tile_X1Y0_FrameStrobe[0] latch
XFILLER_7_105 VPWR VGND sg13cmos5l_decap_8
XANTENNA__214__X Tile_X1Y0_S2BEG[3] VPWR VGND sg13cmos5l_antennanp
XFILLER_3_399 VPWR VGND sg13cmos5l_fill_2
XFILLER_15_462 VPWR VGND sg13cmos5l_decap_8
XFILLER_8_98 VPWR VGND sg13cmos5l_decap_8
XFILLER_8_21 VPWR VGND sg13cmos5l_decap_8
XFILLER_7_661 VPWR VGND sg13cmos5l_decap_8
XFILLER_6_182 VPWR VGND sg13cmos5l_decap_8
XFILLER_5_609 VPWR VGND sg13cmos5l_decap_8
XFILLER_0_347 VPWR VGND sg13cmos5l_fill_1
XANTENNA__209__X Tile_X1Y0_S1BEG[2] VPWR VGND sg13cmos5l_antennanp
XFILLER_16_259 VPWR VGND sg13cmos5l_decap_8
XFILLER_17_749 VPWR VGND sg13cmos5l_decap_8
XFILLER_17_63 VPWR VGND sg13cmos5l_decap_8
XFILLER_12_476 VPWR VGND sg13cmos5l_decap_8
XFILLER_8_469 VPWR VGND sg13cmos5l_decap_8
XFILLER_4_686 VPWR VGND sg13cmos5l_decap_8
XFILLER_14_708 VPWR VGND sg13cmos5l_decap_8
XFILLER_10_903 VPWR VGND sg13cmos5l_decap_8
XFILLER_10_958 VPWR VGND sg13cmos5l_fill_2
XFILLER_1_645 VPWR VGND sg13cmos5l_fill_1
XFILLER_0_177 VPWR VGND sg13cmos5l_decap_8
XFILLER_17_546 VPWR VGND sg13cmos5l_decap_8
XFILLER_13_741 VPWR VGND sg13cmos5l_decap_8
XFILLER_12_273 VPWR VGND sg13cmos5l_decap_8
XFILLER_8_266 VPWR VGND sg13cmos5l_decap_8
XFILLER_5_77 VPWR VGND sg13cmos5l_decap_8
XANTENNA__312__X Tile_X1Y0_FrameData_O[8] VPWR VGND sg13cmos5l_antennanp
XANTENNA_106 Tile_X0Y0_FrameData[3] VPWR VGND sg13cmos5l_antennanp
XANTENNA_117 Tile_X0Y0_FrameData[5] VPWR VGND sg13cmos5l_antennanp
XANTENNA_128 Tile_X0Y0_FrameData[7] VPWR VGND sg13cmos5l_antennanp
XANTENNA_139 Tile_X0Y0_NN4END[2] VPWR VGND sg13cmos5l_antennanp
XFILLER_14_42 VPWR VGND sg13cmos5l_decap_8
X_280_ Tile_X0Y0_S4BEG[12] Tile_X0Y0_N4END[3] VPWR VGND sg13cmos5l_buf_1
XFILLER_10_722 VPWR VGND sg13cmos5l_decap_8
XFILLER_6_737 VPWR VGND sg13cmos5l_decap_8
XFILLER_5_203 VPWR VGND sg13cmos5l_decap_8
XANTENNA__222__X Tile_X1Y0_S2BEGb[3] VPWR VGND sg13cmos5l_antennanp
XFILLER_1_475 VPWR VGND sg13cmos5l_decap_8
XFILLER_18_877 VPWR VGND sg13cmos5l_decap_8
XFILLER_17_343 VPWR VGND sg13cmos5l_decap_8
XFILLER_9_542 VPWR VGND sg13cmos5l_decap_8
XFILLER_4_280 VPWR VGND sg13cmos5l_fill_1
XANTENNA__307__X Tile_X1Y0_FrameData_O[3] VPWR VGND sg13cmos5l_antennanp
X_401_ _401_/X Tile_X0Y0_N1END[0] Tile_X0Y0_N2MID[0] Tile_X0Y0_N2MID[7] Tile_X0Y0_N2END[7]
+ _044_/Q _043_/Q VPWR VGND sg13cmos5l_mux4_1
XANTENNA__217__X Tile_X1Y0_S2BEG[6] VPWR VGND sg13cmos5l_antennanp
XFILLER_14_357 VPWR VGND sg13cmos5l_decap_8
XFILLER_15_847 VPWR VGND sg13cmos5l_decap_8
X_263_ Tile_X0Y0_S2BEGb[3] Tile_X0Y0_N2END[4] VPWR VGND sg13cmos5l_buf_1
X_332_ Tile_X1Y0_FrameData_O[28] Tile_X0Y0_FrameData[28] VPWR VGND sg13cmos5l_buf_1
XFILLER_10_574 VPWR VGND sg13cmos5l_decap_8
X_194_ Tile_X1Y0_FrameStrobe_O[15] Tile_X1Y0_FrameStrobe[15] VPWR VGND sg13cmos5l_buf_1
XFILLER_6_512 VPWR VGND sg13cmos5l_decap_8
XFILLER_2_784 VPWR VGND sg13cmos5l_decap_8
XFILLER_2_56 VPWR VGND sg13cmos5l_decap_8
XFILLER_17_140 VPWR VGND sg13cmos5l_decap_8
XFILLER_18_641 VPWR VGND sg13cmos5l_decap_4
XANTENNA_17 Tile_X0Y0_FrameData[12] VPWR VGND sg13cmos5l_antennanp
XANTENNA_28 Tile_X0Y0_FrameData[14] VPWR VGND sg13cmos5l_antennanp
XANTENNA_39 Tile_X0Y0_FrameData[18] VPWR VGND sg13cmos5l_antennanp
XFILLER_11_21 VPWR VGND sg13cmos5l_decap_8
XFILLER_11_98 VPWR VGND sg13cmos5l_decap_8
XFILLER_14_154 VPWR VGND sg13cmos5l_decap_8
XFILLER_15_644 VPWR VGND sg13cmos5l_decap_8
XFILLER_10_371 VPWR VGND sg13cmos5l_decap_8
XFILLER_11_883 VPWR VGND sg13cmos5l_decap_8
X_177_ _177_/L_HI VPWR VGND sg13cmos5l_tiehi
X_246_ Tile_X1Y0_SS4BEG[3] Tile_X1Y0_NN4END[12] VPWR VGND sg13cmos5l_buf_1
X_315_ Tile_X1Y0_FrameData_O[11] Tile_X0Y0_FrameData[11] VPWR VGND sg13cmos5l_buf_1
XFILLER_7_876 VPWR VGND sg13cmos5l_decap_8
XFILLER_7_832 VPWR VGND sg13cmos5l_fill_2
XFILLER_2_581 VPWR VGND sg13cmos5l_fill_2
XFILLER_2_570 VPWR VGND sg13cmos5l_decap_8
XANTENNA__320__X Tile_X1Y0_FrameData_O[16] VPWR VGND sg13cmos5l_antennanp
XFILLER_11_168 VPWR VGND sg13cmos5l_decap_8
XFILLER_12_658 VPWR VGND sg13cmos5l_decap_8
X_100_ _100_/Q Tile_X0Y0_FrameData[6] VGND VPWR Tile_X1Y0_FrameStrobe[0] latch
XFILLER_8_607 VPWR VGND sg13cmos5l_decap_8
XANTENNA__230__X Tile_X1Y0_S4BEG[3] VPWR VGND sg13cmos5l_antennanp
XFILLER_15_441 VPWR VGND sg13cmos5l_decap_8
XFILLER_11_691 VPWR VGND sg13cmos5l_decap_4
X_229_ Tile_X1Y0_S4BEG[2] Tile_X1Y0_N4END[13] VPWR VGND sg13cmos5l_buf_1
XFILLER_8_77 VPWR VGND sg13cmos5l_decap_8
XFILLER_7_640 VPWR VGND sg13cmos5l_decap_8
XFILLER_6_161 VPWR VGND sg13cmos5l_decap_8
XANTENNA__315__X Tile_X1Y0_FrameData_O[11] VPWR VGND sg13cmos5l_antennanp
XFILLER_17_728 VPWR VGND sg13cmos5l_decap_8
XFILLER_12_455 VPWR VGND sg13cmos5l_decap_8
XFILLER_13_923 VPWR VGND sg13cmos5l_fill_2
XFILLER_16_238 VPWR VGND sg13cmos5l_decap_8
XFILLER_17_42 VPWR VGND sg13cmos5l_decap_8
XANTENNA__225__X Tile_X1Y0_S2BEGb[6] VPWR VGND sg13cmos5l_antennanp
XFILLER_8_448 VPWR VGND sg13cmos5l_decap_8
XFILLER_3_186 VPWR VGND sg13cmos5l_fill_2
XFILLER_3_175 VPWR VGND sg13cmos5l_decap_8
XFILLER_12_7 VPWR VGND sg13cmos5l_decap_8
XFILLER_7_481 VPWR VGND sg13cmos5l_decap_8
XFILLER_0_156 VPWR VGND sg13cmos5l_decap_8
XFILLER_1_624 VPWR VGND sg13cmos5l_decap_8
XFILLER_1_602 VPWR VGND sg13cmos5l_decap_4
XFILLER_17_525 VPWR VGND sg13cmos5l_decap_8
XFILLER_12_252 VPWR VGND sg13cmos5l_decap_8
XFILLER_13_720 VPWR VGND sg13cmos5l_decap_8
XFILLER_13_797 VPWR VGND sg13cmos5l_decap_8
XFILLER_8_245 VPWR VGND sg13cmos5l_decap_8
XFILLER_5_56 VPWR VGND sg13cmos5l_decap_8
XANTENNA_107 Tile_X0Y0_FrameData[4] VPWR VGND sg13cmos5l_antennanp
XANTENNA_118 Tile_X0Y0_FrameData[5] VPWR VGND sg13cmos5l_antennanp
XANTENNA_129 Tile_X0Y0_FrameData[7] VPWR VGND sg13cmos5l_antennanp
XFILLER_14_21 VPWR VGND sg13cmos5l_decap_8
XFILLER_14_539 VPWR VGND sg13cmos5l_decap_8
XFILLER_14_98 VPWR VGND sg13cmos5l_decap_8
XFILLER_5_259 VPWR VGND sg13cmos5l_decap_8
XFILLER_1_498 VPWR VGND sg13cmos5l_decap_4
XFILLER_1_465 VPWR VGND sg13cmos5l_fill_2
XFILLER_18_856 VPWR VGND sg13cmos5l_decap_8
XFILLER_17_399 VPWR VGND sg13cmos5l_decap_8
XFILLER_17_322 VPWR VGND sg13cmos5l_decap_8
XFILLER_13_594 VPWR VGND sg13cmos5l_decap_8
XFILLER_9_598 VPWR VGND sg13cmos5l_decap_8
XFILLER_9_521 VPWR VGND sg13cmos5l_decap_8
XFILLER_11_509 VPWR VGND sg13cmos5l_decap_8
XANTENNA__323__X Tile_X1Y0_FrameData_O[19] VPWR VGND sg13cmos5l_antennanp
XFILLER_3_719 VPWR VGND sg13cmos5l_decap_4
XFILLER_14_336 VPWR VGND sg13cmos5l_decap_8
XFILLER_15_826 VPWR VGND sg13cmos5l_decap_8
X_400_ _400_/X Tile_X0Y0_N1END[1] Tile_X0Y0_N2MID[1] Tile_X0Y0_N2MID[6] Tile_X0Y0_N2END[6]
+ _042_/Q _041_/Q VPWR VGND sg13cmos5l_mux4_1
X_331_ Tile_X1Y0_FrameData_O[27] Tile_X0Y0_FrameData[27] VPWR VGND sg13cmos5l_buf_1
XFILLER_10_553 VPWR VGND sg13cmos5l_decap_8
X_193_ Tile_X1Y0_FrameStrobe_O[14] Tile_X1Y0_FrameStrobe[14] VPWR VGND sg13cmos5l_buf_1
X_262_ Tile_X0Y0_S2BEGb[2] Tile_X0Y0_N2END[5] VPWR VGND sg13cmos5l_buf_1
XANTENNA__233__X Tile_X1Y0_S4BEG[6] VPWR VGND sg13cmos5l_antennanp
XFILLER_2_763 VPWR VGND sg13cmos5l_decap_8
XFILLER_1_240 VPWR VGND sg13cmos5l_decap_4
XFILLER_2_35 VPWR VGND sg13cmos5l_decap_8
XANTENNA_18 Tile_X0Y0_FrameData[12] VPWR VGND sg13cmos5l_antennanp
XANTENNA_29 Tile_X0Y0_FrameData[14] VPWR VGND sg13cmos5l_antennanp
XFILLER_17_196 VPWR VGND sg13cmos5l_decap_8
XFILLER_18_697 VPWR VGND sg13cmos5l_decap_8
XANTENNA__318__X Tile_X1Y0_FrameData_O[14] VPWR VGND sg13cmos5l_antennanp
XFILLER_11_77 VPWR VGND sg13cmos5l_decap_8
XANTENNA__228__X Tile_X1Y0_S4BEG[1] VPWR VGND sg13cmos5l_antennanp
XFILLER_14_133 VPWR VGND sg13cmos5l_decap_8
XFILLER_15_623 VPWR VGND sg13cmos5l_decap_8
X_314_ Tile_X1Y0_FrameData_O[10] Tile_X0Y0_FrameData[10] VPWR VGND sg13cmos5l_buf_1
XFILLER_11_862 VPWR VGND sg13cmos5l_decap_8
X_176_ _176_/L_HI VPWR VGND sg13cmos5l_tiehi
X_245_ Tile_X1Y0_SS4BEG[2] Tile_X1Y0_NN4END[13] VPWR VGND sg13cmos5l_buf_1
XFILLER_0_519 VPWR VGND sg13cmos5l_fill_1
XFILLER_12_637 VPWR VGND sg13cmos5l_decap_8
XFILLER_11_147 VPWR VGND sg13cmos5l_decap_8
XFILLER_15_420 VPWR VGND sg13cmos5l_decap_8
XFILLER_16_910 VPWR VGND sg13cmos5l_decap_8
XFILLER_15_497 VPWR VGND sg13cmos5l_decap_8
XFILLER_8_56 VPWR VGND sg13cmos5l_decap_8
XFILLER_10_191 VPWR VGND sg13cmos5l_decap_8
XFILLER_11_670 VPWR VGND sg13cmos5l_decap_8
X_159_ _159_/L_HI VPWR VGND sg13cmos5l_tiehi
X_228_ Tile_X1Y0_S4BEG[1] Tile_X1Y0_N4END[14] VPWR VGND sg13cmos5l_buf_1
XFILLER_6_140 VPWR VGND sg13cmos5l_decap_8
XANTENNA__331__X Tile_X1Y0_FrameData_O[27] VPWR VGND sg13cmos5l_antennanp
XFILLER_1_806 VPWR VGND sg13cmos5l_decap_8
XFILLER_16_217 VPWR VGND sg13cmos5l_decap_8
XFILLER_17_21 VPWR VGND sg13cmos5l_decap_8
XFILLER_17_707 VPWR VGND sg13cmos5l_decap_8
XFILLER_12_434 VPWR VGND sg13cmos5l_decap_8
XFILLER_13_902 VPWR VGND sg13cmos5l_decap_8
XFILLER_9_928 VPWR VGND sg13cmos5l_fill_2
XFILLER_8_427 VPWR VGND sg13cmos5l_decap_8
XFILLER_17_98 VPWR VGND sg13cmos5l_decap_8
XFILLER_4_600 VPWR VGND sg13cmos5l_fill_2
XFILLER_3_154 VPWR VGND sg13cmos5l_decap_8
XANTENNA__241__X Tile_X1Y0_S4BEG[14] VPWR VGND sg13cmos5l_antennanp
XFILLER_3_198 VPWR VGND sg13cmos5l_decap_8
XFILLER_16_784 VPWR VGND sg13cmos5l_decap_8
XFILLER_15_294 VPWR VGND sg13cmos5l_decap_8
XFILLER_7_460 VPWR VGND sg13cmos5l_decap_8
XANTENNA__326__X Tile_X1Y0_FrameData_O[22] VPWR VGND sg13cmos5l_antennanp
XFILLER_0_124 VPWR VGND sg13cmos5l_fill_1
XFILLER_0_135 VPWR VGND sg13cmos5l_decap_8
XFILLER_1_658 VPWR VGND sg13cmos5l_fill_2
XFILLER_1_614 VPWR VGND sg13cmos5l_decap_8
XFILLER_17_504 VPWR VGND sg13cmos5l_decap_8
XANTENNA__236__X Tile_X1Y0_S4BEG[9] VPWR VGND sg13cmos5l_antennanp
XFILLER_12_231 VPWR VGND sg13cmos5l_decap_8
XFILLER_13_776 VPWR VGND sg13cmos5l_decap_8
XFILLER_8_224 VPWR VGND sg13cmos5l_decap_8
XFILLER_5_35 VPWR VGND sg13cmos5l_decap_8
XFILLER_16_581 VPWR VGND sg13cmos5l_decap_8
XANTENNA_108 Tile_X0Y0_FrameData[4] VPWR VGND sg13cmos5l_antennanp
XANTENNA_119 Tile_X0Y0_FrameData[5] VPWR VGND sg13cmos5l_antennanp
XFILLER_14_518 VPWR VGND sg13cmos5l_decap_8
XFILLER_14_77 VPWR VGND sg13cmos5l_decap_8
XFILLER_5_238 VPWR VGND sg13cmos5l_decap_8
XFILLER_2_923 VPWR VGND sg13cmos5l_decap_8
XFILLER_1_444 VPWR VGND sg13cmos5l_decap_8
XFILLER_18_835 VPWR VGND sg13cmos5l_decap_8
XFILLER_18_813 VPWR VGND sg13cmos5l_decap_4
XFILLER_17_301 VPWR VGND sg13cmos5l_decap_8
XFILLER_9_500 VPWR VGND sg13cmos5l_decap_8
XFILLER_17_378 VPWR VGND sg13cmos5l_decap_8
XFILLER_13_573 VPWR VGND sg13cmos5l_decap_8
XFILLER_9_577 VPWR VGND sg13cmos5l_decap_8
XFILLER_4_260 VPWR VGND sg13cmos5l_decap_8
XFILLER_14_315 VPWR VGND sg13cmos5l_decap_8
XFILLER_15_805 VPWR VGND sg13cmos5l_decap_8
X_330_ Tile_X1Y0_FrameData_O[26] Tile_X0Y0_FrameData[26] VPWR VGND sg13cmos5l_buf_1
XFILLER_10_532 VPWR VGND sg13cmos5l_decap_8
X_192_ Tile_X1Y0_FrameStrobe_O[13] Tile_X1Y0_FrameStrobe[13] VPWR VGND sg13cmos5l_buf_1
X_261_ Tile_X0Y0_S2BEGb[1] Tile_X0Y0_N2END[6] VPWR VGND sg13cmos5l_buf_1
XFILLER_6_547 VPWR VGND sg13cmos5l_decap_4
XFILLER_9_0 VPWR VGND sg13cmos5l_decap_8
XFILLER_2_742 VPWR VGND sg13cmos5l_decap_8
XFILLER_2_720 VPWR VGND sg13cmos5l_decap_8
XFILLER_2_14 VPWR VGND sg13cmos5l_decap_8
XFILLER_1_263 VPWR VGND sg13cmos5l_fill_1
XFILLER_1_296 VPWR VGND sg13cmos5l_fill_2
XFILLER_18_676 VPWR VGND sg13cmos5l_decap_8
XFILLER_18_610 VPWR VGND sg13cmos5l_decap_4
XANTENNA_19 Tile_X0Y0_FrameData[12] VPWR VGND sg13cmos5l_antennanp
XFILLER_13_392 VPWR VGND sg13cmos5l_decap_8
XFILLER_17_175 VPWR VGND sg13cmos5l_decap_8
XFILLER_12_819 VPWR VGND sg13cmos5l_decap_8
XANTENNA__334__X Tile_X1Y0_FrameData_O[30] VPWR VGND sg13cmos5l_antennanp
XFILLER_11_329 VPWR VGND sg13cmos5l_decap_8
XFILLER_11_56 VPWR VGND sg13cmos5l_decap_8
XFILLER_3_539 VPWR VGND sg13cmos5l_fill_2
XFILLER_2_7 VPWR VGND sg13cmos5l_decap_8
XFILLER_15_602 VPWR VGND sg13cmos5l_decap_8
XFILLER_11_841 VPWR VGND sg13cmos5l_decap_8
XFILLER_14_112 VPWR VGND sg13cmos5l_decap_8
XFILLER_14_189 VPWR VGND sg13cmos5l_decap_8
XFILLER_15_679 VPWR VGND sg13cmos5l_decap_8
X_244_ Tile_X1Y0_SS4BEG[1] Tile_X1Y0_NN4END[14] VPWR VGND sg13cmos5l_buf_1
X_313_ Tile_X1Y0_FrameData_O[9] Tile_X0Y0_FrameData[9] VPWR VGND sg13cmos5l_buf_1
XANTENNA__244__X Tile_X1Y0_SS4BEG[1] VPWR VGND sg13cmos5l_antennanp
X_175_ _175_/L_HI VPWR VGND sg13cmos5l_tiehi
XFILLER_18_495 VPWR VGND sg13cmos5l_fill_1
XFILLER_18_462 VPWR VGND sg13cmos5l_fill_2
XFILLER_9_182 VPWR VGND sg13cmos5l_decap_8
XFILLER_0_509 VPWR VGND sg13cmos5l_fill_2
XANTENNA__329__X Tile_X1Y0_FrameData_O[25] VPWR VGND sg13cmos5l_antennanp
XFILLER_11_126 VPWR VGND sg13cmos5l_decap_8
XFILLER_12_616 VPWR VGND sg13cmos5l_decap_8
XFILLER_7_119 VPWR VGND sg13cmos5l_decap_8
XFILLER_4_859 VPWR VGND sg13cmos5l_fill_1
XANTENNA__239__X Tile_X1Y0_S4BEG[12] VPWR VGND sg13cmos5l_antennanp
XFILLER_10_170 VPWR VGND sg13cmos5l_decap_8
XFILLER_15_476 VPWR VGND sg13cmos5l_decap_8
X_227_ Tile_X1Y0_S4BEG[0] Tile_X1Y0_N4END[15] VPWR VGND sg13cmos5l_buf_1
XFILLER_8_35 VPWR VGND sg13cmos5l_decap_8
X_089_ _089_/Q Tile_X0Y0_FrameData[17] VGND VPWR Tile_X1Y0_FrameStrobe[0] latch
X_158_ _158_/L_HI VPWR VGND sg13cmos5l_tiehi
XFILLER_7_675 VPWR VGND sg13cmos5l_fill_2
XFILLER_6_196 VPWR VGND sg13cmos5l_decap_8
XFILLER_18_281 VPWR VGND sg13cmos5l_decap_8
XFILLER_17_77 VPWR VGND sg13cmos5l_decap_8
XFILLER_12_413 VPWR VGND sg13cmos5l_decap_8
XFILLER_13_925 VPWR VGND sg13cmos5l_fill_1
XFILLER_13_958 VPWR VGND sg13cmos5l_fill_2
XFILLER_9_907 VPWR VGND sg13cmos5l_decap_8
XFILLER_8_406 VPWR VGND sg13cmos5l_decap_8
XFILLER_4_645 VPWR VGND sg13cmos5l_fill_1
XFILLER_4_634 VPWR VGND sg13cmos5l_fill_1
XFILLER_4_612 VPWR VGND sg13cmos5l_decap_8
XFILLER_3_133 VPWR VGND sg13cmos5l_decap_8
XFILLER_0_851 VPWR VGND sg13cmos5l_fill_1
XFILLER_15_273 VPWR VGND sg13cmos5l_decap_8
XFILLER_16_763 VPWR VGND sg13cmos5l_decap_8
XFILLER_10_917 VPWR VGND sg13cmos5l_decap_8
XANTENNA__342__X Tile_X0Y0_FrameStrobe_O[6] VPWR VGND sg13cmos5l_antennanp
XFILLER_12_210 VPWR VGND sg13cmos5l_decap_8
XANTENNA__252__X Tile_X1Y0_SS4BEG[9] VPWR VGND sg13cmos5l_antennanp
XFILLER_12_287 VPWR VGND sg13cmos5l_decap_8
XFILLER_13_755 VPWR VGND sg13cmos5l_decap_8
XFILLER_8_203 VPWR VGND sg13cmos5l_decap_8
XFILLER_5_14 VPWR VGND sg13cmos5l_decap_8
XFILLER_16_560 VPWR VGND sg13cmos5l_decap_8
XFILLER_7_280 VPWR VGND sg13cmos5l_decap_8
XANTENNA_109 Tile_X0Y0_FrameData[4] VPWR VGND sg13cmos5l_antennanp
XANTENNA__337__X Tile_X0Y0_FrameStrobe_O[1] VPWR VGND sg13cmos5l_antennanp
XFILLER_14_56 VPWR VGND sg13cmos5l_decap_8
XFILLER_6_729 VPWR VGND sg13cmos5l_decap_4
XFILLER_5_217 VPWR VGND sg13cmos5l_decap_8
XFILLER_2_902 VPWR VGND sg13cmos5l_decap_8
XANTENNA__247__X Tile_X1Y0_SS4BEG[4] VPWR VGND sg13cmos5l_antennanp
XFILLER_13_552 VPWR VGND sg13cmos5l_decap_8
XFILLER_17_357 VPWR VGND sg13cmos5l_decap_8
XFILLER_9_556 VPWR VGND sg13cmos5l_decap_8
XFILLER_10_511 VPWR VGND sg13cmos5l_decap_8
X_260_ Tile_X0Y0_S2BEGb[0] Tile_X0Y0_N2END[7] VPWR VGND sg13cmos5l_buf_1
XFILLER_10_588 VPWR VGND sg13cmos5l_decap_8
X_191_ Tile_X1Y0_FrameStrobe_O[12] Tile_X1Y0_FrameStrobe[12] VPWR VGND sg13cmos5l_buf_1
XFILLER_6_526 VPWR VGND sg13cmos5l_decap_8
XFILLER_2_798 VPWR VGND sg13cmos5l_fill_1
XFILLER_1_231 VPWR VGND sg13cmos5l_fill_2
XFILLER_1_220 VPWR VGND sg13cmos5l_decap_8
XFILLER_17_154 VPWR VGND sg13cmos5l_decap_8
XFILLER_18_655 VPWR VGND sg13cmos5l_decap_4
XFILLER_18_633 VPWR VGND sg13cmos5l_decap_4
XFILLER_18_622 VPWR VGND sg13cmos5l_fill_1
XFILLER_13_371 VPWR VGND sg13cmos5l_decap_8
XFILLER_14_883 VPWR VGND sg13cmos5l_decap_8
X_389_ _389_/X Tile_X1Y0_N4END[9] Tile_X1Y0_N4END[10] Tile_X1Y0_NN4END[9] Tile_X1Y0_NN4END[11]
+ _094_/Q _093_/Q VPWR VGND sg13cmos5l_mux4_1
XFILLER_9_397 VPWR VGND sg13cmos5l_decap_4
XFILLER_5_581 VPWR VGND sg13cmos5l_decap_8
XFILLER_11_308 VPWR VGND sg13cmos5l_decap_4
XFILLER_11_35 VPWR VGND sg13cmos5l_decap_8
XANTENNA__350__X Tile_X0Y0_FrameStrobe_O[14] VPWR VGND sg13cmos5l_antennanp
XFILLER_14_168 VPWR VGND sg13cmos5l_decap_8
XFILLER_15_658 VPWR VGND sg13cmos5l_decap_8
X_243_ Tile_X1Y0_SS4BEG[0] Tile_X1Y0_NN4END[15] VPWR VGND sg13cmos5l_buf_1
X_312_ Tile_X1Y0_FrameData_O[8] Tile_X0Y0_FrameData[8] VPWR VGND sg13cmos5l_buf_1
XFILLER_6_301 VPWR VGND sg13cmos5l_decap_4
XANTENNA__260__X Tile_X0Y0_S2BEGb[0] VPWR VGND sg13cmos5l_antennanp
XFILLER_10_385 VPWR VGND sg13cmos5l_decap_8
XFILLER_11_897 VPWR VGND sg13cmos5l_decap_8
X_174_ _174_/L_HI VPWR VGND sg13cmos5l_tiehi
XFILLER_18_474 VPWR VGND sg13cmos5l_decap_8
XFILLER_18_441 VPWR VGND sg13cmos5l_fill_2
XFILLER_14_680 VPWR VGND sg13cmos5l_decap_8
XFILLER_9_161 VPWR VGND sg13cmos5l_decap_8
XFILLER_3_91 VPWR VGND sg13cmos5l_decap_8
XANTENNA__345__X Tile_X0Y0_FrameStrobe_O[9] VPWR VGND sg13cmos5l_antennanp
XFILLER_11_105 VPWR VGND sg13cmos5l_decap_8
XFILLER_4_838 VPWR VGND sg13cmos5l_decap_4
XFILLER_15_455 VPWR VGND sg13cmos5l_decap_8
XANTENNA__255__X Tile_X1Y0_SS4BEG[12] VPWR VGND sg13cmos5l_antennanp
X_157_ _157_/L_HI VPWR VGND sg13cmos5l_tiehi
X_226_ Tile_X1Y0_S2BEGb[7] Tile_X1Y0_N2END[0] VPWR VGND sg13cmos5l_buf_1
XFILLER_8_14 VPWR VGND sg13cmos5l_decap_8
XFILLER_7_654 VPWR VGND sg13cmos5l_decap_8
X_088_ _088_/Q Tile_X0Y0_FrameData[18] VGND VPWR Tile_X1Y0_FrameStrobe[0] latch
XFILLER_6_175 VPWR VGND sg13cmos5l_decap_8
XFILLER_3_893 VPWR VGND sg13cmos5l_decap_8
XFILLER_3_860 VPWR VGND sg13cmos5l_fill_1
XFILLER_17_56 VPWR VGND sg13cmos5l_decap_8
XFILLER_12_469 VPWR VGND sg13cmos5l_decap_8
XFILLER_3_112 VPWR VGND sg13cmos5l_decap_8
XFILLER_15_252 VPWR VGND sg13cmos5l_decap_8
XFILLER_16_742 VPWR VGND sg13cmos5l_decap_8
X_209_ Tile_X1Y0_S1BEG[2] Tile_X1Y0_N1END[1] VPWR VGND sg13cmos5l_buf_1
XFILLER_7_495 VPWR VGND sg13cmos5l_decap_8
XFILLER_17_0 VPWR VGND sg13cmos5l_decap_8
XFILLER_1_638 VPWR VGND sg13cmos5l_decap_8
XFILLER_13_734 VPWR VGND sg13cmos5l_decap_8
XFILLER_17_539 VPWR VGND sg13cmos5l_decap_8
XFILLER_12_266 VPWR VGND sg13cmos5l_decap_8
XFILLER_9_749 VPWR VGND sg13cmos5l_decap_4
XFILLER_8_259 VPWR VGND sg13cmos5l_decap_8
XFILLER_5_911 VPWR VGND sg13cmos5l_decap_8
XFILLER_0_682 VPWR VGND sg13cmos5l_decap_8
XFILLER_10_7 VPWR VGND sg13cmos5l_decap_4
XFILLER_14_35 VPWR VGND sg13cmos5l_decap_8
XANTENNA__353__X Tile_X0Y0_FrameStrobe_O[17] VPWR VGND sg13cmos5l_antennanp
XFILLER_10_715 VPWR VGND sg13cmos5l_decap_8
XFILLER_2_958 VPWR VGND sg13cmos5l_fill_2
XFILLER_1_402 VPWR VGND sg13cmos5l_fill_2
XFILLER_17_336 VPWR VGND sg13cmos5l_decap_8
XANTENNA__263__X Tile_X0Y0_S2BEGb[3] VPWR VGND sg13cmos5l_antennanp
XFILLER_9_535 VPWR VGND sg13cmos5l_decap_8
XFILLER_5_774 VPWR VGND sg13cmos5l_fill_2
XANTENNA__122__Q NPU_QUANT_SHIFT_IN7 VPWR VGND sg13cmos5l_antennanp
XFILLER_6_91 VPWR VGND sg13cmos5l_decap_8
XANTENNA__348__X Tile_X0Y0_FrameStrobe_O[12] VPWR VGND sg13cmos5l_antennanp
X_190_ Tile_X1Y0_FrameStrobe_O[11] Tile_X1Y0_FrameStrobe[11] VPWR VGND sg13cmos5l_buf_1
XFILLER_10_567 VPWR VGND sg13cmos5l_decap_8
XFILLER_6_505 VPWR VGND sg13cmos5l_decap_8
XFILLER_2_777 VPWR VGND sg13cmos5l_decap_8
XFILLER_2_49 VPWR VGND sg13cmos5l_decap_8
XANTENNA__258__X Tile_X1Y0_SS4BEG[15] VPWR VGND sg13cmos5l_antennanp
XFILLER_17_133 VPWR VGND sg13cmos5l_decap_8
XFILLER_13_350 VPWR VGND sg13cmos5l_decap_8
XFILLER_14_862 VPWR VGND sg13cmos5l_decap_8
X_388_ _388_/X Tile_X1Y0_N4END[8] Tile_X1Y0_N4END[9] Tile_X1Y0_NN4END[8] Tile_X1Y0_NN4END[10]
+ _096_/Q _095_/Q VPWR VGND sg13cmos5l_mux4_1
XFILLER_9_354 VPWR VGND sg13cmos5l_decap_4
XANTENNA__117__Q NPU_QUANT_SHIFT_IN2 VPWR VGND sg13cmos5l_antennanp
XFILLER_11_14 VPWR VGND sg13cmos5l_decap_8
XFILLER_15_637 VPWR VGND sg13cmos5l_decap_8
XFILLER_11_876 VPWR VGND sg13cmos5l_decap_8
XFILLER_14_147 VPWR VGND sg13cmos5l_decap_8
X_173_ _173_/L_HI VPWR VGND sg13cmos5l_tiehi
X_242_ Tile_X1Y0_S4BEG[15] Tile_X1Y0_N4END[0] VPWR VGND sg13cmos5l_buf_1
X_311_ Tile_X1Y0_FrameData_O[7] Tile_X0Y0_FrameData[7] VPWR VGND sg13cmos5l_buf_1
XFILLER_7_869 VPWR VGND sg13cmos5l_decap_8
XFILLER_6_379 VPWR VGND sg13cmos5l_fill_2
XFILLER_2_563 VPWR VGND sg13cmos5l_decap_8
XFILLER_2_552 VPWR VGND sg13cmos5l_decap_8
XFILLER_2_530 VPWR VGND sg13cmos5l_decap_8
XANTENNA_260 Tile_X1Y0_FrameStrobe[17] VPWR VGND sg13cmos5l_antennanp
XFILLER_18_464 VPWR VGND sg13cmos5l_fill_1
XFILLER_9_140 VPWR VGND sg13cmos5l_decap_8
XFILLER_3_70 VPWR VGND sg13cmos5l_decap_8
XANTENNA__361__X Tile_X1Y0_FrameStrobe_O[5] VPWR VGND sg13cmos5l_antennanp
XFILLER_3_305 VPWR VGND sg13cmos5l_fill_2
XFILLER_15_434 VPWR VGND sg13cmos5l_decap_8
XFILLER_16_924 VPWR VGND sg13cmos5l_decap_4
XANTENNA__271__X Tile_X0Y0_S4BEG[3] VPWR VGND sg13cmos5l_antennanp
XFILLER_11_684 VPWR VGND sg13cmos5l_decap_8
XFILLER_11_695 VPWR VGND sg13cmos5l_fill_1
X_087_ _087_/Q Tile_X0Y0_FrameData[19] VGND VPWR Tile_X1Y0_FrameStrobe[0] latch
X_156_ _156_/L_HI VPWR VGND sg13cmos5l_tiehi
X_225_ Tile_X1Y0_S2BEGb[6] Tile_X1Y0_N2END[1] VPWR VGND sg13cmos5l_buf_1
XFILLER_7_633 VPWR VGND sg13cmos5l_decap_8
XFILLER_6_154 VPWR VGND sg13cmos5l_decap_8
XFILLER_3_872 VPWR VGND sg13cmos5l_decap_8
XANTENNA__130__Q NPU_QUANT_SHIFT_IN15 VPWR VGND sg13cmos5l_antennanp
XANTENNA__356__X Tile_X1Y0_FrameStrobe_O[0] VPWR VGND sg13cmos5l_antennanp
XFILLER_13_916 VPWR VGND sg13cmos5l_decap_8
XFILLER_17_35 VPWR VGND sg13cmos5l_decap_8
XFILLER_12_448 VPWR VGND sg13cmos5l_decap_8
XFILLER_3_168 VPWR VGND sg13cmos5l_decap_8
XFILLER_0_897 VPWR VGND sg13cmos5l_decap_8
XFILLER_16_721 VPWR VGND sg13cmos5l_decap_8
XANTENNA__266__X Tile_X0Y0_S2BEGb[6] VPWR VGND sg13cmos5l_antennanp
XFILLER_15_231 VPWR VGND sg13cmos5l_decap_8
XFILLER_16_798 VPWR VGND sg13cmos5l_decap_8
XFILLER_11_481 VPWR VGND sg13cmos5l_decap_8
X_139_ NPU_QUANT_SHIFT_IN24 Tile_X0Y0_UserCLK _389_/X _166_/L_HI VPWR VGND sg13cmos5l_dfrbpq_1
X_208_ Tile_X1Y0_S1BEG[1] Tile_X1Y0_N1END[2] VPWR VGND sg13cmos5l_buf_1
XFILLER_7_474 VPWR VGND sg13cmos5l_decap_8
XFILLER_3_691 VPWR VGND sg13cmos5l_decap_8
XFILLER_2_190 VPWR VGND sg13cmos5l_fill_1
XANTENNA__125__Q NPU_QUANT_SHIFT_IN10 VPWR VGND sg13cmos5l_antennanp
XFILLER_9_91 VPWR VGND sg13cmos5l_decap_8
XFILLER_0_149 VPWR VGND sg13cmos5l_decap_4
XFILLER_1_606 VPWR VGND sg13cmos5l_fill_1
XFILLER_17_518 VPWR VGND sg13cmos5l_decap_8
XFILLER_12_245 VPWR VGND sg13cmos5l_decap_8
XFILLER_13_713 VPWR VGND sg13cmos5l_decap_8
XFILLER_8_238 VPWR VGND sg13cmos5l_decap_8
XFILLER_5_49 VPWR VGND sg13cmos5l_decap_8
XFILLER_16_595 VPWR VGND sg13cmos5l_decap_8
XFILLER_8_761 VPWR VGND sg13cmos5l_decap_8
XFILLER_14_14 VPWR VGND sg13cmos5l_decap_8
XFILLER_2_948 VPWR VGND sg13cmos5l_fill_1
XFILLER_1_458 VPWR VGND sg13cmos5l_decap_8
XFILLER_18_849 VPWR VGND sg13cmos5l_decap_8
XFILLER_17_315 VPWR VGND sg13cmos5l_decap_8
XFILLER_13_532 VPWR VGND sg13cmos5l_decap_8
XFILLER_13_587 VPWR VGND sg13cmos5l_decap_8
XFILLER_9_514 VPWR VGND sg13cmos5l_decap_8
XFILLER_16_392 VPWR VGND sg13cmos5l_decap_8
XFILLER_17_882 VPWR VGND sg13cmos5l_decap_8
XFILLER_6_70 VPWR VGND sg13cmos5l_decap_8
XFILLER_14_329 VPWR VGND sg13cmos5l_decap_8
XFILLER_15_819 VPWR VGND sg13cmos5l_decap_8
XANTENNA__364__X Tile_X1Y0_FrameStrobe_O[8] VPWR VGND sg13cmos5l_antennanp
XFILLER_10_546 VPWR VGND sg13cmos5l_decap_8
XFILLER_2_756 VPWR VGND sg13cmos5l_decap_8
XFILLER_2_734 VPWR VGND sg13cmos5l_fill_1
XFILLER_17_112 VPWR VGND sg13cmos5l_decap_8
XFILLER_2_28 VPWR VGND sg13cmos5l_decap_8
XFILLER_1_244 VPWR VGND sg13cmos5l_fill_1
XFILLER_18_602 VPWR VGND sg13cmos5l_decap_4
XANTENNA__274__X Tile_X0Y0_S4BEG[6] VPWR VGND sg13cmos5l_antennanp
XFILLER_14_841 VPWR VGND sg13cmos5l_decap_8
XFILLER_17_189 VPWR VGND sg13cmos5l_decap_8
X_387_ _387_/X Tile_X1Y0_N4END[4] Tile_X1Y0_N4END[7] Tile_X1Y0_NN4END[5] Tile_X1Y0_NN4END[7]
+ _098_/Q _097_/Q VPWR VGND sg13cmos5l_mux4_1
XANTENNA__133__Q NPU_QUANT_SHIFT_IN18 VPWR VGND sg13cmos5l_antennanp
XANTENNA__359__X Tile_X1Y0_FrameStrobe_O[3] VPWR VGND sg13cmos5l_antennanp
XFILLER_14_126 VPWR VGND sg13cmos5l_decap_8
XFILLER_15_616 VPWR VGND sg13cmos5l_decap_8
X_310_ Tile_X1Y0_FrameData_O[6] Tile_X0Y0_FrameData[6] VPWR VGND sg13cmos5l_buf_1
XFILLER_10_332 VPWR VGND sg13cmos5l_fill_2
XFILLER_10_365 VPWR VGND sg13cmos5l_fill_2
XFILLER_11_855 VPWR VGND sg13cmos5l_decap_8
X_172_ _172_/L_HI VPWR VGND sg13cmos5l_tiehi
X_241_ Tile_X1Y0_S4BEG[14] Tile_X1Y0_N4END[1] VPWR VGND sg13cmos5l_buf_1
XFILLER_7_0 VPWR VGND sg13cmos5l_decap_8
XANTENNA__269__X Tile_X0Y0_S4BEG[1] VPWR VGND sg13cmos5l_antennanp
XFILLER_18_443 VPWR VGND sg13cmos5l_fill_1
XANTENNA_250 Tile_X0Y0_FrameData[13] VPWR VGND sg13cmos5l_antennanp
XANTENNA_261 Tile_X0Y0_FrameData[26] VPWR VGND sg13cmos5l_antennanp
XFILLER_9_196 VPWR VGND sg13cmos5l_decap_8
XANTENNA__128__Q NPU_QUANT_SHIFT_IN13 VPWR VGND sg13cmos5l_antennanp
XFILLER_0_7 VPWR VGND sg13cmos5l_decap_8
XFILLER_16_903 VPWR VGND sg13cmos5l_decap_8
XFILLER_15_413 VPWR VGND sg13cmos5l_decap_8
XFILLER_16_958 VPWR VGND sg13cmos5l_fill_2
X_224_ Tile_X1Y0_S2BEGb[5] Tile_X1Y0_N2END[2] VPWR VGND sg13cmos5l_buf_1
XFILLER_8_49 VPWR VGND sg13cmos5l_decap_8
XFILLER_10_184 VPWR VGND sg13cmos5l_decap_8
XFILLER_11_663 VPWR VGND sg13cmos5l_decap_8
XFILLER_12_91 VPWR VGND sg13cmos5l_decap_8
X_086_ _086_/Q Tile_X0Y0_FrameData[20] VGND VPWR Tile_X1Y0_FrameStrobe[0] latch
X_155_ _155_/L_HI VPWR VGND sg13cmos5l_tiehi
XFILLER_7_612 VPWR VGND sg13cmos5l_decap_8
XFILLER_6_133 VPWR VGND sg13cmos5l_decap_8
XFILLER_18_295 VPWR VGND sg13cmos5l_decap_8
XFILLER_18_273 VPWR VGND sg13cmos5l_decap_4
XFILLER_18_251 VPWR VGND sg13cmos5l_fill_2
XFILLER_18_240 VPWR VGND sg13cmos5l_decap_8
XFILLER_14_490 VPWR VGND sg13cmos5l_decap_8
XFILLER_17_14 VPWR VGND sg13cmos5l_decap_8
XFILLER_12_427 VPWR VGND sg13cmos5l_decap_8
XFILLER_0_810 VPWR VGND sg13cmos5l_fill_1
XFILLER_0_887 VPWR VGND sg13cmos5l_decap_8
XFILLER_3_147 VPWR VGND sg13cmos5l_decap_8
XFILLER_15_210 VPWR VGND sg13cmos5l_decap_8
XFILLER_16_700 VPWR VGND sg13cmos5l_decap_8
XFILLER_16_777 VPWR VGND sg13cmos5l_decap_8
XANTENNA__282__X Tile_X0Y0_S4BEG[14] VPWR VGND sg13cmos5l_antennanp
XFILLER_11_460 VPWR VGND sg13cmos5l_decap_8
XFILLER_15_287 VPWR VGND sg13cmos5l_decap_8
X_207_ Tile_X1Y0_S1BEG[0] Tile_X1Y0_N1END[3] VPWR VGND sg13cmos5l_buf_1
X_069_ _069_/Q Tile_X0Y0_FrameData[1] VGND VPWR Tile_X0Y0_FrameStrobe[0] latch
X_138_ NPU_QUANT_SHIFT_IN23 Tile_X0Y0_UserCLK _388_/X _167_/L_HI VPWR VGND sg13cmos5l_dfrbpq_1
XFILLER_7_453 VPWR VGND sg13cmos5l_decap_8
XANTENNA__192__X Tile_X1Y0_FrameStrobe_O[13] VPWR VGND sg13cmos5l_antennanp
XFILLER_9_70 VPWR VGND sg13cmos5l_fill_2
XANTENNA__141__Q NPU_QUANT_SHIFT_IN26 VPWR VGND sg13cmos5l_antennanp
XFILLER_0_117 VPWR VGND sg13cmos5l_decap_8
XFILLER_0_128 VPWR VGND sg13cmos5l_decap_8
XFILLER_12_224 VPWR VGND sg13cmos5l_decap_8
XFILLER_13_769 VPWR VGND sg13cmos5l_decap_8
XFILLER_9_729 VPWR VGND sg13cmos5l_decap_4
XFILLER_8_217 VPWR VGND sg13cmos5l_decap_8
XFILLER_5_957 VPWR VGND sg13cmos5l_fill_2
XFILLER_5_28 VPWR VGND sg13cmos5l_decap_8
XANTENNA__277__X Tile_X0Y0_S4BEG[9] VPWR VGND sg13cmos5l_antennanp
XFILLER_16_574 VPWR VGND sg13cmos5l_decap_8
XFILLER_12_791 VPWR VGND sg13cmos5l_decap_8
XFILLER_7_294 VPWR VGND sg13cmos5l_decap_8
XANTENNA__136__Q NPU_QUANT_SHIFT_IN21 VPWR VGND sg13cmos5l_antennanp
XFILLER_2_916 VPWR VGND sg13cmos5l_decap_8
XFILLER_1_437 VPWR VGND sg13cmos5l_fill_2
XFILLER_18_817 VPWR VGND sg13cmos5l_fill_1
XFILLER_18_806 VPWR VGND sg13cmos5l_decap_8
XFILLER_13_511 VPWR VGND sg13cmos5l_decap_8
XFILLER_13_544 VPWR VGND sg13cmos5l_decap_4
XFILLER_18_828 VPWR VGND sg13cmos5l_decap_8
XFILLER_13_566 VPWR VGND sg13cmos5l_decap_8
XFILLER_4_297 VPWR VGND sg13cmos5l_fill_1
XFILLER_4_253 VPWR VGND sg13cmos5l_decap_8
XFILLER_0_481 VPWR VGND sg13cmos5l_decap_8
XFILLER_16_371 VPWR VGND sg13cmos5l_decap_8
XFILLER_17_861 VPWR VGND sg13cmos5l_decap_8
XFILLER_14_308 VPWR VGND sg13cmos5l_decap_8
XFILLER_10_525 VPWR VGND sg13cmos5l_decap_8
XFILLER_2_713 VPWR VGND sg13cmos5l_decap_8
XFILLER_18_669 VPWR VGND sg13cmos5l_decap_8
XFILLER_18_614 VPWR VGND sg13cmos5l_fill_1
XFILLER_13_385 VPWR VGND sg13cmos5l_decap_8
XFILLER_14_820 VPWR VGND sg13cmos5l_decap_8
XFILLER_14_897 VPWR VGND sg13cmos5l_decap_8
XFILLER_15_91 VPWR VGND sg13cmos5l_decap_8
XFILLER_17_168 VPWR VGND sg13cmos5l_decap_8
X_386_ _386_/X Tile_X1Y0_N4END[6] Tile_X1Y0_N4END[7] Tile_X1Y0_NN4END[4] Tile_X1Y0_NN4END[6]
+ _100_/Q _099_/Q VPWR VGND sg13cmos5l_mux4_1
XFILLER_9_301 VPWR VGND sg13cmos5l_decap_4
XANTENNA__290__X Tile_X0Y0_SS4BEG[6] VPWR VGND sg13cmos5l_antennanp
XFILLER_5_551 VPWR VGND sg13cmos5l_decap_8
XFILLER_5_595 VPWR VGND sg13cmos5l_decap_8
XFILLER_11_49 VPWR VGND sg13cmos5l_decap_8
XFILLER_11_812 VPWR VGND sg13cmos5l_decap_8
XFILLER_14_105 VPWR VGND sg13cmos5l_decap_8
X_240_ Tile_X1Y0_S4BEG[13] Tile_X1Y0_N4END[2] VPWR VGND sg13cmos5l_buf_1
XFILLER_10_399 VPWR VGND sg13cmos5l_decap_8
X_171_ _171_/L_HI VPWR VGND sg13cmos5l_tiehi
XFILLER_7_838 VPWR VGND sg13cmos5l_decap_4
XANTENNA_240 Tile_X0Y0_NN4END[6] VPWR VGND sg13cmos5l_antennanp
XANTENNA_251 Tile_X0Y0_FrameData[13] VPWR VGND sg13cmos5l_antennanp
XANTENNA__285__X Tile_X0Y0_SS4BEG[1] VPWR VGND sg13cmos5l_antennanp
XFILLER_18_499 VPWR VGND sg13cmos5l_decap_8
XFILLER_18_488 VPWR VGND sg13cmos5l_decap_4
XFILLER_18_455 VPWR VGND sg13cmos5l_decap_8
XANTENNA_262 Tile_X0Y0_FrameData[26] VPWR VGND sg13cmos5l_antennanp
XFILLER_13_182 VPWR VGND sg13cmos5l_decap_8
XFILLER_14_694 VPWR VGND sg13cmos5l_decap_8
X_369_ _369_/X Tile_X0Y0_N4END[4] Tile_X0Y0_N4END[5] Tile_X0Y0_NN4END[4] Tile_X0Y0_NN4END[6]
+ _066_/Q _065_/Q VPWR VGND sg13cmos5l_mux4_1
XFILLER_9_175 VPWR VGND sg13cmos5l_decap_8
XANTENNA__195__X Tile_X1Y0_FrameStrobe_O[16] VPWR VGND sg13cmos5l_antennanp
XFILLER_11_119 VPWR VGND sg13cmos5l_decap_8
XFILLER_12_609 VPWR VGND sg13cmos5l_decap_8
XANTENNA__144__Q NPU_QUANT_SHIFT_IN29 VPWR VGND sg13cmos5l_antennanp
XFILLER_11_642 VPWR VGND sg13cmos5l_decap_8
XFILLER_15_469 VPWR VGND sg13cmos5l_decap_8
X_223_ Tile_X1Y0_S2BEGb[4] Tile_X1Y0_N2END[3] VPWR VGND sg13cmos5l_buf_1
XFILLER_8_28 VPWR VGND sg13cmos5l_decap_8
XFILLER_10_163 VPWR VGND sg13cmos5l_decap_8
XFILLER_12_70 VPWR VGND sg13cmos5l_decap_8
X_085_ _085_/Q Tile_X0Y0_FrameData[21] VGND VPWR Tile_X1Y0_FrameStrobe[0] latch
X_154_ _154_/L_HI VPWR VGND sg13cmos5l_tiehi
XFILLER_7_668 VPWR VGND sg13cmos5l_decap_8
XFILLER_6_189 VPWR VGND sg13cmos5l_decap_8
XFILLER_6_112 VPWR VGND sg13cmos5l_decap_8
XANTENNA__139__Q NPU_QUANT_SHIFT_IN24 VPWR VGND sg13cmos5l_antennanp
XFILLER_12_406 VPWR VGND sg13cmos5l_decap_8
XFILLER_4_638 VPWR VGND sg13cmos5l_decap_8
XFILLER_3_126 VPWR VGND sg13cmos5l_decap_8
XFILLER_0_833 VPWR VGND sg13cmos5l_decap_4
XFILLER_15_266 VPWR VGND sg13cmos5l_decap_8
XFILLER_16_756 VPWR VGND sg13cmos5l_decap_8
X_137_ NPU_QUANT_SHIFT_IN22 Tile_X0Y0_UserCLK _387_/X _152_/L_HI VPWR VGND sg13cmos5l_dfrbpq_1
X_206_ Tile_X0Y0_S2BEG[7] Tile_X0Y0_N2MID[0] VPWR VGND sg13cmos5l_buf_1
XFILLER_8_922 VPWR VGND sg13cmos5l_decap_8
XFILLER_7_432 VPWR VGND sg13cmos5l_decap_8
X_068_ _068_/Q Tile_X0Y0_FrameData[2] VGND VPWR Tile_X0Y0_FrameStrobe[0] latch
XFILLER_12_203 VPWR VGND sg13cmos5l_decap_8
XFILLER_13_748 VPWR VGND sg13cmos5l_decap_8
XFILLER_5_925 VPWR VGND sg13cmos5l_decap_4
XFILLER_4_402 VPWR VGND sg13cmos5l_fill_2
XFILLER_0_696 VPWR VGND sg13cmos5l_decap_4
XANTENNA__293__X Tile_X0Y0_SS4BEG[9] VPWR VGND sg13cmos5l_antennanp
XFILLER_16_553 VPWR VGND sg13cmos5l_decap_8
XFILLER_11_280 VPWR VGND sg13cmos5l_decap_8
XFILLER_12_770 VPWR VGND sg13cmos5l_decap_8
XFILLER_7_273 VPWR VGND sg13cmos5l_decap_8
XFILLER_15_0 VPWR VGND sg13cmos5l_decap_8
XFILLER_10_729 VPWR VGND sg13cmos5l_decap_8
XFILLER_14_49 VPWR VGND sg13cmos5l_decap_8
XFILLER_9_549 VPWR VGND sg13cmos5l_decap_8
XFILLER_4_232 VPWR VGND sg13cmos5l_decap_8
XFILLER_0_460 VPWR VGND sg13cmos5l_decap_8
XFILLER_4_276 VPWR VGND sg13cmos5l_decap_4
XANTENNA__288__X Tile_X0Y0_SS4BEG[4] VPWR VGND sg13cmos5l_antennanp
XFILLER_16_350 VPWR VGND sg13cmos5l_decap_8
XFILLER_17_840 VPWR VGND sg13cmos5l_decap_8
XANTENNA__198__X Tile_X1Y0_FrameStrobe_O[19] VPWR VGND sg13cmos5l_antennanp
XANTENNA__147__Q NPU_PSUM_LUT_EN VPWR VGND sg13cmos5l_antennanp
XFILLER_10_504 VPWR VGND sg13cmos5l_decap_8
XFILLER_6_519 VPWR VGND sg13cmos5l_decap_8
XFILLER_1_213 VPWR VGND sg13cmos5l_decap_8
XFILLER_17_147 VPWR VGND sg13cmos5l_decap_8
XFILLER_18_648 VPWR VGND sg13cmos5l_decap_8
XFILLER_18_637 VPWR VGND sg13cmos5l_fill_1
XFILLER_18_626 VPWR VGND sg13cmos5l_decap_4
XFILLER_13_364 VPWR VGND sg13cmos5l_decap_8
XFILLER_14_876 VPWR VGND sg13cmos5l_decap_8
XFILLER_15_70 VPWR VGND sg13cmos5l_decap_8
X_385_ _385_/X Tile_X1Y0_N4END[5] Tile_X1Y0_N4END[6] Tile_X1Y0_NN4END[5] Tile_X1Y0_NN4END[7]
+ _102_/Q _101_/Q VPWR VGND sg13cmos5l_mux4_1
XFILLER_5_574 VPWR VGND sg13cmos5l_decap_8
XFILLER_11_28 VPWR VGND sg13cmos5l_decap_8
XFILLER_11_824 VPWR VGND sg13cmos5l_fill_1
X_170_ _170_/L_HI VPWR VGND sg13cmos5l_tiehi
XFILLER_10_367 VPWR VGND sg13cmos5l_fill_1
XFILLER_10_378 VPWR VGND sg13cmos5l_decap_8
XFILLER_7_828 VPWR VGND sg13cmos5l_decap_4
XFILLER_2_577 VPWR VGND sg13cmos5l_fill_1
XFILLER_2_544 VPWR VGND sg13cmos5l_decap_4
XANTENNA_230 Tile_X0Y0_FrameData[9] VPWR VGND sg13cmos5l_antennanp
XANTENNA_241 Tile_X0Y0_NN4END[6] VPWR VGND sg13cmos5l_antennanp
XANTENNA_252 Tile_X0Y0_FrameData[30] VPWR VGND sg13cmos5l_antennanp
XANTENNA_263 Tile_X0Y0_FrameData[26] VPWR VGND sg13cmos5l_antennanp
XFILLER_18_423 VPWR VGND sg13cmos5l_fill_2
XFILLER_18_412 VPWR VGND sg13cmos5l_fill_1
XFILLER_13_161 VPWR VGND sg13cmos5l_decap_8
XFILLER_14_651 VPWR VGND sg13cmos5l_decap_4
XFILLER_14_673 VPWR VGND sg13cmos5l_decap_8
X_299_ Tile_X0Y0_SS4BEG[15] Tile_X0Y0_NN4END[0] VPWR VGND sg13cmos5l_buf_1
X_368_ _368_/X Tile_X0Y0_N4END[0] Tile_X0Y0_N4END[3] Tile_X0Y0_NN4END[1] Tile_X0Y0_NN4END[3]
+ _068_/Q _067_/Q VPWR VGND sg13cmos5l_mux4_1
XFILLER_9_154 VPWR VGND sg13cmos5l_decap_8
XFILLER_3_84 VPWR VGND sg13cmos5l_decap_8
XFILLER_15_448 VPWR VGND sg13cmos5l_decap_8
XFILLER_10_142 VPWR VGND sg13cmos5l_decap_8
XFILLER_11_621 VPWR VGND sg13cmos5l_decap_8
X_153_ _153_/L_HI VPWR VGND sg13cmos5l_tiehi
X_222_ Tile_X1Y0_S2BEGb[3] Tile_X1Y0_N2END[4] VPWR VGND sg13cmos5l_buf_1
XFILLER_7_647 VPWR VGND sg13cmos5l_decap_8
X_084_ _084_/Q Tile_X0Y0_FrameData[22] VGND VPWR Tile_X1Y0_FrameStrobe[0] latch
XFILLER_6_168 VPWR VGND sg13cmos5l_decap_8
XFILLER_3_886 VPWR VGND sg13cmos5l_decap_8
XFILLER_3_820 VPWR VGND sg13cmos5l_decap_4
XANTENNA__296__X Tile_X0Y0_SS4BEG[12] VPWR VGND sg13cmos5l_antennanp
XFILLER_17_49 VPWR VGND sg13cmos5l_decap_8
XFILLER_4_606 VPWR VGND sg13cmos5l_fill_2
XFILLER_3_105 VPWR VGND sg13cmos5l_decap_8
XFILLER_0_878 VPWR VGND sg13cmos5l_fill_2
XFILLER_15_245 VPWR VGND sg13cmos5l_decap_8
XFILLER_16_735 VPWR VGND sg13cmos5l_decap_8
XFILLER_11_495 VPWR VGND sg13cmos5l_decap_8
X_136_ NPU_QUANT_SHIFT_IN21 Tile_X0Y0_UserCLK _386_/X _183_/L_HI VPWR VGND sg13cmos5l_dfrbpq_1
X_205_ Tile_X0Y0_S2BEG[6] Tile_X0Y0_N2MID[1] VPWR VGND sg13cmos5l_buf_1
XFILLER_8_901 VPWR VGND sg13cmos5l_decap_8
XFILLER_7_488 VPWR VGND sg13cmos5l_decap_8
XFILLER_7_411 VPWR VGND sg13cmos5l_decap_8
X_067_ _067_/Q Tile_X0Y0_FrameData[3] VGND VPWR Tile_X0Y0_FrameStrobe[0] latch
XFILLER_0_74 VPWR VGND sg13cmos5l_decap_4
XFILLER_9_72 VPWR VGND sg13cmos5l_fill_1
XFILLER_13_727 VPWR VGND sg13cmos5l_decap_8
XFILLER_12_259 VPWR VGND sg13cmos5l_decap_8
XFILLER_5_904 VPWR VGND sg13cmos5l_decap_8
XFILLER_0_664 VPWR VGND sg13cmos5l_decap_8
XFILLER_5_959 VPWR VGND sg13cmos5l_fill_1
XFILLER_0_675 VPWR VGND sg13cmos5l_decap_8
XFILLER_16_532 VPWR VGND sg13cmos5l_decap_8
X_119_ NPU_QUANT_SHIFT_IN4 Tile_X0Y0_UserCLK _369_/X _157_/L_HI VPWR VGND sg13cmos5l_dfrbpq_1
XFILLER_8_775 VPWR VGND sg13cmos5l_fill_1
XFILLER_7_252 VPWR VGND sg13cmos5l_decap_8
XFILLER_14_28 VPWR VGND sg13cmos5l_decap_8
XFILLER_1_439 VPWR VGND sg13cmos5l_fill_1
XFILLER_17_329 VPWR VGND sg13cmos5l_decap_8
XFILLER_9_528 VPWR VGND sg13cmos5l_decap_8
XFILLER_5_767 VPWR VGND sg13cmos5l_decap_8
XFILLER_4_211 VPWR VGND sg13cmos5l_decap_8
XFILLER_1_951 VPWR VGND sg13cmos5l_decap_4
XFILLER_17_896 VPWR VGND sg13cmos5l_decap_8
XFILLER_8_561 VPWR VGND sg13cmos5l_decap_8
XFILLER_6_84 VPWR VGND sg13cmos5l_decap_8
XFILLER_1_236 VPWR VGND sg13cmos5l_fill_1
XFILLER_17_126 VPWR VGND sg13cmos5l_decap_8
XFILLER_13_343 VPWR VGND sg13cmos5l_decap_8
XFILLER_14_855 VPWR VGND sg13cmos5l_decap_8
X_384_ _384_/X Tile_X1Y0_N4END[4] Tile_X1Y0_N4END[5] Tile_X1Y0_NN4END[4] Tile_X1Y0_NN4END[6]
+ _104_/Q _103_/Q VPWR VGND sg13cmos5l_mux4_1
XFILLER_9_358 VPWR VGND sg13cmos5l_fill_2
XANTENNA__299__X Tile_X0Y0_SS4BEG[15] VPWR VGND sg13cmos5l_antennanp
XFILLER_17_693 VPWR VGND sg13cmos5l_decap_8
XFILLER_11_836 VPWR VGND sg13cmos5l_fill_2
XFILLER_11_869 VPWR VGND sg13cmos5l_decap_8
XFILLER_2_523 VPWR VGND sg13cmos5l_decap_8
XFILLER_2_512 VPWR VGND sg13cmos5l_decap_4
XANTENNA_220 Tile_X0Y0_FrameData[31] VPWR VGND sg13cmos5l_antennanp
XANTENNA_231 Tile_X0Y0_FrameData[9] VPWR VGND sg13cmos5l_antennanp
XANTENNA_242 Tile_X0Y0_NN4END[6] VPWR VGND sg13cmos5l_antennanp
XANTENNA_253 Tile_X0Y0_FrameData[30] VPWR VGND sg13cmos5l_antennanp
XANTENNA_264 Tile_X0Y0_FrameData[26] VPWR VGND sg13cmos5l_antennanp
XFILLER_13_140 VPWR VGND sg13cmos5l_decap_8
XFILLER_14_630 VPWR VGND sg13cmos5l_decap_8
XFILLER_18_468 VPWR VGND sg13cmos5l_fill_2
X_298_ Tile_X0Y0_SS4BEG[14] Tile_X0Y0_NN4END[1] VPWR VGND sg13cmos5l_buf_1
X_367_ _367_/X Tile_X0Y0_N4END[2] Tile_X0Y0_N4END[3] Tile_X0Y0_NN4END[0] Tile_X0Y0_NN4END[2]
+ _070_/Q _069_/Q VPWR VGND sg13cmos5l_mux4_1
XFILLER_9_133 VPWR VGND sg13cmos5l_decap_8
XFILLER_6_884 VPWR VGND sg13cmos5l_fill_2
XFILLER_3_63 VPWR VGND sg13cmos5l_decap_8
XFILLER_17_490 VPWR VGND sg13cmos5l_decap_8
XFILLER_11_600 VPWR VGND sg13cmos5l_decap_8
XFILLER_15_427 VPWR VGND sg13cmos5l_decap_8
XFILLER_16_917 VPWR VGND sg13cmos5l_decap_8
XFILLER_16_928 VPWR VGND sg13cmos5l_fill_1
XFILLER_10_121 VPWR VGND sg13cmos5l_decap_8
XFILLER_10_198 VPWR VGND sg13cmos5l_decap_8
XFILLER_11_677 VPWR VGND sg13cmos5l_decap_8
X_083_ _083_/Q Tile_X0Y0_FrameData[23] VGND VPWR Tile_X1Y0_FrameStrobe[0] latch
X_152_ _152_/L_HI VPWR VGND sg13cmos5l_tiehi
X_221_ Tile_X1Y0_S2BEGb[2] Tile_X1Y0_N2END[5] VPWR VGND sg13cmos5l_buf_1
XFILLER_7_626 VPWR VGND sg13cmos5l_decap_8
XFILLER_6_147 VPWR VGND sg13cmos5l_decap_8
XFILLER_5_0 VPWR VGND sg13cmos5l_decap_8
XFILLER_18_210 VPWR VGND sg13cmos5l_decap_8
XFILLER_13_909 VPWR VGND sg13cmos5l_decap_8
XFILLER_17_28 VPWR VGND sg13cmos5l_decap_8
XFILLER_16_714 VPWR VGND sg13cmos5l_decap_8
XFILLER_15_224 VPWR VGND sg13cmos5l_decap_8
X_204_ Tile_X0Y0_S2BEG[5] Tile_X0Y0_N2MID[2] VPWR VGND sg13cmos5l_buf_1
XFILLER_11_474 VPWR VGND sg13cmos5l_decap_8
X_066_ _066_/Q Tile_X0Y0_FrameData[4] VGND VPWR Tile_X0Y0_FrameStrobe[0] latch
X_135_ NPU_QUANT_SHIFT_IN20 Tile_X0Y0_UserCLK _385_/X _182_/L_HI VPWR VGND sg13cmos5l_dfrbpq_1
XFILLER_7_467 VPWR VGND sg13cmos5l_decap_8
XFILLER_3_684 VPWR VGND sg13cmos5l_decap_4
XFILLER_2_194 VPWR VGND sg13cmos5l_fill_2
XFILLER_2_183 VPWR VGND sg13cmos5l_decap_8
XFILLER_15_791 VPWR VGND sg13cmos5l_decap_8
XFILLER_9_84 VPWR VGND sg13cmos5l_decap_8
XFILLER_12_238 VPWR VGND sg13cmos5l_decap_8
XFILLER_13_706 VPWR VGND sg13cmos5l_decap_8
XFILLER_0_610 VPWR VGND sg13cmos5l_fill_1
XFILLER_16_511 VPWR VGND sg13cmos5l_decap_8
XFILLER_18_60 VPWR VGND sg13cmos5l_fill_2
XFILLER_16_588 VPWR VGND sg13cmos5l_decap_8
XFILLER_8_732 VPWR VGND sg13cmos5l_fill_2
XFILLER_7_231 VPWR VGND sg13cmos5l_decap_8
X_049_ _049_/Q Tile_X0Y0_FrameData[21] VGND VPWR Tile_X0Y0_FrameStrobe[0] latch
X_118_ NPU_QUANT_SHIFT_IN3 Tile_X0Y0_UserCLK _368_/X _158_/L_HI VPWR VGND sg13cmos5l_dfrbpq_1
XFILLER_17_308 VPWR VGND sg13cmos5l_decap_8
XFILLER_13_525 VPWR VGND sg13cmos5l_decap_8
XFILLER_9_507 VPWR VGND sg13cmos5l_decap_8
XFILLER_4_267 VPWR VGND sg13cmos5l_fill_2
XFILLER_1_930 VPWR VGND sg13cmos5l_decap_8
XFILLER_0_495 VPWR VGND sg13cmos5l_decap_8
XFILLER_16_385 VPWR VGND sg13cmos5l_decap_8
XFILLER_17_875 VPWR VGND sg13cmos5l_decap_8
XANTENNA_1 Tile_X0Y0_FrameData[0] VPWR VGND sg13cmos5l_antennanp
XFILLER_6_63 VPWR VGND sg13cmos5l_decap_8
XFILLER_10_539 VPWR VGND sg13cmos5l_decap_8
XFILLER_9_7 VPWR VGND sg13cmos5l_decap_8
XFILLER_2_749 VPWR VGND sg13cmos5l_decap_8
XFILLER_2_727 VPWR VGND sg13cmos5l_decap_8
XFILLER_1_204 VPWR VGND sg13cmos5l_fill_1
XFILLER_18_606 VPWR VGND sg13cmos5l_fill_1
XFILLER_13_322 VPWR VGND sg13cmos5l_decap_8
XFILLER_14_834 VPWR VGND sg13cmos5l_decap_8
XFILLER_17_105 VPWR VGND sg13cmos5l_decap_8
X_383_ _383_/X Tile_X1Y0_N4END[0] Tile_X1Y0_N4END[3] Tile_X1Y0_NN4END[1] Tile_X1Y0_NN4END[3]
+ _106_/Q _105_/Q VPWR VGND sg13cmos5l_mux4_1
XFILLER_13_399 VPWR VGND sg13cmos5l_decap_8
XFILLER_16_182 VPWR VGND sg13cmos5l_decap_8
XFILLER_17_672 VPWR VGND sg13cmos5l_decap_8
XFILLER_9_893 VPWR VGND sg13cmos5l_decap_8
XFILLER_14_119 VPWR VGND sg13cmos5l_decap_8
XFILLER_15_609 VPWR VGND sg13cmos5l_decap_8
XFILLER_10_303 VPWR VGND sg13cmos5l_decap_4
XFILLER_11_848 VPWR VGND sg13cmos5l_decap_8
XFILLER_18_447 VPWR VGND sg13cmos5l_fill_2
XFILLER_18_425 VPWR VGND sg13cmos5l_fill_1
XANTENNA_210 Tile_X0Y0_FrameData[31] VPWR VGND sg13cmos5l_antennanp
XANTENNA_221 Tile_X0Y0_FrameData[31] VPWR VGND sg13cmos5l_antennanp
XANTENNA_232 Tile_X0Y0_FrameData[9] VPWR VGND sg13cmos5l_antennanp
XANTENNA_243 Tile_X0Y0_NN4END[6] VPWR VGND sg13cmos5l_antennanp
XANTENNA_254 Tile_X0Y0_FrameData[30] VPWR VGND sg13cmos5l_antennanp
XANTENNA_265 Tile_X0Y0_FrameData[26] VPWR VGND sg13cmos5l_antennanp
X_366_ _366_/X Tile_X0Y0_N4END[1] Tile_X0Y0_N4END[2] Tile_X0Y0_NN4END[1] Tile_X0Y0_NN4END[3]
+ _072_/Q _071_/Q VPWR VGND sg13cmos5l_mux4_1
XFILLER_9_112 VPWR VGND sg13cmos5l_decap_8
XFILLER_13_196 VPWR VGND sg13cmos5l_decap_8
X_297_ Tile_X0Y0_SS4BEG[13] Tile_X0Y0_NN4END[2] VPWR VGND sg13cmos5l_buf_1
XFILLER_9_189 VPWR VGND sg13cmos5l_decap_8
XFILLER_6_896 VPWR VGND sg13cmos5l_decap_8
XFILLER_3_42 VPWR VGND sg13cmos5l_decap_8
XFILLER_10_100 VPWR VGND sg13cmos5l_decap_8
XFILLER_15_406 VPWR VGND sg13cmos5l_decap_8
X_220_ Tile_X1Y0_S2BEGb[1] Tile_X1Y0_N2END[6] VPWR VGND sg13cmos5l_buf_1
XFILLER_10_177 VPWR VGND sg13cmos5l_decap_8
XFILLER_11_656 VPWR VGND sg13cmos5l_decap_8
XFILLER_12_84 VPWR VGND sg13cmos5l_decap_8
X_082_ _082_/Q Tile_X0Y0_FrameData[24] VGND VPWR Tile_X1Y0_FrameStrobe[0] latch
X_151_ _151_/L_HI VPWR VGND sg13cmos5l_tiehi
XFILLER_7_605 VPWR VGND sg13cmos5l_decap_8
XFILLER_6_126 VPWR VGND sg13cmos5l_decap_8
XFILLER_18_288 VPWR VGND sg13cmos5l_decap_8
XFILLER_18_277 VPWR VGND sg13cmos5l_fill_1
XFILLER_18_266 VPWR VGND sg13cmos5l_decap_8
XFILLER_18_233 VPWR VGND sg13cmos5l_decap_8
XFILLER_14_483 VPWR VGND sg13cmos5l_decap_8
X_349_ Tile_X0Y0_FrameStrobe_O[13] Tile_X0Y0_FrameStrobe[13] VPWR VGND sg13cmos5l_buf_1
XFILLER_4_619 VPWR VGND sg13cmos5l_decap_8
XFILLER_4_608 VPWR VGND sg13cmos5l_fill_1
XFILLER_0_803 VPWR VGND sg13cmos5l_decap_8
XFILLER_0_858 VPWR VGND sg13cmos5l_fill_1
XFILLER_15_203 VPWR VGND sg13cmos5l_decap_8
XFILLER_11_453 VPWR VGND sg13cmos5l_decap_8
XFILLER_12_910 VPWR VGND sg13cmos5l_decap_8
X_203_ Tile_X0Y0_S2BEG[4] Tile_X0Y0_N2MID[3] VPWR VGND sg13cmos5l_buf_1
X_065_ _065_/Q Tile_X0Y0_FrameData[5] VGND VPWR Tile_X0Y0_FrameStrobe[0] latch
X_134_ NPU_QUANT_SHIFT_IN19 Tile_X0Y0_UserCLK _384_/X _177_/L_HI VPWR VGND sg13cmos5l_dfrbpq_1
XFILLER_8_958 VPWR VGND sg13cmos5l_fill_2
XFILLER_7_446 VPWR VGND sg13cmos5l_decap_8
XFILLER_3_641 VPWR VGND sg13cmos5l_decap_8
XFILLER_0_43 VPWR VGND sg13cmos5l_decap_4
XFILLER_15_770 VPWR VGND sg13cmos5l_decap_8
XFILLER_14_280 VPWR VGND sg13cmos5l_decap_8
XFILLER_9_63 VPWR VGND sg13cmos5l_decap_8
XFILLER_12_217 VPWR VGND sg13cmos5l_decap_8
XANTENNA__201__X Tile_X0Y0_S2BEG[2] VPWR VGND sg13cmos5l_antennanp
XFILLER_16_567 VPWR VGND sg13cmos5l_decap_8
XFILLER_18_72 VPWR VGND sg13cmos5l_decap_8
XFILLER_11_294 VPWR VGND sg13cmos5l_decap_8
XFILLER_12_784 VPWR VGND sg13cmos5l_decap_8
X_117_ NPU_QUANT_SHIFT_IN2 Tile_X0Y0_UserCLK _367_/X _160_/L_HI VPWR VGND sg13cmos5l_dfrbpq_1
XFILLER_8_700 VPWR VGND sg13cmos5l_fill_1
XFILLER_7_210 VPWR VGND sg13cmos5l_decap_8
X_048_ _048_/Q Tile_X0Y0_FrameData[22] VGND VPWR Tile_X0Y0_FrameStrobe[0] latch
XFILLER_7_287 VPWR VGND sg13cmos5l_decap_8
XFILLER_2_909 VPWR VGND sg13cmos5l_decap_8
XFILLER_13_504 VPWR VGND sg13cmos5l_decap_8
XFILLER_13_548 VPWR VGND sg13cmos5l_fill_1
XFILLER_13_559 VPWR VGND sg13cmos5l_decap_8
XFILLER_5_703 VPWR VGND sg13cmos5l_fill_2
XFILLER_4_246 VPWR VGND sg13cmos5l_decap_8
XFILLER_0_474 VPWR VGND sg13cmos5l_decap_8
XFILLER_16_364 VPWR VGND sg13cmos5l_decap_8
XFILLER_17_854 VPWR VGND sg13cmos5l_decap_8
XANTENNA_2 Tile_X0Y0_FrameData[0] VPWR VGND sg13cmos5l_antennanp
XFILLER_12_581 VPWR VGND sg13cmos5l_decap_8
XFILLER_6_42 VPWR VGND sg13cmos5l_decap_8
XFILLER_13_0 VPWR VGND sg13cmos5l_decap_8
XFILLER_10_518 VPWR VGND sg13cmos5l_decap_8
XFILLER_2_706 VPWR VGND sg13cmos5l_decap_8
XFILLER_1_227 VPWR VGND sg13cmos5l_decap_4
XFILLER_18_618 VPWR VGND sg13cmos5l_decap_4
XFILLER_13_301 VPWR VGND sg13cmos5l_decap_8
XFILLER_14_813 VPWR VGND sg13cmos5l_decap_8
XFILLER_15_84 VPWR VGND sg13cmos5l_decap_8
X_382_ _382_/X Tile_X1Y0_N4END[2] Tile_X1Y0_N4END[3] Tile_X1Y0_NN4END[0] Tile_X1Y0_NN4END[2]
+ _108_/Q _107_/Q VPWR VGND sg13cmos5l_mux4_1
XFILLER_9_305 VPWR VGND sg13cmos5l_fill_1
XFILLER_13_378 VPWR VGND sg13cmos5l_decap_8
XFILLER_5_544 VPWR VGND sg13cmos5l_decap_8
XFILLER_5_522 VPWR VGND sg13cmos5l_decap_8
XFILLER_5_588 VPWR VGND sg13cmos5l_decap_8
XFILLER_1_783 VPWR VGND sg13cmos5l_fill_2
XFILLER_1_761 VPWR VGND sg13cmos5l_fill_1
XFILLER_17_651 VPWR VGND sg13cmos5l_decap_8
XFILLER_16_161 VPWR VGND sg13cmos5l_decap_8
XFILLER_9_872 VPWR VGND sg13cmos5l_decap_8
XFILLER_11_805 VPWR VGND sg13cmos5l_decap_8
XFILLER_10_326 VPWR VGND sg13cmos5l_fill_2
XANTENNA_200 Tile_X0Y0_FrameData[28] VPWR VGND sg13cmos5l_antennanp
XANTENNA_211 Tile_X0Y0_FrameData[31] VPWR VGND sg13cmos5l_antennanp
XANTENNA_222 Tile_X0Y0_FrameData[31] VPWR VGND sg13cmos5l_antennanp
XANTENNA_233 Tile_X0Y0_FrameData[9] VPWR VGND sg13cmos5l_antennanp
XANTENNA_244 Tile_X0Y0_NN4END[6] VPWR VGND sg13cmos5l_antennanp
XANTENNA_255 Tile_X0Y0_FrameData[30] VPWR VGND sg13cmos5l_antennanp
XANTENNA_266 Tile_X0Y0_FrameData[26] VPWR VGND sg13cmos5l_antennanp
XFILLER_13_175 VPWR VGND sg13cmos5l_decap_8
XFILLER_14_687 VPWR VGND sg13cmos5l_decap_8
X_296_ Tile_X0Y0_SS4BEG[12] Tile_X0Y0_NN4END[3] VPWR VGND sg13cmos5l_buf_1
X_365_ _365_/X Tile_X0Y0_N4END[0] Tile_X0Y0_N4END[1] Tile_X0Y0_NN4END[0] Tile_X0Y0_NN4END[2]
+ _074_/Q _073_/Q VPWR VGND sg13cmos5l_mux4_1
XFILLER_10_882 VPWR VGND sg13cmos5l_decap_8
XFILLER_9_168 VPWR VGND sg13cmos5l_decap_8
XFILLER_3_98 VPWR VGND sg13cmos5l_decap_8
XFILLER_3_21 VPWR VGND sg13cmos5l_decap_8
XFILLER_1_591 VPWR VGND sg13cmos5l_decap_4
XFILLER_9_691 VPWR VGND sg13cmos5l_fill_1
XFILLER_11_635 VPWR VGND sg13cmos5l_decap_8
X_150_ NPU_QUANT_SHIFT_EN Tile_X0Y0_UserCLK _401_/X _163_/L_HI VPWR VGND sg13cmos5l_dfrbpq_1
XANTENNA__204__X Tile_X0Y0_S2BEG[5] VPWR VGND sg13cmos5l_antennanp
XFILLER_10_156 VPWR VGND sg13cmos5l_decap_8
XFILLER_12_63 VPWR VGND sg13cmos5l_decap_8
X_081_ _081_/Q Tile_X0Y0_FrameData[25] VGND VPWR Tile_X1Y0_FrameStrobe[0] latch
XFILLER_6_105 VPWR VGND sg13cmos5l_decap_8
XFILLER_3_856 VPWR VGND sg13cmos5l_decap_4
XFILLER_2_366 VPWR VGND sg13cmos5l_fill_2
XFILLER_14_462 VPWR VGND sg13cmos5l_decap_8
X_279_ Tile_X0Y0_S4BEG[11] Tile_X0Y0_N4END[4] VPWR VGND sg13cmos5l_buf_1
X_348_ Tile_X0Y0_FrameStrobe_O[12] Tile_X0Y0_FrameStrobe[12] VPWR VGND sg13cmos5l_buf_1
XFILLER_5_182 VPWR VGND sg13cmos5l_decap_8
XFILLER_3_119 VPWR VGND sg13cmos5l_decap_8
XFILLER_0_837 VPWR VGND sg13cmos5l_fill_2
XFILLER_15_259 VPWR VGND sg13cmos5l_decap_8
XFILLER_16_749 VPWR VGND sg13cmos5l_decap_8
XFILLER_11_432 VPWR VGND sg13cmos5l_decap_8
X_133_ NPU_QUANT_SHIFT_IN18 Tile_X0Y0_UserCLK _383_/X _179_/L_HI VPWR VGND sg13cmos5l_dfrbpq_1
X_202_ Tile_X0Y0_S2BEG[3] Tile_X0Y0_N2MID[4] VPWR VGND sg13cmos5l_buf_1
XFILLER_8_915 VPWR VGND sg13cmos5l_decap_8
XFILLER_7_425 VPWR VGND sg13cmos5l_decap_8
X_064_ _064_/Q Tile_X0Y0_FrameData[6] VGND VPWR Tile_X0Y0_FrameStrobe[0] latch
XFILLER_3_664 VPWR VGND sg13cmos5l_decap_4
XFILLER_3_620 VPWR VGND sg13cmos5l_decap_8
XFILLER_17_7 VPWR VGND sg13cmos5l_decap_8
XFILLER_9_42 VPWR VGND sg13cmos5l_decap_8
XFILLER_6_491 VPWR VGND sg13cmos5l_decap_8
XFILLER_5_929 VPWR VGND sg13cmos5l_fill_2
XFILLER_5_918 VPWR VGND sg13cmos5l_decap_8
XFILLER_0_689 VPWR VGND sg13cmos5l_decap_8
XFILLER_16_546 VPWR VGND sg13cmos5l_decap_8
XFILLER_11_273 VPWR VGND sg13cmos5l_decap_8
XFILLER_12_763 VPWR VGND sg13cmos5l_decap_8
X_116_ NPU_QUANT_SHIFT_IN1 Tile_X0Y0_UserCLK _366_/X _176_/L_HI VPWR VGND sg13cmos5l_dfrbpq_1
XFILLER_7_266 VPWR VGND sg13cmos5l_decap_8
X_047_ _047_/Q Tile_X0Y0_FrameData[23] VGND VPWR Tile_X0Y0_FrameStrobe[0] latch
XFILLER_3_472 VPWR VGND sg13cmos5l_decap_8
XANTENNA__302__X Tile_X0Y0_S1BEG[2] VPWR VGND sg13cmos5l_antennanp
XFILLER_5_737 VPWR VGND sg13cmos5l_fill_2
XANTENNA__212__X Tile_X1Y0_S2BEG[1] VPWR VGND sg13cmos5l_antennanp
XFILLER_0_453 VPWR VGND sg13cmos5l_fill_2
XFILLER_4_225 VPWR VGND sg13cmos5l_decap_8
XFILLER_17_833 VPWR VGND sg13cmos5l_decap_8
XFILLER_12_560 VPWR VGND sg13cmos5l_decap_8
XFILLER_16_343 VPWR VGND sg13cmos5l_decap_8
XANTENNA_3 Tile_X0Y0_FrameData[0] VPWR VGND sg13cmos5l_antennanp
XFILLER_6_98 VPWR VGND sg13cmos5l_decap_8
XFILLER_6_21 VPWR VGND sg13cmos5l_decap_8
XANTENNA__207__X Tile_X1Y0_S1BEG[0] VPWR VGND sg13cmos5l_antennanp
XFILLER_13_357 VPWR VGND sg13cmos5l_decap_8
XFILLER_14_869 VPWR VGND sg13cmos5l_decap_8
XFILLER_15_63 VPWR VGND sg13cmos5l_decap_8
X_381_ _381_/X Tile_X1Y0_N4END[1] Tile_X1Y0_N4END[2] Tile_X1Y0_NN4END[1] Tile_X1Y0_NN4END[3]
+ _110_/Q _109_/Q VPWR VGND sg13cmos5l_mux4_1
XFILLER_5_567 VPWR VGND sg13cmos5l_decap_8
XFILLER_5_501 VPWR VGND sg13cmos5l_decap_8
XFILLER_16_140 VPWR VGND sg13cmos5l_decap_8
XFILLER_17_630 VPWR VGND sg13cmos5l_decap_8
XFILLER_2_559 VPWR VGND sg13cmos5l_fill_1
XFILLER_2_537 VPWR VGND sg13cmos5l_decap_8
XANTENNA_201 Tile_X0Y0_FrameData[28] VPWR VGND sg13cmos5l_antennanp
XANTENNA_212 Tile_X0Y0_FrameData[31] VPWR VGND sg13cmos5l_antennanp
XANTENNA_223 Tile_X0Y0_FrameData[31] VPWR VGND sg13cmos5l_antennanp
XANTENNA_234 Tile_X0Y0_FrameData[9] VPWR VGND sg13cmos5l_antennanp
XANTENNA_245 Tile_X0Y0_NN4END[6] VPWR VGND sg13cmos5l_antennanp
XANTENNA_256 Tile_X0Y0_FrameData[30] VPWR VGND sg13cmos5l_antennanp
XFILLER_18_416 VPWR VGND sg13cmos5l_decap_8
XFILLER_18_405 VPWR VGND sg13cmos5l_decap_8
XFILLER_10_850 VPWR VGND sg13cmos5l_fill_1
XFILLER_10_861 VPWR VGND sg13cmos5l_decap_8
XFILLER_13_154 VPWR VGND sg13cmos5l_decap_8
XFILLER_14_644 VPWR VGND sg13cmos5l_fill_2
XFILLER_14_655 VPWR VGND sg13cmos5l_fill_1
XFILLER_14_666 VPWR VGND sg13cmos5l_decap_8
X_295_ Tile_X0Y0_SS4BEG[11] Tile_X0Y0_NN4END[4] VPWR VGND sg13cmos5l_buf_1
X_364_ Tile_X1Y0_FrameStrobe_O[8] Tile_X1Y0_FrameStrobe[8] VPWR VGND sg13cmos5l_buf_1
XFILLER_9_147 VPWR VGND sg13cmos5l_decap_8
XFILLER_5_397 VPWR VGND sg13cmos5l_fill_2
XFILLER_3_77 VPWR VGND sg13cmos5l_decap_8
XANTENNA__310__X Tile_X1Y0_FrameData_O[6] VPWR VGND sg13cmos5l_antennanp
XFILLER_10_135 VPWR VGND sg13cmos5l_decap_8
XFILLER_11_614 VPWR VGND sg13cmos5l_decap_8
X_080_ _080_/Q Tile_X0Y0_FrameData[26] VGND VPWR Tile_X1Y0_FrameStrobe[0] latch
XFILLER_12_42 VPWR VGND sg13cmos5l_decap_8
XFILLER_3_879 VPWR VGND sg13cmos5l_decap_8
XANTENNA__220__X Tile_X1Y0_S2BEGb[1] VPWR VGND sg13cmos5l_antennanp
XFILLER_18_224 VPWR VGND sg13cmos5l_decap_4
XFILLER_14_441 VPWR VGND sg13cmos5l_decap_8
XFILLER_15_931 VPWR VGND sg13cmos5l_fill_2
X_278_ Tile_X0Y0_S4BEG[10] Tile_X0Y0_N4END[5] VPWR VGND sg13cmos5l_buf_1
X_347_ Tile_X0Y0_FrameStrobe_O[11] Tile_X0Y0_FrameStrobe[11] VPWR VGND sg13cmos5l_buf_1
XFILLER_5_161 VPWR VGND sg13cmos5l_decap_8
XANTENNA__305__X Tile_X1Y0_FrameData_O[1] VPWR VGND sg13cmos5l_antennanp
XFILLER_0_849 VPWR VGND sg13cmos5l_fill_2
XFILLER_15_238 VPWR VGND sg13cmos5l_decap_8
XFILLER_16_728 VPWR VGND sg13cmos5l_decap_8
XANTENNA__215__X Tile_X1Y0_S2BEG[4] VPWR VGND sg13cmos5l_antennanp
XFILLER_11_411 VPWR VGND sg13cmos5l_decap_8
XFILLER_11_488 VPWR VGND sg13cmos5l_decap_8
X_063_ _063_/Q Tile_X0Y0_FrameData[7] VGND VPWR Tile_X0Y0_FrameStrobe[0] latch
X_132_ NPU_QUANT_SHIFT_IN17 Tile_X0Y0_UserCLK _382_/X _181_/L_HI VPWR VGND sg13cmos5l_dfrbpq_1
X_201_ Tile_X0Y0_S2BEG[2] Tile_X0Y0_N2MID[5] VPWR VGND sg13cmos5l_buf_1
XFILLER_7_404 VPWR VGND sg13cmos5l_decap_8
XFILLER_3_698 VPWR VGND sg13cmos5l_fill_2
XFILLER_3_0 VPWR VGND sg13cmos5l_decap_8
XFILLER_9_21 VPWR VGND sg13cmos5l_decap_8
XFILLER_9_98 VPWR VGND sg13cmos5l_decap_8
XFILLER_6_470 VPWR VGND sg13cmos5l_decap_8
XFILLER_0_646 VPWR VGND sg13cmos5l_fill_1
XFILLER_0_657 VPWR VGND sg13cmos5l_decap_8
XFILLER_16_525 VPWR VGND sg13cmos5l_decap_8
XFILLER_12_742 VPWR VGND sg13cmos5l_decap_8
XFILLER_18_96 VPWR VGND sg13cmos5l_decap_8
XFILLER_11_252 VPWR VGND sg13cmos5l_decap_8
X_046_ _046_/Q Tile_X0Y0_FrameData[24] VGND VPWR Tile_X0Y0_FrameStrobe[0] latch
X_115_ NPU_QUANT_SHIFT_IN0 Tile_X0Y0_UserCLK _365_/X _180_/L_HI VPWR VGND sg13cmos5l_dfrbpq_1
XFILLER_8_779 VPWR VGND sg13cmos5l_decap_8
XFILLER_8_768 VPWR VGND sg13cmos5l_decap_8
XFILLER_7_245 VPWR VGND sg13cmos5l_decap_8
XFILLER_13_539 VPWR VGND sg13cmos5l_fill_1
XFILLER_4_204 VPWR VGND sg13cmos5l_decap_8
XFILLER_1_944 VPWR VGND sg13cmos5l_fill_1
XFILLER_16_322 VPWR VGND sg13cmos5l_decap_8
XFILLER_17_889 VPWR VGND sg13cmos5l_decap_8
XFILLER_17_812 VPWR VGND sg13cmos5l_decap_8
XFILLER_16_399 VPWR VGND sg13cmos5l_decap_8
XFILLER_8_554 VPWR VGND sg13cmos5l_decap_8
XFILLER_8_543 VPWR VGND sg13cmos5l_fill_1
XFILLER_8_532 VPWR VGND sg13cmos5l_decap_8
XANTENNA_4 Tile_X0Y0_FrameData[0] VPWR VGND sg13cmos5l_antennanp
XFILLER_6_77 VPWR VGND sg13cmos5l_decap_8
XFILLER_4_793 VPWR VGND sg13cmos5l_fill_1
XANTENNA__313__X Tile_X1Y0_FrameData_O[9] VPWR VGND sg13cmos5l_antennanp
XFILLER_17_119 VPWR VGND sg13cmos5l_decap_8
XFILLER_13_336 VPWR VGND sg13cmos5l_decap_8
XFILLER_14_848 VPWR VGND sg13cmos5l_decap_8
XFILLER_15_42 VPWR VGND sg13cmos5l_decap_8
X_380_ _380_/X Tile_X1Y0_N4END[0] Tile_X1Y0_N4END[1] Tile_X1Y0_NN4END[0] Tile_X1Y0_NN4END[2]
+ _112_/Q _111_/Q VPWR VGND sg13cmos5l_mux4_1
XANTENNA__223__X Tile_X1Y0_S2BEGb[4] VPWR VGND sg13cmos5l_antennanp
XFILLER_0_240 VPWR VGND sg13cmos5l_decap_4
XFILLER_1_752 VPWR VGND sg13cmos5l_fill_2
XFILLER_1_741 VPWR VGND sg13cmos5l_decap_8
XFILLER_16_196 VPWR VGND sg13cmos5l_decap_8
XFILLER_17_686 VPWR VGND sg13cmos5l_decap_8
XFILLER_13_881 VPWR VGND sg13cmos5l_decap_8
XFILLER_9_863 VPWR VGND sg13cmos5l_decap_4
.ends
