* NGSPICE file created from N_term_RAM_IO.ext - technology: ihp-sg13cmos5l

* Black-box entry subcircuit for sg13cmos5l_decap_8 abstract view
.subckt sg13cmos5l_decap_8 VDD VSS
.ends

* Black-box entry subcircuit for sg13cmos5l_buf_1 abstract view
.subckt sg13cmos5l_buf_1 X A VDD VSS
.ends

* Black-box entry subcircuit for sg13cmos5l_fill_2 abstract view
.subckt sg13cmos5l_fill_2 VDD VSS
.ends

* Black-box entry subcircuit for sg13cmos5l_fill_1 abstract view
.subckt sg13cmos5l_fill_1 VDD VSS
.ends

* Black-box entry subcircuit for sg13cmos5l_antennanp abstract view
.subckt sg13cmos5l_antennanp A VDD VSS
.ends

* Black-box entry subcircuit for sg13cmos5l_decap_4 abstract view
.subckt sg13cmos5l_decap_4 VDD VSS
.ends

.subckt N_term_RAM_IO FrameData[0] FrameData[10] FrameData[11] FrameData[12] FrameData[13]
+ FrameData[14] FrameData[15] FrameData[16] FrameData[17] FrameData[18] FrameData[19]
+ FrameData[1] FrameData[20] FrameData[21] FrameData[22] FrameData[23] FrameData[24]
+ FrameData[25] FrameData[26] FrameData[27] FrameData[28] FrameData[29] FrameData[2]
+ FrameData[30] FrameData[31] FrameData[3] FrameData[4] FrameData[5] FrameData[6]
+ FrameData[7] FrameData[8] FrameData[9] FrameData_O[0] FrameData_O[10] FrameData_O[11]
+ FrameData_O[12] FrameData_O[13] FrameData_O[14] FrameData_O[15] FrameData_O[16]
+ FrameData_O[17] FrameData_O[18] FrameData_O[19] FrameData_O[1] FrameData_O[20] FrameData_O[21]
+ FrameData_O[22] FrameData_O[23] FrameData_O[24] FrameData_O[25] FrameData_O[26]
+ FrameData_O[27] FrameData_O[28] FrameData_O[29] FrameData_O[2] FrameData_O[30] FrameData_O[31]
+ FrameData_O[3] FrameData_O[4] FrameData_O[5] FrameData_O[6] FrameData_O[7] FrameData_O[8]
+ FrameData_O[9] FrameStrobe[0] FrameStrobe[10] FrameStrobe[11] FrameStrobe[12] FrameStrobe[13]
+ FrameStrobe[14] FrameStrobe[15] FrameStrobe[16] FrameStrobe[17] FrameStrobe[18]
+ FrameStrobe[19] FrameStrobe[1] FrameStrobe[2] FrameStrobe[3] FrameStrobe[4] FrameStrobe[5]
+ FrameStrobe[6] FrameStrobe[7] FrameStrobe[8] FrameStrobe[9] FrameStrobe_O[0] FrameStrobe_O[10]
+ FrameStrobe_O[11] FrameStrobe_O[12] FrameStrobe_O[13] FrameStrobe_O[14] FrameStrobe_O[15]
+ FrameStrobe_O[16] FrameStrobe_O[17] FrameStrobe_O[18] FrameStrobe_O[19] FrameStrobe_O[1]
+ FrameStrobe_O[2] FrameStrobe_O[3] FrameStrobe_O[4] FrameStrobe_O[5] FrameStrobe_O[6]
+ FrameStrobe_O[7] FrameStrobe_O[8] FrameStrobe_O[9] N1END[0] N1END[1] N1END[2] N1END[3]
+ N2END[0] N2END[1] N2END[2] N2END[3] N2END[4] N2END[5] N2END[6] N2END[7] N2MID[0]
+ N2MID[1] N2MID[2] N2MID[3] N2MID[4] N2MID[5] N2MID[6] N2MID[7] N4END[0] N4END[10]
+ N4END[11] N4END[12] N4END[13] N4END[14] N4END[15] N4END[1] N4END[2] N4END[3] N4END[4]
+ N4END[5] N4END[6] N4END[7] N4END[8] N4END[9] S1BEG[0] S1BEG[1] S1BEG[2] S1BEG[3]
+ S2BEG[0] S2BEG[1] S2BEG[2] S2BEG[3] S2BEG[4] S2BEG[5] S2BEG[6] S2BEG[7] S2BEGb[0]
+ S2BEGb[1] S2BEGb[2] S2BEGb[3] S2BEGb[4] S2BEGb[5] S2BEGb[6] S2BEGb[7] S4BEG[0] S4BEG[10]
+ S4BEG[11] S4BEG[12] S4BEG[13] S4BEG[14] S4BEG[15] S4BEG[1] S4BEG[2] S4BEG[3] S4BEG[4]
+ S4BEG[5] S4BEG[6] S4BEG[7] S4BEG[8] S4BEG[9] UserCLK UserCLKo VGND VPWR
XFILLER_13_166 VPWR VGND sg13cmos5l_decap_8
X_83_ FrameData_O[26] FrameData[26] VPWR VGND sg13cmos5l_buf_1
XFILLER_3_45 VPWR VGND sg13cmos5l_decap_8
XFILLER_10_158 VPWR VGND sg13cmos5l_decap_8
XFILLER_12_43 VPWR VGND sg13cmos5l_decap_8
XFILLER_6_118 VPWR VGND sg13cmos5l_decap_8
X_66_ FrameData_O[9] FrameData[9] VPWR VGND sg13cmos5l_buf_1
XFILLER_5_195 VPWR VGND sg13cmos5l_fill_2
XFILLER_5_184 VPWR VGND sg13cmos5l_decap_8
XFILLER_5_151 VPWR VGND sg13cmos5l_decap_8
XFILLER_15_217 VPWR VGND sg13cmos5l_fill_1
XFILLER_9_44 VPWR VGND sg13cmos5l_decap_8
X_49_ S2BEG[4] N2MID[3] VPWR VGND sg13cmos5l_buf_1
XFILLER_6_34 VPWR VGND sg13cmos5l_decap_8
XFILLER_15_10 VPWR VGND sg13cmos5l_fill_1
XFILLER_15_32 VPWR VGND sg13cmos5l_decap_8
XFILLER_16_120 VPWR VGND sg13cmos5l_decap_8
XFILLER_16_197 VPWR VGND sg13cmos5l_decap_8
XFILLER_11_0 VPWR VGND sg13cmos5l_fill_2
XFILLER_13_145 VPWR VGND sg13cmos5l_decap_8
XFILLER_13_189 VPWR VGND sg13cmos5l_decap_8
XFILLER_9_149 VPWR VGND sg13cmos5l_decap_8
XFILLER_3_24 VPWR VGND sg13cmos5l_decap_8
X_82_ FrameData_O[25] FrameData[25] VPWR VGND sg13cmos5l_buf_1
XFILLER_8_193 VPWR VGND sg13cmos5l_decap_8
XFILLER_10_137 VPWR VGND sg13cmos5l_decap_8
XFILLER_12_22 VPWR VGND sg13cmos5l_decap_8
XFILLER_12_99 VPWR VGND sg13cmos5l_decap_8
X_65_ FrameData_O[8] FrameData[8] VPWR VGND sg13cmos5l_buf_1
XFILLER_5_130 VPWR VGND sg13cmos5l_decap_8
XANTENNA__02__X S4BEG[1] VPWR VGND sg13cmos5l_antennanp
XFILLER_9_23 VPWR VGND sg13cmos5l_decap_8
XFILLER_2_188 VPWR VGND sg13cmos5l_decap_8
XFILLER_2_133 VPWR VGND sg13cmos5l_fill_2
X_48_ S2BEG[3] N2MID[4] VPWR VGND sg13cmos5l_buf_1
XFILLER_18_21 VPWR VGND sg13cmos5l_decap_8
XFILLER_18_87 VPWR VGND sg13cmos5l_decap_8
XFILLER_7_203 VPWR VGND sg13cmos5l_decap_8
XFILLER_4_217 VPWR VGND sg13cmos5l_fill_1
XFILLER_1_209 VPWR VGND sg13cmos5l_decap_8
XANTENNA__10__X S4BEG[9] VPWR VGND sg13cmos5l_antennanp
XFILLER_15_88 VPWR VGND sg13cmos5l_decap_8
XFILLER_16_176 VPWR VGND sg13cmos5l_decap_8
XANTENNA__05__X S4BEG[4] VPWR VGND sg13cmos5l_antennanp
XFILLER_13_124 VPWR VGND sg13cmos5l_decap_8
XFILLER_9_128 VPWR VGND sg13cmos5l_decap_8
X_81_ FrameData_O[24] FrameData[24] VPWR VGND sg13cmos5l_buf_1
XFILLER_8_172 VPWR VGND sg13cmos5l_decap_8
XFILLER_10_116 VPWR VGND sg13cmos5l_decap_8
XFILLER_12_12 VPWR VGND sg13cmos5l_fill_1
XFILLER_12_78 VPWR VGND sg13cmos5l_decap_8
X_64_ FrameData_O[7] FrameData[7] VPWR VGND sg13cmos5l_buf_1
XFILLER_15_208 VPWR VGND sg13cmos5l_decap_8
XFILLER_2_167 VPWR VGND sg13cmos5l_decap_8
XFILLER_2_112 VPWR VGND sg13cmos5l_decap_8
XFILLER_9_79 VPWR VGND sg13cmos5l_decap_8
X_47_ S2BEG[2] N2MID[5] VPWR VGND sg13cmos5l_buf_1
XANTENNA__13__X S4BEG[12] VPWR VGND sg13cmos5l_antennanp
XFILLER_15_8 VPWR VGND sg13cmos5l_fill_2
XANTENNA__08__X S4BEG[7] VPWR VGND sg13cmos5l_antennanp
XFILLER_6_69 VPWR VGND sg13cmos5l_decap_8
XFILLER_15_67 VPWR VGND sg13cmos5l_decap_8
XFILLER_16_155 VPWR VGND sg13cmos5l_decap_8
XFILLER_11_2 VPWR VGND sg13cmos5l_fill_1
XFILLER_13_103 VPWR VGND sg13cmos5l_decap_8
XFILLER_9_107 VPWR VGND sg13cmos5l_decap_8
XANTENNA__21__X S2BEGb[4] VPWR VGND sg13cmos5l_antennanp
XFILLER_12_191 VPWR VGND sg13cmos5l_decap_8
X_80_ FrameData_O[23] FrameData[23] VPWR VGND sg13cmos5l_buf_1
XFILLER_8_151 VPWR VGND sg13cmos5l_decap_8
XFILLER_3_59 VPWR VGND sg13cmos5l_decap_8
XFILLER_12_57 VPWR VGND sg13cmos5l_decap_8
XANTENNA__16__X S4BEG[15] VPWR VGND sg13cmos5l_antennanp
XFILLER_18_217 VPWR VGND sg13cmos5l_fill_1
XFILLER_5_165 VPWR VGND sg13cmos5l_decap_8
X_63_ FrameData_O[6] FrameData[6] VPWR VGND sg13cmos5l_buf_1
XFILLER_2_146 VPWR VGND sg13cmos5l_decap_8
XFILLER_2_135 VPWR VGND sg13cmos5l_fill_1
XFILLER_9_58 VPWR VGND sg13cmos5l_decap_8
X_46_ S2BEG[1] N2MID[6] VPWR VGND sg13cmos5l_buf_1
XFILLER_11_212 VPWR VGND sg13cmos5l_decap_4
X_29_ FrameStrobe_O[4] FrameStrobe[4] VPWR VGND sg13cmos5l_buf_1
XFILLER_4_208 VPWR VGND sg13cmos5l_decap_8
XFILLER_1_81 VPWR VGND sg13cmos5l_fill_1
XFILLER_1_70 VPWR VGND sg13cmos5l_decap_4
XANTENNA__24__X S2BEGb[7] VPWR VGND sg13cmos5l_antennanp
XFILLER_6_48 VPWR VGND sg13cmos5l_decap_8
XANTENNA__19__X S2BEGb[2] VPWR VGND sg13cmos5l_antennanp
XFILLER_15_46 VPWR VGND sg13cmos5l_decap_8
XFILLER_16_134 VPWR VGND sg13cmos5l_decap_8
XFILLER_7_91 VPWR VGND sg13cmos5l_decap_8
XFILLER_13_159 VPWR VGND sg13cmos5l_decap_8
XFILLER_3_38 VPWR VGND sg13cmos5l_decap_8
XFILLER_12_36 VPWR VGND sg13cmos5l_decap_8
XFILLER_8_130 VPWR VGND sg13cmos5l_decap_8
XANTENNA__32__X FrameStrobe_O[7] VPWR VGND sg13cmos5l_antennanp
XFILLER_5_144 VPWR VGND sg13cmos5l_decap_8
X_62_ FrameData_O[5] FrameData[5] VPWR VGND sg13cmos5l_buf_1
XFILLER_5_177 VPWR VGND sg13cmos5l_decap_8
XANTENNA__27__X FrameStrobe_O[2] VPWR VGND sg13cmos5l_antennanp
XFILLER_9_37 VPWR VGND sg13cmos5l_decap_8
XFILLER_18_35 VPWR VGND sg13cmos5l_fill_1
XFILLER_18_46 VPWR VGND sg13cmos5l_fill_1
X_45_ S2BEG[0] N2MID[7] VPWR VGND sg13cmos5l_buf_1
XFILLER_7_217 VPWR VGND sg13cmos5l_fill_1
X_28_ FrameStrobe_O[3] FrameStrobe[3] VPWR VGND sg13cmos5l_buf_1
XANTENNA__40__X FrameStrobe_O[15] VPWR VGND sg13cmos5l_antennanp
XFILLER_13_7 VPWR VGND sg13cmos5l_fill_2
XFILLER_6_27 VPWR VGND sg13cmos5l_decap_8
XFILLER_15_14 VPWR VGND sg13cmos5l_fill_1
XFILLER_15_25 VPWR VGND sg13cmos5l_decap_8
XANTENNA__35__X FrameStrobe_O[10] VPWR VGND sg13cmos5l_antennanp
XFILLER_16_113 VPWR VGND sg13cmos5l_decap_8
XFILLER_7_70 VPWR VGND sg13cmos5l_decap_8
XFILLER_13_138 VPWR VGND sg13cmos5l_decap_8
XFILLER_3_17 VPWR VGND sg13cmos5l_decap_8
XFILLER_8_186 VPWR VGND sg13cmos5l_decap_8
X_61_ FrameData_O[4] FrameData[4] VPWR VGND sg13cmos5l_buf_1
XFILLER_5_123 VPWR VGND sg13cmos5l_decap_8
XFILLER_4_82 VPWR VGND sg13cmos5l_decap_8
XANTENNA__43__X FrameStrobe_O[18] VPWR VGND sg13cmos5l_antennanp
XFILLER_9_16 VPWR VGND sg13cmos5l_decap_8
XFILLER_2_126 VPWR VGND sg13cmos5l_decap_8
X_44_ FrameStrobe_O[19] FrameStrobe[19] VPWR VGND sg13cmos5l_buf_1
XFILLER_1_181 VPWR VGND sg13cmos5l_decap_8
XANTENNA__38__X FrameStrobe_O[13] VPWR VGND sg13cmos5l_antennanp
XFILLER_18_14 VPWR VGND sg13cmos5l_decap_8
X_27_ FrameStrobe_O[2] FrameStrobe[2] VPWR VGND sg13cmos5l_buf_1
XFILLER_10_81 VPWR VGND sg13cmos5l_decap_8
XANTENNA__51__X S2BEG[6] VPWR VGND sg13cmos5l_antennanp
XFILLER_0_202 VPWR VGND sg13cmos5l_decap_8
XFILLER_16_169 VPWR VGND sg13cmos5l_decap_8
XFILLER_13_117 VPWR VGND sg13cmos5l_decap_8
XANTENNA__46__X S2BEG[1] VPWR VGND sg13cmos5l_antennanp
XFILLER_8_165 VPWR VGND sg13cmos5l_decap_8
XFILLER_10_109 VPWR VGND sg13cmos5l_decap_8
X_60_ FrameData_O[3] FrameData[3] VPWR VGND sg13cmos5l_buf_1
XFILLER_5_102 VPWR VGND sg13cmos5l_decap_8
XFILLER_4_61 VPWR VGND sg13cmos5l_decap_8
XFILLER_14_201 VPWR VGND sg13cmos5l_decap_8
XFILLER_2_105 VPWR VGND sg13cmos5l_decap_8
X_43_ FrameStrobe_O[18] FrameStrobe[18] VPWR VGND sg13cmos5l_buf_1
XFILLER_1_160 VPWR VGND sg13cmos5l_fill_1
XANTENNA__54__X S1BEG[1] VPWR VGND sg13cmos5l_antennanp
X_26_ FrameStrobe_O[1] FrameStrobe[1] VPWR VGND sg13cmos5l_buf_1
XFILLER_1_62 VPWR VGND sg13cmos5l_fill_2
XANTENNA__49__X S2BEG[4] VPWR VGND sg13cmos5l_antennanp
XFILLER_10_60 VPWR VGND sg13cmos5l_decap_8
X_09_ S4BEG[8] N4END[7] VPWR VGND sg13cmos5l_buf_1
XFILLER_16_148 VPWR VGND sg13cmos5l_decap_8
XANTENNA__62__X FrameData_O[5] VPWR VGND sg13cmos5l_antennanp
XFILLER_12_162 VPWR VGND sg13cmos5l_decap_8
XFILLER_12_184 VPWR VGND sg13cmos5l_decap_8
XFILLER_16_92 VPWR VGND sg13cmos5l_decap_8
XFILLER_8_144 VPWR VGND sg13cmos5l_decap_8
XANTENNA__57__X FrameData_O[0] VPWR VGND sg13cmos5l_antennanp
XFILLER_17_210 VPWR VGND sg13cmos5l_decap_8
XFILLER_5_158 VPWR VGND sg13cmos5l_decap_8
XFILLER_4_40 VPWR VGND sg13cmos5l_decap_8
XFILLER_4_180 VPWR VGND sg13cmos5l_decap_8
XFILLER_2_139 VPWR VGND sg13cmos5l_decap_8
XFILLER_13_82 VPWR VGND sg13cmos5l_decap_8
X_42_ FrameStrobe_O[17] FrameStrobe[17] VPWR VGND sg13cmos5l_buf_1
XFILLER_11_205 VPWR VGND sg13cmos5l_decap_8
XFILLER_11_216 VPWR VGND sg13cmos5l_fill_2
XANTENNA__70__X FrameData_O[13] VPWR VGND sg13cmos5l_antennanp
X_25_ FrameStrobe_O[0] FrameStrobe[0] VPWR VGND sg13cmos5l_buf_1
XFILLER_1_85 VPWR VGND sg13cmos5l_decap_4
XFILLER_1_74 VPWR VGND sg13cmos5l_fill_2
XANTENNA__65__X FrameData_O[8] VPWR VGND sg13cmos5l_antennanp
XFILLER_18_0 VPWR VGND sg13cmos5l_decap_8
X_08_ S4BEG[7] N4END[8] VPWR VGND sg13cmos5l_buf_1
XFILLER_15_39 VPWR VGND sg13cmos5l_decap_8
XFILLER_16_127 VPWR VGND sg13cmos5l_decap_8
XFILLER_7_84 VPWR VGND sg13cmos5l_decap_8
XFILLER_12_141 VPWR VGND sg13cmos5l_decap_8
XFILLER_16_71 VPWR VGND sg13cmos5l_decap_8
XFILLER_8_123 VPWR VGND sg13cmos5l_decap_8
XFILLER_12_29 VPWR VGND sg13cmos5l_decap_8
XFILLER_5_137 VPWR VGND sg13cmos5l_decap_8
XANTENNA__73__X FrameData_O[16] VPWR VGND sg13cmos5l_antennanp
XFILLER_4_96 VPWR VGND sg13cmos5l_decap_8
XFILLER_3_9 VPWR VGND sg13cmos5l_fill_2
XANTENNA__68__X FrameData_O[11] VPWR VGND sg13cmos5l_antennanp
XFILLER_13_61 VPWR VGND sg13cmos5l_decap_8
X_41_ FrameStrobe_O[16] FrameStrobe[16] VPWR VGND sg13cmos5l_buf_1
XFILLER_1_195 VPWR VGND sg13cmos5l_decap_8
XFILLER_18_28 VPWR VGND sg13cmos5l_decap_8
XFILLER_18_39 VPWR VGND sg13cmos5l_decap_8
X_24_ S2BEGb[7] N2END[0] VPWR VGND sg13cmos5l_buf_1
XFILLER_1_53 VPWR VGND sg13cmos5l_fill_2
XFILLER_3_202 VPWR VGND sg13cmos5l_decap_8
XANTENNA__81__X FrameData_O[24] VPWR VGND sg13cmos5l_antennanp
XFILLER_10_95 VPWR VGND sg13cmos5l_decap_8
XFILLER_15_18 VPWR VGND sg13cmos5l_decap_8
X_07_ S4BEG[6] N4END[9] VPWR VGND sg13cmos5l_buf_1
XANTENNA__76__X FrameData_O[19] VPWR VGND sg13cmos5l_antennanp
XFILLER_16_106 VPWR VGND sg13cmos5l_decap_8
XFILLER_15_172 VPWR VGND sg13cmos5l_decap_8
XFILLER_15_194 VPWR VGND sg13cmos5l_decap_8
XFILLER_7_63 VPWR VGND sg13cmos5l_decap_8
XFILLER_12_120 VPWR VGND sg13cmos5l_decap_8
XFILLER_16_50 VPWR VGND sg13cmos5l_decap_8
XFILLER_8_102 VPWR VGND sg13cmos5l_decap_8
XFILLER_8_179 VPWR VGND sg13cmos5l_decap_8
XFILLER_5_116 VPWR VGND sg13cmos5l_decap_8
XFILLER_4_75 VPWR VGND sg13cmos5l_decap_8
XFILLER_2_119 VPWR VGND sg13cmos5l_decap_8
XFILLER_13_40 VPWR VGND sg13cmos5l_decap_8
XFILLER_14_215 VPWR VGND sg13cmos5l_fill_2
X_40_ FrameStrobe_O[15] FrameStrobe[15] VPWR VGND sg13cmos5l_buf_1
XFILLER_8_0 VPWR VGND sg13cmos5l_fill_2
XFILLER_1_174 VPWR VGND sg13cmos5l_decap_8
XANTENNA__84__X FrameData_O[27] VPWR VGND sg13cmos5l_antennanp
XANTENNA__79__X FrameData_O[22] VPWR VGND sg13cmos5l_antennanp
X_23_ S2BEGb[6] N2END[1] VPWR VGND sg13cmos5l_buf_1
XFILLER_1_21 VPWR VGND sg13cmos5l_fill_2
XFILLER_10_74 VPWR VGND sg13cmos5l_decap_8
XFILLER_0_217 VPWR VGND sg13cmos5l_fill_1
XFILLER_18_192 VPWR VGND sg13cmos5l_decap_4
X_06_ S4BEG[5] N4END[10] VPWR VGND sg13cmos5l_buf_1
XFILLER_15_151 VPWR VGND sg13cmos5l_decap_8
XFILLER_7_42 VPWR VGND sg13cmos5l_decap_8
XANTENNA__87__X FrameData_O[30] VPWR VGND sg13cmos5l_antennanp
XFILLER_12_176 VPWR VGND sg13cmos5l_decap_4
XFILLER_12_198 VPWR VGND sg13cmos5l_decap_8
XFILLER_8_158 VPWR VGND sg13cmos5l_decap_8
XFILLER_4_54 VPWR VGND sg13cmos5l_decap_8
XFILLER_4_194 VPWR VGND sg13cmos5l_decap_8
XFILLER_13_96 VPWR VGND sg13cmos5l_decap_8
XFILLER_1_131 VPWR VGND sg13cmos5l_fill_1
XFILLER_1_8 VPWR VGND sg13cmos5l_decap_8
X_22_ S2BEGb[5] N2END[2] VPWR VGND sg13cmos5l_buf_1
XFILLER_1_55 VPWR VGND sg13cmos5l_fill_1
XFILLER_10_53 VPWR VGND sg13cmos5l_decap_8
X_05_ S4BEG[4] N4END[11] VPWR VGND sg13cmos5l_buf_1
XFILLER_15_130 VPWR VGND sg13cmos5l_decap_8
XFILLER_7_98 VPWR VGND sg13cmos5l_decap_8
XFILLER_7_21 VPWR VGND sg13cmos5l_decap_8
XFILLER_16_0 VPWR VGND sg13cmos5l_fill_2
XFILLER_12_155 VPWR VGND sg13cmos5l_decap_8
XFILLER_16_85 VPWR VGND sg13cmos5l_decap_8
XFILLER_8_137 VPWR VGND sg13cmos5l_decap_8
XFILLER_17_203 VPWR VGND sg13cmos5l_decap_8
XFILLER_4_33 VPWR VGND sg13cmos5l_decap_8
XFILLER_4_173 VPWR VGND sg13cmos5l_fill_2
XFILLER_4_11 VPWR VGND sg13cmos5l_fill_1
XFILLER_13_75 VPWR VGND sg13cmos5l_decap_8
XFILLER_14_217 VPWR VGND sg13cmos5l_fill_1
XFILLER_8_2 VPWR VGND sg13cmos5l_fill_1
X_21_ S2BEGb[4] N2END[3] VPWR VGND sg13cmos5l_buf_1
XFILLER_1_23 VPWR VGND sg13cmos5l_fill_1
XFILLER_1_89 VPWR VGND sg13cmos5l_fill_1
XFILLER_1_34 VPWR VGND sg13cmos5l_decap_4
XFILLER_10_32 VPWR VGND sg13cmos5l_decap_8
XFILLER_3_216 VPWR VGND sg13cmos5l_fill_2
XFILLER_18_150 VPWR VGND sg13cmos5l_decap_8
XFILLER_18_161 VPWR VGND sg13cmos5l_decap_4
X_04_ S4BEG[3] N4END[12] VPWR VGND sg13cmos5l_buf_1
XFILLER_7_77 VPWR VGND sg13cmos5l_decap_8
XFILLER_12_134 VPWR VGND sg13cmos5l_decap_8
XFILLER_16_64 VPWR VGND sg13cmos5l_decap_8
XFILLER_8_116 VPWR VGND sg13cmos5l_decap_8
XFILLER_7_193 VPWR VGND sg13cmos5l_fill_2
XFILLER_7_182 VPWR VGND sg13cmos5l_decap_8
XFILLER_4_89 VPWR VGND sg13cmos5l_decap_8
XFILLER_4_152 VPWR VGND sg13cmos5l_decap_8
XFILLER_13_54 VPWR VGND sg13cmos5l_decap_8
XFILLER_1_188 VPWR VGND sg13cmos5l_decap_8
XFILLER_1_144 VPWR VGND sg13cmos5l_fill_1
XFILLER_6_203 VPWR VGND sg13cmos5l_fill_2
XFILLER_6_0 VPWR VGND sg13cmos5l_fill_2
X_20_ S2BEGb[3] N2END[4] VPWR VGND sg13cmos5l_buf_1
XFILLER_1_79 VPWR VGND sg13cmos5l_fill_2
XFILLER_1_46 VPWR VGND sg13cmos5l_decap_8
XFILLER_10_88 VPWR VGND sg13cmos5l_decap_8
XFILLER_18_140 VPWR VGND sg13cmos5l_decap_8
X_03_ S4BEG[2] N4END[13] VPWR VGND sg13cmos5l_buf_1
XANTENNA__00__X UserCLKo VPWR VGND sg13cmos5l_antennanp
XFILLER_15_165 VPWR VGND sg13cmos5l_decap_8
XFILLER_15_187 VPWR VGND sg13cmos5l_decap_8
XFILLER_16_2 VPWR VGND sg13cmos5l_fill_1
XFILLER_7_56 VPWR VGND sg13cmos5l_decap_8
XFILLER_12_113 VPWR VGND sg13cmos5l_decap_8
XFILLER_16_43 VPWR VGND sg13cmos5l_decap_8
XFILLER_7_161 VPWR VGND sg13cmos5l_decap_8
XFILLER_5_109 VPWR VGND sg13cmos5l_decap_8
XFILLER_4_68 VPWR VGND sg13cmos5l_decap_8
XFILLER_4_175 VPWR VGND sg13cmos5l_fill_1
XFILLER_4_131 VPWR VGND sg13cmos5l_decap_8
XFILLER_13_33 VPWR VGND sg13cmos5l_decap_8
XFILLER_14_208 VPWR VGND sg13cmos5l_decap_8
XFILLER_1_167 VPWR VGND sg13cmos5l_decap_8
XFILLER_9_212 VPWR VGND sg13cmos5l_decap_4
XANTENNA__03__X S4BEG[2] VPWR VGND sg13cmos5l_antennanp
XFILLER_10_200 VPWR VGND sg13cmos5l_fill_2
XFILLER_10_67 VPWR VGND sg13cmos5l_decap_8
X_79_ FrameData_O[22] FrameData[22] VPWR VGND sg13cmos5l_buf_1
XFILLER_18_130 VPWR VGND sg13cmos5l_decap_8
XFILLER_18_185 VPWR VGND sg13cmos5l_decap_8
XFILLER_18_196 VPWR VGND sg13cmos5l_fill_1
X_02_ S4BEG[1] N4END[14] VPWR VGND sg13cmos5l_buf_1
XFILLER_15_144 VPWR VGND sg13cmos5l_decap_8
XFILLER_7_35 VPWR VGND sg13cmos5l_decap_8
XFILLER_12_169 VPWR VGND sg13cmos5l_decap_8
XFILLER_16_22 VPWR VGND sg13cmos5l_decap_8
XFILLER_16_99 VPWR VGND sg13cmos5l_decap_8
XANTENNA__11__X S4BEG[10] VPWR VGND sg13cmos5l_antennanp
XFILLER_11_180 VPWR VGND sg13cmos5l_decap_8
XFILLER_7_140 VPWR VGND sg13cmos5l_decap_8
XFILLER_14_0 VPWR VGND sg13cmos5l_fill_2
XANTENNA__06__X S4BEG[5] VPWR VGND sg13cmos5l_antennanp
XFILLER_17_217 VPWR VGND sg13cmos5l_fill_1
XFILLER_4_47 VPWR VGND sg13cmos5l_decap_8
XFILLER_4_187 VPWR VGND sg13cmos5l_decap_8
XFILLER_4_110 VPWR VGND sg13cmos5l_decap_8
XFILLER_13_89 VPWR VGND sg13cmos5l_decap_8
XFILLER_1_113 VPWR VGND sg13cmos5l_decap_4
XFILLER_1_102 VPWR VGND sg13cmos5l_fill_1
XFILLER_0_190 VPWR VGND sg13cmos5l_fill_1
XFILLER_6_216 VPWR VGND sg13cmos5l_fill_2
XFILLER_6_2 VPWR VGND sg13cmos5l_fill_1
XFILLER_1_15 VPWR VGND sg13cmos5l_fill_2
X_78_ FrameData_O[21] FrameData[21] VPWR VGND sg13cmos5l_buf_1
XANTENNA__14__X S4BEG[13] VPWR VGND sg13cmos5l_antennanp
XFILLER_10_46 VPWR VGND sg13cmos5l_decap_8
XFILLER_18_120 VPWR VGND sg13cmos5l_decap_8
XFILLER_18_7 VPWR VGND sg13cmos5l_decap_8
X_01_ S4BEG[0] N4END[15] VPWR VGND sg13cmos5l_buf_1
XFILLER_2_91 VPWR VGND sg13cmos5l_decap_8
XANTENNA__09__X S4BEG[8] VPWR VGND sg13cmos5l_antennanp
XFILLER_15_123 VPWR VGND sg13cmos5l_decap_8
XFILLER_12_148 VPWR VGND sg13cmos5l_decap_8
XFILLER_16_78 VPWR VGND sg13cmos5l_decap_8
XANTENNA__22__X S2BEGb[5] VPWR VGND sg13cmos5l_antennanp
XFILLER_4_26 VPWR VGND sg13cmos5l_decap_8
XFILLER_4_166 VPWR VGND sg13cmos5l_decap_8
XFILLER_13_68 VPWR VGND sg13cmos5l_decap_8
XFILLER_1_158 VPWR VGND sg13cmos5l_fill_2
XANTENNA__17__X S2BEGb[0] VPWR VGND sg13cmos5l_antennanp
XFILLER_13_210 VPWR VGND sg13cmos5l_decap_8
XFILLER_10_202 VPWR VGND sg13cmos5l_fill_1
XFILLER_1_38 VPWR VGND sg13cmos5l_fill_2
XFILLER_1_27 VPWR VGND sg13cmos5l_decap_8
X_77_ FrameData_O[20] FrameData[20] VPWR VGND sg13cmos5l_buf_1
XFILLER_10_25 VPWR VGND sg13cmos5l_decap_8
XFILLER_3_209 VPWR VGND sg13cmos5l_decap_8
XANTENNA__30__X FrameStrobe_O[5] VPWR VGND sg13cmos5l_antennanp
XFILLER_18_110 VPWR VGND sg13cmos5l_decap_8
XFILLER_18_165 VPWR VGND sg13cmos5l_fill_2
XFILLER_18_176 VPWR VGND sg13cmos5l_fill_2
X_00_ UserCLKo UserCLK VPWR VGND sg13cmos5l_buf_1
XFILLER_4_0 VPWR VGND sg13cmos5l_fill_2
XFILLER_2_70 VPWR VGND sg13cmos5l_decap_8
XANTENNA__25__X FrameStrobe_O[0] VPWR VGND sg13cmos5l_antennanp
XFILLER_15_102 VPWR VGND sg13cmos5l_decap_8
XFILLER_15_179 VPWR VGND sg13cmos5l_decap_4
XFILLER_12_127 VPWR VGND sg13cmos5l_decap_8
XFILLER_16_57 VPWR VGND sg13cmos5l_decap_8
XFILLER_8_109 VPWR VGND sg13cmos5l_decap_8
XFILLER_14_2 VPWR VGND sg13cmos5l_fill_1
XFILLER_7_175 VPWR VGND sg13cmos5l_decap_8
XFILLER_4_145 VPWR VGND sg13cmos5l_decap_8
XFILLER_13_47 VPWR VGND sg13cmos5l_decap_8
XANTENNA__33__X FrameStrobe_O[8] VPWR VGND sg13cmos5l_antennanp
XFILLER_5_81 VPWR VGND sg13cmos5l_decap_8
XFILLER_10_214 VPWR VGND sg13cmos5l_decap_4
XANTENNA__28__X FrameStrobe_O[3] VPWR VGND sg13cmos5l_antennanp
X_76_ FrameData_O[19] FrameData[19] VPWR VGND sg13cmos5l_buf_1
XFILLER_18_100 VPWR VGND sg13cmos5l_decap_8
X_59_ FrameData_O[2] FrameData[2] VPWR VGND sg13cmos5l_buf_1
XANTENNA__41__X FrameStrobe_O[16] VPWR VGND sg13cmos5l_antennanp
XFILLER_15_158 VPWR VGND sg13cmos5l_decap_8
XFILLER_7_49 VPWR VGND sg13cmos5l_decap_8
XFILLER_14_180 VPWR VGND sg13cmos5l_decap_4
XFILLER_12_106 VPWR VGND sg13cmos5l_decap_8
XFILLER_16_36 VPWR VGND sg13cmos5l_decap_8
XANTENNA__36__X FrameStrobe_O[11] VPWR VGND sg13cmos5l_antennanp
XFILLER_11_194 VPWR VGND sg13cmos5l_decap_8
XFILLER_7_154 VPWR VGND sg13cmos5l_decap_8
XFILLER_8_81 VPWR VGND sg13cmos5l_decap_8
XFILLER_4_124 VPWR VGND sg13cmos5l_decap_8
XFILLER_13_26 VPWR VGND sg13cmos5l_decap_8
XFILLER_9_216 VPWR VGND sg13cmos5l_fill_2
XFILLER_9_205 VPWR VGND sg13cmos5l_decap_8
XFILLER_1_138 VPWR VGND sg13cmos5l_fill_2
XFILLER_5_60 VPWR VGND sg13cmos5l_decap_8
XANTENNA__44__X FrameStrobe_O[19] VPWR VGND sg13cmos5l_antennanp
X_75_ FrameData_O[18] FrameData[18] VPWR VGND sg13cmos5l_buf_1
XANTENNA__39__X FrameStrobe_O[14] VPWR VGND sg13cmos5l_antennanp
XFILLER_4_2 VPWR VGND sg13cmos5l_fill_1
XFILLER_18_178 VPWR VGND sg13cmos5l_fill_1
X_58_ FrameData_O[1] FrameData[1] VPWR VGND sg13cmos5l_buf_1
XFILLER_15_137 VPWR VGND sg13cmos5l_decap_8
XFILLER_16_7 VPWR VGND sg13cmos5l_fill_1
XFILLER_7_28 VPWR VGND sg13cmos5l_decap_8
XANTENNA__52__X S2BEG[7] VPWR VGND sg13cmos5l_antennanp
XFILLER_11_173 VPWR VGND sg13cmos5l_decap_8
XFILLER_7_133 VPWR VGND sg13cmos5l_decap_8
XFILLER_8_60 VPWR VGND sg13cmos5l_decap_8
XANTENNA__47__X S2BEG[2] VPWR VGND sg13cmos5l_antennanp
XFILLER_4_18 VPWR VGND sg13cmos5l_fill_1
XFILLER_4_103 VPWR VGND sg13cmos5l_decap_8
XFILLER_17_91 VPWR VGND sg13cmos5l_decap_8
XFILLER_1_117 VPWR VGND sg13cmos5l_fill_2
XFILLER_1_106 VPWR VGND sg13cmos5l_decap_8
XFILLER_0_172 VPWR VGND sg13cmos5l_decap_8
XFILLER_6_209 VPWR VGND sg13cmos5l_decap_8
XANTENNA__60__X FrameData_O[3] VPWR VGND sg13cmos5l_antennanp
XFILLER_10_39 VPWR VGND sg13cmos5l_decap_8
X_74_ FrameData_O[17] FrameData[17] VPWR VGND sg13cmos5l_buf_1
XANTENNA__55__X S1BEG[2] VPWR VGND sg13cmos5l_antennanp
XFILLER_18_157 VPWR VGND sg13cmos5l_fill_1
XFILLER_2_84 VPWR VGND sg13cmos5l_decap_8
XFILLER_15_116 VPWR VGND sg13cmos5l_decap_8
X_57_ FrameData_O[0] FrameData[0] VPWR VGND sg13cmos5l_buf_1
XFILLER_11_82 VPWR VGND sg13cmos5l_decap_8
XFILLER_2_0 VPWR VGND sg13cmos5l_decap_8
XFILLER_11_152 VPWR VGND sg13cmos5l_decap_8
XFILLER_7_112 VPWR VGND sg13cmos5l_decap_8
XFILLER_7_189 VPWR VGND sg13cmos5l_decap_4
XFILLER_4_159 VPWR VGND sg13cmos5l_decap_8
XANTENNA__63__X FrameData_O[6] VPWR VGND sg13cmos5l_antennanp
XFILLER_16_211 VPWR VGND sg13cmos5l_decap_8
XFILLER_17_70 VPWR VGND sg13cmos5l_decap_8
XFILLER_3_181 VPWR VGND sg13cmos5l_decap_8
XANTENNA__58__X FrameData_O[1] VPWR VGND sg13cmos5l_antennanp
XFILLER_0_195 VPWR VGND sg13cmos5l_decap_8
XFILLER_13_203 VPWR VGND sg13cmos5l_decap_8
XFILLER_5_95 VPWR VGND sg13cmos5l_decap_8
XFILLER_14_82 VPWR VGND sg13cmos5l_decap_8
X_73_ FrameData_O[16] FrameData[16] VPWR VGND sg13cmos5l_buf_1
XFILLER_10_18 VPWR VGND sg13cmos5l_decap_8
XFILLER_2_202 VPWR VGND sg13cmos5l_decap_8
XANTENNA__71__X FrameData_O[14] VPWR VGND sg13cmos5l_antennanp
X_56_ S1BEG[3] N1END[0] VPWR VGND sg13cmos5l_buf_1
XFILLER_2_63 VPWR VGND sg13cmos5l_decap_8
XANTENNA__66__X FrameData_O[9] VPWR VGND sg13cmos5l_antennanp
XFILLER_11_61 VPWR VGND sg13cmos5l_decap_8
XFILLER_14_194 VPWR VGND sg13cmos5l_decap_8
X_39_ FrameStrobe_O[14] FrameStrobe[14] VPWR VGND sg13cmos5l_buf_1
XFILLER_11_131 VPWR VGND sg13cmos5l_decap_8
XFILLER_7_168 VPWR VGND sg13cmos5l_decap_8
XFILLER_8_95 VPWR VGND sg13cmos5l_decap_8
XFILLER_6_190 VPWR VGND sg13cmos5l_fill_2
XFILLER_4_138 VPWR VGND sg13cmos5l_decap_8
XFILLER_3_171 VPWR VGND sg13cmos5l_decap_4
XANTENNA__74__X FrameData_O[17] VPWR VGND sg13cmos5l_antennanp
XFILLER_10_0 VPWR VGND sg13cmos5l_fill_2
XFILLER_5_74 VPWR VGND sg13cmos5l_decap_8
XFILLER_10_207 VPWR VGND sg13cmos5l_decap_8
XANTENNA__69__X FrameData_O[12] VPWR VGND sg13cmos5l_antennanp
XFILLER_14_61 VPWR VGND sg13cmos5l_decap_8
X_72_ FrameData_O[15] FrameData[15] VPWR VGND sg13cmos5l_buf_1
XFILLER_5_211 VPWR VGND sg13cmos5l_decap_8
X_55_ S1BEG[2] N1END[1] VPWR VGND sg13cmos5l_buf_1
XFILLER_2_42 VPWR VGND sg13cmos5l_decap_8
XFILLER_11_40 VPWR VGND sg13cmos5l_decap_8
XANTENNA__82__X FrameData_O[25] VPWR VGND sg13cmos5l_antennanp
XFILLER_14_173 VPWR VGND sg13cmos5l_decap_8
XFILLER_14_184 VPWR VGND sg13cmos5l_fill_2
XFILLER_16_29 VPWR VGND sg13cmos5l_decap_8
X_38_ FrameStrobe_O[13] FrameStrobe[13] VPWR VGND sg13cmos5l_buf_1
XANTENNA__77__X FrameData_O[20] VPWR VGND sg13cmos5l_antennanp
XFILLER_11_110 VPWR VGND sg13cmos5l_decap_8
XFILLER_11_187 VPWR VGND sg13cmos5l_decap_8
XFILLER_7_147 VPWR VGND sg13cmos5l_decap_8
XFILLER_8_74 VPWR VGND sg13cmos5l_decap_8
XFILLER_4_117 VPWR VGND sg13cmos5l_decap_8
XFILLER_13_19 VPWR VGND sg13cmos5l_decap_8
XFILLER_3_150 VPWR VGND sg13cmos5l_decap_8
XFILLER_0_186 VPWR VGND sg13cmos5l_decap_4
XFILLER_5_53 VPWR VGND sg13cmos5l_decap_8
XANTENNA__85__X FrameData_O[28] VPWR VGND sg13cmos5l_antennanp
XFILLER_14_40 VPWR VGND sg13cmos5l_decap_8
X_71_ FrameData_O[14] FrameData[14] VPWR VGND sg13cmos5l_buf_1
XFILLER_5_201 VPWR VGND sg13cmos5l_decap_4
XFILLER_17_182 VPWR VGND sg13cmos5l_decap_8
X_54_ S1BEG[1] N1END[2] VPWR VGND sg13cmos5l_buf_1
XFILLER_2_98 VPWR VGND sg13cmos5l_decap_8
XFILLER_2_21 VPWR VGND sg13cmos5l_decap_8
XFILLER_11_96 VPWR VGND sg13cmos5l_decap_8
XFILLER_14_152 VPWR VGND sg13cmos5l_decap_8
X_37_ FrameStrobe_O[12] FrameStrobe[12] VPWR VGND sg13cmos5l_buf_1
XFILLER_0_0 VPWR VGND sg13cmos5l_fill_2
XFILLER_11_166 VPWR VGND sg13cmos5l_decap_8
XFILLER_7_126 VPWR VGND sg13cmos5l_decap_8
XFILLER_8_53 VPWR VGND sg13cmos5l_decap_8
XFILLER_17_84 VPWR VGND sg13cmos5l_decap_8
XANTENNA__88__X FrameData_O[31] VPWR VGND sg13cmos5l_antennanp
XFILLER_3_195 VPWR VGND sg13cmos5l_decap_8
XFILLER_13_217 VPWR VGND sg13cmos5l_fill_1
XFILLER_10_2 VPWR VGND sg13cmos5l_fill_1
XFILLER_5_32 VPWR VGND sg13cmos5l_decap_8
XFILLER_14_96 VPWR VGND sg13cmos5l_decap_8
X_70_ FrameData_O[13] FrameData[13] VPWR VGND sg13cmos5l_buf_1
XFILLER_2_216 VPWR VGND sg13cmos5l_fill_2
XFILLER_17_161 VPWR VGND sg13cmos5l_decap_8
X_53_ S1BEG[0] N1END[3] VPWR VGND sg13cmos5l_buf_1
XFILLER_2_77 VPWR VGND sg13cmos5l_decap_8
XFILLER_15_109 VPWR VGND sg13cmos5l_decap_8
XFILLER_11_75 VPWR VGND sg13cmos5l_decap_8
XFILLER_14_131 VPWR VGND sg13cmos5l_decap_8
X_36_ FrameStrobe_O[11] FrameStrobe[11] VPWR VGND sg13cmos5l_buf_1
XFILLER_11_145 VPWR VGND sg13cmos5l_decap_8
XFILLER_7_105 VPWR VGND sg13cmos5l_decap_8
XFILLER_8_32 VPWR VGND sg13cmos5l_decap_8
XFILLER_6_160 VPWR VGND sg13cmos5l_decap_8
X_19_ S2BEGb[2] N2END[5] VPWR VGND sg13cmos5l_buf_1
XFILLER_16_204 VPWR VGND sg13cmos5l_decap_8
XFILLER_17_63 VPWR VGND sg13cmos5l_decap_8
XFILLER_8_200 VPWR VGND sg13cmos5l_decap_8
XFILLER_5_88 VPWR VGND sg13cmos5l_decap_8
XFILLER_5_11 VPWR VGND sg13cmos5l_fill_1
XFILLER_14_75 VPWR VGND sg13cmos5l_decap_8
X_52_ S2BEG[7] N2MID[0] VPWR VGND sg13cmos5l_buf_1
XFILLER_2_56 VPWR VGND sg13cmos5l_decap_8
XFILLER_17_140 VPWR VGND sg13cmos5l_decap_8
XFILLER_11_54 VPWR VGND sg13cmos5l_decap_8
XFILLER_14_110 VPWR VGND sg13cmos5l_decap_8
X_35_ FrameStrobe_O[10] FrameStrobe[10] VPWR VGND sg13cmos5l_buf_1
XFILLER_11_124 VPWR VGND sg13cmos5l_decap_8
XFILLER_9_191 VPWR VGND sg13cmos5l_decap_8
XFILLER_0_2 VPWR VGND sg13cmos5l_fill_1
XFILLER_8_88 VPWR VGND sg13cmos5l_decap_8
XFILLER_8_11 VPWR VGND sg13cmos5l_fill_1
XFILLER_6_183 VPWR VGND sg13cmos5l_decap_8
X_18_ S2BEGb[1] N2END[6] VPWR VGND sg13cmos5l_buf_1
XFILLER_17_42 VPWR VGND sg13cmos5l_decap_8
XFILLER_3_175 VPWR VGND sg13cmos5l_fill_2
XFILLER_3_164 VPWR VGND sg13cmos5l_decap_8
XFILLER_5_67 VPWR VGND sg13cmos5l_decap_8
XFILLER_14_54 VPWR VGND sg13cmos5l_decap_8
XFILLER_17_196 VPWR VGND sg13cmos5l_decap_8
X_51_ S2BEG[6] N2MID[1] VPWR VGND sg13cmos5l_buf_1
XFILLER_2_35 VPWR VGND sg13cmos5l_decap_8
XFILLER_11_11 VPWR VGND sg13cmos5l_fill_1
XFILLER_11_33 VPWR VGND sg13cmos5l_decap_8
XFILLER_14_166 VPWR VGND sg13cmos5l_decap_8
X_34_ FrameStrobe_O[9] FrameStrobe[9] VPWR VGND sg13cmos5l_buf_1
XFILLER_11_103 VPWR VGND sg13cmos5l_decap_8
XFILLER_9_170 VPWR VGND sg13cmos5l_decap_8
XANTENNA__01__X S4BEG[0] VPWR VGND sg13cmos5l_antennanp
XFILLER_8_67 VPWR VGND sg13cmos5l_decap_8
X_17_ S2BEGb[0] N2END[7] VPWR VGND sg13cmos5l_buf_1
XFILLER_17_21 VPWR VGND sg13cmos5l_decap_8
XFILLER_17_98 VPWR VGND sg13cmos5l_decap_8
XFILLER_3_143 VPWR VGND sg13cmos5l_decap_8
XFILLER_0_179 VPWR VGND sg13cmos5l_decap_8
XFILLER_5_46 VPWR VGND sg13cmos5l_decap_8
XFILLER_14_11 VPWR VGND sg13cmos5l_fill_2
XFILLER_14_33 VPWR VGND sg13cmos5l_decap_8
XFILLER_5_205 VPWR VGND sg13cmos5l_fill_2
XANTENNA__04__X S4BEG[3] VPWR VGND sg13cmos5l_antennanp
XFILLER_17_175 VPWR VGND sg13cmos5l_decap_8
X_50_ S2BEG[5] N2MID[2] VPWR VGND sg13cmos5l_buf_1
XFILLER_9_0 VPWR VGND sg13cmos5l_fill_1
XFILLER_2_14 VPWR VGND sg13cmos5l_decap_8
XFILLER_11_89 VPWR VGND sg13cmos5l_decap_8
XFILLER_2_7 VPWR VGND sg13cmos5l_decap_8
XFILLER_14_145 VPWR VGND sg13cmos5l_decap_8
X_33_ FrameStrobe_O[8] FrameStrobe[8] VPWR VGND sg13cmos5l_buf_1
XFILLER_11_159 VPWR VGND sg13cmos5l_decap_8
XFILLER_7_119 VPWR VGND sg13cmos5l_decap_8
X_16_ S4BEG[15] N4END[0] VPWR VGND sg13cmos5l_buf_1
XFILLER_8_46 VPWR VGND sg13cmos5l_decap_8
XFILLER_6_196 VPWR VGND sg13cmos5l_decap_8
XFILLER_6_174 VPWR VGND sg13cmos5l_decap_4
XFILLER_17_77 VPWR VGND sg13cmos5l_decap_8
XANTENNA__12__X S4BEG[11] VPWR VGND sg13cmos5l_antennanp
XFILLER_3_188 VPWR VGND sg13cmos5l_decap_8
XFILLER_3_122 VPWR VGND sg13cmos5l_decap_8
XANTENNA__07__X S4BEG[6] VPWR VGND sg13cmos5l_antennanp
XFILLER_0_125 VPWR VGND sg13cmos5l_fill_1
XFILLER_8_214 VPWR VGND sg13cmos5l_decap_4
XFILLER_5_25 VPWR VGND sg13cmos5l_decap_8
XFILLER_14_89 VPWR VGND sg13cmos5l_decap_8
XFILLER_6_90 VPWR VGND sg13cmos5l_decap_8
XFILLER_2_209 VPWR VGND sg13cmos5l_decap_8
XANTENNA__20__X S2BEGb[3] VPWR VGND sg13cmos5l_antennanp
XFILLER_17_154 VPWR VGND sg13cmos5l_decap_8
XANTENNA__15__X S4BEG[14] VPWR VGND sg13cmos5l_antennanp
XFILLER_11_68 VPWR VGND sg13cmos5l_decap_8
XFILLER_14_124 VPWR VGND sg13cmos5l_decap_8
X_32_ FrameStrobe_O[7] FrameStrobe[7] VPWR VGND sg13cmos5l_buf_1
XFILLER_11_138 VPWR VGND sg13cmos5l_decap_8
XFILLER_3_80 VPWR VGND sg13cmos5l_decap_8
XFILLER_10_193 VPWR VGND sg13cmos5l_decap_8
X_15_ S4BEG[14] N4END[1] VPWR VGND sg13cmos5l_buf_1
XFILLER_8_25 VPWR VGND sg13cmos5l_decap_8
XFILLER_6_153 VPWR VGND sg13cmos5l_decap_8
XFILLER_17_56 VPWR VGND sg13cmos5l_decap_8
XFILLER_3_101 VPWR VGND sg13cmos5l_decap_8
XFILLER_17_0 VPWR VGND sg13cmos5l_decap_8
XANTENNA__23__X S2BEGb[6] VPWR VGND sg13cmos5l_antennanp
XFILLER_10_7 VPWR VGND sg13cmos5l_fill_1
XFILLER_14_68 VPWR VGND sg13cmos5l_decap_8
XANTENNA__18__X S2BEGb[1] VPWR VGND sg13cmos5l_antennanp
XFILLER_17_133 VPWR VGND sg13cmos5l_decap_8
XFILLER_2_49 VPWR VGND sg13cmos5l_decap_8
XFILLER_11_47 VPWR VGND sg13cmos5l_decap_8
XFILLER_14_103 VPWR VGND sg13cmos5l_decap_8
XANTENNA__31__X FrameStrobe_O[6] VPWR VGND sg13cmos5l_antennanp
XFILLER_13_180 VPWR VGND sg13cmos5l_decap_4
X_31_ FrameStrobe_O[6] FrameStrobe[6] VPWR VGND sg13cmos5l_buf_1
XFILLER_9_184 VPWR VGND sg13cmos5l_decap_8
XFILLER_11_117 VPWR VGND sg13cmos5l_decap_8
XANTENNA__26__X FrameStrobe_O[1] VPWR VGND sg13cmos5l_antennanp
XFILLER_10_172 VPWR VGND sg13cmos5l_decap_8
XFILLER_6_132 VPWR VGND sg13cmos5l_decap_8
X_14_ S4BEG[13] N4END[2] VPWR VGND sg13cmos5l_buf_1
XFILLER_17_35 VPWR VGND sg13cmos5l_decap_8
XFILLER_3_157 VPWR VGND sg13cmos5l_decap_8
XFILLER_12_212 VPWR VGND sg13cmos5l_decap_4
XFILLER_14_47 VPWR VGND sg13cmos5l_decap_8
XANTENNA__34__X FrameStrobe_O[9] VPWR VGND sg13cmos5l_antennanp
XANTENNA__29__X FrameStrobe_O[4] VPWR VGND sg13cmos5l_antennanp
XFILLER_17_112 VPWR VGND sg13cmos5l_decap_8
XFILLER_2_28 VPWR VGND sg13cmos5l_decap_8
XFILLER_17_189 VPWR VGND sg13cmos5l_decap_8
XFILLER_11_15 VPWR VGND sg13cmos5l_fill_1
XFILLER_11_26 VPWR VGND sg13cmos5l_decap_8
XFILLER_14_159 VPWR VGND sg13cmos5l_decap_8
X_30_ FrameStrobe_O[5] FrameStrobe[5] VPWR VGND sg13cmos5l_buf_1
XFILLER_7_0 VPWR VGND sg13cmos5l_fill_2
XFILLER_9_163 VPWR VGND sg13cmos5l_decap_8
XANTENNA__42__X FrameStrobe_O[17] VPWR VGND sg13cmos5l_antennanp
XFILLER_10_151 VPWR VGND sg13cmos5l_decap_8
XFILLER_6_111 VPWR VGND sg13cmos5l_decap_8
X_13_ S4BEG[12] N4END[3] VPWR VGND sg13cmos5l_buf_1
XFILLER_17_14 VPWR VGND sg13cmos5l_decap_8
XFILLER_3_136 VPWR VGND sg13cmos5l_decap_8
XANTENNA__37__X FrameStrobe_O[12] VPWR VGND sg13cmos5l_antennanp
XFILLER_0_72 VPWR VGND sg13cmos5l_fill_1
XFILLER_0_83 VPWR VGND sg13cmos5l_fill_2
XFILLER_5_39 VPWR VGND sg13cmos5l_decap_8
XFILLER_14_26 VPWR VGND sg13cmos5l_decap_8
XANTENNA__50__X S2BEG[5] VPWR VGND sg13cmos5l_antennanp
XANTENNA__45__X S2BEG[0] VPWR VGND sg13cmos5l_antennanp
XFILLER_17_168 VPWR VGND sg13cmos5l_decap_8
XFILLER_16_190 VPWR VGND sg13cmos5l_decap_8
XFILLER_14_138 VPWR VGND sg13cmos5l_decap_8
XFILLER_9_142 VPWR VGND sg13cmos5l_decap_8
XFILLER_3_94 VPWR VGND sg13cmos5l_decap_8
XFILLER_10_130 VPWR VGND sg13cmos5l_decap_8
XFILLER_8_39 VPWR VGND sg13cmos5l_decap_8
XFILLER_12_92 VPWR VGND sg13cmos5l_decap_8
X_12_ S4BEG[11] N4END[4] VPWR VGND sg13cmos5l_buf_1
XFILLER_6_178 VPWR VGND sg13cmos5l_fill_1
XFILLER_6_167 VPWR VGND sg13cmos5l_decap_8
XFILLER_3_115 VPWR VGND sg13cmos5l_decap_8
XANTENNA__53__X S1BEG[0] VPWR VGND sg13cmos5l_antennanp
XFILLER_2_181 VPWR VGND sg13cmos5l_decap_8
XFILLER_9_93 VPWR VGND sg13cmos5l_decap_8
XANTENNA__48__X S2BEG[3] VPWR VGND sg13cmos5l_antennanp
XFILLER_18_80 VPWR VGND sg13cmos5l_decap_8
XFILLER_8_207 VPWR VGND sg13cmos5l_decap_8
XFILLER_5_18 VPWR VGND sg13cmos5l_decap_8
XFILLER_6_83 VPWR VGND sg13cmos5l_decap_8
XANTENNA__61__X FrameData_O[4] VPWR VGND sg13cmos5l_antennanp
XFILLER_15_81 VPWR VGND sg13cmos5l_decap_8
XFILLER_17_147 VPWR VGND sg13cmos5l_decap_8
XFILLER_1_202 VPWR VGND sg13cmos5l_decap_8
XFILLER_14_117 VPWR VGND sg13cmos5l_decap_8
XFILLER_7_2 VPWR VGND sg13cmos5l_fill_1
XANTENNA__56__X S1BEG[3] VPWR VGND sg13cmos5l_antennanp
X_88_ FrameData_O[31] FrameData[31] VPWR VGND sg13cmos5l_buf_1
XFILLER_9_198 VPWR VGND sg13cmos5l_decap_8
XFILLER_9_121 VPWR VGND sg13cmos5l_decap_8
XFILLER_3_73 VPWR VGND sg13cmos5l_decap_8
XFILLER_10_186 VPWR VGND sg13cmos5l_decap_8
XFILLER_12_71 VPWR VGND sg13cmos5l_decap_8
X_11_ S4BEG[10] N4END[5] VPWR VGND sg13cmos5l_buf_1
XFILLER_8_18 VPWR VGND sg13cmos5l_decap_8
XFILLER_6_146 VPWR VGND sg13cmos5l_decap_8
XFILLER_17_49 VPWR VGND sg13cmos5l_decap_8
XFILLER_15_201 VPWR VGND sg13cmos5l_decap_8
XFILLER_9_72 VPWR VGND sg13cmos5l_decap_8
XFILLER_2_160 VPWR VGND sg13cmos5l_decap_8
XANTENNA__64__X FrameData_O[7] VPWR VGND sg13cmos5l_antennanp
XFILLER_18_70 VPWR VGND sg13cmos5l_decap_8
XANTENNA__59__X FrameData_O[2] VPWR VGND sg13cmos5l_antennanp
XFILLER_6_62 VPWR VGND sg13cmos5l_decap_8
XFILLER_15_60 VPWR VGND sg13cmos5l_decap_8
XFILLER_17_126 VPWR VGND sg13cmos5l_decap_8
XANTENNA__72__X FrameData_O[15] VPWR VGND sg13cmos5l_antennanp
XFILLER_13_173 VPWR VGND sg13cmos5l_decap_8
XFILLER_13_184 VPWR VGND sg13cmos5l_fill_1
XFILLER_9_177 VPWR VGND sg13cmos5l_decap_8
XFILLER_9_100 VPWR VGND sg13cmos5l_decap_8
XFILLER_3_52 VPWR VGND sg13cmos5l_decap_8
X_87_ FrameData_O[30] FrameData[30] VPWR VGND sg13cmos5l_buf_1
XANTENNA__67__X FrameData_O[10] VPWR VGND sg13cmos5l_antennanp
XFILLER_10_165 VPWR VGND sg13cmos5l_decap_8
XFILLER_12_50 VPWR VGND sg13cmos5l_decap_8
XFILLER_18_210 VPWR VGND sg13cmos5l_decap_8
X_10_ S4BEG[9] N4END[6] VPWR VGND sg13cmos5l_buf_1
XFILLER_6_125 VPWR VGND sg13cmos5l_decap_8
XFILLER_5_0 VPWR VGND sg13cmos5l_fill_2
XFILLER_17_28 VPWR VGND sg13cmos5l_decap_8
XFILLER_5_191 VPWR VGND sg13cmos5l_decap_4
XFILLER_9_51 VPWR VGND sg13cmos5l_decap_8
XFILLER_12_205 VPWR VGND sg13cmos5l_decap_8
XFILLER_12_216 VPWR VGND sg13cmos5l_fill_2
XANTENNA__80__X FrameData_O[23] VPWR VGND sg13cmos5l_antennanp
XFILLER_18_60 VPWR VGND sg13cmos5l_decap_8
XANTENNA__75__X FrameData_O[18] VPWR VGND sg13cmos5l_antennanp
XFILLER_4_201 VPWR VGND sg13cmos5l_decap_8
XFILLER_6_41 VPWR VGND sg13cmos5l_decap_8
XFILLER_17_105 VPWR VGND sg13cmos5l_decap_8
XFILLER_11_19 VPWR VGND sg13cmos5l_decap_8
XFILLER_13_152 VPWR VGND sg13cmos5l_decap_8
XFILLER_13_196 VPWR VGND sg13cmos5l_decap_8
XFILLER_9_156 VPWR VGND sg13cmos5l_decap_8
X_86_ FrameData_O[29] FrameData[29] VPWR VGND sg13cmos5l_buf_1
XFILLER_3_31 VPWR VGND sg13cmos5l_decap_8
XFILLER_10_144 VPWR VGND sg13cmos5l_decap_8
XFILLER_6_104 VPWR VGND sg13cmos5l_decap_8
XANTENNA__83__X FrameData_O[26] VPWR VGND sg13cmos5l_antennanp
XFILLER_18_200 VPWR VGND sg13cmos5l_decap_4
X_69_ FrameData_O[12] FrameData[12] VPWR VGND sg13cmos5l_buf_1
XFILLER_3_129 VPWR VGND sg13cmos5l_decap_8
XANTENNA__78__X FrameData_O[21] VPWR VGND sg13cmos5l_antennanp
XFILLER_0_43 VPWR VGND sg13cmos5l_fill_1
XFILLER_9_30 VPWR VGND sg13cmos5l_decap_8
XFILLER_2_195 VPWR VGND sg13cmos5l_decap_8
XFILLER_18_50 VPWR VGND sg13cmos5l_decap_8
XFILLER_7_210 VPWR VGND sg13cmos5l_decap_8
XFILLER_18_94 VPWR VGND sg13cmos5l_fill_2
XFILLER_14_19 VPWR VGND sg13cmos5l_decap_8
XFILLER_6_97 VPWR VGND sg13cmos5l_decap_8
XFILLER_6_20 VPWR VGND sg13cmos5l_decap_8
XFILLER_13_0 VPWR VGND sg13cmos5l_fill_2
XFILLER_1_216 VPWR VGND sg13cmos5l_fill_2
XANTENNA__86__X FrameData_O[29] VPWR VGND sg13cmos5l_antennanp
XFILLER_15_95 VPWR VGND sg13cmos5l_decap_8
XFILLER_16_183 VPWR VGND sg13cmos5l_decap_8
XFILLER_13_131 VPWR VGND sg13cmos5l_decap_8
XFILLER_9_135 VPWR VGND sg13cmos5l_decap_8
X_85_ FrameData_O[28] FrameData[28] VPWR VGND sg13cmos5l_buf_1
XFILLER_3_87 VPWR VGND sg13cmos5l_decap_8
XFILLER_10_123 VPWR VGND sg13cmos5l_decap_8
XFILLER_12_85 VPWR VGND sg13cmos5l_decap_8
XFILLER_5_2 VPWR VGND sg13cmos5l_fill_1
X_68_ FrameData_O[11] FrameData[11] VPWR VGND sg13cmos5l_buf_1
XFILLER_3_108 VPWR VGND sg13cmos5l_decap_8
XFILLER_15_215 VPWR VGND sg13cmos5l_fill_2
XFILLER_17_7 VPWR VGND sg13cmos5l_decap_4
XFILLER_2_174 VPWR VGND sg13cmos5l_decap_8
XFILLER_0_77 VPWR VGND sg13cmos5l_fill_2
XFILLER_9_86 VPWR VGND sg13cmos5l_decap_8
XFILLER_6_76 VPWR VGND sg13cmos5l_decap_8
XFILLER_9_9 VPWR VGND sg13cmos5l_fill_1
XFILLER_15_74 VPWR VGND sg13cmos5l_decap_8
XFILLER_16_162 VPWR VGND sg13cmos5l_decap_8
XFILLER_13_110 VPWR VGND sg13cmos5l_decap_8
X_84_ FrameData_O[27] FrameData[27] VPWR VGND sg13cmos5l_buf_1
XFILLER_9_114 VPWR VGND sg13cmos5l_decap_8
XFILLER_3_66 VPWR VGND sg13cmos5l_decap_8
XFILLER_10_102 VPWR VGND sg13cmos5l_decap_8
XFILLER_10_179 VPWR VGND sg13cmos5l_decap_8
XFILLER_12_64 VPWR VGND sg13cmos5l_decap_8
XFILLER_6_139 VPWR VGND sg13cmos5l_decap_8
X_67_ FrameData_O[10] FrameData[10] VPWR VGND sg13cmos5l_buf_1
XFILLER_5_172 VPWR VGND sg13cmos5l_fill_1
XFILLER_3_0 VPWR VGND sg13cmos5l_fill_1
XFILLER_2_153 VPWR VGND sg13cmos5l_decap_8
XFILLER_0_89 VPWR VGND sg13cmos5l_fill_1
XFILLER_9_65 VPWR VGND sg13cmos5l_decap_8
XFILLER_18_96 VPWR VGND sg13cmos5l_fill_1
XFILLER_4_215 VPWR VGND sg13cmos5l_fill_2
XFILLER_13_2 VPWR VGND sg13cmos5l_fill_1
XFILLER_6_55 VPWR VGND sg13cmos5l_decap_8
XFILLER_15_53 VPWR VGND sg13cmos5l_decap_8
XFILLER_17_119 VPWR VGND sg13cmos5l_decap_8
XFILLER_16_141 VPWR VGND sg13cmos5l_decap_8
.ends
