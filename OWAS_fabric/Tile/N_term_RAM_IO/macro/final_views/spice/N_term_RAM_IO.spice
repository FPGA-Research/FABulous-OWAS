* NGSPICE file created from N_term_RAM_IO.ext - technology: ihp-sg13cmos5l

* Black-box entry subcircuit for sg13cmos5l_fill_2 abstract view
.subckt sg13cmos5l_fill_2 VDD VSS
.ends

* Black-box entry subcircuit for sg13cmos5l_decap_8 abstract view
.subckt sg13cmos5l_decap_8 VDD VSS
.ends

* Black-box entry subcircuit for sg13cmos5l_buf_1 abstract view
.subckt sg13cmos5l_buf_1 X A VDD VSS
.ends

* Black-box entry subcircuit for sg13cmos5l_decap_4 abstract view
.subckt sg13cmos5l_decap_4 VDD VSS
.ends

* Black-box entry subcircuit for sg13cmos5l_antennanp abstract view
.subckt sg13cmos5l_antennanp A VDD VSS
.ends

* Black-box entry subcircuit for sg13cmos5l_fill_1 abstract view
.subckt sg13cmos5l_fill_1 VDD VSS
.ends

.subckt N_term_RAM_IO FrameData[0] FrameData[10] FrameData[11] FrameData[12] FrameData[13]
+ FrameData[14] FrameData[15] FrameData[16] FrameData[17] FrameData[18] FrameData[19]
+ FrameData[1] FrameData[20] FrameData[21] FrameData[22] FrameData[23] FrameData[24]
+ FrameData[25] FrameData[26] FrameData[27] FrameData[28] FrameData[29] FrameData[2]
+ FrameData[30] FrameData[31] FrameData[3] FrameData[4] FrameData[5] FrameData[6]
+ FrameData[7] FrameData[8] FrameData[9] FrameData_O[0] FrameData_O[10] FrameData_O[11]
+ FrameData_O[12] FrameData_O[13] FrameData_O[14] FrameData_O[15] FrameData_O[16]
+ FrameData_O[17] FrameData_O[18] FrameData_O[19] FrameData_O[1] FrameData_O[20] FrameData_O[21]
+ FrameData_O[22] FrameData_O[23] FrameData_O[24] FrameData_O[25] FrameData_O[26]
+ FrameData_O[27] FrameData_O[28] FrameData_O[29] FrameData_O[2] FrameData_O[30] FrameData_O[31]
+ FrameData_O[3] FrameData_O[4] FrameData_O[5] FrameData_O[6] FrameData_O[7] FrameData_O[8]
+ FrameData_O[9] FrameStrobe[0] FrameStrobe[10] FrameStrobe[11] FrameStrobe[12] FrameStrobe[13]
+ FrameStrobe[14] FrameStrobe[15] FrameStrobe[16] FrameStrobe[17] FrameStrobe[18]
+ FrameStrobe[19] FrameStrobe[1] FrameStrobe[2] FrameStrobe[3] FrameStrobe[4] FrameStrobe[5]
+ FrameStrobe[6] FrameStrobe[7] FrameStrobe[8] FrameStrobe[9] FrameStrobe_O[0] FrameStrobe_O[10]
+ FrameStrobe_O[11] FrameStrobe_O[12] FrameStrobe_O[13] FrameStrobe_O[14] FrameStrobe_O[15]
+ FrameStrobe_O[16] FrameStrobe_O[17] FrameStrobe_O[18] FrameStrobe_O[19] FrameStrobe_O[1]
+ FrameStrobe_O[2] FrameStrobe_O[3] FrameStrobe_O[4] FrameStrobe_O[5] FrameStrobe_O[6]
+ FrameStrobe_O[7] FrameStrobe_O[8] FrameStrobe_O[9] N1END[0] N1END[1] N1END[2] N1END[3]
+ N2END[0] N2END[1] N2END[2] N2END[3] N2END[4] N2END[5] N2END[6] N2END[7] N2MID[0]
+ N2MID[1] N2MID[2] N2MID[3] N2MID[4] N2MID[5] N2MID[6] N2MID[7] N4END[0] N4END[10]
+ N4END[11] N4END[12] N4END[13] N4END[14] N4END[15] N4END[1] N4END[2] N4END[3] N4END[4]
+ N4END[5] N4END[6] N4END[7] N4END[8] N4END[9] S1BEG[0] S1BEG[1] S1BEG[2] S1BEG[3]
+ S2BEG[0] S2BEG[1] S2BEG[2] S2BEG[3] S2BEG[4] S2BEG[5] S2BEG[6] S2BEG[7] S2BEGb[0]
+ S2BEGb[1] S2BEGb[2] S2BEGb[3] S2BEGb[4] S2BEGb[5] S2BEGb[6] S2BEGb[7] S4BEG[0] S4BEG[10]
+ S4BEG[11] S4BEG[12] S4BEG[13] S4BEG[14] S4BEG[15] S4BEG[1] S4BEG[2] S4BEG[3] S4BEG[4]
+ S4BEG[5] S4BEG[6] S4BEG[7] S4BEG[8] S4BEG[9] UserCLK UserCLKo VGND VPWR
XFILLER_7_7 VPWR VGND sg13cmos5l_fill_2
XFILLER_13_166 VPWR VGND sg13cmos5l_decap_8
X_83_ FrameData_O[26] FrameData[26] VPWR VGND sg13cmos5l_buf_1
XFILLER_9_148 VPWR VGND sg13cmos5l_decap_8
XFILLER_3_56 VPWR VGND sg13cmos5l_decap_8
XFILLER_10_158 VPWR VGND sg13cmos5l_decap_8
XFILLER_12_65 VPWR VGND sg13cmos5l_decap_8
XFILLER_18_214 VPWR VGND sg13cmos5l_decap_4
XFILLER_18_225 VPWR VGND sg13cmos5l_decap_4
XFILLER_6_129 VPWR VGND sg13cmos5l_decap_8
X_66_ FrameData_O[9] FrameData[9] VPWR VGND sg13cmos5l_buf_1
XFILLER_5_151 VPWR VGND sg13cmos5l_decap_8
XFILLER_9_99 VPWR VGND sg13cmos5l_decap_8
XFILLER_9_22 VPWR VGND sg13cmos5l_decap_8
XFILLER_2_165 VPWR VGND sg13cmos5l_decap_8
X_49_ S2BEG[4] N2MID[3] VPWR VGND sg13cmos5l_buf_1
XFILLER_11_220 VPWR VGND sg13cmos5l_decap_8
XFILLER_18_42 VPWR VGND sg13cmos5l_decap_8
XFILLER_4_227 VPWR VGND sg13cmos5l_fill_2
XFILLER_6_45 VPWR VGND sg13cmos5l_decap_8
XFILLER_15_21 VPWR VGND sg13cmos5l_decap_8
XFILLER_15_98 VPWR VGND sg13cmos5l_decap_8
XFILLER_17_109 VPWR VGND sg13cmos5l_decap_8
XFILLER_16_164 VPWR VGND sg13cmos5l_decap_8
XFILLER_11_0 VPWR VGND sg13cmos5l_fill_2
XFILLER_13_145 VPWR VGND sg13cmos5l_decap_8
XFILLER_9_127 VPWR VGND sg13cmos5l_decap_8
XFILLER_3_35 VPWR VGND sg13cmos5l_decap_8
X_82_ FrameData_O[25] FrameData[25] VPWR VGND sg13cmos5l_buf_1
XFILLER_8_193 VPWR VGND sg13cmos5l_decap_8
XFILLER_10_137 VPWR VGND sg13cmos5l_decap_8
XFILLER_12_44 VPWR VGND sg13cmos5l_decap_8
XFILLER_6_108 VPWR VGND sg13cmos5l_decap_8
X_65_ FrameData_O[8] FrameData[8] VPWR VGND sg13cmos5l_buf_1
XFILLER_5_196 VPWR VGND sg13cmos5l_decap_8
XFILLER_5_130 VPWR VGND sg13cmos5l_decap_8
XANTENNA__02__X S4BEG[1] VPWR VGND sg13cmos5l_antennanp
XFILLER_9_78 VPWR VGND sg13cmos5l_decap_8
XFILLER_3_2 VPWR VGND sg13cmos5l_fill_1
XFILLER_2_133 VPWR VGND sg13cmos5l_decap_8
X_48_ S2BEG[3] N2MID[4] VPWR VGND sg13cmos5l_buf_1
XFILLER_18_21 VPWR VGND sg13cmos5l_decap_4
XFILLER_18_54 VPWR VGND sg13cmos5l_decap_8
XFILLER_18_98 VPWR VGND sg13cmos5l_fill_1
XFILLER_7_214 VPWR VGND sg13cmos5l_fill_1
XFILLER_6_24 VPWR VGND sg13cmos5l_decap_8
XANTENNA__10__X S4BEG[9] VPWR VGND sg13cmos5l_antennanp
XFILLER_0_220 VPWR VGND sg13cmos5l_fill_1
XFILLER_15_77 VPWR VGND sg13cmos5l_decap_8
XFILLER_16_143 VPWR VGND sg13cmos5l_decap_8
XANTENNA__05__X S4BEG[4] VPWR VGND sg13cmos5l_antennanp
XFILLER_13_124 VPWR VGND sg13cmos5l_decap_8
XFILLER_9_106 VPWR VGND sg13cmos5l_decap_8
X_81_ FrameData_O[24] FrameData[24] VPWR VGND sg13cmos5l_buf_1
XFILLER_10_116 VPWR VGND sg13cmos5l_decap_8
XFILLER_12_23 VPWR VGND sg13cmos5l_decap_8
X_64_ FrameData_O[7] FrameData[7] VPWR VGND sg13cmos5l_buf_1
XFILLER_5_186 VPWR VGND sg13cmos5l_decap_4
XFILLER_2_112 VPWR VGND sg13cmos5l_decap_8
XFILLER_9_57 VPWR VGND sg13cmos5l_decap_8
X_47_ S2BEG[2] N2MID[5] VPWR VGND sg13cmos5l_buf_1
XANTENNA__13__X S4BEG[12] VPWR VGND sg13cmos5l_antennanp
XFILLER_18_66 VPWR VGND sg13cmos5l_decap_8
XFILLER_7_226 VPWR VGND sg13cmos5l_fill_2
XFILLER_4_218 VPWR VGND sg13cmos5l_fill_1
XFILLER_1_80 VPWR VGND sg13cmos5l_fill_2
XANTENNA__08__X S4BEG[7] VPWR VGND sg13cmos5l_antennanp
XFILLER_15_56 VPWR VGND sg13cmos5l_decap_8
XFILLER_16_122 VPWR VGND sg13cmos5l_decap_8
XFILLER_11_2 VPWR VGND sg13cmos5l_fill_1
XFILLER_13_103 VPWR VGND sg13cmos5l_decap_8
XANTENNA__21__X S2BEGb[4] VPWR VGND sg13cmos5l_antennanp
XFILLER_12_191 VPWR VGND sg13cmos5l_decap_8
X_80_ FrameData_O[23] FrameData[23] VPWR VGND sg13cmos5l_buf_1
XFILLER_8_173 VPWR VGND sg13cmos5l_decap_8
XFILLER_12_79 VPWR VGND sg13cmos5l_decap_8
XFILLER_5_7 VPWR VGND sg13cmos5l_fill_1
XANTENNA__16__X S4BEG[15] VPWR VGND sg13cmos5l_antennanp
XFILLER_18_206 VPWR VGND sg13cmos5l_fill_2
XFILLER_5_165 VPWR VGND sg13cmos5l_decap_8
X_63_ FrameData_O[6] FrameData[6] VPWR VGND sg13cmos5l_buf_1
XFILLER_15_209 VPWR VGND sg13cmos5l_decap_8
XFILLER_2_179 VPWR VGND sg13cmos5l_decap_8
X_46_ S2BEG[1] N2MID[6] VPWR VGND sg13cmos5l_buf_1
XFILLER_9_36 VPWR VGND sg13cmos5l_decap_8
XFILLER_18_78 VPWR VGND sg13cmos5l_decap_8
XFILLER_18_89 VPWR VGND sg13cmos5l_decap_8
XFILLER_7_205 VPWR VGND sg13cmos5l_decap_8
X_29_ FrameStrobe_O[4] FrameStrobe[4] VPWR VGND sg13cmos5l_buf_1
XANTENNA__24__X S2BEGb[7] VPWR VGND sg13cmos5l_antennanp
XFILLER_6_59 VPWR VGND sg13cmos5l_decap_8
XANTENNA__19__X S2BEGb[2] VPWR VGND sg13cmos5l_antennanp
XFILLER_0_211 VPWR VGND sg13cmos5l_decap_8
XFILLER_15_35 VPWR VGND sg13cmos5l_decap_8
XFILLER_16_101 VPWR VGND sg13cmos5l_decap_8
XFILLER_16_178 VPWR VGND sg13cmos5l_decap_8
XFILLER_13_159 VPWR VGND sg13cmos5l_decap_8
XFILLER_3_49 VPWR VGND sg13cmos5l_decap_8
XFILLER_12_170 VPWR VGND sg13cmos5l_decap_8
XFILLER_8_152 VPWR VGND sg13cmos5l_decap_8
XANTENNA__32__X FrameStrobe_O[7] VPWR VGND sg13cmos5l_antennanp
XFILLER_12_58 VPWR VGND sg13cmos5l_decap_8
XFILLER_5_144 VPWR VGND sg13cmos5l_decap_8
X_62_ FrameData_O[5] FrameData[5] VPWR VGND sg13cmos5l_buf_1
XFILLER_4_81 VPWR VGND sg13cmos5l_decap_8
XFILLER_2_158 VPWR VGND sg13cmos5l_decap_8
XFILLER_2_147 VPWR VGND sg13cmos5l_fill_1
XANTENNA__27__X FrameStrobe_O[2] VPWR VGND sg13cmos5l_antennanp
XFILLER_9_15 VPWR VGND sg13cmos5l_decap_8
X_45_ S2BEG[0] N2MID[7] VPWR VGND sg13cmos5l_buf_1
XFILLER_11_213 VPWR VGND sg13cmos5l_decap_8
XFILLER_7_228 VPWR VGND sg13cmos5l_fill_1
X_28_ FrameStrobe_O[3] FrameStrobe[3] VPWR VGND sg13cmos5l_buf_1
XANTENNA__40__X FrameStrobe_O[15] VPWR VGND sg13cmos5l_antennanp
XFILLER_13_7 VPWR VGND sg13cmos5l_fill_2
XFILLER_6_38 VPWR VGND sg13cmos5l_decap_8
XANTENNA__35__X FrameStrobe_O[10] VPWR VGND sg13cmos5l_antennanp
XFILLER_16_157 VPWR VGND sg13cmos5l_decap_8
XFILLER_13_138 VPWR VGND sg13cmos5l_decap_8
XFILLER_3_28 VPWR VGND sg13cmos5l_decap_8
XFILLER_8_131 VPWR VGND sg13cmos5l_decap_8
XFILLER_12_37 VPWR VGND sg13cmos5l_decap_8
X_61_ FrameData_O[4] FrameData[4] VPWR VGND sg13cmos5l_buf_1
XFILLER_5_123 VPWR VGND sg13cmos5l_decap_8
XFILLER_4_60 VPWR VGND sg13cmos5l_decap_8
XANTENNA__43__X FrameStrobe_O[18] VPWR VGND sg13cmos5l_antennanp
XFILLER_14_222 VPWR VGND sg13cmos5l_decap_8
XFILLER_2_126 VPWR VGND sg13cmos5l_decap_8
X_44_ FrameStrobe_O[19] FrameStrobe[19] VPWR VGND sg13cmos5l_buf_1
XANTENNA__38__X FrameStrobe_O[13] VPWR VGND sg13cmos5l_antennanp
XFILLER_18_14 VPWR VGND sg13cmos5l_decap_8
XFILLER_18_25 VPWR VGND sg13cmos5l_fill_1
XFILLER_18_36 VPWR VGND sg13cmos5l_fill_2
X_27_ FrameStrobe_O[2] FrameStrobe[2] VPWR VGND sg13cmos5l_buf_1
XFILLER_1_94 VPWR VGND sg13cmos5l_fill_2
XFILLER_10_81 VPWR VGND sg13cmos5l_decap_8
XFILLER_6_17 VPWR VGND sg13cmos5l_decap_8
XFILLER_3_210 VPWR VGND sg13cmos5l_decap_8
XANTENNA__51__X S2BEG[6] VPWR VGND sg13cmos5l_antennanp
XFILLER_16_136 VPWR VGND sg13cmos5l_decap_8
XFILLER_7_93 VPWR VGND sg13cmos5l_decap_8
XFILLER_13_117 VPWR VGND sg13cmos5l_decap_8
XANTENNA__46__X S2BEG[1] VPWR VGND sg13cmos5l_antennanp
XFILLER_16_80 VPWR VGND sg13cmos5l_decap_8
XFILLER_8_187 VPWR VGND sg13cmos5l_fill_2
XFILLER_8_110 VPWR VGND sg13cmos5l_decap_8
XFILLER_10_109 VPWR VGND sg13cmos5l_decap_8
X_60_ FrameData_O[3] FrameData[3] VPWR VGND sg13cmos5l_buf_1
XFILLER_5_179 VPWR VGND sg13cmos5l_decap_8
XFILLER_5_102 VPWR VGND sg13cmos5l_decap_8
XFILLER_14_201 VPWR VGND sg13cmos5l_decap_8
XFILLER_2_105 VPWR VGND sg13cmos5l_decap_8
X_43_ FrameStrobe_O[18] FrameStrobe[18] VPWR VGND sg13cmos5l_buf_1
XFILLER_1_193 VPWR VGND sg13cmos5l_decap_8
XFILLER_7_219 VPWR VGND sg13cmos5l_decap_8
XANTENNA__54__X S1BEG[1] VPWR VGND sg13cmos5l_antennanp
X_26_ FrameStrobe_O[1] FrameStrobe[1] VPWR VGND sg13cmos5l_buf_1
XANTENNA__49__X S2BEG[4] VPWR VGND sg13cmos5l_antennanp
XFILLER_10_60 VPWR VGND sg13cmos5l_decap_8
XFILLER_15_49 VPWR VGND sg13cmos5l_decap_8
X_09_ S4BEG[8] N4END[7] VPWR VGND sg13cmos5l_buf_1
XFILLER_16_115 VPWR VGND sg13cmos5l_decap_8
XFILLER_7_72 VPWR VGND sg13cmos5l_decap_8
XANTENNA__62__X FrameData_O[5] VPWR VGND sg13cmos5l_antennanp
XFILLER_12_184 VPWR VGND sg13cmos5l_decap_8
XFILLER_8_166 VPWR VGND sg13cmos5l_decap_8
XANTENNA__57__X FrameData_O[0] VPWR VGND sg13cmos5l_antennanp
XFILLER_17_221 VPWR VGND sg13cmos5l_decap_8
XFILLER_5_158 VPWR VGND sg13cmos5l_decap_8
XFILLER_4_95 VPWR VGND sg13cmos5l_decap_8
XFILLER_9_29 VPWR VGND sg13cmos5l_decap_8
XFILLER_13_82 VPWR VGND sg13cmos5l_decap_8
XFILLER_1_172 VPWR VGND sg13cmos5l_decap_8
X_42_ FrameStrobe_O[17] FrameStrobe[17] VPWR VGND sg13cmos5l_buf_1
XFILLER_11_227 VPWR VGND sg13cmos5l_fill_2
XFILLER_18_38 VPWR VGND sg13cmos5l_fill_1
XFILLER_18_49 VPWR VGND sg13cmos5l_fill_2
XANTENNA__70__X FrameData_O[13] VPWR VGND sg13cmos5l_antennanp
XFILLER_6_220 VPWR VGND sg13cmos5l_decap_8
X_25_ FrameStrobe_O[0] FrameStrobe[0] VPWR VGND sg13cmos5l_buf_1
XFILLER_1_96 VPWR VGND sg13cmos5l_fill_1
XFILLER_1_85 VPWR VGND sg13cmos5l_decap_4
XFILLER_1_63 VPWR VGND sg13cmos5l_fill_2
XFILLER_1_30 VPWR VGND sg13cmos5l_decap_4
XANTENNA__65__X FrameData_O[8] VPWR VGND sg13cmos5l_antennanp
XFILLER_18_0 VPWR VGND sg13cmos5l_decap_8
X_08_ S4BEG[7] N4END[8] VPWR VGND sg13cmos5l_buf_1
XFILLER_0_204 VPWR VGND sg13cmos5l_decap_8
XFILLER_15_28 VPWR VGND sg13cmos5l_decap_8
XFILLER_18_190 VPWR VGND sg13cmos5l_decap_4
XFILLER_15_182 VPWR VGND sg13cmos5l_decap_8
XFILLER_7_51 VPWR VGND sg13cmos5l_decap_8
XFILLER_12_163 VPWR VGND sg13cmos5l_decap_8
XFILLER_8_145 VPWR VGND sg13cmos5l_decap_8
XFILLER_5_137 VPWR VGND sg13cmos5l_decap_8
XANTENNA__73__X FrameData_O[16] VPWR VGND sg13cmos5l_antennanp
XFILLER_17_200 VPWR VGND sg13cmos5l_decap_8
XFILLER_4_74 VPWR VGND sg13cmos5l_decap_8
XANTENNA__68__X FrameData_O[11] VPWR VGND sg13cmos5l_antennanp
XFILLER_13_61 VPWR VGND sg13cmos5l_decap_8
X_41_ FrameStrobe_O[16] FrameStrobe[16] VPWR VGND sg13cmos5l_buf_1
XFILLER_11_206 VPWR VGND sg13cmos5l_decap_8
X_24_ S2BEGb[7] N2END[0] VPWR VGND sg13cmos5l_buf_1
XFILLER_1_53 VPWR VGND sg13cmos5l_decap_4
XFILLER_3_224 VPWR VGND sg13cmos5l_decap_4
XANTENNA__81__X FrameData_O[24] VPWR VGND sg13cmos5l_antennanp
XFILLER_10_95 VPWR VGND sg13cmos5l_decap_8
XFILLER_18_180 VPWR VGND sg13cmos5l_fill_1
X_07_ S4BEG[6] N4END[9] VPWR VGND sg13cmos5l_buf_1
XANTENNA__76__X FrameData_O[19] VPWR VGND sg13cmos5l_antennanp
XFILLER_15_161 VPWR VGND sg13cmos5l_decap_8
XFILLER_7_30 VPWR VGND sg13cmos5l_decap_8
XFILLER_12_142 VPWR VGND sg13cmos5l_decap_8
XFILLER_16_94 VPWR VGND sg13cmos5l_decap_8
XFILLER_8_124 VPWR VGND sg13cmos5l_decap_8
XFILLER_5_116 VPWR VGND sg13cmos5l_decap_8
XFILLER_4_193 VPWR VGND sg13cmos5l_decap_8
XFILLER_4_53 VPWR VGND sg13cmos5l_decap_8
XFILLER_2_119 VPWR VGND sg13cmos5l_decap_8
XFILLER_13_40 VPWR VGND sg13cmos5l_decap_8
XFILLER_14_215 VPWR VGND sg13cmos5l_decap_8
XFILLER_1_163 VPWR VGND sg13cmos5l_fill_2
X_40_ FrameStrobe_O[15] FrameStrobe[15] VPWR VGND sg13cmos5l_buf_1
XFILLER_8_0 VPWR VGND sg13cmos5l_fill_2
XANTENNA__84__X FrameData_O[27] VPWR VGND sg13cmos5l_antennanp
XFILLER_18_29 VPWR VGND sg13cmos5l_decap_8
XANTENNA__79__X FrameData_O[22] VPWR VGND sg13cmos5l_antennanp
X_23_ S2BEGb[6] N2END[1] VPWR VGND sg13cmos5l_buf_1
XFILLER_1_76 VPWR VGND sg13cmos5l_decap_4
XFILLER_1_65 VPWR VGND sg13cmos5l_fill_1
XFILLER_1_43 VPWR VGND sg13cmos5l_decap_8
XFILLER_10_74 VPWR VGND sg13cmos5l_decap_8
XFILLER_3_203 VPWR VGND sg13cmos5l_decap_8
X_06_ S4BEG[5] N4END[10] VPWR VGND sg13cmos5l_buf_1
XFILLER_16_129 VPWR VGND sg13cmos5l_decap_8
XFILLER_15_140 VPWR VGND sg13cmos5l_decap_8
XFILLER_15_195 VPWR VGND sg13cmos5l_decap_8
XFILLER_7_86 VPWR VGND sg13cmos5l_decap_8
XANTENNA__87__X FrameData_O[30] VPWR VGND sg13cmos5l_antennanp
XFILLER_12_121 VPWR VGND sg13cmos5l_decap_8
XFILLER_12_198 VPWR VGND sg13cmos5l_decap_8
XFILLER_16_73 VPWR VGND sg13cmos5l_decap_8
XFILLER_8_103 VPWR VGND sg13cmos5l_decap_8
XFILLER_7_191 VPWR VGND sg13cmos5l_decap_8
XFILLER_4_32 VPWR VGND sg13cmos5l_decap_8
XFILLER_4_183 VPWR VGND sg13cmos5l_fill_2
XFILLER_4_172 VPWR VGND sg13cmos5l_decap_8
XFILLER_13_96 VPWR VGND sg13cmos5l_decap_8
XFILLER_1_186 VPWR VGND sg13cmos5l_decap_8
XFILLER_1_8 VPWR VGND sg13cmos5l_decap_4
X_22_ S2BEGb[5] N2END[2] VPWR VGND sg13cmos5l_buf_1
XFILLER_10_53 VPWR VGND sg13cmos5l_decap_8
X_05_ S4BEG[4] N4END[11] VPWR VGND sg13cmos5l_buf_1
XFILLER_0_218 VPWR VGND sg13cmos5l_fill_2
XFILLER_16_108 VPWR VGND sg13cmos5l_decap_8
XFILLER_7_65 VPWR VGND sg13cmos5l_decap_8
XFILLER_16_0 VPWR VGND sg13cmos5l_fill_2
XFILLER_12_100 VPWR VGND sg13cmos5l_decap_8
XFILLER_12_177 VPWR VGND sg13cmos5l_decap_8
XFILLER_16_52 VPWR VGND sg13cmos5l_decap_8
XFILLER_8_159 VPWR VGND sg13cmos5l_decap_8
XFILLER_7_170 VPWR VGND sg13cmos5l_decap_8
XFILLER_17_214 VPWR VGND sg13cmos5l_decap_8
XFILLER_4_88 VPWR VGND sg13cmos5l_decap_8
XFILLER_4_151 VPWR VGND sg13cmos5l_decap_8
XFILLER_13_75 VPWR VGND sg13cmos5l_decap_8
XFILLER_8_2 VPWR VGND sg13cmos5l_fill_1
XFILLER_1_12 VPWR VGND sg13cmos5l_fill_2
X_21_ S2BEGb[4] N2END[3] VPWR VGND sg13cmos5l_buf_1
XFILLER_6_213 VPWR VGND sg13cmos5l_decap_8
XFILLER_1_89 VPWR VGND sg13cmos5l_fill_2
XFILLER_1_34 VPWR VGND sg13cmos5l_fill_2
XFILLER_10_32 VPWR VGND sg13cmos5l_decap_8
XFILLER_18_150 VPWR VGND sg13cmos5l_decap_8
XFILLER_18_194 VPWR VGND sg13cmos5l_fill_2
X_04_ S4BEG[3] N4END[12] VPWR VGND sg13cmos5l_buf_1
XFILLER_15_175 VPWR VGND sg13cmos5l_decap_8
XFILLER_7_44 VPWR VGND sg13cmos5l_decap_8
XFILLER_12_156 VPWR VGND sg13cmos5l_decap_8
XFILLER_16_31 VPWR VGND sg13cmos5l_decap_8
XFILLER_8_138 VPWR VGND sg13cmos5l_decap_8
XFILLER_4_67 VPWR VGND sg13cmos5l_decap_8
XFILLER_4_130 VPWR VGND sg13cmos5l_decap_8
XFILLER_13_54 VPWR VGND sg13cmos5l_decap_8
XFILLER_9_211 VPWR VGND sg13cmos5l_decap_8
XFILLER_10_221 VPWR VGND sg13cmos5l_decap_8
XFILLER_6_203 VPWR VGND sg13cmos5l_fill_1
XFILLER_6_0 VPWR VGND sg13cmos5l_fill_2
X_20_ S2BEGb[3] N2END[4] VPWR VGND sg13cmos5l_buf_1
XFILLER_1_24 VPWR VGND sg13cmos5l_fill_2
XFILLER_10_88 VPWR VGND sg13cmos5l_decap_8
XFILLER_3_228 VPWR VGND sg13cmos5l_fill_1
XFILLER_3_217 VPWR VGND sg13cmos5l_decap_8
X_03_ S4BEG[2] N4END[13] VPWR VGND sg13cmos5l_buf_1
XFILLER_18_162 VPWR VGND sg13cmos5l_decap_8
XANTENNA__00__X UserCLKo VPWR VGND sg13cmos5l_antennanp
XFILLER_15_154 VPWR VGND sg13cmos5l_decap_8
XFILLER_16_2 VPWR VGND sg13cmos5l_fill_1
XFILLER_7_23 VPWR VGND sg13cmos5l_decap_8
XFILLER_12_135 VPWR VGND sg13cmos5l_decap_8
XFILLER_16_87 VPWR VGND sg13cmos5l_decap_8
XFILLER_8_117 VPWR VGND sg13cmos5l_decap_8
XFILLER_5_109 VPWR VGND sg13cmos5l_decap_8
XFILLER_4_46 VPWR VGND sg13cmos5l_decap_8
XFILLER_13_33 VPWR VGND sg13cmos5l_decap_8
XFILLER_14_208 VPWR VGND sg13cmos5l_decap_8
XFILLER_1_123 VPWR VGND sg13cmos5l_decap_8
XANTENNA__03__X S4BEG[2] VPWR VGND sg13cmos5l_antennanp
XFILLER_10_200 VPWR VGND sg13cmos5l_decap_8
XFILLER_1_69 VPWR VGND sg13cmos5l_decap_8
XFILLER_10_67 VPWR VGND sg13cmos5l_decap_8
X_79_ FrameData_O[22] FrameData[22] VPWR VGND sg13cmos5l_buf_1
X_02_ S4BEG[1] N4END[14] VPWR VGND sg13cmos5l_buf_1
XFILLER_15_133 VPWR VGND sg13cmos5l_decap_8
XFILLER_7_79 VPWR VGND sg13cmos5l_decap_8
XFILLER_7_13 VPWR VGND sg13cmos5l_fill_1
XFILLER_12_114 VPWR VGND sg13cmos5l_decap_8
XFILLER_16_66 VPWR VGND sg13cmos5l_decap_8
XANTENNA__11__X S4BEG[10] VPWR VGND sg13cmos5l_antennanp
XFILLER_14_0 VPWR VGND sg13cmos5l_fill_2
XFILLER_7_184 VPWR VGND sg13cmos5l_decap_8
XANTENNA__06__X S4BEG[5] VPWR VGND sg13cmos5l_antennanp
XFILLER_17_228 VPWR VGND sg13cmos5l_fill_1
XFILLER_4_25 VPWR VGND sg13cmos5l_decap_8
XFILLER_4_165 VPWR VGND sg13cmos5l_decap_8
XFILLER_13_89 VPWR VGND sg13cmos5l_decap_8
XFILLER_1_168 VPWR VGND sg13cmos5l_fill_1
XFILLER_1_179 VPWR VGND sg13cmos5l_decap_8
XFILLER_6_227 VPWR VGND sg13cmos5l_fill_2
XFILLER_6_2 VPWR VGND sg13cmos5l_fill_1
XFILLER_1_26 VPWR VGND sg13cmos5l_fill_1
X_78_ FrameData_O[21] FrameData[21] VPWR VGND sg13cmos5l_buf_1
XANTENNA__14__X S4BEG[13] VPWR VGND sg13cmos5l_antennanp
XFILLER_10_46 VPWR VGND sg13cmos5l_decap_8
XFILLER_18_7 VPWR VGND sg13cmos5l_decap_8
X_01_ S4BEG[0] N4END[15] VPWR VGND sg13cmos5l_buf_1
XFILLER_2_91 VPWR VGND sg13cmos5l_decap_8
XANTENNA__09__X S4BEG[8] VPWR VGND sg13cmos5l_antennanp
XFILLER_15_112 VPWR VGND sg13cmos5l_decap_8
XFILLER_15_189 VPWR VGND sg13cmos5l_fill_2
XFILLER_7_58 VPWR VGND sg13cmos5l_decap_8
XFILLER_16_45 VPWR VGND sg13cmos5l_decap_8
XFILLER_11_192 VPWR VGND sg13cmos5l_decap_8
XFILLER_7_163 VPWR VGND sg13cmos5l_decap_8
XANTENNA__22__X S2BEGb[5] VPWR VGND sg13cmos5l_antennanp
XFILLER_17_207 VPWR VGND sg13cmos5l_decap_8
XFILLER_4_144 VPWR VGND sg13cmos5l_decap_8
XFILLER_13_68 VPWR VGND sg13cmos5l_decap_8
XANTENNA__17__X S2BEGb[0] VPWR VGND sg13cmos5l_antennanp
XFILLER_0_180 VPWR VGND sg13cmos5l_decap_8
XFILLER_13_210 VPWR VGND sg13cmos5l_decap_8
XFILLER_9_225 VPWR VGND sg13cmos5l_decap_4
X_77_ FrameData_O[20] FrameData[20] VPWR VGND sg13cmos5l_buf_1
XFILLER_10_25 VPWR VGND sg13cmos5l_decap_8
XANTENNA__30__X FrameStrobe_O[5] VPWR VGND sg13cmos5l_antennanp
XFILLER_18_121 VPWR VGND sg13cmos5l_fill_2
XFILLER_18_176 VPWR VGND sg13cmos5l_decap_4
X_00_ UserCLKo UserCLK VPWR VGND sg13cmos5l_buf_1
XFILLER_4_0 VPWR VGND sg13cmos5l_fill_2
XFILLER_2_70 VPWR VGND sg13cmos5l_decap_8
XANTENNA__25__X FrameStrobe_O[0] VPWR VGND sg13cmos5l_antennanp
XFILLER_15_168 VPWR VGND sg13cmos5l_decap_8
XFILLER_7_37 VPWR VGND sg13cmos5l_decap_8
XFILLER_12_149 VPWR VGND sg13cmos5l_decap_8
XFILLER_16_24 VPWR VGND sg13cmos5l_decap_8
XFILLER_11_171 VPWR VGND sg13cmos5l_decap_8
XFILLER_14_2 VPWR VGND sg13cmos5l_fill_1
XFILLER_7_142 VPWR VGND sg13cmos5l_decap_8
XFILLER_4_123 VPWR VGND sg13cmos5l_decap_8
XFILLER_13_47 VPWR VGND sg13cmos5l_decap_8
XANTENNA__33__X FrameStrobe_O[8] VPWR VGND sg13cmos5l_antennanp
XFILLER_1_148 VPWR VGND sg13cmos5l_fill_2
XFILLER_9_204 VPWR VGND sg13cmos5l_decap_8
XFILLER_5_81 VPWR VGND sg13cmos5l_decap_8
XFILLER_10_214 VPWR VGND sg13cmos5l_decap_8
XFILLER_1_17 VPWR VGND sg13cmos5l_decap_8
XANTENNA__28__X FrameStrobe_O[3] VPWR VGND sg13cmos5l_antennanp
X_76_ FrameData_O[19] FrameData[19] VPWR VGND sg13cmos5l_buf_1
XFILLER_18_133 VPWR VGND sg13cmos5l_fill_2
XFILLER_18_199 VPWR VGND sg13cmos5l_decap_8
XFILLER_2_221 VPWR VGND sg13cmos5l_decap_8
X_59_ FrameData_O[2] FrameData[2] VPWR VGND sg13cmos5l_buf_1
XANTENNA__41__X FrameStrobe_O[16] VPWR VGND sg13cmos5l_antennanp
XFILLER_15_147 VPWR VGND sg13cmos5l_decap_8
XFILLER_11_80 VPWR VGND sg13cmos5l_decap_8
XFILLER_14_180 VPWR VGND sg13cmos5l_decap_8
XFILLER_12_128 VPWR VGND sg13cmos5l_decap_8
XANTENNA__36__X FrameStrobe_O[11] VPWR VGND sg13cmos5l_antennanp
XFILLER_11_150 VPWR VGND sg13cmos5l_decap_8
XFILLER_7_198 VPWR VGND sg13cmos5l_decap_8
XFILLER_7_121 VPWR VGND sg13cmos5l_decap_8
XFILLER_4_39 VPWR VGND sg13cmos5l_decap_8
XFILLER_4_179 VPWR VGND sg13cmos5l_decap_4
XFILLER_4_17 VPWR VGND sg13cmos5l_fill_1
XFILLER_4_102 VPWR VGND sg13cmos5l_decap_8
XFILLER_12_0 VPWR VGND sg13cmos5l_fill_2
XFILLER_13_26 VPWR VGND sg13cmos5l_decap_8
XFILLER_1_116 VPWR VGND sg13cmos5l_decap_8
XFILLER_6_208 VPWR VGND sg13cmos5l_fill_1
XFILLER_5_60 VPWR VGND sg13cmos5l_decap_8
XANTENNA__44__X FrameStrobe_O[19] VPWR VGND sg13cmos5l_antennanp
X_75_ FrameData_O[18] FrameData[18] VPWR VGND sg13cmos5l_buf_1
XANTENNA__39__X FrameStrobe_O[14] VPWR VGND sg13cmos5l_antennanp
XFILLER_18_145 VPWR VGND sg13cmos5l_fill_2
XFILLER_4_2 VPWR VGND sg13cmos5l_fill_1
XFILLER_2_200 VPWR VGND sg13cmos5l_decap_8
X_58_ FrameData_O[1] FrameData[1] VPWR VGND sg13cmos5l_buf_1
XFILLER_15_126 VPWR VGND sg13cmos5l_decap_8
XFILLER_12_107 VPWR VGND sg13cmos5l_decap_8
XFILLER_16_59 VPWR VGND sg13cmos5l_decap_8
XANTENNA__52__X S2BEG[7] VPWR VGND sg13cmos5l_antennanp
XFILLER_7_177 VPWR VGND sg13cmos5l_decap_8
XFILLER_7_100 VPWR VGND sg13cmos5l_decap_8
XFILLER_8_82 VPWR VGND sg13cmos5l_decap_8
XANTENNA__47__X S2BEG[2] VPWR VGND sg13cmos5l_antennanp
XFILLER_4_158 VPWR VGND sg13cmos5l_decap_8
XFILLER_13_224 VPWR VGND sg13cmos5l_decap_4
XFILLER_1_106 VPWR VGND sg13cmos5l_decap_8
XFILLER_0_194 VPWR VGND sg13cmos5l_decap_4
XANTENNA__60__X FrameData_O[3] VPWR VGND sg13cmos5l_antennanp
XFILLER_10_39 VPWR VGND sg13cmos5l_decap_8
X_74_ FrameData_O[17] FrameData[17] VPWR VGND sg13cmos5l_buf_1
XANTENNA__55__X S1BEG[2] VPWR VGND sg13cmos5l_antennanp
XFILLER_18_102 VPWR VGND sg13cmos5l_decap_8
XFILLER_18_157 VPWR VGND sg13cmos5l_fill_2
XFILLER_2_84 VPWR VGND sg13cmos5l_decap_8
XFILLER_15_105 VPWR VGND sg13cmos5l_decap_8
X_57_ FrameData_O[0] FrameData[0] VPWR VGND sg13cmos5l_buf_1
XFILLER_2_0 VPWR VGND sg13cmos5l_decap_8
XFILLER_16_38 VPWR VGND sg13cmos5l_decap_8
XFILLER_11_185 VPWR VGND sg13cmos5l_decap_8
XFILLER_7_156 VPWR VGND sg13cmos5l_decap_8
XFILLER_8_61 VPWR VGND sg13cmos5l_decap_8
XFILLER_4_137 VPWR VGND sg13cmos5l_decap_8
XANTENNA__63__X FrameData_O[6] VPWR VGND sg13cmos5l_antennanp
XFILLER_16_222 VPWR VGND sg13cmos5l_decap_8
XFILLER_17_81 VPWR VGND sg13cmos5l_decap_8
XANTENNA__58__X FrameData_O[1] VPWR VGND sg13cmos5l_antennanp
XFILLER_13_203 VPWR VGND sg13cmos5l_decap_8
XFILLER_9_218 VPWR VGND sg13cmos5l_decap_8
XFILLER_5_95 VPWR VGND sg13cmos5l_decap_8
XFILLER_10_228 VPWR VGND sg13cmos5l_fill_1
XFILLER_14_82 VPWR VGND sg13cmos5l_decap_8
X_73_ FrameData_O[16] FrameData[16] VPWR VGND sg13cmos5l_buf_1
XFILLER_5_221 VPWR VGND sg13cmos5l_decap_8
XFILLER_10_18 VPWR VGND sg13cmos5l_decap_8
XANTENNA__71__X FrameData_O[14] VPWR VGND sg13cmos5l_antennanp
XFILLER_18_114 VPWR VGND sg13cmos5l_decap_8
XFILLER_18_169 VPWR VGND sg13cmos5l_decap_8
X_56_ S1BEG[3] N1END[0] VPWR VGND sg13cmos5l_buf_1
XFILLER_2_63 VPWR VGND sg13cmos5l_decap_8
XANTENNA__66__X FrameData_O[9] VPWR VGND sg13cmos5l_antennanp
XFILLER_11_94 VPWR VGND sg13cmos5l_decap_8
XFILLER_14_194 VPWR VGND sg13cmos5l_decap_8
XFILLER_16_17 VPWR VGND sg13cmos5l_decap_8
X_39_ FrameStrobe_O[14] FrameStrobe[14] VPWR VGND sg13cmos5l_buf_1
XFILLER_11_164 VPWR VGND sg13cmos5l_decap_8
XFILLER_8_40 VPWR VGND sg13cmos5l_decap_8
XFILLER_7_135 VPWR VGND sg13cmos5l_decap_8
XFILLER_16_201 VPWR VGND sg13cmos5l_decap_8
XFILLER_17_60 VPWR VGND sg13cmos5l_decap_8
XFILLER_4_116 VPWR VGND sg13cmos5l_decap_8
XFILLER_3_182 VPWR VGND sg13cmos5l_decap_8
XANTENNA__74__X FrameData_O[17] VPWR VGND sg13cmos5l_antennanp
XFILLER_10_0 VPWR VGND sg13cmos5l_fill_2
XFILLER_5_74 VPWR VGND sg13cmos5l_decap_8
XFILLER_10_207 VPWR VGND sg13cmos5l_decap_8
XANTENNA__69__X FrameData_O[12] VPWR VGND sg13cmos5l_antennanp
XFILLER_14_61 VPWR VGND sg13cmos5l_decap_8
X_72_ FrameData_O[15] FrameData[15] VPWR VGND sg13cmos5l_buf_1
XFILLER_18_126 VPWR VGND sg13cmos5l_decap_8
XFILLER_2_214 VPWR VGND sg13cmos5l_decap_8
X_55_ S1BEG[2] N1END[1] VPWR VGND sg13cmos5l_buf_1
XFILLER_2_42 VPWR VGND sg13cmos5l_decap_8
XFILLER_11_73 VPWR VGND sg13cmos5l_decap_8
XANTENNA__82__X FrameData_O[25] VPWR VGND sg13cmos5l_antennanp
XFILLER_14_173 VPWR VGND sg13cmos5l_decap_8
X_38_ FrameStrobe_O[13] FrameStrobe[13] VPWR VGND sg13cmos5l_buf_1
XANTENNA__77__X FrameData_O[20] VPWR VGND sg13cmos5l_antennanp
XFILLER_11_143 VPWR VGND sg13cmos5l_decap_8
XFILLER_7_114 VPWR VGND sg13cmos5l_decap_8
XFILLER_8_96 VPWR VGND sg13cmos5l_decap_8
XFILLER_13_19 VPWR VGND sg13cmos5l_decap_8
XFILLER_3_161 VPWR VGND sg13cmos5l_decap_8
XFILLER_5_53 VPWR VGND sg13cmos5l_decap_8
XANTENNA__85__X FrameData_O[28] VPWR VGND sg13cmos5l_antennanp
XFILLER_14_40 VPWR VGND sg13cmos5l_decap_8
X_71_ FrameData_O[14] FrameData[14] VPWR VGND sg13cmos5l_buf_1
XFILLER_18_138 VPWR VGND sg13cmos5l_decap_8
XFILLER_17_193 VPWR VGND sg13cmos5l_decap_8
X_54_ S1BEG[1] N1END[2] VPWR VGND sg13cmos5l_buf_1
XFILLER_2_98 VPWR VGND sg13cmos5l_decap_8
XFILLER_2_21 VPWR VGND sg13cmos5l_decap_8
XFILLER_15_119 VPWR VGND sg13cmos5l_decap_8
XFILLER_11_52 VPWR VGND sg13cmos5l_decap_8
XFILLER_14_152 VPWR VGND sg13cmos5l_decap_8
X_37_ FrameStrobe_O[12] FrameStrobe[12] VPWR VGND sg13cmos5l_buf_1
XFILLER_0_0 VPWR VGND sg13cmos5l_fill_2
XFILLER_11_122 VPWR VGND sg13cmos5l_decap_8
XFILLER_11_199 VPWR VGND sg13cmos5l_decap_8
XFILLER_8_75 VPWR VGND sg13cmos5l_decap_8
XFILLER_6_192 VPWR VGND sg13cmos5l_decap_8
XFILLER_17_95 VPWR VGND sg13cmos5l_decap_8
XANTENNA__88__X FrameData_O[31] VPWR VGND sg13cmos5l_antennanp
XFILLER_3_140 VPWR VGND sg13cmos5l_decap_8
XFILLER_13_217 VPWR VGND sg13cmos5l_decap_8
XFILLER_13_228 VPWR VGND sg13cmos5l_fill_1
XFILLER_0_187 VPWR VGND sg13cmos5l_decap_8
XFILLER_0_198 VPWR VGND sg13cmos5l_fill_2
XFILLER_10_2 VPWR VGND sg13cmos5l_fill_1
XFILLER_5_32 VPWR VGND sg13cmos5l_decap_8
XFILLER_14_96 VPWR VGND sg13cmos5l_decap_8
X_70_ FrameData_O[13] FrameData[13] VPWR VGND sg13cmos5l_buf_1
XFILLER_17_172 VPWR VGND sg13cmos5l_decap_8
X_53_ S1BEG[0] N1END[3] VPWR VGND sg13cmos5l_buf_1
XFILLER_2_77 VPWR VGND sg13cmos5l_decap_8
XFILLER_11_31 VPWR VGND sg13cmos5l_decap_8
XFILLER_14_131 VPWR VGND sg13cmos5l_decap_8
X_36_ FrameStrobe_O[11] FrameStrobe[11] VPWR VGND sg13cmos5l_buf_1
XFILLER_9_190 VPWR VGND sg13cmos5l_decap_8
XFILLER_11_101 VPWR VGND sg13cmos5l_decap_8
XFILLER_11_178 VPWR VGND sg13cmos5l_decap_8
XFILLER_7_149 VPWR VGND sg13cmos5l_decap_8
XFILLER_8_54 VPWR VGND sg13cmos5l_decap_8
XFILLER_6_171 VPWR VGND sg13cmos5l_decap_8
X_19_ S2BEGb[2] N2END[5] VPWR VGND sg13cmos5l_buf_1
XFILLER_16_215 VPWR VGND sg13cmos5l_decap_8
XFILLER_17_74 VPWR VGND sg13cmos5l_decap_8
XFILLER_3_196 VPWR VGND sg13cmos5l_decap_8
XFILLER_0_111 VPWR VGND sg13cmos5l_fill_1
XFILLER_0_122 VPWR VGND sg13cmos5l_fill_1
XFILLER_8_200 VPWR VGND sg13cmos5l_decap_8
XFILLER_5_88 VPWR VGND sg13cmos5l_decap_8
XFILLER_14_75 VPWR VGND sg13cmos5l_decap_8
XFILLER_5_214 VPWR VGND sg13cmos5l_fill_2
XFILLER_2_228 VPWR VGND sg13cmos5l_fill_1
X_52_ S2BEG[7] N2MID[0] VPWR VGND sg13cmos5l_buf_1
XFILLER_2_56 VPWR VGND sg13cmos5l_decap_8
XFILLER_17_151 VPWR VGND sg13cmos5l_decap_8
XFILLER_11_87 VPWR VGND sg13cmos5l_decap_8
XFILLER_14_110 VPWR VGND sg13cmos5l_decap_8
XFILLER_14_187 VPWR VGND sg13cmos5l_decap_8
X_35_ FrameStrobe_O[10] FrameStrobe[10] VPWR VGND sg13cmos5l_buf_1
XFILLER_11_157 VPWR VGND sg13cmos5l_decap_8
XFILLER_7_128 VPWR VGND sg13cmos5l_decap_8
XFILLER_8_33 VPWR VGND sg13cmos5l_decap_8
XFILLER_8_11 VPWR VGND sg13cmos5l_fill_2
XFILLER_6_150 VPWR VGND sg13cmos5l_decap_8
X_18_ S2BEGb[1] N2END[6] VPWR VGND sg13cmos5l_buf_1
XFILLER_4_109 VPWR VGND sg13cmos5l_decap_8
XFILLER_17_53 VPWR VGND sg13cmos5l_decap_8
XFILLER_3_175 VPWR VGND sg13cmos5l_decap_8
XFILLER_5_67 VPWR VGND sg13cmos5l_decap_8
XFILLER_14_54 VPWR VGND sg13cmos5l_decap_8
XFILLER_2_207 VPWR VGND sg13cmos5l_decap_8
XFILLER_17_130 VPWR VGND sg13cmos5l_decap_8
X_51_ S2BEG[6] N2MID[1] VPWR VGND sg13cmos5l_buf_1
XFILLER_2_35 VPWR VGND sg13cmos5l_decap_8
XFILLER_11_66 VPWR VGND sg13cmos5l_decap_8
XFILLER_14_166 VPWR VGND sg13cmos5l_decap_8
X_34_ FrameStrobe_O[9] FrameStrobe[9] VPWR VGND sg13cmos5l_buf_1
XANTENNA__01__X S4BEG[0] VPWR VGND sg13cmos5l_antennanp
XFILLER_11_136 VPWR VGND sg13cmos5l_decap_8
XFILLER_7_107 VPWR VGND sg13cmos5l_decap_8
X_17_ S2BEGb[0] N2END[7] VPWR VGND sg13cmos5l_buf_1
XFILLER_8_89 VPWR VGND sg13cmos5l_decap_8
XFILLER_17_32 VPWR VGND sg13cmos5l_decap_8
XFILLER_3_154 VPWR VGND sg13cmos5l_decap_8
XFILLER_5_46 VPWR VGND sg13cmos5l_decap_8
XFILLER_14_11 VPWR VGND sg13cmos5l_fill_2
XFILLER_14_33 VPWR VGND sg13cmos5l_decap_8
XFILLER_5_216 VPWR VGND sg13cmos5l_fill_1
XANTENNA__04__X S4BEG[3] VPWR VGND sg13cmos5l_antennanp
XFILLER_18_109 VPWR VGND sg13cmos5l_fill_2
XFILLER_17_186 VPWR VGND sg13cmos5l_decap_8
X_50_ S2BEG[5] N2MID[2] VPWR VGND sg13cmos5l_buf_1
XFILLER_9_0 VPWR VGND sg13cmos5l_fill_1
XFILLER_2_14 VPWR VGND sg13cmos5l_decap_8
XFILLER_11_45 VPWR VGND sg13cmos5l_decap_8
XFILLER_2_7 VPWR VGND sg13cmos5l_decap_8
XFILLER_14_145 VPWR VGND sg13cmos5l_decap_8
X_33_ FrameStrobe_O[8] FrameStrobe[8] VPWR VGND sg13cmos5l_buf_1
XFILLER_11_115 VPWR VGND sg13cmos5l_decap_8
X_16_ S4BEG[15] N4END[0] VPWR VGND sg13cmos5l_buf_1
XFILLER_8_68 VPWR VGND sg13cmos5l_decap_8
XFILLER_6_185 VPWR VGND sg13cmos5l_decap_8
XFILLER_17_11 VPWR VGND sg13cmos5l_decap_8
XFILLER_17_88 VPWR VGND sg13cmos5l_decap_8
XANTENNA__12__X S4BEG[11] VPWR VGND sg13cmos5l_antennanp
XFILLER_3_133 VPWR VGND sg13cmos5l_decap_8
XANTENNA__07__X S4BEG[6] VPWR VGND sg13cmos5l_antennanp
XFILLER_5_25 VPWR VGND sg13cmos5l_decap_8
XFILLER_14_89 VPWR VGND sg13cmos5l_decap_8
XFILLER_5_228 VPWR VGND sg13cmos5l_fill_1
XANTENNA__20__X S2BEGb[3] VPWR VGND sg13cmos5l_antennanp
XFILLER_17_165 VPWR VGND sg13cmos5l_decap_8
XFILLER_11_24 VPWR VGND sg13cmos5l_decap_8
XANTENNA__15__X S4BEG[14] VPWR VGND sg13cmos5l_antennanp
XFILLER_14_124 VPWR VGND sg13cmos5l_decap_8
X_32_ FrameStrobe_O[7] FrameStrobe[7] VPWR VGND sg13cmos5l_buf_1
XFILLER_9_183 VPWR VGND sg13cmos5l_decap_8
XFILLER_3_91 VPWR VGND sg13cmos5l_decap_8
XFILLER_10_193 VPWR VGND sg13cmos5l_decap_8
X_15_ S4BEG[14] N4END[1] VPWR VGND sg13cmos5l_buf_1
XFILLER_8_47 VPWR VGND sg13cmos5l_decap_8
XFILLER_6_164 VPWR VGND sg13cmos5l_decap_8
XFILLER_16_208 VPWR VGND sg13cmos5l_decap_8
XFILLER_17_67 VPWR VGND sg13cmos5l_decap_8
XFILLER_3_189 VPWR VGND sg13cmos5l_decap_8
XFILLER_3_112 VPWR VGND sg13cmos5l_decap_8
XFILLER_17_0 VPWR VGND sg13cmos5l_decap_8
XANTENNA__23__X S2BEGb[6] VPWR VGND sg13cmos5l_antennanp
XFILLER_8_226 VPWR VGND sg13cmos5l_fill_2
XFILLER_10_7 VPWR VGND sg13cmos5l_fill_1
XFILLER_14_68 VPWR VGND sg13cmos5l_decap_8
XFILLER_5_207 VPWR VGND sg13cmos5l_decap_8
XANTENNA__18__X S2BEGb[1] VPWR VGND sg13cmos5l_antennanp
XFILLER_6_80 VPWR VGND sg13cmos5l_decap_8
XFILLER_17_144 VPWR VGND sg13cmos5l_decap_8
XFILLER_2_49 VPWR VGND sg13cmos5l_decap_8
XFILLER_1_221 VPWR VGND sg13cmos5l_decap_8
XFILLER_14_103 VPWR VGND sg13cmos5l_decap_8
XANTENNA__31__X FrameStrobe_O[6] VPWR VGND sg13cmos5l_antennanp
XFILLER_13_180 VPWR VGND sg13cmos5l_decap_8
X_31_ FrameStrobe_O[6] FrameStrobe[6] VPWR VGND sg13cmos5l_buf_1
XFILLER_9_162 VPWR VGND sg13cmos5l_decap_8
XFILLER_3_70 VPWR VGND sg13cmos5l_decap_8
XANTENNA__26__X FrameStrobe_O[1] VPWR VGND sg13cmos5l_antennanp
XFILLER_10_172 VPWR VGND sg13cmos5l_decap_8
XFILLER_8_26 VPWR VGND sg13cmos5l_decap_8
XFILLER_6_143 VPWR VGND sg13cmos5l_decap_8
X_14_ S4BEG[13] N4END[2] VPWR VGND sg13cmos5l_buf_1
XFILLER_17_46 VPWR VGND sg13cmos5l_decap_8
XFILLER_3_168 VPWR VGND sg13cmos5l_decap_8
XFILLER_0_93 VPWR VGND sg13cmos5l_fill_2
XFILLER_12_212 VPWR VGND sg13cmos5l_decap_8
XFILLER_14_47 VPWR VGND sg13cmos5l_decap_8
XANTENNA__34__X FrameStrobe_O[9] VPWR VGND sg13cmos5l_antennanp
XANTENNA__29__X FrameStrobe_O[4] VPWR VGND sg13cmos5l_antennanp
XFILLER_2_28 VPWR VGND sg13cmos5l_decap_8
XFILLER_1_200 VPWR VGND sg13cmos5l_decap_8
XFILLER_17_123 VPWR VGND sg13cmos5l_decap_8
XFILLER_11_59 VPWR VGND sg13cmos5l_decap_8
XFILLER_14_159 VPWR VGND sg13cmos5l_decap_8
X_30_ FrameStrobe_O[5] FrameStrobe[5] VPWR VGND sg13cmos5l_buf_1
XFILLER_9_141 VPWR VGND sg13cmos5l_decap_8
XFILLER_7_0 VPWR VGND sg13cmos5l_fill_2
XFILLER_11_129 VPWR VGND sg13cmos5l_decap_8
XANTENNA__42__X FrameStrobe_O[17] VPWR VGND sg13cmos5l_antennanp
XFILLER_10_151 VPWR VGND sg13cmos5l_decap_8
XFILLER_6_199 VPWR VGND sg13cmos5l_decap_4
XFILLER_6_122 VPWR VGND sg13cmos5l_decap_8
X_13_ S4BEG[12] N4END[3] VPWR VGND sg13cmos5l_buf_1
XFILLER_17_25 VPWR VGND sg13cmos5l_decap_8
XFILLER_3_147 VPWR VGND sg13cmos5l_decap_8
XANTENNA__37__X FrameStrobe_O[12] VPWR VGND sg13cmos5l_antennanp
XFILLER_0_83 VPWR VGND sg13cmos5l_fill_2
XFILLER_9_92 VPWR VGND sg13cmos5l_decap_8
XFILLER_8_228 VPWR VGND sg13cmos5l_fill_1
XFILLER_5_39 VPWR VGND sg13cmos5l_decap_8
XFILLER_14_26 VPWR VGND sg13cmos5l_decap_8
XANTENNA__50__X S2BEG[5] VPWR VGND sg13cmos5l_antennanp
XANTENNA__45__X S2BEG[0] VPWR VGND sg13cmos5l_antennanp
XFILLER_15_91 VPWR VGND sg13cmos5l_decap_8
XFILLER_17_102 VPWR VGND sg13cmos5l_decap_8
XFILLER_17_179 VPWR VGND sg13cmos5l_decap_8
XFILLER_11_38 VPWR VGND sg13cmos5l_decap_8
XFILLER_14_138 VPWR VGND sg13cmos5l_decap_8
XFILLER_11_108 VPWR VGND sg13cmos5l_decap_8
XFILLER_9_197 VPWR VGND sg13cmos5l_decap_8
XFILLER_9_120 VPWR VGND sg13cmos5l_decap_8
XFILLER_10_130 VPWR VGND sg13cmos5l_decap_8
XFILLER_6_101 VPWR VGND sg13cmos5l_decap_8
X_12_ S4BEG[11] N4END[4] VPWR VGND sg13cmos5l_buf_1
XFILLER_6_178 VPWR VGND sg13cmos5l_decap_8
XFILLER_3_126 VPWR VGND sg13cmos5l_decap_8
XANTENNA__53__X S1BEG[0] VPWR VGND sg13cmos5l_antennanp
XFILLER_0_62 VPWR VGND sg13cmos5l_fill_1
XFILLER_9_71 VPWR VGND sg13cmos5l_decap_8
XANTENNA__48__X S2BEG[3] VPWR VGND sg13cmos5l_antennanp
XFILLER_8_207 VPWR VGND sg13cmos5l_decap_4
XFILLER_5_18 VPWR VGND sg13cmos5l_decap_8
XFILLER_15_0 VPWR VGND sg13cmos5l_fill_2
XFILLER_6_94 VPWR VGND sg13cmos5l_decap_8
XANTENNA__61__X FrameData_O[4] VPWR VGND sg13cmos5l_antennanp
XFILLER_15_70 VPWR VGND sg13cmos5l_decap_8
XFILLER_17_158 VPWR VGND sg13cmos5l_decap_8
XFILLER_11_17 VPWR VGND sg13cmos5l_decap_8
XFILLER_14_117 VPWR VGND sg13cmos5l_decap_8
XFILLER_7_2 VPWR VGND sg13cmos5l_fill_1
XANTENNA__56__X S1BEG[3] VPWR VGND sg13cmos5l_antennanp
XFILLER_13_194 VPWR VGND sg13cmos5l_fill_1
X_88_ FrameData_O[31] FrameData[31] VPWR VGND sg13cmos5l_buf_1
XFILLER_9_176 VPWR VGND sg13cmos5l_decap_8
XFILLER_3_84 VPWR VGND sg13cmos5l_decap_8
XFILLER_10_186 VPWR VGND sg13cmos5l_decap_8
XFILLER_12_93 VPWR VGND sg13cmos5l_decap_8
X_11_ S4BEG[10] N4END[5] VPWR VGND sg13cmos5l_buf_1
XFILLER_6_157 VPWR VGND sg13cmos5l_decap_8
XFILLER_5_190 VPWR VGND sg13cmos5l_fill_2
XFILLER_15_223 VPWR VGND sg13cmos5l_decap_4
XFILLER_3_105 VPWR VGND sg13cmos5l_decap_8
XFILLER_0_74 VPWR VGND sg13cmos5l_fill_1
XFILLER_9_50 VPWR VGND sg13cmos5l_decap_8
XFILLER_2_193 VPWR VGND sg13cmos5l_decap_8
XFILLER_12_226 VPWR VGND sg13cmos5l_fill_2
XFILLER_8_219 VPWR VGND sg13cmos5l_decap_8
XANTENNA__64__X FrameData_O[7] VPWR VGND sg13cmos5l_antennanp
XANTENNA__59__X FrameData_O[2] VPWR VGND sg13cmos5l_antennanp
XFILLER_4_211 VPWR VGND sg13cmos5l_decap_8
XFILLER_4_200 VPWR VGND sg13cmos5l_decap_8
XFILLER_6_73 VPWR VGND sg13cmos5l_decap_8
XFILLER_17_137 VPWR VGND sg13cmos5l_decap_8
XFILLER_1_214 VPWR VGND sg13cmos5l_decap_8
XFILLER_16_192 VPWR VGND sg13cmos5l_decap_4
XANTENNA__72__X FrameData_O[15] VPWR VGND sg13cmos5l_antennanp
XFILLER_13_173 VPWR VGND sg13cmos5l_decap_8
XFILLER_9_155 VPWR VGND sg13cmos5l_decap_8
XFILLER_3_63 VPWR VGND sg13cmos5l_decap_8
X_87_ FrameData_O[30] FrameData[30] VPWR VGND sg13cmos5l_buf_1
XANTENNA__67__X FrameData_O[10] VPWR VGND sg13cmos5l_antennanp
XFILLER_10_165 VPWR VGND sg13cmos5l_decap_8
XFILLER_12_72 VPWR VGND sg13cmos5l_decap_8
XFILLER_18_221 VPWR VGND sg13cmos5l_fill_1
X_10_ S4BEG[9] N4END[6] VPWR VGND sg13cmos5l_buf_1
XFILLER_8_19 VPWR VGND sg13cmos5l_decap_8
XFILLER_6_136 VPWR VGND sg13cmos5l_decap_8
XFILLER_5_0 VPWR VGND sg13cmos5l_fill_2
XFILLER_17_39 VPWR VGND sg13cmos5l_decap_8
XFILLER_15_202 VPWR VGND sg13cmos5l_decap_8
XFILLER_2_172 VPWR VGND sg13cmos5l_decap_8
XFILLER_12_205 VPWR VGND sg13cmos5l_decap_8
XANTENNA__80__X FrameData_O[23] VPWR VGND sg13cmos5l_antennanp
XFILLER_15_2 VPWR VGND sg13cmos5l_fill_1
XANTENNA__75__X FrameData_O[18] VPWR VGND sg13cmos5l_antennanp
XFILLER_4_223 VPWR VGND sg13cmos5l_decap_4
XFILLER_6_52 VPWR VGND sg13cmos5l_decap_8
XFILLER_17_116 VPWR VGND sg13cmos5l_decap_8
XFILLER_16_171 VPWR VGND sg13cmos5l_decap_8
XFILLER_13_152 VPWR VGND sg13cmos5l_decap_8
XFILLER_9_134 VPWR VGND sg13cmos5l_decap_8
X_86_ FrameData_O[29] FrameData[29] VPWR VGND sg13cmos5l_buf_1
XFILLER_3_42 VPWR VGND sg13cmos5l_decap_8
XFILLER_10_144 VPWR VGND sg13cmos5l_decap_8
XFILLER_12_51 VPWR VGND sg13cmos5l_decap_8
XFILLER_6_115 VPWR VGND sg13cmos5l_decap_8
XANTENNA__83__X FrameData_O[26] VPWR VGND sg13cmos5l_antennanp
XFILLER_17_18 VPWR VGND sg13cmos5l_decap_8
X_69_ FrameData_O[12] FrameData[12] VPWR VGND sg13cmos5l_buf_1
XANTENNA__78__X FrameData_O[21] VPWR VGND sg13cmos5l_antennanp
XFILLER_2_151 VPWR VGND sg13cmos5l_decap_8
XFILLER_2_140 VPWR VGND sg13cmos5l_decap_8
XFILLER_12_228 VPWR VGND sg13cmos5l_fill_1
XFILLER_9_85 VPWR VGND sg13cmos5l_decap_8
XFILLER_18_61 VPWR VGND sg13cmos5l_fill_2
XFILLER_14_19 VPWR VGND sg13cmos5l_decap_8
XFILLER_6_31 VPWR VGND sg13cmos5l_decap_8
XFILLER_13_0 VPWR VGND sg13cmos5l_fill_2
XANTENNA__86__X FrameData_O[29] VPWR VGND sg13cmos5l_antennanp
XFILLER_15_84 VPWR VGND sg13cmos5l_decap_8
XFILLER_16_150 VPWR VGND sg13cmos5l_decap_8
XFILLER_13_131 VPWR VGND sg13cmos5l_decap_8
XFILLER_9_113 VPWR VGND sg13cmos5l_decap_8
X_85_ FrameData_O[28] FrameData[28] VPWR VGND sg13cmos5l_buf_1
XFILLER_3_98 VPWR VGND sg13cmos5l_decap_8
XFILLER_3_21 VPWR VGND sg13cmos5l_decap_8
XFILLER_10_123 VPWR VGND sg13cmos5l_decap_8
XFILLER_12_30 VPWR VGND sg13cmos5l_decap_8
XFILLER_5_2 VPWR VGND sg13cmos5l_fill_1
X_68_ FrameData_O[11] FrameData[11] VPWR VGND sg13cmos5l_buf_1
XFILLER_3_119 VPWR VGND sg13cmos5l_decap_8
XFILLER_17_7 VPWR VGND sg13cmos5l_fill_1
XFILLER_0_99 VPWR VGND sg13cmos5l_fill_2
XFILLER_9_64 VPWR VGND sg13cmos5l_decap_8
XFILLER_18_73 VPWR VGND sg13cmos5l_fill_2
XFILLER_6_87 VPWR VGND sg13cmos5l_decap_8
XFILLER_1_228 VPWR VGND sg13cmos5l_fill_1
XFILLER_15_63 VPWR VGND sg13cmos5l_decap_8
XFILLER_13_110 VPWR VGND sg13cmos5l_decap_8
XFILLER_13_187 VPWR VGND sg13cmos5l_decap_8
X_84_ FrameData_O[27] FrameData[27] VPWR VGND sg13cmos5l_buf_1
XFILLER_9_169 VPWR VGND sg13cmos5l_decap_8
XFILLER_3_77 VPWR VGND sg13cmos5l_decap_8
XFILLER_10_102 VPWR VGND sg13cmos5l_decap_8
XFILLER_8_180 VPWR VGND sg13cmos5l_decap_8
XFILLER_10_179 VPWR VGND sg13cmos5l_decap_8
XFILLER_12_86 VPWR VGND sg13cmos5l_decap_8
X_67_ FrameData_O[10] FrameData[10] VPWR VGND sg13cmos5l_buf_1
XFILLER_5_172 VPWR VGND sg13cmos5l_decap_8
XFILLER_15_216 VPWR VGND sg13cmos5l_decap_8
XFILLER_15_227 VPWR VGND sg13cmos5l_fill_2
XFILLER_3_0 VPWR VGND sg13cmos5l_fill_2
XFILLER_2_186 VPWR VGND sg13cmos5l_decap_8
XFILLER_9_43 VPWR VGND sg13cmos5l_decap_8
XFILLER_12_219 VPWR VGND sg13cmos5l_decap_8
XFILLER_18_85 VPWR VGND sg13cmos5l_fill_1
XFILLER_18_96 VPWR VGND sg13cmos5l_fill_2
XFILLER_7_212 VPWR VGND sg13cmos5l_fill_2
XFILLER_13_2 VPWR VGND sg13cmos5l_fill_1
XFILLER_6_66 VPWR VGND sg13cmos5l_decap_8
XFILLER_15_42 VPWR VGND sg13cmos5l_decap_8
XFILLER_1_207 VPWR VGND sg13cmos5l_decap_8
XFILLER_16_185 VPWR VGND sg13cmos5l_decap_8
XFILLER_16_196 VPWR VGND sg13cmos5l_fill_1
.ends
