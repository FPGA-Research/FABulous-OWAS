* NGSPICE file created from NPU_ACCUM_N.ext - technology: ihp-sg13cmos5l

* Black-box entry subcircuit for sg13cmos5l_antennanp abstract view
.subckt sg13cmos5l_antennanp A VDD VSS
.ends

* Black-box entry subcircuit for latch abstract view
.subckt latch Q D VSS VDD GATE
.ends

* Black-box entry subcircuit for sg13cmos5l_decap_8 abstract view
.subckt sg13cmos5l_decap_8 VDD VSS
.ends

* Black-box entry subcircuit for sg13cmos5l_fill_1 abstract view
.subckt sg13cmos5l_fill_1 VDD VSS
.ends

* Black-box entry subcircuit for sg13cmos5l_fill_2 abstract view
.subckt sg13cmos5l_fill_2 VDD VSS
.ends

* Black-box entry subcircuit for sg13cmos5l_mux4_1 abstract view
.subckt sg13cmos5l_mux4_1 X A0 A1 A2 A3 S0 S1 VDD VSS
.ends

* Black-box entry subcircuit for sg13cmos5l_nor2b_1 abstract view
.subckt sg13cmos5l_nor2b_1 Y A B_N VDD VSS
.ends

* Black-box entry subcircuit for sg13cmos5l_buf_1 abstract view
.subckt sg13cmos5l_buf_1 X A VDD VSS
.ends

* Black-box entry subcircuit for sg13cmos5l_decap_4 abstract view
.subckt sg13cmos5l_decap_4 VDD VSS
.ends

* Black-box entry subcircuit for sg13cmos5l_tiehi abstract view
.subckt sg13cmos5l_tiehi L_HI VDD VSS
.ends

* Black-box entry subcircuit for sg13cmos5l_dfrbpq_1 abstract view
.subckt sg13cmos5l_dfrbpq_1 Q CLK D RESET_B VDD VSS
.ends

.subckt NPU_ACCUM_N NPU_ADDR0 NPU_ADDR1 NPU_ADDR2 NPU_ADDR3 NPU_ADDR4 NPU_ADDR5 NPU_ADDR6
+ NPU_ADDR7 NPU_RDATA0 NPU_RDATA1 NPU_RDATA10 NPU_RDATA11 NPU_RDATA12 NPU_RDATA13
+ NPU_RDATA14 NPU_RDATA15 NPU_RDATA16 NPU_RDATA17 NPU_RDATA18 NPU_RDATA19 NPU_RDATA2
+ NPU_RDATA20 NPU_RDATA21 NPU_RDATA22 NPU_RDATA23 NPU_RDATA24 NPU_RDATA25 NPU_RDATA26
+ NPU_RDATA27 NPU_RDATA28 NPU_RDATA29 NPU_RDATA3 NPU_RDATA30 NPU_RDATA31 NPU_RDATA4
+ NPU_RDATA5 NPU_RDATA6 NPU_RDATA7 NPU_RDATA8 NPU_RDATA9 NPU_READ_BANK_SEL0 NPU_READ_BANK_SEL1
+ NPU_READ_BANK_SEL2 NPU_WDATA0 NPU_WDATA1 NPU_WDATA10 NPU_WDATA11 NPU_WDATA12 NPU_WDATA13
+ NPU_WDATA14 NPU_WDATA15 NPU_WDATA16 NPU_WDATA17 NPU_WDATA18 NPU_WDATA19 NPU_WDATA2
+ NPU_WDATA20 NPU_WDATA21 NPU_WDATA22 NPU_WDATA23 NPU_WDATA24 NPU_WDATA25 NPU_WDATA26
+ NPU_WDATA27 NPU_WDATA28 NPU_WDATA29 NPU_WDATA3 NPU_WDATA30 NPU_WDATA31 NPU_WDATA4
+ NPU_WDATA5 NPU_WDATA6 NPU_WDATA7 NPU_WDATA8 NPU_WDATA9 NPU_WE0 NPU_WE1 NPU_WE2 NPU_WE3
+ NPU_WE4 NPU_WE5 NPU_WE6 NPU_WE7 Tile_X0Y0_Ci Tile_X0Y0_FrameData[0] Tile_X0Y0_FrameData[10]
+ Tile_X0Y0_FrameData[11] Tile_X0Y0_FrameData[12] Tile_X0Y0_FrameData[13] Tile_X0Y0_FrameData[14]
+ Tile_X0Y0_FrameData[15] Tile_X0Y0_FrameData[16] Tile_X0Y0_FrameData[17] Tile_X0Y0_FrameData[18]
+ Tile_X0Y0_FrameData[19] Tile_X0Y0_FrameData[1] Tile_X0Y0_FrameData[20] Tile_X0Y0_FrameData[21]
+ Tile_X0Y0_FrameData[22] Tile_X0Y0_FrameData[23] Tile_X0Y0_FrameData[24] Tile_X0Y0_FrameData[25]
+ Tile_X0Y0_FrameData[26] Tile_X0Y0_FrameData[27] Tile_X0Y0_FrameData[28] Tile_X0Y0_FrameData[29]
+ Tile_X0Y0_FrameData[2] Tile_X0Y0_FrameData[30] Tile_X0Y0_FrameData[31] Tile_X0Y0_FrameData[3]
+ Tile_X0Y0_FrameData[4] Tile_X0Y0_FrameData[5] Tile_X0Y0_FrameData[6] Tile_X0Y0_FrameData[7]
+ Tile_X0Y0_FrameData[8] Tile_X0Y0_FrameData[9] Tile_X0Y0_FrameStrobe[0] Tile_X0Y0_FrameStrobe[10]
+ Tile_X0Y0_FrameStrobe[11] Tile_X0Y0_FrameStrobe[12] Tile_X0Y0_FrameStrobe[13] Tile_X0Y0_FrameStrobe[14]
+ Tile_X0Y0_FrameStrobe[15] Tile_X0Y0_FrameStrobe[16] Tile_X0Y0_FrameStrobe[17] Tile_X0Y0_FrameStrobe[18]
+ Tile_X0Y0_FrameStrobe[19] Tile_X0Y0_FrameStrobe[1] Tile_X0Y0_FrameStrobe[2] Tile_X0Y0_FrameStrobe[3]
+ Tile_X0Y0_FrameStrobe[4] Tile_X0Y0_FrameStrobe[5] Tile_X0Y0_FrameStrobe[6] Tile_X0Y0_FrameStrobe[7]
+ Tile_X0Y0_FrameStrobe[8] Tile_X0Y0_FrameStrobe[9] Tile_X0Y0_FrameStrobe_O[0] Tile_X0Y0_FrameStrobe_O[10]
+ Tile_X0Y0_FrameStrobe_O[11] Tile_X0Y0_FrameStrobe_O[12] Tile_X0Y0_FrameStrobe_O[13]
+ Tile_X0Y0_FrameStrobe_O[14] Tile_X0Y0_FrameStrobe_O[15] Tile_X0Y0_FrameStrobe_O[16]
+ Tile_X0Y0_FrameStrobe_O[17] Tile_X0Y0_FrameStrobe_O[18] Tile_X0Y0_FrameStrobe_O[19]
+ Tile_X0Y0_FrameStrobe_O[1] Tile_X0Y0_FrameStrobe_O[2] Tile_X0Y0_FrameStrobe_O[3]
+ Tile_X0Y0_FrameStrobe_O[4] Tile_X0Y0_FrameStrobe_O[5] Tile_X0Y0_FrameStrobe_O[6]
+ Tile_X0Y0_FrameStrobe_O[7] Tile_X0Y0_FrameStrobe_O[8] Tile_X0Y0_FrameStrobe_O[9]
+ Tile_X0Y0_N1END[0] Tile_X0Y0_N1END[1] Tile_X0Y0_N1END[2] Tile_X0Y0_N1END[3] Tile_X0Y0_N2END[0]
+ Tile_X0Y0_N2END[1] Tile_X0Y0_N2END[2] Tile_X0Y0_N2END[3] Tile_X0Y0_N2END[4] Tile_X0Y0_N2END[5]
+ Tile_X0Y0_N2END[6] Tile_X0Y0_N2END[7] Tile_X0Y0_N2MID[0] Tile_X0Y0_N2MID[1] Tile_X0Y0_N2MID[2]
+ Tile_X0Y0_N2MID[3] Tile_X0Y0_N2MID[4] Tile_X0Y0_N2MID[5] Tile_X0Y0_N2MID[6] Tile_X0Y0_N2MID[7]
+ Tile_X0Y0_N4END[0] Tile_X0Y0_N4END[10] Tile_X0Y0_N4END[11] Tile_X0Y0_N4END[12] Tile_X0Y0_N4END[13]
+ Tile_X0Y0_N4END[14] Tile_X0Y0_N4END[15] Tile_X0Y0_N4END[1] Tile_X0Y0_N4END[2] Tile_X0Y0_N4END[3]
+ Tile_X0Y0_N4END[4] Tile_X0Y0_N4END[5] Tile_X0Y0_N4END[6] Tile_X0Y0_N4END[7] Tile_X0Y0_N4END[8]
+ Tile_X0Y0_N4END[9] Tile_X0Y0_NN4END[0] Tile_X0Y0_NN4END[10] Tile_X0Y0_NN4END[11]
+ Tile_X0Y0_NN4END[12] Tile_X0Y0_NN4END[13] Tile_X0Y0_NN4END[14] Tile_X0Y0_NN4END[15]
+ Tile_X0Y0_NN4END[1] Tile_X0Y0_NN4END[2] Tile_X0Y0_NN4END[3] Tile_X0Y0_NN4END[4]
+ Tile_X0Y0_NN4END[5] Tile_X0Y0_NN4END[6] Tile_X0Y0_NN4END[7] Tile_X0Y0_NN4END[8]
+ Tile_X0Y0_NN4END[9] Tile_X0Y0_S1BEG[0] Tile_X0Y0_S1BEG[1] Tile_X0Y0_S1BEG[2] Tile_X0Y0_S1BEG[3]
+ Tile_X0Y0_S2BEG[0] Tile_X0Y0_S2BEG[1] Tile_X0Y0_S2BEG[2] Tile_X0Y0_S2BEG[3] Tile_X0Y0_S2BEG[4]
+ Tile_X0Y0_S2BEG[5] Tile_X0Y0_S2BEG[6] Tile_X0Y0_S2BEG[7] Tile_X0Y0_S2BEGb[0] Tile_X0Y0_S2BEGb[1]
+ Tile_X0Y0_S2BEGb[2] Tile_X0Y0_S2BEGb[3] Tile_X0Y0_S2BEGb[4] Tile_X0Y0_S2BEGb[5]
+ Tile_X0Y0_S2BEGb[6] Tile_X0Y0_S2BEGb[7] Tile_X0Y0_S4BEG[0] Tile_X0Y0_S4BEG[10] Tile_X0Y0_S4BEG[11]
+ Tile_X0Y0_S4BEG[12] Tile_X0Y0_S4BEG[13] Tile_X0Y0_S4BEG[14] Tile_X0Y0_S4BEG[15]
+ Tile_X0Y0_S4BEG[1] Tile_X0Y0_S4BEG[2] Tile_X0Y0_S4BEG[3] Tile_X0Y0_S4BEG[4] Tile_X0Y0_S4BEG[5]
+ Tile_X0Y0_S4BEG[6] Tile_X0Y0_S4BEG[7] Tile_X0Y0_S4BEG[8] Tile_X0Y0_S4BEG[9] Tile_X0Y0_SS4BEG[0]
+ Tile_X0Y0_SS4BEG[10] Tile_X0Y0_SS4BEG[11] Tile_X0Y0_SS4BEG[12] Tile_X0Y0_SS4BEG[13]
+ Tile_X0Y0_SS4BEG[14] Tile_X0Y0_SS4BEG[15] Tile_X0Y0_SS4BEG[1] Tile_X0Y0_SS4BEG[2]
+ Tile_X0Y0_SS4BEG[3] Tile_X0Y0_SS4BEG[4] Tile_X0Y0_SS4BEG[5] Tile_X0Y0_SS4BEG[6]
+ Tile_X0Y0_SS4BEG[7] Tile_X0Y0_SS4BEG[8] Tile_X0Y0_SS4BEG[9] Tile_X0Y0_UserCLK Tile_X1Y0_Ci
+ Tile_X1Y0_FrameStrobe[0] Tile_X1Y0_FrameStrobe[10] Tile_X1Y0_FrameStrobe[11] Tile_X1Y0_FrameStrobe[12]
+ Tile_X1Y0_FrameStrobe[13] Tile_X1Y0_FrameStrobe[14] Tile_X1Y0_FrameStrobe[15] Tile_X1Y0_FrameStrobe[16]
+ Tile_X1Y0_FrameStrobe[17] Tile_X1Y0_FrameStrobe[18] Tile_X1Y0_FrameStrobe[19] Tile_X1Y0_FrameStrobe[1]
+ Tile_X1Y0_FrameStrobe[2] Tile_X1Y0_FrameStrobe[3] Tile_X1Y0_FrameStrobe[4] Tile_X1Y0_FrameStrobe[5]
+ Tile_X1Y0_FrameStrobe[6] Tile_X1Y0_FrameStrobe[7] Tile_X1Y0_FrameStrobe[8] Tile_X1Y0_FrameStrobe[9]
+ Tile_X1Y0_FrameStrobe_O[0] Tile_X1Y0_FrameStrobe_O[10] Tile_X1Y0_FrameStrobe_O[11]
+ Tile_X1Y0_FrameStrobe_O[12] Tile_X1Y0_FrameStrobe_O[13] Tile_X1Y0_FrameStrobe_O[14]
+ Tile_X1Y0_FrameStrobe_O[15] Tile_X1Y0_FrameStrobe_O[16] Tile_X1Y0_FrameStrobe_O[17]
+ Tile_X1Y0_FrameStrobe_O[18] Tile_X1Y0_FrameStrobe_O[19] Tile_X1Y0_FrameStrobe_O[1]
+ Tile_X1Y0_FrameStrobe_O[2] Tile_X1Y0_FrameStrobe_O[3] Tile_X1Y0_FrameStrobe_O[4]
+ Tile_X1Y0_FrameStrobe_O[5] Tile_X1Y0_FrameStrobe_O[6] Tile_X1Y0_FrameStrobe_O[7]
+ Tile_X1Y0_FrameStrobe_O[8] Tile_X1Y0_FrameStrobe_O[9] Tile_X1Y0_N1END[0] Tile_X1Y0_N1END[1]
+ Tile_X1Y0_N1END[2] Tile_X1Y0_N1END[3] Tile_X1Y0_N2END[0] Tile_X1Y0_N2END[1] Tile_X1Y0_N2END[2]
+ Tile_X1Y0_N2END[3] Tile_X1Y0_N2END[4] Tile_X1Y0_N2END[5] Tile_X1Y0_N2END[6] Tile_X1Y0_N2END[7]
+ Tile_X1Y0_N2MID[0] Tile_X1Y0_N2MID[1] Tile_X1Y0_N2MID[2] Tile_X1Y0_N2MID[3] Tile_X1Y0_N2MID[4]
+ Tile_X1Y0_N2MID[5] Tile_X1Y0_N2MID[6] Tile_X1Y0_N2MID[7] Tile_X1Y0_N4END[0] Tile_X1Y0_N4END[10]
+ Tile_X1Y0_N4END[11] Tile_X1Y0_N4END[12] Tile_X1Y0_N4END[13] Tile_X1Y0_N4END[14]
+ Tile_X1Y0_N4END[15] Tile_X1Y0_N4END[1] Tile_X1Y0_N4END[2] Tile_X1Y0_N4END[3] Tile_X1Y0_N4END[4]
+ Tile_X1Y0_N4END[5] Tile_X1Y0_N4END[6] Tile_X1Y0_N4END[7] Tile_X1Y0_N4END[8] Tile_X1Y0_N4END[9]
+ Tile_X1Y0_NN4END[0] Tile_X1Y0_NN4END[10] Tile_X1Y0_NN4END[11] Tile_X1Y0_NN4END[12]
+ Tile_X1Y0_NN4END[13] Tile_X1Y0_NN4END[14] Tile_X1Y0_NN4END[15] Tile_X1Y0_NN4END[1]
+ Tile_X1Y0_NN4END[2] Tile_X1Y0_NN4END[3] Tile_X1Y0_NN4END[4] Tile_X1Y0_NN4END[5]
+ Tile_X1Y0_NN4END[6] Tile_X1Y0_NN4END[7] Tile_X1Y0_NN4END[8] Tile_X1Y0_NN4END[9]
+ Tile_X1Y0_S1BEG[0] Tile_X1Y0_S1BEG[1] Tile_X1Y0_S1BEG[2] Tile_X1Y0_S1BEG[3] Tile_X1Y0_S2BEG[0]
+ Tile_X1Y0_S2BEG[1] Tile_X1Y0_S2BEG[2] Tile_X1Y0_S2BEG[3] Tile_X1Y0_S2BEG[4] Tile_X1Y0_S2BEG[5]
+ Tile_X1Y0_S2BEG[6] Tile_X1Y0_S2BEG[7] Tile_X1Y0_S2BEGb[0] Tile_X1Y0_S2BEGb[1] Tile_X1Y0_S2BEGb[2]
+ Tile_X1Y0_S2BEGb[3] Tile_X1Y0_S2BEGb[4] Tile_X1Y0_S2BEGb[5] Tile_X1Y0_S2BEGb[6]
+ Tile_X1Y0_S2BEGb[7] Tile_X1Y0_S4BEG[0] Tile_X1Y0_S4BEG[10] Tile_X1Y0_S4BEG[11] Tile_X1Y0_S4BEG[12]
+ Tile_X1Y0_S4BEG[13] Tile_X1Y0_S4BEG[14] Tile_X1Y0_S4BEG[15] Tile_X1Y0_S4BEG[1] Tile_X1Y0_S4BEG[2]
+ Tile_X1Y0_S4BEG[3] Tile_X1Y0_S4BEG[4] Tile_X1Y0_S4BEG[5] Tile_X1Y0_S4BEG[6] Tile_X1Y0_S4BEG[7]
+ Tile_X1Y0_S4BEG[8] Tile_X1Y0_S4BEG[9] Tile_X1Y0_SS4BEG[0] Tile_X1Y0_SS4BEG[10] Tile_X1Y0_SS4BEG[11]
+ Tile_X1Y0_SS4BEG[12] Tile_X1Y0_SS4BEG[13] Tile_X1Y0_SS4BEG[14] Tile_X1Y0_SS4BEG[15]
+ Tile_X1Y0_SS4BEG[1] Tile_X1Y0_SS4BEG[2] Tile_X1Y0_SS4BEG[3] Tile_X1Y0_SS4BEG[4]
+ Tile_X1Y0_SS4BEG[5] Tile_X1Y0_SS4BEG[6] Tile_X1Y0_SS4BEG[7] Tile_X1Y0_SS4BEG[8]
+ Tile_X1Y0_SS4BEG[9] Tile_X2Y0_Ci Tile_X2Y0_FrameStrobe[0] Tile_X2Y0_FrameStrobe[10]
+ Tile_X2Y0_FrameStrobe[11] Tile_X2Y0_FrameStrobe[12] Tile_X2Y0_FrameStrobe[13] Tile_X2Y0_FrameStrobe[14]
+ Tile_X2Y0_FrameStrobe[15] Tile_X2Y0_FrameStrobe[16] Tile_X2Y0_FrameStrobe[17] Tile_X2Y0_FrameStrobe[18]
+ Tile_X2Y0_FrameStrobe[19] Tile_X2Y0_FrameStrobe[1] Tile_X2Y0_FrameStrobe[2] Tile_X2Y0_FrameStrobe[3]
+ Tile_X2Y0_FrameStrobe[4] Tile_X2Y0_FrameStrobe[5] Tile_X2Y0_FrameStrobe[6] Tile_X2Y0_FrameStrobe[7]
+ Tile_X2Y0_FrameStrobe[8] Tile_X2Y0_FrameStrobe[9] Tile_X2Y0_FrameStrobe_O[0] Tile_X2Y0_FrameStrobe_O[10]
+ Tile_X2Y0_FrameStrobe_O[11] Tile_X2Y0_FrameStrobe_O[12] Tile_X2Y0_FrameStrobe_O[13]
+ Tile_X2Y0_FrameStrobe_O[14] Tile_X2Y0_FrameStrobe_O[15] Tile_X2Y0_FrameStrobe_O[16]
+ Tile_X2Y0_FrameStrobe_O[17] Tile_X2Y0_FrameStrobe_O[18] Tile_X2Y0_FrameStrobe_O[19]
+ Tile_X2Y0_FrameStrobe_O[1] Tile_X2Y0_FrameStrobe_O[2] Tile_X2Y0_FrameStrobe_O[3]
+ Tile_X2Y0_FrameStrobe_O[4] Tile_X2Y0_FrameStrobe_O[5] Tile_X2Y0_FrameStrobe_O[6]
+ Tile_X2Y0_FrameStrobe_O[7] Tile_X2Y0_FrameStrobe_O[8] Tile_X2Y0_FrameStrobe_O[9]
+ Tile_X2Y0_N1END[0] Tile_X2Y0_N1END[1] Tile_X2Y0_N1END[2] Tile_X2Y0_N1END[3] Tile_X2Y0_N2END[0]
+ Tile_X2Y0_N2END[1] Tile_X2Y0_N2END[2] Tile_X2Y0_N2END[3] Tile_X2Y0_N2END[4] Tile_X2Y0_N2END[5]
+ Tile_X2Y0_N2END[6] Tile_X2Y0_N2END[7] Tile_X2Y0_N2MID[0] Tile_X2Y0_N2MID[1] Tile_X2Y0_N2MID[2]
+ Tile_X2Y0_N2MID[3] Tile_X2Y0_N2MID[4] Tile_X2Y0_N2MID[5] Tile_X2Y0_N2MID[6] Tile_X2Y0_N2MID[7]
+ Tile_X2Y0_N4END[0] Tile_X2Y0_N4END[10] Tile_X2Y0_N4END[11] Tile_X2Y0_N4END[12] Tile_X2Y0_N4END[13]
+ Tile_X2Y0_N4END[14] Tile_X2Y0_N4END[15] Tile_X2Y0_N4END[1] Tile_X2Y0_N4END[2] Tile_X2Y0_N4END[3]
+ Tile_X2Y0_N4END[4] Tile_X2Y0_N4END[5] Tile_X2Y0_N4END[6] Tile_X2Y0_N4END[7] Tile_X2Y0_N4END[8]
+ Tile_X2Y0_N4END[9] Tile_X2Y0_NN4END[0] Tile_X2Y0_NN4END[10] Tile_X2Y0_NN4END[11]
+ Tile_X2Y0_NN4END[12] Tile_X2Y0_NN4END[13] Tile_X2Y0_NN4END[14] Tile_X2Y0_NN4END[15]
+ Tile_X2Y0_NN4END[1] Tile_X2Y0_NN4END[2] Tile_X2Y0_NN4END[3] Tile_X2Y0_NN4END[4]
+ Tile_X2Y0_NN4END[5] Tile_X2Y0_NN4END[6] Tile_X2Y0_NN4END[7] Tile_X2Y0_NN4END[8]
+ Tile_X2Y0_NN4END[9] Tile_X2Y0_S1BEG[0] Tile_X2Y0_S1BEG[1] Tile_X2Y0_S1BEG[2] Tile_X2Y0_S1BEG[3]
+ Tile_X2Y0_S2BEG[0] Tile_X2Y0_S2BEG[1] Tile_X2Y0_S2BEG[2] Tile_X2Y0_S2BEG[3] Tile_X2Y0_S2BEG[4]
+ Tile_X2Y0_S2BEG[5] Tile_X2Y0_S2BEG[6] Tile_X2Y0_S2BEG[7] Tile_X2Y0_S2BEGb[0] Tile_X2Y0_S2BEGb[1]
+ Tile_X2Y0_S2BEGb[2] Tile_X2Y0_S2BEGb[3] Tile_X2Y0_S2BEGb[4] Tile_X2Y0_S2BEGb[5]
+ Tile_X2Y0_S2BEGb[6] Tile_X2Y0_S2BEGb[7] Tile_X2Y0_S4BEG[0] Tile_X2Y0_S4BEG[10] Tile_X2Y0_S4BEG[11]
+ Tile_X2Y0_S4BEG[12] Tile_X2Y0_S4BEG[13] Tile_X2Y0_S4BEG[14] Tile_X2Y0_S4BEG[15]
+ Tile_X2Y0_S4BEG[1] Tile_X2Y0_S4BEG[2] Tile_X2Y0_S4BEG[3] Tile_X2Y0_S4BEG[4] Tile_X2Y0_S4BEG[5]
+ Tile_X2Y0_S4BEG[6] Tile_X2Y0_S4BEG[7] Tile_X2Y0_S4BEG[8] Tile_X2Y0_S4BEG[9] Tile_X2Y0_SS4BEG[0]
+ Tile_X2Y0_SS4BEG[10] Tile_X2Y0_SS4BEG[11] Tile_X2Y0_SS4BEG[12] Tile_X2Y0_SS4BEG[13]
+ Tile_X2Y0_SS4BEG[14] Tile_X2Y0_SS4BEG[15] Tile_X2Y0_SS4BEG[1] Tile_X2Y0_SS4BEG[2]
+ Tile_X2Y0_SS4BEG[3] Tile_X2Y0_SS4BEG[4] Tile_X2Y0_SS4BEG[5] Tile_X2Y0_SS4BEG[6]
+ Tile_X2Y0_SS4BEG[7] Tile_X2Y0_SS4BEG[8] Tile_X2Y0_SS4BEG[9] Tile_X3Y0_Ci Tile_X3Y0_FrameStrobe[0]
+ Tile_X3Y0_FrameStrobe[10] Tile_X3Y0_FrameStrobe[11] Tile_X3Y0_FrameStrobe[12] Tile_X3Y0_FrameStrobe[13]
+ Tile_X3Y0_FrameStrobe[14] Tile_X3Y0_FrameStrobe[15] Tile_X3Y0_FrameStrobe[16] Tile_X3Y0_FrameStrobe[17]
+ Tile_X3Y0_FrameStrobe[18] Tile_X3Y0_FrameStrobe[19] Tile_X3Y0_FrameStrobe[1] Tile_X3Y0_FrameStrobe[2]
+ Tile_X3Y0_FrameStrobe[3] Tile_X3Y0_FrameStrobe[4] Tile_X3Y0_FrameStrobe[5] Tile_X3Y0_FrameStrobe[6]
+ Tile_X3Y0_FrameStrobe[7] Tile_X3Y0_FrameStrobe[8] Tile_X3Y0_FrameStrobe[9] Tile_X3Y0_FrameStrobe_O[0]
+ Tile_X3Y0_FrameStrobe_O[10] Tile_X3Y0_FrameStrobe_O[11] Tile_X3Y0_FrameStrobe_O[12]
+ Tile_X3Y0_FrameStrobe_O[13] Tile_X3Y0_FrameStrobe_O[14] Tile_X3Y0_FrameStrobe_O[15]
+ Tile_X3Y0_FrameStrobe_O[16] Tile_X3Y0_FrameStrobe_O[17] Tile_X3Y0_FrameStrobe_O[18]
+ Tile_X3Y0_FrameStrobe_O[19] Tile_X3Y0_FrameStrobe_O[1] Tile_X3Y0_FrameStrobe_O[2]
+ Tile_X3Y0_FrameStrobe_O[3] Tile_X3Y0_FrameStrobe_O[4] Tile_X3Y0_FrameStrobe_O[5]
+ Tile_X3Y0_FrameStrobe_O[6] Tile_X3Y0_FrameStrobe_O[7] Tile_X3Y0_FrameStrobe_O[8]
+ Tile_X3Y0_FrameStrobe_O[9] Tile_X3Y0_N1END[0] Tile_X3Y0_N1END[1] Tile_X3Y0_N1END[2]
+ Tile_X3Y0_N1END[3] Tile_X3Y0_N2END[0] Tile_X3Y0_N2END[1] Tile_X3Y0_N2END[2] Tile_X3Y0_N2END[3]
+ Tile_X3Y0_N2END[4] Tile_X3Y0_N2END[5] Tile_X3Y0_N2END[6] Tile_X3Y0_N2END[7] Tile_X3Y0_N2MID[0]
+ Tile_X3Y0_N2MID[1] Tile_X3Y0_N2MID[2] Tile_X3Y0_N2MID[3] Tile_X3Y0_N2MID[4] Tile_X3Y0_N2MID[5]
+ Tile_X3Y0_N2MID[6] Tile_X3Y0_N2MID[7] Tile_X3Y0_N4END[0] Tile_X3Y0_N4END[10] Tile_X3Y0_N4END[11]
+ Tile_X3Y0_N4END[12] Tile_X3Y0_N4END[13] Tile_X3Y0_N4END[14] Tile_X3Y0_N4END[15]
+ Tile_X3Y0_N4END[1] Tile_X3Y0_N4END[2] Tile_X3Y0_N4END[3] Tile_X3Y0_N4END[4] Tile_X3Y0_N4END[5]
+ Tile_X3Y0_N4END[6] Tile_X3Y0_N4END[7] Tile_X3Y0_N4END[8] Tile_X3Y0_N4END[9] Tile_X3Y0_NN4END[0]
+ Tile_X3Y0_NN4END[10] Tile_X3Y0_NN4END[11] Tile_X3Y0_NN4END[12] Tile_X3Y0_NN4END[13]
+ Tile_X3Y0_NN4END[14] Tile_X3Y0_NN4END[15] Tile_X3Y0_NN4END[1] Tile_X3Y0_NN4END[2]
+ Tile_X3Y0_NN4END[3] Tile_X3Y0_NN4END[4] Tile_X3Y0_NN4END[5] Tile_X3Y0_NN4END[6]
+ Tile_X3Y0_NN4END[7] Tile_X3Y0_NN4END[8] Tile_X3Y0_NN4END[9] Tile_X3Y0_S1BEG[0] Tile_X3Y0_S1BEG[1]
+ Tile_X3Y0_S1BEG[2] Tile_X3Y0_S1BEG[3] Tile_X3Y0_S2BEG[0] Tile_X3Y0_S2BEG[1] Tile_X3Y0_S2BEG[2]
+ Tile_X3Y0_S2BEG[3] Tile_X3Y0_S2BEG[4] Tile_X3Y0_S2BEG[5] Tile_X3Y0_S2BEG[6] Tile_X3Y0_S2BEG[7]
+ Tile_X3Y0_S2BEGb[0] Tile_X3Y0_S2BEGb[1] Tile_X3Y0_S2BEGb[2] Tile_X3Y0_S2BEGb[3]
+ Tile_X3Y0_S2BEGb[4] Tile_X3Y0_S2BEGb[5] Tile_X3Y0_S2BEGb[6] Tile_X3Y0_S2BEGb[7]
+ Tile_X3Y0_S4BEG[0] Tile_X3Y0_S4BEG[10] Tile_X3Y0_S4BEG[11] Tile_X3Y0_S4BEG[12] Tile_X3Y0_S4BEG[13]
+ Tile_X3Y0_S4BEG[14] Tile_X3Y0_S4BEG[15] Tile_X3Y0_S4BEG[1] Tile_X3Y0_S4BEG[2] Tile_X3Y0_S4BEG[3]
+ Tile_X3Y0_S4BEG[4] Tile_X3Y0_S4BEG[5] Tile_X3Y0_S4BEG[6] Tile_X3Y0_S4BEG[7] Tile_X3Y0_S4BEG[8]
+ Tile_X3Y0_S4BEG[9] Tile_X3Y0_SS4BEG[0] Tile_X3Y0_SS4BEG[10] Tile_X3Y0_SS4BEG[11]
+ Tile_X3Y0_SS4BEG[12] Tile_X3Y0_SS4BEG[13] Tile_X3Y0_SS4BEG[14] Tile_X3Y0_SS4BEG[15]
+ Tile_X3Y0_SS4BEG[1] Tile_X3Y0_SS4BEG[2] Tile_X3Y0_SS4BEG[3] Tile_X3Y0_SS4BEG[4]
+ Tile_X3Y0_SS4BEG[5] Tile_X3Y0_SS4BEG[6] Tile_X3Y0_SS4BEG[7] Tile_X3Y0_SS4BEG[8]
+ Tile_X3Y0_SS4BEG[9] Tile_X4Y0_Ci Tile_X4Y0_FrameData_O[0] Tile_X4Y0_FrameData_O[10]
+ Tile_X4Y0_FrameData_O[11] Tile_X4Y0_FrameData_O[12] Tile_X4Y0_FrameData_O[13] Tile_X4Y0_FrameData_O[14]
+ Tile_X4Y0_FrameData_O[15] Tile_X4Y0_FrameData_O[16] Tile_X4Y0_FrameData_O[17] Tile_X4Y0_FrameData_O[18]
+ Tile_X4Y0_FrameData_O[19] Tile_X4Y0_FrameData_O[1] Tile_X4Y0_FrameData_O[20] Tile_X4Y0_FrameData_O[21]
+ Tile_X4Y0_FrameData_O[22] Tile_X4Y0_FrameData_O[23] Tile_X4Y0_FrameData_O[24] Tile_X4Y0_FrameData_O[25]
+ Tile_X4Y0_FrameData_O[26] Tile_X4Y0_FrameData_O[27] Tile_X4Y0_FrameData_O[28] Tile_X4Y0_FrameData_O[29]
+ Tile_X4Y0_FrameData_O[2] Tile_X4Y0_FrameData_O[30] Tile_X4Y0_FrameData_O[31] Tile_X4Y0_FrameData_O[3]
+ Tile_X4Y0_FrameData_O[4] Tile_X4Y0_FrameData_O[5] Tile_X4Y0_FrameData_O[6] Tile_X4Y0_FrameData_O[7]
+ Tile_X4Y0_FrameData_O[8] Tile_X4Y0_FrameData_O[9] Tile_X4Y0_FrameStrobe[0] Tile_X4Y0_FrameStrobe[10]
+ Tile_X4Y0_FrameStrobe[11] Tile_X4Y0_FrameStrobe[12] Tile_X4Y0_FrameStrobe[13] Tile_X4Y0_FrameStrobe[14]
+ Tile_X4Y0_FrameStrobe[15] Tile_X4Y0_FrameStrobe[16] Tile_X4Y0_FrameStrobe[17] Tile_X4Y0_FrameStrobe[18]
+ Tile_X4Y0_FrameStrobe[19] Tile_X4Y0_FrameStrobe[1] Tile_X4Y0_FrameStrobe[2] Tile_X4Y0_FrameStrobe[3]
+ Tile_X4Y0_FrameStrobe[4] Tile_X4Y0_FrameStrobe[5] Tile_X4Y0_FrameStrobe[6] Tile_X4Y0_FrameStrobe[7]
+ Tile_X4Y0_FrameStrobe[8] Tile_X4Y0_FrameStrobe[9] Tile_X4Y0_FrameStrobe_O[0] Tile_X4Y0_FrameStrobe_O[10]
+ Tile_X4Y0_FrameStrobe_O[11] Tile_X4Y0_FrameStrobe_O[12] Tile_X4Y0_FrameStrobe_O[13]
+ Tile_X4Y0_FrameStrobe_O[14] Tile_X4Y0_FrameStrobe_O[15] Tile_X4Y0_FrameStrobe_O[16]
+ Tile_X4Y0_FrameStrobe_O[17] Tile_X4Y0_FrameStrobe_O[18] Tile_X4Y0_FrameStrobe_O[19]
+ Tile_X4Y0_FrameStrobe_O[1] Tile_X4Y0_FrameStrobe_O[2] Tile_X4Y0_FrameStrobe_O[3]
+ Tile_X4Y0_FrameStrobe_O[4] Tile_X4Y0_FrameStrobe_O[5] Tile_X4Y0_FrameStrobe_O[6]
+ Tile_X4Y0_FrameStrobe_O[7] Tile_X4Y0_FrameStrobe_O[8] Tile_X4Y0_FrameStrobe_O[9]
+ Tile_X4Y0_N1END[0] Tile_X4Y0_N1END[1] Tile_X4Y0_N1END[2] Tile_X4Y0_N1END[3] Tile_X4Y0_N2END[0]
+ Tile_X4Y0_N2END[1] Tile_X4Y0_N2END[2] Tile_X4Y0_N2END[3] Tile_X4Y0_N2END[4] Tile_X4Y0_N2END[5]
+ Tile_X4Y0_N2END[6] Tile_X4Y0_N2END[7] Tile_X4Y0_N2MID[0] Tile_X4Y0_N2MID[1] Tile_X4Y0_N2MID[2]
+ Tile_X4Y0_N2MID[3] Tile_X4Y0_N2MID[4] Tile_X4Y0_N2MID[5] Tile_X4Y0_N2MID[6] Tile_X4Y0_N2MID[7]
+ Tile_X4Y0_N4END[0] Tile_X4Y0_N4END[10] Tile_X4Y0_N4END[11] Tile_X4Y0_N4END[12] Tile_X4Y0_N4END[13]
+ Tile_X4Y0_N4END[14] Tile_X4Y0_N4END[15] Tile_X4Y0_N4END[1] Tile_X4Y0_N4END[2] Tile_X4Y0_N4END[3]
+ Tile_X4Y0_N4END[4] Tile_X4Y0_N4END[5] Tile_X4Y0_N4END[6] Tile_X4Y0_N4END[7] Tile_X4Y0_N4END[8]
+ Tile_X4Y0_N4END[9] Tile_X4Y0_NN4END[0] Tile_X4Y0_NN4END[10] Tile_X4Y0_NN4END[11]
+ Tile_X4Y0_NN4END[12] Tile_X4Y0_NN4END[13] Tile_X4Y0_NN4END[14] Tile_X4Y0_NN4END[15]
+ Tile_X4Y0_NN4END[1] Tile_X4Y0_NN4END[2] Tile_X4Y0_NN4END[3] Tile_X4Y0_NN4END[4]
+ Tile_X4Y0_NN4END[5] Tile_X4Y0_NN4END[6] Tile_X4Y0_NN4END[7] Tile_X4Y0_NN4END[8]
+ Tile_X4Y0_NN4END[9] Tile_X4Y0_S1BEG[0] Tile_X4Y0_S1BEG[1] Tile_X4Y0_S1BEG[2] Tile_X4Y0_S1BEG[3]
+ Tile_X4Y0_S2BEG[0] Tile_X4Y0_S2BEG[1] Tile_X4Y0_S2BEG[2] Tile_X4Y0_S2BEG[3] Tile_X4Y0_S2BEG[4]
+ Tile_X4Y0_S2BEG[5] Tile_X4Y0_S2BEG[6] Tile_X4Y0_S2BEG[7] Tile_X4Y0_S2BEGb[0] Tile_X4Y0_S2BEGb[1]
+ Tile_X4Y0_S2BEGb[2] Tile_X4Y0_S2BEGb[3] Tile_X4Y0_S2BEGb[4] Tile_X4Y0_S2BEGb[5]
+ Tile_X4Y0_S2BEGb[6] Tile_X4Y0_S2BEGb[7] Tile_X4Y0_S4BEG[0] Tile_X4Y0_S4BEG[10] Tile_X4Y0_S4BEG[11]
+ Tile_X4Y0_S4BEG[12] Tile_X4Y0_S4BEG[13] Tile_X4Y0_S4BEG[14] Tile_X4Y0_S4BEG[15]
+ Tile_X4Y0_S4BEG[1] Tile_X4Y0_S4BEG[2] Tile_X4Y0_S4BEG[3] Tile_X4Y0_S4BEG[4] Tile_X4Y0_S4BEG[5]
+ Tile_X4Y0_S4BEG[6] Tile_X4Y0_S4BEG[7] Tile_X4Y0_S4BEG[8] Tile_X4Y0_S4BEG[9] Tile_X4Y0_SS4BEG[0]
+ Tile_X4Y0_SS4BEG[10] Tile_X4Y0_SS4BEG[11] Tile_X4Y0_SS4BEG[12] Tile_X4Y0_SS4BEG[13]
+ Tile_X4Y0_SS4BEG[14] Tile_X4Y0_SS4BEG[15] Tile_X4Y0_SS4BEG[1] Tile_X4Y0_SS4BEG[2]
+ Tile_X4Y0_SS4BEG[3] Tile_X4Y0_SS4BEG[4] Tile_X4Y0_SS4BEG[5] Tile_X4Y0_SS4BEG[6]
+ Tile_X4Y0_SS4BEG[7] Tile_X4Y0_SS4BEG[8] Tile_X4Y0_SS4BEG[9] Tile_X4Y0_UserCLKo VGND
+ VPWR
XANTENNA_1360 Tile_X0Y0_FrameData[30] VPWR VGND sg13cmos5l_antennanp
XANTENNA_1371 Tile_X0Y0_FrameData[31] VPWR VGND sg13cmos5l_antennanp
XANTENNA_1382 Tile_X0Y0_FrameData[31] VPWR VGND sg13cmos5l_antennanp
XANTENNA_1393 Tile_X0Y0_FrameData[31] VPWR VGND sg13cmos5l_antennanp
X_0367_ _0367_/Q Tile_X0Y0_FrameData[10] VGND VPWR Tile_X2Y0_FrameStrobe[1] latch
X_0298_ _0298_/Q Tile_X0Y0_FrameData[31] VGND VPWR Tile_X1Y0_FrameStrobe[3] latch
XFILLER_3_1733 VPWR VGND sg13cmos5l_decap_8
XFILLER_11_1042 VPWR VGND sg13cmos5l_fill_1
XFILLER_7_7 VPWR VGND sg13cmos5l_decap_8
XFILLER_11_1086 VPWR VGND sg13cmos5l_fill_2
XFILLER_8_2345 VPWR VGND sg13cmos5l_decap_8
XFILLER_2_549 VPWR VGND sg13cmos5l_decap_8
XFILLER_8_1699 VPWR VGND sg13cmos5l_decap_8
XANTENNA_202 Tile_X0Y0_FrameData[10] VPWR VGND sg13cmos5l_antennanp
XANTENNA_213 Tile_X0Y0_FrameData[10] VPWR VGND sg13cmos5l_antennanp
XANTENNA_224 Tile_X0Y0_FrameData[10] VPWR VGND sg13cmos5l_antennanp
XANTENNA_235 Tile_X0Y0_FrameData[10] VPWR VGND sg13cmos5l_antennanp
XANTENNA_246 Tile_X0Y0_FrameData[10] VPWR VGND sg13cmos5l_antennanp
XANTENNA_257 Tile_X0Y0_FrameData[10] VPWR VGND sg13cmos5l_antennanp
XANTENNA_268 Tile_X0Y0_FrameData[10] VPWR VGND sg13cmos5l_antennanp
XANTENNA_279 Tile_X0Y0_FrameData[10] VPWR VGND sg13cmos5l_antennanp
XFILLER_13_133 VPWR VGND sg13cmos5l_decap_8
XFILLER_14_667 VPWR VGND sg13cmos5l_decap_8
XFILLER_9_126 VPWR VGND sg13cmos5l_decap_8
XFILLER_13_1852 VPWR VGND sg13cmos5l_decap_8
XFILLER_5_376 VPWR VGND sg13cmos5l_fill_2
XANTENNA__0900__X Tile_X2Y0_SS4BEG[1] VPWR VGND sg13cmos5l_antennanp
XFILLER_3_56 VPWR VGND sg13cmos5l_decap_8
X_1270_ _1270_/X Tile_X3Y0_N2MID[3] Tile_X3Y0_N4END[4] Tile_X3Y0_NN4END[11] _0575_/Q
+ _0467_/Q _0466_/Q VPWR VGND sg13cmos5l_mux4_1
XFILLER_7_1143 VPWR VGND sg13cmos5l_decap_8
XFILLER_4_2710 VPWR VGND sg13cmos5l_decap_8
X_0221_ _0221_/Q Tile_X0Y0_FrameData[12] VGND VPWR Tile_X1Y0_FrameStrobe[0] latch
XFILLER_3_1007 VPWR VGND sg13cmos5l_fill_2
X_0152_ _0152_/Q Tile_X0Y0_FrameData[1] VGND VPWR Tile_X0Y0_FrameStrobe[1] latch
X_0083_ _0558_/D _0518_/Q _1090_/X VPWR VGND sg13cmos5l_nor2b_1
XANTENNA_780 Tile_X0Y0_FrameData[26] VPWR VGND sg13cmos5l_antennanp
XFILLER_14_2317 VPWR VGND sg13cmos5l_decap_8
XANTENNA_791 Tile_X0Y0_FrameData[26] VPWR VGND sg13cmos5l_antennanp
X_0985_ Tile_X0Y0_SS4BEG[10] _1165_/X VPWR VGND sg13cmos5l_buf_1
XFILLER_14_1627 VPWR VGND sg13cmos5l_decap_8
XFILLER_9_693 VPWR VGND sg13cmos5l_decap_8
XFILLER_12_2085 VPWR VGND sg13cmos5l_decap_8
XANTENNA__0810__X Tile_X3Y0_SS4BEG[15] VPWR VGND sg13cmos5l_antennanp
XFILLER_9_2654 VPWR VGND sg13cmos5l_decap_8
XFILLER_9_1986 VPWR VGND sg13cmos5l_fill_2
XFILLER_5_2529 VPWR VGND sg13cmos5l_decap_8
XANTENNA_1190 Tile_X0Y0_FrameData[30] VPWR VGND sg13cmos5l_antennanp
X_0419_ _0419_/Q Tile_X0Y0_FrameData[22] VGND VPWR Tile_X3Y0_FrameStrobe[0] latch
XFILLER_3_2264 VPWR VGND sg13cmos5l_decap_8
XFILLER_11_615 VPWR VGND sg13cmos5l_decap_8
XFILLER_13_1115 VPWR VGND sg13cmos5l_decap_8
XFILLER_12_21 VPWR VGND sg13cmos5l_decap_8
XFILLER_11_659 VPWR VGND sg13cmos5l_fill_1
XFILLER_10_2704 VPWR VGND sg13cmos5l_decap_8
XFILLER_10_158 VPWR VGND sg13cmos5l_fill_1
XFILLER_10_147 VPWR VGND sg13cmos5l_decap_8
XANTENNA_3509 Tile_X0Y0_FrameData[8] VPWR VGND sg13cmos5l_antennanp
XFILLER_3_803 VPWR VGND sg13cmos5l_fill_1
XANTENNA_2808 Tile_X0Y0_FrameData[17] VPWR VGND sg13cmos5l_antennanp
XANTENNA__0720__X Tile_X1Y0_S4BEG[5] VPWR VGND sg13cmos5l_antennanp
XANTENNA_2819 Tile_X0Y0_FrameData[17] VPWR VGND sg13cmos5l_antennanp
XFILLER_8_2175 VPWR VGND sg13cmos5l_decap_8
XFILLER_15_2626 VPWR VGND sg13cmos5l_decap_8
XFILLER_15_1958 VPWR VGND sg13cmos5l_decap_8
X_0770_ Tile_X3Y0_S2BEG[7] Tile_X3Y0_N2MID[0] VPWR VGND sg13cmos5l_buf_1
XFILLER_13_2372 VPWR VGND sg13cmos5l_decap_8
XFILLER_6_663 VPWR VGND sg13cmos5l_decap_8
XFILLER_6_674 VPWR VGND sg13cmos5l_fill_1
X_1253_ _1253_/X Tile_X3Y0_N1END[2] Tile_X3Y0_N2MID[2] Tile_X3Y0_N2END[5] _0574_/Q
+ _0501_/Q _0500_/Q VPWR VGND sg13cmos5l_mux4_1
X_0204_ _0204_/Q Tile_X0Y0_FrameData[29] VGND VPWR Tile_X1Y0_FrameStrobe[0] latch
XFILLER_4_2584 VPWR VGND sg13cmos5l_decap_8
XFILLER_4_2562 VPWR VGND sg13cmos5l_decap_8
X_1184_ _1184_/X Tile_X1Y0_N2MID[5] Tile_X1Y0_N4END[10] Tile_X1Y0_NN4END[5] _0593_/Q
+ _0287_/Q _0286_/Q VPWR VGND sg13cmos5l_mux4_1
XFILLER_0_2437 VPWR VGND sg13cmos5l_decap_8
X_0135_ _0135_/Q Tile_X0Y0_FrameData[18] VGND VPWR Tile_X0Y0_FrameStrobe[1] latch
XANTENNA__0805__X Tile_X3Y0_SS4BEG[10] VPWR VGND sg13cmos5l_antennanp
XFILLER_14_2125 VPWR VGND sg13cmos5l_decap_8
XFILLER_14_1413 VPWR VGND sg13cmos5l_decap_8
X_0968_ Tile_X1Y0_FrameStrobe_O[13] Tile_X1Y0_FrameStrobe[13] VPWR VGND sg13cmos5l_buf_1
X_0899_ Tile_X2Y0_SS4BEG[0] _1235_/X VPWR VGND sg13cmos5l_buf_1
XFILLER_9_2484 VPWR VGND sg13cmos5l_decap_8
XFILLER_5_2326 VPWR VGND sg13cmos5l_decap_8
XFILLER_5_1625 VPWR VGND sg13cmos5l_decap_8
XFILLER_16_707 VPWR VGND sg13cmos5l_decap_8
XFILLER_15_217 VPWR VGND sg13cmos5l_decap_4
XANTENNA__0715__X Tile_X1Y0_S4BEG[0] VPWR VGND sg13cmos5l_antennanp
XFILLER_7_405 VPWR VGND sg13cmos5l_fill_2
XFILLER_11_434 VPWR VGND sg13cmos5l_fill_1
XFILLER_7_427 VPWR VGND sg13cmos5l_fill_1
XANTENNA_4007 Tile_X0Y0_FrameData[18] VPWR VGND sg13cmos5l_antennanp
XANTENNA_4018 Tile_X0Y0_FrameData[18] VPWR VGND sg13cmos5l_antennanp
XANTENNA_4029 Tile_X0Y0_N2END[1] VPWR VGND sg13cmos5l_antennanp
XFILLER_10_2534 VPWR VGND sg13cmos5l_decap_4
XANTENNA_3306 Tile_X0Y0_FrameData[20] VPWR VGND sg13cmos5l_antennanp
XANTENNA_3317 Tile_X0Y0_FrameData[20] VPWR VGND sg13cmos5l_antennanp
XANTENNA_3328 Tile_X0Y0_FrameData[20] VPWR VGND sg13cmos5l_antennanp
XFILLER_3_600 VPWR VGND sg13cmos5l_decap_8
XANTENNA_2605 Tile_X0Y0_FrameData[14] VPWR VGND sg13cmos5l_antennanp
XANTENNA_2616 Tile_X0Y0_FrameData[14] VPWR VGND sg13cmos5l_antennanp
XANTENNA_3339 Tile_X0Y0_FrameData[20] VPWR VGND sg13cmos5l_antennanp
XANTENNA_1904 Tile_X0Y0_FrameData[5] VPWR VGND sg13cmos5l_antennanp
XANTENNA_1915 Tile_X0Y0_FrameData[5] VPWR VGND sg13cmos5l_antennanp
XANTENNA_2627 Tile_X0Y0_FrameData[14] VPWR VGND sg13cmos5l_antennanp
XANTENNA_2638 Tile_X0Y0_FrameData[14] VPWR VGND sg13cmos5l_antennanp
XANTENNA_2649 Tile_X0Y0_FrameData[14] VPWR VGND sg13cmos5l_antennanp
XANTENNA_1926 Tile_X0Y0_FrameData[5] VPWR VGND sg13cmos5l_antennanp
XANTENNA_1937 Tile_X0Y0_FrameData[6] VPWR VGND sg13cmos5l_antennanp
XANTENNA_1948 Tile_X0Y0_FrameData[6] VPWR VGND sg13cmos5l_antennanp
XANTENNA_1959 Tile_X0Y0_FrameData[6] VPWR VGND sg13cmos5l_antennanp
XFILLER_1_2713 VPWR VGND sg13cmos5l_decap_8
XFILLER_4_1168 VPWR VGND sg13cmos5l_decap_8
XFILLER_0_35 VPWR VGND sg13cmos5l_decap_8
XFILLER_0_46 VPWR VGND sg13cmos5l_fill_2
XFILLER_15_762 VPWR VGND sg13cmos5l_decap_8
XFILLER_15_2412 VPWR VGND sg13cmos5l_decap_8
XFILLER_9_77 VPWR VGND sg13cmos5l_decap_8
X_0822_ Tile_X4Y0_FrameData_O[11] Tile_X0Y0_FrameData[11] VPWR VGND sg13cmos5l_buf_1
XFILLER_15_2489 VPWR VGND sg13cmos5l_decap_4
XFILLER_15_1766 VPWR VGND sg13cmos5l_decap_8
XFILLER_13_2180 VPWR VGND sg13cmos5l_decap_8
X_0753_ Tile_X1Y0_S2BEG[2] Tile_X1Y0_N2MID[5] VPWR VGND sg13cmos5l_buf_1
XANTENNA_3840 Tile_X0Y0_FrameData[18] VPWR VGND sg13cmos5l_antennanp
X_0684_ _0684_/L_HI VPWR VGND sg13cmos5l_tiehi
XANTENNA_3851 Tile_X0Y0_FrameData[18] VPWR VGND sg13cmos5l_antennanp
XANTENNA_3862 Tile_X0Y0_FrameData[18] VPWR VGND sg13cmos5l_antennanp
XANTENNA_3873 Tile_X0Y0_FrameData[18] VPWR VGND sg13cmos5l_antennanp
XANTENNA_3884 Tile_X0Y0_FrameData[18] VPWR VGND sg13cmos5l_antennanp
XANTENNA_3895 Tile_X0Y0_FrameData[18] VPWR VGND sg13cmos5l_antennanp
XFILLER_6_2613 VPWR VGND sg13cmos5l_decap_8
XFILLER_9_1079 VPWR VGND sg13cmos5l_decap_8
X_1236_ _1236_/X Tile_X2Y0_N2END[1] Tile_X2Y0_N4END[1] Tile_X2Y0_NN4END[14] _0586_/Q
+ _0359_/Q _0358_/Q VPWR VGND sg13cmos5l_mux4_1
XFILLER_4_2381 VPWR VGND sg13cmos5l_decap_8
XFILLER_2_1809 VPWR VGND sg13cmos5l_fill_2
X_1167_ _1167_/X Tile_X0Y0_N2END[4] Tile_X0Y0_N4END[12] Tile_X0Y0_NN4END[3] _0597_/Q
+ _0129_/Q _0128_/Q VPWR VGND sg13cmos5l_mux4_1
XFILLER_0_2256 VPWR VGND sg13cmos5l_decap_8
X_0118_ _0118_/Q Tile_X0Y0_FrameData[3] VGND VPWR Tile_X0Y0_FrameStrobe[0] latch
XFILLER_4_1691 VPWR VGND sg13cmos5l_decap_8
X_1098_ _1098_/X Tile_X1Y0_N4END[2] Tile_X1Y0_N4END[3] Tile_X1Y0_NN4END[0] Tile_X1Y0_NN4END[2]
+ _0229_/Q _0228_/Q VPWR VGND sg13cmos5l_mux4_1
XFILLER_14_1265 VPWR VGND sg13cmos5l_decap_8
XFILLER_5_2101 VPWR VGND sg13cmos5l_fill_1
XFILLER_12_721 VPWR VGND sg13cmos5l_decap_8
XFILLER_10_2331 VPWR VGND sg13cmos5l_decap_8
XANTENNA_3103 Tile_X0Y0_FrameData[19] VPWR VGND sg13cmos5l_antennanp
XANTENNA_3114 Tile_X0Y0_FrameData[19] VPWR VGND sg13cmos5l_antennanp
XANTENNA_3125 Tile_X0Y0_FrameData[19] VPWR VGND sg13cmos5l_antennanp
XANTENNA_3136 Tile_X0Y0_FrameData[19] VPWR VGND sg13cmos5l_antennanp
XANTENNA_2402 Tile_X0Y0_FrameData[11] VPWR VGND sg13cmos5l_antennanp
XANTENNA_2413 Tile_X0Y0_FrameData[11] VPWR VGND sg13cmos5l_antennanp
XANTENNA_2424 Tile_X0Y0_FrameData[12] VPWR VGND sg13cmos5l_antennanp
XANTENNA_3147 Tile_X0Y0_FrameData[19] VPWR VGND sg13cmos5l_antennanp
XANTENNA_3158 Tile_X0Y0_FrameData[19] VPWR VGND sg13cmos5l_antennanp
XANTENNA_3169 Tile_X0Y0_FrameData[19] VPWR VGND sg13cmos5l_antennanp
XFILLER_10_1685 VPWR VGND sg13cmos5l_decap_8
XANTENNA_1701 Tile_X0Y0_FrameData[4] VPWR VGND sg13cmos5l_antennanp
XANTENNA_1712 Tile_X0Y0_FrameData[4] VPWR VGND sg13cmos5l_antennanp
XANTENNA_1723 Tile_X0Y0_FrameData[4] VPWR VGND sg13cmos5l_antennanp
XANTENNA_2435 Tile_X0Y0_FrameData[12] VPWR VGND sg13cmos5l_antennanp
XANTENNA_2446 Tile_X0Y0_FrameData[12] VPWR VGND sg13cmos5l_antennanp
XANTENNA_2457 Tile_X0Y0_FrameData[12] VPWR VGND sg13cmos5l_antennanp
XANTENNA_2468 Tile_X0Y0_FrameData[12] VPWR VGND sg13cmos5l_antennanp
XANTENNA_1734 Tile_X0Y0_FrameData[4] VPWR VGND sg13cmos5l_antennanp
XANTENNA_1745 Tile_X0Y0_FrameData[4] VPWR VGND sg13cmos5l_antennanp
XANTENNA_1756 Tile_X0Y0_FrameData[4] VPWR VGND sg13cmos5l_antennanp
XANTENNA_2479 Tile_X0Y0_FrameData[12] VPWR VGND sg13cmos5l_antennanp
XANTENNA_1767 Tile_X0Y0_FrameData[5] VPWR VGND sg13cmos5l_antennanp
XANTENNA_1778 Tile_X0Y0_FrameData[5] VPWR VGND sg13cmos5l_antennanp
XANTENNA_1789 Tile_X0Y0_FrameData[5] VPWR VGND sg13cmos5l_antennanp
X_1021_ Tile_X0Y0_S2BEG[6] Tile_X0Y0_N2MID[1] VPWR VGND sg13cmos5l_buf_1
XFILLER_1_2598 VPWR VGND sg13cmos5l_decap_8
XFILLER_1_2576 VPWR VGND sg13cmos5l_decap_8
XFILLER_1_1842 VPWR VGND sg13cmos5l_fill_1
XFILLER_1_1886 VPWR VGND sg13cmos5l_fill_2
XFILLER_15_581 VPWR VGND sg13cmos5l_decap_8
XFILLER_15_2275 VPWR VGND sg13cmos5l_decap_8
XFILLER_15_1563 VPWR VGND sg13cmos5l_decap_8
XFILLER_11_2128 VPWR VGND sg13cmos5l_decap_8
X_0805_ Tile_X3Y0_SS4BEG[10] _1285_/X VPWR VGND sg13cmos5l_buf_1
X_0736_ Tile_X1Y0_SS4BEG[5] _1200_/X VPWR VGND sg13cmos5l_buf_1
XANTENNA_3670 Tile_X1Y0_N2END[3] VPWR VGND sg13cmos5l_antennanp
XANTENNA_3681 Tile_X1Y0_N4END[1] VPWR VGND sg13cmos5l_antennanp
XANTENNA_3692 Tile_X1Y0_N4END[1] VPWR VGND sg13cmos5l_antennanp
X_0667_ _0667_/L_HI VPWR VGND sg13cmos5l_tiehi
XANTENNA_2980 Tile_X0Y0_FrameData[19] VPWR VGND sg13cmos5l_antennanp
X_0598_ _0598_/Q Tile_X0Y0_UserCLK NPU_RDATA26 _0614_/L_HI VPWR VGND sg13cmos5l_dfrbpq_1
XANTENNA_2991 Tile_X0Y0_FrameData[19] VPWR VGND sg13cmos5l_antennanp
XFILLER_6_2465 VPWR VGND sg13cmos5l_decap_8
XFILLER_6_1720 VPWR VGND sg13cmos5l_decap_8
X_1219_ _1219_/X Tile_X2Y0_N2MID[0] Tile_X2Y0_N4END[15] Tile_X2Y0_NN4END[0] _0586_/Q
+ _0393_/Q _0392_/Q VPWR VGND sg13cmos5l_mux4_1
XFILLER_2_1639 VPWR VGND sg13cmos5l_decap_8
XANTENNA_609 Tile_X0Y0_FrameData[23] VPWR VGND sg13cmos5l_antennanp
XFILLER_16_1316 VPWR VGND sg13cmos5l_decap_8
XFILLER_14_1073 VPWR VGND sg13cmos5l_fill_2
XFILLER_14_1062 VPWR VGND sg13cmos5l_decap_8
XFILLER_11_2695 VPWR VGND sg13cmos5l_decap_8
XFILLER_1_901 VPWR VGND sg13cmos5l_fill_1
XANTENNA_1008 Tile_X0Y0_FrameData[28] VPWR VGND sg13cmos5l_antennanp
XFILLER_7_2207 VPWR VGND sg13cmos5l_decap_8
XANTENNA_1019 Tile_X0Y0_FrameData[28] VPWR VGND sg13cmos5l_antennanp
XFILLER_8_522 VPWR VGND sg13cmos5l_decap_8
XANTENNA__0903__X Tile_X2Y0_SS4BEG[4] VPWR VGND sg13cmos5l_antennanp
XFILLER_16_1861 VPWR VGND sg13cmos5l_decap_8
XFILLER_8_577 VPWR VGND sg13cmos5l_decap_8
XFILLER_12_1747 VPWR VGND sg13cmos5l_decap_8
XFILLER_6_56 VPWR VGND sg13cmos5l_decap_8
XANTENNA_5 NPU_RDATA11 VPWR VGND sg13cmos5l_antennanp
X_0521_ NPU_READ_BANK_SEL0 Tile_X0Y0_UserCLK _1128_/X _0631_/L_HI VPWR VGND sg13cmos5l_dfrbpq_1
XANTENNA_2210 Tile_X0Y0_FrameData[9] VPWR VGND sg13cmos5l_antennanp
XANTENNA_2221 Tile_X0Y0_FrameData[9] VPWR VGND sg13cmos5l_antennanp
XANTENNA_2232 Tile_X0Y0_FrameData[9] VPWR VGND sg13cmos5l_antennanp
XANTENNA_2243 Tile_X0Y0_FrameData[9] VPWR VGND sg13cmos5l_antennanp
XANTENNA_1520 Tile_X0Y0_FrameData[3] VPWR VGND sg13cmos5l_antennanp
XANTENNA_1531 Tile_X0Y0_FrameData[3] VPWR VGND sg13cmos5l_antennanp
XANTENNA_2254 Tile_X0Y0_FrameData[9] VPWR VGND sg13cmos5l_antennanp
XANTENNA_2265 Tile_X0Y0_FrameData[9] VPWR VGND sg13cmos5l_antennanp
XANTENNA_2276 Tile_X0Y0_FrameData[9] VPWR VGND sg13cmos5l_antennanp
X_0452_ _0452_/Q Tile_X0Y0_FrameData[21] VGND VPWR Tile_X3Y0_FrameStrobe[1] latch
XANTENNA_1542 Tile_X0Y0_FrameData[3] VPWR VGND sg13cmos5l_antennanp
XANTENNA_1553 Tile_X0Y0_FrameData[3] VPWR VGND sg13cmos5l_antennanp
XANTENNA_1564 Tile_X0Y0_FrameData[3] VPWR VGND sg13cmos5l_antennanp
XANTENNA_2287 Tile_X0Y0_N2END[3] VPWR VGND sg13cmos5l_antennanp
XANTENNA_2298 Tile_X0Y0_N4END[0] VPWR VGND sg13cmos5l_antennanp
X_0383_ _0383_/Q Tile_X0Y0_FrameData[26] VGND VPWR Tile_X2Y0_FrameStrobe[2] latch
XFILLER_7_2763 VPWR VGND sg13cmos5l_decap_8
XFILLER_3_2605 VPWR VGND sg13cmos5l_decap_8
XANTENNA_1575 Tile_X0Y0_FrameData[3] VPWR VGND sg13cmos5l_antennanp
XANTENNA_1586 Tile_X0Y0_FrameData[3] VPWR VGND sg13cmos5l_antennanp
XANTENNA_1597 Tile_X0Y0_FrameData[4] VPWR VGND sg13cmos5l_antennanp
XFILLER_1_2340 VPWR VGND sg13cmos5l_fill_2
XFILLER_1_2351 VPWR VGND sg13cmos5l_decap_8
X_1004_ Tile_X0Y0_S4BEG[13] _1152_/X VPWR VGND sg13cmos5l_buf_1
XFILLER_1_2395 VPWR VGND sg13cmos5l_fill_1
XFILLER_1_2384 VPWR VGND sg13cmos5l_decap_8
XFILLER_1_1683 VPWR VGND sg13cmos5l_decap_8
XFILLER_15_2072 VPWR VGND sg13cmos5l_decap_8
XANTENNA__0813__X Tile_X4Y0_FrameData_O[2] VPWR VGND sg13cmos5l_antennanp
XFILLER_15_1393 VPWR VGND sg13cmos5l_fill_1
XFILLER_11_1224 VPWR VGND sg13cmos5l_decap_8
X_0719_ Tile_X1Y0_S4BEG[4] _1183_/X VPWR VGND sg13cmos5l_buf_1
XFILLER_8_1837 VPWR VGND sg13cmos5l_fill_1
XANTENNA_406 Tile_X0Y0_FrameData[22] VPWR VGND sg13cmos5l_antennanp
XANTENNA_417 Tile_X0Y0_FrameData[22] VPWR VGND sg13cmos5l_antennanp
XANTENNA_428 Tile_X0Y0_FrameData[23] VPWR VGND sg13cmos5l_antennanp
XANTENNA_439 Tile_X0Y0_FrameData[23] VPWR VGND sg13cmos5l_antennanp
XFILLER_15_21 VPWR VGND sg13cmos5l_decap_8
XFILLER_15_98 VPWR VGND sg13cmos5l_decap_8
XFILLER_13_2713 VPWR VGND sg13cmos5l_decap_8
XANTENNA__0723__X Tile_X1Y0_S4BEG[8] VPWR VGND sg13cmos5l_antennanp
XFILLER_5_536 VPWR VGND sg13cmos5l_decap_8
XFILLER_11_2492 VPWR VGND sg13cmos5l_decap_8
XFILLER_1_720 VPWR VGND sg13cmos5l_fill_2
XFILLER_2_2671 VPWR VGND sg13cmos5l_decap_4
XFILLER_2_2693 VPWR VGND sg13cmos5l_decap_8
XFILLER_16_164 VPWR VGND sg13cmos5l_decap_8
XANTENNA_962 Tile_X0Y0_FrameData[28] VPWR VGND sg13cmos5l_antennanp
XANTENNA_951 Tile_X0Y0_FrameData[28] VPWR VGND sg13cmos5l_antennanp
XANTENNA_940 Tile_X0Y0_FrameData[28] VPWR VGND sg13cmos5l_antennanp
XANTENNA_995 Tile_X0Y0_FrameData[28] VPWR VGND sg13cmos5l_antennanp
XANTENNA_984 Tile_X0Y0_FrameData[28] VPWR VGND sg13cmos5l_antennanp
XANTENNA_973 Tile_X0Y0_FrameData[28] VPWR VGND sg13cmos5l_antennanp
XFILLER_16_2381 VPWR VGND sg13cmos5l_decap_8
XFILLER_14_1809 VPWR VGND sg13cmos5l_decap_8
XFILLER_8_363 VPWR VGND sg13cmos5l_fill_2
XFILLER_16_1680 VPWR VGND sg13cmos5l_decap_8
XFILLER_12_2267 VPWR VGND sg13cmos5l_decap_8
XFILLER_12_1544 VPWR VGND sg13cmos5l_decap_8
XANTENNA_2040 Tile_X0Y0_FrameData[6] VPWR VGND sg13cmos5l_antennanp
XANTENNA_2051 Tile_X0Y0_FrameData[6] VPWR VGND sg13cmos5l_antennanp
X_0504_ _0504_/Q Tile_X0Y0_FrameData[1] VGND VPWR Tile_X3Y0_FrameStrobe[2] latch
XANTENNA_2062 Tile_X0Y0_FrameData[6] VPWR VGND sg13cmos5l_antennanp
XANTENNA_2073 Tile_X0Y0_FrameData[6] VPWR VGND sg13cmos5l_antennanp
XANTENNA_2084 Tile_X0Y0_FrameData[6] VPWR VGND sg13cmos5l_antennanp
X_0435_ _0435_/Q Tile_X0Y0_FrameData[6] VGND VPWR Tile_X3Y0_FrameStrobe[0] latch
XANTENNA_1350 Tile_X0Y0_FrameData[30] VPWR VGND sg13cmos5l_antennanp
XANTENNA_1361 Tile_X0Y0_FrameData[30] VPWR VGND sg13cmos5l_antennanp
XANTENNA_1372 Tile_X0Y0_FrameData[31] VPWR VGND sg13cmos5l_antennanp
XANTENNA_2095 Tile_X0Y0_FrameData[6] VPWR VGND sg13cmos5l_antennanp
XANTENNA_1383 Tile_X0Y0_FrameData[31] VPWR VGND sg13cmos5l_antennanp
XANTENNA_1394 Tile_X0Y0_FrameData[31] VPWR VGND sg13cmos5l_antennanp
X_0366_ _0366_/Q Tile_X0Y0_FrameData[11] VGND VPWR Tile_X2Y0_FrameStrobe[1] latch
XFILLER_3_2435 VPWR VGND sg13cmos5l_fill_1
XFILLER_3_1712 VPWR VGND sg13cmos5l_decap_8
XFILLER_11_0 VPWR VGND sg13cmos5l_decap_8
X_0297_ _0297_/Q Tile_X0Y0_FrameData[0] VGND VPWR Tile_X1Y0_FrameStrobe[2] latch
XANTENNA__0808__X Tile_X3Y0_SS4BEG[13] VPWR VGND sg13cmos5l_antennanp
XFILLER_13_1308 VPWR VGND sg13cmos5l_fill_2
XFILLER_11_1065 VPWR VGND sg13cmos5l_decap_8
XFILLER_11_1098 VPWR VGND sg13cmos5l_decap_8
XFILLER_8_2324 VPWR VGND sg13cmos5l_decap_8
XFILLER_8_1612 VPWR VGND sg13cmos5l_decap_8
XFILLER_8_1678 VPWR VGND sg13cmos5l_decap_8
XANTENNA__0718__X Tile_X1Y0_S4BEG[3] VPWR VGND sg13cmos5l_antennanp
XANTENNA_203 Tile_X0Y0_FrameData[10] VPWR VGND sg13cmos5l_antennanp
XANTENNA_214 Tile_X0Y0_FrameData[10] VPWR VGND sg13cmos5l_antennanp
XANTENNA_225 Tile_X0Y0_FrameData[10] VPWR VGND sg13cmos5l_antennanp
XFILLER_2_1244 VPWR VGND sg13cmos5l_fill_2
XANTENNA_236 Tile_X0Y0_FrameData[10] VPWR VGND sg13cmos5l_antennanp
XANTENNA_247 Tile_X0Y0_FrameData[10] VPWR VGND sg13cmos5l_antennanp
XANTENNA_258 Tile_X0Y0_FrameData[10] VPWR VGND sg13cmos5l_antennanp
XANTENNA_269 Tile_X0Y0_FrameData[10] VPWR VGND sg13cmos5l_antennanp
XFILLER_14_646 VPWR VGND sg13cmos5l_decap_8
XFILLER_13_112 VPWR VGND sg13cmos5l_decap_8
XFILLER_9_105 VPWR VGND sg13cmos5l_decap_8
XFILLER_13_189 VPWR VGND sg13cmos5l_decap_8
XFILLER_13_2587 VPWR VGND sg13cmos5l_decap_8
XFILLER_13_1831 VPWR VGND sg13cmos5l_decap_8
XFILLER_3_35 VPWR VGND sg13cmos5l_decap_8
XFILLER_7_1122 VPWR VGND sg13cmos5l_decap_8
XFILLER_1_583 VPWR VGND sg13cmos5l_decap_8
X_0220_ _0220_/Q Tile_X0Y0_FrameData[13] VGND VPWR Tile_X1Y0_FrameStrobe[0] latch
X_0151_ _0151_/Q Tile_X0Y0_FrameData[2] VGND VPWR Tile_X0Y0_FrameStrobe[1] latch
XFILLER_7_1199 VPWR VGND sg13cmos5l_decap_8
XFILLER_4_2799 VPWR VGND sg13cmos5l_fill_1
XFILLER_3_1019 VPWR VGND sg13cmos5l_fill_2
XANTENNA_781 Tile_X0Y0_FrameData[26] VPWR VGND sg13cmos5l_antennanp
XANTENNA_770 Tile_X0Y0_FrameData[26] VPWR VGND sg13cmos5l_antennanp
XANTENNA_792 Tile_X0Y0_FrameData[26] VPWR VGND sg13cmos5l_antennanp
XFILLER_14_1606 VPWR VGND sg13cmos5l_decap_8
X_0984_ Tile_X0Y0_SS4BEG[9] _1164_/X VPWR VGND sg13cmos5l_buf_1
XFILLER_12_2042 VPWR VGND sg13cmos5l_fill_1
XFILLER_9_672 VPWR VGND sg13cmos5l_decap_8
XFILLER_12_2064 VPWR VGND sg13cmos5l_decap_8
XFILLER_12_1385 VPWR VGND sg13cmos5l_fill_2
XFILLER_9_2633 VPWR VGND sg13cmos5l_decap_8
XFILLER_5_2508 VPWR VGND sg13cmos5l_decap_8
XANTENNA_1180 Tile_X0Y0_FrameData[30] VPWR VGND sg13cmos5l_antennanp
XANTENNA_1191 Tile_X0Y0_FrameData[30] VPWR VGND sg13cmos5l_antennanp
X_0418_ _0418_/Q Tile_X0Y0_FrameData[23] VGND VPWR Tile_X3Y0_FrameStrobe[0] latch
XFILLER_3_2210 VPWR VGND sg13cmos5l_fill_1
X_0349_ _0349_/Q Tile_X0Y0_FrameData[28] VGND VPWR Tile_X2Y0_FrameStrobe[1] latch
XFILLER_3_2243 VPWR VGND sg13cmos5l_decap_8
XFILLER_7_609 VPWR VGND sg13cmos5l_decap_8
XFILLER_10_126 VPWR VGND sg13cmos5l_decap_8
XFILLER_12_77 VPWR VGND sg13cmos5l_decap_8
XFILLER_12_99 VPWR VGND sg13cmos5l_decap_8
XANTENNA_2809 Tile_X0Y0_FrameData[17] VPWR VGND sg13cmos5l_antennanp
XFILLER_8_2154 VPWR VGND sg13cmos5l_decap_8
XFILLER_8_2132 VPWR VGND sg13cmos5l_fill_2
XFILLER_2_358 VPWR VGND sg13cmos5l_fill_1
XFILLER_8_1420 VPWR VGND sg13cmos5l_fill_2
XFILLER_15_977 VPWR VGND sg13cmos5l_fill_2
XFILLER_15_2605 VPWR VGND sg13cmos5l_decap_8
XFILLER_15_1937 VPWR VGND sg13cmos5l_decap_8
XFILLER_13_2351 VPWR VGND sg13cmos5l_decap_8
XFILLER_6_642 VPWR VGND sg13cmos5l_decap_8
XFILLER_10_682 VPWR VGND sg13cmos5l_decap_8
XANTENNA__0911__X Tile_X2Y0_SS4BEG[12] VPWR VGND sg13cmos5l_antennanp
X_1252_ _1252_/X Tile_X3Y0_N1END[1] Tile_X3Y0_N2MID[1] Tile_X3Y0_N2END[6] _0573_/Q
+ _0503_/Q _0502_/Q VPWR VGND sg13cmos5l_mux4_1
XFILLER_4_2541 VPWR VGND sg13cmos5l_decap_8
X_0203_ _0203_/Q Tile_X0Y0_FrameData[30] VGND VPWR Tile_X1Y0_FrameStrobe[0] latch
X_1183_ _1183_/X Tile_X1Y0_N2MID[4] Tile_X1Y0_N4END[11] Tile_X1Y0_NN4END[4] _0592_/Q
+ _0289_/Q _0288_/Q VPWR VGND sg13cmos5l_mux4_1
XFILLER_0_2416 VPWR VGND sg13cmos5l_decap_8
X_0134_ _0134_/Q Tile_X0Y0_FrameData[19] VGND VPWR Tile_X0Y0_FrameStrobe[1] latch
XFILLER_0_1748 VPWR VGND sg13cmos5l_decap_8
XFILLER_14_2104 VPWR VGND sg13cmos5l_decap_8
X_0967_ Tile_X1Y0_FrameStrobe_O[12] Tile_X1Y0_FrameStrobe[12] VPWR VGND sg13cmos5l_buf_1
XANTENNA__0821__X Tile_X4Y0_FrameData_O[10] VPWR VGND sg13cmos5l_antennanp
X_0898_ Tile_X2Y0_S4BEG[15] _1234_/X VPWR VGND sg13cmos5l_buf_1
XFILLER_12_1182 VPWR VGND sg13cmos5l_decap_8
XFILLER_0_829 VPWR VGND sg13cmos5l_fill_1
XFILLER_9_2463 VPWR VGND sg13cmos5l_decap_8
XFILLER_5_2305 VPWR VGND sg13cmos5l_decap_8
XFILLER_9_1762 VPWR VGND sg13cmos5l_fill_1
XFILLER_9_1795 VPWR VGND sg13cmos5l_decap_8
XFILLER_10_2513 VPWR VGND sg13cmos5l_decap_8
XANTENNA_4008 Tile_X0Y0_FrameData[18] VPWR VGND sg13cmos5l_antennanp
XANTENNA_4019 Tile_X0Y0_FrameData[18] VPWR VGND sg13cmos5l_antennanp
XFILLER_14_2693 VPWR VGND sg13cmos5l_decap_8
XANTENNA__0731__X Tile_X1Y0_SS4BEG[0] VPWR VGND sg13cmos5l_antennanp
XANTENNA_3307 Tile_X0Y0_FrameData[20] VPWR VGND sg13cmos5l_antennanp
XANTENNA_3318 Tile_X0Y0_FrameData[20] VPWR VGND sg13cmos5l_antennanp
XANTENNA_2606 Tile_X0Y0_FrameData[14] VPWR VGND sg13cmos5l_antennanp
XANTENNA_2617 Tile_X0Y0_FrameData[14] VPWR VGND sg13cmos5l_antennanp
XANTENNA_3329 Tile_X0Y0_FrameData[20] VPWR VGND sg13cmos5l_antennanp
XFILLER_3_623 VPWR VGND sg13cmos5l_fill_1
XANTENNA_1905 Tile_X0Y0_FrameData[5] VPWR VGND sg13cmos5l_antennanp
XANTENNA_2628 Tile_X0Y0_FrameData[14] VPWR VGND sg13cmos5l_antennanp
XANTENNA_2639 Tile_X0Y0_FrameData[14] VPWR VGND sg13cmos5l_antennanp
XANTENNA_1916 Tile_X0Y0_FrameData[5] VPWR VGND sg13cmos5l_antennanp
XANTENNA_1927 Tile_X0Y0_FrameData[5] VPWR VGND sg13cmos5l_antennanp
XANTENNA_1938 Tile_X0Y0_FrameData[6] VPWR VGND sg13cmos5l_antennanp
XANTENNA_1949 Tile_X0Y0_FrameData[6] VPWR VGND sg13cmos5l_antennanp
XFILLER_4_1147 VPWR VGND sg13cmos5l_decap_8
XFILLER_0_14 VPWR VGND sg13cmos5l_decap_8
XFILLER_1_2769 VPWR VGND sg13cmos5l_fill_1
XANTENNA__0906__X Tile_X2Y0_SS4BEG[7] VPWR VGND sg13cmos5l_antennanp
XFILLER_15_741 VPWR VGND sg13cmos5l_decap_8
XFILLER_9_56 VPWR VGND sg13cmos5l_decap_8
XFILLER_15_2468 VPWR VGND sg13cmos5l_decap_8
X_0821_ Tile_X4Y0_FrameData_O[10] Tile_X0Y0_FrameData[10] VPWR VGND sg13cmos5l_buf_1
XFILLER_15_1745 VPWR VGND sg13cmos5l_decap_8
X_0752_ Tile_X1Y0_S2BEG[1] Tile_X1Y0_N2MID[6] VPWR VGND sg13cmos5l_buf_1
XFILLER_7_962 VPWR VGND sg13cmos5l_fill_2
XFILLER_10_490 VPWR VGND sg13cmos5l_fill_1
XANTENNA_3830 Tile_X0Y0_FrameData[18] VPWR VGND sg13cmos5l_antennanp
XANTENNA_3841 Tile_X0Y0_FrameData[18] VPWR VGND sg13cmos5l_antennanp
X_0683_ _0683_/L_HI VPWR VGND sg13cmos5l_tiehi
XANTENNA_3852 Tile_X0Y0_FrameData[18] VPWR VGND sg13cmos5l_antennanp
XANTENNA_3863 Tile_X0Y0_FrameData[18] VPWR VGND sg13cmos5l_antennanp
XANTENNA_3874 Tile_X0Y0_FrameData[18] VPWR VGND sg13cmos5l_antennanp
XANTENNA_3885 Tile_X0Y0_FrameData[18] VPWR VGND sg13cmos5l_antennanp
XANTENNA_3896 Tile_X0Y0_FrameData[18] VPWR VGND sg13cmos5l_antennanp
XFILLER_6_2669 VPWR VGND sg13cmos5l_decap_8
X_1235_ _1235_/X Tile_X2Y0_N2END[0] Tile_X2Y0_N4END[0] Tile_X2Y0_NN4END[15] _0587_/Q
+ _0361_/Q _0360_/Q VPWR VGND sg13cmos5l_mux4_1
XFILLER_4_2360 VPWR VGND sg13cmos5l_decap_8
X_1166_ _1166_/X Tile_X0Y0_N2END[3] Tile_X0Y0_N4END[11] Tile_X0Y0_NN4END[4] _0598_/Q
+ _0131_/Q _0130_/Q VPWR VGND sg13cmos5l_mux4_1
XFILLER_4_1670 VPWR VGND sg13cmos5l_decap_8
X_0117_ _0117_/Q Tile_X0Y0_FrameData[4] VGND VPWR Tile_X0Y0_FrameStrobe[0] latch
XANTENNA__0816__X Tile_X4Y0_FrameData_O[5] VPWR VGND sg13cmos5l_antennanp
X_1097_ _1097_/X Tile_X1Y0_N4END[1] Tile_X1Y0_N4END[2] Tile_X1Y0_NN4END[1] Tile_X1Y0_NN4END[3]
+ _0231_/Q _0230_/Q VPWR VGND sg13cmos5l_mux4_1
XFILLER_14_1244 VPWR VGND sg13cmos5l_decap_8
XFILLER_9_2260 VPWR VGND sg13cmos5l_fill_1
XANTENNA__0726__X Tile_X1Y0_S4BEG[11] VPWR VGND sg13cmos5l_antennanp
XFILLER_16_2711 VPWR VGND sg13cmos5l_decap_8
XFILLER_12_700 VPWR VGND sg13cmos5l_decap_8
XFILLER_12_777 VPWR VGND sg13cmos5l_decap_8
XFILLER_12_2619 VPWR VGND sg13cmos5l_decap_8
XFILLER_10_2310 VPWR VGND sg13cmos5l_decap_8
XANTENNA_3104 Tile_X0Y0_FrameData[19] VPWR VGND sg13cmos5l_antennanp
XANTENNA_3115 Tile_X0Y0_FrameData[19] VPWR VGND sg13cmos5l_antennanp
XANTENNA_3126 Tile_X0Y0_FrameData[19] VPWR VGND sg13cmos5l_antennanp
XFILLER_10_2387 VPWR VGND sg13cmos5l_decap_8
XANTENNA_2403 Tile_X0Y0_FrameData[11] VPWR VGND sg13cmos5l_antennanp
XANTENNA_2414 Tile_X0Y0_FrameData[11] VPWR VGND sg13cmos5l_antennanp
XANTENNA_2425 Tile_X0Y0_FrameData[12] VPWR VGND sg13cmos5l_antennanp
XANTENNA_3137 Tile_X0Y0_FrameData[19] VPWR VGND sg13cmos5l_antennanp
XANTENNA_3148 Tile_X0Y0_FrameData[19] VPWR VGND sg13cmos5l_antennanp
XANTENNA_3159 Tile_X0Y0_FrameData[19] VPWR VGND sg13cmos5l_antennanp
XFILLER_3_453 VPWR VGND sg13cmos5l_fill_2
XFILLER_10_1664 VPWR VGND sg13cmos5l_decap_8
XANTENNA_1702 Tile_X0Y0_FrameData[4] VPWR VGND sg13cmos5l_antennanp
XANTENNA_1713 Tile_X0Y0_FrameData[4] VPWR VGND sg13cmos5l_antennanp
XANTENNA_2436 Tile_X0Y0_FrameData[12] VPWR VGND sg13cmos5l_antennanp
XANTENNA_2447 Tile_X0Y0_FrameData[12] VPWR VGND sg13cmos5l_antennanp
XANTENNA_2458 Tile_X0Y0_FrameData[12] VPWR VGND sg13cmos5l_antennanp
XANTENNA_1724 Tile_X0Y0_FrameData[4] VPWR VGND sg13cmos5l_antennanp
XANTENNA_1735 Tile_X0Y0_FrameData[4] VPWR VGND sg13cmos5l_antennanp
XANTENNA_1746 Tile_X0Y0_FrameData[4] VPWR VGND sg13cmos5l_antennanp
XANTENNA_1757 Tile_X0Y0_FrameData[4] VPWR VGND sg13cmos5l_antennanp
XANTENNA_2469 Tile_X0Y0_FrameData[12] VPWR VGND sg13cmos5l_antennanp
XANTENNA_1768 Tile_X0Y0_FrameData[5] VPWR VGND sg13cmos5l_antennanp
XANTENNA_1779 Tile_X0Y0_FrameData[5] VPWR VGND sg13cmos5l_antennanp
XFILLER_15_7 VPWR VGND sg13cmos5l_decap_8
X_1020_ Tile_X0Y0_S2BEG[5] Tile_X0Y0_N2MID[2] VPWR VGND sg13cmos5l_buf_1
XFILLER_1_1821 VPWR VGND sg13cmos5l_fill_2
XFILLER_1_2566 VPWR VGND sg13cmos5l_decap_4
XFILLER_15_560 VPWR VGND sg13cmos5l_decap_8
XFILLER_15_2254 VPWR VGND sg13cmos5l_decap_8
XFILLER_11_2107 VPWR VGND sg13cmos5l_decap_8
X_0804_ Tile_X3Y0_SS4BEG[9] _1284_/X VPWR VGND sg13cmos5l_buf_1
XFILLER_15_1542 VPWR VGND sg13cmos5l_decap_8
X_0735_ Tile_X1Y0_SS4BEG[4] _1199_/X VPWR VGND sg13cmos5l_buf_1
X_0666_ _0666_/L_HI VPWR VGND sg13cmos5l_tiehi
XANTENNA_3660 Tile_X1Y0_N1END[0] VPWR VGND sg13cmos5l_antennanp
XANTENNA_3671 Tile_X1Y0_N2END[3] VPWR VGND sg13cmos5l_antennanp
XANTENNA_3682 Tile_X1Y0_N4END[1] VPWR VGND sg13cmos5l_antennanp
XANTENNA_2970 Tile_X0Y0_FrameData[19] VPWR VGND sg13cmos5l_antennanp
XANTENNA_2981 Tile_X0Y0_FrameData[19] VPWR VGND sg13cmos5l_antennanp
XANTENNA_3693 Tile_X1Y0_N4END[1] VPWR VGND sg13cmos5l_antennanp
X_0597_ _0597_/Q Tile_X0Y0_UserCLK NPU_RDATA25 _0613_/L_HI VPWR VGND sg13cmos5l_dfrbpq_1
XFILLER_6_2444 VPWR VGND sg13cmos5l_decap_8
XANTENNA_2992 Tile_X0Y0_FrameData[19] VPWR VGND sg13cmos5l_antennanp
X_1218_ _1218_/X Tile_X2Y0_N1END[3] Tile_X2Y0_N2MID[7] Tile_X2Y0_N2END[0] _0587_/Q
+ _0395_/Q _0394_/Q VPWR VGND sg13cmos5l_mux4_1
XFILLER_6_1776 VPWR VGND sg13cmos5l_decap_8
X_1149_ _1149_/X Tile_X0Y0_N2MID[2] Tile_X0Y0_N4END[5] Tile_X0Y0_NN4END[10] _0598_/Q
+ _0165_/Q _0164_/Q VPWR VGND sg13cmos5l_mux4_1
XFILLER_16_2029 VPWR VGND sg13cmos5l_decap_8
XFILLER_0_1375 VPWR VGND sg13cmos5l_fill_2
XFILLER_14_1096 VPWR VGND sg13cmos5l_decap_4
XFILLER_11_2674 VPWR VGND sg13cmos5l_decap_8
XANTENNA_1009 Tile_X0Y0_FrameData[28] VPWR VGND sg13cmos5l_antennanp
XFILLER_0_489 VPWR VGND sg13cmos5l_fill_1
XFILLER_8_501 VPWR VGND sg13cmos5l_decap_8
XFILLER_16_2563 VPWR VGND sg13cmos5l_decap_8
XFILLER_16_1840 VPWR VGND sg13cmos5l_decap_8
XFILLER_12_585 VPWR VGND sg13cmos5l_decap_8
XFILLER_12_2449 VPWR VGND sg13cmos5l_decap_8
XFILLER_8_556 VPWR VGND sg13cmos5l_decap_8
XFILLER_12_1726 VPWR VGND sg13cmos5l_decap_8
XFILLER_6_35 VPWR VGND sg13cmos5l_decap_8
XANTENNA_6 NPU_RDATA11 VPWR VGND sg13cmos5l_antennanp
XANTENNA_2200 Tile_X0Y0_FrameData[9] VPWR VGND sg13cmos5l_antennanp
X_0520_ _0520_/Q Tile_X0Y0_FrameData[25] VGND VPWR Tile_X4Y0_FrameStrobe[0] latch
XFILLER_10_2184 VPWR VGND sg13cmos5l_decap_8
XANTENNA_2211 Tile_X0Y0_FrameData[9] VPWR VGND sg13cmos5l_antennanp
XANTENNA_2222 Tile_X0Y0_FrameData[9] VPWR VGND sg13cmos5l_antennanp
XANTENNA_2233 Tile_X0Y0_FrameData[9] VPWR VGND sg13cmos5l_antennanp
XANTENNA_1510 Tile_X0Y0_FrameData[3] VPWR VGND sg13cmos5l_antennanp
XANTENNA_1521 Tile_X0Y0_FrameData[3] VPWR VGND sg13cmos5l_antennanp
XANTENNA_2244 Tile_X0Y0_FrameData[9] VPWR VGND sg13cmos5l_antennanp
XANTENNA_2255 Tile_X0Y0_FrameData[9] VPWR VGND sg13cmos5l_antennanp
XANTENNA_2266 Tile_X0Y0_FrameData[9] VPWR VGND sg13cmos5l_antennanp
X_0451_ _0451_/Q Tile_X0Y0_FrameData[22] VGND VPWR Tile_X3Y0_FrameStrobe[1] latch
XFILLER_7_2742 VPWR VGND sg13cmos5l_decap_8
XANTENNA_1532 Tile_X0Y0_FrameData[3] VPWR VGND sg13cmos5l_antennanp
XANTENNA_1543 Tile_X0Y0_FrameData[3] VPWR VGND sg13cmos5l_antennanp
XANTENNA_1554 Tile_X0Y0_FrameData[3] VPWR VGND sg13cmos5l_antennanp
XANTENNA_1565 Tile_X0Y0_FrameData[3] VPWR VGND sg13cmos5l_antennanp
XANTENNA_2277 Tile_X0Y0_FrameData[9] VPWR VGND sg13cmos5l_antennanp
XANTENNA_2288 Tile_X0Y0_N2END[3] VPWR VGND sg13cmos5l_antennanp
XANTENNA_2299 Tile_X0Y0_N4END[0] VPWR VGND sg13cmos5l_antennanp
X_0382_ _0382_/Q Tile_X0Y0_FrameData[27] VGND VPWR Tile_X2Y0_FrameStrobe[2] latch
XANTENNA_1576 Tile_X0Y0_FrameData[3] VPWR VGND sg13cmos5l_antennanp
XANTENNA_1587 Tile_X0Y0_FrameData[3] VPWR VGND sg13cmos5l_antennanp
XANTENNA_1598 Tile_X0Y0_FrameData[4] VPWR VGND sg13cmos5l_antennanp
X_1003_ Tile_X0Y0_S4BEG[12] _1151_/X VPWR VGND sg13cmos5l_buf_1
XFILLER_1_1662 VPWR VGND sg13cmos5l_decap_4
XFILLER_15_2051 VPWR VGND sg13cmos5l_decap_8
XFILLER_11_1203 VPWR VGND sg13cmos5l_decap_8
X_0718_ Tile_X1Y0_S4BEG[3] _1182_/X VPWR VGND sg13cmos5l_buf_1
XFILLER_8_2506 VPWR VGND sg13cmos5l_decap_8
XANTENNA_3490 Tile_X0Y0_FrameData[8] VPWR VGND sg13cmos5l_antennanp
X_0649_ _0649_/L_HI VPWR VGND sg13cmos5l_tiehi
XFILLER_8_1805 VPWR VGND sg13cmos5l_decap_4
XFILLER_6_2285 VPWR VGND sg13cmos5l_decap_8
XANTENNA_407 Tile_X0Y0_FrameData[22] VPWR VGND sg13cmos5l_antennanp
XFILLER_2_1426 VPWR VGND sg13cmos5l_fill_1
XANTENNA_418 Tile_X0Y0_FrameData[22] VPWR VGND sg13cmos5l_antennanp
XANTENNA_429 Tile_X0Y0_FrameData[23] VPWR VGND sg13cmos5l_antennanp
XFILLER_16_1103 VPWR VGND sg13cmos5l_fill_1
XFILLER_15_77 VPWR VGND sg13cmos5l_decap_8
XFILLER_11_2471 VPWR VGND sg13cmos5l_decap_8
XFILLER_11_1781 VPWR VGND sg13cmos5l_decap_8
XFILLER_7_1337 VPWR VGND sg13cmos5l_fill_1
XFILLER_2_2650 VPWR VGND sg13cmos5l_decap_8
XANTENNA_930 Tile_X0Y0_FrameData[28] VPWR VGND sg13cmos5l_antennanp
XFILLER_16_143 VPWR VGND sg13cmos5l_decap_8
XANTENNA_963 Tile_X0Y0_FrameData[28] VPWR VGND sg13cmos5l_antennanp
XANTENNA_952 Tile_X0Y0_FrameData[28] VPWR VGND sg13cmos5l_antennanp
XANTENNA_941 Tile_X0Y0_FrameData[28] VPWR VGND sg13cmos5l_antennanp
XANTENNA__0914__X Tile_X2Y0_SS4BEG[15] VPWR VGND sg13cmos5l_antennanp
XANTENNA_996 Tile_X0Y0_FrameData[28] VPWR VGND sg13cmos5l_antennanp
XANTENNA_985 Tile_X0Y0_FrameData[28] VPWR VGND sg13cmos5l_antennanp
XANTENNA_974 Tile_X0Y0_FrameData[28] VPWR VGND sg13cmos5l_antennanp
XFILLER_16_2360 VPWR VGND sg13cmos5l_decap_8
XFILLER_12_2246 VPWR VGND sg13cmos5l_decap_8
XFILLER_8_375 VPWR VGND sg13cmos5l_fill_1
XFILLER_12_1523 VPWR VGND sg13cmos5l_decap_8
XANTENNA_2030 Tile_X0Y0_FrameData[6] VPWR VGND sg13cmos5l_antennanp
XANTENNA_2041 Tile_X0Y0_FrameData[6] VPWR VGND sg13cmos5l_antennanp
X_0503_ _0503_/Q Tile_X0Y0_FrameData[2] VGND VPWR Tile_X3Y0_FrameStrobe[2] latch
XANTENNA_1340 Tile_X0Y0_FrameData[30] VPWR VGND sg13cmos5l_antennanp
XANTENNA_2052 Tile_X0Y0_FrameData[6] VPWR VGND sg13cmos5l_antennanp
XANTENNA_2063 Tile_X0Y0_FrameData[6] VPWR VGND sg13cmos5l_antennanp
XANTENNA_2074 Tile_X0Y0_FrameData[6] VPWR VGND sg13cmos5l_antennanp
X_0434_ _0434_/Q Tile_X0Y0_FrameData[7] VGND VPWR Tile_X3Y0_FrameStrobe[0] latch
XANTENNA_1351 Tile_X0Y0_FrameData[30] VPWR VGND sg13cmos5l_antennanp
XANTENNA_1362 Tile_X0Y0_FrameData[30] VPWR VGND sg13cmos5l_antennanp
XANTENNA_1373 Tile_X0Y0_FrameData[31] VPWR VGND sg13cmos5l_antennanp
XANTENNA_2085 Tile_X0Y0_FrameData[6] VPWR VGND sg13cmos5l_antennanp
XANTENNA_2096 Tile_X0Y0_FrameData[6] VPWR VGND sg13cmos5l_antennanp
XANTENNA_1384 Tile_X0Y0_FrameData[31] VPWR VGND sg13cmos5l_antennanp
XANTENNA_1395 Tile_X0Y0_FrameData[31] VPWR VGND sg13cmos5l_antennanp
X_0365_ _0365_/Q Tile_X0Y0_FrameData[12] VGND VPWR Tile_X2Y0_FrameStrobe[1] latch
XFILLER_3_2447 VPWR VGND sg13cmos5l_decap_8
X_0296_ _0296_/Q Tile_X0Y0_FrameData[1] VGND VPWR Tile_X1Y0_FrameStrobe[2] latch
XFILLER_3_1768 VPWR VGND sg13cmos5l_decap_8
XANTENNA__0824__X Tile_X4Y0_FrameData_O[13] VPWR VGND sg13cmos5l_antennanp
XFILLER_8_2303 VPWR VGND sg13cmos5l_decap_8
XFILLER_8_1624 VPWR VGND sg13cmos5l_decap_8
XFILLER_8_1657 VPWR VGND sg13cmos5l_decap_8
XANTENNA_204 Tile_X0Y0_FrameData[10] VPWR VGND sg13cmos5l_antennanp
XANTENNA_215 Tile_X0Y0_FrameData[10] VPWR VGND sg13cmos5l_antennanp
XANTENNA_226 Tile_X0Y0_FrameData[10] VPWR VGND sg13cmos5l_antennanp
XANTENNA_237 Tile_X0Y0_FrameData[10] VPWR VGND sg13cmos5l_antennanp
XANTENNA_248 Tile_X0Y0_FrameData[10] VPWR VGND sg13cmos5l_antennanp
XANTENNA_259 Tile_X0Y0_FrameData[10] VPWR VGND sg13cmos5l_antennanp
XFILLER_14_625 VPWR VGND sg13cmos5l_decap_8
XANTENNA__0734__X Tile_X1Y0_SS4BEG[3] VPWR VGND sg13cmos5l_antennanp
XFILLER_13_168 VPWR VGND sg13cmos5l_decap_8
XFILLER_13_1810 VPWR VGND sg13cmos5l_decap_8
XFILLER_7_1101 VPWR VGND sg13cmos5l_decap_8
XFILLER_3_14 VPWR VGND sg13cmos5l_decap_8
XFILLER_1_562 VPWR VGND sg13cmos5l_decap_8
XFILLER_7_1178 VPWR VGND sg13cmos5l_decap_8
XFILLER_4_2756 VPWR VGND sg13cmos5l_fill_1
XFILLER_4_2745 VPWR VGND sg13cmos5l_decap_8
XANTENNA__0909__X Tile_X2Y0_SS4BEG[10] VPWR VGND sg13cmos5l_antennanp
X_0150_ _0150_/Q Tile_X0Y0_FrameData[3] VGND VPWR Tile_X0Y0_FrameStrobe[1] latch
XANTENNA_771 Tile_X0Y0_FrameData[26] VPWR VGND sg13cmos5l_antennanp
XANTENNA_760 Tile_X0Y0_FrameData[25] VPWR VGND sg13cmos5l_antennanp
XANTENNA_793 Tile_X0Y0_FrameData[26] VPWR VGND sg13cmos5l_antennanp
XANTENNA_782 Tile_X0Y0_FrameData[26] VPWR VGND sg13cmos5l_antennanp
X_0983_ Tile_X0Y0_SS4BEG[8] _1163_/X VPWR VGND sg13cmos5l_buf_1
XFILLER_9_651 VPWR VGND sg13cmos5l_decap_8
XFILLER_9_2612 VPWR VGND sg13cmos5l_decap_8
XFILLER_9_2689 VPWR VGND sg13cmos5l_decap_8
XANTENNA_1170 Tile_X0Y0_FrameData[30] VPWR VGND sg13cmos5l_antennanp
XANTENNA_1181 Tile_X0Y0_FrameData[30] VPWR VGND sg13cmos5l_antennanp
X_0417_ _0417_/Q Tile_X0Y0_FrameData[24] VGND VPWR Tile_X3Y0_FrameStrobe[0] latch
XFILLER_7_2380 VPWR VGND sg13cmos5l_decap_8
XFILLER_3_2222 VPWR VGND sg13cmos5l_decap_8
XANTENNA__0819__X Tile_X4Y0_FrameData_O[8] VPWR VGND sg13cmos5l_antennanp
XANTENNA_1192 Tile_X0Y0_FrameData[30] VPWR VGND sg13cmos5l_antennanp
X_0348_ _0348_/Q Tile_X0Y0_FrameData[29] VGND VPWR Tile_X2Y0_FrameStrobe[1] latch
XFILLER_3_2299 VPWR VGND sg13cmos5l_decap_4
X_0279_ _0279_/Q Tile_X0Y0_FrameData[18] VGND VPWR Tile_X1Y0_FrameStrobe[2] latch
XFILLER_10_105 VPWR VGND sg13cmos5l_decap_8
XFILLER_10_2739 VPWR VGND sg13cmos5l_decap_8
XFILLER_12_56 VPWR VGND sg13cmos5l_decap_8
XFILLER_3_838 VPWR VGND sg13cmos5l_fill_2
XANTENNA__0729__X Tile_X1Y0_S4BEG[14] VPWR VGND sg13cmos5l_antennanp
XFILLER_2_1053 VPWR VGND sg13cmos5l_fill_2
XFILLER_13_2330 VPWR VGND sg13cmos5l_decap_8
XFILLER_6_621 VPWR VGND sg13cmos5l_decap_8
XFILLER_13_1684 VPWR VGND sg13cmos5l_decap_8
XFILLER_5_197 VPWR VGND sg13cmos5l_fill_2
XFILLER_9_1218 VPWR VGND sg13cmos5l_decap_8
X_1251_ _1251_/X Tile_X3Y0_N1END[0] Tile_X3Y0_N2MID[0] Tile_X3Y0_N2END[7] _0572_/Q
+ _0505_/Q _0504_/Q VPWR VGND sg13cmos5l_mux4_1
XFILLER_4_2520 VPWR VGND sg13cmos5l_decap_8
X_0202_ _0202_/Q Tile_X0Y0_FrameData[31] VGND VPWR Tile_X0Y0_FrameStrobe[0] latch
X_1182_ _1182_/X Tile_X1Y0_N2MID[3] Tile_X1Y0_N4END[12] Tile_X1Y0_NN4END[3] _0595_/Q
+ _0291_/Q _0290_/Q VPWR VGND sg13cmos5l_mux4_1
X_0133_ _0133_/Q Tile_X0Y0_FrameData[20] VGND VPWR Tile_X0Y0_FrameStrobe[1] latch
XFILLER_0_1727 VPWR VGND sg13cmos5l_decap_8
XANTENNA_590 Tile_X0Y0_FrameData[23] VPWR VGND sg13cmos5l_antennanp
X_0966_ Tile_X1Y0_FrameStrobe_O[11] Tile_X1Y0_FrameStrobe[11] VPWR VGND sg13cmos5l_buf_1
XFILLER_9_492 VPWR VGND sg13cmos5l_decap_8
XFILLER_14_1459 VPWR VGND sg13cmos5l_decap_8
X_0897_ Tile_X2Y0_S4BEG[14] _1233_/X VPWR VGND sg13cmos5l_buf_1
XFILLER_12_1161 VPWR VGND sg13cmos5l_decap_8
XFILLER_9_2442 VPWR VGND sg13cmos5l_decap_8
XFILLER_9_1774 VPWR VGND sg13cmos5l_decap_8
XFILLER_14_2672 VPWR VGND sg13cmos5l_decap_8
XANTENNA_4009 Tile_X0Y0_FrameData[18] VPWR VGND sg13cmos5l_antennanp
XANTENNA_3308 Tile_X0Y0_FrameData[20] VPWR VGND sg13cmos5l_antennanp
XANTENNA_3319 Tile_X0Y0_FrameData[20] VPWR VGND sg13cmos5l_antennanp
XFILLER_10_1813 VPWR VGND sg13cmos5l_decap_8
XANTENNA_2607 Tile_X0Y0_FrameData[14] VPWR VGND sg13cmos5l_antennanp
XANTENNA_1906 Tile_X0Y0_FrameData[5] VPWR VGND sg13cmos5l_antennanp
XANTENNA_2618 Tile_X0Y0_FrameData[14] VPWR VGND sg13cmos5l_antennanp
XANTENNA_2629 Tile_X0Y0_FrameData[14] VPWR VGND sg13cmos5l_antennanp
XANTENNA_1917 Tile_X0Y0_FrameData[5] VPWR VGND sg13cmos5l_antennanp
XANTENNA_1928 Tile_X0Y0_FrameData[5] VPWR VGND sg13cmos5l_antennanp
XANTENNA_1939 Tile_X0Y0_FrameData[6] VPWR VGND sg13cmos5l_antennanp
XFILLER_4_1126 VPWR VGND sg13cmos5l_decap_8
XFILLER_1_2704 VPWR VGND sg13cmos5l_fill_2
XFILLER_1_2748 VPWR VGND sg13cmos5l_decap_4
XFILLER_15_720 VPWR VGND sg13cmos5l_decap_8
XFILLER_9_35 VPWR VGND sg13cmos5l_decap_8
XFILLER_15_797 VPWR VGND sg13cmos5l_decap_8
XFILLER_15_2447 VPWR VGND sg13cmos5l_decap_8
XFILLER_15_1724 VPWR VGND sg13cmos5l_decap_8
X_0820_ Tile_X4Y0_FrameData_O[9] Tile_X0Y0_FrameData[9] VPWR VGND sg13cmos5l_buf_1
XANTENNA__0922__X Tile_X3Y0_FrameStrobe_O[7] VPWR VGND sg13cmos5l_antennanp
X_0751_ Tile_X1Y0_S2BEG[0] Tile_X1Y0_N2MID[7] VPWR VGND sg13cmos5l_buf_1
XFILLER_13_1481 VPWR VGND sg13cmos5l_decap_8
XANTENNA_3820 Tile_X0Y0_FrameData[18] VPWR VGND sg13cmos5l_antennanp
XANTENNA_3831 Tile_X0Y0_FrameData[18] VPWR VGND sg13cmos5l_antennanp
X_0682_ _0682_/L_HI VPWR VGND sg13cmos5l_tiehi
XANTENNA_3842 Tile_X0Y0_FrameData[18] VPWR VGND sg13cmos5l_antennanp
XANTENNA_3853 Tile_X0Y0_FrameData[18] VPWR VGND sg13cmos5l_antennanp
XANTENNA_3864 Tile_X0Y0_FrameData[18] VPWR VGND sg13cmos5l_antennanp
XANTENNA_3875 Tile_X0Y0_FrameData[18] VPWR VGND sg13cmos5l_antennanp
XANTENNA_3886 Tile_X0Y0_FrameData[18] VPWR VGND sg13cmos5l_antennanp
XANTENNA_3897 Tile_X0Y0_FrameData[18] VPWR VGND sg13cmos5l_antennanp
XFILLER_6_2648 VPWR VGND sg13cmos5l_decap_8
X_1234_ _1234_/X Tile_X2Y0_N2MID[7] Tile_X2Y0_N4END[0] Tile_X2Y0_NN4END[15] _0581_/Q
+ _0363_/Q _0362_/Q VPWR VGND sg13cmos5l_mux4_1
X_1165_ _1165_/X Tile_X0Y0_N2END[2] Tile_X0Y0_N4END[10] Tile_X0Y0_NN4END[5] _0599_/Q
+ _0133_/Q _0132_/Q VPWR VGND sg13cmos5l_mux4_1
XFILLER_0_2236 VPWR VGND sg13cmos5l_fill_2
X_0116_ _0116_/Q Tile_X0Y0_FrameData[5] VGND VPWR Tile_X0Y0_FrameStrobe[0] latch
X_1096_ _1096_/X Tile_X1Y0_N4END[0] Tile_X1Y0_N4END[1] Tile_X1Y0_NN4END[0] Tile_X1Y0_NN4END[2]
+ _0233_/Q _0232_/Q VPWR VGND sg13cmos5l_mux4_1
XFILLER_14_1223 VPWR VGND sg13cmos5l_decap_8
XFILLER_11_2801 VPWR VGND sg13cmos5l_fill_2
XANTENNA__0832__X Tile_X4Y0_FrameData_O[21] VPWR VGND sg13cmos5l_antennanp
X_0949_ Tile_X2Y0_FrameStrobe_O[14] Tile_X2Y0_FrameStrobe[14] VPWR VGND sg13cmos5l_buf_1
XFILLER_12_756 VPWR VGND sg13cmos5l_decap_8
XANTENNA__0742__X Tile_X1Y0_SS4BEG[11] VPWR VGND sg13cmos5l_antennanp
XFILLER_14_2491 VPWR VGND sg13cmos5l_decap_8
XANTENNA_3105 Tile_X0Y0_FrameData[19] VPWR VGND sg13cmos5l_antennanp
XANTENNA_3116 Tile_X0Y0_FrameData[19] VPWR VGND sg13cmos5l_antennanp
XANTENNA_3127 Tile_X0Y0_FrameData[19] VPWR VGND sg13cmos5l_antennanp
XFILLER_10_2366 VPWR VGND sg13cmos5l_decap_8
XFILLER_10_1643 VPWR VGND sg13cmos5l_decap_8
XANTENNA_2404 Tile_X0Y0_FrameData[11] VPWR VGND sg13cmos5l_antennanp
XANTENNA_2415 Tile_X0Y0_FrameData[11] VPWR VGND sg13cmos5l_antennanp
XANTENNA_3138 Tile_X0Y0_FrameData[19] VPWR VGND sg13cmos5l_antennanp
XANTENNA_3149 Tile_X0Y0_FrameData[19] VPWR VGND sg13cmos5l_antennanp
XANTENNA_1703 Tile_X0Y0_FrameData[4] VPWR VGND sg13cmos5l_antennanp
XANTENNA_1714 Tile_X0Y0_FrameData[4] VPWR VGND sg13cmos5l_antennanp
XANTENNA_2426 Tile_X0Y0_FrameData[12] VPWR VGND sg13cmos5l_antennanp
XANTENNA_2437 Tile_X0Y0_FrameData[12] VPWR VGND sg13cmos5l_antennanp
XANTENNA_2448 Tile_X0Y0_FrameData[12] VPWR VGND sg13cmos5l_antennanp
XANTENNA_2459 Tile_X0Y0_FrameData[12] VPWR VGND sg13cmos5l_antennanp
XFILLER_1_0 VPWR VGND sg13cmos5l_decap_8
XANTENNA_1725 Tile_X0Y0_FrameData[4] VPWR VGND sg13cmos5l_antennanp
XANTENNA_1736 Tile_X0Y0_FrameData[4] VPWR VGND sg13cmos5l_antennanp
XANTENNA_1747 Tile_X0Y0_FrameData[4] VPWR VGND sg13cmos5l_antennanp
XANTENNA_1758 Tile_X0Y0_FrameData[4] VPWR VGND sg13cmos5l_antennanp
XANTENNA_1769 Tile_X0Y0_FrameData[5] VPWR VGND sg13cmos5l_antennanp
XFILLER_8_1081 VPWR VGND sg13cmos5l_decap_8
XFILLER_1_2534 VPWR VGND sg13cmos5l_decap_8
XANTENNA__0917__X Tile_X3Y0_FrameStrobe_O[2] VPWR VGND sg13cmos5l_antennanp
XFILLER_15_2233 VPWR VGND sg13cmos5l_decap_8
XFILLER_15_1521 VPWR VGND sg13cmos5l_decap_8
X_0803_ Tile_X3Y0_SS4BEG[8] _1283_/X VPWR VGND sg13cmos5l_buf_1
XFILLER_15_1598 VPWR VGND sg13cmos5l_decap_8
X_0734_ Tile_X1Y0_SS4BEG[3] _1198_/X VPWR VGND sg13cmos5l_buf_1
X_0665_ _0665_/L_HI VPWR VGND sg13cmos5l_tiehi
XANTENNA_3650 Tile_X0Y0_N4END[2] VPWR VGND sg13cmos5l_antennanp
XANTENNA_3661 Tile_X1Y0_N1END[0] VPWR VGND sg13cmos5l_antennanp
XANTENNA_3672 Tile_X1Y0_N2END[3] VPWR VGND sg13cmos5l_antennanp
XANTENNA_3683 Tile_X1Y0_N4END[1] VPWR VGND sg13cmos5l_antennanp
XANTENNA_2960 Tile_X0Y0_FrameData[19] VPWR VGND sg13cmos5l_antennanp
XANTENNA_2971 Tile_X0Y0_FrameData[19] VPWR VGND sg13cmos5l_antennanp
XANTENNA_3694 Tile_X1Y0_N4END[1] VPWR VGND sg13cmos5l_antennanp
X_0596_ _0596_/Q Tile_X0Y0_UserCLK NPU_RDATA24 _0612_/L_HI VPWR VGND sg13cmos5l_dfrbpq_1
XFILLER_6_2423 VPWR VGND sg13cmos5l_decap_8
XANTENNA_2982 Tile_X0Y0_FrameData[19] VPWR VGND sg13cmos5l_antennanp
XANTENNA_2993 Tile_X0Y0_FrameData[19] VPWR VGND sg13cmos5l_antennanp
XFILLER_6_1755 VPWR VGND sg13cmos5l_decap_8
X_1217_ _1217_/X Tile_X2Y0_N1END[2] Tile_X2Y0_N2MID[6] Tile_X2Y0_N2END[1] _0586_/Q
+ _0397_/Q _0396_/Q VPWR VGND sg13cmos5l_mux4_1
XFILLER_4_2191 VPWR VGND sg13cmos5l_fill_2
XANTENNA__0827__X Tile_X4Y0_FrameData_O[16] VPWR VGND sg13cmos5l_antennanp
X_1148_ _1148_/X Tile_X0Y0_N2MID[1] Tile_X0Y0_N4END[6] Tile_X0Y0_NN4END[9] _0599_/Q
+ _0167_/Q _0166_/Q VPWR VGND sg13cmos5l_mux4_1
X_1079_ Tile_X4Y0_UserCLKo Tile_X0Y0_UserCLK VPWR VGND sg13cmos5l_buf_1
XFILLER_11_2653 VPWR VGND sg13cmos5l_decap_8
XFILLER_11_1985 VPWR VGND sg13cmos5l_fill_1
XFILLER_1_936 VPWR VGND sg13cmos5l_fill_1
XFILLER_0_446 VPWR VGND sg13cmos5l_fill_1
XANTENNA__0737__X Tile_X1Y0_SS4BEG[6] VPWR VGND sg13cmos5l_antennanp
XFILLER_16_2542 VPWR VGND sg13cmos5l_decap_8
XFILLER_12_564 VPWR VGND sg13cmos5l_decap_8
XFILLER_8_535 VPWR VGND sg13cmos5l_decap_8
XFILLER_12_2428 VPWR VGND sg13cmos5l_decap_8
XFILLER_12_1705 VPWR VGND sg13cmos5l_decap_8
XFILLER_6_14 VPWR VGND sg13cmos5l_decap_8
XFILLER_16_1896 VPWR VGND sg13cmos5l_decap_8
XFILLER_10_2163 VPWR VGND sg13cmos5l_decap_8
XANTENNA_7 NPU_RDATA12 VPWR VGND sg13cmos5l_antennanp
XFILLER_4_730 VPWR VGND sg13cmos5l_fill_2
XANTENNA_2201 Tile_X0Y0_FrameData[9] VPWR VGND sg13cmos5l_antennanp
XANTENNA_2212 Tile_X0Y0_FrameData[9] VPWR VGND sg13cmos5l_antennanp
XANTENNA_2223 Tile_X0Y0_FrameData[9] VPWR VGND sg13cmos5l_antennanp
X_0450_ _0450_/Q Tile_X0Y0_FrameData[23] VGND VPWR Tile_X3Y0_FrameStrobe[1] latch
XFILLER_3_240 VPWR VGND sg13cmos5l_fill_2
XANTENNA_1500 Tile_X0Y0_FrameData[3] VPWR VGND sg13cmos5l_antennanp
XANTENNA_1511 Tile_X0Y0_FrameData[3] VPWR VGND sg13cmos5l_antennanp
XANTENNA_1522 Tile_X0Y0_FrameData[3] VPWR VGND sg13cmos5l_antennanp
XANTENNA_2234 Tile_X0Y0_FrameData[9] VPWR VGND sg13cmos5l_antennanp
XANTENNA_2245 Tile_X0Y0_FrameData[9] VPWR VGND sg13cmos5l_antennanp
XANTENNA_2256 Tile_X0Y0_FrameData[9] VPWR VGND sg13cmos5l_antennanp
XANTENNA_2267 Tile_X0Y0_FrameData[9] VPWR VGND sg13cmos5l_antennanp
XFILLER_7_2721 VPWR VGND sg13cmos5l_decap_8
XANTENNA_1533 Tile_X0Y0_FrameData[3] VPWR VGND sg13cmos5l_antennanp
XANTENNA_1544 Tile_X0Y0_FrameData[3] VPWR VGND sg13cmos5l_antennanp
XANTENNA_1555 Tile_X0Y0_FrameData[3] VPWR VGND sg13cmos5l_antennanp
XANTENNA_2278 Tile_X0Y0_FrameData[9] VPWR VGND sg13cmos5l_antennanp
XANTENNA_2289 Tile_X0Y0_N2END[3] VPWR VGND sg13cmos5l_antennanp
X_0381_ _0381_/Q Tile_X0Y0_FrameData[28] VGND VPWR Tile_X2Y0_FrameStrobe[2] latch
XANTENNA_1566 Tile_X0Y0_FrameData[3] VPWR VGND sg13cmos5l_antennanp
XANTENNA_1577 Tile_X0Y0_FrameData[3] VPWR VGND sg13cmos5l_antennanp
XANTENNA_1588 Tile_X0Y0_FrameData[3] VPWR VGND sg13cmos5l_antennanp
XANTENNA_1599 Tile_X0Y0_FrameData[4] VPWR VGND sg13cmos5l_antennanp
X_1002_ Tile_X0Y0_S4BEG[11] _1150_/X VPWR VGND sg13cmos5l_buf_1
XFILLER_15_2030 VPWR VGND sg13cmos5l_decap_8
XFILLER_15_1351 VPWR VGND sg13cmos5l_fill_1
X_0717_ Tile_X1Y0_S4BEG[2] _1181_/X VPWR VGND sg13cmos5l_buf_1
XFILLER_11_1259 VPWR VGND sg13cmos5l_decap_8
XANTENNA_3480 Tile_X0Y0_FrameData[8] VPWR VGND sg13cmos5l_antennanp
XANTENNA_3491 Tile_X0Y0_FrameData[8] VPWR VGND sg13cmos5l_antennanp
X_0648_ _0648_/L_HI VPWR VGND sg13cmos5l_tiehi
X_0579_ _0579_/Q Tile_X0Y0_UserCLK NPU_RDATA7 _0642_/L_HI VPWR VGND sg13cmos5l_dfrbpq_1
XANTENNA_2790 Tile_X0Y0_FrameData[16] VPWR VGND sg13cmos5l_antennanp
XFILLER_6_2264 VPWR VGND sg13cmos5l_decap_8
XFILLER_6_1541 VPWR VGND sg13cmos5l_fill_1
XANTENNA_408 Tile_X0Y0_FrameData[22] VPWR VGND sg13cmos5l_antennanp
XANTENNA_419 Tile_X0Y0_FrameData[22] VPWR VGND sg13cmos5l_antennanp
XFILLER_15_56 VPWR VGND sg13cmos5l_decap_8
XFILLER_16_1126 VPWR VGND sg13cmos5l_decap_8
XFILLER_16_1148 VPWR VGND sg13cmos5l_fill_2
XFILLER_13_2748 VPWR VGND sg13cmos5l_decap_4
XFILLER_11_2450 VPWR VGND sg13cmos5l_decap_8
XFILLER_11_1760 VPWR VGND sg13cmos5l_decap_8
XFILLER_2_2640 VPWR VGND sg13cmos5l_fill_1
XANTENNA_920 Tile_X0Y0_FrameData[27] VPWR VGND sg13cmos5l_antennanp
XANTENNA_953 Tile_X0Y0_FrameData[28] VPWR VGND sg13cmos5l_antennanp
XANTENNA_942 Tile_X0Y0_FrameData[28] VPWR VGND sg13cmos5l_antennanp
XANTENNA_931 Tile_X0Y0_FrameData[28] VPWR VGND sg13cmos5l_antennanp
XFILLER_16_199 VPWR VGND sg13cmos5l_decap_8
XANTENNA_997 Tile_X0Y0_FrameData[28] VPWR VGND sg13cmos5l_antennanp
XANTENNA_986 Tile_X0Y0_FrameData[28] VPWR VGND sg13cmos5l_antennanp
XANTENNA_975 Tile_X0Y0_FrameData[28] VPWR VGND sg13cmos5l_antennanp
XANTENNA_964 Tile_X0Y0_FrameData[28] VPWR VGND sg13cmos5l_antennanp
XFILLER_12_2225 VPWR VGND sg13cmos5l_decap_8
XFILLER_12_1502 VPWR VGND sg13cmos5l_decap_8
XANTENNA__0930__X Tile_X3Y0_FrameStrobe_O[15] VPWR VGND sg13cmos5l_antennanp
XFILLER_12_1579 VPWR VGND sg13cmos5l_decap_8
XANTENNA_2020 Tile_X0Y0_FrameData[6] VPWR VGND sg13cmos5l_antennanp
XANTENNA_2031 Tile_X0Y0_FrameData[6] VPWR VGND sg13cmos5l_antennanp
XANTENNA_2042 Tile_X0Y0_FrameData[6] VPWR VGND sg13cmos5l_antennanp
X_0502_ _0502_/Q Tile_X0Y0_FrameData[3] VGND VPWR Tile_X3Y0_FrameStrobe[2] latch
XANTENNA_1330 Tile_X0Y0_FrameData[30] VPWR VGND sg13cmos5l_antennanp
XANTENNA_2053 Tile_X0Y0_FrameData[6] VPWR VGND sg13cmos5l_antennanp
XANTENNA_2064 Tile_X0Y0_FrameData[6] VPWR VGND sg13cmos5l_antennanp
XANTENNA_2075 Tile_X0Y0_FrameData[6] VPWR VGND sg13cmos5l_antennanp
X_0433_ _0433_/Q Tile_X0Y0_FrameData[8] VGND VPWR Tile_X3Y0_FrameStrobe[0] latch
XANTENNA_1341 Tile_X0Y0_FrameData[30] VPWR VGND sg13cmos5l_antennanp
XANTENNA_1352 Tile_X0Y0_FrameData[30] VPWR VGND sg13cmos5l_antennanp
XANTENNA_1363 Tile_X0Y0_FrameData[31] VPWR VGND sg13cmos5l_antennanp
XANTENNA_2086 Tile_X0Y0_FrameData[6] VPWR VGND sg13cmos5l_antennanp
XANTENNA_2097 Tile_X0Y0_FrameData[6] VPWR VGND sg13cmos5l_antennanp
XANTENNA_1374 Tile_X0Y0_FrameData[31] VPWR VGND sg13cmos5l_antennanp
XANTENNA_1385 Tile_X0Y0_FrameData[31] VPWR VGND sg13cmos5l_antennanp
XANTENNA_1396 Tile_X0Y0_FrameData[31] VPWR VGND sg13cmos5l_antennanp
X_0364_ _0364_/Q Tile_X0Y0_FrameData[13] VGND VPWR Tile_X2Y0_FrameStrobe[1] latch
X_0295_ _0295_/Q Tile_X0Y0_FrameData[2] VGND VPWR Tile_X1Y0_FrameStrobe[2] latch
XFILLER_3_1747 VPWR VGND sg13cmos5l_decap_8
XFILLER_1_1471 VPWR VGND sg13cmos5l_fill_2
XANTENNA__1001__X Tile_X0Y0_S4BEG[10] VPWR VGND sg13cmos5l_antennanp
XANTENNA__0840__X Tile_X4Y0_FrameData_O[29] VPWR VGND sg13cmos5l_antennanp
XFILLER_11_1056 VPWR VGND sg13cmos5l_decap_4
XFILLER_8_2359 VPWR VGND sg13cmos5l_decap_8
XANTENNA_205 Tile_X0Y0_FrameData[10] VPWR VGND sg13cmos5l_antennanp
XANTENNA_216 Tile_X0Y0_FrameData[10] VPWR VGND sg13cmos5l_antennanp
XANTENNA_227 Tile_X0Y0_FrameData[10] VPWR VGND sg13cmos5l_antennanp
XANTENNA_238 Tile_X0Y0_FrameData[10] VPWR VGND sg13cmos5l_antennanp
XANTENNA_249 Tile_X0Y0_FrameData[10] VPWR VGND sg13cmos5l_antennanp
XFILLER_14_604 VPWR VGND sg13cmos5l_decap_8
XFILLER_13_147 VPWR VGND sg13cmos5l_decap_8
XFILLER_13_2512 VPWR VGND sg13cmos5l_decap_8
XANTENNA__0750__X Tile_X1Y0_S1BEG[3] VPWR VGND sg13cmos5l_antennanp
XFILLER_13_1866 VPWR VGND sg13cmos5l_decap_8
XFILLER_4_2724 VPWR VGND sg13cmos5l_decap_8
XFILLER_7_1157 VPWR VGND sg13cmos5l_decap_8
XANTENNA__0925__X Tile_X3Y0_FrameStrobe_O[10] VPWR VGND sg13cmos5l_antennanp
XANTENNA_772 Tile_X0Y0_FrameData[26] VPWR VGND sg13cmos5l_antennanp
XANTENNA_761 Tile_X0Y0_FrameData[25] VPWR VGND sg13cmos5l_antennanp
XANTENNA_750 Tile_X0Y0_FrameData[25] VPWR VGND sg13cmos5l_antennanp
XANTENNA_794 Tile_X0Y0_FrameData[26] VPWR VGND sg13cmos5l_antennanp
XANTENNA_783 Tile_X0Y0_FrameData[26] VPWR VGND sg13cmos5l_antennanp
X_0982_ Tile_X0Y0_SS4BEG[7] _1162_/X VPWR VGND sg13cmos5l_buf_1
XFILLER_9_630 VPWR VGND sg13cmos5l_decap_8
XFILLER_16_2191 VPWR VGND sg13cmos5l_decap_8
XFILLER_13_692 VPWR VGND sg13cmos5l_decap_8
XFILLER_12_2099 VPWR VGND sg13cmos5l_decap_8
XFILLER_5_891 VPWR VGND sg13cmos5l_fill_1
XFILLER_9_2668 VPWR VGND sg13cmos5l_decap_8
XANTENNA_1160 Tile_X0Y0_FrameData[30] VPWR VGND sg13cmos5l_antennanp
XANTENNA_1171 Tile_X0Y0_FrameData[30] VPWR VGND sg13cmos5l_antennanp
XANTENNA_1182 Tile_X0Y0_FrameData[30] VPWR VGND sg13cmos5l_antennanp
X_0416_ _0416_/Q Tile_X0Y0_FrameData[25] VGND VPWR Tile_X3Y0_FrameStrobe[0] latch
XANTENNA_1193 Tile_X0Y0_FrameData[30] VPWR VGND sg13cmos5l_antennanp
X_0347_ _0347_/Q Tile_X0Y0_FrameData[30] VGND VPWR Tile_X2Y0_FrameStrobe[1] latch
XFILLER_7_1680 VPWR VGND sg13cmos5l_decap_8
XFILLER_3_1511 VPWR VGND sg13cmos5l_fill_1
XFILLER_3_2278 VPWR VGND sg13cmos5l_decap_8
XFILLER_3_1555 VPWR VGND sg13cmos5l_fill_2
X_0278_ _0278_/Q Tile_X0Y0_FrameData[19] VGND VPWR Tile_X1Y0_FrameStrobe[2] latch
XANTENNA__0835__X Tile_X4Y0_FrameData_O[24] VPWR VGND sg13cmos5l_antennanp
XFILLER_11_629 VPWR VGND sg13cmos5l_decap_8
XFILLER_13_1129 VPWR VGND sg13cmos5l_decap_8
XFILLER_12_35 VPWR VGND sg13cmos5l_decap_8
XFILLER_10_2718 VPWR VGND sg13cmos5l_decap_8
XFILLER_5_7 VPWR VGND sg13cmos5l_decap_8
XFILLER_8_2189 VPWR VGND sg13cmos5l_decap_8
XFILLER_6_1190 VPWR VGND sg13cmos5l_decap_8
XANTENNA__0745__X Tile_X1Y0_SS4BEG[14] VPWR VGND sg13cmos5l_antennanp
XFILLER_14_456 VPWR VGND sg13cmos5l_fill_1
XFILLER_14_445 VPWR VGND sg13cmos5l_decap_8
XFILLER_15_1906 VPWR VGND sg13cmos5l_decap_4
XFILLER_6_600 VPWR VGND sg13cmos5l_decap_8
XFILLER_10_662 VPWR VGND sg13cmos5l_fill_2
XFILLER_13_2386 VPWR VGND sg13cmos5l_decap_8
XFILLER_13_1663 VPWR VGND sg13cmos5l_decap_8
X_1250_ _1250_/X Tile_X2Y0_N2END[7] Tile_X2Y0_N4END[15] Tile_X2Y0_NN4END[0] _0580_/Q
+ _0331_/Q _0330_/Q VPWR VGND sg13cmos5l_mux4_1
XFILLER_1_382 VPWR VGND sg13cmos5l_fill_2
X_0201_ _0201_/Q Tile_X0Y0_FrameData[16] VGND VPWR Tile_X0Y0_FrameStrobe[3] latch
X_1181_ _1181_/X Tile_X1Y0_N2MID[2] Tile_X1Y0_N4END[13] Tile_X1Y0_NN4END[2] _0594_/Q
+ _0293_/Q _0292_/Q VPWR VGND sg13cmos5l_mux4_1
X_0132_ _0132_/Q Tile_X0Y0_FrameData[21] VGND VPWR Tile_X0Y0_FrameStrobe[1] latch
XFILLER_4_2598 VPWR VGND sg13cmos5l_decap_8
XFILLER_4_2576 VPWR VGND sg13cmos5l_decap_4
XFILLER_0_1706 VPWR VGND sg13cmos5l_decap_8
XANTENNA_580 Tile_X0Y0_FrameData[23] VPWR VGND sg13cmos5l_antennanp
XANTENNA_591 Tile_X0Y0_FrameData[23] VPWR VGND sg13cmos5l_antennanp
XFILLER_14_2139 VPWR VGND sg13cmos5l_decap_8
X_0965_ Tile_X1Y0_FrameStrobe_O[10] Tile_X1Y0_FrameStrobe[10] VPWR VGND sg13cmos5l_buf_1
XFILLER_14_1438 VPWR VGND sg13cmos5l_decap_4
XFILLER_9_482 VPWR VGND sg13cmos5l_fill_1
X_0896_ Tile_X2Y0_S4BEG[13] _1232_/X VPWR VGND sg13cmos5l_buf_1
XFILLER_12_1140 VPWR VGND sg13cmos5l_decap_8
XFILLER_9_2421 VPWR VGND sg13cmos5l_decap_8
XFILLER_9_1753 VPWR VGND sg13cmos5l_decap_8
XFILLER_9_2498 VPWR VGND sg13cmos5l_decap_8
XFILLER_5_1639 VPWR VGND sg13cmos5l_decap_8
XFILLER_3_1396 VPWR VGND sg13cmos5l_fill_1
XFILLER_14_2651 VPWR VGND sg13cmos5l_decap_8
XFILLER_14_1961 VPWR VGND sg13cmos5l_fill_1
XFILLER_14_1950 VPWR VGND sg13cmos5l_decap_4
XANTENNA_3309 Tile_X0Y0_FrameData[20] VPWR VGND sg13cmos5l_antennanp
XFILLER_14_1972 VPWR VGND sg13cmos5l_fill_2
XANTENNA_2608 Tile_X0Y0_FrameData[14] VPWR VGND sg13cmos5l_antennanp
XFILLER_3_614 VPWR VGND sg13cmos5l_decap_8
XANTENNA_2619 Tile_X0Y0_FrameData[14] VPWR VGND sg13cmos5l_antennanp
XANTENNA_1907 Tile_X0Y0_FrameData[5] VPWR VGND sg13cmos5l_antennanp
XANTENNA_1918 Tile_X0Y0_FrameData[5] VPWR VGND sg13cmos5l_antennanp
XANTENNA_1929 Tile_X0Y0_FrameData[5] VPWR VGND sg13cmos5l_antennanp
XFILLER_4_1105 VPWR VGND sg13cmos5l_decap_8
XFILLER_1_2727 VPWR VGND sg13cmos5l_decap_8
XFILLER_9_14 VPWR VGND sg13cmos5l_decap_8
XFILLER_15_776 VPWR VGND sg13cmos5l_decap_8
XFILLER_15_2426 VPWR VGND sg13cmos5l_decap_8
XFILLER_15_1703 VPWR VGND sg13cmos5l_decap_8
X_0750_ Tile_X1Y0_S1BEG[3] Tile_X1Y0_N1END[0] VPWR VGND sg13cmos5l_buf_1
XFILLER_6_441 VPWR VGND sg13cmos5l_fill_2
XFILLER_13_2194 VPWR VGND sg13cmos5l_decap_8
XANTENNA_3810 Tile_X0Y0_FrameData[18] VPWR VGND sg13cmos5l_antennanp
XANTENNA_3821 Tile_X0Y0_FrameData[18] VPWR VGND sg13cmos5l_antennanp
XANTENNA_3832 Tile_X0Y0_FrameData[18] VPWR VGND sg13cmos5l_antennanp
X_0681_ _0681_/L_HI VPWR VGND sg13cmos5l_tiehi
XANTENNA_3843 Tile_X0Y0_FrameData[18] VPWR VGND sg13cmos5l_antennanp
XANTENNA_3854 Tile_X0Y0_FrameData[18] VPWR VGND sg13cmos5l_antennanp
XANTENNA_3865 Tile_X0Y0_FrameData[18] VPWR VGND sg13cmos5l_antennanp
XANTENNA_3876 Tile_X0Y0_FrameData[18] VPWR VGND sg13cmos5l_antennanp
XANTENNA_3887 Tile_X0Y0_FrameData[18] VPWR VGND sg13cmos5l_antennanp
XANTENNA_3898 Tile_X0Y0_FrameData[18] VPWR VGND sg13cmos5l_antennanp
XFILLER_6_2627 VPWR VGND sg13cmos5l_decap_8
X_1233_ _1233_/X Tile_X2Y0_N2MID[6] Tile_X2Y0_N4END[1] Tile_X2Y0_NN4END[14] _0580_/Q
+ _0365_/Q _0364_/Q VPWR VGND sg13cmos5l_mux4_1
X_1164_ _1164_/X Tile_X0Y0_N2END[1] Tile_X0Y0_N4END[9] Tile_X0Y0_NN4END[6] _0598_/Q
+ _0135_/Q _0134_/Q VPWR VGND sg13cmos5l_mux4_1
XFILLER_4_2395 VPWR VGND sg13cmos5l_fill_2
X_0115_ _0115_/Q Tile_X0Y0_FrameData[6] VGND VPWR Tile_X0Y0_FrameStrobe[0] latch
X_1095_ _1095_/X Tile_X3Y0_N1END[3] Tile_X3Y0_N2MID[0] Tile_X3Y0_N2MID[7] Tile_X3Y0_N2END[0]
+ _0411_/Q _0506_/Q VPWR VGND sg13cmos5l_mux4_1
XFILLER_14_1202 VPWR VGND sg13cmos5l_decap_8
X_0948_ Tile_X2Y0_FrameStrobe_O[13] Tile_X2Y0_FrameStrobe[13] VPWR VGND sg13cmos5l_buf_1
XFILLER_14_1279 VPWR VGND sg13cmos5l_decap_8
X_0879_ Tile_X2Y0_S2BEGb[4] _1215_/X VPWR VGND sg13cmos5l_buf_1
XFILLER_9_2251 VPWR VGND sg13cmos5l_decap_8
XFILLER_9_2295 VPWR VGND sg13cmos5l_decap_8
XFILLER_9_1583 VPWR VGND sg13cmos5l_decap_8
XFILLER_16_518 VPWR VGND sg13cmos5l_fill_2
XFILLER_16_2757 VPWR VGND sg13cmos5l_fill_1
XFILLER_12_735 VPWR VGND sg13cmos5l_decap_8
XFILLER_10_2345 VPWR VGND sg13cmos5l_decap_8
XANTENNA_3106 Tile_X0Y0_FrameData[19] VPWR VGND sg13cmos5l_antennanp
XANTENNA_3117 Tile_X0Y0_FrameData[19] VPWR VGND sg13cmos5l_antennanp
XFILLER_10_1622 VPWR VGND sg13cmos5l_decap_8
XANTENNA_2405 Tile_X0Y0_FrameData[11] VPWR VGND sg13cmos5l_antennanp
XANTENNA_2416 Tile_X0Y0_FrameData[12] VPWR VGND sg13cmos5l_antennanp
XANTENNA_3128 Tile_X0Y0_FrameData[19] VPWR VGND sg13cmos5l_antennanp
XANTENNA_3139 Tile_X0Y0_FrameData[19] VPWR VGND sg13cmos5l_antennanp
XANTENNA_1704 Tile_X0Y0_FrameData[4] VPWR VGND sg13cmos5l_antennanp
XANTENNA_2427 Tile_X0Y0_FrameData[12] VPWR VGND sg13cmos5l_antennanp
XANTENNA_2438 Tile_X0Y0_FrameData[12] VPWR VGND sg13cmos5l_antennanp
XANTENNA_2449 Tile_X0Y0_FrameData[12] VPWR VGND sg13cmos5l_antennanp
XFILLER_10_1699 VPWR VGND sg13cmos5l_decap_8
XANTENNA_1715 Tile_X0Y0_FrameData[4] VPWR VGND sg13cmos5l_antennanp
XANTENNA_1726 Tile_X0Y0_FrameData[4] VPWR VGND sg13cmos5l_antennanp
XANTENNA_1737 Tile_X0Y0_FrameData[4] VPWR VGND sg13cmos5l_antennanp
XANTENNA_1748 Tile_X0Y0_FrameData[4] VPWR VGND sg13cmos5l_antennanp
XANTENNA_1759 Tile_X0Y0_FrameData[4] VPWR VGND sg13cmos5l_antennanp
XFILLER_1_2513 VPWR VGND sg13cmos5l_decap_8
XFILLER_5_2693 VPWR VGND sg13cmos5l_decap_8
XFILLER_1_2546 VPWR VGND sg13cmos5l_decap_8
XFILLER_15_595 VPWR VGND sg13cmos5l_decap_8
XFILLER_15_2212 VPWR VGND sg13cmos5l_decap_8
XANTENNA__0933__X Tile_X3Y0_FrameStrobe_O[18] VPWR VGND sg13cmos5l_antennanp
XFILLER_15_1500 VPWR VGND sg13cmos5l_decap_8
X_0802_ Tile_X3Y0_SS4BEG[7] _1282_/X VPWR VGND sg13cmos5l_buf_1
XFILLER_15_2289 VPWR VGND sg13cmos5l_decap_8
XFILLER_15_1577 VPWR VGND sg13cmos5l_decap_8
X_0733_ Tile_X1Y0_SS4BEG[2] _1197_/X VPWR VGND sg13cmos5l_buf_1
XANTENNA_3640 Tile_X0Y0_N4END[1] VPWR VGND sg13cmos5l_antennanp
X_0664_ _0664_/L_HI VPWR VGND sg13cmos5l_tiehi
XFILLER_13_1290 VPWR VGND sg13cmos5l_decap_8
XANTENNA_3651 Tile_X0Y0_N4END[2] VPWR VGND sg13cmos5l_antennanp
XANTENNA_3662 Tile_X1Y0_N1END[0] VPWR VGND sg13cmos5l_antennanp
XANTENNA_3673 Tile_X1Y0_N2END[3] VPWR VGND sg13cmos5l_antennanp
XANTENNA_2950 Tile_X0Y0_FrameData[19] VPWR VGND sg13cmos5l_antennanp
XANTENNA_2961 Tile_X0Y0_FrameData[19] VPWR VGND sg13cmos5l_antennanp
XANTENNA_2972 Tile_X0Y0_FrameData[19] VPWR VGND sg13cmos5l_antennanp
XANTENNA_3684 Tile_X1Y0_N4END[1] VPWR VGND sg13cmos5l_antennanp
XANTENNA_3695 Tile_X1Y0_N4END[1] VPWR VGND sg13cmos5l_antennanp
X_0595_ _0595_/Q Tile_X0Y0_UserCLK NPU_RDATA23 _0611_/L_HI VPWR VGND sg13cmos5l_dfrbpq_1
XFILLER_6_2402 VPWR VGND sg13cmos5l_decap_8
XANTENNA_2983 Tile_X0Y0_FrameData[19] VPWR VGND sg13cmos5l_antennanp
XANTENNA_2994 Tile_X0Y0_FrameData[19] VPWR VGND sg13cmos5l_antennanp
XFILLER_6_2479 VPWR VGND sg13cmos5l_decap_8
XFILLER_6_1734 VPWR VGND sg13cmos5l_decap_8
X_1216_ _1216_/X Tile_X2Y0_N1END[1] Tile_X2Y0_N2MID[5] Tile_X2Y0_N2END[2] _0585_/Q
+ _0399_/Q _0398_/Q VPWR VGND sg13cmos5l_mux4_1
X_1147_ _1147_/X Tile_X0Y0_N2MID[0] Tile_X0Y0_N4END[7] Tile_X0Y0_NN4END[8] _0598_/Q
+ _0169_/Q _0168_/Q VPWR VGND sg13cmos5l_mux4_1
XANTENNA__1004__X Tile_X0Y0_S4BEG[13] VPWR VGND sg13cmos5l_antennanp
X_1078_ Tile_X4Y0_SS4BEG[15] Tile_X4Y0_NN4END[0] VPWR VGND sg13cmos5l_buf_1
XANTENNA__0843__X Tile_X4Y0_FrameStrobe_O[0] VPWR VGND sg13cmos5l_antennanp
XFILLER_11_2632 VPWR VGND sg13cmos5l_decap_8
XFILLER_0_414 VPWR VGND sg13cmos5l_fill_1
XFILLER_16_2521 VPWR VGND sg13cmos5l_decap_8
XANTENNA__0753__X Tile_X1Y0_S2BEG[2] VPWR VGND sg13cmos5l_antennanp
XFILLER_12_543 VPWR VGND sg13cmos5l_decap_8
XFILLER_12_2407 VPWR VGND sg13cmos5l_decap_8
XFILLER_16_2598 VPWR VGND sg13cmos5l_fill_2
XFILLER_16_2587 VPWR VGND sg13cmos5l_decap_8
XFILLER_16_1875 VPWR VGND sg13cmos5l_decap_8
XFILLER_10_2142 VPWR VGND sg13cmos5l_decap_8
XANTENNA_8 NPU_RDATA13 VPWR VGND sg13cmos5l_antennanp
XANTENNA_2202 Tile_X0Y0_FrameData[9] VPWR VGND sg13cmos5l_antennanp
XANTENNA_2213 Tile_X0Y0_FrameData[9] VPWR VGND sg13cmos5l_antennanp
XANTENNA_2224 Tile_X0Y0_FrameData[9] VPWR VGND sg13cmos5l_antennanp
XFILLER_7_2700 VPWR VGND sg13cmos5l_decap_8
XANTENNA_1501 Tile_X0Y0_FrameData[3] VPWR VGND sg13cmos5l_antennanp
XANTENNA_1512 Tile_X0Y0_FrameData[3] VPWR VGND sg13cmos5l_antennanp
XANTENNA_2235 Tile_X0Y0_FrameData[9] VPWR VGND sg13cmos5l_antennanp
XANTENNA_2246 Tile_X0Y0_FrameData[9] VPWR VGND sg13cmos5l_antennanp
XANTENNA_2257 Tile_X0Y0_FrameData[9] VPWR VGND sg13cmos5l_antennanp
XANTENNA_1523 Tile_X0Y0_FrameData[3] VPWR VGND sg13cmos5l_antennanp
XANTENNA_1534 Tile_X0Y0_FrameData[3] VPWR VGND sg13cmos5l_antennanp
XANTENNA_1545 Tile_X0Y0_FrameData[3] VPWR VGND sg13cmos5l_antennanp
XANTENNA_1556 Tile_X0Y0_FrameData[3] VPWR VGND sg13cmos5l_antennanp
XANTENNA_2268 Tile_X0Y0_FrameData[9] VPWR VGND sg13cmos5l_antennanp
XANTENNA_2279 Tile_X0Y0_FrameData[9] VPWR VGND sg13cmos5l_antennanp
X_0380_ _0380_/Q Tile_X0Y0_FrameData[29] VGND VPWR Tile_X2Y0_FrameStrobe[2] latch
XANTENNA_1567 Tile_X0Y0_FrameData[3] VPWR VGND sg13cmos5l_antennanp
XANTENNA_1578 Tile_X0Y0_FrameData[3] VPWR VGND sg13cmos5l_antennanp
XANTENNA_1589 Tile_X0Y0_FrameData[3] VPWR VGND sg13cmos5l_antennanp
XFILLER_7_2777 VPWR VGND sg13cmos5l_decap_8
XFILLER_3_2619 VPWR VGND sg13cmos5l_decap_8
XANTENNA__0928__X Tile_X3Y0_FrameStrobe_O[13] VPWR VGND sg13cmos5l_antennanp
X_1001_ Tile_X0Y0_S4BEG[10] _1149_/X VPWR VGND sg13cmos5l_buf_1
XFILLER_1_2365 VPWR VGND sg13cmos5l_decap_8
XFILLER_1_1631 VPWR VGND sg13cmos5l_decap_8
XFILLER_1_1697 VPWR VGND sg13cmos5l_decap_8
XFILLER_15_2086 VPWR VGND sg13cmos5l_decap_8
XFILLER_15_1363 VPWR VGND sg13cmos5l_decap_8
XFILLER_11_1238 VPWR VGND sg13cmos5l_decap_8
X_0716_ Tile_X1Y0_S4BEG[1] _1180_/X VPWR VGND sg13cmos5l_buf_1
XANTENNA_3470 Tile_X0Y0_FrameData[8] VPWR VGND sg13cmos5l_antennanp
XANTENNA_3481 Tile_X0Y0_FrameData[8] VPWR VGND sg13cmos5l_antennanp
X_0647_ _0647_/L_HI VPWR VGND sg13cmos5l_tiehi
XANTENNA_2780 Tile_X0Y0_FrameData[16] VPWR VGND sg13cmos5l_antennanp
XANTENNA_3492 Tile_X0Y0_FrameData[8] VPWR VGND sg13cmos5l_antennanp
X_0578_ _0578_/Q Tile_X0Y0_UserCLK NPU_RDATA6 _0643_/L_HI VPWR VGND sg13cmos5l_dfrbpq_1
XFILLER_6_2243 VPWR VGND sg13cmos5l_decap_8
XANTENNA_2791 Tile_X0Y0_FrameData[16] VPWR VGND sg13cmos5l_antennanp
XANTENNA__0838__X Tile_X4Y0_FrameData_O[27] VPWR VGND sg13cmos5l_antennanp
XFILLER_2_2118 VPWR VGND sg13cmos5l_fill_1
XFILLER_2_1439 VPWR VGND sg13cmos5l_fill_1
XFILLER_2_1417 VPWR VGND sg13cmos5l_fill_2
XANTENNA_409 Tile_X0Y0_FrameData[22] VPWR VGND sg13cmos5l_antennanp
XFILLER_15_35 VPWR VGND sg13cmos5l_decap_8
XFILLER_13_2727 VPWR VGND sg13cmos5l_decap_8
XANTENNA__0522__Q NPU_READ_BANK_SEL1 VPWR VGND sg13cmos5l_antennanp
XANTENNA__0748__X Tile_X1Y0_S1BEG[1] VPWR VGND sg13cmos5l_antennanp
XFILLER_16_112 VPWR VGND sg13cmos5l_decap_8
XANTENNA_921 Tile_X0Y0_FrameData[27] VPWR VGND sg13cmos5l_antennanp
XANTENNA_910 Tile_X0Y0_FrameData[27] VPWR VGND sg13cmos5l_antennanp
XANTENNA_954 Tile_X0Y0_FrameData[28] VPWR VGND sg13cmos5l_antennanp
XANTENNA_943 Tile_X0Y0_FrameData[28] VPWR VGND sg13cmos5l_antennanp
XANTENNA_932 Tile_X0Y0_FrameData[28] VPWR VGND sg13cmos5l_antennanp
XFILLER_16_178 VPWR VGND sg13cmos5l_decap_8
XANTENNA_987 Tile_X0Y0_FrameData[28] VPWR VGND sg13cmos5l_antennanp
XANTENNA_976 Tile_X0Y0_FrameData[28] VPWR VGND sg13cmos5l_antennanp
XANTENNA_965 Tile_X0Y0_FrameData[28] VPWR VGND sg13cmos5l_antennanp
XANTENNA_998 Tile_X0Y0_FrameData[28] VPWR VGND sg13cmos5l_antennanp
XFILLER_12_2204 VPWR VGND sg13cmos5l_decap_8
XFILLER_9_878 VPWR VGND sg13cmos5l_fill_2
XFILLER_16_2395 VPWR VGND sg13cmos5l_decap_8
XFILLER_16_1694 VPWR VGND sg13cmos5l_decap_8
XFILLER_12_1558 VPWR VGND sg13cmos5l_decap_8
X_0501_ _0501_/Q Tile_X0Y0_FrameData[4] VGND VPWR Tile_X3Y0_FrameStrobe[2] latch
XANTENNA_2010 Tile_X0Y0_FrameData[6] VPWR VGND sg13cmos5l_antennanp
XANTENNA_2021 Tile_X0Y0_FrameData[6] VPWR VGND sg13cmos5l_antennanp
XANTENNA_2032 Tile_X0Y0_FrameData[6] VPWR VGND sg13cmos5l_antennanp
XFILLER_4_583 VPWR VGND sg13cmos5l_decap_8
XANTENNA_1320 Tile_X0Y0_FrameData[30] VPWR VGND sg13cmos5l_antennanp
XANTENNA_1331 Tile_X0Y0_FrameData[30] VPWR VGND sg13cmos5l_antennanp
XANTENNA_2043 Tile_X0Y0_FrameData[6] VPWR VGND sg13cmos5l_antennanp
XANTENNA_2054 Tile_X0Y0_FrameData[6] VPWR VGND sg13cmos5l_antennanp
XANTENNA_2065 Tile_X0Y0_FrameData[6] VPWR VGND sg13cmos5l_antennanp
X_0432_ _0432_/Q Tile_X0Y0_FrameData[9] VGND VPWR Tile_X3Y0_FrameStrobe[0] latch
XFILLER_7_2530 VPWR VGND sg13cmos5l_decap_4
XANTENNA_1342 Tile_X0Y0_FrameData[30] VPWR VGND sg13cmos5l_antennanp
XANTENNA_1353 Tile_X0Y0_FrameData[30] VPWR VGND sg13cmos5l_antennanp
XANTENNA_1364 Tile_X0Y0_FrameData[31] VPWR VGND sg13cmos5l_antennanp
XANTENNA_2076 Tile_X0Y0_FrameData[6] VPWR VGND sg13cmos5l_antennanp
XANTENNA_2087 Tile_X0Y0_FrameData[6] VPWR VGND sg13cmos5l_antennanp
XANTENNA_2098 Tile_X0Y0_FrameData[6] VPWR VGND sg13cmos5l_antennanp
X_0363_ _0363_/Q Tile_X0Y0_FrameData[14] VGND VPWR Tile_X2Y0_FrameStrobe[1] latch
XANTENNA_1375 Tile_X0Y0_FrameData[31] VPWR VGND sg13cmos5l_antennanp
XANTENNA_1386 Tile_X0Y0_FrameData[31] VPWR VGND sg13cmos5l_antennanp
XANTENNA_1397 Tile_X0Y0_FrameData[31] VPWR VGND sg13cmos5l_antennanp
X_0294_ _0294_/Q Tile_X0Y0_FrameData[3] VGND VPWR Tile_X1Y0_FrameStrobe[2] latch
XFILLER_3_1726 VPWR VGND sg13cmos5l_decap_8
XFILLER_7_91 VPWR VGND sg13cmos5l_decap_8
XFILLER_15_1193 VPWR VGND sg13cmos5l_decap_8
XFILLER_11_1035 VPWR VGND sg13cmos5l_fill_1
XFILLER_11_1079 VPWR VGND sg13cmos5l_decap_8
XFILLER_8_2338 VPWR VGND sg13cmos5l_decap_8
XANTENNA_206 Tile_X0Y0_FrameData[10] VPWR VGND sg13cmos5l_antennanp
XANTENNA_217 Tile_X0Y0_FrameData[10] VPWR VGND sg13cmos5l_antennanp
XANTENNA_228 Tile_X0Y0_FrameData[10] VPWR VGND sg13cmos5l_antennanp
XANTENNA_239 Tile_X0Y0_FrameData[10] VPWR VGND sg13cmos5l_antennanp
XFILLER_13_126 VPWR VGND sg13cmos5l_decap_8
XFILLER_9_119 VPWR VGND sg13cmos5l_decap_8
XFILLER_13_1845 VPWR VGND sg13cmos5l_decap_8
XFILLER_4_2703 VPWR VGND sg13cmos5l_decap_8
XFILLER_3_49 VPWR VGND sg13cmos5l_decap_8
XFILLER_7_1136 VPWR VGND sg13cmos5l_decap_8
XFILLER_1_597 VPWR VGND sg13cmos5l_decap_8
XFILLER_2_2460 VPWR VGND sg13cmos5l_decap_8
XANTENNA_762 Tile_X0Y0_FrameData[25] VPWR VGND sg13cmos5l_antennanp
XANTENNA_751 Tile_X0Y0_FrameData[25] VPWR VGND sg13cmos5l_antennanp
XANTENNA_740 Tile_X0Y0_FrameData[25] VPWR VGND sg13cmos5l_antennanp
XANTENNA_795 Tile_X0Y0_FrameData[26] VPWR VGND sg13cmos5l_antennanp
XANTENNA_784 Tile_X0Y0_FrameData[26] VPWR VGND sg13cmos5l_antennanp
XANTENNA_773 Tile_X0Y0_FrameData[26] VPWR VGND sg13cmos5l_antennanp
X_0981_ Tile_X0Y0_SS4BEG[6] _1161_/X VPWR VGND sg13cmos5l_buf_1
XFILLER_13_671 VPWR VGND sg13cmos5l_decap_8
XANTENNA__0941__X Tile_X2Y0_FrameStrobe_O[6] VPWR VGND sg13cmos5l_antennanp
XFILLER_9_686 VPWR VGND sg13cmos5l_decap_8
XFILLER_12_2078 VPWR VGND sg13cmos5l_decap_8
XFILLER_9_2647 VPWR VGND sg13cmos5l_decap_8
XFILLER_10_1090 VPWR VGND sg13cmos5l_decap_8
X_0415_ _0415_/Q Tile_X0Y0_FrameData[26] VGND VPWR Tile_X3Y0_FrameStrobe[0] latch
XANTENNA_1150 Tile_X0Y0_FrameData[2] VPWR VGND sg13cmos5l_antennanp
XANTENNA_1161 Tile_X0Y0_FrameData[30] VPWR VGND sg13cmos5l_antennanp
XANTENNA_1172 Tile_X0Y0_FrameData[30] VPWR VGND sg13cmos5l_antennanp
XANTENNA_1183 Tile_X0Y0_FrameData[30] VPWR VGND sg13cmos5l_antennanp
XANTENNA_1194 Tile_X0Y0_FrameData[30] VPWR VGND sg13cmos5l_antennanp
X_0346_ _0346_/Q Tile_X0Y0_FrameData[31] VGND VPWR Tile_X2Y0_FrameStrobe[1] latch
XFILLER_3_2257 VPWR VGND sg13cmos5l_decap_8
X_0277_ _0277_/Q Tile_X0Y0_FrameData[20] VGND VPWR Tile_X1Y0_FrameStrobe[2] latch
XANTENNA__1012__X Tile_X0Y0_S2BEGb[5] VPWR VGND sg13cmos5l_antennanp
XFILLER_11_608 VPWR VGND sg13cmos5l_decap_8
XFILLER_13_1108 VPWR VGND sg13cmos5l_decap_8
XANTENNA__0851__X Tile_X4Y0_FrameStrobe_O[8] VPWR VGND sg13cmos5l_antennanp
XFILLER_12_14 VPWR VGND sg13cmos5l_decap_8
XFILLER_8_2168 VPWR VGND sg13cmos5l_decap_8
XFILLER_14_435 VPWR VGND sg13cmos5l_fill_1
XFILLER_15_2619 VPWR VGND sg13cmos5l_decap_8
XANTENNA__0761__X Tile_X3Y0_S1BEG[2] VPWR VGND sg13cmos5l_antennanp
XFILLER_13_2365 VPWR VGND sg13cmos5l_decap_8
XFILLER_10_641 VPWR VGND sg13cmos5l_decap_8
XFILLER_13_1642 VPWR VGND sg13cmos5l_decap_8
XFILLER_10_696 VPWR VGND sg13cmos5l_decap_8
XFILLER_6_656 VPWR VGND sg13cmos5l_decap_8
XFILLER_1_394 VPWR VGND sg13cmos5l_fill_2
X_0200_ _0200_/Q Tile_X0Y0_FrameData[17] VGND VPWR Tile_X0Y0_FrameStrobe[3] latch
X_1180_ _1180_/X Tile_X1Y0_N2MID[1] Tile_X1Y0_N4END[14] Tile_X1Y0_NN4END[1] _0595_/Q
+ _0295_/Q _0294_/Q VPWR VGND sg13cmos5l_mux4_1
XFILLER_4_2555 VPWR VGND sg13cmos5l_decap_8
X_0131_ _0131_/Q Tile_X0Y0_FrameData[22] VGND VPWR Tile_X0Y0_FrameStrobe[1] latch
XANTENNA__0936__X Tile_X2Y0_FrameStrobe_O[1] VPWR VGND sg13cmos5l_antennanp
XANTENNA_570 Tile_X0Y0_FrameData[23] VPWR VGND sg13cmos5l_antennanp
XFILLER_14_2118 VPWR VGND sg13cmos5l_decap_8
XANTENNA_592 Tile_X0Y0_FrameData[23] VPWR VGND sg13cmos5l_antennanp
XANTENNA_581 Tile_X0Y0_FrameData[23] VPWR VGND sg13cmos5l_antennanp
X_0964_ Tile_X1Y0_FrameStrobe_O[9] Tile_X1Y0_FrameStrobe[9] VPWR VGND sg13cmos5l_buf_1
X_0895_ Tile_X2Y0_S4BEG[12] _1231_/X VPWR VGND sg13cmos5l_buf_1
XFILLER_9_2400 VPWR VGND sg13cmos5l_decap_8
XFILLER_12_1196 VPWR VGND sg13cmos5l_decap_8
XFILLER_9_1732 VPWR VGND sg13cmos5l_decap_8
XFILLER_9_2477 VPWR VGND sg13cmos5l_decap_8
XFILLER_4_70 VPWR VGND sg13cmos5l_decap_8
XFILLER_5_2319 VPWR VGND sg13cmos5l_decap_8
XFILLER_4_81 VPWR VGND sg13cmos5l_fill_2
XANTENNA__1007__X Tile_X0Y0_S2BEGb[0] VPWR VGND sg13cmos5l_antennanp
XFILLER_5_1618 VPWR VGND sg13cmos5l_decap_8
X_0329_ _0329_/Q Tile_X0Y0_FrameData[16] VGND VPWR Tile_X2Y0_FrameStrobe[0] latch
XANTENNA__0846__X Tile_X4Y0_FrameStrobe_O[3] VPWR VGND sg13cmos5l_antennanp
XFILLER_14_2630 VPWR VGND sg13cmos5l_decap_8
XFILLER_10_2527 VPWR VGND sg13cmos5l_decap_8
XFILLER_10_1826 VPWR VGND sg13cmos5l_decap_4
XANTENNA_2609 Tile_X0Y0_FrameData[14] VPWR VGND sg13cmos5l_antennanp
XANTENNA__0530__Q NPU_WDATA6 VPWR VGND sg13cmos5l_antennanp
XANTENNA_1908 Tile_X0Y0_FrameData[5] VPWR VGND sg13cmos5l_antennanp
XANTENNA_1919 Tile_X0Y0_FrameData[5] VPWR VGND sg13cmos5l_antennanp
XANTENNA__0756__X Tile_X1Y0_S2BEG[5] VPWR VGND sg13cmos5l_antennanp
XFILLER_0_28 VPWR VGND sg13cmos5l_decap_8
XFILLER_15_755 VPWR VGND sg13cmos5l_decap_8
XFILLER_14_210 VPWR VGND sg13cmos5l_fill_1
XFILLER_15_2405 VPWR VGND sg13cmos5l_decap_8
XFILLER_15_1759 VPWR VGND sg13cmos5l_decap_8
XFILLER_13_2173 VPWR VGND sg13cmos5l_decap_8
X_0680_ _0680_/L_HI VPWR VGND sg13cmos5l_tiehi
XANTENNA_3800 Tile_X0Y0_FrameData[18] VPWR VGND sg13cmos5l_antennanp
XANTENNA_3811 Tile_X0Y0_FrameData[18] VPWR VGND sg13cmos5l_antennanp
XANTENNA_3822 Tile_X0Y0_FrameData[18] VPWR VGND sg13cmos5l_antennanp
XANTENNA_3833 Tile_X0Y0_FrameData[18] VPWR VGND sg13cmos5l_antennanp
XANTENNA_3844 Tile_X0Y0_FrameData[18] VPWR VGND sg13cmos5l_antennanp
XANTENNA_3855 Tile_X0Y0_FrameData[18] VPWR VGND sg13cmos5l_antennanp
XANTENNA_3866 Tile_X0Y0_FrameData[18] VPWR VGND sg13cmos5l_antennanp
XANTENNA_3877 Tile_X0Y0_FrameData[18] VPWR VGND sg13cmos5l_antennanp
XANTENNA_3888 Tile_X0Y0_FrameData[18] VPWR VGND sg13cmos5l_antennanp
XANTENNA_3899 Tile_X0Y0_FrameData[18] VPWR VGND sg13cmos5l_antennanp
XFILLER_6_2606 VPWR VGND sg13cmos5l_decap_8
XFILLER_9_1039 VPWR VGND sg13cmos5l_fill_2
X_1232_ _1232_/X Tile_X2Y0_N2MID[5] Tile_X2Y0_N4END[2] Tile_X2Y0_NN4END[13] _0581_/Q
+ _0367_/Q _0366_/Q VPWR VGND sg13cmos5l_mux4_1
XFILLER_4_2374 VPWR VGND sg13cmos5l_decap_8
X_1163_ _1163_/X Tile_X0Y0_N2END[0] Tile_X0Y0_N4END[8] Tile_X0Y0_NN4END[7] _0599_/Q
+ _0137_/Q _0136_/Q VPWR VGND sg13cmos5l_mux4_1
X_0114_ _0114_/Q Tile_X0Y0_FrameData[7] VGND VPWR Tile_X0Y0_FrameStrobe[0] latch
X_1094_ _1094_/X Tile_X3Y0_N1END[2] Tile_X3Y0_N2MID[1] Tile_X3Y0_N2MID[6] Tile_X3Y0_N2END[1]
+ _0413_/Q _0412_/Q VPWR VGND sg13cmos5l_mux4_1
XFILLER_4_1684 VPWR VGND sg13cmos5l_decap_8
XFILLER_0_2249 VPWR VGND sg13cmos5l_decap_8
X_0947_ Tile_X2Y0_FrameStrobe_O[12] Tile_X2Y0_FrameStrobe[12] VPWR VGND sg13cmos5l_buf_1
XFILLER_14_1258 VPWR VGND sg13cmos5l_decap_8
X_0878_ Tile_X2Y0_S2BEGb[3] _1214_/X VPWR VGND sg13cmos5l_buf_1
XFILLER_9_2230 VPWR VGND sg13cmos5l_decap_8
XFILLER_16_2725 VPWR VGND sg13cmos5l_decap_4
XFILLER_12_714 VPWR VGND sg13cmos5l_decap_8
XANTENNA__0525__Q NPU_WDATA1 VPWR VGND sg13cmos5l_antennanp
XFILLER_10_2324 VPWR VGND sg13cmos5l_decap_8
XFILLER_10_1601 VPWR VGND sg13cmos5l_decap_8
XANTENNA_3107 Tile_X0Y0_FrameData[19] VPWR VGND sg13cmos5l_antennanp
XANTENNA_3118 Tile_X0Y0_FrameData[19] VPWR VGND sg13cmos5l_antennanp
XFILLER_14_1781 VPWR VGND sg13cmos5l_decap_8
XANTENNA_2406 Tile_X0Y0_FrameData[11] VPWR VGND sg13cmos5l_antennanp
XANTENNA_3129 Tile_X0Y0_FrameData[19] VPWR VGND sg13cmos5l_antennanp
XFILLER_10_1678 VPWR VGND sg13cmos5l_decap_8
XANTENNA_1705 Tile_X0Y0_FrameData[4] VPWR VGND sg13cmos5l_antennanp
XANTENNA_2417 Tile_X0Y0_FrameData[12] VPWR VGND sg13cmos5l_antennanp
XANTENNA_2428 Tile_X0Y0_FrameData[12] VPWR VGND sg13cmos5l_antennanp
XANTENNA_2439 Tile_X0Y0_FrameData[12] VPWR VGND sg13cmos5l_antennanp
XANTENNA_1716 Tile_X0Y0_FrameData[4] VPWR VGND sg13cmos5l_antennanp
XANTENNA_1727 Tile_X0Y0_FrameData[4] VPWR VGND sg13cmos5l_antennanp
XANTENNA_1738 Tile_X0Y0_FrameData[4] VPWR VGND sg13cmos5l_antennanp
XANTENNA_1749 Tile_X0Y0_FrameData[4] VPWR VGND sg13cmos5l_antennanp
XFILLER_8_1050 VPWR VGND sg13cmos5l_fill_1
XFILLER_5_2672 VPWR VGND sg13cmos5l_decap_8
XFILLER_1_1846 VPWR VGND sg13cmos5l_fill_1
XFILLER_15_574 VPWR VGND sg13cmos5l_decap_8
XFILLER_15_2268 VPWR VGND sg13cmos5l_decap_8
X_0801_ Tile_X3Y0_SS4BEG[6] _1281_/X VPWR VGND sg13cmos5l_buf_1
XFILLER_15_1556 VPWR VGND sg13cmos5l_decap_8
X_0732_ Tile_X1Y0_SS4BEG[1] _1196_/X VPWR VGND sg13cmos5l_buf_1
XFILLER_7_762 VPWR VGND sg13cmos5l_fill_1
XANTENNA_3630 Tile_X0Y0_N4END[1] VPWR VGND sg13cmos5l_antennanp
X_0663_ _0663_/L_HI VPWR VGND sg13cmos5l_tiehi
XFILLER_6_283 VPWR VGND sg13cmos5l_fill_1
XANTENNA_3641 Tile_X0Y0_N4END[1] VPWR VGND sg13cmos5l_antennanp
XANTENNA_3652 Tile_X0Y0_N4END[2] VPWR VGND sg13cmos5l_antennanp
XANTENNA_3663 Tile_X1Y0_N1END[0] VPWR VGND sg13cmos5l_antennanp
XANTENNA_3674 Tile_X1Y0_N2END[3] VPWR VGND sg13cmos5l_antennanp
X_0594_ _0594_/Q Tile_X0Y0_UserCLK NPU_RDATA22 _0610_/L_HI VPWR VGND sg13cmos5l_dfrbpq_1
XANTENNA_2940 Tile_X0Y0_FrameData[19] VPWR VGND sg13cmos5l_antennanp
XANTENNA_2951 Tile_X0Y0_FrameData[19] VPWR VGND sg13cmos5l_antennanp
XANTENNA_2962 Tile_X0Y0_FrameData[19] VPWR VGND sg13cmos5l_antennanp
XANTENNA_3685 Tile_X1Y0_N4END[1] VPWR VGND sg13cmos5l_antennanp
XANTENNA_3696 Tile_X1Y0_N4END[1] VPWR VGND sg13cmos5l_antennanp
XANTENNA_2973 Tile_X0Y0_FrameData[19] VPWR VGND sg13cmos5l_antennanp
XANTENNA_2984 Tile_X0Y0_FrameData[19] VPWR VGND sg13cmos5l_antennanp
XANTENNA_2995 Tile_X0Y0_FrameData[19] VPWR VGND sg13cmos5l_antennanp
XFILLER_6_2458 VPWR VGND sg13cmos5l_decap_8
XFILLER_6_1713 VPWR VGND sg13cmos5l_decap_8
X_1215_ _1215_/X Tile_X2Y0_N1END[0] Tile_X2Y0_N2MID[4] Tile_X2Y0_N2END[3] _0584_/Q
+ _0401_/Q _0400_/Q VPWR VGND sg13cmos5l_mux4_1
X_1146_ _1146_/X Tile_X0Y0_N2MID[7] Tile_X0Y0_N4END[8] Tile_X0Y0_NN4END[7] _0601_/Q
+ _0171_/Q _0170_/Q VPWR VGND sg13cmos5l_mux4_1
XFILLER_4_1481 VPWR VGND sg13cmos5l_fill_2
X_1077_ Tile_X4Y0_SS4BEG[14] Tile_X4Y0_NN4END[1] VPWR VGND sg13cmos5l_buf_1
XFILLER_16_1309 VPWR VGND sg13cmos5l_decap_8
XANTENNA__1020__X Tile_X0Y0_S2BEG[5] VPWR VGND sg13cmos5l_antennanp
XFILLER_11_2611 VPWR VGND sg13cmos5l_decap_8
XFILLER_14_1044 VPWR VGND sg13cmos5l_fill_2
XFILLER_11_2688 VPWR VGND sg13cmos5l_decap_8
XFILLER_11_1932 VPWR VGND sg13cmos5l_fill_2
XFILLER_16_2500 VPWR VGND sg13cmos5l_decap_8
XFILLER_12_522 VPWR VGND sg13cmos5l_decap_8
XFILLER_8_515 VPWR VGND sg13cmos5l_decap_8
XFILLER_16_2577 VPWR VGND sg13cmos5l_decap_8
XFILLER_16_1854 VPWR VGND sg13cmos5l_decap_8
XFILLER_12_599 VPWR VGND sg13cmos5l_decap_8
XFILLER_10_2121 VPWR VGND sg13cmos5l_decap_8
XFILLER_6_49 VPWR VGND sg13cmos5l_decap_8
XANTENNA_9 NPU_RDATA14 VPWR VGND sg13cmos5l_antennanp
XFILLER_10_2198 VPWR VGND sg13cmos5l_decap_8
XANTENNA_2203 Tile_X0Y0_FrameData[9] VPWR VGND sg13cmos5l_antennanp
XANTENNA_2214 Tile_X0Y0_FrameData[9] VPWR VGND sg13cmos5l_antennanp
XANTENNA_1502 Tile_X0Y0_FrameData[3] VPWR VGND sg13cmos5l_antennanp
XANTENNA_1513 Tile_X0Y0_FrameData[3] VPWR VGND sg13cmos5l_antennanp
XANTENNA_2225 Tile_X0Y0_FrameData[9] VPWR VGND sg13cmos5l_antennanp
XANTENNA_2236 Tile_X0Y0_FrameData[9] VPWR VGND sg13cmos5l_antennanp
XANTENNA_2247 Tile_X0Y0_FrameData[9] VPWR VGND sg13cmos5l_antennanp
XANTENNA_2258 Tile_X0Y0_FrameData[9] VPWR VGND sg13cmos5l_antennanp
XFILLER_10_91 VPWR VGND sg13cmos5l_decap_8
XANTENNA_1524 Tile_X0Y0_FrameData[3] VPWR VGND sg13cmos5l_antennanp
XANTENNA_1535 Tile_X0Y0_FrameData[3] VPWR VGND sg13cmos5l_antennanp
XANTENNA_1546 Tile_X0Y0_FrameData[3] VPWR VGND sg13cmos5l_antennanp
XANTENNA_2269 Tile_X0Y0_FrameData[9] VPWR VGND sg13cmos5l_antennanp
XFILLER_7_2756 VPWR VGND sg13cmos5l_decap_8
XANTENNA_1557 Tile_X0Y0_FrameData[3] VPWR VGND sg13cmos5l_antennanp
XANTENNA_1568 Tile_X0Y0_FrameData[3] VPWR VGND sg13cmos5l_antennanp
XANTENNA_1579 Tile_X0Y0_FrameData[3] VPWR VGND sg13cmos5l_antennanp
XFILLER_5_2480 VPWR VGND sg13cmos5l_decap_8
XFILLER_13_7 VPWR VGND sg13cmos5l_decap_8
X_1000_ Tile_X0Y0_S4BEG[9] _1148_/X VPWR VGND sg13cmos5l_buf_1
XFILLER_1_2333 VPWR VGND sg13cmos5l_decap_8
XFILLER_1_1676 VPWR VGND sg13cmos5l_decap_8
XANTENNA__0944__X Tile_X2Y0_FrameStrobe_O[9] VPWR VGND sg13cmos5l_antennanp
XFILLER_15_2065 VPWR VGND sg13cmos5l_decap_8
XFILLER_11_1217 VPWR VGND sg13cmos5l_decap_8
XANTENNA_4150 Tile_X1Y0_N2MID[1] VPWR VGND sg13cmos5l_antennanp
X_0715_ Tile_X1Y0_S4BEG[0] _1179_/X VPWR VGND sg13cmos5l_buf_1
XANTENNA_3460 Tile_X0Y0_FrameData[8] VPWR VGND sg13cmos5l_antennanp
XANTENNA_3471 Tile_X0Y0_FrameData[8] VPWR VGND sg13cmos5l_antennanp
XANTENNA_3482 Tile_X0Y0_FrameData[8] VPWR VGND sg13cmos5l_antennanp
X_0646_ _0646_/L_HI VPWR VGND sg13cmos5l_tiehi
XANTENNA_2770 Tile_X0Y0_FrameData[14] VPWR VGND sg13cmos5l_antennanp
XANTENNA_3493 Tile_X0Y0_FrameData[8] VPWR VGND sg13cmos5l_antennanp
X_0577_ _0577_/Q Tile_X0Y0_UserCLK NPU_RDATA5 _0644_/L_HI VPWR VGND sg13cmos5l_dfrbpq_1
XFILLER_6_2222 VPWR VGND sg13cmos5l_decap_8
XANTENNA_2781 Tile_X0Y0_FrameData[16] VPWR VGND sg13cmos5l_antennanp
XANTENNA_2792 Tile_X0Y0_FrameData[16] VPWR VGND sg13cmos5l_antennanp
XFILLER_6_2299 VPWR VGND sg13cmos5l_decap_8
XANTENNA__1015__X Tile_X0Y0_S2BEG[0] VPWR VGND sg13cmos5l_antennanp
X_1129_ _1129_/X Tile_X4Y0_N1END[1] Tile_X4Y0_N2MID[1] Tile_X4Y0_N2MID[6] Tile_X4Y0_N2END[6]
+ _0509_/Q _0508_/Q VPWR VGND sg13cmos5l_mux4_1
XFILLER_15_14 VPWR VGND sg13cmos5l_decap_8
XANTENNA__0854__X Tile_X4Y0_FrameStrobe_O[11] VPWR VGND sg13cmos5l_antennanp
XFILLER_13_2706 VPWR VGND sg13cmos5l_decap_8
XFILLER_11_2485 VPWR VGND sg13cmos5l_decap_8
XFILLER_11_1795 VPWR VGND sg13cmos5l_decap_8
XFILLER_7_1307 VPWR VGND sg13cmos5l_fill_1
XFILLER_2_2664 VPWR VGND sg13cmos5l_decap_8
XFILLER_2_2686 VPWR VGND sg13cmos5l_decap_8
XFILLER_2_2675 VPWR VGND sg13cmos5l_fill_1
XANTENNA_911 Tile_X0Y0_FrameData[27] VPWR VGND sg13cmos5l_antennanp
XANTENNA_900 Tile_X0Y0_FrameData[27] VPWR VGND sg13cmos5l_antennanp
XFILLER_16_157 VPWR VGND sg13cmos5l_decap_8
XANTENNA__0764__X Tile_X3Y0_S2BEG[1] VPWR VGND sg13cmos5l_antennanp
XANTENNA_944 Tile_X0Y0_FrameData[28] VPWR VGND sg13cmos5l_antennanp
XANTENNA_933 Tile_X0Y0_FrameData[28] VPWR VGND sg13cmos5l_antennanp
XANTENNA_922 Tile_X0Y0_FrameData[27] VPWR VGND sg13cmos5l_antennanp
XANTENNA_988 Tile_X0Y0_FrameData[28] VPWR VGND sg13cmos5l_antennanp
XANTENNA_977 Tile_X0Y0_FrameData[28] VPWR VGND sg13cmos5l_antennanp
XANTENNA_966 Tile_X0Y0_FrameData[28] VPWR VGND sg13cmos5l_antennanp
XANTENNA_955 Tile_X0Y0_FrameData[28] VPWR VGND sg13cmos5l_antennanp
XANTENNA_999 Tile_X0Y0_FrameData[28] VPWR VGND sg13cmos5l_antennanp
XFILLER_16_2374 VPWR VGND sg13cmos5l_decap_8
XFILLER_9_857 VPWR VGND sg13cmos5l_fill_2
XFILLER_16_1673 VPWR VGND sg13cmos5l_decap_8
XFILLER_16_1651 VPWR VGND sg13cmos5l_fill_1
XFILLER_12_1537 VPWR VGND sg13cmos5l_decap_8
X_0500_ _0500_/Q Tile_X0Y0_FrameData[5] VGND VPWR Tile_X3Y0_FrameStrobe[2] latch
XANTENNA_2000 Tile_X0Y0_FrameData[6] VPWR VGND sg13cmos5l_antennanp
XANTENNA_2011 Tile_X0Y0_FrameData[6] VPWR VGND sg13cmos5l_antennanp
XANTENNA_2022 Tile_X0Y0_FrameData[6] VPWR VGND sg13cmos5l_antennanp
XANTENNA_2033 Tile_X0Y0_FrameData[6] VPWR VGND sg13cmos5l_antennanp
XFILLER_4_562 VPWR VGND sg13cmos5l_decap_8
XANTENNA_1310 Tile_X0Y0_FrameData[30] VPWR VGND sg13cmos5l_antennanp
XANTENNA_1321 Tile_X0Y0_FrameData[30] VPWR VGND sg13cmos5l_antennanp
XANTENNA_2044 Tile_X0Y0_FrameData[6] VPWR VGND sg13cmos5l_antennanp
XANTENNA_2055 Tile_X0Y0_FrameData[6] VPWR VGND sg13cmos5l_antennanp
XANTENNA_2066 Tile_X0Y0_FrameData[6] VPWR VGND sg13cmos5l_antennanp
X_0431_ _0431_/Q Tile_X0Y0_FrameData[10] VGND VPWR Tile_X3Y0_FrameStrobe[0] latch
XANTENNA__0939__X Tile_X2Y0_FrameStrobe_O[4] VPWR VGND sg13cmos5l_antennanp
XANTENNA_1332 Tile_X0Y0_FrameData[30] VPWR VGND sg13cmos5l_antennanp
XANTENNA_1343 Tile_X0Y0_FrameData[30] VPWR VGND sg13cmos5l_antennanp
XANTENNA_1354 Tile_X0Y0_FrameData[30] VPWR VGND sg13cmos5l_antennanp
XANTENNA_2077 Tile_X0Y0_FrameData[6] VPWR VGND sg13cmos5l_antennanp
XANTENNA_2088 Tile_X0Y0_FrameData[6] VPWR VGND sg13cmos5l_antennanp
XANTENNA_2099 Tile_X0Y0_FrameData[6] VPWR VGND sg13cmos5l_antennanp
X_0362_ _0362_/Q Tile_X0Y0_FrameData[15] VGND VPWR Tile_X2Y0_FrameStrobe[1] latch
XANTENNA_1365 Tile_X0Y0_FrameData[31] VPWR VGND sg13cmos5l_antennanp
XANTENNA_1376 Tile_X0Y0_FrameData[31] VPWR VGND sg13cmos5l_antennanp
XANTENNA_1387 Tile_X0Y0_FrameData[31] VPWR VGND sg13cmos5l_antennanp
XANTENNA_1398 Tile_X0Y0_FrameData[31] VPWR VGND sg13cmos5l_antennanp
XFILLER_7_1863 VPWR VGND sg13cmos5l_fill_2
XFILLER_3_1705 VPWR VGND sg13cmos5l_decap_8
X_0293_ _0293_/Q Tile_X0Y0_FrameData[4] VGND VPWR Tile_X1Y0_FrameStrobe[2] latch
XFILLER_7_1896 VPWR VGND sg13cmos5l_fill_1
XFILLER_15_1172 VPWR VGND sg13cmos5l_decap_8
XFILLER_7_70 VPWR VGND sg13cmos5l_decap_8
XFILLER_8_2317 VPWR VGND sg13cmos5l_decap_8
XANTENNA_3290 Tile_X0Y0_FrameData[20] VPWR VGND sg13cmos5l_antennanp
X_0629_ _0629_/L_HI VPWR VGND sg13cmos5l_tiehi
XFILLER_8_1605 VPWR VGND sg13cmos5l_decap_8
XANTENNA__0849__X Tile_X4Y0_FrameStrobe_O[6] VPWR VGND sg13cmos5l_antennanp
XFILLER_8_1638 VPWR VGND sg13cmos5l_fill_1
XANTENNA_207 Tile_X0Y0_FrameData[10] VPWR VGND sg13cmos5l_antennanp
XANTENNA_218 Tile_X0Y0_FrameData[10] VPWR VGND sg13cmos5l_antennanp
XANTENNA_229 Tile_X0Y0_FrameData[10] VPWR VGND sg13cmos5l_antennanp
XFILLER_14_639 VPWR VGND sg13cmos5l_decap_8
XFILLER_13_105 VPWR VGND sg13cmos5l_decap_8
XANTENNA__0533__Q NPU_WDATA9 VPWR VGND sg13cmos5l_antennanp
XFILLER_13_1824 VPWR VGND sg13cmos5l_decap_8
XFILLER_6_849 VPWR VGND sg13cmos5l_fill_1
XFILLER_11_2282 VPWR VGND sg13cmos5l_decap_8
XFILLER_11_1592 VPWR VGND sg13cmos5l_decap_8
XFILLER_3_28 VPWR VGND sg13cmos5l_decap_8
XANTENNA__0759__X Tile_X3Y0_S1BEG[0] VPWR VGND sg13cmos5l_antennanp
XFILLER_7_1115 VPWR VGND sg13cmos5l_decap_8
XFILLER_1_576 VPWR VGND sg13cmos5l_decap_8
XFILLER_2_1793 VPWR VGND sg13cmos5l_fill_2
XANTENNA_763 Tile_X0Y0_FrameData[25] VPWR VGND sg13cmos5l_antennanp
XANTENNA_752 Tile_X0Y0_FrameData[25] VPWR VGND sg13cmos5l_antennanp
XANTENNA_741 Tile_X0Y0_FrameData[25] VPWR VGND sg13cmos5l_antennanp
XANTENNA_730 Tile_X0Y0_FrameData[25] VPWR VGND sg13cmos5l_antennanp
XANTENNA_796 Tile_X0Y0_FrameData[26] VPWR VGND sg13cmos5l_antennanp
XANTENNA_785 Tile_X0Y0_FrameData[26] VPWR VGND sg13cmos5l_antennanp
XANTENNA_774 Tile_X0Y0_FrameData[26] VPWR VGND sg13cmos5l_antennanp
X_0980_ Tile_X0Y0_SS4BEG[5] _1160_/X VPWR VGND sg13cmos5l_buf_1
XFILLER_13_650 VPWR VGND sg13cmos5l_decap_8
XFILLER_9_665 VPWR VGND sg13cmos5l_decap_8
XFILLER_12_182 VPWR VGND sg13cmos5l_decap_4
XFILLER_12_1356 VPWR VGND sg13cmos5l_fill_2
XFILLER_9_2626 VPWR VGND sg13cmos5l_decap_8
X_0414_ _0414_/Q Tile_X0Y0_FrameData[27] VGND VPWR Tile_X3Y0_FrameStrobe[0] latch
XANTENNA_1140 Tile_X0Y0_FrameData[2] VPWR VGND sg13cmos5l_antennanp
XANTENNA_1151 Tile_X0Y0_FrameData[2] VPWR VGND sg13cmos5l_antennanp
XANTENNA_1162 Tile_X0Y0_FrameData[30] VPWR VGND sg13cmos5l_antennanp
XANTENNA_1173 Tile_X0Y0_FrameData[30] VPWR VGND sg13cmos5l_antennanp
XANTENNA_1184 Tile_X0Y0_FrameData[30] VPWR VGND sg13cmos5l_antennanp
XANTENNA_1195 Tile_X0Y0_FrameData[30] VPWR VGND sg13cmos5l_antennanp
X_0345_ _0345_/Q Tile_X0Y0_FrameData[0] VGND VPWR Tile_X2Y0_FrameStrobe[0] latch
XFILLER_7_2394 VPWR VGND sg13cmos5l_decap_8
XFILLER_3_2236 VPWR VGND sg13cmos5l_decap_8
X_0276_ _0276_/Q Tile_X0Y0_FrameData[21] VGND VPWR Tile_X1Y0_FrameStrobe[2] latch
XFILLER_3_1568 VPWR VGND sg13cmos5l_fill_1
XFILLER_10_119 VPWR VGND sg13cmos5l_decap_8
XFILLER_12_2591 VPWR VGND sg13cmos5l_decap_8
XFILLER_8_2147 VPWR VGND sg13cmos5l_decap_8
XFILLER_3_2792 VPWR VGND sg13cmos5l_fill_2
XANTENNA__0528__Q NPU_WDATA4 VPWR VGND sg13cmos5l_antennanp
XFILLER_10_620 VPWR VGND sg13cmos5l_decap_8
XFILLER_13_2344 VPWR VGND sg13cmos5l_decap_8
XFILLER_13_1621 VPWR VGND sg13cmos5l_decap_8
XFILLER_6_635 VPWR VGND sg13cmos5l_decap_8
XFILLER_10_675 VPWR VGND sg13cmos5l_decap_8
XFILLER_13_1698 VPWR VGND sg13cmos5l_decap_8
XFILLER_8_2692 VPWR VGND sg13cmos5l_decap_8
XFILLER_4_2534 VPWR VGND sg13cmos5l_decap_8
X_0130_ _0130_/Q Tile_X0Y0_FrameData[23] VGND VPWR Tile_X0Y0_FrameStrobe[1] latch
XFILLER_0_2409 VPWR VGND sg13cmos5l_decap_8
XANTENNA_571 Tile_X0Y0_FrameData[23] VPWR VGND sg13cmos5l_antennanp
XANTENNA_560 Tile_X0Y0_FrameData[23] VPWR VGND sg13cmos5l_antennanp
XANTENNA__0952__X Tile_X2Y0_FrameStrobe_O[17] VPWR VGND sg13cmos5l_antennanp
XANTENNA_593 Tile_X0Y0_FrameData[23] VPWR VGND sg13cmos5l_antennanp
XANTENNA_582 Tile_X0Y0_FrameData[23] VPWR VGND sg13cmos5l_antennanp
X_0963_ Tile_X1Y0_FrameStrobe_O[8] Tile_X1Y0_FrameStrobe[8] VPWR VGND sg13cmos5l_buf_1
X_0894_ Tile_X2Y0_S4BEG[11] _1230_/X VPWR VGND sg13cmos5l_buf_1
XFILLER_12_1175 VPWR VGND sg13cmos5l_decap_8
XFILLER_9_1711 VPWR VGND sg13cmos5l_decap_8
XFILLER_9_2456 VPWR VGND sg13cmos5l_decap_8
XFILLER_9_1788 VPWR VGND sg13cmos5l_decap_8
X_0328_ _0328_/Q Tile_X0Y0_FrameData[17] VGND VPWR Tile_X2Y0_FrameStrobe[0] latch
X_0259_ _0259_/Q Tile_X0Y0_FrameData[6] VGND VPWR Tile_X1Y0_FrameStrobe[1] latch
XANTENNA__1023__X Tile_X0Y0_S1BEG[0] VPWR VGND sg13cmos5l_antennanp
XFILLER_12_929 VPWR VGND sg13cmos5l_fill_1
XANTENNA__0862__X Tile_X4Y0_FrameStrobe_O[19] VPWR VGND sg13cmos5l_antennanp
XFILLER_14_2686 VPWR VGND sg13cmos5l_decap_8
XFILLER_10_2506 VPWR VGND sg13cmos5l_decap_8
XFILLER_14_1996 VPWR VGND sg13cmos5l_fill_1
XANTENNA_1909 Tile_X0Y0_FrameData[5] VPWR VGND sg13cmos5l_antennanp
XFILLER_8_1210 VPWR VGND sg13cmos5l_decap_8
XFILLER_15_734 VPWR VGND sg13cmos5l_decap_8
XANTENNA__0772__X Tile_X3Y0_S2BEGb[1] VPWR VGND sg13cmos5l_antennanp
XFILLER_9_49 VPWR VGND sg13cmos5l_decap_8
XFILLER_15_1738 VPWR VGND sg13cmos5l_decap_8
XFILLER_13_2152 VPWR VGND sg13cmos5l_decap_8
XFILLER_13_91 VPWR VGND sg13cmos5l_decap_8
XFILLER_10_483 VPWR VGND sg13cmos5l_fill_2
XANTENNA_3801 Tile_X0Y0_FrameData[18] VPWR VGND sg13cmos5l_antennanp
XANTENNA_3812 Tile_X0Y0_FrameData[18] VPWR VGND sg13cmos5l_antennanp
XANTENNA_3823 Tile_X0Y0_FrameData[18] VPWR VGND sg13cmos5l_antennanp
XFILLER_13_1495 VPWR VGND sg13cmos5l_decap_8
XANTENNA_3834 Tile_X0Y0_FrameData[18] VPWR VGND sg13cmos5l_antennanp
XANTENNA_3845 Tile_X0Y0_FrameData[18] VPWR VGND sg13cmos5l_antennanp
XANTENNA_3856 Tile_X0Y0_FrameData[18] VPWR VGND sg13cmos5l_antennanp
XANTENNA_3867 Tile_X0Y0_FrameData[18] VPWR VGND sg13cmos5l_antennanp
XANTENNA_3878 Tile_X0Y0_FrameData[18] VPWR VGND sg13cmos5l_antennanp
XANTENNA_3889 Tile_X0Y0_FrameData[18] VPWR VGND sg13cmos5l_antennanp
X_1231_ _1231_/X Tile_X2Y0_N2MID[4] Tile_X2Y0_N4END[3] Tile_X2Y0_NN4END[12] _0580_/Q
+ _0369_/Q _0368_/Q VPWR VGND sg13cmos5l_mux4_1
XANTENNA__0947__X Tile_X2Y0_FrameStrobe_O[12] VPWR VGND sg13cmos5l_antennanp
XFILLER_4_2353 VPWR VGND sg13cmos5l_decap_8
X_1162_ _1162_/X Tile_X0Y0_N2END[7] Tile_X0Y0_N4END[7] Tile_X0Y0_NN4END[8] _0600_/Q
+ _0139_/Q _0138_/Q VPWR VGND sg13cmos5l_mux4_1
XFILLER_4_2397 VPWR VGND sg13cmos5l_fill_1
XFILLER_4_1663 VPWR VGND sg13cmos5l_decap_8
X_0113_ _0113_/Q Tile_X0Y0_FrameData[8] VGND VPWR Tile_X0Y0_FrameStrobe[0] latch
X_1093_ _1093_/X Tile_X3Y0_N1END[1] Tile_X3Y0_N2MID[2] Tile_X3Y0_N2MID[5] Tile_X3Y0_N2END[2]
+ _0415_/Q _0414_/Q VPWR VGND sg13cmos5l_mux4_1
XANTENNA_390 Tile_X0Y0_FrameData[22] VPWR VGND sg13cmos5l_antennanp
X_0946_ Tile_X2Y0_FrameStrobe_O[11] Tile_X2Y0_FrameStrobe[11] VPWR VGND sg13cmos5l_buf_1
XFILLER_14_1237 VPWR VGND sg13cmos5l_decap_8
X_0877_ Tile_X2Y0_S2BEGb[2] _1213_/X VPWR VGND sg13cmos5l_buf_1
XANTENNA__1018__X Tile_X0Y0_S2BEG[3] VPWR VGND sg13cmos5l_antennanp
XANTENNA__0857__X Tile_X4Y0_FrameStrobe_O[14] VPWR VGND sg13cmos5l_antennanp
XFILLER_5_1438 VPWR VGND sg13cmos5l_fill_2
XFILLER_16_2704 VPWR VGND sg13cmos5l_decap_8
XFILLER_14_2450 VPWR VGND sg13cmos5l_decap_8
XFILLER_10_2303 VPWR VGND sg13cmos5l_decap_8
XFILLER_14_1760 VPWR VGND sg13cmos5l_decap_8
XANTENNA_3108 Tile_X0Y0_FrameData[19] VPWR VGND sg13cmos5l_antennanp
XANTENNA__0541__Q NPU_WDATA17 VPWR VGND sg13cmos5l_antennanp
XANTENNA_2407 Tile_X0Y0_FrameData[11] VPWR VGND sg13cmos5l_antennanp
XANTENNA_3119 Tile_X0Y0_FrameData[19] VPWR VGND sg13cmos5l_antennanp
XFILLER_3_424 VPWR VGND sg13cmos5l_fill_1
XFILLER_10_1657 VPWR VGND sg13cmos5l_decap_8
XANTENNA_2418 Tile_X0Y0_FrameData[12] VPWR VGND sg13cmos5l_antennanp
XANTENNA_2429 Tile_X0Y0_FrameData[12] VPWR VGND sg13cmos5l_antennanp
XANTENNA_1706 Tile_X0Y0_FrameData[4] VPWR VGND sg13cmos5l_antennanp
XANTENNA_1717 Tile_X0Y0_FrameData[4] VPWR VGND sg13cmos5l_antennanp
XANTENNA_1728 Tile_X0Y0_FrameData[4] VPWR VGND sg13cmos5l_antennanp
XANTENNA_1739 Tile_X0Y0_FrameData[4] VPWR VGND sg13cmos5l_antennanp
XANTENNA__0767__X Tile_X3Y0_S2BEG[4] VPWR VGND sg13cmos5l_antennanp
XFILLER_5_2651 VPWR VGND sg13cmos5l_decap_8
XFILLER_8_1095 VPWR VGND sg13cmos5l_decap_8
XFILLER_1_2559 VPWR VGND sg13cmos5l_decap_8
XFILLER_15_2247 VPWR VGND sg13cmos5l_decap_8
X_0800_ Tile_X3Y0_SS4BEG[5] _1280_/X VPWR VGND sg13cmos5l_buf_1
XFILLER_15_1535 VPWR VGND sg13cmos5l_decap_8
X_0731_ Tile_X1Y0_SS4BEG[0] _1195_/X VPWR VGND sg13cmos5l_buf_1
XANTENNA_3620 Tile_X0Y0_N2END[6] VPWR VGND sg13cmos5l_antennanp
XANTENNA_3631 Tile_X0Y0_N4END[1] VPWR VGND sg13cmos5l_antennanp
X_0662_ _0662_/L_HI VPWR VGND sg13cmos5l_tiehi
XANTENNA_3642 Tile_X0Y0_N4END[1] VPWR VGND sg13cmos5l_antennanp
XANTENNA_3653 Tile_X0Y0_N4END[2] VPWR VGND sg13cmos5l_antennanp
XANTENNA_3664 Tile_X1Y0_N1END[0] VPWR VGND sg13cmos5l_antennanp
X_0593_ _0593_/Q Tile_X0Y0_UserCLK NPU_RDATA21 _0609_/L_HI VPWR VGND sg13cmos5l_dfrbpq_1
XANTENNA_2930 Tile_X0Y0_FrameData[17] VPWR VGND sg13cmos5l_antennanp
XANTENNA_2941 Tile_X0Y0_FrameData[19] VPWR VGND sg13cmos5l_antennanp
XANTENNA_2952 Tile_X0Y0_FrameData[19] VPWR VGND sg13cmos5l_antennanp
XANTENNA_2963 Tile_X0Y0_FrameData[19] VPWR VGND sg13cmos5l_antennanp
XANTENNA_3675 Tile_X1Y0_N2END[3] VPWR VGND sg13cmos5l_antennanp
XANTENNA_3686 Tile_X1Y0_N4END[1] VPWR VGND sg13cmos5l_antennanp
XANTENNA_3697 Tile_X1Y0_N4END[2] VPWR VGND sg13cmos5l_antennanp
XFILLER_3_991 VPWR VGND sg13cmos5l_fill_1
XANTENNA_2974 Tile_X0Y0_FrameData[19] VPWR VGND sg13cmos5l_antennanp
XANTENNA_2985 Tile_X0Y0_FrameData[19] VPWR VGND sg13cmos5l_antennanp
XANTENNA_2996 Tile_X0Y0_FrameData[19] VPWR VGND sg13cmos5l_antennanp
XFILLER_6_2437 VPWR VGND sg13cmos5l_decap_8
X_1214_ _1214_/X Tile_X2Y0_N1END[3] Tile_X2Y0_N2MID[3] Tile_X2Y0_N2END[4] _0583_/Q
+ _0403_/Q _0402_/Q VPWR VGND sg13cmos5l_mux4_1
XFILLER_6_1769 VPWR VGND sg13cmos5l_decap_8
X_1145_ _1145_/X Tile_X0Y0_N2MID[6] Tile_X0Y0_N4END[9] Tile_X0Y0_NN4END[6] _0600_/Q
+ _0173_/Q _0172_/Q VPWR VGND sg13cmos5l_mux4_1
X_1076_ Tile_X4Y0_SS4BEG[13] Tile_X4Y0_NN4END[2] VPWR VGND sg13cmos5l_buf_1
XFILLER_15_2792 VPWR VGND sg13cmos5l_fill_1
XFILLER_11_1900 VPWR VGND sg13cmos5l_fill_2
X_0929_ Tile_X3Y0_FrameStrobe_O[14] Tile_X3Y0_FrameStrobe[14] VPWR VGND sg13cmos5l_buf_1
XFILLER_14_1089 VPWR VGND sg13cmos5l_decap_8
XFILLER_11_2667 VPWR VGND sg13cmos5l_decap_8
XFILLER_9_2050 VPWR VGND sg13cmos5l_fill_2
XFILLER_0_2581 VPWR VGND sg13cmos5l_decap_8
XANTENNA__0536__Q NPU_WDATA12 VPWR VGND sg13cmos5l_antennanp
XFILLER_12_501 VPWR VGND sg13cmos5l_decap_8
XFILLER_16_2556 VPWR VGND sg13cmos5l_decap_8
XFILLER_16_1833 VPWR VGND sg13cmos5l_decap_8
XFILLER_12_578 VPWR VGND sg13cmos5l_decap_8
XFILLER_8_549 VPWR VGND sg13cmos5l_decap_8
XFILLER_12_1719 VPWR VGND sg13cmos5l_decap_8
XFILLER_10_2100 VPWR VGND sg13cmos5l_decap_8
XFILLER_6_28 VPWR VGND sg13cmos5l_decap_8
XFILLER_10_2177 VPWR VGND sg13cmos5l_decap_8
XFILLER_10_1421 VPWR VGND sg13cmos5l_fill_1
XANTENNA_2204 Tile_X0Y0_FrameData[9] VPWR VGND sg13cmos5l_antennanp
XANTENNA_2215 Tile_X0Y0_FrameData[9] VPWR VGND sg13cmos5l_antennanp
XANTENNA_1503 Tile_X0Y0_FrameData[3] VPWR VGND sg13cmos5l_antennanp
XANTENNA_2226 Tile_X0Y0_FrameData[9] VPWR VGND sg13cmos5l_antennanp
XANTENNA_2237 Tile_X0Y0_FrameData[9] VPWR VGND sg13cmos5l_antennanp
XANTENNA_2248 Tile_X0Y0_FrameData[9] VPWR VGND sg13cmos5l_antennanp
XFILLER_4_788 VPWR VGND sg13cmos5l_fill_1
XFILLER_10_70 VPWR VGND sg13cmos5l_decap_8
XANTENNA_1514 Tile_X0Y0_FrameData[3] VPWR VGND sg13cmos5l_antennanp
XANTENNA_1525 Tile_X0Y0_FrameData[3] VPWR VGND sg13cmos5l_antennanp
XANTENNA_1536 Tile_X0Y0_FrameData[3] VPWR VGND sg13cmos5l_antennanp
XANTENNA_1547 Tile_X0Y0_FrameData[3] VPWR VGND sg13cmos5l_antennanp
XANTENNA_2259 Tile_X0Y0_FrameData[9] VPWR VGND sg13cmos5l_antennanp
XFILLER_7_2735 VPWR VGND sg13cmos5l_decap_8
XANTENNA_1558 Tile_X0Y0_FrameData[3] VPWR VGND sg13cmos5l_antennanp
XANTENNA_1569 Tile_X0Y0_FrameData[3] VPWR VGND sg13cmos5l_antennanp
XFILLER_1_2323 VPWR VGND sg13cmos5l_fill_2
XFILLER_1_1655 VPWR VGND sg13cmos5l_decap_8
XFILLER_15_2044 VPWR VGND sg13cmos5l_decap_8
XFILLER_15_1332 VPWR VGND sg13cmos5l_decap_8
XANTENNA__0960__X Tile_X1Y0_FrameStrobe_O[5] VPWR VGND sg13cmos5l_antennanp
XANTENNA_4140 Tile_X1Y0_N2END[2] VPWR VGND sg13cmos5l_antennanp
XANTENNA_4151 Tile_X1Y0_NN4END[6] VPWR VGND sg13cmos5l_antennanp
X_0714_ Tile_X1Y0_S2BEGb[7] _1178_/X VPWR VGND sg13cmos5l_buf_1
X_0645_ _0645_/L_HI VPWR VGND sg13cmos5l_tiehi
XANTENNA_3450 Tile_X0Y0_FrameData[8] VPWR VGND sg13cmos5l_antennanp
XANTENNA_3461 Tile_X0Y0_FrameData[8] VPWR VGND sg13cmos5l_antennanp
XANTENNA_3472 Tile_X0Y0_FrameData[8] VPWR VGND sg13cmos5l_antennanp
XANTENNA_2760 Tile_X0Y0_FrameData[14] VPWR VGND sg13cmos5l_antennanp
XANTENNA_2771 Tile_X0Y0_FrameData[14] VPWR VGND sg13cmos5l_antennanp
XANTENNA_3483 Tile_X0Y0_FrameData[8] VPWR VGND sg13cmos5l_antennanp
XANTENNA_3494 Tile_X0Y0_FrameData[8] VPWR VGND sg13cmos5l_antennanp
X_0576_ _0576_/Q Tile_X0Y0_UserCLK NPU_RDATA4 _0646_/L_HI VPWR VGND sg13cmos5l_dfrbpq_1
XFILLER_8_1809 VPWR VGND sg13cmos5l_fill_1
XANTENNA_2782 Tile_X0Y0_FrameData[16] VPWR VGND sg13cmos5l_antennanp
XANTENNA_2793 Tile_X0Y0_FrameData[16] VPWR VGND sg13cmos5l_antennanp
XFILLER_6_1511 VPWR VGND sg13cmos5l_fill_2
XFILLER_6_2278 VPWR VGND sg13cmos5l_decap_8
XFILLER_6_1599 VPWR VGND sg13cmos5l_decap_8
X_1128_ _1128_/X Tile_X4Y0_N1END[0] Tile_X4Y0_N2MID[0] Tile_X4Y0_N2MID[7] Tile_X4Y0_N2END[7]
+ _0511_/Q _0510_/Q VPWR VGND sg13cmos5l_mux4_1
XFILLER_0_1143 VPWR VGND sg13cmos5l_fill_1
X_1059_ Tile_X4Y0_S4BEG[12] Tile_X4Y0_N4END[3] VPWR VGND sg13cmos5l_buf_1
XANTENNA__1031__X Tile_X4Y0_S2BEG[0] VPWR VGND sg13cmos5l_antennanp
XFILLER_16_1107 VPWR VGND sg13cmos5l_fill_2
XANTENNA__0870__X Tile_X2Y0_S2BEG[3] VPWR VGND sg13cmos5l_antennanp
XFILLER_5_508 VPWR VGND sg13cmos5l_fill_1
XFILLER_11_2464 VPWR VGND sg13cmos5l_decap_8
XFILLER_11_1774 VPWR VGND sg13cmos5l_decap_8
XFILLER_1_769 VPWR VGND sg13cmos5l_fill_1
XFILLER_0_257 VPWR VGND sg13cmos5l_fill_2
XFILLER_9_1190 VPWR VGND sg13cmos5l_decap_8
XFILLER_2_2610 VPWR VGND sg13cmos5l_fill_1
XFILLER_5_1054 VPWR VGND sg13cmos5l_fill_2
XANTENNA_912 Tile_X0Y0_FrameData[27] VPWR VGND sg13cmos5l_antennanp
XANTENNA_901 Tile_X0Y0_FrameData[27] VPWR VGND sg13cmos5l_antennanp
XFILLER_16_136 VPWR VGND sg13cmos5l_decap_8
XANTENNA_945 Tile_X0Y0_FrameData[28] VPWR VGND sg13cmos5l_antennanp
XANTENNA_934 Tile_X0Y0_FrameData[28] VPWR VGND sg13cmos5l_antennanp
XANTENNA_923 Tile_X0Y0_FrameData[27] VPWR VGND sg13cmos5l_antennanp
XANTENNA_978 Tile_X0Y0_FrameData[28] VPWR VGND sg13cmos5l_antennanp
XANTENNA_967 Tile_X0Y0_FrameData[28] VPWR VGND sg13cmos5l_antennanp
XANTENNA_956 Tile_X0Y0_FrameData[28] VPWR VGND sg13cmos5l_antennanp
XFILLER_16_2342 VPWR VGND sg13cmos5l_fill_1
XANTENNA_989 Tile_X0Y0_FrameData[28] VPWR VGND sg13cmos5l_antennanp
XFILLER_16_2353 VPWR VGND sg13cmos5l_decap_4
XANTENNA__0780__X Tile_X3Y0_S4BEG[1] VPWR VGND sg13cmos5l_antennanp
XFILLER_8_335 VPWR VGND sg13cmos5l_fill_2
XFILLER_12_2239 VPWR VGND sg13cmos5l_decap_8
XFILLER_12_1516 VPWR VGND sg13cmos5l_decap_8
XFILLER_4_541 VPWR VGND sg13cmos5l_decap_8
XANTENNA_2001 Tile_X0Y0_FrameData[6] VPWR VGND sg13cmos5l_antennanp
XANTENNA_2012 Tile_X0Y0_FrameData[6] VPWR VGND sg13cmos5l_antennanp
XANTENNA_2023 Tile_X0Y0_FrameData[6] VPWR VGND sg13cmos5l_antennanp
XANTENNA_1300 Tile_X0Y0_FrameData[30] VPWR VGND sg13cmos5l_antennanp
XANTENNA_1311 Tile_X0Y0_FrameData[30] VPWR VGND sg13cmos5l_antennanp
XANTENNA_1322 Tile_X0Y0_FrameData[30] VPWR VGND sg13cmos5l_antennanp
XANTENNA_2034 Tile_X0Y0_FrameData[6] VPWR VGND sg13cmos5l_antennanp
XANTENNA_2045 Tile_X0Y0_FrameData[6] VPWR VGND sg13cmos5l_antennanp
XANTENNA_2056 Tile_X0Y0_FrameData[6] VPWR VGND sg13cmos5l_antennanp
X_0430_ _0430_/Q Tile_X0Y0_FrameData[11] VGND VPWR Tile_X3Y0_FrameStrobe[0] latch
XANTENNA_1333 Tile_X0Y0_FrameData[30] VPWR VGND sg13cmos5l_antennanp
XANTENNA_1344 Tile_X0Y0_FrameData[30] VPWR VGND sg13cmos5l_antennanp
XANTENNA_1355 Tile_X0Y0_FrameData[30] VPWR VGND sg13cmos5l_antennanp
XANTENNA_2067 Tile_X0Y0_FrameData[6] VPWR VGND sg13cmos5l_antennanp
XANTENNA_2078 Tile_X0Y0_FrameData[6] VPWR VGND sg13cmos5l_antennanp
XANTENNA_2089 Tile_X0Y0_FrameData[6] VPWR VGND sg13cmos5l_antennanp
X_0361_ _0361_/Q Tile_X0Y0_FrameData[16] VGND VPWR Tile_X2Y0_FrameStrobe[1] latch
XANTENNA_1366 Tile_X0Y0_FrameData[31] VPWR VGND sg13cmos5l_antennanp
XANTENNA_1377 Tile_X0Y0_FrameData[31] VPWR VGND sg13cmos5l_antennanp
XANTENNA_1388 Tile_X0Y0_FrameData[31] VPWR VGND sg13cmos5l_antennanp
XANTENNA_1399 Tile_X0Y0_FrameData[31] VPWR VGND sg13cmos5l_antennanp
X_0292_ _0292_/Q Tile_X0Y0_FrameData[5] VGND VPWR Tile_X1Y0_FrameStrobe[2] latch
XANTENNA__0955__X Tile_X1Y0_FrameStrobe_O[0] VPWR VGND sg13cmos5l_antennanp
XANTENNA__0690__X Tile_X0Y0_FrameStrobe_O[3] VPWR VGND sg13cmos5l_antennanp
XFILLER_15_1151 VPWR VGND sg13cmos5l_decap_8
XFILLER_12_2773 VPWR VGND sg13cmos5l_fill_2
XANTENNA_3280 Tile_X0Y0_FrameData[20] VPWR VGND sg13cmos5l_antennanp
XANTENNA_3291 Tile_X0Y0_FrameData[20] VPWR VGND sg13cmos5l_antennanp
X_0628_ _0628_/L_HI VPWR VGND sg13cmos5l_tiehi
X_0559_ NPU_WE3 Tile_X0Y0_UserCLK _0559_/D _0668_/L_HI VPWR VGND sg13cmos5l_dfrbpq_1
XANTENNA_2590 Tile_X0Y0_FrameData[13] VPWR VGND sg13cmos5l_antennanp
XANTENNA__1026__X Tile_X0Y0_S1BEG[3] VPWR VGND sg13cmos5l_antennanp
XANTENNA__0865__X Tile_X2Y0_S1BEG[2] VPWR VGND sg13cmos5l_antennanp
XANTENNA_208 Tile_X0Y0_FrameData[10] VPWR VGND sg13cmos5l_antennanp
XANTENNA_219 Tile_X0Y0_FrameData[10] VPWR VGND sg13cmos5l_antennanp
XFILLER_14_618 VPWR VGND sg13cmos5l_decap_8
XFILLER_13_2526 VPWR VGND sg13cmos5l_fill_2
XFILLER_13_1803 VPWR VGND sg13cmos5l_decap_8
XFILLER_11_2261 VPWR VGND sg13cmos5l_decap_8
XFILLER_11_1571 VPWR VGND sg13cmos5l_decap_8
XFILLER_1_555 VPWR VGND sg13cmos5l_decap_8
XFILLER_4_2738 VPWR VGND sg13cmos5l_decap_8
XANTENNA__0775__X Tile_X3Y0_S2BEGb[4] VPWR VGND sg13cmos5l_antennanp
XANTENNA_720 Tile_X0Y0_FrameData[25] VPWR VGND sg13cmos5l_antennanp
XANTENNA_753 Tile_X0Y0_FrameData[25] VPWR VGND sg13cmos5l_antennanp
XANTENNA_742 Tile_X0Y0_FrameData[25] VPWR VGND sg13cmos5l_antennanp
XANTENNA_731 Tile_X0Y0_FrameData[25] VPWR VGND sg13cmos5l_antennanp
XANTENNA_786 Tile_X0Y0_FrameData[26] VPWR VGND sg13cmos5l_antennanp
XANTENNA_775 Tile_X0Y0_FrameData[26] VPWR VGND sg13cmos5l_antennanp
XANTENNA_764 Tile_X0Y0_FrameData[25] VPWR VGND sg13cmos5l_antennanp
XFILLER_16_91 VPWR VGND sg13cmos5l_decap_8
XANTENNA_797 Tile_X0Y0_FrameData[27] VPWR VGND sg13cmos5l_antennanp
XFILLER_9_644 VPWR VGND sg13cmos5l_decap_8
XFILLER_12_161 VPWR VGND sg13cmos5l_decap_8
XFILLER_16_1493 VPWR VGND sg13cmos5l_decap_8
XFILLER_9_2605 VPWR VGND sg13cmos5l_decap_8
XANTENNA_1130 Tile_X0Y0_FrameData[2] VPWR VGND sg13cmos5l_antennanp
X_0413_ _0413_/Q Tile_X0Y0_FrameData[28] VGND VPWR Tile_X3Y0_FrameStrobe[0] latch
XANTENNA_1141 Tile_X0Y0_FrameData[2] VPWR VGND sg13cmos5l_antennanp
XANTENNA_1152 Tile_X0Y0_FrameData[30] VPWR VGND sg13cmos5l_antennanp
XANTENNA_1163 Tile_X0Y0_FrameData[30] VPWR VGND sg13cmos5l_antennanp
XFILLER_7_2373 VPWR VGND sg13cmos5l_decap_8
XFILLER_3_2215 VPWR VGND sg13cmos5l_decap_8
XANTENNA_1174 Tile_X0Y0_FrameData[30] VPWR VGND sg13cmos5l_antennanp
XANTENNA_1185 Tile_X0Y0_FrameData[30] VPWR VGND sg13cmos5l_antennanp
XANTENNA_1196 Tile_X0Y0_FrameData[30] VPWR VGND sg13cmos5l_antennanp
X_0344_ _0344_/Q Tile_X0Y0_FrameData[1] VGND VPWR Tile_X2Y0_FrameStrobe[0] latch
X_0275_ _0275_/Q Tile_X0Y0_FrameData[22] VGND VPWR Tile_X1Y0_FrameStrobe[2] latch
XFILLER_7_1694 VPWR VGND sg13cmos5l_decap_8
XFILLER_14_2802 VPWR VGND sg13cmos5l_fill_1
XFILLER_12_49 VPWR VGND sg13cmos5l_decap_8
XANTENNA__0544__Q NPU_WDATA20 VPWR VGND sg13cmos5l_antennanp
XFILLER_13_2323 VPWR VGND sg13cmos5l_decap_8
XFILLER_13_1600 VPWR VGND sg13cmos5l_decap_8
XFILLER_6_614 VPWR VGND sg13cmos5l_decap_8
XFILLER_13_1677 VPWR VGND sg13cmos5l_decap_8
XFILLER_8_2671 VPWR VGND sg13cmos5l_decap_8
XFILLER_4_2513 VPWR VGND sg13cmos5l_decap_8
XFILLER_2_2270 VPWR VGND sg13cmos5l_decap_8
XANTENNA_561 Tile_X0Y0_FrameData[23] VPWR VGND sg13cmos5l_antennanp
XANTENNA_550 Tile_X0Y0_FrameData[23] VPWR VGND sg13cmos5l_antennanp
XANTENNA_594 Tile_X0Y0_FrameData[23] VPWR VGND sg13cmos5l_antennanp
XANTENNA_583 Tile_X0Y0_FrameData[23] VPWR VGND sg13cmos5l_antennanp
XANTENNA_572 Tile_X0Y0_FrameData[23] VPWR VGND sg13cmos5l_antennanp
X_0962_ Tile_X1Y0_FrameStrobe_O[7] Tile_X1Y0_FrameStrobe[7] VPWR VGND sg13cmos5l_buf_1
XFILLER_13_492 VPWR VGND sg13cmos5l_decap_8
X_0893_ Tile_X2Y0_S4BEG[10] _1229_/X VPWR VGND sg13cmos5l_buf_1
XFILLER_16_1290 VPWR VGND sg13cmos5l_fill_2
XFILLER_12_1154 VPWR VGND sg13cmos5l_decap_8
XFILLER_9_2435 VPWR VGND sg13cmos5l_decap_8
XFILLER_9_1767 VPWR VGND sg13cmos5l_decap_8
X_0327_ _0327_/Q Tile_X0Y0_FrameData[18] VGND VPWR Tile_X2Y0_FrameStrobe[0] latch
X_0258_ _0258_/Q Tile_X0Y0_FrameData[7] VGND VPWR Tile_X1Y0_FrameStrobe[1] latch
X_0189_ _0189_/Q Tile_X0Y0_FrameData[28] VGND VPWR Tile_X0Y0_FrameStrobe[3] latch
XFILLER_14_2665 VPWR VGND sg13cmos5l_decap_8
XFILLER_10_1806 VPWR VGND sg13cmos5l_decap_8
XFILLER_3_7 VPWR VGND sg13cmos5l_decap_8
XFILLER_4_1119 VPWR VGND sg13cmos5l_decap_8
XANTENNA__0539__Q NPU_WDATA15 VPWR VGND sg13cmos5l_antennanp
XFILLER_15_713 VPWR VGND sg13cmos5l_decap_8
XFILLER_9_28 VPWR VGND sg13cmos5l_decap_8
XFILLER_15_1717 VPWR VGND sg13cmos5l_decap_8
XFILLER_13_2131 VPWR VGND sg13cmos5l_decap_8
XFILLER_13_70 VPWR VGND sg13cmos5l_decap_8
XANTENNA_3802 Tile_X0Y0_FrameData[18] VPWR VGND sg13cmos5l_antennanp
XANTENNA_3813 Tile_X0Y0_FrameData[18] VPWR VGND sg13cmos5l_antennanp
XFILLER_6_455 VPWR VGND sg13cmos5l_fill_1
XFILLER_13_1474 VPWR VGND sg13cmos5l_decap_8
XANTENNA_3824 Tile_X0Y0_FrameData[18] VPWR VGND sg13cmos5l_antennanp
XANTENNA_3835 Tile_X0Y0_FrameData[18] VPWR VGND sg13cmos5l_antennanp
XANTENNA_3846 Tile_X0Y0_FrameData[18] VPWR VGND sg13cmos5l_antennanp
XANTENNA_3857 Tile_X0Y0_FrameData[18] VPWR VGND sg13cmos5l_antennanp
XANTENNA_3868 Tile_X0Y0_FrameData[18] VPWR VGND sg13cmos5l_antennanp
XANTENNA_3879 Tile_X0Y0_FrameData[18] VPWR VGND sg13cmos5l_antennanp
X_1230_ _1230_/X Tile_X2Y0_N2MID[3] Tile_X2Y0_N4END[4] Tile_X2Y0_NN4END[11] _0583_/Q
+ _0371_/Q _0370_/Q VPWR VGND sg13cmos5l_mux4_1
XFILLER_4_2332 VPWR VGND sg13cmos5l_decap_8
X_1161_ _1161_/X Tile_X0Y0_N2END[6] Tile_X0Y0_N4END[6] Tile_X0Y0_NN4END[9] _0601_/Q
+ _0141_/Q _0140_/Q VPWR VGND sg13cmos5l_mux4_1
X_0112_ _0112_/Q Tile_X0Y0_FrameData[9] VGND VPWR Tile_X0Y0_FrameStrobe[0] latch
XFILLER_4_1642 VPWR VGND sg13cmos5l_decap_8
X_1092_ _1092_/X Tile_X3Y0_N1END[0] Tile_X3Y0_N2MID[3] Tile_X3Y0_N2MID[4] Tile_X3Y0_N2END[3]
+ _0417_/Q _0416_/Q VPWR VGND sg13cmos5l_mux4_1
XANTENNA__0963__X Tile_X1Y0_FrameStrobe_O[8] VPWR VGND sg13cmos5l_antennanp
XANTENNA_380 Tile_X0Y0_FrameData[1] VPWR VGND sg13cmos5l_antennanp
XANTENNA_391 Tile_X0Y0_FrameData[22] VPWR VGND sg13cmos5l_antennanp
X_0945_ Tile_X2Y0_FrameStrobe_O[10] Tile_X2Y0_FrameStrobe[10] VPWR VGND sg13cmos5l_buf_1
XFILLER_14_1216 VPWR VGND sg13cmos5l_decap_8
X_0876_ Tile_X2Y0_S2BEGb[1] _1212_/X VPWR VGND sg13cmos5l_buf_1
XFILLER_9_1597 VPWR VGND sg13cmos5l_decap_8
XANTENNA__1034__X Tile_X4Y0_S2BEG[3] VPWR VGND sg13cmos5l_antennanp
XFILLER_3_1152 VPWR VGND sg13cmos5l_decap_8
XANTENNA__0873__X Tile_X2Y0_S2BEG[6] VPWR VGND sg13cmos5l_antennanp
XFILLER_12_749 VPWR VGND sg13cmos5l_decap_8
XANTENNA_3109 Tile_X0Y0_FrameData[19] VPWR VGND sg13cmos5l_antennanp
XFILLER_10_2359 VPWR VGND sg13cmos5l_decap_8
XFILLER_10_1636 VPWR VGND sg13cmos5l_decap_8
XANTENNA_2408 Tile_X0Y0_FrameData[11] VPWR VGND sg13cmos5l_antennanp
XANTENNA_2419 Tile_X0Y0_FrameData[12] VPWR VGND sg13cmos5l_antennanp
XANTENNA_1707 Tile_X0Y0_FrameData[4] VPWR VGND sg13cmos5l_antennanp
XANTENNA_1718 Tile_X0Y0_FrameData[4] VPWR VGND sg13cmos5l_antennanp
XANTENNA_1729 Tile_X0Y0_FrameData[4] VPWR VGND sg13cmos5l_antennanp
XFILLER_5_2630 VPWR VGND sg13cmos5l_decap_8
XFILLER_8_1074 VPWR VGND sg13cmos5l_decap_8
XFILLER_1_2527 VPWR VGND sg13cmos5l_decap_8
XFILLER_1_1804 VPWR VGND sg13cmos5l_fill_1
XANTENNA__0783__X Tile_X3Y0_S4BEG[4] VPWR VGND sg13cmos5l_antennanp
XFILLER_15_2226 VPWR VGND sg13cmos5l_decap_8
XFILLER_15_1514 VPWR VGND sg13cmos5l_decap_8
X_0730_ Tile_X1Y0_S4BEG[15] _1194_/X VPWR VGND sg13cmos5l_buf_1
XFILLER_11_771 VPWR VGND sg13cmos5l_fill_2
XANTENNA_3610 Tile_X0Y0_FrameData[8] VPWR VGND sg13cmos5l_antennanp
XANTENNA_3621 Tile_X0Y0_N2END[6] VPWR VGND sg13cmos5l_antennanp
X_0661_ _0661_/L_HI VPWR VGND sg13cmos5l_tiehi
XANTENNA_2920 Tile_X0Y0_FrameData[17] VPWR VGND sg13cmos5l_antennanp
XANTENNA_3632 Tile_X0Y0_N4END[1] VPWR VGND sg13cmos5l_antennanp
XANTENNA_3643 Tile_X0Y0_N4END[1] VPWR VGND sg13cmos5l_antennanp
XANTENNA_3654 Tile_X0Y0_N4END[2] VPWR VGND sg13cmos5l_antennanp
XANTENNA_3665 Tile_X1Y0_N1END[0] VPWR VGND sg13cmos5l_antennanp
X_0592_ _0592_/Q Tile_X0Y0_UserCLK NPU_RDATA20 _0608_/L_HI VPWR VGND sg13cmos5l_dfrbpq_1
XANTENNA_2931 Tile_X0Y0_FrameData[17] VPWR VGND sg13cmos5l_antennanp
XANTENNA_2942 Tile_X0Y0_FrameData[19] VPWR VGND sg13cmos5l_antennanp
XANTENNA_2953 Tile_X0Y0_FrameData[19] VPWR VGND sg13cmos5l_antennanp
XANTENNA_3676 Tile_X1Y0_N2END[3] VPWR VGND sg13cmos5l_antennanp
XANTENNA_3687 Tile_X1Y0_N4END[1] VPWR VGND sg13cmos5l_antennanp
XANTENNA_3698 Tile_X1Y0_N4END[2] VPWR VGND sg13cmos5l_antennanp
XFILLER_6_2416 VPWR VGND sg13cmos5l_decap_8
XANTENNA__0958__X Tile_X1Y0_FrameStrobe_O[3] VPWR VGND sg13cmos5l_antennanp
XANTENNA_2964 Tile_X0Y0_FrameData[19] VPWR VGND sg13cmos5l_antennanp
XANTENNA_2975 Tile_X0Y0_FrameData[19] VPWR VGND sg13cmos5l_antennanp
XANTENNA_2986 Tile_X0Y0_FrameData[19] VPWR VGND sg13cmos5l_antennanp
XANTENNA_2997 Tile_X0Y0_FrameData[19] VPWR VGND sg13cmos5l_antennanp
X_1213_ _1213_/X Tile_X2Y0_N1END[2] Tile_X2Y0_N2MID[2] Tile_X2Y0_N2END[5] _0582_/Q
+ _0405_/Q _0404_/Q VPWR VGND sg13cmos5l_mux4_1
XFILLER_6_1748 VPWR VGND sg13cmos5l_decap_8
X_1144_ _1144_/X Tile_X0Y0_N2MID[5] Tile_X0Y0_N4END[10] Tile_X0Y0_NN4END[5] _0601_/Q
+ _0175_/Q _0174_/Q VPWR VGND sg13cmos5l_mux4_1
X_1075_ Tile_X4Y0_SS4BEG[12] Tile_X4Y0_NN4END[3] VPWR VGND sg13cmos5l_buf_1
XANTENNA__0693__X Tile_X0Y0_FrameStrobe_O[6] VPWR VGND sg13cmos5l_antennanp
XFILLER_14_1057 VPWR VGND sg13cmos5l_fill_2
XFILLER_11_2646 VPWR VGND sg13cmos5l_decap_8
X_0928_ Tile_X3Y0_FrameStrobe_O[13] Tile_X3Y0_FrameStrobe[13] VPWR VGND sg13cmos5l_buf_1
X_0859_ Tile_X4Y0_FrameStrobe_O[16] Tile_X4Y0_FrameStrobe[16] VPWR VGND sg13cmos5l_buf_1
XANTENNA__1029__X Tile_X4Y0_S1BEG[2] VPWR VGND sg13cmos5l_antennanp
XFILLER_1_918 VPWR VGND sg13cmos5l_fill_2
XANTENNA__0868__X Tile_X2Y0_S2BEG[1] VPWR VGND sg13cmos5l_antennanp
XFILLER_16_2535 VPWR VGND sg13cmos5l_decap_8
XFILLER_16_1812 VPWR VGND sg13cmos5l_decap_4
XFILLER_12_557 VPWR VGND sg13cmos5l_decap_8
XFILLER_16_1889 VPWR VGND sg13cmos5l_decap_8
XANTENNA__0552__Q NPU_WDATA28 VPWR VGND sg13cmos5l_antennanp
XFILLER_10_2156 VPWR VGND sg13cmos5l_decap_8
XANTENNA_2205 Tile_X0Y0_FrameData[9] VPWR VGND sg13cmos5l_antennanp
XANTENNA_1504 Tile_X0Y0_FrameData[3] VPWR VGND sg13cmos5l_antennanp
XANTENNA_2216 Tile_X0Y0_FrameData[9] VPWR VGND sg13cmos5l_antennanp
XANTENNA_2227 Tile_X0Y0_FrameData[9] VPWR VGND sg13cmos5l_antennanp
XANTENNA_2238 Tile_X0Y0_FrameData[9] VPWR VGND sg13cmos5l_antennanp
XANTENNA_2249 Tile_X0Y0_FrameData[9] VPWR VGND sg13cmos5l_antennanp
XFILLER_7_2714 VPWR VGND sg13cmos5l_decap_8
XANTENNA__0778__X Tile_X3Y0_S2BEGb[7] VPWR VGND sg13cmos5l_antennanp
XANTENNA_1515 Tile_X0Y0_FrameData[3] VPWR VGND sg13cmos5l_antennanp
XANTENNA_1526 Tile_X0Y0_FrameData[3] VPWR VGND sg13cmos5l_antennanp
XANTENNA_1537 Tile_X0Y0_FrameData[3] VPWR VGND sg13cmos5l_antennanp
XANTENNA_1548 Tile_X0Y0_FrameData[3] VPWR VGND sg13cmos5l_antennanp
XANTENNA_1559 Tile_X0Y0_FrameData[3] VPWR VGND sg13cmos5l_antennanp
XFILLER_5_1781 VPWR VGND sg13cmos5l_fill_1
XFILLER_1_2379 VPWR VGND sg13cmos5l_fill_1
XFILLER_15_2023 VPWR VGND sg13cmos5l_decap_8
XFILLER_15_1311 VPWR VGND sg13cmos5l_decap_8
XFILLER_15_1377 VPWR VGND sg13cmos5l_decap_4
XANTENNA_4130 Tile_X2Y0_NN4END[1] VPWR VGND sg13cmos5l_antennanp
XANTENNA_4141 Tile_X1Y0_N2END[2] VPWR VGND sg13cmos5l_antennanp
X_0713_ Tile_X1Y0_S2BEGb[6] _1177_/X VPWR VGND sg13cmos5l_buf_1
XANTENNA_3440 Tile_X0Y0_FrameData[21] VPWR VGND sg13cmos5l_antennanp
XANTENNA_4152 Tile_X1Y0_NN4END[6] VPWR VGND sg13cmos5l_antennanp
X_0644_ _0644_/L_HI VPWR VGND sg13cmos5l_tiehi
XFILLER_10_2690 VPWR VGND sg13cmos5l_decap_8
XANTENNA_3451 Tile_X0Y0_FrameData[8] VPWR VGND sg13cmos5l_antennanp
XANTENNA_3462 Tile_X0Y0_FrameData[8] VPWR VGND sg13cmos5l_antennanp
XANTENNA_3473 Tile_X0Y0_FrameData[8] VPWR VGND sg13cmos5l_antennanp
XANTENNA__0688__X Tile_X0Y0_FrameStrobe_O[1] VPWR VGND sg13cmos5l_antennanp
XANTENNA_2750 Tile_X0Y0_FrameData[14] VPWR VGND sg13cmos5l_antennanp
XANTENNA_2761 Tile_X0Y0_FrameData[14] VPWR VGND sg13cmos5l_antennanp
XANTENNA_3484 Tile_X0Y0_FrameData[8] VPWR VGND sg13cmos5l_antennanp
XANTENNA_3495 Tile_X0Y0_FrameData[8] VPWR VGND sg13cmos5l_antennanp
X_0575_ _0575_/Q Tile_X0Y0_UserCLK NPU_RDATA3 _0647_/L_HI VPWR VGND sg13cmos5l_dfrbpq_1
XANTENNA_2772 Tile_X0Y0_FrameData[14] VPWR VGND sg13cmos5l_antennanp
XANTENNA_2783 Tile_X0Y0_FrameData[16] VPWR VGND sg13cmos5l_antennanp
XANTENNA_2794 Tile_X0Y0_FrameData[16] VPWR VGND sg13cmos5l_antennanp
XFILLER_6_2257 VPWR VGND sg13cmos5l_decap_8
X_1127_ _1127_/X Tile_X0Y0_N4END[12] Tile_X0Y0_N4END[15] Tile_X0Y0_NN4END[13] Tile_X0Y0_NN4END[15]
+ _0091_/Q _0202_/Q VPWR VGND sg13cmos5l_mux4_1
X_1058_ Tile_X4Y0_S4BEG[11] Tile_X4Y0_N4END[4] VPWR VGND sg13cmos5l_buf_1
XFILLER_15_49 VPWR VGND sg13cmos5l_decap_8
XFILLER_16_1119 VPWR VGND sg13cmos5l_decap_8
XFILLER_11_2443 VPWR VGND sg13cmos5l_decap_8
XFILLER_11_1753 VPWR VGND sg13cmos5l_decap_8
XFILLER_2_2622 VPWR VGND sg13cmos5l_decap_8
XANTENNA__0547__Q NPU_WDATA23 VPWR VGND sg13cmos5l_antennanp
XANTENNA_902 Tile_X0Y0_FrameData[27] VPWR VGND sg13cmos5l_antennanp
XANTENNA_935 Tile_X0Y0_FrameData[28] VPWR VGND sg13cmos5l_antennanp
XANTENNA_924 Tile_X0Y0_FrameData[27] VPWR VGND sg13cmos5l_antennanp
XANTENNA_913 Tile_X0Y0_FrameData[27] VPWR VGND sg13cmos5l_antennanp
XFILLER_2_1987 VPWR VGND sg13cmos5l_fill_2
XANTENNA_979 Tile_X0Y0_FrameData[28] VPWR VGND sg13cmos5l_antennanp
XANTENNA_968 Tile_X0Y0_FrameData[28] VPWR VGND sg13cmos5l_antennanp
XANTENNA_957 Tile_X0Y0_FrameData[28] VPWR VGND sg13cmos5l_antennanp
XANTENNA_946 Tile_X0Y0_FrameData[28] VPWR VGND sg13cmos5l_antennanp
XFILLER_12_2218 VPWR VGND sg13cmos5l_decap_8
XANTENNA_2002 Tile_X0Y0_FrameData[6] VPWR VGND sg13cmos5l_antennanp
XANTENNA_2013 Tile_X0Y0_FrameData[6] VPWR VGND sg13cmos5l_antennanp
XANTENNA_2024 Tile_X0Y0_FrameData[6] VPWR VGND sg13cmos5l_antennanp
XANTENNA_1301 Tile_X0Y0_FrameData[30] VPWR VGND sg13cmos5l_antennanp
XANTENNA_1312 Tile_X0Y0_FrameData[30] VPWR VGND sg13cmos5l_antennanp
XANTENNA_2035 Tile_X0Y0_FrameData[6] VPWR VGND sg13cmos5l_antennanp
XANTENNA_2046 Tile_X0Y0_FrameData[6] VPWR VGND sg13cmos5l_antennanp
XANTENNA_2057 Tile_X0Y0_FrameData[6] VPWR VGND sg13cmos5l_antennanp
XFILLER_4_597 VPWR VGND sg13cmos5l_decap_8
XANTENNA_1323 Tile_X0Y0_FrameData[30] VPWR VGND sg13cmos5l_antennanp
XANTENNA_1334 Tile_X0Y0_FrameData[30] VPWR VGND sg13cmos5l_antennanp
XANTENNA_1345 Tile_X0Y0_FrameData[30] VPWR VGND sg13cmos5l_antennanp
XANTENNA_2068 Tile_X0Y0_FrameData[6] VPWR VGND sg13cmos5l_antennanp
XANTENNA_2079 Tile_X0Y0_FrameData[6] VPWR VGND sg13cmos5l_antennanp
X_0360_ _0360_/Q Tile_X0Y0_FrameData[17] VGND VPWR Tile_X2Y0_FrameStrobe[1] latch
XANTENNA_1356 Tile_X0Y0_FrameData[30] VPWR VGND sg13cmos5l_antennanp
XANTENNA_1367 Tile_X0Y0_FrameData[31] VPWR VGND sg13cmos5l_antennanp
XANTENNA_1378 Tile_X0Y0_FrameData[31] VPWR VGND sg13cmos5l_antennanp
XANTENNA_1389 Tile_X0Y0_FrameData[31] VPWR VGND sg13cmos5l_antennanp
X_0291_ _0291_/Q Tile_X0Y0_FrameData[6] VGND VPWR Tile_X1Y0_FrameStrobe[2] latch
XFILLER_16_693 VPWR VGND sg13cmos5l_decap_8
XANTENNA__0971__X Tile_X1Y0_FrameStrobe_O[16] VPWR VGND sg13cmos5l_antennanp
XFILLER_15_1130 VPWR VGND sg13cmos5l_decap_8
XFILLER_12_2752 VPWR VGND sg13cmos5l_decap_8
XFILLER_11_1049 VPWR VGND sg13cmos5l_decap_8
XANTENNA_3270 Tile_X0Y0_FrameData[20] VPWR VGND sg13cmos5l_antennanp
XANTENNA_3281 Tile_X0Y0_FrameData[20] VPWR VGND sg13cmos5l_antennanp
X_0627_ _0627_/L_HI VPWR VGND sg13cmos5l_tiehi
XANTENNA_2580 Tile_X0Y0_FrameData[12] VPWR VGND sg13cmos5l_antennanp
XANTENNA_3292 Tile_X0Y0_FrameData[20] VPWR VGND sg13cmos5l_antennanp
X_0558_ NPU_WE2 Tile_X0Y0_UserCLK _0558_/D _0669_/L_HI VPWR VGND sg13cmos5l_dfrbpq_1
XANTENNA_2591 Tile_X0Y0_FrameData[13] VPWR VGND sg13cmos5l_antennanp
XANTENNA_1890 Tile_X0Y0_FrameData[5] VPWR VGND sg13cmos5l_antennanp
X_0489_ _0489_/Q Tile_X0Y0_FrameData[16] VGND VPWR Tile_X3Y0_FrameStrobe[2] latch
XANTENNA_209 Tile_X0Y0_FrameData[10] VPWR VGND sg13cmos5l_antennanp
XANTENNA__1042__X Tile_X4Y0_S2BEGb[3] VPWR VGND sg13cmos5l_antennanp
XANTENNA__0881__X Tile_X2Y0_S2BEGb[6] VPWR VGND sg13cmos5l_antennanp
XFILLER_13_2505 VPWR VGND sg13cmos5l_decap_8
XFILLER_13_2549 VPWR VGND sg13cmos5l_fill_1
XFILLER_13_1859 VPWR VGND sg13cmos5l_decap_8
XFILLER_11_2240 VPWR VGND sg13cmos5l_decap_8
XFILLER_11_1550 VPWR VGND sg13cmos5l_decap_8
XFILLER_4_2717 VPWR VGND sg13cmos5l_decap_8
XFILLER_2_2430 VPWR VGND sg13cmos5l_decap_4
XFILLER_2_1751 VPWR VGND sg13cmos5l_decap_8
XANTENNA_710 Tile_X0Y0_FrameData[25] VPWR VGND sg13cmos5l_antennanp
XANTENNA_754 Tile_X0Y0_FrameData[25] VPWR VGND sg13cmos5l_antennanp
XANTENNA_743 Tile_X0Y0_FrameData[25] VPWR VGND sg13cmos5l_antennanp
XANTENNA_732 Tile_X0Y0_FrameData[25] VPWR VGND sg13cmos5l_antennanp
XANTENNA_721 Tile_X0Y0_FrameData[25] VPWR VGND sg13cmos5l_antennanp
XFILLER_16_70 VPWR VGND sg13cmos5l_decap_8
XANTENNA__0791__X Tile_X3Y0_S4BEG[12] VPWR VGND sg13cmos5l_antennanp
XANTENNA_787 Tile_X0Y0_FrameData[26] VPWR VGND sg13cmos5l_antennanp
XANTENNA_776 Tile_X0Y0_FrameData[26] VPWR VGND sg13cmos5l_antennanp
XANTENNA_765 Tile_X0Y0_FrameData[26] VPWR VGND sg13cmos5l_antennanp
XANTENNA_798 Tile_X0Y0_FrameData[27] VPWR VGND sg13cmos5l_antennanp
XFILLER_9_623 VPWR VGND sg13cmos5l_decap_8
XFILLER_16_2184 VPWR VGND sg13cmos5l_decap_8
XFILLER_16_2173 VPWR VGND sg13cmos5l_fill_1
XFILLER_16_2162 VPWR VGND sg13cmos5l_decap_8
XFILLER_13_685 VPWR VGND sg13cmos5l_decap_8
XFILLER_12_140 VPWR VGND sg13cmos5l_decap_8
XFILLER_16_1472 VPWR VGND sg13cmos5l_decap_8
XANTENNA_1120 Tile_X0Y0_FrameData[2] VPWR VGND sg13cmos5l_antennanp
X_0412_ _0412_/Q Tile_X0Y0_FrameData[29] VGND VPWR Tile_X3Y0_FrameStrobe[0] latch
XANTENNA_1131 Tile_X0Y0_FrameData[2] VPWR VGND sg13cmos5l_antennanp
XANTENNA_1142 Tile_X0Y0_FrameData[2] VPWR VGND sg13cmos5l_antennanp
XANTENNA_1153 Tile_X0Y0_FrameData[30] VPWR VGND sg13cmos5l_antennanp
XANTENNA_1164 Tile_X0Y0_FrameData[30] VPWR VGND sg13cmos5l_antennanp
X_0343_ _0343_/Q Tile_X0Y0_FrameData[2] VGND VPWR Tile_X2Y0_FrameStrobe[0] latch
XANTENNA__0966__X Tile_X1Y0_FrameStrobe_O[11] VPWR VGND sg13cmos5l_antennanp
XANTENNA_1175 Tile_X0Y0_FrameData[30] VPWR VGND sg13cmos5l_antennanp
XANTENNA_1186 Tile_X0Y0_FrameData[30] VPWR VGND sg13cmos5l_antennanp
XANTENNA_1197 Tile_X0Y0_FrameData[30] VPWR VGND sg13cmos5l_antennanp
XFILLER_7_1673 VPWR VGND sg13cmos5l_decap_8
X_0274_ _0274_/Q Tile_X0Y0_FrameData[23] VGND VPWR Tile_X1Y0_FrameStrobe[2] latch
XFILLER_12_28 VPWR VGND sg13cmos5l_decap_8
XFILLER_12_1870 VPWR VGND sg13cmos5l_decap_4
XANTENNA__1037__X Tile_X4Y0_S2BEG[6] VPWR VGND sg13cmos5l_antennanp
XANTENNA__0876__X Tile_X2Y0_S2BEGb[1] VPWR VGND sg13cmos5l_antennanp
XFILLER_6_1183 VPWR VGND sg13cmos5l_decap_8
XFILLER_13_2302 VPWR VGND sg13cmos5l_decap_8
XFILLER_13_2379 VPWR VGND sg13cmos5l_decap_8
XFILLER_10_655 VPWR VGND sg13cmos5l_decap_8
XFILLER_13_1656 VPWR VGND sg13cmos5l_decap_8
XANTENNA__0560__Q NPU_WE4 VPWR VGND sg13cmos5l_antennanp
XFILLER_8_2650 VPWR VGND sg13cmos5l_decap_8
XANTENNA__0786__X Tile_X3Y0_S4BEG[7] VPWR VGND sg13cmos5l_antennanp
XFILLER_4_2569 VPWR VGND sg13cmos5l_decap_8
XANTENNA_562 Tile_X0Y0_FrameData[23] VPWR VGND sg13cmos5l_antennanp
XANTENNA_551 Tile_X0Y0_FrameData[23] VPWR VGND sg13cmos5l_antennanp
XANTENNA_540 Tile_X0Y0_FrameData[23] VPWR VGND sg13cmos5l_antennanp
XANTENNA_595 Tile_X0Y0_FrameData[23] VPWR VGND sg13cmos5l_antennanp
XANTENNA_584 Tile_X0Y0_FrameData[23] VPWR VGND sg13cmos5l_antennanp
XANTENNA_573 Tile_X0Y0_FrameData[23] VPWR VGND sg13cmos5l_antennanp
X_0961_ Tile_X1Y0_FrameStrobe_O[6] Tile_X1Y0_FrameStrobe[6] VPWR VGND sg13cmos5l_buf_1
XFILLER_13_471 VPWR VGND sg13cmos5l_decap_8
X_0892_ Tile_X2Y0_S4BEG[9] _1228_/X VPWR VGND sg13cmos5l_buf_1
XFILLER_12_1133 VPWR VGND sg13cmos5l_decap_8
XFILLER_9_2414 VPWR VGND sg13cmos5l_decap_8
XFILLER_9_1746 VPWR VGND sg13cmos5l_decap_8
XANTENNA__0696__X Tile_X0Y0_FrameStrobe_O[9] VPWR VGND sg13cmos5l_antennanp
X_0326_ _0326_/Q Tile_X0Y0_FrameData[19] VGND VPWR Tile_X2Y0_FrameStrobe[0] latch
XFILLER_7_2193 VPWR VGND sg13cmos5l_decap_8
X_0257_ _0257_/Q Tile_X0Y0_FrameData[8] VGND VPWR Tile_X1Y0_FrameStrobe[1] latch
X_0188_ _0188_/Q Tile_X0Y0_FrameData[29] VGND VPWR Tile_X0Y0_FrameStrobe[3] latch
XFILLER_14_2644 VPWR VGND sg13cmos5l_decap_8
XFILLER_14_1954 VPWR VGND sg13cmos5l_fill_2
XFILLER_3_607 VPWR VGND sg13cmos5l_decap_8
XFILLER_3_2591 VPWR VGND sg13cmos5l_decap_8
XANTENNA__0555__Q NPU_WDATA31 VPWR VGND sg13cmos5l_antennanp
XFILLER_15_769 VPWR VGND sg13cmos5l_decap_8
XFILLER_15_2419 VPWR VGND sg13cmos5l_decap_8
XFILLER_13_2110 VPWR VGND sg13cmos5l_decap_8
XFILLER_13_2187 VPWR VGND sg13cmos5l_decap_8
XFILLER_10_485 VPWR VGND sg13cmos5l_fill_1
XANTENNA_3803 Tile_X0Y0_FrameData[18] VPWR VGND sg13cmos5l_antennanp
XANTENNA_3814 Tile_X0Y0_FrameData[18] VPWR VGND sg13cmos5l_antennanp
XANTENNA_3825 Tile_X0Y0_FrameData[18] VPWR VGND sg13cmos5l_antennanp
XANTENNA_3836 Tile_X0Y0_FrameData[18] VPWR VGND sg13cmos5l_antennanp
XANTENNA_3847 Tile_X0Y0_FrameData[18] VPWR VGND sg13cmos5l_antennanp
XANTENNA_3858 Tile_X0Y0_FrameData[18] VPWR VGND sg13cmos5l_antennanp
XANTENNA_3869 Tile_X0Y0_FrameData[18] VPWR VGND sg13cmos5l_antennanp
XFILLER_4_2311 VPWR VGND sg13cmos5l_decap_8
X_1160_ _1160_/X Tile_X0Y0_N2END[5] Tile_X0Y0_N4END[5] Tile_X0Y0_NN4END[10] _0600_/Q
+ _0143_/Q _0142_/Q VPWR VGND sg13cmos5l_mux4_1
XFILLER_4_1621 VPWR VGND sg13cmos5l_decap_8
X_0111_ _0111_/Q Tile_X0Y0_FrameData[10] VGND VPWR Tile_X0Y0_FrameStrobe[0] latch
XFILLER_4_2388 VPWR VGND sg13cmos5l_decap_8
X_1091_ _1091_/X Tile_X3Y0_N1END[3] Tile_X3Y0_N2MID[3] Tile_X3Y0_N2MID[4] Tile_X3Y0_N2END[4]
+ _0419_/Q _0418_/Q VPWR VGND sg13cmos5l_mux4_1
XFILLER_4_1698 VPWR VGND sg13cmos5l_decap_8
XANTENNA_370 Tile_X0Y0_FrameData[1] VPWR VGND sg13cmos5l_antennanp
XANTENNA_381 Tile_X0Y0_FrameData[1] VPWR VGND sg13cmos5l_antennanp
XANTENNA_392 Tile_X0Y0_FrameData[22] VPWR VGND sg13cmos5l_antennanp
X_0944_ Tile_X2Y0_FrameStrobe_O[9] Tile_X2Y0_FrameStrobe[9] VPWR VGND sg13cmos5l_buf_1
X_0875_ Tile_X2Y0_S2BEGb[0] _1211_/X VPWR VGND sg13cmos5l_buf_1
XFILLER_9_2244 VPWR VGND sg13cmos5l_decap_8
XFILLER_9_2288 VPWR VGND sg13cmos5l_decap_8
XFILLER_9_1576 VPWR VGND sg13cmos5l_decap_8
X_0309_ _0309_/Q Tile_X0Y0_FrameData[20] VGND VPWR Tile_X1Y0_FrameStrobe[3] latch
X_1289_ _1289_/X Tile_X3Y0_N2END[6] Tile_X3Y0_N4END[14] Tile_X3Y0_NN4END[1] _0573_/Q
+ _0429_/Q _0428_/Q VPWR VGND sg13cmos5l_mux4_1
XFILLER_3_1131 VPWR VGND sg13cmos5l_decap_8
XANTENNA__1050__X Tile_X4Y0_S4BEG[3] VPWR VGND sg13cmos5l_antennanp
XFILLER_12_728 VPWR VGND sg13cmos5l_decap_8
XFILLER_10_2338 VPWR VGND sg13cmos5l_decap_8
XFILLER_14_1795 VPWR VGND sg13cmos5l_decap_8
XFILLER_10_1615 VPWR VGND sg13cmos5l_decap_8
XANTENNA_2409 Tile_X0Y0_FrameData[11] VPWR VGND sg13cmos5l_antennanp
XANTENNA_1708 Tile_X0Y0_FrameData[4] VPWR VGND sg13cmos5l_antennanp
XANTENNA_1719 Tile_X0Y0_FrameData[4] VPWR VGND sg13cmos5l_antennanp
XFILLER_5_2686 VPWR VGND sg13cmos5l_decap_8
XFILLER_1_2506 VPWR VGND sg13cmos5l_decap_8
XFILLER_15_522 VPWR VGND sg13cmos5l_decap_8
XFILLER_15_588 VPWR VGND sg13cmos5l_decap_8
XFILLER_15_2205 VPWR VGND sg13cmos5l_decap_8
XFILLER_10_282 VPWR VGND sg13cmos5l_fill_1
XANTENNA_3600 Tile_X0Y0_FrameData[8] VPWR VGND sg13cmos5l_antennanp
XANTENNA_3611 Tile_X0Y0_FrameData[8] VPWR VGND sg13cmos5l_antennanp
XANTENNA_3622 Tile_X0Y0_N2END[6] VPWR VGND sg13cmos5l_antennanp
X_0660_ _0660_/L_HI VPWR VGND sg13cmos5l_tiehi
XFILLER_13_1283 VPWR VGND sg13cmos5l_decap_8
XANTENNA_2910 Tile_X0Y0_FrameData[17] VPWR VGND sg13cmos5l_antennanp
XANTENNA_3633 Tile_X0Y0_N4END[1] VPWR VGND sg13cmos5l_antennanp
XANTENNA_3644 Tile_X0Y0_N4END[2] VPWR VGND sg13cmos5l_antennanp
XANTENNA_3655 Tile_X0Y0_N4END[2] VPWR VGND sg13cmos5l_antennanp
X_0591_ _0591_/Q Tile_X0Y0_UserCLK NPU_RDATA19 _0607_/L_HI VPWR VGND sg13cmos5l_dfrbpq_1
XANTENNA_2921 Tile_X0Y0_FrameData[17] VPWR VGND sg13cmos5l_antennanp
XANTENNA_2932 Tile_X0Y0_FrameData[17] VPWR VGND sg13cmos5l_antennanp
XANTENNA_2943 Tile_X0Y0_FrameData[19] VPWR VGND sg13cmos5l_antennanp
XANTENNA_2954 Tile_X0Y0_FrameData[19] VPWR VGND sg13cmos5l_antennanp
XANTENNA_3666 Tile_X1Y0_N1END[0] VPWR VGND sg13cmos5l_antennanp
XANTENNA_3677 Tile_X1Y0_N2END[3] VPWR VGND sg13cmos5l_antennanp
XANTENNA_3688 Tile_X1Y0_N4END[1] VPWR VGND sg13cmos5l_antennanp
XANTENNA_2965 Tile_X0Y0_FrameData[19] VPWR VGND sg13cmos5l_antennanp
XANTENNA_2976 Tile_X0Y0_FrameData[19] VPWR VGND sg13cmos5l_antennanp
XANTENNA_2987 Tile_X0Y0_FrameData[19] VPWR VGND sg13cmos5l_antennanp
XANTENNA_3699 Tile_X1Y0_N4END[2] VPWR VGND sg13cmos5l_antennanp
XANTENNA_2998 Tile_X0Y0_FrameData[19] VPWR VGND sg13cmos5l_antennanp
X_1212_ _1212_/X Tile_X2Y0_N1END[1] Tile_X2Y0_N2MID[1] Tile_X2Y0_N2END[6] _0581_/Q
+ _0407_/Q _0406_/Q VPWR VGND sg13cmos5l_mux4_1
XFILLER_6_1727 VPWR VGND sg13cmos5l_decap_8
X_1143_ _1143_/X Tile_X0Y0_N2MID[4] Tile_X0Y0_N4END[11] Tile_X0Y0_NN4END[4] _0600_/Q
+ _0177_/Q _0176_/Q VPWR VGND sg13cmos5l_mux4_1
XANTENNA__0974__X Tile_X1Y0_FrameStrobe_O[19] VPWR VGND sg13cmos5l_antennanp
X_1074_ Tile_X4Y0_SS4BEG[11] Tile_X4Y0_NN4END[4] VPWR VGND sg13cmos5l_buf_1
XFILLER_4_1473 VPWR VGND sg13cmos5l_fill_2
X_0927_ Tile_X3Y0_FrameStrobe_O[12] Tile_X3Y0_FrameStrobe[12] VPWR VGND sg13cmos5l_buf_1
XFILLER_11_2625 VPWR VGND sg13cmos5l_decap_8
XFILLER_14_1069 VPWR VGND sg13cmos5l_decap_4
X_0858_ Tile_X4Y0_FrameStrobe_O[15] Tile_X4Y0_FrameStrobe[15] VPWR VGND sg13cmos5l_buf_1
X_0789_ Tile_X3Y0_S4BEG[10] _1269_/X VPWR VGND sg13cmos5l_buf_1
XANTENNA__1045__X Tile_X4Y0_S2BEGb[6] VPWR VGND sg13cmos5l_antennanp
XANTENNA__0884__X Tile_X2Y0_S4BEG[1] VPWR VGND sg13cmos5l_antennanp
XFILLER_0_2561 VPWR VGND sg13cmos5l_fill_2
XFILLER_0_2550 VPWR VGND sg13cmos5l_decap_8
XFILLER_16_2514 VPWR VGND sg13cmos5l_decap_8
XFILLER_12_536 VPWR VGND sg13cmos5l_decap_8
XFILLER_8_529 VPWR VGND sg13cmos5l_fill_2
XFILLER_16_1868 VPWR VGND sg13cmos5l_decap_8
XFILLER_14_2282 VPWR VGND sg13cmos5l_decap_8
XFILLER_10_2135 VPWR VGND sg13cmos5l_decap_8
XFILLER_10_1401 VPWR VGND sg13cmos5l_fill_1
XFILLER_14_1592 VPWR VGND sg13cmos5l_decap_8
XANTENNA_2206 Tile_X0Y0_FrameData[9] VPWR VGND sg13cmos5l_antennanp
XANTENNA_2217 Tile_X0Y0_FrameData[9] VPWR VGND sg13cmos5l_antennanp
XANTENNA_2228 Tile_X0Y0_FrameData[9] VPWR VGND sg13cmos5l_antennanp
XANTENNA_2239 Tile_X0Y0_FrameData[9] VPWR VGND sg13cmos5l_antennanp
XANTENNA_1505 Tile_X0Y0_FrameData[3] VPWR VGND sg13cmos5l_antennanp
XANTENNA_1516 Tile_X0Y0_FrameData[3] VPWR VGND sg13cmos5l_antennanp
XANTENNA_1527 Tile_X0Y0_FrameData[3] VPWR VGND sg13cmos5l_antennanp
XANTENNA_1538 Tile_X0Y0_FrameData[3] VPWR VGND sg13cmos5l_antennanp
XANTENNA_1549 Tile_X0Y0_FrameData[3] VPWR VGND sg13cmos5l_antennanp
XFILLER_0_996 VPWR VGND sg13cmos5l_fill_1
XFILLER_5_2494 VPWR VGND sg13cmos5l_decap_8
XFILLER_1_2325 VPWR VGND sg13cmos5l_fill_1
XANTENNA__0794__X Tile_X3Y0_S4BEG[15] VPWR VGND sg13cmos5l_antennanp
XFILLER_1_2358 VPWR VGND sg13cmos5l_decap_8
XFILLER_15_2079 VPWR VGND sg13cmos5l_decap_8
XFILLER_11_580 VPWR VGND sg13cmos5l_decap_8
XANTENNA_4120 Tile_X1Y0_N4END[5] VPWR VGND sg13cmos5l_antennanp
XANTENNA_4131 Tile_X2Y0_NN4END[1] VPWR VGND sg13cmos5l_antennanp
XANTENNA_4142 Tile_X1Y0_N2END[2] VPWR VGND sg13cmos5l_antennanp
X_0712_ Tile_X1Y0_S2BEGb[5] _1176_/X VPWR VGND sg13cmos5l_buf_1
XANTENNA_3430 Tile_X0Y0_FrameData[21] VPWR VGND sg13cmos5l_antennanp
XANTENNA_4153 Tile_X1Y0_NN4END[6] VPWR VGND sg13cmos5l_antennanp
X_0643_ _0643_/L_HI VPWR VGND sg13cmos5l_tiehi
XFILLER_7_595 VPWR VGND sg13cmos5l_decap_8
XANTENNA__0969__X Tile_X1Y0_FrameStrobe_O[14] VPWR VGND sg13cmos5l_antennanp
XANTENNA_3441 Tile_X0Y0_FrameData[21] VPWR VGND sg13cmos5l_antennanp
XANTENNA_3452 Tile_X0Y0_FrameData[8] VPWR VGND sg13cmos5l_antennanp
XANTENNA_3463 Tile_X0Y0_FrameData[8] VPWR VGND sg13cmos5l_antennanp
XANTENNA_2740 Tile_X0Y0_FrameData[14] VPWR VGND sg13cmos5l_antennanp
XANTENNA_2751 Tile_X0Y0_FrameData[14] VPWR VGND sg13cmos5l_antennanp
XANTENNA_2762 Tile_X0Y0_FrameData[14] VPWR VGND sg13cmos5l_antennanp
XANTENNA_3474 Tile_X0Y0_FrameData[8] VPWR VGND sg13cmos5l_antennanp
XANTENNA_3485 Tile_X0Y0_FrameData[8] VPWR VGND sg13cmos5l_antennanp
XANTENNA_3496 Tile_X0Y0_FrameData[8] VPWR VGND sg13cmos5l_antennanp
X_0574_ _0574_/Q Tile_X0Y0_UserCLK NPU_RDATA2 _0648_/L_HI VPWR VGND sg13cmos5l_dfrbpq_1
XANTENNA_2773 Tile_X0Y0_FrameData[16] VPWR VGND sg13cmos5l_antennanp
XANTENNA_2784 Tile_X0Y0_FrameData[16] VPWR VGND sg13cmos5l_antennanp
XANTENNA_2795 Tile_X0Y0_FrameData[16] VPWR VGND sg13cmos5l_antennanp
XFILLER_6_2236 VPWR VGND sg13cmos5l_decap_8
X_1126_ _1126_/X Tile_X0Y0_N4END[14] Tile_X0Y0_N4END[15] Tile_X0Y0_NN4END[12] Tile_X0Y0_NN4END[14]
+ _0093_/Q _0092_/Q VPWR VGND sg13cmos5l_mux4_1
X_1057_ Tile_X4Y0_S4BEG[10] Tile_X4Y0_N4END[5] VPWR VGND sg13cmos5l_buf_1
XFILLER_15_28 VPWR VGND sg13cmos5l_decap_8
XFILLER_15_2591 VPWR VGND sg13cmos5l_decap_8
XFILLER_11_2422 VPWR VGND sg13cmos5l_decap_8
XFILLER_11_1732 VPWR VGND sg13cmos5l_decap_8
XFILLER_11_2499 VPWR VGND sg13cmos5l_decap_8
XANTENNA__0879__X Tile_X2Y0_S2BEGb[4] VPWR VGND sg13cmos5l_antennanp
XFILLER_1_716 VPWR VGND sg13cmos5l_fill_1
XFILLER_6_2781 VPWR VGND sg13cmos5l_fill_1
XFILLER_2_2645 VPWR VGND sg13cmos5l_fill_2
XFILLER_16_105 VPWR VGND sg13cmos5l_decap_8
XANTENNA_903 Tile_X0Y0_FrameData[27] VPWR VGND sg13cmos5l_antennanp
XANTENNA_936 Tile_X0Y0_FrameData[28] VPWR VGND sg13cmos5l_antennanp
XANTENNA_925 Tile_X0Y0_FrameData[27] VPWR VGND sg13cmos5l_antennanp
XANTENNA_914 Tile_X0Y0_FrameData[27] VPWR VGND sg13cmos5l_antennanp
XANTENNA_969 Tile_X0Y0_FrameData[28] VPWR VGND sg13cmos5l_antennanp
XANTENNA_958 Tile_X0Y0_FrameData[28] VPWR VGND sg13cmos5l_antennanp
XANTENNA_947 Tile_X0Y0_FrameData[28] VPWR VGND sg13cmos5l_antennanp
XFILLER_16_2333 VPWR VGND sg13cmos5l_decap_4
XANTENNA__0563__Q NPU_WE7 VPWR VGND sg13cmos5l_antennanp
XFILLER_16_2388 VPWR VGND sg13cmos5l_decap_8
XFILLER_16_1643 VPWR VGND sg13cmos5l_fill_2
XFILLER_16_1687 VPWR VGND sg13cmos5l_decap_8
XFILLER_14_2090 VPWR VGND sg13cmos5l_decap_8
XFILLER_10_1253 VPWR VGND sg13cmos5l_fill_1
XFILLER_10_1242 VPWR VGND sg13cmos5l_decap_8
XANTENNA__0789__X Tile_X3Y0_S4BEG[10] VPWR VGND sg13cmos5l_antennanp
XANTENNA_2003 Tile_X0Y0_FrameData[6] VPWR VGND sg13cmos5l_antennanp
XANTENNA_2014 Tile_X0Y0_FrameData[6] VPWR VGND sg13cmos5l_antennanp
XFILLER_4_576 VPWR VGND sg13cmos5l_decap_8
XANTENNA_1302 Tile_X0Y0_FrameData[30] VPWR VGND sg13cmos5l_antennanp
XANTENNA_1313 Tile_X0Y0_FrameData[30] VPWR VGND sg13cmos5l_antennanp
XANTENNA_2025 Tile_X0Y0_FrameData[6] VPWR VGND sg13cmos5l_antennanp
XANTENNA_2036 Tile_X0Y0_FrameData[6] VPWR VGND sg13cmos5l_antennanp
XANTENNA_2047 Tile_X0Y0_FrameData[6] VPWR VGND sg13cmos5l_antennanp
XFILLER_7_2523 VPWR VGND sg13cmos5l_decap_8
XANTENNA_1324 Tile_X0Y0_FrameData[30] VPWR VGND sg13cmos5l_antennanp
XANTENNA_1335 Tile_X0Y0_FrameData[30] VPWR VGND sg13cmos5l_antennanp
XANTENNA_1346 Tile_X0Y0_FrameData[30] VPWR VGND sg13cmos5l_antennanp
XANTENNA_2058 Tile_X0Y0_FrameData[6] VPWR VGND sg13cmos5l_antennanp
XANTENNA_2069 Tile_X0Y0_FrameData[6] VPWR VGND sg13cmos5l_antennanp
XFILLER_7_2534 VPWR VGND sg13cmos5l_fill_1
XANTENNA_1357 Tile_X0Y0_FrameData[30] VPWR VGND sg13cmos5l_antennanp
XANTENNA_1368 Tile_X0Y0_FrameData[31] VPWR VGND sg13cmos5l_antennanp
XANTENNA_1379 Tile_X0Y0_FrameData[31] VPWR VGND sg13cmos5l_antennanp
X_0290_ _0290_/Q Tile_X0Y0_FrameData[7] VGND VPWR Tile_X1Y0_FrameStrobe[2] latch
XFILLER_3_1719 VPWR VGND sg13cmos5l_decap_8
XFILLER_11_7 VPWR VGND sg13cmos5l_decap_8
XFILLER_5_2291 VPWR VGND sg13cmos5l_decap_8
XFILLER_1_1454 VPWR VGND sg13cmos5l_fill_1
XFILLER_16_683 VPWR VGND sg13cmos5l_decap_8
XFILLER_15_182 VPWR VGND sg13cmos5l_decap_8
XFILLER_12_2731 VPWR VGND sg13cmos5l_decap_8
XFILLER_15_1186 VPWR VGND sg13cmos5l_decap_8
XFILLER_7_84 VPWR VGND sg13cmos5l_decap_8
XANTENNA__0699__X Tile_X0Y0_FrameStrobe_O[12] VPWR VGND sg13cmos5l_antennanp
XANTENNA_3260 Tile_X0Y0_FrameData[20] VPWR VGND sg13cmos5l_antennanp
XANTENNA_3271 Tile_X0Y0_FrameData[20] VPWR VGND sg13cmos5l_antennanp
XANTENNA_3282 Tile_X0Y0_FrameData[20] VPWR VGND sg13cmos5l_antennanp
X_0626_ _0626_/L_HI VPWR VGND sg13cmos5l_tiehi
XANTENNA_2570 Tile_X0Y0_FrameData[12] VPWR VGND sg13cmos5l_antennanp
XANTENNA_3293 Tile_X0Y0_FrameData[20] VPWR VGND sg13cmos5l_antennanp
X_0557_ NPU_WE1 Tile_X0Y0_UserCLK _0557_/D _0670_/L_HI VPWR VGND sg13cmos5l_dfrbpq_1
XFILLER_8_1619 VPWR VGND sg13cmos5l_fill_2
XANTENNA_2581 Tile_X0Y0_FrameData[12] VPWR VGND sg13cmos5l_antennanp
XANTENNA_2592 Tile_X0Y0_FrameData[13] VPWR VGND sg13cmos5l_antennanp
XANTENNA_1880 Tile_X0Y0_FrameData[5] VPWR VGND sg13cmos5l_antennanp
XANTENNA_1891 Tile_X0Y0_FrameData[5] VPWR VGND sg13cmos5l_antennanp
X_0488_ _0488_/Q Tile_X0Y0_FrameData[17] VGND VPWR Tile_X3Y0_FrameStrobe[2] latch
X_1109_ _1109_/X Tile_X1Y0_N4END[13] Tile_X1Y0_N4END[14] Tile_X1Y0_NN4END[13] Tile_X1Y0_NN4END[15]
+ _0207_/Q _0206_/Q VPWR VGND sg13cmos5l_mux4_1
XFILLER_13_119 VPWR VGND sg13cmos5l_decap_8
XFILLER_13_1838 VPWR VGND sg13cmos5l_decap_8
XFILLER_11_2296 VPWR VGND sg13cmos5l_decap_8
XFILLER_7_1129 VPWR VGND sg13cmos5l_decap_8
XANTENNA__0558__Q NPU_WE2 VPWR VGND sg13cmos5l_antennanp
XFILLER_2_2453 VPWR VGND sg13cmos5l_decap_8
XFILLER_2_1730 VPWR VGND sg13cmos5l_decap_8
XANTENNA_711 Tile_X0Y0_FrameData[25] VPWR VGND sg13cmos5l_antennanp
XANTENNA_700 Tile_X0Y0_FrameData[25] VPWR VGND sg13cmos5l_antennanp
XANTENNA_744 Tile_X0Y0_FrameData[25] VPWR VGND sg13cmos5l_antennanp
XANTENNA_733 Tile_X0Y0_FrameData[25] VPWR VGND sg13cmos5l_antennanp
XANTENNA_722 Tile_X0Y0_FrameData[25] VPWR VGND sg13cmos5l_antennanp
XANTENNA_777 Tile_X0Y0_FrameData[26] VPWR VGND sg13cmos5l_antennanp
XANTENNA_766 Tile_X0Y0_FrameData[26] VPWR VGND sg13cmos5l_antennanp
XANTENNA_755 Tile_X0Y0_FrameData[25] VPWR VGND sg13cmos5l_antennanp
XFILLER_9_602 VPWR VGND sg13cmos5l_decap_8
XFILLER_16_2141 VPWR VGND sg13cmos5l_decap_8
XANTENNA_799 Tile_X0Y0_FrameData[27] VPWR VGND sg13cmos5l_antennanp
XANTENNA_788 Tile_X0Y0_FrameData[26] VPWR VGND sg13cmos5l_antennanp
XFILLER_8_112 VPWR VGND sg13cmos5l_decap_8
XFILLER_13_664 VPWR VGND sg13cmos5l_decap_8
XFILLER_16_1451 VPWR VGND sg13cmos5l_decap_8
XFILLER_9_679 VPWR VGND sg13cmos5l_decap_8
XFILLER_10_1083 VPWR VGND sg13cmos5l_decap_8
XANTENNA_1110 Tile_X0Y0_FrameData[2] VPWR VGND sg13cmos5l_antennanp
XANTENNA_1121 Tile_X0Y0_FrameData[2] VPWR VGND sg13cmos5l_antennanp
X_0411_ _0411_/Q Tile_X0Y0_FrameData[30] VGND VPWR Tile_X3Y0_FrameStrobe[0] latch
XANTENNA_1132 Tile_X0Y0_FrameData[2] VPWR VGND sg13cmos5l_antennanp
XANTENNA_1143 Tile_X0Y0_FrameData[2] VPWR VGND sg13cmos5l_antennanp
XANTENNA_1154 Tile_X0Y0_FrameData[30] VPWR VGND sg13cmos5l_antennanp
X_0342_ _0342_/Q Tile_X0Y0_FrameData[3] VGND VPWR Tile_X2Y0_FrameStrobe[0] latch
XFILLER_3_2206 VPWR VGND sg13cmos5l_decap_4
XANTENNA_1165 Tile_X0Y0_FrameData[30] VPWR VGND sg13cmos5l_antennanp
XANTENNA_1176 Tile_X0Y0_FrameData[30] VPWR VGND sg13cmos5l_antennanp
XANTENNA_1187 Tile_X0Y0_FrameData[30] VPWR VGND sg13cmos5l_antennanp
XFILLER_7_1652 VPWR VGND sg13cmos5l_decap_8
XANTENNA_1198 Tile_X0Y0_FrameData[30] VPWR VGND sg13cmos5l_antennanp
X_0273_ _0273_/Q Tile_X0Y0_FrameData[24] VGND VPWR Tile_X1Y0_FrameStrobe[2] latch
XANTENNA__0982__X Tile_X0Y0_SS4BEG[7] VPWR VGND sg13cmos5l_antennanp
XANTENNA_3090 Tile_X0Y0_FrameData[19] VPWR VGND sg13cmos5l_antennanp
X_0609_ _0609_/L_HI VPWR VGND sg13cmos5l_tiehi
XFILLER_8_2128 VPWR VGND sg13cmos5l_decap_4
XFILLER_8_1449 VPWR VGND sg13cmos5l_fill_2
XFILLER_6_1162 VPWR VGND sg13cmos5l_decap_8
XANTENNA__1053__X Tile_X4Y0_S4BEG[6] VPWR VGND sg13cmos5l_antennanp
XANTENNA__0892__X Tile_X2Y0_S4BEG[9] VPWR VGND sg13cmos5l_antennanp
XFILLER_10_634 VPWR VGND sg13cmos5l_decap_8
XFILLER_13_2358 VPWR VGND sg13cmos5l_decap_8
XFILLER_13_1635 VPWR VGND sg13cmos5l_decap_8
XFILLER_6_649 VPWR VGND sg13cmos5l_decap_8
XFILLER_10_689 VPWR VGND sg13cmos5l_decap_8
XFILLER_11_2093 VPWR VGND sg13cmos5l_decap_8
XFILLER_4_2548 VPWR VGND sg13cmos5l_decap_8
XANTENNA_552 Tile_X0Y0_FrameData[23] VPWR VGND sg13cmos5l_antennanp
XANTENNA_541 Tile_X0Y0_FrameData[23] VPWR VGND sg13cmos5l_antennanp
XANTENNA_530 Tile_X0Y0_FrameData[23] VPWR VGND sg13cmos5l_antennanp
XANTENNA_596 Tile_X0Y0_FrameData[23] VPWR VGND sg13cmos5l_antennanp
XANTENNA_585 Tile_X0Y0_FrameData[23] VPWR VGND sg13cmos5l_antennanp
XANTENNA_574 Tile_X0Y0_FrameData[23] VPWR VGND sg13cmos5l_antennanp
XANTENNA_563 Tile_X0Y0_FrameData[23] VPWR VGND sg13cmos5l_antennanp
X_0960_ Tile_X1Y0_FrameStrobe_O[5] Tile_X1Y0_FrameStrobe[5] VPWR VGND sg13cmos5l_buf_1
XFILLER_13_450 VPWR VGND sg13cmos5l_decap_8
X_0891_ Tile_X2Y0_S4BEG[8] _1227_/X VPWR VGND sg13cmos5l_buf_1
XFILLER_12_1112 VPWR VGND sg13cmos5l_decap_8
XFILLER_12_1189 VPWR VGND sg13cmos5l_decap_8
XANTENNA__0977__X Tile_X0Y0_SS4BEG[2] VPWR VGND sg13cmos5l_antennanp
XFILLER_9_1725 VPWR VGND sg13cmos5l_decap_8
XFILLER_4_63 VPWR VGND sg13cmos5l_decap_8
XFILLER_7_2183 VPWR VGND sg13cmos5l_decap_8
X_0325_ _0325_/Q Tile_X0Y0_FrameData[20] VGND VPWR Tile_X2Y0_FrameStrobe[0] latch
X_0256_ _0256_/Q Tile_X0Y0_FrameData[9] VGND VPWR Tile_X1Y0_FrameStrobe[1] latch
X_0187_ _0187_/Q Tile_X0Y0_FrameData[30] VGND VPWR Tile_X0Y0_FrameStrobe[3] latch
XFILLER_14_2623 VPWR VGND sg13cmos5l_decap_8
XFILLER_14_1977 VPWR VGND sg13cmos5l_decap_4
XANTENNA__1048__X Tile_X4Y0_S4BEG[1] VPWR VGND sg13cmos5l_antennanp
XANTENNA__0887__X Tile_X2Y0_S4BEG[4] VPWR VGND sg13cmos5l_antennanp
XFILLER_3_2570 VPWR VGND sg13cmos5l_decap_8
XFILLER_14_203 VPWR VGND sg13cmos5l_decap_8
XFILLER_15_748 VPWR VGND sg13cmos5l_decap_8
XFILLER_13_1410 VPWR VGND sg13cmos5l_fill_2
XANTENNA__0571__Q NPU_ADDR7 VPWR VGND sg13cmos5l_antennanp
XFILLER_13_2166 VPWR VGND sg13cmos5l_decap_8
XANTENNA_3804 Tile_X0Y0_FrameData[18] VPWR VGND sg13cmos5l_antennanp
XANTENNA_3815 Tile_X0Y0_FrameData[18] VPWR VGND sg13cmos5l_antennanp
XANTENNA_3826 Tile_X0Y0_FrameData[18] VPWR VGND sg13cmos5l_antennanp
XANTENNA_3837 Tile_X0Y0_FrameData[18] VPWR VGND sg13cmos5l_antennanp
XANTENNA_3848 Tile_X0Y0_FrameData[18] VPWR VGND sg13cmos5l_antennanp
XANTENNA_3859 Tile_X0Y0_FrameData[18] VPWR VGND sg13cmos5l_antennanp
XANTENNA__0797__X Tile_X3Y0_SS4BEG[2] VPWR VGND sg13cmos5l_antennanp
XFILLER_8_2492 VPWR VGND sg13cmos5l_decap_8
XFILLER_4_1600 VPWR VGND sg13cmos5l_decap_8
X_0110_ _0110_/Q Tile_X0Y0_FrameData[11] VGND VPWR Tile_X0Y0_FrameStrobe[0] latch
XFILLER_4_2367 VPWR VGND sg13cmos5l_decap_8
X_1090_ _1090_/X Tile_X3Y0_N1END[2] Tile_X3Y0_N2MID[2] Tile_X3Y0_N2MID[5] Tile_X3Y0_N2END[5]
+ _0421_/Q _0420_/Q VPWR VGND sg13cmos5l_mux4_1
XFILLER_4_1677 VPWR VGND sg13cmos5l_decap_8
XANTENNA_360 Tile_X0Y0_FrameData[1] VPWR VGND sg13cmos5l_antennanp
XANTENNA_371 Tile_X0Y0_FrameData[1] VPWR VGND sg13cmos5l_antennanp
XANTENNA_382 Tile_X0Y0_FrameData[1] VPWR VGND sg13cmos5l_antennanp
XANTENNA_393 Tile_X0Y0_FrameData[22] VPWR VGND sg13cmos5l_antennanp
X_0943_ Tile_X2Y0_FrameStrobe_O[8] Tile_X2Y0_FrameStrobe[8] VPWR VGND sg13cmos5l_buf_1
X_0874_ Tile_X2Y0_S2BEG[7] Tile_X2Y0_N2MID[0] VPWR VGND sg13cmos5l_buf_1
XFILLER_6_991 VPWR VGND sg13cmos5l_fill_1
XFILLER_9_2223 VPWR VGND sg13cmos5l_decap_8
XFILLER_9_1500 VPWR VGND sg13cmos5l_fill_1
X_0308_ _0308_/Q Tile_X0Y0_FrameData[21] VGND VPWR Tile_X1Y0_FrameStrobe[3] latch
X_1288_ _1288_/X Tile_X3Y0_N2END[5] Tile_X3Y0_N4END[13] Tile_X3Y0_NN4END[2] _0572_/Q
+ _0431_/Q _0430_/Q VPWR VGND sg13cmos5l_mux4_1
X_0239_ _0239_/Q Tile_X0Y0_FrameData[26] VGND VPWR Tile_X1Y0_FrameStrobe[1] latch
XFILLER_16_2729 VPWR VGND sg13cmos5l_fill_1
XFILLER_16_2718 VPWR VGND sg13cmos5l_decap_8
XFILLER_12_707 VPWR VGND sg13cmos5l_decap_8
XFILLER_11_239 VPWR VGND sg13cmos5l_fill_2
XFILLER_10_2317 VPWR VGND sg13cmos5l_decap_8
XFILLER_14_1774 VPWR VGND sg13cmos5l_decap_8
XFILLER_4_928 VPWR VGND sg13cmos5l_fill_2
XANTENNA_1709 Tile_X0Y0_FrameData[4] VPWR VGND sg13cmos5l_antennanp
XFILLER_5_2665 VPWR VGND sg13cmos5l_decap_8
XANTENNA__0566__Q NPU_ADDR2 VPWR VGND sg13cmos5l_antennanp
XFILLER_15_567 VPWR VGND sg13cmos5l_decap_8
XFILLER_11_751 VPWR VGND sg13cmos5l_fill_1
XFILLER_11_740 VPWR VGND sg13cmos5l_decap_8
XFILLER_15_1549 VPWR VGND sg13cmos5l_decap_8
XFILLER_13_1262 VPWR VGND sg13cmos5l_decap_8
XANTENNA_3601 Tile_X0Y0_FrameData[8] VPWR VGND sg13cmos5l_antennanp
XANTENNA_3612 Tile_X0Y0_FrameData[8] VPWR VGND sg13cmos5l_antennanp
XANTENNA_2900 Tile_X0Y0_FrameData[17] VPWR VGND sg13cmos5l_antennanp
XANTENNA_2911 Tile_X0Y0_FrameData[17] VPWR VGND sg13cmos5l_antennanp
XANTENNA_3623 Tile_X0Y0_N2END[6] VPWR VGND sg13cmos5l_antennanp
XANTENNA_3634 Tile_X0Y0_N4END[1] VPWR VGND sg13cmos5l_antennanp
XANTENNA_3645 Tile_X0Y0_N4END[2] VPWR VGND sg13cmos5l_antennanp
XANTENNA_3656 Tile_X0Y0_N4END[2] VPWR VGND sg13cmos5l_antennanp
X_0590_ _0590_/Q Tile_X0Y0_UserCLK NPU_RDATA18 _0606_/L_HI VPWR VGND sg13cmos5l_dfrbpq_1
XANTENNA_2922 Tile_X0Y0_FrameData[17] VPWR VGND sg13cmos5l_antennanp
XANTENNA_2933 Tile_X0Y0_FrameData[17] VPWR VGND sg13cmos5l_antennanp
XANTENNA_2944 Tile_X0Y0_FrameData[19] VPWR VGND sg13cmos5l_antennanp
XANTENNA_3667 Tile_X1Y0_N1END[0] VPWR VGND sg13cmos5l_antennanp
XANTENNA_3678 Tile_X1Y0_N2END[5] VPWR VGND sg13cmos5l_antennanp
XANTENNA_3689 Tile_X1Y0_N4END[1] VPWR VGND sg13cmos5l_antennanp
XANTENNA_2955 Tile_X0Y0_FrameData[19] VPWR VGND sg13cmos5l_antennanp
XANTENNA_2966 Tile_X0Y0_FrameData[19] VPWR VGND sg13cmos5l_antennanp
XANTENNA_2977 Tile_X0Y0_FrameData[19] VPWR VGND sg13cmos5l_antennanp
XFILLER_6_1706 VPWR VGND sg13cmos5l_decap_8
XANTENNA_2988 Tile_X0Y0_FrameData[19] VPWR VGND sg13cmos5l_antennanp
XANTENNA_2999 Tile_X0Y0_FrameData[19] VPWR VGND sg13cmos5l_antennanp
X_1211_ _1211_/X Tile_X2Y0_N1END[0] Tile_X2Y0_N2MID[0] Tile_X2Y0_N2END[7] _0580_/Q
+ _0409_/Q _0408_/Q VPWR VGND sg13cmos5l_mux4_1
X_1142_ _1142_/X Tile_X0Y0_N2MID[3] Tile_X0Y0_N4END[12] Tile_X0Y0_NN4END[3] _0603_/Q
+ _0179_/Q _0178_/Q VPWR VGND sg13cmos5l_mux4_1
XFILLER_1_42 VPWR VGND sg13cmos5l_decap_8
X_1073_ Tile_X4Y0_SS4BEG[10] Tile_X4Y0_NN4END[5] VPWR VGND sg13cmos5l_buf_1
XFILLER_0_1305 VPWR VGND sg13cmos5l_fill_1
XANTENNA__0990__X Tile_X0Y0_SS4BEG[15] VPWR VGND sg13cmos5l_antennanp
XANTENNA_190 Tile_X0Y0_FrameData[10] VPWR VGND sg13cmos5l_antennanp
X_0926_ Tile_X3Y0_FrameStrobe_O[11] Tile_X3Y0_FrameStrobe[11] VPWR VGND sg13cmos5l_buf_1
XFILLER_14_1037 VPWR VGND sg13cmos5l_decap_8
XFILLER_11_2604 VPWR VGND sg13cmos5l_decap_8
X_0857_ Tile_X4Y0_FrameStrobe_O[14] Tile_X4Y0_FrameStrobe[14] VPWR VGND sg13cmos5l_buf_1
X_0788_ Tile_X3Y0_S4BEG[9] _1268_/X VPWR VGND sg13cmos5l_buf_1
XFILLER_0_2540 VPWR VGND sg13cmos5l_decap_8
XANTENNA__1061__X Tile_X4Y0_S4BEG[14] VPWR VGND sg13cmos5l_antennanp
XFILLER_0_2573 VPWR VGND sg13cmos5l_decap_4
XFILLER_0_2595 VPWR VGND sg13cmos5l_decap_8
XFILLER_12_515 VPWR VGND sg13cmos5l_decap_8
XFILLER_8_508 VPWR VGND sg13cmos5l_decap_8
XFILLER_16_1847 VPWR VGND sg13cmos5l_decap_8
XFILLER_10_2114 VPWR VGND sg13cmos5l_decap_8
XFILLER_14_1571 VPWR VGND sg13cmos5l_decap_8
XANTENNA_2207 Tile_X0Y0_FrameData[9] VPWR VGND sg13cmos5l_antennanp
XANTENNA_2218 Tile_X0Y0_FrameData[9] VPWR VGND sg13cmos5l_antennanp
XANTENNA_2229 Tile_X0Y0_FrameData[9] VPWR VGND sg13cmos5l_antennanp
XANTENNA_1506 Tile_X0Y0_FrameData[3] VPWR VGND sg13cmos5l_antennanp
XANTENNA_1517 Tile_X0Y0_FrameData[3] VPWR VGND sg13cmos5l_antennanp
XANTENNA_1528 Tile_X0Y0_FrameData[3] VPWR VGND sg13cmos5l_antennanp
XFILLER_7_2749 VPWR VGND sg13cmos5l_decap_8
XFILLER_10_84 VPWR VGND sg13cmos5l_decap_8
XANTENNA_1539 Tile_X0Y0_FrameData[3] VPWR VGND sg13cmos5l_antennanp
XFILLER_5_2473 VPWR VGND sg13cmos5l_decap_8
XFILLER_5_1772 VPWR VGND sg13cmos5l_decap_8
XFILLER_1_1669 VPWR VGND sg13cmos5l_decap_8
XFILLER_15_2014 VPWR VGND sg13cmos5l_decap_4
XFILLER_15_2003 VPWR VGND sg13cmos5l_fill_2
XFILLER_15_2058 VPWR VGND sg13cmos5l_decap_8
X_0711_ Tile_X1Y0_S2BEGb[4] _1175_/X VPWR VGND sg13cmos5l_buf_1
XFILLER_7_541 VPWR VGND sg13cmos5l_decap_8
XANTENNA_4110 Tile_X1Y0_N4END[13] VPWR VGND sg13cmos5l_antennanp
XANTENNA_4121 Tile_X1Y0_N4END[5] VPWR VGND sg13cmos5l_antennanp
XANTENNA_4132 Tile_X2Y0_NN4END[1] VPWR VGND sg13cmos5l_antennanp
XANTENNA_3420 Tile_X0Y0_FrameData[21] VPWR VGND sg13cmos5l_antennanp
XANTENNA_3431 Tile_X0Y0_FrameData[21] VPWR VGND sg13cmos5l_antennanp
XANTENNA_4143 Tile_X1Y0_N2END[2] VPWR VGND sg13cmos5l_antennanp
XANTENNA_4154 Tile_X1Y0_NN4END[6] VPWR VGND sg13cmos5l_antennanp
X_0642_ _0642_/L_HI VPWR VGND sg13cmos5l_tiehi
XANTENNA_3442 Tile_X0Y0_FrameData[21] VPWR VGND sg13cmos5l_antennanp
XANTENNA_3453 Tile_X0Y0_FrameData[8] VPWR VGND sg13cmos5l_antennanp
XANTENNA_3464 Tile_X0Y0_FrameData[8] VPWR VGND sg13cmos5l_antennanp
X_0573_ _0573_/Q Tile_X0Y0_UserCLK NPU_RDATA1 _0649_/L_HI VPWR VGND sg13cmos5l_dfrbpq_1
XANTENNA_2730 Tile_X0Y0_FrameData[14] VPWR VGND sg13cmos5l_antennanp
XANTENNA_2741 Tile_X0Y0_FrameData[14] VPWR VGND sg13cmos5l_antennanp
XANTENNA_2752 Tile_X0Y0_FrameData[14] VPWR VGND sg13cmos5l_antennanp
XANTENNA_3475 Tile_X0Y0_FrameData[8] VPWR VGND sg13cmos5l_antennanp
XANTENNA_3486 Tile_X0Y0_FrameData[8] VPWR VGND sg13cmos5l_antennanp
XANTENNA_3497 Tile_X0Y0_FrameData[8] VPWR VGND sg13cmos5l_antennanp
XFILLER_6_2215 VPWR VGND sg13cmos5l_decap_8
XANTENNA_2763 Tile_X0Y0_FrameData[14] VPWR VGND sg13cmos5l_antennanp
XANTENNA_2774 Tile_X0Y0_FrameData[16] VPWR VGND sg13cmos5l_antennanp
XANTENNA_2785 Tile_X0Y0_FrameData[16] VPWR VGND sg13cmos5l_antennanp
XANTENNA_2796 Tile_X0Y0_FrameData[16] VPWR VGND sg13cmos5l_antennanp
XANTENNA__0985__X Tile_X0Y0_SS4BEG[10] VPWR VGND sg13cmos5l_antennanp
X_1125_ _1125_/X Tile_X0Y0_N4END[13] Tile_X0Y0_N4END[14] Tile_X0Y0_NN4END[13] Tile_X0Y0_NN4END[15]
+ _0095_/Q _0094_/Q VPWR VGND sg13cmos5l_mux4_1
X_1056_ Tile_X4Y0_S4BEG[9] Tile_X4Y0_N4END[6] VPWR VGND sg13cmos5l_buf_1
XFILLER_11_2401 VPWR VGND sg13cmos5l_decap_8
X_0909_ Tile_X2Y0_SS4BEG[10] _1245_/X VPWR VGND sg13cmos5l_buf_1
XFILLER_11_2478 VPWR VGND sg13cmos5l_decap_8
XFILLER_11_1711 VPWR VGND sg13cmos5l_decap_8
XFILLER_11_1788 VPWR VGND sg13cmos5l_decap_8
XANTENNA__1056__X Tile_X4Y0_S4BEG[9] VPWR VGND sg13cmos5l_antennanp
XFILLER_6_2760 VPWR VGND sg13cmos5l_decap_8
XANTENNA__0895__X Tile_X2Y0_S4BEG[12] VPWR VGND sg13cmos5l_antennanp
XFILLER_2_2679 VPWR VGND sg13cmos5l_decap_8
XFILLER_2_2657 VPWR VGND sg13cmos5l_decap_8
XANTENNA_926 Tile_X0Y0_FrameData[28] VPWR VGND sg13cmos5l_antennanp
XANTENNA_915 Tile_X0Y0_FrameData[27] VPWR VGND sg13cmos5l_antennanp
XANTENNA_904 Tile_X0Y0_FrameData[27] VPWR VGND sg13cmos5l_antennanp
XANTENNA_959 Tile_X0Y0_FrameData[28] VPWR VGND sg13cmos5l_antennanp
XANTENNA_948 Tile_X0Y0_FrameData[28] VPWR VGND sg13cmos5l_antennanp
XANTENNA_937 Tile_X0Y0_FrameData[28] VPWR VGND sg13cmos5l_antennanp
XFILLER_16_2312 VPWR VGND sg13cmos5l_decap_8
XFILLER_16_2301 VPWR VGND sg13cmos5l_fill_1
XFILLER_16_1611 VPWR VGND sg13cmos5l_fill_1
XFILLER_8_327 VPWR VGND sg13cmos5l_fill_1
XFILLER_16_2367 VPWR VGND sg13cmos5l_decap_8
XFILLER_16_1655 VPWR VGND sg13cmos5l_fill_1
XFILLER_16_1633 VPWR VGND sg13cmos5l_fill_2
XFILLER_16_1622 VPWR VGND sg13cmos5l_fill_1
XFILLER_16_1666 VPWR VGND sg13cmos5l_decap_8
XANTENNA_90 Tile_X0Y0_FrameData[0] VPWR VGND sg13cmos5l_antennanp
XANTENNA_2004 Tile_X0Y0_FrameData[6] VPWR VGND sg13cmos5l_antennanp
XANTENNA_2015 Tile_X0Y0_FrameData[6] VPWR VGND sg13cmos5l_antennanp
XFILLER_4_555 VPWR VGND sg13cmos5l_decap_8
XANTENNA_1303 Tile_X0Y0_FrameData[30] VPWR VGND sg13cmos5l_antennanp
XANTENNA_2026 Tile_X0Y0_FrameData[6] VPWR VGND sg13cmos5l_antennanp
XANTENNA_2037 Tile_X0Y0_FrameData[6] VPWR VGND sg13cmos5l_antennanp
XANTENNA_2048 Tile_X0Y0_FrameData[6] VPWR VGND sg13cmos5l_antennanp
XFILLER_7_2502 VPWR VGND sg13cmos5l_decap_8
XANTENNA_1314 Tile_X0Y0_FrameData[30] VPWR VGND sg13cmos5l_antennanp
XANTENNA_1325 Tile_X0Y0_FrameData[30] VPWR VGND sg13cmos5l_antennanp
XANTENNA_1336 Tile_X0Y0_FrameData[30] VPWR VGND sg13cmos5l_antennanp
XANTENNA_2059 Tile_X0Y0_FrameData[6] VPWR VGND sg13cmos5l_antennanp
XANTENNA_1347 Tile_X0Y0_FrameData[30] VPWR VGND sg13cmos5l_antennanp
XANTENNA_1358 Tile_X0Y0_FrameData[30] VPWR VGND sg13cmos5l_antennanp
XANTENNA_1369 Tile_X0Y0_FrameData[31] VPWR VGND sg13cmos5l_antennanp
XFILLER_0_761 VPWR VGND sg13cmos5l_fill_1
XFILLER_7_1878 VPWR VGND sg13cmos5l_fill_2
XFILLER_5_2270 VPWR VGND sg13cmos5l_decap_8
XFILLER_1_1499 VPWR VGND sg13cmos5l_fill_2
XFILLER_16_662 VPWR VGND sg13cmos5l_decap_8
XFILLER_15_161 VPWR VGND sg13cmos5l_decap_8
XFILLER_12_2710 VPWR VGND sg13cmos5l_decap_8
XFILLER_7_63 VPWR VGND sg13cmos5l_decap_8
XFILLER_15_1165 VPWR VGND sg13cmos5l_decap_8
XFILLER_12_2787 VPWR VGND sg13cmos5l_fill_1
X_0625_ _0625_/L_HI VPWR VGND sg13cmos5l_tiehi
XANTENNA_3250 Tile_X0Y0_FrameData[20] VPWR VGND sg13cmos5l_antennanp
XANTENNA_3261 Tile_X0Y0_FrameData[20] VPWR VGND sg13cmos5l_antennanp
XANTENNA_3272 Tile_X0Y0_FrameData[20] VPWR VGND sg13cmos5l_antennanp
XANTENNA_2560 Tile_X0Y0_FrameData[12] VPWR VGND sg13cmos5l_antennanp
XANTENNA_3283 Tile_X0Y0_FrameData[20] VPWR VGND sg13cmos5l_antennanp
XANTENNA_3294 Tile_X0Y0_FrameData[20] VPWR VGND sg13cmos5l_antennanp
X_0556_ NPU_WE0 Tile_X0Y0_UserCLK _0556_/D _0671_/L_HI VPWR VGND sg13cmos5l_dfrbpq_1
XANTENNA_2571 Tile_X0Y0_FrameData[12] VPWR VGND sg13cmos5l_antennanp
XANTENNA_2582 Tile_X0Y0_FrameData[12] VPWR VGND sg13cmos5l_antennanp
XANTENNA_2593 Tile_X0Y0_FrameData[13] VPWR VGND sg13cmos5l_antennanp
X_0487_ _0487_/Q Tile_X0Y0_FrameData[18] VGND VPWR Tile_X3Y0_FrameStrobe[2] latch
XANTENNA_1870 Tile_X0Y0_FrameData[5] VPWR VGND sg13cmos5l_antennanp
XANTENNA_1881 Tile_X0Y0_FrameData[5] VPWR VGND sg13cmos5l_antennanp
XANTENNA_1892 Tile_X0Y0_FrameData[5] VPWR VGND sg13cmos5l_antennanp
X_1108_ _1108_/X Tile_X1Y0_N4END[12] Tile_X1Y0_N4END[13] Tile_X1Y0_NN4END[12] Tile_X1Y0_NN4END[14]
+ _0209_/Q _0208_/Q VPWR VGND sg13cmos5l_mux4_1
X_1039_ Tile_X4Y0_S2BEGb[0] Tile_X4Y0_N2END[7] VPWR VGND sg13cmos5l_buf_1
XFILLER_13_1817 VPWR VGND sg13cmos5l_decap_8
XFILLER_11_2275 VPWR VGND sg13cmos5l_decap_8
XFILLER_11_1585 VPWR VGND sg13cmos5l_decap_8
XFILLER_7_1108 VPWR VGND sg13cmos5l_decap_8
XFILLER_1_569 VPWR VGND sg13cmos5l_decap_8
XANTENNA_701 Tile_X0Y0_FrameData[25] VPWR VGND sg13cmos5l_antennanp
XANTENNA_745 Tile_X0Y0_FrameData[25] VPWR VGND sg13cmos5l_antennanp
XANTENNA_734 Tile_X0Y0_FrameData[25] VPWR VGND sg13cmos5l_antennanp
XANTENNA_723 Tile_X0Y0_FrameData[25] VPWR VGND sg13cmos5l_antennanp
XANTENNA_712 Tile_X0Y0_FrameData[25] VPWR VGND sg13cmos5l_antennanp
XANTENNA_778 Tile_X0Y0_FrameData[26] VPWR VGND sg13cmos5l_antennanp
XANTENNA_767 Tile_X0Y0_FrameData[26] VPWR VGND sg13cmos5l_antennanp
XANTENNA_756 Tile_X0Y0_FrameData[25] VPWR VGND sg13cmos5l_antennanp
XFILLER_16_2120 VPWR VGND sg13cmos5l_decap_8
XFILLER_13_643 VPWR VGND sg13cmos5l_decap_8
XANTENNA_789 Tile_X0Y0_FrameData[26] VPWR VGND sg13cmos5l_antennanp
XFILLER_16_1430 VPWR VGND sg13cmos5l_decap_8
XFILLER_9_658 VPWR VGND sg13cmos5l_decap_8
XFILLER_12_186 VPWR VGND sg13cmos5l_fill_2
XFILLER_12_175 VPWR VGND sg13cmos5l_decap_8
XFILLER_9_2619 VPWR VGND sg13cmos5l_decap_8
XFILLER_10_1062 VPWR VGND sg13cmos5l_decap_8
XANTENNA_1100 Tile_X0Y0_FrameData[2] VPWR VGND sg13cmos5l_antennanp
XANTENNA_1111 Tile_X0Y0_FrameData[2] VPWR VGND sg13cmos5l_antennanp
X_0410_ _0410_/Q Tile_X0Y0_FrameData[31] VGND VPWR Tile_X2Y0_FrameStrobe[0] latch
XANTENNA_1122 Tile_X0Y0_FrameData[2] VPWR VGND sg13cmos5l_antennanp
XANTENNA_1133 Tile_X0Y0_FrameData[2] VPWR VGND sg13cmos5l_antennanp
XANTENNA_1144 Tile_X0Y0_FrameData[2] VPWR VGND sg13cmos5l_antennanp
XANTENNA_1155 Tile_X0Y0_FrameData[30] VPWR VGND sg13cmos5l_antennanp
X_0341_ _0341_/Q Tile_X0Y0_FrameData[4] VGND VPWR Tile_X2Y0_FrameStrobe[0] latch
XANTENNA_1166 Tile_X0Y0_FrameData[30] VPWR VGND sg13cmos5l_antennanp
XANTENNA_1177 Tile_X0Y0_FrameData[30] VPWR VGND sg13cmos5l_antennanp
XANTENNA_1188 Tile_X0Y0_FrameData[30] VPWR VGND sg13cmos5l_antennanp
XFILLER_7_2387 VPWR VGND sg13cmos5l_decap_8
XFILLER_7_1631 VPWR VGND sg13cmos5l_decap_8
XFILLER_3_2229 VPWR VGND sg13cmos5l_decap_8
XFILLER_0_591 VPWR VGND sg13cmos5l_decap_8
XANTENNA_1199 Tile_X0Y0_FrameData[30] VPWR VGND sg13cmos5l_antennanp
X_0272_ _0272_/Q Tile_X0Y0_FrameData[25] VGND VPWR Tile_X1Y0_FrameStrobe[2] latch
XFILLER_12_2584 VPWR VGND sg13cmos5l_decap_8
XANTENNA_3080 Tile_X0Y0_FrameData[19] VPWR VGND sg13cmos5l_antennanp
X_0608_ _0608_/L_HI VPWR VGND sg13cmos5l_tiehi
XANTENNA_3091 Tile_X0Y0_FrameData[19] VPWR VGND sg13cmos5l_antennanp
X_0539_ NPU_WDATA15 Tile_X0Y0_UserCLK _1111_/X _0662_/L_HI VPWR VGND sg13cmos5l_dfrbpq_1
XANTENNA_2390 Tile_X0Y0_FrameData[11] VPWR VGND sg13cmos5l_antennanp
XFILLER_6_1141 VPWR VGND sg13cmos5l_decap_8
XFILLER_3_2752 VPWR VGND sg13cmos5l_decap_8
XFILLER_2_1027 VPWR VGND sg13cmos5l_fill_1
XFILLER_2_1049 VPWR VGND sg13cmos5l_fill_1
XFILLER_13_2337 VPWR VGND sg13cmos5l_decap_8
XFILLER_10_613 VPWR VGND sg13cmos5l_decap_8
XFILLER_13_1614 VPWR VGND sg13cmos5l_decap_8
XFILLER_10_668 VPWR VGND sg13cmos5l_decap_8
XFILLER_6_628 VPWR VGND sg13cmos5l_decap_8
XFILLER_5_149 VPWR VGND sg13cmos5l_fill_1
XANTENNA__0569__Q NPU_ADDR5 VPWR VGND sg13cmos5l_antennanp
XFILLER_8_2685 VPWR VGND sg13cmos5l_decap_8
XFILLER_8_1962 VPWR VGND sg13cmos5l_fill_1
XFILLER_4_2527 VPWR VGND sg13cmos5l_decap_8
XFILLER_2_2284 VPWR VGND sg13cmos5l_decap_4
XANTENNA_553 Tile_X0Y0_FrameData[23] VPWR VGND sg13cmos5l_antennanp
XANTENNA_542 Tile_X0Y0_FrameData[23] VPWR VGND sg13cmos5l_antennanp
XANTENNA_531 Tile_X0Y0_FrameData[23] VPWR VGND sg13cmos5l_antennanp
XANTENNA_520 Tile_X0Y0_FrameData[23] VPWR VGND sg13cmos5l_antennanp
XANTENNA_586 Tile_X0Y0_FrameData[23] VPWR VGND sg13cmos5l_antennanp
XANTENNA_575 Tile_X0Y0_FrameData[23] VPWR VGND sg13cmos5l_antennanp
XANTENNA_564 Tile_X0Y0_FrameData[23] VPWR VGND sg13cmos5l_antennanp
XANTENNA_597 Tile_X0Y0_FrameData[23] VPWR VGND sg13cmos5l_antennanp
X_0890_ Tile_X2Y0_S4BEG[7] _1226_/X VPWR VGND sg13cmos5l_buf_1
XFILLER_9_499 VPWR VGND sg13cmos5l_decap_8
XFILLER_12_1168 VPWR VGND sg13cmos5l_decap_8
XFILLER_9_1704 VPWR VGND sg13cmos5l_decap_8
XFILLER_9_2449 VPWR VGND sg13cmos5l_decap_8
XFILLER_4_42 VPWR VGND sg13cmos5l_decap_8
XFILLER_4_86 VPWR VGND sg13cmos5l_fill_1
X_0324_ _0324_/Q Tile_X0Y0_FrameData[21] VGND VPWR Tile_X2Y0_FrameStrobe[0] latch
X_0255_ _0255_/Q Tile_X0Y0_FrameData[10] VGND VPWR Tile_X1Y0_FrameStrobe[1] latch
XFILLER_3_1314 VPWR VGND sg13cmos5l_fill_2
XANTENNA__0993__X Tile_X0Y0_S4BEG[2] VPWR VGND sg13cmos5l_antennanp
X_0186_ _0186_/Q Tile_X0Y0_FrameData[31] VGND VPWR Tile_X0Y0_FrameStrobe[3] latch
XFILLER_14_2602 VPWR VGND sg13cmos5l_decap_8
XFILLER_14_2679 VPWR VGND sg13cmos5l_decap_8
XFILLER_12_1691 VPWR VGND sg13cmos5l_decap_8
XFILLER_8_1203 VPWR VGND sg13cmos5l_decap_8
XANTENNA__1064__X Tile_X4Y0_SS4BEG[1] VPWR VGND sg13cmos5l_antennanp
XFILLER_15_727 VPWR VGND sg13cmos5l_decap_8
XFILLER_13_2145 VPWR VGND sg13cmos5l_decap_8
XFILLER_6_403 VPWR VGND sg13cmos5l_fill_2
XFILLER_13_84 VPWR VGND sg13cmos5l_decap_8
XFILLER_13_1433 VPWR VGND sg13cmos5l_fill_2
XFILLER_10_476 VPWR VGND sg13cmos5l_decap_8
XANTENNA_3805 Tile_X0Y0_FrameData[18] VPWR VGND sg13cmos5l_antennanp
XANTENNA_3816 Tile_X0Y0_FrameData[18] VPWR VGND sg13cmos5l_antennanp
XANTENNA_3827 Tile_X0Y0_FrameData[18] VPWR VGND sg13cmos5l_antennanp
XANTENNA_3838 Tile_X0Y0_FrameData[18] VPWR VGND sg13cmos5l_antennanp
XFILLER_13_1488 VPWR VGND sg13cmos5l_decap_8
XANTENNA_3849 Tile_X0Y0_FrameData[18] VPWR VGND sg13cmos5l_antennanp
XFILLER_8_0 VPWR VGND sg13cmos5l_decap_8
XFILLER_8_2471 VPWR VGND sg13cmos5l_decap_8
XFILLER_4_2346 VPWR VGND sg13cmos5l_decap_8
XFILLER_4_1656 VPWR VGND sg13cmos5l_decap_8
XANTENNA_350 Tile_X0Y0_FrameData[1] VPWR VGND sg13cmos5l_antennanp
XANTENNA_361 Tile_X0Y0_FrameData[1] VPWR VGND sg13cmos5l_antennanp
XANTENNA_372 Tile_X0Y0_FrameData[1] VPWR VGND sg13cmos5l_antennanp
XANTENNA_383 Tile_X0Y0_FrameData[1] VPWR VGND sg13cmos5l_antennanp
XANTENNA_394 Tile_X0Y0_FrameData[22] VPWR VGND sg13cmos5l_antennanp
XFILLER_14_793 VPWR VGND sg13cmos5l_decap_8
XFILLER_9_241 VPWR VGND sg13cmos5l_fill_2
X_0942_ Tile_X2Y0_FrameStrobe_O[7] Tile_X2Y0_FrameStrobe[7] VPWR VGND sg13cmos5l_buf_1
X_0873_ Tile_X2Y0_S2BEG[6] Tile_X2Y0_N2MID[1] VPWR VGND sg13cmos5l_buf_1
XANTENNA__0988__X Tile_X0Y0_SS4BEG[13] VPWR VGND sg13cmos5l_antennanp
XFILLER_9_2202 VPWR VGND sg13cmos5l_decap_8
XFILLER_9_1534 VPWR VGND sg13cmos5l_decap_4
X_0307_ _0307_/Q Tile_X0Y0_FrameData[22] VGND VPWR Tile_X1Y0_FrameStrobe[3] latch
XFILLER_3_1100 VPWR VGND sg13cmos5l_fill_1
X_1287_ _1287_/X Tile_X3Y0_N2END[4] Tile_X3Y0_N4END[12] Tile_X3Y0_NN4END[3] _0573_/Q
+ _0433_/Q _0432_/Q VPWR VGND sg13cmos5l_mux4_1
X_0238_ _0238_/Q Tile_X0Y0_FrameData[27] VGND VPWR Tile_X1Y0_FrameStrobe[1] latch
XFILLER_3_1166 VPWR VGND sg13cmos5l_decap_8
X_0169_ _0169_/Q Tile_X0Y0_FrameData[16] VGND VPWR Tile_X0Y0_FrameStrobe[2] latch
XFILLER_14_2443 VPWR VGND sg13cmos5l_decap_8
XFILLER_14_1753 VPWR VGND sg13cmos5l_decap_8
XANTENNA__1059__X Tile_X4Y0_S4BEG[12] VPWR VGND sg13cmos5l_antennanp
XFILLER_14_2498 VPWR VGND sg13cmos5l_decap_8
XANTENNA__0898__X Tile_X2Y0_S4BEG[15] VPWR VGND sg13cmos5l_antennanp
XFILLER_1_7 VPWR VGND sg13cmos5l_decap_8
XFILLER_8_1022 VPWR VGND sg13cmos5l_fill_1
XFILLER_5_2644 VPWR VGND sg13cmos5l_decap_8
XFILLER_8_1088 VPWR VGND sg13cmos5l_decap_8
XFILLER_15_1528 VPWR VGND sg13cmos5l_decap_8
XFILLER_13_1241 VPWR VGND sg13cmos5l_decap_8
XANTENNA_3602 Tile_X0Y0_FrameData[8] VPWR VGND sg13cmos5l_antennanp
XANTENNA_3613 Tile_X0Y0_FrameData[8] VPWR VGND sg13cmos5l_antennanp
XANTENNA_2901 Tile_X0Y0_FrameData[17] VPWR VGND sg13cmos5l_antennanp
XANTENNA_3624 Tile_X0Y0_N2END[6] VPWR VGND sg13cmos5l_antennanp
XANTENNA_3635 Tile_X0Y0_N4END[1] VPWR VGND sg13cmos5l_antennanp
XANTENNA_3646 Tile_X0Y0_N4END[2] VPWR VGND sg13cmos5l_antennanp
XANTENNA_2912 Tile_X0Y0_FrameData[17] VPWR VGND sg13cmos5l_antennanp
XANTENNA_2923 Tile_X0Y0_FrameData[17] VPWR VGND sg13cmos5l_antennanp
XANTENNA_2934 Tile_X0Y0_FrameData[17] VPWR VGND sg13cmos5l_antennanp
XANTENNA_2945 Tile_X0Y0_FrameData[19] VPWR VGND sg13cmos5l_antennanp
XANTENNA_3657 Tile_X0Y0_N4END[2] VPWR VGND sg13cmos5l_antennanp
XANTENNA_3668 Tile_X1Y0_N1END[0] VPWR VGND sg13cmos5l_antennanp
XANTENNA_3679 Tile_X1Y0_N2END[5] VPWR VGND sg13cmos5l_antennanp
XANTENNA_2956 Tile_X0Y0_FrameData[19] VPWR VGND sg13cmos5l_antennanp
XANTENNA_2967 Tile_X0Y0_FrameData[19] VPWR VGND sg13cmos5l_antennanp
XANTENNA_2978 Tile_X0Y0_FrameData[19] VPWR VGND sg13cmos5l_antennanp
XANTENNA_2989 Tile_X0Y0_FrameData[19] VPWR VGND sg13cmos5l_antennanp
X_1210_ _1210_/X Tile_X1Y0_N2END[7] Tile_X1Y0_N4END[15] Tile_X1Y0_NN4END[0] _0588_/Q
+ _0235_/Q _0234_/Q VPWR VGND sg13cmos5l_mux4_1
X_1141_ _1141_/X Tile_X0Y0_N2MID[2] Tile_X0Y0_N4END[13] Tile_X0Y0_NN4END[2] _0602_/Q
+ _0181_/Q _0180_/Q VPWR VGND sg13cmos5l_mux4_1
XFILLER_1_21 VPWR VGND sg13cmos5l_decap_8
X_1072_ Tile_X4Y0_SS4BEG[9] Tile_X4Y0_NN4END[6] VPWR VGND sg13cmos5l_buf_1
XANTENNA_180 Tile_X0Y0_FrameData[10] VPWR VGND sg13cmos5l_antennanp
XANTENNA_191 Tile_X0Y0_FrameData[10] VPWR VGND sg13cmos5l_antennanp
XFILLER_14_590 VPWR VGND sg13cmos5l_decap_8
X_0925_ Tile_X3Y0_FrameStrobe_O[10] Tile_X3Y0_FrameStrobe[10] VPWR VGND sg13cmos5l_buf_1
XFILLER_15_2796 VPWR VGND sg13cmos5l_fill_2
X_0856_ Tile_X4Y0_FrameStrobe_O[13] Tile_X4Y0_FrameStrobe[13] VPWR VGND sg13cmos5l_buf_1
X_0787_ Tile_X3Y0_S4BEG[8] _1267_/X VPWR VGND sg13cmos5l_buf_1
XFILLER_0_2530 VPWR VGND sg13cmos5l_decap_8
XFILLER_16_2549 VPWR VGND sg13cmos5l_decap_8
XFILLER_16_1826 VPWR VGND sg13cmos5l_decap_8
XFILLER_14_2251 VPWR VGND sg13cmos5l_decap_8
XFILLER_14_1550 VPWR VGND sg13cmos5l_decap_8
XANTENNA_2208 Tile_X0Y0_FrameData[9] VPWR VGND sg13cmos5l_antennanp
XANTENNA_2219 Tile_X0Y0_FrameData[9] VPWR VGND sg13cmos5l_antennanp
XFILLER_10_63 VPWR VGND sg13cmos5l_decap_8
XANTENNA_1507 Tile_X0Y0_FrameData[3] VPWR VGND sg13cmos5l_antennanp
XANTENNA_1518 Tile_X0Y0_FrameData[3] VPWR VGND sg13cmos5l_antennanp
XANTENNA_1529 Tile_X0Y0_FrameData[3] VPWR VGND sg13cmos5l_antennanp
XFILLER_7_2728 VPWR VGND sg13cmos5l_decap_8
XFILLER_5_2452 VPWR VGND sg13cmos5l_decap_8
XFILLER_5_1751 VPWR VGND sg13cmos5l_decap_8
XFILLER_1_2316 VPWR VGND sg13cmos5l_decap_8
XFILLER_1_1648 VPWR VGND sg13cmos5l_decap_8
XFILLER_15_2037 VPWR VGND sg13cmos5l_decap_8
XFILLER_15_1347 VPWR VGND sg13cmos5l_decap_4
XFILLER_15_1325 VPWR VGND sg13cmos5l_decap_8
X_0710_ Tile_X1Y0_S2BEGb[3] _1174_/X VPWR VGND sg13cmos5l_buf_1
XFILLER_7_520 VPWR VGND sg13cmos5l_decap_8
XFILLER_15_1358 VPWR VGND sg13cmos5l_fill_2
XANTENNA_4100 Tile_X1Y0_N4END[0] VPWR VGND sg13cmos5l_antennanp
XANTENNA_4111 Tile_X1Y0_N4END[13] VPWR VGND sg13cmos5l_antennanp
XANTENNA_4122 Tile_X1Y0_N4END[5] VPWR VGND sg13cmos5l_antennanp
XANTENNA_4133 Tile_X2Y0_NN4END[1] VPWR VGND sg13cmos5l_antennanp
XANTENNA_3410 Tile_X0Y0_FrameData[21] VPWR VGND sg13cmos5l_antennanp
XANTENNA_3421 Tile_X0Y0_FrameData[21] VPWR VGND sg13cmos5l_antennanp
XANTENNA_4144 Tile_X1Y0_N2END[2] VPWR VGND sg13cmos5l_antennanp
XANTENNA_4155 _1091_/X VPWR VGND sg13cmos5l_antennanp
X_0641_ _0641_/L_HI VPWR VGND sg13cmos5l_tiehi
XANTENNA_3432 Tile_X0Y0_FrameData[21] VPWR VGND sg13cmos5l_antennanp
XANTENNA_3443 Tile_X0Y0_FrameData[21] VPWR VGND sg13cmos5l_antennanp
XANTENNA_3454 Tile_X0Y0_FrameData[8] VPWR VGND sg13cmos5l_antennanp
X_0572_ _0572_/Q Tile_X0Y0_UserCLK NPU_RDATA0 _0650_/L_HI VPWR VGND sg13cmos5l_dfrbpq_1
XANTENNA_2720 Tile_X0Y0_FrameData[14] VPWR VGND sg13cmos5l_antennanp
XANTENNA_2731 Tile_X0Y0_FrameData[14] VPWR VGND sg13cmos5l_antennanp
XANTENNA_2742 Tile_X0Y0_FrameData[14] VPWR VGND sg13cmos5l_antennanp
XANTENNA_2753 Tile_X0Y0_FrameData[14] VPWR VGND sg13cmos5l_antennanp
XANTENNA_3465 Tile_X0Y0_FrameData[8] VPWR VGND sg13cmos5l_antennanp
XANTENNA_3476 Tile_X0Y0_FrameData[8] VPWR VGND sg13cmos5l_antennanp
XANTENNA_3487 Tile_X0Y0_FrameData[8] VPWR VGND sg13cmos5l_antennanp
XANTENNA_3498 Tile_X0Y0_FrameData[8] VPWR VGND sg13cmos5l_antennanp
XFILLER_10_1992 VPWR VGND sg13cmos5l_fill_2
XANTENNA_2764 Tile_X0Y0_FrameData[14] VPWR VGND sg13cmos5l_antennanp
XANTENNA_2775 Tile_X0Y0_FrameData[16] VPWR VGND sg13cmos5l_antennanp
XANTENNA_2786 Tile_X0Y0_FrameData[16] VPWR VGND sg13cmos5l_antennanp
XANTENNA_2797 Tile_X0Y0_FrameData[16] VPWR VGND sg13cmos5l_antennanp
X_1124_ _1124_/X Tile_X0Y0_N4END[12] Tile_X0Y0_N4END[13] Tile_X0Y0_NN4END[12] Tile_X0Y0_NN4END[14]
+ _0097_/Q _0096_/Q VPWR VGND sg13cmos5l_mux4_1
X_1055_ Tile_X4Y0_S4BEG[8] Tile_X4Y0_N4END[7] VPWR VGND sg13cmos5l_buf_1
X_0908_ Tile_X2Y0_SS4BEG[9] _1244_/X VPWR VGND sg13cmos5l_buf_1
XFILLER_15_1892 VPWR VGND sg13cmos5l_decap_8
XFILLER_11_2457 VPWR VGND sg13cmos5l_decap_8
X_0839_ Tile_X4Y0_FrameData_O[28] Tile_X0Y0_FrameData[28] VPWR VGND sg13cmos5l_buf_1
XFILLER_11_1767 VPWR VGND sg13cmos5l_decap_8
XFILLER_9_1183 VPWR VGND sg13cmos5l_decap_8
XFILLER_2_2603 VPWR VGND sg13cmos5l_decap_8
XFILLER_2_2636 VPWR VGND sg13cmos5l_decap_4
XANTENNA__1072__X Tile_X4Y0_SS4BEG[9] VPWR VGND sg13cmos5l_antennanp
XFILLER_16_129 VPWR VGND sg13cmos5l_decap_8
XFILLER_0_2360 VPWR VGND sg13cmos5l_fill_1
XANTENNA_927 Tile_X0Y0_FrameData[28] VPWR VGND sg13cmos5l_antennanp
XANTENNA_916 Tile_X0Y0_FrameData[27] VPWR VGND sg13cmos5l_antennanp
XANTENNA_905 Tile_X0Y0_FrameData[27] VPWR VGND sg13cmos5l_antennanp
XFILLER_0_2382 VPWR VGND sg13cmos5l_decap_8
XANTENNA_949 Tile_X0Y0_FrameData[28] VPWR VGND sg13cmos5l_antennanp
XANTENNA_938 Tile_X0Y0_FrameData[28] VPWR VGND sg13cmos5l_antennanp
XFILLER_0_1692 VPWR VGND sg13cmos5l_decap_8
XFILLER_16_2346 VPWR VGND sg13cmos5l_decap_8
XFILLER_12_1509 VPWR VGND sg13cmos5l_decap_8
XANTENNA_91 Tile_X0Y0_FrameData[0] VPWR VGND sg13cmos5l_antennanp
XANTENNA_80 Tile_X0Y0_FrameData[0] VPWR VGND sg13cmos5l_antennanp
XFILLER_4_534 VPWR VGND sg13cmos5l_decap_8
XFILLER_10_1222 VPWR VGND sg13cmos5l_fill_2
XFILLER_10_1211 VPWR VGND sg13cmos5l_decap_8
XANTENNA_2005 Tile_X0Y0_FrameData[6] VPWR VGND sg13cmos5l_antennanp
XANTENNA_1304 Tile_X0Y0_FrameData[30] VPWR VGND sg13cmos5l_antennanp
XANTENNA_2016 Tile_X0Y0_FrameData[6] VPWR VGND sg13cmos5l_antennanp
XANTENNA_2027 Tile_X0Y0_FrameData[6] VPWR VGND sg13cmos5l_antennanp
XANTENNA_2038 Tile_X0Y0_FrameData[6] VPWR VGND sg13cmos5l_antennanp
XANTENNA_1315 Tile_X0Y0_FrameData[30] VPWR VGND sg13cmos5l_antennanp
XANTENNA_1326 Tile_X0Y0_FrameData[30] VPWR VGND sg13cmos5l_antennanp
XANTENNA_1337 Tile_X0Y0_FrameData[30] VPWR VGND sg13cmos5l_antennanp
XANTENNA_2049 Tile_X0Y0_FrameData[6] VPWR VGND sg13cmos5l_antennanp
XANTENNA_1348 Tile_X0Y0_FrameData[30] VPWR VGND sg13cmos5l_antennanp
XANTENNA_1359 Tile_X0Y0_FrameData[30] VPWR VGND sg13cmos5l_antennanp
XFILLER_1_1434 VPWR VGND sg13cmos5l_fill_1
XFILLER_16_641 VPWR VGND sg13cmos5l_decap_8
XFILLER_15_140 VPWR VGND sg13cmos5l_decap_8
XFILLER_15_1144 VPWR VGND sg13cmos5l_decap_8
XFILLER_7_42 VPWR VGND sg13cmos5l_decap_8
XFILLER_12_2799 VPWR VGND sg13cmos5l_fill_1
X_0624_ _0624_/L_HI VPWR VGND sg13cmos5l_tiehi
XANTENNA_3240 Tile_X0Y0_FrameData[20] VPWR VGND sg13cmos5l_antennanp
XANTENNA_3251 Tile_X0Y0_FrameData[20] VPWR VGND sg13cmos5l_antennanp
XANTENNA_3262 Tile_X0Y0_FrameData[20] VPWR VGND sg13cmos5l_antennanp
XANTENNA_3273 Tile_X0Y0_FrameData[20] VPWR VGND sg13cmos5l_antennanp
XANTENNA__0996__X Tile_X0Y0_S4BEG[5] VPWR VGND sg13cmos5l_antennanp
XANTENNA_2550 Tile_X0Y0_FrameData[12] VPWR VGND sg13cmos5l_antennanp
XANTENNA_2561 Tile_X0Y0_FrameData[12] VPWR VGND sg13cmos5l_antennanp
XANTENNA_3284 Tile_X0Y0_FrameData[20] VPWR VGND sg13cmos5l_antennanp
XANTENNA_3295 Tile_X0Y0_FrameData[20] VPWR VGND sg13cmos5l_antennanp
X_0555_ NPU_WDATA31 Tile_X0Y0_UserCLK _1127_/X _0678_/L_HI VPWR VGND sg13cmos5l_dfrbpq_1
XANTENNA_2572 Tile_X0Y0_FrameData[12] VPWR VGND sg13cmos5l_antennanp
XANTENNA_2583 Tile_X0Y0_FrameData[12] VPWR VGND sg13cmos5l_antennanp
XANTENNA_2594 Tile_X0Y0_FrameData[13] VPWR VGND sg13cmos5l_antennanp
X_0486_ _0486_/Q Tile_X0Y0_FrameData[19] VGND VPWR Tile_X3Y0_FrameStrobe[2] latch
XANTENNA_1860 Tile_X0Y0_FrameData[5] VPWR VGND sg13cmos5l_antennanp
XANTENNA_1871 Tile_X0Y0_FrameData[5] VPWR VGND sg13cmos5l_antennanp
XANTENNA_1882 Tile_X0Y0_FrameData[5] VPWR VGND sg13cmos5l_antennanp
XANTENNA_1893 Tile_X0Y0_FrameData[5] VPWR VGND sg13cmos5l_antennanp
X_1107_ _1107_/X Tile_X1Y0_N4END[8] Tile_X1Y0_N4END[11] Tile_X1Y0_NN4END[9] Tile_X1Y0_NN4END[11]
+ _0211_/Q _0210_/Q VPWR VGND sg13cmos5l_mux4_1
XFILLER_1_2680 VPWR VGND sg13cmos5l_decap_4
X_1038_ Tile_X4Y0_S2BEG[7] Tile_X4Y0_N2MID[0] VPWR VGND sg13cmos5l_buf_1
XFILLER_13_2519 VPWR VGND sg13cmos5l_decap_8
XFILLER_11_2254 VPWR VGND sg13cmos5l_decap_8
XFILLER_11_1564 VPWR VGND sg13cmos5l_decap_8
XANTENNA__1067__X Tile_X4Y0_SS4BEG[4] VPWR VGND sg13cmos5l_antennanp
XFILLER_1_548 VPWR VGND sg13cmos5l_decap_8
XANTENNA_702 Tile_X0Y0_FrameData[25] VPWR VGND sg13cmos5l_antennanp
XANTENNA_735 Tile_X0Y0_FrameData[25] VPWR VGND sg13cmos5l_antennanp
XANTENNA_724 Tile_X0Y0_FrameData[25] VPWR VGND sg13cmos5l_antennanp
XANTENNA_713 Tile_X0Y0_FrameData[25] VPWR VGND sg13cmos5l_antennanp
XANTENNA_768 Tile_X0Y0_FrameData[26] VPWR VGND sg13cmos5l_antennanp
XANTENNA_757 Tile_X0Y0_FrameData[25] VPWR VGND sg13cmos5l_antennanp
XANTENNA_746 Tile_X0Y0_FrameData[25] VPWR VGND sg13cmos5l_antennanp
XFILLER_16_84 VPWR VGND sg13cmos5l_decap_8
XFILLER_13_622 VPWR VGND sg13cmos5l_decap_8
XANTENNA_779 Tile_X0Y0_FrameData[26] VPWR VGND sg13cmos5l_antennanp
XFILLER_12_154 VPWR VGND sg13cmos5l_decap_8
XFILLER_9_637 VPWR VGND sg13cmos5l_decap_8
XFILLER_16_2198 VPWR VGND sg13cmos5l_decap_4
XFILLER_13_699 VPWR VGND sg13cmos5l_decap_8
XFILLER_16_1486 VPWR VGND sg13cmos5l_decap_8
XFILLER_5_865 VPWR VGND sg13cmos5l_fill_1
XANTENNA_1101 Tile_X0Y0_FrameData[2] VPWR VGND sg13cmos5l_antennanp
XANTENNA_1112 Tile_X0Y0_FrameData[2] VPWR VGND sg13cmos5l_antennanp
XFILLER_7_2322 VPWR VGND sg13cmos5l_fill_1
XFILLER_7_2311 VPWR VGND sg13cmos5l_decap_8
XANTENNA_1123 Tile_X0Y0_FrameData[2] VPWR VGND sg13cmos5l_antennanp
XANTENNA_1134 Tile_X0Y0_FrameData[2] VPWR VGND sg13cmos5l_antennanp
XANTENNA_1145 Tile_X0Y0_FrameData[2] VPWR VGND sg13cmos5l_antennanp
X_0340_ _0340_/Q Tile_X0Y0_FrameData[5] VGND VPWR Tile_X2Y0_FrameStrobe[0] latch
XFILLER_7_2366 VPWR VGND sg13cmos5l_decap_8
XFILLER_7_1610 VPWR VGND sg13cmos5l_decap_8
XANTENNA_1156 Tile_X0Y0_FrameData[30] VPWR VGND sg13cmos5l_antennanp
XANTENNA_1167 Tile_X0Y0_FrameData[30] VPWR VGND sg13cmos5l_antennanp
XANTENNA_1178 Tile_X0Y0_FrameData[30] VPWR VGND sg13cmos5l_antennanp
X_0271_ _0271_/Q Tile_X0Y0_FrameData[26] VGND VPWR Tile_X1Y0_FrameStrobe[2] latch
XFILLER_0_570 VPWR VGND sg13cmos5l_decap_8
XANTENNA_1189 Tile_X0Y0_FrameData[30] VPWR VGND sg13cmos5l_antennanp
XFILLER_7_1687 VPWR VGND sg13cmos5l_decap_8
XANTENNA_3070 Tile_X0Y0_FrameData[19] VPWR VGND sg13cmos5l_antennanp
XANTENNA_3081 Tile_X0Y0_FrameData[19] VPWR VGND sg13cmos5l_antennanp
X_0607_ _0607_/L_HI VPWR VGND sg13cmos5l_tiehi
XANTENNA_3092 Tile_X0Y0_FrameData[19] VPWR VGND sg13cmos5l_antennanp
X_0538_ NPU_WDATA14 Tile_X0Y0_UserCLK _1110_/X _0663_/L_HI VPWR VGND sg13cmos5l_dfrbpq_1
XANTENNA_2380 Tile_X0Y0_FrameData[11] VPWR VGND sg13cmos5l_antennanp
XANTENNA_2391 Tile_X0Y0_FrameData[11] VPWR VGND sg13cmos5l_antennanp
XFILLER_6_1120 VPWR VGND sg13cmos5l_decap_8
XANTENNA_1690 Tile_X0Y0_FrameData[4] VPWR VGND sg13cmos5l_antennanp
X_0469_ _0469_/Q Tile_X0Y0_FrameData[4] VGND VPWR Tile_X3Y0_FrameStrobe[1] latch
XFILLER_3_2731 VPWR VGND sg13cmos5l_decap_8
XFILLER_6_1197 VPWR VGND sg13cmos5l_decap_4
XFILLER_13_2316 VPWR VGND sg13cmos5l_decap_8
XFILLER_6_607 VPWR VGND sg13cmos5l_decap_8
XFILLER_8_2664 VPWR VGND sg13cmos5l_decap_8
XFILLER_8_1930 VPWR VGND sg13cmos5l_fill_1
XFILLER_4_2506 VPWR VGND sg13cmos5l_decap_8
XFILLER_4_1838 VPWR VGND sg13cmos5l_fill_2
XFILLER_2_2263 VPWR VGND sg13cmos5l_decap_8
XANTENNA_510 Tile_X0Y0_FrameData[23] VPWR VGND sg13cmos5l_antennanp
XANTENNA_543 Tile_X0Y0_FrameData[23] VPWR VGND sg13cmos5l_antennanp
XANTENNA_532 Tile_X0Y0_FrameData[23] VPWR VGND sg13cmos5l_antennanp
XANTENNA_521 Tile_X0Y0_FrameData[23] VPWR VGND sg13cmos5l_antennanp
XANTENNA_587 Tile_X0Y0_FrameData[23] VPWR VGND sg13cmos5l_antennanp
XANTENNA_576 Tile_X0Y0_FrameData[23] VPWR VGND sg13cmos5l_antennanp
XANTENNA_565 Tile_X0Y0_FrameData[23] VPWR VGND sg13cmos5l_antennanp
XANTENNA_554 Tile_X0Y0_FrameData[23] VPWR VGND sg13cmos5l_antennanp
XANTENNA_598 Tile_X0Y0_FrameData[23] VPWR VGND sg13cmos5l_antennanp
XFILLER_13_485 VPWR VGND sg13cmos5l_decap_8
XFILLER_16_1283 VPWR VGND sg13cmos5l_decap_8
XFILLER_12_1147 VPWR VGND sg13cmos5l_decap_8
XFILLER_9_2428 VPWR VGND sg13cmos5l_decap_8
XFILLER_4_21 VPWR VGND sg13cmos5l_decap_8
X_0323_ _0323_/Q Tile_X0Y0_FrameData[22] VGND VPWR Tile_X2Y0_FrameStrobe[0] latch
X_0254_ _0254_/Q Tile_X0Y0_FrameData[11] VGND VPWR Tile_X1Y0_FrameStrobe[1] latch
XFILLER_3_2049 VPWR VGND sg13cmos5l_fill_2
X_0185_ _0185_/Q Tile_X0Y0_FrameData[0] VGND VPWR Tile_X0Y0_FrameStrobe[2] latch
XFILLER_14_1902 VPWR VGND sg13cmos5l_fill_1
XFILLER_14_2658 VPWR VGND sg13cmos5l_decap_8
XFILLER_14_1968 VPWR VGND sg13cmos5l_decap_4
XFILLER_12_2393 VPWR VGND sg13cmos5l_decap_8
XFILLER_12_1670 VPWR VGND sg13cmos5l_decap_8
XFILLER_15_706 VPWR VGND sg13cmos5l_decap_8
XFILLER_13_2124 VPWR VGND sg13cmos5l_decap_8
XFILLER_13_63 VPWR VGND sg13cmos5l_decap_8
XFILLER_13_1467 VPWR VGND sg13cmos5l_fill_1
XANTENNA_3806 Tile_X0Y0_FrameData[18] VPWR VGND sg13cmos5l_antennanp
XANTENNA_3817 Tile_X0Y0_FrameData[18] VPWR VGND sg13cmos5l_antennanp
XANTENNA_3828 Tile_X0Y0_FrameData[18] VPWR VGND sg13cmos5l_antennanp
XANTENNA_3839 Tile_X0Y0_FrameData[18] VPWR VGND sg13cmos5l_antennanp
XFILLER_8_2450 VPWR VGND sg13cmos5l_decap_8
XFILLER_4_2325 VPWR VGND sg13cmos5l_decap_8
XFILLER_4_1635 VPWR VGND sg13cmos5l_decap_8
XANTENNA_340 Tile_X0Y0_FrameData[1] VPWR VGND sg13cmos5l_antennanp
XANTENNA_351 Tile_X0Y0_FrameData[1] VPWR VGND sg13cmos5l_antennanp
XANTENNA_362 Tile_X0Y0_FrameData[1] VPWR VGND sg13cmos5l_antennanp
XANTENNA_373 Tile_X0Y0_FrameData[1] VPWR VGND sg13cmos5l_antennanp
XANTENNA_384 Tile_X0Y0_FrameData[1] VPWR VGND sg13cmos5l_antennanp
XANTENNA_395 Tile_X0Y0_FrameData[22] VPWR VGND sg13cmos5l_antennanp
X_0941_ Tile_X2Y0_FrameStrobe_O[6] Tile_X2Y0_FrameStrobe[6] VPWR VGND sg13cmos5l_buf_1
XFILLER_14_772 VPWR VGND sg13cmos5l_decap_8
XFILLER_14_1209 VPWR VGND sg13cmos5l_decap_8
X_0872_ Tile_X2Y0_S2BEG[5] Tile_X2Y0_N2MID[2] VPWR VGND sg13cmos5l_buf_1
XFILLER_16_1091 VPWR VGND sg13cmos5l_fill_2
XFILLER_5_481 VPWR VGND sg13cmos5l_fill_1
XFILLER_9_2258 VPWR VGND sg13cmos5l_fill_2
X_0306_ _0306_/Q Tile_X0Y0_FrameData[23] VGND VPWR Tile_X1Y0_FrameStrobe[3] latch
X_1286_ _1286_/X Tile_X3Y0_N2END[3] Tile_X3Y0_N4END[11] Tile_X3Y0_NN4END[4] _0574_/Q
+ _0435_/Q _0434_/Q VPWR VGND sg13cmos5l_mux4_1
XFILLER_3_1145 VPWR VGND sg13cmos5l_decap_8
XFILLER_0_2712 VPWR VGND sg13cmos5l_decap_8
X_0237_ _0237_/Q Tile_X0Y0_FrameData[28] VGND VPWR Tile_X1Y0_FrameStrobe[1] latch
X_0168_ _0168_/Q Tile_X0Y0_FrameData[17] VGND VPWR Tile_X0Y0_FrameStrobe[2] latch
X_0099_ _0099_/Q Tile_X0Y0_FrameData[22] VGND VPWR Tile_X0Y0_FrameStrobe[0] latch
XFILLER_14_2422 VPWR VGND sg13cmos5l_decap_8
XFILLER_14_1732 VPWR VGND sg13cmos5l_decap_8
XFILLER_12_2190 VPWR VGND sg13cmos5l_decap_8
XFILLER_10_1629 VPWR VGND sg13cmos5l_decap_8
XANTENNA__1075__X Tile_X4Y0_SS4BEG[12] VPWR VGND sg13cmos5l_antennanp
XFILLER_5_2623 VPWR VGND sg13cmos5l_decap_8
XFILLER_15_2219 VPWR VGND sg13cmos5l_decap_8
XFILLER_15_1507 VPWR VGND sg13cmos5l_decap_8
XFILLER_13_1220 VPWR VGND sg13cmos5l_decap_8
XFILLER_11_764 VPWR VGND sg13cmos5l_decap_8
XFILLER_6_212 VPWR VGND sg13cmos5l_fill_1
XANTENNA_3603 Tile_X0Y0_FrameData[8] VPWR VGND sg13cmos5l_antennanp
XANTENNA_2902 Tile_X0Y0_FrameData[17] VPWR VGND sg13cmos5l_antennanp
XANTENNA_3614 Tile_X0Y0_FrameData[8] VPWR VGND sg13cmos5l_antennanp
XANTENNA_3625 Tile_X0Y0_N2END[6] VPWR VGND sg13cmos5l_antennanp
XANTENNA_3636 Tile_X0Y0_N4END[1] VPWR VGND sg13cmos5l_antennanp
XANTENNA_3647 Tile_X0Y0_N4END[2] VPWR VGND sg13cmos5l_antennanp
XFILLER_13_1297 VPWR VGND sg13cmos5l_decap_4
XANTENNA_2913 Tile_X0Y0_FrameData[17] VPWR VGND sg13cmos5l_antennanp
XANTENNA_2924 Tile_X0Y0_FrameData[17] VPWR VGND sg13cmos5l_antennanp
XANTENNA_2935 Tile_X0Y0_FrameData[17] VPWR VGND sg13cmos5l_antennanp
XANTENNA_3658 Tile_X0Y0_N4END[2] VPWR VGND sg13cmos5l_antennanp
XANTENNA_3669 Tile_X1Y0_N2END[3] VPWR VGND sg13cmos5l_antennanp
XFILLER_2_440 VPWR VGND sg13cmos5l_fill_2
XANTENNA_2946 Tile_X0Y0_FrameData[19] VPWR VGND sg13cmos5l_antennanp
XANTENNA_2957 Tile_X0Y0_FrameData[19] VPWR VGND sg13cmos5l_antennanp
XANTENNA_2968 Tile_X0Y0_FrameData[19] VPWR VGND sg13cmos5l_antennanp
XFILLER_6_2409 VPWR VGND sg13cmos5l_decap_8
XANTENNA_2979 Tile_X0Y0_FrameData[19] VPWR VGND sg13cmos5l_antennanp
X_1140_ _1140_/X Tile_X0Y0_N2MID[1] Tile_X0Y0_N4END[14] Tile_X0Y0_NN4END[1] _0603_/Q
+ _0183_/Q _0182_/Q VPWR VGND sg13cmos5l_mux4_1
XFILLER_4_1421 VPWR VGND sg13cmos5l_fill_2
X_1071_ Tile_X4Y0_SS4BEG[8] Tile_X4Y0_NN4END[7] VPWR VGND sg13cmos5l_buf_1
XANTENNA_170 Tile_X0Y0_FrameData[10] VPWR VGND sg13cmos5l_antennanp
XANTENNA_181 Tile_X0Y0_FrameData[10] VPWR VGND sg13cmos5l_antennanp
XANTENNA_192 Tile_X0Y0_FrameData[10] VPWR VGND sg13cmos5l_antennanp
XFILLER_15_2731 VPWR VGND sg13cmos5l_decap_8
X_0924_ Tile_X3Y0_FrameStrobe_O[9] Tile_X3Y0_FrameStrobe[9] VPWR VGND sg13cmos5l_buf_1
XFILLER_14_1017 VPWR VGND sg13cmos5l_fill_1
X_0855_ Tile_X4Y0_FrameStrobe_O[12] Tile_X4Y0_FrameStrobe[12] VPWR VGND sg13cmos5l_buf_1
XFILLER_11_2639 VPWR VGND sg13cmos5l_decap_8
XANTENNA__0999__X Tile_X0Y0_S4BEG[8] VPWR VGND sg13cmos5l_antennanp
X_0786_ Tile_X3Y0_S4BEG[7] _1266_/X VPWR VGND sg13cmos5l_buf_1
X_1269_ _1269_/X Tile_X3Y0_N2MID[2] Tile_X3Y0_N4END[5] Tile_X3Y0_NN4END[10] _0574_/Q
+ _0469_/Q _0468_/Q VPWR VGND sg13cmos5l_mux4_1
XFILLER_16_2528 VPWR VGND sg13cmos5l_decap_8
XFILLER_16_1805 VPWR VGND sg13cmos5l_decap_8
XFILLER_14_2230 VPWR VGND sg13cmos5l_decap_8
XFILLER_14_2296 VPWR VGND sg13cmos5l_decap_8
XFILLER_10_2149 VPWR VGND sg13cmos5l_decap_8
XANTENNA__0702__X Tile_X0Y0_FrameStrobe_O[15] VPWR VGND sg13cmos5l_antennanp
XANTENNA_2209 Tile_X0Y0_FrameData[9] VPWR VGND sg13cmos5l_antennanp
XFILLER_7_2707 VPWR VGND sg13cmos5l_decap_8
XFILLER_10_42 VPWR VGND sg13cmos5l_decap_8
XANTENNA_1508 Tile_X0Y0_FrameData[3] VPWR VGND sg13cmos5l_antennanp
XANTENNA_1519 Tile_X0Y0_FrameData[3] VPWR VGND sg13cmos5l_antennanp
XFILLER_5_2431 VPWR VGND sg13cmos5l_decap_8
XFILLER_5_1730 VPWR VGND sg13cmos5l_decap_8
XFILLER_1_1638 VPWR VGND sg13cmos5l_decap_8
XFILLER_16_812 VPWR VGND sg13cmos5l_decap_8
XFILLER_15_388 VPWR VGND sg13cmos5l_fill_1
XFILLER_15_1304 VPWR VGND sg13cmos5l_decap_8
XFILLER_11_594 VPWR VGND sg13cmos5l_decap_8
XANTENNA_4101 Tile_X1Y0_N4END[0] VPWR VGND sg13cmos5l_antennanp
XANTENNA_4112 Tile_X1Y0_N4END[13] VPWR VGND sg13cmos5l_antennanp
XANTENNA_4123 Tile_X1Y0_N4END[5] VPWR VGND sg13cmos5l_antennanp
XANTENNA_3400 Tile_X0Y0_FrameData[21] VPWR VGND sg13cmos5l_antennanp
XANTENNA_3411 Tile_X0Y0_FrameData[21] VPWR VGND sg13cmos5l_antennanp
XANTENNA_3422 Tile_X0Y0_FrameData[21] VPWR VGND sg13cmos5l_antennanp
XANTENNA_4134 Tile_X3Y0_N4END[3] VPWR VGND sg13cmos5l_antennanp
XANTENNA_4145 Tile_X1Y0_N2END[2] VPWR VGND sg13cmos5l_antennanp
X_0640_ _0640_/L_HI VPWR VGND sg13cmos5l_tiehi
XFILLER_10_2683 VPWR VGND sg13cmos5l_decap_8
XANTENNA_2710 Tile_X0Y0_FrameData[14] VPWR VGND sg13cmos5l_antennanp
XANTENNA_3433 Tile_X0Y0_FrameData[21] VPWR VGND sg13cmos5l_antennanp
XANTENNA_3444 Tile_X0Y0_FrameData[21] VPWR VGND sg13cmos5l_antennanp
XANTENNA_3455 Tile_X0Y0_FrameData[8] VPWR VGND sg13cmos5l_antennanp
X_0571_ NPU_ADDR7 Tile_X0Y0_UserCLK _1087_/X _0658_/L_HI VPWR VGND sg13cmos5l_dfrbpq_1
XANTENNA_2721 Tile_X0Y0_FrameData[14] VPWR VGND sg13cmos5l_antennanp
XANTENNA_2732 Tile_X0Y0_FrameData[14] VPWR VGND sg13cmos5l_antennanp
XANTENNA_2743 Tile_X0Y0_FrameData[14] VPWR VGND sg13cmos5l_antennanp
XANTENNA_3466 Tile_X0Y0_FrameData[8] VPWR VGND sg13cmos5l_antennanp
XANTENNA_3477 Tile_X0Y0_FrameData[8] VPWR VGND sg13cmos5l_antennanp
XANTENNA_3488 Tile_X0Y0_FrameData[8] VPWR VGND sg13cmos5l_antennanp
XANTENNA_2754 Tile_X0Y0_FrameData[14] VPWR VGND sg13cmos5l_antennanp
XANTENNA_2765 Tile_X0Y0_FrameData[14] VPWR VGND sg13cmos5l_antennanp
XANTENNA_2776 Tile_X0Y0_FrameData[16] VPWR VGND sg13cmos5l_antennanp
XANTENNA_2787 Tile_X0Y0_FrameData[16] VPWR VGND sg13cmos5l_antennanp
XANTENNA_3499 Tile_X0Y0_FrameData[8] VPWR VGND sg13cmos5l_antennanp
XANTENNA_2798 Tile_X0Y0_FrameData[16] VPWR VGND sg13cmos5l_antennanp
X_1123_ _1123_/X Tile_X0Y0_N4END[8] Tile_X0Y0_N4END[11] Tile_X0Y0_NN4END[9] Tile_X0Y0_NN4END[11]
+ _0099_/Q _0098_/Q VPWR VGND sg13cmos5l_mux4_1
X_1054_ Tile_X4Y0_S4BEG[7] Tile_X4Y0_N4END[8] VPWR VGND sg13cmos5l_buf_1
X_0907_ Tile_X2Y0_SS4BEG[8] _1243_/X VPWR VGND sg13cmos5l_buf_1
XFILLER_15_2572 VPWR VGND sg13cmos5l_decap_8
XFILLER_11_2436 VPWR VGND sg13cmos5l_decap_8
XFILLER_15_1871 VPWR VGND sg13cmos5l_decap_8
X_0838_ Tile_X4Y0_FrameData_O[27] Tile_X0Y0_FrameData[27] VPWR VGND sg13cmos5l_buf_1
XFILLER_11_1746 VPWR VGND sg13cmos5l_decap_8
X_0769_ Tile_X3Y0_S2BEG[6] Tile_X3Y0_N2MID[1] VPWR VGND sg13cmos5l_buf_1
XFILLER_9_1162 VPWR VGND sg13cmos5l_decap_8
XFILLER_2_2615 VPWR VGND sg13cmos5l_decap_8
XFILLER_16_119 VPWR VGND sg13cmos5l_decap_8
XANTENNA_917 Tile_X0Y0_FrameData[27] VPWR VGND sg13cmos5l_antennanp
XANTENNA_906 Tile_X0Y0_FrameData[27] VPWR VGND sg13cmos5l_antennanp
XANTENNA_939 Tile_X0Y0_FrameData[28] VPWR VGND sg13cmos5l_antennanp
XANTENNA_928 Tile_X0Y0_FrameData[28] VPWR VGND sg13cmos5l_antennanp
XFILLER_8_318 VPWR VGND sg13cmos5l_fill_2
XFILLER_16_1635 VPWR VGND sg13cmos5l_fill_1
XANTENNA_92 Tile_X0Y0_FrameData[0] VPWR VGND sg13cmos5l_antennanp
XANTENNA_81 Tile_X0Y0_FrameData[0] VPWR VGND sg13cmos5l_antennanp
XANTENNA_70 Tile_X0Y0_FrameData[0] VPWR VGND sg13cmos5l_antennanp
XANTENNA_2006 Tile_X0Y0_FrameData[6] VPWR VGND sg13cmos5l_antennanp
XANTENNA_2017 Tile_X0Y0_FrameData[6] VPWR VGND sg13cmos5l_antennanp
XANTENNA_2028 Tile_X0Y0_FrameData[6] VPWR VGND sg13cmos5l_antennanp
XANTENNA_2039 Tile_X0Y0_FrameData[6] VPWR VGND sg13cmos5l_antennanp
XANTENNA_1305 Tile_X0Y0_FrameData[30] VPWR VGND sg13cmos5l_antennanp
XANTENNA_1316 Tile_X0Y0_FrameData[30] VPWR VGND sg13cmos5l_antennanp
XANTENNA_1327 Tile_X0Y0_FrameData[30] VPWR VGND sg13cmos5l_antennanp
XFILLER_7_1803 VPWR VGND sg13cmos5l_fill_1
XANTENNA_1338 Tile_X0Y0_FrameData[30] VPWR VGND sg13cmos5l_antennanp
XANTENNA_1349 Tile_X0Y0_FrameData[30] VPWR VGND sg13cmos5l_antennanp
XFILLER_16_620 VPWR VGND sg13cmos5l_decap_8
XFILLER_15_196 VPWR VGND sg13cmos5l_decap_8
XFILLER_7_21 VPWR VGND sg13cmos5l_decap_8
XFILLER_15_1123 VPWR VGND sg13cmos5l_decap_8
XFILLER_12_2745 VPWR VGND sg13cmos5l_decap_8
XFILLER_7_373 VPWR VGND sg13cmos5l_fill_2
XANTENNA_3230 Tile_X0Y0_FrameData[20] VPWR VGND sg13cmos5l_antennanp
X_0623_ _0623_/L_HI VPWR VGND sg13cmos5l_tiehi
XFILLER_7_98 VPWR VGND sg13cmos5l_decap_8
XFILLER_7_395 VPWR VGND sg13cmos5l_fill_1
XANTENNA_3241 Tile_X0Y0_FrameData[20] VPWR VGND sg13cmos5l_antennanp
XANTENNA_3252 Tile_X0Y0_FrameData[20] VPWR VGND sg13cmos5l_antennanp
XANTENNA_3263 Tile_X0Y0_FrameData[20] VPWR VGND sg13cmos5l_antennanp
XANTENNA_2540 Tile_X0Y0_FrameData[12] VPWR VGND sg13cmos5l_antennanp
XANTENNA_2551 Tile_X0Y0_FrameData[12] VPWR VGND sg13cmos5l_antennanp
XANTENNA_3274 Tile_X0Y0_FrameData[20] VPWR VGND sg13cmos5l_antennanp
XANTENNA_3285 Tile_X0Y0_FrameData[20] VPWR VGND sg13cmos5l_antennanp
XANTENNA_3296 Tile_X0Y0_FrameData[20] VPWR VGND sg13cmos5l_antennanp
X_0554_ NPU_WDATA30 Tile_X0Y0_UserCLK _1126_/X _0679_/L_HI VPWR VGND sg13cmos5l_dfrbpq_1
XANTENNA_1850 Tile_X0Y0_FrameData[5] VPWR VGND sg13cmos5l_antennanp
XANTENNA_2562 Tile_X0Y0_FrameData[12] VPWR VGND sg13cmos5l_antennanp
XANTENNA_2573 Tile_X0Y0_FrameData[12] VPWR VGND sg13cmos5l_antennanp
XANTENNA_2584 Tile_X0Y0_FrameData[12] VPWR VGND sg13cmos5l_antennanp
XANTENNA_2595 Tile_X0Y0_FrameData[13] VPWR VGND sg13cmos5l_antennanp
X_0485_ _0485_/Q Tile_X0Y0_FrameData[20] VGND VPWR Tile_X3Y0_FrameStrobe[2] latch
XANTENNA_1861 Tile_X0Y0_FrameData[5] VPWR VGND sg13cmos5l_antennanp
XANTENNA_1872 Tile_X0Y0_FrameData[5] VPWR VGND sg13cmos5l_antennanp
XANTENNA_1883 Tile_X0Y0_FrameData[5] VPWR VGND sg13cmos5l_antennanp
XANTENNA_1894 Tile_X0Y0_FrameData[5] VPWR VGND sg13cmos5l_antennanp
XFILLER_16_0 VPWR VGND sg13cmos5l_decap_8
X_1106_ _1106_/X Tile_X1Y0_N4END[10] Tile_X1Y0_N4END[11] Tile_X1Y0_NN4END[8] Tile_X1Y0_NN4END[10]
+ _0213_/Q _0212_/Q VPWR VGND sg13cmos5l_mux4_1
X_1037_ Tile_X4Y0_S2BEG[6] Tile_X4Y0_N2MID[1] VPWR VGND sg13cmos5l_buf_1
XFILLER_15_2391 VPWR VGND sg13cmos5l_decap_8
XFILLER_11_2233 VPWR VGND sg13cmos5l_decap_8
XFILLER_11_1543 VPWR VGND sg13cmos5l_decap_8
XFILLER_2_2434 VPWR VGND sg13cmos5l_fill_2
XFILLER_2_2467 VPWR VGND sg13cmos5l_fill_2
XFILLER_2_1744 VPWR VGND sg13cmos5l_decap_8
XANTENNA_736 Tile_X0Y0_FrameData[25] VPWR VGND sg13cmos5l_antennanp
XANTENNA_725 Tile_X0Y0_FrameData[25] VPWR VGND sg13cmos5l_antennanp
XANTENNA_714 Tile_X0Y0_FrameData[25] VPWR VGND sg13cmos5l_antennanp
XANTENNA_703 Tile_X0Y0_FrameData[25] VPWR VGND sg13cmos5l_antennanp
XFILLER_13_601 VPWR VGND sg13cmos5l_decap_8
XANTENNA_769 Tile_X0Y0_FrameData[26] VPWR VGND sg13cmos5l_antennanp
XANTENNA_758 Tile_X0Y0_FrameData[25] VPWR VGND sg13cmos5l_antennanp
XANTENNA_747 Tile_X0Y0_FrameData[25] VPWR VGND sg13cmos5l_antennanp
XFILLER_16_63 VPWR VGND sg13cmos5l_decap_8
XFILLER_9_616 VPWR VGND sg13cmos5l_decap_8
XFILLER_16_2155 VPWR VGND sg13cmos5l_decap_8
XFILLER_12_133 VPWR VGND sg13cmos5l_decap_8
XFILLER_8_126 VPWR VGND sg13cmos5l_decap_4
XFILLER_16_2177 VPWR VGND sg13cmos5l_decap_8
XFILLER_13_678 VPWR VGND sg13cmos5l_decap_8
XFILLER_16_1465 VPWR VGND sg13cmos5l_decap_8
XANTENNA_1102 Tile_X0Y0_FrameData[2] VPWR VGND sg13cmos5l_antennanp
XFILLER_10_1097 VPWR VGND sg13cmos5l_decap_4
XANTENNA_1113 Tile_X0Y0_FrameData[2] VPWR VGND sg13cmos5l_antennanp
XANTENNA_1124 Tile_X0Y0_FrameData[2] VPWR VGND sg13cmos5l_antennanp
XANTENNA_1135 Tile_X0Y0_FrameData[2] VPWR VGND sg13cmos5l_antennanp
XANTENNA_1146 Tile_X0Y0_FrameData[2] VPWR VGND sg13cmos5l_antennanp
XANTENNA_1157 Tile_X0Y0_FrameData[30] VPWR VGND sg13cmos5l_antennanp
XANTENNA_1168 Tile_X0Y0_FrameData[30] VPWR VGND sg13cmos5l_antennanp
XANTENNA_1179 Tile_X0Y0_FrameData[30] VPWR VGND sg13cmos5l_antennanp
X_0270_ _0270_/Q Tile_X0Y0_FrameData[27] VGND VPWR Tile_X1Y0_FrameStrobe[2] latch
XFILLER_7_1666 VPWR VGND sg13cmos5l_decap_8
XFILLER_3_1519 VPWR VGND sg13cmos5l_fill_1
XFILLER_16_472 VPWR VGND sg13cmos5l_fill_2
XFILLER_16_461 VPWR VGND sg13cmos5l_fill_1
XFILLER_8_682 VPWR VGND sg13cmos5l_decap_8
XANTENNA_3060 Tile_X0Y0_FrameData[19] VPWR VGND sg13cmos5l_antennanp
XANTENNA_3071 Tile_X0Y0_FrameData[19] VPWR VGND sg13cmos5l_antennanp
X_0606_ _0606_/L_HI VPWR VGND sg13cmos5l_tiehi
XANTENNA__0800__X Tile_X3Y0_SS4BEG[5] VPWR VGND sg13cmos5l_antennanp
XANTENNA_2370 Tile_X0Y0_FrameData[11] VPWR VGND sg13cmos5l_antennanp
XANTENNA_3082 Tile_X0Y0_FrameData[19] VPWR VGND sg13cmos5l_antennanp
XANTENNA_3093 Tile_X0Y0_FrameData[19] VPWR VGND sg13cmos5l_antennanp
X_0537_ NPU_WDATA13 Tile_X0Y0_UserCLK _1109_/X _0664_/L_HI VPWR VGND sg13cmos5l_dfrbpq_1
XANTENNA_2381 Tile_X0Y0_FrameData[11] VPWR VGND sg13cmos5l_antennanp
XANTENNA_2392 Tile_X0Y0_FrameData[11] VPWR VGND sg13cmos5l_antennanp
XFILLER_3_2710 VPWR VGND sg13cmos5l_decap_8
XANTENNA_1680 Tile_X0Y0_FrameData[4] VPWR VGND sg13cmos5l_antennanp
XANTENNA_1691 Tile_X0Y0_FrameData[4] VPWR VGND sg13cmos5l_antennanp
X_0468_ _0468_/Q Tile_X0Y0_FrameData[5] VGND VPWR Tile_X3Y0_FrameStrobe[1] latch
X_0399_ _0399_/Q Tile_X0Y0_FrameData[10] VGND VPWR Tile_X2Y0_FrameStrobe[2] latch
XFILLER_6_1176 VPWR VGND sg13cmos5l_decap_8
XFILLER_10_648 VPWR VGND sg13cmos5l_decap_8
XFILLER_13_1649 VPWR VGND sg13cmos5l_decap_8
XANTENNA__1078__X Tile_X4Y0_SS4BEG[15] VPWR VGND sg13cmos5l_antennanp
XANTENNA__0710__X Tile_X1Y0_S2BEGb[3] VPWR VGND sg13cmos5l_antennanp
XFILLER_8_2643 VPWR VGND sg13cmos5l_decap_8
XFILLER_4_1806 VPWR VGND sg13cmos5l_fill_2
XFILLER_2_2242 VPWR VGND sg13cmos5l_decap_8
XANTENNA_500 Tile_X0Y0_FrameData[23] VPWR VGND sg13cmos5l_antennanp
XFILLER_2_1563 VPWR VGND sg13cmos5l_fill_2
XANTENNA_544 Tile_X0Y0_FrameData[23] VPWR VGND sg13cmos5l_antennanp
XANTENNA_533 Tile_X0Y0_FrameData[23] VPWR VGND sg13cmos5l_antennanp
XANTENNA_522 Tile_X0Y0_FrameData[23] VPWR VGND sg13cmos5l_antennanp
XANTENNA_511 Tile_X0Y0_FrameData[23] VPWR VGND sg13cmos5l_antennanp
XANTENNA_577 Tile_X0Y0_FrameData[23] VPWR VGND sg13cmos5l_antennanp
XANTENNA_566 Tile_X0Y0_FrameData[23] VPWR VGND sg13cmos5l_antennanp
XANTENNA_555 Tile_X0Y0_FrameData[23] VPWR VGND sg13cmos5l_antennanp
XANTENNA_599 Tile_X0Y0_FrameData[23] VPWR VGND sg13cmos5l_antennanp
XANTENNA_588 Tile_X0Y0_FrameData[23] VPWR VGND sg13cmos5l_antennanp
XFILLER_13_464 VPWR VGND sg13cmos5l_decap_8
XFILLER_16_1262 VPWR VGND sg13cmos5l_decap_8
XFILLER_16_1251 VPWR VGND sg13cmos5l_fill_1
XFILLER_16_1295 VPWR VGND sg13cmos5l_decap_8
XFILLER_12_1126 VPWR VGND sg13cmos5l_decap_8
XFILLER_5_641 VPWR VGND sg13cmos5l_decap_8
XFILLER_9_2407 VPWR VGND sg13cmos5l_decap_8
XFILLER_5_652 VPWR VGND sg13cmos5l_fill_1
XFILLER_9_1739 VPWR VGND sg13cmos5l_decap_8
XFILLER_4_77 VPWR VGND sg13cmos5l_decap_4
X_0322_ _0322_/Q Tile_X0Y0_FrameData[23] VGND VPWR Tile_X2Y0_FrameStrobe[0] latch
X_0253_ _0253_/Q Tile_X0Y0_FrameData[12] VGND VPWR Tile_X1Y0_FrameStrobe[1] latch
X_0184_ _0184_/Q Tile_X0Y0_FrameData[1] VGND VPWR Tile_X0Y0_FrameStrobe[2] latch
XFILLER_14_2637 VPWR VGND sg13cmos5l_decap_8
XFILLER_12_2372 VPWR VGND sg13cmos5l_decap_8
XFILLER_3_2584 VPWR VGND sg13cmos5l_decap_8
XFILLER_13_2103 VPWR VGND sg13cmos5l_decap_8
XANTENNA__0705__X Tile_X0Y0_FrameStrobe_O[18] VPWR VGND sg13cmos5l_antennanp
XFILLER_13_42 VPWR VGND sg13cmos5l_decap_8
XFILLER_13_1435 VPWR VGND sg13cmos5l_fill_1
XANTENNA_3807 Tile_X0Y0_FrameData[18] VPWR VGND sg13cmos5l_antennanp
XANTENNA_3818 Tile_X0Y0_FrameData[18] VPWR VGND sg13cmos5l_antennanp
XANTENNA_3829 Tile_X0Y0_FrameData[18] VPWR VGND sg13cmos5l_antennanp
XFILLER_4_2304 VPWR VGND sg13cmos5l_decap_8
XFILLER_1_198 VPWR VGND sg13cmos5l_fill_2
XFILLER_4_1614 VPWR VGND sg13cmos5l_decap_8
XANTENNA_330 Tile_X0Y0_FrameData[1] VPWR VGND sg13cmos5l_antennanp
XANTENNA_341 Tile_X0Y0_FrameData[1] VPWR VGND sg13cmos5l_antennanp
XANTENNA_352 Tile_X0Y0_FrameData[1] VPWR VGND sg13cmos5l_antennanp
XANTENNA_363 Tile_X0Y0_FrameData[1] VPWR VGND sg13cmos5l_antennanp
XANTENNA_374 Tile_X0Y0_FrameData[1] VPWR VGND sg13cmos5l_antennanp
XANTENNA_385 Tile_X0Y0_FrameData[1] VPWR VGND sg13cmos5l_antennanp
XFILLER_14_751 VPWR VGND sg13cmos5l_decap_8
XANTENNA_396 Tile_X0Y0_FrameData[22] VPWR VGND sg13cmos5l_antennanp
X_0940_ Tile_X2Y0_FrameStrobe_O[5] Tile_X2Y0_FrameStrobe[5] VPWR VGND sg13cmos5l_buf_1
X_0871_ Tile_X2Y0_S2BEG[4] Tile_X2Y0_N2MID[3] VPWR VGND sg13cmos5l_buf_1
XFILLER_13_2692 VPWR VGND sg13cmos5l_decap_8
XFILLER_6_950 VPWR VGND sg13cmos5l_fill_2
XFILLER_13_1991 VPWR VGND sg13cmos5l_fill_2
XFILLER_13_1980 VPWR VGND sg13cmos5l_fill_2
XFILLER_6_983 VPWR VGND sg13cmos5l_fill_2
XFILLER_9_2237 VPWR VGND sg13cmos5l_decap_8
XFILLER_9_1569 VPWR VGND sg13cmos5l_decap_8
X_0305_ _0305_/Q Tile_X0Y0_FrameData[24] VGND VPWR Tile_X1Y0_FrameStrobe[3] latch
X_1285_ _1285_/X Tile_X3Y0_N2END[2] Tile_X3Y0_N4END[10] Tile_X3Y0_NN4END[5] _0575_/Q
+ _0437_/Q _0436_/Q VPWR VGND sg13cmos5l_mux4_1
X_0236_ _0236_/Q Tile_X0Y0_FrameData[29] VGND VPWR Tile_X1Y0_FrameStrobe[1] latch
XFILLER_3_1124 VPWR VGND sg13cmos5l_decap_8
X_0167_ _0167_/Q Tile_X0Y0_FrameData[18] VGND VPWR Tile_X0Y0_FrameStrobe[2] latch
X_0098_ _0098_/Q Tile_X0Y0_FrameData[23] VGND VPWR Tile_X0Y0_FrameStrobe[0] latch
XFILLER_14_2401 VPWR VGND sg13cmos5l_decap_8
XFILLER_14_1711 VPWR VGND sg13cmos5l_decap_8
XFILLER_10_1608 VPWR VGND sg13cmos5l_decap_8
XFILLER_14_1788 VPWR VGND sg13cmos5l_decap_8
XFILLER_5_2602 VPWR VGND sg13cmos5l_decap_8
XFILLER_5_2679 VPWR VGND sg13cmos5l_decap_8
XFILLER_3_1691 VPWR VGND sg13cmos5l_decap_8
XANTENNA_3604 Tile_X0Y0_FrameData[8] VPWR VGND sg13cmos5l_antennanp
XFILLER_13_1276 VPWR VGND sg13cmos5l_decap_8
XANTENNA_3615 Tile_X0Y0_FrameData[8] VPWR VGND sg13cmos5l_antennanp
XANTENNA_3626 Tile_X0Y0_N2END[6] VPWR VGND sg13cmos5l_antennanp
XANTENNA_3637 Tile_X0Y0_N4END[1] VPWR VGND sg13cmos5l_antennanp
XANTENNA_2903 Tile_X0Y0_FrameData[17] VPWR VGND sg13cmos5l_antennanp
XANTENNA_2914 Tile_X0Y0_FrameData[17] VPWR VGND sg13cmos5l_antennanp
XANTENNA_2925 Tile_X0Y0_FrameData[17] VPWR VGND sg13cmos5l_antennanp
XANTENNA_2936 Tile_X0Y0_FrameData[17] VPWR VGND sg13cmos5l_antennanp
XANTENNA_3648 Tile_X0Y0_N4END[2] VPWR VGND sg13cmos5l_antennanp
XANTENNA_3659 Tile_X0Y0_N4END[2] VPWR VGND sg13cmos5l_antennanp
XANTENNA_2947 Tile_X0Y0_FrameData[19] VPWR VGND sg13cmos5l_antennanp
XANTENNA_2958 Tile_X0Y0_FrameData[19] VPWR VGND sg13cmos5l_antennanp
XANTENNA_2969 Tile_X0Y0_FrameData[19] VPWR VGND sg13cmos5l_antennanp
XFILLER_8_1591 VPWR VGND sg13cmos5l_decap_8
X_1070_ Tile_X4Y0_SS4BEG[7] Tile_X4Y0_NN4END[8] VPWR VGND sg13cmos5l_buf_1
XANTENNA_160 Tile_X0Y0_FrameData[10] VPWR VGND sg13cmos5l_antennanp
XANTENNA_171 Tile_X0Y0_FrameData[10] VPWR VGND sg13cmos5l_antennanp
XANTENNA_182 Tile_X0Y0_FrameData[10] VPWR VGND sg13cmos5l_antennanp
XANTENNA_193 Tile_X0Y0_FrameData[10] VPWR VGND sg13cmos5l_antennanp
XFILLER_15_2710 VPWR VGND sg13cmos5l_decap_8
X_0923_ Tile_X3Y0_FrameStrobe_O[8] Tile_X3Y0_FrameStrobe[8] VPWR VGND sg13cmos5l_buf_1
XFILLER_14_1007 VPWR VGND sg13cmos5l_fill_1
XFILLER_11_2618 VPWR VGND sg13cmos5l_decap_8
X_0854_ Tile_X4Y0_FrameStrobe_O[11] Tile_X4Y0_FrameStrobe[11] VPWR VGND sg13cmos5l_buf_1
X_0785_ Tile_X3Y0_S4BEG[6] _1265_/X VPWR VGND sg13cmos5l_buf_1
XFILLER_9_1311 VPWR VGND sg13cmos5l_fill_1
X_1268_ _1268_/X Tile_X3Y0_N2MID[1] Tile_X3Y0_N4END[6] Tile_X3Y0_NN4END[9] _0575_/Q
+ _0471_/Q _0470_/Q VPWR VGND sg13cmos5l_mux4_1
X_0219_ _0219_/Q Tile_X0Y0_FrameData[14] VGND VPWR Tile_X1Y0_FrameStrobe[0] latch
X_1199_ _1199_/X Tile_X1Y0_N2END[4] Tile_X1Y0_N4END[4] Tile_X1Y0_NN4END[11] _0593_/Q
+ _0257_/Q _0256_/Q VPWR VGND sg13cmos5l_mux4_1
XFILLER_16_2507 VPWR VGND sg13cmos5l_decap_8
XFILLER_12_529 VPWR VGND sg13cmos5l_decap_8
XFILLER_14_2275 VPWR VGND sg13cmos5l_decap_8
XFILLER_10_2128 VPWR VGND sg13cmos5l_decap_8
XFILLER_14_1585 VPWR VGND sg13cmos5l_decap_8
XFILLER_10_21 VPWR VGND sg13cmos5l_decap_8
XANTENNA_1509 Tile_X0Y0_FrameData[3] VPWR VGND sg13cmos5l_antennanp
XFILLER_5_2410 VPWR VGND sg13cmos5l_decap_8
XFILLER_10_98 VPWR VGND sg13cmos5l_decap_8
XFILLER_5_2487 VPWR VGND sg13cmos5l_decap_8
XFILLER_11_573 VPWR VGND sg13cmos5l_decap_8
XANTENNA_4102 Tile_X1Y0_N4END[13] VPWR VGND sg13cmos5l_antennanp
XANTENNA_4113 Tile_X1Y0_N4END[13] VPWR VGND sg13cmos5l_antennanp
XANTENNA_4124 Tile_X1Y0_N4END[5] VPWR VGND sg13cmos5l_antennanp
XFILLER_7_555 VPWR VGND sg13cmos5l_decap_4
XANTENNA_3401 Tile_X0Y0_FrameData[21] VPWR VGND sg13cmos5l_antennanp
XANTENNA_3412 Tile_X0Y0_FrameData[21] VPWR VGND sg13cmos5l_antennanp
XANTENNA_4135 Tile_X3Y0_N4END[3] VPWR VGND sg13cmos5l_antennanp
XANTENNA_4146 Tile_X1Y0_N2END[2] VPWR VGND sg13cmos5l_antennanp
XFILLER_7_588 VPWR VGND sg13cmos5l_decap_8
XFILLER_13_1073 VPWR VGND sg13cmos5l_fill_1
XFILLER_10_2662 VPWR VGND sg13cmos5l_decap_8
XANTENNA_2700 Tile_X0Y0_FrameData[14] VPWR VGND sg13cmos5l_antennanp
XANTENNA_3423 Tile_X0Y0_FrameData[21] VPWR VGND sg13cmos5l_antennanp
XANTENNA_3434 Tile_X0Y0_FrameData[21] VPWR VGND sg13cmos5l_antennanp
XANTENNA_3445 Tile_X0Y0_FrameData[21] VPWR VGND sg13cmos5l_antennanp
X_0570_ NPU_ADDR6 Tile_X0Y0_UserCLK _1086_/X _0632_/L_HI VPWR VGND sg13cmos5l_dfrbpq_1
XANTENNA_2711 Tile_X0Y0_FrameData[14] VPWR VGND sg13cmos5l_antennanp
XANTENNA_2722 Tile_X0Y0_FrameData[14] VPWR VGND sg13cmos5l_antennanp
XANTENNA_2733 Tile_X0Y0_FrameData[14] VPWR VGND sg13cmos5l_antennanp
XANTENNA_2744 Tile_X0Y0_FrameData[14] VPWR VGND sg13cmos5l_antennanp
XANTENNA_3456 Tile_X0Y0_FrameData[8] VPWR VGND sg13cmos5l_antennanp
XANTENNA_3467 Tile_X0Y0_FrameData[8] VPWR VGND sg13cmos5l_antennanp
XANTENNA_3478 Tile_X0Y0_FrameData[8] VPWR VGND sg13cmos5l_antennanp
XANTENNA_3489 Tile_X0Y0_FrameData[8] VPWR VGND sg13cmos5l_antennanp
XFILLER_3_750 VPWR VGND sg13cmos5l_fill_2
XANTENNA_2755 Tile_X0Y0_FrameData[14] VPWR VGND sg13cmos5l_antennanp
XANTENNA_2766 Tile_X0Y0_FrameData[14] VPWR VGND sg13cmos5l_antennanp
XANTENNA_2777 Tile_X0Y0_FrameData[16] VPWR VGND sg13cmos5l_antennanp
XFILLER_6_2229 VPWR VGND sg13cmos5l_decap_8
XFILLER_3_783 VPWR VGND sg13cmos5l_fill_1
XANTENNA_2788 Tile_X0Y0_FrameData[16] VPWR VGND sg13cmos5l_antennanp
XANTENNA_2799 Tile_X0Y0_FrameData[16] VPWR VGND sg13cmos5l_antennanp
X_1122_ _1122_/X Tile_X0Y0_N4END[10] Tile_X0Y0_N4END[11] Tile_X0Y0_NN4END[8] Tile_X0Y0_NN4END[10]
+ _0101_/Q _0100_/Q VPWR VGND sg13cmos5l_mux4_1
XFILLER_4_1241 VPWR VGND sg13cmos5l_fill_2
XFILLER_4_1230 VPWR VGND sg13cmos5l_fill_1
X_1053_ Tile_X4Y0_S4BEG[6] Tile_X4Y0_N4END[9] VPWR VGND sg13cmos5l_buf_1
XFILLER_15_2551 VPWR VGND sg13cmos5l_decap_8
X_0906_ Tile_X2Y0_SS4BEG[7] _1242_/X VPWR VGND sg13cmos5l_buf_1
XFILLER_15_2584 VPWR VGND sg13cmos5l_decap_8
XFILLER_15_1850 VPWR VGND sg13cmos5l_decap_8
XFILLER_11_2415 VPWR VGND sg13cmos5l_decap_8
XANTENNA__0803__X Tile_X3Y0_SS4BEG[8] VPWR VGND sg13cmos5l_antennanp
XFILLER_11_1725 VPWR VGND sg13cmos5l_decap_8
X_0837_ Tile_X4Y0_FrameData_O[26] Tile_X0Y0_FrameData[26] VPWR VGND sg13cmos5l_buf_1
X_0768_ Tile_X3Y0_S2BEG[5] Tile_X3Y0_N2MID[2] VPWR VGND sg13cmos5l_buf_1
XANTENNA_3990 Tile_X0Y0_FrameData[18] VPWR VGND sg13cmos5l_antennanp
X_0699_ Tile_X0Y0_FrameStrobe_O[12] Tile_X0Y0_FrameStrobe[12] VPWR VGND sg13cmos5l_buf_1
XFILLER_9_1141 VPWR VGND sg13cmos5l_decap_8
XFILLER_6_2774 VPWR VGND sg13cmos5l_decap_8
XFILLER_0_2340 VPWR VGND sg13cmos5l_decap_4
XANTENNA_918 Tile_X0Y0_FrameData[27] VPWR VGND sg13cmos5l_antennanp
XANTENNA_907 Tile_X0Y0_FrameData[27] VPWR VGND sg13cmos5l_antennanp
XANTENNA_929 Tile_X0Y0_FrameData[28] VPWR VGND sg13cmos5l_antennanp
XFILLER_16_2337 VPWR VGND sg13cmos5l_fill_2
XFILLER_16_2326 VPWR VGND sg13cmos5l_decap_8
XANTENNA__0713__X Tile_X1Y0_S2BEGb[6] VPWR VGND sg13cmos5l_antennanp
XFILLER_14_2083 VPWR VGND sg13cmos5l_decap_8
XANTENNA_93 Tile_X0Y0_FrameData[0] VPWR VGND sg13cmos5l_antennanp
XANTENNA_82 Tile_X0Y0_FrameData[0] VPWR VGND sg13cmos5l_antennanp
XANTENNA_71 Tile_X0Y0_FrameData[0] VPWR VGND sg13cmos5l_antennanp
XANTENNA_60 Tile_X0Y0_FrameData[0] VPWR VGND sg13cmos5l_antennanp
XFILLER_10_1235 VPWR VGND sg13cmos5l_decap_8
XANTENNA_2007 Tile_X0Y0_FrameData[6] VPWR VGND sg13cmos5l_antennanp
XANTENNA_2018 Tile_X0Y0_FrameData[6] VPWR VGND sg13cmos5l_antennanp
XANTENNA_2029 Tile_X0Y0_FrameData[6] VPWR VGND sg13cmos5l_antennanp
XFILLER_4_569 VPWR VGND sg13cmos5l_decap_8
XANTENNA_1306 Tile_X0Y0_FrameData[30] VPWR VGND sg13cmos5l_antennanp
XANTENNA_1317 Tile_X0Y0_FrameData[30] VPWR VGND sg13cmos5l_antennanp
XANTENNA_1328 Tile_X0Y0_FrameData[30] VPWR VGND sg13cmos5l_antennanp
XFILLER_7_2516 VPWR VGND sg13cmos5l_decap_8
XANTENNA_1339 Tile_X0Y0_FrameData[30] VPWR VGND sg13cmos5l_antennanp
XFILLER_5_2284 VPWR VGND sg13cmos5l_decap_8
XFILLER_16_676 VPWR VGND sg13cmos5l_decap_8
XFILLER_15_175 VPWR VGND sg13cmos5l_decap_8
XFILLER_15_1102 VPWR VGND sg13cmos5l_decap_8
XFILLER_12_2724 VPWR VGND sg13cmos5l_decap_8
XFILLER_15_1179 VPWR VGND sg13cmos5l_decap_8
XFILLER_11_370 VPWR VGND sg13cmos5l_fill_2
XFILLER_7_77 VPWR VGND sg13cmos5l_decap_8
XANTENNA_3220 Tile_X0Y0_FrameData[20] VPWR VGND sg13cmos5l_antennanp
X_0622_ _0622_/L_HI VPWR VGND sg13cmos5l_tiehi
XFILLER_10_2492 VPWR VGND sg13cmos5l_decap_8
XANTENNA_3231 Tile_X0Y0_FrameData[20] VPWR VGND sg13cmos5l_antennanp
XANTENNA_3242 Tile_X0Y0_FrameData[20] VPWR VGND sg13cmos5l_antennanp
XANTENNA_3253 Tile_X0Y0_FrameData[20] VPWR VGND sg13cmos5l_antennanp
XANTENNA_3264 Tile_X0Y0_FrameData[20] VPWR VGND sg13cmos5l_antennanp
X_0553_ NPU_WDATA29 Tile_X0Y0_UserCLK _1125_/X _0634_/L_HI VPWR VGND sg13cmos5l_dfrbpq_1
XANTENNA_2530 Tile_X0Y0_FrameData[12] VPWR VGND sg13cmos5l_antennanp
XANTENNA_2541 Tile_X0Y0_FrameData[12] VPWR VGND sg13cmos5l_antennanp
XANTENNA_2552 Tile_X0Y0_FrameData[12] VPWR VGND sg13cmos5l_antennanp
XANTENNA_3275 Tile_X0Y0_FrameData[20] VPWR VGND sg13cmos5l_antennanp
XANTENNA_3286 Tile_X0Y0_FrameData[20] VPWR VGND sg13cmos5l_antennanp
XANTENNA_3297 Tile_X0Y0_FrameData[20] VPWR VGND sg13cmos5l_antennanp
XANTENNA_1840 Tile_X0Y0_FrameData[5] VPWR VGND sg13cmos5l_antennanp
XANTENNA_2563 Tile_X0Y0_FrameData[12] VPWR VGND sg13cmos5l_antennanp
XANTENNA_2574 Tile_X0Y0_FrameData[12] VPWR VGND sg13cmos5l_antennanp
XANTENNA_2585 Tile_X0Y0_FrameData[13] VPWR VGND sg13cmos5l_antennanp
X_0484_ _0484_/Q Tile_X0Y0_FrameData[21] VGND VPWR Tile_X3Y0_FrameStrobe[2] latch
XANTENNA_1851 Tile_X0Y0_FrameData[5] VPWR VGND sg13cmos5l_antennanp
XANTENNA_1862 Tile_X0Y0_FrameData[5] VPWR VGND sg13cmos5l_antennanp
XANTENNA_1873 Tile_X0Y0_FrameData[5] VPWR VGND sg13cmos5l_antennanp
XANTENNA_1884 Tile_X0Y0_FrameData[5] VPWR VGND sg13cmos5l_antennanp
XANTENNA_2596 Tile_X0Y0_FrameData[13] VPWR VGND sg13cmos5l_antennanp
XANTENNA_1895 Tile_X0Y0_FrameData[5] VPWR VGND sg13cmos5l_antennanp
X_1105_ _1105_/X Tile_X1Y0_N4END[9] Tile_X1Y0_N4END[10] Tile_X1Y0_NN4END[9] Tile_X1Y0_NN4END[11]
+ _0215_/Q _0214_/Q VPWR VGND sg13cmos5l_mux4_1
XFILLER_1_2660 VPWR VGND sg13cmos5l_fill_2
X_1036_ Tile_X4Y0_S2BEG[5] Tile_X4Y0_N2MID[2] VPWR VGND sg13cmos5l_buf_1
XFILLER_15_2370 VPWR VGND sg13cmos5l_decap_8
XFILLER_11_2212 VPWR VGND sg13cmos5l_decap_8
XFILLER_11_1522 VPWR VGND sg13cmos5l_decap_8
XFILLER_11_2289 VPWR VGND sg13cmos5l_decap_8
XFILLER_11_1599 VPWR VGND sg13cmos5l_decap_8
XFILLER_2_2446 VPWR VGND sg13cmos5l_decap_8
XFILLER_2_1723 VPWR VGND sg13cmos5l_decap_8
XANTENNA__0708__X Tile_X1Y0_S2BEGb[1] VPWR VGND sg13cmos5l_antennanp
XANTENNA_726 Tile_X0Y0_FrameData[25] VPWR VGND sg13cmos5l_antennanp
XANTENNA_715 Tile_X0Y0_FrameData[25] VPWR VGND sg13cmos5l_antennanp
XANTENNA_704 Tile_X0Y0_FrameData[25] VPWR VGND sg13cmos5l_antennanp
XFILLER_16_42 VPWR VGND sg13cmos5l_decap_8
XANTENNA_759 Tile_X0Y0_FrameData[25] VPWR VGND sg13cmos5l_antennanp
XANTENNA_748 Tile_X0Y0_FrameData[25] VPWR VGND sg13cmos5l_antennanp
XANTENNA_737 Tile_X0Y0_FrameData[25] VPWR VGND sg13cmos5l_antennanp
XFILLER_16_2134 VPWR VGND sg13cmos5l_decap_8
XFILLER_13_657 VPWR VGND sg13cmos5l_decap_8
XFILLER_8_105 VPWR VGND sg13cmos5l_decap_8
XFILLER_16_1444 VPWR VGND sg13cmos5l_decap_4
XFILLER_10_1076 VPWR VGND sg13cmos5l_decap_8
XANTENNA_1103 Tile_X0Y0_FrameData[2] VPWR VGND sg13cmos5l_antennanp
XANTENNA_1114 Tile_X0Y0_FrameData[2] VPWR VGND sg13cmos5l_antennanp
XANTENNA_1125 Tile_X0Y0_FrameData[2] VPWR VGND sg13cmos5l_antennanp
XANTENNA_1136 Tile_X0Y0_FrameData[2] VPWR VGND sg13cmos5l_antennanp
XANTENNA_1147 Tile_X0Y0_FrameData[2] VPWR VGND sg13cmos5l_antennanp
XANTENNA_1158 Tile_X0Y0_FrameData[30] VPWR VGND sg13cmos5l_antennanp
XANTENNA_1169 Tile_X0Y0_FrameData[30] VPWR VGND sg13cmos5l_antennanp
XFILLER_7_1645 VPWR VGND sg13cmos5l_decap_8
XFILLER_16_2690 VPWR VGND sg13cmos5l_decap_8
XFILLER_8_661 VPWR VGND sg13cmos5l_decap_8
XFILLER_12_1831 VPWR VGND sg13cmos5l_decap_8
XFILLER_12_2598 VPWR VGND sg13cmos5l_decap_8
XANTENNA_3050 Tile_X0Y0_FrameData[19] VPWR VGND sg13cmos5l_antennanp
XANTENNA_3061 Tile_X0Y0_FrameData[19] VPWR VGND sg13cmos5l_antennanp
XANTENNA_3072 Tile_X0Y0_FrameData[19] VPWR VGND sg13cmos5l_antennanp
X_0605_ _0605_/L_HI VPWR VGND sg13cmos5l_tiehi
XANTENNA_2360 Tile_X0Y0_FrameData[11] VPWR VGND sg13cmos5l_antennanp
XANTENNA_3083 Tile_X0Y0_FrameData[19] VPWR VGND sg13cmos5l_antennanp
XANTENNA_3094 Tile_X0Y0_FrameData[19] VPWR VGND sg13cmos5l_antennanp
X_0536_ NPU_WDATA12 Tile_X0Y0_UserCLK _1108_/X _0635_/L_HI VPWR VGND sg13cmos5l_dfrbpq_1
XANTENNA_2371 Tile_X0Y0_FrameData[11] VPWR VGND sg13cmos5l_antennanp
XANTENNA_2382 Tile_X0Y0_FrameData[11] VPWR VGND sg13cmos5l_antennanp
XANTENNA_2393 Tile_X0Y0_FrameData[11] VPWR VGND sg13cmos5l_antennanp
X_0467_ _0467_/Q Tile_X0Y0_FrameData[6] VGND VPWR Tile_X3Y0_FrameStrobe[1] latch
XANTENNA_1670 Tile_X0Y0_FrameData[4] VPWR VGND sg13cmos5l_antennanp
XANTENNA_1681 Tile_X0Y0_FrameData[4] VPWR VGND sg13cmos5l_antennanp
XANTENNA_1692 Tile_X0Y0_FrameData[4] VPWR VGND sg13cmos5l_antennanp
XFILLER_6_1155 VPWR VGND sg13cmos5l_decap_8
X_0398_ _0398_/Q Tile_X0Y0_FrameData[11] VGND VPWR Tile_X2Y0_FrameStrobe[2] latch
X_1019_ Tile_X0Y0_S2BEG[4] Tile_X0Y0_N2MID[3] VPWR VGND sg13cmos5l_buf_1
XFILLER_10_627 VPWR VGND sg13cmos5l_decap_8
XFILLER_13_1628 VPWR VGND sg13cmos5l_decap_8
XFILLER_11_2086 VPWR VGND sg13cmos5l_decap_8
XFILLER_8_2622 VPWR VGND sg13cmos5l_decap_8
XFILLER_8_2699 VPWR VGND sg13cmos5l_decap_8
XFILLER_2_2221 VPWR VGND sg13cmos5l_decap_8
XANTENNA_501 Tile_X0Y0_FrameData[23] VPWR VGND sg13cmos5l_antennanp
XANTENNA_534 Tile_X0Y0_FrameData[23] VPWR VGND sg13cmos5l_antennanp
XANTENNA_523 Tile_X0Y0_FrameData[23] VPWR VGND sg13cmos5l_antennanp
XANTENNA_512 Tile_X0Y0_FrameData[23] VPWR VGND sg13cmos5l_antennanp
XANTENNA_567 Tile_X0Y0_FrameData[23] VPWR VGND sg13cmos5l_antennanp
XANTENNA_556 Tile_X0Y0_FrameData[23] VPWR VGND sg13cmos5l_antennanp
XANTENNA_545 Tile_X0Y0_FrameData[23] VPWR VGND sg13cmos5l_antennanp
XANTENNA_589 Tile_X0Y0_FrameData[23] VPWR VGND sg13cmos5l_antennanp
XANTENNA_578 Tile_X0Y0_FrameData[23] VPWR VGND sg13cmos5l_antennanp
XFILLER_12_1105 VPWR VGND sg13cmos5l_decap_8
XFILLER_5_620 VPWR VGND sg13cmos5l_decap_8
XANTENNA__0901__X Tile_X2Y0_SS4BEG[2] VPWR VGND sg13cmos5l_antennanp
XFILLER_9_1718 VPWR VGND sg13cmos5l_decap_8
XFILLER_4_56 VPWR VGND sg13cmos5l_decap_8
X_0321_ _0321_/Q Tile_X0Y0_FrameData[24] VGND VPWR Tile_X2Y0_FrameStrobe[0] latch
XFILLER_7_2176 VPWR VGND sg13cmos5l_fill_1
X_0252_ _0252_/Q Tile_X0Y0_FrameData[13] VGND VPWR Tile_X1Y0_FrameStrobe[1] latch
X_0183_ _0183_/Q Tile_X0Y0_FrameData[2] VGND VPWR Tile_X0Y0_FrameStrobe[2] latch
XFILLER_1_1030 VPWR VGND sg13cmos5l_fill_1
XFILLER_14_2616 VPWR VGND sg13cmos5l_decap_8
XFILLER_14_1915 VPWR VGND sg13cmos5l_fill_1
XFILLER_14_1959 VPWR VGND sg13cmos5l_fill_2
XFILLER_14_1937 VPWR VGND sg13cmos5l_fill_1
XFILLER_12_2351 VPWR VGND sg13cmos5l_decap_8
XANTENNA__0811__X Tile_X4Y0_FrameData_O[0] VPWR VGND sg13cmos5l_antennanp
XFILLER_8_1217 VPWR VGND sg13cmos5l_fill_2
XANTENNA_2190 Tile_X0Y0_FrameData[9] VPWR VGND sg13cmos5l_antennanp
X_0519_ _0519_/Q Tile_X0Y0_FrameData[24] VGND VPWR Tile_X4Y0_FrameStrobe[0] latch
XFILLER_3_2563 VPWR VGND sg13cmos5l_decap_8
XFILLER_13_21 VPWR VGND sg13cmos5l_decap_8
XFILLER_10_435 VPWR VGND sg13cmos5l_fill_2
XFILLER_13_2159 VPWR VGND sg13cmos5l_decap_8
XFILLER_13_98 VPWR VGND sg13cmos5l_decap_8
XANTENNA_3808 Tile_X0Y0_FrameData[18] VPWR VGND sg13cmos5l_antennanp
XANTENNA_3819 Tile_X0Y0_FrameData[18] VPWR VGND sg13cmos5l_antennanp
XANTENNA__0721__X Tile_X1Y0_S4BEG[6] VPWR VGND sg13cmos5l_antennanp
XFILLER_11_1182 VPWR VGND sg13cmos5l_decap_8
XFILLER_8_2485 VPWR VGND sg13cmos5l_decap_8
XFILLER_8_1762 VPWR VGND sg13cmos5l_decap_8
XFILLER_8_1773 VPWR VGND sg13cmos5l_fill_2
XANTENNA_320 Tile_X0Y0_FrameData[1] VPWR VGND sg13cmos5l_antennanp
XANTENNA_331 Tile_X0Y0_FrameData[1] VPWR VGND sg13cmos5l_antennanp
XANTENNA_342 Tile_X0Y0_FrameData[1] VPWR VGND sg13cmos5l_antennanp
XANTENNA_353 Tile_X0Y0_FrameData[1] VPWR VGND sg13cmos5l_antennanp
XANTENNA_364 Tile_X0Y0_FrameData[1] VPWR VGND sg13cmos5l_antennanp
XANTENNA_375 Tile_X0Y0_FrameData[1] VPWR VGND sg13cmos5l_antennanp
XANTENNA_386 Tile_X0Y0_FrameData[1] VPWR VGND sg13cmos5l_antennanp
XFILLER_14_730 VPWR VGND sg13cmos5l_decap_8
XANTENNA_397 Tile_X0Y0_FrameData[22] VPWR VGND sg13cmos5l_antennanp
X_0870_ Tile_X2Y0_S2BEG[3] Tile_X2Y0_N2MID[4] VPWR VGND sg13cmos5l_buf_1
XFILLER_16_1071 VPWR VGND sg13cmos5l_fill_1
XFILLER_13_2671 VPWR VGND sg13cmos5l_decap_8
XFILLER_10_980 VPWR VGND sg13cmos5l_fill_2
XFILLER_9_2216 VPWR VGND sg13cmos5l_decap_8
X_0304_ _0304_/Q Tile_X0Y0_FrameData[25] VGND VPWR Tile_X1Y0_FrameStrobe[3] latch
X_1284_ _1284_/X Tile_X3Y0_N2END[1] Tile_X3Y0_N4END[9] Tile_X3Y0_NN4END[6] _0574_/Q
+ _0439_/Q _0438_/Q VPWR VGND sg13cmos5l_mux4_1
X_0235_ _0235_/Q Tile_X0Y0_FrameData[30] VGND VPWR Tile_X1Y0_FrameStrobe[1] latch
X_0166_ _0166_/Q Tile_X0Y0_FrameData[19] VGND VPWR Tile_X0Y0_FrameStrobe[2] latch
X_0097_ _0097_/Q Tile_X0Y0_FrameData[24] VGND VPWR Tile_X0Y0_FrameStrobe[0] latch
XANTENNA__0806__X Tile_X3Y0_SS4BEG[11] VPWR VGND sg13cmos5l_antennanp
XFILLER_14_2457 VPWR VGND sg13cmos5l_fill_2
X_0999_ Tile_X0Y0_S4BEG[8] _1147_/X VPWR VGND sg13cmos5l_buf_1
XFILLER_14_1767 VPWR VGND sg13cmos5l_decap_8
XFILLER_5_2658 VPWR VGND sg13cmos5l_decap_8
XFILLER_5_1935 VPWR VGND sg13cmos5l_fill_1
XFILLER_3_1670 VPWR VGND sg13cmos5l_decap_8
XANTENNA__0716__X Tile_X1Y0_S4BEG[1] VPWR VGND sg13cmos5l_antennanp
XFILLER_11_733 VPWR VGND sg13cmos5l_decap_8
XFILLER_11_755 VPWR VGND sg13cmos5l_fill_2
XFILLER_6_203 VPWR VGND sg13cmos5l_fill_2
XFILLER_13_1255 VPWR VGND sg13cmos5l_decap_8
XANTENNA_3605 Tile_X0Y0_FrameData[8] VPWR VGND sg13cmos5l_antennanp
XANTENNA_3616 Tile_X0Y0_FrameData[8] VPWR VGND sg13cmos5l_antennanp
XANTENNA_3627 Tile_X0Y0_N2END[6] VPWR VGND sg13cmos5l_antennanp
XANTENNA_3638 Tile_X0Y0_N4END[1] VPWR VGND sg13cmos5l_antennanp
XANTENNA_2904 Tile_X0Y0_FrameData[17] VPWR VGND sg13cmos5l_antennanp
XANTENNA_2915 Tile_X0Y0_FrameData[17] VPWR VGND sg13cmos5l_antennanp
XANTENNA_2926 Tile_X0Y0_FrameData[17] VPWR VGND sg13cmos5l_antennanp
XANTENNA_3649 Tile_X0Y0_N4END[2] VPWR VGND sg13cmos5l_antennanp
XFILLER_6_0 VPWR VGND sg13cmos5l_decap_8
XANTENNA_2937 Tile_X0Y0_FrameData[17] VPWR VGND sg13cmos5l_antennanp
XANTENNA_2948 Tile_X0Y0_FrameData[19] VPWR VGND sg13cmos5l_antennanp
XANTENNA_2959 Tile_X0Y0_FrameData[19] VPWR VGND sg13cmos5l_antennanp
XFILLER_3_998 VPWR VGND sg13cmos5l_fill_2
XFILLER_8_2282 VPWR VGND sg13cmos5l_decap_8
XFILLER_8_2260 VPWR VGND sg13cmos5l_decap_8
XFILLER_8_1570 VPWR VGND sg13cmos5l_decap_8
XFILLER_4_2124 VPWR VGND sg13cmos5l_fill_1
XFILLER_1_35 VPWR VGND sg13cmos5l_decap_8
XANTENNA_150 Tile_X0Y0_FrameData[10] VPWR VGND sg13cmos5l_antennanp
XANTENNA_161 Tile_X0Y0_FrameData[10] VPWR VGND sg13cmos5l_antennanp
XANTENNA_172 Tile_X0Y0_FrameData[10] VPWR VGND sg13cmos5l_antennanp
XANTENNA_183 Tile_X0Y0_FrameData[10] VPWR VGND sg13cmos5l_antennanp
XANTENNA_194 Tile_X0Y0_FrameData[10] VPWR VGND sg13cmos5l_antennanp
X_0922_ Tile_X3Y0_FrameStrobe_O[7] Tile_X3Y0_FrameStrobe[7] VPWR VGND sg13cmos5l_buf_1
X_0853_ Tile_X4Y0_FrameStrobe_O[10] Tile_X4Y0_FrameStrobe[10] VPWR VGND sg13cmos5l_buf_1
X_0784_ Tile_X3Y0_S4BEG[5] _1264_/X VPWR VGND sg13cmos5l_buf_1
XFILLER_7_1080 VPWR VGND sg13cmos5l_decap_8
X_1267_ _1267_/X Tile_X3Y0_N2MID[0] Tile_X3Y0_N4END[7] Tile_X3Y0_NN4END[8] _0574_/Q
+ _0473_/Q _0472_/Q VPWR VGND sg13cmos5l_mux4_1
X_0218_ _0218_/Q Tile_X0Y0_FrameData[15] VGND VPWR Tile_X1Y0_FrameStrobe[0] latch
X_1198_ _1198_/X Tile_X1Y0_N2END[3] Tile_X1Y0_N4END[3] Tile_X1Y0_NN4END[12] _0594_/Q
+ _0259_/Q _0258_/Q VPWR VGND sg13cmos5l_mux4_1
XFILLER_0_2566 VPWR VGND sg13cmos5l_decap_8
X_0149_ _0149_/Q Tile_X0Y0_FrameData[4] VGND VPWR Tile_X0Y0_FrameStrobe[1] latch
XFILLER_0_2588 VPWR VGND sg13cmos5l_decap_8
XFILLER_0_2577 VPWR VGND sg13cmos5l_fill_1
XFILLER_12_508 VPWR VGND sg13cmos5l_decap_8
XFILLER_10_2107 VPWR VGND sg13cmos5l_decap_8
XFILLER_14_1564 VPWR VGND sg13cmos5l_decap_8
XFILLER_10_77 VPWR VGND sg13cmos5l_decap_8
XFILLER_5_2466 VPWR VGND sg13cmos5l_decap_8
XFILLER_5_1765 VPWR VGND sg13cmos5l_decap_8
XFILLER_15_2018 VPWR VGND sg13cmos5l_fill_1
XFILLER_15_1339 VPWR VGND sg13cmos5l_fill_2
XFILLER_11_552 VPWR VGND sg13cmos5l_decap_8
XANTENNA_4103 Tile_X1Y0_N4END[13] VPWR VGND sg13cmos5l_antennanp
XANTENNA_4114 Tile_X1Y0_N4END[13] VPWR VGND sg13cmos5l_antennanp
XFILLER_7_534 VPWR VGND sg13cmos5l_decap_8
XFILLER_10_2641 VPWR VGND sg13cmos5l_decap_8
XANTENNA_3402 Tile_X0Y0_FrameData[21] VPWR VGND sg13cmos5l_antennanp
XANTENNA_3413 Tile_X0Y0_FrameData[21] VPWR VGND sg13cmos5l_antennanp
XANTENNA_4125 Tile_X1Y0_N4END[5] VPWR VGND sg13cmos5l_antennanp
XANTENNA_4136 Tile_X3Y0_N4END[3] VPWR VGND sg13cmos5l_antennanp
XANTENNA_4147 Tile_X1Y0_N2MID[1] VPWR VGND sg13cmos5l_antennanp
XANTENNA_2701 Tile_X0Y0_FrameData[14] VPWR VGND sg13cmos5l_antennanp
XANTENNA_3424 Tile_X0Y0_FrameData[21] VPWR VGND sg13cmos5l_antennanp
XANTENNA_3435 Tile_X0Y0_FrameData[21] VPWR VGND sg13cmos5l_antennanp
XANTENNA_3446 Tile_X0Y0_FrameData[21] VPWR VGND sg13cmos5l_antennanp
XANTENNA_2712 Tile_X0Y0_FrameData[14] VPWR VGND sg13cmos5l_antennanp
XANTENNA_2723 Tile_X0Y0_FrameData[14] VPWR VGND sg13cmos5l_antennanp
XANTENNA_2734 Tile_X0Y0_FrameData[14] VPWR VGND sg13cmos5l_antennanp
XANTENNA_3457 Tile_X0Y0_FrameData[8] VPWR VGND sg13cmos5l_antennanp
XANTENNA_3468 Tile_X0Y0_FrameData[8] VPWR VGND sg13cmos5l_antennanp
XANTENNA_3479 Tile_X0Y0_FrameData[8] VPWR VGND sg13cmos5l_antennanp
XANTENNA_2745 Tile_X0Y0_FrameData[14] VPWR VGND sg13cmos5l_antennanp
XANTENNA_2756 Tile_X0Y0_FrameData[14] VPWR VGND sg13cmos5l_antennanp
XANTENNA_2767 Tile_X0Y0_FrameData[14] VPWR VGND sg13cmos5l_antennanp
XANTENNA_2778 Tile_X0Y0_FrameData[16] VPWR VGND sg13cmos5l_antennanp
XFILLER_6_2208 VPWR VGND sg13cmos5l_decap_8
XANTENNA_2789 Tile_X0Y0_FrameData[16] VPWR VGND sg13cmos5l_antennanp
XFILLER_8_2090 VPWR VGND sg13cmos5l_fill_1
X_1121_ _1121_/X Tile_X0Y0_N4END[9] Tile_X0Y0_N4END[10] Tile_X0Y0_NN4END[9] Tile_X0Y0_NN4END[11]
+ _0103_/Q _0102_/Q VPWR VGND sg13cmos5l_mux4_1
X_1052_ Tile_X4Y0_S4BEG[5] Tile_X4Y0_N4END[10] VPWR VGND sg13cmos5l_buf_1
XFILLER_0_1139 VPWR VGND sg13cmos5l_decap_4
X_0905_ Tile_X2Y0_SS4BEG[6] _1241_/X VPWR VGND sg13cmos5l_buf_1
XFILLER_11_1704 VPWR VGND sg13cmos5l_decap_8
X_0836_ Tile_X4Y0_FrameData_O[25] Tile_X0Y0_FrameData[25] VPWR VGND sg13cmos5l_buf_1
X_0767_ Tile_X3Y0_S2BEG[4] Tile_X3Y0_N2MID[3] VPWR VGND sg13cmos5l_buf_1
XANTENNA_3980 Tile_X0Y0_FrameData[18] VPWR VGND sg13cmos5l_antennanp
XANTENNA_3991 Tile_X0Y0_FrameData[18] VPWR VGND sg13cmos5l_antennanp
X_0698_ Tile_X0Y0_FrameStrobe_O[11] Tile_X0Y0_FrameStrobe[11] VPWR VGND sg13cmos5l_buf_1
XFILLER_6_2753 VPWR VGND sg13cmos5l_decap_8
XFILLER_9_1197 VPWR VGND sg13cmos5l_decap_8
XANTENNA_908 Tile_X0Y0_FrameData[27] VPWR VGND sg13cmos5l_antennanp
XANTENNA_919 Tile_X0Y0_FrameData[27] VPWR VGND sg13cmos5l_antennanp
XFILLER_16_2305 VPWR VGND sg13cmos5l_decap_8
XFILLER_0_1673 VPWR VGND sg13cmos5l_fill_1
XFILLER_16_1626 VPWR VGND sg13cmos5l_decap_8
XFILLER_16_1659 VPWR VGND sg13cmos5l_decap_8
XFILLER_14_2062 VPWR VGND sg13cmos5l_decap_8
XANTENNA_50 Tile_X0Y0_FrameData[0] VPWR VGND sg13cmos5l_antennanp
XANTENNA_83 Tile_X0Y0_FrameData[0] VPWR VGND sg13cmos5l_antennanp
XANTENNA_72 Tile_X0Y0_FrameData[0] VPWR VGND sg13cmos5l_antennanp
XANTENNA_61 Tile_X0Y0_FrameData[0] VPWR VGND sg13cmos5l_antennanp
XANTENNA_94 Tile_X0Y0_FrameData[0] VPWR VGND sg13cmos5l_antennanp
XFILLER_4_548 VPWR VGND sg13cmos5l_decap_8
XANTENNA_2008 Tile_X0Y0_FrameData[6] VPWR VGND sg13cmos5l_antennanp
XANTENNA_2019 Tile_X0Y0_FrameData[6] VPWR VGND sg13cmos5l_antennanp
XANTENNA_1307 Tile_X0Y0_FrameData[30] VPWR VGND sg13cmos5l_antennanp
XANTENNA_1318 Tile_X0Y0_FrameData[30] VPWR VGND sg13cmos5l_antennanp
XANTENNA_1329 Tile_X0Y0_FrameData[30] VPWR VGND sg13cmos5l_antennanp
XFILLER_0_743 VPWR VGND sg13cmos5l_fill_2
XFILLER_7_1838 VPWR VGND sg13cmos5l_fill_1
XFILLER_5_2263 VPWR VGND sg13cmos5l_decap_8
XFILLER_16_655 VPWR VGND sg13cmos5l_decap_8
XFILLER_15_154 VPWR VGND sg13cmos5l_decap_8
XANTENNA__0904__X Tile_X2Y0_SS4BEG[5] VPWR VGND sg13cmos5l_antennanp
XFILLER_12_2703 VPWR VGND sg13cmos5l_decap_8
XFILLER_15_1158 VPWR VGND sg13cmos5l_decap_8
XFILLER_7_56 VPWR VGND sg13cmos5l_decap_8
XANTENNA_3210 Tile_X0Y0_FrameData[20] VPWR VGND sg13cmos5l_antennanp
XANTENNA_3221 Tile_X0Y0_FrameData[20] VPWR VGND sg13cmos5l_antennanp
X_0621_ _0621_/L_HI VPWR VGND sg13cmos5l_tiehi
XFILLER_10_2471 VPWR VGND sg13cmos5l_decap_8
XANTENNA_3232 Tile_X0Y0_FrameData[20] VPWR VGND sg13cmos5l_antennanp
XANTENNA_3243 Tile_X0Y0_FrameData[20] VPWR VGND sg13cmos5l_antennanp
XANTENNA_3254 Tile_X0Y0_FrameData[20] VPWR VGND sg13cmos5l_antennanp
X_0552_ NPU_WDATA28 Tile_X0Y0_UserCLK _1124_/X _0645_/L_HI VPWR VGND sg13cmos5l_dfrbpq_1
XANTENNA_2520 Tile_X0Y0_FrameData[12] VPWR VGND sg13cmos5l_antennanp
XANTENNA_2531 Tile_X0Y0_FrameData[12] VPWR VGND sg13cmos5l_antennanp
XANTENNA_2542 Tile_X0Y0_FrameData[12] VPWR VGND sg13cmos5l_antennanp
XANTENNA_3265 Tile_X0Y0_FrameData[20] VPWR VGND sg13cmos5l_antennanp
XANTENNA_3276 Tile_X0Y0_FrameData[20] VPWR VGND sg13cmos5l_antennanp
XANTENNA_3287 Tile_X0Y0_FrameData[20] VPWR VGND sg13cmos5l_antennanp
XFILLER_10_1792 VPWR VGND sg13cmos5l_decap_8
XANTENNA_1830 Tile_X0Y0_FrameData[5] VPWR VGND sg13cmos5l_antennanp
XANTENNA_1841 Tile_X0Y0_FrameData[5] VPWR VGND sg13cmos5l_antennanp
XANTENNA_2553 Tile_X0Y0_FrameData[12] VPWR VGND sg13cmos5l_antennanp
XANTENNA_2564 Tile_X0Y0_FrameData[12] VPWR VGND sg13cmos5l_antennanp
XANTENNA_2575 Tile_X0Y0_FrameData[12] VPWR VGND sg13cmos5l_antennanp
XANTENNA_2586 Tile_X0Y0_FrameData[13] VPWR VGND sg13cmos5l_antennanp
XANTENNA_3298 Tile_X0Y0_FrameData[20] VPWR VGND sg13cmos5l_antennanp
X_0483_ _0483_/Q Tile_X0Y0_FrameData[22] VGND VPWR Tile_X3Y0_FrameStrobe[2] latch
XANTENNA_1852 Tile_X0Y0_FrameData[5] VPWR VGND sg13cmos5l_antennanp
XANTENNA_1863 Tile_X0Y0_FrameData[5] VPWR VGND sg13cmos5l_antennanp
XANTENNA_1874 Tile_X0Y0_FrameData[5] VPWR VGND sg13cmos5l_antennanp
XANTENNA_2597 Tile_X0Y0_FrameData[13] VPWR VGND sg13cmos5l_antennanp
XANTENNA_1885 Tile_X0Y0_FrameData[5] VPWR VGND sg13cmos5l_antennanp
XANTENNA_1896 Tile_X0Y0_FrameData[5] VPWR VGND sg13cmos5l_antennanp
X_1104_ _1104_/X Tile_X1Y0_N4END[8] Tile_X1Y0_N4END[9] Tile_X1Y0_NN4END[8] Tile_X1Y0_NN4END[10]
+ _0217_/Q _0216_/Q VPWR VGND sg13cmos5l_mux4_1
XFILLER_1_2672 VPWR VGND sg13cmos5l_decap_4
X_1035_ Tile_X4Y0_S2BEG[4] Tile_X4Y0_N2MID[3] VPWR VGND sg13cmos5l_buf_1
XFILLER_1_2694 VPWR VGND sg13cmos5l_decap_4
XANTENNA__0814__X Tile_X4Y0_FrameData_O[3] VPWR VGND sg13cmos5l_antennanp
XFILLER_11_2268 VPWR VGND sg13cmos5l_decap_8
X_0819_ Tile_X4Y0_FrameData_O[8] Tile_X0Y0_FrameData[8] VPWR VGND sg13cmos5l_buf_1
XFILLER_11_1578 VPWR VGND sg13cmos5l_decap_8
XFILLER_2_1702 VPWR VGND sg13cmos5l_decap_8
XANTENNA_716 Tile_X0Y0_FrameData[25] VPWR VGND sg13cmos5l_antennanp
XANTENNA_705 Tile_X0Y0_FrameData[25] VPWR VGND sg13cmos5l_antennanp
XFILLER_16_21 VPWR VGND sg13cmos5l_decap_8
XANTENNA_749 Tile_X0Y0_FrameData[25] VPWR VGND sg13cmos5l_antennanp
XANTENNA_738 Tile_X0Y0_FrameData[25] VPWR VGND sg13cmos5l_antennanp
XANTENNA_727 Tile_X0Y0_FrameData[25] VPWR VGND sg13cmos5l_antennanp
XFILLER_16_2113 VPWR VGND sg13cmos5l_decap_8
XFILLER_16_98 VPWR VGND sg13cmos5l_decap_8
XFILLER_13_636 VPWR VGND sg13cmos5l_decap_8
XFILLER_12_113 VPWR VGND sg13cmos5l_fill_2
XANTENNA__0724__X Tile_X1Y0_S4BEG[9] VPWR VGND sg13cmos5l_antennanp
XFILLER_12_168 VPWR VGND sg13cmos5l_decap_8
XFILLER_5_857 VPWR VGND sg13cmos5l_fill_1
XANTENNA_1104 Tile_X0Y0_FrameData[2] VPWR VGND sg13cmos5l_antennanp
XANTENNA_1115 Tile_X0Y0_FrameData[2] VPWR VGND sg13cmos5l_antennanp
XANTENNA_1126 Tile_X0Y0_FrameData[2] VPWR VGND sg13cmos5l_antennanp
XANTENNA_1137 Tile_X0Y0_FrameData[2] VPWR VGND sg13cmos5l_antennanp
XANTENNA_1148 Tile_X0Y0_FrameData[2] VPWR VGND sg13cmos5l_antennanp
XANTENNA_1159 Tile_X0Y0_FrameData[30] VPWR VGND sg13cmos5l_antennanp
XFILLER_7_1624 VPWR VGND sg13cmos5l_decap_8
XFILLER_0_584 VPWR VGND sg13cmos5l_decap_8
XFILLER_16_474 VPWR VGND sg13cmos5l_fill_1
XFILLER_8_640 VPWR VGND sg13cmos5l_decap_8
XFILLER_12_2577 VPWR VGND sg13cmos5l_decap_8
XFILLER_12_1810 VPWR VGND sg13cmos5l_decap_8
X_0604_ _0604_/L_HI VPWR VGND sg13cmos5l_tiehi
XANTENNA_3040 Tile_X0Y0_FrameData[19] VPWR VGND sg13cmos5l_antennanp
XANTENNA_3051 Tile_X0Y0_FrameData[19] VPWR VGND sg13cmos5l_antennanp
XANTENNA_3062 Tile_X0Y0_FrameData[19] VPWR VGND sg13cmos5l_antennanp
XANTENNA_2350 Tile_X0Y0_FrameData[11] VPWR VGND sg13cmos5l_antennanp
XANTENNA_2361 Tile_X0Y0_FrameData[11] VPWR VGND sg13cmos5l_antennanp
XANTENNA_3073 Tile_X0Y0_FrameData[19] VPWR VGND sg13cmos5l_antennanp
XANTENNA_3084 Tile_X0Y0_FrameData[19] VPWR VGND sg13cmos5l_antennanp
XANTENNA_3095 Tile_X0Y0_FrameData[19] VPWR VGND sg13cmos5l_antennanp
X_0535_ NPU_WDATA11 Tile_X0Y0_UserCLK _1107_/X _0636_/L_HI VPWR VGND sg13cmos5l_dfrbpq_1
XANTENNA_2372 Tile_X0Y0_FrameData[11] VPWR VGND sg13cmos5l_antennanp
XANTENNA_2383 Tile_X0Y0_FrameData[11] VPWR VGND sg13cmos5l_antennanp
XANTENNA_2394 Tile_X0Y0_FrameData[11] VPWR VGND sg13cmos5l_antennanp
X_0466_ _0466_/Q Tile_X0Y0_FrameData[7] VGND VPWR Tile_X3Y0_FrameStrobe[1] latch
XANTENNA_1660 Tile_X0Y0_FrameData[4] VPWR VGND sg13cmos5l_antennanp
XANTENNA_1671 Tile_X0Y0_FrameData[4] VPWR VGND sg13cmos5l_antennanp
XANTENNA_1682 Tile_X0Y0_FrameData[4] VPWR VGND sg13cmos5l_antennanp
XFILLER_6_1134 VPWR VGND sg13cmos5l_decap_8
XANTENNA__0809__X Tile_X3Y0_SS4BEG[14] VPWR VGND sg13cmos5l_antennanp
XANTENNA_1693 Tile_X0Y0_FrameData[4] VPWR VGND sg13cmos5l_antennanp
X_0397_ _0397_/Q Tile_X0Y0_FrameData[12] VGND VPWR Tile_X2Y0_FrameStrobe[2] latch
XFILLER_3_2745 VPWR VGND sg13cmos5l_decap_8
X_1018_ Tile_X0Y0_S2BEG[3] Tile_X0Y0_N2MID[4] VPWR VGND sg13cmos5l_buf_1
XFILLER_10_606 VPWR VGND sg13cmos5l_decap_8
XFILLER_13_1607 VPWR VGND sg13cmos5l_decap_8
XFILLER_8_2678 VPWR VGND sg13cmos5l_decap_8
XANTENNA__0719__X Tile_X1Y0_S4BEG[4] VPWR VGND sg13cmos5l_antennanp
XFILLER_2_2277 VPWR VGND sg13cmos5l_decap_8
XANTENNA_535 Tile_X0Y0_FrameData[23] VPWR VGND sg13cmos5l_antennanp
XANTENNA_524 Tile_X0Y0_FrameData[23] VPWR VGND sg13cmos5l_antennanp
XANTENNA_513 Tile_X0Y0_FrameData[23] VPWR VGND sg13cmos5l_antennanp
XANTENNA_502 Tile_X0Y0_FrameData[23] VPWR VGND sg13cmos5l_antennanp
XANTENNA_568 Tile_X0Y0_FrameData[23] VPWR VGND sg13cmos5l_antennanp
XANTENNA_557 Tile_X0Y0_FrameData[23] VPWR VGND sg13cmos5l_antennanp
XANTENNA_546 Tile_X0Y0_FrameData[23] VPWR VGND sg13cmos5l_antennanp
XANTENNA_579 Tile_X0Y0_FrameData[23] VPWR VGND sg13cmos5l_antennanp
XFILLER_16_1242 VPWR VGND sg13cmos5l_decap_8
XFILLER_13_499 VPWR VGND sg13cmos5l_decap_8
XFILLER_4_35 VPWR VGND sg13cmos5l_decap_8
X_0320_ _0320_/Q Tile_X0Y0_FrameData[25] VGND VPWR Tile_X2Y0_FrameStrobe[0] latch
XFILLER_3_2008 VPWR VGND sg13cmos5l_fill_2
X_0251_ _0251_/Q Tile_X0Y0_FrameData[14] VGND VPWR Tile_X1Y0_FrameStrobe[1] latch
X_0182_ _0182_/Q Tile_X0Y0_FrameData[3] VGND VPWR Tile_X0Y0_FrameStrobe[2] latch
XFILLER_12_2330 VPWR VGND sg13cmos5l_decap_8
XFILLER_12_1684 VPWR VGND sg13cmos5l_decap_8
X_0518_ _0518_/Q Tile_X0Y0_FrameData[23] VGND VPWR Tile_X4Y0_FrameStrobe[0] latch
XANTENNA_2180 Tile_X0Y0_FrameData[9] VPWR VGND sg13cmos5l_antennanp
XANTENNA_2191 Tile_X0Y0_FrameData[9] VPWR VGND sg13cmos5l_antennanp
XANTENNA_1490 Tile_X0Y0_FrameData[31] VPWR VGND sg13cmos5l_antennanp
X_0449_ _0449_/Q Tile_X0Y0_FrameData[24] VGND VPWR Tile_X3Y0_FrameStrobe[1] latch
XFILLER_3_2542 VPWR VGND sg13cmos5l_decap_8
XFILLER_13_2138 VPWR VGND sg13cmos5l_decap_8
XFILLER_13_77 VPWR VGND sg13cmos5l_decap_8
XFILLER_13_1448 VPWR VGND sg13cmos5l_fill_1
XANTENNA_3809 Tile_X0Y0_FrameData[18] VPWR VGND sg13cmos5l_antennanp
XFILLER_11_1161 VPWR VGND sg13cmos5l_decap_8
XFILLER_8_2464 VPWR VGND sg13cmos5l_decap_8
XFILLER_1_156 VPWR VGND sg13cmos5l_fill_2
XFILLER_8_1741 VPWR VGND sg13cmos5l_decap_8
XFILLER_4_2339 VPWR VGND sg13cmos5l_decap_8
XFILLER_4_1649 VPWR VGND sg13cmos5l_decap_8
XANTENNA_310 Tile_X0Y0_FrameData[1] VPWR VGND sg13cmos5l_antennanp
XANTENNA_321 Tile_X0Y0_FrameData[1] VPWR VGND sg13cmos5l_antennanp
XANTENNA_332 Tile_X0Y0_FrameData[1] VPWR VGND sg13cmos5l_antennanp
XANTENNA_343 Tile_X0Y0_FrameData[1] VPWR VGND sg13cmos5l_antennanp
XANTENNA_354 Tile_X0Y0_FrameData[1] VPWR VGND sg13cmos5l_antennanp
XANTENNA_365 Tile_X0Y0_FrameData[1] VPWR VGND sg13cmos5l_antennanp
XANTENNA_376 Tile_X0Y0_FrameData[1] VPWR VGND sg13cmos5l_antennanp
XANTENNA_387 Tile_X0Y0_FrameData[1] VPWR VGND sg13cmos5l_antennanp
XANTENNA_398 Tile_X0Y0_FrameData[22] VPWR VGND sg13cmos5l_antennanp
XFILLER_14_786 VPWR VGND sg13cmos5l_decap_8
XFILLER_13_2650 VPWR VGND sg13cmos5l_decap_8
XANTENNA__0912__X Tile_X2Y0_SS4BEG[13] VPWR VGND sg13cmos5l_antennanp
XFILLER_9_1538 VPWR VGND sg13cmos5l_fill_1
X_0303_ _0303_/Q Tile_X0Y0_FrameData[26] VGND VPWR Tile_X1Y0_FrameStrobe[3] latch
X_1283_ _1283_/X Tile_X3Y0_N2END[0] Tile_X3Y0_N4END[8] Tile_X3Y0_NN4END[7] _0575_/Q
+ _0441_/Q _0440_/Q VPWR VGND sg13cmos5l_mux4_1
X_0234_ _0234_/Q Tile_X0Y0_FrameData[31] VGND VPWR Tile_X1Y0_FrameStrobe[1] latch
XFILLER_3_1159 VPWR VGND sg13cmos5l_decap_8
X_0165_ _0165_/Q Tile_X0Y0_FrameData[20] VGND VPWR Tile_X0Y0_FrameStrobe[2] latch
X_0096_ _0096_/Q Tile_X0Y0_FrameData[25] VGND VPWR Tile_X0Y0_FrameStrobe[0] latch
XFILLER_14_2436 VPWR VGND sg13cmos5l_decap_8
XANTENNA__0822__X Tile_X4Y0_FrameData_O[11] VPWR VGND sg13cmos5l_antennanp
X_0998_ Tile_X0Y0_S4BEG[7] _1146_/X VPWR VGND sg13cmos5l_buf_1
XFILLER_14_1746 VPWR VGND sg13cmos5l_decap_8
XFILLER_8_1026 VPWR VGND sg13cmos5l_fill_1
XFILLER_5_2637 VPWR VGND sg13cmos5l_decap_8
XFILLER_11_712 VPWR VGND sg13cmos5l_decap_8
XANTENNA__0732__X Tile_X1Y0_SS4BEG[1] VPWR VGND sg13cmos5l_antennanp
XFILLER_13_1234 VPWR VGND sg13cmos5l_decap_8
XANTENNA_3606 Tile_X0Y0_FrameData[8] VPWR VGND sg13cmos5l_antennanp
XANTENNA_3617 Tile_X0Y0_FrameData[8] VPWR VGND sg13cmos5l_antennanp
XANTENNA_3628 Tile_X0Y0_N4END[1] VPWR VGND sg13cmos5l_antennanp
XANTENNA_2905 Tile_X0Y0_FrameData[17] VPWR VGND sg13cmos5l_antennanp
XANTENNA_2916 Tile_X0Y0_FrameData[17] VPWR VGND sg13cmos5l_antennanp
XANTENNA_2927 Tile_X0Y0_FrameData[17] VPWR VGND sg13cmos5l_antennanp
XANTENNA_3639 Tile_X0Y0_N4END[1] VPWR VGND sg13cmos5l_antennanp
XANTENNA_2938 Tile_X0Y0_FrameData[19] VPWR VGND sg13cmos5l_antennanp
XANTENNA_2949 Tile_X0Y0_FrameData[19] VPWR VGND sg13cmos5l_antennanp
XFILLER_1_14 VPWR VGND sg13cmos5l_decap_8
XANTENNA__0907__X Tile_X2Y0_SS4BEG[8] VPWR VGND sg13cmos5l_antennanp
XANTENNA_140 Tile_X0Y0_FrameData[10] VPWR VGND sg13cmos5l_antennanp
XANTENNA_151 Tile_X0Y0_FrameData[10] VPWR VGND sg13cmos5l_antennanp
XANTENNA_162 Tile_X0Y0_FrameData[10] VPWR VGND sg13cmos5l_antennanp
XANTENNA_173 Tile_X0Y0_FrameData[10] VPWR VGND sg13cmos5l_antennanp
XANTENNA_184 Tile_X0Y0_FrameData[10] VPWR VGND sg13cmos5l_antennanp
XFILLER_14_550 VPWR VGND sg13cmos5l_fill_1
XANTENNA_195 Tile_X0Y0_FrameData[10] VPWR VGND sg13cmos5l_antennanp
X_0921_ Tile_X3Y0_FrameStrobe_O[6] Tile_X3Y0_FrameStrobe[6] VPWR VGND sg13cmos5l_buf_1
XFILLER_14_583 VPWR VGND sg13cmos5l_decap_8
X_0852_ Tile_X4Y0_FrameStrobe_O[9] Tile_X4Y0_FrameStrobe[9] VPWR VGND sg13cmos5l_buf_1
X_0783_ Tile_X3Y0_S4BEG[4] _1263_/X VPWR VGND sg13cmos5l_buf_1
XFILLER_13_2491 VPWR VGND sg13cmos5l_decap_8
XFILLER_9_2014 VPWR VGND sg13cmos5l_fill_2
X_1266_ _1266_/X Tile_X3Y0_N2MID[7] Tile_X3Y0_N4END[8] Tile_X3Y0_NN4END[7] _0577_/Q
+ _0475_/Q _0474_/Q VPWR VGND sg13cmos5l_mux4_1
X_0217_ _0217_/Q Tile_X0Y0_FrameData[16] VGND VPWR Tile_X1Y0_FrameStrobe[0] latch
X_1197_ _1197_/X Tile_X1Y0_N2END[2] Tile_X1Y0_N4END[2] Tile_X1Y0_NN4END[13] _0595_/Q
+ _0261_/Q _0260_/Q VPWR VGND sg13cmos5l_mux4_1
XANTENNA__0817__X Tile_X4Y0_FrameData_O[6] VPWR VGND sg13cmos5l_antennanp
X_0148_ _0148_/Q Tile_X0Y0_FrameData[5] VGND VPWR Tile_X0Y0_FrameStrobe[1] latch
XFILLER_16_1819 VPWR VGND sg13cmos5l_decap_8
XFILLER_14_2244 VPWR VGND sg13cmos5l_decap_8
XFILLER_14_1543 VPWR VGND sg13cmos5l_decap_8
XFILLER_10_56 VPWR VGND sg13cmos5l_decap_8
XFILLER_5_2445 VPWR VGND sg13cmos5l_decap_8
XFILLER_5_1744 VPWR VGND sg13cmos5l_decap_8
XFILLER_1_2309 VPWR VGND sg13cmos5l_decap_8
XANTENNA__0727__X Tile_X1Y0_S4BEG[12] VPWR VGND sg13cmos5l_antennanp
XFILLER_15_358 VPWR VGND sg13cmos5l_fill_1
XFILLER_15_1318 VPWR VGND sg13cmos5l_decap_8
XFILLER_11_531 VPWR VGND sg13cmos5l_decap_8
XFILLER_7_513 VPWR VGND sg13cmos5l_decap_8
XANTENNA_4104 Tile_X1Y0_N4END[13] VPWR VGND sg13cmos5l_antennanp
XANTENNA_4115 Tile_X1Y0_N4END[13] VPWR VGND sg13cmos5l_antennanp
XFILLER_10_2620 VPWR VGND sg13cmos5l_decap_8
XANTENNA_3403 Tile_X0Y0_FrameData[21] VPWR VGND sg13cmos5l_antennanp
XANTENNA_4126 Tile_X1Y0_NN4END[2] VPWR VGND sg13cmos5l_antennanp
XANTENNA_4137 Tile_X3Y0_N4END[3] VPWR VGND sg13cmos5l_antennanp
XANTENNA_4148 Tile_X1Y0_N2MID[1] VPWR VGND sg13cmos5l_antennanp
XANTENNA_3414 Tile_X0Y0_FrameData[21] VPWR VGND sg13cmos5l_antennanp
XANTENNA_3425 Tile_X0Y0_FrameData[21] VPWR VGND sg13cmos5l_antennanp
XANTENNA_3436 Tile_X0Y0_FrameData[21] VPWR VGND sg13cmos5l_antennanp
XFILLER_10_2697 VPWR VGND sg13cmos5l_decap_8
XANTENNA_2702 Tile_X0Y0_FrameData[14] VPWR VGND sg13cmos5l_antennanp
XANTENNA_2713 Tile_X0Y0_FrameData[14] VPWR VGND sg13cmos5l_antennanp
XANTENNA_2724 Tile_X0Y0_FrameData[14] VPWR VGND sg13cmos5l_antennanp
XANTENNA_2735 Tile_X0Y0_FrameData[14] VPWR VGND sg13cmos5l_antennanp
XANTENNA_3447 Tile_X0Y0_FrameData[21] VPWR VGND sg13cmos5l_antennanp
XANTENNA_3458 Tile_X0Y0_FrameData[8] VPWR VGND sg13cmos5l_antennanp
XANTENNA_3469 Tile_X0Y0_FrameData[8] VPWR VGND sg13cmos5l_antennanp
XANTENNA_2746 Tile_X0Y0_FrameData[14] VPWR VGND sg13cmos5l_antennanp
XANTENNA_2757 Tile_X0Y0_FrameData[14] VPWR VGND sg13cmos5l_antennanp
XANTENNA_2768 Tile_X0Y0_FrameData[14] VPWR VGND sg13cmos5l_antennanp
XANTENNA_2779 Tile_X0Y0_FrameData[16] VPWR VGND sg13cmos5l_antennanp
X_1120_ _1120_/X Tile_X0Y0_N4END[8] Tile_X0Y0_N4END[9] Tile_X0Y0_NN4END[8] Tile_X0Y0_NN4END[10]
+ _0105_/Q _0104_/Q VPWR VGND sg13cmos5l_mux4_1
X_1051_ Tile_X4Y0_S4BEG[4] Tile_X4Y0_N4END[11] VPWR VGND sg13cmos5l_buf_1
XFILLER_0_1129 VPWR VGND sg13cmos5l_fill_1
XFILLER_15_2531 VPWR VGND sg13cmos5l_decap_8
X_0904_ Tile_X2Y0_SS4BEG[5] _1240_/X VPWR VGND sg13cmos5l_buf_1
X_0835_ Tile_X4Y0_FrameData_O[24] Tile_X0Y0_FrameData[24] VPWR VGND sg13cmos5l_buf_1
XFILLER_15_1885 VPWR VGND sg13cmos5l_decap_8
X_0766_ Tile_X3Y0_S2BEG[3] Tile_X3Y0_N2MID[4] VPWR VGND sg13cmos5l_buf_1
X_0697_ Tile_X0Y0_FrameStrobe_O[10] Tile_X0Y0_FrameStrobe[10] VPWR VGND sg13cmos5l_buf_1
XANTENNA_3970 Tile_X0Y0_FrameData[18] VPWR VGND sg13cmos5l_antennanp
XANTENNA_3981 Tile_X0Y0_FrameData[18] VPWR VGND sg13cmos5l_antennanp
XANTENNA_3992 Tile_X0Y0_FrameData[18] VPWR VGND sg13cmos5l_antennanp
XFILLER_6_2732 VPWR VGND sg13cmos5l_decap_8
XFILLER_9_1176 VPWR VGND sg13cmos5l_decap_8
XFILLER_2_2629 VPWR VGND sg13cmos5l_decap_8
X_1249_ _1249_/X Tile_X2Y0_N2END[6] Tile_X2Y0_N4END[14] Tile_X2Y0_NN4END[1] _0581_/Q
+ _0333_/Q _0332_/Q VPWR VGND sg13cmos5l_mux4_1
XANTENNA_909 Tile_X0Y0_FrameData[27] VPWR VGND sg13cmos5l_antennanp
XFILLER_0_2375 VPWR VGND sg13cmos5l_decap_8
XFILLER_0_2353 VPWR VGND sg13cmos5l_fill_1
XFILLER_0_1685 VPWR VGND sg13cmos5l_decap_8
XFILLER_16_1605 VPWR VGND sg13cmos5l_fill_2
XANTENNA_40 Tile_X0Y0_FrameData[0] VPWR VGND sg13cmos5l_antennanp
XFILLER_14_2041 VPWR VGND sg13cmos5l_decap_8
XFILLER_14_1340 VPWR VGND sg13cmos5l_fill_1
XANTENNA_84 Tile_X0Y0_FrameData[0] VPWR VGND sg13cmos5l_antennanp
XANTENNA_73 Tile_X0Y0_FrameData[0] VPWR VGND sg13cmos5l_antennanp
XANTENNA_62 Tile_X0Y0_FrameData[0] VPWR VGND sg13cmos5l_antennanp
XANTENNA_51 Tile_X0Y0_FrameData[0] VPWR VGND sg13cmos5l_antennanp
XFILLER_14_1362 VPWR VGND sg13cmos5l_fill_1
XFILLER_10_1204 VPWR VGND sg13cmos5l_decap_8
XANTENNA_95 Tile_X0Y0_FrameData[0] VPWR VGND sg13cmos5l_antennanp
XANTENNA_2009 Tile_X0Y0_FrameData[6] VPWR VGND sg13cmos5l_antennanp
XANTENNA_1308 Tile_X0Y0_FrameData[30] VPWR VGND sg13cmos5l_antennanp
XANTENNA_1319 Tile_X0Y0_FrameData[30] VPWR VGND sg13cmos5l_antennanp
XFILLER_0_733 VPWR VGND sg13cmos5l_fill_2
XFILLER_5_2242 VPWR VGND sg13cmos5l_decap_8
XFILLER_16_634 VPWR VGND sg13cmos5l_decap_8
XFILLER_15_133 VPWR VGND sg13cmos5l_decap_8
XFILLER_15_1137 VPWR VGND sg13cmos5l_decap_8
XFILLER_7_35 VPWR VGND sg13cmos5l_decap_8
XFILLER_12_2759 VPWR VGND sg13cmos5l_fill_2
XFILLER_10_2450 VPWR VGND sg13cmos5l_decap_8
XANTENNA_3200 Tile_X0Y0_FrameData[20] VPWR VGND sg13cmos5l_antennanp
XANTENNA_3211 Tile_X0Y0_FrameData[20] VPWR VGND sg13cmos5l_antennanp
X_0620_ _0620_/L_HI VPWR VGND sg13cmos5l_tiehi
XANTENNA__0920__X Tile_X3Y0_FrameStrobe_O[5] VPWR VGND sg13cmos5l_antennanp
XANTENNA_2510 Tile_X0Y0_FrameData[12] VPWR VGND sg13cmos5l_antennanp
XANTENNA_3222 Tile_X0Y0_FrameData[20] VPWR VGND sg13cmos5l_antennanp
XANTENNA_3233 Tile_X0Y0_FrameData[20] VPWR VGND sg13cmos5l_antennanp
XANTENNA_3244 Tile_X0Y0_FrameData[20] VPWR VGND sg13cmos5l_antennanp
XANTENNA_3255 Tile_X0Y0_FrameData[20] VPWR VGND sg13cmos5l_antennanp
X_0551_ NPU_WDATA27 Tile_X0Y0_UserCLK _1123_/X _0656_/L_HI VPWR VGND sg13cmos5l_dfrbpq_1
XANTENNA_2521 Tile_X0Y0_FrameData[12] VPWR VGND sg13cmos5l_antennanp
XANTENNA_2532 Tile_X0Y0_FrameData[12] VPWR VGND sg13cmos5l_antennanp
XANTENNA_2543 Tile_X0Y0_FrameData[12] VPWR VGND sg13cmos5l_antennanp
XANTENNA_3266 Tile_X0Y0_FrameData[20] VPWR VGND sg13cmos5l_antennanp
XANTENNA_3277 Tile_X0Y0_FrameData[20] VPWR VGND sg13cmos5l_antennanp
XANTENNA_3288 Tile_X0Y0_FrameData[20] VPWR VGND sg13cmos5l_antennanp
XANTENNA_1820 Tile_X0Y0_FrameData[5] VPWR VGND sg13cmos5l_antennanp
XANTENNA_1831 Tile_X0Y0_FrameData[5] VPWR VGND sg13cmos5l_antennanp
XANTENNA_2554 Tile_X0Y0_FrameData[12] VPWR VGND sg13cmos5l_antennanp
XANTENNA_2565 Tile_X0Y0_FrameData[12] VPWR VGND sg13cmos5l_antennanp
XANTENNA_2576 Tile_X0Y0_FrameData[12] VPWR VGND sg13cmos5l_antennanp
XANTENNA_3299 Tile_X0Y0_FrameData[20] VPWR VGND sg13cmos5l_antennanp
X_0482_ _0482_/Q Tile_X0Y0_FrameData[23] VGND VPWR Tile_X3Y0_FrameStrobe[2] latch
XFILLER_3_593 VPWR VGND sg13cmos5l_decap_8
XANTENNA_1842 Tile_X0Y0_FrameData[5] VPWR VGND sg13cmos5l_antennanp
XANTENNA_1853 Tile_X0Y0_FrameData[5] VPWR VGND sg13cmos5l_antennanp
XANTENNA_1864 Tile_X0Y0_FrameData[5] VPWR VGND sg13cmos5l_antennanp
XANTENNA_1875 Tile_X0Y0_FrameData[5] VPWR VGND sg13cmos5l_antennanp
XANTENNA_2587 Tile_X0Y0_FrameData[13] VPWR VGND sg13cmos5l_antennanp
XANTENNA_2598 Tile_X0Y0_FrameData[13] VPWR VGND sg13cmos5l_antennanp
XANTENNA_1886 Tile_X0Y0_FrameData[5] VPWR VGND sg13cmos5l_antennanp
XANTENNA_1897 Tile_X0Y0_FrameData[5] VPWR VGND sg13cmos5l_antennanp
X_1103_ _1103_/X Tile_X1Y0_N4END[4] Tile_X1Y0_N4END[7] Tile_X1Y0_NN4END[5] Tile_X1Y0_NN4END[7]
+ _0219_/Q _0218_/Q VPWR VGND sg13cmos5l_mux4_1
XFILLER_4_1040 VPWR VGND sg13cmos5l_fill_2
X_1034_ Tile_X4Y0_S2BEG[3] Tile_X4Y0_N2MID[4] VPWR VGND sg13cmos5l_buf_1
XFILLER_4_1062 VPWR VGND sg13cmos5l_fill_2
XFILLER_1_2684 VPWR VGND sg13cmos5l_fill_1
XFILLER_15_1682 VPWR VGND sg13cmos5l_decap_8
XFILLER_11_2247 VPWR VGND sg13cmos5l_decap_8
X_0818_ Tile_X4Y0_FrameData_O[7] Tile_X0Y0_FrameData[7] VPWR VGND sg13cmos5l_buf_1
XFILLER_11_1557 VPWR VGND sg13cmos5l_decap_8
XANTENNA__0830__X Tile_X4Y0_FrameData_O[19] VPWR VGND sg13cmos5l_antennanp
X_0749_ Tile_X1Y0_S1BEG[2] Tile_X1Y0_N1END[1] VPWR VGND sg13cmos5l_buf_1
XFILLER_2_1758 VPWR VGND sg13cmos5l_fill_1
XANTENNA_717 Tile_X0Y0_FrameData[25] VPWR VGND sg13cmos5l_antennanp
XANTENNA_706 Tile_X0Y0_FrameData[25] VPWR VGND sg13cmos5l_antennanp
XANTENNA_739 Tile_X0Y0_FrameData[25] VPWR VGND sg13cmos5l_antennanp
XANTENNA_728 Tile_X0Y0_FrameData[25] VPWR VGND sg13cmos5l_antennanp
XFILLER_16_77 VPWR VGND sg13cmos5l_decap_8
XFILLER_13_615 VPWR VGND sg13cmos5l_decap_8
XFILLER_16_2169 VPWR VGND sg13cmos5l_decap_4
XFILLER_12_147 VPWR VGND sg13cmos5l_decap_8
XFILLER_16_1479 VPWR VGND sg13cmos5l_decap_8
XFILLER_14_1181 VPWR VGND sg13cmos5l_decap_8
XANTENNA__0740__X Tile_X1Y0_SS4BEG[9] VPWR VGND sg13cmos5l_antennanp
XFILLER_7_2304 VPWR VGND sg13cmos5l_decap_8
XANTENNA_1105 Tile_X0Y0_FrameData[2] VPWR VGND sg13cmos5l_antennanp
XANTENNA_1116 Tile_X0Y0_FrameData[2] VPWR VGND sg13cmos5l_antennanp
XANTENNA_1127 Tile_X0Y0_FrameData[2] VPWR VGND sg13cmos5l_antennanp
XFILLER_7_1603 VPWR VGND sg13cmos5l_decap_8
XANTENNA_1138 Tile_X0Y0_FrameData[2] VPWR VGND sg13cmos5l_antennanp
XANTENNA_1149 Tile_X0Y0_FrameData[2] VPWR VGND sg13cmos5l_antennanp
XFILLER_0_563 VPWR VGND sg13cmos5l_decap_8
XFILLER_1_1235 VPWR VGND sg13cmos5l_fill_2
XANTENNA__0915__X Tile_X3Y0_FrameStrobe_O[0] VPWR VGND sg13cmos5l_antennanp
XFILLER_12_2512 VPWR VGND sg13cmos5l_decap_8
XFILLER_8_696 VPWR VGND sg13cmos5l_fill_1
X_0603_ _0603_/Q Tile_X0Y0_UserCLK NPU_RDATA31 _0619_/L_HI VPWR VGND sg13cmos5l_dfrbpq_1
XANTENNA_3030 Tile_X0Y0_FrameData[19] VPWR VGND sg13cmos5l_antennanp
XANTENNA_3041 Tile_X0Y0_FrameData[19] VPWR VGND sg13cmos5l_antennanp
XANTENNA_3052 Tile_X0Y0_FrameData[19] VPWR VGND sg13cmos5l_antennanp
XANTENNA_3063 Tile_X0Y0_FrameData[19] VPWR VGND sg13cmos5l_antennanp
XANTENNA_2340 Tile_X0Y0_FrameData[11] VPWR VGND sg13cmos5l_antennanp
XANTENNA_2351 Tile_X0Y0_FrameData[11] VPWR VGND sg13cmos5l_antennanp
XANTENNA_3074 Tile_X0Y0_FrameData[19] VPWR VGND sg13cmos5l_antennanp
XANTENNA_3085 Tile_X0Y0_FrameData[19] VPWR VGND sg13cmos5l_antennanp
XANTENNA_3096 Tile_X0Y0_FrameData[19] VPWR VGND sg13cmos5l_antennanp
X_0534_ NPU_WDATA10 Tile_X0Y0_UserCLK _1106_/X _0637_/L_HI VPWR VGND sg13cmos5l_dfrbpq_1
XANTENNA_1650 Tile_X0Y0_FrameData[4] VPWR VGND sg13cmos5l_antennanp
XANTENNA_2362 Tile_X0Y0_FrameData[11] VPWR VGND sg13cmos5l_antennanp
XANTENNA_2373 Tile_X0Y0_FrameData[11] VPWR VGND sg13cmos5l_antennanp
XANTENNA_2384 Tile_X0Y0_FrameData[11] VPWR VGND sg13cmos5l_antennanp
X_0465_ _0465_/Q Tile_X0Y0_FrameData[8] VGND VPWR Tile_X3Y0_FrameStrobe[1] latch
XFILLER_6_1113 VPWR VGND sg13cmos5l_decap_8
XANTENNA_1661 Tile_X0Y0_FrameData[4] VPWR VGND sg13cmos5l_antennanp
XANTENNA_1672 Tile_X0Y0_FrameData[4] VPWR VGND sg13cmos5l_antennanp
XANTENNA_1683 Tile_X0Y0_FrameData[4] VPWR VGND sg13cmos5l_antennanp
XANTENNA_2395 Tile_X0Y0_FrameData[11] VPWR VGND sg13cmos5l_antennanp
XFILLER_3_2724 VPWR VGND sg13cmos5l_decap_8
XANTENNA_1694 Tile_X0Y0_FrameData[4] VPWR VGND sg13cmos5l_antennanp
X_0396_ _0396_/Q Tile_X0Y0_FrameData[13] VGND VPWR Tile_X2Y0_FrameStrobe[2] latch
XFILLER_14_0 VPWR VGND sg13cmos5l_decap_8
XFILLER_1_2492 VPWR VGND sg13cmos5l_decap_8
X_1017_ Tile_X0Y0_S2BEG[2] Tile_X0Y0_N2MID[5] VPWR VGND sg13cmos5l_buf_1
XANTENNA__0825__X Tile_X4Y0_FrameData_O[14] VPWR VGND sg13cmos5l_antennanp
XFILLER_13_2309 VPWR VGND sg13cmos5l_decap_8
XFILLER_15_2191 VPWR VGND sg13cmos5l_decap_8
XFILLER_11_1398 VPWR VGND sg13cmos5l_fill_1
XFILLER_8_2657 VPWR VGND sg13cmos5l_decap_8
XFILLER_6_2381 VPWR VGND sg13cmos5l_decap_8
XFILLER_2_2256 VPWR VGND sg13cmos5l_decap_8
XANTENNA_525 Tile_X0Y0_FrameData[23] VPWR VGND sg13cmos5l_antennanp
XANTENNA_514 Tile_X0Y0_FrameData[23] VPWR VGND sg13cmos5l_antennanp
XANTENNA_503 Tile_X0Y0_FrameData[23] VPWR VGND sg13cmos5l_antennanp
XANTENNA__0735__X Tile_X1Y0_SS4BEG[4] VPWR VGND sg13cmos5l_antennanp
XANTENNA_558 Tile_X0Y0_FrameData[23] VPWR VGND sg13cmos5l_antennanp
XANTENNA_547 Tile_X0Y0_FrameData[23] VPWR VGND sg13cmos5l_antennanp
XANTENNA_536 Tile_X0Y0_FrameData[23] VPWR VGND sg13cmos5l_antennanp
XFILLER_13_423 VPWR VGND sg13cmos5l_fill_2
XANTENNA_569 Tile_X0Y0_FrameData[23] VPWR VGND sg13cmos5l_antennanp
XFILLER_13_478 VPWR VGND sg13cmos5l_decap_8
XFILLER_16_1276 VPWR VGND sg13cmos5l_decap_8
XFILLER_4_14 VPWR VGND sg13cmos5l_decap_8
XFILLER_1_850 VPWR VGND sg13cmos5l_fill_1
X_0250_ _0250_/Q Tile_X0Y0_FrameData[15] VGND VPWR Tile_X1Y0_FrameStrobe[1] latch
XFILLER_0_393 VPWR VGND sg13cmos5l_fill_2
X_0181_ _0181_/Q Tile_X0Y0_FrameData[4] VGND VPWR Tile_X0Y0_FrameStrobe[2] latch
XFILLER_12_2386 VPWR VGND sg13cmos5l_decap_8
XFILLER_12_1663 VPWR VGND sg13cmos5l_decap_8
X_0517_ _0517_/Q Tile_X0Y0_FrameData[22] VGND VPWR Tile_X4Y0_FrameStrobe[0] latch
XFILLER_8_1219 VPWR VGND sg13cmos5l_fill_1
XANTENNA_2170 Tile_X0Y0_FrameData[9] VPWR VGND sg13cmos5l_antennanp
XANTENNA_2181 Tile_X0Y0_FrameData[9] VPWR VGND sg13cmos5l_antennanp
XANTENNA_2192 Tile_X0Y0_FrameData[9] VPWR VGND sg13cmos5l_antennanp
XANTENNA_1480 Tile_X0Y0_FrameData[31] VPWR VGND sg13cmos5l_antennanp
XANTENNA_1491 Tile_X0Y0_FrameData[31] VPWR VGND sg13cmos5l_antennanp
X_0448_ _0448_/Q Tile_X0Y0_FrameData[25] VGND VPWR Tile_X3Y0_FrameStrobe[1] latch
XFILLER_3_2521 VPWR VGND sg13cmos5l_fill_2
X_0379_ _0379_/Q Tile_X0Y0_FrameData[30] VGND VPWR Tile_X2Y0_FrameStrobe[2] latch
XFILLER_3_2598 VPWR VGND sg13cmos5l_decap_8
XFILLER_13_2117 VPWR VGND sg13cmos5l_decap_8
XFILLER_10_426 VPWR VGND sg13cmos5l_fill_1
XFILLER_7_909 VPWR VGND sg13cmos5l_fill_2
XFILLER_13_56 VPWR VGND sg13cmos5l_decap_8
XFILLER_13_1416 VPWR VGND sg13cmos5l_fill_2
XFILLER_11_1140 VPWR VGND sg13cmos5l_decap_8
XFILLER_8_2443 VPWR VGND sg13cmos5l_decap_8
XFILLER_8_1720 VPWR VGND sg13cmos5l_decap_8
XFILLER_4_2318 VPWR VGND sg13cmos5l_decap_8
XFILLER_4_1628 VPWR VGND sg13cmos5l_decap_8
XANTENNA_300 Tile_X0Y0_FrameData[1] VPWR VGND sg13cmos5l_antennanp
XANTENNA_311 Tile_X0Y0_FrameData[1] VPWR VGND sg13cmos5l_antennanp
XANTENNA_322 Tile_X0Y0_FrameData[1] VPWR VGND sg13cmos5l_antennanp
XANTENNA_333 Tile_X0Y0_FrameData[1] VPWR VGND sg13cmos5l_antennanp
XANTENNA_344 Tile_X0Y0_FrameData[1] VPWR VGND sg13cmos5l_antennanp
XANTENNA_355 Tile_X0Y0_FrameData[1] VPWR VGND sg13cmos5l_antennanp
XANTENNA_366 Tile_X0Y0_FrameData[1] VPWR VGND sg13cmos5l_antennanp
XANTENNA_377 Tile_X0Y0_FrameData[1] VPWR VGND sg13cmos5l_antennanp
XANTENNA_388 Tile_X0Y0_FrameData[22] VPWR VGND sg13cmos5l_antennanp
XANTENNA_399 Tile_X0Y0_FrameData[22] VPWR VGND sg13cmos5l_antennanp
XFILLER_14_765 VPWR VGND sg13cmos5l_decap_8
XFILLER_16_1084 VPWR VGND sg13cmos5l_decap_4
XFILLER_6_942 VPWR VGND sg13cmos5l_fill_1
XFILLER_13_1961 VPWR VGND sg13cmos5l_fill_1
X_0302_ _0302_/Q Tile_X0Y0_FrameData[27] VGND VPWR Tile_X1Y0_FrameStrobe[3] latch
X_1282_ _1282_/X Tile_X3Y0_N2END[7] Tile_X3Y0_N4END[7] Tile_X3Y0_NN4END[8] _0576_/Q
+ _0443_/Q _0442_/Q VPWR VGND sg13cmos5l_mux4_1
X_0233_ _0233_/Q Tile_X0Y0_FrameData[0] VGND VPWR Tile_X1Y0_FrameStrobe[0] latch
XFILLER_0_2705 VPWR VGND sg13cmos5l_decap_4
X_0164_ _0164_/Q Tile_X0Y0_FrameData[21] VGND VPWR Tile_X0Y0_FrameStrobe[2] latch
XFILLER_3_1138 VPWR VGND sg13cmos5l_decap_8
X_0095_ _0095_/Q Tile_X0Y0_FrameData[26] VGND VPWR Tile_X0Y0_FrameStrobe[0] latch
XFILLER_14_2415 VPWR VGND sg13cmos5l_decap_8
XFILLER_14_2459 VPWR VGND sg13cmos5l_fill_1
XFILLER_14_1725 VPWR VGND sg13cmos5l_decap_8
X_0997_ Tile_X0Y0_S4BEG[6] _1145_/X VPWR VGND sg13cmos5l_buf_1
XFILLER_12_2183 VPWR VGND sg13cmos5l_decap_8
XFILLER_12_1460 VPWR VGND sg13cmos5l_fill_1
XFILLER_9_2752 VPWR VGND sg13cmos5l_decap_8
XFILLER_5_2616 VPWR VGND sg13cmos5l_decap_8
XFILLER_15_529 VPWR VGND sg13cmos5l_fill_1
XFILLER_11_757 VPWR VGND sg13cmos5l_fill_1
XFILLER_13_1213 VPWR VGND sg13cmos5l_decap_8
XFILLER_11_779 VPWR VGND sg13cmos5l_decap_4
XANTENNA_3607 Tile_X0Y0_FrameData[8] VPWR VGND sg13cmos5l_antennanp
XANTENNA_3618 Tile_X0Y0_FrameData[8] VPWR VGND sg13cmos5l_antennanp
XANTENNA_3629 Tile_X0Y0_N4END[1] VPWR VGND sg13cmos5l_antennanp
XANTENNA_2906 Tile_X0Y0_FrameData[17] VPWR VGND sg13cmos5l_antennanp
XANTENNA_2917 Tile_X0Y0_FrameData[17] VPWR VGND sg13cmos5l_antennanp
XFILLER_3_956 VPWR VGND sg13cmos5l_fill_1
XFILLER_3_945 VPWR VGND sg13cmos5l_fill_1
XANTENNA_2928 Tile_X0Y0_FrameData[17] VPWR VGND sg13cmos5l_antennanp
XANTENNA_2939 Tile_X0Y0_FrameData[19] VPWR VGND sg13cmos5l_antennanp
XANTENNA_130 Tile_X0Y0_FrameData[0] VPWR VGND sg13cmos5l_antennanp
XANTENNA_141 Tile_X0Y0_FrameData[10] VPWR VGND sg13cmos5l_antennanp
XANTENNA_152 Tile_X0Y0_FrameData[10] VPWR VGND sg13cmos5l_antennanp
XANTENNA_163 Tile_X0Y0_FrameData[10] VPWR VGND sg13cmos5l_antennanp
XANTENNA_174 Tile_X0Y0_FrameData[10] VPWR VGND sg13cmos5l_antennanp
XANTENNA_185 Tile_X0Y0_FrameData[10] VPWR VGND sg13cmos5l_antennanp
XANTENNA_196 Tile_X0Y0_FrameData[10] VPWR VGND sg13cmos5l_antennanp
X_0920_ Tile_X3Y0_FrameStrobe_O[5] Tile_X3Y0_FrameStrobe[5] VPWR VGND sg13cmos5l_buf_1
XFILLER_15_2724 VPWR VGND sg13cmos5l_decap_8
XFILLER_14_562 VPWR VGND sg13cmos5l_decap_8
XANTENNA__0923__X Tile_X3Y0_FrameStrobe_O[8] VPWR VGND sg13cmos5l_antennanp
X_0851_ Tile_X4Y0_FrameStrobe_O[8] Tile_X4Y0_FrameStrobe[8] VPWR VGND sg13cmos5l_buf_1
X_0782_ Tile_X3Y0_S4BEG[3] _1262_/X VPWR VGND sg13cmos5l_buf_1
XFILLER_13_2470 VPWR VGND sg13cmos5l_decap_8
X_1265_ _1265_/X Tile_X3Y0_N2MID[6] Tile_X3Y0_N4END[9] Tile_X3Y0_NN4END[6] _0576_/Q
+ _0477_/Q _0476_/Q VPWR VGND sg13cmos5l_mux4_1
XFILLER_4_2682 VPWR VGND sg13cmos5l_decap_8
X_0216_ _0216_/Q Tile_X0Y0_FrameData[17] VGND VPWR Tile_X1Y0_FrameStrobe[0] latch
X_1196_ _1196_/X Tile_X1Y0_N2END[1] Tile_X1Y0_N4END[1] Tile_X1Y0_NN4END[14] _0594_/Q
+ _0263_/Q _0262_/Q VPWR VGND sg13cmos5l_mux4_1
XFILLER_0_2557 VPWR VGND sg13cmos5l_decap_4
XFILLER_0_1812 VPWR VGND sg13cmos5l_fill_2
X_0147_ _0147_/Q Tile_X0Y0_FrameData[6] VGND VPWR Tile_X0Y0_FrameStrobe[1] latch
XANTENNA__0833__X Tile_X4Y0_FrameData_O[22] VPWR VGND sg13cmos5l_antennanp
XFILLER_14_2223 VPWR VGND sg13cmos5l_decap_8
XFILLER_14_1522 VPWR VGND sg13cmos5l_decap_8
XFILLER_14_2289 VPWR VGND sg13cmos5l_decap_8
XFILLER_14_1599 VPWR VGND sg13cmos5l_decap_8
XFILLER_10_35 VPWR VGND sg13cmos5l_decap_8
XFILLER_5_2424 VPWR VGND sg13cmos5l_decap_8
XFILLER_5_1723 VPWR VGND sg13cmos5l_decap_8
XFILLER_16_805 VPWR VGND sg13cmos5l_decap_8
XANTENNA__0743__X Tile_X1Y0_SS4BEG[12] VPWR VGND sg13cmos5l_antennanp
XFILLER_11_510 VPWR VGND sg13cmos5l_decap_8
XANTENNA_4105 Tile_X1Y0_N4END[13] VPWR VGND sg13cmos5l_antennanp
XFILLER_11_587 VPWR VGND sg13cmos5l_decap_8
XANTENNA_3404 Tile_X0Y0_FrameData[21] VPWR VGND sg13cmos5l_antennanp
XANTENNA_4116 Tile_X1Y0_N4END[13] VPWR VGND sg13cmos5l_antennanp
XANTENNA_4127 Tile_X1Y0_NN4END[2] VPWR VGND sg13cmos5l_antennanp
XANTENNA_4138 Tile_X1Y0_N2END[2] VPWR VGND sg13cmos5l_antennanp
XANTENNA_3415 Tile_X0Y0_FrameData[21] VPWR VGND sg13cmos5l_antennanp
XANTENNA_3426 Tile_X0Y0_FrameData[21] VPWR VGND sg13cmos5l_antennanp
XANTENNA_3437 Tile_X0Y0_FrameData[21] VPWR VGND sg13cmos5l_antennanp
XANTENNA_4149 Tile_X1Y0_N2MID[1] VPWR VGND sg13cmos5l_antennanp
XFILLER_10_2676 VPWR VGND sg13cmos5l_decap_8
XANTENNA_2703 Tile_X0Y0_FrameData[14] VPWR VGND sg13cmos5l_antennanp
XANTENNA_2714 Tile_X0Y0_FrameData[14] VPWR VGND sg13cmos5l_antennanp
XANTENNA_2725 Tile_X0Y0_FrameData[14] VPWR VGND sg13cmos5l_antennanp
XANTENNA_3448 Tile_X0Y0_FrameData[21] VPWR VGND sg13cmos5l_antennanp
XANTENNA_3459 Tile_X0Y0_FrameData[8] VPWR VGND sg13cmos5l_antennanp
XANTENNA_2736 Tile_X0Y0_FrameData[14] VPWR VGND sg13cmos5l_antennanp
XANTENNA_2747 Tile_X0Y0_FrameData[14] VPWR VGND sg13cmos5l_antennanp
XANTENNA_2758 Tile_X0Y0_FrameData[14] VPWR VGND sg13cmos5l_antennanp
XANTENNA_2769 Tile_X0Y0_FrameData[14] VPWR VGND sg13cmos5l_antennanp
XANTENNA__0918__X Tile_X3Y0_FrameStrobe_O[3] VPWR VGND sg13cmos5l_antennanp
X_1050_ Tile_X4Y0_S4BEG[3] Tile_X4Y0_N4END[12] VPWR VGND sg13cmos5l_buf_1
XFILLER_15_2510 VPWR VGND sg13cmos5l_decap_8
X_0903_ Tile_X2Y0_SS4BEG[4] _1239_/X VPWR VGND sg13cmos5l_buf_1
XFILLER_15_2565 VPWR VGND sg13cmos5l_decap_8
X_0834_ Tile_X4Y0_FrameData_O[23] Tile_X0Y0_FrameData[23] VPWR VGND sg13cmos5l_buf_1
XFILLER_15_2598 VPWR VGND sg13cmos5l_decap_8
XFILLER_15_1864 VPWR VGND sg13cmos5l_decap_8
XFILLER_11_2429 VPWR VGND sg13cmos5l_decap_8
XFILLER_11_1739 VPWR VGND sg13cmos5l_decap_8
X_0765_ Tile_X3Y0_S2BEG[2] Tile_X3Y0_N2MID[5] VPWR VGND sg13cmos5l_buf_1
X_0696_ Tile_X0Y0_FrameStrobe_O[9] Tile_X0Y0_FrameStrobe[9] VPWR VGND sg13cmos5l_buf_1
XANTENNA_3960 Tile_X0Y0_FrameData[18] VPWR VGND sg13cmos5l_antennanp
XANTENNA_3971 Tile_X0Y0_FrameData[18] VPWR VGND sg13cmos5l_antennanp
XANTENNA_3982 Tile_X0Y0_FrameData[18] VPWR VGND sg13cmos5l_antennanp
XANTENNA_3993 Tile_X0Y0_FrameData[18] VPWR VGND sg13cmos5l_antennanp
XFILLER_9_1100 VPWR VGND sg13cmos5l_decap_4
XFILLER_6_2711 VPWR VGND sg13cmos5l_decap_8
XFILLER_9_1155 VPWR VGND sg13cmos5l_decap_8
XANTENNA__0828__X Tile_X4Y0_FrameData_O[17] VPWR VGND sg13cmos5l_antennanp
X_1248_ _1248_/X Tile_X2Y0_N2END[5] Tile_X2Y0_N4END[13] Tile_X2Y0_NN4END[2] _0580_/Q
+ _0335_/Q _0334_/Q VPWR VGND sg13cmos5l_mux4_1
X_1179_ _1179_/X Tile_X1Y0_N2MID[0] Tile_X1Y0_N4END[15] Tile_X1Y0_NN4END[0] _0594_/Q
+ _0297_/Q _0296_/Q VPWR VGND sg13cmos5l_mux4_1
XANTENNA_30 NPU_RDATA31 VPWR VGND sg13cmos5l_antennanp
XANTENNA_41 Tile_X0Y0_FrameData[0] VPWR VGND sg13cmos5l_antennanp
XFILLER_16_1639 VPWR VGND sg13cmos5l_fill_1
XANTENNA_74 Tile_X0Y0_FrameData[0] VPWR VGND sg13cmos5l_antennanp
XANTENNA_63 Tile_X0Y0_FrameData[0] VPWR VGND sg13cmos5l_antennanp
XANTENNA_52 Tile_X0Y0_FrameData[0] VPWR VGND sg13cmos5l_antennanp
XFILLER_14_2097 VPWR VGND sg13cmos5l_decap_8
XANTENNA_96 Tile_X0Y0_FrameData[0] VPWR VGND sg13cmos5l_antennanp
XANTENNA_85 Tile_X0Y0_FrameData[0] VPWR VGND sg13cmos5l_antennanp
XFILLER_10_1249 VPWR VGND sg13cmos5l_decap_4
XANTENNA_1309 Tile_X0Y0_FrameData[30] VPWR VGND sg13cmos5l_antennanp
XFILLER_0_712 VPWR VGND sg13cmos5l_fill_2
XFILLER_5_2221 VPWR VGND sg13cmos5l_decap_8
XANTENNA__0738__X Tile_X1Y0_SS4BEG[7] VPWR VGND sg13cmos5l_antennanp
XFILLER_5_2298 VPWR VGND sg13cmos5l_decap_8
XFILLER_16_613 VPWR VGND sg13cmos5l_decap_8
XFILLER_15_112 VPWR VGND sg13cmos5l_decap_8
XFILLER_15_189 VPWR VGND sg13cmos5l_decap_8
XFILLER_15_1116 VPWR VGND sg13cmos5l_decap_8
XFILLER_7_14 VPWR VGND sg13cmos5l_decap_8
XFILLER_12_2738 VPWR VGND sg13cmos5l_decap_8
XANTENNA_3201 Tile_X0Y0_FrameData[20] VPWR VGND sg13cmos5l_antennanp
XANTENNA_3212 Tile_X0Y0_FrameData[20] VPWR VGND sg13cmos5l_antennanp
XANTENNA_2500 Tile_X0Y0_FrameData[12] VPWR VGND sg13cmos5l_antennanp
XANTENNA_3223 Tile_X0Y0_FrameData[20] VPWR VGND sg13cmos5l_antennanp
XANTENNA_3234 Tile_X0Y0_FrameData[20] VPWR VGND sg13cmos5l_antennanp
XANTENNA_3245 Tile_X0Y0_FrameData[20] VPWR VGND sg13cmos5l_antennanp
X_0550_ NPU_WDATA26 Tile_X0Y0_UserCLK _1122_/X _0659_/L_HI VPWR VGND sg13cmos5l_dfrbpq_1
XFILLER_10_1772 VPWR VGND sg13cmos5l_fill_2
XFILLER_10_1761 VPWR VGND sg13cmos5l_decap_8
XANTENNA_2511 Tile_X0Y0_FrameData[12] VPWR VGND sg13cmos5l_antennanp
XANTENNA_2522 Tile_X0Y0_FrameData[12] VPWR VGND sg13cmos5l_antennanp
XANTENNA_2533 Tile_X0Y0_FrameData[12] VPWR VGND sg13cmos5l_antennanp
XANTENNA_3256 Tile_X0Y0_FrameData[20] VPWR VGND sg13cmos5l_antennanp
XANTENNA_3267 Tile_X0Y0_FrameData[20] VPWR VGND sg13cmos5l_antennanp
XANTENNA_3278 Tile_X0Y0_FrameData[20] VPWR VGND sg13cmos5l_antennanp
XFILLER_3_572 VPWR VGND sg13cmos5l_decap_8
XANTENNA_1810 Tile_X0Y0_FrameData[5] VPWR VGND sg13cmos5l_antennanp
XANTENNA_1821 Tile_X0Y0_FrameData[5] VPWR VGND sg13cmos5l_antennanp
XANTENNA_1832 Tile_X0Y0_FrameData[5] VPWR VGND sg13cmos5l_antennanp
XANTENNA_2544 Tile_X0Y0_FrameData[12] VPWR VGND sg13cmos5l_antennanp
XANTENNA_2555 Tile_X0Y0_FrameData[12] VPWR VGND sg13cmos5l_antennanp
XANTENNA_2566 Tile_X0Y0_FrameData[12] VPWR VGND sg13cmos5l_antennanp
XANTENNA_2577 Tile_X0Y0_FrameData[12] VPWR VGND sg13cmos5l_antennanp
XANTENNA_3289 Tile_X0Y0_FrameData[20] VPWR VGND sg13cmos5l_antennanp
X_0481_ _0481_/Q Tile_X0Y0_FrameData[24] VGND VPWR Tile_X3Y0_FrameStrobe[2] latch
XANTENNA_1843 Tile_X0Y0_FrameData[5] VPWR VGND sg13cmos5l_antennanp
XANTENNA_1854 Tile_X0Y0_FrameData[5] VPWR VGND sg13cmos5l_antennanp
XANTENNA_1865 Tile_X0Y0_FrameData[5] VPWR VGND sg13cmos5l_antennanp
XANTENNA_2588 Tile_X0Y0_FrameData[13] VPWR VGND sg13cmos5l_antennanp
XANTENNA_2599 Tile_X0Y0_FrameData[13] VPWR VGND sg13cmos5l_antennanp
XANTENNA_1876 Tile_X0Y0_FrameData[5] VPWR VGND sg13cmos5l_antennanp
XANTENNA_1887 Tile_X0Y0_FrameData[5] VPWR VGND sg13cmos5l_antennanp
XANTENNA_1898 Tile_X0Y0_FrameData[5] VPWR VGND sg13cmos5l_antennanp
X_1102_ _1102_/X Tile_X1Y0_N4END[6] Tile_X1Y0_N4END[7] Tile_X1Y0_NN4END[4] Tile_X1Y0_NN4END[6]
+ _0221_/Q _0220_/Q VPWR VGND sg13cmos5l_mux4_1
XFILLER_4_1052 VPWR VGND sg13cmos5l_fill_1
X_1033_ Tile_X4Y0_S2BEG[2] Tile_X4Y0_N2MID[5] VPWR VGND sg13cmos5l_buf_1
XFILLER_15_2384 VPWR VGND sg13cmos5l_decap_8
XFILLER_11_2226 VPWR VGND sg13cmos5l_decap_8
XFILLER_15_1661 VPWR VGND sg13cmos5l_decap_8
X_0817_ Tile_X4Y0_FrameData_O[6] Tile_X0Y0_FrameData[6] VPWR VGND sg13cmos5l_buf_1
XFILLER_11_1536 VPWR VGND sg13cmos5l_decap_8
X_0748_ Tile_X1Y0_S1BEG[1] Tile_X1Y0_N1END[2] VPWR VGND sg13cmos5l_buf_1
XANTENNA_3790 Tile_X0Y0_FrameData[18] VPWR VGND sg13cmos5l_antennanp
X_0679_ _0679_/L_HI VPWR VGND sg13cmos5l_tiehi
XFILLER_2_1737 VPWR VGND sg13cmos5l_decap_8
XANTENNA_707 Tile_X0Y0_FrameData[25] VPWR VGND sg13cmos5l_antennanp
XANTENNA_729 Tile_X0Y0_FrameData[25] VPWR VGND sg13cmos5l_antennanp
XANTENNA_718 Tile_X0Y0_FrameData[25] VPWR VGND sg13cmos5l_antennanp
XFILLER_16_56 VPWR VGND sg13cmos5l_decap_8
XFILLER_12_126 VPWR VGND sg13cmos5l_decap_8
XFILLER_12_115 VPWR VGND sg13cmos5l_fill_1
XFILLER_9_609 VPWR VGND sg13cmos5l_decap_8
XFILLER_16_2148 VPWR VGND sg13cmos5l_decap_8
XFILLER_8_119 VPWR VGND sg13cmos5l_decap_8
XFILLER_16_1458 VPWR VGND sg13cmos5l_decap_8
XFILLER_14_1160 VPWR VGND sg13cmos5l_decap_8
XFILLER_10_1024 VPWR VGND sg13cmos5l_fill_2
XANTENNA_1106 Tile_X0Y0_FrameData[2] VPWR VGND sg13cmos5l_antennanp
XANTENNA_1117 Tile_X0Y0_FrameData[2] VPWR VGND sg13cmos5l_antennanp
XANTENNA_1128 Tile_X0Y0_FrameData[2] VPWR VGND sg13cmos5l_antennanp
XANTENNA_1139 Tile_X0Y0_FrameData[2] VPWR VGND sg13cmos5l_antennanp
XFILLER_7_1659 VPWR VGND sg13cmos5l_decap_8
XFILLER_5_2062 VPWR VGND sg13cmos5l_fill_2
XFILLER_16_465 VPWR VGND sg13cmos5l_decap_8
XFILLER_16_454 VPWR VGND sg13cmos5l_decap_8
XFILLER_12_693 VPWR VGND sg13cmos5l_decap_8
XANTENNA__0931__X Tile_X3Y0_FrameStrobe_O[16] VPWR VGND sg13cmos5l_antennanp
XFILLER_8_675 VPWR VGND sg13cmos5l_decap_8
XFILLER_12_1845 VPWR VGND sg13cmos5l_decap_4
XANTENNA_3020 Tile_X0Y0_FrameData[19] VPWR VGND sg13cmos5l_antennanp
X_0602_ _0602_/Q Tile_X0Y0_UserCLK NPU_RDATA30 _0618_/L_HI VPWR VGND sg13cmos5l_dfrbpq_1
XANTENNA_3031 Tile_X0Y0_FrameData[19] VPWR VGND sg13cmos5l_antennanp
XANTENNA_3042 Tile_X0Y0_FrameData[19] VPWR VGND sg13cmos5l_antennanp
XANTENNA_3053 Tile_X0Y0_FrameData[19] VPWR VGND sg13cmos5l_antennanp
XFILLER_10_1580 VPWR VGND sg13cmos5l_decap_8
XANTENNA_2330 Tile_X0Y0_FrameData[11] VPWR VGND sg13cmos5l_antennanp
XANTENNA_2341 Tile_X0Y0_FrameData[11] VPWR VGND sg13cmos5l_antennanp
XANTENNA_2352 Tile_X0Y0_FrameData[11] VPWR VGND sg13cmos5l_antennanp
XANTENNA_3064 Tile_X0Y0_FrameData[19] VPWR VGND sg13cmos5l_antennanp
XANTENNA_3075 Tile_X0Y0_FrameData[19] VPWR VGND sg13cmos5l_antennanp
XANTENNA_3086 Tile_X0Y0_FrameData[19] VPWR VGND sg13cmos5l_antennanp
XANTENNA_3097 Tile_X0Y0_FrameData[19] VPWR VGND sg13cmos5l_antennanp
X_0533_ NPU_WDATA9 Tile_X0Y0_UserCLK _1105_/X _0638_/L_HI VPWR VGND sg13cmos5l_dfrbpq_1
XANTENNA_1640 Tile_X0Y0_FrameData[4] VPWR VGND sg13cmos5l_antennanp
XANTENNA_2363 Tile_X0Y0_FrameData[11] VPWR VGND sg13cmos5l_antennanp
XANTENNA_2374 Tile_X0Y0_FrameData[11] VPWR VGND sg13cmos5l_antennanp
XANTENNA_2385 Tile_X0Y0_FrameData[11] VPWR VGND sg13cmos5l_antennanp
X_0464_ _0464_/Q Tile_X0Y0_FrameData[9] VGND VPWR Tile_X3Y0_FrameStrobe[1] latch
XANTENNA_1651 Tile_X0Y0_FrameData[4] VPWR VGND sg13cmos5l_antennanp
XANTENNA_1662 Tile_X0Y0_FrameData[4] VPWR VGND sg13cmos5l_antennanp
XANTENNA_1673 Tile_X0Y0_FrameData[4] VPWR VGND sg13cmos5l_antennanp
XANTENNA_2396 Tile_X0Y0_FrameData[11] VPWR VGND sg13cmos5l_antennanp
XFILLER_3_2703 VPWR VGND sg13cmos5l_decap_8
XANTENNA_1684 Tile_X0Y0_FrameData[4] VPWR VGND sg13cmos5l_antennanp
XANTENNA_1695 Tile_X0Y0_FrameData[4] VPWR VGND sg13cmos5l_antennanp
X_0395_ _0395_/Q Tile_X0Y0_FrameData[14] VGND VPWR Tile_X2Y0_FrameStrobe[2] latch
XFILLER_6_1169 VPWR VGND sg13cmos5l_decap_8
XFILLER_1_2471 VPWR VGND sg13cmos5l_decap_8
X_1016_ Tile_X0Y0_S2BEG[1] Tile_X0Y0_N2MID[6] VPWR VGND sg13cmos5l_buf_1
XANTENNA__1002__X Tile_X0Y0_S4BEG[11] VPWR VGND sg13cmos5l_antennanp
XFILLER_15_2170 VPWR VGND sg13cmos5l_decap_8
XANTENNA__0841__X Tile_X4Y0_FrameData_O[30] VPWR VGND sg13cmos5l_antennanp
XFILLER_8_2636 VPWR VGND sg13cmos5l_decap_8
XFILLER_6_2360 VPWR VGND sg13cmos5l_decap_8
XFILLER_2_2235 VPWR VGND sg13cmos5l_decap_8
XFILLER_6_1692 VPWR VGND sg13cmos5l_decap_8
XANTENNA_526 Tile_X0Y0_FrameData[23] VPWR VGND sg13cmos5l_antennanp
XANTENNA_515 Tile_X0Y0_FrameData[23] VPWR VGND sg13cmos5l_antennanp
XANTENNA_504 Tile_X0Y0_FrameData[23] VPWR VGND sg13cmos5l_antennanp
XANTENNA_559 Tile_X0Y0_FrameData[23] VPWR VGND sg13cmos5l_antennanp
XANTENNA_548 Tile_X0Y0_FrameData[23] VPWR VGND sg13cmos5l_antennanp
XANTENNA_537 Tile_X0Y0_FrameData[23] VPWR VGND sg13cmos5l_antennanp
XFILLER_13_413 VPWR VGND sg13cmos5l_fill_1
XFILLER_16_1211 VPWR VGND sg13cmos5l_decap_8
XFILLER_16_1200 VPWR VGND sg13cmos5l_fill_1
XFILLER_13_457 VPWR VGND sg13cmos5l_decap_8
XFILLER_16_1255 VPWR VGND sg13cmos5l_decap_8
XFILLER_12_1119 VPWR VGND sg13cmos5l_decap_8
XANTENNA__0751__X Tile_X1Y0_S2BEG[0] VPWR VGND sg13cmos5l_antennanp
XFILLER_5_634 VPWR VGND sg13cmos5l_decap_8
XFILLER_11_2590 VPWR VGND sg13cmos5l_decap_8
X_0180_ _0180_/Q Tile_X0Y0_FrameData[5] VGND VPWR Tile_X0Y0_FrameStrobe[2] latch
XFILLER_5_1180 VPWR VGND sg13cmos5l_fill_1
XANTENNA__0926__X Tile_X3Y0_FrameStrobe_O[11] VPWR VGND sg13cmos5l_antennanp
XFILLER_13_991 VPWR VGND sg13cmos5l_fill_1
XFILLER_12_2365 VPWR VGND sg13cmos5l_decap_8
XFILLER_12_1642 VPWR VGND sg13cmos5l_decap_8
XANTENNA_2160 Tile_X0Y0_FrameData[9] VPWR VGND sg13cmos5l_antennanp
X_0516_ _0516_/Q Tile_X0Y0_FrameData[21] VGND VPWR Tile_X4Y0_FrameStrobe[0] latch
XANTENNA_2171 Tile_X0Y0_FrameData[9] VPWR VGND sg13cmos5l_antennanp
XANTENNA_2182 Tile_X0Y0_FrameData[9] VPWR VGND sg13cmos5l_antennanp
XANTENNA_2193 Tile_X0Y0_FrameData[9] VPWR VGND sg13cmos5l_antennanp
XANTENNA_1470 Tile_X0Y0_FrameData[31] VPWR VGND sg13cmos5l_antennanp
XANTENNA_1481 Tile_X0Y0_FrameData[31] VPWR VGND sg13cmos5l_antennanp
XANTENNA_1492 Tile_X0Y0_FrameData[31] VPWR VGND sg13cmos5l_antennanp
X_0447_ _0447_/Q Tile_X0Y0_FrameData[26] VGND VPWR Tile_X3Y0_FrameStrobe[1] latch
X_0378_ _0378_/Q Tile_X0Y0_FrameData[31] VGND VPWR Tile_X2Y0_FrameStrobe[2] latch
XFILLER_3_2577 VPWR VGND sg13cmos5l_decap_8
XANTENNA__0836__X Tile_X4Y0_FrameData_O[25] VPWR VGND sg13cmos5l_antennanp
XFILLER_13_35 VPWR VGND sg13cmos5l_decap_8
XFILLER_11_1196 VPWR VGND sg13cmos5l_decap_8
XFILLER_8_2499 VPWR VGND sg13cmos5l_decap_8
XFILLER_4_1607 VPWR VGND sg13cmos5l_decap_8
XANTENNA_301 Tile_X0Y0_FrameData[1] VPWR VGND sg13cmos5l_antennanp
XANTENNA__0746__X Tile_X1Y0_SS4BEG[15] VPWR VGND sg13cmos5l_antennanp
XANTENNA_312 Tile_X0Y0_FrameData[1] VPWR VGND sg13cmos5l_antennanp
XANTENNA_323 Tile_X0Y0_FrameData[1] VPWR VGND sg13cmos5l_antennanp
XANTENNA_334 Tile_X0Y0_FrameData[1] VPWR VGND sg13cmos5l_antennanp
XFILLER_2_2098 VPWR VGND sg13cmos5l_fill_1
XANTENNA_345 Tile_X0Y0_FrameData[1] VPWR VGND sg13cmos5l_antennanp
XANTENNA_356 Tile_X0Y0_FrameData[1] VPWR VGND sg13cmos5l_antennanp
XANTENNA_367 Tile_X0Y0_FrameData[1] VPWR VGND sg13cmos5l_antennanp
XANTENNA_378 Tile_X0Y0_FrameData[1] VPWR VGND sg13cmos5l_antennanp
XANTENNA_389 Tile_X0Y0_FrameData[22] VPWR VGND sg13cmos5l_antennanp
XFILLER_14_744 VPWR VGND sg13cmos5l_decap_8
XFILLER_16_1096 VPWR VGND sg13cmos5l_decap_8
XFILLER_10_972 VPWR VGND sg13cmos5l_fill_1
XFILLER_13_2685 VPWR VGND sg13cmos5l_decap_8
X_0301_ _0301_/Q Tile_X0Y0_FrameData[28] VGND VPWR Tile_X1Y0_FrameStrobe[3] latch
X_1281_ _1281_/X Tile_X3Y0_N2END[6] Tile_X3Y0_N4END[6] Tile_X3Y0_NN4END[9] _0577_/Q
+ _0445_/Q _0444_/Q VPWR VGND sg13cmos5l_mux4_1
X_0232_ _0232_/Q Tile_X0Y0_FrameData[1] VGND VPWR Tile_X1Y0_FrameStrobe[0] latch
XFILLER_3_1117 VPWR VGND sg13cmos5l_decap_8
X_0163_ _0163_/Q Tile_X0Y0_FrameData[22] VGND VPWR Tile_X0Y0_FrameStrobe[2] latch
X_0094_ _0094_/Q Tile_X0Y0_FrameData[27] VGND VPWR Tile_X0Y0_FrameStrobe[0] latch
XANTENNA_890 Tile_X0Y0_FrameData[27] VPWR VGND sg13cmos5l_antennanp
XFILLER_14_1704 VPWR VGND sg13cmos5l_decap_8
X_0996_ Tile_X0Y0_S4BEG[5] _1144_/X VPWR VGND sg13cmos5l_buf_1
XFILLER_12_2162 VPWR VGND sg13cmos5l_decap_8
XFILLER_9_2731 VPWR VGND sg13cmos5l_decap_8
XFILLER_5_91 VPWR VGND sg13cmos5l_decap_8
XFILLER_8_1039 VPWR VGND sg13cmos5l_fill_1
XFILLER_3_1684 VPWR VGND sg13cmos5l_decap_8
XFILLER_11_747 VPWR VGND sg13cmos5l_decap_4
XFILLER_13_1269 VPWR VGND sg13cmos5l_decap_8
XANTENNA_3608 Tile_X0Y0_FrameData[8] VPWR VGND sg13cmos5l_antennanp
XANTENNA_3619 Tile_X0Y0_N2END[6] VPWR VGND sg13cmos5l_antennanp
XANTENNA_2907 Tile_X0Y0_FrameData[17] VPWR VGND sg13cmos5l_antennanp
XANTENNA_2918 Tile_X0Y0_FrameData[17] VPWR VGND sg13cmos5l_antennanp
XANTENNA_2929 Tile_X0Y0_FrameData[17] VPWR VGND sg13cmos5l_antennanp
XFILLER_8_2296 VPWR VGND sg13cmos5l_decap_8
XFILLER_8_2274 VPWR VGND sg13cmos5l_decap_4
XFILLER_8_1551 VPWR VGND sg13cmos5l_decap_4
XFILLER_8_1584 VPWR VGND sg13cmos5l_decap_8
XFILLER_1_49 VPWR VGND sg13cmos5l_decap_8
XANTENNA_120 Tile_X0Y0_FrameData[0] VPWR VGND sg13cmos5l_antennanp
XANTENNA_131 Tile_X0Y0_FrameData[0] VPWR VGND sg13cmos5l_antennanp
XANTENNA_142 Tile_X0Y0_FrameData[10] VPWR VGND sg13cmos5l_antennanp
XFILLER_2_1161 VPWR VGND sg13cmos5l_fill_2
XANTENNA_153 Tile_X0Y0_FrameData[10] VPWR VGND sg13cmos5l_antennanp
XANTENNA_164 Tile_X0Y0_FrameData[10] VPWR VGND sg13cmos5l_antennanp
XANTENNA_175 Tile_X0Y0_FrameData[10] VPWR VGND sg13cmos5l_antennanp
XFILLER_14_530 VPWR VGND sg13cmos5l_fill_2
XANTENNA_186 Tile_X0Y0_FrameData[10] VPWR VGND sg13cmos5l_antennanp
XANTENNA_197 Tile_X0Y0_FrameData[10] VPWR VGND sg13cmos5l_antennanp
XFILLER_15_2703 VPWR VGND sg13cmos5l_decap_8
X_0850_ Tile_X4Y0_FrameStrobe_O[7] Tile_X4Y0_FrameStrobe[7] VPWR VGND sg13cmos5l_buf_1
X_0781_ Tile_X3Y0_S4BEG[2] _1261_/X VPWR VGND sg13cmos5l_buf_1
XFILLER_5_283 VPWR VGND sg13cmos5l_fill_2
X_1264_ _1264_/X Tile_X3Y0_N2MID[5] Tile_X3Y0_N4END[10] Tile_X3Y0_NN4END[5] _0577_/Q
+ _0479_/Q _0478_/Q VPWR VGND sg13cmos5l_mux4_1
X_0215_ _0215_/Q Tile_X0Y0_FrameData[18] VGND VPWR Tile_X1Y0_FrameStrobe[0] latch
XFILLER_7_1094 VPWR VGND sg13cmos5l_decap_8
XFILLER_4_2661 VPWR VGND sg13cmos5l_decap_8
XFILLER_0_2503 VPWR VGND sg13cmos5l_fill_1
X_1195_ _1195_/X Tile_X1Y0_N2END[0] Tile_X1Y0_N4END[0] Tile_X1Y0_NN4END[15] _0595_/Q
+ _0265_/Q _0264_/Q VPWR VGND sg13cmos5l_mux4_1
X_0146_ _0146_/Q Tile_X0Y0_FrameData[7] VGND VPWR Tile_X0Y0_FrameStrobe[1] latch
XFILLER_14_2202 VPWR VGND sg13cmos5l_decap_8
XFILLER_14_2268 VPWR VGND sg13cmos5l_decap_8
XFILLER_14_1501 VPWR VGND sg13cmos5l_decap_8
XANTENNA__1010__X Tile_X0Y0_S2BEGb[3] VPWR VGND sg13cmos5l_antennanp
X_0979_ Tile_X0Y0_SS4BEG[4] _1159_/X VPWR VGND sg13cmos5l_buf_1
XFILLER_14_1578 VPWR VGND sg13cmos5l_decap_8
XFILLER_12_1291 VPWR VGND sg13cmos5l_fill_2
XFILLER_12_1280 VPWR VGND sg13cmos5l_decap_8
XFILLER_10_14 VPWR VGND sg13cmos5l_decap_8
XFILLER_5_2403 VPWR VGND sg13cmos5l_decap_8
XFILLER_5_1702 VPWR VGND sg13cmos5l_decap_8
XFILLER_5_1779 VPWR VGND sg13cmos5l_fill_2
XFILLER_11_566 VPWR VGND sg13cmos5l_decap_8
XANTENNA_4106 Tile_X1Y0_N4END[13] VPWR VGND sg13cmos5l_antennanp
XFILLER_7_548 VPWR VGND sg13cmos5l_decap_8
XANTENNA_4117 Tile_X1Y0_N4END[13] VPWR VGND sg13cmos5l_antennanp
XANTENNA_4128 Tile_X1Y0_NN4END[2] VPWR VGND sg13cmos5l_antennanp
XANTENNA_4139 Tile_X1Y0_N2END[2] VPWR VGND sg13cmos5l_antennanp
XFILLER_7_559 VPWR VGND sg13cmos5l_fill_2
XFILLER_10_2655 VPWR VGND sg13cmos5l_decap_8
XANTENNA_3405 Tile_X0Y0_FrameData[21] VPWR VGND sg13cmos5l_antennanp
XANTENNA_3416 Tile_X0Y0_FrameData[21] VPWR VGND sg13cmos5l_antennanp
XANTENNA_3427 Tile_X0Y0_FrameData[21] VPWR VGND sg13cmos5l_antennanp
XANTENNA_2704 Tile_X0Y0_FrameData[14] VPWR VGND sg13cmos5l_antennanp
XANTENNA_2715 Tile_X0Y0_FrameData[14] VPWR VGND sg13cmos5l_antennanp
XANTENNA_2726 Tile_X0Y0_FrameData[14] VPWR VGND sg13cmos5l_antennanp
XANTENNA_3438 Tile_X0Y0_FrameData[21] VPWR VGND sg13cmos5l_antennanp
XANTENNA_3449 Tile_X0Y0_FrameData[21] VPWR VGND sg13cmos5l_antennanp
XFILLER_4_0 VPWR VGND sg13cmos5l_decap_8
XANTENNA_2737 Tile_X0Y0_FrameData[14] VPWR VGND sg13cmos5l_antennanp
XANTENNA_2748 Tile_X0Y0_FrameData[14] VPWR VGND sg13cmos5l_antennanp
XANTENNA_2759 Tile_X0Y0_FrameData[14] VPWR VGND sg13cmos5l_antennanp
XANTENNA__0934__X Tile_X3Y0_FrameStrobe_O[19] VPWR VGND sg13cmos5l_antennanp
X_0902_ Tile_X2Y0_SS4BEG[3] _1238_/X VPWR VGND sg13cmos5l_buf_1
XFILLER_11_2408 VPWR VGND sg13cmos5l_decap_8
X_0833_ Tile_X4Y0_FrameData_O[22] Tile_X0Y0_FrameData[22] VPWR VGND sg13cmos5l_buf_1
XFILLER_15_1843 VPWR VGND sg13cmos5l_decap_8
XFILLER_11_1718 VPWR VGND sg13cmos5l_decap_8
X_0764_ Tile_X3Y0_S2BEG[1] Tile_X3Y0_N2MID[6] VPWR VGND sg13cmos5l_buf_1
XANTENNA_3950 Tile_X0Y0_FrameData[18] VPWR VGND sg13cmos5l_antennanp
X_0695_ Tile_X0Y0_FrameStrobe_O[8] Tile_X0Y0_FrameStrobe[8] VPWR VGND sg13cmos5l_buf_1
XANTENNA_3961 Tile_X0Y0_FrameData[18] VPWR VGND sg13cmos5l_antennanp
XANTENNA_3972 Tile_X0Y0_FrameData[18] VPWR VGND sg13cmos5l_antennanp
XANTENNA_3983 Tile_X0Y0_FrameData[18] VPWR VGND sg13cmos5l_antennanp
XANTENNA_3994 Tile_X0Y0_FrameData[18] VPWR VGND sg13cmos5l_antennanp
XFILLER_9_1134 VPWR VGND sg13cmos5l_decap_8
XFILLER_6_2767 VPWR VGND sg13cmos5l_decap_8
X_1247_ _1247_/X Tile_X2Y0_N2END[4] Tile_X2Y0_N4END[12] Tile_X2Y0_NN4END[3] _0581_/Q
+ _0337_/Q _0336_/Q VPWR VGND sg13cmos5l_mux4_1
XFILLER_0_2333 VPWR VGND sg13cmos5l_decap_8
XANTENNA__1005__X Tile_X0Y0_S4BEG[14] VPWR VGND sg13cmos5l_antennanp
X_1178_ _1178_/X Tile_X1Y0_N1END[3] Tile_X1Y0_N2MID[7] Tile_X1Y0_N2END[0] _0595_/Q
+ _0299_/Q _0298_/Q VPWR VGND sg13cmos5l_mux4_1
X_0129_ _0129_/Q Tile_X0Y0_FrameData[24] VGND VPWR Tile_X0Y0_FrameStrobe[1] latch
XANTENNA__0844__X Tile_X4Y0_FrameStrobe_O[1] VPWR VGND sg13cmos5l_antennanp
XFILLER_16_2319 VPWR VGND sg13cmos5l_decap_8
XFILLER_16_1618 VPWR VGND sg13cmos5l_fill_1
XFILLER_16_1607 VPWR VGND sg13cmos5l_fill_1
XANTENNA_20 NPU_RDATA23 VPWR VGND sg13cmos5l_antennanp
XANTENNA_31 NPU_RDATA31 VPWR VGND sg13cmos5l_antennanp
XANTENNA_42 Tile_X0Y0_FrameData[0] VPWR VGND sg13cmos5l_antennanp
XFILLER_14_2076 VPWR VGND sg13cmos5l_decap_8
XANTENNA_75 Tile_X0Y0_FrameData[0] VPWR VGND sg13cmos5l_antennanp
XANTENNA_64 Tile_X0Y0_FrameData[0] VPWR VGND sg13cmos5l_antennanp
XANTENNA_53 Tile_X0Y0_FrameData[0] VPWR VGND sg13cmos5l_antennanp
XFILLER_14_1375 VPWR VGND sg13cmos5l_decap_4
XANTENNA_97 Tile_X0Y0_FrameData[0] VPWR VGND sg13cmos5l_antennanp
XANTENNA_86 Tile_X0Y0_FrameData[0] VPWR VGND sg13cmos5l_antennanp
XFILLER_10_1228 VPWR VGND sg13cmos5l_decap_8
XFILLER_7_2509 VPWR VGND sg13cmos5l_decap_8
XFILLER_9_1690 VPWR VGND sg13cmos5l_decap_8
XFILLER_5_2277 VPWR VGND sg13cmos5l_decap_8
XFILLER_5_1532 VPWR VGND sg13cmos5l_fill_1
XANTENNA__0754__X Tile_X1Y0_S2BEG[3] VPWR VGND sg13cmos5l_antennanp
XFILLER_16_669 VPWR VGND sg13cmos5l_decap_8
XFILLER_15_168 VPWR VGND sg13cmos5l_decap_8
XFILLER_8_802 VPWR VGND sg13cmos5l_fill_2
XFILLER_12_2717 VPWR VGND sg13cmos5l_decap_8
XFILLER_12_875 VPWR VGND sg13cmos5l_fill_2
XANTENNA_3202 Tile_X0Y0_FrameData[20] VPWR VGND sg13cmos5l_antennanp
XANTENNA_2501 Tile_X0Y0_FrameData[12] VPWR VGND sg13cmos5l_antennanp
XANTENNA_3213 Tile_X0Y0_FrameData[20] VPWR VGND sg13cmos5l_antennanp
XANTENNA_3224 Tile_X0Y0_FrameData[20] VPWR VGND sg13cmos5l_antennanp
XANTENNA_3235 Tile_X0Y0_FrameData[20] VPWR VGND sg13cmos5l_antennanp
XANTENNA_3246 Tile_X0Y0_FrameData[20] VPWR VGND sg13cmos5l_antennanp
XFILLER_10_2485 VPWR VGND sg13cmos5l_decap_8
XANTENNA_2512 Tile_X0Y0_FrameData[12] VPWR VGND sg13cmos5l_antennanp
XANTENNA_2523 Tile_X0Y0_FrameData[12] VPWR VGND sg13cmos5l_antennanp
XANTENNA_2534 Tile_X0Y0_FrameData[12] VPWR VGND sg13cmos5l_antennanp
XANTENNA_3257 Tile_X0Y0_FrameData[20] VPWR VGND sg13cmos5l_antennanp
XANTENNA_3268 Tile_X0Y0_FrameData[20] VPWR VGND sg13cmos5l_antennanp
XANTENNA_3279 Tile_X0Y0_FrameData[20] VPWR VGND sg13cmos5l_antennanp
X_0480_ _0480_/Q Tile_X0Y0_FrameData[25] VGND VPWR Tile_X3Y0_FrameStrobe[2] latch
XFILLER_3_551 VPWR VGND sg13cmos5l_decap_8
XANTENNA_1800 Tile_X0Y0_FrameData[5] VPWR VGND sg13cmos5l_antennanp
XANTENNA_1811 Tile_X0Y0_FrameData[5] VPWR VGND sg13cmos5l_antennanp
XANTENNA_1822 Tile_X0Y0_FrameData[5] VPWR VGND sg13cmos5l_antennanp
XANTENNA_2545 Tile_X0Y0_FrameData[12] VPWR VGND sg13cmos5l_antennanp
XANTENNA_2556 Tile_X0Y0_FrameData[12] VPWR VGND sg13cmos5l_antennanp
XANTENNA_2567 Tile_X0Y0_FrameData[12] VPWR VGND sg13cmos5l_antennanp
XANTENNA__0929__X Tile_X3Y0_FrameStrobe_O[14] VPWR VGND sg13cmos5l_antennanp
XANTENNA_1833 Tile_X0Y0_FrameData[5] VPWR VGND sg13cmos5l_antennanp
XANTENNA_1844 Tile_X0Y0_FrameData[5] VPWR VGND sg13cmos5l_antennanp
XANTENNA_1855 Tile_X0Y0_FrameData[5] VPWR VGND sg13cmos5l_antennanp
XANTENNA_1866 Tile_X0Y0_FrameData[5] VPWR VGND sg13cmos5l_antennanp
XANTENNA_2578 Tile_X0Y0_FrameData[12] VPWR VGND sg13cmos5l_antennanp
XANTENNA_2589 Tile_X0Y0_FrameData[13] VPWR VGND sg13cmos5l_antennanp
XANTENNA_1877 Tile_X0Y0_FrameData[5] VPWR VGND sg13cmos5l_antennanp
XANTENNA_1888 Tile_X0Y0_FrameData[5] VPWR VGND sg13cmos5l_antennanp
XANTENNA_1899 Tile_X0Y0_FrameData[5] VPWR VGND sg13cmos5l_antennanp
X_1101_ _1101_/X Tile_X1Y0_N4END[5] Tile_X1Y0_N4END[6] Tile_X1Y0_NN4END[5] Tile_X1Y0_NN4END[7]
+ _0223_/Q _0222_/Q VPWR VGND sg13cmos5l_mux4_1
X_1032_ Tile_X4Y0_S2BEG[1] Tile_X4Y0_N2MID[6] VPWR VGND sg13cmos5l_buf_1
XFILLER_1_2642 VPWR VGND sg13cmos5l_decap_8
XFILLER_1_1941 VPWR VGND sg13cmos5l_fill_2
XFILLER_15_2363 VPWR VGND sg13cmos5l_decap_8
XFILLER_15_1640 VPWR VGND sg13cmos5l_decap_8
XFILLER_11_2205 VPWR VGND sg13cmos5l_decap_8
XFILLER_11_1515 VPWR VGND sg13cmos5l_decap_8
X_0816_ Tile_X4Y0_FrameData_O[5] Tile_X0Y0_FrameData[5] VPWR VGND sg13cmos5l_buf_1
X_0747_ Tile_X1Y0_S1BEG[0] Tile_X1Y0_N1END[3] VPWR VGND sg13cmos5l_buf_1
XANTENNA_3780 Tile_X0Y0_FrameData[18] VPWR VGND sg13cmos5l_antennanp
XANTENNA_3791 Tile_X0Y0_FrameData[18] VPWR VGND sg13cmos5l_antennanp
X_0678_ _0678_/L_HI VPWR VGND sg13cmos5l_tiehi
XANTENNA__0839__X Tile_X4Y0_FrameData_O[28] VPWR VGND sg13cmos5l_antennanp
XFILLER_2_2439 VPWR VGND sg13cmos5l_decap_8
XFILLER_2_1716 VPWR VGND sg13cmos5l_decap_8
XANTENNA_708 Tile_X0Y0_FrameData[25] VPWR VGND sg13cmos5l_antennanp
XFILLER_16_35 VPWR VGND sg13cmos5l_decap_8
XANTENNA_719 Tile_X0Y0_FrameData[25] VPWR VGND sg13cmos5l_antennanp
XFILLER_16_2127 VPWR VGND sg13cmos5l_decap_8
XFILLER_16_1437 VPWR VGND sg13cmos5l_decap_8
XANTENNA__0523__Q NPU_READ_BANK_SEL2 VPWR VGND sg13cmos5l_antennanp
XFILLER_5_838 VPWR VGND sg13cmos5l_fill_1
XFILLER_10_1069 VPWR VGND sg13cmos5l_decap_8
XANTENNA_1107 Tile_X0Y0_FrameData[2] VPWR VGND sg13cmos5l_antennanp
XANTENNA_1118 Tile_X0Y0_FrameData[2] VPWR VGND sg13cmos5l_antennanp
XANTENNA_1129 Tile_X0Y0_FrameData[2] VPWR VGND sg13cmos5l_antennanp
XANTENNA__0749__X Tile_X1Y0_S1BEG[2] VPWR VGND sg13cmos5l_antennanp
XFILLER_7_1638 VPWR VGND sg13cmos5l_decap_8
XFILLER_0_598 VPWR VGND sg13cmos5l_fill_1
XFILLER_5_1362 VPWR VGND sg13cmos5l_fill_2
XFILLER_16_433 VPWR VGND sg13cmos5l_fill_2
XFILLER_16_411 VPWR VGND sg13cmos5l_fill_1
XFILLER_16_2683 VPWR VGND sg13cmos5l_decap_8
XFILLER_12_672 VPWR VGND sg13cmos5l_decap_8
XFILLER_8_654 VPWR VGND sg13cmos5l_decap_8
XFILLER_16_1993 VPWR VGND sg13cmos5l_decap_4
XFILLER_12_1857 VPWR VGND sg13cmos5l_decap_8
XFILLER_12_1824 VPWR VGND sg13cmos5l_decap_8
XANTENNA_3010 Tile_X0Y0_FrameData[19] VPWR VGND sg13cmos5l_antennanp
X_0601_ _0601_/Q Tile_X0Y0_UserCLK NPU_RDATA29 _0617_/L_HI VPWR VGND sg13cmos5l_dfrbpq_1
XFILLER_10_2282 VPWR VGND sg13cmos5l_decap_8
XANTENNA_3021 Tile_X0Y0_FrameData[19] VPWR VGND sg13cmos5l_antennanp
XANTENNA_3032 Tile_X0Y0_FrameData[19] VPWR VGND sg13cmos5l_antennanp
XANTENNA_3043 Tile_X0Y0_FrameData[19] VPWR VGND sg13cmos5l_antennanp
XANTENNA_3054 Tile_X0Y0_FrameData[19] VPWR VGND sg13cmos5l_antennanp
X_0532_ NPU_WDATA8 Tile_X0Y0_UserCLK _1104_/X _0639_/L_HI VPWR VGND sg13cmos5l_dfrbpq_1
XANTENNA_2320 Tile_X3Y0_NN4END[3] VPWR VGND sg13cmos5l_antennanp
XANTENNA_2331 Tile_X0Y0_FrameData[11] VPWR VGND sg13cmos5l_antennanp
XANTENNA_2342 Tile_X0Y0_FrameData[11] VPWR VGND sg13cmos5l_antennanp
XANTENNA_3065 Tile_X0Y0_FrameData[19] VPWR VGND sg13cmos5l_antennanp
XANTENNA_3076 Tile_X0Y0_FrameData[19] VPWR VGND sg13cmos5l_antennanp
XANTENNA_3087 Tile_X0Y0_FrameData[19] VPWR VGND sg13cmos5l_antennanp
XANTENNA_1630 Tile_X0Y0_FrameData[4] VPWR VGND sg13cmos5l_antennanp
XANTENNA_1641 Tile_X0Y0_FrameData[4] VPWR VGND sg13cmos5l_antennanp
XANTENNA_2353 Tile_X0Y0_FrameData[11] VPWR VGND sg13cmos5l_antennanp
XANTENNA_2364 Tile_X0Y0_FrameData[11] VPWR VGND sg13cmos5l_antennanp
XANTENNA_2375 Tile_X0Y0_FrameData[11] VPWR VGND sg13cmos5l_antennanp
XANTENNA_3098 Tile_X0Y0_FrameData[19] VPWR VGND sg13cmos5l_antennanp
X_0463_ _0463_/Q Tile_X0Y0_FrameData[10] VGND VPWR Tile_X3Y0_FrameStrobe[1] latch
XANTENNA_1652 Tile_X0Y0_FrameData[4] VPWR VGND sg13cmos5l_antennanp
XANTENNA_1663 Tile_X0Y0_FrameData[4] VPWR VGND sg13cmos5l_antennanp
XANTENNA_1674 Tile_X0Y0_FrameData[4] VPWR VGND sg13cmos5l_antennanp
XANTENNA_2386 Tile_X0Y0_FrameData[11] VPWR VGND sg13cmos5l_antennanp
XANTENNA_2397 Tile_X0Y0_FrameData[11] VPWR VGND sg13cmos5l_antennanp
X_0394_ _0394_/Q Tile_X0Y0_FrameData[15] VGND VPWR Tile_X2Y0_FrameStrobe[2] latch
XANTENNA_1685 Tile_X0Y0_FrameData[4] VPWR VGND sg13cmos5l_antennanp
XANTENNA_1696 Tile_X0Y0_FrameData[4] VPWR VGND sg13cmos5l_antennanp
XFILLER_6_1148 VPWR VGND sg13cmos5l_decap_8
XFILLER_3_2759 VPWR VGND sg13cmos5l_decap_4
XFILLER_1_2461 VPWR VGND sg13cmos5l_decap_8
X_1015_ Tile_X0Y0_S2BEG[0] Tile_X0Y0_N2MID[7] VPWR VGND sg13cmos5l_buf_1
XFILLER_1_1760 VPWR VGND sg13cmos5l_fill_1
XFILLER_8_91 VPWR VGND sg13cmos5l_decap_8
XFILLER_11_2079 VPWR VGND sg13cmos5l_decap_8
XFILLER_8_2615 VPWR VGND sg13cmos5l_decap_8
XFILLER_6_1671 VPWR VGND sg13cmos5l_decap_8
XANTENNA_516 Tile_X0Y0_FrameData[23] VPWR VGND sg13cmos5l_antennanp
XANTENNA_505 Tile_X0Y0_FrameData[23] VPWR VGND sg13cmos5l_antennanp
XANTENNA_549 Tile_X0Y0_FrameData[23] VPWR VGND sg13cmos5l_antennanp
XANTENNA_538 Tile_X0Y0_FrameData[23] VPWR VGND sg13cmos5l_antennanp
XANTENNA_527 Tile_X0Y0_FrameData[23] VPWR VGND sg13cmos5l_antennanp
XFILLER_5_613 VPWR VGND sg13cmos5l_decap_8
XFILLER_4_49 VPWR VGND sg13cmos5l_decap_8
XFILLER_1_1034 VPWR VGND sg13cmos5l_fill_2
XFILLER_14_2609 VPWR VGND sg13cmos5l_decap_8
XANTENNA__0942__X Tile_X2Y0_FrameStrobe_O[7] VPWR VGND sg13cmos5l_antennanp
XFILLER_12_480 VPWR VGND sg13cmos5l_decap_8
XFILLER_12_2344 VPWR VGND sg13cmos5l_decap_8
XFILLER_12_1621 VPWR VGND sg13cmos5l_decap_8
XFILLER_12_1698 VPWR VGND sg13cmos5l_decap_8
XANTENNA_2150 Tile_X0Y0_FrameData[9] VPWR VGND sg13cmos5l_antennanp
X_0515_ _0515_/Q Tile_X0Y0_FrameData[20] VGND VPWR Tile_X4Y0_FrameStrobe[0] latch
XANTENNA_2161 Tile_X0Y0_FrameData[9] VPWR VGND sg13cmos5l_antennanp
XANTENNA_2172 Tile_X0Y0_FrameData[9] VPWR VGND sg13cmos5l_antennanp
XANTENNA_2183 Tile_X0Y0_FrameData[9] VPWR VGND sg13cmos5l_antennanp
XANTENNA_2194 Tile_X0Y0_FrameData[9] VPWR VGND sg13cmos5l_antennanp
X_0446_ _0446_/Q Tile_X0Y0_FrameData[27] VGND VPWR Tile_X3Y0_FrameStrobe[1] latch
XANTENNA_1460 Tile_X0Y0_FrameData[31] VPWR VGND sg13cmos5l_antennanp
XANTENNA_1471 Tile_X0Y0_FrameData[31] VPWR VGND sg13cmos5l_antennanp
XANTENNA_1482 Tile_X0Y0_FrameData[31] VPWR VGND sg13cmos5l_antennanp
XFILLER_3_2534 VPWR VGND sg13cmos5l_fill_1
XFILLER_3_2523 VPWR VGND sg13cmos5l_fill_1
XANTENNA_1493 Tile_X0Y0_FrameData[3] VPWR VGND sg13cmos5l_antennanp
X_0377_ _0377_/Q Tile_X0Y0_FrameData[0] VGND VPWR Tile_X2Y0_FrameStrobe[1] latch
XFILLER_3_2556 VPWR VGND sg13cmos5l_decap_8
XFILLER_1_2291 VPWR VGND sg13cmos5l_decap_8
XANTENNA__1013__X Tile_X0Y0_S2BEGb[6] VPWR VGND sg13cmos5l_antennanp
XFILLER_13_14 VPWR VGND sg13cmos5l_decap_8
XANTENNA__0852__X Tile_X4Y0_FrameStrobe_O[9] VPWR VGND sg13cmos5l_antennanp
XFILLER_2_605 VPWR VGND sg13cmos5l_decap_8
XFILLER_11_1175 VPWR VGND sg13cmos5l_decap_8
XFILLER_8_2401 VPWR VGND sg13cmos5l_decap_8
XFILLER_8_7 VPWR VGND sg13cmos5l_decap_8
XFILLER_8_2478 VPWR VGND sg13cmos5l_decap_8
XFILLER_8_1755 VPWR VGND sg13cmos5l_decap_8
XANTENNA_302 Tile_X0Y0_FrameData[1] VPWR VGND sg13cmos5l_antennanp
XANTENNA_313 Tile_X0Y0_FrameData[1] VPWR VGND sg13cmos5l_antennanp
XANTENNA_324 Tile_X0Y0_FrameData[1] VPWR VGND sg13cmos5l_antennanp
XANTENNA_335 Tile_X0Y0_FrameData[1] VPWR VGND sg13cmos5l_antennanp
XANTENNA_346 Tile_X0Y0_FrameData[1] VPWR VGND sg13cmos5l_antennanp
XANTENNA_357 Tile_X0Y0_FrameData[1] VPWR VGND sg13cmos5l_antennanp
XANTENNA_368 Tile_X0Y0_FrameData[1] VPWR VGND sg13cmos5l_antennanp
XFILLER_14_723 VPWR VGND sg13cmos5l_decap_8
XANTENNA_379 Tile_X0Y0_FrameData[1] VPWR VGND sg13cmos5l_antennanp
XANTENNA__0762__X Tile_X3Y0_S1BEG[3] VPWR VGND sg13cmos5l_antennanp
XFILLER_13_2664 VPWR VGND sg13cmos5l_decap_8
XFILLER_9_2209 VPWR VGND sg13cmos5l_decap_8
X_0300_ _0300_/Q Tile_X0Y0_FrameData[29] VGND VPWR Tile_X1Y0_FrameStrobe[3] latch
X_1280_ _1280_/X Tile_X3Y0_N2END[5] Tile_X3Y0_N4END[5] Tile_X3Y0_NN4END[10] _0576_/Q
+ _0447_/Q _0446_/Q VPWR VGND sg13cmos5l_mux4_1
X_0231_ _0231_/Q Tile_X0Y0_FrameData[2] VGND VPWR Tile_X1Y0_FrameStrobe[0] latch
XFILLER_3_1107 VPWR VGND sg13cmos5l_fill_1
XANTENNA__0937__X Tile_X2Y0_FrameStrobe_O[2] VPWR VGND sg13cmos5l_antennanp
X_0162_ _0162_/Q Tile_X0Y0_FrameData[23] VGND VPWR Tile_X0Y0_FrameStrobe[2] latch
X_0093_ _0093_/Q Tile_X0Y0_FrameData[28] VGND VPWR Tile_X0Y0_FrameStrobe[0] latch
XANTENNA_880 Tile_X0Y0_FrameData[27] VPWR VGND sg13cmos5l_antennanp
XANTENNA_891 Tile_X0Y0_FrameData[27] VPWR VGND sg13cmos5l_antennanp
X_0995_ Tile_X0Y0_S4BEG[4] _1143_/X VPWR VGND sg13cmos5l_buf_1
XFILLER_12_2141 VPWR VGND sg13cmos5l_decap_8
XFILLER_9_2710 VPWR VGND sg13cmos5l_decap_8
XFILLER_12_1495 VPWR VGND sg13cmos5l_decap_8
XFILLER_5_70 VPWR VGND sg13cmos5l_decap_8
XANTENNA__1008__X Tile_X0Y0_S2BEGb[1] VPWR VGND sg13cmos5l_antennanp
XANTENNA_1290 Tile_X0Y0_FrameData[30] VPWR VGND sg13cmos5l_antennanp
X_0429_ _0429_/Q Tile_X0Y0_FrameData[12] VGND VPWR Tile_X3Y0_FrameStrobe[0] latch
XANTENNA__0847__X Tile_X4Y0_FrameStrobe_O[4] VPWR VGND sg13cmos5l_antennanp
XFILLER_3_2353 VPWR VGND sg13cmos5l_decap_8
XFILLER_3_1663 VPWR VGND sg13cmos5l_decap_8
XFILLER_11_726 VPWR VGND sg13cmos5l_decap_8
XFILLER_13_1248 VPWR VGND sg13cmos5l_decap_8
XANTENNA_3609 Tile_X0Y0_FrameData[8] VPWR VGND sg13cmos5l_antennanp
XANTENNA__0531__Q NPU_WDATA7 VPWR VGND sg13cmos5l_antennanp
XANTENNA_2908 Tile_X0Y0_FrameData[17] VPWR VGND sg13cmos5l_antennanp
XFILLER_2_402 VPWR VGND sg13cmos5l_fill_2
XANTENNA_2919 Tile_X0Y0_FrameData[17] VPWR VGND sg13cmos5l_antennanp
XFILLER_8_2253 VPWR VGND sg13cmos5l_decap_8
XFILLER_8_1563 VPWR VGND sg13cmos5l_decap_8
XFILLER_1_28 VPWR VGND sg13cmos5l_decap_8
XANTENNA__0757__X Tile_X1Y0_S2BEG[6] VPWR VGND sg13cmos5l_antennanp
XFILLER_2_1140 VPWR VGND sg13cmos5l_decap_8
XANTENNA_110 Tile_X0Y0_FrameData[0] VPWR VGND sg13cmos5l_antennanp
XANTENNA_121 Tile_X0Y0_FrameData[0] VPWR VGND sg13cmos5l_antennanp
XANTENNA_132 Tile_X0Y0_FrameData[0] VPWR VGND sg13cmos5l_antennanp
XANTENNA_143 Tile_X0Y0_FrameData[10] VPWR VGND sg13cmos5l_antennanp
XANTENNA_154 Tile_X0Y0_FrameData[10] VPWR VGND sg13cmos5l_antennanp
XANTENNA_165 Tile_X0Y0_FrameData[10] VPWR VGND sg13cmos5l_antennanp
XANTENNA_176 Tile_X0Y0_FrameData[10] VPWR VGND sg13cmos5l_antennanp
XANTENNA_187 Tile_X0Y0_FrameData[10] VPWR VGND sg13cmos5l_antennanp
XANTENNA_198 Tile_X0Y0_FrameData[10] VPWR VGND sg13cmos5l_antennanp
XFILLER_14_597 VPWR VGND sg13cmos5l_decap_8
X_0780_ Tile_X3Y0_S4BEG[1] _1260_/X VPWR VGND sg13cmos5l_buf_1
XFILLER_13_1782 VPWR VGND sg13cmos5l_decap_8
XFILLER_6_796 VPWR VGND sg13cmos5l_fill_1
XFILLER_5_251 VPWR VGND sg13cmos5l_fill_1
XFILLER_9_1349 VPWR VGND sg13cmos5l_fill_2
X_1263_ _1263_/X Tile_X3Y0_N2MID[4] Tile_X3Y0_N4END[11] Tile_X3Y0_NN4END[4] _0576_/Q
+ _0481_/Q _0480_/Q VPWR VGND sg13cmos5l_mux4_1
XFILLER_7_1051 VPWR VGND sg13cmos5l_fill_2
XFILLER_4_2640 VPWR VGND sg13cmos5l_decap_8
X_0214_ _0214_/Q Tile_X0Y0_FrameData[19] VGND VPWR Tile_X1Y0_FrameStrobe[0] latch
XFILLER_0_2515 VPWR VGND sg13cmos5l_decap_4
X_1194_ _1194_/X Tile_X1Y0_N2MID[7] Tile_X1Y0_N4END[0] Tile_X1Y0_NN4END[15] _0589_/Q
+ _0267_/Q _0266_/Q VPWR VGND sg13cmos5l_mux4_1
X_0145_ _0145_/Q Tile_X0Y0_FrameData[8] VGND VPWR Tile_X0Y0_FrameStrobe[1] latch
XFILLER_14_2258 VPWR VGND sg13cmos5l_decap_8
X_0978_ Tile_X0Y0_SS4BEG[3] _1158_/X VPWR VGND sg13cmos5l_buf_1
XFILLER_14_1557 VPWR VGND sg13cmos5l_decap_8
XFILLER_5_2459 VPWR VGND sg13cmos5l_decap_8
XFILLER_5_1758 VPWR VGND sg13cmos5l_decap_8
XANTENNA__0526__Q NPU_WDATA2 VPWR VGND sg13cmos5l_antennanp
XFILLER_11_545 VPWR VGND sg13cmos5l_decap_8
XFILLER_7_527 VPWR VGND sg13cmos5l_decap_8
XFILLER_13_1012 VPWR VGND sg13cmos5l_fill_2
XANTENNA_4107 Tile_X1Y0_N4END[13] VPWR VGND sg13cmos5l_antennanp
XANTENNA_4118 Tile_X1Y0_N4END[5] VPWR VGND sg13cmos5l_antennanp
XANTENNA_4129 Tile_X1Y0_NN4END[2] VPWR VGND sg13cmos5l_antennanp
XFILLER_10_2634 VPWR VGND sg13cmos5l_decap_8
XANTENNA_3406 Tile_X0Y0_FrameData[21] VPWR VGND sg13cmos5l_antennanp
XANTENNA_3417 Tile_X0Y0_FrameData[21] VPWR VGND sg13cmos5l_antennanp
XANTENNA_3428 Tile_X0Y0_FrameData[21] VPWR VGND sg13cmos5l_antennanp
XANTENNA_2705 Tile_X0Y0_FrameData[14] VPWR VGND sg13cmos5l_antennanp
XANTENNA_2716 Tile_X0Y0_FrameData[14] VPWR VGND sg13cmos5l_antennanp
XANTENNA_3439 Tile_X0Y0_FrameData[21] VPWR VGND sg13cmos5l_antennanp
XANTENNA_2727 Tile_X0Y0_FrameData[14] VPWR VGND sg13cmos5l_antennanp
XANTENNA_2738 Tile_X0Y0_FrameData[14] VPWR VGND sg13cmos5l_antennanp
XANTENNA_2749 Tile_X0Y0_FrameData[14] VPWR VGND sg13cmos5l_antennanp
XFILLER_1_2802 VPWR VGND sg13cmos5l_fill_1
X_0901_ Tile_X2Y0_SS4BEG[2] _1237_/X VPWR VGND sg13cmos5l_buf_1
XFILLER_15_2545 VPWR VGND sg13cmos5l_fill_2
XFILLER_15_1822 VPWR VGND sg13cmos5l_decap_8
X_0832_ Tile_X4Y0_FrameData_O[21] Tile_X0Y0_FrameData[21] VPWR VGND sg13cmos5l_buf_1
XANTENNA__0950__X Tile_X2Y0_FrameStrobe_O[15] VPWR VGND sg13cmos5l_antennanp
XFILLER_15_1899 VPWR VGND sg13cmos5l_decap_8
X_0763_ Tile_X3Y0_S2BEG[0] Tile_X3Y0_N2MID[7] VPWR VGND sg13cmos5l_buf_1
XFILLER_6_560 VPWR VGND sg13cmos5l_fill_1
XANTENNA_3940 Tile_X0Y0_FrameData[18] VPWR VGND sg13cmos5l_antennanp
X_0694_ Tile_X0Y0_FrameStrobe_O[7] Tile_X0Y0_FrameStrobe[7] VPWR VGND sg13cmos5l_buf_1
XFILLER_6_593 VPWR VGND sg13cmos5l_decap_8
XANTENNA_3951 Tile_X0Y0_FrameData[18] VPWR VGND sg13cmos5l_antennanp
XANTENNA_3962 Tile_X0Y0_FrameData[18] VPWR VGND sg13cmos5l_antennanp
XANTENNA_3973 Tile_X0Y0_FrameData[18] VPWR VGND sg13cmos5l_antennanp
XANTENNA_3984 Tile_X0Y0_FrameData[18] VPWR VGND sg13cmos5l_antennanp
XANTENNA_3995 Tile_X0Y0_FrameData[18] VPWR VGND sg13cmos5l_antennanp
XFILLER_6_2746 VPWR VGND sg13cmos5l_decap_8
X_1246_ _1246_/X Tile_X2Y0_N2END[3] Tile_X2Y0_N4END[11] Tile_X2Y0_NN4END[4] _0582_/Q
+ _0339_/Q _0338_/Q VPWR VGND sg13cmos5l_mux4_1
XFILLER_4_2492 VPWR VGND sg13cmos5l_decap_8
X_1177_ _1177_/X Tile_X1Y0_N1END[2] Tile_X1Y0_N2MID[6] Tile_X1Y0_N2END[1] _0594_/Q
+ _0301_/Q _0300_/Q VPWR VGND sg13cmos5l_mux4_1
X_0128_ _0128_/Q Tile_X0Y0_FrameData[25] VGND VPWR Tile_X0Y0_FrameStrobe[1] latch
XFILLER_0_2389 VPWR VGND sg13cmos5l_decap_4
XFILLER_14_2000 VPWR VGND sg13cmos5l_fill_2
XFILLER_0_1699 VPWR VGND sg13cmos5l_decap_8
XANTENNA__1021__X Tile_X0Y0_S2BEG[6] VPWR VGND sg13cmos5l_antennanp
XANTENNA_10 NPU_RDATA15 VPWR VGND sg13cmos5l_antennanp
XANTENNA_21 NPU_RDATA24 VPWR VGND sg13cmos5l_antennanp
XANTENNA_32 NPU_RDATA4 VPWR VGND sg13cmos5l_antennanp
XANTENNA_43 Tile_X0Y0_FrameData[0] VPWR VGND sg13cmos5l_antennanp
XFILLER_14_2055 VPWR VGND sg13cmos5l_decap_8
XANTENNA__0860__X Tile_X4Y0_FrameStrobe_O[17] VPWR VGND sg13cmos5l_antennanp
XANTENNA_65 Tile_X0Y0_FrameData[0] VPWR VGND sg13cmos5l_antennanp
XANTENNA_54 Tile_X0Y0_FrameData[0] VPWR VGND sg13cmos5l_antennanp
XANTENNA_98 Tile_X0Y0_FrameData[0] VPWR VGND sg13cmos5l_antennanp
XANTENNA_87 Tile_X0Y0_FrameData[0] VPWR VGND sg13cmos5l_antennanp
XANTENNA_76 Tile_X0Y0_FrameData[0] VPWR VGND sg13cmos5l_antennanp
XFILLER_10_1218 VPWR VGND sg13cmos5l_decap_4
XFILLER_5_2256 VPWR VGND sg13cmos5l_decap_8
XFILLER_16_648 VPWR VGND sg13cmos5l_decap_8
XFILLER_15_147 VPWR VGND sg13cmos5l_decap_8
XANTENNA__0770__X Tile_X3Y0_S2BEG[7] VPWR VGND sg13cmos5l_antennanp
XFILLER_7_49 VPWR VGND sg13cmos5l_decap_8
XANTENNA_3203 Tile_X0Y0_FrameData[20] VPWR VGND sg13cmos5l_antennanp
XFILLER_7_379 VPWR VGND sg13cmos5l_fill_2
XFILLER_10_2464 VPWR VGND sg13cmos5l_decap_8
XANTENNA_3214 Tile_X0Y0_FrameData[20] VPWR VGND sg13cmos5l_antennanp
XANTENNA_3225 Tile_X0Y0_FrameData[20] VPWR VGND sg13cmos5l_antennanp
XANTENNA_3236 Tile_X0Y0_FrameData[20] VPWR VGND sg13cmos5l_antennanp
XFILLER_10_1741 VPWR VGND sg13cmos5l_decap_8
XANTENNA_2502 Tile_X0Y0_FrameData[12] VPWR VGND sg13cmos5l_antennanp
XANTENNA_2513 Tile_X0Y0_FrameData[12] VPWR VGND sg13cmos5l_antennanp
XANTENNA_2524 Tile_X0Y0_FrameData[12] VPWR VGND sg13cmos5l_antennanp
XANTENNA_3247 Tile_X0Y0_FrameData[20] VPWR VGND sg13cmos5l_antennanp
XANTENNA_3258 Tile_X0Y0_FrameData[20] VPWR VGND sg13cmos5l_antennanp
XANTENNA_3269 Tile_X0Y0_FrameData[20] VPWR VGND sg13cmos5l_antennanp
XFILLER_10_1785 VPWR VGND sg13cmos5l_decap_8
XANTENNA_1801 Tile_X0Y0_FrameData[5] VPWR VGND sg13cmos5l_antennanp
XANTENNA_1812 Tile_X0Y0_FrameData[5] VPWR VGND sg13cmos5l_antennanp
XANTENNA_1823 Tile_X0Y0_FrameData[5] VPWR VGND sg13cmos5l_antennanp
XANTENNA_2535 Tile_X0Y0_FrameData[12] VPWR VGND sg13cmos5l_antennanp
XANTENNA_2546 Tile_X0Y0_FrameData[12] VPWR VGND sg13cmos5l_antennanp
XANTENNA_2557 Tile_X0Y0_FrameData[12] VPWR VGND sg13cmos5l_antennanp
XANTENNA_2568 Tile_X0Y0_FrameData[12] VPWR VGND sg13cmos5l_antennanp
XANTENNA_1834 Tile_X0Y0_FrameData[5] VPWR VGND sg13cmos5l_antennanp
XANTENNA_1845 Tile_X0Y0_FrameData[5] VPWR VGND sg13cmos5l_antennanp
XANTENNA_1856 Tile_X0Y0_FrameData[5] VPWR VGND sg13cmos5l_antennanp
XANTENNA_2579 Tile_X0Y0_FrameData[12] VPWR VGND sg13cmos5l_antennanp
XANTENNA_1867 Tile_X0Y0_FrameData[5] VPWR VGND sg13cmos5l_antennanp
XANTENNA_1878 Tile_X0Y0_FrameData[5] VPWR VGND sg13cmos5l_antennanp
XANTENNA_1889 Tile_X0Y0_FrameData[5] VPWR VGND sg13cmos5l_antennanp
X_1100_ _1100_/X Tile_X1Y0_N4END[4] Tile_X1Y0_N4END[5] Tile_X1Y0_NN4END[4] Tile_X1Y0_NN4END[6]
+ _0225_/Q _0224_/Q VPWR VGND sg13cmos5l_mux4_1
X_1031_ Tile_X4Y0_S2BEG[0] Tile_X4Y0_N2MID[7] VPWR VGND sg13cmos5l_buf_1
XFILLER_4_1076 VPWR VGND sg13cmos5l_fill_1
XANTENNA__0945__X Tile_X2Y0_FrameStrobe_O[10] VPWR VGND sg13cmos5l_antennanp
XFILLER_1_2698 VPWR VGND sg13cmos5l_fill_2
XFILLER_15_692 VPWR VGND sg13cmos5l_decap_8
X_0815_ Tile_X4Y0_FrameData_O[4] Tile_X0Y0_FrameData[4] VPWR VGND sg13cmos5l_buf_1
XFILLER_15_1696 VPWR VGND sg13cmos5l_decap_8
X_0746_ Tile_X1Y0_SS4BEG[15] _1210_/X VPWR VGND sg13cmos5l_buf_1
XANTENNA_3770 Tile_X0Y0_FrameData[18] VPWR VGND sg13cmos5l_antennanp
XANTENNA_3781 Tile_X0Y0_FrameData[18] VPWR VGND sg13cmos5l_antennanp
XANTENNA_3792 Tile_X0Y0_FrameData[18] VPWR VGND sg13cmos5l_antennanp
X_0677_ _0677_/L_HI VPWR VGND sg13cmos5l_tiehi
XFILLER_6_2543 VPWR VGND sg13cmos5l_fill_1
XANTENNA__1016__X Tile_X0Y0_S2BEG[1] VPWR VGND sg13cmos5l_antennanp
X_1229_ _1229_/X Tile_X2Y0_N2MID[2] Tile_X2Y0_N4END[5] Tile_X2Y0_NN4END[10] _0582_/Q
+ _0373_/Q _0372_/Q VPWR VGND sg13cmos5l_mux4_1
XANTENNA__0855__X Tile_X4Y0_FrameStrobe_O[12] VPWR VGND sg13cmos5l_antennanp
XFILLER_16_14 VPWR VGND sg13cmos5l_decap_8
XANTENNA_709 Tile_X0Y0_FrameData[25] VPWR VGND sg13cmos5l_antennanp
XFILLER_16_2106 VPWR VGND sg13cmos5l_decap_8
XFILLER_13_629 VPWR VGND sg13cmos5l_decap_8
XFILLER_12_106 VPWR VGND sg13cmos5l_decap_8
XFILLER_11_2751 VPWR VGND sg13cmos5l_decap_4
XFILLER_14_1195 VPWR VGND sg13cmos5l_decap_8
XANTENNA_1108 Tile_X0Y0_FrameData[2] VPWR VGND sg13cmos5l_antennanp
XANTENNA_1119 Tile_X0Y0_FrameData[2] VPWR VGND sg13cmos5l_antennanp
XFILLER_7_2318 VPWR VGND sg13cmos5l_decap_4
XFILLER_7_1617 VPWR VGND sg13cmos5l_decap_8
XFILLER_0_533 VPWR VGND sg13cmos5l_fill_2
XFILLER_0_577 VPWR VGND sg13cmos5l_decap_8
XANTENNA__0765__X Tile_X3Y0_S2BEG[2] VPWR VGND sg13cmos5l_antennanp
XFILLER_16_2662 VPWR VGND sg13cmos5l_decap_8
XFILLER_12_651 VPWR VGND sg13cmos5l_decap_8
XFILLER_8_633 VPWR VGND sg13cmos5l_decap_8
XFILLER_16_1972 VPWR VGND sg13cmos5l_decap_8
XFILLER_12_2526 VPWR VGND sg13cmos5l_fill_1
XFILLER_12_1803 VPWR VGND sg13cmos5l_decap_8
XFILLER_11_161 VPWR VGND sg13cmos5l_decap_8
XANTENNA_3000 Tile_X0Y0_FrameData[19] VPWR VGND sg13cmos5l_antennanp
XANTENNA_3011 Tile_X0Y0_FrameData[19] VPWR VGND sg13cmos5l_antennanp
X_0600_ _0600_/Q Tile_X0Y0_UserCLK NPU_RDATA28 _0616_/L_HI VPWR VGND sg13cmos5l_dfrbpq_1
XFILLER_10_2261 VPWR VGND sg13cmos5l_decap_8
XANTENNA_3022 Tile_X0Y0_FrameData[19] VPWR VGND sg13cmos5l_antennanp
XANTENNA_3033 Tile_X0Y0_FrameData[19] VPWR VGND sg13cmos5l_antennanp
XANTENNA_3044 Tile_X0Y0_FrameData[19] VPWR VGND sg13cmos5l_antennanp
X_0531_ NPU_WDATA7 Tile_X0Y0_UserCLK _1103_/X _0640_/L_HI VPWR VGND sg13cmos5l_dfrbpq_1
XANTENNA_2310 Tile_X0Y0_N4END[0] VPWR VGND sg13cmos5l_antennanp
XANTENNA_2321 Tile_X3Y0_NN4END[3] VPWR VGND sg13cmos5l_antennanp
XANTENNA_2332 Tile_X0Y0_FrameData[11] VPWR VGND sg13cmos5l_antennanp
XANTENNA_2343 Tile_X0Y0_FrameData[11] VPWR VGND sg13cmos5l_antennanp
XANTENNA_3055 Tile_X0Y0_FrameData[19] VPWR VGND sg13cmos5l_antennanp
XANTENNA_3066 Tile_X0Y0_FrameData[19] VPWR VGND sg13cmos5l_antennanp
XANTENNA_3077 Tile_X0Y0_FrameData[19] VPWR VGND sg13cmos5l_antennanp
XANTENNA_3088 Tile_X0Y0_FrameData[19] VPWR VGND sg13cmos5l_antennanp
XANTENNA_1620 Tile_X0Y0_FrameData[4] VPWR VGND sg13cmos5l_antennanp
XANTENNA_1631 Tile_X0Y0_FrameData[4] VPWR VGND sg13cmos5l_antennanp
XANTENNA_2354 Tile_X0Y0_FrameData[11] VPWR VGND sg13cmos5l_antennanp
XANTENNA_2365 Tile_X0Y0_FrameData[11] VPWR VGND sg13cmos5l_antennanp
XANTENNA_2376 Tile_X0Y0_FrameData[11] VPWR VGND sg13cmos5l_antennanp
XANTENNA_3099 Tile_X0Y0_FrameData[19] VPWR VGND sg13cmos5l_antennanp
X_0462_ _0462_/Q Tile_X0Y0_FrameData[11] VGND VPWR Tile_X3Y0_FrameStrobe[1] latch
XANTENNA_1642 Tile_X0Y0_FrameData[4] VPWR VGND sg13cmos5l_antennanp
XANTENNA_1653 Tile_X0Y0_FrameData[4] VPWR VGND sg13cmos5l_antennanp
XANTENNA_1664 Tile_X0Y0_FrameData[4] VPWR VGND sg13cmos5l_antennanp
XANTENNA_2387 Tile_X0Y0_FrameData[11] VPWR VGND sg13cmos5l_antennanp
XANTENNA_2398 Tile_X0Y0_FrameData[11] VPWR VGND sg13cmos5l_antennanp
X_0393_ _0393_/Q Tile_X0Y0_FrameData[16] VGND VPWR Tile_X2Y0_FrameStrobe[2] latch
XFILLER_6_1127 VPWR VGND sg13cmos5l_decap_8
XANTENNA_1675 Tile_X0Y0_FrameData[4] VPWR VGND sg13cmos5l_antennanp
XANTENNA_1686 Tile_X0Y0_FrameData[4] VPWR VGND sg13cmos5l_antennanp
XANTENNA_1697 Tile_X0Y0_FrameData[4] VPWR VGND sg13cmos5l_antennanp
XFILLER_3_2738 VPWR VGND sg13cmos5l_decap_8
X_1014_ Tile_X0Y0_S2BEGb[7] _1138_/X VPWR VGND sg13cmos5l_buf_1
XFILLER_8_70 VPWR VGND sg13cmos5l_decap_8
X_0729_ Tile_X1Y0_S4BEG[14] _1193_/X VPWR VGND sg13cmos5l_buf_1
XFILLER_6_2395 VPWR VGND sg13cmos5l_decap_8
XFILLER_6_1650 VPWR VGND sg13cmos5l_decap_8
XANTENNA_517 Tile_X0Y0_FrameData[23] VPWR VGND sg13cmos5l_antennanp
XANTENNA_506 Tile_X0Y0_FrameData[23] VPWR VGND sg13cmos5l_antennanp
XANTENNA_539 Tile_X0Y0_FrameData[23] VPWR VGND sg13cmos5l_antennanp
XANTENNA_528 Tile_X0Y0_FrameData[23] VPWR VGND sg13cmos5l_antennanp
XFILLER_13_437 VPWR VGND sg13cmos5l_fill_1
XFILLER_16_1235 VPWR VGND sg13cmos5l_decap_8
XANTENNA__0534__Q NPU_WDATA10 VPWR VGND sg13cmos5l_antennanp
XFILLER_4_146 VPWR VGND sg13cmos5l_fill_2
XFILLER_4_28 VPWR VGND sg13cmos5l_decap_8
XFILLER_7_1436 VPWR VGND sg13cmos5l_fill_2
XFILLER_0_363 VPWR VGND sg13cmos5l_fill_1
XFILLER_5_1171 VPWR VGND sg13cmos5l_decap_8
XFILLER_12_2323 VPWR VGND sg13cmos5l_decap_8
XFILLER_16_1791 VPWR VGND sg13cmos5l_decap_8
XFILLER_12_1600 VPWR VGND sg13cmos5l_decap_8
XFILLER_12_1677 VPWR VGND sg13cmos5l_decap_8
XANTENNA_2140 Tile_X0Y0_FrameData[9] VPWR VGND sg13cmos5l_antennanp
XANTENNA_2151 Tile_X0Y0_FrameData[9] VPWR VGND sg13cmos5l_antennanp
X_0514_ _0514_/Q Tile_X0Y0_FrameData[19] VGND VPWR Tile_X4Y0_FrameStrobe[0] latch
XANTENNA_2162 Tile_X0Y0_FrameData[9] VPWR VGND sg13cmos5l_antennanp
XANTENNA_2173 Tile_X0Y0_FrameData[9] VPWR VGND sg13cmos5l_antennanp
XANTENNA_2184 Tile_X0Y0_FrameData[9] VPWR VGND sg13cmos5l_antennanp
X_0445_ _0445_/Q Tile_X0Y0_FrameData[28] VGND VPWR Tile_X3Y0_FrameStrobe[1] latch
XANTENNA_1450 Tile_X0Y0_FrameData[31] VPWR VGND sg13cmos5l_antennanp
XANTENNA_1461 Tile_X0Y0_FrameData[31] VPWR VGND sg13cmos5l_antennanp
XANTENNA_1472 Tile_X0Y0_FrameData[31] VPWR VGND sg13cmos5l_antennanp
XANTENNA_1483 Tile_X0Y0_FrameData[31] VPWR VGND sg13cmos5l_antennanp
XANTENNA_2195 Tile_X0Y0_FrameData[9] VPWR VGND sg13cmos5l_antennanp
XFILLER_7_2693 VPWR VGND sg13cmos5l_decap_8
XFILLER_3_2502 VPWR VGND sg13cmos5l_decap_4
XANTENNA_1494 Tile_X0Y0_FrameData[3] VPWR VGND sg13cmos5l_antennanp
X_0376_ _0376_/Q Tile_X0Y0_FrameData[1] VGND VPWR Tile_X2Y0_FrameStrobe[1] latch
XFILLER_12_0 VPWR VGND sg13cmos5l_decap_8
XFILLER_15_1290 VPWR VGND sg13cmos5l_decap_8
XFILLER_11_1154 VPWR VGND sg13cmos5l_decap_8
XFILLER_8_2457 VPWR VGND sg13cmos5l_decap_8
XFILLER_8_1734 VPWR VGND sg13cmos5l_decap_8
XANTENNA__0529__Q NPU_WDATA5 VPWR VGND sg13cmos5l_antennanp
XANTENNA_303 Tile_X0Y0_FrameData[1] VPWR VGND sg13cmos5l_antennanp
XANTENNA_314 Tile_X0Y0_FrameData[1] VPWR VGND sg13cmos5l_antennanp
XANTENNA_325 Tile_X0Y0_FrameData[1] VPWR VGND sg13cmos5l_antennanp
XANTENNA_336 Tile_X0Y0_FrameData[1] VPWR VGND sg13cmos5l_antennanp
XANTENNA_347 Tile_X0Y0_FrameData[1] VPWR VGND sg13cmos5l_antennanp
XANTENNA_358 Tile_X0Y0_FrameData[1] VPWR VGND sg13cmos5l_antennanp
XFILLER_14_702 VPWR VGND sg13cmos5l_decap_8
XANTENNA_369 Tile_X0Y0_FrameData[1] VPWR VGND sg13cmos5l_antennanp
XFILLER_14_779 VPWR VGND sg13cmos5l_decap_8
XFILLER_13_2643 VPWR VGND sg13cmos5l_decap_8
XFILLER_6_978 VPWR VGND sg13cmos5l_fill_2
XFILLER_6_967 VPWR VGND sg13cmos5l_fill_1
X_0230_ _0230_/Q Tile_X0Y0_FrameData[3] VGND VPWR Tile_X1Y0_FrameStrobe[0] latch
XFILLER_0_182 VPWR VGND sg13cmos5l_fill_2
X_0161_ _0161_/Q Tile_X0Y0_FrameData[24] VGND VPWR Tile_X0Y0_FrameStrobe[2] latch
XFILLER_0_2719 VPWR VGND sg13cmos5l_decap_4
X_0092_ _0092_/Q Tile_X0Y0_FrameData[29] VGND VPWR Tile_X0Y0_FrameStrobe[0] latch
XANTENNA__0953__X Tile_X2Y0_FrameStrobe_O[18] VPWR VGND sg13cmos5l_antennanp
XANTENNA_881 Tile_X0Y0_FrameData[27] VPWR VGND sg13cmos5l_antennanp
XANTENNA_870 Tile_X0Y0_FrameData[27] VPWR VGND sg13cmos5l_antennanp
XANTENNA_892 Tile_X0Y0_FrameData[27] VPWR VGND sg13cmos5l_antennanp
XFILLER_14_2429 VPWR VGND sg13cmos5l_decap_8
XFILLER_9_761 VPWR VGND sg13cmos5l_fill_1
X_0994_ Tile_X0Y0_S4BEG[3] _1142_/X VPWR VGND sg13cmos5l_buf_1
XFILLER_14_1739 VPWR VGND sg13cmos5l_decap_8
XFILLER_13_790 VPWR VGND sg13cmos5l_decap_8
XFILLER_12_2120 VPWR VGND sg13cmos5l_decap_8
XFILLER_12_2197 VPWR VGND sg13cmos5l_decap_8
XANTENNA_1280 Tile_X0Y0_FrameData[30] VPWR VGND sg13cmos5l_antennanp
XANTENNA_1291 Tile_X0Y0_FrameData[30] VPWR VGND sg13cmos5l_antennanp
X_0428_ _0428_/Q Tile_X0Y0_FrameData[13] VGND VPWR Tile_X3Y0_FrameStrobe[0] latch
XFILLER_3_2332 VPWR VGND sg13cmos5l_decap_8
X_0359_ _0359_/Q Tile_X0Y0_FrameData[18] VGND VPWR Tile_X2Y0_FrameStrobe[1] latch
XFILLER_3_1642 VPWR VGND sg13cmos5l_decap_8
XANTENNA__1024__X Tile_X0Y0_S1BEG[1] VPWR VGND sg13cmos5l_antennanp
XANTENNA__0863__X Tile_X2Y0_S1BEG[0] VPWR VGND sg13cmos5l_antennanp
XFILLER_11_705 VPWR VGND sg13cmos5l_decap_8
XFILLER_13_1227 VPWR VGND sg13cmos5l_decap_8
XANTENNA_2909 Tile_X0Y0_FrameData[17] VPWR VGND sg13cmos5l_antennanp
XFILLER_8_2210 VPWR VGND sg13cmos5l_decap_8
XFILLER_4_2129 VPWR VGND sg13cmos5l_fill_1
XANTENNA_100 Tile_X0Y0_FrameData[0] VPWR VGND sg13cmos5l_antennanp
XANTENNA_111 Tile_X0Y0_FrameData[0] VPWR VGND sg13cmos5l_antennanp
XANTENNA_122 Tile_X0Y0_FrameData[0] VPWR VGND sg13cmos5l_antennanp
XANTENNA_133 Tile_X0Y0_FrameData[0] VPWR VGND sg13cmos5l_antennanp
XANTENNA_144 Tile_X0Y0_FrameData[10] VPWR VGND sg13cmos5l_antennanp
XANTENNA_155 Tile_X0Y0_FrameData[10] VPWR VGND sg13cmos5l_antennanp
XANTENNA_166 Tile_X0Y0_FrameData[10] VPWR VGND sg13cmos5l_antennanp
XFILLER_14_532 VPWR VGND sg13cmos5l_fill_1
XANTENNA__0773__X Tile_X3Y0_S2BEGb[2] VPWR VGND sg13cmos5l_antennanp
XANTENNA_177 Tile_X0Y0_FrameData[10] VPWR VGND sg13cmos5l_antennanp
XANTENNA_188 Tile_X0Y0_FrameData[10] VPWR VGND sg13cmos5l_antennanp
XANTENNA_199 Tile_X0Y0_FrameData[10] VPWR VGND sg13cmos5l_antennanp
XFILLER_14_543 VPWR VGND sg13cmos5l_decap_8
XFILLER_15_2738 VPWR VGND sg13cmos5l_fill_1
XFILLER_14_576 VPWR VGND sg13cmos5l_decap_8
XFILLER_14_91 VPWR VGND sg13cmos5l_decap_8
XFILLER_13_2484 VPWR VGND sg13cmos5l_decap_8
XFILLER_13_1761 VPWR VGND sg13cmos5l_decap_8
XANTENNA__0948__X Tile_X2Y0_FrameStrobe_O[13] VPWR VGND sg13cmos5l_antennanp
X_1262_ _1262_/X Tile_X3Y0_N2MID[3] Tile_X3Y0_N4END[12] Tile_X3Y0_NN4END[3] _0579_/Q
+ _0483_/Q _0482_/Q VPWR VGND sg13cmos5l_mux4_1
X_0213_ _0213_/Q Tile_X0Y0_FrameData[20] VGND VPWR Tile_X1Y0_FrameStrobe[0] latch
X_1193_ _1193_/X Tile_X1Y0_N2MID[6] Tile_X1Y0_N4END[1] Tile_X1Y0_NN4END[14] _0588_/Q
+ _0269_/Q _0268_/Q VPWR VGND sg13cmos5l_mux4_1
XFILLER_4_2696 VPWR VGND sg13cmos5l_decap_8
X_0144_ _0144_/Q Tile_X0Y0_FrameData[9] VGND VPWR Tile_X0Y0_FrameStrobe[1] latch
XFILLER_14_2237 VPWR VGND sg13cmos5l_decap_8
X_0977_ Tile_X0Y0_SS4BEG[2] _1157_/X VPWR VGND sg13cmos5l_buf_1
XFILLER_14_1536 VPWR VGND sg13cmos5l_decap_8
XFILLER_10_49 VPWR VGND sg13cmos5l_decap_8
XANTENNA__1019__X Tile_X0Y0_S2BEG[4] VPWR VGND sg13cmos5l_antennanp
XFILLER_0_929 VPWR VGND sg13cmos5l_fill_1
XANTENNA__0858__X Tile_X4Y0_FrameStrobe_O[15] VPWR VGND sg13cmos5l_antennanp
XFILLER_5_2438 VPWR VGND sg13cmos5l_decap_8
XFILLER_5_1737 VPWR VGND sg13cmos5l_decap_8
XFILLER_16_819 VPWR VGND sg13cmos5l_fill_1
XFILLER_11_524 VPWR VGND sg13cmos5l_decap_8
XFILLER_7_506 VPWR VGND sg13cmos5l_decap_8
XFILLER_13_1035 VPWR VGND sg13cmos5l_decap_8
XFILLER_10_2613 VPWR VGND sg13cmos5l_decap_8
XANTENNA__0542__Q NPU_WDATA18 VPWR VGND sg13cmos5l_antennanp
XANTENNA_4108 Tile_X1Y0_N4END[13] VPWR VGND sg13cmos5l_antennanp
XANTENNA_4119 Tile_X1Y0_N4END[5] VPWR VGND sg13cmos5l_antennanp
XANTENNA_3407 Tile_X0Y0_FrameData[21] VPWR VGND sg13cmos5l_antennanp
XANTENNA_3418 Tile_X0Y0_FrameData[21] VPWR VGND sg13cmos5l_antennanp
XANTENNA_2706 Tile_X0Y0_FrameData[14] VPWR VGND sg13cmos5l_antennanp
XANTENNA_2717 Tile_X0Y0_FrameData[14] VPWR VGND sg13cmos5l_antennanp
XANTENNA_3429 Tile_X0Y0_FrameData[21] VPWR VGND sg13cmos5l_antennanp
XANTENNA_2728 Tile_X0Y0_FrameData[14] VPWR VGND sg13cmos5l_antennanp
XANTENNA_2739 Tile_X0Y0_FrameData[14] VPWR VGND sg13cmos5l_antennanp
XANTENNA__0768__X Tile_X3Y0_S2BEG[5] VPWR VGND sg13cmos5l_antennanp
XFILLER_8_1383 VPWR VGND sg13cmos5l_fill_1
X_0900_ Tile_X2Y0_SS4BEG[1] _1236_/X VPWR VGND sg13cmos5l_buf_1
XFILLER_15_2524 VPWR VGND sg13cmos5l_decap_8
XFILLER_14_351 VPWR VGND sg13cmos5l_fill_1
XFILLER_15_1801 VPWR VGND sg13cmos5l_decap_8
XFILLER_14_395 VPWR VGND sg13cmos5l_fill_1
X_0831_ Tile_X4Y0_FrameData_O[20] Tile_X0Y0_FrameData[20] VPWR VGND sg13cmos5l_buf_1
XFILLER_15_2579 VPWR VGND sg13cmos5l_fill_2
X_0762_ Tile_X3Y0_S1BEG[3] Tile_X3Y0_N1END[0] VPWR VGND sg13cmos5l_buf_1
XFILLER_15_1878 VPWR VGND sg13cmos5l_decap_8
XFILLER_13_2281 VPWR VGND sg13cmos5l_decap_8
XFILLER_6_572 VPWR VGND sg13cmos5l_decap_8
XANTENNA_3930 Tile_X0Y0_FrameData[18] VPWR VGND sg13cmos5l_antennanp
XANTENNA_3941 Tile_X0Y0_FrameData[18] VPWR VGND sg13cmos5l_antennanp
X_0693_ Tile_X0Y0_FrameStrobe_O[6] Tile_X0Y0_FrameStrobe[6] VPWR VGND sg13cmos5l_buf_1
XANTENNA_3952 Tile_X0Y0_FrameData[18] VPWR VGND sg13cmos5l_antennanp
XANTENNA_3963 Tile_X0Y0_FrameData[18] VPWR VGND sg13cmos5l_antennanp
XANTENNA_3974 Tile_X0Y0_FrameData[18] VPWR VGND sg13cmos5l_antennanp
XANTENNA_3985 Tile_X0Y0_FrameData[18] VPWR VGND sg13cmos5l_antennanp
XANTENNA_3996 Tile_X0Y0_FrameData[18] VPWR VGND sg13cmos5l_antennanp
XFILLER_6_2725 VPWR VGND sg13cmos5l_decap_8
XFILLER_9_1169 VPWR VGND sg13cmos5l_decap_8
X_1245_ _1245_/X Tile_X2Y0_N2END[2] Tile_X2Y0_N4END[10] Tile_X2Y0_NN4END[5] _0583_/Q
+ _0341_/Q _0340_/Q VPWR VGND sg13cmos5l_mux4_1
XFILLER_4_2471 VPWR VGND sg13cmos5l_decap_8
XFILLER_0_2302 VPWR VGND sg13cmos5l_decap_4
X_1176_ _1176_/X Tile_X1Y0_N1END[1] Tile_X1Y0_N2MID[5] Tile_X1Y0_N2END[2] _0593_/Q
+ _0303_/Q _0302_/Q VPWR VGND sg13cmos5l_mux4_1
X_0127_ _0127_/Q Tile_X0Y0_FrameData[26] VGND VPWR Tile_X0Y0_FrameStrobe[1] latch
XFILLER_0_1678 VPWR VGND sg13cmos5l_decap_8
XANTENNA_11 NPU_RDATA16 VPWR VGND sg13cmos5l_antennanp
XANTENNA_22 NPU_RDATA25 VPWR VGND sg13cmos5l_antennanp
XFILLER_14_2034 VPWR VGND sg13cmos5l_decap_8
XFILLER_14_1300 VPWR VGND sg13cmos5l_decap_8
XANTENNA_33 NPU_RDATA6 VPWR VGND sg13cmos5l_antennanp
XANTENNA_44 Tile_X0Y0_FrameData[0] VPWR VGND sg13cmos5l_antennanp
XANTENNA_66 Tile_X0Y0_FrameData[0] VPWR VGND sg13cmos5l_antennanp
XANTENNA_55 Tile_X0Y0_FrameData[0] VPWR VGND sg13cmos5l_antennanp
XANTENNA_99 Tile_X0Y0_FrameData[0] VPWR VGND sg13cmos5l_antennanp
XANTENNA_88 Tile_X0Y0_FrameData[0] VPWR VGND sg13cmos5l_antennanp
XANTENNA_77 Tile_X0Y0_FrameData[0] VPWR VGND sg13cmos5l_antennanp
XFILLER_9_2393 VPWR VGND sg13cmos5l_decap_8
XFILLER_5_2235 VPWR VGND sg13cmos5l_decap_8
XANTENNA__0537__Q NPU_WDATA13 VPWR VGND sg13cmos5l_antennanp
XFILLER_16_627 VPWR VGND sg13cmos5l_decap_8
XFILLER_15_126 VPWR VGND sg13cmos5l_decap_8
XFILLER_7_28 VPWR VGND sg13cmos5l_decap_8
XFILLER_10_2443 VPWR VGND sg13cmos5l_decap_8
XFILLER_10_1720 VPWR VGND sg13cmos5l_decap_8
XANTENNA_3204 Tile_X0Y0_FrameData[20] VPWR VGND sg13cmos5l_antennanp
XANTENNA_3215 Tile_X0Y0_FrameData[20] VPWR VGND sg13cmos5l_antennanp
XANTENNA_3226 Tile_X0Y0_FrameData[20] VPWR VGND sg13cmos5l_antennanp
XANTENNA_3237 Tile_X0Y0_FrameData[20] VPWR VGND sg13cmos5l_antennanp
XANTENNA_2503 Tile_X0Y0_FrameData[12] VPWR VGND sg13cmos5l_antennanp
XANTENNA_2514 Tile_X0Y0_FrameData[12] VPWR VGND sg13cmos5l_antennanp
XANTENNA_2525 Tile_X0Y0_FrameData[12] VPWR VGND sg13cmos5l_antennanp
XANTENNA_3248 Tile_X0Y0_FrameData[20] VPWR VGND sg13cmos5l_antennanp
XANTENNA_3259 Tile_X0Y0_FrameData[20] VPWR VGND sg13cmos5l_antennanp
XFILLER_11_81 VPWR VGND sg13cmos5l_decap_8
XANTENNA_1802 Tile_X0Y0_FrameData[5] VPWR VGND sg13cmos5l_antennanp
XANTENNA_1813 Tile_X0Y0_FrameData[5] VPWR VGND sg13cmos5l_antennanp
XANTENNA_2536 Tile_X0Y0_FrameData[12] VPWR VGND sg13cmos5l_antennanp
XANTENNA_2547 Tile_X0Y0_FrameData[12] VPWR VGND sg13cmos5l_antennanp
XANTENNA_2558 Tile_X0Y0_FrameData[12] VPWR VGND sg13cmos5l_antennanp
XFILLER_3_586 VPWR VGND sg13cmos5l_decap_8
XANTENNA_1824 Tile_X0Y0_FrameData[5] VPWR VGND sg13cmos5l_antennanp
XANTENNA_1835 Tile_X0Y0_FrameData[5] VPWR VGND sg13cmos5l_antennanp
XANTENNA_1846 Tile_X0Y0_FrameData[5] VPWR VGND sg13cmos5l_antennanp
XANTENNA_1857 Tile_X0Y0_FrameData[5] VPWR VGND sg13cmos5l_antennanp
XANTENNA_2569 Tile_X0Y0_FrameData[12] VPWR VGND sg13cmos5l_antennanp
XANTENNA_1868 Tile_X0Y0_FrameData[5] VPWR VGND sg13cmos5l_antennanp
XANTENNA_1879 Tile_X0Y0_FrameData[5] VPWR VGND sg13cmos5l_antennanp
XFILLER_16_7 VPWR VGND sg13cmos5l_decap_8
X_1030_ Tile_X4Y0_S1BEG[3] Tile_X4Y0_N1END[0] VPWR VGND sg13cmos5l_buf_1
XFILLER_1_2666 VPWR VGND sg13cmos5l_fill_2
XFILLER_1_2688 VPWR VGND sg13cmos5l_fill_2
XFILLER_15_671 VPWR VGND sg13cmos5l_decap_8
XFILLER_15_2310 VPWR VGND sg13cmos5l_decap_8
XANTENNA__0961__X Tile_X1Y0_FrameStrobe_O[6] VPWR VGND sg13cmos5l_antennanp
X_0814_ Tile_X4Y0_FrameData_O[3] Tile_X0Y0_FrameData[3] VPWR VGND sg13cmos5l_buf_1
XFILLER_15_2398 VPWR VGND sg13cmos5l_decap_8
XFILLER_15_1675 VPWR VGND sg13cmos5l_decap_8
X_0745_ Tile_X1Y0_SS4BEG[14] _1209_/X VPWR VGND sg13cmos5l_buf_1
X_0676_ _0676_/L_HI VPWR VGND sg13cmos5l_tiehi
XANTENNA_3760 Tile_X3Y0_N4END[8] VPWR VGND sg13cmos5l_antennanp
XANTENNA_3771 Tile_X0Y0_FrameData[18] VPWR VGND sg13cmos5l_antennanp
XANTENNA_3782 Tile_X0Y0_FrameData[18] VPWR VGND sg13cmos5l_antennanp
XANTENNA_3793 Tile_X0Y0_FrameData[18] VPWR VGND sg13cmos5l_antennanp
XFILLER_6_2522 VPWR VGND sg13cmos5l_decap_8
XFILLER_6_2599 VPWR VGND sg13cmos5l_decap_8
X_1228_ _1228_/X Tile_X2Y0_N2MID[1] Tile_X2Y0_N4END[6] Tile_X2Y0_NN4END[9] _0583_/Q
+ _0375_/Q _0374_/Q VPWR VGND sg13cmos5l_mux4_1
XFILLER_4_2290 VPWR VGND sg13cmos5l_decap_8
X_1159_ _1159_/X Tile_X0Y0_N2END[4] Tile_X0Y0_N4END[4] Tile_X0Y0_NN4END[11] _0601_/Q
+ _0145_/Q _0144_/Q VPWR VGND sg13cmos5l_mux4_1
XFILLER_13_608 VPWR VGND sg13cmos5l_decap_8
XANTENNA__1032__X Tile_X4Y0_S2BEG[1] VPWR VGND sg13cmos5l_antennanp
XFILLER_0_1497 VPWR VGND sg13cmos5l_fill_2
XANTENNA__0871__X Tile_X2Y0_S2BEG[4] VPWR VGND sg13cmos5l_antennanp
XFILLER_11_2730 VPWR VGND sg13cmos5l_decap_8
XFILLER_14_1174 VPWR VGND sg13cmos5l_decap_8
XFILLER_14_1152 VPWR VGND sg13cmos5l_decap_4
XANTENNA_1109 Tile_X0Y0_FrameData[2] VPWR VGND sg13cmos5l_antennanp
XFILLER_0_556 VPWR VGND sg13cmos5l_decap_8
XFILLER_16_2641 VPWR VGND sg13cmos5l_decap_8
XANTENNA__0781__X Tile_X3Y0_S4BEG[2] VPWR VGND sg13cmos5l_antennanp
XFILLER_8_612 VPWR VGND sg13cmos5l_decap_8
XFILLER_12_2505 VPWR VGND sg13cmos5l_decap_8
XFILLER_11_140 VPWR VGND sg13cmos5l_decap_8
XFILLER_8_689 VPWR VGND sg13cmos5l_decap_8
XFILLER_10_2240 VPWR VGND sg13cmos5l_decap_8
XANTENNA_3001 Tile_X0Y0_FrameData[19] VPWR VGND sg13cmos5l_antennanp
XANTENNA_2300 Tile_X0Y0_N4END[0] VPWR VGND sg13cmos5l_antennanp
XANTENNA_3012 Tile_X0Y0_FrameData[19] VPWR VGND sg13cmos5l_antennanp
XANTENNA_3023 Tile_X0Y0_FrameData[19] VPWR VGND sg13cmos5l_antennanp
XANTENNA_3034 Tile_X0Y0_FrameData[19] VPWR VGND sg13cmos5l_antennanp
XANTENNA_3045 Tile_X0Y0_FrameData[19] VPWR VGND sg13cmos5l_antennanp
X_0530_ NPU_WDATA6 Tile_X0Y0_UserCLK _1102_/X _0641_/L_HI VPWR VGND sg13cmos5l_dfrbpq_1
XANTENNA_2311 Tile_X0Y0_N4END[0] VPWR VGND sg13cmos5l_antennanp
XANTENNA_2322 Tile_X3Y0_NN4END[3] VPWR VGND sg13cmos5l_antennanp
XANTENNA_2333 Tile_X0Y0_FrameData[11] VPWR VGND sg13cmos5l_antennanp
XANTENNA_3056 Tile_X0Y0_FrameData[19] VPWR VGND sg13cmos5l_antennanp
XANTENNA_3067 Tile_X0Y0_FrameData[19] VPWR VGND sg13cmos5l_antennanp
XANTENNA_3078 Tile_X0Y0_FrameData[19] VPWR VGND sg13cmos5l_antennanp
XFILLER_4_873 VPWR VGND sg13cmos5l_fill_2
XFILLER_10_1594 VPWR VGND sg13cmos5l_decap_8
XANTENNA_1610 Tile_X0Y0_FrameData[4] VPWR VGND sg13cmos5l_antennanp
XANTENNA_1621 Tile_X0Y0_FrameData[4] VPWR VGND sg13cmos5l_antennanp
XANTENNA_1632 Tile_X0Y0_FrameData[4] VPWR VGND sg13cmos5l_antennanp
XANTENNA_2344 Tile_X0Y0_FrameData[11] VPWR VGND sg13cmos5l_antennanp
XANTENNA_2355 Tile_X0Y0_FrameData[11] VPWR VGND sg13cmos5l_antennanp
XANTENNA_2366 Tile_X0Y0_FrameData[11] VPWR VGND sg13cmos5l_antennanp
XANTENNA_3089 Tile_X0Y0_FrameData[19] VPWR VGND sg13cmos5l_antennanp
X_0461_ _0461_/Q Tile_X0Y0_FrameData[12] VGND VPWR Tile_X3Y0_FrameStrobe[1] latch
XANTENNA_1643 Tile_X0Y0_FrameData[4] VPWR VGND sg13cmos5l_antennanp
XANTENNA_1654 Tile_X0Y0_FrameData[4] VPWR VGND sg13cmos5l_antennanp
XANTENNA_1665 Tile_X0Y0_FrameData[4] VPWR VGND sg13cmos5l_antennanp
XANTENNA_2377 Tile_X0Y0_FrameData[11] VPWR VGND sg13cmos5l_antennanp
XANTENNA_2388 Tile_X0Y0_FrameData[11] VPWR VGND sg13cmos5l_antennanp
XANTENNA_2399 Tile_X0Y0_FrameData[11] VPWR VGND sg13cmos5l_antennanp
X_0392_ _0392_/Q Tile_X0Y0_FrameData[17] VGND VPWR Tile_X2Y0_FrameStrobe[2] latch
XFILLER_6_1106 VPWR VGND sg13cmos5l_decap_8
XFILLER_3_2717 VPWR VGND sg13cmos5l_decap_8
XANTENNA_1676 Tile_X0Y0_FrameData[4] VPWR VGND sg13cmos5l_antennanp
XANTENNA_1687 Tile_X0Y0_FrameData[4] VPWR VGND sg13cmos5l_antennanp
XANTENNA_1698 Tile_X0Y0_FrameData[4] VPWR VGND sg13cmos5l_antennanp
XANTENNA__0956__X Tile_X1Y0_FrameStrobe_O[1] VPWR VGND sg13cmos5l_antennanp
X_1013_ Tile_X0Y0_S2BEGb[6] _1137_/X VPWR VGND sg13cmos5l_buf_1
XFILLER_1_2485 VPWR VGND sg13cmos5l_decap_8
XANTENNA__0691__X Tile_X0Y0_FrameStrobe_O[4] VPWR VGND sg13cmos5l_antennanp
XFILLER_15_2184 VPWR VGND sg13cmos5l_decap_8
X_0728_ Tile_X1Y0_S4BEG[13] _1192_/X VPWR VGND sg13cmos5l_buf_1
XANTENNA_3590 Tile_X0Y0_FrameData[8] VPWR VGND sg13cmos5l_antennanp
X_0659_ _0659_/L_HI VPWR VGND sg13cmos5l_tiehi
XANTENNA__1027__X Tile_X4Y0_S1BEG[0] VPWR VGND sg13cmos5l_antennanp
XFILLER_6_2341 VPWR VGND sg13cmos5l_decap_8
XFILLER_6_2374 VPWR VGND sg13cmos5l_decap_8
XFILLER_2_2216 VPWR VGND sg13cmos5l_fill_2
XANTENNA__0866__X Tile_X2Y0_S1BEG[3] VPWR VGND sg13cmos5l_antennanp
XFILLER_2_2249 VPWR VGND sg13cmos5l_decap_8
XANTENNA_507 Tile_X0Y0_FrameData[23] VPWR VGND sg13cmos5l_antennanp
XANTENNA_529 Tile_X0Y0_FrameData[23] VPWR VGND sg13cmos5l_antennanp
XANTENNA_518 Tile_X0Y0_FrameData[23] VPWR VGND sg13cmos5l_antennanp
XFILLER_16_1269 VPWR VGND sg13cmos5l_decap_8
XFILLER_5_648 VPWR VGND sg13cmos5l_decap_4
XANTENNA__0550__Q NPU_WDATA26 VPWR VGND sg13cmos5l_antennanp
XFILLER_7_1448 VPWR VGND sg13cmos5l_fill_1
XANTENNA__0776__X Tile_X3Y0_S2BEGb[5] VPWR VGND sg13cmos5l_antennanp
XFILLER_5_1150 VPWR VGND sg13cmos5l_decap_8
XFILLER_16_221 VPWR VGND sg13cmos5l_decap_8
XFILLER_16_210 VPWR VGND sg13cmos5l_fill_1
XFILLER_16_2493 VPWR VGND sg13cmos5l_decap_8
XFILLER_12_2302 VPWR VGND sg13cmos5l_decap_8
XFILLER_16_1770 VPWR VGND sg13cmos5l_decap_8
XFILLER_12_2379 VPWR VGND sg13cmos5l_decap_8
XFILLER_12_1656 VPWR VGND sg13cmos5l_decap_8
XANTENNA_2130 Tile_X0Y0_FrameData[9] VPWR VGND sg13cmos5l_antennanp
XANTENNA_2141 Tile_X0Y0_FrameData[9] VPWR VGND sg13cmos5l_antennanp
X_0513_ _0513_/Q Tile_X0Y0_FrameData[18] VGND VPWR Tile_X4Y0_FrameStrobe[0] latch
XANTENNA_1440 Tile_X0Y0_FrameData[31] VPWR VGND sg13cmos5l_antennanp
XANTENNA_2152 Tile_X0Y0_FrameData[9] VPWR VGND sg13cmos5l_antennanp
XANTENNA_2163 Tile_X0Y0_FrameData[9] VPWR VGND sg13cmos5l_antennanp
XANTENNA_2174 Tile_X0Y0_FrameData[9] VPWR VGND sg13cmos5l_antennanp
XANTENNA_2185 Tile_X0Y0_FrameData[9] VPWR VGND sg13cmos5l_antennanp
X_0444_ _0444_/Q Tile_X0Y0_FrameData[29] VGND VPWR Tile_X3Y0_FrameStrobe[1] latch
XANTENNA_1451 Tile_X0Y0_FrameData[31] VPWR VGND sg13cmos5l_antennanp
XANTENNA_1462 Tile_X0Y0_FrameData[31] VPWR VGND sg13cmos5l_antennanp
XANTENNA_1473 Tile_X0Y0_FrameData[31] VPWR VGND sg13cmos5l_antennanp
XANTENNA_2196 Tile_X0Y0_FrameData[9] VPWR VGND sg13cmos5l_antennanp
XFILLER_7_2672 VPWR VGND sg13cmos5l_decap_8
XANTENNA_1484 Tile_X0Y0_FrameData[31] VPWR VGND sg13cmos5l_antennanp
XANTENNA_1495 Tile_X0Y0_FrameData[3] VPWR VGND sg13cmos5l_antennanp
X_0375_ _0375_/Q Tile_X0Y0_FrameData[2] VGND VPWR Tile_X2Y0_FrameStrobe[1] latch
XFILLER_3_1802 VPWR VGND sg13cmos5l_fill_1
XFILLER_1_2282 VPWR VGND sg13cmos5l_decap_4
XFILLER_13_49 VPWR VGND sg13cmos5l_decap_8
XFILLER_11_1133 VPWR VGND sg13cmos5l_decap_8
XFILLER_8_1713 VPWR VGND sg13cmos5l_decap_8
XFILLER_2_1323 VPWR VGND sg13cmos5l_fill_2
XANTENNA_304 Tile_X0Y0_FrameData[1] VPWR VGND sg13cmos5l_antennanp
XANTENNA_315 Tile_X0Y0_FrameData[1] VPWR VGND sg13cmos5l_antennanp
XANTENNA_326 Tile_X0Y0_FrameData[1] VPWR VGND sg13cmos5l_antennanp
XANTENNA_337 Tile_X0Y0_FrameData[1] VPWR VGND sg13cmos5l_antennanp
XANTENNA_348 Tile_X0Y0_FrameData[1] VPWR VGND sg13cmos5l_antennanp
XANTENNA_359 Tile_X0Y0_FrameData[1] VPWR VGND sg13cmos5l_antennanp
XANTENNA__0545__Q NPU_WDATA21 VPWR VGND sg13cmos5l_antennanp
XFILLER_14_758 VPWR VGND sg13cmos5l_decap_8
XFILLER_16_1033 VPWR VGND sg13cmos5l_fill_2
XFILLER_13_2622 VPWR VGND sg13cmos5l_decap_8
XFILLER_13_2699 VPWR VGND sg13cmos5l_decap_8
XFILLER_5_456 VPWR VGND sg13cmos5l_fill_1
XFILLER_5_489 VPWR VGND sg13cmos5l_fill_1
X_0160_ _0160_/Q Tile_X0Y0_FrameData[25] VGND VPWR Tile_X0Y0_FrameStrobe[2] latch
X_0091_ _0091_/Q Tile_X0Y0_FrameData[30] VGND VPWR Tile_X0Y0_FrameStrobe[0] latch
XANTENNA_871 Tile_X0Y0_FrameData[27] VPWR VGND sg13cmos5l_antennanp
XANTENNA_860 Tile_X0Y0_FrameData[27] VPWR VGND sg13cmos5l_antennanp
XFILLER_14_2408 VPWR VGND sg13cmos5l_decap_8
XANTENNA_893 Tile_X0Y0_FrameData[27] VPWR VGND sg13cmos5l_antennanp
XANTENNA_882 Tile_X0Y0_FrameData[27] VPWR VGND sg13cmos5l_antennanp
X_0993_ Tile_X0Y0_S4BEG[2] _1141_/X VPWR VGND sg13cmos5l_buf_1
XFILLER_16_2290 VPWR VGND sg13cmos5l_fill_1
XFILLER_14_1718 VPWR VGND sg13cmos5l_decap_8
XFILLER_12_2176 VPWR VGND sg13cmos5l_decap_8
XFILLER_9_2745 VPWR VGND sg13cmos5l_decap_8
XFILLER_5_2609 VPWR VGND sg13cmos5l_decap_8
XANTENNA_1270 Tile_X0Y0_FrameData[30] VPWR VGND sg13cmos5l_antennanp
XANTENNA_1281 Tile_X0Y0_FrameData[30] VPWR VGND sg13cmos5l_antennanp
X_0427_ _0427_/Q Tile_X0Y0_FrameData[14] VGND VPWR Tile_X3Y0_FrameStrobe[0] latch
XANTENNA_1292 Tile_X0Y0_FrameData[30] VPWR VGND sg13cmos5l_antennanp
X_0358_ _0358_/Q Tile_X0Y0_FrameData[19] VGND VPWR Tile_X2Y0_FrameStrobe[1] latch
XFILLER_3_1621 VPWR VGND sg13cmos5l_decap_8
X_0289_ _0289_/Q Tile_X0Y0_FrameData[8] VGND VPWR Tile_X1Y0_FrameStrobe[2] latch
XFILLER_3_1698 VPWR VGND sg13cmos5l_decap_8
XANTENNA__1040__X Tile_X4Y0_S2BEGb[1] VPWR VGND sg13cmos5l_antennanp
XFILLER_13_1206 VPWR VGND sg13cmos5l_decap_8
XFILLER_3_916 VPWR VGND sg13cmos5l_fill_2
XFILLER_8_1598 VPWR VGND sg13cmos5l_decap_8
XANTENNA_101 Tile_X0Y0_FrameData[0] VPWR VGND sg13cmos5l_antennanp
XANTENNA_112 Tile_X0Y0_FrameData[0] VPWR VGND sg13cmos5l_antennanp
XANTENNA_123 Tile_X0Y0_FrameData[0] VPWR VGND sg13cmos5l_antennanp
XANTENNA_134 Tile_X0Y0_FrameData[0] VPWR VGND sg13cmos5l_antennanp
XANTENNA_145 Tile_X0Y0_FrameData[10] VPWR VGND sg13cmos5l_antennanp
XANTENNA_156 Tile_X0Y0_FrameData[10] VPWR VGND sg13cmos5l_antennanp
XANTENNA_167 Tile_X0Y0_FrameData[10] VPWR VGND sg13cmos5l_antennanp
XANTENNA_178 Tile_X0Y0_FrameData[10] VPWR VGND sg13cmos5l_antennanp
XANTENNA_189 Tile_X0Y0_FrameData[10] VPWR VGND sg13cmos5l_antennanp
XFILLER_15_2717 VPWR VGND sg13cmos5l_decap_8
XFILLER_14_555 VPWR VGND sg13cmos5l_decap_8
XFILLER_14_70 VPWR VGND sg13cmos5l_decap_8
XFILLER_13_2463 VPWR VGND sg13cmos5l_decap_8
XFILLER_13_1740 VPWR VGND sg13cmos5l_decap_8
X_1261_ _1261_/X Tile_X3Y0_N2MID[2] Tile_X3Y0_N4END[13] Tile_X3Y0_NN4END[2] _0578_/Q
+ _0485_/Q _0484_/Q VPWR VGND sg13cmos5l_mux4_1
X_0212_ _0212_/Q Tile_X0Y0_FrameData[21] VGND VPWR Tile_X1Y0_FrameStrobe[0] latch
X_1192_ _1192_/X Tile_X1Y0_N2MID[5] Tile_X1Y0_N4END[2] Tile_X1Y0_NN4END[13] _0589_/Q
+ _0271_/Q _0270_/Q VPWR VGND sg13cmos5l_mux4_1
XFILLER_4_2675 VPWR VGND sg13cmos5l_decap_8
X_0143_ _0143_/Q Tile_X0Y0_FrameData[10] VGND VPWR Tile_X0Y0_FrameStrobe[1] latch
XANTENNA__0964__X Tile_X1Y0_FrameStrobe_O[9] VPWR VGND sg13cmos5l_antennanp
XFILLER_14_2216 VPWR VGND sg13cmos5l_decap_8
XANTENNA_690 Tile_X0Y0_FrameData[24] VPWR VGND sg13cmos5l_antennanp
XFILLER_14_1515 VPWR VGND sg13cmos5l_decap_8
X_0976_ Tile_X0Y0_SS4BEG[1] _1156_/X VPWR VGND sg13cmos5l_buf_1
XFILLER_9_581 VPWR VGND sg13cmos5l_decap_8
XFILLER_10_28 VPWR VGND sg13cmos5l_decap_8
XFILLER_5_2417 VPWR VGND sg13cmos5l_decap_8
XFILLER_5_1716 VPWR VGND sg13cmos5l_decap_8
XANTENNA__1035__X Tile_X4Y0_S2BEG[4] VPWR VGND sg13cmos5l_antennanp
XANTENNA__0874__X Tile_X2Y0_S2BEG[7] VPWR VGND sg13cmos5l_antennanp
XFILLER_11_503 VPWR VGND sg13cmos5l_decap_8
XANTENNA_4109 Tile_X1Y0_N4END[13] VPWR VGND sg13cmos5l_antennanp
XANTENNA_3408 Tile_X0Y0_FrameData[21] VPWR VGND sg13cmos5l_antennanp
XANTENNA_3419 Tile_X0Y0_FrameData[21] VPWR VGND sg13cmos5l_antennanp
XFILLER_10_2669 VPWR VGND sg13cmos5l_decap_8
XANTENNA_2707 Tile_X0Y0_FrameData[14] VPWR VGND sg13cmos5l_antennanp
XANTENNA_2718 Tile_X0Y0_FrameData[14] VPWR VGND sg13cmos5l_antennanp
XANTENNA_2729 Tile_X0Y0_FrameData[14] VPWR VGND sg13cmos5l_antennanp
XFILLER_8_1340 VPWR VGND sg13cmos5l_fill_2
XANTENNA__0784__X Tile_X3Y0_S4BEG[5] VPWR VGND sg13cmos5l_antennanp
XFILLER_15_2503 VPWR VGND sg13cmos5l_decap_8
XFILLER_15_2558 VPWR VGND sg13cmos5l_decap_8
X_0830_ Tile_X4Y0_FrameData_O[19] Tile_X0Y0_FrameData[19] VPWR VGND sg13cmos5l_buf_1
XFILLER_15_1857 VPWR VGND sg13cmos5l_decap_8
X_0761_ Tile_X3Y0_S1BEG[2] Tile_X3Y0_N1END[1] VPWR VGND sg13cmos5l_buf_1
XANTENNA_3920 Tile_X0Y0_FrameData[18] VPWR VGND sg13cmos5l_antennanp
XANTENNA_3931 Tile_X0Y0_FrameData[18] VPWR VGND sg13cmos5l_antennanp
X_0692_ Tile_X0Y0_FrameStrobe_O[5] Tile_X0Y0_FrameStrobe[5] VPWR VGND sg13cmos5l_buf_1
XANTENNA_3942 Tile_X0Y0_FrameData[18] VPWR VGND sg13cmos5l_antennanp
XANTENNA_3953 Tile_X0Y0_FrameData[18] VPWR VGND sg13cmos5l_antennanp
XANTENNA_3964 Tile_X0Y0_FrameData[18] VPWR VGND sg13cmos5l_antennanp
XANTENNA_3975 Tile_X0Y0_FrameData[18] VPWR VGND sg13cmos5l_antennanp
XFILLER_9_1104 VPWR VGND sg13cmos5l_fill_2
XANTENNA__0959__X Tile_X1Y0_FrameStrobe_O[4] VPWR VGND sg13cmos5l_antennanp
XANTENNA_3986 Tile_X0Y0_FrameData[18] VPWR VGND sg13cmos5l_antennanp
XANTENNA_3997 Tile_X0Y0_FrameData[18] VPWR VGND sg13cmos5l_antennanp
XFILLER_6_2704 VPWR VGND sg13cmos5l_decap_8
XFILLER_9_1148 VPWR VGND sg13cmos5l_decap_8
X_1244_ _1244_/X Tile_X2Y0_N2END[1] Tile_X2Y0_N4END[9] Tile_X2Y0_NN4END[6] _0582_/Q
+ _0343_/Q _0342_/Q VPWR VGND sg13cmos5l_mux4_1
X_1175_ _1175_/X Tile_X1Y0_N1END[0] Tile_X1Y0_N2MID[4] Tile_X1Y0_N2END[3] _0592_/Q
+ _0305_/Q _0304_/Q VPWR VGND sg13cmos5l_mux4_1
XFILLER_0_2358 VPWR VGND sg13cmos5l_fill_2
XANTENNA__0694__X Tile_X0Y0_FrameStrobe_O[7] VPWR VGND sg13cmos5l_antennanp
X_0126_ _0126_/Q Tile_X0Y0_FrameData[27] VGND VPWR Tile_X0Y0_FrameStrobe[1] latch
XFILLER_0_2369 VPWR VGND sg13cmos5l_fill_2
XANTENNA_12 NPU_RDATA17 VPWR VGND sg13cmos5l_antennanp
XANTENNA_23 NPU_RDATA25 VPWR VGND sg13cmos5l_antennanp
XANTENNA_34 NPU_RDATA8 VPWR VGND sg13cmos5l_antennanp
XANTENNA_56 Tile_X0Y0_FrameData[0] VPWR VGND sg13cmos5l_antennanp
XANTENNA_45 Tile_X0Y0_FrameData[0] VPWR VGND sg13cmos5l_antennanp
XANTENNA_89 Tile_X0Y0_FrameData[0] VPWR VGND sg13cmos5l_antennanp
XANTENNA_78 Tile_X0Y0_FrameData[0] VPWR VGND sg13cmos5l_antennanp
XANTENNA_67 Tile_X0Y0_FrameData[0] VPWR VGND sg13cmos5l_antennanp
X_0959_ Tile_X1Y0_FrameStrobe_O[4] Tile_X1Y0_FrameStrobe[4] VPWR VGND sg13cmos5l_buf_1
XFILLER_12_1091 VPWR VGND sg13cmos5l_decap_8
XANTENNA__0869__X Tile_X2Y0_S2BEG[2] VPWR VGND sg13cmos5l_antennanp
XFILLER_9_2372 VPWR VGND sg13cmos5l_decap_8
XFILLER_5_2214 VPWR VGND sg13cmos5l_decap_8
XFILLER_16_606 VPWR VGND sg13cmos5l_decap_8
XFILLER_15_105 VPWR VGND sg13cmos5l_decap_8
XFILLER_15_1109 VPWR VGND sg13cmos5l_decap_8
XANTENNA__0553__Q NPU_WDATA29 VPWR VGND sg13cmos5l_antennanp
XFILLER_10_2422 VPWR VGND sg13cmos5l_decap_8
XANTENNA_3205 Tile_X0Y0_FrameData[20] VPWR VGND sg13cmos5l_antennanp
XANTENNA_3216 Tile_X0Y0_FrameData[20] VPWR VGND sg13cmos5l_antennanp
XANTENNA_3227 Tile_X0Y0_FrameData[20] VPWR VGND sg13cmos5l_antennanp
XFILLER_11_60 VPWR VGND sg13cmos5l_decap_8
XFILLER_10_2499 VPWR VGND sg13cmos5l_decap_8
XANTENNA_2504 Tile_X0Y0_FrameData[12] VPWR VGND sg13cmos5l_antennanp
XANTENNA_2515 Tile_X0Y0_FrameData[12] VPWR VGND sg13cmos5l_antennanp
XANTENNA_3238 Tile_X0Y0_FrameData[20] VPWR VGND sg13cmos5l_antennanp
XANTENNA_3249 Tile_X0Y0_FrameData[20] VPWR VGND sg13cmos5l_antennanp
XFILLER_2_0 VPWR VGND sg13cmos5l_decap_8
XANTENNA__0779__X Tile_X3Y0_S4BEG[0] VPWR VGND sg13cmos5l_antennanp
XANTENNA_1803 Tile_X0Y0_FrameData[5] VPWR VGND sg13cmos5l_antennanp
XANTENNA_1814 Tile_X0Y0_FrameData[5] VPWR VGND sg13cmos5l_antennanp
XANTENNA_2526 Tile_X0Y0_FrameData[12] VPWR VGND sg13cmos5l_antennanp
XANTENNA_2537 Tile_X0Y0_FrameData[12] VPWR VGND sg13cmos5l_antennanp
XANTENNA_2548 Tile_X0Y0_FrameData[12] VPWR VGND sg13cmos5l_antennanp
XANTENNA_2559 Tile_X0Y0_FrameData[12] VPWR VGND sg13cmos5l_antennanp
XFILLER_3_565 VPWR VGND sg13cmos5l_decap_8
XANTENNA_1825 Tile_X0Y0_FrameData[5] VPWR VGND sg13cmos5l_antennanp
XANTENNA_1836 Tile_X0Y0_FrameData[5] VPWR VGND sg13cmos5l_antennanp
XANTENNA_1847 Tile_X0Y0_FrameData[5] VPWR VGND sg13cmos5l_antennanp
XANTENNA_1858 Tile_X0Y0_FrameData[5] VPWR VGND sg13cmos5l_antennanp
XANTENNA_1869 Tile_X0Y0_FrameData[5] VPWR VGND sg13cmos5l_antennanp
XFILLER_5_2770 VPWR VGND sg13cmos5l_fill_2
XFILLER_1_2623 VPWR VGND sg13cmos5l_fill_1
XFILLER_1_2612 VPWR VGND sg13cmos5l_decap_8
XFILLER_1_2656 VPWR VGND sg13cmos5l_decap_4
XFILLER_1_1977 VPWR VGND sg13cmos5l_fill_1
XFILLER_14_182 VPWR VGND sg13cmos5l_decap_8
XFILLER_15_2377 VPWR VGND sg13cmos5l_decap_8
X_0813_ Tile_X4Y0_FrameData_O[2] Tile_X0Y0_FrameData[2] VPWR VGND sg13cmos5l_buf_1
XFILLER_15_1654 VPWR VGND sg13cmos5l_decap_8
XFILLER_11_2219 VPWR VGND sg13cmos5l_decap_8
XFILLER_11_1529 VPWR VGND sg13cmos5l_decap_8
X_0744_ Tile_X1Y0_SS4BEG[13] _1208_/X VPWR VGND sg13cmos5l_buf_1
XANTENNA_3750 Tile_X2Y0_N4END[4] VPWR VGND sg13cmos5l_antennanp
X_0675_ _0675_/L_HI VPWR VGND sg13cmos5l_tiehi
XANTENNA__0689__X Tile_X0Y0_FrameStrobe_O[2] VPWR VGND sg13cmos5l_antennanp
XANTENNA_3761 Tile_X3Y0_NN4END[5] VPWR VGND sg13cmos5l_antennanp
XANTENNA_3772 Tile_X0Y0_FrameData[18] VPWR VGND sg13cmos5l_antennanp
XANTENNA_3783 Tile_X0Y0_FrameData[18] VPWR VGND sg13cmos5l_antennanp
XANTENNA_3794 Tile_X0Y0_FrameData[18] VPWR VGND sg13cmos5l_antennanp
X_1227_ _1227_/X Tile_X2Y0_N2MID[0] Tile_X2Y0_N4END[7] Tile_X2Y0_NN4END[8] _0582_/Q
+ _0377_/Q _0376_/Q VPWR VGND sg13cmos5l_mux4_1
X_1158_ _1158_/X Tile_X0Y0_N2END[3] Tile_X0Y0_N4END[3] Tile_X0Y0_NN4END[12] _0602_/Q
+ _0147_/Q _0146_/Q VPWR VGND sg13cmos5l_mux4_1
X_0109_ _0109_/Q Tile_X0Y0_FrameData[12] VGND VPWR Tile_X0Y0_FrameStrobe[0] latch
XFILLER_16_49 VPWR VGND sg13cmos5l_decap_8
X_1089_ _1089_/X Tile_X3Y0_N1END[1] Tile_X3Y0_N2MID[1] Tile_X3Y0_N2MID[6] Tile_X3Y0_N2END[6]
+ _0423_/Q _0422_/Q VPWR VGND sg13cmos5l_mux4_1
XFILLER_12_119 VPWR VGND sg13cmos5l_decap_8
XFILLER_14_1131 VPWR VGND sg13cmos5l_decap_8
XANTENNA__0548__Q NPU_WDATA24 VPWR VGND sg13cmos5l_antennanp
XFILLER_16_447 VPWR VGND sg13cmos5l_decap_8
XFILLER_16_2620 VPWR VGND sg13cmos5l_decap_8
XFILLER_12_620 VPWR VGND sg13cmos5l_decap_8
XFILLER_7_112 VPWR VGND sg13cmos5l_decap_4
XFILLER_16_2697 VPWR VGND sg13cmos5l_decap_8
XFILLER_16_1941 VPWR VGND sg13cmos5l_decap_8
XFILLER_12_686 VPWR VGND sg13cmos5l_decap_8
XFILLER_8_668 VPWR VGND sg13cmos5l_decap_8
XFILLER_12_1838 VPWR VGND sg13cmos5l_decap_8
XANTENNA_3002 Tile_X0Y0_FrameData[19] VPWR VGND sg13cmos5l_antennanp
XFILLER_12_1849 VPWR VGND sg13cmos5l_fill_2
XANTENNA_3013 Tile_X0Y0_FrameData[19] VPWR VGND sg13cmos5l_antennanp
XANTENNA_3024 Tile_X0Y0_FrameData[19] VPWR VGND sg13cmos5l_antennanp
XANTENNA_3035 Tile_X0Y0_FrameData[19] VPWR VGND sg13cmos5l_antennanp
XFILLER_10_2296 VPWR VGND sg13cmos5l_decap_8
XANTENNA_2301 Tile_X0Y0_N4END[0] VPWR VGND sg13cmos5l_antennanp
XANTENNA_2312 Tile_X2Y0_N4END[12] VPWR VGND sg13cmos5l_antennanp
XANTENNA_2323 Tile_X3Y0_NN4END[3] VPWR VGND sg13cmos5l_antennanp
XANTENNA_2334 Tile_X0Y0_FrameData[11] VPWR VGND sg13cmos5l_antennanp
XANTENNA_3046 Tile_X0Y0_FrameData[19] VPWR VGND sg13cmos5l_antennanp
XANTENNA_3057 Tile_X0Y0_FrameData[19] VPWR VGND sg13cmos5l_antennanp
XANTENNA_3068 Tile_X0Y0_FrameData[19] VPWR VGND sg13cmos5l_antennanp
X_0460_ _0460_/Q Tile_X0Y0_FrameData[13] VGND VPWR Tile_X3Y0_FrameStrobe[1] latch
XFILLER_10_1573 VPWR VGND sg13cmos5l_decap_8
XANTENNA_1600 Tile_X0Y0_FrameData[4] VPWR VGND sg13cmos5l_antennanp
XANTENNA_1611 Tile_X0Y0_FrameData[4] VPWR VGND sg13cmos5l_antennanp
XANTENNA_1622 Tile_X0Y0_FrameData[4] VPWR VGND sg13cmos5l_antennanp
XANTENNA_2345 Tile_X0Y0_FrameData[11] VPWR VGND sg13cmos5l_antennanp
XANTENNA_2356 Tile_X0Y0_FrameData[11] VPWR VGND sg13cmos5l_antennanp
XANTENNA_2367 Tile_X0Y0_FrameData[11] VPWR VGND sg13cmos5l_antennanp
XANTENNA_3079 Tile_X0Y0_FrameData[19] VPWR VGND sg13cmos5l_antennanp
XANTENNA_1633 Tile_X0Y0_FrameData[4] VPWR VGND sg13cmos5l_antennanp
XANTENNA_1644 Tile_X0Y0_FrameData[4] VPWR VGND sg13cmos5l_antennanp
XANTENNA_1655 Tile_X0Y0_FrameData[4] VPWR VGND sg13cmos5l_antennanp
XANTENNA_2378 Tile_X0Y0_FrameData[11] VPWR VGND sg13cmos5l_antennanp
XANTENNA_2389 Tile_X0Y0_FrameData[11] VPWR VGND sg13cmos5l_antennanp
X_0391_ _0391_/Q Tile_X0Y0_FrameData[18] VGND VPWR Tile_X2Y0_FrameStrobe[2] latch
XANTENNA_1666 Tile_X0Y0_FrameData[4] VPWR VGND sg13cmos5l_antennanp
XANTENNA_1677 Tile_X0Y0_FrameData[4] VPWR VGND sg13cmos5l_antennanp
XANTENNA_1688 Tile_X0Y0_FrameData[4] VPWR VGND sg13cmos5l_antennanp
XANTENNA_1699 Tile_X0Y0_FrameData[4] VPWR VGND sg13cmos5l_antennanp
X_1012_ Tile_X0Y0_S2BEGb[5] _1136_/X VPWR VGND sg13cmos5l_buf_1
XFILLER_1_2442 VPWR VGND sg13cmos5l_decap_4
XANTENNA__0972__X Tile_X1Y0_FrameStrobe_O[17] VPWR VGND sg13cmos5l_antennanp
XFILLER_15_2163 VPWR VGND sg13cmos5l_decap_8
X_0727_ Tile_X1Y0_S4BEG[12] _1191_/X VPWR VGND sg13cmos5l_buf_1
XFILLER_7_690 VPWR VGND sg13cmos5l_fill_2
XFILLER_8_2629 VPWR VGND sg13cmos5l_decap_8
XANTENNA_3580 Tile_X0Y0_FrameData[8] VPWR VGND sg13cmos5l_antennanp
XANTENNA_3591 Tile_X0Y0_FrameData[8] VPWR VGND sg13cmos5l_antennanp
X_0658_ _0658_/L_HI VPWR VGND sg13cmos5l_tiehi
X_0589_ _0589_/Q Tile_X0Y0_UserCLK NPU_RDATA17 _0622_/L_HI VPWR VGND sg13cmos5l_dfrbpq_1
XFILLER_6_2320 VPWR VGND sg13cmos5l_decap_8
XANTENNA_2890 Tile_X0Y0_FrameData[17] VPWR VGND sg13cmos5l_antennanp
XFILLER_6_2353 VPWR VGND sg13cmos5l_decap_8
XFILLER_2_2228 VPWR VGND sg13cmos5l_decap_8
XFILLER_6_1685 VPWR VGND sg13cmos5l_decap_8
XANTENNA__1043__X Tile_X4Y0_S2BEGb[4] VPWR VGND sg13cmos5l_antennanp
XANTENNA_508 Tile_X0Y0_FrameData[23] VPWR VGND sg13cmos5l_antennanp
XANTENNA_519 Tile_X0Y0_FrameData[23] VPWR VGND sg13cmos5l_antennanp
XANTENNA__0882__X Tile_X2Y0_S2BEGb[7] VPWR VGND sg13cmos5l_antennanp
XFILLER_16_1204 VPWR VGND sg13cmos5l_decap_8
XFILLER_5_627 VPWR VGND sg13cmos5l_decap_8
XFILLER_11_2583 VPWR VGND sg13cmos5l_decap_8
XFILLER_7_2128 VPWR VGND sg13cmos5l_fill_1
XFILLER_5_1184 VPWR VGND sg13cmos5l_decap_4
XFILLER_2_2795 VPWR VGND sg13cmos5l_fill_1
XANTENNA__0792__X Tile_X3Y0_S4BEG[13] VPWR VGND sg13cmos5l_antennanp
XFILLER_16_2472 VPWR VGND sg13cmos5l_decap_8
XFILLER_12_494 VPWR VGND sg13cmos5l_decap_8
XFILLER_12_2358 VPWR VGND sg13cmos5l_decap_8
XFILLER_12_1635 VPWR VGND sg13cmos5l_decap_8
XFILLER_10_2093 VPWR VGND sg13cmos5l_decap_8
XANTENNA_2120 Tile_X0Y0_FrameData[9] VPWR VGND sg13cmos5l_antennanp
XANTENNA_2131 Tile_X0Y0_FrameData[9] VPWR VGND sg13cmos5l_antennanp
XANTENNA_2142 Tile_X0Y0_FrameData[9] VPWR VGND sg13cmos5l_antennanp
X_0512_ _0512_/Q Tile_X0Y0_FrameData[31] VGND VPWR Tile_X4Y0_FrameStrobe[0] latch
XANTENNA_1430 Tile_X0Y0_FrameData[31] VPWR VGND sg13cmos5l_antennanp
XANTENNA_2153 Tile_X0Y0_FrameData[9] VPWR VGND sg13cmos5l_antennanp
XANTENNA_2164 Tile_X0Y0_FrameData[9] VPWR VGND sg13cmos5l_antennanp
XANTENNA_2175 Tile_X0Y0_FrameData[9] VPWR VGND sg13cmos5l_antennanp
X_0443_ _0443_/Q Tile_X0Y0_FrameData[30] VGND VPWR Tile_X3Y0_FrameStrobe[1] latch
XFILLER_7_2651 VPWR VGND sg13cmos5l_decap_8
XANTENNA__0967__X Tile_X1Y0_FrameStrobe_O[12] VPWR VGND sg13cmos5l_antennanp
XANTENNA_1441 Tile_X0Y0_FrameData[31] VPWR VGND sg13cmos5l_antennanp
XANTENNA_1452 Tile_X0Y0_FrameData[31] VPWR VGND sg13cmos5l_antennanp
XANTENNA_1463 Tile_X0Y0_FrameData[31] VPWR VGND sg13cmos5l_antennanp
XANTENNA_1474 Tile_X0Y0_FrameData[31] VPWR VGND sg13cmos5l_antennanp
XANTENNA_2186 Tile_X0Y0_FrameData[9] VPWR VGND sg13cmos5l_antennanp
XANTENNA_2197 Tile_X0Y0_FrameData[9] VPWR VGND sg13cmos5l_antennanp
X_0374_ _0374_/Q Tile_X0Y0_FrameData[3] VGND VPWR Tile_X2Y0_FrameStrobe[1] latch
XANTENNA_1485 Tile_X0Y0_FrameData[31] VPWR VGND sg13cmos5l_antennanp
XANTENNA_1496 Tile_X0Y0_FrameData[3] VPWR VGND sg13cmos5l_antennanp
XFILLER_1_2261 VPWR VGND sg13cmos5l_decap_8
XFILLER_13_28 VPWR VGND sg13cmos5l_decap_8
XFILLER_11_1112 VPWR VGND sg13cmos5l_decap_8
XFILLER_11_1189 VPWR VGND sg13cmos5l_decap_8
XANTENNA__1038__X Tile_X4Y0_S2BEG[7] VPWR VGND sg13cmos5l_antennanp
XFILLER_8_2415 VPWR VGND sg13cmos5l_fill_1
XANTENNA__0877__X Tile_X2Y0_S2BEGb[2] VPWR VGND sg13cmos5l_antennanp
XFILLER_8_1769 VPWR VGND sg13cmos5l_decap_4
XFILLER_2_2014 VPWR VGND sg13cmos5l_fill_2
XANTENNA_305 Tile_X0Y0_FrameData[1] VPWR VGND sg13cmos5l_antennanp
XANTENNA_316 Tile_X0Y0_FrameData[1] VPWR VGND sg13cmos5l_antennanp
XANTENNA_327 Tile_X0Y0_FrameData[1] VPWR VGND sg13cmos5l_antennanp
XANTENNA_338 Tile_X0Y0_FrameData[1] VPWR VGND sg13cmos5l_antennanp
XANTENNA_349 Tile_X0Y0_FrameData[1] VPWR VGND sg13cmos5l_antennanp
XFILLER_14_737 VPWR VGND sg13cmos5l_decap_8
XFILLER_13_2601 VPWR VGND sg13cmos5l_decap_8
XANTENNA__0561__Q NPU_WE5 VPWR VGND sg13cmos5l_antennanp
XFILLER_13_2678 VPWR VGND sg13cmos5l_decap_8
XFILLER_11_2380 VPWR VGND sg13cmos5l_decap_8
XFILLER_11_1690 VPWR VGND sg13cmos5l_decap_8
XANTENNA__0787__X Tile_X3Y0_S4BEG[8] VPWR VGND sg13cmos5l_antennanp
XFILLER_0_162 VPWR VGND sg13cmos5l_fill_1
X_0090_ _0560_/D _0516_/Q _1092_/X VPWR VGND sg13cmos5l_nor2b_1
XFILLER_2_2570 VPWR VGND sg13cmos5l_fill_2
XANTENNA_872 Tile_X0Y0_FrameData[27] VPWR VGND sg13cmos5l_antennanp
XANTENNA_861 Tile_X0Y0_FrameData[27] VPWR VGND sg13cmos5l_antennanp
XANTENNA_850 Tile_X0Y0_FrameData[27] VPWR VGND sg13cmos5l_antennanp
XANTENNA_894 Tile_X0Y0_FrameData[27] VPWR VGND sg13cmos5l_antennanp
XANTENNA_883 Tile_X0Y0_FrameData[27] VPWR VGND sg13cmos5l_antennanp
X_0992_ Tile_X0Y0_S4BEG[1] _1140_/X VPWR VGND sg13cmos5l_buf_1
XFILLER_12_2155 VPWR VGND sg13cmos5l_decap_8
XFILLER_8_284 VPWR VGND sg13cmos5l_fill_2
XFILLER_9_2724 VPWR VGND sg13cmos5l_decap_8
XFILLER_5_84 VPWR VGND sg13cmos5l_decap_8
XANTENNA__0697__X Tile_X0Y0_FrameStrobe_O[10] VPWR VGND sg13cmos5l_antennanp
XANTENNA_1260 Tile_X0Y0_FrameData[30] VPWR VGND sg13cmos5l_antennanp
XANTENNA_1271 Tile_X0Y0_FrameData[30] VPWR VGND sg13cmos5l_antennanp
XANTENNA_1282 Tile_X0Y0_FrameData[30] VPWR VGND sg13cmos5l_antennanp
X_0426_ _0426_/Q Tile_X0Y0_FrameData[15] VGND VPWR Tile_X3Y0_FrameStrobe[0] latch
XFILLER_7_2481 VPWR VGND sg13cmos5l_decap_8
XANTENNA_1293 Tile_X0Y0_FrameData[30] VPWR VGND sg13cmos5l_antennanp
X_0357_ _0357_/Q Tile_X0Y0_FrameData[20] VGND VPWR Tile_X2Y0_FrameStrobe[1] latch
X_0288_ _0288_/Q Tile_X0Y0_FrameData[9] VGND VPWR Tile_X1Y0_FrameStrobe[2] latch
XFILLER_3_2389 VPWR VGND sg13cmos5l_fill_1
XFILLER_3_1677 VPWR VGND sg13cmos5l_decap_8
XFILLER_6_7 VPWR VGND sg13cmos5l_decap_8
XFILLER_8_2267 VPWR VGND sg13cmos5l_decap_8
XFILLER_8_1544 VPWR VGND sg13cmos5l_decap_8
XFILLER_8_2289 VPWR VGND sg13cmos5l_decap_8
XFILLER_8_1577 VPWR VGND sg13cmos5l_decap_8
XFILLER_8_1555 VPWR VGND sg13cmos5l_fill_1
XANTENNA_102 Tile_X0Y0_FrameData[0] VPWR VGND sg13cmos5l_antennanp
XANTENNA_113 Tile_X0Y0_FrameData[0] VPWR VGND sg13cmos5l_antennanp
XANTENNA_124 Tile_X0Y0_FrameData[0] VPWR VGND sg13cmos5l_antennanp
XFILLER_2_1154 VPWR VGND sg13cmos5l_decap_8
XANTENNA__0556__Q NPU_WE0 VPWR VGND sg13cmos5l_antennanp
XANTENNA_135 Tile_X0Y0_FrameData[0] VPWR VGND sg13cmos5l_antennanp
XANTENNA_146 Tile_X0Y0_FrameData[10] VPWR VGND sg13cmos5l_antennanp
XANTENNA_157 Tile_X0Y0_FrameData[10] VPWR VGND sg13cmos5l_antennanp
XFILLER_14_523 VPWR VGND sg13cmos5l_decap_8
XANTENNA_168 Tile_X0Y0_FrameData[10] VPWR VGND sg13cmos5l_antennanp
XANTENNA_179 Tile_X0Y0_FrameData[10] VPWR VGND sg13cmos5l_antennanp
XFILLER_13_2442 VPWR VGND sg13cmos5l_decap_8
XFILLER_10_773 VPWR VGND sg13cmos5l_fill_2
XFILLER_13_1796 VPWR VGND sg13cmos5l_decap_8
X_1260_ _1260_/X Tile_X3Y0_N2MID[1] Tile_X3Y0_N4END[14] Tile_X3Y0_NN4END[1] _0579_/Q
+ _0487_/Q _0486_/Q VPWR VGND sg13cmos5l_mux4_1
X_0211_ _0211_/Q Tile_X0Y0_FrameData[22] VGND VPWR Tile_X1Y0_FrameStrobe[0] latch
X_1191_ _1191_/X Tile_X1Y0_N2MID[4] Tile_X1Y0_N4END[3] Tile_X1Y0_NN4END[12] _0588_/Q
+ _0273_/Q _0272_/Q VPWR VGND sg13cmos5l_mux4_1
XFILLER_7_1087 VPWR VGND sg13cmos5l_decap_8
XFILLER_4_2654 VPWR VGND sg13cmos5l_decap_8
X_0142_ _0142_/Q Tile_X0Y0_FrameData[11] VGND VPWR Tile_X0Y0_FrameStrobe[1] latch
XANTENNA_680 Tile_X0Y0_FrameData[24] VPWR VGND sg13cmos5l_antennanp
XANTENNA__0980__X Tile_X0Y0_SS4BEG[5] VPWR VGND sg13cmos5l_antennanp
XANTENNA_691 Tile_X0Y0_FrameData[24] VPWR VGND sg13cmos5l_antennanp
XFILLER_9_560 VPWR VGND sg13cmos5l_decap_8
X_0975_ Tile_X0Y0_SS4BEG[0] _1155_/X VPWR VGND sg13cmos5l_buf_1
XFILLER_12_1273 VPWR VGND sg13cmos5l_decap_8
XFILLER_9_2598 VPWR VGND sg13cmos5l_decap_8
XANTENNA_1090 Tile_X0Y0_FrameData[2] VPWR VGND sg13cmos5l_antennanp
X_0409_ _0409_/Q Tile_X0Y0_FrameData[0] VGND VPWR Tile_X2Y0_FrameStrobe[2] latch
XANTENNA__1051__X Tile_X4Y0_S4BEG[4] VPWR VGND sg13cmos5l_antennanp
XANTENNA__0890__X Tile_X2Y0_S4BEG[7] VPWR VGND sg13cmos5l_antennanp
XFILLER_13_1004 VPWR VGND sg13cmos5l_fill_1
XFILLER_11_559 VPWR VGND sg13cmos5l_decap_8
XFILLER_10_2648 VPWR VGND sg13cmos5l_decap_8
XANTENNA_3409 Tile_X0Y0_FrameData[21] VPWR VGND sg13cmos5l_antennanp
XANTENNA_2708 Tile_X0Y0_FrameData[14] VPWR VGND sg13cmos5l_antennanp
XANTENNA_2719 Tile_X0Y0_FrameData[14] VPWR VGND sg13cmos5l_antennanp
XFILLER_8_1396 VPWR VGND sg13cmos5l_fill_2
XFILLER_15_1836 VPWR VGND sg13cmos5l_decap_8
XFILLER_13_2250 VPWR VGND sg13cmos5l_decap_8
X_0760_ Tile_X3Y0_S1BEG[1] Tile_X3Y0_N1END[2] VPWR VGND sg13cmos5l_buf_1
XFILLER_10_592 VPWR VGND sg13cmos5l_decap_8
XANTENNA_3910 Tile_X0Y0_FrameData[18] VPWR VGND sg13cmos5l_antennanp
XANTENNA_3921 Tile_X0Y0_FrameData[18] VPWR VGND sg13cmos5l_antennanp
XANTENNA_3932 Tile_X0Y0_FrameData[18] VPWR VGND sg13cmos5l_antennanp
X_0691_ Tile_X0Y0_FrameStrobe_O[4] Tile_X0Y0_FrameStrobe[4] VPWR VGND sg13cmos5l_buf_1
XFILLER_13_1593 VPWR VGND sg13cmos5l_decap_8
XANTENNA_3943 Tile_X0Y0_FrameData[18] VPWR VGND sg13cmos5l_antennanp
XANTENNA_3954 Tile_X0Y0_FrameData[18] VPWR VGND sg13cmos5l_antennanp
XANTENNA_3965 Tile_X0Y0_FrameData[18] VPWR VGND sg13cmos5l_antennanp
XANTENNA_3976 Tile_X0Y0_FrameData[18] VPWR VGND sg13cmos5l_antennanp
XANTENNA_3987 Tile_X0Y0_FrameData[18] VPWR VGND sg13cmos5l_antennanp
XANTENNA_3998 Tile_X0Y0_FrameData[18] VPWR VGND sg13cmos5l_antennanp
XFILLER_9_1116 VPWR VGND sg13cmos5l_decap_8
XFILLER_9_1127 VPWR VGND sg13cmos5l_decap_8
XFILLER_2_791 VPWR VGND sg13cmos5l_fill_2
X_1243_ _1243_/X Tile_X2Y0_N2END[0] Tile_X2Y0_N4END[8] Tile_X2Y0_NN4END[7] _0583_/Q
+ _0345_/Q _0344_/Q VPWR VGND sg13cmos5l_mux4_1
XFILLER_4_2440 VPWR VGND sg13cmos5l_decap_8
XANTENNA__0975__X Tile_X0Y0_SS4BEG[0] VPWR VGND sg13cmos5l_antennanp
XFILLER_2_63 VPWR VGND sg13cmos5l_fill_2
X_1174_ _1174_/X Tile_X1Y0_N1END[3] Tile_X1Y0_N2MID[3] Tile_X1Y0_N2END[4] _0591_/Q
+ _0307_/Q _0306_/Q VPWR VGND sg13cmos5l_mux4_1
XFILLER_0_2348 VPWR VGND sg13cmos5l_fill_1
XFILLER_0_2326 VPWR VGND sg13cmos5l_decap_8
X_0125_ _0125_/Q Tile_X0Y0_FrameData[28] VGND VPWR Tile_X0Y0_FrameStrobe[1] latch
XFILLER_0_1669 VPWR VGND sg13cmos5l_decap_4
XANTENNA_13 NPU_RDATA18 VPWR VGND sg13cmos5l_antennanp
XANTENNA_24 NPU_RDATA26 VPWR VGND sg13cmos5l_antennanp
XANTENNA_35 NPU_RDATA9 VPWR VGND sg13cmos5l_antennanp
XFILLER_14_2069 VPWR VGND sg13cmos5l_decap_8
XANTENNA_57 Tile_X0Y0_FrameData[0] VPWR VGND sg13cmos5l_antennanp
XANTENNA_46 Tile_X0Y0_FrameData[0] VPWR VGND sg13cmos5l_antennanp
X_0958_ Tile_X1Y0_FrameStrobe_O[3] Tile_X1Y0_FrameStrobe[3] VPWR VGND sg13cmos5l_buf_1
XANTENNA_79 Tile_X0Y0_FrameData[0] VPWR VGND sg13cmos5l_antennanp
XANTENNA_68 Tile_X0Y0_FrameData[0] VPWR VGND sg13cmos5l_antennanp
X_0889_ Tile_X2Y0_S4BEG[6] _1225_/X VPWR VGND sg13cmos5l_buf_1
XFILLER_9_2351 VPWR VGND sg13cmos5l_decap_8
XANTENNA__1046__X Tile_X4Y0_S2BEGb[7] VPWR VGND sg13cmos5l_antennanp
XFILLER_9_1683 VPWR VGND sg13cmos5l_decap_8
XANTENNA__0885__X Tile_X2Y0_S4BEG[2] VPWR VGND sg13cmos5l_antennanp
XFILLER_16_2802 VPWR VGND sg13cmos5l_fill_1
XFILLER_11_323 VPWR VGND sg13cmos5l_fill_1
XFILLER_14_2581 VPWR VGND sg13cmos5l_decap_8
XFILLER_10_2401 VPWR VGND sg13cmos5l_decap_8
XANTENNA_3206 Tile_X0Y0_FrameData[20] VPWR VGND sg13cmos5l_antennanp
XANTENNA_3217 Tile_X0Y0_FrameData[20] VPWR VGND sg13cmos5l_antennanp
XFILLER_10_2478 VPWR VGND sg13cmos5l_decap_8
XANTENNA_2505 Tile_X0Y0_FrameData[12] VPWR VGND sg13cmos5l_antennanp
XANTENNA_2516 Tile_X0Y0_FrameData[12] VPWR VGND sg13cmos5l_antennanp
XANTENNA_3228 Tile_X0Y0_FrameData[20] VPWR VGND sg13cmos5l_antennanp
XANTENNA_3239 Tile_X0Y0_FrameData[20] VPWR VGND sg13cmos5l_antennanp
XFILLER_3_544 VPWR VGND sg13cmos5l_decap_8
XFILLER_3_533 VPWR VGND sg13cmos5l_fill_2
XFILLER_10_1755 VPWR VGND sg13cmos5l_fill_2
XANTENNA_1804 Tile_X0Y0_FrameData[5] VPWR VGND sg13cmos5l_antennanp
XANTENNA_2527 Tile_X0Y0_FrameData[12] VPWR VGND sg13cmos5l_antennanp
XANTENNA_2538 Tile_X0Y0_FrameData[12] VPWR VGND sg13cmos5l_antennanp
XANTENNA_2549 Tile_X0Y0_FrameData[12] VPWR VGND sg13cmos5l_antennanp
XFILLER_10_1799 VPWR VGND sg13cmos5l_decap_8
XANTENNA_1815 Tile_X0Y0_FrameData[5] VPWR VGND sg13cmos5l_antennanp
XANTENNA_1826 Tile_X0Y0_FrameData[5] VPWR VGND sg13cmos5l_antennanp
XANTENNA_1837 Tile_X0Y0_FrameData[5] VPWR VGND sg13cmos5l_antennanp
XANTENNA_1848 Tile_X0Y0_FrameData[5] VPWR VGND sg13cmos5l_antennanp
XANTENNA_1859 Tile_X0Y0_FrameData[5] VPWR VGND sg13cmos5l_antennanp
XANTENNA__0795__X Tile_X3Y0_SS4BEG[0] VPWR VGND sg13cmos5l_antennanp
XFILLER_8_1193 VPWR VGND sg13cmos5l_decap_8
XFILLER_4_1035 VPWR VGND sg13cmos5l_fill_2
XFILLER_1_2635 VPWR VGND sg13cmos5l_decap_8
XFILLER_1_2668 VPWR VGND sg13cmos5l_fill_1
XFILLER_15_651 VPWR VGND sg13cmos5l_fill_2
XFILLER_14_161 VPWR VGND sg13cmos5l_decap_8
XFILLER_15_2356 VPWR VGND sg13cmos5l_decap_8
X_0812_ Tile_X4Y0_FrameData_O[1] Tile_X0Y0_FrameData[1] VPWR VGND sg13cmos5l_buf_1
XFILLER_15_1633 VPWR VGND sg13cmos5l_decap_8
X_0743_ Tile_X1Y0_SS4BEG[12] _1207_/X VPWR VGND sg13cmos5l_buf_1
XANTENNA_3740 Tile_X2Y0_N2END[4] VPWR VGND sg13cmos5l_antennanp
X_0674_ _0674_/L_HI VPWR VGND sg13cmos5l_tiehi
XANTENNA_3751 Tile_X2Y0_N4END[4] VPWR VGND sg13cmos5l_antennanp
XANTENNA_3762 Tile_X3Y0_NN4END[5] VPWR VGND sg13cmos5l_antennanp
XANTENNA_3773 Tile_X0Y0_FrameData[18] VPWR VGND sg13cmos5l_antennanp
XANTENNA_3784 Tile_X0Y0_FrameData[18] VPWR VGND sg13cmos5l_antennanp
XANTENNA_3795 Tile_X0Y0_FrameData[18] VPWR VGND sg13cmos5l_antennanp
X_1226_ _1226_/X Tile_X2Y0_N2MID[7] Tile_X2Y0_N4END[8] Tile_X2Y0_NN4END[7] _0585_/Q
+ _0379_/Q _0378_/Q VPWR VGND sg13cmos5l_mux4_1
XFILLER_2_1709 VPWR VGND sg13cmos5l_decap_8
X_1157_ _1157_/X Tile_X0Y0_N2END[2] Tile_X0Y0_N4END[2] Tile_X0Y0_NN4END[13] _0603_/Q
+ _0149_/Q _0148_/Q VPWR VGND sg13cmos5l_mux4_1
X_0108_ _0108_/Q Tile_X0Y0_FrameData[13] VGND VPWR Tile_X0Y0_FrameStrobe[0] latch
XFILLER_16_28 VPWR VGND sg13cmos5l_decap_8
XFILLER_0_2167 VPWR VGND sg13cmos5l_fill_1
X_1088_ _1088_/X Tile_X3Y0_N1END[0] Tile_X3Y0_N2MID[0] Tile_X3Y0_N2MID[7] Tile_X3Y0_N2END[7]
+ _0425_/Q _0424_/Q VPWR VGND sg13cmos5l_mux4_1
XFILLER_0_547 VPWR VGND sg13cmos5l_fill_2
XFILLER_9_2181 VPWR VGND sg13cmos5l_decap_8
XFILLER_5_1333 VPWR VGND sg13cmos5l_fill_2
XFILLER_0_2690 VPWR VGND sg13cmos5l_decap_4
XANTENNA__0564__Q NPU_ADDR0 VPWR VGND sg13cmos5l_antennanp
XFILLER_16_2676 VPWR VGND sg13cmos5l_decap_8
XFILLER_8_647 VPWR VGND sg13cmos5l_decap_8
XFILLER_12_665 VPWR VGND sg13cmos5l_decap_8
XFILLER_16_1997 VPWR VGND sg13cmos5l_fill_2
XFILLER_16_1986 VPWR VGND sg13cmos5l_decap_8
XFILLER_12_1817 VPWR VGND sg13cmos5l_decap_8
XFILLER_11_175 VPWR VGND sg13cmos5l_fill_2
XANTENNA_3003 Tile_X0Y0_FrameData[19] VPWR VGND sg13cmos5l_antennanp
XANTENNA_3014 Tile_X0Y0_FrameData[19] VPWR VGND sg13cmos5l_antennanp
XANTENNA_3025 Tile_X0Y0_FrameData[19] VPWR VGND sg13cmos5l_antennanp
XANTENNA_3036 Tile_X0Y0_FrameData[19] VPWR VGND sg13cmos5l_antennanp
XFILLER_10_2275 VPWR VGND sg13cmos5l_decap_8
XFILLER_10_1552 VPWR VGND sg13cmos5l_decap_8
XANTENNA_2302 Tile_X0Y0_N4END[0] VPWR VGND sg13cmos5l_antennanp
XANTENNA_2313 Tile_X2Y0_N4END[12] VPWR VGND sg13cmos5l_antennanp
XANTENNA_2324 Tile_X4Y0_NN4END[0] VPWR VGND sg13cmos5l_antennanp
XANTENNA_3047 Tile_X0Y0_FrameData[19] VPWR VGND sg13cmos5l_antennanp
XANTENNA_3058 Tile_X0Y0_FrameData[19] VPWR VGND sg13cmos5l_antennanp
XANTENNA_3069 Tile_X0Y0_FrameData[19] VPWR VGND sg13cmos5l_antennanp
XANTENNA_1601 Tile_X0Y0_FrameData[4] VPWR VGND sg13cmos5l_antennanp
XANTENNA_1612 Tile_X0Y0_FrameData[4] VPWR VGND sg13cmos5l_antennanp
XANTENNA_1623 Tile_X0Y0_FrameData[4] VPWR VGND sg13cmos5l_antennanp
XANTENNA_2335 Tile_X0Y0_FrameData[11] VPWR VGND sg13cmos5l_antennanp
XANTENNA_2346 Tile_X0Y0_FrameData[11] VPWR VGND sg13cmos5l_antennanp
XANTENNA_2357 Tile_X0Y0_FrameData[11] VPWR VGND sg13cmos5l_antennanp
XANTENNA_1634 Tile_X0Y0_FrameData[4] VPWR VGND sg13cmos5l_antennanp
XANTENNA_1645 Tile_X0Y0_FrameData[4] VPWR VGND sg13cmos5l_antennanp
XANTENNA_1656 Tile_X0Y0_FrameData[4] VPWR VGND sg13cmos5l_antennanp
XANTENNA_2368 Tile_X0Y0_FrameData[11] VPWR VGND sg13cmos5l_antennanp
XANTENNA_2379 Tile_X0Y0_FrameData[11] VPWR VGND sg13cmos5l_antennanp
X_0390_ _0390_/Q Tile_X0Y0_FrameData[19] VGND VPWR Tile_X2Y0_FrameStrobe[2] latch
XANTENNA_1667 Tile_X0Y0_FrameData[4] VPWR VGND sg13cmos5l_antennanp
XANTENNA_1678 Tile_X0Y0_FrameData[4] VPWR VGND sg13cmos5l_antennanp
XANTENNA_1689 Tile_X0Y0_FrameData[4] VPWR VGND sg13cmos5l_antennanp
XFILLER_1_2410 VPWR VGND sg13cmos5l_fill_1
X_1011_ Tile_X0Y0_S2BEGb[4] _1135_/X VPWR VGND sg13cmos5l_buf_1
XFILLER_1_2454 VPWR VGND sg13cmos5l_decap_8
XFILLER_1_1753 VPWR VGND sg13cmos5l_decap_8
XFILLER_15_492 VPWR VGND sg13cmos5l_fill_2
XFILLER_15_2142 VPWR VGND sg13cmos5l_decap_8
XFILLER_8_84 VPWR VGND sg13cmos5l_decap_8
X_0726_ Tile_X1Y0_S4BEG[11] _1190_/X VPWR VGND sg13cmos5l_buf_1
XFILLER_8_2608 VPWR VGND sg13cmos5l_decap_8
XANTENNA_3570 Tile_X0Y0_FrameData[8] VPWR VGND sg13cmos5l_antennanp
XANTENNA_3581 Tile_X0Y0_FrameData[8] VPWR VGND sg13cmos5l_antennanp
XANTENNA_3592 Tile_X0Y0_FrameData[8] VPWR VGND sg13cmos5l_antennanp
X_0657_ _0657_/L_HI VPWR VGND sg13cmos5l_tiehi
XANTENNA_2880 Tile_X0Y0_FrameData[17] VPWR VGND sg13cmos5l_antennanp
X_0588_ _0588_/Q Tile_X0Y0_UserCLK NPU_RDATA16 _0621_/L_HI VPWR VGND sg13cmos5l_dfrbpq_1
XANTENNA_2891 Tile_X0Y0_FrameData[17] VPWR VGND sg13cmos5l_antennanp
XFILLER_6_1664 VPWR VGND sg13cmos5l_decap_8
X_1209_ _1209_/X Tile_X1Y0_N2END[6] Tile_X1Y0_N4END[14] Tile_X1Y0_NN4END[1] _0589_/Q
+ _0237_/Q _0236_/Q VPWR VGND sg13cmos5l_mux4_1
XANTENNA_509 Tile_X0Y0_FrameData[23] VPWR VGND sg13cmos5l_antennanp
XFILLER_16_1249 VPWR VGND sg13cmos5l_fill_2
XFILLER_5_606 VPWR VGND sg13cmos5l_decap_8
XFILLER_11_2540 VPWR VGND sg13cmos5l_fill_1
XFILLER_11_1872 VPWR VGND sg13cmos5l_fill_1
XANTENNA__0559__Q NPU_WE3 VPWR VGND sg13cmos5l_antennanp
XFILLER_1_1005 VPWR VGND sg13cmos5l_fill_2
XFILLER_16_2451 VPWR VGND sg13cmos5l_decap_8
XFILLER_8_400 VPWR VGND sg13cmos5l_fill_2
XFILLER_12_473 VPWR VGND sg13cmos5l_decap_8
XFILLER_12_2337 VPWR VGND sg13cmos5l_decap_8
XFILLER_12_1614 VPWR VGND sg13cmos5l_decap_8
X_0511_ _0511_/Q Tile_X0Y0_FrameData[26] VGND VPWR Tile_X4Y0_FrameStrobe[0] latch
XANTENNA_2110 Tile_X0Y0_FrameData[7] VPWR VGND sg13cmos5l_antennanp
XANTENNA_2121 Tile_X0Y0_FrameData[9] VPWR VGND sg13cmos5l_antennanp
XANTENNA_2132 Tile_X0Y0_FrameData[9] VPWR VGND sg13cmos5l_antennanp
XANTENNA_1420 Tile_X0Y0_FrameData[31] VPWR VGND sg13cmos5l_antennanp
XANTENNA_1431 Tile_X0Y0_FrameData[31] VPWR VGND sg13cmos5l_antennanp
XANTENNA_2143 Tile_X0Y0_FrameData[9] VPWR VGND sg13cmos5l_antennanp
XANTENNA_2154 Tile_X0Y0_FrameData[9] VPWR VGND sg13cmos5l_antennanp
XANTENNA_2165 Tile_X0Y0_FrameData[9] VPWR VGND sg13cmos5l_antennanp
XANTENNA_2176 Tile_X0Y0_FrameData[9] VPWR VGND sg13cmos5l_antennanp
X_0442_ _0442_/Q Tile_X0Y0_FrameData[31] VGND VPWR Tile_X3Y0_FrameStrobe[1] latch
XFILLER_7_2630 VPWR VGND sg13cmos5l_decap_8
XANTENNA_1442 Tile_X0Y0_FrameData[31] VPWR VGND sg13cmos5l_antennanp
XANTENNA_1453 Tile_X0Y0_FrameData[31] VPWR VGND sg13cmos5l_antennanp
XANTENNA_1464 Tile_X0Y0_FrameData[31] VPWR VGND sg13cmos5l_antennanp
XANTENNA_2187 Tile_X0Y0_FrameData[9] VPWR VGND sg13cmos5l_antennanp
XANTENNA_2198 Tile_X0Y0_FrameData[9] VPWR VGND sg13cmos5l_antennanp
X_0373_ _0373_/Q Tile_X0Y0_FrameData[4] VGND VPWR Tile_X2Y0_FrameStrobe[1] latch
XFILLER_3_2516 VPWR VGND sg13cmos5l_fill_1
XANTENNA_1475 Tile_X0Y0_FrameData[31] VPWR VGND sg13cmos5l_antennanp
XANTENNA_1486 Tile_X0Y0_FrameData[31] VPWR VGND sg13cmos5l_antennanp
XANTENNA_1497 Tile_X0Y0_FrameData[3] VPWR VGND sg13cmos5l_antennanp
XFILLER_3_2549 VPWR VGND sg13cmos5l_decap_8
XFILLER_3_2527 VPWR VGND sg13cmos5l_decap_8
XFILLER_1_2240 VPWR VGND sg13cmos5l_decap_8
XANTENNA__0983__X Tile_X0Y0_SS4BEG[8] VPWR VGND sg13cmos5l_antennanp
XFILLER_11_1168 VPWR VGND sg13cmos5l_decap_8
XANTENNA_4090 Tile_X1Y0_N2END[7] VPWR VGND sg13cmos5l_antennanp
X_0709_ Tile_X1Y0_S2BEGb[2] _1173_/X VPWR VGND sg13cmos5l_buf_1
XFILLER_8_1748 VPWR VGND sg13cmos5l_decap_8
XANTENNA__1054__X Tile_X4Y0_S4BEG[7] VPWR VGND sg13cmos5l_antennanp
XANTENNA_306 Tile_X0Y0_FrameData[1] VPWR VGND sg13cmos5l_antennanp
XANTENNA__0893__X Tile_X2Y0_S4BEG[10] VPWR VGND sg13cmos5l_antennanp
XANTENNA_317 Tile_X0Y0_FrameData[1] VPWR VGND sg13cmos5l_antennanp
XANTENNA_328 Tile_X0Y0_FrameData[1] VPWR VGND sg13cmos5l_antennanp
XANTENNA_339 Tile_X0Y0_FrameData[1] VPWR VGND sg13cmos5l_antennanp
XFILLER_14_716 VPWR VGND sg13cmos5l_decap_8
XFILLER_13_2657 VPWR VGND sg13cmos5l_decap_8
XFILLER_2_2582 VPWR VGND sg13cmos5l_decap_8
XANTENNA_862 Tile_X0Y0_FrameData[27] VPWR VGND sg13cmos5l_antennanp
XANTENNA_851 Tile_X0Y0_FrameData[27] VPWR VGND sg13cmos5l_antennanp
XANTENNA_840 Tile_X0Y0_FrameData[27] VPWR VGND sg13cmos5l_antennanp
XANTENNA_895 Tile_X0Y0_FrameData[27] VPWR VGND sg13cmos5l_antennanp
XANTENNA_884 Tile_X0Y0_FrameData[27] VPWR VGND sg13cmos5l_antennanp
XANTENNA_873 Tile_X0Y0_FrameData[27] VPWR VGND sg13cmos5l_antennanp
X_0991_ Tile_X0Y0_S4BEG[0] _1139_/X VPWR VGND sg13cmos5l_buf_1
XFILLER_16_2281 VPWR VGND sg13cmos5l_fill_2
XFILLER_16_1591 VPWR VGND sg13cmos5l_decap_8
XFILLER_12_292 VPWR VGND sg13cmos5l_fill_1
XFILLER_12_2134 VPWR VGND sg13cmos5l_decap_8
XFILLER_9_2703 VPWR VGND sg13cmos5l_decap_8
XFILLER_5_63 VPWR VGND sg13cmos5l_decap_8
XANTENNA__0978__X Tile_X0Y0_SS4BEG[3] VPWR VGND sg13cmos5l_antennanp
X_0425_ _0425_/Q Tile_X0Y0_FrameData[16] VGND VPWR Tile_X3Y0_FrameStrobe[0] latch
XFILLER_7_2460 VPWR VGND sg13cmos5l_decap_8
XANTENNA_1250 Tile_X0Y0_FrameData[30] VPWR VGND sg13cmos5l_antennanp
XANTENNA_1261 Tile_X0Y0_FrameData[30] VPWR VGND sg13cmos5l_antennanp
XANTENNA_1272 Tile_X0Y0_FrameData[30] VPWR VGND sg13cmos5l_antennanp
XANTENNA_1283 Tile_X0Y0_FrameData[30] VPWR VGND sg13cmos5l_antennanp
XANTENNA_1294 Tile_X0Y0_FrameData[30] VPWR VGND sg13cmos5l_antennanp
X_0356_ _0356_/Q Tile_X0Y0_FrameData[21] VGND VPWR Tile_X2Y0_FrameStrobe[1] latch
XFILLER_3_2346 VPWR VGND sg13cmos5l_decap_8
XFILLER_10_0 VPWR VGND sg13cmos5l_decap_8
X_0287_ _0287_/Q Tile_X0Y0_FrameData[10] VGND VPWR Tile_X1Y0_FrameStrobe[2] latch
XFILLER_7_1792 VPWR VGND sg13cmos5l_fill_2
XFILLER_3_1656 VPWR VGND sg13cmos5l_decap_8
XFILLER_11_719 VPWR VGND sg13cmos5l_decap_8
XFILLER_10_218 VPWR VGND sg13cmos5l_fill_2
XANTENNA__1049__X Tile_X4Y0_S4BEG[2] VPWR VGND sg13cmos5l_antennanp
XFILLER_2_428 VPWR VGND sg13cmos5l_fill_2
XANTENNA__0888__X Tile_X2Y0_S4BEG[5] VPWR VGND sg13cmos5l_antennanp
XFILLER_8_2246 VPWR VGND sg13cmos5l_decap_8
XANTENNA_103 Tile_X0Y0_FrameData[0] VPWR VGND sg13cmos5l_antennanp
XANTENNA_114 Tile_X0Y0_FrameData[0] VPWR VGND sg13cmos5l_antennanp
XANTENNA_125 Tile_X0Y0_FrameData[0] VPWR VGND sg13cmos5l_antennanp
XFILLER_2_1133 VPWR VGND sg13cmos5l_decap_8
XANTENNA_136 Tile_X0Y0_FrameData[0] VPWR VGND sg13cmos5l_antennanp
XANTENNA_147 Tile_X0Y0_FrameData[10] VPWR VGND sg13cmos5l_antennanp
XANTENNA_158 Tile_X0Y0_FrameData[10] VPWR VGND sg13cmos5l_antennanp
XANTENNA_169 Tile_X0Y0_FrameData[10] VPWR VGND sg13cmos5l_antennanp
XFILLER_13_2421 VPWR VGND sg13cmos5l_decap_8
XFILLER_13_2498 VPWR VGND sg13cmos5l_decap_8
XFILLER_13_1775 VPWR VGND sg13cmos5l_decap_8
XANTENNA__0798__X Tile_X3Y0_SS4BEG[3] VPWR VGND sg13cmos5l_antennanp
XFILLER_4_2633 VPWR VGND sg13cmos5l_decap_8
X_0210_ _0210_/Q Tile_X0Y0_FrameData[23] VGND VPWR Tile_X1Y0_FrameStrobe[0] latch
X_1190_ _1190_/X Tile_X1Y0_N2MID[3] Tile_X1Y0_N4END[4] Tile_X1Y0_NN4END[11] _0591_/Q
+ _0275_/Q _0274_/Q VPWR VGND sg13cmos5l_mux4_1
X_0141_ _0141_/Q Tile_X0Y0_FrameData[12] VGND VPWR Tile_X0Y0_FrameStrobe[1] latch
XFILLER_4_1932 VPWR VGND sg13cmos5l_fill_2
XFILLER_0_2519 VPWR VGND sg13cmos5l_fill_1
XFILLER_0_2508 VPWR VGND sg13cmos5l_fill_1
XFILLER_0_1807 VPWR VGND sg13cmos5l_fill_2
XANTENNA_670 Tile_X0Y0_FrameData[24] VPWR VGND sg13cmos5l_antennanp
XANTENNA_692 Tile_X0Y0_FrameData[24] VPWR VGND sg13cmos5l_antennanp
XANTENNA_681 Tile_X0Y0_FrameData[24] VPWR VGND sg13cmos5l_antennanp
X_0974_ Tile_X1Y0_FrameStrobe_O[19] Tile_X1Y0_FrameStrobe[19] VPWR VGND sg13cmos5l_buf_1
XFILLER_12_1252 VPWR VGND sg13cmos5l_decap_8
XANTENNA_1080 Tile_X0Y0_FrameData[2] VPWR VGND sg13cmos5l_antennanp
XANTENNA_1091 Tile_X0Y0_FrameData[2] VPWR VGND sg13cmos5l_antennanp
X_0408_ _0408_/Q Tile_X0Y0_FrameData[1] VGND VPWR Tile_X2Y0_FrameStrobe[2] latch
XFILLER_7_2290 VPWR VGND sg13cmos5l_decap_8
XFILLER_3_2132 VPWR VGND sg13cmos5l_fill_1
X_0339_ _0339_/Q Tile_X0Y0_FrameData[6] VGND VPWR Tile_X2Y0_FrameStrobe[0] latch
XFILLER_3_1420 VPWR VGND sg13cmos5l_fill_1
XFILLER_3_1453 VPWR VGND sg13cmos5l_fill_1
XFILLER_11_538 VPWR VGND sg13cmos5l_decap_8
XFILLER_10_2627 VPWR VGND sg13cmos5l_decap_8
XFILLER_10_1959 VPWR VGND sg13cmos5l_fill_2
XANTENNA_2709 Tile_X0Y0_FrameData[14] VPWR VGND sg13cmos5l_antennanp
XANTENNA__0567__Q NPU_ADDR3 VPWR VGND sg13cmos5l_antennanp
XFILLER_15_811 VPWR VGND sg13cmos5l_decap_4
XFILLER_15_2538 VPWR VGND sg13cmos5l_decap_8
XFILLER_15_1815 VPWR VGND sg13cmos5l_decap_8
XFILLER_10_571 VPWR VGND sg13cmos5l_decap_8
X_0690_ Tile_X0Y0_FrameStrobe_O[3] Tile_X0Y0_FrameStrobe[3] VPWR VGND sg13cmos5l_buf_1
XFILLER_6_542 VPWR VGND sg13cmos5l_decap_8
XFILLER_13_2295 VPWR VGND sg13cmos5l_decap_8
XFILLER_13_1572 VPWR VGND sg13cmos5l_decap_8
XANTENNA_3900 Tile_X0Y0_FrameData[18] VPWR VGND sg13cmos5l_antennanp
XANTENNA_3911 Tile_X0Y0_FrameData[18] VPWR VGND sg13cmos5l_antennanp
XANTENNA_3922 Tile_X0Y0_FrameData[18] VPWR VGND sg13cmos5l_antennanp
XFILLER_6_586 VPWR VGND sg13cmos5l_decap_8
XANTENNA_3933 Tile_X0Y0_FrameData[18] VPWR VGND sg13cmos5l_antennanp
XANTENNA_3944 Tile_X0Y0_FrameData[18] VPWR VGND sg13cmos5l_antennanp
XANTENNA_3955 Tile_X0Y0_FrameData[18] VPWR VGND sg13cmos5l_antennanp
XANTENNA_3966 Tile_X0Y0_FrameData[18] VPWR VGND sg13cmos5l_antennanp
XANTENNA_3977 Tile_X0Y0_FrameData[18] VPWR VGND sg13cmos5l_antennanp
XANTENNA_3988 Tile_X0Y0_FrameData[18] VPWR VGND sg13cmos5l_antennanp
XANTENNA_3999 Tile_X0Y0_FrameData[18] VPWR VGND sg13cmos5l_antennanp
XFILLER_6_2739 VPWR VGND sg13cmos5l_decap_8
X_1242_ _1242_/X Tile_X2Y0_N2END[7] Tile_X2Y0_N4END[7] Tile_X2Y0_NN4END[8] _0584_/Q
+ _0347_/Q _0346_/Q VPWR VGND sg13cmos5l_mux4_1
XFILLER_2_42 VPWR VGND sg13cmos5l_decap_8
X_1173_ _1173_/X Tile_X1Y0_N1END[2] Tile_X1Y0_N2MID[2] Tile_X1Y0_N2END[5] _0590_/Q
+ _0309_/Q _0308_/Q VPWR VGND sg13cmos5l_mux4_1
XFILLER_4_2485 VPWR VGND sg13cmos5l_decap_8
XFILLER_4_1740 VPWR VGND sg13cmos5l_decap_8
XFILLER_0_1604 VPWR VGND sg13cmos5l_fill_1
X_0124_ _0124_/Q Tile_X0Y0_FrameData[29] VGND VPWR Tile_X0Y0_FrameStrobe[1] latch
XANTENNA__0991__X Tile_X0Y0_S4BEG[0] VPWR VGND sg13cmos5l_antennanp
XANTENNA_14 NPU_RDATA19 VPWR VGND sg13cmos5l_antennanp
XANTENNA_25 NPU_RDATA27 VPWR VGND sg13cmos5l_antennanp
XANTENNA_36 Tile_X0Y0_FrameData[0] VPWR VGND sg13cmos5l_antennanp
XFILLER_14_2048 VPWR VGND sg13cmos5l_decap_8
XANTENNA_47 Tile_X0Y0_FrameData[0] VPWR VGND sg13cmos5l_antennanp
X_0957_ Tile_X1Y0_FrameStrobe_O[2] Tile_X1Y0_FrameStrobe[2] VPWR VGND sg13cmos5l_buf_1
XANTENNA_69 Tile_X0Y0_FrameData[0] VPWR VGND sg13cmos5l_antennanp
XANTENNA_58 Tile_X0Y0_FrameData[0] VPWR VGND sg13cmos5l_antennanp
X_0888_ Tile_X2Y0_S4BEG[5] _1224_/X VPWR VGND sg13cmos5l_buf_1
XFILLER_9_2330 VPWR VGND sg13cmos5l_decap_8
XFILLER_9_1662 VPWR VGND sg13cmos5l_decap_8
XFILLER_5_2249 VPWR VGND sg13cmos5l_decap_8
XANTENNA__1062__X Tile_X4Y0_S4BEG[15] VPWR VGND sg13cmos5l_antennanp
XFILLER_8_829 VPWR VGND sg13cmos5l_fill_2
XFILLER_11_335 VPWR VGND sg13cmos5l_fill_2
XANTENNA_3207 Tile_X0Y0_FrameData[20] VPWR VGND sg13cmos5l_antennanp
XANTENNA_3218 Tile_X0Y0_FrameData[20] VPWR VGND sg13cmos5l_antennanp
XFILLER_10_2457 VPWR VGND sg13cmos5l_decap_8
XFILLER_10_1734 VPWR VGND sg13cmos5l_decap_8
XANTENNA_2506 Tile_X0Y0_FrameData[12] VPWR VGND sg13cmos5l_antennanp
XANTENNA_3229 Tile_X0Y0_FrameData[20] VPWR VGND sg13cmos5l_antennanp
XFILLER_10_1778 VPWR VGND sg13cmos5l_decap_8
XANTENNA_1805 Tile_X0Y0_FrameData[5] VPWR VGND sg13cmos5l_antennanp
XANTENNA_2517 Tile_X0Y0_FrameData[12] VPWR VGND sg13cmos5l_antennanp
XANTENNA_2528 Tile_X0Y0_FrameData[12] VPWR VGND sg13cmos5l_antennanp
XANTENNA_2539 Tile_X0Y0_FrameData[12] VPWR VGND sg13cmos5l_antennanp
XFILLER_11_95 VPWR VGND sg13cmos5l_decap_4
XANTENNA_1816 Tile_X0Y0_FrameData[5] VPWR VGND sg13cmos5l_antennanp
XANTENNA_1827 Tile_X0Y0_FrameData[5] VPWR VGND sg13cmos5l_antennanp
XANTENNA_1838 Tile_X0Y0_FrameData[5] VPWR VGND sg13cmos5l_antennanp
XANTENNA_1849 Tile_X0Y0_FrameData[5] VPWR VGND sg13cmos5l_antennanp
XFILLER_8_1172 VPWR VGND sg13cmos5l_decap_8
XFILLER_5_2772 VPWR VGND sg13cmos5l_fill_1
XFILLER_15_630 VPWR VGND sg13cmos5l_decap_8
XFILLER_14_140 VPWR VGND sg13cmos5l_decap_8
XFILLER_15_685 VPWR VGND sg13cmos5l_decap_8
XFILLER_15_2324 VPWR VGND sg13cmos5l_fill_1
XFILLER_15_1612 VPWR VGND sg13cmos5l_decap_8
X_0811_ Tile_X4Y0_FrameData_O[0] Tile_X0Y0_FrameData[0] VPWR VGND sg13cmos5l_buf_1
X_0742_ Tile_X1Y0_SS4BEG[11] _1206_/X VPWR VGND sg13cmos5l_buf_1
XFILLER_15_1689 VPWR VGND sg13cmos5l_decap_8
XANTENNA_3730 Tile_X1Y0_NN4END[0] VPWR VGND sg13cmos5l_antennanp
XANTENNA_3741 Tile_X2Y0_N2END[4] VPWR VGND sg13cmos5l_antennanp
X_0673_ _0673_/L_HI VPWR VGND sg13cmos5l_tiehi
XFILLER_6_372 VPWR VGND sg13cmos5l_fill_1
XANTENNA_3752 Tile_X2Y0_N4END[4] VPWR VGND sg13cmos5l_antennanp
XANTENNA_3763 Tile_X3Y0_NN4END[5] VPWR VGND sg13cmos5l_antennanp
XANTENNA_3774 Tile_X0Y0_FrameData[18] VPWR VGND sg13cmos5l_antennanp
XANTENNA_3785 Tile_X0Y0_FrameData[18] VPWR VGND sg13cmos5l_antennanp
XANTENNA_3796 Tile_X0Y0_FrameData[18] VPWR VGND sg13cmos5l_antennanp
XANTENNA__0986__X Tile_X0Y0_SS4BEG[11] VPWR VGND sg13cmos5l_antennanp
XFILLER_6_2536 VPWR VGND sg13cmos5l_decap_8
X_1225_ _1225_/X Tile_X2Y0_N2MID[6] Tile_X2Y0_N4END[9] Tile_X2Y0_NN4END[6] _0584_/Q
+ _0381_/Q _0380_/Q VPWR VGND sg13cmos5l_mux4_1
X_1156_ _1156_/X Tile_X0Y0_N2END[1] Tile_X0Y0_N4END[1] Tile_X0Y0_NN4END[14] _0602_/Q
+ _0151_/Q _0150_/Q VPWR VGND sg13cmos5l_mux4_1
X_0107_ _0107_/Q Tile_X0Y0_FrameData[14] VGND VPWR Tile_X0Y0_FrameStrobe[0] latch
X_1087_ _1087_/X Tile_X2Y0_N1END[3] Tile_X2Y0_N2MID[0] Tile_X2Y0_N2MID[7] Tile_X2Y0_N2END[0]
+ _0315_/Q _0410_/Q VPWR VGND sg13cmos5l_mux4_1
XFILLER_0_1489 VPWR VGND sg13cmos5l_fill_1
XFILLER_14_1111 VPWR VGND sg13cmos5l_decap_8
XFILLER_14_1100 VPWR VGND sg13cmos5l_fill_2
XFILLER_11_2755 VPWR VGND sg13cmos5l_fill_2
XFILLER_11_2744 VPWR VGND sg13cmos5l_decap_8
XFILLER_14_1188 VPWR VGND sg13cmos5l_decap_8
XANTENNA__1057__X Tile_X4Y0_S4BEG[10] VPWR VGND sg13cmos5l_antennanp
XFILLER_9_2160 VPWR VGND sg13cmos5l_decap_8
XANTENNA__0896__X Tile_X2Y0_S4BEG[13] VPWR VGND sg13cmos5l_antennanp
XFILLER_16_2655 VPWR VGND sg13cmos5l_decap_8
XFILLER_16_1921 VPWR VGND sg13cmos5l_fill_1
XFILLER_16_1910 VPWR VGND sg13cmos5l_decap_8
XFILLER_12_644 VPWR VGND sg13cmos5l_decap_8
XFILLER_8_626 VPWR VGND sg13cmos5l_decap_8
XFILLER_16_1965 VPWR VGND sg13cmos5l_decap_8
XFILLER_12_2519 VPWR VGND sg13cmos5l_decap_8
XFILLER_11_154 VPWR VGND sg13cmos5l_decap_8
XFILLER_10_2254 VPWR VGND sg13cmos5l_decap_8
XFILLER_10_1520 VPWR VGND sg13cmos5l_fill_1
XANTENNA_3004 Tile_X0Y0_FrameData[19] VPWR VGND sg13cmos5l_antennanp
XANTENNA_3015 Tile_X0Y0_FrameData[19] VPWR VGND sg13cmos5l_antennanp
XANTENNA_3026 Tile_X0Y0_FrameData[19] VPWR VGND sg13cmos5l_antennanp
XFILLER_10_1531 VPWR VGND sg13cmos5l_decap_8
XANTENNA_2303 Tile_X0Y0_N4END[0] VPWR VGND sg13cmos5l_antennanp
XANTENNA_2314 Tile_X2Y0_N4END[12] VPWR VGND sg13cmos5l_antennanp
XANTENNA_2325 Tile_X0Y0_FrameData[11] VPWR VGND sg13cmos5l_antennanp
XANTENNA_3037 Tile_X0Y0_FrameData[19] VPWR VGND sg13cmos5l_antennanp
XANTENNA_3048 Tile_X0Y0_FrameData[19] VPWR VGND sg13cmos5l_antennanp
XANTENNA_3059 Tile_X0Y0_FrameData[19] VPWR VGND sg13cmos5l_antennanp
XANTENNA_1602 Tile_X0Y0_FrameData[4] VPWR VGND sg13cmos5l_antennanp
XANTENNA_1613 Tile_X0Y0_FrameData[4] VPWR VGND sg13cmos5l_antennanp
XANTENNA_2336 Tile_X0Y0_FrameData[11] VPWR VGND sg13cmos5l_antennanp
XANTENNA_2347 Tile_X0Y0_FrameData[11] VPWR VGND sg13cmos5l_antennanp
XANTENNA_2358 Tile_X0Y0_FrameData[11] VPWR VGND sg13cmos5l_antennanp
XANTENNA_1624 Tile_X0Y0_FrameData[4] VPWR VGND sg13cmos5l_antennanp
XANTENNA_1635 Tile_X0Y0_FrameData[4] VPWR VGND sg13cmos5l_antennanp
XANTENNA_1646 Tile_X0Y0_FrameData[4] VPWR VGND sg13cmos5l_antennanp
XANTENNA_2369 Tile_X0Y0_FrameData[11] VPWR VGND sg13cmos5l_antennanp
XANTENNA_1657 Tile_X0Y0_FrameData[4] VPWR VGND sg13cmos5l_antennanp
XANTENNA_1668 Tile_X0Y0_FrameData[4] VPWR VGND sg13cmos5l_antennanp
XANTENNA_1679 Tile_X0Y0_FrameData[4] VPWR VGND sg13cmos5l_antennanp
XFILLER_1_2422 VPWR VGND sg13cmos5l_fill_2
XFILLER_1_2400 VPWR VGND sg13cmos5l_decap_4
XFILLER_14_7 VPWR VGND sg13cmos5l_decap_8
X_1010_ Tile_X0Y0_S2BEGb[3] _1134_/X VPWR VGND sg13cmos5l_buf_1
XFILLER_1_2499 VPWR VGND sg13cmos5l_decap_8
XFILLER_1_1732 VPWR VGND sg13cmos5l_decap_8
XFILLER_15_2121 VPWR VGND sg13cmos5l_decap_8
XFILLER_8_63 VPWR VGND sg13cmos5l_decap_8
XFILLER_15_2198 VPWR VGND sg13cmos5l_decap_8
XFILLER_15_1464 VPWR VGND sg13cmos5l_decap_4
XFILLER_15_1453 VPWR VGND sg13cmos5l_fill_1
X_0725_ Tile_X1Y0_S4BEG[10] _1189_/X VPWR VGND sg13cmos5l_buf_1
X_0656_ _0656_/L_HI VPWR VGND sg13cmos5l_tiehi
XANTENNA_3560 Tile_X0Y0_FrameData[8] VPWR VGND sg13cmos5l_antennanp
XANTENNA_3571 Tile_X0Y0_FrameData[8] VPWR VGND sg13cmos5l_antennanp
XANTENNA_3582 Tile_X0Y0_FrameData[8] VPWR VGND sg13cmos5l_antennanp
XANTENNA_2870 Tile_X0Y0_FrameData[17] VPWR VGND sg13cmos5l_antennanp
XANTENNA_3593 Tile_X0Y0_FrameData[8] VPWR VGND sg13cmos5l_antennanp
X_0587_ _0587_/Q Tile_X0Y0_UserCLK NPU_RDATA15 _0620_/L_HI VPWR VGND sg13cmos5l_dfrbpq_1
XANTENNA_2881 Tile_X0Y0_FrameData[17] VPWR VGND sg13cmos5l_antennanp
XANTENNA_2892 Tile_X0Y0_FrameData[17] VPWR VGND sg13cmos5l_antennanp
XFILLER_6_1610 VPWR VGND sg13cmos5l_fill_2
XFILLER_6_2388 VPWR VGND sg13cmos5l_decap_8
XFILLER_6_1643 VPWR VGND sg13cmos5l_decap_8
X_1208_ _1208_/X Tile_X1Y0_N2END[5] Tile_X1Y0_N4END[13] Tile_X1Y0_NN4END[2] _0588_/Q
+ _0239_/Q _0238_/Q VPWR VGND sg13cmos5l_mux4_1
X_1139_ _1139_/X Tile_X0Y0_N2MID[0] Tile_X0Y0_N4END[15] Tile_X0Y0_NN4END[0] _0602_/Q
+ _0185_/Q _0184_/Q VPWR VGND sg13cmos5l_mux4_1
XFILLER_0_1264 VPWR VGND sg13cmos5l_fill_2
XFILLER_16_1228 VPWR VGND sg13cmos5l_decap_8
XFILLER_1_824 VPWR VGND sg13cmos5l_fill_2
XFILLER_5_1164 VPWR VGND sg13cmos5l_decap_8
XFILLER_2_2742 VPWR VGND sg13cmos5l_decap_8
XFILLER_16_2430 VPWR VGND sg13cmos5l_decap_8
XFILLER_12_2316 VPWR VGND sg13cmos5l_decap_8
XFILLER_16_1784 VPWR VGND sg13cmos5l_decap_8
XANTENNA_2100 Tile_X0Y0_FrameData[6] VPWR VGND sg13cmos5l_antennanp
X_0510_ _0510_/Q Tile_X0Y0_FrameData[27] VGND VPWR Tile_X4Y0_FrameStrobe[0] latch
XANTENNA_2111 Tile_X0Y0_FrameData[7] VPWR VGND sg13cmos5l_antennanp
XANTENNA_2122 Tile_X0Y0_FrameData[9] VPWR VGND sg13cmos5l_antennanp
XANTENNA_2133 Tile_X0Y0_FrameData[9] VPWR VGND sg13cmos5l_antennanp
XANTENNA_1410 Tile_X0Y0_FrameData[31] VPWR VGND sg13cmos5l_antennanp
XANTENNA_1421 Tile_X0Y0_FrameData[31] VPWR VGND sg13cmos5l_antennanp
XANTENNA_2144 Tile_X0Y0_FrameData[9] VPWR VGND sg13cmos5l_antennanp
XANTENNA_2155 Tile_X0Y0_FrameData[9] VPWR VGND sg13cmos5l_antennanp
XANTENNA_2166 Tile_X0Y0_FrameData[9] VPWR VGND sg13cmos5l_antennanp
X_0441_ _0441_/Q Tile_X0Y0_FrameData[0] VGND VPWR Tile_X3Y0_FrameStrobe[0] latch
XANTENNA_1432 Tile_X0Y0_FrameData[31] VPWR VGND sg13cmos5l_antennanp
XANTENNA_1443 Tile_X0Y0_FrameData[31] VPWR VGND sg13cmos5l_antennanp
XANTENNA_1454 Tile_X0Y0_FrameData[31] VPWR VGND sg13cmos5l_antennanp
XANTENNA_1465 Tile_X0Y0_FrameData[31] VPWR VGND sg13cmos5l_antennanp
XANTENNA_2177 Tile_X0Y0_FrameData[9] VPWR VGND sg13cmos5l_antennanp
XANTENNA_2188 Tile_X0Y0_FrameData[9] VPWR VGND sg13cmos5l_antennanp
XANTENNA_2199 Tile_X0Y0_FrameData[9] VPWR VGND sg13cmos5l_antennanp
X_0372_ _0372_/Q Tile_X0Y0_FrameData[5] VGND VPWR Tile_X2Y0_FrameStrobe[1] latch
XANTENNA_1476 Tile_X0Y0_FrameData[31] VPWR VGND sg13cmos5l_antennanp
XANTENNA_1487 Tile_X0Y0_FrameData[31] VPWR VGND sg13cmos5l_antennanp
XANTENNA_1498 Tile_X0Y0_FrameData[3] VPWR VGND sg13cmos5l_antennanp
XFILLER_7_2686 VPWR VGND sg13cmos5l_decap_8
XFILLER_16_791 VPWR VGND sg13cmos5l_decap_8
XFILLER_11_1147 VPWR VGND sg13cmos5l_decap_8
XANTENNA_4080 Tile_X1Y0_N2END[4] VPWR VGND sg13cmos5l_antennanp
XANTENNA_4091 Tile_X1Y0_N2END[7] VPWR VGND sg13cmos5l_antennanp
X_0708_ Tile_X1Y0_S2BEGb[1] _1172_/X VPWR VGND sg13cmos5l_buf_1
XANTENNA_3390 Tile_X0Y0_FrameData[21] VPWR VGND sg13cmos5l_antennanp
X_0639_ _0639_/L_HI VPWR VGND sg13cmos5l_tiehi
XFILLER_8_1727 VPWR VGND sg13cmos5l_decap_8
XFILLER_2_1315 VPWR VGND sg13cmos5l_fill_2
XANTENNA_307 Tile_X0Y0_FrameData[1] VPWR VGND sg13cmos5l_antennanp
XANTENNA_318 Tile_X0Y0_FrameData[1] VPWR VGND sg13cmos5l_antennanp
XANTENNA_329 Tile_X0Y0_FrameData[1] VPWR VGND sg13cmos5l_antennanp
XANTENNA__1070__X Tile_X4Y0_SS4BEG[7] VPWR VGND sg13cmos5l_antennanp
XFILLER_13_2636 VPWR VGND sg13cmos5l_decap_8
XFILLER_5_426 VPWR VGND sg13cmos5l_fill_1
XANTENNA_863 Tile_X0Y0_FrameData[27] VPWR VGND sg13cmos5l_antennanp
XANTENNA_852 Tile_X0Y0_FrameData[27] VPWR VGND sg13cmos5l_antennanp
XANTENNA_841 Tile_X0Y0_FrameData[27] VPWR VGND sg13cmos5l_antennanp
XANTENNA_830 Tile_X0Y0_FrameData[27] VPWR VGND sg13cmos5l_antennanp
XANTENNA_896 Tile_X0Y0_FrameData[27] VPWR VGND sg13cmos5l_antennanp
XANTENNA_885 Tile_X0Y0_FrameData[27] VPWR VGND sg13cmos5l_antennanp
XANTENNA_874 Tile_X0Y0_FrameData[27] VPWR VGND sg13cmos5l_antennanp
X_0990_ Tile_X0Y0_SS4BEG[15] _1170_/X VPWR VGND sg13cmos5l_buf_1
XFILLER_9_721 VPWR VGND sg13cmos5l_decap_4
XFILLER_16_2260 VPWR VGND sg13cmos5l_decap_8
XFILLER_13_783 VPWR VGND sg13cmos5l_decap_8
XFILLER_12_2113 VPWR VGND sg13cmos5l_decap_8
XFILLER_16_1570 VPWR VGND sg13cmos5l_decap_8
XFILLER_9_798 VPWR VGND sg13cmos5l_fill_1
XFILLER_5_42 VPWR VGND sg13cmos5l_decap_8
XFILLER_9_2759 VPWR VGND sg13cmos5l_fill_2
X_0424_ _0424_/Q Tile_X0Y0_FrameData[17] VGND VPWR Tile_X3Y0_FrameStrobe[0] latch
XANTENNA_1240 Tile_X0Y0_FrameData[30] VPWR VGND sg13cmos5l_antennanp
XANTENNA_1251 Tile_X0Y0_FrameData[30] VPWR VGND sg13cmos5l_antennanp
XANTENNA_1262 Tile_X0Y0_FrameData[30] VPWR VGND sg13cmos5l_antennanp
XANTENNA_1273 Tile_X0Y0_FrameData[30] VPWR VGND sg13cmos5l_antennanp
XFILLER_3_2325 VPWR VGND sg13cmos5l_decap_8
XFILLER_3_2303 VPWR VGND sg13cmos5l_fill_1
XANTENNA__0994__X Tile_X0Y0_S4BEG[3] VPWR VGND sg13cmos5l_antennanp
XANTENNA_1284 Tile_X0Y0_FrameData[30] VPWR VGND sg13cmos5l_antennanp
XANTENNA_1295 Tile_X0Y0_FrameData[30] VPWR VGND sg13cmos5l_antennanp
X_0355_ _0355_/Q Tile_X0Y0_FrameData[22] VGND VPWR Tile_X2Y0_FrameStrobe[1] latch
XFILLER_7_1771 VPWR VGND sg13cmos5l_decap_8
X_0286_ _0286_/Q Tile_X0Y0_FrameData[11] VGND VPWR Tile_X1Y0_FrameStrobe[2] latch
XFILLER_3_1635 VPWR VGND sg13cmos5l_decap_8
XFILLER_8_2203 VPWR VGND sg13cmos5l_decap_8
XANTENNA__1065__X Tile_X4Y0_SS4BEG[2] VPWR VGND sg13cmos5l_antennanp
XANTENNA_104 Tile_X0Y0_FrameData[0] VPWR VGND sg13cmos5l_antennanp
XANTENNA_115 Tile_X0Y0_FrameData[0] VPWR VGND sg13cmos5l_antennanp
XANTENNA_126 Tile_X0Y0_FrameData[0] VPWR VGND sg13cmos5l_antennanp
XANTENNA_137 Tile_X0Y0_FrameData[0] VPWR VGND sg13cmos5l_antennanp
XANTENNA_148 Tile_X0Y0_FrameData[10] VPWR VGND sg13cmos5l_antennanp
XANTENNA_159 Tile_X0Y0_FrameData[10] VPWR VGND sg13cmos5l_antennanp
XFILLER_14_536 VPWR VGND sg13cmos5l_decap_8
XFILLER_14_569 VPWR VGND sg13cmos5l_decap_8
XFILLER_13_2400 VPWR VGND sg13cmos5l_decap_8
XFILLER_14_84 VPWR VGND sg13cmos5l_decap_8
XFILLER_10_731 VPWR VGND sg13cmos5l_decap_8
XFILLER_13_2477 VPWR VGND sg13cmos5l_decap_8
XFILLER_13_1754 VPWR VGND sg13cmos5l_decap_8
XFILLER_7_1023 VPWR VGND sg13cmos5l_fill_1
XFILLER_4_2612 VPWR VGND sg13cmos5l_decap_8
X_0140_ _0140_/Q Tile_X0Y0_FrameData[13] VGND VPWR Tile_X0Y0_FrameStrobe[1] latch
XFILLER_4_2689 VPWR VGND sg13cmos5l_decap_8
XFILLER_4_1944 VPWR VGND sg13cmos5l_fill_1
XANTENNA_671 Tile_X0Y0_FrameData[24] VPWR VGND sg13cmos5l_antennanp
XANTENNA_660 Tile_X0Y0_FrameData[24] VPWR VGND sg13cmos5l_antennanp
XANTENNA_693 Tile_X0Y0_FrameData[24] VPWR VGND sg13cmos5l_antennanp
XANTENNA_682 Tile_X0Y0_FrameData[24] VPWR VGND sg13cmos5l_antennanp
XFILLER_13_580 VPWR VGND sg13cmos5l_decap_8
X_0973_ Tile_X1Y0_FrameStrobe_O[18] Tile_X1Y0_FrameStrobe[18] VPWR VGND sg13cmos5l_buf_1
XFILLER_14_1529 VPWR VGND sg13cmos5l_decap_8
XFILLER_9_595 VPWR VGND sg13cmos5l_decap_8
XFILLER_12_1231 VPWR VGND sg13cmos5l_decap_8
XANTENNA__0989__X Tile_X0Y0_SS4BEG[14] VPWR VGND sg13cmos5l_antennanp
XFILLER_9_2512 VPWR VGND sg13cmos5l_decap_8
XFILLER_3_2100 VPWR VGND sg13cmos5l_fill_1
XANTENNA_1070 Tile_X0Y0_FrameData[2] VPWR VGND sg13cmos5l_antennanp
XANTENNA_1081 Tile_X0Y0_FrameData[2] VPWR VGND sg13cmos5l_antennanp
X_0407_ _0407_/Q Tile_X0Y0_FrameData[2] VGND VPWR Tile_X2Y0_FrameStrobe[2] latch
XANTENNA_1092 Tile_X0Y0_FrameData[2] VPWR VGND sg13cmos5l_antennanp
X_0338_ _0338_/Q Tile_X0Y0_FrameData[7] VGND VPWR Tile_X2Y0_FrameStrobe[0] latch
X_0269_ _0269_/Q Tile_X0Y0_FrameData[28] VGND VPWR Tile_X1Y0_FrameStrobe[2] latch
XFILLER_11_517 VPWR VGND sg13cmos5l_decap_8
XFILLER_14_2742 VPWR VGND sg13cmos5l_decap_4
XFILLER_10_2606 VPWR VGND sg13cmos5l_decap_8
XANTENNA__0899__X Tile_X2Y0_SS4BEG[0] VPWR VGND sg13cmos5l_antennanp
XFILLER_15_2517 VPWR VGND sg13cmos5l_decap_8
XFILLER_13_2274 VPWR VGND sg13cmos5l_decap_8
XFILLER_10_550 VPWR VGND sg13cmos5l_decap_8
XFILLER_6_521 VPWR VGND sg13cmos5l_decap_8
XFILLER_13_1551 VPWR VGND sg13cmos5l_decap_8
XANTENNA_3901 Tile_X0Y0_FrameData[18] VPWR VGND sg13cmos5l_antennanp
XANTENNA_3912 Tile_X0Y0_FrameData[18] VPWR VGND sg13cmos5l_antennanp
XANTENNA_3923 Tile_X0Y0_FrameData[18] VPWR VGND sg13cmos5l_antennanp
XFILLER_6_565 VPWR VGND sg13cmos5l_decap_8
XANTENNA_3934 Tile_X0Y0_FrameData[18] VPWR VGND sg13cmos5l_antennanp
XANTENNA_3945 Tile_X0Y0_FrameData[18] VPWR VGND sg13cmos5l_antennanp
XANTENNA_3956 Tile_X0Y0_FrameData[18] VPWR VGND sg13cmos5l_antennanp
XANTENNA_3967 Tile_X0Y0_FrameData[18] VPWR VGND sg13cmos5l_antennanp
XANTENNA_3978 Tile_X0Y0_FrameData[18] VPWR VGND sg13cmos5l_antennanp
XANTENNA_3989 Tile_X0Y0_FrameData[18] VPWR VGND sg13cmos5l_antennanp
XFILLER_6_2718 VPWR VGND sg13cmos5l_decap_8
X_1241_ _1241_/X Tile_X2Y0_N2END[6] Tile_X2Y0_N4END[6] Tile_X2Y0_NN4END[9] _0585_/Q
+ _0349_/Q _0348_/Q VPWR VGND sg13cmos5l_mux4_1
XFILLER_2_21 VPWR VGND sg13cmos5l_decap_8
X_1172_ _1172_/X Tile_X1Y0_N1END[1] Tile_X1Y0_N2MID[1] Tile_X1Y0_N2END[6] _0589_/Q
+ _0311_/Q _0310_/Q VPWR VGND sg13cmos5l_mux4_1
XFILLER_4_2464 VPWR VGND sg13cmos5l_decap_8
XFILLER_2_65 VPWR VGND sg13cmos5l_fill_1
X_0123_ _0123_/Q Tile_X0Y0_FrameData[30] VGND VPWR Tile_X0Y0_FrameStrobe[1] latch
XFILLER_14_2027 VPWR VGND sg13cmos5l_decap_8
XANTENNA_490 Tile_X0Y0_FrameData[23] VPWR VGND sg13cmos5l_antennanp
XANTENNA_15 NPU_RDATA2 VPWR VGND sg13cmos5l_antennanp
XANTENNA_26 NPU_RDATA28 VPWR VGND sg13cmos5l_antennanp
XANTENNA_37 Tile_X0Y0_FrameData[0] VPWR VGND sg13cmos5l_antennanp
XANTENNA_48 Tile_X0Y0_FrameData[0] VPWR VGND sg13cmos5l_antennanp
X_0956_ Tile_X1Y0_FrameStrobe_O[1] Tile_X1Y0_FrameStrobe[1] VPWR VGND sg13cmos5l_buf_1
XANTENNA_59 Tile_X0Y0_FrameData[0] VPWR VGND sg13cmos5l_antennanp
X_0887_ Tile_X2Y0_S4BEG[4] _1223_/X VPWR VGND sg13cmos5l_buf_1
XFILLER_9_2386 VPWR VGND sg13cmos5l_decap_8
XFILLER_5_2228 VPWR VGND sg13cmos5l_decap_8
XFILLER_5_1549 VPWR VGND sg13cmos5l_fill_1
XFILLER_15_119 VPWR VGND sg13cmos5l_decap_8
XFILLER_14_2550 VPWR VGND sg13cmos5l_fill_1
XFILLER_10_2436 VPWR VGND sg13cmos5l_decap_8
XANTENNA_3208 Tile_X0Y0_FrameData[20] VPWR VGND sg13cmos5l_antennanp
XFILLER_14_1893 VPWR VGND sg13cmos5l_fill_2
XFILLER_10_1713 VPWR VGND sg13cmos5l_decap_8
XANTENNA_2507 Tile_X0Y0_FrameData[12] VPWR VGND sg13cmos5l_antennanp
XANTENNA_3219 Tile_X0Y0_FrameData[20] VPWR VGND sg13cmos5l_antennanp
XFILLER_11_74 VPWR VGND sg13cmos5l_decap_8
XFILLER_10_1768 VPWR VGND sg13cmos5l_decap_4
XFILLER_10_1757 VPWR VGND sg13cmos5l_fill_1
XANTENNA_2518 Tile_X0Y0_FrameData[12] VPWR VGND sg13cmos5l_antennanp
XANTENNA_2529 Tile_X0Y0_FrameData[12] VPWR VGND sg13cmos5l_antennanp
XFILLER_3_579 VPWR VGND sg13cmos5l_decap_8
XANTENNA_1806 Tile_X0Y0_FrameData[5] VPWR VGND sg13cmos5l_antennanp
XANTENNA_1817 Tile_X0Y0_FrameData[5] VPWR VGND sg13cmos5l_antennanp
XANTENNA_1828 Tile_X0Y0_FrameData[5] VPWR VGND sg13cmos5l_antennanp
XANTENNA_1839 Tile_X0Y0_FrameData[5] VPWR VGND sg13cmos5l_antennanp
XFILLER_8_1151 VPWR VGND sg13cmos5l_decap_8
XFILLER_15_664 VPWR VGND sg13cmos5l_decap_8
XFILLER_15_653 VPWR VGND sg13cmos5l_fill_1
XFILLER_15_2303 VPWR VGND sg13cmos5l_decap_8
XFILLER_14_196 VPWR VGND sg13cmos5l_decap_8
X_0810_ Tile_X3Y0_SS4BEG[15] _1290_/X VPWR VGND sg13cmos5l_buf_1
X_0741_ Tile_X1Y0_SS4BEG[10] _1205_/X VPWR VGND sg13cmos5l_buf_1
XFILLER_15_1668 VPWR VGND sg13cmos5l_decap_8
XFILLER_13_2082 VPWR VGND sg13cmos5l_decap_8
XANTENNA_3720 Tile_X1Y0_N4END[3] VPWR VGND sg13cmos5l_antennanp
XANTENNA_3731 Tile_X1Y0_NN4END[0] VPWR VGND sg13cmos5l_antennanp
X_0672_ _0672_/L_HI VPWR VGND sg13cmos5l_tiehi
XANTENNA_3742 Tile_X2Y0_N2END[4] VPWR VGND sg13cmos5l_antennanp
XANTENNA_3753 Tile_X3Y0_N4END[4] VPWR VGND sg13cmos5l_antennanp
XANTENNA_3764 Tile_X3Y0_NN4END[5] VPWR VGND sg13cmos5l_antennanp
XANTENNA_3775 Tile_X0Y0_FrameData[18] VPWR VGND sg13cmos5l_antennanp
XANTENNA_3786 Tile_X0Y0_FrameData[18] VPWR VGND sg13cmos5l_antennanp
XANTENNA_3797 Tile_X0Y0_FrameData[18] VPWR VGND sg13cmos5l_antennanp
XFILLER_6_1814 VPWR VGND sg13cmos5l_fill_1
X_1224_ _1224_/X Tile_X2Y0_N2MID[5] Tile_X2Y0_N4END[10] Tile_X2Y0_NN4END[5] _0585_/Q
+ _0383_/Q _0382_/Q VPWR VGND sg13cmos5l_mux4_1
XFILLER_4_2283 VPWR VGND sg13cmos5l_decap_8
X_1155_ _1155_/X Tile_X0Y0_N2END[0] Tile_X0Y0_N4END[0] Tile_X0Y0_NN4END[15] _0603_/Q
+ _0153_/Q _0152_/Q VPWR VGND sg13cmos5l_mux4_1
X_0106_ _0106_/Q Tile_X0Y0_FrameData[15] VGND VPWR Tile_X0Y0_FrameStrobe[0] latch
X_1086_ _1086_/X Tile_X2Y0_N1END[2] Tile_X2Y0_N2MID[1] Tile_X2Y0_N2MID[6] Tile_X2Y0_N2END[1]
+ _0317_/Q _0316_/Q VPWR VGND sg13cmos5l_mux4_1
XFILLER_14_1156 VPWR VGND sg13cmos5l_fill_1
XFILLER_14_1145 VPWR VGND sg13cmos5l_decap_8
XFILLER_11_2723 VPWR VGND sg13cmos5l_decap_8
X_0939_ Tile_X2Y0_FrameStrobe_O[4] Tile_X2Y0_FrameStrobe[4] VPWR VGND sg13cmos5l_buf_1
XFILLER_14_1167 VPWR VGND sg13cmos5l_decap_8
XANTENNA__1073__X Tile_X4Y0_SS4BEG[10] VPWR VGND sg13cmos5l_antennanp
XFILLER_5_1357 VPWR VGND sg13cmos5l_fill_2
XFILLER_16_2634 VPWR VGND sg13cmos5l_decap_8
XFILLER_11_111 VPWR VGND sg13cmos5l_decap_8
XFILLER_8_605 VPWR VGND sg13cmos5l_decap_8
XFILLER_11_133 VPWR VGND sg13cmos5l_decap_8
XFILLER_14_2380 VPWR VGND sg13cmos5l_decap_8
XFILLER_11_177 VPWR VGND sg13cmos5l_fill_1
XFILLER_10_2233 VPWR VGND sg13cmos5l_decap_8
XANTENNA_3005 Tile_X0Y0_FrameData[19] VPWR VGND sg13cmos5l_antennanp
XANTENNA_3016 Tile_X0Y0_FrameData[19] VPWR VGND sg13cmos5l_antennanp
XANTENNA_3027 Tile_X0Y0_FrameData[19] VPWR VGND sg13cmos5l_antennanp
XFILLER_14_1690 VPWR VGND sg13cmos5l_decap_8
XANTENNA_2304 Tile_X0Y0_N4END[0] VPWR VGND sg13cmos5l_antennanp
XANTENNA_2315 Tile_X2Y0_N4END[12] VPWR VGND sg13cmos5l_antennanp
XANTENNA_3038 Tile_X0Y0_FrameData[19] VPWR VGND sg13cmos5l_antennanp
XANTENNA_3049 Tile_X0Y0_FrameData[19] VPWR VGND sg13cmos5l_antennanp
XFILLER_10_1587 VPWR VGND sg13cmos5l_decap_8
XANTENNA_1603 Tile_X0Y0_FrameData[4] VPWR VGND sg13cmos5l_antennanp
XANTENNA_1614 Tile_X0Y0_FrameData[4] VPWR VGND sg13cmos5l_antennanp
XANTENNA_2326 Tile_X0Y0_FrameData[11] VPWR VGND sg13cmos5l_antennanp
XANTENNA_2337 Tile_X0Y0_FrameData[11] VPWR VGND sg13cmos5l_antennanp
XANTENNA_2348 Tile_X0Y0_FrameData[11] VPWR VGND sg13cmos5l_antennanp
XFILLER_7_2802 VPWR VGND sg13cmos5l_fill_1
XFILLER_0_0 VPWR VGND sg13cmos5l_decap_8
XANTENNA_1625 Tile_X0Y0_FrameData[4] VPWR VGND sg13cmos5l_antennanp
XANTENNA_1636 Tile_X0Y0_FrameData[4] VPWR VGND sg13cmos5l_antennanp
XANTENNA_1647 Tile_X0Y0_FrameData[4] VPWR VGND sg13cmos5l_antennanp
XANTENNA_2359 Tile_X0Y0_FrameData[11] VPWR VGND sg13cmos5l_antennanp
XANTENNA_1658 Tile_X0Y0_FrameData[4] VPWR VGND sg13cmos5l_antennanp
XANTENNA_1669 Tile_X0Y0_FrameData[4] VPWR VGND sg13cmos5l_antennanp
XFILLER_1_1711 VPWR VGND sg13cmos5l_decap_8
XFILLER_1_2478 VPWR VGND sg13cmos5l_decap_8
XFILLER_15_2100 VPWR VGND sg13cmos5l_decap_8
XFILLER_15_494 VPWR VGND sg13cmos5l_fill_1
XFILLER_8_42 VPWR VGND sg13cmos5l_decap_8
XFILLER_15_2177 VPWR VGND sg13cmos5l_decap_8
XFILLER_15_1421 VPWR VGND sg13cmos5l_decap_4
X_0724_ Tile_X1Y0_S4BEG[9] _1188_/X VPWR VGND sg13cmos5l_buf_1
X_0655_ _0655_/L_HI VPWR VGND sg13cmos5l_tiehi
XANTENNA__0997__X Tile_X0Y0_S4BEG[6] VPWR VGND sg13cmos5l_antennanp
XANTENNA_3550 Tile_X0Y0_FrameData[8] VPWR VGND sg13cmos5l_antennanp
XANTENNA_3561 Tile_X0Y0_FrameData[8] VPWR VGND sg13cmos5l_antennanp
XANTENNA_3572 Tile_X0Y0_FrameData[8] VPWR VGND sg13cmos5l_antennanp
XANTENNA_3583 Tile_X0Y0_FrameData[8] VPWR VGND sg13cmos5l_antennanp
XANTENNA_2860 Tile_X0Y0_FrameData[17] VPWR VGND sg13cmos5l_antennanp
XANTENNA_2871 Tile_X0Y0_FrameData[17] VPWR VGND sg13cmos5l_antennanp
XANTENNA_3594 Tile_X0Y0_FrameData[8] VPWR VGND sg13cmos5l_antennanp
X_0586_ _0586_/Q Tile_X0Y0_UserCLK NPU_RDATA14 _0623_/L_HI VPWR VGND sg13cmos5l_dfrbpq_1
XFILLER_6_2334 VPWR VGND sg13cmos5l_decap_8
XANTENNA_2882 Tile_X0Y0_FrameData[17] VPWR VGND sg13cmos5l_antennanp
XANTENNA_2893 Tile_X0Y0_FrameData[17] VPWR VGND sg13cmos5l_antennanp
XFILLER_6_2367 VPWR VGND sg13cmos5l_decap_8
X_1207_ _1207_/X Tile_X1Y0_N2END[4] Tile_X1Y0_N4END[12] Tile_X1Y0_NN4END[3] _0589_/Q
+ _0241_/Q _0240_/Q VPWR VGND sg13cmos5l_mux4_1
XFILLER_6_1699 VPWR VGND sg13cmos5l_decap_8
X_1138_ _1138_/X Tile_X0Y0_N1END[3] Tile_X0Y0_N2MID[7] Tile_X0Y0_N2END[0] _0603_/Q
+ _0187_/Q _0186_/Q VPWR VGND sg13cmos5l_mux4_1
X_1069_ Tile_X4Y0_SS4BEG[6] Tile_X4Y0_NN4END[9] VPWR VGND sg13cmos5l_buf_1
XFILLER_16_1218 VPWR VGND sg13cmos5l_decap_8
XFILLER_11_2520 VPWR VGND sg13cmos5l_decap_8
XANTENNA__1068__X Tile_X4Y0_SS4BEG[5] VPWR VGND sg13cmos5l_antennanp
XFILLER_11_2597 VPWR VGND sg13cmos5l_decap_8
XFILLER_11_1830 VPWR VGND sg13cmos5l_decap_8
XANTENNA__0700__X Tile_X0Y0_FrameStrobe_O[13] VPWR VGND sg13cmos5l_antennanp
XFILLER_2_2721 VPWR VGND sg13cmos5l_decap_8
XFILLER_5_1143 VPWR VGND sg13cmos5l_decap_8
XFILLER_16_214 VPWR VGND sg13cmos5l_decap_8
XFILLER_9_936 VPWR VGND sg13cmos5l_fill_1
XFILLER_16_2486 VPWR VGND sg13cmos5l_decap_8
XFILLER_16_1763 VPWR VGND sg13cmos5l_decap_8
XFILLER_13_998 VPWR VGND sg13cmos5l_fill_2
XFILLER_12_1649 VPWR VGND sg13cmos5l_decap_8
XANTENNA_2101 Tile_X0Y0_FrameData[6] VPWR VGND sg13cmos5l_antennanp
XANTENNA_2112 Tile_X0Y0_FrameData[7] VPWR VGND sg13cmos5l_antennanp
XANTENNA_2123 Tile_X0Y0_FrameData[9] VPWR VGND sg13cmos5l_antennanp
XANTENNA_1400 Tile_X0Y0_FrameData[31] VPWR VGND sg13cmos5l_antennanp
XANTENNA_1411 Tile_X0Y0_FrameData[31] VPWR VGND sg13cmos5l_antennanp
XANTENNA_1422 Tile_X0Y0_FrameData[31] VPWR VGND sg13cmos5l_antennanp
XANTENNA_2134 Tile_X0Y0_FrameData[9] VPWR VGND sg13cmos5l_antennanp
XANTENNA_2145 Tile_X0Y0_FrameData[9] VPWR VGND sg13cmos5l_antennanp
XANTENNA_2156 Tile_X0Y0_FrameData[9] VPWR VGND sg13cmos5l_antennanp
XANTENNA_2167 Tile_X0Y0_FrameData[9] VPWR VGND sg13cmos5l_antennanp
X_0440_ _0440_/Q Tile_X0Y0_FrameData[1] VGND VPWR Tile_X3Y0_FrameStrobe[0] latch
XANTENNA_1433 Tile_X0Y0_FrameData[31] VPWR VGND sg13cmos5l_antennanp
XANTENNA_1444 Tile_X0Y0_FrameData[31] VPWR VGND sg13cmos5l_antennanp
XANTENNA_1455 Tile_X0Y0_FrameData[31] VPWR VGND sg13cmos5l_antennanp
XANTENNA_2178 Tile_X0Y0_FrameData[9] VPWR VGND sg13cmos5l_antennanp
XANTENNA_2189 Tile_X0Y0_FrameData[9] VPWR VGND sg13cmos5l_antennanp
X_0371_ _0371_/Q Tile_X0Y0_FrameData[6] VGND VPWR Tile_X2Y0_FrameStrobe[1] latch
XFILLER_7_2665 VPWR VGND sg13cmos5l_decap_8
XANTENNA_1466 Tile_X0Y0_FrameData[31] VPWR VGND sg13cmos5l_antennanp
XANTENNA_1477 Tile_X0Y0_FrameData[31] VPWR VGND sg13cmos5l_antennanp
XANTENNA_1488 Tile_X0Y0_FrameData[31] VPWR VGND sg13cmos5l_antennanp
XANTENNA_1499 Tile_X0Y0_FrameData[3] VPWR VGND sg13cmos5l_antennanp
XFILLER_1_2286 VPWR VGND sg13cmos5l_fill_1
XFILLER_1_2275 VPWR VGND sg13cmos5l_decap_8
XFILLER_16_770 VPWR VGND sg13cmos5l_decap_8
XFILLER_11_1126 VPWR VGND sg13cmos5l_decap_8
X_0707_ Tile_X1Y0_S2BEGb[0] _1171_/X VPWR VGND sg13cmos5l_buf_1
XANTENNA_4070 Tile_X0Y0_NN4END[2] VPWR VGND sg13cmos5l_antennanp
XANTENNA_4081 Tile_X1Y0_N2END[4] VPWR VGND sg13cmos5l_antennanp
XANTENNA_4092 Tile_X1Y0_N2END[7] VPWR VGND sg13cmos5l_antennanp
XANTENNA_3380 Tile_X0Y0_FrameData[21] VPWR VGND sg13cmos5l_antennanp
XANTENNA_3391 Tile_X0Y0_FrameData[21] VPWR VGND sg13cmos5l_antennanp
X_0638_ _0638_/L_HI VPWR VGND sg13cmos5l_tiehi
XFILLER_8_1706 VPWR VGND sg13cmos5l_decap_8
X_0569_ NPU_ADDR5 Tile_X0Y0_UserCLK _1085_/X _0672_/L_HI VPWR VGND sg13cmos5l_dfrbpq_1
XANTENNA_2690 Tile_X0Y0_FrameData[14] VPWR VGND sg13cmos5l_antennanp
XANTENNA_308 Tile_X0Y0_FrameData[1] VPWR VGND sg13cmos5l_antennanp
XANTENNA_319 Tile_X0Y0_FrameData[1] VPWR VGND sg13cmos5l_antennanp
XFILLER_13_2615 VPWR VGND sg13cmos5l_decap_8
XFILLER_11_2394 VPWR VGND sg13cmos5l_decap_8
XFILLER_1_677 VPWR VGND sg13cmos5l_fill_2
XFILLER_0_132 VPWR VGND sg13cmos5l_fill_2
XANTENNA_820 Tile_X0Y0_FrameData[27] VPWR VGND sg13cmos5l_antennanp
XFILLER_2_1894 VPWR VGND sg13cmos5l_fill_1
XANTENNA_853 Tile_X0Y0_FrameData[27] VPWR VGND sg13cmos5l_antennanp
XANTENNA_842 Tile_X0Y0_FrameData[27] VPWR VGND sg13cmos5l_antennanp
XANTENNA_831 Tile_X0Y0_FrameData[27] VPWR VGND sg13cmos5l_antennanp
XANTENNA_886 Tile_X0Y0_FrameData[27] VPWR VGND sg13cmos5l_antennanp
XANTENNA_875 Tile_X0Y0_FrameData[27] VPWR VGND sg13cmos5l_antennanp
XANTENNA_864 Tile_X0Y0_FrameData[27] VPWR VGND sg13cmos5l_antennanp
XFILLER_9_700 VPWR VGND sg13cmos5l_decap_8
XFILLER_13_762 VPWR VGND sg13cmos5l_decap_8
XANTENNA_897 Tile_X0Y0_FrameData[27] VPWR VGND sg13cmos5l_antennanp
XFILLER_16_2294 VPWR VGND sg13cmos5l_fill_1
XFILLER_12_2169 VPWR VGND sg13cmos5l_decap_8
XFILLER_5_21 VPWR VGND sg13cmos5l_decap_8
XFILLER_10_1170 VPWR VGND sg13cmos5l_fill_1
XFILLER_9_2738 VPWR VGND sg13cmos5l_decap_8
XANTENNA_1230 Tile_X0Y0_FrameData[30] VPWR VGND sg13cmos5l_antennanp
X_0423_ _0423_/Q Tile_X0Y0_FrameData[18] VGND VPWR Tile_X3Y0_FrameStrobe[0] latch
XANTENNA_1241 Tile_X0Y0_FrameData[30] VPWR VGND sg13cmos5l_antennanp
XANTENNA_1252 Tile_X0Y0_FrameData[30] VPWR VGND sg13cmos5l_antennanp
XANTENNA_1263 Tile_X0Y0_FrameData[30] VPWR VGND sg13cmos5l_antennanp
XANTENNA_1274 Tile_X0Y0_FrameData[30] VPWR VGND sg13cmos5l_antennanp
XANTENNA_1285 Tile_X0Y0_FrameData[30] VPWR VGND sg13cmos5l_antennanp
XANTENNA_1296 Tile_X0Y0_FrameData[30] VPWR VGND sg13cmos5l_antennanp
X_0354_ _0354_/Q Tile_X0Y0_FrameData[23] VGND VPWR Tile_X2Y0_FrameStrobe[1] latch
XFILLER_7_2495 VPWR VGND sg13cmos5l_decap_8
XFILLER_7_1750 VPWR VGND sg13cmos5l_decap_8
XFILLER_3_1614 VPWR VGND sg13cmos5l_decap_8
X_0285_ _0285_/Q Tile_X0Y0_FrameData[12] VGND VPWR Tile_X1Y0_FrameStrobe[2] latch
XFILLER_7_1794 VPWR VGND sg13cmos5l_fill_1
XFILLER_12_1980 VPWR VGND sg13cmos5l_fill_2
XANTENNA_105 Tile_X0Y0_FrameData[0] VPWR VGND sg13cmos5l_antennanp
XANTENNA_116 Tile_X0Y0_FrameData[0] VPWR VGND sg13cmos5l_antennanp
XANTENNA_127 Tile_X0Y0_FrameData[0] VPWR VGND sg13cmos5l_antennanp
XANTENNA_138 Tile_X0Y0_FrameData[0] VPWR VGND sg13cmos5l_antennanp
XANTENNA_149 Tile_X0Y0_FrameData[10] VPWR VGND sg13cmos5l_antennanp
XFILLER_14_63 VPWR VGND sg13cmos5l_decap_8
XFILLER_10_710 VPWR VGND sg13cmos5l_decap_8
XFILLER_13_2456 VPWR VGND sg13cmos5l_decap_8
XFILLER_13_1733 VPWR VGND sg13cmos5l_decap_8
XFILLER_11_2191 VPWR VGND sg13cmos5l_decap_8
XFILLER_4_2668 VPWR VGND sg13cmos5l_decap_8
XFILLER_4_1956 VPWR VGND sg13cmos5l_fill_1
XANTENNA_661 Tile_X0Y0_FrameData[24] VPWR VGND sg13cmos5l_antennanp
XANTENNA_650 Tile_X0Y0_FrameData[23] VPWR VGND sg13cmos5l_antennanp
XFILLER_14_2209 VPWR VGND sg13cmos5l_decap_8
XANTENNA_694 Tile_X0Y0_FrameData[24] VPWR VGND sg13cmos5l_antennanp
XANTENNA_683 Tile_X0Y0_FrameData[24] VPWR VGND sg13cmos5l_antennanp
XANTENNA_672 Tile_X0Y0_FrameData[24] VPWR VGND sg13cmos5l_antennanp
X_0972_ Tile_X1Y0_FrameStrobe_O[17] Tile_X1Y0_FrameStrobe[17] VPWR VGND sg13cmos5l_buf_1
XFILLER_14_1508 VPWR VGND sg13cmos5l_decap_8
XFILLER_9_574 VPWR VGND sg13cmos5l_decap_8
XFILLER_12_1210 VPWR VGND sg13cmos5l_decap_8
XFILLER_12_1287 VPWR VGND sg13cmos5l_decap_4
XANTENNA_1060 Tile_X0Y0_FrameData[29] VPWR VGND sg13cmos5l_antennanp
XANTENNA_1071 Tile_X0Y0_FrameData[2] VPWR VGND sg13cmos5l_antennanp
X_0406_ _0406_/Q Tile_X0Y0_FrameData[3] VGND VPWR Tile_X2Y0_FrameStrobe[2] latch
XFILLER_5_1709 VPWR VGND sg13cmos5l_decap_8
XANTENNA_1082 Tile_X0Y0_FrameData[2] VPWR VGND sg13cmos5l_antennanp
XANTENNA_1093 Tile_X0Y0_FrameData[2] VPWR VGND sg13cmos5l_antennanp
X_0337_ _0337_/Q Tile_X0Y0_FrameData[8] VGND VPWR Tile_X2Y0_FrameStrobe[0] latch
X_0268_ _0268_/Q Tile_X0Y0_FrameData[29] VGND VPWR Tile_X1Y0_FrameStrobe[2] latch
X_0199_ _0199_/Q Tile_X0Y0_FrameData[18] VGND VPWR Tile_X0Y0_FrameStrobe[3] latch
XFILLER_14_2721 VPWR VGND sg13cmos5l_decap_8
XANTENNA__1076__X Tile_X4Y0_SS4BEG[13] VPWR VGND sg13cmos5l_antennanp
XFILLER_4_7 VPWR VGND sg13cmos5l_decap_8
XFILLER_13_2264 VPWR VGND sg13cmos5l_decap_4
XFILLER_13_1530 VPWR VGND sg13cmos5l_decap_8
XANTENNA_3902 Tile_X0Y0_FrameData[18] VPWR VGND sg13cmos5l_antennanp
XANTENNA_3913 Tile_X0Y0_FrameData[18] VPWR VGND sg13cmos5l_antennanp
XANTENNA_3924 Tile_X0Y0_FrameData[18] VPWR VGND sg13cmos5l_antennanp
XANTENNA_3935 Tile_X0Y0_FrameData[18] VPWR VGND sg13cmos5l_antennanp
XANTENNA_3946 Tile_X0Y0_FrameData[18] VPWR VGND sg13cmos5l_antennanp
XANTENNA_3957 Tile_X0Y0_FrameData[18] VPWR VGND sg13cmos5l_antennanp
XANTENNA_3968 Tile_X0Y0_FrameData[18] VPWR VGND sg13cmos5l_antennanp
XANTENNA_3979 Tile_X0Y0_FrameData[18] VPWR VGND sg13cmos5l_antennanp
X_1240_ _1240_/X Tile_X2Y0_N2END[5] Tile_X2Y0_N4END[5] Tile_X2Y0_NN4END[10] _0584_/Q
+ _0351_/Q _0350_/Q VPWR VGND sg13cmos5l_mux4_1
X_1171_ _1171_/X Tile_X1Y0_N1END[0] Tile_X1Y0_N2MID[0] Tile_X1Y0_N2END[7] _0588_/Q
+ _0313_/Q _0312_/Q VPWR VGND sg13cmos5l_mux4_1
XFILLER_4_2454 VPWR VGND sg13cmos5l_decap_8
X_0122_ _0122_/Q Tile_X0Y0_FrameData[31] VGND VPWR Tile_X0Y0_FrameStrobe[1] latch
XANTENNA_480 Tile_X0Y0_FrameData[23] VPWR VGND sg13cmos5l_antennanp
XANTENNA_491 Tile_X0Y0_FrameData[23] VPWR VGND sg13cmos5l_antennanp
XANTENNA_16 NPU_RDATA20 VPWR VGND sg13cmos5l_antennanp
XANTENNA_27 NPU_RDATA29 VPWR VGND sg13cmos5l_antennanp
XANTENNA_38 Tile_X0Y0_FrameData[0] VPWR VGND sg13cmos5l_antennanp
X_0955_ Tile_X1Y0_FrameStrobe_O[0] Tile_X1Y0_FrameStrobe[0] VPWR VGND sg13cmos5l_buf_1
XANTENNA_49 Tile_X0Y0_FrameData[0] VPWR VGND sg13cmos5l_antennanp
X_0886_ Tile_X2Y0_S4BEG[3] _1222_/X VPWR VGND sg13cmos5l_buf_1
XFILLER_12_1062 VPWR VGND sg13cmos5l_decap_8
XFILLER_12_1084 VPWR VGND sg13cmos5l_decap_8
XFILLER_9_1620 VPWR VGND sg13cmos5l_fill_1
XFILLER_9_2365 VPWR VGND sg13cmos5l_decap_8
XFILLER_5_2207 VPWR VGND sg13cmos5l_decap_8
XFILLER_5_1506 VPWR VGND sg13cmos5l_fill_2
XFILLER_9_1697 VPWR VGND sg13cmos5l_decap_8
XFILLER_5_1517 VPWR VGND sg13cmos5l_fill_1
XFILLER_14_2540 VPWR VGND sg13cmos5l_fill_1
XFILLER_14_2595 VPWR VGND sg13cmos5l_decap_8
XFILLER_10_2415 VPWR VGND sg13cmos5l_decap_8
XANTENNA__0703__X Tile_X0Y0_FrameStrobe_O[16] VPWR VGND sg13cmos5l_antennanp
XANTENNA_3209 Tile_X0Y0_FrameData[20] VPWR VGND sg13cmos5l_antennanp
XFILLER_14_1872 VPWR VGND sg13cmos5l_decap_8
XFILLER_11_42 VPWR VGND sg13cmos5l_fill_1
XFILLER_11_53 VPWR VGND sg13cmos5l_decap_8
XANTENNA_2508 Tile_X0Y0_FrameData[12] VPWR VGND sg13cmos5l_antennanp
XANTENNA_2519 Tile_X0Y0_FrameData[12] VPWR VGND sg13cmos5l_antennanp
XFILLER_3_558 VPWR VGND sg13cmos5l_decap_8
XANTENNA_1807 Tile_X0Y0_FrameData[5] VPWR VGND sg13cmos5l_antennanp
XANTENNA_1818 Tile_X0Y0_FrameData[5] VPWR VGND sg13cmos5l_antennanp
XANTENNA_1829 Tile_X0Y0_FrameData[5] VPWR VGND sg13cmos5l_antennanp
XFILLER_8_1130 VPWR VGND sg13cmos5l_decap_8
XFILLER_5_2763 VPWR VGND sg13cmos5l_decap_8
XFILLER_1_2605 VPWR VGND sg13cmos5l_decap_8
XFILLER_4_1027 VPWR VGND sg13cmos5l_fill_2
XFILLER_1_2649 VPWR VGND sg13cmos5l_decap_8
XFILLER_14_175 VPWR VGND sg13cmos5l_decap_8
XFILLER_15_1647 VPWR VGND sg13cmos5l_decap_8
X_0740_ Tile_X1Y0_SS4BEG[9] _1204_/X VPWR VGND sg13cmos5l_buf_1
XFILLER_13_2061 VPWR VGND sg13cmos5l_decap_8
XANTENNA_3710 Tile_X1Y0_N4END[2] VPWR VGND sg13cmos5l_antennanp
XANTENNA_3721 Tile_X1Y0_N4END[3] VPWR VGND sg13cmos5l_antennanp
XANTENNA_3732 Tile_X1Y0_NN4END[0] VPWR VGND sg13cmos5l_antennanp
X_0671_ _0671_/L_HI VPWR VGND sg13cmos5l_tiehi
XANTENNA_3743 Tile_X2Y0_N2END[4] VPWR VGND sg13cmos5l_antennanp
XANTENNA_3754 Tile_X3Y0_N4END[4] VPWR VGND sg13cmos5l_antennanp
XANTENNA_3765 Tile_X0Y0_FrameData[18] VPWR VGND sg13cmos5l_antennanp
XANTENNA_3776 Tile_X0Y0_FrameData[18] VPWR VGND sg13cmos5l_antennanp
XANTENNA_3787 Tile_X0Y0_FrameData[18] VPWR VGND sg13cmos5l_antennanp
XANTENNA_3798 Tile_X0Y0_FrameData[18] VPWR VGND sg13cmos5l_antennanp
XFILLER_2_591 VPWR VGND sg13cmos5l_decap_8
X_1223_ _1223_/X Tile_X2Y0_N2MID[4] Tile_X2Y0_N4END[11] Tile_X2Y0_NN4END[4] _0584_/Q
+ _0385_/Q _0384_/Q VPWR VGND sg13cmos5l_mux4_1
XFILLER_4_2262 VPWR VGND sg13cmos5l_decap_8
X_1154_ _1154_/X Tile_X0Y0_N2MID[7] Tile_X0Y0_N4END[0] Tile_X0Y0_NN4END[15] _0597_/Q
+ _0155_/Q _0154_/Q VPWR VGND sg13cmos5l_mux4_1
X_0105_ _0105_/Q Tile_X0Y0_FrameData[16] VGND VPWR Tile_X0Y0_FrameStrobe[0] latch
X_1085_ _1085_/X Tile_X2Y0_N1END[1] Tile_X2Y0_N2MID[2] Tile_X2Y0_N2MID[5] Tile_X2Y0_N2END[2]
+ _0319_/Q _0318_/Q VPWR VGND sg13cmos5l_mux4_1
XFILLER_0_1414 VPWR VGND sg13cmos5l_fill_1
XFILLER_11_2702 VPWR VGND sg13cmos5l_decap_8
X_0938_ Tile_X2Y0_FrameStrobe_O[3] Tile_X2Y0_FrameStrobe[3] VPWR VGND sg13cmos5l_buf_1
X_0869_ Tile_X2Y0_S2BEG[2] Tile_X2Y0_N2MID[5] VPWR VGND sg13cmos5l_buf_1
XFILLER_9_2195 VPWR VGND sg13cmos5l_decap_8
XFILLER_16_2613 VPWR VGND sg13cmos5l_decap_8
XFILLER_12_613 VPWR VGND sg13cmos5l_decap_8
XFILLER_7_105 VPWR VGND sg13cmos5l_decap_8
XFILLER_16_1934 VPWR VGND sg13cmos5l_decap_8
XFILLER_12_679 VPWR VGND sg13cmos5l_decap_8
XFILLER_7_116 VPWR VGND sg13cmos5l_fill_1
XFILLER_10_2212 VPWR VGND sg13cmos5l_decap_8
XFILLER_4_801 VPWR VGND sg13cmos5l_fill_1
XANTENNA_3006 Tile_X0Y0_FrameData[19] VPWR VGND sg13cmos5l_antennanp
XANTENNA_3017 Tile_X0Y0_FrameData[19] VPWR VGND sg13cmos5l_antennanp
XFILLER_10_2289 VPWR VGND sg13cmos5l_decap_8
XANTENNA_2305 Tile_X0Y0_N4END[0] VPWR VGND sg13cmos5l_antennanp
XANTENNA_2316 Tile_X3Y0_N4END[6] VPWR VGND sg13cmos5l_antennanp
XANTENNA_3028 Tile_X0Y0_FrameData[19] VPWR VGND sg13cmos5l_antennanp
XANTENNA_3039 Tile_X0Y0_FrameData[19] VPWR VGND sg13cmos5l_antennanp
XFILLER_10_1566 VPWR VGND sg13cmos5l_decap_8
XANTENNA_1604 Tile_X0Y0_FrameData[4] VPWR VGND sg13cmos5l_antennanp
XANTENNA_2327 Tile_X0Y0_FrameData[11] VPWR VGND sg13cmos5l_antennanp
XANTENNA_2338 Tile_X0Y0_FrameData[11] VPWR VGND sg13cmos5l_antennanp
XANTENNA_2349 Tile_X0Y0_FrameData[11] VPWR VGND sg13cmos5l_antennanp
XANTENNA_1615 Tile_X0Y0_FrameData[4] VPWR VGND sg13cmos5l_antennanp
XANTENNA_1626 Tile_X0Y0_FrameData[4] VPWR VGND sg13cmos5l_antennanp
XANTENNA_1637 Tile_X0Y0_FrameData[4] VPWR VGND sg13cmos5l_antennanp
XANTENNA_1648 Tile_X0Y0_FrameData[4] VPWR VGND sg13cmos5l_antennanp
XANTENNA_1659 Tile_X0Y0_FrameData[4] VPWR VGND sg13cmos5l_antennanp
XFILLER_1_2446 VPWR VGND sg13cmos5l_fill_1
XFILLER_1_2435 VPWR VGND sg13cmos5l_decap_8
XFILLER_1_2424 VPWR VGND sg13cmos5l_fill_1
XFILLER_5_1881 VPWR VGND sg13cmos5l_fill_1
XFILLER_8_21 VPWR VGND sg13cmos5l_decap_8
XFILLER_15_2156 VPWR VGND sg13cmos5l_decap_8
XFILLER_15_1400 VPWR VGND sg13cmos5l_decap_8
XFILLER_8_98 VPWR VGND sg13cmos5l_decap_8
X_0723_ Tile_X1Y0_S4BEG[8] _1187_/X VPWR VGND sg13cmos5l_buf_1
XFILLER_7_672 VPWR VGND sg13cmos5l_decap_8
XANTENNA_3540 Tile_X0Y0_FrameData[8] VPWR VGND sg13cmos5l_antennanp
X_0654_ _0654_/L_HI VPWR VGND sg13cmos5l_tiehi
XANTENNA_3551 Tile_X0Y0_FrameData[8] VPWR VGND sg13cmos5l_antennanp
XANTENNA_3562 Tile_X0Y0_FrameData[8] VPWR VGND sg13cmos5l_antennanp
XANTENNA_3573 Tile_X0Y0_FrameData[8] VPWR VGND sg13cmos5l_antennanp
XANTENNA_2850 Tile_X0Y0_FrameData[17] VPWR VGND sg13cmos5l_antennanp
XANTENNA_2861 Tile_X0Y0_FrameData[17] VPWR VGND sg13cmos5l_antennanp
XANTENNA_3584 Tile_X0Y0_FrameData[8] VPWR VGND sg13cmos5l_antennanp
XANTENNA_3595 Tile_X0Y0_FrameData[8] VPWR VGND sg13cmos5l_antennanp
X_0585_ _0585_/Q Tile_X0Y0_UserCLK NPU_RDATA13 _0651_/L_HI VPWR VGND sg13cmos5l_dfrbpq_1
XFILLER_6_2313 VPWR VGND sg13cmos5l_decap_8
XANTENNA_2872 Tile_X0Y0_FrameData[17] VPWR VGND sg13cmos5l_antennanp
XANTENNA_2883 Tile_X0Y0_FrameData[17] VPWR VGND sg13cmos5l_antennanp
XANTENNA_2894 Tile_X0Y0_FrameData[17] VPWR VGND sg13cmos5l_antennanp
X_1206_ _1206_/X Tile_X1Y0_N2END[3] Tile_X1Y0_N4END[11] Tile_X1Y0_NN4END[4] _0590_/Q
+ _0243_/Q _0242_/Q VPWR VGND sg13cmos5l_mux4_1
XFILLER_6_1678 VPWR VGND sg13cmos5l_decap_8
X_1137_ _1137_/X Tile_X0Y0_N1END[2] Tile_X0Y0_N2MID[6] Tile_X0Y0_N2END[1] _0602_/Q
+ _0189_/Q _0188_/Q VPWR VGND sg13cmos5l_mux4_1
X_1068_ Tile_X4Y0_SS4BEG[5] Tile_X4Y0_NN4END[10] VPWR VGND sg13cmos5l_buf_1
XFILLER_11_2554 VPWR VGND sg13cmos5l_fill_2
XFILLER_5_1122 VPWR VGND sg13cmos5l_decap_8
XFILLER_2_2700 VPWR VGND sg13cmos5l_decap_8
XFILLER_5_1188 VPWR VGND sg13cmos5l_fill_1
XFILLER_2_2788 VPWR VGND sg13cmos5l_fill_1
XFILLER_2_2799 VPWR VGND sg13cmos5l_fill_1
XFILLER_16_2465 VPWR VGND sg13cmos5l_decap_8
XFILLER_12_443 VPWR VGND sg13cmos5l_fill_1
XFILLER_16_1742 VPWR VGND sg13cmos5l_decap_8
XFILLER_12_487 VPWR VGND sg13cmos5l_decap_8
XFILLER_12_1628 VPWR VGND sg13cmos5l_decap_8
XANTENNA_2102 Tile_X0Y0_FrameData[6] VPWR VGND sg13cmos5l_antennanp
XANTENNA_2113 Tile_X0Y0_FrameData[7] VPWR VGND sg13cmos5l_antennanp
XANTENNA_2124 Tile_X0Y0_FrameData[9] VPWR VGND sg13cmos5l_antennanp
XANTENNA_1401 Tile_X0Y0_FrameData[31] VPWR VGND sg13cmos5l_antennanp
XANTENNA_1412 Tile_X0Y0_FrameData[31] VPWR VGND sg13cmos5l_antennanp
XANTENNA_2135 Tile_X0Y0_FrameData[9] VPWR VGND sg13cmos5l_antennanp
XANTENNA_2146 Tile_X0Y0_FrameData[9] VPWR VGND sg13cmos5l_antennanp
XANTENNA_2157 Tile_X0Y0_FrameData[9] VPWR VGND sg13cmos5l_antennanp
XANTENNA_1423 Tile_X0Y0_FrameData[31] VPWR VGND sg13cmos5l_antennanp
XANTENNA_1434 Tile_X0Y0_FrameData[31] VPWR VGND sg13cmos5l_antennanp
XANTENNA_1445 Tile_X0Y0_FrameData[31] VPWR VGND sg13cmos5l_antennanp
XANTENNA_1456 Tile_X0Y0_FrameData[31] VPWR VGND sg13cmos5l_antennanp
XANTENNA_2168 Tile_X0Y0_FrameData[9] VPWR VGND sg13cmos5l_antennanp
XANTENNA_2179 Tile_X0Y0_FrameData[9] VPWR VGND sg13cmos5l_antennanp
X_0370_ _0370_/Q Tile_X0Y0_FrameData[7] VGND VPWR Tile_X2Y0_FrameStrobe[1] latch
XFILLER_7_2644 VPWR VGND sg13cmos5l_decap_8
XANTENNA_1467 Tile_X0Y0_FrameData[31] VPWR VGND sg13cmos5l_antennanp
XANTENNA_1478 Tile_X0Y0_FrameData[31] VPWR VGND sg13cmos5l_antennanp
XANTENNA_1489 Tile_X0Y0_FrameData[31] VPWR VGND sg13cmos5l_antennanp
XFILLER_1_2254 VPWR VGND sg13cmos5l_decap_8
XFILLER_1_2298 VPWR VGND sg13cmos5l_decap_8
XFILLER_11_1105 VPWR VGND sg13cmos5l_decap_8
XFILLER_8_981 VPWR VGND sg13cmos5l_fill_1
X_0706_ Tile_X0Y0_FrameStrobe_O[19] Tile_X0Y0_FrameStrobe[19] VPWR VGND sg13cmos5l_buf_1
XANTENNA__0801__X Tile_X3Y0_SS4BEG[6] VPWR VGND sg13cmos5l_antennanp
XANTENNA_4060 Tile_X0Y0_N4END[3] VPWR VGND sg13cmos5l_antennanp
XANTENNA_4071 Tile_X0Y0_NN4END[2] VPWR VGND sg13cmos5l_antennanp
XANTENNA_4082 Tile_X1Y0_N2END[4] VPWR VGND sg13cmos5l_antennanp
XANTENNA_4093 Tile_X1Y0_N2END[7] VPWR VGND sg13cmos5l_antennanp
XFILLER_8_2408 VPWR VGND sg13cmos5l_decap_8
XANTENNA_3370 Tile_X0Y0_FrameData[21] VPWR VGND sg13cmos5l_antennanp
XANTENNA_3381 Tile_X0Y0_FrameData[21] VPWR VGND sg13cmos5l_antennanp
X_0637_ _0637_/L_HI VPWR VGND sg13cmos5l_tiehi
XANTENNA_2680 Tile_X0Y0_FrameData[14] VPWR VGND sg13cmos5l_antennanp
XANTENNA_3392 Tile_X0Y0_FrameData[21] VPWR VGND sg13cmos5l_antennanp
X_0568_ NPU_ADDR4 Tile_X0Y0_UserCLK _1084_/X _0673_/L_HI VPWR VGND sg13cmos5l_dfrbpq_1
XANTENNA_2691 Tile_X0Y0_FrameData[14] VPWR VGND sg13cmos5l_antennanp
XANTENNA_1990 Tile_X0Y0_FrameData[6] VPWR VGND sg13cmos5l_antennanp
X_0499_ _0499_/Q Tile_X0Y0_FrameData[6] VGND VPWR Tile_X3Y0_FrameStrobe[2] latch
XFILLER_2_1328 VPWR VGND sg13cmos5l_fill_1
XANTENNA_309 Tile_X0Y0_FrameData[1] VPWR VGND sg13cmos5l_antennanp
XFILLER_10_914 VPWR VGND sg13cmos5l_fill_1
XANTENNA__1079__X Tile_X4Y0_UserCLKo VPWR VGND sg13cmos5l_antennanp
XFILLER_11_2373 VPWR VGND sg13cmos5l_decap_8
XANTENNA__0711__X Tile_X1Y0_S2BEGb[4] VPWR VGND sg13cmos5l_antennanp
XFILLER_11_1683 VPWR VGND sg13cmos5l_decap_8
XFILLER_7_1206 VPWR VGND sg13cmos5l_fill_2
XFILLER_7_1239 VPWR VGND sg13cmos5l_fill_1
XFILLER_2_2563 VPWR VGND sg13cmos5l_fill_2
XFILLER_2_2596 VPWR VGND sg13cmos5l_decap_8
XANTENNA_810 Tile_X0Y0_FrameData[27] VPWR VGND sg13cmos5l_antennanp
XANTENNA_854 Tile_X0Y0_FrameData[27] VPWR VGND sg13cmos5l_antennanp
XANTENNA_843 Tile_X0Y0_FrameData[27] VPWR VGND sg13cmos5l_antennanp
XANTENNA_832 Tile_X0Y0_FrameData[27] VPWR VGND sg13cmos5l_antennanp
XANTENNA_821 Tile_X0Y0_FrameData[27] VPWR VGND sg13cmos5l_antennanp
XANTENNA_887 Tile_X0Y0_FrameData[27] VPWR VGND sg13cmos5l_antennanp
XANTENNA_876 Tile_X0Y0_FrameData[27] VPWR VGND sg13cmos5l_antennanp
XANTENNA_865 Tile_X0Y0_FrameData[27] VPWR VGND sg13cmos5l_antennanp
XFILLER_13_741 VPWR VGND sg13cmos5l_decap_8
XANTENNA_898 Tile_X0Y0_FrameData[27] VPWR VGND sg13cmos5l_antennanp
XFILLER_16_2273 VPWR VGND sg13cmos5l_fill_1
XFILLER_12_2148 VPWR VGND sg13cmos5l_decap_8
XFILLER_9_789 VPWR VGND sg13cmos5l_fill_2
XFILLER_9_2717 VPWR VGND sg13cmos5l_decap_8
XFILLER_5_77 VPWR VGND sg13cmos5l_decap_8
XFILLER_10_1182 VPWR VGND sg13cmos5l_decap_8
XANTENNA_1220 Tile_X0Y0_FrameData[30] VPWR VGND sg13cmos5l_antennanp
X_0422_ _0422_/Q Tile_X0Y0_FrameData[19] VGND VPWR Tile_X3Y0_FrameStrobe[0] latch
XANTENNA_1231 Tile_X0Y0_FrameData[30] VPWR VGND sg13cmos5l_antennanp
XANTENNA_1242 Tile_X0Y0_FrameData[30] VPWR VGND sg13cmos5l_antennanp
XANTENNA_1253 Tile_X0Y0_FrameData[30] VPWR VGND sg13cmos5l_antennanp
XANTENNA_1264 Tile_X0Y0_FrameData[30] VPWR VGND sg13cmos5l_antennanp
X_0353_ _0353_/Q Tile_X0Y0_FrameData[24] VGND VPWR Tile_X2Y0_FrameStrobe[1] latch
XFILLER_7_2474 VPWR VGND sg13cmos5l_decap_8
XANTENNA_1275 Tile_X0Y0_FrameData[30] VPWR VGND sg13cmos5l_antennanp
XANTENNA_1286 Tile_X0Y0_FrameData[30] VPWR VGND sg13cmos5l_antennanp
XANTENNA_1297 Tile_X0Y0_FrameData[30] VPWR VGND sg13cmos5l_antennanp
X_0284_ _0284_/Q Tile_X0Y0_FrameData[13] VGND VPWR Tile_X1Y0_FrameStrobe[2] latch
XFILLER_12_2682 VPWR VGND sg13cmos5l_decap_8
XFILLER_12_1970 VPWR VGND sg13cmos5l_fill_1
XANTENNA_106 Tile_X0Y0_FrameData[0] VPWR VGND sg13cmos5l_antennanp
XFILLER_2_1147 VPWR VGND sg13cmos5l_decap_8
XANTENNA_117 Tile_X0Y0_FrameData[0] VPWR VGND sg13cmos5l_antennanp
XANTENNA_128 Tile_X0Y0_FrameData[0] VPWR VGND sg13cmos5l_antennanp
XANTENNA_139 Tile_X0Y0_FrameData[0] VPWR VGND sg13cmos5l_antennanp
XANTENNA__0706__X Tile_X0Y0_FrameStrobe_O[19] VPWR VGND sg13cmos5l_antennanp
XFILLER_14_42 VPWR VGND sg13cmos5l_decap_8
XFILLER_13_2435 VPWR VGND sg13cmos5l_decap_8
XFILLER_13_1712 VPWR VGND sg13cmos5l_decap_8
XFILLER_5_236 VPWR VGND sg13cmos5l_fill_2
XFILLER_11_2170 VPWR VGND sg13cmos5l_decap_8
XFILLER_13_1789 VPWR VGND sg13cmos5l_decap_8
XFILLER_2_921 VPWR VGND sg13cmos5l_fill_2
XFILLER_4_2647 VPWR VGND sg13cmos5l_decap_8
XFILLER_2_2371 VPWR VGND sg13cmos5l_decap_4
XFILLER_2_2393 VPWR VGND sg13cmos5l_fill_2
XFILLER_2_2382 VPWR VGND sg13cmos5l_fill_2
XFILLER_2_1681 VPWR VGND sg13cmos5l_decap_8
XANTENNA_662 Tile_X0Y0_FrameData[24] VPWR VGND sg13cmos5l_antennanp
XANTENNA_651 Tile_X0Y0_FrameData[24] VPWR VGND sg13cmos5l_antennanp
XANTENNA_640 Tile_X0Y0_FrameData[23] VPWR VGND sg13cmos5l_antennanp
XANTENNA_695 Tile_X0Y0_FrameData[24] VPWR VGND sg13cmos5l_antennanp
XANTENNA_684 Tile_X0Y0_FrameData[24] VPWR VGND sg13cmos5l_antennanp
XANTENNA_673 Tile_X0Y0_FrameData[24] VPWR VGND sg13cmos5l_antennanp
X_0971_ Tile_X1Y0_FrameStrobe_O[16] Tile_X1Y0_FrameStrobe[16] VPWR VGND sg13cmos5l_buf_1
XFILLER_9_553 VPWR VGND sg13cmos5l_decap_8
XFILLER_16_2092 VPWR VGND sg13cmos5l_decap_8
XFILLER_12_1266 VPWR VGND sg13cmos5l_decap_8
XFILLER_9_1802 VPWR VGND sg13cmos5l_decap_8
XFILLER_9_2558 VPWR VGND sg13cmos5l_fill_1
X_0405_ _0405_/Q Tile_X0Y0_FrameData[4] VGND VPWR Tile_X2Y0_FrameStrobe[2] latch
XANTENNA_1050 Tile_X0Y0_FrameData[29] VPWR VGND sg13cmos5l_antennanp
XANTENNA_1061 Tile_X0Y0_FrameData[29] VPWR VGND sg13cmos5l_antennanp
XANTENNA_1072 Tile_X0Y0_FrameData[2] VPWR VGND sg13cmos5l_antennanp
XANTENNA_1083 Tile_X0Y0_FrameData[2] VPWR VGND sg13cmos5l_antennanp
XANTENNA_1094 Tile_X0Y0_FrameData[2] VPWR VGND sg13cmos5l_antennanp
X_0336_ _0336_/Q Tile_X0Y0_FrameData[9] VGND VPWR Tile_X2Y0_FrameStrobe[0] latch
X_0267_ _0267_/Q Tile_X0Y0_FrameData[30] VGND VPWR Tile_X1Y0_FrameStrobe[2] latch
XFILLER_3_1489 VPWR VGND sg13cmos5l_fill_1
X_0198_ _0198_/Q Tile_X0Y0_FrameData[19] VGND VPWR Tile_X0Y0_FrameStrobe[3] latch
XFILLER_14_2700 VPWR VGND sg13cmos5l_decap_8
XFILLER_8_2079 VPWR VGND sg13cmos5l_fill_1
XFILLER_8_2068 VPWR VGND sg13cmos5l_fill_1
XFILLER_15_1829 VPWR VGND sg13cmos5l_decap_8
XFILLER_13_2243 VPWR VGND sg13cmos5l_decap_8
XFILLER_10_585 VPWR VGND sg13cmos5l_decap_8
XANTENNA_3903 Tile_X0Y0_FrameData[18] VPWR VGND sg13cmos5l_antennanp
XANTENNA_3914 Tile_X0Y0_FrameData[18] VPWR VGND sg13cmos5l_antennanp
XFILLER_6_556 VPWR VGND sg13cmos5l_decap_4
XFILLER_13_1586 VPWR VGND sg13cmos5l_decap_8
XANTENNA_3925 Tile_X0Y0_FrameData[18] VPWR VGND sg13cmos5l_antennanp
XANTENNA_3936 Tile_X0Y0_FrameData[18] VPWR VGND sg13cmos5l_antennanp
XANTENNA_3947 Tile_X0Y0_FrameData[18] VPWR VGND sg13cmos5l_antennanp
XANTENNA_3958 Tile_X0Y0_FrameData[18] VPWR VGND sg13cmos5l_antennanp
XANTENNA_3969 Tile_X0Y0_FrameData[18] VPWR VGND sg13cmos5l_antennanp
XFILLER_9_1109 VPWR VGND sg13cmos5l_decap_8
X_1170_ _1170_/X Tile_X0Y0_N2END[7] Tile_X0Y0_N4END[15] Tile_X0Y0_NN4END[0] _0596_/Q
+ _0123_/Q _0122_/Q VPWR VGND sg13cmos5l_mux4_1
XFILLER_4_2433 VPWR VGND sg13cmos5l_decap_8
XFILLER_2_56 VPWR VGND sg13cmos5l_decap_8
X_0121_ _0121_/Q Tile_X0Y0_FrameData[0] VGND VPWR Tile_X0Y0_FrameStrobe[0] latch
XFILLER_4_2499 VPWR VGND sg13cmos5l_decap_8
XFILLER_4_1754 VPWR VGND sg13cmos5l_decap_4
XANTENNA_470 Tile_X0Y0_FrameData[23] VPWR VGND sg13cmos5l_antennanp
XANTENNA_492 Tile_X0Y0_FrameData[23] VPWR VGND sg13cmos5l_antennanp
XANTENNA_481 Tile_X0Y0_FrameData[23] VPWR VGND sg13cmos5l_antennanp
XANTENNA_17 NPU_RDATA21 VPWR VGND sg13cmos5l_antennanp
XANTENNA_28 NPU_RDATA3 VPWR VGND sg13cmos5l_antennanp
XANTENNA_39 Tile_X0Y0_FrameData[0] VPWR VGND sg13cmos5l_antennanp
X_0954_ Tile_X2Y0_FrameStrobe_O[19] Tile_X2Y0_FrameStrobe[19] VPWR VGND sg13cmos5l_buf_1
X_0885_ Tile_X2Y0_S4BEG[2] _1221_/X VPWR VGND sg13cmos5l_buf_1
XFILLER_12_1041 VPWR VGND sg13cmos5l_decap_8
XFILLER_9_2344 VPWR VGND sg13cmos5l_decap_8
XFILLER_9_1676 VPWR VGND sg13cmos5l_decap_8
X_0319_ _0319_/Q Tile_X0Y0_FrameData[26] VGND VPWR Tile_X2Y0_FrameStrobe[0] latch
XFILLER_14_1851 VPWR VGND sg13cmos5l_decap_8
XFILLER_14_1895 VPWR VGND sg13cmos5l_fill_1
XFILLER_11_21 VPWR VGND sg13cmos5l_decap_8
XFILLER_10_1748 VPWR VGND sg13cmos5l_decap_8
XANTENNA_2509 Tile_X0Y0_FrameData[12] VPWR VGND sg13cmos5l_antennanp
XANTENNA_1808 Tile_X0Y0_FrameData[5] VPWR VGND sg13cmos5l_antennanp
XANTENNA_1819 Tile_X0Y0_FrameData[5] VPWR VGND sg13cmos5l_antennanp
XFILLER_5_2742 VPWR VGND sg13cmos5l_decap_8
XFILLER_8_1186 VPWR VGND sg13cmos5l_decap_8
XFILLER_1_2628 VPWR VGND sg13cmos5l_decap_8
XFILLER_15_644 VPWR VGND sg13cmos5l_decap_8
XFILLER_14_154 VPWR VGND sg13cmos5l_decap_8
XFILLER_15_699 VPWR VGND sg13cmos5l_decap_8
XFILLER_15_1626 VPWR VGND sg13cmos5l_decap_8
XFILLER_13_2040 VPWR VGND sg13cmos5l_decap_8
X_0670_ _0670_/L_HI VPWR VGND sg13cmos5l_tiehi
XANTENNA_3700 Tile_X1Y0_N4END[2] VPWR VGND sg13cmos5l_antennanp
XANTENNA_3711 Tile_X1Y0_N4END[2] VPWR VGND sg13cmos5l_antennanp
XANTENNA_3722 Tile_X1Y0_N4END[3] VPWR VGND sg13cmos5l_antennanp
XANTENNA_3733 Tile_X1Y0_NN4END[0] VPWR VGND sg13cmos5l_antennanp
XANTENNA_3744 Tile_X2Y0_N2END[4] VPWR VGND sg13cmos5l_antennanp
XANTENNA_3755 Tile_X3Y0_N4END[4] VPWR VGND sg13cmos5l_antennanp
XANTENNA_3766 Tile_X0Y0_FrameData[18] VPWR VGND sg13cmos5l_antennanp
XANTENNA_3777 Tile_X0Y0_FrameData[18] VPWR VGND sg13cmos5l_antennanp
XANTENNA_3788 Tile_X0Y0_FrameData[18] VPWR VGND sg13cmos5l_antennanp
XANTENNA_3799 Tile_X0Y0_FrameData[18] VPWR VGND sg13cmos5l_antennanp
XFILLER_2_570 VPWR VGND sg13cmos5l_decap_8
X_1222_ _1222_/X Tile_X2Y0_N2MID[3] Tile_X2Y0_N4END[12] Tile_X2Y0_NN4END[3] _0587_/Q
+ _0387_/Q _0386_/Q VPWR VGND sg13cmos5l_mux4_1
XFILLER_6_1827 VPWR VGND sg13cmos5l_fill_2
XFILLER_4_2241 VPWR VGND sg13cmos5l_decap_8
X_1153_ _1153_/X Tile_X0Y0_N2MID[6] Tile_X0Y0_N4END[1] Tile_X0Y0_NN4END[14] _0596_/Q
+ _0157_/Q _0156_/Q VPWR VGND sg13cmos5l_mux4_1
X_0104_ _0104_/Q Tile_X0Y0_FrameData[17] VGND VPWR Tile_X0Y0_FrameStrobe[0] latch
X_1084_ _1084_/X Tile_X2Y0_N1END[0] Tile_X2Y0_N2MID[3] Tile_X2Y0_N2MID[4] Tile_X2Y0_N2END[3]
+ _0321_/Q _0320_/Q VPWR VGND sg13cmos5l_mux4_1
XANTENNA__0804__X Tile_X3Y0_SS4BEG[9] VPWR VGND sg13cmos5l_antennanp
X_0937_ Tile_X2Y0_FrameStrobe_O[2] Tile_X2Y0_FrameStrobe[2] VPWR VGND sg13cmos5l_buf_1
XFILLER_14_1125 VPWR VGND sg13cmos5l_fill_2
X_0868_ Tile_X2Y0_S2BEG[1] Tile_X2Y0_N2MID[6] VPWR VGND sg13cmos5l_buf_1
X_0799_ Tile_X3Y0_SS4BEG[4] _1279_/X VPWR VGND sg13cmos5l_buf_1
XFILLER_9_2174 VPWR VGND sg13cmos5l_decap_8
XFILLER_3_1050 VPWR VGND sg13cmos5l_fill_2
XFILLER_0_2661 VPWR VGND sg13cmos5l_decap_8
XFILLER_0_2694 VPWR VGND sg13cmos5l_fill_1
XFILLER_0_2683 VPWR VGND sg13cmos5l_decap_8
XFILLER_0_2672 VPWR VGND sg13cmos5l_fill_1
XFILLER_16_2669 VPWR VGND sg13cmos5l_decap_8
XFILLER_12_658 VPWR VGND sg13cmos5l_decap_8
XANTENNA__0714__X Tile_X1Y0_S2BEGb[7] VPWR VGND sg13cmos5l_antennanp
XFILLER_16_1979 VPWR VGND sg13cmos5l_decap_4
XFILLER_11_168 VPWR VGND sg13cmos5l_decap_8
XANTENNA_3007 Tile_X0Y0_FrameData[19] VPWR VGND sg13cmos5l_antennanp
XANTENNA_3018 Tile_X0Y0_FrameData[19] VPWR VGND sg13cmos5l_antennanp
XFILLER_4_835 VPWR VGND sg13cmos5l_fill_1
XFILLER_10_2268 VPWR VGND sg13cmos5l_decap_8
XANTENNA_2306 Tile_X0Y0_N4END[0] VPWR VGND sg13cmos5l_antennanp
XANTENNA_3029 Tile_X0Y0_FrameData[19] VPWR VGND sg13cmos5l_antennanp
XFILLER_10_1545 VPWR VGND sg13cmos5l_decap_8
XANTENNA_1605 Tile_X0Y0_FrameData[4] VPWR VGND sg13cmos5l_antennanp
XANTENNA_2317 Tile_X3Y0_N4END[6] VPWR VGND sg13cmos5l_antennanp
XANTENNA_2328 Tile_X0Y0_FrameData[11] VPWR VGND sg13cmos5l_antennanp
XANTENNA_2339 Tile_X0Y0_FrameData[11] VPWR VGND sg13cmos5l_antennanp
XANTENNA_1616 Tile_X0Y0_FrameData[4] VPWR VGND sg13cmos5l_antennanp
XANTENNA_1627 Tile_X0Y0_FrameData[4] VPWR VGND sg13cmos5l_antennanp
XANTENNA_1638 Tile_X0Y0_FrameData[4] VPWR VGND sg13cmos5l_antennanp
XANTENNA_1649 Tile_X0Y0_FrameData[4] VPWR VGND sg13cmos5l_antennanp
XFILLER_5_2550 VPWR VGND sg13cmos5l_fill_2
XFILLER_1_2414 VPWR VGND sg13cmos5l_decap_4
XFILLER_1_1746 VPWR VGND sg13cmos5l_decap_8
XFILLER_16_997 VPWR VGND sg13cmos5l_fill_2
XFILLER_15_2135 VPWR VGND sg13cmos5l_decap_8
XFILLER_8_77 VPWR VGND sg13cmos5l_decap_8
XFILLER_7_651 VPWR VGND sg13cmos5l_decap_8
XFILLER_11_691 VPWR VGND sg13cmos5l_decap_8
X_0722_ Tile_X1Y0_S4BEG[7] _1186_/X VPWR VGND sg13cmos5l_buf_1
XANTENNA_3530 Tile_X0Y0_FrameData[8] VPWR VGND sg13cmos5l_antennanp
X_0653_ _0653_/L_HI VPWR VGND sg13cmos5l_tiehi
XANTENNA_3541 Tile_X0Y0_FrameData[8] VPWR VGND sg13cmos5l_antennanp
XANTENNA_3552 Tile_X0Y0_FrameData[8] VPWR VGND sg13cmos5l_antennanp
XANTENNA_3563 Tile_X0Y0_FrameData[8] VPWR VGND sg13cmos5l_antennanp
XANTENNA_3574 Tile_X0Y0_FrameData[8] VPWR VGND sg13cmos5l_antennanp
X_0584_ _0584_/Q Tile_X0Y0_UserCLK NPU_RDATA12 _0652_/L_HI VPWR VGND sg13cmos5l_dfrbpq_1
XANTENNA_2840 Tile_X0Y0_FrameData[17] VPWR VGND sg13cmos5l_antennanp
XANTENNA_2851 Tile_X0Y0_FrameData[17] VPWR VGND sg13cmos5l_antennanp
XANTENNA_2862 Tile_X0Y0_FrameData[17] VPWR VGND sg13cmos5l_antennanp
XANTENNA_3585 Tile_X0Y0_FrameData[8] VPWR VGND sg13cmos5l_antennanp
XANTENNA_3596 Tile_X0Y0_FrameData[8] VPWR VGND sg13cmos5l_antennanp
XANTENNA_2873 Tile_X0Y0_FrameData[17] VPWR VGND sg13cmos5l_antennanp
XANTENNA_2884 Tile_X0Y0_FrameData[17] VPWR VGND sg13cmos5l_antennanp
XANTENNA_2895 Tile_X0Y0_FrameData[17] VPWR VGND sg13cmos5l_antennanp
XFILLER_6_1657 VPWR VGND sg13cmos5l_decap_8
X_1205_ _1205_/X Tile_X1Y0_N2END[2] Tile_X1Y0_N4END[10] Tile_X1Y0_NN4END[5] _0591_/Q
+ _0245_/Q _0244_/Q VPWR VGND sg13cmos5l_mux4_1
X_1136_ _1136_/X Tile_X0Y0_N1END[1] Tile_X0Y0_N2MID[5] Tile_X0Y0_N2END[2] _0601_/Q
+ _0191_/Q _0190_/Q VPWR VGND sg13cmos5l_mux4_1
X_1067_ Tile_X4Y0_SS4BEG[4] Tile_X4Y0_NN4END[11] VPWR VGND sg13cmos5l_buf_1
XFILLER_9_1270 VPWR VGND sg13cmos5l_fill_2
XFILLER_5_1101 VPWR VGND sg13cmos5l_decap_8
XANTENNA__0709__X Tile_X1Y0_S2BEGb[2] VPWR VGND sg13cmos5l_antennanp
XFILLER_5_1178 VPWR VGND sg13cmos5l_fill_2
XFILLER_2_2756 VPWR VGND sg13cmos5l_fill_2
XFILLER_16_2444 VPWR VGND sg13cmos5l_decap_8
XFILLER_16_1721 VPWR VGND sg13cmos5l_decap_8
XFILLER_12_466 VPWR VGND sg13cmos5l_decap_8
XFILLER_16_1798 VPWR VGND sg13cmos5l_decap_8
XFILLER_12_1607 VPWR VGND sg13cmos5l_decap_8
XFILLER_4_632 VPWR VGND sg13cmos5l_decap_8
XFILLER_10_1342 VPWR VGND sg13cmos5l_fill_2
XANTENNA_2103 Tile_X0Y0_FrameData[6] VPWR VGND sg13cmos5l_antennanp
XANTENNA_2114 Tile_X0Y0_FrameData[7] VPWR VGND sg13cmos5l_antennanp
XANTENNA_1402 Tile_X0Y0_FrameData[31] VPWR VGND sg13cmos5l_antennanp
XANTENNA_1413 Tile_X0Y0_FrameData[31] VPWR VGND sg13cmos5l_antennanp
XANTENNA_2125 Tile_X0Y0_FrameData[9] VPWR VGND sg13cmos5l_antennanp
XANTENNA_2136 Tile_X0Y0_FrameData[9] VPWR VGND sg13cmos5l_antennanp
XANTENNA_2147 Tile_X0Y0_FrameData[9] VPWR VGND sg13cmos5l_antennanp
XANTENNA_2158 Tile_X0Y0_FrameData[9] VPWR VGND sg13cmos5l_antennanp
XFILLER_7_2623 VPWR VGND sg13cmos5l_decap_8
XANTENNA_1424 Tile_X0Y0_FrameData[31] VPWR VGND sg13cmos5l_antennanp
XANTENNA_1435 Tile_X0Y0_FrameData[31] VPWR VGND sg13cmos5l_antennanp
XANTENNA_1446 Tile_X0Y0_FrameData[31] VPWR VGND sg13cmos5l_antennanp
XANTENNA_2169 Tile_X0Y0_FrameData[9] VPWR VGND sg13cmos5l_antennanp
XANTENNA_1457 Tile_X0Y0_FrameData[31] VPWR VGND sg13cmos5l_antennanp
XANTENNA_1468 Tile_X0Y0_FrameData[31] VPWR VGND sg13cmos5l_antennanp
XANTENNA_1479 Tile_X0Y0_FrameData[31] VPWR VGND sg13cmos5l_antennanp
XFILLER_3_2509 VPWR VGND sg13cmos5l_decap_8
XFILLER_12_7 VPWR VGND sg13cmos5l_decap_8
XFILLER_1_2233 VPWR VGND sg13cmos5l_decap_8
XFILLER_15_1242 VPWR VGND sg13cmos5l_decap_8
XFILLER_15_1297 VPWR VGND sg13cmos5l_decap_8
XANTENNA_4050 Tile_X0Y0_N4END[3] VPWR VGND sg13cmos5l_antennanp
X_0705_ Tile_X0Y0_FrameStrobe_O[18] Tile_X0Y0_FrameStrobe[18] VPWR VGND sg13cmos5l_buf_1
XANTENNA_4061 Tile_X0Y0_N4END[3] VPWR VGND sg13cmos5l_antennanp
XANTENNA_4072 Tile_X0Y0_NN4END[2] VPWR VGND sg13cmos5l_antennanp
XANTENNA_4083 Tile_X1Y0_N2END[4] VPWR VGND sg13cmos5l_antennanp
XANTENNA_3360 Tile_X0Y0_FrameData[20] VPWR VGND sg13cmos5l_antennanp
XANTENNA_3371 Tile_X0Y0_FrameData[21] VPWR VGND sg13cmos5l_antennanp
XANTENNA_3382 Tile_X0Y0_FrameData[21] VPWR VGND sg13cmos5l_antennanp
XANTENNA_4094 Tile_X1Y0_N4END[0] VPWR VGND sg13cmos5l_antennanp
X_0636_ _0636_/L_HI VPWR VGND sg13cmos5l_tiehi
XANTENNA_2670 Tile_X0Y0_FrameData[14] VPWR VGND sg13cmos5l_antennanp
XANTENNA_3393 Tile_X0Y0_FrameData[21] VPWR VGND sg13cmos5l_antennanp
X_0567_ NPU_ADDR3 Tile_X0Y0_UserCLK _1083_/X _0674_/L_HI VPWR VGND sg13cmos5l_dfrbpq_1
XANTENNA_2681 Tile_X0Y0_FrameData[14] VPWR VGND sg13cmos5l_antennanp
XANTENNA_2692 Tile_X0Y0_FrameData[14] VPWR VGND sg13cmos5l_antennanp
XANTENNA_1980 Tile_X0Y0_FrameData[6] VPWR VGND sg13cmos5l_antennanp
XANTENNA_1991 Tile_X0Y0_FrameData[6] VPWR VGND sg13cmos5l_antennanp
X_0498_ _0498_/Q Tile_X0Y0_FrameData[7] VGND VPWR Tile_X3Y0_FrameStrobe[2] latch
X_1119_ _1119_/X Tile_X0Y0_N4END[4] Tile_X0Y0_N4END[7] Tile_X0Y0_NN4END[5] Tile_X0Y0_NN4END[7]
+ _0107_/Q _0106_/Q VPWR VGND sg13cmos5l_mux4_1
XFILLER_14_709 VPWR VGND sg13cmos5l_decap_8
XFILLER_11_2352 VPWR VGND sg13cmos5l_decap_8
XFILLER_11_1662 VPWR VGND sg13cmos5l_decap_8
XFILLER_0_112 VPWR VGND sg13cmos5l_fill_1
XFILLER_2_2542 VPWR VGND sg13cmos5l_decap_8
XFILLER_2_2575 VPWR VGND sg13cmos5l_decap_8
XANTENNA_811 Tile_X0Y0_FrameData[27] VPWR VGND sg13cmos5l_antennanp
XANTENNA_800 Tile_X0Y0_FrameData[27] VPWR VGND sg13cmos5l_antennanp
XANTENNA_844 Tile_X0Y0_FrameData[27] VPWR VGND sg13cmos5l_antennanp
XANTENNA_833 Tile_X0Y0_FrameData[27] VPWR VGND sg13cmos5l_antennanp
XANTENNA_822 Tile_X0Y0_FrameData[27] VPWR VGND sg13cmos5l_antennanp
XFILLER_13_720 VPWR VGND sg13cmos5l_decap_8
XANTENNA_877 Tile_X0Y0_FrameData[27] VPWR VGND sg13cmos5l_antennanp
XANTENNA_866 Tile_X0Y0_FrameData[27] VPWR VGND sg13cmos5l_antennanp
XANTENNA_855 Tile_X0Y0_FrameData[27] VPWR VGND sg13cmos5l_antennanp
XANTENNA_899 Tile_X0Y0_FrameData[27] VPWR VGND sg13cmos5l_antennanp
XANTENNA_888 Tile_X0Y0_FrameData[27] VPWR VGND sg13cmos5l_antennanp
XFILLER_13_797 VPWR VGND sg13cmos5l_fill_1
XFILLER_12_2127 VPWR VGND sg13cmos5l_decap_8
XFILLER_16_1584 VPWR VGND sg13cmos5l_decap_8
XANTENNA__0902__X Tile_X2Y0_SS4BEG[3] VPWR VGND sg13cmos5l_antennanp
XFILLER_10_1161 VPWR VGND sg13cmos5l_decap_8
XFILLER_5_56 VPWR VGND sg13cmos5l_decap_8
XANTENNA_1210 Tile_X0Y0_FrameData[30] VPWR VGND sg13cmos5l_antennanp
XANTENNA_1221 Tile_X0Y0_FrameData[30] VPWR VGND sg13cmos5l_antennanp
X_0421_ _0421_/Q Tile_X0Y0_FrameData[20] VGND VPWR Tile_X3Y0_FrameStrobe[0] latch
XANTENNA_1232 Tile_X0Y0_FrameData[30] VPWR VGND sg13cmos5l_antennanp
XANTENNA_1243 Tile_X0Y0_FrameData[30] VPWR VGND sg13cmos5l_antennanp
XANTENNA_1254 Tile_X0Y0_FrameData[30] VPWR VGND sg13cmos5l_antennanp
X_0352_ _0352_/Q Tile_X0Y0_FrameData[25] VGND VPWR Tile_X2Y0_FrameStrobe[1] latch
XFILLER_7_2453 VPWR VGND sg13cmos5l_decap_8
XANTENNA_1265 Tile_X0Y0_FrameData[30] VPWR VGND sg13cmos5l_antennanp
XANTENNA_1276 Tile_X0Y0_FrameData[30] VPWR VGND sg13cmos5l_antennanp
XANTENNA_1287 Tile_X0Y0_FrameData[30] VPWR VGND sg13cmos5l_antennanp
XANTENNA_1298 Tile_X0Y0_FrameData[30] VPWR VGND sg13cmos5l_antennanp
XFILLER_3_2339 VPWR VGND sg13cmos5l_decap_8
X_0283_ _0283_/Q Tile_X0Y0_FrameData[14] VGND VPWR Tile_X1Y0_FrameStrobe[2] latch
XFILLER_7_1785 VPWR VGND sg13cmos5l_decap_8
XFILLER_3_1649 VPWR VGND sg13cmos5l_decap_8
XFILLER_1_1395 VPWR VGND sg13cmos5l_fill_2
XFILLER_12_2661 VPWR VGND sg13cmos5l_decap_8
XANTENNA__0812__X Tile_X4Y0_FrameData_O[1] VPWR VGND sg13cmos5l_antennanp
XFILLER_8_2217 VPWR VGND sg13cmos5l_fill_2
XANTENNA_3190 Tile_X0Y0_FrameData[20] VPWR VGND sg13cmos5l_antennanp
X_0619_ _0619_/L_HI VPWR VGND sg13cmos5l_tiehi
XFILLER_6_1262 VPWR VGND sg13cmos5l_fill_1
XANTENNA_107 Tile_X0Y0_FrameData[0] VPWR VGND sg13cmos5l_antennanp
XFILLER_2_1126 VPWR VGND sg13cmos5l_decap_8
XANTENNA_118 Tile_X0Y0_FrameData[0] VPWR VGND sg13cmos5l_antennanp
XANTENNA_129 Tile_X0Y0_FrameData[0] VPWR VGND sg13cmos5l_antennanp
XFILLER_14_21 VPWR VGND sg13cmos5l_decap_8
XFILLER_13_2414 VPWR VGND sg13cmos5l_decap_8
XFILLER_10_745 VPWR VGND sg13cmos5l_fill_1
XFILLER_14_98 VPWR VGND sg13cmos5l_decap_8
XANTENNA__0722__X Tile_X1Y0_S4BEG[7] VPWR VGND sg13cmos5l_antennanp
XFILLER_6_738 VPWR VGND sg13cmos5l_fill_2
XFILLER_13_1768 VPWR VGND sg13cmos5l_decap_8
XFILLER_8_2762 VPWR VGND sg13cmos5l_decap_8
XFILLER_8_2773 VPWR VGND sg13cmos5l_fill_2
XFILLER_8_2784 VPWR VGND sg13cmos5l_fill_1
XFILLER_4_2626 VPWR VGND sg13cmos5l_decap_8
XFILLER_2_1660 VPWR VGND sg13cmos5l_decap_8
XANTENNA_652 Tile_X0Y0_FrameData[24] VPWR VGND sg13cmos5l_antennanp
XANTENNA_641 Tile_X0Y0_FrameData[23] VPWR VGND sg13cmos5l_antennanp
XANTENNA_630 Tile_X0Y0_FrameData[23] VPWR VGND sg13cmos5l_antennanp
XANTENNA_696 Tile_X0Y0_FrameData[24] VPWR VGND sg13cmos5l_antennanp
XANTENNA_685 Tile_X0Y0_FrameData[24] VPWR VGND sg13cmos5l_antennanp
XANTENNA_674 Tile_X0Y0_FrameData[24] VPWR VGND sg13cmos5l_antennanp
XANTENNA_663 Tile_X0Y0_FrameData[24] VPWR VGND sg13cmos5l_antennanp
X_0970_ Tile_X1Y0_FrameStrobe_O[15] Tile_X1Y0_FrameStrobe[15] VPWR VGND sg13cmos5l_buf_1
XFILLER_16_2071 VPWR VGND sg13cmos5l_decap_8
XFILLER_13_594 VPWR VGND sg13cmos5l_decap_8
XFILLER_12_1245 VPWR VGND sg13cmos5l_decap_8
XFILLER_5_793 VPWR VGND sg13cmos5l_fill_2
X_0404_ _0404_/Q Tile_X0Y0_FrameData[5] VGND VPWR Tile_X2Y0_FrameStrobe[2] latch
XANTENNA_1040 Tile_X0Y0_FrameData[29] VPWR VGND sg13cmos5l_antennanp
XANTENNA_1051 Tile_X0Y0_FrameData[29] VPWR VGND sg13cmos5l_antennanp
XANTENNA_1062 Tile_X0Y0_FrameData[29] VPWR VGND sg13cmos5l_antennanp
XFILLER_7_2283 VPWR VGND sg13cmos5l_decap_8
XANTENNA_1073 Tile_X0Y0_FrameData[2] VPWR VGND sg13cmos5l_antennanp
XANTENNA_1084 Tile_X0Y0_FrameData[2] VPWR VGND sg13cmos5l_antennanp
XANTENNA_1095 Tile_X0Y0_FrameData[2] VPWR VGND sg13cmos5l_antennanp
X_0335_ _0335_/Q Tile_X0Y0_FrameData[10] VGND VPWR Tile_X2Y0_FrameStrobe[0] latch
XFILLER_7_1582 VPWR VGND sg13cmos5l_decap_8
X_0266_ _0266_/Q Tile_X0Y0_FrameData[31] VGND VPWR Tile_X1Y0_FrameStrobe[2] latch
XANTENNA__0807__X Tile_X3Y0_SS4BEG[12] VPWR VGND sg13cmos5l_antennanp
X_0197_ _0197_/Q Tile_X0Y0_FrameData[20] VGND VPWR Tile_X0Y0_FrameStrobe[3] latch
XFILLER_12_2491 VPWR VGND sg13cmos5l_decap_8
XFILLER_8_2036 VPWR VGND sg13cmos5l_fill_1
XFILLER_6_1092 VPWR VGND sg13cmos5l_decap_8
XANTENNA__0717__X Tile_X1Y0_S4BEG[2] VPWR VGND sg13cmos5l_antennanp
XFILLER_15_804 VPWR VGND sg13cmos5l_decap_8
XFILLER_15_1808 VPWR VGND sg13cmos5l_decap_8
XFILLER_13_2222 VPWR VGND sg13cmos5l_decap_8
XFILLER_6_535 VPWR VGND sg13cmos5l_decap_8
XFILLER_13_2288 VPWR VGND sg13cmos5l_decap_8
XFILLER_10_564 VPWR VGND sg13cmos5l_decap_8
XANTENNA_3904 Tile_X0Y0_FrameData[18] VPWR VGND sg13cmos5l_antennanp
XFILLER_13_1565 VPWR VGND sg13cmos5l_decap_8
XANTENNA_3915 Tile_X0Y0_FrameData[18] VPWR VGND sg13cmos5l_antennanp
XANTENNA_3926 Tile_X0Y0_FrameData[18] VPWR VGND sg13cmos5l_antennanp
XANTENNA_3937 Tile_X0Y0_FrameData[18] VPWR VGND sg13cmos5l_antennanp
XANTENNA_3948 Tile_X0Y0_FrameData[18] VPWR VGND sg13cmos5l_antennanp
XFILLER_6_579 VPWR VGND sg13cmos5l_decap_8
XANTENNA_3959 Tile_X0Y0_FrameData[18] VPWR VGND sg13cmos5l_antennanp
XFILLER_2_35 VPWR VGND sg13cmos5l_decap_8
X_0120_ _0120_/Q Tile_X0Y0_FrameData[1] VGND VPWR Tile_X0Y0_FrameStrobe[0] latch
XFILLER_4_2478 VPWR VGND sg13cmos5l_decap_8
XFILLER_4_1733 VPWR VGND sg13cmos5l_decap_8
XANTENNA_471 Tile_X0Y0_FrameData[23] VPWR VGND sg13cmos5l_antennanp
XANTENNA_460 Tile_X0Y0_FrameData[23] VPWR VGND sg13cmos5l_antennanp
XFILLER_14_2008 VPWR VGND sg13cmos5l_fill_1
XANTENNA_493 Tile_X0Y0_FrameData[23] VPWR VGND sg13cmos5l_antennanp
XANTENNA_482 Tile_X0Y0_FrameData[23] VPWR VGND sg13cmos5l_antennanp
XANTENNA_18 NPU_RDATA22 VPWR VGND sg13cmos5l_antennanp
XANTENNA_29 NPU_RDATA30 VPWR VGND sg13cmos5l_antennanp
X_0953_ Tile_X2Y0_FrameStrobe_O[18] Tile_X2Y0_FrameStrobe[18] VPWR VGND sg13cmos5l_buf_1
XFILLER_14_1307 VPWR VGND sg13cmos5l_fill_2
X_0884_ Tile_X2Y0_S4BEG[1] _1220_/X VPWR VGND sg13cmos5l_buf_1
XFILLER_9_2323 VPWR VGND sg13cmos5l_decap_8
XFILLER_9_1611 VPWR VGND sg13cmos5l_decap_8
XFILLER_9_1655 VPWR VGND sg13cmos5l_decap_8
X_0318_ _0318_/Q Tile_X0Y0_FrameData[27] VGND VPWR Tile_X2Y0_FrameStrobe[0] latch
X_0249_ _0249_/Q Tile_X0Y0_FrameData[16] VGND VPWR Tile_X1Y0_FrameStrobe[1] latch
XFILLER_14_1830 VPWR VGND sg13cmos5l_decap_8
XFILLER_10_1727 VPWR VGND sg13cmos5l_decap_8
XFILLER_11_99 VPWR VGND sg13cmos5l_fill_1
XFILLER_11_88 VPWR VGND sg13cmos5l_decap_8
XANTENNA_1809 Tile_X0Y0_FrameData[5] VPWR VGND sg13cmos5l_antennanp
XFILLER_5_2721 VPWR VGND sg13cmos5l_decap_8
XFILLER_8_1165 VPWR VGND sg13cmos5l_decap_8
XFILLER_15_623 VPWR VGND sg13cmos5l_decap_8
XFILLER_15_678 VPWR VGND sg13cmos5l_decap_8
XFILLER_14_133 VPWR VGND sg13cmos5l_decap_8
XFILLER_15_2317 VPWR VGND sg13cmos5l_decap_8
XFILLER_15_1605 VPWR VGND sg13cmos5l_decap_8
XFILLER_13_2030 VPWR VGND sg13cmos5l_fill_1
XFILLER_11_862 VPWR VGND sg13cmos5l_fill_2
XFILLER_6_321 VPWR VGND sg13cmos5l_fill_2
XFILLER_13_2096 VPWR VGND sg13cmos5l_decap_8
XANTENNA_3701 Tile_X1Y0_N4END[2] VPWR VGND sg13cmos5l_antennanp
XANTENNA_3712 Tile_X1Y0_N4END[2] VPWR VGND sg13cmos5l_antennanp
XANTENNA__0910__X Tile_X2Y0_SS4BEG[11] VPWR VGND sg13cmos5l_antennanp
XANTENNA_3723 Tile_X1Y0_N4END[3] VPWR VGND sg13cmos5l_antennanp
XANTENNA_3734 Tile_X1Y0_NN4END[0] VPWR VGND sg13cmos5l_antennanp
XANTENNA_3745 Tile_X2Y0_N2END[4] VPWR VGND sg13cmos5l_antennanp
XANTENNA_3756 Tile_X3Y0_N4END[4] VPWR VGND sg13cmos5l_antennanp
XANTENNA_3767 Tile_X0Y0_FrameData[18] VPWR VGND sg13cmos5l_antennanp
XANTENNA_3778 Tile_X0Y0_FrameData[18] VPWR VGND sg13cmos5l_antennanp
XANTENNA_3789 Tile_X0Y0_FrameData[18] VPWR VGND sg13cmos5l_antennanp
XFILLER_6_2529 VPWR VGND sg13cmos5l_decap_8
X_1221_ _1221_/X Tile_X2Y0_N2MID[2] Tile_X2Y0_N4END[13] Tile_X2Y0_NN4END[2] _0586_/Q
+ _0389_/Q _0388_/Q VPWR VGND sg13cmos5l_mux4_1
XFILLER_4_2220 VPWR VGND sg13cmos5l_decap_8
X_1152_ _1152_/X Tile_X0Y0_N2MID[5] Tile_X0Y0_N4END[2] Tile_X0Y0_NN4END[13] _0597_/Q
+ _0159_/Q _0158_/Q VPWR VGND sg13cmos5l_mux4_1
XFILLER_4_2297 VPWR VGND sg13cmos5l_decap_8
X_0103_ _0103_/Q Tile_X0Y0_FrameData[18] VGND VPWR Tile_X0Y0_FrameStrobe[0] latch
X_1083_ _1083_/X Tile_X2Y0_N1END[3] Tile_X2Y0_N2MID[3] Tile_X2Y0_N2MID[4] Tile_X2Y0_N2END[4]
+ _0323_/Q _0322_/Q VPWR VGND sg13cmos5l_mux4_1
XANTENNA_290 Tile_X0Y0_FrameData[15] VPWR VGND sg13cmos5l_antennanp
X_0936_ Tile_X2Y0_FrameStrobe_O[1] Tile_X2Y0_FrameStrobe[1] VPWR VGND sg13cmos5l_buf_1
XFILLER_11_2737 VPWR VGND sg13cmos5l_decap_8
X_0867_ Tile_X2Y0_S2BEG[0] Tile_X2Y0_N2MID[7] VPWR VGND sg13cmos5l_buf_1
XANTENNA__0820__X Tile_X4Y0_FrameData_O[9] VPWR VGND sg13cmos5l_antennanp
X_0798_ Tile_X3Y0_SS4BEG[3] _1278_/X VPWR VGND sg13cmos5l_buf_1
XFILLER_9_2153 VPWR VGND sg13cmos5l_decap_8
XFILLER_9_1452 VPWR VGND sg13cmos5l_fill_2
XFILLER_16_2648 VPWR VGND sg13cmos5l_decap_8
XFILLER_16_1903 VPWR VGND sg13cmos5l_decap_8
XFILLER_12_637 VPWR VGND sg13cmos5l_decap_8
XFILLER_8_619 VPWR VGND sg13cmos5l_decap_8
XFILLER_11_147 VPWR VGND sg13cmos5l_decap_8
XFILLER_16_1958 VPWR VGND sg13cmos5l_decap_8
XFILLER_14_2394 VPWR VGND sg13cmos5l_decap_8
XFILLER_10_2247 VPWR VGND sg13cmos5l_decap_8
XANTENNA_3008 Tile_X0Y0_FrameData[19] VPWR VGND sg13cmos5l_antennanp
XFILLER_10_1524 VPWR VGND sg13cmos5l_decap_8
XANTENNA__0730__X Tile_X1Y0_S4BEG[15] VPWR VGND sg13cmos5l_antennanp
XANTENNA_2307 Tile_X0Y0_N4END[0] VPWR VGND sg13cmos5l_antennanp
XANTENNA_3019 Tile_X0Y0_FrameData[19] VPWR VGND sg13cmos5l_antennanp
XANTENNA_2318 Tile_X3Y0_N4END[6] VPWR VGND sg13cmos5l_antennanp
XANTENNA_2329 Tile_X0Y0_FrameData[11] VPWR VGND sg13cmos5l_antennanp
XANTENNA_1606 Tile_X0Y0_FrameData[4] VPWR VGND sg13cmos5l_antennanp
XANTENNA_1617 Tile_X0Y0_FrameData[4] VPWR VGND sg13cmos5l_antennanp
XANTENNA_1628 Tile_X0Y0_FrameData[4] VPWR VGND sg13cmos5l_antennanp
XANTENNA_1639 Tile_X0Y0_FrameData[4] VPWR VGND sg13cmos5l_antennanp
XFILLER_1_2404 VPWR VGND sg13cmos5l_fill_2
XFILLER_1_1725 VPWR VGND sg13cmos5l_decap_8
XFILLER_15_442 VPWR VGND sg13cmos5l_decap_8
XFILLER_15_2114 VPWR VGND sg13cmos5l_decap_8
XANTENNA__0905__X Tile_X2Y0_SS4BEG[6] VPWR VGND sg13cmos5l_antennanp
XFILLER_8_56 VPWR VGND sg13cmos5l_decap_8
X_0721_ Tile_X1Y0_S4BEG[6] _1185_/X VPWR VGND sg13cmos5l_buf_1
XFILLER_7_630 VPWR VGND sg13cmos5l_decap_8
XFILLER_15_1468 VPWR VGND sg13cmos5l_fill_2
XFILLER_15_1457 VPWR VGND sg13cmos5l_decap_8
XFILLER_11_670 VPWR VGND sg13cmos5l_decap_8
XANTENNA_3520 Tile_X0Y0_FrameData[8] VPWR VGND sg13cmos5l_antennanp
XANTENNA_3531 Tile_X0Y0_FrameData[8] VPWR VGND sg13cmos5l_antennanp
X_0652_ _0652_/L_HI VPWR VGND sg13cmos5l_tiehi
XFILLER_13_1192 VPWR VGND sg13cmos5l_decap_8
XANTENNA_3542 Tile_X0Y0_FrameData[8] VPWR VGND sg13cmos5l_antennanp
XANTENNA_3553 Tile_X0Y0_FrameData[8] VPWR VGND sg13cmos5l_antennanp
XANTENNA_3564 Tile_X0Y0_FrameData[8] VPWR VGND sg13cmos5l_antennanp
X_0583_ _0583_/Q Tile_X0Y0_UserCLK NPU_RDATA11 _0653_/L_HI VPWR VGND sg13cmos5l_dfrbpq_1
XANTENNA_2830 Tile_X0Y0_FrameData[17] VPWR VGND sg13cmos5l_antennanp
XANTENNA_2841 Tile_X0Y0_FrameData[17] VPWR VGND sg13cmos5l_antennanp
XANTENNA_2852 Tile_X0Y0_FrameData[17] VPWR VGND sg13cmos5l_antennanp
XANTENNA_3575 Tile_X0Y0_FrameData[8] VPWR VGND sg13cmos5l_antennanp
XANTENNA_3586 Tile_X0Y0_FrameData[8] VPWR VGND sg13cmos5l_antennanp
XANTENNA_3597 Tile_X0Y0_FrameData[8] VPWR VGND sg13cmos5l_antennanp
XANTENNA_2863 Tile_X0Y0_FrameData[17] VPWR VGND sg13cmos5l_antennanp
XANTENNA_2874 Tile_X0Y0_FrameData[17] VPWR VGND sg13cmos5l_antennanp
XANTENNA_2885 Tile_X0Y0_FrameData[17] VPWR VGND sg13cmos5l_antennanp
XANTENNA_2896 Tile_X0Y0_FrameData[17] VPWR VGND sg13cmos5l_antennanp
XFILLER_6_2348 VPWR VGND sg13cmos5l_fill_2
X_1204_ _1204_/X Tile_X1Y0_N2END[1] Tile_X1Y0_N4END[9] Tile_X1Y0_NN4END[6] _0590_/Q
+ _0247_/Q _0246_/Q VPWR VGND sg13cmos5l_mux4_1
X_1135_ _1135_/X Tile_X0Y0_N1END[0] Tile_X0Y0_N2MID[4] Tile_X0Y0_N2END[3] _0600_/Q
+ _0193_/Q _0192_/Q VPWR VGND sg13cmos5l_mux4_1
X_1066_ Tile_X4Y0_SS4BEG[3] Tile_X4Y0_NN4END[12] VPWR VGND sg13cmos5l_buf_1
XANTENNA__0815__X Tile_X4Y0_FrameData_O[4] VPWR VGND sg13cmos5l_antennanp
XFILLER_11_2534 VPWR VGND sg13cmos5l_fill_1
X_0919_ Tile_X3Y0_FrameStrobe_O[4] Tile_X3Y0_FrameStrobe[4] VPWR VGND sg13cmos5l_buf_1
XFILLER_5_1157 VPWR VGND sg13cmos5l_decap_8
XFILLER_2_2735 VPWR VGND sg13cmos5l_decap_8
XFILLER_16_206 VPWR VGND sg13cmos5l_decap_4
XFILLER_16_228 VPWR VGND sg13cmos5l_fill_2
XFILLER_0_2492 VPWR VGND sg13cmos5l_decap_8
XFILLER_0_2481 VPWR VGND sg13cmos5l_fill_1
XFILLER_16_2423 VPWR VGND sg13cmos5l_decap_8
XANTENNA__0725__X Tile_X1Y0_S4BEG[10] VPWR VGND sg13cmos5l_antennanp
XFILLER_12_2309 VPWR VGND sg13cmos5l_decap_8
XFILLER_16_1777 VPWR VGND sg13cmos5l_decap_8
XFILLER_4_611 VPWR VGND sg13cmos5l_decap_8
XANTENNA_2104 Tile_X0Y0_FrameData[6] VPWR VGND sg13cmos5l_antennanp
XANTENNA_2115 Tile_X0Y0_FrameData[7] VPWR VGND sg13cmos5l_antennanp
XANTENNA_1403 Tile_X0Y0_FrameData[31] VPWR VGND sg13cmos5l_antennanp
XANTENNA_2126 Tile_X0Y0_FrameData[9] VPWR VGND sg13cmos5l_antennanp
XANTENNA_2137 Tile_X0Y0_FrameData[9] VPWR VGND sg13cmos5l_antennanp
XANTENNA_2148 Tile_X0Y0_FrameData[9] VPWR VGND sg13cmos5l_antennanp
XFILLER_7_2602 VPWR VGND sg13cmos5l_decap_8
XANTENNA_1414 Tile_X0Y0_FrameData[31] VPWR VGND sg13cmos5l_antennanp
XANTENNA_1425 Tile_X0Y0_FrameData[31] VPWR VGND sg13cmos5l_antennanp
XANTENNA_1436 Tile_X0Y0_FrameData[31] VPWR VGND sg13cmos5l_antennanp
XANTENNA_1447 Tile_X0Y0_FrameData[31] VPWR VGND sg13cmos5l_antennanp
XANTENNA_2159 Tile_X0Y0_FrameData[9] VPWR VGND sg13cmos5l_antennanp
XANTENNA_1458 Tile_X0Y0_FrameData[31] VPWR VGND sg13cmos5l_antennanp
XANTENNA_1469 Tile_X0Y0_FrameData[31] VPWR VGND sg13cmos5l_antennanp
XFILLER_7_2679 VPWR VGND sg13cmos5l_decap_8
XFILLER_0_861 VPWR VGND sg13cmos5l_fill_1
XFILLER_16_784 VPWR VGND sg13cmos5l_decap_8
XFILLER_15_1221 VPWR VGND sg13cmos5l_decap_8
XANTENNA_4040 Tile_X0Y0_N2END[5] VPWR VGND sg13cmos5l_antennanp
X_0704_ Tile_X0Y0_FrameStrobe_O[17] Tile_X0Y0_FrameStrobe[17] VPWR VGND sg13cmos5l_buf_1
XANTENNA_4051 Tile_X0Y0_N4END[3] VPWR VGND sg13cmos5l_antennanp
XANTENNA_4062 Tile_X0Y0_N4END[3] VPWR VGND sg13cmos5l_antennanp
XANTENNA_4073 Tile_X0Y0_NN4END[2] VPWR VGND sg13cmos5l_antennanp
XANTENNA_4084 Tile_X1Y0_N2END[4] VPWR VGND sg13cmos5l_antennanp
X_0635_ _0635_/L_HI VPWR VGND sg13cmos5l_tiehi
XANTENNA_3350 Tile_X0Y0_FrameData[20] VPWR VGND sg13cmos5l_antennanp
XANTENNA_3361 Tile_X0Y0_FrameData[20] VPWR VGND sg13cmos5l_antennanp
XANTENNA_3372 Tile_X0Y0_FrameData[21] VPWR VGND sg13cmos5l_antennanp
XANTENNA_4095 Tile_X1Y0_N4END[0] VPWR VGND sg13cmos5l_antennanp
XANTENNA_2660 Tile_X0Y0_FrameData[14] VPWR VGND sg13cmos5l_antennanp
XANTENNA_2671 Tile_X0Y0_FrameData[14] VPWR VGND sg13cmos5l_antennanp
XANTENNA_3383 Tile_X0Y0_FrameData[21] VPWR VGND sg13cmos5l_antennanp
XANTENNA_3394 Tile_X0Y0_FrameData[21] VPWR VGND sg13cmos5l_antennanp
X_0566_ NPU_ADDR2 Tile_X0Y0_UserCLK _1082_/X _0675_/L_HI VPWR VGND sg13cmos5l_dfrbpq_1
XFILLER_6_2123 VPWR VGND sg13cmos5l_fill_2
XANTENNA_2682 Tile_X0Y0_FrameData[14] VPWR VGND sg13cmos5l_antennanp
XANTENNA_2693 Tile_X0Y0_FrameData[14] VPWR VGND sg13cmos5l_antennanp
X_0497_ _0497_/Q Tile_X0Y0_FrameData[8] VGND VPWR Tile_X3Y0_FrameStrobe[2] latch
XANTENNA_1970 Tile_X0Y0_FrameData[6] VPWR VGND sg13cmos5l_antennanp
XANTENNA_1981 Tile_X0Y0_FrameData[6] VPWR VGND sg13cmos5l_antennanp
XANTENNA_1992 Tile_X0Y0_FrameData[6] VPWR VGND sg13cmos5l_antennanp
X_1118_ _1118_/X Tile_X0Y0_N4END[6] Tile_X0Y0_N4END[7] Tile_X0Y0_NN4END[4] Tile_X0Y0_NN4END[6]
+ _0109_/Q _0108_/Q VPWR VGND sg13cmos5l_mux4_1
X_1049_ Tile_X4Y0_S4BEG[2] Tile_X4Y0_N4END[13] VPWR VGND sg13cmos5l_buf_1
XFILLER_13_2629 VPWR VGND sg13cmos5l_decap_8
XFILLER_11_2331 VPWR VGND sg13cmos5l_decap_8
XFILLER_11_1641 VPWR VGND sg13cmos5l_decap_8
XFILLER_7_1208 VPWR VGND sg13cmos5l_fill_1
XFILLER_2_2521 VPWR VGND sg13cmos5l_decap_8
XFILLER_6_2690 VPWR VGND sg13cmos5l_decap_8
XFILLER_2_2565 VPWR VGND sg13cmos5l_fill_1
XFILLER_2_1842 VPWR VGND sg13cmos5l_fill_2
XANTENNA_801 Tile_X0Y0_FrameData[27] VPWR VGND sg13cmos5l_antennanp
XANTENNA_845 Tile_X0Y0_FrameData[27] VPWR VGND sg13cmos5l_antennanp
XANTENNA_834 Tile_X0Y0_FrameData[27] VPWR VGND sg13cmos5l_antennanp
XANTENNA_823 Tile_X0Y0_FrameData[27] VPWR VGND sg13cmos5l_antennanp
XANTENNA_812 Tile_X0Y0_FrameData[27] VPWR VGND sg13cmos5l_antennanp
XANTENNA_878 Tile_X0Y0_FrameData[27] VPWR VGND sg13cmos5l_antennanp
XANTENNA_867 Tile_X0Y0_FrameData[27] VPWR VGND sg13cmos5l_antennanp
XANTENNA_856 Tile_X0Y0_FrameData[27] VPWR VGND sg13cmos5l_antennanp
XANTENNA_889 Tile_X0Y0_FrameData[27] VPWR VGND sg13cmos5l_antennanp
XFILLER_9_714 VPWR VGND sg13cmos5l_decap_8
XFILLER_9_725 VPWR VGND sg13cmos5l_fill_2
XFILLER_16_2253 VPWR VGND sg13cmos5l_decap_8
XFILLER_13_776 VPWR VGND sg13cmos5l_decap_8
XFILLER_12_2106 VPWR VGND sg13cmos5l_decap_8
XFILLER_16_2286 VPWR VGND sg13cmos5l_fill_1
XFILLER_16_1563 VPWR VGND sg13cmos5l_decap_8
XFILLER_12_1405 VPWR VGND sg13cmos5l_fill_1
XFILLER_5_35 VPWR VGND sg13cmos5l_decap_8
XFILLER_4_441 VPWR VGND sg13cmos5l_fill_1
XFILLER_10_1140 VPWR VGND sg13cmos5l_decap_8
XANTENNA_1200 Tile_X0Y0_FrameData[30] VPWR VGND sg13cmos5l_antennanp
XANTENNA_1211 Tile_X0Y0_FrameData[30] VPWR VGND sg13cmos5l_antennanp
X_0420_ _0420_/Q Tile_X0Y0_FrameData[21] VGND VPWR Tile_X3Y0_FrameStrobe[0] latch
XANTENNA_1222 Tile_X0Y0_FrameData[30] VPWR VGND sg13cmos5l_antennanp
XANTENNA_1233 Tile_X0Y0_FrameData[30] VPWR VGND sg13cmos5l_antennanp
XANTENNA_1244 Tile_X0Y0_FrameData[30] VPWR VGND sg13cmos5l_antennanp
XANTENNA_1255 Tile_X0Y0_FrameData[30] VPWR VGND sg13cmos5l_antennanp
X_0351_ _0351_/Q Tile_X0Y0_FrameData[26] VGND VPWR Tile_X2Y0_FrameStrobe[1] latch
XANTENNA_1266 Tile_X0Y0_FrameData[30] VPWR VGND sg13cmos5l_antennanp
XANTENNA_1277 Tile_X0Y0_FrameData[30] VPWR VGND sg13cmos5l_antennanp
XANTENNA_1288 Tile_X0Y0_FrameData[30] VPWR VGND sg13cmos5l_antennanp
XFILLER_7_1764 VPWR VGND sg13cmos5l_decap_8
XANTENNA_1299 Tile_X0Y0_FrameData[30] VPWR VGND sg13cmos5l_antennanp
X_0282_ _0282_/Q Tile_X0Y0_FrameData[15] VGND VPWR Tile_X1Y0_FrameStrobe[2] latch
XFILLER_3_1628 VPWR VGND sg13cmos5l_decap_8
XFILLER_16_592 VPWR VGND sg13cmos5l_decap_8
XFILLER_15_1040 VPWR VGND sg13cmos5l_fill_2
XFILLER_15_1073 VPWR VGND sg13cmos5l_fill_2
XFILLER_12_2640 VPWR VGND sg13cmos5l_decap_8
XANTENNA_3180 Tile_X0Y0_FrameData[20] VPWR VGND sg13cmos5l_antennanp
X_0618_ _0618_/L_HI VPWR VGND sg13cmos5l_tiehi
XANTENNA_3191 Tile_X0Y0_FrameData[20] VPWR VGND sg13cmos5l_antennanp
X_0549_ NPU_WDATA25 Tile_X0Y0_UserCLK _1121_/X _0660_/L_HI VPWR VGND sg13cmos5l_dfrbpq_1
XANTENNA_2490 Tile_X0Y0_FrameData[12] VPWR VGND sg13cmos5l_antennanp
XFILLER_6_1274 VPWR VGND sg13cmos5l_fill_1
XANTENNA_108 Tile_X0Y0_FrameData[0] VPWR VGND sg13cmos5l_antennanp
XANTENNA_119 Tile_X0Y0_FrameData[0] VPWR VGND sg13cmos5l_antennanp
XFILLER_14_77 VPWR VGND sg13cmos5l_decap_8
XFILLER_10_724 VPWR VGND sg13cmos5l_decap_8
XFILLER_13_1747 VPWR VGND sg13cmos5l_decap_8
XFILLER_8_2741 VPWR VGND sg13cmos5l_decap_8
XFILLER_4_2605 VPWR VGND sg13cmos5l_decap_8
XFILLER_4_1948 VPWR VGND sg13cmos5l_fill_1
XFILLER_2_2395 VPWR VGND sg13cmos5l_fill_1
XANTENNA_620 Tile_X0Y0_FrameData[23] VPWR VGND sg13cmos5l_antennanp
XANTENNA_653 Tile_X0Y0_FrameData[24] VPWR VGND sg13cmos5l_antennanp
XANTENNA_642 Tile_X0Y0_FrameData[23] VPWR VGND sg13cmos5l_antennanp
XANTENNA_631 Tile_X0Y0_FrameData[23] VPWR VGND sg13cmos5l_antennanp
XANTENNA_686 Tile_X0Y0_FrameData[24] VPWR VGND sg13cmos5l_antennanp
XANTENNA_675 Tile_X0Y0_FrameData[24] VPWR VGND sg13cmos5l_antennanp
XANTENNA_664 Tile_X0Y0_FrameData[24] VPWR VGND sg13cmos5l_antennanp
XFILLER_16_2050 VPWR VGND sg13cmos5l_decap_8
XFILLER_13_562 VPWR VGND sg13cmos5l_decap_8
XANTENNA_697 Tile_X0Y0_FrameData[24] VPWR VGND sg13cmos5l_antennanp
XANTENNA__0913__X Tile_X2Y0_SS4BEG[14] VPWR VGND sg13cmos5l_antennanp
XFILLER_9_588 VPWR VGND sg13cmos5l_decap_8
XFILLER_16_1393 VPWR VGND sg13cmos5l_decap_4
XFILLER_12_1224 VPWR VGND sg13cmos5l_decap_8
XFILLER_9_2505 VPWR VGND sg13cmos5l_decap_8
XANTENNA_1030 Tile_X0Y0_FrameData[29] VPWR VGND sg13cmos5l_antennanp
X_0403_ _0403_/Q Tile_X0Y0_FrameData[6] VGND VPWR Tile_X2Y0_FrameStrobe[2] latch
XANTENNA_1041 Tile_X0Y0_FrameData[29] VPWR VGND sg13cmos5l_antennanp
XANTENNA_1052 Tile_X0Y0_FrameData[29] VPWR VGND sg13cmos5l_antennanp
XANTENNA_1063 Tile_X0Y0_FrameData[29] VPWR VGND sg13cmos5l_antennanp
XFILLER_7_2262 VPWR VGND sg13cmos5l_decap_8
XANTENNA_1074 Tile_X0Y0_FrameData[2] VPWR VGND sg13cmos5l_antennanp
XANTENNA_1085 Tile_X0Y0_FrameData[2] VPWR VGND sg13cmos5l_antennanp
XANTENNA_1096 Tile_X0Y0_FrameData[2] VPWR VGND sg13cmos5l_antennanp
X_0334_ _0334_/Q Tile_X0Y0_FrameData[11] VGND VPWR Tile_X2Y0_FrameStrobe[0] latch
X_0265_ _0265_/Q Tile_X0Y0_FrameData[0] VGND VPWR Tile_X1Y0_FrameStrobe[1] latch
X_0196_ _0196_/Q Tile_X0Y0_FrameData[21] VGND VPWR Tile_X0Y0_FrameStrobe[3] latch
XFILLER_14_2746 VPWR VGND sg13cmos5l_fill_2
XFILLER_14_2735 VPWR VGND sg13cmos5l_decap_8
XANTENNA__0823__X Tile_X4Y0_FrameData_O[12] VPWR VGND sg13cmos5l_antennanp
XFILLER_12_2470 VPWR VGND sg13cmos5l_decap_8
XFILLER_3_2682 VPWR VGND sg13cmos5l_decap_8
XFILLER_3_1970 VPWR VGND sg13cmos5l_fill_1
XFILLER_13_2201 VPWR VGND sg13cmos5l_decap_8
XANTENNA__0733__X Tile_X1Y0_SS4BEG[2] VPWR VGND sg13cmos5l_antennanp
XFILLER_10_543 VPWR VGND sg13cmos5l_decap_8
XFILLER_13_1544 VPWR VGND sg13cmos5l_decap_8
XANTENNA_3905 Tile_X0Y0_FrameData[18] VPWR VGND sg13cmos5l_antennanp
XANTENNA_3916 Tile_X0Y0_FrameData[18] VPWR VGND sg13cmos5l_antennanp
XANTENNA_3927 Tile_X0Y0_FrameData[18] VPWR VGND sg13cmos5l_antennanp
XANTENNA_3938 Tile_X0Y0_FrameData[18] VPWR VGND sg13cmos5l_antennanp
XANTENNA_3949 Tile_X0Y0_FrameData[18] VPWR VGND sg13cmos5l_antennanp
XFILLER_9_0 VPWR VGND sg13cmos5l_decap_8
XFILLER_2_14 VPWR VGND sg13cmos5l_decap_8
XFILLER_4_1712 VPWR VGND sg13cmos5l_decap_8
XANTENNA__0908__X Tile_X2Y0_SS4BEG[9] VPWR VGND sg13cmos5l_antennanp
XANTENNA_461 Tile_X0Y0_FrameData[23] VPWR VGND sg13cmos5l_antennanp
XANTENNA_450 Tile_X0Y0_FrameData[23] VPWR VGND sg13cmos5l_antennanp
XANTENNA_494 Tile_X0Y0_FrameData[23] VPWR VGND sg13cmos5l_antennanp
XANTENNA_483 Tile_X0Y0_FrameData[23] VPWR VGND sg13cmos5l_antennanp
XANTENNA_472 Tile_X0Y0_FrameData[23] VPWR VGND sg13cmos5l_antennanp
XANTENNA_19 NPU_RDATA22 VPWR VGND sg13cmos5l_antennanp
X_0952_ Tile_X2Y0_FrameStrobe_O[17] Tile_X2Y0_FrameStrobe[17] VPWR VGND sg13cmos5l_buf_1
XFILLER_13_392 VPWR VGND sg13cmos5l_fill_2
X_0883_ Tile_X2Y0_S4BEG[0] _1219_/X VPWR VGND sg13cmos5l_buf_1
XFILLER_9_2302 VPWR VGND sg13cmos5l_decap_8
XFILLER_12_1098 VPWR VGND sg13cmos5l_decap_8
XFILLER_9_2379 VPWR VGND sg13cmos5l_decap_8
X_0317_ _0317_/Q Tile_X0Y0_FrameData[28] VGND VPWR Tile_X2Y0_FrameStrobe[0] latch
XANTENNA__0818__X Tile_X4Y0_FrameData_O[7] VPWR VGND sg13cmos5l_antennanp
X_0248_ _0248_/Q Tile_X0Y0_FrameData[17] VGND VPWR Tile_X1Y0_FrameStrobe[1] latch
XFILLER_3_1277 VPWR VGND sg13cmos5l_fill_2
X_0179_ _0179_/Q Tile_X0Y0_FrameData[6] VGND VPWR Tile_X0Y0_FrameStrobe[2] latch
XFILLER_10_2429 VPWR VGND sg13cmos5l_decap_8
XFILLER_14_1886 VPWR VGND sg13cmos5l_decap_8
XFILLER_10_1706 VPWR VGND sg13cmos5l_decap_8
XFILLER_11_67 VPWR VGND sg13cmos5l_decap_8
XFILLER_2_7 VPWR VGND sg13cmos5l_decap_8
XFILLER_5_2700 VPWR VGND sg13cmos5l_decap_8
XFILLER_8_1144 VPWR VGND sg13cmos5l_decap_8
XFILLER_1_2619 VPWR VGND sg13cmos5l_decap_4
XANTENNA__0728__X Tile_X1Y0_S4BEG[13] VPWR VGND sg13cmos5l_antennanp
XFILLER_15_602 VPWR VGND sg13cmos5l_decap_8
XFILLER_14_112 VPWR VGND sg13cmos5l_decap_8
XFILLER_15_657 VPWR VGND sg13cmos5l_decap_8
XFILLER_14_189 VPWR VGND sg13cmos5l_decap_8
XFILLER_6_333 VPWR VGND sg13cmos5l_fill_2
XFILLER_13_2075 VPWR VGND sg13cmos5l_decap_8
XANTENNA_3702 Tile_X1Y0_N4END[2] VPWR VGND sg13cmos5l_antennanp
XANTENNA_3713 Tile_X1Y0_N4END[3] VPWR VGND sg13cmos5l_antennanp
XANTENNA_3724 Tile_X1Y0_N4END[3] VPWR VGND sg13cmos5l_antennanp
XANTENNA_3735 Tile_X1Y0_NN4END[0] VPWR VGND sg13cmos5l_antennanp
XANTENNA_3746 Tile_X2Y0_N2END[4] VPWR VGND sg13cmos5l_antennanp
XANTENNA_3757 Tile_X3Y0_N4END[8] VPWR VGND sg13cmos5l_antennanp
XANTENNA_3768 Tile_X0Y0_FrameData[18] VPWR VGND sg13cmos5l_antennanp
XANTENNA_3779 Tile_X0Y0_FrameData[18] VPWR VGND sg13cmos5l_antennanp
X_1220_ _1220_/X Tile_X2Y0_N2MID[1] Tile_X2Y0_N4END[14] Tile_X2Y0_NN4END[1] _0587_/Q
+ _0391_/Q _0390_/Q VPWR VGND sg13cmos5l_mux4_1
X_1151_ _1151_/X Tile_X0Y0_N2MID[4] Tile_X0Y0_N4END[3] Tile_X0Y0_NN4END[12] _0596_/Q
+ _0161_/Q _0160_/Q VPWR VGND sg13cmos5l_mux4_1
X_0102_ _0102_/Q Tile_X0Y0_FrameData[19] VGND VPWR Tile_X0Y0_FrameStrobe[0] latch
XFILLER_4_2276 VPWR VGND sg13cmos5l_decap_8
X_1082_ _1082_/X Tile_X2Y0_N1END[2] Tile_X2Y0_N2MID[2] Tile_X2Y0_N2MID[5] Tile_X2Y0_N2END[5]
+ _0325_/Q _0324_/Q VPWR VGND sg13cmos5l_mux4_1
XANTENNA_280 Tile_X0Y0_FrameData[10] VPWR VGND sg13cmos5l_antennanp
XANTENNA_291 Tile_X0Y0_FrameData[15] VPWR VGND sg13cmos5l_antennanp
XFILLER_14_1105 VPWR VGND sg13cmos5l_fill_2
X_0935_ Tile_X2Y0_FrameStrobe_O[0] Tile_X2Y0_FrameStrobe[0] VPWR VGND sg13cmos5l_buf_1
XFILLER_14_1138 VPWR VGND sg13cmos5l_decap_8
XFILLER_14_1127 VPWR VGND sg13cmos5l_fill_1
XFILLER_11_2716 VPWR VGND sg13cmos5l_decap_8
X_0866_ Tile_X2Y0_S1BEG[3] Tile_X2Y0_N1END[0] VPWR VGND sg13cmos5l_buf_1
X_0797_ Tile_X3Y0_SS4BEG[2] _1277_/X VPWR VGND sg13cmos5l_buf_1
XFILLER_9_2132 VPWR VGND sg13cmos5l_decap_8
XFILLER_5_1317 VPWR VGND sg13cmos5l_fill_1
XFILLER_16_2627 VPWR VGND sg13cmos5l_decap_8
XFILLER_12_627 VPWR VGND sg13cmos5l_decap_8
XFILLER_11_104 VPWR VGND sg13cmos5l_decap_8
XFILLER_11_126 VPWR VGND sg13cmos5l_decap_8
XFILLER_16_1948 VPWR VGND sg13cmos5l_decap_8
XFILLER_14_2373 VPWR VGND sg13cmos5l_decap_8
XFILLER_10_2226 VPWR VGND sg13cmos5l_decap_8
XANTENNA_3009 Tile_X0Y0_FrameData[19] VPWR VGND sg13cmos5l_antennanp
XFILLER_14_1683 VPWR VGND sg13cmos5l_decap_8
XANTENNA_2308 Tile_X0Y0_N4END[0] VPWR VGND sg13cmos5l_antennanp
XANTENNA_2319 Tile_X3Y0_N4END[6] VPWR VGND sg13cmos5l_antennanp
XANTENNA_1607 Tile_X0Y0_FrameData[4] VPWR VGND sg13cmos5l_antennanp
XANTENNA_1618 Tile_X0Y0_FrameData[4] VPWR VGND sg13cmos5l_antennanp
XANTENNA_1629 Tile_X0Y0_FrameData[4] VPWR VGND sg13cmos5l_antennanp
XFILLER_5_1862 VPWR VGND sg13cmos5l_fill_2
XFILLER_1_1704 VPWR VGND sg13cmos5l_decap_8
XFILLER_15_487 VPWR VGND sg13cmos5l_fill_2
XFILLER_15_1414 VPWR VGND sg13cmos5l_fill_2
XFILLER_8_35 VPWR VGND sg13cmos5l_decap_8
XFILLER_15_1425 VPWR VGND sg13cmos5l_fill_1
X_0720_ Tile_X1Y0_S4BEG[5] _1184_/X VPWR VGND sg13cmos5l_buf_1
XANTENNA__0921__X Tile_X3Y0_FrameStrobe_O[6] VPWR VGND sg13cmos5l_antennanp
XFILLER_13_1171 VPWR VGND sg13cmos5l_decap_8
XANTENNA_3510 Tile_X0Y0_FrameData[8] VPWR VGND sg13cmos5l_antennanp
XANTENNA_3521 Tile_X0Y0_FrameData[8] VPWR VGND sg13cmos5l_antennanp
X_0651_ _0651_/L_HI VPWR VGND sg13cmos5l_tiehi
XFILLER_7_686 VPWR VGND sg13cmos5l_decap_4
XANTENNA_2820 Tile_X0Y0_FrameData[17] VPWR VGND sg13cmos5l_antennanp
XANTENNA_3532 Tile_X0Y0_FrameData[8] VPWR VGND sg13cmos5l_antennanp
XANTENNA_3543 Tile_X0Y0_FrameData[8] VPWR VGND sg13cmos5l_antennanp
XANTENNA_3554 Tile_X0Y0_FrameData[8] VPWR VGND sg13cmos5l_antennanp
X_0582_ _0582_/Q Tile_X0Y0_UserCLK NPU_RDATA10 _0654_/L_HI VPWR VGND sg13cmos5l_dfrbpq_1
XANTENNA_2831 Tile_X0Y0_FrameData[17] VPWR VGND sg13cmos5l_antennanp
XANTENNA_2842 Tile_X0Y0_FrameData[17] VPWR VGND sg13cmos5l_antennanp
XANTENNA_2853 Tile_X0Y0_FrameData[17] VPWR VGND sg13cmos5l_antennanp
XANTENNA_3565 Tile_X0Y0_FrameData[8] VPWR VGND sg13cmos5l_antennanp
XANTENNA_3576 Tile_X0Y0_FrameData[8] VPWR VGND sg13cmos5l_antennanp
XANTENNA_3587 Tile_X0Y0_FrameData[8] VPWR VGND sg13cmos5l_antennanp
XANTENNA_3598 Tile_X0Y0_FrameData[8] VPWR VGND sg13cmos5l_antennanp
XANTENNA_2864 Tile_X0Y0_FrameData[17] VPWR VGND sg13cmos5l_antennanp
XANTENNA_2875 Tile_X0Y0_FrameData[17] VPWR VGND sg13cmos5l_antennanp
XANTENNA_2886 Tile_X0Y0_FrameData[17] VPWR VGND sg13cmos5l_antennanp
XFILLER_6_2327 VPWR VGND sg13cmos5l_decap_8
XANTENNA_2897 Tile_X0Y0_FrameData[17] VPWR VGND sg13cmos5l_antennanp
X_1203_ _1203_/X Tile_X1Y0_N2END[0] Tile_X1Y0_N4END[8] Tile_X1Y0_NN4END[7] _0591_/Q
+ _0249_/Q _0248_/Q VPWR VGND sg13cmos5l_mux4_1
X_1134_ _1134_/X Tile_X0Y0_N1END[3] Tile_X0Y0_N2MID[3] Tile_X0Y0_N2END[4] _0599_/Q
+ _0195_/Q _0194_/Q VPWR VGND sg13cmos5l_mux4_1
X_1065_ Tile_X4Y0_SS4BEG[2] Tile_X4Y0_NN4END[13] VPWR VGND sg13cmos5l_buf_1
XFILLER_15_2682 VPWR VGND sg13cmos5l_decap_8
XFILLER_11_2513 VPWR VGND sg13cmos5l_decap_8
XANTENNA__0831__X Tile_X4Y0_FrameData_O[20] VPWR VGND sg13cmos5l_antennanp
X_0918_ Tile_X3Y0_FrameStrobe_O[3] Tile_X3Y0_FrameStrobe[3] VPWR VGND sg13cmos5l_buf_1
XFILLER_11_1823 VPWR VGND sg13cmos5l_decap_8
X_0849_ Tile_X4Y0_FrameStrobe_O[6] Tile_X4Y0_FrameStrobe[6] VPWR VGND sg13cmos5l_buf_1
XFILLER_5_1136 VPWR VGND sg13cmos5l_decap_8
XFILLER_2_2714 VPWR VGND sg13cmos5l_decap_8
XFILLER_16_2402 VPWR VGND sg13cmos5l_decap_8
XFILLER_16_1701 VPWR VGND sg13cmos5l_fill_2
XFILLER_12_435 VPWR VGND sg13cmos5l_fill_2
XFILLER_16_2479 VPWR VGND sg13cmos5l_decap_8
XFILLER_16_1756 VPWR VGND sg13cmos5l_decap_8
XFILLER_14_2181 VPWR VGND sg13cmos5l_decap_8
XANTENNA__0741__X Tile_X1Y0_SS4BEG[10] VPWR VGND sg13cmos5l_antennanp
XFILLER_14_1480 VPWR VGND sg13cmos5l_decap_8
XANTENNA_2105 Tile_X0Y0_FrameData[7] VPWR VGND sg13cmos5l_antennanp
XANTENNA_1404 Tile_X0Y0_FrameData[31] VPWR VGND sg13cmos5l_antennanp
XANTENNA_2116 Tile_X0Y0_FrameData[7] VPWR VGND sg13cmos5l_antennanp
XANTENNA_2127 Tile_X0Y0_FrameData[9] VPWR VGND sg13cmos5l_antennanp
XANTENNA_2138 Tile_X0Y0_FrameData[9] VPWR VGND sg13cmos5l_antennanp
XANTENNA_2149 Tile_X0Y0_FrameData[9] VPWR VGND sg13cmos5l_antennanp
XANTENNA_1415 Tile_X0Y0_FrameData[31] VPWR VGND sg13cmos5l_antennanp
XANTENNA_1426 Tile_X0Y0_FrameData[31] VPWR VGND sg13cmos5l_antennanp
XANTENNA_1437 Tile_X0Y0_FrameData[31] VPWR VGND sg13cmos5l_antennanp
XFILLER_7_2658 VPWR VGND sg13cmos5l_decap_8
XANTENNA_1448 Tile_X0Y0_FrameData[31] VPWR VGND sg13cmos5l_antennanp
XANTENNA_1459 Tile_X0Y0_FrameData[31] VPWR VGND sg13cmos5l_antennanp
XFILLER_5_2382 VPWR VGND sg13cmos5l_decap_8
XFILLER_5_1681 VPWR VGND sg13cmos5l_decap_8
XFILLER_1_2268 VPWR VGND sg13cmos5l_decap_8
XANTENNA__0916__X Tile_X3Y0_FrameStrobe_O[1] VPWR VGND sg13cmos5l_antennanp
XFILLER_16_763 VPWR VGND sg13cmos5l_decap_8
XFILLER_15_1200 VPWR VGND sg13cmos5l_decap_8
XFILLER_8_973 VPWR VGND sg13cmos5l_fill_1
XFILLER_11_1119 VPWR VGND sg13cmos5l_decap_8
XANTENNA_4030 Tile_X0Y0_N2END[4] VPWR VGND sg13cmos5l_antennanp
XANTENNA_4041 Tile_X0Y0_N2END[5] VPWR VGND sg13cmos5l_antennanp
X_0703_ Tile_X0Y0_FrameStrobe_O[16] Tile_X0Y0_FrameStrobe[16] VPWR VGND sg13cmos5l_buf_1
XANTENNA_4052 Tile_X0Y0_N4END[3] VPWR VGND sg13cmos5l_antennanp
XANTENNA_4063 Tile_X0Y0_N4END[3] VPWR VGND sg13cmos5l_antennanp
XANTENNA_4074 Tile_X0Y0_NN4END[2] VPWR VGND sg13cmos5l_antennanp
X_0634_ _0634_/L_HI VPWR VGND sg13cmos5l_tiehi
XANTENNA_3340 Tile_X0Y0_FrameData[20] VPWR VGND sg13cmos5l_antennanp
XANTENNA_3351 Tile_X0Y0_FrameData[20] VPWR VGND sg13cmos5l_antennanp
XANTENNA_3362 Tile_X0Y0_FrameData[20] VPWR VGND sg13cmos5l_antennanp
XANTENNA_3373 Tile_X0Y0_FrameData[21] VPWR VGND sg13cmos5l_antennanp
XANTENNA_4085 Tile_X1Y0_N2END[7] VPWR VGND sg13cmos5l_antennanp
XANTENNA_4096 Tile_X1Y0_N4END[0] VPWR VGND sg13cmos5l_antennanp
XANTENNA_2650 Tile_X0Y0_FrameData[14] VPWR VGND sg13cmos5l_antennanp
XANTENNA_2661 Tile_X0Y0_FrameData[14] VPWR VGND sg13cmos5l_antennanp
XANTENNA_3384 Tile_X0Y0_FrameData[21] VPWR VGND sg13cmos5l_antennanp
XANTENNA_3395 Tile_X0Y0_FrameData[21] VPWR VGND sg13cmos5l_antennanp
X_0565_ NPU_ADDR1 Tile_X0Y0_UserCLK _1081_/X _0676_/L_HI VPWR VGND sg13cmos5l_dfrbpq_1
XANTENNA_1960 Tile_X0Y0_FrameData[6] VPWR VGND sg13cmos5l_antennanp
XANTENNA_2672 Tile_X0Y0_FrameData[14] VPWR VGND sg13cmos5l_antennanp
XANTENNA_2683 Tile_X0Y0_FrameData[14] VPWR VGND sg13cmos5l_antennanp
XANTENNA_2694 Tile_X0Y0_FrameData[14] VPWR VGND sg13cmos5l_antennanp
X_0496_ _0496_/Q Tile_X0Y0_FrameData[9] VGND VPWR Tile_X3Y0_FrameStrobe[2] latch
XANTENNA_1971 Tile_X0Y0_FrameData[6] VPWR VGND sg13cmos5l_antennanp
XANTENNA_1982 Tile_X0Y0_FrameData[6] VPWR VGND sg13cmos5l_antennanp
XANTENNA_1993 Tile_X0Y0_FrameData[6] VPWR VGND sg13cmos5l_antennanp
XFILLER_6_1445 VPWR VGND sg13cmos5l_fill_2
X_1117_ _1117_/X Tile_X0Y0_N4END[5] Tile_X0Y0_N4END[6] Tile_X0Y0_NN4END[5] Tile_X0Y0_NN4END[7]
+ _0111_/Q _0110_/Q VPWR VGND sg13cmos5l_mux4_1
XFILLER_1_2780 VPWR VGND sg13cmos5l_fill_1
XANTENNA__0826__X Tile_X4Y0_FrameData_O[15] VPWR VGND sg13cmos5l_antennanp
X_1048_ Tile_X4Y0_S4BEG[1] Tile_X4Y0_N4END[14] VPWR VGND sg13cmos5l_buf_1
XFILLER_16_1008 VPWR VGND sg13cmos5l_fill_1
XFILLER_13_2608 VPWR VGND sg13cmos5l_decap_8
XFILLER_11_2310 VPWR VGND sg13cmos5l_decap_8
XFILLER_11_2387 VPWR VGND sg13cmos5l_decap_8
XFILLER_11_1620 VPWR VGND sg13cmos5l_decap_8
XFILLER_11_1697 VPWR VGND sg13cmos5l_decap_8
XFILLER_2_2500 VPWR VGND sg13cmos5l_decap_8
XFILLER_2_1821 VPWR VGND sg13cmos5l_fill_1
XANTENNA_802 Tile_X0Y0_FrameData[27] VPWR VGND sg13cmos5l_antennanp
XANTENNA__0736__X Tile_X1Y0_SS4BEG[5] VPWR VGND sg13cmos5l_antennanp
XANTENNA_835 Tile_X0Y0_FrameData[27] VPWR VGND sg13cmos5l_antennanp
XANTENNA_824 Tile_X0Y0_FrameData[27] VPWR VGND sg13cmos5l_antennanp
XANTENNA_813 Tile_X0Y0_FrameData[27] VPWR VGND sg13cmos5l_antennanp
XANTENNA_868 Tile_X0Y0_FrameData[27] VPWR VGND sg13cmos5l_antennanp
XANTENNA_857 Tile_X0Y0_FrameData[27] VPWR VGND sg13cmos5l_antennanp
XANTENNA_846 Tile_X0Y0_FrameData[27] VPWR VGND sg13cmos5l_antennanp
XFILLER_16_2232 VPWR VGND sg13cmos5l_decap_8
XFILLER_16_2221 VPWR VGND sg13cmos5l_fill_1
XANTENNA_879 Tile_X0Y0_FrameData[27] VPWR VGND sg13cmos5l_antennanp
XFILLER_13_755 VPWR VGND sg13cmos5l_decap_8
XFILLER_16_1542 VPWR VGND sg13cmos5l_decap_8
XFILLER_5_14 VPWR VGND sg13cmos5l_decap_8
XFILLER_4_420 VPWR VGND sg13cmos5l_fill_2
XANTENNA_1201 Tile_X0Y0_FrameData[30] VPWR VGND sg13cmos5l_antennanp
XANTENNA_1212 Tile_X0Y0_FrameData[30] VPWR VGND sg13cmos5l_antennanp
XFILLER_7_2433 VPWR VGND sg13cmos5l_fill_2
XFILLER_7_2422 VPWR VGND sg13cmos5l_decap_8
XANTENNA_1223 Tile_X0Y0_FrameData[30] VPWR VGND sg13cmos5l_antennanp
XANTENNA_1234 Tile_X0Y0_FrameData[30] VPWR VGND sg13cmos5l_antennanp
XANTENNA_1245 Tile_X0Y0_FrameData[30] VPWR VGND sg13cmos5l_antennanp
X_0350_ _0350_/Q Tile_X0Y0_FrameData[27] VGND VPWR Tile_X2Y0_FrameStrobe[1] latch
XANTENNA_1256 Tile_X0Y0_FrameData[30] VPWR VGND sg13cmos5l_antennanp
XANTENNA_1267 Tile_X0Y0_FrameData[30] VPWR VGND sg13cmos5l_antennanp
XANTENNA_1278 Tile_X0Y0_FrameData[30] VPWR VGND sg13cmos5l_antennanp
XANTENNA_1289 Tile_X0Y0_FrameData[30] VPWR VGND sg13cmos5l_antennanp
X_0281_ _0281_/Q Tile_X0Y0_FrameData[16] VGND VPWR Tile_X1Y0_FrameStrobe[2] latch
XFILLER_7_2488 VPWR VGND sg13cmos5l_decap_8
XFILLER_7_1743 VPWR VGND sg13cmos5l_decap_8
XFILLER_3_1607 VPWR VGND sg13cmos5l_decap_8
XFILLER_16_571 VPWR VGND sg13cmos5l_decap_8
XFILLER_12_2696 VPWR VGND sg13cmos5l_decap_8
XANTENNA_3170 Tile_X0Y0_FrameData[19] VPWR VGND sg13cmos5l_antennanp
XANTENNA_3181 Tile_X0Y0_FrameData[20] VPWR VGND sg13cmos5l_antennanp
X_0617_ _0617_/L_HI VPWR VGND sg13cmos5l_tiehi
XANTENNA_3192 Tile_X0Y0_FrameData[20] VPWR VGND sg13cmos5l_antennanp
X_0548_ NPU_WDATA24 Tile_X0Y0_UserCLK _1120_/X _0661_/L_HI VPWR VGND sg13cmos5l_dfrbpq_1
XANTENNA_2480 Tile_X0Y0_FrameData[12] VPWR VGND sg13cmos5l_antennanp
XANTENNA_2491 Tile_X0Y0_FrameData[12] VPWR VGND sg13cmos5l_antennanp
XANTENNA_1790 Tile_X0Y0_FrameData[5] VPWR VGND sg13cmos5l_antennanp
X_0479_ _0479_/Q Tile_X0Y0_FrameData[26] VGND VPWR Tile_X3Y0_FrameStrobe[2] latch
XANTENNA_109 Tile_X0Y0_FrameData[0] VPWR VGND sg13cmos5l_antennanp
XFILLER_14_56 VPWR VGND sg13cmos5l_decap_8
XFILLER_10_703 VPWR VGND sg13cmos5l_decap_8
XFILLER_13_2449 VPWR VGND sg13cmos5l_decap_8
XFILLER_13_1726 VPWR VGND sg13cmos5l_decap_8
XFILLER_11_2184 VPWR VGND sg13cmos5l_decap_8
XFILLER_8_2720 VPWR VGND sg13cmos5l_decap_8
XANTENNA_610 Tile_X0Y0_FrameData[23] VPWR VGND sg13cmos5l_antennanp
XANTENNA_643 Tile_X0Y0_FrameData[23] VPWR VGND sg13cmos5l_antennanp
XANTENNA_632 Tile_X0Y0_FrameData[23] VPWR VGND sg13cmos5l_antennanp
XANTENNA_621 Tile_X0Y0_FrameData[23] VPWR VGND sg13cmos5l_antennanp
XFILLER_2_1695 VPWR VGND sg13cmos5l_decap_8
XANTENNA_687 Tile_X0Y0_FrameData[24] VPWR VGND sg13cmos5l_antennanp
XANTENNA_676 Tile_X0Y0_FrameData[24] VPWR VGND sg13cmos5l_antennanp
XANTENNA_665 Tile_X0Y0_FrameData[24] VPWR VGND sg13cmos5l_antennanp
XANTENNA_654 Tile_X0Y0_FrameData[24] VPWR VGND sg13cmos5l_antennanp
XFILLER_13_541 VPWR VGND sg13cmos5l_decap_8
XANTENNA_698 Tile_X0Y0_FrameData[24] VPWR VGND sg13cmos5l_antennanp
XFILLER_9_567 VPWR VGND sg13cmos5l_decap_8
XFILLER_16_1372 VPWR VGND sg13cmos5l_decap_8
XFILLER_12_1203 VPWR VGND sg13cmos5l_decap_8
XFILLER_9_1816 VPWR VGND sg13cmos5l_decap_4
XFILLER_4_294 VPWR VGND sg13cmos5l_fill_1
XANTENNA_1020 Tile_X0Y0_FrameData[28] VPWR VGND sg13cmos5l_antennanp
XFILLER_9_1838 VPWR VGND sg13cmos5l_fill_1
X_0402_ _0402_/Q Tile_X0Y0_FrameData[7] VGND VPWR Tile_X2Y0_FrameStrobe[2] latch
XFILLER_7_2241 VPWR VGND sg13cmos5l_decap_8
XANTENNA_1031 Tile_X0Y0_FrameData[29] VPWR VGND sg13cmos5l_antennanp
XANTENNA_1042 Tile_X0Y0_FrameData[29] VPWR VGND sg13cmos5l_antennanp
XANTENNA_1053 Tile_X0Y0_FrameData[29] VPWR VGND sg13cmos5l_antennanp
XANTENNA_1064 Tile_X0Y0_FrameData[29] VPWR VGND sg13cmos5l_antennanp
XANTENNA_1075 Tile_X0Y0_FrameData[2] VPWR VGND sg13cmos5l_antennanp
XANTENNA_1086 Tile_X0Y0_FrameData[2] VPWR VGND sg13cmos5l_antennanp
XANTENNA_1097 Tile_X0Y0_FrameData[2] VPWR VGND sg13cmos5l_antennanp
X_0333_ _0333_/Q Tile_X0Y0_FrameData[12] VGND VPWR Tile_X2Y0_FrameStrobe[0] latch
X_0264_ _0264_/Q Tile_X0Y0_FrameData[1] VGND VPWR Tile_X1Y0_FrameStrobe[1] latch
X_0195_ _0195_/Q Tile_X0Y0_FrameData[22] VGND VPWR Tile_X0Y0_FrameStrobe[3] latch
XFILLER_14_2714 VPWR VGND sg13cmos5l_decap_8
XANTENNA__1000__X Tile_X0Y0_S4BEG[9] VPWR VGND sg13cmos5l_antennanp
XFILLER_3_2661 VPWR VGND sg13cmos5l_decap_8
XFILLER_10_522 VPWR VGND sg13cmos5l_decap_8
XFILLER_13_2268 VPWR VGND sg13cmos5l_fill_2
XFILLER_13_2257 VPWR VGND sg13cmos5l_decap_8
XFILLER_13_1523 VPWR VGND sg13cmos5l_decap_8
XFILLER_10_599 VPWR VGND sg13cmos5l_decap_8
XANTENNA_3906 Tile_X0Y0_FrameData[18] VPWR VGND sg13cmos5l_antennanp
XANTENNA_3917 Tile_X0Y0_FrameData[18] VPWR VGND sg13cmos5l_antennanp
XANTENNA_3928 Tile_X0Y0_FrameData[18] VPWR VGND sg13cmos5l_antennanp
XANTENNA_3939 Tile_X0Y0_FrameData[18] VPWR VGND sg13cmos5l_antennanp
XFILLER_4_2447 VPWR VGND sg13cmos5l_decap_8
XANTENNA_440 Tile_X0Y0_FrameData[23] VPWR VGND sg13cmos5l_antennanp
XANTENNA_462 Tile_X0Y0_FrameData[23] VPWR VGND sg13cmos5l_antennanp
XANTENNA_451 Tile_X0Y0_FrameData[23] VPWR VGND sg13cmos5l_antennanp
XANTENNA__0924__X Tile_X3Y0_FrameStrobe_O[9] VPWR VGND sg13cmos5l_antennanp
XANTENNA_495 Tile_X0Y0_FrameData[23] VPWR VGND sg13cmos5l_antennanp
XANTENNA_484 Tile_X0Y0_FrameData[23] VPWR VGND sg13cmos5l_antennanp
XANTENNA_473 Tile_X0Y0_FrameData[23] VPWR VGND sg13cmos5l_antennanp
X_0951_ Tile_X2Y0_FrameStrobe_O[16] Tile_X2Y0_FrameStrobe[16] VPWR VGND sg13cmos5l_buf_1
X_0882_ Tile_X2Y0_S2BEGb[7] _1218_/X VPWR VGND sg13cmos5l_buf_1
XFILLER_16_1191 VPWR VGND sg13cmos5l_decap_8
XFILLER_12_1055 VPWR VGND sg13cmos5l_decap_8
XFILLER_12_1077 VPWR VGND sg13cmos5l_decap_8
XFILLER_5_592 VPWR VGND sg13cmos5l_decap_8
XFILLER_9_2358 VPWR VGND sg13cmos5l_decap_8
X_0316_ _0316_/Q Tile_X0Y0_FrameData[29] VGND VPWR Tile_X2Y0_FrameStrobe[0] latch
X_0247_ _0247_/Q Tile_X0Y0_FrameData[18] VGND VPWR Tile_X1Y0_FrameStrobe[1] latch
X_0178_ _0178_/Q Tile_X0Y0_FrameData[7] VGND VPWR Tile_X0Y0_FrameStrobe[2] latch
XANTENNA__0834__X Tile_X4Y0_FrameData_O[23] VPWR VGND sg13cmos5l_antennanp
XFILLER_14_2533 VPWR VGND sg13cmos5l_decap_8
XFILLER_14_2588 VPWR VGND sg13cmos5l_decap_8
XFILLER_10_2408 VPWR VGND sg13cmos5l_decap_8
XFILLER_14_1865 VPWR VGND sg13cmos5l_decap_8
XFILLER_11_46 VPWR VGND sg13cmos5l_decap_8
XFILLER_11_35 VPWR VGND sg13cmos5l_decap_8
XFILLER_8_1123 VPWR VGND sg13cmos5l_decap_8
XFILLER_5_2756 VPWR VGND sg13cmos5l_decap_8
XANTENNA__0744__X Tile_X1Y0_SS4BEG[13] VPWR VGND sg13cmos5l_antennanp
XFILLER_14_168 VPWR VGND sg13cmos5l_decap_8
XFILLER_13_2054 VPWR VGND sg13cmos5l_decap_8
XANTENNA_3703 Tile_X1Y0_N4END[2] VPWR VGND sg13cmos5l_antennanp
XFILLER_6_367 VPWR VGND sg13cmos5l_fill_1
XANTENNA_3714 Tile_X1Y0_N4END[3] VPWR VGND sg13cmos5l_antennanp
XANTENNA_3725 Tile_X1Y0_N4END[3] VPWR VGND sg13cmos5l_antennanp
XANTENNA_3736 Tile_X1Y0_NN4END[0] VPWR VGND sg13cmos5l_antennanp
XANTENNA_3747 Tile_X2Y0_N2END[4] VPWR VGND sg13cmos5l_antennanp
XANTENNA_3758 Tile_X3Y0_N4END[8] VPWR VGND sg13cmos5l_antennanp
XANTENNA_3769 Tile_X0Y0_FrameData[18] VPWR VGND sg13cmos5l_antennanp
XFILLER_2_584 VPWR VGND sg13cmos5l_decap_8
XFILLER_8_2380 VPWR VGND sg13cmos5l_decap_8
XANTENNA__0919__X Tile_X3Y0_FrameStrobe_O[4] VPWR VGND sg13cmos5l_antennanp
X_1150_ _1150_/X Tile_X0Y0_N2MID[3] Tile_X0Y0_N4END[4] Tile_X0Y0_NN4END[11] _0599_/Q
+ _0163_/Q _0162_/Q VPWR VGND sg13cmos5l_mux4_1
XFILLER_4_2255 VPWR VGND sg13cmos5l_decap_8
X_0101_ _0101_/Q Tile_X0Y0_FrameData[20] VGND VPWR Tile_X0Y0_FrameStrobe[0] latch
X_1081_ _1081_/X Tile_X2Y0_N1END[1] Tile_X2Y0_N2MID[1] Tile_X2Y0_N2MID[6] Tile_X2Y0_N2END[6]
+ _0327_/Q _0326_/Q VPWR VGND sg13cmos5l_mux4_1
XANTENNA_270 Tile_X0Y0_FrameData[10] VPWR VGND sg13cmos5l_antennanp
XANTENNA_281 Tile_X0Y0_FrameData[10] VPWR VGND sg13cmos5l_antennanp
XANTENNA_292 Tile_X0Y0_FrameData[15] VPWR VGND sg13cmos5l_antennanp
X_0934_ Tile_X3Y0_FrameStrobe_O[19] Tile_X3Y0_FrameStrobe[19] VPWR VGND sg13cmos5l_buf_1
X_0865_ Tile_X2Y0_S1BEG[2] Tile_X2Y0_N1END[1] VPWR VGND sg13cmos5l_buf_1
X_0796_ Tile_X3Y0_SS4BEG[1] _1276_/X VPWR VGND sg13cmos5l_buf_1
XFILLER_9_2111 VPWR VGND sg13cmos5l_decap_8
XFILLER_9_2188 VPWR VGND sg13cmos5l_decap_8
XANTENNA__0829__X Tile_X4Y0_FrameData_O[18] VPWR VGND sg13cmos5l_antennanp
X_1279_ _1279_/X Tile_X3Y0_N2END[4] Tile_X3Y0_N4END[4] Tile_X3Y0_NN4END[11] _0577_/Q
+ _0449_/Q _0448_/Q VPWR VGND sg13cmos5l_mux4_1
XFILLER_3_1042 VPWR VGND sg13cmos5l_fill_1
XFILLER_0_2631 VPWR VGND sg13cmos5l_fill_2
XFILLER_3_1064 VPWR VGND sg13cmos5l_fill_1
XFILLER_16_2606 VPWR VGND sg13cmos5l_decap_8
XFILLER_12_606 VPWR VGND sg13cmos5l_decap_8
XFILLER_14_2352 VPWR VGND sg13cmos5l_decap_8
XFILLER_10_2205 VPWR VGND sg13cmos5l_decap_8
XFILLER_14_1662 VPWR VGND sg13cmos5l_decap_8
XFILLER_4_827 VPWR VGND sg13cmos5l_fill_2
XFILLER_10_1559 VPWR VGND sg13cmos5l_decap_8
XANTENNA_2309 Tile_X0Y0_N4END[0] VPWR VGND sg13cmos5l_antennanp
XANTENNA_1608 Tile_X0Y0_FrameData[4] VPWR VGND sg13cmos5l_antennanp
XANTENNA_1619 Tile_X0Y0_FrameData[4] VPWR VGND sg13cmos5l_antennanp
XANTENNA__0739__X Tile_X1Y0_SS4BEG[8] VPWR VGND sg13cmos5l_antennanp
XFILLER_1_2428 VPWR VGND sg13cmos5l_decap_4
XFILLER_8_14 VPWR VGND sg13cmos5l_decap_8
XFILLER_15_2149 VPWR VGND sg13cmos5l_decap_8
XFILLER_11_650 VPWR VGND sg13cmos5l_decap_8
XFILLER_7_665 VPWR VGND sg13cmos5l_decap_8
XFILLER_13_1150 VPWR VGND sg13cmos5l_decap_8
XANTENNA_3500 Tile_X0Y0_FrameData[8] VPWR VGND sg13cmos5l_antennanp
XANTENNA_3511 Tile_X0Y0_FrameData[8] VPWR VGND sg13cmos5l_antennanp
XANTENNA_3522 Tile_X0Y0_FrameData[8] VPWR VGND sg13cmos5l_antennanp
X_0650_ _0650_/L_HI VPWR VGND sg13cmos5l_tiehi
XANTENNA_2810 Tile_X0Y0_FrameData[17] VPWR VGND sg13cmos5l_antennanp
XANTENNA_3533 Tile_X0Y0_FrameData[8] VPWR VGND sg13cmos5l_antennanp
XANTENNA_3544 Tile_X0Y0_FrameData[8] VPWR VGND sg13cmos5l_antennanp
XANTENNA_3555 Tile_X0Y0_FrameData[8] VPWR VGND sg13cmos5l_antennanp
X_0581_ _0581_/Q Tile_X0Y0_UserCLK NPU_RDATA9 _0655_/L_HI VPWR VGND sg13cmos5l_dfrbpq_1
XANTENNA_2821 Tile_X0Y0_FrameData[17] VPWR VGND sg13cmos5l_antennanp
XANTENNA_2832 Tile_X0Y0_FrameData[17] VPWR VGND sg13cmos5l_antennanp
XANTENNA_2843 Tile_X0Y0_FrameData[17] VPWR VGND sg13cmos5l_antennanp
XANTENNA_3566 Tile_X0Y0_FrameData[8] VPWR VGND sg13cmos5l_antennanp
XANTENNA_3577 Tile_X0Y0_FrameData[8] VPWR VGND sg13cmos5l_antennanp
XANTENNA_3588 Tile_X0Y0_FrameData[8] VPWR VGND sg13cmos5l_antennanp
XFILLER_6_2306 VPWR VGND sg13cmos5l_decap_8
XANTENNA_2854 Tile_X0Y0_FrameData[17] VPWR VGND sg13cmos5l_antennanp
XANTENNA_2865 Tile_X0Y0_FrameData[17] VPWR VGND sg13cmos5l_antennanp
XANTENNA_2876 Tile_X0Y0_FrameData[17] VPWR VGND sg13cmos5l_antennanp
XANTENNA_2887 Tile_X0Y0_FrameData[17] VPWR VGND sg13cmos5l_antennanp
XANTENNA_3599 Tile_X0Y0_FrameData[8] VPWR VGND sg13cmos5l_antennanp
XANTENNA_2898 Tile_X0Y0_FrameData[17] VPWR VGND sg13cmos5l_antennanp
X_1202_ _1202_/X Tile_X1Y0_N2END[7] Tile_X1Y0_N4END[7] Tile_X1Y0_NN4END[8] _0592_/Q
+ _0251_/Q _0250_/Q VPWR VGND sg13cmos5l_mux4_1
XFILLER_4_2030 VPWR VGND sg13cmos5l_fill_1
X_1133_ _1133_/X Tile_X0Y0_N1END[2] Tile_X0Y0_N2MID[2] Tile_X0Y0_N2END[5] _0598_/Q
+ _0197_/Q _0196_/Q VPWR VGND sg13cmos5l_mux4_1
X_1064_ Tile_X4Y0_SS4BEG[1] Tile_X4Y0_NN4END[14] VPWR VGND sg13cmos5l_buf_1
XFILLER_15_2661 VPWR VGND sg13cmos5l_decap_8
X_0917_ Tile_X3Y0_FrameStrobe_O[2] Tile_X3Y0_FrameStrobe[2] VPWR VGND sg13cmos5l_buf_1
XFILLER_11_1802 VPWR VGND sg13cmos5l_decap_8
X_0848_ Tile_X4Y0_FrameStrobe_O[5] Tile_X4Y0_FrameStrobe[5] VPWR VGND sg13cmos5l_buf_1
X_0779_ Tile_X3Y0_S4BEG[0] _1259_/X VPWR VGND sg13cmos5l_buf_1
XFILLER_5_1115 VPWR VGND sg13cmos5l_decap_8
XFILLER_0_2472 VPWR VGND sg13cmos5l_fill_2
XFILLER_16_2458 VPWR VGND sg13cmos5l_decap_8
XFILLER_16_1735 VPWR VGND sg13cmos5l_decap_8
XFILLER_14_2160 VPWR VGND sg13cmos5l_decap_8
XANTENNA_2106 Tile_X0Y0_FrameData[7] VPWR VGND sg13cmos5l_antennanp
XANTENNA_2117 Tile_X0Y0_FrameData[7] VPWR VGND sg13cmos5l_antennanp
XANTENNA_2128 Tile_X0Y0_FrameData[9] VPWR VGND sg13cmos5l_antennanp
XANTENNA_2139 Tile_X0Y0_FrameData[9] VPWR VGND sg13cmos5l_antennanp
XANTENNA_1405 Tile_X0Y0_FrameData[31] VPWR VGND sg13cmos5l_antennanp
XANTENNA_1416 Tile_X0Y0_FrameData[31] VPWR VGND sg13cmos5l_antennanp
XANTENNA_1427 Tile_X0Y0_FrameData[31] VPWR VGND sg13cmos5l_antennanp
XANTENNA_1438 Tile_X0Y0_FrameData[31] VPWR VGND sg13cmos5l_antennanp
XFILLER_7_2637 VPWR VGND sg13cmos5l_decap_8
XANTENNA_1449 Tile_X0Y0_FrameData[31] VPWR VGND sg13cmos5l_antennanp
XFILLER_5_2361 VPWR VGND sg13cmos5l_decap_8
XFILLER_5_1660 VPWR VGND sg13cmos5l_decap_8
XFILLER_1_2247 VPWR VGND sg13cmos5l_decap_8
XFILLER_16_742 VPWR VGND sg13cmos5l_decap_8
XANTENNA__0932__X Tile_X3Y0_FrameStrobe_O[17] VPWR VGND sg13cmos5l_antennanp
XFILLER_15_1256 VPWR VGND sg13cmos5l_fill_2
XFILLER_7_451 VPWR VGND sg13cmos5l_fill_1
XANTENNA_4020 Tile_X0Y0_FrameData[18] VPWR VGND sg13cmos5l_antennanp
XANTENNA_4031 Tile_X0Y0_N2END[4] VPWR VGND sg13cmos5l_antennanp
X_0702_ Tile_X0Y0_FrameStrobe_O[15] Tile_X0Y0_FrameStrobe[15] VPWR VGND sg13cmos5l_buf_1
XANTENNA_3330 Tile_X0Y0_FrameData[20] VPWR VGND sg13cmos5l_antennanp
XANTENNA_4042 Tile_X0Y0_N2END[5] VPWR VGND sg13cmos5l_antennanp
XANTENNA_4053 Tile_X0Y0_N4END[3] VPWR VGND sg13cmos5l_antennanp
XANTENNA_4064 Tile_X0Y0_N4END[8] VPWR VGND sg13cmos5l_antennanp
XANTENNA_4075 Tile_X0Y0_NN4END[2] VPWR VGND sg13cmos5l_antennanp
X_0633_ _0633_/L_HI VPWR VGND sg13cmos5l_tiehi
XANTENNA_3341 Tile_X0Y0_FrameData[20] VPWR VGND sg13cmos5l_antennanp
XANTENNA_3352 Tile_X0Y0_FrameData[20] VPWR VGND sg13cmos5l_antennanp
XANTENNA_3363 Tile_X0Y0_FrameData[20] VPWR VGND sg13cmos5l_antennanp
XANTENNA_4086 Tile_X1Y0_N2END[7] VPWR VGND sg13cmos5l_antennanp
XANTENNA_4097 Tile_X1Y0_N4END[0] VPWR VGND sg13cmos5l_antennanp
XANTENNA_2640 Tile_X0Y0_FrameData[14] VPWR VGND sg13cmos5l_antennanp
XANTENNA_2651 Tile_X0Y0_FrameData[14] VPWR VGND sg13cmos5l_antennanp
XANTENNA_2662 Tile_X0Y0_FrameData[14] VPWR VGND sg13cmos5l_antennanp
XANTENNA_3374 Tile_X0Y0_FrameData[21] VPWR VGND sg13cmos5l_antennanp
XANTENNA_3385 Tile_X0Y0_FrameData[21] VPWR VGND sg13cmos5l_antennanp
XANTENNA_3396 Tile_X0Y0_FrameData[21] VPWR VGND sg13cmos5l_antennanp
X_0564_ NPU_ADDR0 Tile_X0Y0_UserCLK _1080_/X _0677_/L_HI VPWR VGND sg13cmos5l_dfrbpq_1
XANTENNA_1950 Tile_X0Y0_FrameData[6] VPWR VGND sg13cmos5l_antennanp
XANTENNA_2673 Tile_X0Y0_FrameData[14] VPWR VGND sg13cmos5l_antennanp
XANTENNA_2684 Tile_X0Y0_FrameData[14] VPWR VGND sg13cmos5l_antennanp
XANTENNA_2695 Tile_X0Y0_FrameData[14] VPWR VGND sg13cmos5l_antennanp
X_0495_ _0495_/Q Tile_X0Y0_FrameData[10] VGND VPWR Tile_X3Y0_FrameStrobe[2] latch
XANTENNA_1961 Tile_X0Y0_FrameData[6] VPWR VGND sg13cmos5l_antennanp
XANTENNA_1972 Tile_X0Y0_FrameData[6] VPWR VGND sg13cmos5l_antennanp
XANTENNA_1983 Tile_X0Y0_FrameData[6] VPWR VGND sg13cmos5l_antennanp
XANTENNA_1994 Tile_X0Y0_FrameData[6] VPWR VGND sg13cmos5l_antennanp
X_1116_ _1116_/X Tile_X0Y0_N4END[4] Tile_X0Y0_N4END[5] Tile_X0Y0_NN4END[4] Tile_X0Y0_NN4END[6]
+ _0113_/Q _0112_/Q VPWR VGND sg13cmos5l_mux4_1
X_1047_ Tile_X4Y0_S4BEG[0] Tile_X4Y0_N4END[15] VPWR VGND sg13cmos5l_buf_1
XANTENNA__1003__X Tile_X0Y0_S4BEG[12] VPWR VGND sg13cmos5l_antennanp
XANTENNA__0842__X Tile_X4Y0_FrameData_O[31] VPWR VGND sg13cmos5l_antennanp
XFILLER_11_2366 VPWR VGND sg13cmos5l_decap_8
XFILLER_11_1676 VPWR VGND sg13cmos5l_decap_8
XFILLER_2_2556 VPWR VGND sg13cmos5l_decap_8
XFILLER_2_2589 VPWR VGND sg13cmos5l_decap_8
XANTENNA_836 Tile_X0Y0_FrameData[27] VPWR VGND sg13cmos5l_antennanp
XANTENNA_825 Tile_X0Y0_FrameData[27] VPWR VGND sg13cmos5l_antennanp
XANTENNA_814 Tile_X0Y0_FrameData[27] VPWR VGND sg13cmos5l_antennanp
XANTENNA_803 Tile_X0Y0_FrameData[27] VPWR VGND sg13cmos5l_antennanp
XANTENNA_869 Tile_X0Y0_FrameData[27] VPWR VGND sg13cmos5l_antennanp
XANTENNA_858 Tile_X0Y0_FrameData[27] VPWR VGND sg13cmos5l_antennanp
XANTENNA_847 Tile_X0Y0_FrameData[27] VPWR VGND sg13cmos5l_antennanp
XFILLER_13_734 VPWR VGND sg13cmos5l_decap_8
XFILLER_16_1521 VPWR VGND sg13cmos5l_decap_8
XANTENNA__0752__X Tile_X1Y0_S2BEG[1] VPWR VGND sg13cmos5l_antennanp
XFILLER_16_2277 VPWR VGND sg13cmos5l_fill_1
XFILLER_16_1598 VPWR VGND sg13cmos5l_decap_8
XFILLER_10_1175 VPWR VGND sg13cmos5l_decap_8
XANTENNA_1202 Tile_X0Y0_FrameData[30] VPWR VGND sg13cmos5l_antennanp
XFILLER_7_2401 VPWR VGND sg13cmos5l_decap_8
XANTENNA_1213 Tile_X0Y0_FrameData[30] VPWR VGND sg13cmos5l_antennanp
XANTENNA_1224 Tile_X0Y0_FrameData[30] VPWR VGND sg13cmos5l_antennanp
XANTENNA_1235 Tile_X0Y0_FrameData[30] VPWR VGND sg13cmos5l_antennanp
XANTENNA_1246 Tile_X0Y0_FrameData[30] VPWR VGND sg13cmos5l_antennanp
XFILLER_7_1722 VPWR VGND sg13cmos5l_decap_8
XANTENNA_1257 Tile_X0Y0_FrameData[30] VPWR VGND sg13cmos5l_antennanp
XANTENNA_1268 Tile_X0Y0_FrameData[30] VPWR VGND sg13cmos5l_antennanp
XANTENNA_1279 Tile_X0Y0_FrameData[30] VPWR VGND sg13cmos5l_antennanp
X_0280_ _0280_/Q Tile_X0Y0_FrameData[17] VGND VPWR Tile_X1Y0_FrameStrobe[2] latch
XFILLER_7_2467 VPWR VGND sg13cmos5l_decap_8
XFILLER_10_7 VPWR VGND sg13cmos5l_decap_8
XANTENNA__0927__X Tile_X3Y0_FrameStrobe_O[12] VPWR VGND sg13cmos5l_antennanp
XFILLER_7_1799 VPWR VGND sg13cmos5l_decap_4
XFILLER_16_550 VPWR VGND sg13cmos5l_decap_8
XFILLER_12_2675 VPWR VGND sg13cmos5l_decap_8
XANTENNA_3160 Tile_X0Y0_FrameData[19] VPWR VGND sg13cmos5l_antennanp
XANTENNA_3171 Tile_X0Y0_FrameData[19] VPWR VGND sg13cmos5l_antennanp
X_0616_ _0616_/L_HI VPWR VGND sg13cmos5l_tiehi
XANTENNA_2470 Tile_X0Y0_FrameData[12] VPWR VGND sg13cmos5l_antennanp
XANTENNA_3182 Tile_X0Y0_FrameData[20] VPWR VGND sg13cmos5l_antennanp
XANTENNA_3193 Tile_X0Y0_FrameData[20] VPWR VGND sg13cmos5l_antennanp
X_0547_ NPU_WDATA23 Tile_X0Y0_UserCLK _1119_/X _0680_/L_HI VPWR VGND sg13cmos5l_dfrbpq_1
XANTENNA_2481 Tile_X0Y0_FrameData[12] VPWR VGND sg13cmos5l_antennanp
XANTENNA_2492 Tile_X0Y0_FrameData[12] VPWR VGND sg13cmos5l_antennanp
XANTENNA_1780 Tile_X0Y0_FrameData[5] VPWR VGND sg13cmos5l_antennanp
XANTENNA_1791 Tile_X0Y0_FrameData[5] VPWR VGND sg13cmos5l_antennanp
X_0478_ _0478_/Q Tile_X0Y0_FrameData[27] VGND VPWR Tile_X3Y0_FrameStrobe[2] latch
XANTENNA__0837__X Tile_X4Y0_FrameData_O[26] VPWR VGND sg13cmos5l_antennanp
XFILLER_6_1287 VPWR VGND sg13cmos5l_fill_2
XFILLER_14_35 VPWR VGND sg13cmos5l_decap_8
XFILLER_13_2428 VPWR VGND sg13cmos5l_decap_8
XFILLER_13_1705 VPWR VGND sg13cmos5l_decap_8
XFILLER_11_2163 VPWR VGND sg13cmos5l_decap_8
XFILLER_2_914 VPWR VGND sg13cmos5l_fill_1
XANTENNA__0521__Q NPU_READ_BANK_SEL0 VPWR VGND sg13cmos5l_antennanp
XFILLER_2_936 VPWR VGND sg13cmos5l_fill_1
XANTENNA__0747__X Tile_X1Y0_S1BEG[0] VPWR VGND sg13cmos5l_antennanp
XFILLER_2_2364 VPWR VGND sg13cmos5l_decap_8
XANTENNA_611 Tile_X0Y0_FrameData[23] VPWR VGND sg13cmos5l_antennanp
XANTENNA_600 Tile_X0Y0_FrameData[23] VPWR VGND sg13cmos5l_antennanp
XFILLER_2_1674 VPWR VGND sg13cmos5l_decap_8
XANTENNA_644 Tile_X0Y0_FrameData[23] VPWR VGND sg13cmos5l_antennanp
XANTENNA_633 Tile_X0Y0_FrameData[23] VPWR VGND sg13cmos5l_antennanp
XANTENNA_622 Tile_X0Y0_FrameData[23] VPWR VGND sg13cmos5l_antennanp
XANTENNA_677 Tile_X0Y0_FrameData[24] VPWR VGND sg13cmos5l_antennanp
XANTENNA_666 Tile_X0Y0_FrameData[24] VPWR VGND sg13cmos5l_antennanp
XANTENNA_655 Tile_X0Y0_FrameData[24] VPWR VGND sg13cmos5l_antennanp
XFILLER_13_520 VPWR VGND sg13cmos5l_decap_8
XANTENNA_699 Tile_X0Y0_FrameData[25] VPWR VGND sg13cmos5l_antennanp
XANTENNA_688 Tile_X0Y0_FrameData[24] VPWR VGND sg13cmos5l_antennanp
XFILLER_9_546 VPWR VGND sg13cmos5l_decap_8
XFILLER_16_2085 VPWR VGND sg13cmos5l_decap_8
XFILLER_16_1351 VPWR VGND sg13cmos5l_decap_8
XFILLER_12_1259 VPWR VGND sg13cmos5l_decap_8
XANTENNA_1010 Tile_X0Y0_FrameData[28] VPWR VGND sg13cmos5l_antennanp
XANTENNA_1021 Tile_X0Y0_FrameData[28] VPWR VGND sg13cmos5l_antennanp
X_0401_ _0401_/Q Tile_X0Y0_FrameData[8] VGND VPWR Tile_X2Y0_FrameStrobe[2] latch
XANTENNA_1032 Tile_X0Y0_FrameData[29] VPWR VGND sg13cmos5l_antennanp
XANTENNA_1043 Tile_X0Y0_FrameData[29] VPWR VGND sg13cmos5l_antennanp
XANTENNA_1054 Tile_X0Y0_FrameData[29] VPWR VGND sg13cmos5l_antennanp
X_0332_ _0332_/Q Tile_X0Y0_FrameData[13] VGND VPWR Tile_X2Y0_FrameStrobe[0] latch
XANTENNA_1065 Tile_X0Y0_FrameData[29] VPWR VGND sg13cmos5l_antennanp
XANTENNA_1076 Tile_X0Y0_FrameData[2] VPWR VGND sg13cmos5l_antennanp
XANTENNA_1087 Tile_X0Y0_FrameData[2] VPWR VGND sg13cmos5l_antennanp
XFILLER_7_2297 VPWR VGND sg13cmos5l_decap_8
XANTENNA_1098 Tile_X0Y0_FrameData[2] VPWR VGND sg13cmos5l_antennanp
X_0263_ _0263_/Q Tile_X0Y0_FrameData[2] VGND VPWR Tile_X1Y0_FrameStrobe[1] latch
XFILLER_7_1596 VPWR VGND sg13cmos5l_decap_8
XFILLER_3_1427 VPWR VGND sg13cmos5l_fill_2
X_0194_ _0194_/Q Tile_X0Y0_FrameData[23] VGND VPWR Tile_X0Y0_FrameStrobe[3] latch
XFILLER_12_1782 VPWR VGND sg13cmos5l_decap_8
XFILLER_6_91 VPWR VGND sg13cmos5l_decap_8
XFILLER_3_2640 VPWR VGND sg13cmos5l_decap_8
XFILLER_13_2236 VPWR VGND sg13cmos5l_decap_8
XFILLER_13_1502 VPWR VGND sg13cmos5l_decap_8
XFILLER_10_578 VPWR VGND sg13cmos5l_decap_8
XFILLER_6_549 VPWR VGND sg13cmos5l_decap_8
XFILLER_13_1579 VPWR VGND sg13cmos5l_decap_8
XANTENNA_3907 Tile_X0Y0_FrameData[18] VPWR VGND sg13cmos5l_antennanp
XANTENNA_3918 Tile_X0Y0_FrameData[18] VPWR VGND sg13cmos5l_antennanp
XANTENNA_3929 Tile_X0Y0_FrameData[18] VPWR VGND sg13cmos5l_antennanp
XFILLER_4_2426 VPWR VGND sg13cmos5l_decap_8
XFILLER_2_49 VPWR VGND sg13cmos5l_decap_8
XFILLER_4_1758 VPWR VGND sg13cmos5l_fill_2
XFILLER_4_1747 VPWR VGND sg13cmos5l_decap_8
XANTENNA_430 Tile_X0Y0_FrameData[23] VPWR VGND sg13cmos5l_antennanp
XANTENNA_441 Tile_X0Y0_FrameData[23] VPWR VGND sg13cmos5l_antennanp
XANTENNA_452 Tile_X0Y0_FrameData[23] VPWR VGND sg13cmos5l_antennanp
XANTENNA_485 Tile_X0Y0_FrameData[23] VPWR VGND sg13cmos5l_antennanp
XANTENNA_474 Tile_X0Y0_FrameData[23] VPWR VGND sg13cmos5l_antennanp
XANTENNA_463 Tile_X0Y0_FrameData[23] VPWR VGND sg13cmos5l_antennanp
X_0950_ Tile_X2Y0_FrameStrobe_O[15] Tile_X2Y0_FrameStrobe[15] VPWR VGND sg13cmos5l_buf_1
XANTENNA_496 Tile_X0Y0_FrameData[23] VPWR VGND sg13cmos5l_antennanp
X_0881_ Tile_X2Y0_S2BEGb[6] _1217_/X VPWR VGND sg13cmos5l_buf_1
XFILLER_16_1170 VPWR VGND sg13cmos5l_decap_8
XANTENNA__0940__X Tile_X2Y0_FrameStrobe_O[5] VPWR VGND sg13cmos5l_antennanp
XFILLER_5_571 VPWR VGND sg13cmos5l_decap_8
XFILLER_9_2337 VPWR VGND sg13cmos5l_decap_8
XFILLER_9_1669 VPWR VGND sg13cmos5l_decap_8
X_0315_ _0315_/Q Tile_X0Y0_FrameData[30] VGND VPWR Tile_X2Y0_FrameStrobe[0] latch
X_0246_ _0246_/Q Tile_X0Y0_FrameData[19] VGND VPWR Tile_X1Y0_FrameStrobe[1] latch
XFILLER_0_2802 VPWR VGND sg13cmos5l_fill_1
XFILLER_3_1268 VPWR VGND sg13cmos5l_fill_2
X_0177_ _0177_/Q Tile_X0Y0_FrameData[8] VGND VPWR Tile_X0Y0_FrameStrobe[2] latch
XFILLER_14_2512 VPWR VGND sg13cmos5l_decap_8
XFILLER_14_2545 VPWR VGND sg13cmos5l_fill_1
XANTENNA__1011__X Tile_X0Y0_S2BEGb[4] VPWR VGND sg13cmos5l_antennanp
XFILLER_14_1844 VPWR VGND sg13cmos5l_decap_8
XANTENNA__0850__X Tile_X4Y0_FrameStrobe_O[7] VPWR VGND sg13cmos5l_antennanp
XFILLER_11_14 VPWR VGND sg13cmos5l_decap_8
XFILLER_8_1102 VPWR VGND sg13cmos5l_decap_8
XFILLER_5_2735 VPWR VGND sg13cmos5l_decap_8
XFILLER_8_1179 VPWR VGND sg13cmos5l_decap_8
XFILLER_15_637 VPWR VGND sg13cmos5l_decap_8
XFILLER_14_147 VPWR VGND sg13cmos5l_decap_8
XFILLER_15_1619 VPWR VGND sg13cmos5l_decap_8
XANTENNA__0760__X Tile_X3Y0_S1BEG[1] VPWR VGND sg13cmos5l_antennanp
XANTENNA_3704 Tile_X1Y0_N4END[2] VPWR VGND sg13cmos5l_antennanp
XANTENNA_3715 Tile_X1Y0_N4END[3] VPWR VGND sg13cmos5l_antennanp
XANTENNA_3726 Tile_X1Y0_N4END[3] VPWR VGND sg13cmos5l_antennanp
XANTENNA_3737 Tile_X2Y0_N2END[4] VPWR VGND sg13cmos5l_antennanp
XANTENNA_3748 Tile_X2Y0_N2END[4] VPWR VGND sg13cmos5l_antennanp
XANTENNA_3759 Tile_X3Y0_N4END[8] VPWR VGND sg13cmos5l_antennanp
XFILLER_2_563 VPWR VGND sg13cmos5l_decap_8
XFILLER_4_2234 VPWR VGND sg13cmos5l_decap_8
X_0100_ _0100_/Q Tile_X0Y0_FrameData[21] VGND VPWR Tile_X0Y0_FrameStrobe[0] latch
X_1080_ _1080_/X Tile_X2Y0_N1END[0] Tile_X2Y0_N2MID[0] Tile_X2Y0_N2MID[7] Tile_X2Y0_N2END[7]
+ _0329_/Q _0328_/Q VPWR VGND sg13cmos5l_mux4_1
XANTENNA__0935__X Tile_X2Y0_FrameStrobe_O[0] VPWR VGND sg13cmos5l_antennanp
XANTENNA_260 Tile_X0Y0_FrameData[10] VPWR VGND sg13cmos5l_antennanp
XANTENNA_271 Tile_X0Y0_FrameData[10] VPWR VGND sg13cmos5l_antennanp
XANTENNA_282 Tile_X0Y0_FrameData[10] VPWR VGND sg13cmos5l_antennanp
XANTENNA_293 Tile_X0Y0_FrameData[15] VPWR VGND sg13cmos5l_antennanp
XFILLER_14_681 VPWR VGND sg13cmos5l_decap_8
XFILLER_9_140 VPWR VGND sg13cmos5l_decap_4
X_0933_ Tile_X3Y0_FrameStrobe_O[18] Tile_X3Y0_FrameStrobe[18] VPWR VGND sg13cmos5l_buf_1
XFILLER_14_1118 VPWR VGND sg13cmos5l_decap_8
XFILLER_14_1107 VPWR VGND sg13cmos5l_fill_1
X_0864_ Tile_X2Y0_S1BEG[1] Tile_X2Y0_N1END[2] VPWR VGND sg13cmos5l_buf_1
X_0795_ Tile_X3Y0_SS4BEG[0] _1275_/X VPWR VGND sg13cmos5l_buf_1
XFILLER_9_2167 VPWR VGND sg13cmos5l_decap_8
XFILLER_3_70 VPWR VGND sg13cmos5l_fill_2
XANTENNA__1006__X Tile_X0Y0_S4BEG[15] VPWR VGND sg13cmos5l_antennanp
X_1278_ _1278_/X Tile_X3Y0_N2END[3] Tile_X3Y0_N4END[3] Tile_X3Y0_NN4END[12] _0578_/Q
+ _0451_/Q _0450_/Q VPWR VGND sg13cmos5l_mux4_1
XFILLER_0_2643 VPWR VGND sg13cmos5l_fill_1
X_0229_ _0229_/Q Tile_X0Y0_FrameData[4] VGND VPWR Tile_X1Y0_FrameStrobe[0] latch
XFILLER_0_2676 VPWR VGND sg13cmos5l_decap_8
XANTENNA__0845__X Tile_X4Y0_FrameStrobe_O[2] VPWR VGND sg13cmos5l_antennanp
XFILLER_0_2698 VPWR VGND sg13cmos5l_decap_4
XFILLER_16_1917 VPWR VGND sg13cmos5l_decap_4
XFILLER_14_2331 VPWR VGND sg13cmos5l_decap_8
XFILLER_14_1641 VPWR VGND sg13cmos5l_decap_8
XFILLER_3_316 VPWR VGND sg13cmos5l_fill_1
XFILLER_10_1538 VPWR VGND sg13cmos5l_decap_8
XANTENNA_1609 Tile_X0Y0_FrameData[4] VPWR VGND sg13cmos5l_antennanp
XFILLER_5_2543 VPWR VGND sg13cmos5l_decap_8
XFILLER_1_1739 VPWR VGND sg13cmos5l_decap_8
XFILLER_15_401 VPWR VGND sg13cmos5l_fill_2
XANTENNA__0755__X Tile_X1Y0_S2BEG[4] VPWR VGND sg13cmos5l_antennanp
XFILLER_15_2128 VPWR VGND sg13cmos5l_decap_8
XFILLER_15_1416 VPWR VGND sg13cmos5l_fill_1
XFILLER_11_684 VPWR VGND sg13cmos5l_decap_8
XFILLER_7_644 VPWR VGND sg13cmos5l_decap_8
XANTENNA_3501 Tile_X0Y0_FrameData[8] VPWR VGND sg13cmos5l_antennanp
XANTENNA_3512 Tile_X0Y0_FrameData[8] VPWR VGND sg13cmos5l_antennanp
XANTENNA_2800 Tile_X0Y0_FrameData[16] VPWR VGND sg13cmos5l_antennanp
XANTENNA_2811 Tile_X0Y0_FrameData[17] VPWR VGND sg13cmos5l_antennanp
XANTENNA_3523 Tile_X0Y0_FrameData[8] VPWR VGND sg13cmos5l_antennanp
XANTENNA_3534 Tile_X0Y0_FrameData[8] VPWR VGND sg13cmos5l_antennanp
XANTENNA_3545 Tile_X0Y0_FrameData[8] VPWR VGND sg13cmos5l_antennanp
X_0580_ _0580_/Q Tile_X0Y0_UserCLK NPU_RDATA8 _0657_/L_HI VPWR VGND sg13cmos5l_dfrbpq_1
XANTENNA_2822 Tile_X0Y0_FrameData[17] VPWR VGND sg13cmos5l_antennanp
XANTENNA_2833 Tile_X0Y0_FrameData[17] VPWR VGND sg13cmos5l_antennanp
XANTENNA_2844 Tile_X0Y0_FrameData[17] VPWR VGND sg13cmos5l_antennanp
XANTENNA_3556 Tile_X0Y0_FrameData[8] VPWR VGND sg13cmos5l_antennanp
XANTENNA_3567 Tile_X0Y0_FrameData[8] VPWR VGND sg13cmos5l_antennanp
XANTENNA_3578 Tile_X0Y0_FrameData[8] VPWR VGND sg13cmos5l_antennanp
XANTENNA_3589 Tile_X0Y0_FrameData[8] VPWR VGND sg13cmos5l_antennanp
XANTENNA_2855 Tile_X0Y0_FrameData[17] VPWR VGND sg13cmos5l_antennanp
XANTENNA_2866 Tile_X0Y0_FrameData[17] VPWR VGND sg13cmos5l_antennanp
XANTENNA_2877 Tile_X0Y0_FrameData[17] VPWR VGND sg13cmos5l_antennanp
XANTENNA_2888 Tile_X0Y0_FrameData[17] VPWR VGND sg13cmos5l_antennanp
XANTENNA_2899 Tile_X0Y0_FrameData[17] VPWR VGND sg13cmos5l_antennanp
X_1201_ _1201_/X Tile_X1Y0_N2END[6] Tile_X1Y0_N4END[6] Tile_X1Y0_NN4END[9] _0593_/Q
+ _0253_/Q _0252_/Q VPWR VGND sg13cmos5l_mux4_1
XFILLER_6_1606 VPWR VGND sg13cmos5l_decap_4
X_1132_ _1132_/X Tile_X0Y0_N1END[1] Tile_X0Y0_N2MID[1] Tile_X0Y0_N2END[6] _0597_/Q
+ _0199_/Q _0198_/Q VPWR VGND sg13cmos5l_mux4_1
X_1063_ Tile_X4Y0_SS4BEG[0] Tile_X4Y0_NN4END[15] VPWR VGND sg13cmos5l_buf_1
XFILLER_15_2640 VPWR VGND sg13cmos5l_decap_8
X_0916_ Tile_X3Y0_FrameStrobe_O[1] Tile_X3Y0_FrameStrobe[1] VPWR VGND sg13cmos5l_buf_1
XFILLER_15_1972 VPWR VGND sg13cmos5l_decap_8
X_0847_ Tile_X4Y0_FrameStrobe_O[4] Tile_X4Y0_FrameStrobe[4] VPWR VGND sg13cmos5l_buf_1
X_0778_ Tile_X3Y0_S2BEGb[7] _1258_/X VPWR VGND sg13cmos5l_buf_1
XFILLER_9_1252 VPWR VGND sg13cmos5l_fill_2
XFILLER_2_2749 VPWR VGND sg13cmos5l_decap_8
XFILLER_0_2451 VPWR VGND sg13cmos5l_decap_4
XFILLER_16_2437 VPWR VGND sg13cmos5l_decap_8
XFILLER_16_1703 VPWR VGND sg13cmos5l_fill_1
XFILLER_16_1714 VPWR VGND sg13cmos5l_decap_8
XFILLER_12_459 VPWR VGND sg13cmos5l_decap_8
XANTENNA__0524__Q NPU_WDATA0 VPWR VGND sg13cmos5l_antennanp
XFILLER_4_625 VPWR VGND sg13cmos5l_decap_8
XANTENNA_2107 Tile_X0Y0_FrameData[7] VPWR VGND sg13cmos5l_antennanp
XANTENNA_2118 Tile_X0Y0_FrameData[9] VPWR VGND sg13cmos5l_antennanp
XANTENNA_2129 Tile_X0Y0_FrameData[9] VPWR VGND sg13cmos5l_antennanp
XFILLER_3_157 VPWR VGND sg13cmos5l_fill_1
XANTENNA_1406 Tile_X0Y0_FrameData[31] VPWR VGND sg13cmos5l_antennanp
XANTENNA_1417 Tile_X0Y0_FrameData[31] VPWR VGND sg13cmos5l_antennanp
XANTENNA_1428 Tile_X0Y0_FrameData[31] VPWR VGND sg13cmos5l_antennanp
XFILLER_7_2616 VPWR VGND sg13cmos5l_decap_8
XANTENNA_1439 Tile_X0Y0_FrameData[31] VPWR VGND sg13cmos5l_antennanp
XFILLER_5_2340 VPWR VGND sg13cmos5l_decap_8
XFILLER_1_2226 VPWR VGND sg13cmos5l_decap_8
XFILLER_16_721 VPWR VGND sg13cmos5l_decap_8
XFILLER_16_798 VPWR VGND sg13cmos5l_decap_8
XFILLER_15_1235 VPWR VGND sg13cmos5l_decap_8
XFILLER_12_960 VPWR VGND sg13cmos5l_fill_1
X_0701_ Tile_X0Y0_FrameStrobe_O[14] Tile_X0Y0_FrameStrobe[14] VPWR VGND sg13cmos5l_buf_1
XANTENNA_4010 Tile_X0Y0_FrameData[18] VPWR VGND sg13cmos5l_antennanp
XANTENNA_4021 Tile_X0Y0_N2END[1] VPWR VGND sg13cmos5l_antennanp
XANTENNA_4032 Tile_X0Y0_N2END[4] VPWR VGND sg13cmos5l_antennanp
XANTENNA_3320 Tile_X0Y0_FrameData[20] VPWR VGND sg13cmos5l_antennanp
XANTENNA_4043 Tile_X0Y0_N2END[5] VPWR VGND sg13cmos5l_antennanp
XANTENNA_4054 Tile_X0Y0_N4END[3] VPWR VGND sg13cmos5l_antennanp
XANTENNA_4065 Tile_X0Y0_N4END[8] VPWR VGND sg13cmos5l_antennanp
X_0632_ _0632_/L_HI VPWR VGND sg13cmos5l_tiehi
XANTENNA_3331 Tile_X0Y0_FrameData[20] VPWR VGND sg13cmos5l_antennanp
XANTENNA_3342 Tile_X0Y0_FrameData[20] VPWR VGND sg13cmos5l_antennanp
XANTENNA_3353 Tile_X0Y0_FrameData[20] VPWR VGND sg13cmos5l_antennanp
XANTENNA_3364 Tile_X0Y0_FrameData[20] VPWR VGND sg13cmos5l_antennanp
XANTENNA_4076 Tile_X1Y0_N2END[4] VPWR VGND sg13cmos5l_antennanp
XANTENNA_4087 Tile_X1Y0_N2END[7] VPWR VGND sg13cmos5l_antennanp
XANTENNA_4098 Tile_X1Y0_N4END[0] VPWR VGND sg13cmos5l_antennanp
X_0563_ NPU_WE7 Tile_X0Y0_UserCLK _0563_/D _0604_/L_HI VPWR VGND sg13cmos5l_dfrbpq_1
XANTENNA_2630 Tile_X0Y0_FrameData[14] VPWR VGND sg13cmos5l_antennanp
XANTENNA_2641 Tile_X0Y0_FrameData[14] VPWR VGND sg13cmos5l_antennanp
XANTENNA_2652 Tile_X0Y0_FrameData[14] VPWR VGND sg13cmos5l_antennanp
XANTENNA_3375 Tile_X0Y0_FrameData[21] VPWR VGND sg13cmos5l_antennanp
XANTENNA_3386 Tile_X0Y0_FrameData[21] VPWR VGND sg13cmos5l_antennanp
XANTENNA_3397 Tile_X0Y0_FrameData[21] VPWR VGND sg13cmos5l_antennanp
XANTENNA_1940 Tile_X0Y0_FrameData[6] VPWR VGND sg13cmos5l_antennanp
XANTENNA_1951 Tile_X0Y0_FrameData[6] VPWR VGND sg13cmos5l_antennanp
XANTENNA_2663 Tile_X0Y0_FrameData[14] VPWR VGND sg13cmos5l_antennanp
XANTENNA_2674 Tile_X0Y0_FrameData[14] VPWR VGND sg13cmos5l_antennanp
XANTENNA_2685 Tile_X0Y0_FrameData[14] VPWR VGND sg13cmos5l_antennanp
X_0494_ _0494_/Q Tile_X0Y0_FrameData[11] VGND VPWR Tile_X3Y0_FrameStrobe[2] latch
XANTENNA_1962 Tile_X0Y0_FrameData[6] VPWR VGND sg13cmos5l_antennanp
XANTENNA_1973 Tile_X0Y0_FrameData[6] VPWR VGND sg13cmos5l_antennanp
XANTENNA_1984 Tile_X0Y0_FrameData[6] VPWR VGND sg13cmos5l_antennanp
XANTENNA_2696 Tile_X0Y0_FrameData[14] VPWR VGND sg13cmos5l_antennanp
XANTENNA_1995 Tile_X0Y0_FrameData[6] VPWR VGND sg13cmos5l_antennanp
X_1115_ _1115_/X Tile_X0Y0_N4END[0] Tile_X0Y0_N4END[3] Tile_X0Y0_NN4END[1] Tile_X0Y0_NN4END[3]
+ _0115_/Q _0114_/Q VPWR VGND sg13cmos5l_mux4_1
XFILLER_4_1182 VPWR VGND sg13cmos5l_fill_2
X_1046_ Tile_X4Y0_S2BEGb[7] Tile_X4Y0_N2END[0] VPWR VGND sg13cmos5l_buf_1
XFILLER_9_91 VPWR VGND sg13cmos5l_decap_8
XFILLER_11_2345 VPWR VGND sg13cmos5l_decap_8
XFILLER_15_1780 VPWR VGND sg13cmos5l_decap_8
XFILLER_11_1655 VPWR VGND sg13cmos5l_decap_8
XFILLER_9_1093 VPWR VGND sg13cmos5l_decap_8
XFILLER_2_2535 VPWR VGND sg13cmos5l_decap_8
XFILLER_2_1834 VPWR VGND sg13cmos5l_fill_1
XANTENNA_826 Tile_X0Y0_FrameData[27] VPWR VGND sg13cmos5l_antennanp
XANTENNA_815 Tile_X0Y0_FrameData[27] VPWR VGND sg13cmos5l_antennanp
XANTENNA_804 Tile_X0Y0_FrameData[27] VPWR VGND sg13cmos5l_antennanp
XANTENNA_859 Tile_X0Y0_FrameData[27] VPWR VGND sg13cmos5l_antennanp
XANTENNA_848 Tile_X0Y0_FrameData[27] VPWR VGND sg13cmos5l_antennanp
XANTENNA_837 Tile_X0Y0_FrameData[27] VPWR VGND sg13cmos5l_antennanp
XFILLER_16_2212 VPWR VGND sg13cmos5l_decap_8
XFILLER_13_713 VPWR VGND sg13cmos5l_decap_8
XFILLER_16_1500 VPWR VGND sg13cmos5l_decap_8
XFILLER_16_2267 VPWR VGND sg13cmos5l_fill_2
XFILLER_16_1577 VPWR VGND sg13cmos5l_decap_8
XFILLER_5_956 VPWR VGND sg13cmos5l_fill_1
XFILLER_5_945 VPWR VGND sg13cmos5l_fill_2
XFILLER_4_411 VPWR VGND sg13cmos5l_fill_2
XFILLER_5_49 VPWR VGND sg13cmos5l_decap_8
XFILLER_10_1154 VPWR VGND sg13cmos5l_decap_8
XANTENNA_1203 Tile_X0Y0_FrameData[30] VPWR VGND sg13cmos5l_antennanp
XANTENNA_1214 Tile_X0Y0_FrameData[30] VPWR VGND sg13cmos5l_antennanp
XANTENNA_1225 Tile_X0Y0_FrameData[30] VPWR VGND sg13cmos5l_antennanp
XANTENNA_1236 Tile_X0Y0_FrameData[30] VPWR VGND sg13cmos5l_antennanp
XFILLER_7_2446 VPWR VGND sg13cmos5l_decap_8
XFILLER_7_1701 VPWR VGND sg13cmos5l_decap_8
XANTENNA_1247 Tile_X0Y0_FrameData[30] VPWR VGND sg13cmos5l_antennanp
XANTENNA_1258 Tile_X0Y0_FrameData[30] VPWR VGND sg13cmos5l_antennanp
XANTENNA_1269 Tile_X0Y0_FrameData[30] VPWR VGND sg13cmos5l_antennanp
XFILLER_7_1778 VPWR VGND sg13cmos5l_decap_8
XFILLER_1_2034 VPWR VGND sg13cmos5l_fill_2
XANTENNA__0943__X Tile_X2Y0_FrameStrobe_O[8] VPWR VGND sg13cmos5l_antennanp
XFILLER_12_2654 VPWR VGND sg13cmos5l_decap_8
XFILLER_8_794 VPWR VGND sg13cmos5l_fill_2
XANTENNA_3150 Tile_X0Y0_FrameData[19] VPWR VGND sg13cmos5l_antennanp
XANTENNA_3161 Tile_X0Y0_FrameData[19] VPWR VGND sg13cmos5l_antennanp
XANTENNA_3172 Tile_X0Y0_FrameData[19] VPWR VGND sg13cmos5l_antennanp
X_0615_ _0615_/L_HI VPWR VGND sg13cmos5l_tiehi
XANTENNA_2460 Tile_X0Y0_FrameData[12] VPWR VGND sg13cmos5l_antennanp
XANTENNA_3183 Tile_X0Y0_FrameData[20] VPWR VGND sg13cmos5l_antennanp
XANTENNA_3194 Tile_X0Y0_FrameData[20] VPWR VGND sg13cmos5l_antennanp
X_0546_ NPU_WDATA22 Tile_X0Y0_UserCLK _1118_/X _0681_/L_HI VPWR VGND sg13cmos5l_dfrbpq_1
XANTENNA_2471 Tile_X0Y0_FrameData[12] VPWR VGND sg13cmos5l_antennanp
XANTENNA_2482 Tile_X0Y0_FrameData[12] VPWR VGND sg13cmos5l_antennanp
XANTENNA_2493 Tile_X0Y0_FrameData[12] VPWR VGND sg13cmos5l_antennanp
X_0477_ _0477_/Q Tile_X0Y0_FrameData[28] VGND VPWR Tile_X3Y0_FrameStrobe[2] latch
XANTENNA_1770 Tile_X0Y0_FrameData[5] VPWR VGND sg13cmos5l_antennanp
XANTENNA_1781 Tile_X0Y0_FrameData[5] VPWR VGND sg13cmos5l_antennanp
XANTENNA_1792 Tile_X0Y0_FrameData[5] VPWR VGND sg13cmos5l_antennanp
XANTENNA__1014__X Tile_X0Y0_S2BEGb[7] VPWR VGND sg13cmos5l_antennanp
X_1029_ Tile_X4Y0_S1BEG[2] Tile_X4Y0_N1END[1] VPWR VGND sg13cmos5l_buf_1
XANTENNA__0853__X Tile_X4Y0_FrameStrobe_O[10] VPWR VGND sg13cmos5l_antennanp
XFILLER_14_14 VPWR VGND sg13cmos5l_decap_8
XFILLER_13_2407 VPWR VGND sg13cmos5l_decap_8
XFILLER_10_738 VPWR VGND sg13cmos5l_fill_1
XFILLER_11_2142 VPWR VGND sg13cmos5l_decap_8
XFILLER_8_2755 VPWR VGND sg13cmos5l_decap_8
XFILLER_7_1008 VPWR VGND sg13cmos5l_fill_2
XFILLER_4_2619 VPWR VGND sg13cmos5l_decap_8
XFILLER_6_2490 VPWR VGND sg13cmos5l_fill_1
XFILLER_2_2387 VPWR VGND sg13cmos5l_fill_2
XANTENNA_601 Tile_X0Y0_FrameData[23] VPWR VGND sg13cmos5l_antennanp
XFILLER_2_1653 VPWR VGND sg13cmos5l_decap_8
XANTENNA_634 Tile_X0Y0_FrameData[23] VPWR VGND sg13cmos5l_antennanp
XANTENNA_623 Tile_X0Y0_FrameData[23] VPWR VGND sg13cmos5l_antennanp
XANTENNA_612 Tile_X0Y0_FrameData[23] VPWR VGND sg13cmos5l_antennanp
XANTENNA__0763__X Tile_X3Y0_S2BEG[0] VPWR VGND sg13cmos5l_antennanp
XANTENNA_678 Tile_X0Y0_FrameData[24] VPWR VGND sg13cmos5l_antennanp
XANTENNA_667 Tile_X0Y0_FrameData[24] VPWR VGND sg13cmos5l_antennanp
XANTENNA_656 Tile_X0Y0_FrameData[24] VPWR VGND sg13cmos5l_antennanp
XANTENNA_645 Tile_X0Y0_FrameData[23] VPWR VGND sg13cmos5l_antennanp
XANTENNA_689 Tile_X0Y0_FrameData[24] VPWR VGND sg13cmos5l_antennanp
XFILLER_16_2064 VPWR VGND sg13cmos5l_decap_8
XFILLER_16_1330 VPWR VGND sg13cmos5l_decap_8
XFILLER_13_576 VPWR VGND sg13cmos5l_fill_1
XFILLER_13_587 VPWR VGND sg13cmos5l_decap_8
XFILLER_12_1238 VPWR VGND sg13cmos5l_decap_8
XANTENNA_1000 Tile_X0Y0_FrameData[28] VPWR VGND sg13cmos5l_antennanp
XANTENNA_1011 Tile_X0Y0_FrameData[28] VPWR VGND sg13cmos5l_antennanp
X_0400_ _0400_/Q Tile_X0Y0_FrameData[9] VGND VPWR Tile_X2Y0_FrameStrobe[2] latch
XFILLER_7_2221 VPWR VGND sg13cmos5l_decap_8
XANTENNA_1022 Tile_X0Y0_FrameData[29] VPWR VGND sg13cmos5l_antennanp
XANTENNA_1033 Tile_X0Y0_FrameData[29] VPWR VGND sg13cmos5l_antennanp
XANTENNA_1044 Tile_X0Y0_FrameData[29] VPWR VGND sg13cmos5l_antennanp
X_0331_ _0331_/Q Tile_X0Y0_FrameData[14] VGND VPWR Tile_X2Y0_FrameStrobe[0] latch
XANTENNA__0938__X Tile_X2Y0_FrameStrobe_O[3] VPWR VGND sg13cmos5l_antennanp
XANTENNA_1055 Tile_X0Y0_FrameData[29] VPWR VGND sg13cmos5l_antennanp
XANTENNA_1066 Tile_X0Y0_FrameData[29] VPWR VGND sg13cmos5l_antennanp
XANTENNA_1077 Tile_X0Y0_FrameData[2] VPWR VGND sg13cmos5l_antennanp
XANTENNA_1088 Tile_X0Y0_FrameData[2] VPWR VGND sg13cmos5l_antennanp
XFILLER_7_2276 VPWR VGND sg13cmos5l_decap_8
XANTENNA_1099 Tile_X0Y0_FrameData[2] VPWR VGND sg13cmos5l_antennanp
X_0262_ _0262_/Q Tile_X0Y0_FrameData[3] VGND VPWR Tile_X1Y0_FrameStrobe[1] latch
X_0193_ _0193_/Q Tile_X0Y0_FrameData[24] VGND VPWR Tile_X0Y0_FrameStrobe[3] latch
XFILLER_1_1152 VPWR VGND sg13cmos5l_fill_1
XFILLER_1_1141 VPWR VGND sg13cmos5l_decap_8
XFILLER_8_591 VPWR VGND sg13cmos5l_decap_8
XFILLER_12_2484 VPWR VGND sg13cmos5l_decap_8
XFILLER_6_70 VPWR VGND sg13cmos5l_decap_8
XFILLER_12_1761 VPWR VGND sg13cmos5l_decap_8
XANTENNA__1009__X Tile_X0Y0_S2BEGb[2] VPWR VGND sg13cmos5l_antennanp
XANTENNA__0848__X Tile_X4Y0_FrameStrobe_O[5] VPWR VGND sg13cmos5l_antennanp
XANTENNA_2290 Tile_X0Y0_N2END[3] VPWR VGND sg13cmos5l_antennanp
X_0529_ NPU_WDATA5 Tile_X0Y0_UserCLK _1101_/X _0605_/L_HI VPWR VGND sg13cmos5l_dfrbpq_1
XFILLER_3_2696 VPWR VGND sg13cmos5l_decap_8
XFILLER_13_2215 VPWR VGND sg13cmos5l_decap_8
XFILLER_10_557 VPWR VGND sg13cmos5l_decap_8
XFILLER_6_528 VPWR VGND sg13cmos5l_decap_8
XFILLER_13_1558 VPWR VGND sg13cmos5l_decap_8
XANTENNA__0532__Q NPU_WDATA8 VPWR VGND sg13cmos5l_antennanp
XANTENNA_3908 Tile_X0Y0_FrameData[18] VPWR VGND sg13cmos5l_antennanp
XANTENNA_3919 Tile_X0Y0_FrameData[18] VPWR VGND sg13cmos5l_antennanp
XFILLER_2_723 VPWR VGND sg13cmos5l_fill_1
XFILLER_2_712 VPWR VGND sg13cmos5l_fill_2
XANTENNA__0758__X Tile_X1Y0_S2BEG[7] VPWR VGND sg13cmos5l_antennanp
XFILLER_2_28 VPWR VGND sg13cmos5l_decap_8
XFILLER_4_1726 VPWR VGND sg13cmos5l_decap_8
XANTENNA_420 Tile_X0Y0_FrameData[22] VPWR VGND sg13cmos5l_antennanp
XANTENNA_431 Tile_X0Y0_FrameData[23] VPWR VGND sg13cmos5l_antennanp
XANTENNA_442 Tile_X0Y0_FrameData[23] VPWR VGND sg13cmos5l_antennanp
XANTENNA_453 Tile_X0Y0_FrameData[23] VPWR VGND sg13cmos5l_antennanp
XANTENNA_486 Tile_X0Y0_FrameData[23] VPWR VGND sg13cmos5l_antennanp
XANTENNA_475 Tile_X0Y0_FrameData[23] VPWR VGND sg13cmos5l_antennanp
XANTENNA_464 Tile_X0Y0_FrameData[23] VPWR VGND sg13cmos5l_antennanp
XANTENNA_497 Tile_X0Y0_FrameData[23] VPWR VGND sg13cmos5l_antennanp
X_0880_ Tile_X2Y0_S2BEGb[5] _1216_/X VPWR VGND sg13cmos5l_buf_1
XFILLER_16_1160 VPWR VGND sg13cmos5l_decap_8
XFILLER_9_399 VPWR VGND sg13cmos5l_fill_2
XFILLER_13_2782 VPWR VGND sg13cmos5l_fill_2
XFILLER_5_550 VPWR VGND sg13cmos5l_decap_8
XFILLER_9_2316 VPWR VGND sg13cmos5l_decap_8
XFILLER_9_1604 VPWR VGND sg13cmos5l_decap_8
XFILLER_9_1648 VPWR VGND sg13cmos5l_decap_8
X_0314_ _0314_/Q Tile_X0Y0_FrameData[31] VGND VPWR Tile_X1Y0_FrameStrobe[0] latch
X_0245_ _0245_/Q Tile_X0Y0_FrameData[20] VGND VPWR Tile_X1Y0_FrameStrobe[1] latch
X_0176_ _0176_/Q Tile_X0Y0_FrameData[9] VGND VPWR Tile_X0Y0_FrameStrobe[2] latch
XFILLER_14_1823 VPWR VGND sg13cmos5l_decap_8
XFILLER_12_2281 VPWR VGND sg13cmos5l_decap_8
XFILLER_8_1158 VPWR VGND sg13cmos5l_decap_8
XFILLER_5_2714 VPWR VGND sg13cmos5l_decap_8
XFILLER_15_616 VPWR VGND sg13cmos5l_decap_8
XANTENNA__0527__Q NPU_WDATA3 VPWR VGND sg13cmos5l_antennanp
XFILLER_14_126 VPWR VGND sg13cmos5l_decap_8
XFILLER_13_2089 VPWR VGND sg13cmos5l_decap_8
XFILLER_6_347 VPWR VGND sg13cmos5l_fill_1
XANTENNA_3705 Tile_X1Y0_N4END[2] VPWR VGND sg13cmos5l_antennanp
XANTENNA_3716 Tile_X1Y0_N4END[3] VPWR VGND sg13cmos5l_antennanp
XANTENNA_3727 Tile_X1Y0_N4END[3] VPWR VGND sg13cmos5l_antennanp
XANTENNA_3738 Tile_X2Y0_N2END[4] VPWR VGND sg13cmos5l_antennanp
XANTENNA_3749 Tile_X2Y0_N4END[4] VPWR VGND sg13cmos5l_antennanp
XFILLER_7_0 VPWR VGND sg13cmos5l_decap_8
XFILLER_8_1692 VPWR VGND sg13cmos5l_decap_8
XANTENNA_250 Tile_X0Y0_FrameData[10] VPWR VGND sg13cmos5l_antennanp
XANTENNA_261 Tile_X0Y0_FrameData[10] VPWR VGND sg13cmos5l_antennanp
XANTENNA_272 Tile_X0Y0_FrameData[10] VPWR VGND sg13cmos5l_antennanp
XANTENNA_283 Tile_X0Y0_FrameData[15] VPWR VGND sg13cmos5l_antennanp
XANTENNA_294 Tile_X0Y0_FrameData[15] VPWR VGND sg13cmos5l_antennanp
XFILLER_14_660 VPWR VGND sg13cmos5l_decap_8
XANTENNA__0951__X Tile_X2Y0_FrameStrobe_O[16] VPWR VGND sg13cmos5l_antennanp
X_0932_ Tile_X3Y0_FrameStrobe_O[17] Tile_X3Y0_FrameStrobe[17] VPWR VGND sg13cmos5l_buf_1
X_0863_ Tile_X2Y0_S1BEG[0] Tile_X2Y0_N1END[3] VPWR VGND sg13cmos5l_buf_1
X_0794_ Tile_X3Y0_S4BEG[15] _1274_/X VPWR VGND sg13cmos5l_buf_1
XFILLER_9_2146 VPWR VGND sg13cmos5l_decap_8
X_1277_ _1277_/X Tile_X3Y0_N2END[2] Tile_X3Y0_N4END[2] Tile_X3Y0_NN4END[13] _0579_/Q
+ _0453_/Q _0452_/Q VPWR VGND sg13cmos5l_mux4_1
XFILLER_0_2633 VPWR VGND sg13cmos5l_fill_1
X_0228_ _0228_/Q Tile_X0Y0_FrameData[5] VGND VPWR Tile_X1Y0_FrameStrobe[0] latch
X_0159_ _0159_/Q Tile_X0Y0_FrameData[26] VGND VPWR Tile_X0Y0_FrameStrobe[2] latch
XANTENNA__1022__X Tile_X0Y0_S2BEG[7] VPWR VGND sg13cmos5l_antennanp
XFILLER_14_2310 VPWR VGND sg13cmos5l_decap_8
XFILLER_11_118 VPWR VGND sg13cmos5l_decap_4
XANTENNA__0861__X Tile_X4Y0_FrameStrobe_O[18] VPWR VGND sg13cmos5l_antennanp
XFILLER_14_2387 VPWR VGND sg13cmos5l_decap_8
XFILLER_14_1620 VPWR VGND sg13cmos5l_decap_8
XFILLER_14_1697 VPWR VGND sg13cmos5l_decap_8
XFILLER_0_7 VPWR VGND sg13cmos5l_decap_8
XFILLER_5_2522 VPWR VGND sg13cmos5l_decap_8
XFILLER_5_1843 VPWR VGND sg13cmos5l_fill_1
XFILLER_1_1718 VPWR VGND sg13cmos5l_decap_8
XFILLER_15_2107 VPWR VGND sg13cmos5l_decap_8
XANTENNA__0771__X Tile_X3Y0_S2BEGb[0] VPWR VGND sg13cmos5l_antennanp
XFILLER_8_49 VPWR VGND sg13cmos5l_decap_8
XFILLER_7_623 VPWR VGND sg13cmos5l_decap_8
XFILLER_11_663 VPWR VGND sg13cmos5l_decap_8
XFILLER_10_140 VPWR VGND sg13cmos5l_decap_8
XANTENNA_3502 Tile_X0Y0_FrameData[8] VPWR VGND sg13cmos5l_antennanp
XANTENNA_3513 Tile_X0Y0_FrameData[8] VPWR VGND sg13cmos5l_antennanp
XFILLER_13_1185 VPWR VGND sg13cmos5l_decap_8
XANTENNA_2801 Tile_X0Y0_FrameData[16] VPWR VGND sg13cmos5l_antennanp
XANTENNA_3524 Tile_X0Y0_FrameData[8] VPWR VGND sg13cmos5l_antennanp
XANTENNA_3535 Tile_X0Y0_FrameData[8] VPWR VGND sg13cmos5l_antennanp
XANTENNA_3546 Tile_X0Y0_FrameData[8] VPWR VGND sg13cmos5l_antennanp
XFILLER_12_91 VPWR VGND sg13cmos5l_decap_4
XANTENNA_2812 Tile_X0Y0_FrameData[17] VPWR VGND sg13cmos5l_antennanp
XANTENNA_2823 Tile_X0Y0_FrameData[17] VPWR VGND sg13cmos5l_antennanp
XANTENNA_2834 Tile_X0Y0_FrameData[17] VPWR VGND sg13cmos5l_antennanp
XANTENNA_3557 Tile_X0Y0_FrameData[8] VPWR VGND sg13cmos5l_antennanp
XANTENNA_3568 Tile_X0Y0_FrameData[8] VPWR VGND sg13cmos5l_antennanp
XANTENNA_3579 Tile_X0Y0_FrameData[8] VPWR VGND sg13cmos5l_antennanp
XANTENNA_2845 Tile_X0Y0_FrameData[17] VPWR VGND sg13cmos5l_antennanp
XANTENNA_2856 Tile_X0Y0_FrameData[17] VPWR VGND sg13cmos5l_antennanp
XANTENNA_2867 Tile_X0Y0_FrameData[17] VPWR VGND sg13cmos5l_antennanp
XANTENNA_2878 Tile_X0Y0_FrameData[17] VPWR VGND sg13cmos5l_antennanp
XANTENNA_2889 Tile_X0Y0_FrameData[17] VPWR VGND sg13cmos5l_antennanp
X_1200_ _1200_/X Tile_X1Y0_N2END[5] Tile_X1Y0_N4END[5] Tile_X1Y0_NN4END[10] _0592_/Q
+ _0255_/Q _0254_/Q VPWR VGND sg13cmos5l_mux4_1
X_1131_ _1131_/X Tile_X0Y0_N1END[0] Tile_X0Y0_N2MID[0] Tile_X0Y0_N2END[7] _0596_/Q
+ _0201_/Q _0200_/Q VPWR VGND sg13cmos5l_mux4_1
XANTENNA__0946__X Tile_X2Y0_FrameStrobe_O[11] VPWR VGND sg13cmos5l_antennanp
X_1062_ Tile_X4Y0_S4BEG[15] Tile_X4Y0_N4END[0] VPWR VGND sg13cmos5l_buf_1
XFILLER_15_991 VPWR VGND sg13cmos5l_fill_1
X_0915_ Tile_X3Y0_FrameStrobe_O[0] Tile_X3Y0_FrameStrobe[0] VPWR VGND sg13cmos5l_buf_1
XFILLER_15_2696 VPWR VGND sg13cmos5l_decap_8
XFILLER_15_1951 VPWR VGND sg13cmos5l_decap_8
XFILLER_11_2527 VPWR VGND sg13cmos5l_decap_8
X_0846_ Tile_X4Y0_FrameStrobe_O[3] Tile_X4Y0_FrameStrobe[3] VPWR VGND sg13cmos5l_buf_1
XFILLER_11_1837 VPWR VGND sg13cmos5l_fill_2
X_0777_ Tile_X3Y0_S2BEGb[6] _1257_/X VPWR VGND sg13cmos5l_buf_1
XANTENNA__1017__X Tile_X0Y0_S2BEG[2] VPWR VGND sg13cmos5l_antennanp
XFILLER_2_2728 VPWR VGND sg13cmos5l_decap_8
XANTENNA__0856__X Tile_X4Y0_FrameStrobe_O[13] VPWR VGND sg13cmos5l_antennanp
XFILLER_0_2430 VPWR VGND sg13cmos5l_decap_8
XFILLER_16_2416 VPWR VGND sg13cmos5l_decap_8
XFILLER_14_2195 VPWR VGND sg13cmos5l_decap_8
XFILLER_4_604 VPWR VGND sg13cmos5l_decap_8
XFILLER_14_1494 VPWR VGND sg13cmos5l_decap_8
XFILLER_10_1336 VPWR VGND sg13cmos5l_fill_2
XANTENNA__0540__Q NPU_WDATA16 VPWR VGND sg13cmos5l_antennanp
XANTENNA_2108 Tile_X0Y0_FrameData[7] VPWR VGND sg13cmos5l_antennanp
XANTENNA_2119 Tile_X0Y0_FrameData[9] VPWR VGND sg13cmos5l_antennanp
XFILLER_3_136 VPWR VGND sg13cmos5l_fill_2
XANTENNA_1407 Tile_X0Y0_FrameData[31] VPWR VGND sg13cmos5l_antennanp
XANTENNA_1418 Tile_X0Y0_FrameData[31] VPWR VGND sg13cmos5l_antennanp
XANTENNA_1429 Tile_X0Y0_FrameData[31] VPWR VGND sg13cmos5l_antennanp
XFILLER_0_898 VPWR VGND sg13cmos5l_fill_1
XFILLER_5_2396 VPWR VGND sg13cmos5l_decap_8
XANTENNA__0766__X Tile_X3Y0_S2BEG[3] VPWR VGND sg13cmos5l_antennanp
XFILLER_5_1695 VPWR VGND sg13cmos5l_decap_8
XFILLER_16_700 VPWR VGND sg13cmos5l_decap_8
XFILLER_15_210 VPWR VGND sg13cmos5l_decap_8
XFILLER_16_777 VPWR VGND sg13cmos5l_decap_8
XFILLER_15_221 VPWR VGND sg13cmos5l_fill_2
XFILLER_15_1214 VPWR VGND sg13cmos5l_decap_8
X_0700_ Tile_X0Y0_FrameStrobe_O[13] Tile_X0Y0_FrameStrobe[13] VPWR VGND sg13cmos5l_buf_1
XFILLER_7_442 VPWR VGND sg13cmos5l_fill_2
XFILLER_15_1258 VPWR VGND sg13cmos5l_fill_1
XANTENNA_4000 Tile_X0Y0_FrameData[18] VPWR VGND sg13cmos5l_antennanp
XANTENNA_4011 Tile_X0Y0_FrameData[18] VPWR VGND sg13cmos5l_antennanp
XANTENNA_4022 Tile_X0Y0_N2END[1] VPWR VGND sg13cmos5l_antennanp
XANTENNA_3310 Tile_X0Y0_FrameData[20] VPWR VGND sg13cmos5l_antennanp
XANTENNA_3321 Tile_X0Y0_FrameData[20] VPWR VGND sg13cmos5l_antennanp
XANTENNA_4033 Tile_X0Y0_N2END[4] VPWR VGND sg13cmos5l_antennanp
XANTENNA_4044 Tile_X0Y0_N2END[5] VPWR VGND sg13cmos5l_antennanp
XANTENNA_4055 Tile_X0Y0_N4END[3] VPWR VGND sg13cmos5l_antennanp
XANTENNA_4066 Tile_X0Y0_N4END[8] VPWR VGND sg13cmos5l_antennanp
X_0631_ _0631_/L_HI VPWR VGND sg13cmos5l_tiehi
XANTENNA_3332 Tile_X0Y0_FrameData[20] VPWR VGND sg13cmos5l_antennanp
XANTENNA_3343 Tile_X0Y0_FrameData[20] VPWR VGND sg13cmos5l_antennanp
XANTENNA_3354 Tile_X0Y0_FrameData[20] VPWR VGND sg13cmos5l_antennanp
XANTENNA_4077 Tile_X1Y0_N2END[4] VPWR VGND sg13cmos5l_antennanp
XANTENNA_4088 Tile_X1Y0_N2END[7] VPWR VGND sg13cmos5l_antennanp
XANTENNA_4099 Tile_X1Y0_N4END[0] VPWR VGND sg13cmos5l_antennanp
X_0562_ NPU_WE6 Tile_X0Y0_UserCLK _0562_/D _0665_/L_HI VPWR VGND sg13cmos5l_dfrbpq_1
XANTENNA_2620 Tile_X0Y0_FrameData[14] VPWR VGND sg13cmos5l_antennanp
XANTENNA_2631 Tile_X0Y0_FrameData[14] VPWR VGND sg13cmos5l_antennanp
XANTENNA_2642 Tile_X0Y0_FrameData[14] VPWR VGND sg13cmos5l_antennanp
XANTENNA_2653 Tile_X0Y0_FrameData[14] VPWR VGND sg13cmos5l_antennanp
XANTENNA_3365 Tile_X0Y0_FrameData[20] VPWR VGND sg13cmos5l_antennanp
XANTENNA_3376 Tile_X0Y0_FrameData[21] VPWR VGND sg13cmos5l_antennanp
XANTENNA_3387 Tile_X0Y0_FrameData[21] VPWR VGND sg13cmos5l_antennanp
XANTENNA_1930 Tile_X0Y0_FrameData[5] VPWR VGND sg13cmos5l_antennanp
XANTENNA_1941 Tile_X0Y0_FrameData[6] VPWR VGND sg13cmos5l_antennanp
XANTENNA_2664 Tile_X0Y0_FrameData[14] VPWR VGND sg13cmos5l_antennanp
XANTENNA_2675 Tile_X0Y0_FrameData[14] VPWR VGND sg13cmos5l_antennanp
XANTENNA_2686 Tile_X0Y0_FrameData[14] VPWR VGND sg13cmos5l_antennanp
XANTENNA_3398 Tile_X0Y0_FrameData[21] VPWR VGND sg13cmos5l_antennanp
X_0493_ _0493_/Q Tile_X0Y0_FrameData[12] VGND VPWR Tile_X3Y0_FrameStrobe[2] latch
XANTENNA_1952 Tile_X0Y0_FrameData[6] VPWR VGND sg13cmos5l_antennanp
XANTENNA_1963 Tile_X0Y0_FrameData[6] VPWR VGND sg13cmos5l_antennanp
XANTENNA_1974 Tile_X0Y0_FrameData[6] VPWR VGND sg13cmos5l_antennanp
XANTENNA_2697 Tile_X0Y0_FrameData[14] VPWR VGND sg13cmos5l_antennanp
XANTENNA_1985 Tile_X0Y0_FrameData[6] VPWR VGND sg13cmos5l_antennanp
XANTENNA_1996 Tile_X0Y0_FrameData[6] VPWR VGND sg13cmos5l_antennanp
X_1114_ _1114_/X Tile_X0Y0_N4END[2] Tile_X0Y0_N4END[3] Tile_X0Y0_NN4END[0] Tile_X0Y0_NN4END[2]
+ _0117_/Q _0116_/Q VPWR VGND sg13cmos5l_mux4_1
XFILLER_4_1161 VPWR VGND sg13cmos5l_decap_8
XFILLER_0_1036 VPWR VGND sg13cmos5l_fill_1
X_1045_ Tile_X4Y0_S2BEGb[6] Tile_X4Y0_N2END[1] VPWR VGND sg13cmos5l_buf_1
XFILLER_9_70 VPWR VGND sg13cmos5l_decap_8
XFILLER_15_2482 VPWR VGND sg13cmos5l_decap_8
XFILLER_11_2324 VPWR VGND sg13cmos5l_decap_8
XFILLER_11_1634 VPWR VGND sg13cmos5l_decap_8
X_0829_ Tile_X4Y0_FrameData_O[18] Tile_X0Y0_FrameData[18] VPWR VGND sg13cmos5l_buf_1
XFILLER_6_2683 VPWR VGND sg13cmos5l_decap_8
XFILLER_2_2514 VPWR VGND sg13cmos5l_decap_8
XANTENNA_827 Tile_X0Y0_FrameData[27] VPWR VGND sg13cmos5l_antennanp
XANTENNA_816 Tile_X0Y0_FrameData[27] VPWR VGND sg13cmos5l_antennanp
XANTENNA_805 Tile_X0Y0_FrameData[27] VPWR VGND sg13cmos5l_antennanp
XFILLER_0_2271 VPWR VGND sg13cmos5l_fill_2
XANTENNA_849 Tile_X0Y0_FrameData[27] VPWR VGND sg13cmos5l_antennanp
XANTENNA_838 Tile_X0Y0_FrameData[27] VPWR VGND sg13cmos5l_antennanp
XANTENNA__0535__Q NPU_WDATA11 VPWR VGND sg13cmos5l_antennanp
XFILLER_9_707 VPWR VGND sg13cmos5l_decap_8
XFILLER_16_2246 VPWR VGND sg13cmos5l_decap_8
XFILLER_13_769 VPWR VGND sg13cmos5l_decap_8
XFILLER_16_1556 VPWR VGND sg13cmos5l_decap_8
XFILLER_5_913 VPWR VGND sg13cmos5l_fill_2
XFILLER_5_28 VPWR VGND sg13cmos5l_decap_8
XFILLER_10_1133 VPWR VGND sg13cmos5l_decap_8
XFILLER_10_1199 VPWR VGND sg13cmos5l_fill_1
XANTENNA_1204 Tile_X0Y0_FrameData[30] VPWR VGND sg13cmos5l_antennanp
XANTENNA_1215 Tile_X0Y0_FrameData[30] VPWR VGND sg13cmos5l_antennanp
XANTENNA_1226 Tile_X0Y0_FrameData[30] VPWR VGND sg13cmos5l_antennanp
XANTENNA_1237 Tile_X0Y0_FrameData[30] VPWR VGND sg13cmos5l_antennanp
XANTENNA_1248 Tile_X0Y0_FrameData[30] VPWR VGND sg13cmos5l_antennanp
XANTENNA_1259 Tile_X0Y0_FrameData[30] VPWR VGND sg13cmos5l_antennanp
XFILLER_7_1757 VPWR VGND sg13cmos5l_decap_8
XFILLER_5_2171 VPWR VGND sg13cmos5l_fill_2
XFILLER_1_2046 VPWR VGND sg13cmos5l_fill_2
XFILLER_1_1312 VPWR VGND sg13cmos5l_fill_1
XFILLER_16_585 VPWR VGND sg13cmos5l_decap_8
XFILLER_12_2633 VPWR VGND sg13cmos5l_decap_8
X_0614_ _0614_/L_HI VPWR VGND sg13cmos5l_tiehi
XANTENNA_3140 Tile_X0Y0_FrameData[19] VPWR VGND sg13cmos5l_antennanp
XANTENNA_3151 Tile_X0Y0_FrameData[19] VPWR VGND sg13cmos5l_antennanp
XANTENNA_3162 Tile_X0Y0_FrameData[19] VPWR VGND sg13cmos5l_antennanp
XANTENNA_2450 Tile_X0Y0_FrameData[12] VPWR VGND sg13cmos5l_antennanp
XANTENNA_2461 Tile_X0Y0_FrameData[12] VPWR VGND sg13cmos5l_antennanp
XANTENNA_3173 Tile_X0Y0_FrameData[19] VPWR VGND sg13cmos5l_antennanp
XANTENNA_3184 Tile_X0Y0_FrameData[20] VPWR VGND sg13cmos5l_antennanp
XANTENNA_3195 Tile_X0Y0_FrameData[20] VPWR VGND sg13cmos5l_antennanp
X_0545_ NPU_WDATA21 Tile_X0Y0_UserCLK _1117_/X _0682_/L_HI VPWR VGND sg13cmos5l_dfrbpq_1
XANTENNA_2472 Tile_X0Y0_FrameData[12] VPWR VGND sg13cmos5l_antennanp
XANTENNA_2483 Tile_X0Y0_FrameData[12] VPWR VGND sg13cmos5l_antennanp
XANTENNA_2494 Tile_X0Y0_FrameData[12] VPWR VGND sg13cmos5l_antennanp
X_0476_ _0476_/Q Tile_X0Y0_FrameData[29] VGND VPWR Tile_X3Y0_FrameStrobe[2] latch
XFILLER_6_1201 VPWR VGND sg13cmos5l_fill_1
XANTENNA_1760 Tile_X0Y0_FrameData[4] VPWR VGND sg13cmos5l_antennanp
XANTENNA_1771 Tile_X0Y0_FrameData[5] VPWR VGND sg13cmos5l_antennanp
XANTENNA_1782 Tile_X0Y0_FrameData[5] VPWR VGND sg13cmos5l_antennanp
XANTENNA_1793 Tile_X0Y0_FrameData[5] VPWR VGND sg13cmos5l_antennanp
X_1028_ Tile_X4Y0_S1BEG[1] Tile_X4Y0_N1END[2] VPWR VGND sg13cmos5l_buf_1
XFILLER_10_717 VPWR VGND sg13cmos5l_decap_8
XANTENNA__1030__X Tile_X4Y0_S1BEG[3] VPWR VGND sg13cmos5l_antennanp
XFILLER_11_2121 VPWR VGND sg13cmos5l_decap_8
XFILLER_11_2198 VPWR VGND sg13cmos5l_decap_8
XFILLER_8_2734 VPWR VGND sg13cmos5l_decap_8
XFILLER_6_1790 VPWR VGND sg13cmos5l_fill_2
XFILLER_2_1632 VPWR VGND sg13cmos5l_decap_8
XANTENNA_602 Tile_X0Y0_FrameData[23] VPWR VGND sg13cmos5l_antennanp
XANTENNA_635 Tile_X0Y0_FrameData[23] VPWR VGND sg13cmos5l_antennanp
XANTENNA_624 Tile_X0Y0_FrameData[23] VPWR VGND sg13cmos5l_antennanp
XANTENNA_613 Tile_X0Y0_FrameData[23] VPWR VGND sg13cmos5l_antennanp
XANTENNA_668 Tile_X0Y0_FrameData[24] VPWR VGND sg13cmos5l_antennanp
XANTENNA_657 Tile_X0Y0_FrameData[24] VPWR VGND sg13cmos5l_antennanp
XANTENNA_646 Tile_X0Y0_FrameData[23] VPWR VGND sg13cmos5l_antennanp
XANTENNA_679 Tile_X0Y0_FrameData[24] VPWR VGND sg13cmos5l_antennanp
XFILLER_16_2043 VPWR VGND sg13cmos5l_decap_8
XFILLER_13_555 VPWR VGND sg13cmos5l_decap_8
XFILLER_16_1386 VPWR VGND sg13cmos5l_decap_8
XFILLER_12_1217 VPWR VGND sg13cmos5l_decap_8
XANTENNA_1001 Tile_X0Y0_FrameData[28] VPWR VGND sg13cmos5l_antennanp
XANTENNA_1012 Tile_X0Y0_FrameData[28] VPWR VGND sg13cmos5l_antennanp
XFILLER_7_2200 VPWR VGND sg13cmos5l_decap_8
XANTENNA_1023 Tile_X0Y0_FrameData[29] VPWR VGND sg13cmos5l_antennanp
XANTENNA_1034 Tile_X0Y0_FrameData[29] VPWR VGND sg13cmos5l_antennanp
XANTENNA_1045 Tile_X0Y0_FrameData[29] VPWR VGND sg13cmos5l_antennanp
X_0330_ _0330_/Q Tile_X0Y0_FrameData[15] VGND VPWR Tile_X2Y0_FrameStrobe[0] latch
XFILLER_7_2255 VPWR VGND sg13cmos5l_decap_8
XANTENNA_1056 Tile_X0Y0_FrameData[29] VPWR VGND sg13cmos5l_antennanp
XANTENNA_1067 Tile_X0Y0_FrameData[29] VPWR VGND sg13cmos5l_antennanp
XANTENNA_1078 Tile_X0Y0_FrameData[2] VPWR VGND sg13cmos5l_antennanp
XANTENNA_1089 Tile_X0Y0_FrameData[2] VPWR VGND sg13cmos5l_antennanp
X_0261_ _0261_/Q Tile_X0Y0_FrameData[4] VGND VPWR Tile_X1Y0_FrameStrobe[1] latch
X_0192_ _0192_/Q Tile_X0Y0_FrameData[25] VGND VPWR Tile_X0Y0_FrameStrobe[3] latch
XANTENNA__0954__X Tile_X2Y0_FrameStrobe_O[19] VPWR VGND sg13cmos5l_antennanp
XFILLER_14_2728 VPWR VGND sg13cmos5l_decap_8
XFILLER_8_570 VPWR VGND sg13cmos5l_decap_8
XFILLER_12_2463 VPWR VGND sg13cmos5l_decap_8
XFILLER_12_1740 VPWR VGND sg13cmos5l_decap_8
X_0528_ NPU_WDATA4 Tile_X0Y0_UserCLK _1100_/X _0624_/L_HI VPWR VGND sg13cmos5l_dfrbpq_1
XANTENNA_2280 Tile_X0Y0_FrameData[9] VPWR VGND sg13cmos5l_antennanp
XANTENNA_2291 Tile_X0Y0_N2END[3] VPWR VGND sg13cmos5l_antennanp
XANTENNA_1590 Tile_X0Y0_FrameData[3] VPWR VGND sg13cmos5l_antennanp
X_0459_ _0459_/Q Tile_X0Y0_FrameData[14] VGND VPWR Tile_X3Y0_FrameStrobe[1] latch
XANTENNA__1025__X Tile_X0Y0_S1BEG[2] VPWR VGND sg13cmos5l_antennanp
XFILLER_3_2675 VPWR VGND sg13cmos5l_decap_8
XANTENNA__0864__X Tile_X2Y0_S1BEG[1] VPWR VGND sg13cmos5l_antennanp
XFILLER_10_536 VPWR VGND sg13cmos5l_decap_8
XFILLER_13_1537 VPWR VGND sg13cmos5l_decap_8
XANTENNA_3909 Tile_X0Y0_FrameData[18] VPWR VGND sg13cmos5l_antennanp
XFILLER_8_2520 VPWR VGND sg13cmos5l_decap_4
XFILLER_2_746 VPWR VGND sg13cmos5l_fill_1
XFILLER_1_289 VPWR VGND sg13cmos5l_fill_1
XFILLER_4_1705 VPWR VGND sg13cmos5l_decap_8
XANTENNA_410 Tile_X0Y0_FrameData[22] VPWR VGND sg13cmos5l_antennanp
XANTENNA__0774__X Tile_X3Y0_S2BEGb[3] VPWR VGND sg13cmos5l_antennanp
XANTENNA_421 Tile_X0Y0_FrameData[22] VPWR VGND sg13cmos5l_antennanp
XANTENNA_432 Tile_X0Y0_FrameData[23] VPWR VGND sg13cmos5l_antennanp
XANTENNA_443 Tile_X0Y0_FrameData[23] VPWR VGND sg13cmos5l_antennanp
XANTENNA_476 Tile_X0Y0_FrameData[23] VPWR VGND sg13cmos5l_antennanp
XANTENNA_465 Tile_X0Y0_FrameData[23] VPWR VGND sg13cmos5l_antennanp
XANTENNA_454 Tile_X0Y0_FrameData[23] VPWR VGND sg13cmos5l_antennanp
XANTENNA_498 Tile_X0Y0_FrameData[23] VPWR VGND sg13cmos5l_antennanp
XANTENNA_487 Tile_X0Y0_FrameData[23] VPWR VGND sg13cmos5l_antennanp
XFILLER_15_91 VPWR VGND sg13cmos5l_decap_8
XFILLER_13_2772 VPWR VGND sg13cmos5l_fill_1
XFILLER_12_1036 VPWR VGND sg13cmos5l_fill_2
XFILLER_12_1069 VPWR VGND sg13cmos5l_decap_4
XANTENNA__0949__X Tile_X2Y0_FrameStrobe_O[14] VPWR VGND sg13cmos5l_antennanp
X_0313_ _0313_/Q Tile_X0Y0_FrameData[16] VGND VPWR Tile_X1Y0_FrameStrobe[3] latch
X_0244_ _0244_/Q Tile_X0Y0_FrameData[21] VGND VPWR Tile_X1Y0_FrameStrobe[1] latch
X_0175_ _0175_/Q Tile_X0Y0_FrameData[10] VGND VPWR Tile_X0Y0_FrameStrobe[2] latch
XFILLER_14_1802 VPWR VGND sg13cmos5l_decap_8
XFILLER_12_2260 VPWR VGND sg13cmos5l_decap_8
XFILLER_14_1879 VPWR VGND sg13cmos5l_decap_8
XANTENNA__0859__X Tile_X4Y0_FrameStrobe_O[16] VPWR VGND sg13cmos5l_antennanp
XFILLER_8_1137 VPWR VGND sg13cmos5l_decap_8
XFILLER_14_105 VPWR VGND sg13cmos5l_decap_8
XFILLER_13_1301 VPWR VGND sg13cmos5l_fill_1
XANTENNA__0543__Q NPU_WDATA19 VPWR VGND sg13cmos5l_antennanp
XFILLER_13_2068 VPWR VGND sg13cmos5l_decap_8
XANTENNA_3706 Tile_X1Y0_N4END[2] VPWR VGND sg13cmos5l_antennanp
XANTENNA_3717 Tile_X1Y0_N4END[3] VPWR VGND sg13cmos5l_antennanp
XANTENNA_3728 Tile_X1Y0_N4END[3] VPWR VGND sg13cmos5l_antennanp
XANTENNA_3739 Tile_X2Y0_N2END[4] VPWR VGND sg13cmos5l_antennanp
XFILLER_11_1091 VPWR VGND sg13cmos5l_decap_8
XANTENNA__0769__X Tile_X3Y0_S2BEG[6] VPWR VGND sg13cmos5l_antennanp
XFILLER_2_598 VPWR VGND sg13cmos5l_decap_8
XFILLER_8_2394 VPWR VGND sg13cmos5l_decap_8
XFILLER_8_1671 VPWR VGND sg13cmos5l_decap_8
XFILLER_4_2269 VPWR VGND sg13cmos5l_decap_8
XFILLER_4_1524 VPWR VGND sg13cmos5l_fill_2
XANTENNA_240 Tile_X0Y0_FrameData[10] VPWR VGND sg13cmos5l_antennanp
XANTENNA_251 Tile_X0Y0_FrameData[10] VPWR VGND sg13cmos5l_antennanp
XANTENNA_262 Tile_X0Y0_FrameData[10] VPWR VGND sg13cmos5l_antennanp
XANTENNA_273 Tile_X0Y0_FrameData[10] VPWR VGND sg13cmos5l_antennanp
XANTENNA_284 Tile_X0Y0_FrameData[15] VPWR VGND sg13cmos5l_antennanp
XANTENNA_295 Tile_X0Y0_FrameData[15] VPWR VGND sg13cmos5l_antennanp
XFILLER_15_2801 VPWR VGND sg13cmos5l_fill_2
X_0931_ Tile_X3Y0_FrameStrobe_O[16] Tile_X3Y0_FrameStrobe[16] VPWR VGND sg13cmos5l_buf_1
XFILLER_13_182 VPWR VGND sg13cmos5l_decap_8
XFILLER_11_2709 VPWR VGND sg13cmos5l_decap_8
X_0862_ Tile_X4Y0_FrameStrobe_O[19] Tile_X4Y0_FrameStrobe[19] VPWR VGND sg13cmos5l_buf_1
X_0793_ Tile_X3Y0_S4BEG[14] _1273_/X VPWR VGND sg13cmos5l_buf_1
XFILLER_13_2580 VPWR VGND sg13cmos5l_decap_8
XFILLER_13_1890 VPWR VGND sg13cmos5l_fill_1
XFILLER_9_2125 VPWR VGND sg13cmos5l_decap_8
X_1276_ _1276_/X Tile_X3Y0_N2END[1] Tile_X3Y0_N4END[1] Tile_X3Y0_NN4END[14] _0578_/Q
+ _0455_/Q _0454_/Q VPWR VGND sg13cmos5l_mux4_1
XFILLER_7_1192 VPWR VGND sg13cmos5l_decap_8
X_0227_ _0227_/Q Tile_X0Y0_FrameData[6] VGND VPWR Tile_X1Y0_FrameStrobe[0] latch
X_0158_ _0158_/Q Tile_X0Y0_FrameData[27] VGND VPWR Tile_X0Y0_FrameStrobe[2] latch
X_0089_ _0557_/D _0519_/Q _1089_/X VPWR VGND sg13cmos5l_nor2b_1
XFILLER_14_2366 VPWR VGND sg13cmos5l_decap_8
XFILLER_10_2219 VPWR VGND sg13cmos5l_decap_8
XFILLER_14_1676 VPWR VGND sg13cmos5l_decap_8
XFILLER_5_2501 VPWR VGND sg13cmos5l_decap_8
XFILLER_5_1800 VPWR VGND sg13cmos5l_fill_2
XANTENNA__0538__Q NPU_WDATA14 VPWR VGND sg13cmos5l_antennanp
XFILLER_8_28 VPWR VGND sg13cmos5l_decap_8
XFILLER_15_1407 VPWR VGND sg13cmos5l_decap_4
XFILLER_7_602 VPWR VGND sg13cmos5l_decap_8
XANTENNA_3503 Tile_X0Y0_FrameData[8] VPWR VGND sg13cmos5l_antennanp
XFILLER_7_679 VPWR VGND sg13cmos5l_decap_8
XFILLER_13_1164 VPWR VGND sg13cmos5l_decap_8
XFILLER_12_70 VPWR VGND sg13cmos5l_decap_8
XFILLER_10_2753 VPWR VGND sg13cmos5l_decap_4
XANTENNA_2802 Tile_X0Y0_FrameData[16] VPWR VGND sg13cmos5l_antennanp
XANTENNA_3514 Tile_X0Y0_FrameData[8] VPWR VGND sg13cmos5l_antennanp
XANTENNA_3525 Tile_X0Y0_FrameData[8] VPWR VGND sg13cmos5l_antennanp
XANTENNA_3536 Tile_X0Y0_FrameData[8] VPWR VGND sg13cmos5l_antennanp
XANTENNA_2813 Tile_X0Y0_FrameData[17] VPWR VGND sg13cmos5l_antennanp
XANTENNA_2824 Tile_X0Y0_FrameData[17] VPWR VGND sg13cmos5l_antennanp
XANTENNA_2835 Tile_X0Y0_FrameData[17] VPWR VGND sg13cmos5l_antennanp
XANTENNA_3547 Tile_X0Y0_FrameData[8] VPWR VGND sg13cmos5l_antennanp
XANTENNA_3558 Tile_X0Y0_FrameData[8] VPWR VGND sg13cmos5l_antennanp
XANTENNA_3569 Tile_X0Y0_FrameData[8] VPWR VGND sg13cmos5l_antennanp
XANTENNA_2846 Tile_X0Y0_FrameData[17] VPWR VGND sg13cmos5l_antennanp
XANTENNA_2857 Tile_X0Y0_FrameData[17] VPWR VGND sg13cmos5l_antennanp
XANTENNA_2868 Tile_X0Y0_FrameData[17] VPWR VGND sg13cmos5l_antennanp
XANTENNA_2879 Tile_X0Y0_FrameData[17] VPWR VGND sg13cmos5l_antennanp
X_1130_ _1130_/X Tile_X4Y0_N1END[2] Tile_X4Y0_N2MID[2] Tile_X4Y0_N2MID[5] Tile_X4Y0_N2END[5]
+ _0507_/Q _0512_/Q VPWR VGND sg13cmos5l_mux4_1
X_1061_ Tile_X4Y0_S4BEG[14] Tile_X4Y0_N4END[1] VPWR VGND sg13cmos5l_buf_1
XANTENNA__0962__X Tile_X1Y0_FrameStrobe_O[7] VPWR VGND sg13cmos5l_antennanp
X_0914_ Tile_X2Y0_SS4BEG[15] _1250_/X VPWR VGND sg13cmos5l_buf_1
XFILLER_15_2675 VPWR VGND sg13cmos5l_decap_8
XFILLER_11_2506 VPWR VGND sg13cmos5l_decap_8
X_0845_ Tile_X4Y0_FrameStrobe_O[2] Tile_X4Y0_FrameStrobe[2] VPWR VGND sg13cmos5l_buf_1
XFILLER_11_1816 VPWR VGND sg13cmos5l_decap_8
X_0776_ Tile_X3Y0_S2BEGb[5] _1256_/X VPWR VGND sg13cmos5l_buf_1
XFILLER_9_1232 VPWR VGND sg13cmos5l_decap_4
XFILLER_5_1129 VPWR VGND sg13cmos5l_decap_8
XFILLER_2_2707 VPWR VGND sg13cmos5l_decap_8
X_1259_ _1259_/X Tile_X3Y0_N2MID[0] Tile_X3Y0_N4END[15] Tile_X3Y0_NN4END[0] _0578_/Q
+ _0489_/Q _0488_/Q VPWR VGND sg13cmos5l_mux4_1
XANTENNA__1033__X Tile_X4Y0_S2BEG[2] VPWR VGND sg13cmos5l_antennanp
XFILLER_0_1741 VPWR VGND sg13cmos5l_decap_8
XANTENNA__0872__X Tile_X2Y0_S2BEG[5] VPWR VGND sg13cmos5l_antennanp
XFILLER_16_1749 VPWR VGND sg13cmos5l_decap_8
XFILLER_14_2174 VPWR VGND sg13cmos5l_decap_8
XFILLER_14_1473 VPWR VGND sg13cmos5l_decap_8
XANTENNA_2109 Tile_X0Y0_FrameData[7] VPWR VGND sg13cmos5l_antennanp
XANTENNA_1408 Tile_X0Y0_FrameData[31] VPWR VGND sg13cmos5l_antennanp
XANTENNA_1419 Tile_X0Y0_FrameData[31] VPWR VGND sg13cmos5l_antennanp
XFILLER_5_2375 VPWR VGND sg13cmos5l_decap_8
XFILLER_5_1674 VPWR VGND sg13cmos5l_decap_8
XFILLER_1_1516 VPWR VGND sg13cmos5l_fill_1
XFILLER_16_756 VPWR VGND sg13cmos5l_decap_8
XANTENNA__0782__X Tile_X3Y0_S4BEG[3] VPWR VGND sg13cmos5l_antennanp
XANTENNA_4001 Tile_X0Y0_FrameData[18] VPWR VGND sg13cmos5l_antennanp
XANTENNA_4012 Tile_X0Y0_FrameData[18] VPWR VGND sg13cmos5l_antennanp
XANTENNA_4023 Tile_X0Y0_N2END[1] VPWR VGND sg13cmos5l_antennanp
XANTENNA_3300 Tile_X0Y0_FrameData[20] VPWR VGND sg13cmos5l_antennanp
XANTENNA_3311 Tile_X0Y0_FrameData[20] VPWR VGND sg13cmos5l_antennanp
XANTENNA_4034 Tile_X0Y0_N2END[4] VPWR VGND sg13cmos5l_antennanp
XANTENNA_4045 Tile_X0Y0_N2END[5] VPWR VGND sg13cmos5l_antennanp
XANTENNA_4056 Tile_X0Y0_N4END[3] VPWR VGND sg13cmos5l_antennanp
X_0630_ _0630_/L_HI VPWR VGND sg13cmos5l_tiehi
XANTENNA_2610 Tile_X0Y0_FrameData[14] VPWR VGND sg13cmos5l_antennanp
XANTENNA_3322 Tile_X0Y0_FrameData[20] VPWR VGND sg13cmos5l_antennanp
XANTENNA_3333 Tile_X0Y0_FrameData[20] VPWR VGND sg13cmos5l_antennanp
XANTENNA_3344 Tile_X0Y0_FrameData[20] VPWR VGND sg13cmos5l_antennanp
XANTENNA_3355 Tile_X0Y0_FrameData[20] VPWR VGND sg13cmos5l_antennanp
XANTENNA_4067 Tile_X0Y0_N4END[8] VPWR VGND sg13cmos5l_antennanp
XANTENNA_4078 Tile_X1Y0_N2END[4] VPWR VGND sg13cmos5l_antennanp
XANTENNA_4089 Tile_X1Y0_N2END[7] VPWR VGND sg13cmos5l_antennanp
X_0561_ NPU_WE5 Tile_X0Y0_UserCLK _0561_/D _0666_/L_HI VPWR VGND sg13cmos5l_dfrbpq_1
XANTENNA_2621 Tile_X0Y0_FrameData[14] VPWR VGND sg13cmos5l_antennanp
XANTENNA_2632 Tile_X0Y0_FrameData[14] VPWR VGND sg13cmos5l_antennanp
XANTENNA_2643 Tile_X0Y0_FrameData[14] VPWR VGND sg13cmos5l_antennanp
XANTENNA_3366 Tile_X0Y0_FrameData[20] VPWR VGND sg13cmos5l_antennanp
XANTENNA_3377 Tile_X0Y0_FrameData[21] VPWR VGND sg13cmos5l_antennanp
XANTENNA_3388 Tile_X0Y0_FrameData[21] VPWR VGND sg13cmos5l_antennanp
XANTENNA_1920 Tile_X0Y0_FrameData[5] VPWR VGND sg13cmos5l_antennanp
XANTENNA_1931 Tile_X0Y0_FrameData[5] VPWR VGND sg13cmos5l_antennanp
XANTENNA_1942 Tile_X0Y0_FrameData[6] VPWR VGND sg13cmos5l_antennanp
XANTENNA_2654 Tile_X0Y0_FrameData[14] VPWR VGND sg13cmos5l_antennanp
XANTENNA_2665 Tile_X0Y0_FrameData[14] VPWR VGND sg13cmos5l_antennanp
XANTENNA_2676 Tile_X0Y0_FrameData[14] VPWR VGND sg13cmos5l_antennanp
XANTENNA_3399 Tile_X0Y0_FrameData[21] VPWR VGND sg13cmos5l_antennanp
X_0492_ _0492_/Q Tile_X0Y0_FrameData[13] VGND VPWR Tile_X3Y0_FrameStrobe[2] latch
XANTENNA_1953 Tile_X0Y0_FrameData[6] VPWR VGND sg13cmos5l_antennanp
XANTENNA_1964 Tile_X0Y0_FrameData[6] VPWR VGND sg13cmos5l_antennanp
XANTENNA_1975 Tile_X0Y0_FrameData[6] VPWR VGND sg13cmos5l_antennanp
XANTENNA_2687 Tile_X0Y0_FrameData[14] VPWR VGND sg13cmos5l_antennanp
XANTENNA_2698 Tile_X0Y0_FrameData[14] VPWR VGND sg13cmos5l_antennanp
XANTENNA__0957__X Tile_X1Y0_FrameStrobe_O[2] VPWR VGND sg13cmos5l_antennanp
XANTENNA_1986 Tile_X0Y0_FrameData[6] VPWR VGND sg13cmos5l_antennanp
XANTENNA_1997 Tile_X0Y0_FrameData[6] VPWR VGND sg13cmos5l_antennanp
X_1113_ _1113_/X Tile_X0Y0_N4END[1] Tile_X0Y0_N4END[2] Tile_X0Y0_NN4END[1] Tile_X0Y0_NN4END[3]
+ _0119_/Q _0118_/Q VPWR VGND sg13cmos5l_mux4_1
XFILLER_4_1140 VPWR VGND sg13cmos5l_decap_8
X_1044_ Tile_X4Y0_S2BEGb[5] Tile_X4Y0_N2END[2] VPWR VGND sg13cmos5l_buf_1
XFILLER_4_1184 VPWR VGND sg13cmos5l_fill_1
XFILLER_1_2784 VPWR VGND sg13cmos5l_fill_1
XANTENNA__0692__X Tile_X0Y0_FrameStrobe_O[5] VPWR VGND sg13cmos5l_antennanp
XFILLER_15_2461 VPWR VGND sg13cmos5l_decap_8
XFILLER_11_2303 VPWR VGND sg13cmos5l_decap_8
XFILLER_11_1613 VPWR VGND sg13cmos5l_decap_8
X_0828_ Tile_X4Y0_FrameData_O[17] Tile_X0Y0_FrameData[17] VPWR VGND sg13cmos5l_buf_1
X_0759_ Tile_X3Y0_S1BEG[0] Tile_X3Y0_N1END[3] VPWR VGND sg13cmos5l_buf_1
XANTENNA__1028__X Tile_X4Y0_S1BEG[1] VPWR VGND sg13cmos5l_antennanp
XFILLER_6_2662 VPWR VGND sg13cmos5l_decap_8
XANTENNA__0867__X Tile_X2Y0_S2BEG[0] VPWR VGND sg13cmos5l_antennanp
XFILLER_2_1825 VPWR VGND sg13cmos5l_fill_2
XANTENNA_817 Tile_X0Y0_FrameData[27] VPWR VGND sg13cmos5l_antennanp
XANTENNA_806 Tile_X0Y0_FrameData[27] VPWR VGND sg13cmos5l_antennanp
XFILLER_0_2283 VPWR VGND sg13cmos5l_fill_1
XANTENNA_839 Tile_X0Y0_FrameData[27] VPWR VGND sg13cmos5l_antennanp
XANTENNA_828 Tile_X0Y0_FrameData[27] VPWR VGND sg13cmos5l_antennanp
XFILLER_0_1582 VPWR VGND sg13cmos5l_fill_1
XFILLER_16_2225 VPWR VGND sg13cmos5l_decap_4
XFILLER_13_748 VPWR VGND sg13cmos5l_decap_8
XFILLER_16_2269 VPWR VGND sg13cmos5l_fill_1
XFILLER_16_1535 VPWR VGND sg13cmos5l_decap_8
XFILLER_10_1101 VPWR VGND sg13cmos5l_fill_2
XANTENNA__0551__Q NPU_WDATA27 VPWR VGND sg13cmos5l_antennanp
XFILLER_7_2415 VPWR VGND sg13cmos5l_decap_8
XFILLER_10_1189 VPWR VGND sg13cmos5l_decap_8
XANTENNA_1205 Tile_X0Y0_FrameData[30] VPWR VGND sg13cmos5l_antennanp
XANTENNA_1216 Tile_X0Y0_FrameData[30] VPWR VGND sg13cmos5l_antennanp
XANTENNA_1227 Tile_X0Y0_FrameData[30] VPWR VGND sg13cmos5l_antennanp
XANTENNA_1238 Tile_X0Y0_FrameData[30] VPWR VGND sg13cmos5l_antennanp
XANTENNA_1249 Tile_X0Y0_FrameData[30] VPWR VGND sg13cmos5l_antennanp
XFILLER_7_1736 VPWR VGND sg13cmos5l_decap_8
XANTENNA__0777__X Tile_X3Y0_S2BEGb[6] VPWR VGND sg13cmos5l_antennanp
XFILLER_16_564 VPWR VGND sg13cmos5l_decap_8
XFILLER_12_770 VPWR VGND sg13cmos5l_decap_8
XFILLER_12_2612 VPWR VGND sg13cmos5l_decap_8
XFILLER_12_2689 VPWR VGND sg13cmos5l_decap_8
XANTENNA_3130 Tile_X0Y0_FrameData[19] VPWR VGND sg13cmos5l_antennanp
X_0613_ _0613_/L_HI VPWR VGND sg13cmos5l_tiehi
XFILLER_10_2380 VPWR VGND sg13cmos5l_decap_8
XANTENNA_3141 Tile_X0Y0_FrameData[19] VPWR VGND sg13cmos5l_antennanp
XANTENNA_3152 Tile_X0Y0_FrameData[19] VPWR VGND sg13cmos5l_antennanp
XANTENNA_3163 Tile_X0Y0_FrameData[19] VPWR VGND sg13cmos5l_antennanp
XANTENNA_2440 Tile_X0Y0_FrameData[12] VPWR VGND sg13cmos5l_antennanp
XANTENNA_2451 Tile_X0Y0_FrameData[12] VPWR VGND sg13cmos5l_antennanp
XANTENNA_3174 Tile_X0Y0_FrameData[19] VPWR VGND sg13cmos5l_antennanp
XANTENNA_3185 Tile_X0Y0_FrameData[20] VPWR VGND sg13cmos5l_antennanp
XANTENNA_3196 Tile_X0Y0_FrameData[20] VPWR VGND sg13cmos5l_antennanp
X_0544_ NPU_WDATA20 Tile_X0Y0_UserCLK _1116_/X _0683_/L_HI VPWR VGND sg13cmos5l_dfrbpq_1
XANTENNA_1750 Tile_X0Y0_FrameData[4] VPWR VGND sg13cmos5l_antennanp
XANTENNA_2462 Tile_X0Y0_FrameData[12] VPWR VGND sg13cmos5l_antennanp
XANTENNA_2473 Tile_X0Y0_FrameData[12] VPWR VGND sg13cmos5l_antennanp
XANTENNA_2484 Tile_X0Y0_FrameData[12] VPWR VGND sg13cmos5l_antennanp
XANTENNA_2495 Tile_X0Y0_FrameData[12] VPWR VGND sg13cmos5l_antennanp
X_0475_ _0475_/Q Tile_X0Y0_FrameData[30] VGND VPWR Tile_X3Y0_FrameStrobe[2] latch
XANTENNA__0687__X Tile_X0Y0_FrameStrobe_O[0] VPWR VGND sg13cmos5l_antennanp
XANTENNA_1761 Tile_X0Y0_FrameData[4] VPWR VGND sg13cmos5l_antennanp
XANTENNA_1772 Tile_X0Y0_FrameData[5] VPWR VGND sg13cmos5l_antennanp
XANTENNA_1783 Tile_X0Y0_FrameData[5] VPWR VGND sg13cmos5l_antennanp
XANTENNA_1794 Tile_X0Y0_FrameData[5] VPWR VGND sg13cmos5l_antennanp
XFILLER_15_0 VPWR VGND sg13cmos5l_decap_8
XFILLER_1_2570 VPWR VGND sg13cmos5l_fill_2
X_1027_ Tile_X4Y0_S1BEG[0] Tile_X4Y0_N1END[3] VPWR VGND sg13cmos5l_buf_1
XFILLER_14_49 VPWR VGND sg13cmos5l_decap_8
XFILLER_13_1719 VPWR VGND sg13cmos5l_decap_8
XFILLER_11_2100 VPWR VGND sg13cmos5l_decap_8
XFILLER_11_2177 VPWR VGND sg13cmos5l_decap_8
XFILLER_11_1421 VPWR VGND sg13cmos5l_fill_2
XFILLER_8_2713 VPWR VGND sg13cmos5l_decap_8
XFILLER_2_2378 VPWR VGND sg13cmos5l_decap_4
XFILLER_2_2389 VPWR VGND sg13cmos5l_fill_1
XANTENNA__0546__Q NPU_WDATA22 VPWR VGND sg13cmos5l_antennanp
XANTENNA_625 Tile_X0Y0_FrameData[23] VPWR VGND sg13cmos5l_antennanp
XANTENNA_614 Tile_X0Y0_FrameData[23] VPWR VGND sg13cmos5l_antennanp
XANTENNA_603 Tile_X0Y0_FrameData[23] VPWR VGND sg13cmos5l_antennanp
XFILLER_2_1688 VPWR VGND sg13cmos5l_decap_8
XANTENNA_669 Tile_X0Y0_FrameData[24] VPWR VGND sg13cmos5l_antennanp
XANTENNA_658 Tile_X0Y0_FrameData[24] VPWR VGND sg13cmos5l_antennanp
XANTENNA_647 Tile_X0Y0_FrameData[23] VPWR VGND sg13cmos5l_antennanp
XANTENNA_636 Tile_X0Y0_FrameData[23] VPWR VGND sg13cmos5l_antennanp
XFILLER_13_534 VPWR VGND sg13cmos5l_decap_8
XFILLER_16_2099 VPWR VGND sg13cmos5l_decap_8
XFILLER_16_1365 VPWR VGND sg13cmos5l_decap_8
XFILLER_5_711 VPWR VGND sg13cmos5l_fill_1
XANTENNA_1002 Tile_X0Y0_FrameData[28] VPWR VGND sg13cmos5l_antennanp
XFILLER_9_1809 VPWR VGND sg13cmos5l_decap_8
XANTENNA_1013 Tile_X0Y0_FrameData[28] VPWR VGND sg13cmos5l_antennanp
XANTENNA_1024 Tile_X0Y0_FrameData[29] VPWR VGND sg13cmos5l_antennanp
XANTENNA_1035 Tile_X0Y0_FrameData[29] VPWR VGND sg13cmos5l_antennanp
XANTENNA_1046 Tile_X0Y0_FrameData[29] VPWR VGND sg13cmos5l_antennanp
XANTENNA_1057 Tile_X0Y0_FrameData[29] VPWR VGND sg13cmos5l_antennanp
XANTENNA_1068 Tile_X0Y0_FrameData[29] VPWR VGND sg13cmos5l_antennanp
XANTENNA_1079 Tile_X0Y0_FrameData[2] VPWR VGND sg13cmos5l_antennanp
X_0260_ _0260_/Q Tile_X0Y0_FrameData[5] VGND VPWR Tile_X1Y0_FrameStrobe[1] latch
X_0191_ _0191_/Q Tile_X0Y0_FrameData[26] VGND VPWR Tile_X0Y0_FrameStrobe[3] latch
XFILLER_14_2707 VPWR VGND sg13cmos5l_decap_8
XANTENNA__0970__X Tile_X1Y0_FrameStrobe_O[15] VPWR VGND sg13cmos5l_antennanp
XFILLER_12_2442 VPWR VGND sg13cmos5l_decap_8
XFILLER_12_1796 VPWR VGND sg13cmos5l_decap_8
XANTENNA_2270 Tile_X0Y0_FrameData[9] VPWR VGND sg13cmos5l_antennanp
X_0527_ NPU_WDATA3 Tile_X0Y0_UserCLK _1099_/X _0625_/L_HI VPWR VGND sg13cmos5l_dfrbpq_1
XANTENNA_2281 Tile_X0Y0_FrameData[9] VPWR VGND sg13cmos5l_antennanp
XANTENNA_2292 Tile_X0Y0_N2END[3] VPWR VGND sg13cmos5l_antennanp
XANTENNA_1580 Tile_X0Y0_FrameData[3] VPWR VGND sg13cmos5l_antennanp
XANTENNA_1591 Tile_X0Y0_FrameData[3] VPWR VGND sg13cmos5l_antennanp
X_0458_ _0458_/Q Tile_X0Y0_FrameData[15] VGND VPWR Tile_X3Y0_FrameStrobe[1] latch
X_0389_ _0389_/Q Tile_X0Y0_FrameData[20] VGND VPWR Tile_X2Y0_FrameStrobe[2] latch
XFILLER_3_2654 VPWR VGND sg13cmos5l_decap_8
XANTENNA__1041__X Tile_X4Y0_S2BEGb[2] VPWR VGND sg13cmos5l_antennanp
XANTENNA__0880__X Tile_X2Y0_S2BEGb[5] VPWR VGND sg13cmos5l_antennanp
XFILLER_13_1516 VPWR VGND sg13cmos5l_decap_8
XFILLER_11_1273 VPWR VGND sg13cmos5l_fill_1
XFILLER_8_1864 VPWR VGND sg13cmos5l_fill_2
XANTENNA_400 Tile_X0Y0_FrameData[22] VPWR VGND sg13cmos5l_antennanp
XFILLER_2_1430 VPWR VGND sg13cmos5l_fill_2
XANTENNA_411 Tile_X0Y0_FrameData[22] VPWR VGND sg13cmos5l_antennanp
XANTENNA_422 Tile_X0Y0_FrameData[22] VPWR VGND sg13cmos5l_antennanp
XANTENNA_433 Tile_X0Y0_FrameData[23] VPWR VGND sg13cmos5l_antennanp
XANTENNA_444 Tile_X0Y0_FrameData[23] VPWR VGND sg13cmos5l_antennanp
XANTENNA_477 Tile_X0Y0_FrameData[23] VPWR VGND sg13cmos5l_antennanp
XANTENNA_466 Tile_X0Y0_FrameData[23] VPWR VGND sg13cmos5l_antennanp
XANTENNA_455 Tile_X0Y0_FrameData[23] VPWR VGND sg13cmos5l_antennanp
XANTENNA_499 Tile_X0Y0_FrameData[23] VPWR VGND sg13cmos5l_antennanp
XANTENNA_488 Tile_X0Y0_FrameData[23] VPWR VGND sg13cmos5l_antennanp
XFILLER_15_70 VPWR VGND sg13cmos5l_decap_8
XANTENNA__0790__X Tile_X3Y0_S4BEG[11] VPWR VGND sg13cmos5l_antennanp
XFILLER_16_1140 VPWR VGND sg13cmos5l_fill_1
XFILLER_16_1184 VPWR VGND sg13cmos5l_decap_8
XFILLER_12_1048 VPWR VGND sg13cmos5l_decap_8
XFILLER_5_585 VPWR VGND sg13cmos5l_decap_8
X_0312_ _0312_/Q Tile_X0Y0_FrameData[17] VGND VPWR Tile_X1Y0_FrameStrobe[3] latch
X_0243_ _0243_/Q Tile_X0Y0_FrameData[22] VGND VPWR Tile_X1Y0_FrameStrobe[1] latch
XFILLER_7_1396 VPWR VGND sg13cmos5l_fill_2
XANTENNA__0965__X Tile_X1Y0_FrameStrobe_O[10] VPWR VGND sg13cmos5l_antennanp
X_0174_ _0174_/Q Tile_X0Y0_FrameData[11] VGND VPWR Tile_X0Y0_FrameStrobe[2] latch
XFILLER_3_1238 VPWR VGND sg13cmos5l_fill_2
XFILLER_14_2526 VPWR VGND sg13cmos5l_decap_8
XFILLER_14_1858 VPWR VGND sg13cmos5l_decap_8
XFILLER_11_28 VPWR VGND sg13cmos5l_decap_8
XFILLER_12_1593 VPWR VGND sg13cmos5l_decap_8
XFILLER_8_1116 VPWR VGND sg13cmos5l_decap_8
XANTENNA__1036__X Tile_X4Y0_S2BEG[5] VPWR VGND sg13cmos5l_antennanp
XFILLER_5_2749 VPWR VGND sg13cmos5l_decap_8
XFILLER_3_2440 VPWR VGND sg13cmos5l_decap_8
XANTENNA__0875__X Tile_X2Y0_S2BEGb[0] VPWR VGND sg13cmos5l_antennanp
XFILLER_3_1761 VPWR VGND sg13cmos5l_decap_8
XFILLER_13_2047 VPWR VGND sg13cmos5l_decap_8
XANTENNA_3707 Tile_X1Y0_N4END[2] VPWR VGND sg13cmos5l_antennanp
XANTENNA_3718 Tile_X1Y0_N4END[3] VPWR VGND sg13cmos5l_antennanp
XANTENNA_3729 Tile_X1Y0_NN4END[0] VPWR VGND sg13cmos5l_antennanp
XFILLER_13_1379 VPWR VGND sg13cmos5l_fill_1
XFILLER_8_2373 VPWR VGND sg13cmos5l_decap_8
XFILLER_2_577 VPWR VGND sg13cmos5l_decap_8
XFILLER_8_1650 VPWR VGND sg13cmos5l_decap_8
XFILLER_4_2248 VPWR VGND sg13cmos5l_decap_8
XANTENNA__0785__X Tile_X3Y0_S4BEG[6] VPWR VGND sg13cmos5l_antennanp
XANTENNA_230 Tile_X0Y0_FrameData[10] VPWR VGND sg13cmos5l_antennanp
XANTENNA_241 Tile_X0Y0_FrameData[10] VPWR VGND sg13cmos5l_antennanp
XANTENNA_252 Tile_X0Y0_FrameData[10] VPWR VGND sg13cmos5l_antennanp
XANTENNA_263 Tile_X0Y0_FrameData[10] VPWR VGND sg13cmos5l_antennanp
XANTENNA_274 Tile_X0Y0_FrameData[10] VPWR VGND sg13cmos5l_antennanp
XANTENNA_285 Tile_X0Y0_FrameData[15] VPWR VGND sg13cmos5l_antennanp
XANTENNA_296 Tile_X0Y0_FrameData[15] VPWR VGND sg13cmos5l_antennanp
X_0930_ Tile_X3Y0_FrameStrobe_O[15] Tile_X3Y0_FrameStrobe[15] VPWR VGND sg13cmos5l_buf_1
XFILLER_14_695 VPWR VGND sg13cmos5l_decap_8
XFILLER_13_161 VPWR VGND sg13cmos5l_decap_8
X_0861_ Tile_X4Y0_FrameStrobe_O[18] Tile_X4Y0_FrameStrobe[18] VPWR VGND sg13cmos5l_buf_1
X_0792_ Tile_X3Y0_S4BEG[13] _1272_/X VPWR VGND sg13cmos5l_buf_1
XFILLER_13_1880 VPWR VGND sg13cmos5l_decap_4
XFILLER_9_2104 VPWR VGND sg13cmos5l_decap_8
X_1275_ _1275_/X Tile_X3Y0_N2END[0] Tile_X3Y0_N4END[0] Tile_X3Y0_NN4END[15] _0579_/Q
+ _0457_/Q _0456_/Q VPWR VGND sg13cmos5l_mux4_1
XFILLER_7_1171 VPWR VGND sg13cmos5l_decap_8
XANTENNA__0695__X Tile_X0Y0_FrameStrobe_O[8] VPWR VGND sg13cmos5l_antennanp
X_0226_ _0226_/Q Tile_X0Y0_FrameData[7] VGND VPWR Tile_X1Y0_FrameStrobe[0] latch
XFILLER_0_2624 VPWR VGND sg13cmos5l_fill_1
XFILLER_0_2668 VPWR VGND sg13cmos5l_decap_4
X_0157_ _0157_/Q Tile_X0Y0_FrameData[28] VGND VPWR Tile_X0Y0_FrameStrobe[2] latch
X_0088_ _0559_/D _0517_/Q _1091_/X VPWR VGND sg13cmos5l_nor2b_1
XFILLER_14_2345 VPWR VGND sg13cmos5l_decap_8
XFILLER_14_1655 VPWR VGND sg13cmos5l_decap_8
XFILLER_9_2682 VPWR VGND sg13cmos5l_decap_8
XFILLER_5_2568 VPWR VGND sg13cmos5l_decap_8
XFILLER_5_2557 VPWR VGND sg13cmos5l_fill_1
XFILLER_3_2292 VPWR VGND sg13cmos5l_decap_8
XANTENNA__0554__Q NPU_WDATA30 VPWR VGND sg13cmos5l_antennanp
XFILLER_11_643 VPWR VGND sg13cmos5l_decap_8
XFILLER_7_658 VPWR VGND sg13cmos5l_decap_8
XFILLER_13_1143 VPWR VGND sg13cmos5l_decap_8
XFILLER_11_698 VPWR VGND sg13cmos5l_decap_8
XFILLER_10_2732 VPWR VGND sg13cmos5l_decap_8
XANTENNA_3504 Tile_X0Y0_FrameData[8] VPWR VGND sg13cmos5l_antennanp
XANTENNA_3515 Tile_X0Y0_FrameData[8] VPWR VGND sg13cmos5l_antennanp
XANTENNA_3526 Tile_X0Y0_FrameData[8] VPWR VGND sg13cmos5l_antennanp
XANTENNA_3537 Tile_X0Y0_FrameData[8] VPWR VGND sg13cmos5l_antennanp
XANTENNA_2803 Tile_X0Y0_FrameData[17] VPWR VGND sg13cmos5l_antennanp
XANTENNA_2814 Tile_X0Y0_FrameData[17] VPWR VGND sg13cmos5l_antennanp
XANTENNA_2825 Tile_X0Y0_FrameData[17] VPWR VGND sg13cmos5l_antennanp
XANTENNA_3548 Tile_X0Y0_FrameData[8] VPWR VGND sg13cmos5l_antennanp
XANTENNA_3559 Tile_X0Y0_FrameData[8] VPWR VGND sg13cmos5l_antennanp
XANTENNA_2836 Tile_X0Y0_FrameData[17] VPWR VGND sg13cmos5l_antennanp
XANTENNA_2847 Tile_X0Y0_FrameData[17] VPWR VGND sg13cmos5l_antennanp
XANTENNA_2858 Tile_X0Y0_FrameData[17] VPWR VGND sg13cmos5l_antennanp
XANTENNA_2869 Tile_X0Y0_FrameData[17] VPWR VGND sg13cmos5l_antennanp
X_1060_ Tile_X4Y0_S4BEG[13] Tile_X4Y0_N4END[2] VPWR VGND sg13cmos5l_buf_1
X_0913_ Tile_X2Y0_SS4BEG[14] _1249_/X VPWR VGND sg13cmos5l_buf_1
XFILLER_15_2654 VPWR VGND sg13cmos5l_decap_8
X_0844_ Tile_X4Y0_FrameStrobe_O[1] Tile_X4Y0_FrameStrobe[1] VPWR VGND sg13cmos5l_buf_1
XFILLER_15_1986 VPWR VGND sg13cmos5l_decap_4
X_0775_ Tile_X3Y0_S2BEGb[4] _1255_/X VPWR VGND sg13cmos5l_buf_1
XFILLER_9_1211 VPWR VGND sg13cmos5l_decap_8
XFILLER_5_1108 VPWR VGND sg13cmos5l_decap_8
X_1258_ _1258_/X Tile_X3Y0_N1END[3] Tile_X3Y0_N2MID[7] Tile_X3Y0_N2END[0] _0579_/Q
+ _0491_/Q _0490_/Q VPWR VGND sg13cmos5l_mux4_1
X_0209_ _0209_/Q Tile_X0Y0_FrameData[24] VGND VPWR Tile_X1Y0_FrameStrobe[0] latch
X_1189_ _1189_/X Tile_X1Y0_N2MID[2] Tile_X1Y0_N4END[5] Tile_X1Y0_NN4END[10] _0590_/Q
+ _0277_/Q _0276_/Q VPWR VGND sg13cmos5l_mux4_1
XFILLER_0_2465 VPWR VGND sg13cmos5l_fill_2
XFILLER_0_1720 VPWR VGND sg13cmos5l_decap_8
XFILLER_16_1728 VPWR VGND sg13cmos5l_decap_4
XFILLER_14_2153 VPWR VGND sg13cmos5l_decap_8
XFILLER_14_1452 VPWR VGND sg13cmos5l_decap_8
XANTENNA_1409 Tile_X0Y0_FrameData[31] VPWR VGND sg13cmos5l_antennanp
XFILLER_5_2354 VPWR VGND sg13cmos5l_decap_8
XFILLER_0_878 VPWR VGND sg13cmos5l_fill_1
XANTENNA__0549__Q NPU_WDATA25 VPWR VGND sg13cmos5l_antennanp
XFILLER_5_1653 VPWR VGND sg13cmos5l_decap_8
XFILLER_16_735 VPWR VGND sg13cmos5l_decap_8
XFILLER_8_912 VPWR VGND sg13cmos5l_fill_2
XFILLER_15_1249 VPWR VGND sg13cmos5l_decap_8
XANTENNA_4002 Tile_X0Y0_FrameData[18] VPWR VGND sg13cmos5l_antennanp
XANTENNA_4013 Tile_X0Y0_FrameData[18] VPWR VGND sg13cmos5l_antennanp
XFILLER_7_455 VPWR VGND sg13cmos5l_fill_2
XANTENNA_3301 Tile_X0Y0_FrameData[20] VPWR VGND sg13cmos5l_antennanp
XANTENNA_3312 Tile_X0Y0_FrameData[20] VPWR VGND sg13cmos5l_antennanp
XANTENNA_4024 Tile_X0Y0_N2END[1] VPWR VGND sg13cmos5l_antennanp
XANTENNA_4035 Tile_X0Y0_N2END[4] VPWR VGND sg13cmos5l_antennanp
XANTENNA_4046 Tile_X0Y0_N2END[5] VPWR VGND sg13cmos5l_antennanp
XANTENNA_4057 Tile_X0Y0_N4END[3] VPWR VGND sg13cmos5l_antennanp
XANTENNA_2600 Tile_X0Y0_FrameData[13] VPWR VGND sg13cmos5l_antennanp
XANTENNA_3323 Tile_X0Y0_FrameData[20] VPWR VGND sg13cmos5l_antennanp
XANTENNA_3334 Tile_X0Y0_FrameData[20] VPWR VGND sg13cmos5l_antennanp
XANTENNA_3345 Tile_X0Y0_FrameData[20] VPWR VGND sg13cmos5l_antennanp
XANTENNA_4068 Tile_X0Y0_NN4END[2] VPWR VGND sg13cmos5l_antennanp
XANTENNA_4079 Tile_X1Y0_N2END[4] VPWR VGND sg13cmos5l_antennanp
X_0560_ NPU_WE4 Tile_X0Y0_UserCLK _0560_/D _0667_/L_HI VPWR VGND sg13cmos5l_dfrbpq_1
XANTENNA_2611 Tile_X0Y0_FrameData[14] VPWR VGND sg13cmos5l_antennanp
XANTENNA_2622 Tile_X0Y0_FrameData[14] VPWR VGND sg13cmos5l_antennanp
XANTENNA_2633 Tile_X0Y0_FrameData[14] VPWR VGND sg13cmos5l_antennanp
XANTENNA_2644 Tile_X0Y0_FrameData[14] VPWR VGND sg13cmos5l_antennanp
XANTENNA_3356 Tile_X0Y0_FrameData[20] VPWR VGND sg13cmos5l_antennanp
XANTENNA_3367 Tile_X0Y0_FrameData[20] VPWR VGND sg13cmos5l_antennanp
XANTENNA_3378 Tile_X0Y0_FrameData[21] VPWR VGND sg13cmos5l_antennanp
X_0491_ _0491_/Q Tile_X0Y0_FrameData[14] VGND VPWR Tile_X3Y0_FrameStrobe[2] latch
XANTENNA_1910 Tile_X0Y0_FrameData[5] VPWR VGND sg13cmos5l_antennanp
XANTENNA_1921 Tile_X0Y0_FrameData[5] VPWR VGND sg13cmos5l_antennanp
XANTENNA_1932 Tile_X0Y0_FrameData[5] VPWR VGND sg13cmos5l_antennanp
XANTENNA_2655 Tile_X0Y0_FrameData[14] VPWR VGND sg13cmos5l_antennanp
XANTENNA_2666 Tile_X0Y0_FrameData[14] VPWR VGND sg13cmos5l_antennanp
XANTENNA_2677 Tile_X0Y0_FrameData[14] VPWR VGND sg13cmos5l_antennanp
XANTENNA_3389 Tile_X0Y0_FrameData[21] VPWR VGND sg13cmos5l_antennanp
XFILLER_3_694 VPWR VGND sg13cmos5l_fill_1
XANTENNA_1943 Tile_X0Y0_FrameData[6] VPWR VGND sg13cmos5l_antennanp
XANTENNA_1954 Tile_X0Y0_FrameData[6] VPWR VGND sg13cmos5l_antennanp
XANTENNA_1965 Tile_X0Y0_FrameData[6] VPWR VGND sg13cmos5l_antennanp
XANTENNA_2688 Tile_X0Y0_FrameData[14] VPWR VGND sg13cmos5l_antennanp
XANTENNA_2699 Tile_X0Y0_FrameData[14] VPWR VGND sg13cmos5l_antennanp
XANTENNA_1976 Tile_X0Y0_FrameData[6] VPWR VGND sg13cmos5l_antennanp
XANTENNA_1987 Tile_X0Y0_FrameData[6] VPWR VGND sg13cmos5l_antennanp
XANTENNA_1998 Tile_X0Y0_FrameData[6] VPWR VGND sg13cmos5l_antennanp
X_1112_ _1112_/X Tile_X0Y0_N4END[0] Tile_X0Y0_N4END[1] Tile_X0Y0_NN4END[0] Tile_X0Y0_NN4END[2]
+ _0121_/Q _0120_/Q VPWR VGND sg13cmos5l_mux4_1
XFILLER_1_2741 VPWR VGND sg13cmos5l_decap_8
X_1043_ Tile_X4Y0_S2BEGb[4] Tile_X4Y0_N2END[3] VPWR VGND sg13cmos5l_buf_1
XFILLER_1_2752 VPWR VGND sg13cmos5l_fill_1
XANTENNA__0973__X Tile_X1Y0_FrameStrobe_O[18] VPWR VGND sg13cmos5l_antennanp
XFILLER_15_790 VPWR VGND sg13cmos5l_decap_8
XFILLER_15_2440 VPWR VGND sg13cmos5l_decap_8
XFILLER_11_2359 VPWR VGND sg13cmos5l_decap_8
X_0827_ Tile_X4Y0_FrameData_O[16] Tile_X0Y0_FrameData[16] VPWR VGND sg13cmos5l_buf_1
XFILLER_15_1794 VPWR VGND sg13cmos5l_decap_8
X_0758_ Tile_X1Y0_S2BEG[7] Tile_X1Y0_N2MID[0] VPWR VGND sg13cmos5l_buf_1
XFILLER_11_1669 VPWR VGND sg13cmos5l_decap_8
XANTENNA_3890 Tile_X0Y0_FrameData[18] VPWR VGND sg13cmos5l_antennanp
X_0689_ Tile_X0Y0_FrameStrobe_O[2] Tile_X0Y0_FrameStrobe[2] VPWR VGND sg13cmos5l_buf_1
XFILLER_6_2641 VPWR VGND sg13cmos5l_decap_8
XANTENNA__1044__X Tile_X4Y0_S2BEGb[5] VPWR VGND sg13cmos5l_antennanp
XFILLER_2_2549 VPWR VGND sg13cmos5l_decap_8
XANTENNA__0883__X Tile_X2Y0_S4BEG[0] VPWR VGND sg13cmos5l_antennanp
XANTENNA_818 Tile_X0Y0_FrameData[27] VPWR VGND sg13cmos5l_antennanp
XANTENNA_807 Tile_X0Y0_FrameData[27] VPWR VGND sg13cmos5l_antennanp
XANTENNA_829 Tile_X0Y0_FrameData[27] VPWR VGND sg13cmos5l_antennanp
XFILLER_0_2295 VPWR VGND sg13cmos5l_decap_8
XFILLER_13_727 VPWR VGND sg13cmos5l_decap_8
XFILLER_16_1514 VPWR VGND sg13cmos5l_decap_8
XFILLER_8_219 VPWR VGND sg13cmos5l_fill_2
XFILLER_14_1293 VPWR VGND sg13cmos5l_decap_8
XFILLER_10_1168 VPWR VGND sg13cmos5l_fill_2
XANTENNA_1206 Tile_X0Y0_FrameData[30] VPWR VGND sg13cmos5l_antennanp
XANTENNA_1217 Tile_X0Y0_FrameData[30] VPWR VGND sg13cmos5l_antennanp
XANTENNA_1228 Tile_X0Y0_FrameData[30] VPWR VGND sg13cmos5l_antennanp
XANTENNA_1239 Tile_X0Y0_FrameData[30] VPWR VGND sg13cmos5l_antennanp
XFILLER_7_1715 VPWR VGND sg13cmos5l_decap_8
XFILLER_1_2015 VPWR VGND sg13cmos5l_fill_2
XANTENNA__0793__X Tile_X3Y0_S4BEG[14] VPWR VGND sg13cmos5l_antennanp
XFILLER_16_543 VPWR VGND sg13cmos5l_decap_8
XFILLER_12_2668 VPWR VGND sg13cmos5l_decap_8
XFILLER_8_786 VPWR VGND sg13cmos5l_fill_1
XANTENNA_3120 Tile_X0Y0_FrameData[19] VPWR VGND sg13cmos5l_antennanp
X_0612_ _0612_/L_HI VPWR VGND sg13cmos5l_tiehi
XANTENNA_3131 Tile_X0Y0_FrameData[19] VPWR VGND sg13cmos5l_antennanp
XANTENNA_3142 Tile_X0Y0_FrameData[19] VPWR VGND sg13cmos5l_antennanp
XANTENNA_3153 Tile_X0Y0_FrameData[19] VPWR VGND sg13cmos5l_antennanp
XANTENNA__0968__X Tile_X1Y0_FrameStrobe_O[13] VPWR VGND sg13cmos5l_antennanp
XANTENNA_2430 Tile_X0Y0_FrameData[12] VPWR VGND sg13cmos5l_antennanp
XANTENNA_2441 Tile_X0Y0_FrameData[12] VPWR VGND sg13cmos5l_antennanp
XANTENNA_2452 Tile_X0Y0_FrameData[12] VPWR VGND sg13cmos5l_antennanp
XANTENNA_3164 Tile_X0Y0_FrameData[19] VPWR VGND sg13cmos5l_antennanp
XANTENNA_3175 Tile_X0Y0_FrameData[19] VPWR VGND sg13cmos5l_antennanp
XANTENNA_3186 Tile_X0Y0_FrameData[20] VPWR VGND sg13cmos5l_antennanp
XANTENNA_3197 Tile_X0Y0_FrameData[20] VPWR VGND sg13cmos5l_antennanp
X_0543_ NPU_WDATA19 Tile_X0Y0_UserCLK _1115_/X _0684_/L_HI VPWR VGND sg13cmos5l_dfrbpq_1
XANTENNA_1740 Tile_X0Y0_FrameData[4] VPWR VGND sg13cmos5l_antennanp
XANTENNA_2463 Tile_X0Y0_FrameData[12] VPWR VGND sg13cmos5l_antennanp
XANTENNA_2474 Tile_X0Y0_FrameData[12] VPWR VGND sg13cmos5l_antennanp
XANTENNA_2485 Tile_X0Y0_FrameData[12] VPWR VGND sg13cmos5l_antennanp
X_0474_ _0474_/Q Tile_X0Y0_FrameData[31] VGND VPWR Tile_X3Y0_FrameStrobe[2] latch
XANTENNA_1751 Tile_X0Y0_FrameData[4] VPWR VGND sg13cmos5l_antennanp
XANTENNA_1762 Tile_X0Y0_FrameData[4] VPWR VGND sg13cmos5l_antennanp
XANTENNA_1773 Tile_X0Y0_FrameData[5] VPWR VGND sg13cmos5l_antennanp
XANTENNA_1784 Tile_X0Y0_FrameData[5] VPWR VGND sg13cmos5l_antennanp
XANTENNA_2496 Tile_X0Y0_FrameData[12] VPWR VGND sg13cmos5l_antennanp
XANTENNA_1795 Tile_X0Y0_FrameData[5] VPWR VGND sg13cmos5l_antennanp
X_1026_ Tile_X0Y0_S1BEG[3] Tile_X0Y0_N1END[0] VPWR VGND sg13cmos5l_buf_1
XFILLER_14_28 VPWR VGND sg13cmos5l_decap_8
XFILLER_15_1591 VPWR VGND sg13cmos5l_decap_8
XFILLER_11_2156 VPWR VGND sg13cmos5l_decap_8
XANTENNA__1039__X Tile_X4Y0_S2BEGb[0] VPWR VGND sg13cmos5l_antennanp
XANTENNA__0878__X Tile_X2Y0_S2BEGb[3] VPWR VGND sg13cmos5l_antennanp
XFILLER_8_2769 VPWR VGND sg13cmos5l_decap_4
XFILLER_6_1792 VPWR VGND sg13cmos5l_fill_1
XFILLER_2_2357 VPWR VGND sg13cmos5l_decap_8
XFILLER_2_1667 VPWR VGND sg13cmos5l_decap_8
XANTENNA_626 Tile_X0Y0_FrameData[23] VPWR VGND sg13cmos5l_antennanp
XANTENNA_615 Tile_X0Y0_FrameData[23] VPWR VGND sg13cmos5l_antennanp
XANTENNA_604 Tile_X0Y0_FrameData[23] VPWR VGND sg13cmos5l_antennanp
XFILLER_0_2092 VPWR VGND sg13cmos5l_fill_2
XANTENNA_659 Tile_X0Y0_FrameData[24] VPWR VGND sg13cmos5l_antennanp
XANTENNA_648 Tile_X0Y0_FrameData[23] VPWR VGND sg13cmos5l_antennanp
XANTENNA_637 Tile_X0Y0_FrameData[23] VPWR VGND sg13cmos5l_antennanp
XFILLER_13_513 VPWR VGND sg13cmos5l_decap_8
XFILLER_9_506 VPWR VGND sg13cmos5l_fill_2
XFILLER_9_539 VPWR VGND sg13cmos5l_decap_8
XFILLER_16_2078 VPWR VGND sg13cmos5l_decap_8
XFILLER_16_1344 VPWR VGND sg13cmos5l_decap_8
XANTENNA__0562__Q NPU_WE6 VPWR VGND sg13cmos5l_antennanp
XFILLER_5_734 VPWR VGND sg13cmos5l_fill_2
XANTENNA_1003 Tile_X0Y0_FrameData[28] VPWR VGND sg13cmos5l_antennanp
XANTENNA__0788__X Tile_X3Y0_S4BEG[9] VPWR VGND sg13cmos5l_antennanp
XANTENNA_1014 Tile_X0Y0_FrameData[28] VPWR VGND sg13cmos5l_antennanp
XANTENNA_1025 Tile_X0Y0_FrameData[29] VPWR VGND sg13cmos5l_antennanp
XANTENNA_1036 Tile_X0Y0_FrameData[29] VPWR VGND sg13cmos5l_antennanp
XFILLER_7_2235 VPWR VGND sg13cmos5l_fill_2
XFILLER_1_951 VPWR VGND sg13cmos5l_fill_2
XFILLER_1_940 VPWR VGND sg13cmos5l_fill_1
XANTENNA_1047 Tile_X0Y0_FrameData[29] VPWR VGND sg13cmos5l_antennanp
XANTENNA_1058 Tile_X0Y0_FrameData[29] VPWR VGND sg13cmos5l_antennanp
XANTENNA_1069 Tile_X0Y0_FrameData[29] VPWR VGND sg13cmos5l_antennanp
XFILLER_0_472 VPWR VGND sg13cmos5l_fill_1
X_0190_ _0190_/Q Tile_X0Y0_FrameData[27] VGND VPWR Tile_X0Y0_FrameStrobe[3] latch
XFILLER_7_1589 VPWR VGND sg13cmos5l_decap_8
XFILLER_1_1199 VPWR VGND sg13cmos5l_fill_2
XFILLER_12_2421 VPWR VGND sg13cmos5l_decap_8
XFILLER_12_2498 VPWR VGND sg13cmos5l_decap_8
XFILLER_12_1775 VPWR VGND sg13cmos5l_decap_8
XFILLER_6_84 VPWR VGND sg13cmos5l_decap_8
XANTENNA__0698__X Tile_X0Y0_FrameStrobe_O[11] VPWR VGND sg13cmos5l_antennanp
XANTENNA_2260 Tile_X0Y0_FrameData[9] VPWR VGND sg13cmos5l_antennanp
X_0526_ NPU_WDATA2 Tile_X0Y0_UserCLK _1098_/X _0626_/L_HI VPWR VGND sg13cmos5l_dfrbpq_1
XANTENNA_2271 Tile_X0Y0_FrameData[9] VPWR VGND sg13cmos5l_antennanp
XANTENNA_2282 Tile_X0Y0_FrameData[9] VPWR VGND sg13cmos5l_antennanp
XANTENNA_2293 Tile_X0Y0_N2END[3] VPWR VGND sg13cmos5l_antennanp
XFILLER_6_1011 VPWR VGND sg13cmos5l_fill_1
XANTENNA_1570 Tile_X0Y0_FrameData[3] VPWR VGND sg13cmos5l_antennanp
XANTENNA_1581 Tile_X0Y0_FrameData[3] VPWR VGND sg13cmos5l_antennanp
XANTENNA_1592 Tile_X0Y0_FrameData[3] VPWR VGND sg13cmos5l_antennanp
X_0457_ _0457_/Q Tile_X0Y0_FrameData[16] VGND VPWR Tile_X3Y0_FrameStrobe[1] latch
XFILLER_3_2633 VPWR VGND sg13cmos5l_decap_8
X_0388_ _0388_/Q Tile_X0Y0_FrameData[21] VGND VPWR Tile_X2Y0_FrameStrobe[2] latch
XFILLER_6_1099 VPWR VGND sg13cmos5l_decap_8
X_1009_ Tile_X0Y0_S2BEGb[2] _1133_/X VPWR VGND sg13cmos5l_buf_1
XFILLER_13_2229 VPWR VGND sg13cmos5l_decap_8
XFILLER_11_1252 VPWR VGND sg13cmos5l_decap_8
XFILLER_4_2419 VPWR VGND sg13cmos5l_fill_1
XANTENNA__0557__Q NPU_WE1 VPWR VGND sg13cmos5l_antennanp
XANTENNA_401 Tile_X0Y0_FrameData[22] VPWR VGND sg13cmos5l_antennanp
XANTENNA_412 Tile_X0Y0_FrameData[22] VPWR VGND sg13cmos5l_antennanp
XANTENNA_423 Tile_X0Y0_FrameData[22] VPWR VGND sg13cmos5l_antennanp
XANTENNA_434 Tile_X0Y0_FrameData[23] VPWR VGND sg13cmos5l_antennanp
XANTENNA_445 Tile_X0Y0_FrameData[23] VPWR VGND sg13cmos5l_antennanp
XFILLER_14_800 VPWR VGND sg13cmos5l_decap_8
XANTENNA_467 Tile_X0Y0_FrameData[23] VPWR VGND sg13cmos5l_antennanp
XANTENNA_456 Tile_X0Y0_FrameData[23] VPWR VGND sg13cmos5l_antennanp
XANTENNA_489 Tile_X0Y0_FrameData[23] VPWR VGND sg13cmos5l_antennanp
XANTENNA_478 Tile_X0Y0_FrameData[23] VPWR VGND sg13cmos5l_antennanp
XFILLER_13_2741 VPWR VGND sg13cmos5l_decap_8
XFILLER_13_2752 VPWR VGND sg13cmos5l_fill_2
XFILLER_13_2796 VPWR VGND sg13cmos5l_fill_1
XFILLER_5_564 VPWR VGND sg13cmos5l_decap_8
XFILLER_9_1618 VPWR VGND sg13cmos5l_fill_2
X_0311_ _0311_/Q Tile_X0Y0_FrameData[18] VGND VPWR Tile_X1Y0_FrameStrobe[3] latch
X_0242_ _0242_/Q Tile_X0Y0_FrameData[23] VGND VPWR Tile_X1Y0_FrameStrobe[1] latch
X_0173_ _0173_/Q Tile_X0Y0_FrameData[12] VGND VPWR Tile_X0Y0_FrameStrobe[2] latch
XANTENNA__0981__X Tile_X0Y0_SS4BEG[6] VPWR VGND sg13cmos5l_antennanp
XFILLER_16_192 VPWR VGND sg13cmos5l_decap_8
XANTENNA_990 Tile_X0Y0_FrameData[28] VPWR VGND sg13cmos5l_antennanp
XFILLER_14_2505 VPWR VGND sg13cmos5l_decap_8
XFILLER_14_1837 VPWR VGND sg13cmos5l_decap_8
XFILLER_12_2295 VPWR VGND sg13cmos5l_decap_8
XFILLER_12_1572 VPWR VGND sg13cmos5l_decap_8
XFILLER_5_2728 VPWR VGND sg13cmos5l_decap_8
XANTENNA_2090 Tile_X0Y0_FrameData[6] VPWR VGND sg13cmos5l_antennanp
X_0509_ _0509_/Q Tile_X0Y0_FrameData[28] VGND VPWR Tile_X4Y0_FrameStrobe[0] latch
XFILLER_3_1740 VPWR VGND sg13cmos5l_decap_8
XANTENNA__1052__X Tile_X4Y0_S4BEG[5] VPWR VGND sg13cmos5l_antennanp
XANTENNA__0891__X Tile_X2Y0_S4BEG[8] VPWR VGND sg13cmos5l_antennanp
XFILLER_13_1358 VPWR VGND sg13cmos5l_fill_2
XANTENNA_3708 Tile_X1Y0_N4END[2] VPWR VGND sg13cmos5l_antennanp
XANTENNA_3719 Tile_X1Y0_N4END[3] VPWR VGND sg13cmos5l_antennanp
XFILLER_11_1060 VPWR VGND sg13cmos5l_fill_2
XFILLER_2_556 VPWR VGND sg13cmos5l_decap_8
XFILLER_8_2352 VPWR VGND sg13cmos5l_decap_8
XFILLER_4_2227 VPWR VGND sg13cmos5l_decap_8
XANTENNA_220 Tile_X0Y0_FrameData[10] VPWR VGND sg13cmos5l_antennanp
XANTENNA_231 Tile_X0Y0_FrameData[10] VPWR VGND sg13cmos5l_antennanp
XANTENNA_242 Tile_X0Y0_FrameData[10] VPWR VGND sg13cmos5l_antennanp
XANTENNA_253 Tile_X0Y0_FrameData[10] VPWR VGND sg13cmos5l_antennanp
XANTENNA_264 Tile_X0Y0_FrameData[10] VPWR VGND sg13cmos5l_antennanp
XANTENNA_275 Tile_X0Y0_FrameData[10] VPWR VGND sg13cmos5l_antennanp
XANTENNA_286 Tile_X0Y0_FrameData[15] VPWR VGND sg13cmos5l_antennanp
XANTENNA_297 Tile_X0Y0_FrameData[1] VPWR VGND sg13cmos5l_antennanp
XFILLER_14_674 VPWR VGND sg13cmos5l_decap_8
XFILLER_13_140 VPWR VGND sg13cmos5l_decap_8
XFILLER_9_133 VPWR VGND sg13cmos5l_decap_8
X_0860_ Tile_X4Y0_FrameStrobe_O[17] Tile_X4Y0_FrameStrobe[17] VPWR VGND sg13cmos5l_buf_1
X_0791_ Tile_X3Y0_S4BEG[12] _1271_/X VPWR VGND sg13cmos5l_buf_1
XFILLER_3_63 VPWR VGND sg13cmos5l_decap_8
XANTENNA__0976__X Tile_X0Y0_SS4BEG[1] VPWR VGND sg13cmos5l_antennanp
X_1274_ _1274_/X Tile_X3Y0_N2MID[7] Tile_X3Y0_N4END[0] Tile_X3Y0_NN4END[15] _0573_/Q
+ _0459_/Q _0458_/Q VPWR VGND sg13cmos5l_mux4_1
XFILLER_7_1150 VPWR VGND sg13cmos5l_decap_8
X_0225_ _0225_/Q Tile_X0Y0_FrameData[8] VGND VPWR Tile_X1Y0_FrameStrobe[0] latch
X_0156_ _0156_/Q Tile_X0Y0_FrameData[29] VGND VPWR Tile_X0Y0_FrameStrobe[2] latch
XFILLER_0_1946 VPWR VGND sg13cmos5l_fill_1
X_0087_ _0562_/D _0514_/Q _1094_/X VPWR VGND sg13cmos5l_nor2b_1
XFILLER_14_2324 VPWR VGND sg13cmos5l_decap_8
XFILLER_14_1634 VPWR VGND sg13cmos5l_decap_8
X_0989_ Tile_X0Y0_SS4BEG[14] _1169_/X VPWR VGND sg13cmos5l_buf_1
XFILLER_12_2092 VPWR VGND sg13cmos5l_decap_8
XANTENNA__1047__X Tile_X4Y0_S4BEG[0] VPWR VGND sg13cmos5l_antennanp
XFILLER_9_2661 VPWR VGND sg13cmos5l_decap_8
XFILLER_5_2536 VPWR VGND sg13cmos5l_decap_8
XANTENNA__0886__X Tile_X2Y0_S4BEG[3] VPWR VGND sg13cmos5l_antennanp
XFILLER_3_2271 VPWR VGND sg13cmos5l_decap_8
XFILLER_15_449 VPWR VGND sg13cmos5l_decap_4
XFILLER_11_622 VPWR VGND sg13cmos5l_decap_8
XFILLER_7_637 VPWR VGND sg13cmos5l_decap_8
XFILLER_13_1122 VPWR VGND sg13cmos5l_decap_8
XFILLER_11_677 VPWR VGND sg13cmos5l_fill_2
XFILLER_10_2711 VPWR VGND sg13cmos5l_decap_8
XFILLER_10_165 VPWR VGND sg13cmos5l_fill_1
XFILLER_10_154 VPWR VGND sg13cmos5l_decap_4
XANTENNA__0570__Q NPU_ADDR6 VPWR VGND sg13cmos5l_antennanp
XANTENNA_3505 Tile_X0Y0_FrameData[8] VPWR VGND sg13cmos5l_antennanp
XANTENNA_3516 Tile_X0Y0_FrameData[8] VPWR VGND sg13cmos5l_antennanp
XANTENNA_3527 Tile_X0Y0_FrameData[8] VPWR VGND sg13cmos5l_antennanp
XFILLER_13_1199 VPWR VGND sg13cmos5l_decap_8
XANTENNA_2804 Tile_X0Y0_FrameData[17] VPWR VGND sg13cmos5l_antennanp
XANTENNA_2815 Tile_X0Y0_FrameData[17] VPWR VGND sg13cmos5l_antennanp
XANTENNA_2826 Tile_X0Y0_FrameData[17] VPWR VGND sg13cmos5l_antennanp
XANTENNA_3538 Tile_X0Y0_FrameData[8] VPWR VGND sg13cmos5l_antennanp
XANTENNA_3549 Tile_X0Y0_FrameData[8] VPWR VGND sg13cmos5l_antennanp
XFILLER_5_0 VPWR VGND sg13cmos5l_decap_8
XANTENNA_2837 Tile_X0Y0_FrameData[17] VPWR VGND sg13cmos5l_antennanp
XANTENNA_2848 Tile_X0Y0_FrameData[17] VPWR VGND sg13cmos5l_antennanp
XANTENNA_2859 Tile_X0Y0_FrameData[17] VPWR VGND sg13cmos5l_antennanp
XFILLER_8_2182 VPWR VGND sg13cmos5l_decap_8
XANTENNA__0796__X Tile_X3Y0_SS4BEG[1] VPWR VGND sg13cmos5l_antennanp
XFILLER_4_1389 VPWR VGND sg13cmos5l_fill_2
XFILLER_15_961 VPWR VGND sg13cmos5l_fill_2
XFILLER_15_2633 VPWR VGND sg13cmos5l_decap_8
X_0912_ Tile_X2Y0_SS4BEG[13] _1248_/X VPWR VGND sg13cmos5l_buf_1
X_0843_ Tile_X4Y0_FrameStrobe_O[0] Tile_X4Y0_FrameStrobe[0] VPWR VGND sg13cmos5l_buf_1
XFILLER_15_1965 VPWR VGND sg13cmos5l_decap_8
X_0774_ Tile_X3Y0_S2BEGb[3] _1254_/X VPWR VGND sg13cmos5l_buf_1
XFILLER_6_670 VPWR VGND sg13cmos5l_decap_4
X_1257_ _1257_/X Tile_X3Y0_N1END[2] Tile_X3Y0_N2MID[6] Tile_X3Y0_N2END[1] _0578_/Q
+ _0493_/Q _0492_/Q VPWR VGND sg13cmos5l_mux4_1
XFILLER_4_2591 VPWR VGND sg13cmos5l_decap_8
X_0208_ _0208_/Q Tile_X0Y0_FrameData[25] VGND VPWR Tile_X1Y0_FrameStrobe[0] latch
X_1188_ _1188_/X Tile_X1Y0_N2MID[1] Tile_X1Y0_N4END[6] Tile_X1Y0_NN4END[9] _0591_/Q
+ _0279_/Q _0278_/Q VPWR VGND sg13cmos5l_mux4_1
XFILLER_0_2444 VPWR VGND sg13cmos5l_decap_8
X_0139_ _0139_/Q Tile_X0Y0_FrameData[14] VGND VPWR Tile_X0Y0_FrameStrobe[1] latch
XFILLER_0_2499 VPWR VGND sg13cmos5l_fill_1
XFILLER_0_2477 VPWR VGND sg13cmos5l_decap_4
XFILLER_16_1707 VPWR VGND sg13cmos5l_decap_8
XFILLER_14_2132 VPWR VGND sg13cmos5l_decap_8
XFILLER_14_1431 VPWR VGND sg13cmos5l_decap_8
XFILLER_14_1420 VPWR VGND sg13cmos5l_decap_8
XFILLER_4_618 VPWR VGND sg13cmos5l_decap_8
XFILLER_7_2609 VPWR VGND sg13cmos5l_decap_8
XFILLER_9_2491 VPWR VGND sg13cmos5l_decap_8
XFILLER_5_2333 VPWR VGND sg13cmos5l_decap_8
XFILLER_5_1632 VPWR VGND sg13cmos5l_decap_8
XFILLER_16_714 VPWR VGND sg13cmos5l_decap_8
XANTENNA__0565__Q NPU_ADDR1 VPWR VGND sg13cmos5l_antennanp
XFILLER_15_1228 VPWR VGND sg13cmos5l_decap_8
XFILLER_11_430 VPWR VGND sg13cmos5l_fill_1
XANTENNA_4003 Tile_X0Y0_FrameData[18] VPWR VGND sg13cmos5l_antennanp
XANTENNA_4014 Tile_X0Y0_FrameData[18] VPWR VGND sg13cmos5l_antennanp
XFILLER_11_496 VPWR VGND sg13cmos5l_decap_8
XANTENNA_3302 Tile_X0Y0_FrameData[20] VPWR VGND sg13cmos5l_antennanp
XANTENNA_4025 Tile_X0Y0_N2END[1] VPWR VGND sg13cmos5l_antennanp
XANTENNA_4036 Tile_X0Y0_N2END[4] VPWR VGND sg13cmos5l_antennanp
XANTENNA_4047 Tile_X0Y0_N2END[5] VPWR VGND sg13cmos5l_antennanp
XANTENNA_2601 Tile_X0Y0_FrameData[13] VPWR VGND sg13cmos5l_antennanp
XANTENNA_3313 Tile_X0Y0_FrameData[20] VPWR VGND sg13cmos5l_antennanp
XANTENNA_3324 Tile_X0Y0_FrameData[20] VPWR VGND sg13cmos5l_antennanp
XANTENNA_3335 Tile_X0Y0_FrameData[20] VPWR VGND sg13cmos5l_antennanp
XANTENNA_3346 Tile_X0Y0_FrameData[20] VPWR VGND sg13cmos5l_antennanp
XANTENNA_4058 Tile_X0Y0_N4END[3] VPWR VGND sg13cmos5l_antennanp
XANTENNA_4069 Tile_X0Y0_NN4END[2] VPWR VGND sg13cmos5l_antennanp
XANTENNA_2612 Tile_X0Y0_FrameData[14] VPWR VGND sg13cmos5l_antennanp
XANTENNA_2623 Tile_X0Y0_FrameData[14] VPWR VGND sg13cmos5l_antennanp
XANTENNA_2634 Tile_X0Y0_FrameData[14] VPWR VGND sg13cmos5l_antennanp
XANTENNA_3357 Tile_X0Y0_FrameData[20] VPWR VGND sg13cmos5l_antennanp
XANTENNA_3368 Tile_X0Y0_FrameData[20] VPWR VGND sg13cmos5l_antennanp
XANTENNA_3379 Tile_X0Y0_FrameData[21] VPWR VGND sg13cmos5l_antennanp
X_0490_ _0490_/Q Tile_X0Y0_FrameData[15] VGND VPWR Tile_X3Y0_FrameStrobe[2] latch
XANTENNA_1900 Tile_X0Y0_FrameData[5] VPWR VGND sg13cmos5l_antennanp
XANTENNA_1911 Tile_X0Y0_FrameData[5] VPWR VGND sg13cmos5l_antennanp
XANTENNA_1922 Tile_X0Y0_FrameData[5] VPWR VGND sg13cmos5l_antennanp
XANTENNA_1933 Tile_X0Y0_FrameData[5] VPWR VGND sg13cmos5l_antennanp
XANTENNA_2645 Tile_X0Y0_FrameData[14] VPWR VGND sg13cmos5l_antennanp
XANTENNA_2656 Tile_X0Y0_FrameData[14] VPWR VGND sg13cmos5l_antennanp
XANTENNA_2667 Tile_X0Y0_FrameData[14] VPWR VGND sg13cmos5l_antennanp
XANTENNA_1944 Tile_X0Y0_FrameData[6] VPWR VGND sg13cmos5l_antennanp
XANTENNA_1955 Tile_X0Y0_FrameData[6] VPWR VGND sg13cmos5l_antennanp
XANTENNA_1966 Tile_X0Y0_FrameData[6] VPWR VGND sg13cmos5l_antennanp
XANTENNA_2678 Tile_X0Y0_FrameData[14] VPWR VGND sg13cmos5l_antennanp
XANTENNA_2689 Tile_X0Y0_FrameData[14] VPWR VGND sg13cmos5l_antennanp
XANTENNA_1977 Tile_X0Y0_FrameData[6] VPWR VGND sg13cmos5l_antennanp
XANTENNA_1988 Tile_X0Y0_FrameData[6] VPWR VGND sg13cmos5l_antennanp
XANTENNA_1999 Tile_X0Y0_FrameData[6] VPWR VGND sg13cmos5l_antennanp
X_1111_ _1111_/X Tile_X1Y0_N4END[12] Tile_X1Y0_N4END[15] Tile_X1Y0_NN4END[13] Tile_X1Y0_NN4END[15]
+ _0203_/Q _0314_/Q VPWR VGND sg13cmos5l_mux4_1
XFILLER_1_2720 VPWR VGND sg13cmos5l_decap_8
X_1042_ Tile_X4Y0_S2BEGb[3] Tile_X4Y0_N2END[4] VPWR VGND sg13cmos5l_buf_1
XFILLER_4_1175 VPWR VGND sg13cmos5l_decap_8
XFILLER_0_42 VPWR VGND sg13cmos5l_decap_4
XFILLER_1_2797 VPWR VGND sg13cmos5l_fill_2
XFILLER_0_1028 VPWR VGND sg13cmos5l_fill_1
XFILLER_9_84 VPWR VGND sg13cmos5l_decap_8
XFILLER_15_2496 VPWR VGND sg13cmos5l_decap_8
XFILLER_15_1773 VPWR VGND sg13cmos5l_decap_8
XFILLER_11_2338 VPWR VGND sg13cmos5l_decap_8
X_0826_ Tile_X4Y0_FrameData_O[15] Tile_X0Y0_FrameData[15] VPWR VGND sg13cmos5l_buf_1
XFILLER_11_1648 VPWR VGND sg13cmos5l_decap_8
X_0757_ Tile_X1Y0_S2BEG[6] Tile_X1Y0_N2MID[1] VPWR VGND sg13cmos5l_buf_1
XANTENNA_3880 Tile_X0Y0_FrameData[18] VPWR VGND sg13cmos5l_antennanp
XANTENNA_3891 Tile_X0Y0_FrameData[18] VPWR VGND sg13cmos5l_antennanp
X_0688_ Tile_X0Y0_FrameStrobe_O[1] Tile_X0Y0_FrameStrobe[1] VPWR VGND sg13cmos5l_buf_1
XFILLER_6_2620 VPWR VGND sg13cmos5l_decap_8
XFILLER_9_1086 VPWR VGND sg13cmos5l_decap_8
XFILLER_6_2697 VPWR VGND sg13cmos5l_decap_8
XFILLER_2_2528 VPWR VGND sg13cmos5l_decap_8
XANTENNA_808 Tile_X0Y0_FrameData[27] VPWR VGND sg13cmos5l_antennanp
XFILLER_0_2263 VPWR VGND sg13cmos5l_decap_4
XANTENNA_819 Tile_X0Y0_FrameData[27] VPWR VGND sg13cmos5l_antennanp
XFILLER_16_2205 VPWR VGND sg13cmos5l_decap_8
XFILLER_13_706 VPWR VGND sg13cmos5l_decap_8
XANTENNA__1060__X Tile_X4Y0_S4BEG[13] VPWR VGND sg13cmos5l_antennanp
XFILLER_14_1272 VPWR VGND sg13cmos5l_decap_8
XFILLER_10_1147 VPWR VGND sg13cmos5l_decap_8
XANTENNA_1207 Tile_X0Y0_FrameData[30] VPWR VGND sg13cmos5l_antennanp
XANTENNA_1218 Tile_X0Y0_FrameData[30] VPWR VGND sg13cmos5l_antennanp
XFILLER_7_2439 VPWR VGND sg13cmos5l_decap_8
XANTENNA_1229 Tile_X0Y0_FrameData[30] VPWR VGND sg13cmos5l_antennanp
XFILLER_16_533 VPWR VGND sg13cmos5l_decap_8
XFILLER_16_599 VPWR VGND sg13cmos5l_decap_8
XFILLER_12_2647 VPWR VGND sg13cmos5l_decap_8
XANTENNA_3110 Tile_X0Y0_FrameData[19] VPWR VGND sg13cmos5l_antennanp
XANTENNA_3121 Tile_X0Y0_FrameData[19] VPWR VGND sg13cmos5l_antennanp
X_0611_ _0611_/L_HI VPWR VGND sg13cmos5l_tiehi
XANTENNA_3132 Tile_X0Y0_FrameData[19] VPWR VGND sg13cmos5l_antennanp
XANTENNA_3143 Tile_X0Y0_FrameData[19] VPWR VGND sg13cmos5l_antennanp
XANTENNA_3154 Tile_X0Y0_FrameData[19] VPWR VGND sg13cmos5l_antennanp
X_0542_ NPU_WDATA18 Tile_X0Y0_UserCLK _1114_/X _0685_/L_HI VPWR VGND sg13cmos5l_dfrbpq_1
XANTENNA_2420 Tile_X0Y0_FrameData[12] VPWR VGND sg13cmos5l_antennanp
XANTENNA_2431 Tile_X0Y0_FrameData[12] VPWR VGND sg13cmos5l_antennanp
XANTENNA_2442 Tile_X0Y0_FrameData[12] VPWR VGND sg13cmos5l_antennanp
XANTENNA_3165 Tile_X0Y0_FrameData[19] VPWR VGND sg13cmos5l_antennanp
XANTENNA_3176 Tile_X0Y0_FrameData[19] VPWR VGND sg13cmos5l_antennanp
XANTENNA_3187 Tile_X0Y0_FrameData[20] VPWR VGND sg13cmos5l_antennanp
XFILLER_10_1692 VPWR VGND sg13cmos5l_decap_8
XANTENNA_1730 Tile_X0Y0_FrameData[4] VPWR VGND sg13cmos5l_antennanp
XANTENNA_1741 Tile_X0Y0_FrameData[4] VPWR VGND sg13cmos5l_antennanp
XANTENNA_2453 Tile_X0Y0_FrameData[12] VPWR VGND sg13cmos5l_antennanp
XANTENNA_2464 Tile_X0Y0_FrameData[12] VPWR VGND sg13cmos5l_antennanp
XANTENNA_2475 Tile_X0Y0_FrameData[12] VPWR VGND sg13cmos5l_antennanp
XANTENNA_2486 Tile_X0Y0_FrameData[12] VPWR VGND sg13cmos5l_antennanp
XANTENNA_3198 Tile_X0Y0_FrameData[20] VPWR VGND sg13cmos5l_antennanp
X_0473_ _0473_/Q Tile_X0Y0_FrameData[0] VGND VPWR Tile_X3Y0_FrameStrobe[1] latch
XANTENNA_1752 Tile_X0Y0_FrameData[4] VPWR VGND sg13cmos5l_antennanp
XANTENNA_1763 Tile_X0Y0_FrameData[4] VPWR VGND sg13cmos5l_antennanp
XANTENNA_1774 Tile_X0Y0_FrameData[5] VPWR VGND sg13cmos5l_antennanp
XANTENNA_2497 Tile_X0Y0_FrameData[12] VPWR VGND sg13cmos5l_antennanp
XANTENNA_1785 Tile_X0Y0_FrameData[5] VPWR VGND sg13cmos5l_antennanp
XANTENNA_1796 Tile_X0Y0_FrameData[5] VPWR VGND sg13cmos5l_antennanp
XANTENNA__0984__X Tile_X0Y0_SS4BEG[9] VPWR VGND sg13cmos5l_antennanp
XFILLER_1_2583 VPWR VGND sg13cmos5l_decap_4
X_1025_ Tile_X0Y0_S1BEG[2] Tile_X0Y0_N1END[1] VPWR VGND sg13cmos5l_buf_1
XFILLER_15_2282 VPWR VGND sg13cmos5l_decap_8
XFILLER_11_2135 VPWR VGND sg13cmos5l_decap_8
XFILLER_15_1570 VPWR VGND sg13cmos5l_decap_8
X_0809_ Tile_X3Y0_SS4BEG[14] _1289_/X VPWR VGND sg13cmos5l_buf_1
XFILLER_8_2748 VPWR VGND sg13cmos5l_decap_8
XANTENNA__1055__X Tile_X4Y0_S4BEG[8] VPWR VGND sg13cmos5l_antennanp
XFILLER_6_2472 VPWR VGND sg13cmos5l_decap_8
XANTENNA__0894__X Tile_X2Y0_S4BEG[11] VPWR VGND sg13cmos5l_antennanp
XFILLER_2_1646 VPWR VGND sg13cmos5l_decap_8
XANTENNA_616 Tile_X0Y0_FrameData[23] VPWR VGND sg13cmos5l_antennanp
XANTENNA_605 Tile_X0Y0_FrameData[23] VPWR VGND sg13cmos5l_antennanp
XANTENNA_649 Tile_X0Y0_FrameData[23] VPWR VGND sg13cmos5l_antennanp
XANTENNA_638 Tile_X0Y0_FrameData[23] VPWR VGND sg13cmos5l_antennanp
XANTENNA_627 Tile_X0Y0_FrameData[23] VPWR VGND sg13cmos5l_antennanp
XFILLER_0_1370 VPWR VGND sg13cmos5l_fill_1
XFILLER_16_2057 VPWR VGND sg13cmos5l_decap_8
XFILLER_16_1323 VPWR VGND sg13cmos5l_decap_8
XFILLER_13_569 VPWR VGND sg13cmos5l_decap_8
XFILLER_4_245 VPWR VGND sg13cmos5l_fill_2
XFILLER_7_2214 VPWR VGND sg13cmos5l_decap_8
XANTENNA_1004 Tile_X0Y0_FrameData[28] VPWR VGND sg13cmos5l_antennanp
XANTENNA_1015 Tile_X0Y0_FrameData[28] VPWR VGND sg13cmos5l_antennanp
XANTENNA_1026 Tile_X0Y0_FrameData[29] VPWR VGND sg13cmos5l_antennanp
XANTENNA_1037 Tile_X0Y0_FrameData[29] VPWR VGND sg13cmos5l_antennanp
XANTENNA_1048 Tile_X0Y0_FrameData[29] VPWR VGND sg13cmos5l_antennanp
XANTENNA_1059 Tile_X0Y0_FrameData[29] VPWR VGND sg13cmos5l_antennanp
XFILLER_7_2269 VPWR VGND sg13cmos5l_decap_8
XFILLER_1_1134 VPWR VGND sg13cmos5l_decap_8
XFILLER_12_2400 VPWR VGND sg13cmos5l_decap_8
XFILLER_12_2477 VPWR VGND sg13cmos5l_decap_8
XANTENNA_1 _1090_/X VPWR VGND sg13cmos5l_antennanp
XFILLER_8_584 VPWR VGND sg13cmos5l_decap_8
XFILLER_12_1754 VPWR VGND sg13cmos5l_decap_8
XANTENNA__0979__X Tile_X0Y0_SS4BEG[4] VPWR VGND sg13cmos5l_antennanp
XFILLER_6_63 VPWR VGND sg13cmos5l_decap_8
XANTENNA_2250 Tile_X0Y0_FrameData[9] VPWR VGND sg13cmos5l_antennanp
XANTENNA_2261 Tile_X0Y0_FrameData[9] VPWR VGND sg13cmos5l_antennanp
X_0525_ NPU_WDATA1 Tile_X0Y0_UserCLK _1097_/X _0627_/L_HI VPWR VGND sg13cmos5l_dfrbpq_1
XANTENNA_2272 Tile_X0Y0_FrameData[9] VPWR VGND sg13cmos5l_antennanp
XANTENNA_2283 Tile_X0Y0_FrameData[9] VPWR VGND sg13cmos5l_antennanp
XANTENNA_2294 Tile_X0Y0_N2END[3] VPWR VGND sg13cmos5l_antennanp
X_0456_ _0456_/Q Tile_X0Y0_FrameData[17] VGND VPWR Tile_X3Y0_FrameStrobe[1] latch
XFILLER_7_2770 VPWR VGND sg13cmos5l_decap_8
XANTENNA_1560 Tile_X0Y0_FrameData[3] VPWR VGND sg13cmos5l_antennanp
XANTENNA_1571 Tile_X0Y0_FrameData[3] VPWR VGND sg13cmos5l_antennanp
XANTENNA_1582 Tile_X0Y0_FrameData[3] VPWR VGND sg13cmos5l_antennanp
XFILLER_3_2612 VPWR VGND sg13cmos5l_decap_8
XANTENNA_1593 Tile_X0Y0_FrameData[3] VPWR VGND sg13cmos5l_antennanp
X_0387_ _0387_/Q Tile_X0Y0_FrameData[22] VGND VPWR Tile_X2Y0_FrameStrobe[2] latch
XFILLER_3_2689 VPWR VGND sg13cmos5l_decap_8
XFILLER_3_1944 VPWR VGND sg13cmos5l_fill_1
XFILLER_1_2391 VPWR VGND sg13cmos5l_decap_4
X_1008_ Tile_X0Y0_S2BEGb[1] _1132_/X VPWR VGND sg13cmos5l_buf_1
XFILLER_1_1690 VPWR VGND sg13cmos5l_decap_8
XFILLER_13_2208 VPWR VGND sg13cmos5l_decap_8
XFILLER_11_1231 VPWR VGND sg13cmos5l_decap_8
XANTENNA__0889__X Tile_X2Y0_S4BEG[6] VPWR VGND sg13cmos5l_antennanp
XFILLER_9_7 VPWR VGND sg13cmos5l_decap_8
XFILLER_4_1719 VPWR VGND sg13cmos5l_decap_8
XFILLER_2_1410 VPWR VGND sg13cmos5l_fill_1
XANTENNA_402 Tile_X0Y0_FrameData[22] VPWR VGND sg13cmos5l_antennanp
XANTENNA_413 Tile_X0Y0_FrameData[22] VPWR VGND sg13cmos5l_antennanp
XANTENNA_424 Tile_X0Y0_FrameData[22] VPWR VGND sg13cmos5l_antennanp
XANTENNA_435 Tile_X0Y0_FrameData[23] VPWR VGND sg13cmos5l_antennanp
XFILLER_2_1465 VPWR VGND sg13cmos5l_fill_1
XANTENNA_446 Tile_X0Y0_FrameData[23] VPWR VGND sg13cmos5l_antennanp
XANTENNA_468 Tile_X0Y0_FrameData[23] VPWR VGND sg13cmos5l_antennanp
XANTENNA_457 Tile_X0Y0_FrameData[23] VPWR VGND sg13cmos5l_antennanp
XANTENNA_479 Tile_X0Y0_FrameData[23] VPWR VGND sg13cmos5l_antennanp
XFILLER_9_337 VPWR VGND sg13cmos5l_fill_2
XFILLER_16_1153 VPWR VGND sg13cmos5l_decap_8
XFILLER_13_2720 VPWR VGND sg13cmos5l_decap_8
XFILLER_5_543 VPWR VGND sg13cmos5l_decap_8
XANTENNA__0799__X Tile_X3Y0_SS4BEG[4] VPWR VGND sg13cmos5l_antennanp
XFILLER_9_2309 VPWR VGND sg13cmos5l_decap_8
X_0310_ _0310_/Q Tile_X0Y0_FrameData[19] VGND VPWR Tile_X1Y0_FrameStrobe[3] latch
X_1290_ _1290_/X Tile_X3Y0_N2END[7] Tile_X3Y0_N4END[15] Tile_X3Y0_NN4END[0] _0572_/Q
+ _0427_/Q _0426_/Q VPWR VGND sg13cmos5l_mux4_1
X_0241_ _0241_/Q Tile_X0Y0_FrameData[24] VGND VPWR Tile_X1Y0_FrameStrobe[1] latch
X_0172_ _0172_/Q Tile_X0Y0_FrameData[13] VGND VPWR Tile_X0Y0_FrameStrobe[2] latch
XFILLER_16_171 VPWR VGND sg13cmos5l_decap_8
XANTENNA_980 Tile_X0Y0_FrameData[28] VPWR VGND sg13cmos5l_antennanp
XANTENNA_991 Tile_X0Y0_FrameData[28] VPWR VGND sg13cmos5l_antennanp
XFILLER_14_1816 VPWR VGND sg13cmos5l_decap_8
XFILLER_12_2274 VPWR VGND sg13cmos5l_decap_8
XFILLER_12_1551 VPWR VGND sg13cmos5l_decap_8
X_0508_ _0508_/Q Tile_X0Y0_FrameData[29] VGND VPWR Tile_X4Y0_FrameStrobe[0] latch
XFILLER_5_2707 VPWR VGND sg13cmos5l_decap_8
XANTENNA_2080 Tile_X0Y0_FrameData[6] VPWR VGND sg13cmos5l_antennanp
XANTENNA_2091 Tile_X0Y0_FrameData[6] VPWR VGND sg13cmos5l_antennanp
XANTENNA_1390 Tile_X0Y0_FrameData[31] VPWR VGND sg13cmos5l_antennanp
X_0439_ _0439_/Q Tile_X0Y0_FrameData[2] VGND VPWR Tile_X3Y0_FrameStrobe[0] latch
XFILLER_3_2497 VPWR VGND sg13cmos5l_fill_2
XFILLER_15_609 VPWR VGND sg13cmos5l_decap_8
XFILLER_14_119 VPWR VGND sg13cmos5l_decap_8
XANTENNA_3709 Tile_X1Y0_N4END[2] VPWR VGND sg13cmos5l_antennanp
XFILLER_11_1072 VPWR VGND sg13cmos5l_decap_8
XFILLER_8_2331 VPWR VGND sg13cmos5l_decap_8
XANTENNA__0568__Q NPU_ADDR4 VPWR VGND sg13cmos5l_antennanp
XFILLER_8_1685 VPWR VGND sg13cmos5l_decap_8
XANTENNA_210 Tile_X0Y0_FrameData[10] VPWR VGND sg13cmos5l_antennanp
XANTENNA_221 Tile_X0Y0_FrameData[10] VPWR VGND sg13cmos5l_antennanp
XANTENNA_232 Tile_X0Y0_FrameData[10] VPWR VGND sg13cmos5l_antennanp
XANTENNA_243 Tile_X0Y0_FrameData[10] VPWR VGND sg13cmos5l_antennanp
XANTENNA_254 Tile_X0Y0_FrameData[10] VPWR VGND sg13cmos5l_antennanp
XANTENNA_265 Tile_X0Y0_FrameData[10] VPWR VGND sg13cmos5l_antennanp
XANTENNA_276 Tile_X0Y0_FrameData[10] VPWR VGND sg13cmos5l_antennanp
XANTENNA_287 Tile_X0Y0_FrameData[15] VPWR VGND sg13cmos5l_antennanp
XANTENNA_298 Tile_X0Y0_FrameData[1] VPWR VGND sg13cmos5l_antennanp
XFILLER_14_653 VPWR VGND sg13cmos5l_decap_8
XFILLER_9_112 VPWR VGND sg13cmos5l_decap_8
XFILLER_13_196 VPWR VGND sg13cmos5l_fill_1
X_0790_ Tile_X3Y0_S4BEG[11] _1270_/X VPWR VGND sg13cmos5l_buf_1
XFILLER_13_2594 VPWR VGND sg13cmos5l_decap_8
XFILLER_9_2139 VPWR VGND sg13cmos5l_decap_8
XFILLER_3_42 VPWR VGND sg13cmos5l_decap_8
X_1273_ _1273_/X Tile_X3Y0_N2MID[6] Tile_X3Y0_N4END[1] Tile_X3Y0_NN4END[14] _0572_/Q
+ _0461_/Q _0460_/Q VPWR VGND sg13cmos5l_mux4_1
XFILLER_1_590 VPWR VGND sg13cmos5l_decap_8
X_0224_ _0224_/Q Tile_X0Y0_FrameData[9] VGND VPWR Tile_X1Y0_FrameStrobe[0] latch
XANTENNA__0992__X Tile_X0Y0_S4BEG[1] VPWR VGND sg13cmos5l_antennanp
X_0155_ _0155_/Q Tile_X0Y0_FrameData[30] VGND VPWR Tile_X0Y0_FrameStrobe[2] latch
X_0086_ _0563_/D _0513_/Q _1095_/X VPWR VGND sg13cmos5l_nor2b_1
XFILLER_14_2303 VPWR VGND sg13cmos5l_decap_8
XFILLER_14_1613 VPWR VGND sg13cmos5l_decap_8
X_0988_ Tile_X0Y0_SS4BEG[13] _1168_/X VPWR VGND sg13cmos5l_buf_1
XFILLER_12_2071 VPWR VGND sg13cmos5l_decap_8
XFILLER_9_2640 VPWR VGND sg13cmos5l_decap_8
XFILLER_5_2515 VPWR VGND sg13cmos5l_decap_8
XANTENNA__1063__X Tile_X4Y0_SS4BEG[0] VPWR VGND sg13cmos5l_antennanp
XFILLER_3_2250 VPWR VGND sg13cmos5l_decap_8
XFILLER_11_601 VPWR VGND sg13cmos5l_decap_8
XFILLER_7_616 VPWR VGND sg13cmos5l_decap_8
XFILLER_13_1101 VPWR VGND sg13cmos5l_decap_8
XFILLER_10_133 VPWR VGND sg13cmos5l_decap_8
XANTENNA_3506 Tile_X0Y0_FrameData[8] VPWR VGND sg13cmos5l_antennanp
XANTENNA_3517 Tile_X0Y0_FrameData[8] VPWR VGND sg13cmos5l_antennanp
XANTENNA_3528 Tile_X0Y0_FrameData[8] VPWR VGND sg13cmos5l_antennanp
XFILLER_13_1178 VPWR VGND sg13cmos5l_decap_8
XFILLER_12_95 VPWR VGND sg13cmos5l_fill_1
XFILLER_12_84 VPWR VGND sg13cmos5l_decap_8
XANTENNA_2805 Tile_X0Y0_FrameData[17] VPWR VGND sg13cmos5l_antennanp
XANTENNA_2816 Tile_X0Y0_FrameData[17] VPWR VGND sg13cmos5l_antennanp
XANTENNA_3539 Tile_X0Y0_FrameData[8] VPWR VGND sg13cmos5l_antennanp
XANTENNA_2827 Tile_X0Y0_FrameData[17] VPWR VGND sg13cmos5l_antennanp
XANTENNA_2838 Tile_X0Y0_FrameData[17] VPWR VGND sg13cmos5l_antennanp
XANTENNA_2849 Tile_X0Y0_FrameData[17] VPWR VGND sg13cmos5l_antennanp
XFILLER_8_2161 VPWR VGND sg13cmos5l_decap_8
XFILLER_8_1460 VPWR VGND sg13cmos5l_decap_8
XFILLER_15_2612 VPWR VGND sg13cmos5l_decap_8
X_0911_ Tile_X2Y0_SS4BEG[12] _1247_/X VPWR VGND sg13cmos5l_buf_1
X_0842_ Tile_X4Y0_FrameData_O[31] Tile_X0Y0_FrameData[31] VPWR VGND sg13cmos5l_buf_1
XFILLER_15_2689 VPWR VGND sg13cmos5l_decap_8
XFILLER_15_1944 VPWR VGND sg13cmos5l_decap_8
X_0773_ Tile_X3Y0_S2BEGb[2] _1253_/X VPWR VGND sg13cmos5l_buf_1
XFILLER_15_1999 VPWR VGND sg13cmos5l_fill_1
XANTENNA__0987__X Tile_X0Y0_SS4BEG[12] VPWR VGND sg13cmos5l_antennanp
X_1256_ _1256_/X Tile_X3Y0_N1END[1] Tile_X3Y0_N2MID[5] Tile_X3Y0_N2END[2] _0577_/Q
+ _0495_/Q _0494_/Q VPWR VGND sg13cmos5l_mux4_1
XFILLER_0_2423 VPWR VGND sg13cmos5l_decap_8
XFILLER_0_2401 VPWR VGND sg13cmos5l_decap_4
X_0207_ _0207_/Q Tile_X0Y0_FrameData[26] VGND VPWR Tile_X1Y0_FrameStrobe[0] latch
X_1187_ _1187_/X Tile_X1Y0_N2MID[0] Tile_X1Y0_N4END[7] Tile_X1Y0_NN4END[8] _0590_/Q
+ _0281_/Q _0280_/Q VPWR VGND sg13cmos5l_mux4_1
XFILLER_0_2467 VPWR VGND sg13cmos5l_fill_1
X_0138_ _0138_/Q Tile_X0Y0_FrameData[15] VGND VPWR Tile_X0Y0_FrameStrobe[1] latch
XFILLER_16_2409 VPWR VGND sg13cmos5l_decap_8
XFILLER_14_2111 VPWR VGND sg13cmos5l_decap_8
XFILLER_14_2188 VPWR VGND sg13cmos5l_decap_8
XFILLER_14_1487 VPWR VGND sg13cmos5l_fill_2
XANTENNA__1058__X Tile_X4Y0_S4BEG[11] VPWR VGND sg13cmos5l_antennanp
XANTENNA__0897__X Tile_X2Y0_S4BEG[14] VPWR VGND sg13cmos5l_antennanp
XFILLER_9_2470 VPWR VGND sg13cmos5l_decap_8
XFILLER_5_2312 VPWR VGND sg13cmos5l_decap_8
XFILLER_5_1611 VPWR VGND sg13cmos5l_decap_8
XFILLER_5_2389 VPWR VGND sg13cmos5l_decap_8
XFILLER_5_1688 VPWR VGND sg13cmos5l_decap_8
XFILLER_15_203 VPWR VGND sg13cmos5l_decap_8
XFILLER_15_1207 VPWR VGND sg13cmos5l_decap_8
XANTENNA_4004 Tile_X0Y0_FrameData[18] VPWR VGND sg13cmos5l_antennanp
XFILLER_8_958 VPWR VGND sg13cmos5l_fill_2
XFILLER_10_2520 VPWR VGND sg13cmos5l_decap_8
XANTENNA_3303 Tile_X0Y0_FrameData[20] VPWR VGND sg13cmos5l_antennanp
XANTENNA_4015 Tile_X0Y0_FrameData[18] VPWR VGND sg13cmos5l_antennanp
XANTENNA_4026 Tile_X0Y0_N2END[1] VPWR VGND sg13cmos5l_antennanp
XANTENNA_4037 Tile_X0Y0_N2END[4] VPWR VGND sg13cmos5l_antennanp
XANTENNA_4048 Tile_X0Y0_N4END[3] VPWR VGND sg13cmos5l_antennanp
XANTENNA_3314 Tile_X0Y0_FrameData[20] VPWR VGND sg13cmos5l_antennanp
XANTENNA_3325 Tile_X0Y0_FrameData[20] VPWR VGND sg13cmos5l_antennanp
XANTENNA_3336 Tile_X0Y0_FrameData[20] VPWR VGND sg13cmos5l_antennanp
XANTENNA_4059 Tile_X0Y0_N4END[3] VPWR VGND sg13cmos5l_antennanp
XANTENNA_2602 Tile_X0Y0_FrameData[13] VPWR VGND sg13cmos5l_antennanp
XANTENNA_2613 Tile_X0Y0_FrameData[14] VPWR VGND sg13cmos5l_antennanp
XANTENNA_2624 Tile_X0Y0_FrameData[14] VPWR VGND sg13cmos5l_antennanp
XANTENNA_2635 Tile_X0Y0_FrameData[14] VPWR VGND sg13cmos5l_antennanp
XANTENNA_3347 Tile_X0Y0_FrameData[20] VPWR VGND sg13cmos5l_antennanp
XANTENNA_3358 Tile_X0Y0_FrameData[20] VPWR VGND sg13cmos5l_antennanp
XANTENNA_3369 Tile_X0Y0_FrameData[20] VPWR VGND sg13cmos5l_antennanp
XANTENNA_1901 Tile_X0Y0_FrameData[5] VPWR VGND sg13cmos5l_antennanp
XANTENNA_1912 Tile_X0Y0_FrameData[5] VPWR VGND sg13cmos5l_antennanp
XANTENNA_1923 Tile_X0Y0_FrameData[5] VPWR VGND sg13cmos5l_antennanp
XANTENNA_2646 Tile_X0Y0_FrameData[14] VPWR VGND sg13cmos5l_antennanp
XANTENNA_2657 Tile_X0Y0_FrameData[14] VPWR VGND sg13cmos5l_antennanp
XANTENNA_2668 Tile_X0Y0_FrameData[14] VPWR VGND sg13cmos5l_antennanp
XANTENNA_1934 Tile_X0Y0_FrameData[5] VPWR VGND sg13cmos5l_antennanp
XANTENNA_1945 Tile_X0Y0_FrameData[6] VPWR VGND sg13cmos5l_antennanp
XANTENNA_1956 Tile_X0Y0_FrameData[6] VPWR VGND sg13cmos5l_antennanp
XANTENNA_2679 Tile_X0Y0_FrameData[14] VPWR VGND sg13cmos5l_antennanp
XANTENNA_1967 Tile_X0Y0_FrameData[6] VPWR VGND sg13cmos5l_antennanp
XANTENNA_1978 Tile_X0Y0_FrameData[6] VPWR VGND sg13cmos5l_antennanp
XANTENNA_1989 Tile_X0Y0_FrameData[6] VPWR VGND sg13cmos5l_antennanp
X_1110_ _1110_/X Tile_X1Y0_N4END[14] Tile_X1Y0_N4END[15] Tile_X1Y0_NN4END[12] Tile_X1Y0_NN4END[14]
+ _0205_/Q _0204_/Q VPWR VGND sg13cmos5l_mux4_1
XFILLER_8_1290 VPWR VGND sg13cmos5l_fill_1
X_1041_ Tile_X4Y0_S2BEGb[2] Tile_X4Y0_N2END[5] VPWR VGND sg13cmos5l_buf_1
XFILLER_4_1154 VPWR VGND sg13cmos5l_decap_8
XFILLER_1_2765 VPWR VGND sg13cmos5l_fill_1
XFILLER_0_21 VPWR VGND sg13cmos5l_decap_8
XFILLER_1_2776 VPWR VGND sg13cmos5l_fill_1
XFILLER_9_63 VPWR VGND sg13cmos5l_decap_8
XFILLER_15_2475 VPWR VGND sg13cmos5l_decap_8
XFILLER_11_2317 VPWR VGND sg13cmos5l_decap_8
XFILLER_15_1752 VPWR VGND sg13cmos5l_decap_8
X_0825_ Tile_X4Y0_FrameData_O[14] Tile_X0Y0_FrameData[14] VPWR VGND sg13cmos5l_buf_1
XFILLER_11_1627 VPWR VGND sg13cmos5l_decap_8
X_0756_ Tile_X1Y0_S2BEG[5] Tile_X1Y0_N2MID[2] VPWR VGND sg13cmos5l_buf_1
X_0687_ Tile_X0Y0_FrameStrobe_O[0] Tile_X0Y0_FrameStrobe[0] VPWR VGND sg13cmos5l_buf_1
XANTENNA_3870 Tile_X0Y0_FrameData[18] VPWR VGND sg13cmos5l_antennanp
XANTENNA_3881 Tile_X0Y0_FrameData[18] VPWR VGND sg13cmos5l_antennanp
XANTENNA_3892 Tile_X0Y0_FrameData[18] VPWR VGND sg13cmos5l_antennanp
XFILLER_6_2676 VPWR VGND sg13cmos5l_decap_8
XFILLER_6_1942 VPWR VGND sg13cmos5l_fill_2
XFILLER_2_2507 VPWR VGND sg13cmos5l_decap_8
X_1239_ _1239_/X Tile_X2Y0_N2END[4] Tile_X2Y0_N4END[4] Tile_X2Y0_NN4END[11] _0585_/Q
+ _0353_/Q _0352_/Q VPWR VGND sg13cmos5l_mux4_1
XFILLER_0_2242 VPWR VGND sg13cmos5l_decap_8
XANTENNA_809 Tile_X0Y0_FrameData[27] VPWR VGND sg13cmos5l_antennanp
XFILLER_16_2239 VPWR VGND sg13cmos5l_decap_8
XFILLER_16_1549 VPWR VGND sg13cmos5l_decap_8
XFILLER_14_1251 VPWR VGND sg13cmos5l_decap_8
XANTENNA_1208 Tile_X0Y0_FrameData[30] VPWR VGND sg13cmos5l_antennanp
XANTENNA_1219 Tile_X0Y0_FrameData[30] VPWR VGND sg13cmos5l_antennanp
XFILLER_7_2429 VPWR VGND sg13cmos5l_decap_4
XFILLER_5_2142 VPWR VGND sg13cmos5l_fill_1
XFILLER_16_523 VPWR VGND sg13cmos5l_decap_8
XFILLER_16_578 VPWR VGND sg13cmos5l_decap_8
XFILLER_16_2773 VPWR VGND sg13cmos5l_fill_2
XFILLER_12_2626 VPWR VGND sg13cmos5l_decap_8
XFILLER_12_784 VPWR VGND sg13cmos5l_decap_8
XANTENNA_3100 Tile_X0Y0_FrameData[19] VPWR VGND sg13cmos5l_antennanp
XANTENNA_3111 Tile_X0Y0_FrameData[19] VPWR VGND sg13cmos5l_antennanp
X_0610_ _0610_/L_HI VPWR VGND sg13cmos5l_tiehi
XANTENNA_2410 Tile_X0Y0_FrameData[11] VPWR VGND sg13cmos5l_antennanp
XANTENNA_3122 Tile_X0Y0_FrameData[19] VPWR VGND sg13cmos5l_antennanp
XANTENNA_3133 Tile_X0Y0_FrameData[19] VPWR VGND sg13cmos5l_antennanp
XANTENNA_3144 Tile_X0Y0_FrameData[19] VPWR VGND sg13cmos5l_antennanp
X_0541_ NPU_WDATA17 Tile_X0Y0_UserCLK _1113_/X _0686_/L_HI VPWR VGND sg13cmos5l_dfrbpq_1
XFILLER_10_2394 VPWR VGND sg13cmos5l_decap_8
XFILLER_10_1671 VPWR VGND sg13cmos5l_decap_8
XANTENNA_2421 Tile_X0Y0_FrameData[12] VPWR VGND sg13cmos5l_antennanp
XANTENNA_2432 Tile_X0Y0_FrameData[12] VPWR VGND sg13cmos5l_antennanp
XANTENNA_2443 Tile_X0Y0_FrameData[12] VPWR VGND sg13cmos5l_antennanp
XANTENNA_3155 Tile_X0Y0_FrameData[19] VPWR VGND sg13cmos5l_antennanp
XANTENNA_3166 Tile_X0Y0_FrameData[19] VPWR VGND sg13cmos5l_antennanp
XANTENNA_3177 Tile_X0Y0_FrameData[19] VPWR VGND sg13cmos5l_antennanp
XANTENNA_3188 Tile_X0Y0_FrameData[20] VPWR VGND sg13cmos5l_antennanp
XANTENNA_1720 Tile_X0Y0_FrameData[4] VPWR VGND sg13cmos5l_antennanp
XANTENNA_1731 Tile_X0Y0_FrameData[4] VPWR VGND sg13cmos5l_antennanp
XANTENNA_2454 Tile_X0Y0_FrameData[12] VPWR VGND sg13cmos5l_antennanp
XANTENNA_2465 Tile_X0Y0_FrameData[12] VPWR VGND sg13cmos5l_antennanp
XANTENNA_2476 Tile_X0Y0_FrameData[12] VPWR VGND sg13cmos5l_antennanp
XANTENNA_3199 Tile_X0Y0_FrameData[20] VPWR VGND sg13cmos5l_antennanp
X_0472_ _0472_/Q Tile_X0Y0_FrameData[1] VGND VPWR Tile_X3Y0_FrameStrobe[1] latch
XANTENNA_1742 Tile_X0Y0_FrameData[4] VPWR VGND sg13cmos5l_antennanp
XANTENNA_1753 Tile_X0Y0_FrameData[4] VPWR VGND sg13cmos5l_antennanp
XANTENNA_1764 Tile_X0Y0_FrameData[4] VPWR VGND sg13cmos5l_antennanp
XANTENNA_1775 Tile_X0Y0_FrameData[5] VPWR VGND sg13cmos5l_antennanp
XANTENNA_2487 Tile_X0Y0_FrameData[12] VPWR VGND sg13cmos5l_antennanp
XANTENNA_2498 Tile_X0Y0_FrameData[12] VPWR VGND sg13cmos5l_antennanp
XANTENNA_1786 Tile_X0Y0_FrameData[5] VPWR VGND sg13cmos5l_antennanp
XANTENNA_1797 Tile_X0Y0_FrameData[5] VPWR VGND sg13cmos5l_antennanp
X_1024_ Tile_X0Y0_S1BEG[1] Tile_X0Y0_N1END[2] VPWR VGND sg13cmos5l_buf_1
XFILLER_15_2261 VPWR VGND sg13cmos5l_decap_8
XFILLER_11_2114 VPWR VGND sg13cmos5l_decap_8
X_0808_ Tile_X3Y0_SS4BEG[13] _1288_/X VPWR VGND sg13cmos5l_buf_1
XFILLER_8_2727 VPWR VGND sg13cmos5l_decap_8
X_0739_ Tile_X1Y0_SS4BEG[8] _1203_/X VPWR VGND sg13cmos5l_buf_1
XFILLER_6_2451 VPWR VGND sg13cmos5l_decap_8
XFILLER_6_1783 VPWR VGND sg13cmos5l_decap_8
XFILLER_2_1625 VPWR VGND sg13cmos5l_decap_8
XANTENNA__1071__X Tile_X4Y0_SS4BEG[8] VPWR VGND sg13cmos5l_antennanp
XANTENNA_617 Tile_X0Y0_FrameData[23] VPWR VGND sg13cmos5l_antennanp
XANTENNA_606 Tile_X0Y0_FrameData[23] VPWR VGND sg13cmos5l_antennanp
XANTENNA_639 Tile_X0Y0_FrameData[23] VPWR VGND sg13cmos5l_antennanp
XANTENNA_628 Tile_X0Y0_FrameData[23] VPWR VGND sg13cmos5l_antennanp
XFILLER_9_508 VPWR VGND sg13cmos5l_fill_1
XFILLER_16_2036 VPWR VGND sg13cmos5l_decap_4
XFILLER_16_1302 VPWR VGND sg13cmos5l_decap_8
XFILLER_13_548 VPWR VGND sg13cmos5l_decap_8
XFILLER_16_1379 VPWR VGND sg13cmos5l_decap_8
XFILLER_11_2681 VPWR VGND sg13cmos5l_decap_8
XANTENNA_1005 Tile_X0Y0_FrameData[28] VPWR VGND sg13cmos5l_antennanp
XANTENNA_1016 Tile_X0Y0_FrameData[28] VPWR VGND sg13cmos5l_antennanp
XANTENNA_1027 Tile_X0Y0_FrameData[29] VPWR VGND sg13cmos5l_antennanp
XFILLER_7_2248 VPWR VGND sg13cmos5l_decap_8
XANTENNA_1038 Tile_X0Y0_FrameData[29] VPWR VGND sg13cmos5l_antennanp
XANTENNA_1049 Tile_X0Y0_FrameData[29] VPWR VGND sg13cmos5l_antennanp
XFILLER_16_2570 VPWR VGND sg13cmos5l_decap_8
XFILLER_8_563 VPWR VGND sg13cmos5l_decap_8
XFILLER_12_592 VPWR VGND sg13cmos5l_decap_8
XFILLER_12_2456 VPWR VGND sg13cmos5l_decap_8
XANTENNA_2 _1090_/X VPWR VGND sg13cmos5l_antennanp
XFILLER_6_42 VPWR VGND sg13cmos5l_decap_8
XFILLER_12_1733 VPWR VGND sg13cmos5l_decap_8
XFILLER_10_2191 VPWR VGND sg13cmos5l_decap_8
XANTENNA_2240 Tile_X0Y0_FrameData[9] VPWR VGND sg13cmos5l_antennanp
XANTENNA_2251 Tile_X0Y0_FrameData[9] VPWR VGND sg13cmos5l_antennanp
X_0524_ NPU_WDATA0 Tile_X0Y0_UserCLK _1096_/X _0628_/L_HI VPWR VGND sg13cmos5l_dfrbpq_1
XANTENNA_2262 Tile_X0Y0_FrameData[9] VPWR VGND sg13cmos5l_antennanp
XANTENNA_2273 Tile_X0Y0_FrameData[9] VPWR VGND sg13cmos5l_antennanp
XANTENNA_2284 Tile_X0Y0_FrameData[9] VPWR VGND sg13cmos5l_antennanp
X_0455_ _0455_/Q Tile_X0Y0_FrameData[18] VGND VPWR Tile_X3Y0_FrameStrobe[1] latch
XANTENNA__0995__X Tile_X0Y0_S4BEG[4] VPWR VGND sg13cmos5l_antennanp
XANTENNA_1550 Tile_X0Y0_FrameData[3] VPWR VGND sg13cmos5l_antennanp
XANTENNA_1561 Tile_X0Y0_FrameData[3] VPWR VGND sg13cmos5l_antennanp
XANTENNA_1572 Tile_X0Y0_FrameData[3] VPWR VGND sg13cmos5l_antennanp
XANTENNA_1583 Tile_X0Y0_FrameData[3] VPWR VGND sg13cmos5l_antennanp
XANTENNA_2295 Tile_X0Y0_N2END[3] VPWR VGND sg13cmos5l_antennanp
XANTENNA_1594 Tile_X0Y0_FrameData[3] VPWR VGND sg13cmos5l_antennanp
X_0386_ _0386_/Q Tile_X0Y0_FrameData[23] VGND VPWR Tile_X2Y0_FrameStrobe[2] latch
XFILLER_6_1079 VPWR VGND sg13cmos5l_fill_1
XFILLER_3_2668 VPWR VGND sg13cmos5l_decap_8
XFILLER_13_0 VPWR VGND sg13cmos5l_decap_8
XFILLER_3_1978 VPWR VGND sg13cmos5l_fill_2
X_1007_ Tile_X0Y0_S2BEGb[0] _1131_/X VPWR VGND sg13cmos5l_buf_1
XFILLER_10_529 VPWR VGND sg13cmos5l_decap_8
XFILLER_11_1210 VPWR VGND sg13cmos5l_decap_8
XFILLER_8_2513 VPWR VGND sg13cmos5l_decap_8
XANTENNA__1066__X Tile_X4Y0_SS4BEG[3] VPWR VGND sg13cmos5l_antennanp
XFILLER_8_2524 VPWR VGND sg13cmos5l_fill_1
XFILLER_6_2292 VPWR VGND sg13cmos5l_decap_8
XANTENNA_403 Tile_X0Y0_FrameData[22] VPWR VGND sg13cmos5l_antennanp
XANTENNA_414 Tile_X0Y0_FrameData[22] VPWR VGND sg13cmos5l_antennanp
XANTENNA_425 Tile_X0Y0_FrameData[22] VPWR VGND sg13cmos5l_antennanp
XANTENNA_436 Tile_X0Y0_FrameData[23] VPWR VGND sg13cmos5l_antennanp
XANTENNA_447 Tile_X0Y0_FrameData[23] VPWR VGND sg13cmos5l_antennanp
XANTENNA_458 Tile_X0Y0_FrameData[23] VPWR VGND sg13cmos5l_antennanp
XANTENNA_469 Tile_X0Y0_FrameData[23] VPWR VGND sg13cmos5l_antennanp
XFILLER_15_84 VPWR VGND sg13cmos5l_decap_8
XFILLER_16_1198 VPWR VGND sg13cmos5l_fill_2
XFILLER_12_1029 VPWR VGND sg13cmos5l_fill_1
XFILLER_5_599 VPWR VGND sg13cmos5l_decap_8
X_0240_ _0240_/Q Tile_X0Y0_FrameData[25] VGND VPWR Tile_X1Y0_FrameStrobe[1] latch
XFILLER_0_271 VPWR VGND sg13cmos5l_fill_1
X_0171_ _0171_/Q Tile_X0Y0_FrameData[14] VGND VPWR Tile_X0Y0_FrameStrobe[2] latch
XFILLER_16_150 VPWR VGND sg13cmos5l_decap_8
XANTENNA_981 Tile_X0Y0_FrameData[28] VPWR VGND sg13cmos5l_antennanp
XANTENNA_970 Tile_X0Y0_FrameData[28] VPWR VGND sg13cmos5l_antennanp
XANTENNA_992 Tile_X0Y0_FrameData[28] VPWR VGND sg13cmos5l_antennanp
XFILLER_12_2253 VPWR VGND sg13cmos5l_decap_8
XFILLER_12_1530 VPWR VGND sg13cmos5l_decap_8
X_0507_ _0507_/Q Tile_X0Y0_FrameData[30] VGND VPWR Tile_X4Y0_FrameStrobe[0] latch
XANTENNA_2070 Tile_X0Y0_FrameData[6] VPWR VGND sg13cmos5l_antennanp
XANTENNA_2081 Tile_X0Y0_FrameData[6] VPWR VGND sg13cmos5l_antennanp
XANTENNA_2092 Tile_X0Y0_FrameData[6] VPWR VGND sg13cmos5l_antennanp
XANTENNA_1380 Tile_X0Y0_FrameData[31] VPWR VGND sg13cmos5l_antennanp
XANTENNA_1391 Tile_X0Y0_FrameData[31] VPWR VGND sg13cmos5l_antennanp
X_0438_ _0438_/Q Tile_X0Y0_FrameData[3] VGND VPWR Tile_X3Y0_FrameStrobe[0] latch
X_0369_ _0369_/Q Tile_X0Y0_FrameData[8] VGND VPWR Tile_X2Y0_FrameStrobe[1] latch
XFILLER_3_2454 VPWR VGND sg13cmos5l_fill_1
XFILLER_13_2017 VPWR VGND sg13cmos5l_fill_1
XFILLER_8_2310 VPWR VGND sg13cmos5l_decap_8
XFILLER_8_2387 VPWR VGND sg13cmos5l_decap_8
XFILLER_8_1631 VPWR VGND sg13cmos5l_decap_8
XFILLER_8_1664 VPWR VGND sg13cmos5l_decap_8
XANTENNA_200 Tile_X0Y0_FrameData[10] VPWR VGND sg13cmos5l_antennanp
XANTENNA_211 Tile_X0Y0_FrameData[10] VPWR VGND sg13cmos5l_antennanp
XANTENNA_222 Tile_X0Y0_FrameData[10] VPWR VGND sg13cmos5l_antennanp
XANTENNA_233 Tile_X0Y0_FrameData[10] VPWR VGND sg13cmos5l_antennanp
XANTENNA_244 Tile_X0Y0_FrameData[10] VPWR VGND sg13cmos5l_antennanp
XANTENNA_255 Tile_X0Y0_FrameData[10] VPWR VGND sg13cmos5l_antennanp
XANTENNA_266 Tile_X0Y0_FrameData[10] VPWR VGND sg13cmos5l_antennanp
XANTENNA_277 Tile_X0Y0_FrameData[10] VPWR VGND sg13cmos5l_antennanp
XFILLER_14_632 VPWR VGND sg13cmos5l_decap_8
XANTENNA_288 Tile_X0Y0_FrameData[15] VPWR VGND sg13cmos5l_antennanp
XANTENNA_299 Tile_X0Y0_FrameData[1] VPWR VGND sg13cmos5l_antennanp
XFILLER_13_175 VPWR VGND sg13cmos5l_decap_8
XFILLER_9_2118 VPWR VGND sg13cmos5l_decap_8
XFILLER_3_21 VPWR VGND sg13cmos5l_decap_8
X_1272_ _1272_/X Tile_X3Y0_N2MID[5] Tile_X3Y0_N4END[2] Tile_X3Y0_NN4END[13] _0573_/Q
+ _0463_/Q _0462_/Q VPWR VGND sg13cmos5l_mux4_1
X_0223_ _0223_/Q Tile_X0Y0_FrameData[10] VGND VPWR Tile_X1Y0_FrameStrobe[0] latch
XFILLER_7_1185 VPWR VGND sg13cmos5l_decap_8
XFILLER_4_2752 VPWR VGND sg13cmos5l_decap_4
X_0154_ _0154_/Q Tile_X0Y0_FrameData[31] VGND VPWR Tile_X0Y0_FrameStrobe[2] latch
XFILLER_0_2638 VPWR VGND sg13cmos5l_fill_2
X_0085_ _0561_/D _0515_/Q _1093_/X VPWR VGND sg13cmos5l_nor2b_1
XFILLER_14_2359 VPWR VGND sg13cmos5l_decap_8
X_0987_ Tile_X0Y0_SS4BEG[12] _1167_/X VPWR VGND sg13cmos5l_buf_1
XFILLER_14_1669 VPWR VGND sg13cmos5l_decap_8
XFILLER_9_2696 VPWR VGND sg13cmos5l_decap_8
XFILLER_16_919 VPWR VGND sg13cmos5l_fill_1
XFILLER_11_657 VPWR VGND sg13cmos5l_fill_2
XFILLER_10_112 VPWR VGND sg13cmos5l_decap_8
XFILLER_6_105 VPWR VGND sg13cmos5l_fill_1
XFILLER_11_679 VPWR VGND sg13cmos5l_fill_1
XFILLER_13_1157 VPWR VGND sg13cmos5l_decap_8
XFILLER_12_63 VPWR VGND sg13cmos5l_decap_8
XFILLER_10_2746 VPWR VGND sg13cmos5l_decap_8
XANTENNA_3507 Tile_X0Y0_FrameData[8] VPWR VGND sg13cmos5l_antennanp
XANTENNA_3518 Tile_X0Y0_FrameData[8] VPWR VGND sg13cmos5l_antennanp
XANTENNA_2806 Tile_X0Y0_FrameData[17] VPWR VGND sg13cmos5l_antennanp
XANTENNA_2817 Tile_X0Y0_FrameData[17] VPWR VGND sg13cmos5l_antennanp
XANTENNA_3529 Tile_X0Y0_FrameData[8] VPWR VGND sg13cmos5l_antennanp
XANTENNA_2828 Tile_X0Y0_FrameData[17] VPWR VGND sg13cmos5l_antennanp
XANTENNA_2839 Tile_X0Y0_FrameData[17] VPWR VGND sg13cmos5l_antennanp
XFILLER_8_2140 VPWR VGND sg13cmos5l_decap_8
X_0910_ Tile_X2Y0_SS4BEG[11] _1246_/X VPWR VGND sg13cmos5l_buf_1
XFILLER_15_2668 VPWR VGND sg13cmos5l_decap_8
X_0841_ Tile_X4Y0_FrameData_O[30] Tile_X0Y0_FrameData[30] VPWR VGND sg13cmos5l_buf_1
X_0772_ Tile_X3Y0_S2BEGb[1] _1252_/X VPWR VGND sg13cmos5l_buf_1
XFILLER_11_1809 VPWR VGND sg13cmos5l_decap_8
XFILLER_13_1691 VPWR VGND sg13cmos5l_decap_8
XFILLER_9_1225 VPWR VGND sg13cmos5l_decap_8
XFILLER_9_1236 VPWR VGND sg13cmos5l_fill_1
X_1255_ _1255_/X Tile_X3Y0_N1END[0] Tile_X3Y0_N2MID[4] Tile_X3Y0_N2END[3] _0576_/Q
+ _0497_/Q _0496_/Q VPWR VGND sg13cmos5l_mux4_1
X_0206_ _0206_/Q Tile_X0Y0_FrameData[27] VGND VPWR Tile_X1Y0_FrameStrobe[0] latch
X_1186_ _1186_/X Tile_X1Y0_N2MID[7] Tile_X1Y0_N4END[8] Tile_X1Y0_NN4END[7] _0593_/Q
+ _0283_/Q _0282_/Q VPWR VGND sg13cmos5l_mux4_1
X_0137_ _0137_/Q Tile_X0Y0_FrameData[16] VGND VPWR Tile_X0Y0_FrameStrobe[1] latch
XFILLER_0_1734 VPWR VGND sg13cmos5l_decap_8
XFILLER_14_2167 VPWR VGND sg13cmos5l_decap_8
XFILLER_14_1466 VPWR VGND sg13cmos5l_decap_8
XANTENNA__1074__X Tile_X4Y0_SS4BEG[11] VPWR VGND sg13cmos5l_antennanp
XFILLER_9_1781 VPWR VGND sg13cmos5l_decap_8
XFILLER_5_2368 VPWR VGND sg13cmos5l_decap_8
XFILLER_5_1667 VPWR VGND sg13cmos5l_decap_8
XFILLER_16_749 VPWR VGND sg13cmos5l_decap_8
XFILLER_12_911 VPWR VGND sg13cmos5l_fill_1
XFILLER_11_465 VPWR VGND sg13cmos5l_fill_1
XANTENNA_4005 Tile_X0Y0_FrameData[18] VPWR VGND sg13cmos5l_antennanp
XANTENNA_4016 Tile_X0Y0_FrameData[18] VPWR VGND sg13cmos5l_antennanp
XANTENNA_4027 Tile_X0Y0_N2END[1] VPWR VGND sg13cmos5l_antennanp
XANTENNA_4038 Tile_X0Y0_N2END[4] VPWR VGND sg13cmos5l_antennanp
XFILLER_10_1820 VPWR VGND sg13cmos5l_fill_2
XANTENNA_3304 Tile_X0Y0_FrameData[20] VPWR VGND sg13cmos5l_antennanp
XANTENNA_3315 Tile_X0Y0_FrameData[20] VPWR VGND sg13cmos5l_antennanp
XANTENNA_3326 Tile_X0Y0_FrameData[20] VPWR VGND sg13cmos5l_antennanp
XANTENNA_3337 Tile_X0Y0_FrameData[20] VPWR VGND sg13cmos5l_antennanp
XANTENNA_4049 Tile_X0Y0_N4END[3] VPWR VGND sg13cmos5l_antennanp
XANTENNA_2603 Tile_X0Y0_FrameData[13] VPWR VGND sg13cmos5l_antennanp
XANTENNA_2614 Tile_X0Y0_FrameData[14] VPWR VGND sg13cmos5l_antennanp
XANTENNA_2625 Tile_X0Y0_FrameData[14] VPWR VGND sg13cmos5l_antennanp
XANTENNA_3348 Tile_X0Y0_FrameData[20] VPWR VGND sg13cmos5l_antennanp
XANTENNA_3359 Tile_X0Y0_FrameData[20] VPWR VGND sg13cmos5l_antennanp
XFILLER_10_1897 VPWR VGND sg13cmos5l_fill_2
XFILLER_10_1875 VPWR VGND sg13cmos5l_fill_1
XANTENNA_1902 Tile_X0Y0_FrameData[5] VPWR VGND sg13cmos5l_antennanp
XANTENNA_1913 Tile_X0Y0_FrameData[5] VPWR VGND sg13cmos5l_antennanp
XANTENNA_1924 Tile_X0Y0_FrameData[5] VPWR VGND sg13cmos5l_antennanp
XANTENNA_2636 Tile_X0Y0_FrameData[14] VPWR VGND sg13cmos5l_antennanp
XANTENNA_2647 Tile_X0Y0_FrameData[14] VPWR VGND sg13cmos5l_antennanp
XANTENNA_2658 Tile_X0Y0_FrameData[14] VPWR VGND sg13cmos5l_antennanp
XANTENNA_1935 Tile_X0Y0_FrameData[5] VPWR VGND sg13cmos5l_antennanp
XANTENNA_1946 Tile_X0Y0_FrameData[6] VPWR VGND sg13cmos5l_antennanp
XANTENNA_1957 Tile_X0Y0_FrameData[6] VPWR VGND sg13cmos5l_antennanp
XANTENNA_2669 Tile_X0Y0_FrameData[14] VPWR VGND sg13cmos5l_antennanp
XANTENNA_1968 Tile_X0Y0_FrameData[6] VPWR VGND sg13cmos5l_antennanp
XANTENNA_1979 Tile_X0Y0_FrameData[6] VPWR VGND sg13cmos5l_antennanp
XFILLER_4_1133 VPWR VGND sg13cmos5l_decap_8
X_1040_ Tile_X4Y0_S2BEGb[1] Tile_X4Y0_N2END[6] VPWR VGND sg13cmos5l_buf_1
XFILLER_0_1019 VPWR VGND sg13cmos5l_fill_2
XFILLER_9_42 VPWR VGND sg13cmos5l_decap_8
XFILLER_15_2454 VPWR VGND sg13cmos5l_decap_8
XFILLER_15_1731 VPWR VGND sg13cmos5l_decap_8
X_0824_ Tile_X4Y0_FrameData_O[13] Tile_X0Y0_FrameData[13] VPWR VGND sg13cmos5l_buf_1
XFILLER_11_1606 VPWR VGND sg13cmos5l_decap_8
X_0755_ Tile_X1Y0_S2BEG[4] Tile_X1Y0_N2MID[3] VPWR VGND sg13cmos5l_buf_1
XANTENNA__0998__X Tile_X0Y0_S4BEG[7] VPWR VGND sg13cmos5l_antennanp
X_0686_ _0686_/L_HI VPWR VGND sg13cmos5l_tiehi
XANTENNA_3860 Tile_X0Y0_FrameData[18] VPWR VGND sg13cmos5l_antennanp
XANTENNA_3871 Tile_X0Y0_FrameData[18] VPWR VGND sg13cmos5l_antennanp
XANTENNA_3882 Tile_X0Y0_FrameData[18] VPWR VGND sg13cmos5l_antennanp
XANTENNA_3893 Tile_X0Y0_FrameData[18] VPWR VGND sg13cmos5l_antennanp
XFILLER_6_2655 VPWR VGND sg13cmos5l_decap_8
X_1238_ _1238_/X Tile_X2Y0_N2END[3] Tile_X2Y0_N4END[3] Tile_X2Y0_NN4END[12] _0586_/Q
+ _0355_/Q _0354_/Q VPWR VGND sg13cmos5l_mux4_1
XFILLER_0_2232 VPWR VGND sg13cmos5l_decap_4
X_1169_ _1169_/X Tile_X0Y0_N2END[6] Tile_X0Y0_N4END[14] Tile_X0Y0_NN4END[1] _0597_/Q
+ _0125_/Q _0124_/Q VPWR VGND sg13cmos5l_mux4_1
XFILLER_0_2276 VPWR VGND sg13cmos5l_decap_8
XFILLER_16_1528 VPWR VGND sg13cmos5l_decap_4
XFILLER_14_1230 VPWR VGND sg13cmos5l_decap_8
XANTENNA__1069__X Tile_X4Y0_SS4BEG[6] VPWR VGND sg13cmos5l_antennanp
XANTENNA__0701__X Tile_X0Y0_FrameStrobe_O[14] VPWR VGND sg13cmos5l_antennanp
XANTENNA_1209 Tile_X0Y0_FrameData[30] VPWR VGND sg13cmos5l_antennanp
XFILLER_7_2408 VPWR VGND sg13cmos5l_decap_8
XFILLER_7_1729 VPWR VGND sg13cmos5l_decap_8
XFILLER_1_2007 VPWR VGND sg13cmos5l_fill_1
XFILLER_5_1497 VPWR VGND sg13cmos5l_fill_2
XFILLER_16_557 VPWR VGND sg13cmos5l_decap_8
XFILLER_12_763 VPWR VGND sg13cmos5l_decap_8
XFILLER_12_2605 VPWR VGND sg13cmos5l_decap_8
XANTENNA_3101 Tile_X0Y0_FrameData[19] VPWR VGND sg13cmos5l_antennanp
XANTENNA_3112 Tile_X0Y0_FrameData[19] VPWR VGND sg13cmos5l_antennanp
XFILLER_10_2373 VPWR VGND sg13cmos5l_decap_8
XANTENNA_2400 Tile_X0Y0_FrameData[11] VPWR VGND sg13cmos5l_antennanp
XANTENNA_3123 Tile_X0Y0_FrameData[19] VPWR VGND sg13cmos5l_antennanp
XANTENNA_3134 Tile_X0Y0_FrameData[19] VPWR VGND sg13cmos5l_antennanp
XANTENNA_3145 Tile_X0Y0_FrameData[19] VPWR VGND sg13cmos5l_antennanp
X_0540_ NPU_WDATA16 Tile_X0Y0_UserCLK _1112_/X _0633_/L_HI VPWR VGND sg13cmos5l_dfrbpq_1
XFILLER_10_1650 VPWR VGND sg13cmos5l_decap_8
XANTENNA_2411 Tile_X0Y0_FrameData[11] VPWR VGND sg13cmos5l_antennanp
XANTENNA_2422 Tile_X0Y0_FrameData[12] VPWR VGND sg13cmos5l_antennanp
XANTENNA_2433 Tile_X0Y0_FrameData[12] VPWR VGND sg13cmos5l_antennanp
XANTENNA_3156 Tile_X0Y0_FrameData[19] VPWR VGND sg13cmos5l_antennanp
XANTENNA_3167 Tile_X0Y0_FrameData[19] VPWR VGND sg13cmos5l_antennanp
XANTENNA_3178 Tile_X0Y0_FrameData[20] VPWR VGND sg13cmos5l_antennanp
XANTENNA_1710 Tile_X0Y0_FrameData[4] VPWR VGND sg13cmos5l_antennanp
XANTENNA_1721 Tile_X0Y0_FrameData[4] VPWR VGND sg13cmos5l_antennanp
XANTENNA_1732 Tile_X0Y0_FrameData[4] VPWR VGND sg13cmos5l_antennanp
XANTENNA_2444 Tile_X0Y0_FrameData[12] VPWR VGND sg13cmos5l_antennanp
XANTENNA_2455 Tile_X0Y0_FrameData[12] VPWR VGND sg13cmos5l_antennanp
XANTENNA_2466 Tile_X0Y0_FrameData[12] VPWR VGND sg13cmos5l_antennanp
XANTENNA_2477 Tile_X0Y0_FrameData[12] VPWR VGND sg13cmos5l_antennanp
XANTENNA_3189 Tile_X0Y0_FrameData[20] VPWR VGND sg13cmos5l_antennanp
X_0471_ _0471_/Q Tile_X0Y0_FrameData[2] VGND VPWR Tile_X3Y0_FrameStrobe[1] latch
XANTENNA_1743 Tile_X0Y0_FrameData[4] VPWR VGND sg13cmos5l_antennanp
XANTENNA_1754 Tile_X0Y0_FrameData[4] VPWR VGND sg13cmos5l_antennanp
XANTENNA_1765 Tile_X0Y0_FrameData[4] VPWR VGND sg13cmos5l_antennanp
XANTENNA_2488 Tile_X0Y0_FrameData[12] VPWR VGND sg13cmos5l_antennanp
XANTENNA_2499 Tile_X0Y0_FrameData[12] VPWR VGND sg13cmos5l_antennanp
XFILLER_6_1228 VPWR VGND sg13cmos5l_fill_1
XANTENNA_1776 Tile_X0Y0_FrameData[5] VPWR VGND sg13cmos5l_antennanp
XANTENNA_1787 Tile_X0Y0_FrameData[5] VPWR VGND sg13cmos5l_antennanp
XANTENNA_1798 Tile_X0Y0_FrameData[5] VPWR VGND sg13cmos5l_antennanp
XFILLER_1_2541 VPWR VGND sg13cmos5l_fill_1
X_1023_ Tile_X0Y0_S1BEG[0] Tile_X0Y0_N1END[3] VPWR VGND sg13cmos5l_buf_1
XFILLER_15_2240 VPWR VGND sg13cmos5l_decap_8
XFILLER_11_1414 VPWR VGND sg13cmos5l_fill_1
X_0807_ Tile_X3Y0_SS4BEG[12] _1287_/X VPWR VGND sg13cmos5l_buf_1
X_0738_ Tile_X1Y0_SS4BEG[7] _1202_/X VPWR VGND sg13cmos5l_buf_1
XFILLER_8_2706 VPWR VGND sg13cmos5l_decap_8
XANTENNA_3690 Tile_X1Y0_N4END[1] VPWR VGND sg13cmos5l_antennanp
X_0669_ _0669_/L_HI VPWR VGND sg13cmos5l_tiehi
XFILLER_6_2430 VPWR VGND sg13cmos5l_decap_8
XFILLER_6_1762 VPWR VGND sg13cmos5l_decap_8
XANTENNA_607 Tile_X0Y0_FrameData[23] VPWR VGND sg13cmos5l_antennanp
XANTENNA_629 Tile_X0Y0_FrameData[23] VPWR VGND sg13cmos5l_antennanp
XANTENNA_618 Tile_X0Y0_FrameData[23] VPWR VGND sg13cmos5l_antennanp
XFILLER_13_527 VPWR VGND sg13cmos5l_decap_8
XFILLER_16_1358 VPWR VGND sg13cmos5l_decap_8
XFILLER_14_1082 VPWR VGND sg13cmos5l_decap_8
XFILLER_11_2660 VPWR VGND sg13cmos5l_decap_8
XANTENNA_1006 Tile_X0Y0_FrameData[28] VPWR VGND sg13cmos5l_antennanp
XANTENNA_1017 Tile_X0Y0_FrameData[28] VPWR VGND sg13cmos5l_antennanp
XANTENNA_1028 Tile_X0Y0_FrameData[29] VPWR VGND sg13cmos5l_antennanp
XANTENNA_1039 Tile_X0Y0_FrameData[29] VPWR VGND sg13cmos5l_antennanp
XFILLER_12_571 VPWR VGND sg13cmos5l_decap_8
XFILLER_8_542 VPWR VGND sg13cmos5l_decap_8
XFILLER_12_2435 VPWR VGND sg13cmos5l_decap_8
XFILLER_12_1712 VPWR VGND sg13cmos5l_decap_8
XANTENNA_3 NPU_RDATA0 VPWR VGND sg13cmos5l_antennanp
XFILLER_6_21 VPWR VGND sg13cmos5l_decap_8
XFILLER_12_1789 VPWR VGND sg13cmos5l_decap_8
XFILLER_10_2170 VPWR VGND sg13cmos5l_decap_8
XFILLER_6_98 VPWR VGND sg13cmos5l_decap_8
XANTENNA_2230 Tile_X0Y0_FrameData[9] VPWR VGND sg13cmos5l_antennanp
XANTENNA_2241 Tile_X0Y0_FrameData[9] VPWR VGND sg13cmos5l_antennanp
XANTENNA_2252 Tile_X0Y0_FrameData[9] VPWR VGND sg13cmos5l_antennanp
X_0523_ NPU_READ_BANK_SEL2 Tile_X0Y0_UserCLK _1130_/X _0629_/L_HI VPWR VGND sg13cmos5l_dfrbpq_1
XANTENNA_1540 Tile_X0Y0_FrameData[3] VPWR VGND sg13cmos5l_antennanp
XANTENNA_2263 Tile_X0Y0_FrameData[9] VPWR VGND sg13cmos5l_antennanp
XANTENNA_2274 Tile_X0Y0_FrameData[9] VPWR VGND sg13cmos5l_antennanp
XANTENNA_2285 Tile_X0Y0_FrameData[9] VPWR VGND sg13cmos5l_antennanp
X_0454_ _0454_/Q Tile_X0Y0_FrameData[19] VGND VPWR Tile_X3Y0_FrameStrobe[1] latch
XANTENNA_1551 Tile_X0Y0_FrameData[3] VPWR VGND sg13cmos5l_antennanp
XANTENNA_1562 Tile_X0Y0_FrameData[3] VPWR VGND sg13cmos5l_antennanp
XANTENNA_1573 Tile_X0Y0_FrameData[3] VPWR VGND sg13cmos5l_antennanp
XANTENNA_2296 Tile_X0Y0_N4END[0] VPWR VGND sg13cmos5l_antennanp
XANTENNA_1584 Tile_X0Y0_FrameData[3] VPWR VGND sg13cmos5l_antennanp
XANTENNA_1595 Tile_X0Y0_FrameData[3] VPWR VGND sg13cmos5l_antennanp
X_0385_ _0385_/Q Tile_X0Y0_FrameData[24] VGND VPWR Tile_X2Y0_FrameStrobe[2] latch
XFILLER_3_2647 VPWR VGND sg13cmos5l_decap_8
X_1006_ Tile_X0Y0_S4BEG[15] _1154_/X VPWR VGND sg13cmos5l_buf_1
XFILLER_13_1509 VPWR VGND sg13cmos5l_decap_8
XFILLER_11_1266 VPWR VGND sg13cmos5l_decap_8
XFILLER_6_2271 VPWR VGND sg13cmos5l_decap_8
XANTENNA_404 Tile_X0Y0_FrameData[22] VPWR VGND sg13cmos5l_antennanp
XANTENNA_415 Tile_X0Y0_FrameData[22] VPWR VGND sg13cmos5l_antennanp
XANTENNA_426 Tile_X0Y0_FrameData[22] VPWR VGND sg13cmos5l_antennanp
XANTENNA_437 Tile_X0Y0_FrameData[23] VPWR VGND sg13cmos5l_antennanp
XANTENNA_448 Tile_X0Y0_FrameData[23] VPWR VGND sg13cmos5l_antennanp
XANTENNA_459 Tile_X0Y0_FrameData[23] VPWR VGND sg13cmos5l_antennanp
XFILLER_15_63 VPWR VGND sg13cmos5l_decap_8
XFILLER_16_1144 VPWR VGND sg13cmos5l_decap_4
XFILLER_16_1133 VPWR VGND sg13cmos5l_decap_8
XFILLER_16_1177 VPWR VGND sg13cmos5l_decap_8
XFILLER_12_1019 VPWR VGND sg13cmos5l_fill_1
XFILLER_5_578 VPWR VGND sg13cmos5l_decap_8
XFILLER_7_2002 VPWR VGND sg13cmos5l_fill_2
XFILLER_0_283 VPWR VGND sg13cmos5l_fill_2
X_0170_ _0170_/Q Tile_X0Y0_FrameData[15] VGND VPWR Tile_X0Y0_FrameStrobe[2] latch
XANTENNA_971 Tile_X0Y0_FrameData[28] VPWR VGND sg13cmos5l_antennanp
XANTENNA_960 Tile_X0Y0_FrameData[28] VPWR VGND sg13cmos5l_antennanp
XFILLER_14_2519 VPWR VGND sg13cmos5l_decap_8
XANTENNA_993 Tile_X0Y0_FrameData[28] VPWR VGND sg13cmos5l_antennanp
XANTENNA_982 Tile_X0Y0_FrameData[28] VPWR VGND sg13cmos5l_antennanp
XFILLER_12_2232 VPWR VGND sg13cmos5l_decap_8
XFILLER_9_2801 VPWR VGND sg13cmos5l_fill_2
XFILLER_12_1586 VPWR VGND sg13cmos5l_decap_8
XANTENNA_2060 Tile_X0Y0_FrameData[6] VPWR VGND sg13cmos5l_antennanp
X_0506_ _0506_/Q Tile_X0Y0_FrameData[31] VGND VPWR Tile_X3Y0_FrameStrobe[0] latch
XFILLER_8_1109 VPWR VGND sg13cmos5l_decap_8
XANTENNA_2071 Tile_X0Y0_FrameData[6] VPWR VGND sg13cmos5l_antennanp
XANTENNA_2082 Tile_X0Y0_FrameData[6] VPWR VGND sg13cmos5l_antennanp
XANTENNA_2093 Tile_X0Y0_FrameData[6] VPWR VGND sg13cmos5l_antennanp
XANTENNA_1370 Tile_X0Y0_FrameData[31] VPWR VGND sg13cmos5l_antennanp
XANTENNA_1381 Tile_X0Y0_FrameData[31] VPWR VGND sg13cmos5l_antennanp
X_0437_ _0437_/Q Tile_X0Y0_FrameData[4] VGND VPWR Tile_X3Y0_FrameStrobe[0] latch
XFILLER_3_2433 VPWR VGND sg13cmos5l_fill_2
XANTENNA_1392 Tile_X0Y0_FrameData[31] VPWR VGND sg13cmos5l_antennanp
X_0368_ _0368_/Q Tile_X0Y0_FrameData[9] VGND VPWR Tile_X2Y0_FrameStrobe[1] latch
XFILLER_3_1754 VPWR VGND sg13cmos5l_decap_8
X_0299_ _0299_/Q Tile_X0Y0_FrameData[30] VGND VPWR Tile_X1Y0_FrameStrobe[3] latch
XANTENNA__1077__X Tile_X4Y0_SS4BEG[14] VPWR VGND sg13cmos5l_antennanp
XFILLER_8_2366 VPWR VGND sg13cmos5l_decap_8
XFILLER_8_1643 VPWR VGND sg13cmos5l_decap_8
XANTENNA_201 Tile_X0Y0_FrameData[10] VPWR VGND sg13cmos5l_antennanp
XANTENNA_212 Tile_X0Y0_FrameData[10] VPWR VGND sg13cmos5l_antennanp
XANTENNA_223 Tile_X0Y0_FrameData[10] VPWR VGND sg13cmos5l_antennanp
XANTENNA_234 Tile_X0Y0_FrameData[10] VPWR VGND sg13cmos5l_antennanp
XANTENNA_245 Tile_X0Y0_FrameData[10] VPWR VGND sg13cmos5l_antennanp
XANTENNA_256 Tile_X0Y0_FrameData[10] VPWR VGND sg13cmos5l_antennanp
XANTENNA_267 Tile_X0Y0_FrameData[10] VPWR VGND sg13cmos5l_antennanp
XFILLER_14_611 VPWR VGND sg13cmos5l_decap_8
XANTENNA_278 Tile_X0Y0_FrameData[10] VPWR VGND sg13cmos5l_antennanp
XANTENNA_289 Tile_X0Y0_FrameData[15] VPWR VGND sg13cmos5l_antennanp
XFILLER_14_688 VPWR VGND sg13cmos5l_decap_8
XFILLER_13_154 VPWR VGND sg13cmos5l_decap_8
XFILLER_13_1873 VPWR VGND sg13cmos5l_decap_8
X_1271_ _1271_/X Tile_X3Y0_N2MID[4] Tile_X3Y0_N4END[3] Tile_X3Y0_NN4END[12] _0572_/Q
+ _0465_/Q _0464_/Q VPWR VGND sg13cmos5l_mux4_1
XFILLER_4_2731 VPWR VGND sg13cmos5l_decap_8
X_0222_ _0222_/Q Tile_X0Y0_FrameData[11] VGND VPWR Tile_X1Y0_FrameStrobe[0] latch
XFILLER_7_1164 VPWR VGND sg13cmos5l_decap_8
X_0153_ _0153_/Q Tile_X0Y0_FrameData[0] VGND VPWR Tile_X0Y0_FrameStrobe[1] latch
X_0084_ _0556_/D _0520_/Q _1088_/X VPWR VGND sg13cmos5l_nor2b_1
XANTENNA_790 Tile_X0Y0_FrameData[26] VPWR VGND sg13cmos5l_antennanp
XFILLER_14_2338 VPWR VGND sg13cmos5l_decap_8
X_0986_ Tile_X0Y0_SS4BEG[11] _1166_/X VPWR VGND sg13cmos5l_buf_1
XFILLER_14_1648 VPWR VGND sg13cmos5l_decap_8
XFILLER_9_2675 VPWR VGND sg13cmos5l_decap_8
XFILLER_3_2285 VPWR VGND sg13cmos5l_decap_8
XFILLER_11_636 VPWR VGND sg13cmos5l_decap_8
XANTENNA__0704__X Tile_X0Y0_FrameStrobe_O[17] VPWR VGND sg13cmos5l_antennanp
XFILLER_13_1136 VPWR VGND sg13cmos5l_decap_8
XFILLER_12_42 VPWR VGND sg13cmos5l_decap_8
XFILLER_10_2725 VPWR VGND sg13cmos5l_decap_8
XANTENNA_3508 Tile_X0Y0_FrameData[8] VPWR VGND sg13cmos5l_antennanp
XANTENNA_3519 Tile_X0Y0_FrameData[8] VPWR VGND sg13cmos5l_antennanp
XANTENNA_2807 Tile_X0Y0_FrameData[17] VPWR VGND sg13cmos5l_antennanp
XANTENNA_2818 Tile_X0Y0_FrameData[17] VPWR VGND sg13cmos5l_antennanp
XANTENNA_2829 Tile_X0Y0_FrameData[17] VPWR VGND sg13cmos5l_antennanp
XFILLER_8_2196 VPWR VGND sg13cmos5l_decap_8
XFILLER_14_430 VPWR VGND sg13cmos5l_fill_2
XFILLER_14_452 VPWR VGND sg13cmos5l_decap_4
XFILLER_15_2647 VPWR VGND sg13cmos5l_decap_8
X_0840_ Tile_X4Y0_FrameData_O[29] Tile_X0Y0_FrameData[29] VPWR VGND sg13cmos5l_buf_1
X_0771_ Tile_X3Y0_S2BEGb[0] _1251_/X VPWR VGND sg13cmos5l_buf_1
XFILLER_15_1979 VPWR VGND sg13cmos5l_decap_8
XFILLER_13_2393 VPWR VGND sg13cmos5l_decap_8
XFILLER_13_1670 VPWR VGND sg13cmos5l_decap_8
XFILLER_5_172 VPWR VGND sg13cmos5l_fill_2
XFILLER_9_1204 VPWR VGND sg13cmos5l_decap_8
X_1254_ _1254_/X Tile_X3Y0_N1END[3] Tile_X3Y0_N2MID[3] Tile_X3Y0_N2END[4] _0575_/Q
+ _0499_/Q _0498_/Q VPWR VGND sg13cmos5l_mux4_1
X_0205_ _0205_/Q Tile_X0Y0_FrameData[28] VGND VPWR Tile_X1Y0_FrameStrobe[0] latch
X_1185_ _1185_/X Tile_X1Y0_N2MID[6] Tile_X1Y0_N4END[9] Tile_X1Y0_NN4END[6] _0592_/Q
+ _0285_/Q _0284_/Q VPWR VGND sg13cmos5l_mux4_1
XFILLER_0_2458 VPWR VGND sg13cmos5l_decap_8
XFILLER_0_1713 VPWR VGND sg13cmos5l_decap_8
X_0136_ _0136_/Q Tile_X0Y0_FrameData[17] VGND VPWR Tile_X0Y0_FrameStrobe[1] latch
XFILLER_14_2146 VPWR VGND sg13cmos5l_decap_8
X_0969_ Tile_X1Y0_FrameStrobe_O[14] Tile_X1Y0_FrameStrobe[14] VPWR VGND sg13cmos5l_buf_1
XFILLER_14_1445 VPWR VGND sg13cmos5l_decap_8
XFILLER_14_1489 VPWR VGND sg13cmos5l_fill_1
XFILLER_9_1760 VPWR VGND sg13cmos5l_fill_2
XFILLER_5_2347 VPWR VGND sg13cmos5l_decap_8
XFILLER_5_1646 VPWR VGND sg13cmos5l_decap_8
XFILLER_16_728 VPWR VGND sg13cmos5l_decap_8
XANTENNA_4006 Tile_X0Y0_FrameData[18] VPWR VGND sg13cmos5l_antennanp
XANTENNA_4017 Tile_X0Y0_FrameData[18] VPWR VGND sg13cmos5l_antennanp
XANTENNA_4028 Tile_X0Y0_N2END[1] VPWR VGND sg13cmos5l_antennanp
XANTENNA_4039 Tile_X0Y0_N2END[5] VPWR VGND sg13cmos5l_antennanp
XANTENNA_3305 Tile_X0Y0_FrameData[20] VPWR VGND sg13cmos5l_antennanp
XANTENNA_3316 Tile_X0Y0_FrameData[20] VPWR VGND sg13cmos5l_antennanp
XANTENNA_3327 Tile_X0Y0_FrameData[20] VPWR VGND sg13cmos5l_antennanp
XFILLER_3_621 VPWR VGND sg13cmos5l_fill_2
XFILLER_10_2599 VPWR VGND sg13cmos5l_decap_8
XANTENNA_2604 Tile_X0Y0_FrameData[14] VPWR VGND sg13cmos5l_antennanp
XANTENNA_2615 Tile_X0Y0_FrameData[14] VPWR VGND sg13cmos5l_antennanp
XANTENNA_2626 Tile_X0Y0_FrameData[14] VPWR VGND sg13cmos5l_antennanp
XANTENNA_3338 Tile_X0Y0_FrameData[20] VPWR VGND sg13cmos5l_antennanp
XANTENNA_3349 Tile_X0Y0_FrameData[20] VPWR VGND sg13cmos5l_antennanp
XFILLER_3_0 VPWR VGND sg13cmos5l_decap_8
XANTENNA_1903 Tile_X0Y0_FrameData[5] VPWR VGND sg13cmos5l_antennanp
XANTENNA_1914 Tile_X0Y0_FrameData[5] VPWR VGND sg13cmos5l_antennanp
XANTENNA_2637 Tile_X0Y0_FrameData[14] VPWR VGND sg13cmos5l_antennanp
XANTENNA_2648 Tile_X0Y0_FrameData[14] VPWR VGND sg13cmos5l_antennanp
XANTENNA_2659 Tile_X0Y0_FrameData[14] VPWR VGND sg13cmos5l_antennanp
XANTENNA_1925 Tile_X0Y0_FrameData[5] VPWR VGND sg13cmos5l_antennanp
XANTENNA_1936 Tile_X0Y0_FrameData[6] VPWR VGND sg13cmos5l_antennanp
XANTENNA_1947 Tile_X0Y0_FrameData[6] VPWR VGND sg13cmos5l_antennanp
XFILLER_2_197 VPWR VGND sg13cmos5l_fill_1
XANTENNA_1958 Tile_X0Y0_FrameData[6] VPWR VGND sg13cmos5l_antennanp
XANTENNA_1969 Tile_X0Y0_FrameData[6] VPWR VGND sg13cmos5l_antennanp
XFILLER_4_1112 VPWR VGND sg13cmos5l_decap_8
XFILLER_1_2734 VPWR VGND sg13cmos5l_decap_8
XFILLER_9_21 VPWR VGND sg13cmos5l_decap_8
XFILLER_15_783 VPWR VGND sg13cmos5l_decap_8
XFILLER_15_2433 VPWR VGND sg13cmos5l_decap_8
XFILLER_15_1710 VPWR VGND sg13cmos5l_decap_8
XFILLER_9_98 VPWR VGND sg13cmos5l_decap_8
X_0823_ Tile_X4Y0_FrameData_O[12] Tile_X0Y0_FrameData[12] VPWR VGND sg13cmos5l_buf_1
XFILLER_15_1787 VPWR VGND sg13cmos5l_decap_8
X_0754_ Tile_X1Y0_S2BEG[3] Tile_X1Y0_N2MID[4] VPWR VGND sg13cmos5l_buf_1
XANTENNA_3850 Tile_X0Y0_FrameData[18] VPWR VGND sg13cmos5l_antennanp
X_0685_ _0685_/L_HI VPWR VGND sg13cmos5l_tiehi
XANTENNA_3861 Tile_X0Y0_FrameData[18] VPWR VGND sg13cmos5l_antennanp
XANTENNA_3872 Tile_X0Y0_FrameData[18] VPWR VGND sg13cmos5l_antennanp
XANTENNA_3883 Tile_X0Y0_FrameData[18] VPWR VGND sg13cmos5l_antennanp
XANTENNA_3894 Tile_X0Y0_FrameData[18] VPWR VGND sg13cmos5l_antennanp
XFILLER_6_2634 VPWR VGND sg13cmos5l_decap_8
X_1237_ _1237_/X Tile_X2Y0_N2END[2] Tile_X2Y0_N4END[2] Tile_X2Y0_NN4END[13] _0587_/Q
+ _0357_/Q _0356_/Q VPWR VGND sg13cmos5l_mux4_1
XFILLER_6_1988 VPWR VGND sg13cmos5l_fill_2
X_1168_ _1168_/X Tile_X0Y0_N2END[5] Tile_X0Y0_N4END[13] Tile_X0Y0_NN4END[2] _0596_/Q
+ _0127_/Q _0126_/Q VPWR VGND sg13cmos5l_mux4_1
X_0119_ _0119_/Q Tile_X0Y0_FrameData[2] VGND VPWR Tile_X0Y0_FrameStrobe[0] latch
X_1099_ _1099_/X Tile_X1Y0_N4END[0] Tile_X1Y0_N4END[3] Tile_X1Y0_NN4END[1] Tile_X1Y0_NN4END[3]
+ _0227_/Q _0226_/Q VPWR VGND sg13cmos5l_mux4_1
XFILLER_16_2219 VPWR VGND sg13cmos5l_fill_2
XFILLER_16_1507 VPWR VGND sg13cmos5l_decap_8
XFILLER_4_407 VPWR VGND sg13cmos5l_fill_1
XFILLER_14_1286 VPWR VGND sg13cmos5l_decap_8
XFILLER_7_1708 VPWR VGND sg13cmos5l_decap_8
XFILLER_9_1590 VPWR VGND sg13cmos5l_decap_8
XFILLER_12_742 VPWR VGND sg13cmos5l_decap_8
XFILLER_8_768 VPWR VGND sg13cmos5l_fill_2
XFILLER_12_1916 VPWR VGND sg13cmos5l_fill_2
XANTENNA_3102 Tile_X0Y0_FrameData[19] VPWR VGND sg13cmos5l_antennanp
XFILLER_10_2352 VPWR VGND sg13cmos5l_decap_8
XANTENNA_2401 Tile_X0Y0_FrameData[11] VPWR VGND sg13cmos5l_antennanp
XANTENNA_3113 Tile_X0Y0_FrameData[19] VPWR VGND sg13cmos5l_antennanp
XANTENNA_3124 Tile_X0Y0_FrameData[19] VPWR VGND sg13cmos5l_antennanp
XANTENNA_3135 Tile_X0Y0_FrameData[19] VPWR VGND sg13cmos5l_antennanp
XFILLER_4_963 VPWR VGND sg13cmos5l_fill_2
XANTENNA_2412 Tile_X0Y0_FrameData[11] VPWR VGND sg13cmos5l_antennanp
XANTENNA_2423 Tile_X0Y0_FrameData[12] VPWR VGND sg13cmos5l_antennanp
XANTENNA_2434 Tile_X0Y0_FrameData[12] VPWR VGND sg13cmos5l_antennanp
XANTENNA_3146 Tile_X0Y0_FrameData[19] VPWR VGND sg13cmos5l_antennanp
XANTENNA_3157 Tile_X0Y0_FrameData[19] VPWR VGND sg13cmos5l_antennanp
XANTENNA_3168 Tile_X0Y0_FrameData[19] VPWR VGND sg13cmos5l_antennanp
XANTENNA_3179 Tile_X0Y0_FrameData[20] VPWR VGND sg13cmos5l_antennanp
X_0470_ _0470_/Q Tile_X0Y0_FrameData[3] VGND VPWR Tile_X3Y0_FrameStrobe[1] latch
XANTENNA_1700 Tile_X0Y0_FrameData[4] VPWR VGND sg13cmos5l_antennanp
XANTENNA_1711 Tile_X0Y0_FrameData[4] VPWR VGND sg13cmos5l_antennanp
XANTENNA_1722 Tile_X0Y0_FrameData[4] VPWR VGND sg13cmos5l_antennanp
XANTENNA_2445 Tile_X0Y0_FrameData[12] VPWR VGND sg13cmos5l_antennanp
XANTENNA_2456 Tile_X0Y0_FrameData[12] VPWR VGND sg13cmos5l_antennanp
XANTENNA_2467 Tile_X0Y0_FrameData[12] VPWR VGND sg13cmos5l_antennanp
XANTENNA_1733 Tile_X0Y0_FrameData[4] VPWR VGND sg13cmos5l_antennanp
XANTENNA_1744 Tile_X0Y0_FrameData[4] VPWR VGND sg13cmos5l_antennanp
XANTENNA_1755 Tile_X0Y0_FrameData[4] VPWR VGND sg13cmos5l_antennanp
XANTENNA_1766 Tile_X0Y0_FrameData[5] VPWR VGND sg13cmos5l_antennanp
XANTENNA_2478 Tile_X0Y0_FrameData[12] VPWR VGND sg13cmos5l_antennanp
XANTENNA_2489 Tile_X0Y0_FrameData[12] VPWR VGND sg13cmos5l_antennanp
XANTENNA_1777 Tile_X0Y0_FrameData[5] VPWR VGND sg13cmos5l_antennanp
XANTENNA_1788 Tile_X0Y0_FrameData[5] VPWR VGND sg13cmos5l_antennanp
XANTENNA_1799 Tile_X0Y0_FrameData[5] VPWR VGND sg13cmos5l_antennanp
XFILLER_1_2520 VPWR VGND sg13cmos5l_decap_8
X_1022_ Tile_X0Y0_S2BEG[7] Tile_X0Y0_N2MID[0] VPWR VGND sg13cmos5l_buf_1
XFILLER_1_2553 VPWR VGND sg13cmos5l_fill_2
XFILLER_15_2296 VPWR VGND sg13cmos5l_decap_8
XFILLER_15_1584 VPWR VGND sg13cmos5l_decap_8
XFILLER_11_2149 VPWR VGND sg13cmos5l_decap_8
X_0806_ Tile_X3Y0_SS4BEG[11] _1286_/X VPWR VGND sg13cmos5l_buf_1
XANTENNA__0802__X Tile_X3Y0_SS4BEG[7] VPWR VGND sg13cmos5l_antennanp
X_0737_ Tile_X1Y0_SS4BEG[6] _1201_/X VPWR VGND sg13cmos5l_buf_1
XANTENNA_3680 Tile_X1Y0_N2END[5] VPWR VGND sg13cmos5l_antennanp
XANTENNA_3691 Tile_X1Y0_N4END[1] VPWR VGND sg13cmos5l_antennanp
X_0668_ _0668_/L_HI VPWR VGND sg13cmos5l_tiehi
XANTENNA_2990 Tile_X0Y0_FrameData[19] VPWR VGND sg13cmos5l_antennanp
X_0599_ _0599_/Q Tile_X0Y0_UserCLK NPU_RDATA27 _0615_/L_HI VPWR VGND sg13cmos5l_dfrbpq_1
XFILLER_6_2486 VPWR VGND sg13cmos5l_decap_4
XFILLER_6_1741 VPWR VGND sg13cmos5l_decap_8
XANTENNA_608 Tile_X0Y0_FrameData[23] VPWR VGND sg13cmos5l_antennanp
XANTENNA_619 Tile_X0Y0_FrameData[23] VPWR VGND sg13cmos5l_antennanp
XFILLER_13_506 VPWR VGND sg13cmos5l_decap_8
XFILLER_16_1337 VPWR VGND sg13cmos5l_decap_8
XFILLER_14_1050 VPWR VGND sg13cmos5l_decap_8
XANTENNA__0712__X Tile_X1Y0_S2BEGb[5] VPWR VGND sg13cmos5l_antennanp
XFILLER_5_749 VPWR VGND sg13cmos5l_fill_1
XFILLER_4_226 VPWR VGND sg13cmos5l_fill_2
XANTENNA_1007 Tile_X0Y0_FrameData[28] VPWR VGND sg13cmos5l_antennanp
XANTENNA_1018 Tile_X0Y0_FrameData[28] VPWR VGND sg13cmos5l_antennanp
XFILLER_7_2228 VPWR VGND sg13cmos5l_decap_8
XANTENNA_1029 Tile_X0Y0_FrameData[29] VPWR VGND sg13cmos5l_antennanp
XFILLER_1_1148 VPWR VGND sg13cmos5l_decap_4
XFILLER_16_2594 VPWR VGND sg13cmos5l_fill_1
XFILLER_12_550 VPWR VGND sg13cmos5l_decap_8
XFILLER_12_2414 VPWR VGND sg13cmos5l_decap_8
XFILLER_16_1882 VPWR VGND sg13cmos5l_decap_8
XFILLER_8_598 VPWR VGND sg13cmos5l_decap_8
XANTENNA_4 NPU_RDATA10 VPWR VGND sg13cmos5l_antennanp
XFILLER_12_1768 VPWR VGND sg13cmos5l_decap_8
X_0522_ NPU_READ_BANK_SEL1 Tile_X0Y0_UserCLK _1129_/X _0630_/L_HI VPWR VGND sg13cmos5l_dfrbpq_1
XFILLER_6_77 VPWR VGND sg13cmos5l_decap_8
XANTENNA_2220 Tile_X0Y0_FrameData[9] VPWR VGND sg13cmos5l_antennanp
XANTENNA_2231 Tile_X0Y0_FrameData[9] VPWR VGND sg13cmos5l_antennanp
XANTENNA_2242 Tile_X0Y0_FrameData[9] VPWR VGND sg13cmos5l_antennanp
XANTENNA_1530 Tile_X0Y0_FrameData[3] VPWR VGND sg13cmos5l_antennanp
XANTENNA_2253 Tile_X0Y0_FrameData[9] VPWR VGND sg13cmos5l_antennanp
XANTENNA_2264 Tile_X0Y0_FrameData[9] VPWR VGND sg13cmos5l_antennanp
XANTENNA_2275 Tile_X0Y0_FrameData[9] VPWR VGND sg13cmos5l_antennanp
X_0453_ _0453_/Q Tile_X0Y0_FrameData[20] VGND VPWR Tile_X3Y0_FrameStrobe[1] latch
XANTENNA_1541 Tile_X0Y0_FrameData[3] VPWR VGND sg13cmos5l_antennanp
XANTENNA_1552 Tile_X0Y0_FrameData[3] VPWR VGND sg13cmos5l_antennanp
XANTENNA_1563 Tile_X0Y0_FrameData[3] VPWR VGND sg13cmos5l_antennanp
XANTENNA_1574 Tile_X0Y0_FrameData[3] VPWR VGND sg13cmos5l_antennanp
XANTENNA_2286 Tile_X0Y0_FrameData[9] VPWR VGND sg13cmos5l_antennanp
XANTENNA_2297 Tile_X0Y0_N4END[0] VPWR VGND sg13cmos5l_antennanp
X_0384_ _0384_/Q Tile_X0Y0_FrameData[25] VGND VPWR Tile_X2Y0_FrameStrobe[2] latch
XFILLER_3_2626 VPWR VGND sg13cmos5l_decap_8
XANTENNA_1585 Tile_X0Y0_FrameData[3] VPWR VGND sg13cmos5l_antennanp
XANTENNA_1596 Tile_X0Y0_FrameData[3] VPWR VGND sg13cmos5l_antennanp
XFILLER_1_2372 VPWR VGND sg13cmos5l_decap_8
X_1005_ Tile_X0Y0_S4BEG[14] _1153_/X VPWR VGND sg13cmos5l_buf_1
XFILLER_15_2093 VPWR VGND sg13cmos5l_decap_8
XFILLER_15_1381 VPWR VGND sg13cmos5l_fill_2
XFILLER_15_1370 VPWR VGND sg13cmos5l_decap_8
XFILLER_11_1245 VPWR VGND sg13cmos5l_decap_8
XFILLER_6_2250 VPWR VGND sg13cmos5l_decap_8
XANTENNA_405 Tile_X0Y0_FrameData[22] VPWR VGND sg13cmos5l_antennanp
XANTENNA_416 Tile_X0Y0_FrameData[22] VPWR VGND sg13cmos5l_antennanp
XFILLER_2_1435 VPWR VGND sg13cmos5l_fill_1
XANTENNA_427 Tile_X0Y0_FrameData[23] VPWR VGND sg13cmos5l_antennanp
XANTENNA_438 Tile_X0Y0_FrameData[23] VPWR VGND sg13cmos5l_antennanp
XANTENNA_449 Tile_X0Y0_FrameData[23] VPWR VGND sg13cmos5l_antennanp
XANTENNA__0707__X Tile_X1Y0_S2BEGb[0] VPWR VGND sg13cmos5l_antennanp
XFILLER_15_42 VPWR VGND sg13cmos5l_decap_8
XFILLER_16_1112 VPWR VGND sg13cmos5l_decap_8
XFILLER_13_2734 VPWR VGND sg13cmos5l_decap_8
XFILLER_5_557 VPWR VGND sg13cmos5l_decap_8
XANTENNA_972 Tile_X0Y0_FrameData[28] VPWR VGND sg13cmos5l_antennanp
XANTENNA_961 Tile_X0Y0_FrameData[28] VPWR VGND sg13cmos5l_antennanp
XANTENNA_950 Tile_X0Y0_FrameData[28] VPWR VGND sg13cmos5l_antennanp
XFILLER_16_185 VPWR VGND sg13cmos5l_decap_8
XANTENNA_994 Tile_X0Y0_FrameData[28] VPWR VGND sg13cmos5l_antennanp
XANTENNA_983 Tile_X0Y0_FrameData[28] VPWR VGND sg13cmos5l_antennanp
XFILLER_12_2211 VPWR VGND sg13cmos5l_decap_8
XFILLER_8_340 VPWR VGND sg13cmos5l_fill_1
XFILLER_12_2288 VPWR VGND sg13cmos5l_decap_8
XFILLER_12_1565 VPWR VGND sg13cmos5l_decap_8
XANTENNA_2050 Tile_X0Y0_FrameData[6] VPWR VGND sg13cmos5l_antennanp
X_0505_ _0505_/Q Tile_X0Y0_FrameData[0] VGND VPWR Tile_X3Y0_FrameStrobe[2] latch
XFILLER_4_590 VPWR VGND sg13cmos5l_decap_8
XANTENNA_2061 Tile_X0Y0_FrameData[6] VPWR VGND sg13cmos5l_antennanp
XANTENNA_2072 Tile_X0Y0_FrameData[6] VPWR VGND sg13cmos5l_antennanp
XANTENNA_2083 Tile_X0Y0_FrameData[6] VPWR VGND sg13cmos5l_antennanp
XANTENNA_2094 Tile_X0Y0_FrameData[6] VPWR VGND sg13cmos5l_antennanp
X_0436_ _0436_/Q Tile_X0Y0_FrameData[5] VGND VPWR Tile_X3Y0_FrameStrobe[0] latch
.ends
